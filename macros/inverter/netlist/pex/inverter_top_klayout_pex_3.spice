* NGSPICE file created from inverter_top_pex.ext - technology: ihp-sg13g2

.subckt inverter_top_pex VDD vin4 vout4 VSS vin3 vout3 vin2 vout2 vout1 vin1
X0 vout3 vin3 VSS.t104 VSS.t85 sg13_lv_nmos ad=0.19p pd=1.38u as=0.19p ps=1.38u w=1u l=1u
X1 VDD VDD VDD VDD sg13_lv_pmos ad=1.14p pd=6.38u as=0.56797n ps=1.006m w=6u l=1u
X2 VSS.t1 VSS.t52 VSS.t54 VSS.t53 sg13_lv_nmos ad=0.34p pd=2.68u as=0 ps=0 w=1u l=1u
X3 VDD VDD VDD VDD sg13_lv_pmos ad=1.14p pd=6.38u as=0 ps=0 w=6u l=1u
X4 VDD vin4 vout4 VDD sg13_lv_pmos ad=1.14p pd=6.38u as=1.14p ps=6.38u w=6u l=1u
X5 vout2 vin2 VSS.t75 VSS.t76 sg13_lv_nmos ad=0.19p pd=1.38u as=0.19p ps=1.38u w=1u l=1u
X6 vout3 vin3 VDD VDD sg13_lv_pmos ad=1.14p pd=6.38u as=1.14p ps=6.38u w=6u l=1u
X7 vout4 vin4 VSS.t109 VSS.t110 sg13_lv_nmos ad=0.19p pd=1.38u as=0.19p ps=1.38u w=1u l=1u
X8 vout3 vin3 VSS.t42 VSS.t58 sg13_lv_nmos ad=0.19p pd=1.38u as=0.19p ps=1.38u w=1u l=1u
X9 vout2 vin2 VSS.t69 VSS.t70 sg13_lv_nmos ad=0.19p pd=1.38u as=0.19p ps=1.38u w=1u l=1u
X10 vout4 vin4 VDD VDD sg13_lv_pmos ad=1.14p pd=6.38u as=1.14p ps=6.38u w=6u l=1u
X11 VDD vin2 vout2 VDD sg13_lv_pmos ad=1.14p pd=6.38u as=1.14p ps=6.38u w=6u l=1u
X12 VSS.t75 vin2 vout2 VSS.t74 sg13_lv_nmos ad=0.19p pd=1.38u as=0.19p ps=1.38u w=1u l=1u
X13 vout2 vin2 VSS.t78 VSS.t79 sg13_lv_nmos ad=0.19p pd=1.38u as=0.19p ps=1.38u w=1u l=1u
X14 vout2 vin2 VDD VDD sg13_lv_pmos ad=1.14p pd=6.38u as=1.14p ps=6.38u w=6u l=1u
X15 VSS.t115 vin4 vout4 VSS.t114 sg13_lv_nmos ad=0.19p pd=1.38u as=0.19p ps=1.38u w=1u l=1u
X16 vout1 vin1 VSS.t24 VSS.t25 sg13_lv_nmos ad=0.19p pd=1.38u as=0.19p ps=1.38u w=1u l=1u
X17 VDD vin2 vout2 VDD sg13_lv_pmos ad=1.14p pd=6.38u as=1.14p ps=6.38u w=6u l=1u
X18 vout4 vin4 VSS.t34 VSS.t107 sg13_lv_nmos ad=0.19p pd=1.38u as=0.19p ps=1.38u w=1u l=1u
X19 VDD vin2 vout2 VDD sg13_lv_pmos ad=1.14p pd=6.38u as=1.14p ps=6.38u w=6u l=1u
X20 VSS.t104 vin3 vout3 VSS.t83 sg13_lv_nmos ad=0.19p pd=1.38u as=0.19p ps=1.38u w=1u l=1u
X21 vout4 vin4 VSS.t124 VSS.t125 sg13_lv_nmos ad=0.19p pd=1.38u as=0.19p ps=1.38u w=1u l=1u
X22 VSS.t118 vin4 vout4 VSS.t117 sg13_lv_nmos ad=0.19p pd=1.38u as=0.19p ps=1.38u w=1u l=1u
X23 VDD vin3 vout3 VDD sg13_lv_pmos ad=1.14p pd=6.38u as=1.14p ps=6.38u w=6u l=1u
X24 VDD vin2 vout2 VDD sg13_lv_pmos ad=1.14p pd=6.38u as=1.14p ps=6.38u w=6u l=1u
X25 vout3 vin3 VDD VDD sg13_lv_pmos ad=1.14p pd=6.38u as=1.14p ps=6.38u w=6u l=1u
X26 VSS.t69 vin2 vout2 VSS.t68 sg13_lv_nmos ad=0.19p pd=1.38u as=0.19p ps=1.38u w=1u l=1u
X27 VDD vin3 vout3 VDD sg13_lv_pmos ad=1.14p pd=6.38u as=1.14p ps=6.38u w=6u l=1u
X28 VSS.t42 VSS.t39 VSS.t41 VSS.t40 sg13_lv_nmos ad=0.34p pd=2.68u as=0 ps=0 w=1u l=1u
X29 vout2 vin2 VDD VDD sg13_lv_pmos ad=1.14p pd=6.38u as=1.14p ps=6.38u w=6u l=1u
X30 vout2 vin2 VSS.t72 VSS.t73 sg13_lv_nmos ad=0.19p pd=1.38u as=0.19p ps=1.38u w=1u l=1u
X31 vout1 vin1 VSS.t18 VSS.t19 sg13_lv_nmos ad=0.19p pd=1.38u as=0.19p ps=1.38u w=1u l=1u
X32 VSS.t78 vin2 vout2 VSS.t77 sg13_lv_nmos ad=0.19p pd=1.38u as=0.19p ps=1.38u w=1u l=1u
X33 vout4 vin4 VSS.t121 VSS.t122 sg13_lv_nmos ad=0.19p pd=1.38u as=0.19p ps=1.38u w=1u l=1u
X34 vout1 vin1 VDD VDD sg13_lv_pmos ad=1.14p pd=6.38u as=1.14p ps=6.38u w=6u l=1u
X35 vout1 vin1 VSS.t12 VSS.t13 sg13_lv_nmos ad=0.19p pd=1.38u as=0.19p ps=1.38u w=1u l=1u
X36 VSS.t127 vin4 vout4 VSS.t126 sg13_lv_nmos ad=0.19p pd=1.38u as=0.19p ps=1.38u w=1u l=1u
X37 VDD VDD VDD VDD sg13_lv_pmos ad=1.14p pd=6.38u as=0 ps=0 w=6u l=1u
X38 VSS.t18 vin1 vout1 VSS.t17 sg13_lv_nmos ad=0.19p pd=1.38u as=0.19p ps=1.38u w=1u l=1u
X39 vout2 vin2 VDD VDD sg13_lv_pmos ad=1.14p pd=6.38u as=1.14p ps=6.38u w=6u l=1u
X40 VDD vin4 vout4 VDD sg13_lv_pmos ad=1.14p pd=6.38u as=1.14p ps=6.38u w=6u l=1u
X41 vout1 vin1 VSS.t21 VSS.t22 sg13_lv_nmos ad=0.19p pd=1.38u as=0.19p ps=1.38u w=1u l=1u
X42 vout3 vin3 VSS.t102 VSS.t82 sg13_lv_nmos ad=0.19p pd=1.38u as=0.19p ps=1.38u w=1u l=1u
X43 VDD vin3 vout3 VDD sg13_lv_pmos ad=1.14p pd=6.38u as=1.14p ps=6.38u w=6u l=1u
X44 vout4 vin4 VDD VDD sg13_lv_pmos ad=1.14p pd=6.38u as=1.14p ps=6.38u w=6u l=1u
X45 VDD vin4 vout4 VDD sg13_lv_pmos ad=1.14p pd=6.38u as=1.14p ps=6.38u w=6u l=1u
X46 vout3 vin3 VDD VDD sg13_lv_pmos ad=1.14p pd=6.38u as=1.14p ps=6.38u w=6u l=1u
X47 VDD vin3 vout3 VDD sg13_lv_pmos ad=1.14p pd=6.38u as=1.14p ps=6.38u w=6u l=1u
X48 VSS.t38 VSS.t35 VSS.t37 VSS.t36 sg13_lv_nmos ad=0.19p pd=1.38u as=0 ps=0 w=1u l=1u
X49 VDD vin4 vout4 VDD sg13_lv_pmos ad=1.14p pd=6.38u as=1.14p ps=6.38u w=6u l=1u
X50 VDD vin2 vout2 VDD sg13_lv_pmos ad=1.14p pd=6.38u as=1.14p ps=6.38u w=6u l=1u
X51 VSS.t130 vin4 vout4 VSS.t129 sg13_lv_nmos ad=0.19p pd=1.38u as=0.19p ps=1.38u w=1u l=1u
X52 VDD vin3 vout3 VDD sg13_lv_pmos ad=1.14p pd=6.38u as=1.14p ps=6.38u w=6u l=1u
X53 VSS.t12 vin1 vout1 VSS.t11 sg13_lv_nmos ad=0.19p pd=1.38u as=0.19p ps=1.38u w=1u l=1u
X54 VDD vin1 vout1 VDD sg13_lv_pmos ad=1.14p pd=6.38u as=1.14p ps=6.38u w=6u l=1u
X55 vout4 vin4 VSS.t133 VSS.t134 sg13_lv_nmos ad=0.19p pd=1.38u as=0.19p ps=1.38u w=1u l=1u
X56 vout1 vin1 VDD VDD sg13_lv_pmos ad=1.14p pd=6.38u as=1.14p ps=6.38u w=6u l=1u
X57 vout4 vin4 VDD VDD sg13_lv_pmos ad=1.14p pd=6.38u as=1.14p ps=6.38u w=6u l=1u
X58 vout1 vin1 VSS.t15 VSS.t16 sg13_lv_nmos ad=0.19p pd=1.38u as=0.19p ps=1.38u w=1u l=1u
X59 VDD vin1 vout1 VDD sg13_lv_pmos ad=1.14p pd=6.38u as=1.14p ps=6.38u w=6u l=1u
X60 vout3 vin3 VSS.t98 VSS.t76 sg13_lv_nmos ad=0.19p pd=1.38u as=0.19p ps=1.38u w=1u l=1u
X61 VSS.t21 vin1 vout1 VSS.t20 sg13_lv_nmos ad=0.19p pd=1.38u as=0.19p ps=1.38u w=1u l=1u
X62 VDD VDD VDD VDD sg13_lv_pmos ad=2.04p pd=12.68u as=0 ps=0 w=6u l=1u
X63 vout4 vin4 VDD VDD sg13_lv_pmos ad=1.14p pd=6.38u as=1.14p ps=6.38u w=6u l=1u
X64 VDD vin3 vout3 VDD sg13_lv_pmos ad=1.14p pd=6.38u as=1.14p ps=6.38u w=6u l=1u
X65 VDD vin4 vout4 VDD sg13_lv_pmos ad=1.14p pd=6.38u as=1.14p ps=6.38u w=6u l=1u
X66 vout3 vin3 VDD VDD sg13_lv_pmos ad=1.14p pd=6.38u as=1.14p ps=6.38u w=6u l=1u
X67 vout3 vin3 VSS.t94 VSS.t70 sg13_lv_nmos ad=0.19p pd=1.38u as=0.19p ps=1.38u w=1u l=1u
X68 VSS.t98 vin3 vout3 VSS.t74 sg13_lv_nmos ad=0.19p pd=1.38u as=0.19p ps=1.38u w=1u l=1u
X69 VDD VDD VDD VDD sg13_lv_pmos ad=1.14p pd=6.38u as=0 ps=0 w=6u l=1u
X70 vout3 vin3 VSS.t100 VSS.t79 sg13_lv_nmos ad=0.19p pd=1.38u as=0.19p ps=1.38u w=1u l=1u
X71 vout4 vin4 VDD VDD sg13_lv_pmos ad=1.14p pd=6.38u as=1.14p ps=6.38u w=6u l=1u
X72 vout3 vin3 VDD VDD sg13_lv_pmos ad=1.14p pd=6.38u as=1.14p ps=6.38u w=6u l=1u
X73 VDD vin1 vout1 VDD sg13_lv_pmos ad=1.14p pd=6.38u as=1.14p ps=6.38u w=6u l=1u
X74 vout2 vin2 VDD VDD sg13_lv_pmos ad=1.14p pd=6.38u as=1.14p ps=6.38u w=6u l=1u
X75 vout1 vin1 VDD VDD sg13_lv_pmos ad=1.14p pd=6.38u as=1.14p ps=6.38u w=6u l=1u
X76 vout2 vin2 VSS.t63 VSS.t64 sg13_lv_nmos ad=0.19p pd=1.38u as=0.19p ps=1.38u w=1u l=1u
X77 VDD vin1 vout1 VDD sg13_lv_pmos ad=1.14p pd=6.38u as=1.14p ps=6.38u w=6u l=1u
X78 VDD vin1 vout1 VDD sg13_lv_pmos ad=1.14p pd=6.38u as=1.14p ps=6.38u w=6u l=1u
X79 VDD vin3 vout3 VDD sg13_lv_pmos ad=1.14p pd=6.38u as=1.14p ps=6.38u w=6u l=1u
X80 VSS.t94 vin3 vout3 VSS.t68 sg13_lv_nmos ad=0.19p pd=1.38u as=0.19p ps=1.38u w=1u l=1u
X81 vout3 vin3 VSS.t96 VSS.t73 sg13_lv_nmos ad=0.19p pd=1.38u as=0.19p ps=1.38u w=1u l=1u
X82 VSS.t112 vin4 vout4 VSS.t111 sg13_lv_nmos ad=0.19p pd=1.38u as=0.19p ps=1.38u w=1u l=1u
X83 VDD vin4 vout4 VDD sg13_lv_pmos ad=1.14p pd=6.38u as=1.14p ps=6.38u w=6u l=1u
X84 VSS.t100 vin3 vout3 VSS.t77 sg13_lv_nmos ad=0.19p pd=1.38u as=0.19p ps=1.38u w=1u l=1u
X85 vout4 vin4 VSS.t115 VSS.t116 sg13_lv_nmos ad=0.19p pd=1.38u as=0.19p ps=1.38u w=1u l=1u
X86 VDD vin1 vout1 VDD sg13_lv_pmos ad=1.14p pd=6.38u as=1.14p ps=6.38u w=6u l=1u
X87 vout2 vin2 VDD VDD sg13_lv_pmos ad=1.14p pd=6.38u as=1.14p ps=6.38u w=6u l=1u
X88 vout1 vin1 VDD VDD sg13_lv_pmos ad=1.14p pd=6.38u as=1.14p ps=6.38u w=6u l=1u
X89 VSS.t109 vin4 vout4 VSS.t108 sg13_lv_nmos ad=0.19p pd=1.38u as=0.19p ps=1.38u w=1u l=1u
X90 VDD VDD VDD VDD sg13_lv_pmos ad=2.04p pd=12.68u as=0 ps=0 w=6u l=1u
X91 vout2 vin2 VDD VDD sg13_lv_pmos ad=1.14p pd=6.38u as=1.14p ps=6.38u w=6u l=1u
X92 VDD vin2 vout2 VDD sg13_lv_pmos ad=1.14p pd=6.38u as=1.14p ps=6.38u w=6u l=1u
X93 VSS.t63 vin2 vout2 VSS.t62 sg13_lv_nmos ad=0.19p pd=1.38u as=0.19p ps=1.38u w=1u l=1u
X94 VSS.t121 vin4 vout4 VSS.t120 sg13_lv_nmos ad=0.19p pd=1.38u as=0.19p ps=1.38u w=1u l=1u
X95 vout2 vin2 VDD VDD sg13_lv_pmos ad=1.14p pd=6.38u as=1.14p ps=6.38u w=6u l=1u
X96 VDD VDD VDD VDD sg13_lv_pmos ad=2.04p pd=12.68u as=0 ps=0 w=6u l=1u
X97 vout2 vin2 VSS.t66 VSS.t67 sg13_lv_nmos ad=0.19p pd=1.38u as=0.19p ps=1.38u w=1u l=1u
X98 VSS.t72 vin2 vout2 VSS.t71 sg13_lv_nmos ad=0.19p pd=1.38u as=0.19p ps=1.38u w=1u l=1u
X99 vout1 vin1 VDD VDD sg13_lv_pmos ad=1.14p pd=6.38u as=1.14p ps=6.38u w=6u l=1u
X100 vout1 vin1 VSS.t6 VSS.t7 sg13_lv_nmos ad=0.19p pd=1.38u as=0.19p ps=1.38u w=1u l=1u
X101 vout4 vin4 VSS.t118 VSS.t119 sg13_lv_nmos ad=0.19p pd=1.38u as=0.19p ps=1.38u w=1u l=1u
X102 vout3 vin3 VDD VDD sg13_lv_pmos ad=1.14p pd=6.38u as=1.14p ps=6.38u w=6u l=1u
X103 vout4 vin4 VSS.t130 VSS.t131 sg13_lv_nmos ad=0.19p pd=1.38u as=0.19p ps=1.38u w=1u l=1u
X104 VSS.t46 VSS.t50 VSS.t51 VSS.t44 sg13_lv_nmos ad=0.19p pd=1.38u as=0 ps=0 w=1u l=1u
X105 VSS.t124 vin4 vout4 VSS.t123 sg13_lv_nmos ad=0.19p pd=1.38u as=0.19p ps=1.38u w=1u l=1u
X106 VDD vin1 vout1 VDD sg13_lv_pmos ad=1.14p pd=6.38u as=1.14p ps=6.38u w=6u l=1u
X107 VSS.t51 vin2 vout2 VSS.t86 sg13_lv_nmos ad=0.19p pd=1.38u as=0.19p ps=1.38u w=1u l=1u
X108 VDD vin2 vout2 VDD sg13_lv_pmos ad=1.14p pd=6.38u as=1.14p ps=6.38u w=6u l=1u
X109 vout4 vin4 VSS.t127 VSS.t128 sg13_lv_nmos ad=0.19p pd=1.38u as=0.19p ps=1.38u w=1u l=1u
X110 vout4 vin4 VDD VDD sg13_lv_pmos ad=1.14p pd=6.38u as=1.14p ps=6.38u w=6u l=1u
X111 vout2 vin2 VDD VDD sg13_lv_pmos ad=1.14p pd=6.38u as=1.14p ps=6.38u w=6u l=1u
X112 vout2 vin2 VSS.t60 VSS.t61 sg13_lv_nmos ad=0.19p pd=1.38u as=0.19p ps=1.38u w=1u l=1u
X113 VDD vin2 vout2 VDD sg13_lv_pmos ad=1.14p pd=6.38u as=1.14p ps=6.38u w=6u l=1u
X114 VSS.t66 vin2 vout2 VSS.t65 sg13_lv_nmos ad=0.19p pd=1.38u as=0.19p ps=1.38u w=1u l=1u
X115 VDD vin4 vout4 VDD sg13_lv_pmos ad=1.14p pd=6.38u as=1.14p ps=6.38u w=6u l=1u
X116 VDD VDD VDD VDD sg13_lv_pmos ad=2.04p pd=12.68u as=0 ps=0 w=6u l=1u
X117 VSS.t60 vin2 vout2 VSS.t59 sg13_lv_nmos ad=0.19p pd=1.38u as=0.19p ps=1.38u w=1u l=1u
X118 VSS.t6 vin1 vout1 VSS.t5 sg13_lv_nmos ad=0.19p pd=1.38u as=0.19p ps=1.38u w=1u l=1u
X119 vout3 vin3 VDD VDD sg13_lv_pmos ad=1.14p pd=6.38u as=1.14p ps=6.38u w=6u l=1u
X120 vout1 vin1 VSS.t9 VSS.t10 sg13_lv_nmos ad=0.19p pd=1.38u as=0.19p ps=1.38u w=1u l=1u
X121 VSS.t15 vin1 vout1 VSS.t14 sg13_lv_nmos ad=0.19p pd=1.38u as=0.19p ps=1.38u w=1u l=1u
X122 vout3 vin3 VDD VDD sg13_lv_pmos ad=1.14p pd=6.38u as=1.14p ps=6.38u w=6u l=1u
X123 VDD vin3 vout3 VDD sg13_lv_pmos ad=1.14p pd=6.38u as=1.14p ps=6.38u w=6u l=1u
X124 vout3 vin3 VDD VDD sg13_lv_pmos ad=1.14p pd=6.38u as=1.14p ps=6.38u w=6u l=1u
X125 vout3 vin3 VSS.t90 VSS.t64 sg13_lv_nmos ad=0.19p pd=1.38u as=0.19p ps=1.38u w=1u l=1u
X126 VSS.t81 vin2 vout2 VSS.t80 sg13_lv_nmos ad=0.19p pd=1.38u as=0.19p ps=1.38u w=1u l=1u
X127 vout1 vin1 VDD VDD sg13_lv_pmos ad=1.14p pd=6.38u as=1.14p ps=6.38u w=6u l=1u
X128 vout2 vin2 VSS.t84 VSS.t85 sg13_lv_nmos ad=0.19p pd=1.38u as=0.19p ps=1.38u w=1u l=1u
X129 VSS.t37 vin4 vout4 VSS.t135 sg13_lv_nmos ad=0.19p pd=1.38u as=0.19p ps=1.38u w=1u l=1u
X130 VSS.t57 VSS.t55 VSS.t30 VSS.t56 sg13_lv_nmos ad=0.19p pd=1.38u as=0 ps=0 w=1u l=1u
X131 VSS.t30 vin1 vout1 VSS.t29 sg13_lv_nmos ad=0.19p pd=1.38u as=0.19p ps=1.38u w=1u l=1u
X132 vout2 vin2 VSS.t49 VSS.t58 sg13_lv_nmos ad=0.19p pd=1.38u as=0.19p ps=1.38u w=1u l=1u
X133 VSS.t34 VSS.t31 VSS.t33 VSS.t32 sg13_lv_nmos ad=0.34p pd=2.68u as=0 ps=0 w=1u l=1u
X134 vout1 vin1 VSS.t3 VSS.t4 sg13_lv_nmos ad=0.19p pd=1.38u as=0.19p ps=1.38u w=1u l=1u
X135 VSS.t9 vin1 vout1 VSS.t8 sg13_lv_nmos ad=0.19p pd=1.38u as=0.19p ps=1.38u w=1u l=1u
X136 VDD vin3 vout3 VDD sg13_lv_pmos ad=1.14p pd=6.38u as=1.14p ps=6.38u w=6u l=1u
X137 VSS.t3 vin1 vout1 VSS.t2 sg13_lv_nmos ad=0.19p pd=1.38u as=0.19p ps=1.38u w=1u l=1u
X138 vout4 vin4 VDD VDD sg13_lv_pmos ad=1.14p pd=6.38u as=1.14p ps=6.38u w=6u l=1u
X139 vout3 vin3 VDD VDD sg13_lv_pmos ad=1.14p pd=6.38u as=1.14p ps=6.38u w=6u l=1u
X140 VDD vin3 vout3 VDD sg13_lv_pmos ad=1.14p pd=6.38u as=1.14p ps=6.38u w=6u l=1u
X141 VSS.t90 vin3 vout3 VSS.t62 sg13_lv_nmos ad=0.19p pd=1.38u as=0.19p ps=1.38u w=1u l=1u
X142 vout3 vin3 VSS.t92 VSS.t67 sg13_lv_nmos ad=0.19p pd=1.38u as=0.19p ps=1.38u w=1u l=1u
X143 vout1 vin1 VDD VDD sg13_lv_pmos ad=1.14p pd=6.38u as=1.14p ps=6.38u w=6u l=1u
X144 VSS.t84 vin2 vout2 VSS.t83 sg13_lv_nmos ad=0.19p pd=1.38u as=0.19p ps=1.38u w=1u l=1u
X145 VSS.t96 vin3 vout3 VSS.t71 sg13_lv_nmos ad=0.19p pd=1.38u as=0.19p ps=1.38u w=1u l=1u
X146 VDD vin4 vout4 VDD sg13_lv_pmos ad=1.14p pd=6.38u as=1.14p ps=6.38u w=6u l=1u
X147 vout1 vin1 VDD VDD sg13_lv_pmos ad=1.14p pd=6.38u as=1.14p ps=6.38u w=6u l=1u
X148 VDD vin1 vout1 VDD sg13_lv_pmos ad=1.14p pd=6.38u as=1.14p ps=6.38u w=6u l=1u
X149 vout4 vin4 VDD VDD sg13_lv_pmos ad=1.14p pd=6.38u as=1.14p ps=6.38u w=6u l=1u
X150 VSS.t24 vin1 vout1 VSS.t23 sg13_lv_nmos ad=0.19p pd=1.38u as=0.19p ps=1.38u w=1u l=1u
X151 vout1 vin1 VSS.t27 VSS.t28 sg13_lv_nmos ad=0.19p pd=1.38u as=0.19p ps=1.38u w=1u l=1u
X152 vout1 vin1 VDD VDD sg13_lv_pmos ad=1.14p pd=6.38u as=1.14p ps=6.38u w=6u l=1u
X153 vout2 vin2 VDD VDD sg13_lv_pmos ad=1.14p pd=6.38u as=1.14p ps=6.38u w=6u l=1u
X154 vout4 vin4 VSS.t112 VSS.t113 sg13_lv_nmos ad=0.19p pd=1.38u as=0.19p ps=1.38u w=1u l=1u
X155 VSS.t49 VSS.t47 VSS.t48 VSS.t40 sg13_lv_nmos ad=0.34p pd=2.68u as=0 ps=0 w=1u l=1u
X156 VSS.t46 VSS.t43 VSS.t45 VSS.t44 sg13_lv_nmos ad=0.19p pd=1.38u as=0 ps=0 w=1u l=1u
X157 vout4 vin4 VDD VDD sg13_lv_pmos ad=1.14p pd=6.38u as=1.14p ps=6.38u w=6u l=1u
X158 VSS.t45 vin3 vout3 VSS.t86 sg13_lv_nmos ad=0.19p pd=1.38u as=0.19p ps=1.38u w=1u l=1u
X159 VSS.t133 vin4 vout4 VSS.t132 sg13_lv_nmos ad=0.19p pd=1.38u as=0.19p ps=1.38u w=1u l=1u
X160 VDD vin4 vout4 VDD sg13_lv_pmos ad=1.14p pd=6.38u as=1.14p ps=6.38u w=6u l=1u
X161 vout1 vin1 VSS.t1 VSS.t0 sg13_lv_nmos ad=0.19p pd=1.38u as=0.19p ps=1.38u w=1u l=1u
X162 vout3 vin3 VSS.t88 VSS.t61 sg13_lv_nmos ad=0.19p pd=1.38u as=0.19p ps=1.38u w=1u l=1u
X163 VSS.t92 vin3 vout3 VSS.t65 sg13_lv_nmos ad=0.19p pd=1.38u as=0.19p ps=1.38u w=1u l=1u
X164 vout4 vin4 VDD VDD sg13_lv_pmos ad=1.14p pd=6.38u as=1.14p ps=6.38u w=6u l=1u
X165 vout2 vin2 VSS.t81 VSS.t82 sg13_lv_nmos ad=0.19p pd=1.38u as=0.19p ps=1.38u w=1u l=1u
X166 VSS.t88 vin3 vout3 VSS.t59 sg13_lv_nmos ad=0.19p pd=1.38u as=0.19p ps=1.38u w=1u l=1u
X167 VDD vin1 vout1 VDD sg13_lv_pmos ad=1.14p pd=6.38u as=1.14p ps=6.38u w=6u l=1u
X168 vout1 vin1 VDD VDD sg13_lv_pmos ad=1.14p pd=6.38u as=1.14p ps=6.38u w=6u l=1u
X169 VDD vin1 vout1 VDD sg13_lv_pmos ad=1.14p pd=6.38u as=1.14p ps=6.38u w=6u l=1u
X170 VDD vin4 vout4 VDD sg13_lv_pmos ad=1.14p pd=6.38u as=1.14p ps=6.38u w=6u l=1u
X171 VSS.t27 vin1 vout1 VSS.t26 sg13_lv_nmos ad=0.19p pd=1.38u as=0.19p ps=1.38u w=1u l=1u
X172 VDD vin2 vout2 VDD sg13_lv_pmos ad=1.14p pd=6.38u as=1.14p ps=6.38u w=6u l=1u
X173 vout2 vin2 VDD VDD sg13_lv_pmos ad=1.14p pd=6.38u as=1.14p ps=6.38u w=6u l=1u
X174 VDD vin2 vout2 VDD sg13_lv_pmos ad=1.14p pd=6.38u as=1.14p ps=6.38u w=6u l=1u
X175 VSS.t102 vin3 vout3 VSS.t80 sg13_lv_nmos ad=0.19p pd=1.38u as=0.19p ps=1.38u w=1u l=1u
C0 vin4 VDD 29.2329f
C1 VDD vin3 29.202f
C2 vin2 vin3 0.05785f
C3 vout4 vin4 18.2968f
C4 vout3 VDD 15.3834f
C5 VDD vout1 15.3949f
C6 vin2 VDD 29.202f
C7 vout2 VDD 15.3834f
C8 vin4 vin3 0.05053f
C9 vout4 VDD 15.3949f
C10 vin2 vout2 18.2968f
C11 vin1 vout1 18.2968f
C12 VDD vin1 29.2329f
C13 vout3 vin3 18.2968f
C14 vin2 vin1 0.05053f
R0 VSS.t35 VSS.n93 6777.49
R1 VSS.n253 VSS.t35 6777.49
R2 VSS.n93 VSS.n214 1580.41
R3 VSS.t58 VSS.n161 88.7251
R4 VSS.n117 VSS.t86 88.7251
R5 VSS.t59 VSS.n159 83.1798
R6 VSS.n119 VSS.t85 83.1798
R7 VSS.t61 VSS.n146 77.6345
R8 VSS.n121 VSS.t83 77.6345
R9 VSS.t36 VSS.t35 6.87897
R10 VSS.t62 VSS.n144 72.0892
R11 VSS.n123 VSS.t82 72.0892
R12 VSS.t135 VSS.t35 9.76925
R13 VSS.t64 VSS.n142 66.5439
R14 VSS.n125 VSS.t80 66.5439
R15 VSS.t35 VSS.t108 12.3005
R16 VSS.t65 VSS.n140 60.9987
R17 VSS.n127 VSS.t79 60.9987
R18 VSS.t132 VSS.t35 14.4648
R19 VSS.n3 VSS.t29 9.77002
R20 VSS.t131 VSS.t35 16.2707
R21 VSS.n3 VSS.t28 12.2984
R22 VSS.t67 VSS.n138 55.4534
R23 VSS.n135 VSS.t71 55.4534
R24 VSS.t73 VSS.n132 55.4534
R25 VSS.n129 VSS.t77 55.4534
R26 VSS.t35 VSS.t128 18.799
R27 VSS.n157 VSS.t68 49.9081
R28 VSS.n156 VSS.t70 49.9081
R29 VSS.n154 VSS.t74 49.9081
R30 VSS.n153 VSS.t76 49.9081
R31 VSS.t126 VSS.t35 19.5212
R32 VSS.t35 VSS.t116 19.5219
R33 VSS.t68 VSS.n137 44.3628
R34 VSS.t70 VSS.n136 44.3628
R35 VSS.t74 VSS.n131 44.3628
R36 VSS.t76 VSS.n130 44.3628
R37 VSS.t119 VSS.t35 19.8818
R38 VSS.t35 VSS.t117 19.8825
R39 VSS.n139 VSS.t67 38.8175
R40 VSS.t71 VSS.n134 38.8175
R41 VSS.n133 VSS.t73 38.8175
R42 VSS.t77 VSS.n128 38.8175
R43 VSS.t123 VSS.t35 19.882
R44 VSS.n3 VSS.t20 19.5213
R45 VSS.t35 VSS.t120 19.5591
R46 VSS.n3 VSS.t19 19.882
R47 VSS.n141 VSS.t65 33.2722
R48 VSS.t79 VSS.n126 33.2722
R49 VSS.t114 VSS.t35 18.8
R50 VSS.n143 VSS.t64 27.7269
R51 VSS.t80 VSS.n124 27.7269
R52 VSS.t113 VSS.t35 17.717
R53 VSS.t111 VSS.t35 16.2727
R54 VSS.n3 VSS.n93 6777.49
R55 VSS.t13 VSS.n3 19.8816
R56 VSS.t56 VSS.n3 6.87971
R57 VSS.n145 VSS.t62 22.1816
R58 VSS.t82 VSS.n122 22.1816
R59 VSS.t110 VSS.t35 14.4672
R60 VSS.n3 VSS.t26 14.4654
R61 VSS.n3 VSS.t23 17.7157
R62 VSS.n3 VSS.t16 19.5017
R63 VSS.n3 VSS.t14 19.5619
R64 VSS.n3 VSS.t11 19.8817
R65 VSS.n3 VSS.t10 19.5211
R66 VSS.n3 VSS.t5 16.271
R67 VSS.n3 VSS.t4 14.4652
R68 VSS.n3 VSS.t2 12.2982
R69 VSS.n3 VSS.t0 9.76976
R70 VSS.n1 VSS.t55 0.00253091
R71 VSS.n1 VSS.n3 0.929718
R72 VSS.t57 VSS.t55 17.0005
R73 VSS.n199 VSS.t57 17.0005
R74 VSS.n198 VSS.t30 17.0005
R75 VSS.n199 VSS.t30 17.0005
R76 VSS.t57 VSS.n198 17.0005
R77 VSS.t55 VSS.t30 17.0005
R78 VSS.n178 VSS.n3 17.0005
R79 VSS.n3 VSS.n110 17.0005
R80 VSS.n180 VSS.t1 17.0005
R81 VSS.t1 VSS.n179 17.0005
R82 VSS.t1 VSS.n95 17.0005
R83 VSS.n179 VSS.t54 17.0005
R84 VSS.t54 VSS.n95 17.0005
R85 VSS.n180 VSS.t54 17.0005
R86 VSS.n6 VSS.n63 14.4044
R87 VSS.n7 VSS.n77 14.4044
R88 VSS.n116 VSS.n45 8.49655
R89 VSS.n117 VSS.n45 8.49631
R90 VSS.n65 VSS.n45 0.650675
R91 VSS.n9 VSS.n65 14.4044
R92 VSS.n118 VSS.n45 8.49606
R93 VSS.n119 VSS.n45 8.49846
R94 VSS.n11 VSS.n83 14.4044
R95 VSS.n68 VSS.n45 0.650675
R96 VSS.n13 VSS.n68 14.4044
R97 VSS.n122 VSS.n45 8.49879
R98 VSS.n123 VSS.n45 8.49829
R99 VSS.n15 VSS.n82 14.4044
R100 VSS.n125 VSS.n45 8.49581
R101 VSS.n80 VSS.n45 0.650675
R102 VSS.n17 VSS.n80 14.4044
R103 VSS.n127 VSS.n45 8.4973
R104 VSS.n19 VSS.n78 14.4044
R105 VSS.n129 VSS.n45 8.49986
R106 VSS.n21 VSS.n67 14.4044
R107 VSS.n130 VSS.n45 8.49557
R108 VSS.n74 VSS.n45 0.650675
R109 VSS.n22 VSS.n74 14.4044
R110 VSS.n103 VSS.n45 5.66421
R111 VSS.n62 VSS.n45 0.650675
R112 VSS.n154 VSS.n62 7.20256
R113 VSS.n131 VSS.n45 8.49532
R114 VSS.n70 VSS.n45 0.650675
R115 VSS.n24 VSS.n70 14.4044
R116 VSS.n132 VSS.n45 8.4968
R117 VSS.n25 VSS.n84 14.6203
R118 VSS.n84 VSS.n45 0.542754
R119 VSS.n134 VSS.n45 8.49507
R120 VSS.n75 VSS.n45 0.650675
R121 VSS.n28 VSS.n75 14.4044
R122 VSS.n136 VSS.n45 8.49984
R123 VSS.n29 VSS.n64 14.4044
R124 VSS.n100 VSS.n45 5.66421
R125 VSS.n157 VSS.n72 7.20256
R126 VSS.n31 VSS.n71 14.4044
R127 VSS.n138 VSS.n45 8.49483
R128 VSS.n139 VSS.n45 8.49458
R129 VSS.n69 VSS.n45 0.650675
R130 VSS.n141 VSS.n45 8.49779
R131 VSS.n86 VSS.n45 0.650675
R132 VSS.n35 VSS.n86 14.4044
R133 VSS.n142 VSS.n45 8.49923
R134 VSS.n143 VSS.n45 8.50161
R135 VSS.n79 VSS.n45 0.650675
R136 VSS.n37 VSS.n79 14.4044
R137 VSS.n144 VSS.n45 8.49434
R138 VSS.n145 VSS.n45 8.49919
R139 VSS.n38 VSS.n61 14.4044
R140 VSS.n61 VSS.n45 0.650675
R141 VSS.n146 VSS.n45 8.49409
R142 VSS.n158 VSS.n76 7.20256
R143 VSS.n159 VSS.n85 7.20256
R144 VSS.n81 VSS.n45 0.650675
R145 VSS.n41 VSS.n81 14.4044
R146 VSS.n73 VSS.n45 0.650675
R147 VSS.n161 VSS.n73 7.20256
R148 VSS.n162 VSS.n66 7.20256
R149 VSS.n88 VSS.n45 1.20771
R150 VSS.n43 VSS.t40 7.66689
R151 VSS.n44 VSS.n45 0.649972
R152 VSS.n45 VSS.n120 8.4996
R153 VSS.n45 VSS.n121 8.49898
R154 VSS.n45 VSS.n124 8.49754
R155 VSS.n45 VSS.n126 8.49894
R156 VSS.n45 VSS.n128 8.49854
R157 VSS.n45 VSS.n133 8.49904
R158 VSS.n45 VSS.n135 8.49804
R159 VSS.n45 VSS.n137 8.49705
R160 VSS.n45 VSS.n140 8.49819
R161 VSS.n45 VSS.n87 1.20771
R162 VSS.n99 VSS.n98 0.0142099
R163 VSS.n43 VSS.n60 1.40428
R164 VSS.n43 VSS.n105 5.66316
R165 VSS.n43 VSS.n52 1.5312
R166 VSS.n43 VSS.n102 5.66316
R167 VSS.t35 VSS.n235 17.0005
R168 VSS.t35 VSS.n224 17.0005
R169 VSS.n223 VSS.t38 17.0005
R170 VSS.t38 VSS.n215 17.0005
R171 VSS.t38 VSS.n222 17.0005
R172 VSS.n222 VSS.t37 17.0005
R173 VSS.n215 VSS.t37 17.0005
R174 VSS.n223 VSS.t37 17.0005
R175 VSS.n234 VSS.t34 17.0005
R176 VSS.t34 VSS.n225 17.0005
R177 VSS.t34 VSS.n233 17.0005
R178 VSS.n225 VSS.t33 17.0005
R179 VSS.n233 VSS.t33 17.0005
R180 VSS.n234 VSS.t33 17.0005
R181 VSS.n158 VSS.t61 16.6364
R182 VSS.t83 VSS.n120 16.6364
R183 VSS.t47 VSS.n90 15.0005
R184 VSS.t39 VSS.n91 15.0005
R185 VSS.n210 VSS.t43 15.0005
R186 VSS.t50 VSS.n201 15.0005
R187 VSS.n26 VSS.n84 14.6209
R188 VSS.n163 VSS.n87 13.3823
R189 VSS.t44 VSS.n63 7.20324
R190 VSS.n10 VSS.n83 14.4051
R191 VSS.n14 VSS.n82 14.4051
R192 VSS.n18 VSS.n78 14.4051
R193 VSS.n20 VSS.n67 14.4051
R194 VSS.n30 VSS.n71 14.4051
R195 VSS.n163 VSS.n88 13.3823
R196 VSS.t40 VSS.n88 6.69134
R197 VSS.n42 VSS.n66 14.4051
R198 VSS.n160 VSS.n81 7.20324
R199 VSS.n40 VSS.n76 14.4051
R200 VSS.n39 VSS.n61 14.4051
R201 VSS.n33 VSS.n69 14.4051
R202 VSS.n156 VSS.n64 7.20324
R203 VSS.n153 VSS.n74 7.20324
R204 VSS.t107 VSS.t35 9.77299
R205 VSS.t7 VSS.n3 17.7155
R206 VSS.t22 VSS.n3 18.7992
R207 VSS.t25 VSS.n3 16.2715
R208 VSS.n160 VSS.t59 11.0911
R209 VSS.t85 VSS.n118 11.0911
R210 VSS.n214 VSS.n45 1.69441
R211 VSS.n43 VSS.n153 8.5005
R212 VSS.n43 VSS.n154 8.5005
R213 VSS.n43 VSS.n156 8.5005
R214 VSS.n43 VSS.n157 8.5005
R215 VSS.n43 VSS.n158 8.5005
R216 VSS.n43 VSS.n159 8.5005
R217 VSS.n43 VSS.n160 8.5005
R218 VSS.n43 VSS.n161 8.5005
R219 VSS.n43 VSS.n162 8.5005
R220 VSS.n43 VSS.n163 8.5005
R221 VSS.n147 VSS.n45 8.4984
R222 VSS.n148 VSS.n57 0.0330498
R223 VSS.n57 VSS.n45 1.69278
R224 VSS.n149 VSS.n45 8.4984
R225 VSS.n151 VSS.n45 8.4984
R226 VSS.n97 VSS.n45 4.24643
R227 VSS.n60 VSS.n59 0.0110127
R228 VSS.n59 VSS.n58 0.015683
R229 VSS.n58 VSS.n45 1.52697
R230 VSS.n152 VSS.n103 0.0161786
R231 VSS.n105 VSS.n92 0.0277723
R232 VSS.n92 VSS.n45 3.39626
R233 VSS.n52 VSS.t96 0.0211655
R234 VSS.t96 VSS.n53 0.0254728
R235 VSS.n53 VSS.n45 2.10363
R236 VSS.n155 VSS.n100 0.0161786
R237 VSS.n102 VSS.n50 0.0624895
R238 VSS.n50 VSS.n45 0.881651
R239 VSS.n46 VSS.n45 1.39729
R240 VSS.n164 VSS.n45 8.4984
R241 VSS.n165 VSS.t48 0.0161786
R242 VSS.n43 VSS.n48 0.723977
R243 VSS.n43 VSS.n148 8.4984
R244 VSS.n54 VSS.n57 0.0112884
R245 VSS.n55 VSS.n54 0.0342178
R246 VSS.n43 VSS.n55 1.68134
R247 VSS.n43 VSS.n150 8.4984
R248 VSS.n43 VSS.n99 5.66233
R249 VSS.n60 VSS.n97 0.0487466
R250 VSS.n43 VSS.n152 8.4984
R251 VSS.n105 VSS.n104 0.00635632
R252 VSS.n52 VSS.n92 0.0458667
R253 VSS.n43 VSS.n155 8.4984
R254 VSS.n102 VSS.n101 0.00635632
R255 VSS.n49 VSS.n50 0.0131462
R256 VSS.n46 VSS.n49 0.102862
R257 VSS.n47 VSS.n46 0.012054
R258 VSS.n43 VSS.n165 8.4984
R259 VSS.n43 VSS.n89 0.777241
R260 VSS.n108 VSS.n3 0.910943
R261 VSS.n258 VSS.n111 8.22525
R262 VSS.n238 VSS.n237 8.22525
R263 VSS.n237 VSS.n167 8.22525
R264 VSS.n259 VSS.n258 8.22525
R265 VSS.t35 VSS.t32 6.87896
R266 VSS.n251 VSS.t47 7.49606
R267 VSS.n245 VSS.t39 7.49606
R268 VSS.t43 VSS.n209 7.49606
R269 VSS.n202 VSS.t50 7.49606
R270 VSS.n8 VSS.n117 7.20236
R271 VSS.n9 VSS.n118 7.20236
R272 VSS.n12 VSS.n68 14.4051
R273 VSS.n16 VSS.n125 7.20236
R274 VSS.n21 VSS.n130 7.20236
R275 VSS.n23 VSS.n131 7.20236
R276 VSS.n26 VSS.n134 7.20236
R277 VSS.n27 VSS.n135 7.20236
R278 VSS.n32 VSS.n139 7.20236
R279 VSS.n34 VSS.n86 14.4051
R280 VSS.n36 VSS.n79 14.4051
R281 VSS.n37 VSS.n144 7.20236
R282 VSS.n39 VSS.n146 7.20236
R283 VSS.n42 VSS.n87 13.8932
R284 VSS.n41 VSS.n73 14.4051
R285 VSS.n40 VSS.n85 14.4051
R286 VSS.n38 VSS.n145 7.20236
R287 VSS.n36 VSS.n143 7.20236
R288 VSS.n35 VSS.n142 7.20236
R289 VSS.n34 VSS.n141 7.20236
R290 VSS.n33 VSS.n140 7.20236
R291 VSS.n32 VSS.n69 14.4044
R292 VSS.n31 VSS.n138 7.20236
R293 VSS.n30 VSS.n137 7.20236
R294 VSS.n29 VSS.n72 14.4051
R295 VSS.n28 VSS.n136 7.20236
R296 VSS.n27 VSS.n75 14.4051
R297 VSS.n25 VSS.n133 7.20236
R298 VSS.n24 VSS.n132 7.20236
R299 VSS.n23 VSS.n70 14.4051
R300 VSS.n22 VSS.n62 14.4051
R301 VSS.n20 VSS.n129 7.20236
R302 VSS.n19 VSS.n128 7.20236
R303 VSS.n18 VSS.n127 7.20236
R304 VSS.n17 VSS.n126 7.20236
R305 VSS.n16 VSS.n80 14.4051
R306 VSS.n15 VSS.n124 7.20236
R307 VSS.n14 VSS.n123 7.20236
R308 VSS.n13 VSS.n122 7.20236
R309 VSS.n12 VSS.n121 7.20236
R310 VSS.n11 VSS.n120 7.20236
R311 VSS.n10 VSS.n119 7.20236
R312 VSS.n8 VSS.n65 14.4051
R313 VSS.n7 VSS.n116 7.20236
R314 VSS.n6 VSS.n77 14.4051
R315 VSS.n43 VSS.t44 7.66688
R316 VSS.n253 VSS.n3 6777.49
R317 VSS.n162 VSS.t58 5.54579
R318 VSS.t86 VSS.n116 5.54579
R319 VSS.n252 VSS.t49 4.5005
R320 VSS.t42 VSS.n244 4.5005
R321 VSS.t51 VSS.n200 4.5005
R322 VSS.n213 VSS.t45 4.5005
R323 VSS.n89 VSS.n45 2.45462
R324 VSS.t46 VSS.n45 0.770098
R325 VSS.n253 VSS.n44 1580.91
R326 VSS.t96 VSS.n239 4.11287
R327 VSS.t96 VSS.n56 4.11287
R328 VSS.n197 VSS.t55 3.0005
R329 VSS.n254 VSS.t52 3.0005
R330 VSS.n221 VSS.t35 3.0005
R331 VSS.n232 VSS.t31 3.0005
R332 VSS.n250 VSS.n249 3.0005
R333 VSS.n247 VSS.n246 3.0005
R334 VSS.n204 VSS.n203 3.0005
R335 VSS.n212 VSS.n211 3.0005
R336 VSS.n3 VSS.t17 19.8816
R337 VSS.n3 VSS.t8 18.799
R338 VSS.n3 VSS.t53 6.8797
R339 VSS.n167 VSS.n166 2.71193
R340 VSS.n261 VSS.n260 2.6297
R341 VSS.n255 VSS.t3 2.4821
R342 VSS.n256 VSS.t6 2.4821
R343 VSS.n257 VSS.t9 2.4821
R344 VSS.n115 VSS.t12 2.4821
R345 VSS.t18 VSS.n114 2.4821
R346 VSS.t21 VSS.n183 2.4821
R347 VSS.n182 VSS.t24 2.4821
R348 VSS.t27 VSS.n181 2.4821
R349 VSS.n220 VSS.t133 2.4821
R350 VSS.n219 VSS.t130 2.4821
R351 VSS.n218 VSS.t127 2.4821
R352 VSS.t124 VSS.n168 2.4821
R353 VSS.t118 VSS.n169 2.4821
R354 VSS.n229 VSS.t115 2.4821
R355 VSS.n230 VSS.t112 2.4821
R356 VSS.n231 VSS.t109 2.4821
R357 VSS.n243 VSS.t88 2.4821
R358 VSS.n243 VSS.t60 2.4821
R359 VSS.n242 VSS.t90 2.4821
R360 VSS.n242 VSS.t63 2.4821
R361 VSS.n241 VSS.t92 2.4821
R362 VSS.n241 VSS.t66 2.4821
R363 VSS.n240 VSS.t94 2.4821
R364 VSS.n240 VSS.t69 2.4821
R365 VSS.n51 VSS.t98 2.4821
R366 VSS.n51 VSS.t75 2.4821
R367 VSS.n205 VSS.t100 2.4821
R368 VSS.n205 VSS.t78 2.4821
R369 VSS.n206 VSS.t102 2.4821
R370 VSS.n206 VSS.t81 2.4821
R371 VSS.n207 VSS.t104 2.4821
R372 VSS.n207 VSS.t84 2.4821
R373 VSS.n45 VSS.n63 0.650675
R374 VSS.n45 VSS.n77 0.650675
R375 VSS.n45 VSS.n83 0.650675
R376 VSS.n45 VSS.n82 0.650675
R377 VSS.n45 VSS.n78 0.650675
R378 VSS.n45 VSS.n67 0.650675
R379 VSS.n45 VSS.n64 0.650675
R380 VSS.n45 VSS.n72 0.650675
R381 VSS.n45 VSS.n71 0.650675
R382 VSS.n45 VSS.n76 0.650675
R383 VSS.n45 VSS.n85 0.650675
R384 VSS.n45 VSS.n66 0.650675
R385 VSS.t48 VSS.n252 2.2505
R386 VSS.n244 VSS.t41 2.2505
R387 VSS.n200 VSS.t46 2.2505
R388 VSS.t46 VSS.n213 2.2505
R389 VSS.n4 VSS.n3 0.133431
R390 VSS.n195 VSS.n3 2.09947
R391 VSS.n193 VSS.n3 2.09947
R392 VSS.n191 VSS.n3 2.09947
R393 VSS.n112 VSS.n3 2.09947
R394 VSS.n189 VSS.n3 2.09947
R395 VSS.n187 VSS.n3 2.09947
R396 VSS.n185 VSS.n3 2.09947
R397 VSS.t35 VSS.n177 2.09887
R398 VSS.t35 VSS.n174 2.09868
R399 VSS.n5 VSS.n216 0.165993
R400 VSS.t35 VSS.n109 2.09862
R401 VSS.n236 VSS.t35 2.0986
R402 VSS.t35 VSS.n173 2.09849
R403 VSS.t35 VSS.n176 2.09849
R404 VSS.t35 VSS.n172 2.09849
R405 VSS.t41 VSS.n45 1.05416
R406 VSS.n214 VSS.n43 1.53502
R407 VSS.n44 VSS.n43 0.586892
R408 VSS.n254 VSS.n95 1.52811
R409 VSS.n222 VSS.n221 1.52811
R410 VSS.n233 VSS.n232 1.52811
R411 VSS.n198 VSS.n197 1.52811
R412 VSS.n107 VSS.t35 1.31147
R413 VSS.t35 VSS.n106 1.27596
R414 VSS.t48 VSS.n89 0.0107315
R415 VSS.t46 VSS.n48 0.00753659
R416 VSS.n108 VSS.n184 0.144834
R417 VSS.t35 VSS.n0 0.910334
R418 VSS.n43 VSS.n6 0.650322
R419 VSS.n43 VSS.n7 0.650322
R420 VSS.n43 VSS.n8 0.650322
R421 VSS.n43 VSS.n9 0.650322
R422 VSS.n43 VSS.n10 0.650322
R423 VSS.n43 VSS.n11 0.650322
R424 VSS.n43 VSS.n12 0.650322
R425 VSS.n43 VSS.n13 0.650322
R426 VSS.n43 VSS.n14 0.650322
R427 VSS.n43 VSS.n15 0.650322
R428 VSS.n43 VSS.n16 0.650322
R429 VSS.n43 VSS.n17 0.650322
R430 VSS.n43 VSS.n18 0.650322
R431 VSS.n43 VSS.n19 0.650322
R432 VSS.n43 VSS.n20 0.650322
R433 VSS.n43 VSS.n21 0.650322
R434 VSS.n43 VSS.n22 0.650322
R435 VSS.n43 VSS.n23 0.650322
R436 VSS.n43 VSS.n24 0.650322
R437 VSS.n43 VSS.n25 0.650322
R438 VSS.n43 VSS.n26 0.650322
R439 VSS.n43 VSS.n27 0.650322
R440 VSS.n43 VSS.n28 0.650322
R441 VSS.n43 VSS.n29 0.650322
R442 VSS.n43 VSS.n30 0.650322
R443 VSS.n43 VSS.n31 0.650322
R444 VSS.n43 VSS.n32 0.650322
R445 VSS.n43 VSS.n33 0.650322
R446 VSS.n43 VSS.n34 0.650322
R447 VSS.n43 VSS.n35 0.650322
R448 VSS.n43 VSS.n36 0.650322
R449 VSS.n43 VSS.n37 0.650322
R450 VSS.n43 VSS.n38 0.650322
R451 VSS.n43 VSS.n39 0.650322
R452 VSS.n43 VSS.n40 0.650322
R453 VSS.n43 VSS.n41 0.650322
R454 VSS.n43 VSS.n42 0.650322
R455 VSS.n238 VSS.n166 0.632727
R456 VSS.n262 VSS.n261 0.5505
R457 VSS.n239 VSS.n111 0.2444
R458 VSS.n239 VSS.n238 0.2444
R459 VSS.n259 VSS.n56 0.2444
R460 VSS.n167 VSS.n56 0.2444
R461 VSS.n255 VSS.n254 0.209825
R462 VSS.n221 VSS.n220 0.209825
R463 VSS.n232 VSS.n231 0.209825
R464 VSS.n197 VSS.n181 0.209825
R465 VSS.n184 VSS.t3 0.201663
R466 VSS.n186 VSS.t6 0.201663
R467 VSS.n188 VSS.t9 0.201663
R468 VSS.n190 VSS.t12 0.201663
R469 VSS.n192 VSS.t18 0.201663
R470 VSS.n194 VSS.t21 0.201663
R471 VSS.n196 VSS.t24 0.201663
R472 VSS.n4 VSS.t27 0.207972
R473 VSS.t133 VSS.n5 0.208003
R474 VSS.t130 VSS.n216 0.201663
R475 VSS.t127 VSS.n217 0.201663
R476 VSS.n175 VSS.t124 0.201663
R477 VSS.n171 VSS.t118 0.201663
R478 VSS.t115 VSS.n228 0.201663
R479 VSS.t112 VSS.n227 0.201663
R480 VSS.t109 VSS.n226 0.201663
R481 VSS.n46 VSS.t88 0.201663
R482 VSS.t60 VSS.n46 0.201663
R483 VSS.n49 VSS.t90 0.201663
R484 VSS.t63 VSS.n49 0.201663
R485 VSS.n49 VSS.t92 0.201663
R486 VSS.t66 VSS.n49 0.201663
R487 VSS.n101 VSS.t94 0.201663
R488 VSS.t69 VSS.n101 0.201663
R489 VSS.n104 VSS.t98 0.201663
R490 VSS.t75 VSS.n104 0.201663
R491 VSS.n59 VSS.t100 0.201663
R492 VSS.t78 VSS.n59 0.201663
R493 VSS.n98 VSS.t102 0.201663
R494 VSS.t81 VSS.n98 0.201663
R495 VSS.n54 VSS.t104 0.201663
R496 VSS.t84 VSS.n54 0.201663
R497 VSS.t72 VSS.t96 0.185696
R498 VSS.n256 VSS.n255 0.16242
R499 VSS.n257 VSS.n256 0.16242
R500 VSS.n115 VSS.n257 0.16242
R501 VSS.n113 VSS.n115 0.16242
R502 VSS.n113 VSS.n114 0.16242
R503 VSS.n183 VSS.n114 0.16242
R504 VSS.n183 VSS.n182 0.16242
R505 VSS.n182 VSS.n181 0.16242
R506 VSS.n231 VSS.n230 0.16242
R507 VSS.n230 VSS.n229 0.16242
R508 VSS.n229 VSS.n169 0.16242
R509 VSS.n170 VSS.n169 0.16242
R510 VSS.n170 VSS.n168 0.16242
R511 VSS.n218 VSS.n168 0.16242
R512 VSS.n219 VSS.n218 0.16242
R513 VSS.n220 VSS.n219 0.16242
R514 VSS.n5 VSS.t35 0.13248
R515 VSS.n226 VSS.n0 0.145358
R516 VSS.n248 VSS.n243 0.117247
R517 VSS.n208 VSS.n207 0.1171
R518 VSS.n185 VSS.n184 0.0952183
R519 VSS.n226 VSS.n172 0.0936887
R520 VSS.n187 VSS.n186 0.0927738
R521 VSS.n227 VSS.n173 0.0916257
R522 VSS.n216 VSS.n177 0.0908678
R523 VSS.n189 VSS.n188 0.0903294
R524 VSS.n191 VSS.t15 0.0903294
R525 VSS.n196 VSS.n195 0.0901212
R526 VSS.n228 VSS.n174 0.089375
R527 VSS.t121 VSS.n109 0.08912
R528 VSS.n217 VSS.n176 0.0889922
R529 VSS.t121 VSS.n236 0.0888607
R530 VSS.n112 VSS.n190 0.0878849
R531 VSS.n193 VSS.n192 0.0878849
R532 VSS.t15 VSS.n112 0.0876767
R533 VSS.n194 VSS.n193 0.0876767
R534 VSS.n236 VSS.n171 0.0866766
R535 VSS.n176 VSS.n175 0.0865477
R536 VSS.n175 VSS.n109 0.0864173
R537 VSS.n174 VSS.n171 0.0861674
R538 VSS.n195 VSS.n194 0.0854405
R539 VSS.n190 VSS.n189 0.0852323
R540 VSS.n192 VSS.n191 0.0852323
R541 VSS.n217 VSS.n177 0.0846727
R542 VSS.t52 VSS.n108 0.0840328
R543 VSS.n228 VSS.n173 0.0839099
R544 VSS.t31 VSS.n0 0.0834709
R545 VSS.n4 VSS.n196 0.166128
R546 VSS.n188 VSS.n187 0.0827878
R547 VSS.n262 VSS.n111 0.0827273
R548 VSS.n260 VSS.n259 0.0827273
R549 VSS.n227 VSS.n172 0.0818468
R550 VSS.n243 VSS.n242 0.08146
R551 VSS.n242 VSS.n241 0.08146
R552 VSS.n241 VSS.n240 0.08146
R553 VSS.n240 VSS.t96 0.08146
R554 VSS.t96 VSS.n51 0.08146
R555 VSS.n205 VSS.n51 0.08146
R556 VSS.n206 VSS.n205 0.08146
R557 VSS.n207 VSS.n206 0.08146
R558 VSS.n186 VSS.n185 0.0803434
R559 VSS.n3 VSS.n96 1.32552
R560 VSS.n261 VSS 0.0445
R561 VSS.n166 VSS 0.0445
R562 VSS.n170 VSS.t121 0.0394179
R563 VSS.t15 VSS.n113 0.0394179
R564 VSS.n258 VSS.n113 0.0389615
R565 VSS.n237 VSS.n170 0.0389615
R566 VSS.t49 VSS.n251 0.031258
R567 VSS.n245 VSS.t42 0.031258
R568 VSS.n202 VSS.t51 0.031258
R569 VSS.n248 VSS.n247 0.0291125
R570 VSS.n208 VSS.n204 0.0291125
R571 VSS.n212 VSS.n208 0.0291125
R572 VSS.n249 VSS.n248 0.0291125
R573 VSS.n247 VSS.n244 0.0281144
R574 VSS.n204 VSS.n200 0.0281144
R575 VSS.n213 VSS.n212 0.0281144
R576 VSS.n252 VSS.n249 0.0281144
R577 VSS.n209 VSS.t46 0.0216549
R578 VSS.n210 VSS.t45 0.0208704
R579 VSS.n250 VSS.n90 0.0202884
R580 VSS.n246 VSS.n91 0.0202884
R581 VSS.n211 VSS.n210 0.0202884
R582 VSS.n203 VSS.n201 0.0202884
R583 VSS.t52 VSS.n110 0.0133922
R584 VSS.n235 VSS.t31 0.0133922
R585 VSS.n148 VSS.n147 0.0118857
R586 VSS.n150 VSS.n149 0.0118857
R587 VSS.n104 VSS.n103 0.00858771
R588 VSS.n155 VSS.n53 0.0859649
R589 VSS.n101 VSS.n100 0.00858771
R590 VSS.n165 VSS.n164 0.0118857
R591 VSS.n164 VSS.n47 0.188038
R592 VSS.n152 VSS.n58 0.0788305
R593 VSS.n99 VSS.n151 0.018989
R594 VSS.n151 VSS.n150 0.0118857
R595 VSS.n149 VSS.n55 0.0558032
R596 VSS.n147 VSS.n48 0.0363758
R597 VSS.t48 VSS.n90 0.0115582
R598 VSS.t48 VSS.n91 0.0115582
R599 VSS.n201 VSS.t46 0.0112672
R600 VSS.t35 VSS.t122 19.5044
R601 VSS.t35 VSS.t125 19.8823
R602 VSS.t35 VSS.t129 17.7154
R603 VSS.t35 VSS.t134 12.2976
R604 VSS.n251 VSS.n250 0.0108877
R605 VSS.n246 VSS.n245 0.0108877
R606 VSS.n211 VSS.n209 0.0108877
R607 VSS.n203 VSS.n202 0.0108877
R608 VSS.t48 VSS.t41 0.00981217
R609 VSS VSS.n262 0.0095
R610 VSS.n260 VSS 0.0095
R611 VSS.n98 VSS.n97 0.0079094
R612 VSS.n198 VSS.n1 0.0349342
R613 VSS.n198 VSS.n94 0.0150237
R614 VSS.n178 VSS.n95 0.00798582
R615 VSS.n96 VSS.n95 0.0150022
R616 VSS.n222 VSS.n106 0.0150228
R617 VSS.n222 VSS.n2 0.0155446
R618 VSS.n233 VSS.n107 0.0150081
R619 VSS.n233 VSS.n224 0.00798582
R620 VSS.n199 VSS.n94 0.00152939
R621 VSS.n179 VSS.n110 0.00756994
R622 VSS.n179 VSS.n178 0.00756994
R623 VSS.n180 VSS.n96 0.00155084
R624 VSS.n223 VSS.n106 0.00153023
R625 VSS.n215 VSS.n2 0.00100818
R626 VSS.n225 VSS.n107 0.001545
R627 VSS.n234 VSS.n224 0.00756994
R628 VSS.n235 VSS.n234 0.00756994
R629 VSS.n3 VSS.n94 1.27394
R630 VSS.n43 VSS.n47 1.1058
R631 VSS.n2 VSS.t35 1.00295
C15 vout1 VSS 5.54899f
C16 vin1 VSS 16.0542f
C17 vout2 VSS 5.54814f
C18 vin2 VSS 16.0189f
C19 vout3 VSS 5.54814f
C20 vin3 VSS 16.0189f
C21 vout4 VSS 5.54899f
C22 vin4 VSS 16.0542f
C23 VDD VSS 21.8873f
.ends

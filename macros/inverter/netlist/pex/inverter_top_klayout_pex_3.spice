* NGSPICE file created from inverter_top_pex.ext - technology: ihp-sg13g2

.subckt inverter_top_pex VDD vin4 vout4 VSS vin3 vout3 vin2 vout2 vout1 vin1
X0 vout3 vin3 VSS.t105 VSS.t86 sg13_lv_nmos ad=0.19p pd=1.38u as=0.19p ps=1.38u w=1u l=1u
X1 VDD VDD VDD VDD sg13_lv_pmos ad=1.14p pd=6.38u as=0.56797n ps=1.006m w=6u l=1u
X2 VSS.t1 VSS.t53 VSS.t55 VSS.t54 sg13_lv_nmos ad=0.34p pd=2.68u as=0 ps=0 w=1u l=1u
X3 VDD VDD VDD VDD sg13_lv_pmos ad=1.14p pd=6.38u as=0 ps=0 w=6u l=1u
X4 VDD vin4 vout4 VDD sg13_lv_pmos ad=1.14p pd=6.38u as=1.14p ps=6.38u w=6u l=1u
X5 vout2 vin2 VSS.t76 VSS.t77 sg13_lv_nmos ad=0.19p pd=1.38u as=0.19p ps=1.38u w=1u l=1u
X6 vout3 vin3 VDD VDD sg13_lv_pmos ad=1.14p pd=6.38u as=1.14p ps=6.38u w=6u l=1u
X7 vout4 vin4 VSS.t110 VSS.t111 sg13_lv_nmos ad=0.19p pd=1.38u as=0.19p ps=1.38u w=1u l=1u
X8 vout3 vin3 VSS.t42 VSS.t59 sg13_lv_nmos ad=0.19p pd=1.38u as=0.19p ps=1.38u w=1u l=1u
X9 vout2 vin2 VSS.t70 VSS.t71 sg13_lv_nmos ad=0.19p pd=1.38u as=0.19p ps=1.38u w=1u l=1u
X10 vout4 vin4 VDD VDD sg13_lv_pmos ad=1.14p pd=6.38u as=1.14p ps=6.38u w=6u l=1u
X11 VDD vin2 vout2 VDD sg13_lv_pmos ad=1.14p pd=6.38u as=1.14p ps=6.38u w=6u l=1u
X12 VSS.t76 vin2 vout2 VSS.t75 sg13_lv_nmos ad=0.19p pd=1.38u as=0.19p ps=1.38u w=1u l=1u
X13 vout2 vin2 VSS.t79 VSS.t80 sg13_lv_nmos ad=0.19p pd=1.38u as=0.19p ps=1.38u w=1u l=1u
X14 vout2 vin2 VDD VDD sg13_lv_pmos ad=1.14p pd=6.38u as=1.14p ps=6.38u w=6u l=1u
X15 VSS.t116 vin4 vout4 VSS.t115 sg13_lv_nmos ad=0.19p pd=1.38u as=0.19p ps=1.38u w=1u l=1u
X16 vout1 vin1 VSS.t24 VSS.t25 sg13_lv_nmos ad=0.19p pd=1.38u as=0.19p ps=1.38u w=1u l=1u
X17 VDD vin2 vout2 VDD sg13_lv_pmos ad=1.14p pd=6.38u as=1.14p ps=6.38u w=6u l=1u
X18 vout4 vin4 VSS.t34 VSS.t108 sg13_lv_nmos ad=0.19p pd=1.38u as=0.19p ps=1.38u w=1u l=1u
X19 VDD vin2 vout2 VDD sg13_lv_pmos ad=1.14p pd=6.38u as=1.14p ps=6.38u w=6u l=1u
X20 VSS.t105 vin3 vout3 VSS.t84 sg13_lv_nmos ad=0.19p pd=1.38u as=0.19p ps=1.38u w=1u l=1u
X21 vout4 vin4 VSS.t125 VSS.t126 sg13_lv_nmos ad=0.19p pd=1.38u as=0.19p ps=1.38u w=1u l=1u
X22 VSS.t119 vin4 vout4 VSS.t118 sg13_lv_nmos ad=0.19p pd=1.38u as=0.19p ps=1.38u w=1u l=1u
X23 VDD vin3 vout3 VDD sg13_lv_pmos ad=1.14p pd=6.38u as=1.14p ps=6.38u w=6u l=1u
X24 VDD vin2 vout2 VDD sg13_lv_pmos ad=1.14p pd=6.38u as=1.14p ps=6.38u w=6u l=1u
X25 vout3 vin3 VDD VDD sg13_lv_pmos ad=1.14p pd=6.38u as=1.14p ps=6.38u w=6u l=1u
X26 VSS.t70 vin2 vout2 VSS.t69 sg13_lv_nmos ad=0.19p pd=1.38u as=0.19p ps=1.38u w=1u l=1u
X27 VDD vin3 vout3 VDD sg13_lv_pmos ad=1.14p pd=6.38u as=1.14p ps=6.38u w=6u l=1u
X28 VSS.t42 VSS.t39 VSS.t41 VSS.t40 sg13_lv_nmos ad=0.34p pd=2.68u as=0 ps=0 w=1u l=1u
X29 vout2 vin2 VDD VDD sg13_lv_pmos ad=1.14p pd=6.38u as=1.14p ps=6.38u w=6u l=1u
X30 vout2 vin2 VSS.t73 VSS.t74 sg13_lv_nmos ad=0.19p pd=1.38u as=0.19p ps=1.38u w=1u l=1u
X31 vout1 vin1 VSS.t18 VSS.t19 sg13_lv_nmos ad=0.19p pd=1.38u as=0.19p ps=1.38u w=1u l=1u
X32 VSS.t79 vin2 vout2 VSS.t78 sg13_lv_nmos ad=0.19p pd=1.38u as=0.19p ps=1.38u w=1u l=1u
X33 vout4 vin4 VSS.t122 VSS.t123 sg13_lv_nmos ad=0.19p pd=1.38u as=0.19p ps=1.38u w=1u l=1u
X34 vout1 vin1 VDD VDD sg13_lv_pmos ad=1.14p pd=6.38u as=1.14p ps=6.38u w=6u l=1u
X35 vout1 vin1 VSS.t12 VSS.t13 sg13_lv_nmos ad=0.19p pd=1.38u as=0.19p ps=1.38u w=1u l=1u
X36 VSS.t128 vin4 vout4 VSS.t127 sg13_lv_nmos ad=0.19p pd=1.38u as=0.19p ps=1.38u w=1u l=1u
X37 VDD VDD VDD VDD sg13_lv_pmos ad=1.14p pd=6.38u as=0 ps=0 w=6u l=1u
X38 VSS.t18 vin1 vout1 VSS.t17 sg13_lv_nmos ad=0.19p pd=1.38u as=0.19p ps=1.38u w=1u l=1u
X39 vout2 vin2 VDD VDD sg13_lv_pmos ad=1.14p pd=6.38u as=1.14p ps=6.38u w=6u l=1u
X40 VDD vin4 vout4 VDD sg13_lv_pmos ad=1.14p pd=6.38u as=1.14p ps=6.38u w=6u l=1u
X41 vout1 vin1 VSS.t21 VSS.t22 sg13_lv_nmos ad=0.19p pd=1.38u as=0.19p ps=1.38u w=1u l=1u
X42 vout3 vin3 VSS.t103 VSS.t83 sg13_lv_nmos ad=0.19p pd=1.38u as=0.19p ps=1.38u w=1u l=1u
X43 VDD vin3 vout3 VDD sg13_lv_pmos ad=1.14p pd=6.38u as=1.14p ps=6.38u w=6u l=1u
X44 vout4 vin4 VDD VDD sg13_lv_pmos ad=1.14p pd=6.38u as=1.14p ps=6.38u w=6u l=1u
X45 VDD vin4 vout4 VDD sg13_lv_pmos ad=1.14p pd=6.38u as=1.14p ps=6.38u w=6u l=1u
X46 vout3 vin3 VDD VDD sg13_lv_pmos ad=1.14p pd=6.38u as=1.14p ps=6.38u w=6u l=1u
X47 VDD vin3 vout3 VDD sg13_lv_pmos ad=1.14p pd=6.38u as=1.14p ps=6.38u w=6u l=1u
X48 VSS.t38 VSS.t35 VSS.t37 VSS.t36 sg13_lv_nmos ad=0.19p pd=1.38u as=0 ps=0 w=1u l=1u
X49 VDD vin4 vout4 VDD sg13_lv_pmos ad=1.14p pd=6.38u as=1.14p ps=6.38u w=6u l=1u
X50 VDD vin2 vout2 VDD sg13_lv_pmos ad=1.14p pd=6.38u as=1.14p ps=6.38u w=6u l=1u
X51 VSS.t131 vin4 vout4 VSS.t130 sg13_lv_nmos ad=0.19p pd=1.38u as=0.19p ps=1.38u w=1u l=1u
X52 VDD vin3 vout3 VDD sg13_lv_pmos ad=1.14p pd=6.38u as=1.14p ps=6.38u w=6u l=1u
X53 VSS.t12 vin1 vout1 VSS.t11 sg13_lv_nmos ad=0.19p pd=1.38u as=0.19p ps=1.38u w=1u l=1u
X54 VDD vin1 vout1 VDD sg13_lv_pmos ad=1.14p pd=6.38u as=1.14p ps=6.38u w=6u l=1u
X55 vout4 vin4 VSS.t134 VSS.t135 sg13_lv_nmos ad=0.19p pd=1.38u as=0.19p ps=1.38u w=1u l=1u
X56 vout1 vin1 VDD VDD sg13_lv_pmos ad=1.14p pd=6.38u as=1.14p ps=6.38u w=6u l=1u
X57 vout4 vin4 VDD VDD sg13_lv_pmos ad=1.14p pd=6.38u as=1.14p ps=6.38u w=6u l=1u
X58 vout1 vin1 VSS.t15 VSS.t16 sg13_lv_nmos ad=0.19p pd=1.38u as=0.19p ps=1.38u w=1u l=1u
X59 VDD vin1 vout1 VDD sg13_lv_pmos ad=1.14p pd=6.38u as=1.14p ps=6.38u w=6u l=1u
X60 vout3 vin3 VSS.t99 VSS.t77 sg13_lv_nmos ad=0.19p pd=1.38u as=0.19p ps=1.38u w=1u l=1u
X61 VSS.t21 vin1 vout1 VSS.t20 sg13_lv_nmos ad=0.19p pd=1.38u as=0.19p ps=1.38u w=1u l=1u
X62 VDD VDD VDD VDD sg13_lv_pmos ad=2.04p pd=12.68u as=0 ps=0 w=6u l=1u
X63 vout4 vin4 VDD VDD sg13_lv_pmos ad=1.14p pd=6.38u as=1.14p ps=6.38u w=6u l=1u
X64 VDD vin3 vout3 VDD sg13_lv_pmos ad=1.14p pd=6.38u as=1.14p ps=6.38u w=6u l=1u
X65 VDD vin4 vout4 VDD sg13_lv_pmos ad=1.14p pd=6.38u as=1.14p ps=6.38u w=6u l=1u
X66 vout3 vin3 VDD VDD sg13_lv_pmos ad=1.14p pd=6.38u as=1.14p ps=6.38u w=6u l=1u
X67 vout3 vin3 VSS.t95 VSS.t71 sg13_lv_nmos ad=0.19p pd=1.38u as=0.19p ps=1.38u w=1u l=1u
X68 VSS.t99 vin3 vout3 VSS.t75 sg13_lv_nmos ad=0.19p pd=1.38u as=0.19p ps=1.38u w=1u l=1u
X69 VDD VDD VDD VDD sg13_lv_pmos ad=1.14p pd=6.38u as=0 ps=0 w=6u l=1u
X70 vout3 vin3 VSS.t101 VSS.t80 sg13_lv_nmos ad=0.19p pd=1.38u as=0.19p ps=1.38u w=1u l=1u
X71 vout4 vin4 VDD VDD sg13_lv_pmos ad=1.14p pd=6.38u as=1.14p ps=6.38u w=6u l=1u
X72 vout3 vin3 VDD VDD sg13_lv_pmos ad=1.14p pd=6.38u as=1.14p ps=6.38u w=6u l=1u
X73 VDD vin1 vout1 VDD sg13_lv_pmos ad=1.14p pd=6.38u as=1.14p ps=6.38u w=6u l=1u
X74 vout2 vin2 VDD VDD sg13_lv_pmos ad=1.14p pd=6.38u as=1.14p ps=6.38u w=6u l=1u
X75 vout1 vin1 VDD VDD sg13_lv_pmos ad=1.14p pd=6.38u as=1.14p ps=6.38u w=6u l=1u
X76 vout2 vin2 VSS.t64 VSS.t65 sg13_lv_nmos ad=0.19p pd=1.38u as=0.19p ps=1.38u w=1u l=1u
X77 VDD vin1 vout1 VDD sg13_lv_pmos ad=1.14p pd=6.38u as=1.14p ps=6.38u w=6u l=1u
X78 VDD vin1 vout1 VDD sg13_lv_pmos ad=1.14p pd=6.38u as=1.14p ps=6.38u w=6u l=1u
X79 VDD vin3 vout3 VDD sg13_lv_pmos ad=1.14p pd=6.38u as=1.14p ps=6.38u w=6u l=1u
X80 VSS.t95 vin3 vout3 VSS.t69 sg13_lv_nmos ad=0.19p pd=1.38u as=0.19p ps=1.38u w=1u l=1u
X81 vout3 vin3 VSS.t97 VSS.t74 sg13_lv_nmos ad=0.19p pd=1.38u as=0.19p ps=1.38u w=1u l=1u
X82 VSS.t113 vin4 vout4 VSS.t112 sg13_lv_nmos ad=0.19p pd=1.38u as=0.19p ps=1.38u w=1u l=1u
X83 VDD vin4 vout4 VDD sg13_lv_pmos ad=1.14p pd=6.38u as=1.14p ps=6.38u w=6u l=1u
X84 VSS.t101 vin3 vout3 VSS.t78 sg13_lv_nmos ad=0.19p pd=1.38u as=0.19p ps=1.38u w=1u l=1u
X85 vout4 vin4 VSS.t116 VSS.t117 sg13_lv_nmos ad=0.19p pd=1.38u as=0.19p ps=1.38u w=1u l=1u
X86 VDD vin1 vout1 VDD sg13_lv_pmos ad=1.14p pd=6.38u as=1.14p ps=6.38u w=6u l=1u
X87 vout2 vin2 VDD VDD sg13_lv_pmos ad=1.14p pd=6.38u as=1.14p ps=6.38u w=6u l=1u
X88 vout1 vin1 VDD VDD sg13_lv_pmos ad=1.14p pd=6.38u as=1.14p ps=6.38u w=6u l=1u
X89 VSS.t110 vin4 vout4 VSS.t109 sg13_lv_nmos ad=0.19p pd=1.38u as=0.19p ps=1.38u w=1u l=1u
X90 VDD VDD VDD VDD sg13_lv_pmos ad=2.04p pd=12.68u as=0 ps=0 w=6u l=1u
X91 vout2 vin2 VDD VDD sg13_lv_pmos ad=1.14p pd=6.38u as=1.14p ps=6.38u w=6u l=1u
X92 VDD vin2 vout2 VDD sg13_lv_pmos ad=1.14p pd=6.38u as=1.14p ps=6.38u w=6u l=1u
X93 VSS.t64 vin2 vout2 VSS.t63 sg13_lv_nmos ad=0.19p pd=1.38u as=0.19p ps=1.38u w=1u l=1u
X94 VSS.t122 vin4 vout4 VSS.t121 sg13_lv_nmos ad=0.19p pd=1.38u as=0.19p ps=1.38u w=1u l=1u
X95 vout2 vin2 VDD VDD sg13_lv_pmos ad=1.14p pd=6.38u as=1.14p ps=6.38u w=6u l=1u
X96 VDD VDD VDD VDD sg13_lv_pmos ad=2.04p pd=12.68u as=0 ps=0 w=6u l=1u
X97 vout2 vin2 VSS.t67 VSS.t68 sg13_lv_nmos ad=0.19p pd=1.38u as=0.19p ps=1.38u w=1u l=1u
X98 VSS.t73 vin2 vout2 VSS.t72 sg13_lv_nmos ad=0.19p pd=1.38u as=0.19p ps=1.38u w=1u l=1u
X99 vout1 vin1 VDD VDD sg13_lv_pmos ad=1.14p pd=6.38u as=1.14p ps=6.38u w=6u l=1u
X100 vout1 vin1 VSS.t6 VSS.t7 sg13_lv_nmos ad=0.19p pd=1.38u as=0.19p ps=1.38u w=1u l=1u
X101 vout4 vin4 VSS.t119 VSS.t120 sg13_lv_nmos ad=0.19p pd=1.38u as=0.19p ps=1.38u w=1u l=1u
X102 vout3 vin3 VDD VDD sg13_lv_pmos ad=1.14p pd=6.38u as=1.14p ps=6.38u w=6u l=1u
X103 vout4 vin4 VSS.t131 VSS.t132 sg13_lv_nmos ad=0.19p pd=1.38u as=0.19p ps=1.38u w=1u l=1u
X104 VSS.t52 VSS.t50 VSS.t51 VSS.t44 sg13_lv_nmos ad=0.19p pd=1.38u as=0 ps=0 w=1u l=1u
X105 VSS.t125 vin4 vout4 VSS.t124 sg13_lv_nmos ad=0.19p pd=1.38u as=0.19p ps=1.38u w=1u l=1u
X106 VDD vin1 vout1 VDD sg13_lv_pmos ad=1.14p pd=6.38u as=1.14p ps=6.38u w=6u l=1u
X107 VSS.t51 vin2 vout2 VSS.t87 sg13_lv_nmos ad=0.19p pd=1.38u as=0.19p ps=1.38u w=1u l=1u
X108 VDD vin2 vout2 VDD sg13_lv_pmos ad=1.14p pd=6.38u as=1.14p ps=6.38u w=6u l=1u
X109 vout4 vin4 VSS.t128 VSS.t129 sg13_lv_nmos ad=0.19p pd=1.38u as=0.19p ps=1.38u w=1u l=1u
X110 vout4 vin4 VDD VDD sg13_lv_pmos ad=1.14p pd=6.38u as=1.14p ps=6.38u w=6u l=1u
X111 vout2 vin2 VDD VDD sg13_lv_pmos ad=1.14p pd=6.38u as=1.14p ps=6.38u w=6u l=1u
X112 vout2 vin2 VSS.t61 VSS.t62 sg13_lv_nmos ad=0.19p pd=1.38u as=0.19p ps=1.38u w=1u l=1u
X113 VDD vin2 vout2 VDD sg13_lv_pmos ad=1.14p pd=6.38u as=1.14p ps=6.38u w=6u l=1u
X114 VSS.t67 vin2 vout2 VSS.t66 sg13_lv_nmos ad=0.19p pd=1.38u as=0.19p ps=1.38u w=1u l=1u
X115 VDD vin4 vout4 VDD sg13_lv_pmos ad=1.14p pd=6.38u as=1.14p ps=6.38u w=6u l=1u
X116 VDD VDD VDD VDD sg13_lv_pmos ad=2.04p pd=12.68u as=0 ps=0 w=6u l=1u
X117 VSS.t61 vin2 vout2 VSS.t60 sg13_lv_nmos ad=0.19p pd=1.38u as=0.19p ps=1.38u w=1u l=1u
X118 VSS.t6 vin1 vout1 VSS.t5 sg13_lv_nmos ad=0.19p pd=1.38u as=0.19p ps=1.38u w=1u l=1u
X119 vout3 vin3 VDD VDD sg13_lv_pmos ad=1.14p pd=6.38u as=1.14p ps=6.38u w=6u l=1u
X120 vout1 vin1 VSS.t9 VSS.t10 sg13_lv_nmos ad=0.19p pd=1.38u as=0.19p ps=1.38u w=1u l=1u
X121 VSS.t15 vin1 vout1 VSS.t14 sg13_lv_nmos ad=0.19p pd=1.38u as=0.19p ps=1.38u w=1u l=1u
X122 vout3 vin3 VDD VDD sg13_lv_pmos ad=1.14p pd=6.38u as=1.14p ps=6.38u w=6u l=1u
X123 VDD vin3 vout3 VDD sg13_lv_pmos ad=1.14p pd=6.38u as=1.14p ps=6.38u w=6u l=1u
X124 vout3 vin3 VDD VDD sg13_lv_pmos ad=1.14p pd=6.38u as=1.14p ps=6.38u w=6u l=1u
X125 vout3 vin3 VSS.t91 VSS.t65 sg13_lv_nmos ad=0.19p pd=1.38u as=0.19p ps=1.38u w=1u l=1u
X126 VSS.t82 vin2 vout2 VSS.t81 sg13_lv_nmos ad=0.19p pd=1.38u as=0.19p ps=1.38u w=1u l=1u
X127 vout1 vin1 VDD VDD sg13_lv_pmos ad=1.14p pd=6.38u as=1.14p ps=6.38u w=6u l=1u
X128 vout2 vin2 VSS.t85 VSS.t86 sg13_lv_nmos ad=0.19p pd=1.38u as=0.19p ps=1.38u w=1u l=1u
X129 VSS.t37 vin4 vout4 VSS.t136 sg13_lv_nmos ad=0.19p pd=1.38u as=0.19p ps=1.38u w=1u l=1u
X130 VSS.t58 VSS.t56 VSS.t30 VSS.t57 sg13_lv_nmos ad=0.19p pd=1.38u as=0 ps=0 w=1u l=1u
X131 VSS.t30 vin1 vout1 VSS.t29 sg13_lv_nmos ad=0.19p pd=1.38u as=0.19p ps=1.38u w=1u l=1u
X132 vout2 vin2 VSS.t49 VSS.t59 sg13_lv_nmos ad=0.19p pd=1.38u as=0.19p ps=1.38u w=1u l=1u
X133 VSS.t34 VSS.t31 VSS.t33 VSS.t32 sg13_lv_nmos ad=0.34p pd=2.68u as=0 ps=0 w=1u l=1u
X134 vout1 vin1 VSS.t3 VSS.t4 sg13_lv_nmos ad=0.19p pd=1.38u as=0.19p ps=1.38u w=1u l=1u
X135 VSS.t9 vin1 vout1 VSS.t8 sg13_lv_nmos ad=0.19p pd=1.38u as=0.19p ps=1.38u w=1u l=1u
X136 VDD vin3 vout3 VDD sg13_lv_pmos ad=1.14p pd=6.38u as=1.14p ps=6.38u w=6u l=1u
X137 VSS.t3 vin1 vout1 VSS.t2 sg13_lv_nmos ad=0.19p pd=1.38u as=0.19p ps=1.38u w=1u l=1u
X138 vout4 vin4 VDD VDD sg13_lv_pmos ad=1.14p pd=6.38u as=1.14p ps=6.38u w=6u l=1u
X139 vout3 vin3 VDD VDD sg13_lv_pmos ad=1.14p pd=6.38u as=1.14p ps=6.38u w=6u l=1u
X140 VDD vin3 vout3 VDD sg13_lv_pmos ad=1.14p pd=6.38u as=1.14p ps=6.38u w=6u l=1u
X141 VSS.t91 vin3 vout3 VSS.t63 sg13_lv_nmos ad=0.19p pd=1.38u as=0.19p ps=1.38u w=1u l=1u
X142 vout3 vin3 VSS.t93 VSS.t68 sg13_lv_nmos ad=0.19p pd=1.38u as=0.19p ps=1.38u w=1u l=1u
X143 vout1 vin1 VDD VDD sg13_lv_pmos ad=1.14p pd=6.38u as=1.14p ps=6.38u w=6u l=1u
X144 VSS.t85 vin2 vout2 VSS.t84 sg13_lv_nmos ad=0.19p pd=1.38u as=0.19p ps=1.38u w=1u l=1u
X145 VSS.t97 vin3 vout3 VSS.t72 sg13_lv_nmos ad=0.19p pd=1.38u as=0.19p ps=1.38u w=1u l=1u
X146 VDD vin4 vout4 VDD sg13_lv_pmos ad=1.14p pd=6.38u as=1.14p ps=6.38u w=6u l=1u
X147 vout1 vin1 VDD VDD sg13_lv_pmos ad=1.14p pd=6.38u as=1.14p ps=6.38u w=6u l=1u
X148 VDD vin1 vout1 VDD sg13_lv_pmos ad=1.14p pd=6.38u as=1.14p ps=6.38u w=6u l=1u
X149 vout4 vin4 VDD VDD sg13_lv_pmos ad=1.14p pd=6.38u as=1.14p ps=6.38u w=6u l=1u
X150 VSS.t24 vin1 vout1 VSS.t23 sg13_lv_nmos ad=0.19p pd=1.38u as=0.19p ps=1.38u w=1u l=1u
X151 vout1 vin1 VSS.t27 VSS.t28 sg13_lv_nmos ad=0.19p pd=1.38u as=0.19p ps=1.38u w=1u l=1u
X152 vout1 vin1 VDD VDD sg13_lv_pmos ad=1.14p pd=6.38u as=1.14p ps=6.38u w=6u l=1u
X153 vout2 vin2 VDD VDD sg13_lv_pmos ad=1.14p pd=6.38u as=1.14p ps=6.38u w=6u l=1u
X154 vout4 vin4 VSS.t113 VSS.t114 sg13_lv_nmos ad=0.19p pd=1.38u as=0.19p ps=1.38u w=1u l=1u
X155 VSS.t49 VSS.t47 VSS.t48 VSS.t40 sg13_lv_nmos ad=0.34p pd=2.68u as=0 ps=0 w=1u l=1u
X156 VSS.t46 VSS.t43 VSS.t45 VSS.t44 sg13_lv_nmos ad=0.19p pd=1.38u as=0 ps=0 w=1u l=1u
X157 vout4 vin4 VDD VDD sg13_lv_pmos ad=1.14p pd=6.38u as=1.14p ps=6.38u w=6u l=1u
X158 VSS.t45 vin3 vout3 VSS.t87 sg13_lv_nmos ad=0.19p pd=1.38u as=0.19p ps=1.38u w=1u l=1u
X159 VSS.t134 vin4 vout4 VSS.t133 sg13_lv_nmos ad=0.19p pd=1.38u as=0.19p ps=1.38u w=1u l=1u
X160 VDD vin4 vout4 VDD sg13_lv_pmos ad=1.14p pd=6.38u as=1.14p ps=6.38u w=6u l=1u
X161 vout1 vin1 VSS.t1 VSS.t0 sg13_lv_nmos ad=0.19p pd=1.38u as=0.19p ps=1.38u w=1u l=1u
X162 vout3 vin3 VSS.t89 VSS.t62 sg13_lv_nmos ad=0.19p pd=1.38u as=0.19p ps=1.38u w=1u l=1u
X163 VSS.t93 vin3 vout3 VSS.t66 sg13_lv_nmos ad=0.19p pd=1.38u as=0.19p ps=1.38u w=1u l=1u
X164 vout4 vin4 VDD VDD sg13_lv_pmos ad=1.14p pd=6.38u as=1.14p ps=6.38u w=6u l=1u
X165 vout2 vin2 VSS.t82 VSS.t83 sg13_lv_nmos ad=0.19p pd=1.38u as=0.19p ps=1.38u w=1u l=1u
X166 VSS.t89 vin3 vout3 VSS.t60 sg13_lv_nmos ad=0.19p pd=1.38u as=0.19p ps=1.38u w=1u l=1u
X167 VDD vin1 vout1 VDD sg13_lv_pmos ad=1.14p pd=6.38u as=1.14p ps=6.38u w=6u l=1u
X168 vout1 vin1 VDD VDD sg13_lv_pmos ad=1.14p pd=6.38u as=1.14p ps=6.38u w=6u l=1u
X169 VDD vin1 vout1 VDD sg13_lv_pmos ad=1.14p pd=6.38u as=1.14p ps=6.38u w=6u l=1u
X170 VDD vin4 vout4 VDD sg13_lv_pmos ad=1.14p pd=6.38u as=1.14p ps=6.38u w=6u l=1u
X171 VSS.t27 vin1 vout1 VSS.t26 sg13_lv_nmos ad=0.19p pd=1.38u as=0.19p ps=1.38u w=1u l=1u
X172 VDD vin2 vout2 VDD sg13_lv_pmos ad=1.14p pd=6.38u as=1.14p ps=6.38u w=6u l=1u
X173 vout2 vin2 VDD VDD sg13_lv_pmos ad=1.14p pd=6.38u as=1.14p ps=6.38u w=6u l=1u
X174 VDD vin2 vout2 VDD sg13_lv_pmos ad=1.14p pd=6.38u as=1.14p ps=6.38u w=6u l=1u
X175 VSS.t103 vin3 vout3 VSS.t81 sg13_lv_nmos ad=0.19p pd=1.38u as=0.19p ps=1.38u w=1u l=1u
C0 vin1 VDD 29.2329f
C1 vout1 vin1 18.2968f
C2 vin2 vin3 0.05785f
C3 vin2 VDD 29.202f
C4 vin3 vin4 0.05053f
C5 vin4 VDD 29.2329f
C6 vin3 VDD 29.202f
C7 vout1 VDD 15.3949f
C8 vout4 vin4 18.2968f
C9 vout4 VDD 15.3949f
C10 vin2 vout2 18.2968f
C11 vout3 vin3 18.2968f
C12 vout3 VDD 15.3834f
C13 vin2 vin1 0.05053f
C14 VDD vout2 15.3834f
R0 VSS.n5 VSS.n119 6777.49
R1 VSS.n82 VSS.n331 1580.41
R2 VSS.n267 VSS.n119 1580.41
R3 VSS.t59 VSS.n242 88.7251
R4 VSS.n142 VSS.t87 88.7251
R5 VSS.t60 VSS.n238 83.1798
R6 VSS.n181 VSS.t86 83.1798
R7 VSS.t62 VSS.n167 77.6345
R8 VSS.t84 VSS.n144 77.6345
R9 VSS.t32 VSS.n5 6.87896
R10 VSS.t36 VSS.n5 6.87897
R11 VSS.t63 VSS.n165 72.0892
R12 VSS.n187 VSS.t83 72.0892
R13 VSS.n5 VSS.t135 12.2976
R14 VSS.t65 VSS.n163 66.5439
R15 VSS.n189 VSS.t81 66.5439
R16 VSS.n5 VSS.t109 12.3005
R17 VSS.t66 VSS.n161 60.9987
R18 VSS.t80 VSS.n146 60.9987
R19 VSS.t133 VSS.n5 14.4648
R20 VSS.t132 VSS.n5 16.2707
R21 VSS.t28 VSS.n106 64.5222
R22 VSS.t68 VSS.n159 55.4534
R23 VSS.n154 VSS.t72 55.4534
R24 VSS.t74 VSS.n151 55.4534
R25 VSS.n148 VSS.t78 55.4534
R26 VSS.n5 VSS.t129 18.799
R27 VSS.t26 VSS.n93 60.7271
R28 VSS.t69 VSS.n157 49.9081
R29 VSS.n156 VSS.t71 49.9081
R30 VSS.n202 VSS.t75 49.9081
R31 VSS.n198 VSS.t77 49.9081
R32 VSS.n5 VSS.t127 19.5212
R33 VSS.t25 VSS.n102 56.932
R34 VSS.n5 VSS.t126 19.8823
R35 VSS.t121 VSS.n5 19.5038
R36 VSS.n5 VSS.t117 19.5219
R37 VSS.t23 VSS.n89 53.137
R38 VSS.n158 VSS.t69 44.3628
R39 VSS.t71 VSS.n155 44.3628
R40 VSS.t75 VSS.n150 44.3628
R41 VSS.t77 VSS.n149 44.3628
R42 VSS.t120 VSS.n5 19.8818
R43 VSS.n5 VSS.t118 19.8825
R44 VSS.t22 VSS.n86 49.3419
R45 VSS.n160 VSS.t68 38.8175
R46 VSS.t72 VSS.n153 38.8175
R47 VSS.n152 VSS.t74 38.8175
R48 VSS.t78 VSS.n147 38.8175
R49 VSS.t124 VSS.n5 19.882
R50 VSS.t20 VSS.n99 45.5468
R51 VSS.t123 VSS.n5 19.5596
R52 VSS.t13 VSS.n104 41.7518
R53 VSS.t19 VSS.n107 41.7518
R54 VSS.n162 VSS.t66 33.2722
R55 VSS.n190 VSS.t80 33.2722
R56 VSS.t115 VSS.n5 18.8
R57 VSS.t11 VSS.n94 37.9567
R58 VSS.t17 VSS.n105 37.9567
R59 VSS.n164 VSS.t65 27.7269
R60 VSS.t81 VSS.n188 27.7269
R61 VSS.t114 VSS.n5 17.717
R62 VSS.t10 VSS.n88 34.1616
R63 VSS.n103 VSS.n82 6777.49
R64 VSS.t112 VSS.n5 16.2727
R65 VSS.t8 VSS.n101 30.3673
R66 VSS.n98 VSS.t54 13.7582
R67 VSS.n101 VSS.t7 53.1364
R68 VSS.t57 VSS.n85 13.7572
R69 VSS.n95 VSS.t57 13.76
R70 VSS.n166 VSS.t63 22.1816
R71 VSS.t83 VSS.n145 22.1816
R72 VSS.t111 VSS.n5 14.4672
R73 VSS.t7 VSS.n90 26.5715
R74 VSS.t29 VSS.n85 11.4002
R75 VSS.t28 VSS.n100 15.1866
R76 VSS.n106 VSS.n84 0.0109013
R77 VSS.t26 VSS.n106 18.9817
R78 VSS.t23 VSS.n102 26.5718
R79 VSS.n89 VSS.n84 0.0108886
R80 VSS.t20 VSS.n86 34.162
R81 VSS.n99 VSS.n84 0.0109013
R82 VSS.t19 VSS.n99 37.957
R83 VSS.n107 VSS.n84 0.0109013
R84 VSS.t17 VSS.n107 41.7521
R85 VSS.n105 VSS.n84 0.0109013
R86 VSS.t16 VSS.n105 45.5472
R87 VSS.t14 VSS.n91 34.1651
R88 VSS.t13 VSS.n87 37.957
R89 VSS.n104 VSS.n84 0.0109013
R90 VSS.t11 VSS.n104 41.7521
R91 VSS.n94 VSS.n84 0.0108886
R92 VSS.t8 VSS.n88 49.3422
R93 VSS.n101 VSS.n84 0.0111485
R94 VSS.n90 VSS.n84 0.0109013
R95 VSS.t5 VSS.n90 56.9324
R96 VSS.t2 VSS.n96 64.5225
R97 VSS.t0 VSS.n97 68.3176
R98 VSS.n84 VSS.n129 17.0005
R99 VSS.n133 VSS.n84 17.0005
R100 VSS.n84 VSS.n118 17.0005
R101 VSS.t58 VSS.n132 17.0005
R102 VSS.n139 VSS.t58 17.0005
R103 VSS.n138 VSS.t30 17.0005
R104 VSS.n139 VSS.t30 17.0005
R105 VSS.t58 VSS.n138 17.0005
R106 VSS.n132 VSS.t30 17.0005
R107 VSS.n84 VSS.n130 17.0005
R108 VSS.n84 VSS.n131 17.0005
R109 VSS.n84 VSS.n121 17.0005
R110 VSS.n141 VSS.t1 17.0005
R111 VSS.t1 VSS.n140 17.0005
R112 VSS.t1 VSS.n128 17.0005
R113 VSS.n140 VSS.t55 17.0005
R114 VSS.t55 VSS.n128 17.0005
R115 VSS.n141 VSS.t55 17.0005
R116 VSS.n8 VSS.n7 1.97372
R117 VSS.n142 VSS.n7 8.49359
R118 VSS.n176 VSS.n7 17.0005
R119 VSS.n10 VSS.n61 14.4044
R120 VSS.n143 VSS.n7 8.49383
R121 VSS.n70 VSS.n7 0.650675
R122 VSS.n11 VSS.n70 14.4044
R123 VSS.n117 VSS.n7 17.0005
R124 VSS.n56 VSS.n7 0.650675
R125 VSS.n182 VSS.n56 7.20256
R126 VSS.n144 VSS.n7 8.49407
R127 VSS.n68 VSS.n7 0.650675
R128 VSS.n13 VSS.n68 14.4044
R129 VSS.n145 VSS.n7 8.49432
R130 VSS.n187 VSS.n69 7.20256
R131 VSS.n69 VSS.n7 0.650675
R132 VSS.n57 VSS.n7 0.650675
R133 VSS.n48 VSS.n7 2.4234
R134 VSS.n188 VSS.n57 7.20256
R135 VSS.n72 VSS.n7 0.650675
R136 VSS.n62 VSS.n7 0.650675
R137 VSS.n190 VSS.n62 7.20256
R138 VSS.n146 VSS.n7 8.49456
R139 VSS.n55 VSS.n7 0.650675
R140 VSS.n262 VSS.n7 17.0005
R141 VSS.n17 VSS.n55 14.4044
R142 VSS.n263 VSS.n7 17.0005
R143 VSS.n147 VSS.n7 8.49481
R144 VSS.n148 VSS.n7 8.49505
R145 VSS.n58 VSS.n7 0.650675
R146 VSS.n19 VSS.n58 14.4044
R147 VSS.n149 VSS.n7 8.4953
R148 VSS.n198 VSS.n60 7.20256
R149 VSS.n260 VSS.n7 17.0005
R150 VSS.n51 VSS.n7 0.650675
R151 VSS.n202 VSS.n51 7.20256
R152 VSS.n150 VSS.n7 8.49555
R153 VSS.n22 VSS.n63 14.4044
R154 VSS.n151 VSS.n7 8.49579
R155 VSS.n152 VSS.n7 8.49604
R156 VSS.n24 VSS.n65 14.6203
R157 VSS.n111 VSS.n7 17.0005
R158 VSS.n153 VSS.n7 8.49629
R159 VSS.n154 VSS.n7 8.49653
R160 VSS.n76 VSS.n7 0.650675
R161 VSS.n26 VSS.n76 14.4044
R162 VSS.n155 VSS.n7 8.49678
R163 VSS.n156 VSS.n7 8.49703
R164 VSS.n64 VSS.n7 0.650675
R165 VSS.n258 VSS.n7 17.0005
R166 VSS.n28 VSS.n64 14.4044
R167 VSS.n157 VSS.n7 8.49728
R168 VSS.n158 VSS.n7 8.49752
R169 VSS.n30 VSS.n53 14.4044
R170 VSS.n222 VSS.n7 17.0005
R171 VSS.n159 VSS.n7 8.49777
R172 VSS.n160 VSS.n7 8.49802
R173 VSS.n255 VSS.n7 17.0005
R174 VSS.n52 VSS.n7 0.650675
R175 VSS.n256 VSS.n7 17.0005
R176 VSS.n161 VSS.n7 8.49827
R177 VSS.n227 VSS.n7 17.0005
R178 VSS.n162 VSS.n7 8.49852
R179 VSS.n75 VSS.n7 0.650675
R180 VSS.n34 VSS.n75 14.4044
R181 VSS.n231 VSS.n7 17.0005
R182 VSS.n163 VSS.n7 8.49877
R183 VSS.n164 VSS.n7 8.49902
R184 VSS.n35 VSS.n66 14.4044
R185 VSS.n66 VSS.n7 0.650675
R186 VSS.n81 VSS.n78 0.00714631
R187 VSS.n165 VSS.n7 8.49927
R188 VSS.n78 VSS.n77 0.0125236
R189 VSS.n166 VSS.n7 8.49927
R190 VSS.n54 VSS.n7 0.650675
R191 VSS.n38 VSS.n54 14.4044
R192 VSS.n167 VSS.n7 8.49952
R193 VSS.n236 VSS.n74 7.20256
R194 VSS.n114 VSS.n7 17.0005
R195 VSS.n238 VSS.n73 7.20256
R196 VSS.n67 VSS.n7 0.650675
R197 VSS.n40 VSS.n67 14.4044
R198 VSS.n242 VSS.n50 7.20256
R199 VSS.n247 VSS.n71 7.20256
R200 VSS.n71 VSS.n7 0.650675
R201 VSS.n59 VSS.n7 0.650675
R202 VSS.n42 VSS.n59 14.4044
R203 VSS.n45 VSS.n7 0.166532
R204 VSS.n253 VSS.n7 17.0005
R205 VSS.n7 VSS.n44 1.79001
R206 VSS.n43 VSS.n169 17.0005
R207 VSS.n43 VSS.n177 17.0005
R208 VSS.n43 VSS.n115 17.0005
R209 VSS.n43 VSS.n201 17.0005
R210 VSS.n43 VSS.n110 17.0005
R211 VSS.n43 VSS.n217 17.0005
R212 VSS.n43 VSS.n223 17.0005
R213 VSS.n43 VSS.n228 17.0005
R214 VSS.n43 VSS.n232 17.0005
R215 VSS.n43 VSS.n78 17.0005
R216 VSS.n43 VSS.n112 17.0005
R217 VSS.n5 VSS.n309 17.0005
R218 VSS.n5 VSS.n298 17.0005
R219 VSS.n5 VSS.n83 1.31087
R220 VSS.n5 VSS.n0 0.533917
R221 VSS.n1 VSS.t38 5.65588
R222 VSS.n0 VSS.n2 0.010528
R223 VSS.n1 VSS.n0 0.0128169
R224 VSS.n2 VSS.t37 8.49624
R225 VSS.t35 VSS.n2 0.010528
R226 VSS.n308 VSS.t34 17.0005
R227 VSS.t34 VSS.n299 17.0005
R228 VSS.t34 VSS.n307 17.0005
R229 VSS.n299 VSS.t33 17.0005
R230 VSS.n307 VSS.t33 17.0005
R231 VSS.n308 VSS.t33 17.0005
R232 VSS.n236 VSS.t62 16.6364
R233 VSS.n182 VSS.t84 16.6364
R234 VSS.t5 VSS.n92 22.7758
R235 VSS.n327 VSS.t47 15.0005
R236 VSS.n322 VSS.t39 15.0005
R237 VSS.t43 VSS.n270 15.0005
R238 VSS.t50 VSS.n273 15.0005
R239 VSS.n23 VSS.n65 14.6209
R240 VSS.n9 VSS.n61 14.4051
R241 VSS.n189 VSS.n72 7.20324
R242 VSS.n29 VSS.n53 14.4051
R243 VSS.n45 VSS.n43 3.99279
R244 VSS.t40 VSS.n45 7.66801
R245 VSS.n41 VSS.n71 14.4051
R246 VSS.n241 VSS.n67 7.20324
R247 VSS.n39 VSS.n74 14.4051
R248 VSS.n36 VSS.n66 14.4051
R249 VSS.n32 VSS.n52 14.4051
R250 VSS.n20 VSS.n60 14.4051
R251 VSS.n15 VSS.n72 14.4044
R252 VSS.n14 VSS.n69 14.4051
R253 VSS.n181 VSS.n70 7.20324
R254 VSS.t108 VSS.n5 9.77299
R255 VSS.t29 VSS.n100 68.3172
R256 VSS.t16 VSS.n91 34.1648
R257 VSS.t14 VSS.n87 45.5468
R258 VSS.t4 VSS.n96 18.9814
R259 VSS.t54 VSS.n103 13.759
R260 VSS.n92 VSS.t4 60.7278
R261 VSS.n94 VSS.t10 45.5478
R262 VSS.n89 VSS.t22 30.3676
R263 VSS.n93 VSS.t25 22.7774
R264 VSS.n241 VSS.t60 11.0911
R265 VSS.t86 VSS.n143 11.0911
R266 VSS.n95 VSS.n119 6777.49
R267 VSS.n331 VSS.n7 1.70002
R268 VSS.n43 VSS.n44 1.52564
R269 VSS.n43 VSS.n181 8.5005
R270 VSS.n43 VSS.n182 8.5005
R271 VSS.n43 VSS.n187 8.5005
R272 VSS.n43 VSS.n188 8.5005
R273 VSS.n43 VSS.n189 8.5005
R274 VSS.n43 VSS.n190 8.5005
R275 VSS.n43 VSS.n198 8.5005
R276 VSS.n43 VSS.n202 8.5005
R277 VSS.n43 VSS.n236 8.5005
R278 VSS.n43 VSS.n238 8.5005
R279 VSS.n43 VSS.n241 8.5005
R280 VSS.n43 VSS.n242 8.5005
R281 VSS.n43 VSS.n247 8.5005
R282 VSS.n170 VSS.n7 8.4984
R283 VSS.n172 VSS.n7 8.4984
R284 VSS.n174 VSS.n7 8.4984
R285 VSS.n178 VSS.n7 8.4984
R286 VSS.n180 VSS.n7 8.4984
R287 VSS.n183 VSS.n7 8.4984
R288 VSS.n185 VSS.n7 8.4984
R289 VSS.n186 VSS.n48 0.0262321
R290 VSS.n46 VSS.n7 8.4984
R291 VSS.n191 VSS.n7 8.4984
R292 VSS.n194 VSS.n7 8.4984
R293 VSS.n196 VSS.n7 8.4984
R294 VSS.n199 VSS.n7 8.4984
R295 VSS.n203 VSS.n7 8.4984
R296 VSS.n205 VSS.n7 8.4984
R297 VSS.n207 VSS.n7 8.4984
R298 VSS.n209 VSS.n7 8.4984
R299 VSS.n211 VSS.n7 8.4984
R300 VSS.n213 VSS.n7 8.4984
R301 VSS.n215 VSS.n7 8.4984
R302 VSS.n218 VSS.n7 8.4984
R303 VSS.n220 VSS.n7 8.4984
R304 VSS.n224 VSS.n7 8.4984
R305 VSS.n229 VSS.n7 8.4984
R306 VSS.n79 VSS.n7 8.4984
R307 VSS.n77 VSS.n7 3.39223
R308 VSS.n234 VSS.n7 8.4984
R309 VSS.n237 VSS.n7 8.4984
R310 VSS.n239 VSS.n7 8.4984
R311 VSS.n243 VSS.n7 8.4984
R312 VSS.n245 VSS.n7 8.4984
R313 VSS.n248 VSS.n7 8.4984
R314 VSS.n250 VSS.n7 8.4984
R315 VSS.n43 VSS.n171 8.4984
R316 VSS.n43 VSS.n173 8.4984
R317 VSS.n43 VSS.n175 8.4984
R318 VSS.n43 VSS.n179 8.4984
R319 VSS.n43 VSS.n116 8.4984
R320 VSS.n43 VSS.n184 8.4984
R321 VSS.n43 VSS.n186 8.4984
R322 VSS.n46 VSS.n49 0.0157515
R323 VSS.n47 VSS.n46 0.014251
R324 VSS.n43 VSS.n47 1.87241
R325 VSS.n43 VSS.n192 8.4984
R326 VSS.n43 VSS.n193 8.4984
R327 VSS.n43 VSS.n195 8.4984
R328 VSS.n43 VSS.n197 8.4984
R329 VSS.n43 VSS.n200 8.4984
R330 VSS.n43 VSS.n204 8.4984
R331 VSS.n43 VSS.n206 8.4984
R332 VSS.n43 VSS.n208 8.4984
R333 VSS.n43 VSS.n210 8.4984
R334 VSS.n43 VSS.n212 8.4984
R335 VSS.n43 VSS.n214 8.4984
R336 VSS.n43 VSS.n216 8.4984
R337 VSS.n43 VSS.n219 8.4984
R338 VSS.n43 VSS.n221 8.4984
R339 VSS.n43 VSS.n225 8.4984
R340 VSS.n43 VSS.n226 8.4984
R341 VSS.n43 VSS.n230 8.4984
R342 VSS.n43 VSS.n80 4.24745
R343 VSS.n43 VSS.n233 8.4984
R344 VSS.n43 VSS.n235 8.4984
R345 VSS.n43 VSS.n113 8.4984
R346 VSS.n43 VSS.n240 8.4984
R347 VSS.n43 VSS.n244 8.4984
R348 VSS.n43 VSS.n246 8.4984
R349 VSS.n43 VSS.n249 8.4984
R350 VSS.n43 VSS.n251 8.4984
R351 VSS.n108 VSS.n84 0.910042
R352 VSS.n109 VSS.n84 0.00903635
R353 VSS.n352 VSS.n122 8.22525
R354 VSS.n312 VSS.n311 8.22525
R355 VSS.n311 VSS.n283 8.22525
R356 VSS.n353 VSS.n352 8.22525
R357 VSS.t2 VSS.n97 15.1863
R358 VSS.n329 VSS.t47 7.49606
R359 VSS.t39 VSS.n321 7.49606
R360 VSS.n271 VSS.t43 7.49606
R361 VSS.n274 VSS.t50 7.49606
R362 VSS.n44 VSS.t44 2.92833
R363 VSS.n12 VSS.n68 14.4051
R364 VSS.n16 VSS.n146 7.20236
R365 VSS.n18 VSS.n148 7.20236
R366 VSS.n21 VSS.n150 7.20236
R367 VSS.n25 VSS.n154 7.20236
R368 VSS.n27 VSS.n156 7.20236
R369 VSS.n31 VSS.n160 7.20236
R370 VSS.n33 VSS.n75 14.4051
R371 VSS.n34 VSS.n163 7.20236
R372 VSS.n36 VSS.n165 7.20236
R373 VSS.n37 VSS.n166 7.20236
R374 VSS.n42 VSS.t40 7.20236
R375 VSS.n41 VSS.n59 14.4051
R376 VSS.n40 VSS.n50 14.4051
R377 VSS.n39 VSS.n73 14.4051
R378 VSS.n38 VSS.n167 7.20236
R379 VSS.n37 VSS.n54 14.4051
R380 VSS.n35 VSS.n164 7.20236
R381 VSS.n33 VSS.n162 7.20236
R382 VSS.n32 VSS.n161 7.20236
R383 VSS.n31 VSS.n52 14.4044
R384 VSS.n30 VSS.n159 7.20236
R385 VSS.n29 VSS.n158 7.20236
R386 VSS.n28 VSS.n157 7.20236
R387 VSS.n27 VSS.n64 14.4051
R388 VSS.n26 VSS.n155 7.20236
R389 VSS.n25 VSS.n76 14.4051
R390 VSS.n24 VSS.n153 7.20236
R391 VSS.n23 VSS.n152 7.20236
R392 VSS.n22 VSS.n151 7.20236
R393 VSS.n21 VSS.n63 14.4051
R394 VSS.n20 VSS.n51 14.4051
R395 VSS.n19 VSS.n149 7.20236
R396 VSS.n18 VSS.n58 14.4051
R397 VSS.n17 VSS.n147 7.20236
R398 VSS.n16 VSS.n55 14.4051
R399 VSS.n15 VSS.n62 14.4051
R400 VSS.n14 VSS.n57 14.4051
R401 VSS.n13 VSS.n145 7.20236
R402 VSS.n12 VSS.n144 7.20236
R403 VSS.n11 VSS.n56 14.4051
R404 VSS.n10 VSS.n143 7.20236
R405 VSS.n9 VSS.n142 7.20236
R406 VSS.n8 VSS.t87 8.74527
R407 VSS.n43 VSS.n8 2.40474
R408 VSS.n247 VSS.t59 5.54579
R409 VSS.n330 VSS.t49 4.5005
R410 VSS.t42 VSS.n320 4.5005
R411 VSS.t51 VSS.n266 4.5005
R412 VSS.t45 VSS.n269 4.5005
R413 VSS.n43 VSS.n252 4.25219
R414 VSS.n168 VSS.n7 4.25206
R415 VSS.n43 VSS.n168 4.25175
R416 VSS.n252 VSS.n7 4.25169
R417 VSS.n267 VSS.n7 1.69992
R418 VSS.n314 VSS.n313 4.11287
R419 VSS.n314 VSS.n123 4.11287
R420 VSS.t0 VSS.n98 11.3996
R421 VSS.n137 VSS.t56 3.0005
R422 VSS.n348 VSS.t53 3.0005
R423 VSS.n306 VSS.t31 3.0005
R424 VSS.n328 VSS.n326 3.0005
R425 VSS.n324 VSS.n323 3.0005
R426 VSS.n276 VSS.n275 3.0005
R427 VSS.n268 VSS.n265 3.0005
R428 VSS.n92 VSS.n84 0.0111485
R429 VSS.n95 VSS.n84 0.00104906
R430 VSS.n85 VSS.n84 0.00293611
R431 VSS.n100 VSS.n84 0.0109013
R432 VSS.n93 VSS.n84 0.0108886
R433 VSS.n102 VSS.n84 0.0109013
R434 VSS.n86 VSS.n84 0.0109013
R435 VSS.n91 VSS.n84 0.0093246
R436 VSS.n87 VSS.n84 0.0109013
R437 VSS.n88 VSS.n84 0.0109013
R438 VSS.n96 VSS.n84 0.0109013
R439 VSS.n97 VSS.n84 0.0109013
R440 VSS.n98 VSS.n84 0.00289146
R441 VSS.n103 VSS.n84 0.00109675
R442 VSS.n283 VSS.n282 2.71193
R443 VSS.n355 VSS.n354 2.6297
R444 VSS.n349 VSS.t3 2.4821
R445 VSS.n350 VSS.t6 2.4821
R446 VSS.n351 VSS.t9 2.4821
R447 VSS.n127 VSS.t12 2.4821
R448 VSS.t18 VSS.n126 2.4821
R449 VSS.n134 VSS.t21 2.4821
R450 VSS.n135 VSS.t24 2.4821
R451 VSS.n136 VSS.t27 2.4821
R452 VSS.n3 VSS.t134 2.4821
R453 VSS.n297 VSS.t131 2.4821
R454 VSS.n296 VSS.t128 2.4821
R455 VSS.t125 VSS.n284 2.4821
R456 VSS.t119 VSS.n285 2.4821
R457 VSS.n303 VSS.t116 2.4821
R458 VSS.n304 VSS.t113 2.4821
R459 VSS.n305 VSS.t110 2.4821
R460 VSS.n319 VSS.t89 2.4821
R461 VSS.n319 VSS.t61 2.4821
R462 VSS.n318 VSS.t91 2.4821
R463 VSS.n318 VSS.t64 2.4821
R464 VSS.n317 VSS.t93 2.4821
R465 VSS.n317 VSS.t67 2.4821
R466 VSS.n316 VSS.t95 2.4821
R467 VSS.n316 VSS.t70 2.4821
R468 VSS.n281 VSS.t99 2.4821
R469 VSS.n281 VSS.t76 2.4821
R470 VSS.n280 VSS.t101 2.4821
R471 VSS.n280 VSS.t79 2.4821
R472 VSS.n279 VSS.t103 2.4821
R473 VSS.n279 VSS.t82 2.4821
R474 VSS.n278 VSS.t105 2.4821
R475 VSS.n278 VSS.t85 2.4821
R476 VSS.n7 VSS.n61 0.650675
R477 VSS.n7 VSS.n60 0.650675
R478 VSS.n7 VSS.n63 0.650675
R479 VSS.n7 VSS.n53 0.650675
R480 VSS.n7 VSS.n74 0.650675
R481 VSS.n7 VSS.n73 0.650675
R482 VSS.n7 VSS.n50 0.650675
R483 VSS.t48 VSS.n330 2.2505
R484 VSS.n320 VSS.t41 2.2505
R485 VSS.n266 VSS.t52 2.2505
R486 VSS.n269 VSS.t46 2.2505
R487 VSS.n333 VSS.n84 2.09947
R488 VSS.n335 VSS.n84 2.09947
R489 VSS.n337 VSS.n84 2.09947
R490 VSS.n124 VSS.n84 2.09947
R491 VSS.n339 VSS.n84 2.09947
R492 VSS.n341 VSS.n84 2.09947
R493 VSS.n343 VSS.n84 2.09947
R494 VSS.n345 VSS.n84 2.09947
R495 VSS.n5 VSS.n293 2.09887
R496 VSS.n5 VSS.n292 2.0988
R497 VSS.n5 VSS.n290 2.09874
R498 VSS.n5 VSS.n120 2.09868
R499 VSS.n5 VSS.n6 0.133294
R500 VSS.n310 VSS.n5 2.09849
R501 VSS.n5 VSS.n288 2.09849
R502 VSS.n5 VSS.n289 2.09849
R503 VSS.n7 VSS.n65 0.542754
R504 VSS.n109 VSS.n139 1.37881
R505 VSS.n267 VSS.n43 1.53502
R506 VSS.n331 VSS.n43 1.53502
R507 VSS.n348 VSS.n128 1.52811
R508 VSS.n307 VSS.n306 1.52811
R509 VSS.n138 VSS.n137 1.52811
R510 VSS.n299 VSS.n83 0.00154475
R511 VSS.n43 VSS.t48 1.08267
R512 VSS.n43 VSS.t52 1.03721
R513 VSS.n332 VSS.n108 0.148049
R514 VSS.n347 VSS.n84 0.91152
R515 VSS.n5 VSS.n4 0.910334
R516 VSS.n43 VSS.n9 0.650322
R517 VSS.n43 VSS.n10 0.650322
R518 VSS.n43 VSS.n11 0.650322
R519 VSS.n43 VSS.n12 0.650322
R520 VSS.n43 VSS.n13 0.650322
R521 VSS.n43 VSS.n14 0.650322
R522 VSS.n43 VSS.n15 0.650322
R523 VSS.n43 VSS.n16 0.650322
R524 VSS.n43 VSS.n17 0.650322
R525 VSS.n43 VSS.n18 0.650322
R526 VSS.n43 VSS.n19 0.650322
R527 VSS.n43 VSS.n20 0.650322
R528 VSS.n43 VSS.n21 0.650322
R529 VSS.n43 VSS.n22 0.650322
R530 VSS.n43 VSS.n23 0.650322
R531 VSS.n43 VSS.n24 0.650322
R532 VSS.n43 VSS.n25 0.650322
R533 VSS.n43 VSS.n26 0.650322
R534 VSS.n43 VSS.n27 0.650322
R535 VSS.n43 VSS.n28 0.650322
R536 VSS.n43 VSS.n29 0.650322
R537 VSS.n43 VSS.n30 0.650322
R538 VSS.n43 VSS.n31 0.650322
R539 VSS.n43 VSS.n32 0.650322
R540 VSS.n43 VSS.n33 0.650322
R541 VSS.n43 VSS.n34 0.650322
R542 VSS.n43 VSS.n35 0.650322
R543 VSS.n43 VSS.n36 0.650322
R544 VSS.n43 VSS.n37 0.650322
R545 VSS.n43 VSS.n38 0.650322
R546 VSS.n43 VSS.n39 0.650322
R547 VSS.n43 VSS.n40 0.650322
R548 VSS.n43 VSS.n41 0.650322
R549 VSS.n43 VSS.n42 0.650322
R550 VSS.n312 VSS.n282 0.632727
R551 VSS.n356 VSS.n355 0.5505
R552 VSS.n313 VSS.n122 0.2444
R553 VSS.n313 VSS.n312 0.2444
R554 VSS.n353 VSS.n123 0.2444
R555 VSS.n283 VSS.n123 0.2444
R556 VSS.n349 VSS.n348 0.209825
R557 VSS.t35 VSS.n3 1.21444
R558 VSS.n306 VSS.n305 0.209825
R559 VSS.n137 VSS.n136 0.209825
R560 VSS.n346 VSS.t3 0.201663
R561 VSS.n344 VSS.t6 0.201663
R562 VSS.n342 VSS.t9 0.201663
R563 VSS.n340 VSS.t12 0.201663
R564 VSS.n338 VSS.t18 0.201663
R565 VSS.n336 VSS.t21 0.201663
R566 VSS.n334 VSS.t24 0.201663
R567 VSS.n332 VSS.t27 0.201663
R568 VSS.t134 VSS.n6 0.208027
R569 VSS.t131 VSS.n294 0.201663
R570 VSS.t128 VSS.n295 0.201663
R571 VSS.n291 VSS.t125 0.201663
R572 VSS.n287 VSS.t119 0.201663
R573 VSS.t116 VSS.n302 0.201663
R574 VSS.t113 VSS.n301 0.201663
R575 VSS.t110 VSS.n300 0.201663
R576 VSS.n114 VSS.t89 0.201663
R577 VSS.t61 VSS.n114 0.201663
R578 VSS.n81 VSS.t91 0.201663
R579 VSS.t64 VSS.n81 0.201663
R580 VSS.n257 VSS.t93 0.201663
R581 VSS.t67 VSS.n257 0.201663
R582 VSS.n259 VSS.t95 0.201663
R583 VSS.t70 VSS.n259 0.201663
R584 VSS.n261 VSS.t99 0.201663
R585 VSS.t76 VSS.n261 0.201663
R586 VSS.n264 VSS.t101 0.201663
R587 VSS.t79 VSS.n264 0.201663
R588 VSS.n49 VSS.t103 0.201663
R589 VSS.t82 VSS.n49 0.201663
R590 VSS.n117 VSS.t105 0.201663
R591 VSS.t85 VSS.n117 0.201663
R592 VSS.n141 VSS.n109 1.42693
R593 VSS.t73 VSS.t97 0.185696
R594 VSS.n350 VSS.n349 0.16242
R595 VSS.n351 VSS.n350 0.16242
R596 VSS.n127 VSS.n351 0.16242
R597 VSS.n125 VSS.n127 0.16242
R598 VSS.n125 VSS.n126 0.16242
R599 VSS.n134 VSS.n126 0.16242
R600 VSS.n135 VSS.n134 0.16242
R601 VSS.n136 VSS.n135 0.16242
R602 VSS.n305 VSS.n304 0.16242
R603 VSS.n304 VSS.n303 0.16242
R604 VSS.n303 VSS.n285 0.16242
R605 VSS.n286 VSS.n285 0.16242
R606 VSS.n286 VSS.n284 0.16242
R607 VSS.n296 VSS.n284 0.16242
R608 VSS.n297 VSS.n296 0.16242
R609 VSS.n3 VSS.n297 0.16242
R610 VSS.n300 VSS.n4 0.145358
R611 VSS.n347 VSS.n346 0.144129
R612 VSS.n325 VSS.n319 0.117247
R613 VSS.n278 VSS.n277 0.1171
R614 VSS.n346 VSS.n345 0.0952183
R615 VSS.n300 VSS.n288 0.0938811
R616 VSS.n344 VSS.n343 0.0927738
R617 VSS.n333 VSS.n332 0.0925656
R618 VSS.n301 VSS.n289 0.0912443
R619 VSS.n294 VSS.n293 0.0908678
R620 VSS.n342 VSS.n341 0.0903294
R621 VSS.t15 VSS.n124 0.0903294
R622 VSS.n335 VSS.n334 0.0901212
R623 VSS.n302 VSS.n290 0.0894394
R624 VSS.t122 VSS.n310 0.0889915
R625 VSS.t122 VSS.n120 0.0886118
R626 VSS.n295 VSS.n292 0.0884862
R627 VSS.n340 VSS.n339 0.0878849
R628 VSS.n338 VSS.n337 0.0878849
R629 VSS.n339 VSS.t15 0.0876767
R630 VSS.n337 VSS.n336 0.0876767
R631 VSS.n292 VSS.n291 0.0870574
R632 VSS.n291 VSS.n120 0.0869305
R633 VSS.n310 VSS.n287 0.0865396
R634 VSS.n290 VSS.n287 0.0861049
R635 VSS.n336 VSS.n335 0.0854405
R636 VSS.n341 VSS.n340 0.0852323
R637 VSS.n124 VSS.n338 0.0852323
R638 VSS.t53 VSS.n347 0.0847768
R639 VSS.n295 VSS.n293 0.0846727
R640 VSS.n302 VSS.n289 0.0842912
R641 VSS.t31 VSS.n4 0.0834709
R642 VSS.n334 VSS.n333 0.082996
R643 VSS.n343 VSS.n342 0.0827878
R644 VSS.n356 VSS.n122 0.0827273
R645 VSS.n354 VSS.n353 0.0827273
R646 VSS.n294 VSS.n6 0.16598
R647 VSS.n301 VSS.n288 0.0816588
R648 VSS.n319 VSS.n318 0.08146
R649 VSS.n318 VSS.n317 0.08146
R650 VSS.n317 VSS.n316 0.08146
R651 VSS.n316 VSS.n315 0.08146
R652 VSS.n315 VSS.n281 0.08146
R653 VSS.n281 VSS.n280 0.08146
R654 VSS.n280 VSS.n279 0.08146
R655 VSS.n279 VSS.n278 0.08146
R656 VSS.n345 VSS.n344 0.0803434
R657 VSS.n7 VSS.t41 1.05345
R658 VSS.n355 VSS 0.0445
R659 VSS.n282 VSS 0.0445
R660 VSS.n286 VSS.t122 0.0394179
R661 VSS.t15 VSS.n125 0.0394179
R662 VSS.n352 VSS.n125 0.0389615
R663 VSS.n311 VSS.n286 0.0389615
R664 VSS.t49 VSS.n329 0.031258
R665 VSS.n321 VSS.t42 0.031258
R666 VSS.n274 VSS.t51 0.031258
R667 VSS.n325 VSS.n324 0.0291125
R668 VSS.n277 VSS.n276 0.0291125
R669 VSS.n277 VSS.n265 0.0291125
R670 VSS.n326 VSS.n325 0.0291125
R671 VSS.n324 VSS.n320 0.0281144
R672 VSS.n276 VSS.n266 0.0281144
R673 VSS.n269 VSS.n265 0.0281144
R674 VSS.n330 VSS.n326 0.0281144
R675 VSS.n272 VSS.n271 0.0216549
R676 VSS.n270 VSS.t45 0.0208704
R677 VSS.n328 VSS.n327 0.0202884
R678 VSS.n323 VSS.n322 0.0202884
R679 VSS.n270 VSS.n268 0.0202884
R680 VSS.n275 VSS.n273 0.0202884
R681 VSS.n315 VSS.n314 0.0197308
R682 VSS.n315 VSS.t97 0.019449
R683 VSS.n272 VSS.n168 0.0162424
R684 VSS.n254 VSS.n252 0.0159649
R685 VSS.n129 VSS.t56 0.0133922
R686 VSS.t53 VSS.n121 0.0133922
R687 VSS.n309 VSS.t31 0.0133922
R688 VSS.n171 VSS.n170 0.0118857
R689 VSS.n173 VSS.n172 0.0118857
R690 VSS.n175 VSS.n174 0.0118857
R691 VSS.n179 VSS.n178 0.0118857
R692 VSS.n184 VSS.n183 0.0118857
R693 VSS.n186 VSS.n185 0.0118857
R694 VSS.n192 VSS.n191 0.0118857
R695 VSS.n194 VSS.n193 0.0118857
R696 VSS.n195 VSS.n194 0.0118857
R697 VSS.n199 VSS.n197 0.0118857
R698 VSS.n200 VSS.n199 0.0118857
R699 VSS.n204 VSS.n203 0.0118857
R700 VSS.n206 VSS.n205 0.0118857
R701 VSS.n208 VSS.n207 0.0118857
R702 VSS.n212 VSS.n211 0.0118857
R703 VSS.n214 VSS.n213 0.0118857
R704 VSS.n216 VSS.n215 0.0118857
R705 VSS.n219 VSS.n218 0.0118857
R706 VSS.n221 VSS.n220 0.0118857
R707 VSS.n225 VSS.n224 0.0118857
R708 VSS.n230 VSS.n229 0.0118857
R709 VSS.n80 VSS.n79 0.0173885
R710 VSS.n233 VSS.n77 0.0296797
R711 VSS.n235 VSS.n234 0.0118857
R712 VSS.n243 VSS.n240 0.0118857
R713 VSS.n244 VSS.n243 0.0118857
R714 VSS.n248 VSS.n246 0.0118857
R715 VSS.n249 VSS.n248 0.0118857
R716 VSS.n251 VSS.n250 0.0118857
R717 VSS.n250 VSS.n249 0.0118857
R718 VSS.n246 VSS.n245 0.0118857
R719 VSS.n245 VSS.n244 0.0118857
R720 VSS.n240 VSS.n239 0.0118857
R721 VSS.n239 VSS.n113 0.0118857
R722 VSS.n237 VSS.n235 0.0118857
R723 VSS.n234 VSS.n233 0.0118857
R724 VSS.n220 VSS.n219 0.0118857
R725 VSS.n215 VSS.n214 0.0118857
R726 VSS.n213 VSS.n212 0.0118857
R727 VSS.n211 VSS.n210 0.0118857
R728 VSS.n209 VSS.n208 0.0118857
R729 VSS.n207 VSS.n206 0.0118857
R730 VSS.n205 VSS.n204 0.0118857
R731 VSS.n197 VSS.n196 0.0118857
R732 VSS.n196 VSS.n195 0.0118857
R733 VSS.n191 VSS.n47 0.0589766
R734 VSS.n49 VSS.n48 0.00653337
R735 VSS.n185 VSS.n184 0.0118857
R736 VSS.n116 VSS.n180 0.0118857
R737 VSS.n180 VSS.n179 0.0118857
R738 VSS.n174 VSS.n173 0.0118857
R739 VSS.n172 VSS.n171 0.0118857
R740 VSS.n327 VSS.n254 0.0115582
R741 VSS.n322 VSS.n254 0.0115582
R742 VSS.n273 VSS.n272 0.0112672
R743 VSS.n5 VSS.t130 17.7154
R744 VSS.n5 VSS.t136 9.76925
R745 VSS.n232 VSS.n231 0.0108889
R746 VSS.n228 VSS.n227 0.0108889
R747 VSS.n223 VSS.n222 0.0108889
R748 VSS.n177 VSS.n176 0.0108889
R749 VSS.n329 VSS.n328 0.0108877
R750 VSS.n323 VSS.n321 0.0108877
R751 VSS.n271 VSS.n268 0.0108877
R752 VSS.n275 VSS.n274 0.0108877
R753 VSS.n272 VSS.t46 0.0101032
R754 VSS.n272 VSS.t52 0.0101032
R755 VSS.t48 VSS.n254 0.00981217
R756 VSS.n254 VSS.t41 0.00981217
R757 VSS VSS.n356 0.0095
R758 VSS.n354 VSS 0.0095
R759 VSS.n114 VSS.n112 0.00936111
R760 VSS.n117 VSS.n115 0.00936111
R761 VSS.n108 VSS.t56 0.0818274
R762 VSS.n138 VSS.n133 0.00798582
R763 VSS.n138 VSS.n118 0.00798582
R764 VSS.n131 VSS.n128 0.00798582
R765 VSS.n130 VSS.n128 0.00798582
R766 VSS.n307 VSS.n83 0.0150083
R767 VSS.n307 VSS.n298 0.00798582
R768 VSS.n132 VSS.n129 0.00756994
R769 VSS.n133 VSS.n132 0.00756994
R770 VSS.n139 VSS.n118 0.00756994
R771 VSS.n140 VSS.n121 0.00756994
R772 VSS.n140 VSS.n131 0.00756994
R773 VSS.n141 VSS.n130 0.00756994
R774 VSS.n308 VSS.n298 0.00756994
R775 VSS.n309 VSS.n308 0.00756994
R776 VSS.n117 VSS.n116 0.00772064
R777 VSS.n114 VSS.n113 0.00772064
R778 VSS.n257 VSS.n255 0.00691667
R779 VSS.t97 VSS.n111 0.00691667
R780 VSS.n264 VSS.n263 0.00691667
R781 VSS.n254 VSS.n253 0.00630556
R782 VSS.n110 VSS.n209 0.00619286
R783 VSS.n112 VSS.n237 0.00619286
R784 VSS.n111 VSS.n210 0.00619286
R785 VSS.n256 VSS.n226 0.00619286
R786 VSS.n253 VSS.n251 0.00619286
R787 VSS.n81 VSS.n80 0.00600277
R788 VSS.n79 VSS.n232 0.00619286
R789 VSS.n231 VSS.n230 0.00619286
R790 VSS.n229 VSS.n228 0.00619286
R791 VSS.n227 VSS.n226 0.00619286
R792 VSS.n255 VSS.n225 0.00619286
R793 VSS.n224 VSS.n223 0.00619286
R794 VSS.n222 VSS.n221 0.00619286
R795 VSS.n218 VSS.n217 0.00619286
R796 VSS.n258 VSS.n216 0.00619286
R797 VSS.n203 VSS.n201 0.00619286
R798 VSS.n260 VSS.n200 0.00619286
R799 VSS.n263 VSS.n193 0.00619286
R800 VSS.n262 VSS.n192 0.00619286
R801 VSS.n183 VSS.n115 0.00619286
R802 VSS.n178 VSS.n177 0.00619286
R803 VSS.n176 VSS.n175 0.00619286
R804 VSS.n170 VSS.n169 0.00619286
R805 VSS.n272 VSS.n169 0.00615278
R806 VSS.n259 VSS.n217 0.00569444
R807 VSS.n259 VSS.n258 0.00569444
R808 VSS.n261 VSS.n201 0.00569444
R809 VSS.n261 VSS.n260 0.00569444
R810 VSS.t97 VSS.n110 0.00891217
R811 VSS.n257 VSS.n256 0.00447222
R812 VSS.n264 VSS.n262 0.00447222
R813 VSS.n5 VSS.n82 6777.49
R814 VSS.t46 VSS.n7 1.07042
R815 VSS.t37 VSS.n1 17.0247
C15 vout1 VSS 5.54899f
C16 vin1 VSS 16.0542f
C17 vout2 VSS 5.54814f
C18 vin2 VSS 16.0189f
C19 vout3 VSS 5.54814f
C20 vin3 VSS 16.0189f
C21 vout4 VSS 5.54899f
C22 vin4 VSS 16.0542f
C23 VDD VSS 21.8873f
.ends

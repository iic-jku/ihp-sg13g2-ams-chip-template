* NGSPICE file created from inverter_top_pex.ext - technology: ihp-sg13g2

.subckt inverter_top_pex VDD vin4 vout4 VSS vin3 vout3 vin2 vout2 vout1 vin1
X0 vout3 vin3 VSS.t105 VSS.t86 sg13_lv_nmos ad=0.19p pd=1.38u as=0.19p ps=1.38u w=1u l=1u
X1 VDD VDD VDD VDD sg13_lv_pmos ad=1.14p pd=6.38u as=0.56797n ps=1.006m w=6u l=1u
X2 VSS.t1 VSS.t53 VSS.t55 VSS.t54 sg13_lv_nmos ad=0.34p pd=2.68u as=0 ps=0 w=1u l=1u
X3 VDD VDD VDD VDD sg13_lv_pmos ad=1.14p pd=6.38u as=0 ps=0 w=6u l=1u
X4 VDD vin4 vout4 VDD sg13_lv_pmos ad=1.14p pd=6.38u as=1.14p ps=6.38u w=6u l=1u
X5 vout2 vin2 VSS.t76 VSS.t77 sg13_lv_nmos ad=0.19p pd=1.38u as=0.19p ps=1.38u w=1u l=1u
X6 vout3 vin3 VDD VDD sg13_lv_pmos ad=1.14p pd=6.38u as=1.14p ps=6.38u w=6u l=1u
X7 vout4 vin4 VSS.t110 VSS.t111 sg13_lv_nmos ad=0.19p pd=1.38u as=0.19p ps=1.38u w=1u l=1u
X8 vout3 vin3 VSS.t42 VSS.t59 sg13_lv_nmos ad=0.19p pd=1.38u as=0.19p ps=1.38u w=1u l=1u
X9 vout2 vin2 VSS.t70 VSS.t71 sg13_lv_nmos ad=0.19p pd=1.38u as=0.19p ps=1.38u w=1u l=1u
X10 vout4 vin4 VDD VDD sg13_lv_pmos ad=1.14p pd=6.38u as=1.14p ps=6.38u w=6u l=1u
X11 VDD vin2 vout2 VDD sg13_lv_pmos ad=1.14p pd=6.38u as=1.14p ps=6.38u w=6u l=1u
X12 VSS.t76 vin2 vout2 VSS.t75 sg13_lv_nmos ad=0.19p pd=1.38u as=0.19p ps=1.38u w=1u l=1u
X13 vout2 vin2 VSS.t79 VSS.t80 sg13_lv_nmos ad=0.19p pd=1.38u as=0.19p ps=1.38u w=1u l=1u
X14 vout2 vin2 VDD VDD sg13_lv_pmos ad=1.14p pd=6.38u as=1.14p ps=6.38u w=6u l=1u
X15 VSS.t116 vin4 vout4 VSS.t115 sg13_lv_nmos ad=0.19p pd=1.38u as=0.19p ps=1.38u w=1u l=1u
X16 vout1 vin1 VSS.t24 VSS.t25 sg13_lv_nmos ad=0.19p pd=1.38u as=0.19p ps=1.38u w=1u l=1u
X17 VDD vin2 vout2 VDD sg13_lv_pmos ad=1.14p pd=6.38u as=1.14p ps=6.38u w=6u l=1u
X18 vout4 vin4 VSS.t34 VSS.t108 sg13_lv_nmos ad=0.19p pd=1.38u as=0.19p ps=1.38u w=1u l=1u
X19 VDD vin2 vout2 VDD sg13_lv_pmos ad=1.14p pd=6.38u as=1.14p ps=6.38u w=6u l=1u
X20 VSS.t105 vin3 vout3 VSS.t84 sg13_lv_nmos ad=0.19p pd=1.38u as=0.19p ps=1.38u w=1u l=1u
X21 vout4 vin4 VSS.t125 VSS.t126 sg13_lv_nmos ad=0.19p pd=1.38u as=0.19p ps=1.38u w=1u l=1u
X22 VSS.t119 vin4 vout4 VSS.t118 sg13_lv_nmos ad=0.19p pd=1.38u as=0.19p ps=1.38u w=1u l=1u
X23 VDD vin3 vout3 VDD sg13_lv_pmos ad=1.14p pd=6.38u as=1.14p ps=6.38u w=6u l=1u
X24 VDD vin2 vout2 VDD sg13_lv_pmos ad=1.14p pd=6.38u as=1.14p ps=6.38u w=6u l=1u
X25 vout3 vin3 VDD VDD sg13_lv_pmos ad=1.14p pd=6.38u as=1.14p ps=6.38u w=6u l=1u
X26 VSS.t70 vin2 vout2 VSS.t69 sg13_lv_nmos ad=0.19p pd=1.38u as=0.19p ps=1.38u w=1u l=1u
X27 VDD vin3 vout3 VDD sg13_lv_pmos ad=1.14p pd=6.38u as=1.14p ps=6.38u w=6u l=1u
X28 VSS.t42 VSS.t39 VSS.t41 VSS.t40 sg13_lv_nmos ad=0.34p pd=2.68u as=0 ps=0 w=1u l=1u
X29 vout2 vin2 VDD VDD sg13_lv_pmos ad=1.14p pd=6.38u as=1.14p ps=6.38u w=6u l=1u
X30 vout2 vin2 VSS.t73 VSS.t74 sg13_lv_nmos ad=0.19p pd=1.38u as=0.19p ps=1.38u w=1u l=1u
X31 vout1 vin1 VSS.t18 VSS.t19 sg13_lv_nmos ad=0.19p pd=1.38u as=0.19p ps=1.38u w=1u l=1u
X32 VSS.t79 vin2 vout2 VSS.t78 sg13_lv_nmos ad=0.19p pd=1.38u as=0.19p ps=1.38u w=1u l=1u
X33 vout4 vin4 VSS.t122 VSS.t123 sg13_lv_nmos ad=0.19p pd=1.38u as=0.19p ps=1.38u w=1u l=1u
X34 vout1 vin1 VDD VDD sg13_lv_pmos ad=1.14p pd=6.38u as=1.14p ps=6.38u w=6u l=1u
X35 vout1 vin1 VSS.t12 VSS.t13 sg13_lv_nmos ad=0.19p pd=1.38u as=0.19p ps=1.38u w=1u l=1u
X36 VSS.t128 vin4 vout4 VSS.t127 sg13_lv_nmos ad=0.19p pd=1.38u as=0.19p ps=1.38u w=1u l=1u
X37 VDD VDD VDD VDD sg13_lv_pmos ad=1.14p pd=6.38u as=0 ps=0 w=6u l=1u
X38 VSS.t18 vin1 vout1 VSS.t17 sg13_lv_nmos ad=0.19p pd=1.38u as=0.19p ps=1.38u w=1u l=1u
X39 vout2 vin2 VDD VDD sg13_lv_pmos ad=1.14p pd=6.38u as=1.14p ps=6.38u w=6u l=1u
X40 VDD vin4 vout4 VDD sg13_lv_pmos ad=1.14p pd=6.38u as=1.14p ps=6.38u w=6u l=1u
X41 vout1 vin1 VSS.t21 VSS.t22 sg13_lv_nmos ad=0.19p pd=1.38u as=0.19p ps=1.38u w=1u l=1u
X42 vout3 vin3 VSS.t103 VSS.t83 sg13_lv_nmos ad=0.19p pd=1.38u as=0.19p ps=1.38u w=1u l=1u
X43 VDD vin3 vout3 VDD sg13_lv_pmos ad=1.14p pd=6.38u as=1.14p ps=6.38u w=6u l=1u
X44 vout4 vin4 VDD VDD sg13_lv_pmos ad=1.14p pd=6.38u as=1.14p ps=6.38u w=6u l=1u
X45 VDD vin4 vout4 VDD sg13_lv_pmos ad=1.14p pd=6.38u as=1.14p ps=6.38u w=6u l=1u
X46 vout3 vin3 VDD VDD sg13_lv_pmos ad=1.14p pd=6.38u as=1.14p ps=6.38u w=6u l=1u
X47 VDD vin3 vout3 VDD sg13_lv_pmos ad=1.14p pd=6.38u as=1.14p ps=6.38u w=6u l=1u
X48 VSS.t38 VSS.t35 VSS.t37 VSS.t36 sg13_lv_nmos ad=0.19p pd=1.38u as=0 ps=0 w=1u l=1u
X49 VDD vin4 vout4 VDD sg13_lv_pmos ad=1.14p pd=6.38u as=1.14p ps=6.38u w=6u l=1u
X50 VDD vin2 vout2 VDD sg13_lv_pmos ad=1.14p pd=6.38u as=1.14p ps=6.38u w=6u l=1u
X51 VSS.t131 vin4 vout4 VSS.t130 sg13_lv_nmos ad=0.19p pd=1.38u as=0.19p ps=1.38u w=1u l=1u
X52 VDD vin3 vout3 VDD sg13_lv_pmos ad=1.14p pd=6.38u as=1.14p ps=6.38u w=6u l=1u
X53 VSS.t12 vin1 vout1 VSS.t11 sg13_lv_nmos ad=0.19p pd=1.38u as=0.19p ps=1.38u w=1u l=1u
X54 VDD vin1 vout1 VDD sg13_lv_pmos ad=1.14p pd=6.38u as=1.14p ps=6.38u w=6u l=1u
X55 vout4 vin4 VSS.t134 VSS.t135 sg13_lv_nmos ad=0.19p pd=1.38u as=0.19p ps=1.38u w=1u l=1u
X56 vout1 vin1 VDD VDD sg13_lv_pmos ad=1.14p pd=6.38u as=1.14p ps=6.38u w=6u l=1u
X57 vout4 vin4 VDD VDD sg13_lv_pmos ad=1.14p pd=6.38u as=1.14p ps=6.38u w=6u l=1u
X58 vout1 vin1 VSS.t15 VSS.t16 sg13_lv_nmos ad=0.19p pd=1.38u as=0.19p ps=1.38u w=1u l=1u
X59 VDD vin1 vout1 VDD sg13_lv_pmos ad=1.14p pd=6.38u as=1.14p ps=6.38u w=6u l=1u
X60 vout3 vin3 VSS.t99 VSS.t77 sg13_lv_nmos ad=0.19p pd=1.38u as=0.19p ps=1.38u w=1u l=1u
X61 VSS.t21 vin1 vout1 VSS.t20 sg13_lv_nmos ad=0.19p pd=1.38u as=0.19p ps=1.38u w=1u l=1u
X62 VDD VDD VDD VDD sg13_lv_pmos ad=2.04p pd=12.68u as=0 ps=0 w=6u l=1u
X63 vout4 vin4 VDD VDD sg13_lv_pmos ad=1.14p pd=6.38u as=1.14p ps=6.38u w=6u l=1u
X64 VDD vin3 vout3 VDD sg13_lv_pmos ad=1.14p pd=6.38u as=1.14p ps=6.38u w=6u l=1u
X65 VDD vin4 vout4 VDD sg13_lv_pmos ad=1.14p pd=6.38u as=1.14p ps=6.38u w=6u l=1u
X66 vout3 vin3 VDD VDD sg13_lv_pmos ad=1.14p pd=6.38u as=1.14p ps=6.38u w=6u l=1u
X67 vout3 vin3 VSS.t95 VSS.t71 sg13_lv_nmos ad=0.19p pd=1.38u as=0.19p ps=1.38u w=1u l=1u
X68 VSS.t99 vin3 vout3 VSS.t75 sg13_lv_nmos ad=0.19p pd=1.38u as=0.19p ps=1.38u w=1u l=1u
X69 VDD VDD VDD VDD sg13_lv_pmos ad=1.14p pd=6.38u as=0 ps=0 w=6u l=1u
X70 vout3 vin3 VSS.t101 VSS.t80 sg13_lv_nmos ad=0.19p pd=1.38u as=0.19p ps=1.38u w=1u l=1u
X71 vout4 vin4 VDD VDD sg13_lv_pmos ad=1.14p pd=6.38u as=1.14p ps=6.38u w=6u l=1u
X72 vout3 vin3 VDD VDD sg13_lv_pmos ad=1.14p pd=6.38u as=1.14p ps=6.38u w=6u l=1u
X73 VDD vin1 vout1 VDD sg13_lv_pmos ad=1.14p pd=6.38u as=1.14p ps=6.38u w=6u l=1u
X74 vout2 vin2 VDD VDD sg13_lv_pmos ad=1.14p pd=6.38u as=1.14p ps=6.38u w=6u l=1u
X75 vout1 vin1 VDD VDD sg13_lv_pmos ad=1.14p pd=6.38u as=1.14p ps=6.38u w=6u l=1u
X76 vout2 vin2 VSS.t64 VSS.t65 sg13_lv_nmos ad=0.19p pd=1.38u as=0.19p ps=1.38u w=1u l=1u
X77 VDD vin1 vout1 VDD sg13_lv_pmos ad=1.14p pd=6.38u as=1.14p ps=6.38u w=6u l=1u
X78 VDD vin1 vout1 VDD sg13_lv_pmos ad=1.14p pd=6.38u as=1.14p ps=6.38u w=6u l=1u
X79 VDD vin3 vout3 VDD sg13_lv_pmos ad=1.14p pd=6.38u as=1.14p ps=6.38u w=6u l=1u
X80 VSS.t95 vin3 vout3 VSS.t69 sg13_lv_nmos ad=0.19p pd=1.38u as=0.19p ps=1.38u w=1u l=1u
X81 vout3 vin3 VSS.t97 VSS.t74 sg13_lv_nmos ad=0.19p pd=1.38u as=0.19p ps=1.38u w=1u l=1u
X82 VSS.t113 vin4 vout4 VSS.t112 sg13_lv_nmos ad=0.19p pd=1.38u as=0.19p ps=1.38u w=1u l=1u
X83 VDD vin4 vout4 VDD sg13_lv_pmos ad=1.14p pd=6.38u as=1.14p ps=6.38u w=6u l=1u
X84 VSS.t101 vin3 vout3 VSS.t78 sg13_lv_nmos ad=0.19p pd=1.38u as=0.19p ps=1.38u w=1u l=1u
X85 vout4 vin4 VSS.t116 VSS.t117 sg13_lv_nmos ad=0.19p pd=1.38u as=0.19p ps=1.38u w=1u l=1u
X86 VDD vin1 vout1 VDD sg13_lv_pmos ad=1.14p pd=6.38u as=1.14p ps=6.38u w=6u l=1u
X87 vout2 vin2 VDD VDD sg13_lv_pmos ad=1.14p pd=6.38u as=1.14p ps=6.38u w=6u l=1u
X88 vout1 vin1 VDD VDD sg13_lv_pmos ad=1.14p pd=6.38u as=1.14p ps=6.38u w=6u l=1u
X89 VSS.t110 vin4 vout4 VSS.t109 sg13_lv_nmos ad=0.19p pd=1.38u as=0.19p ps=1.38u w=1u l=1u
X90 VDD VDD VDD VDD sg13_lv_pmos ad=2.04p pd=12.68u as=0 ps=0 w=6u l=1u
X91 vout2 vin2 VDD VDD sg13_lv_pmos ad=1.14p pd=6.38u as=1.14p ps=6.38u w=6u l=1u
X92 VDD vin2 vout2 VDD sg13_lv_pmos ad=1.14p pd=6.38u as=1.14p ps=6.38u w=6u l=1u
X93 VSS.t64 vin2 vout2 VSS.t63 sg13_lv_nmos ad=0.19p pd=1.38u as=0.19p ps=1.38u w=1u l=1u
X94 VSS.t122 vin4 vout4 VSS.t121 sg13_lv_nmos ad=0.19p pd=1.38u as=0.19p ps=1.38u w=1u l=1u
X95 vout2 vin2 VDD VDD sg13_lv_pmos ad=1.14p pd=6.38u as=1.14p ps=6.38u w=6u l=1u
X96 VDD VDD VDD VDD sg13_lv_pmos ad=2.04p pd=12.68u as=0 ps=0 w=6u l=1u
X97 vout2 vin2 VSS.t67 VSS.t68 sg13_lv_nmos ad=0.19p pd=1.38u as=0.19p ps=1.38u w=1u l=1u
X98 VSS.t73 vin2 vout2 VSS.t72 sg13_lv_nmos ad=0.19p pd=1.38u as=0.19p ps=1.38u w=1u l=1u
X99 vout1 vin1 VDD VDD sg13_lv_pmos ad=1.14p pd=6.38u as=1.14p ps=6.38u w=6u l=1u
X100 vout1 vin1 VSS.t6 VSS.t7 sg13_lv_nmos ad=0.19p pd=1.38u as=0.19p ps=1.38u w=1u l=1u
X101 vout4 vin4 VSS.t119 VSS.t120 sg13_lv_nmos ad=0.19p pd=1.38u as=0.19p ps=1.38u w=1u l=1u
X102 vout3 vin3 VDD VDD sg13_lv_pmos ad=1.14p pd=6.38u as=1.14p ps=6.38u w=6u l=1u
X103 vout4 vin4 VSS.t131 VSS.t132 sg13_lv_nmos ad=0.19p pd=1.38u as=0.19p ps=1.38u w=1u l=1u
X104 VSS.t52 VSS.t50 VSS.t51 VSS.t44 sg13_lv_nmos ad=0.19p pd=1.38u as=0 ps=0 w=1u l=1u
X105 VSS.t125 vin4 vout4 VSS.t124 sg13_lv_nmos ad=0.19p pd=1.38u as=0.19p ps=1.38u w=1u l=1u
X106 VDD vin1 vout1 VDD sg13_lv_pmos ad=1.14p pd=6.38u as=1.14p ps=6.38u w=6u l=1u
X107 VSS.t51 vin2 vout2 VSS.t87 sg13_lv_nmos ad=0.19p pd=1.38u as=0.19p ps=1.38u w=1u l=1u
X108 VDD vin2 vout2 VDD sg13_lv_pmos ad=1.14p pd=6.38u as=1.14p ps=6.38u w=6u l=1u
X109 vout4 vin4 VSS.t128 VSS.t129 sg13_lv_nmos ad=0.19p pd=1.38u as=0.19p ps=1.38u w=1u l=1u
X110 vout4 vin4 VDD VDD sg13_lv_pmos ad=1.14p pd=6.38u as=1.14p ps=6.38u w=6u l=1u
X111 vout2 vin2 VDD VDD sg13_lv_pmos ad=1.14p pd=6.38u as=1.14p ps=6.38u w=6u l=1u
X112 vout2 vin2 VSS.t61 VSS.t62 sg13_lv_nmos ad=0.19p pd=1.38u as=0.19p ps=1.38u w=1u l=1u
X113 VDD vin2 vout2 VDD sg13_lv_pmos ad=1.14p pd=6.38u as=1.14p ps=6.38u w=6u l=1u
X114 VSS.t67 vin2 vout2 VSS.t66 sg13_lv_nmos ad=0.19p pd=1.38u as=0.19p ps=1.38u w=1u l=1u
X115 VDD vin4 vout4 VDD sg13_lv_pmos ad=1.14p pd=6.38u as=1.14p ps=6.38u w=6u l=1u
X116 VDD VDD VDD VDD sg13_lv_pmos ad=2.04p pd=12.68u as=0 ps=0 w=6u l=1u
X117 VSS.t61 vin2 vout2 VSS.t60 sg13_lv_nmos ad=0.19p pd=1.38u as=0.19p ps=1.38u w=1u l=1u
X118 VSS.t6 vin1 vout1 VSS.t5 sg13_lv_nmos ad=0.19p pd=1.38u as=0.19p ps=1.38u w=1u l=1u
X119 vout3 vin3 VDD VDD sg13_lv_pmos ad=1.14p pd=6.38u as=1.14p ps=6.38u w=6u l=1u
X120 vout1 vin1 VSS.t9 VSS.t10 sg13_lv_nmos ad=0.19p pd=1.38u as=0.19p ps=1.38u w=1u l=1u
X121 VSS.t15 vin1 vout1 VSS.t14 sg13_lv_nmos ad=0.19p pd=1.38u as=0.19p ps=1.38u w=1u l=1u
X122 vout3 vin3 VDD VDD sg13_lv_pmos ad=1.14p pd=6.38u as=1.14p ps=6.38u w=6u l=1u
X123 VDD vin3 vout3 VDD sg13_lv_pmos ad=1.14p pd=6.38u as=1.14p ps=6.38u w=6u l=1u
X124 vout3 vin3 VDD VDD sg13_lv_pmos ad=1.14p pd=6.38u as=1.14p ps=6.38u w=6u l=1u
X125 vout3 vin3 VSS.t91 VSS.t65 sg13_lv_nmos ad=0.19p pd=1.38u as=0.19p ps=1.38u w=1u l=1u
X126 VSS.t82 vin2 vout2 VSS.t81 sg13_lv_nmos ad=0.19p pd=1.38u as=0.19p ps=1.38u w=1u l=1u
X127 vout1 vin1 VDD VDD sg13_lv_pmos ad=1.14p pd=6.38u as=1.14p ps=6.38u w=6u l=1u
X128 vout2 vin2 VSS.t85 VSS.t86 sg13_lv_nmos ad=0.19p pd=1.38u as=0.19p ps=1.38u w=1u l=1u
X129 VSS.t37 vin4 vout4 VSS.t136 sg13_lv_nmos ad=0.19p pd=1.38u as=0.19p ps=1.38u w=1u l=1u
X130 VSS.t58 VSS.t56 VSS.t30 VSS.t57 sg13_lv_nmos ad=0.19p pd=1.38u as=0 ps=0 w=1u l=1u
X131 VSS.t30 vin1 vout1 VSS.t29 sg13_lv_nmos ad=0.19p pd=1.38u as=0.19p ps=1.38u w=1u l=1u
X132 vout2 vin2 VSS.t49 VSS.t59 sg13_lv_nmos ad=0.19p pd=1.38u as=0.19p ps=1.38u w=1u l=1u
X133 VSS.t34 VSS.t31 VSS.t33 VSS.t32 sg13_lv_nmos ad=0.34p pd=2.68u as=0 ps=0 w=1u l=1u
X134 vout1 vin1 VSS.t3 VSS.t4 sg13_lv_nmos ad=0.19p pd=1.38u as=0.19p ps=1.38u w=1u l=1u
X135 VSS.t9 vin1 vout1 VSS.t8 sg13_lv_nmos ad=0.19p pd=1.38u as=0.19p ps=1.38u w=1u l=1u
X136 VDD vin3 vout3 VDD sg13_lv_pmos ad=1.14p pd=6.38u as=1.14p ps=6.38u w=6u l=1u
X137 VSS.t3 vin1 vout1 VSS.t2 sg13_lv_nmos ad=0.19p pd=1.38u as=0.19p ps=1.38u w=1u l=1u
X138 vout4 vin4 VDD VDD sg13_lv_pmos ad=1.14p pd=6.38u as=1.14p ps=6.38u w=6u l=1u
X139 vout3 vin3 VDD VDD sg13_lv_pmos ad=1.14p pd=6.38u as=1.14p ps=6.38u w=6u l=1u
X140 VDD vin3 vout3 VDD sg13_lv_pmos ad=1.14p pd=6.38u as=1.14p ps=6.38u w=6u l=1u
X141 VSS.t91 vin3 vout3 VSS.t63 sg13_lv_nmos ad=0.19p pd=1.38u as=0.19p ps=1.38u w=1u l=1u
X142 vout3 vin3 VSS.t93 VSS.t68 sg13_lv_nmos ad=0.19p pd=1.38u as=0.19p ps=1.38u w=1u l=1u
X143 vout1 vin1 VDD VDD sg13_lv_pmos ad=1.14p pd=6.38u as=1.14p ps=6.38u w=6u l=1u
X144 VSS.t85 vin2 vout2 VSS.t84 sg13_lv_nmos ad=0.19p pd=1.38u as=0.19p ps=1.38u w=1u l=1u
X145 VSS.t97 vin3 vout3 VSS.t72 sg13_lv_nmos ad=0.19p pd=1.38u as=0.19p ps=1.38u w=1u l=1u
X146 VDD vin4 vout4 VDD sg13_lv_pmos ad=1.14p pd=6.38u as=1.14p ps=6.38u w=6u l=1u
X147 vout1 vin1 VDD VDD sg13_lv_pmos ad=1.14p pd=6.38u as=1.14p ps=6.38u w=6u l=1u
X148 VDD vin1 vout1 VDD sg13_lv_pmos ad=1.14p pd=6.38u as=1.14p ps=6.38u w=6u l=1u
X149 vout4 vin4 VDD VDD sg13_lv_pmos ad=1.14p pd=6.38u as=1.14p ps=6.38u w=6u l=1u
X150 VSS.t24 vin1 vout1 VSS.t23 sg13_lv_nmos ad=0.19p pd=1.38u as=0.19p ps=1.38u w=1u l=1u
X151 vout1 vin1 VSS.t27 VSS.t28 sg13_lv_nmos ad=0.19p pd=1.38u as=0.19p ps=1.38u w=1u l=1u
X152 vout1 vin1 VDD VDD sg13_lv_pmos ad=1.14p pd=6.38u as=1.14p ps=6.38u w=6u l=1u
X153 vout2 vin2 VDD VDD sg13_lv_pmos ad=1.14p pd=6.38u as=1.14p ps=6.38u w=6u l=1u
X154 vout4 vin4 VSS.t113 VSS.t114 sg13_lv_nmos ad=0.19p pd=1.38u as=0.19p ps=1.38u w=1u l=1u
X155 VSS.t49 VSS.t47 VSS.t48 VSS.t40 sg13_lv_nmos ad=0.34p pd=2.68u as=0 ps=0 w=1u l=1u
X156 VSS.t46 VSS.t43 VSS.t45 VSS.t44 sg13_lv_nmos ad=0.19p pd=1.38u as=0 ps=0 w=1u l=1u
X157 vout4 vin4 VDD VDD sg13_lv_pmos ad=1.14p pd=6.38u as=1.14p ps=6.38u w=6u l=1u
X158 VSS.t45 vin3 vout3 VSS.t87 sg13_lv_nmos ad=0.19p pd=1.38u as=0.19p ps=1.38u w=1u l=1u
X159 VSS.t134 vin4 vout4 VSS.t133 sg13_lv_nmos ad=0.19p pd=1.38u as=0.19p ps=1.38u w=1u l=1u
X160 VDD vin4 vout4 VDD sg13_lv_pmos ad=1.14p pd=6.38u as=1.14p ps=6.38u w=6u l=1u
X161 vout1 vin1 VSS.t1 VSS.t0 sg13_lv_nmos ad=0.19p pd=1.38u as=0.19p ps=1.38u w=1u l=1u
X162 vout3 vin3 VSS.t89 VSS.t62 sg13_lv_nmos ad=0.19p pd=1.38u as=0.19p ps=1.38u w=1u l=1u
X163 VSS.t93 vin3 vout3 VSS.t66 sg13_lv_nmos ad=0.19p pd=1.38u as=0.19p ps=1.38u w=1u l=1u
X164 vout4 vin4 VDD VDD sg13_lv_pmos ad=1.14p pd=6.38u as=1.14p ps=6.38u w=6u l=1u
X165 vout2 vin2 VSS.t82 VSS.t83 sg13_lv_nmos ad=0.19p pd=1.38u as=0.19p ps=1.38u w=1u l=1u
X166 VSS.t89 vin3 vout3 VSS.t60 sg13_lv_nmos ad=0.19p pd=1.38u as=0.19p ps=1.38u w=1u l=1u
X167 VDD vin1 vout1 VDD sg13_lv_pmos ad=1.14p pd=6.38u as=1.14p ps=6.38u w=6u l=1u
X168 vout1 vin1 VDD VDD sg13_lv_pmos ad=1.14p pd=6.38u as=1.14p ps=6.38u w=6u l=1u
X169 VDD vin1 vout1 VDD sg13_lv_pmos ad=1.14p pd=6.38u as=1.14p ps=6.38u w=6u l=1u
X170 VDD vin4 vout4 VDD sg13_lv_pmos ad=1.14p pd=6.38u as=1.14p ps=6.38u w=6u l=1u
X171 VSS.t27 vin1 vout1 VSS.t26 sg13_lv_nmos ad=0.19p pd=1.38u as=0.19p ps=1.38u w=1u l=1u
X172 VDD vin2 vout2 VDD sg13_lv_pmos ad=1.14p pd=6.38u as=1.14p ps=6.38u w=6u l=1u
X173 vout2 vin2 VDD VDD sg13_lv_pmos ad=1.14p pd=6.38u as=1.14p ps=6.38u w=6u l=1u
X174 VDD vin2 vout2 VDD sg13_lv_pmos ad=1.14p pd=6.38u as=1.14p ps=6.38u w=6u l=1u
X175 VSS.t103 vin3 vout3 VSS.t81 sg13_lv_nmos ad=0.19p pd=1.38u as=0.19p ps=1.38u w=1u l=1u
C0 vout3 vin3 18.2968f
C1 vin4 vout4 18.2968f
C2 VDD vin2 29.202f
C3 vout2 VDD 15.3834f
C4 vout4 VDD 15.3949f
C5 vout2 vin2 18.2968f
C6 vin4 vin3 0.05053f
C7 vin3 VDD 29.202f
C8 vout1 VDD 15.3949f
C9 vin3 vin2 0.05785f
C10 VDD vin1 29.2329f
C11 vin2 vin1 0.05053f
C12 vout3 VDD 15.3834f
C13 vin4 VDD 29.2329f
C14 vout1 vin1 18.2968f
R0 VSS.n23 VSS.n76 6777.49
R1 VSS.n226 VSS.n23 6777.49
R2 VSS.n20 VSS.n76 6777.49
R3 VSS.n226 VSS.n225 1580.41
R4 VSS.n224 VSS.n76 1580.41
R5 VSS.n149 VSS.t59 88.7251
R6 VSS.t87 VSS.n220 88.7251
R7 VSS.n153 VSS.t60 83.1798
R8 VSS.t86 VSS.n216 83.1798
R9 VSS.n157 VSS.t62 77.6345
R10 VSS.t84 VSS.n213 77.6345
R11 VSS.n160 VSS.t63 72.0892
R12 VSS.t83 VSS.n210 72.0892
R13 VSS.t136 VSS.n23 9.76925
R14 VSS.n164 VSS.t65 66.5439
R15 VSS.t81 VSS.n206 66.5439
R16 VSS.n168 VSS.t66 60.9987
R17 VSS.t80 VSS.n202 60.9987
R18 VSS.t133 VSS.n23 14.4648
R19 VSS.n23 VSS.t111 14.4672
R20 VSS.t29 VSS.n20 9.77049
R21 VSS.t132 VSS.n23 16.2707
R22 VSS.n172 VSS.t68 55.4534
R23 VSS.t72 VSS.n183 55.4534
R24 VSS.n188 VSS.t74 55.4534
R25 VSS.t78 VSS.n198 55.4534
R26 VSS.t130 VSS.n23 17.7154
R27 VSS.n23 VSS.t114 17.717
R28 VSS.n176 VSS.t69 49.9081
R29 VSS.t71 VSS.n179 49.9081
R30 VSS.n192 VSS.t75 49.9081
R31 VSS.t77 VSS.n195 49.9081
R32 VSS.t129 VSS.n23 18.799
R33 VSS.n23 VSS.t115 18.8
R34 VSS.t23 VSS.n20 17.7157
R35 VSS.t69 VSS.n175 44.3628
R36 VSS.n180 VSS.t71 44.3628
R37 VSS.t75 VSS.n191 44.3628
R38 VSS.n196 VSS.t77 44.3628
R39 VSS.t126 VSS.n23 19.8823
R40 VSS.t120 VSS.n23 19.8818
R41 VSS.n23 VSS.t118 19.8825
R42 VSS.t22 VSS.n20 18.7991
R43 VSS.t68 VSS.n171 38.8175
R44 VSS.n184 VSS.t72 38.8175
R45 VSS.t74 VSS.n187 38.8175
R46 VSS.n199 VSS.t78 38.8175
R47 VSS.t124 VSS.n24 19.9324
R48 VSS.t20 VSS.n20 19.5213
R49 VSS.n24 VSS.n23 0.0384341
R50 VSS.t117 VSS.n23 19.5219
R51 VSS.n23 VSS.t121 19.5213
R52 VSS.t19 VSS.n20 19.882
R53 VSS.t66 VSS.n167 33.2722
R54 VSS.n203 VSS.t80 33.2722
R55 VSS.t17 VSS.n20 19.8817
R56 VSS.t65 VSS.n163 27.7269
R57 VSS.n207 VSS.t81 27.7269
R58 VSS.t16 VSS.n21 19.5609
R59 VSS.t112 VSS.n23 16.2727
R60 VSS.n20 VSS.t54 6.88007
R61 VSS.t4 VSS.n20 14.4658
R62 VSS.t63 VSS.n159 22.1816
R63 VSS.n211 VSS.t83 22.1816
R64 VSS.t28 VSS.n20 12.2984
R65 VSS.t25 VSS.n20 16.2712
R66 VSS.t14 VSS.n21 19.5024
R67 VSS.t11 VSS.n20 19.882
R68 VSS.t0 VSS.n20 9.76942
R69 VSS.n3 VSS.n2 0.0204054
R70 VSS.t58 VSS.n2 5.66432
R71 VSS.n3 VSS.t30 5.6666
R72 VSS.n9 VSS.n20 1.14058
R73 VSS.n9 VSS.t1 17.0005
R74 VSS.t1 VSS.n10 8.501
R75 VSS.n9 VSS.t55 17.0005
R76 VSS.n10 VSS.n8 0.00513447
R77 VSS.n10 VSS.t55 8.50175
R78 VSS.n13 VSS.n12 3.99348
R79 VSS.n39 VSS.n11 0.650675
R80 VSS.n222 VSS.n39 14.4044
R81 VSS.n221 VSS.n47 7.20256
R82 VSS.n219 VSS.n46 14.4044
R83 VSS.n46 VSS.n11 0.650675
R84 VSS.n217 VSS.n11 8.49055
R85 VSS.n216 VSS.n42 7.20256
R86 VSS.n32 VSS.n11 0.650675
R87 VSS.n214 VSS.n32 7.20256
R88 VSS.n213 VSS.n41 7.20256
R89 VSS.n34 VSS.n11 0.650675
R90 VSS.n211 VSS.n34 7.20256
R91 VSS.n210 VSS.n11 8.49078
R92 VSS.n56 VSS.n11 0.650675
R93 VSS.n208 VSS.n56 14.4044
R94 VSS.n206 VSS.n11 8.49102
R95 VSS.n204 VSS.n49 14.4044
R96 VSS.n203 VSS.n11 8.49126
R97 VSS.n202 VSS.n11 8.49711
R98 VSS.n201 VSS.n57 14.4044
R99 VSS.n57 VSS.n11 0.650675
R100 VSS.n199 VSS.n11 8.4915
R101 VSS.n198 VSS.n43 7.20256
R102 VSS.n43 VSS.n11 0.650675
R103 VSS.n40 VSS.n11 0.650675
R104 VSS.n196 VSS.n40 7.20256
R105 VSS.n195 VSS.n11 8.49174
R106 VSS.n44 VSS.n11 0.650675
R107 VSS.n193 VSS.n44 14.4044
R108 VSS.n11 VSS.n69 4.24711
R109 VSS.n192 VSS.n11 8.49198
R110 VSS.n191 VSS.n11 8.49222
R111 VSS.n189 VSS.n33 14.4044
R112 VSS.n187 VSS.n11 8.49246
R113 VSS.n45 VSS.n11 0.542754
R114 VSS.n185 VSS.n45 14.6203
R115 VSS.n11 VSS.n18 1.40234
R116 VSS.n184 VSS.n11 8.49611
R117 VSS.n183 VSS.n11 8.4927
R118 VSS.n181 VSS.n48 14.4044
R119 VSS.n180 VSS.n11 8.49294
R120 VSS.n179 VSS.n11 8.4976
R121 VSS.n178 VSS.n37 14.4044
R122 VSS.n37 VSS.n11 0.650675
R123 VSS.n11 VSS.n14 2.11143
R124 VSS.n176 VSS.n11 8.49319
R125 VSS.n175 VSS.n11 8.49343
R126 VSS.n173 VSS.n50 14.4044
R127 VSS.n14 VSS.n29 0.026256
R128 VSS.n172 VSS.n11 8.49367
R129 VSS.n171 VSS.n11 8.49392
R130 VSS.n51 VSS.n11 0.650675
R131 VSS.n169 VSS.n51 14.4044
R132 VSS.n168 VSS.n11 8.49416
R133 VSS.n167 VSS.n11 8.49441
R134 VSS.n38 VSS.n11 0.650675
R135 VSS.n165 VSS.n38 14.4044
R136 VSS.n164 VSS.n11 8.49465
R137 VSS.n163 VSS.n11 8.49661
R138 VSS.n54 VSS.n11 0.650675
R139 VSS.n161 VSS.n54 14.4044
R140 VSS.n160 VSS.n11 8.49489
R141 VSS.n158 VSS.n52 14.4044
R142 VSS.n55 VSS.n11 0.650675
R143 VSS.n157 VSS.n55 7.20256
R144 VSS.n36 VSS.n11 0.650675
R145 VSS.n154 VSS.n36 14.4044
R146 VSS.n68 VSS.n67 0.0124956
R147 VSS.n153 VSS.n11 8.49514
R148 VSS.n152 VSS.n11 8.50122
R149 VSS.n150 VSS.n35 14.4044
R150 VSS.n149 VSS.n11 8.49539
R151 VSS.n11 VSS.n73 5.66421
R152 VSS.n148 VSS.n11 8.49563
R153 VSS.n146 VSS.n31 14.4044
R154 VSS.n11 VSS.n71 5.66421
R155 VSS.n58 VSS.n11 1.20771
R156 VSS.n53 VSS.n11 0.650675
R157 VSS.n144 VSS.n53 14.4044
R158 VSS.n220 VSS.n11 8.49735
R159 VSS.n207 VSS.n11 8.49975
R160 VSS.n188 VSS.n11 8.49686
R161 VSS.n156 VSS.n11 8.49636
R162 VSS.n26 VSS.n27 0.0348056
R163 VSS.n65 VSS.n61 0.0128214
R164 VSS.n29 VSS.n28 0.0214647
R165 VSS.n74 VSS.n13 5.66316
R166 VSS.n72 VSS.n13 5.66316
R167 VSS.n23 VSS.n6 1.13543
R168 VSS.t38 VSS.t35 5.66092
R169 VSS.t35 VSS.t37 5.65692
R170 VSS.n5 VSS.t34 17.0005
R171 VSS.t34 VSS.n7 8.49687
R172 VSS.n7 VSS.n6 0.0092618
R173 VSS.n7 VSS.t33 17.0093
R174 VSS.n5 VSS.t33 8.49535
R175 VSS.t62 VSS.n156 16.6364
R176 VSS.n214 VSS.t84 16.6364
R177 VSS.t109 VSS.n23 12.3005
R178 VSS.t47 VSS.n62 15.0005
R179 VSS.n129 VSS.t39 15.0005
R180 VSS.t43 VSS.n143 15.0005
R181 VSS.t50 VSS.t46 4.99672
R182 VSS.n205 VSS.n49 14.4051
R183 VSS.n190 VSS.n33 14.4051
R184 VSS.n182 VSS.n48 14.4051
R185 VSS.n174 VSS.n50 14.4051
R186 VSS.n151 VSS.n35 14.4051
R187 VSS.t40 VSS.n59 13.3823
R188 VSS.n159 VSS.n52 7.20324
R189 VSS.n37 VSS.n177 14.4051
R190 VSS.n43 VSS.n197 14.4051
R191 VSS.n57 VSS.n200 14.4051
R192 VSS.n41 VSS.n212 14.4051
R193 VSS.n42 VSS.n215 14.4051
R194 VSS.n46 VSS.n218 14.4051
R195 VSS.n12 VSS.t44 7.66709
R196 VSS.t108 VSS.n23 9.77299
R197 VSS.n20 VSS.n226 6777.49
R198 VSS.n20 VSS.t5 16.2716
R199 VSS.n20 VSS.t8 18.7994
R200 VSS.n20 VSS.t10 19.521
R201 VSS.n20 VSS.t13 19.8817
R202 VSS.n20 VSS.t26 14.4652
R203 VSS.t57 VSS.n20 6.87996
R204 VSS.t60 VSS.n152 11.0911
R205 VSS.n217 VSS.t86 11.0911
R206 VSS.n221 VSS.n13 8.5005
R207 VSS.n216 VSS.n13 8.5005
R208 VSS.n214 VSS.n13 8.5005
R209 VSS.n213 VSS.n13 8.5005
R210 VSS.n211 VSS.n13 8.5005
R211 VSS.n198 VSS.n13 8.5005
R212 VSS.n196 VSS.n13 8.5005
R213 VSS.n159 VSS.n13 8.5005
R214 VSS.n157 VSS.n13 8.5005
R215 VSS.t40 VSS.n13 8.5005
R216 VSS.n11 VSS.t46 0.393578
R217 VSS.t46 VSS.n26 0.0416542
R218 VSS.n11 VSS.n90 8.4984
R219 VSS.n11 VSS.n61 8.4984
R220 VSS.n11 VSS.n66 3.39657
R221 VSS.n11 VSS.n87 8.4984
R222 VSS.n69 VSS.n88 0.0180748
R223 VSS.n18 VSS.n70 0.0652329
R224 VSS.n18 VSS.t97 0.0152033
R225 VSS.n11 VSS.n16 0.98338
R226 VSS.n11 VSS.n68 3.39245
R227 VSS.n73 VSS.n89 0.0161786
R228 VSS.n71 VSS.n74 0.0217011
R229 VSS.t48 VSS.n72 0.0217011
R230 VSS.t46 VSS.n19 0.0368446
R231 VSS.n27 VSS.n13 1.87243
R232 VSS.n60 VSS.n13 2.41696
R233 VSS.n61 VSS.n60 0.0126588
R234 VSS.n66 VSS.n65 0.00856708
R235 VSS.n86 VSS.n13 8.4984
R236 VSS.n88 VSS.n13 8.4984
R237 VSS.n14 VSS.n13 1.0396
R238 VSS.n28 VSS.n13 1.40634
R239 VSS.n64 VSS.n28 0.0254884
R240 VSS.n16 VSS.n13 1.04902
R241 VSS.n67 VSS.n16 0.0430256
R242 VSS.n89 VSS.n13 8.4984
R243 VSS.n73 VSS.n74 0.014444
R244 VSS.n71 VSS.n72 0.014444
R245 VSS.n63 VSS.n13 0.777617
R246 VSS.n247 VSS.n78 8.22525
R247 VSS.n121 VSS.n120 8.22525
R248 VSS.n120 VSS.n95 8.22525
R249 VSS.n248 VSS.n247 8.22525
R250 VSS.n23 VSS.t36 6.87897
R251 VSS.n23 VSS.t32 6.87896
R252 VSS.n127 VSS.t47 7.49606
R253 VSS.t39 VSS.n125 7.49606
R254 VSS.n15 VSS.t43 7.49606
R255 VSS.t51 VSS.t46 0.0352176
R256 VSS.t44 VSS.n223 7.20236
R257 VSS.n218 VSS.n217 7.20236
R258 VSS.n210 VSS.n209 7.20236
R259 VSS.n204 VSS.n203 7.20236
R260 VSS.n195 VSS.n194 7.20236
R261 VSS.n193 VSS.n192 7.20236
R262 VSS.n187 VSS.n186 7.20236
R263 VSS.n177 VSS.n176 7.20236
R264 VSS.n170 VSS.n51 14.4051
R265 VSS.n167 VSS.n166 7.20236
R266 VSS.n162 VSS.n54 14.4051
R267 VSS.n161 VSS.n160 7.20236
R268 VSS.n156 VSS.n155 7.20236
R269 VSS.n150 VSS.n149 7.20236
R270 VSS.n148 VSS.n147 7.20236
R271 VSS.n59 VSS.n145 13.8932
R272 VSS.n144 VSS.n30 14.8777
R273 VSS.n145 VSS.n53 14.4051
R274 VSS.n146 VSS.n58 13.8932
R275 VSS.n147 VSS.n31 14.4051
R276 VSS.n152 VSS.n151 7.20236
R277 VSS.n154 VSS.n153 7.20236
R278 VSS.n155 VSS.n36 14.4051
R279 VSS.n158 VSS.n55 14.4051
R280 VSS.n163 VSS.n162 7.20236
R281 VSS.n165 VSS.n164 7.20236
R282 VSS.n166 VSS.n38 14.4051
R283 VSS.n169 VSS.n168 7.20236
R284 VSS.n171 VSS.n170 7.20236
R285 VSS.n173 VSS.n172 7.20236
R286 VSS.n175 VSS.n174 7.20236
R287 VSS.n179 VSS.n178 7.20236
R288 VSS.n181 VSS.n180 7.20236
R289 VSS.n183 VSS.n182 7.20236
R290 VSS.n185 VSS.n184 7.20236
R291 VSS.n186 VSS.n45 14.6209
R292 VSS.n189 VSS.n188 7.20236
R293 VSS.n191 VSS.n190 7.20236
R294 VSS.n194 VSS.n44 14.4051
R295 VSS.n197 VSS.n40 14.4051
R296 VSS.n200 VSS.n199 7.20236
R297 VSS.n202 VSS.n201 7.20236
R298 VSS.n206 VSS.n205 7.20236
R299 VSS.n208 VSS.n207 7.20236
R300 VSS.n209 VSS.n56 14.4051
R301 VSS.n212 VSS.n34 14.4051
R302 VSS.n215 VSS.n32 14.4051
R303 VSS.n220 VSS.n219 7.20236
R304 VSS.n222 VSS.n47 14.4051
R305 VSS.n223 VSS.n39 14.4051
R306 VSS.n225 VSS.n30 1.53281
R307 VSS.n224 VSS.n11 1.70065
R308 VSS.t59 VSS.n148 5.54579
R309 VSS.n221 VSS.t87 5.54579
R310 VSS.n128 VSS.t49 4.5005
R311 VSS.t42 VSS.n124 4.5005
R312 VSS.t51 VSS.n92 4.5005
R313 VSS.t45 VSS.n142 4.5005
R314 VSS.n11 VSS.n63 2.45461
R315 VSS.t97 VSS.n122 4.11287
R316 VSS.t97 VSS.n25 4.11287
R317 VSS.n4 VSS.t56 0.0144953
R318 VSS.n243 VSS.t53 3.0005
R319 VSS.n118 VSS.t31 3.0005
R320 VSS.n126 VSS.n123 3.0005
R321 VSS.n131 VSS.n130 3.0005
R322 VSS.n93 VSS.t46 3.0005
R323 VSS.n141 VSS.n91 3.0005
R324 VSS.n21 VSS.n20 0.0533912
R325 VSS.t7 VSS.n20 17.7155
R326 VSS.t2 VSS.n20 12.2981
R327 VSS.n95 VSS.n94 2.71193
R328 VSS.n250 VSS.n249 2.6297
R329 VSS.n244 VSS.t3 2.4821
R330 VSS.n245 VSS.t6 2.4821
R331 VSS.n246 VSS.t9 2.4821
R332 VSS.n82 VSS.t12 2.4821
R333 VSS.t18 VSS.n81 2.4821
R334 VSS.n83 VSS.t21 2.4821
R335 VSS.n84 VSS.t24 2.4821
R336 VSS.n85 VSS.t27 2.4821
R337 VSS.n1 VSS.t134 2.4821
R338 VSS.n110 VSS.t131 2.4821
R339 VSS.n109 VSS.t128 2.4821
R340 VSS.t125 VSS.n96 2.4821
R341 VSS.t119 VSS.n97 2.4821
R342 VSS.n115 VSS.t116 2.4821
R343 VSS.n116 VSS.t113 2.4821
R344 VSS.n117 VSS.t110 2.4821
R345 VSS.n133 VSS.t89 2.4821
R346 VSS.n133 VSS.t61 2.4821
R347 VSS.n134 VSS.t91 2.4821
R348 VSS.n134 VSS.t64 2.4821
R349 VSS.n135 VSS.t93 2.4821
R350 VSS.n135 VSS.t67 2.4821
R351 VSS.n17 VSS.t95 2.4821
R352 VSS.n17 VSS.t70 2.4821
R353 VSS.n136 VSS.t99 2.4821
R354 VSS.n136 VSS.t76 2.4821
R355 VSS.n137 VSS.t101 2.4821
R356 VSS.n137 VSS.t79 2.4821
R357 VSS.n138 VSS.t103 2.4821
R358 VSS.n138 VSS.t82 2.4821
R359 VSS.n139 VSS.t105 2.4821
R360 VSS.n139 VSS.t85 2.4821
R361 VSS.n12 VSS.n11 0.16648
R362 VSS.n59 VSS.n11 1.20771
R363 VSS.n47 VSS.n11 0.650675
R364 VSS.n42 VSS.n11 0.650675
R365 VSS.n41 VSS.n11 0.650675
R366 VSS.n49 VSS.n11 0.650675
R367 VSS.n33 VSS.n11 0.650675
R368 VSS.n48 VSS.n11 0.650675
R369 VSS.n50 VSS.n11 0.650675
R370 VSS.n52 VSS.n11 0.650675
R371 VSS.n35 VSS.n11 0.650675
R372 VSS.n31 VSS.n11 0.650675
R373 VSS.t40 VSS.n58 13.3823
R374 VSS.t48 VSS.n128 2.2505
R375 VSS.t41 VSS.n124 2.2505
R376 VSS.n92 VSS.t52 2.2505
R377 VSS.n142 VSS.t46 2.2505
R378 VSS.n228 VSS.n20 2.09947
R379 VSS.n230 VSS.n20 2.09947
R380 VSS.n232 VSS.n20 2.09947
R381 VSS.n79 VSS.n20 2.09947
R382 VSS.n234 VSS.n20 2.09947
R383 VSS.n236 VSS.n20 2.09947
R384 VSS.n238 VSS.n20 2.09947
R385 VSS.n240 VSS.n20 2.09947
R386 VSS.n23 VSS.n101 2.09894
R387 VSS.n119 VSS.n23 2.09874
R388 VSS.n23 VSS.n105 2.09868
R389 VSS.n23 VSS.n106 2.09868
R390 VSS.n23 VSS.n102 2.09865
R391 VSS.n23 VSS.n100 2.09859
R392 VSS.n23 VSS.n77 2.09849
R393 VSS.n23 VSS.n104 2.09849
R394 VSS.n225 VSS.n13 1.7005
R395 VSS.n224 VSS.n13 1.53502
R396 VSS.n243 VSS.n8 1.52811
R397 VSS.n6 VSS.n118 1.52811
R398 VSS.n4 VSS.n85 1.21797
R399 VSS.n0 VSS.t35 0.0710118
R400 VSS.t48 VSS.n63 0.0107362
R401 VSS.n75 VSS.n20 0.910042
R402 VSS.n242 VSS.n20 0.91152
R403 VSS.n23 VSS.n22 0.910334
R404 VSS.n23 VSS.n0 0.468597
R405 VSS.n223 VSS.n13 0.650322
R406 VSS.n222 VSS.n13 0.650322
R407 VSS.n219 VSS.n13 0.650322
R408 VSS.n218 VSS.n13 0.650322
R409 VSS.n215 VSS.n13 0.650322
R410 VSS.n212 VSS.n13 0.650322
R411 VSS.n209 VSS.n13 0.650322
R412 VSS.n208 VSS.n13 0.650322
R413 VSS.n205 VSS.n13 0.650322
R414 VSS.n204 VSS.n13 0.650322
R415 VSS.n201 VSS.n13 0.650322
R416 VSS.n200 VSS.n13 0.650322
R417 VSS.n197 VSS.n13 0.650322
R418 VSS.n194 VSS.n13 0.650322
R419 VSS.n193 VSS.n13 0.650322
R420 VSS.n190 VSS.n13 0.650322
R421 VSS.n189 VSS.n13 0.650322
R422 VSS.n186 VSS.n13 0.650322
R423 VSS.n185 VSS.n13 0.650322
R424 VSS.n182 VSS.n13 0.650322
R425 VSS.n181 VSS.n13 0.650322
R426 VSS.n178 VSS.n13 0.650322
R427 VSS.n177 VSS.n13 0.650322
R428 VSS.n174 VSS.n13 0.650322
R429 VSS.n173 VSS.n13 0.650322
R430 VSS.n170 VSS.n13 0.650322
R431 VSS.n169 VSS.n13 0.650322
R432 VSS.n166 VSS.n13 0.650322
R433 VSS.n165 VSS.n13 0.650322
R434 VSS.n162 VSS.n13 0.650322
R435 VSS.n161 VSS.n13 0.650322
R436 VSS.n158 VSS.n13 0.650322
R437 VSS.n155 VSS.n13 0.650322
R438 VSS.n154 VSS.n13 0.650322
R439 VSS.n151 VSS.n13 0.650322
R440 VSS.n150 VSS.n13 0.650322
R441 VSS.n147 VSS.n13 0.650322
R442 VSS.n146 VSS.n13 0.650322
R443 VSS.n145 VSS.n13 0.650322
R444 VSS.n144 VSS.n13 0.650322
R445 VSS.n121 VSS.n94 0.632727
R446 VSS.n251 VSS.n250 0.5505
R447 VSS.n122 VSS.n78 0.2444
R448 VSS.n122 VSS.n121 0.2444
R449 VSS.n248 VSS.n25 0.2444
R450 VSS.n95 VSS.n25 0.2444
R451 VSS.n244 VSS.n243 0.209825
R452 VSS.t35 VSS.n1 1.21075
R453 VSS.n118 VSS.n117 0.209825
R454 VSS.n241 VSS.t3 0.201663
R455 VSS.n239 VSS.t6 0.201663
R456 VSS.n237 VSS.t9 0.201663
R457 VSS.n235 VSS.t12 0.201663
R458 VSS.n233 VSS.t18 0.201663
R459 VSS.n231 VSS.t21 0.201663
R460 VSS.n229 VSS.t24 0.201663
R461 VSS.n227 VSS.t27 0.201663
R462 VSS.t134 VSS.n111 0.201663
R463 VSS.t131 VSS.n107 0.201663
R464 VSS.t128 VSS.n108 0.201663
R465 VSS.n103 VSS.t125 0.201663
R466 VSS.n99 VSS.t119 0.201663
R467 VSS.t116 VSS.n114 0.201663
R468 VSS.t113 VSS.n113 0.201663
R469 VSS.t110 VSS.n112 0.201663
R470 VSS.n67 VSS.t89 0.201663
R471 VSS.t61 VSS.n67 0.201663
R472 VSS.n16 VSS.t91 0.201663
R473 VSS.t64 VSS.n16 0.201663
R474 VSS.n64 VSS.t93 0.201663
R475 VSS.t67 VSS.n64 0.201663
R476 VSS.n29 VSS.t95 0.201663
R477 VSS.t70 VSS.n29 0.201663
R478 VSS.n70 VSS.t99 0.201663
R479 VSS.t76 VSS.n70 0.201663
R480 VSS.n65 VSS.t101 0.201663
R481 VSS.t79 VSS.n65 0.201663
R482 VSS.n26 VSS.t103 0.201663
R483 VSS.t82 VSS.n26 0.201663
R484 VSS.t46 VSS.t105 0.201663
R485 VSS.t85 VSS.t46 0.201663
R486 VSS.t73 VSS.t97 0.185696
R487 VSS.n245 VSS.n244 0.16242
R488 VSS.n246 VSS.n245 0.16242
R489 VSS.n82 VSS.n246 0.16242
R490 VSS.n80 VSS.n82 0.16242
R491 VSS.n80 VSS.n81 0.16242
R492 VSS.n83 VSS.n81 0.16242
R493 VSS.n84 VSS.n83 0.16242
R494 VSS.n85 VSS.n84 0.16242
R495 VSS.n117 VSS.n116 0.16242
R496 VSS.n116 VSS.n115 0.16242
R497 VSS.n115 VSS.n97 0.16242
R498 VSS.n98 VSS.n97 0.16242
R499 VSS.n98 VSS.n96 0.16242
R500 VSS.n109 VSS.n96 0.16242
R501 VSS.n110 VSS.n109 0.16242
R502 VSS.n1 VSS.n110 0.16242
R503 VSS.n111 VSS.n0 0.20477
R504 VSS.n112 VSS.n22 0.145358
R505 VSS.n242 VSS.n241 0.144129
R506 VSS.n133 VSS.n132 0.117247
R507 VSS.n140 VSS.n139 0.1171
R508 VSS.n241 VSS.n240 0.0952183
R509 VSS.n112 VSS.n100 0.0936249
R510 VSS.n111 VSS.n106 0.0935007
R511 VSS.n239 VSS.n238 0.0927738
R512 VSS.n228 VSS.n227 0.0925656
R513 VSS.n113 VSS.n101 0.0921362
R514 VSS.n107 VSS.n105 0.0910563
R515 VSS.n237 VSS.n236 0.0903294
R516 VSS.t15 VSS.n79 0.0903294
R517 VSS.n230 VSS.n229 0.0901212
R518 VSS.n114 VSS.n102 0.0891874
R519 VSS.n108 VSS.n104 0.0891801
R520 VSS.t122 VSS.n77 0.0889922
R521 VSS.t122 VSS.n119 0.0885493
R522 VSS.n235 VSS.n234 0.0878849
R523 VSS.n233 VSS.n232 0.0878849
R524 VSS.n234 VSS.t15 0.0876767
R525 VSS.n232 VSS.n231 0.0876767
R526 VSS.n119 VSS.n99 0.086995
R527 VSS.n103 VSS.n77 0.0865477
R528 VSS.n102 VSS.n99 0.0863606
R529 VSS.n104 VSS.n103 0.0863554
R530 VSS.n231 VSS.n230 0.0854405
R531 VSS.n236 VSS.n235 0.0852323
R532 VSS.n79 VSS.n233 0.0852323
R533 VSS.t53 VSS.n242 0.0847768
R534 VSS.n108 VSS.n105 0.0844861
R535 VSS.t31 VSS.n22 0.0834709
R536 VSS.n114 VSS.n101 0.0834106
R537 VSS.n229 VSS.n228 0.082996
R538 VSS.n238 VSS.n237 0.0827878
R539 VSS.n251 VSS.n78 0.0827273
R540 VSS.n249 VSS.n248 0.0827273
R541 VSS.n107 VSS.n106 0.0820417
R542 VSS.n227 VSS.n75 0.148049
R543 VSS.n113 VSS.n100 0.0819112
R544 VSS.n134 VSS.n133 0.08146
R545 VSS.n135 VSS.n134 0.08146
R546 VSS.n17 VSS.n135 0.08146
R547 VSS.t97 VSS.n17 0.08146
R548 VSS.n136 VSS.t97 0.08146
R549 VSS.n137 VSS.n136 0.08146
R550 VSS.n138 VSS.n137 0.08146
R551 VSS.n139 VSS.n138 0.08146
R552 VSS.n240 VSS.n239 0.0803434
R553 VSS.n11 VSS.t41 1.05281
R554 VSS.n250 VSS 0.0445
R555 VSS.n94 VSS 0.0445
R556 VSS.n98 VSS.t122 0.0394179
R557 VSS.t15 VSS.n80 0.0394179
R558 VSS.n247 VSS.n80 0.0389615
R559 VSS.n120 VSS.n98 0.0389615
R560 VSS.t49 VSS.n127 0.031258
R561 VSS.n125 VSS.t42 0.031258
R562 VSS.n132 VSS.n131 0.0291125
R563 VSS.n140 VSS.n93 0.0291125
R564 VSS.n141 VSS.n140 0.0291125
R565 VSS.n132 VSS.n123 0.0291125
R566 VSS.n131 VSS.n124 0.0281144
R567 VSS.n93 VSS.n92 0.0281144
R568 VSS.n142 VSS.n141 0.0281144
R569 VSS.n128 VSS.n123 0.0281144
R570 VSS.n143 VSS.t45 0.0208704
R571 VSS.n126 VSS.n62 0.0202884
R572 VSS.n130 VSS.n129 0.0202884
R573 VSS.n143 VSS.n91 0.0202884
R574 VSS.t53 VSS.n9 0.0204855
R575 VSS.n5 VSS.t31 0.0133922
R576 VSS.n86 VSS.n66 0.021722
R577 VSS.n88 VSS.n87 0.0118857
R578 VSS.n70 VSS.n69 0.00668905
R579 VSS.n89 VSS.n68 0.0296359
R580 VSS.n87 VSS.n86 0.0118857
R581 VSS.n90 VSS.n60 0.0415948
R582 VSS.n27 VSS.n90 0.0494353
R583 VSS.t48 VSS.n62 0.0115582
R584 VSS.n129 VSS.t48 0.0115582
R585 VSS.n24 VSS.t123 19.5043
R586 VSS.n23 VSS.t127 19.5212
R587 VSS.n23 VSS.t135 12.2976
R588 VSS.n13 VSS.n19 0.622137
R589 VSS.t46 VSS.n15 0.176023
R590 VSS.t97 VSS.n14 0.175531
R591 VSS.n16 VSS.n64 0.164697
R592 VSS.n11 VSS.n30 0.145765
R593 VSS.n127 VSS.n126 0.0108877
R594 VSS.n130 VSS.n125 0.0108877
R595 VSS.n15 VSS.n91 0.0108877
R596 VSS.n19 VSS.t52 0.0259898
R597 VSS.t48 VSS.t41 0.00981217
R598 VSS VSS.n251 0.0095
R599 VSS.n249 VSS 0.0095
R600 VSS.n75 VSS.t56 0.0818274
R601 VSS.n9 VSS.n8 0.0170266
R602 VSS.n4 VSS.n2 0.00787189
R603 VSS.n6 VSS.n5 0.0241048
R604 VSS.n3 VSS.n20 1.11564
C15 vout1 VSS 5.54899f
C16 vin1 VSS 16.0542f
C17 vout2 VSS 5.54814f
C18 vin2 VSS 16.0189f
C19 vout3 VSS 5.54814f
C20 vin3 VSS 16.0189f
C21 vout4 VSS 5.54899f
C22 vin4 VSS 16.0542f
C23 VDD VSS 21.8873f
.ends

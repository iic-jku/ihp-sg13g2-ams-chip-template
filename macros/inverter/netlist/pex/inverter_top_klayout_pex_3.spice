* NGSPICE file created from inverter_top_pex.ext - technology: ihp-sg13g2

.subckt inverter_top_pex VDD vin4 vout4 VSS vin3 vout3 vin2 vout2 vout1 vin1
X0 vout3 vin3 VSS.t105 VSS.t86 sg13_lv_nmos ad=0.19p pd=1.38u as=0.19p ps=1.38u w=1u l=1u
X1 VDD VDD VDD VDD sg13_lv_pmos ad=1.14p pd=6.38u as=0.56797n ps=1.006m w=6u l=1u
X2 VSS.t1 VSS.t53 VSS.t55 VSS.t54 sg13_lv_nmos ad=0.34p pd=2.68u as=0 ps=0 w=1u l=1u
X3 VDD VDD VDD VDD sg13_lv_pmos ad=1.14p pd=6.38u as=0 ps=0 w=6u l=1u
X4 VDD vin4 vout4 VDD sg13_lv_pmos ad=1.14p pd=6.38u as=1.14p ps=6.38u w=6u l=1u
X5 vout2 vin2 VSS.t76 VSS.t77 sg13_lv_nmos ad=0.19p pd=1.38u as=0.19p ps=1.38u w=1u l=1u
X6 vout3 vin3 VDD VDD sg13_lv_pmos ad=1.14p pd=6.38u as=1.14p ps=6.38u w=6u l=1u
X7 vout4 vin4 VSS.t110 VSS.t111 sg13_lv_nmos ad=0.19p pd=1.38u as=0.19p ps=1.38u w=1u l=1u
X8 vout3 vin3 VSS.t42 VSS.t59 sg13_lv_nmos ad=0.19p pd=1.38u as=0.19p ps=1.38u w=1u l=1u
X9 vout2 vin2 VSS.t70 VSS.t71 sg13_lv_nmos ad=0.19p pd=1.38u as=0.19p ps=1.38u w=1u l=1u
X10 vout4 vin4 VDD VDD sg13_lv_pmos ad=1.14p pd=6.38u as=1.14p ps=6.38u w=6u l=1u
X11 VDD vin2 vout2 VDD sg13_lv_pmos ad=1.14p pd=6.38u as=1.14p ps=6.38u w=6u l=1u
X12 VSS.t76 vin2 vout2 VSS.t75 sg13_lv_nmos ad=0.19p pd=1.38u as=0.19p ps=1.38u w=1u l=1u
X13 vout2 vin2 VSS.t79 VSS.t80 sg13_lv_nmos ad=0.19p pd=1.38u as=0.19p ps=1.38u w=1u l=1u
X14 vout2 vin2 VDD VDD sg13_lv_pmos ad=1.14p pd=6.38u as=1.14p ps=6.38u w=6u l=1u
X15 VSS.t116 vin4 vout4 VSS.t115 sg13_lv_nmos ad=0.19p pd=1.38u as=0.19p ps=1.38u w=1u l=1u
X16 vout1 vin1 VSS.t24 VSS.t25 sg13_lv_nmos ad=0.19p pd=1.38u as=0.19p ps=1.38u w=1u l=1u
X17 VDD vin2 vout2 VDD sg13_lv_pmos ad=1.14p pd=6.38u as=1.14p ps=6.38u w=6u l=1u
X18 vout4 vin4 VSS.t34 VSS.t108 sg13_lv_nmos ad=0.19p pd=1.38u as=0.19p ps=1.38u w=1u l=1u
X19 VDD vin2 vout2 VDD sg13_lv_pmos ad=1.14p pd=6.38u as=1.14p ps=6.38u w=6u l=1u
X20 VSS.t105 vin3 vout3 VSS.t84 sg13_lv_nmos ad=0.19p pd=1.38u as=0.19p ps=1.38u w=1u l=1u
X21 vout4 vin4 VSS.t125 VSS.t126 sg13_lv_nmos ad=0.19p pd=1.38u as=0.19p ps=1.38u w=1u l=1u
X22 VSS.t119 vin4 vout4 VSS.t118 sg13_lv_nmos ad=0.19p pd=1.38u as=0.19p ps=1.38u w=1u l=1u
X23 VDD vin3 vout3 VDD sg13_lv_pmos ad=1.14p pd=6.38u as=1.14p ps=6.38u w=6u l=1u
X24 VDD vin2 vout2 VDD sg13_lv_pmos ad=1.14p pd=6.38u as=1.14p ps=6.38u w=6u l=1u
X25 vout3 vin3 VDD VDD sg13_lv_pmos ad=1.14p pd=6.38u as=1.14p ps=6.38u w=6u l=1u
X26 VSS.t70 vin2 vout2 VSS.t69 sg13_lv_nmos ad=0.19p pd=1.38u as=0.19p ps=1.38u w=1u l=1u
X27 VDD vin3 vout3 VDD sg13_lv_pmos ad=1.14p pd=6.38u as=1.14p ps=6.38u w=6u l=1u
X28 VSS.t42 VSS.t39 VSS.t41 VSS.t40 sg13_lv_nmos ad=0.34p pd=2.68u as=0 ps=0 w=1u l=1u
X29 vout2 vin2 VDD VDD sg13_lv_pmos ad=1.14p pd=6.38u as=1.14p ps=6.38u w=6u l=1u
X30 vout2 vin2 VSS.t73 VSS.t74 sg13_lv_nmos ad=0.19p pd=1.38u as=0.19p ps=1.38u w=1u l=1u
X31 vout1 vin1 VSS.t18 VSS.t19 sg13_lv_nmos ad=0.19p pd=1.38u as=0.19p ps=1.38u w=1u l=1u
X32 VSS.t79 vin2 vout2 VSS.t78 sg13_lv_nmos ad=0.19p pd=1.38u as=0.19p ps=1.38u w=1u l=1u
X33 vout4 vin4 VSS.t122 VSS.t123 sg13_lv_nmos ad=0.19p pd=1.38u as=0.19p ps=1.38u w=1u l=1u
X34 vout1 vin1 VDD VDD sg13_lv_pmos ad=1.14p pd=6.38u as=1.14p ps=6.38u w=6u l=1u
X35 vout1 vin1 VSS.t12 VSS.t13 sg13_lv_nmos ad=0.19p pd=1.38u as=0.19p ps=1.38u w=1u l=1u
X36 VSS.t128 vin4 vout4 VSS.t127 sg13_lv_nmos ad=0.19p pd=1.38u as=0.19p ps=1.38u w=1u l=1u
X37 VDD VDD VDD VDD sg13_lv_pmos ad=1.14p pd=6.38u as=0 ps=0 w=6u l=1u
X38 VSS.t18 vin1 vout1 VSS.t17 sg13_lv_nmos ad=0.19p pd=1.38u as=0.19p ps=1.38u w=1u l=1u
X39 vout2 vin2 VDD VDD sg13_lv_pmos ad=1.14p pd=6.38u as=1.14p ps=6.38u w=6u l=1u
X40 VDD vin4 vout4 VDD sg13_lv_pmos ad=1.14p pd=6.38u as=1.14p ps=6.38u w=6u l=1u
X41 vout1 vin1 VSS.t21 VSS.t22 sg13_lv_nmos ad=0.19p pd=1.38u as=0.19p ps=1.38u w=1u l=1u
X42 vout3 vin3 VSS.t103 VSS.t83 sg13_lv_nmos ad=0.19p pd=1.38u as=0.19p ps=1.38u w=1u l=1u
X43 VDD vin3 vout3 VDD sg13_lv_pmos ad=1.14p pd=6.38u as=1.14p ps=6.38u w=6u l=1u
X44 vout4 vin4 VDD VDD sg13_lv_pmos ad=1.14p pd=6.38u as=1.14p ps=6.38u w=6u l=1u
X45 VDD vin4 vout4 VDD sg13_lv_pmos ad=1.14p pd=6.38u as=1.14p ps=6.38u w=6u l=1u
X46 vout3 vin3 VDD VDD sg13_lv_pmos ad=1.14p pd=6.38u as=1.14p ps=6.38u w=6u l=1u
X47 VDD vin3 vout3 VDD sg13_lv_pmos ad=1.14p pd=6.38u as=1.14p ps=6.38u w=6u l=1u
X48 VSS.t38 VSS.t35 VSS.t37 VSS.t36 sg13_lv_nmos ad=0.19p pd=1.38u as=0 ps=0 w=1u l=1u
X49 VDD vin4 vout4 VDD sg13_lv_pmos ad=1.14p pd=6.38u as=1.14p ps=6.38u w=6u l=1u
X50 VDD vin2 vout2 VDD sg13_lv_pmos ad=1.14p pd=6.38u as=1.14p ps=6.38u w=6u l=1u
X51 VSS.t131 vin4 vout4 VSS.t130 sg13_lv_nmos ad=0.19p pd=1.38u as=0.19p ps=1.38u w=1u l=1u
X52 VDD vin3 vout3 VDD sg13_lv_pmos ad=1.14p pd=6.38u as=1.14p ps=6.38u w=6u l=1u
X53 VSS.t12 vin1 vout1 VSS.t11 sg13_lv_nmos ad=0.19p pd=1.38u as=0.19p ps=1.38u w=1u l=1u
X54 VDD vin1 vout1 VDD sg13_lv_pmos ad=1.14p pd=6.38u as=1.14p ps=6.38u w=6u l=1u
X55 vout4 vin4 VSS.t134 VSS.t135 sg13_lv_nmos ad=0.19p pd=1.38u as=0.19p ps=1.38u w=1u l=1u
X56 vout1 vin1 VDD VDD sg13_lv_pmos ad=1.14p pd=6.38u as=1.14p ps=6.38u w=6u l=1u
X57 vout4 vin4 VDD VDD sg13_lv_pmos ad=1.14p pd=6.38u as=1.14p ps=6.38u w=6u l=1u
X58 vout1 vin1 VSS.t15 VSS.t16 sg13_lv_nmos ad=0.19p pd=1.38u as=0.19p ps=1.38u w=1u l=1u
X59 VDD vin1 vout1 VDD sg13_lv_pmos ad=1.14p pd=6.38u as=1.14p ps=6.38u w=6u l=1u
X60 vout3 vin3 VSS.t99 VSS.t77 sg13_lv_nmos ad=0.19p pd=1.38u as=0.19p ps=1.38u w=1u l=1u
X61 VSS.t21 vin1 vout1 VSS.t20 sg13_lv_nmos ad=0.19p pd=1.38u as=0.19p ps=1.38u w=1u l=1u
X62 VDD VDD VDD VDD sg13_lv_pmos ad=2.04p pd=12.68u as=0 ps=0 w=6u l=1u
X63 vout4 vin4 VDD VDD sg13_lv_pmos ad=1.14p pd=6.38u as=1.14p ps=6.38u w=6u l=1u
X64 VDD vin3 vout3 VDD sg13_lv_pmos ad=1.14p pd=6.38u as=1.14p ps=6.38u w=6u l=1u
X65 VDD vin4 vout4 VDD sg13_lv_pmos ad=1.14p pd=6.38u as=1.14p ps=6.38u w=6u l=1u
X66 vout3 vin3 VDD VDD sg13_lv_pmos ad=1.14p pd=6.38u as=1.14p ps=6.38u w=6u l=1u
X67 vout3 vin3 VSS.t95 VSS.t71 sg13_lv_nmos ad=0.19p pd=1.38u as=0.19p ps=1.38u w=1u l=1u
X68 VSS.t99 vin3 vout3 VSS.t75 sg13_lv_nmos ad=0.19p pd=1.38u as=0.19p ps=1.38u w=1u l=1u
X69 VDD VDD VDD VDD sg13_lv_pmos ad=1.14p pd=6.38u as=0 ps=0 w=6u l=1u
X70 vout3 vin3 VSS.t101 VSS.t80 sg13_lv_nmos ad=0.19p pd=1.38u as=0.19p ps=1.38u w=1u l=1u
X71 vout4 vin4 VDD VDD sg13_lv_pmos ad=1.14p pd=6.38u as=1.14p ps=6.38u w=6u l=1u
X72 vout3 vin3 VDD VDD sg13_lv_pmos ad=1.14p pd=6.38u as=1.14p ps=6.38u w=6u l=1u
X73 VDD vin1 vout1 VDD sg13_lv_pmos ad=1.14p pd=6.38u as=1.14p ps=6.38u w=6u l=1u
X74 vout2 vin2 VDD VDD sg13_lv_pmos ad=1.14p pd=6.38u as=1.14p ps=6.38u w=6u l=1u
X75 vout1 vin1 VDD VDD sg13_lv_pmos ad=1.14p pd=6.38u as=1.14p ps=6.38u w=6u l=1u
X76 vout2 vin2 VSS.t64 VSS.t65 sg13_lv_nmos ad=0.19p pd=1.38u as=0.19p ps=1.38u w=1u l=1u
X77 VDD vin1 vout1 VDD sg13_lv_pmos ad=1.14p pd=6.38u as=1.14p ps=6.38u w=6u l=1u
X78 VDD vin1 vout1 VDD sg13_lv_pmos ad=1.14p pd=6.38u as=1.14p ps=6.38u w=6u l=1u
X79 VDD vin3 vout3 VDD sg13_lv_pmos ad=1.14p pd=6.38u as=1.14p ps=6.38u w=6u l=1u
X80 VSS.t95 vin3 vout3 VSS.t69 sg13_lv_nmos ad=0.19p pd=1.38u as=0.19p ps=1.38u w=1u l=1u
X81 vout3 vin3 VSS.t97 VSS.t74 sg13_lv_nmos ad=0.19p pd=1.38u as=0.19p ps=1.38u w=1u l=1u
X82 VSS.t113 vin4 vout4 VSS.t112 sg13_lv_nmos ad=0.19p pd=1.38u as=0.19p ps=1.38u w=1u l=1u
X83 VDD vin4 vout4 VDD sg13_lv_pmos ad=1.14p pd=6.38u as=1.14p ps=6.38u w=6u l=1u
X84 VSS.t101 vin3 vout3 VSS.t78 sg13_lv_nmos ad=0.19p pd=1.38u as=0.19p ps=1.38u w=1u l=1u
X85 vout4 vin4 VSS.t116 VSS.t117 sg13_lv_nmos ad=0.19p pd=1.38u as=0.19p ps=1.38u w=1u l=1u
X86 VDD vin1 vout1 VDD sg13_lv_pmos ad=1.14p pd=6.38u as=1.14p ps=6.38u w=6u l=1u
X87 vout2 vin2 VDD VDD sg13_lv_pmos ad=1.14p pd=6.38u as=1.14p ps=6.38u w=6u l=1u
X88 vout1 vin1 VDD VDD sg13_lv_pmos ad=1.14p pd=6.38u as=1.14p ps=6.38u w=6u l=1u
X89 VSS.t110 vin4 vout4 VSS.t109 sg13_lv_nmos ad=0.19p pd=1.38u as=0.19p ps=1.38u w=1u l=1u
X90 VDD VDD VDD VDD sg13_lv_pmos ad=2.04p pd=12.68u as=0 ps=0 w=6u l=1u
X91 vout2 vin2 VDD VDD sg13_lv_pmos ad=1.14p pd=6.38u as=1.14p ps=6.38u w=6u l=1u
X92 VDD vin2 vout2 VDD sg13_lv_pmos ad=1.14p pd=6.38u as=1.14p ps=6.38u w=6u l=1u
X93 VSS.t64 vin2 vout2 VSS.t63 sg13_lv_nmos ad=0.19p pd=1.38u as=0.19p ps=1.38u w=1u l=1u
X94 VSS.t122 vin4 vout4 VSS.t121 sg13_lv_nmos ad=0.19p pd=1.38u as=0.19p ps=1.38u w=1u l=1u
X95 vout2 vin2 VDD VDD sg13_lv_pmos ad=1.14p pd=6.38u as=1.14p ps=6.38u w=6u l=1u
X96 VDD VDD VDD VDD sg13_lv_pmos ad=2.04p pd=12.68u as=0 ps=0 w=6u l=1u
X97 vout2 vin2 VSS.t67 VSS.t68 sg13_lv_nmos ad=0.19p pd=1.38u as=0.19p ps=1.38u w=1u l=1u
X98 VSS.t73 vin2 vout2 VSS.t72 sg13_lv_nmos ad=0.19p pd=1.38u as=0.19p ps=1.38u w=1u l=1u
X99 vout1 vin1 VDD VDD sg13_lv_pmos ad=1.14p pd=6.38u as=1.14p ps=6.38u w=6u l=1u
X100 vout1 vin1 VSS.t6 VSS.t7 sg13_lv_nmos ad=0.19p pd=1.38u as=0.19p ps=1.38u w=1u l=1u
X101 vout4 vin4 VSS.t119 VSS.t120 sg13_lv_nmos ad=0.19p pd=1.38u as=0.19p ps=1.38u w=1u l=1u
X102 vout3 vin3 VDD VDD sg13_lv_pmos ad=1.14p pd=6.38u as=1.14p ps=6.38u w=6u l=1u
X103 vout4 vin4 VSS.t131 VSS.t132 sg13_lv_nmos ad=0.19p pd=1.38u as=0.19p ps=1.38u w=1u l=1u
X104 VSS.t52 VSS.t50 VSS.t51 VSS.t44 sg13_lv_nmos ad=0.19p pd=1.38u as=0 ps=0 w=1u l=1u
X105 VSS.t125 vin4 vout4 VSS.t124 sg13_lv_nmos ad=0.19p pd=1.38u as=0.19p ps=1.38u w=1u l=1u
X106 VDD vin1 vout1 VDD sg13_lv_pmos ad=1.14p pd=6.38u as=1.14p ps=6.38u w=6u l=1u
X107 VSS.t51 vin2 vout2 VSS.t87 sg13_lv_nmos ad=0.19p pd=1.38u as=0.19p ps=1.38u w=1u l=1u
X108 VDD vin2 vout2 VDD sg13_lv_pmos ad=1.14p pd=6.38u as=1.14p ps=6.38u w=6u l=1u
X109 vout4 vin4 VSS.t128 VSS.t129 sg13_lv_nmos ad=0.19p pd=1.38u as=0.19p ps=1.38u w=1u l=1u
X110 vout4 vin4 VDD VDD sg13_lv_pmos ad=1.14p pd=6.38u as=1.14p ps=6.38u w=6u l=1u
X111 vout2 vin2 VDD VDD sg13_lv_pmos ad=1.14p pd=6.38u as=1.14p ps=6.38u w=6u l=1u
X112 vout2 vin2 VSS.t61 VSS.t62 sg13_lv_nmos ad=0.19p pd=1.38u as=0.19p ps=1.38u w=1u l=1u
X113 VDD vin2 vout2 VDD sg13_lv_pmos ad=1.14p pd=6.38u as=1.14p ps=6.38u w=6u l=1u
X114 VSS.t67 vin2 vout2 VSS.t66 sg13_lv_nmos ad=0.19p pd=1.38u as=0.19p ps=1.38u w=1u l=1u
X115 VDD vin4 vout4 VDD sg13_lv_pmos ad=1.14p pd=6.38u as=1.14p ps=6.38u w=6u l=1u
X116 VDD VDD VDD VDD sg13_lv_pmos ad=2.04p pd=12.68u as=0 ps=0 w=6u l=1u
X117 VSS.t61 vin2 vout2 VSS.t60 sg13_lv_nmos ad=0.19p pd=1.38u as=0.19p ps=1.38u w=1u l=1u
X118 VSS.t6 vin1 vout1 VSS.t5 sg13_lv_nmos ad=0.19p pd=1.38u as=0.19p ps=1.38u w=1u l=1u
X119 vout3 vin3 VDD VDD sg13_lv_pmos ad=1.14p pd=6.38u as=1.14p ps=6.38u w=6u l=1u
X120 vout1 vin1 VSS.t9 VSS.t10 sg13_lv_nmos ad=0.19p pd=1.38u as=0.19p ps=1.38u w=1u l=1u
X121 VSS.t15 vin1 vout1 VSS.t14 sg13_lv_nmos ad=0.19p pd=1.38u as=0.19p ps=1.38u w=1u l=1u
X122 vout3 vin3 VDD VDD sg13_lv_pmos ad=1.14p pd=6.38u as=1.14p ps=6.38u w=6u l=1u
X123 VDD vin3 vout3 VDD sg13_lv_pmos ad=1.14p pd=6.38u as=1.14p ps=6.38u w=6u l=1u
X124 vout3 vin3 VDD VDD sg13_lv_pmos ad=1.14p pd=6.38u as=1.14p ps=6.38u w=6u l=1u
X125 vout3 vin3 VSS.t91 VSS.t65 sg13_lv_nmos ad=0.19p pd=1.38u as=0.19p ps=1.38u w=1u l=1u
X126 VSS.t82 vin2 vout2 VSS.t81 sg13_lv_nmos ad=0.19p pd=1.38u as=0.19p ps=1.38u w=1u l=1u
X127 vout1 vin1 VDD VDD sg13_lv_pmos ad=1.14p pd=6.38u as=1.14p ps=6.38u w=6u l=1u
X128 vout2 vin2 VSS.t85 VSS.t86 sg13_lv_nmos ad=0.19p pd=1.38u as=0.19p ps=1.38u w=1u l=1u
X129 VSS.t37 vin4 vout4 VSS.t136 sg13_lv_nmos ad=0.19p pd=1.38u as=0.19p ps=1.38u w=1u l=1u
X130 VSS.t58 VSS.t56 VSS.t30 VSS.t57 sg13_lv_nmos ad=0.19p pd=1.38u as=0 ps=0 w=1u l=1u
X131 VSS.t30 vin1 vout1 VSS.t29 sg13_lv_nmos ad=0.19p pd=1.38u as=0.19p ps=1.38u w=1u l=1u
X132 vout2 vin2 VSS.t49 VSS.t59 sg13_lv_nmos ad=0.19p pd=1.38u as=0.19p ps=1.38u w=1u l=1u
X133 VSS.t34 VSS.t31 VSS.t33 VSS.t32 sg13_lv_nmos ad=0.34p pd=2.68u as=0 ps=0 w=1u l=1u
X134 vout1 vin1 VSS.t3 VSS.t4 sg13_lv_nmos ad=0.19p pd=1.38u as=0.19p ps=1.38u w=1u l=1u
X135 VSS.t9 vin1 vout1 VSS.t8 sg13_lv_nmos ad=0.19p pd=1.38u as=0.19p ps=1.38u w=1u l=1u
X136 VDD vin3 vout3 VDD sg13_lv_pmos ad=1.14p pd=6.38u as=1.14p ps=6.38u w=6u l=1u
X137 VSS.t3 vin1 vout1 VSS.t2 sg13_lv_nmos ad=0.19p pd=1.38u as=0.19p ps=1.38u w=1u l=1u
X138 vout4 vin4 VDD VDD sg13_lv_pmos ad=1.14p pd=6.38u as=1.14p ps=6.38u w=6u l=1u
X139 vout3 vin3 VDD VDD sg13_lv_pmos ad=1.14p pd=6.38u as=1.14p ps=6.38u w=6u l=1u
X140 VDD vin3 vout3 VDD sg13_lv_pmos ad=1.14p pd=6.38u as=1.14p ps=6.38u w=6u l=1u
X141 VSS.t91 vin3 vout3 VSS.t63 sg13_lv_nmos ad=0.19p pd=1.38u as=0.19p ps=1.38u w=1u l=1u
X142 vout3 vin3 VSS.t93 VSS.t68 sg13_lv_nmos ad=0.19p pd=1.38u as=0.19p ps=1.38u w=1u l=1u
X143 vout1 vin1 VDD VDD sg13_lv_pmos ad=1.14p pd=6.38u as=1.14p ps=6.38u w=6u l=1u
X144 VSS.t85 vin2 vout2 VSS.t84 sg13_lv_nmos ad=0.19p pd=1.38u as=0.19p ps=1.38u w=1u l=1u
X145 VSS.t97 vin3 vout3 VSS.t72 sg13_lv_nmos ad=0.19p pd=1.38u as=0.19p ps=1.38u w=1u l=1u
X146 VDD vin4 vout4 VDD sg13_lv_pmos ad=1.14p pd=6.38u as=1.14p ps=6.38u w=6u l=1u
X147 vout1 vin1 VDD VDD sg13_lv_pmos ad=1.14p pd=6.38u as=1.14p ps=6.38u w=6u l=1u
X148 VDD vin1 vout1 VDD sg13_lv_pmos ad=1.14p pd=6.38u as=1.14p ps=6.38u w=6u l=1u
X149 vout4 vin4 VDD VDD sg13_lv_pmos ad=1.14p pd=6.38u as=1.14p ps=6.38u w=6u l=1u
X150 VSS.t24 vin1 vout1 VSS.t23 sg13_lv_nmos ad=0.19p pd=1.38u as=0.19p ps=1.38u w=1u l=1u
X151 vout1 vin1 VSS.t27 VSS.t28 sg13_lv_nmos ad=0.19p pd=1.38u as=0.19p ps=1.38u w=1u l=1u
X152 vout1 vin1 VDD VDD sg13_lv_pmos ad=1.14p pd=6.38u as=1.14p ps=6.38u w=6u l=1u
X153 vout2 vin2 VDD VDD sg13_lv_pmos ad=1.14p pd=6.38u as=1.14p ps=6.38u w=6u l=1u
X154 vout4 vin4 VSS.t113 VSS.t114 sg13_lv_nmos ad=0.19p pd=1.38u as=0.19p ps=1.38u w=1u l=1u
X155 VSS.t49 VSS.t47 VSS.t48 VSS.t40 sg13_lv_nmos ad=0.34p pd=2.68u as=0 ps=0 w=1u l=1u
X156 VSS.t46 VSS.t43 VSS.t45 VSS.t44 sg13_lv_nmos ad=0.19p pd=1.38u as=0 ps=0 w=1u l=1u
X157 vout4 vin4 VDD VDD sg13_lv_pmos ad=1.14p pd=6.38u as=1.14p ps=6.38u w=6u l=1u
X158 VSS.t45 vin3 vout3 VSS.t87 sg13_lv_nmos ad=0.19p pd=1.38u as=0.19p ps=1.38u w=1u l=1u
X159 VSS.t134 vin4 vout4 VSS.t133 sg13_lv_nmos ad=0.19p pd=1.38u as=0.19p ps=1.38u w=1u l=1u
X160 VDD vin4 vout4 VDD sg13_lv_pmos ad=1.14p pd=6.38u as=1.14p ps=6.38u w=6u l=1u
X161 vout1 vin1 VSS.t1 VSS.t0 sg13_lv_nmos ad=0.19p pd=1.38u as=0.19p ps=1.38u w=1u l=1u
X162 vout3 vin3 VSS.t89 VSS.t62 sg13_lv_nmos ad=0.19p pd=1.38u as=0.19p ps=1.38u w=1u l=1u
X163 VSS.t93 vin3 vout3 VSS.t66 sg13_lv_nmos ad=0.19p pd=1.38u as=0.19p ps=1.38u w=1u l=1u
X164 vout4 vin4 VDD VDD sg13_lv_pmos ad=1.14p pd=6.38u as=1.14p ps=6.38u w=6u l=1u
X165 vout2 vin2 VSS.t82 VSS.t83 sg13_lv_nmos ad=0.19p pd=1.38u as=0.19p ps=1.38u w=1u l=1u
X166 VSS.t89 vin3 vout3 VSS.t60 sg13_lv_nmos ad=0.19p pd=1.38u as=0.19p ps=1.38u w=1u l=1u
X167 VDD vin1 vout1 VDD sg13_lv_pmos ad=1.14p pd=6.38u as=1.14p ps=6.38u w=6u l=1u
X168 vout1 vin1 VDD VDD sg13_lv_pmos ad=1.14p pd=6.38u as=1.14p ps=6.38u w=6u l=1u
X169 VDD vin1 vout1 VDD sg13_lv_pmos ad=1.14p pd=6.38u as=1.14p ps=6.38u w=6u l=1u
X170 VDD vin4 vout4 VDD sg13_lv_pmos ad=1.14p pd=6.38u as=1.14p ps=6.38u w=6u l=1u
X171 VSS.t27 vin1 vout1 VSS.t26 sg13_lv_nmos ad=0.19p pd=1.38u as=0.19p ps=1.38u w=1u l=1u
X172 VDD vin2 vout2 VDD sg13_lv_pmos ad=1.14p pd=6.38u as=1.14p ps=6.38u w=6u l=1u
X173 vout2 vin2 VDD VDD sg13_lv_pmos ad=1.14p pd=6.38u as=1.14p ps=6.38u w=6u l=1u
X174 VDD vin2 vout2 VDD sg13_lv_pmos ad=1.14p pd=6.38u as=1.14p ps=6.38u w=6u l=1u
X175 VSS.t103 vin3 vout3 VSS.t81 sg13_lv_nmos ad=0.19p pd=1.38u as=0.19p ps=1.38u w=1u l=1u
C0 VDD vin4 29.2329f
C1 vout4 VDD 15.3949f
C2 vout2 VDD 15.3834f
C3 vin3 vout3 18.2968f
C4 vin3 VDD 29.202f
C5 vout1 vin1 18.2968f
C6 VDD vin1 29.2329f
C7 vin2 vout2 18.2968f
C8 vout4 vin4 18.2968f
C9 vin3 vin2 0.05785f
C10 vout1 VDD 15.3949f
C11 vout3 VDD 15.3834f
C12 vin2 vin1 0.05053f
C13 vin2 VDD 29.202f
C14 vin3 vin4 0.05053f
R0 VSS.n44 VSS.n113 6777.49
R1 VSS.t53 VSS.n113 6777.49
R2 VSS.n85 VSS.n317 1580.41
R3 VSS.n40 VSS.n113 1580.77
R4 VSS.t59 VSS.n96 88.7251
R5 VSS.n196 VSS.t87 88.7251
R6 VSS.t60 VSS.n94 83.1798
R7 VSS.n193 VSS.t86 83.1798
R8 VSS.t62 VSS.n160 77.6345
R9 VSS.n192 VSS.t84 77.6345
R10 VSS.t32 VSS.n44 6.87872
R11 VSS.t36 VSS.n44 6.87897
R12 VSS.t63 VSS.n158 72.0892
R13 VSS.n87 VSS.t83 72.0892
R14 VSS.t65 VSS.n156 66.5439
R15 VSS.n190 VSS.t81 66.5439
R16 VSS.t135 VSS.n44 12.2976
R17 VSS.t66 VSS.n154 60.9987
R18 VSS.n188 VSS.t80 60.9987
R19 VSS.t29 VSS.t53 9.77049
R20 VSS.t132 VSS.n44 16.2707
R21 VSS.n44 VSS.t112 16.2727
R22 VSS.t28 VSS.t53 12.2984
R23 VSS.t68 VSS.n153 55.4534
R24 VSS.n178 VSS.t72 55.4534
R25 VSS.t74 VSS.n145 55.4534
R26 VSS.n89 VSS.t78 55.4534
R27 VSS.n44 VSS.t114 17.717
R28 VSS.t69 VSS.n92 49.9081
R29 VSS.n91 VSS.t71 49.9081
R30 VSS.t75 VSS.n143 49.9081
R31 VSS.n186 VSS.t77 49.9081
R32 VSS.t129 VSS.n44 18.799
R33 VSS.n44 VSS.t115 18.8
R34 VSS.n45 VSS.n44 0.0490479
R35 VSS.n176 VSS.t69 44.3628
R36 VSS.t71 VSS.n149 44.3628
R37 VSS.n183 VSS.t75 44.3628
R38 VSS.t77 VSS.n90 44.3628
R39 VSS.t126 VSS.n44 19.8823
R40 VSS.n44 VSS.t118 19.8825
R41 VSS.n173 VSS.t68 38.8175
R42 VSS.t72 VSS.n146 38.8175
R43 VSS.n180 VSS.t74 38.8175
R44 VSS.t78 VSS.n142 38.8175
R45 VSS.t124 VSS.n44 19.882
R46 VSS.n44 VSS.t120 19.8818
R47 VSS.t20 VSS.t53 19.5213
R48 VSS.t123 VSS.n45 19.5585
R49 VSS.t117 VSS.n44 19.5219
R50 VSS.n172 VSS.t66 33.2722
R51 VSS.t80 VSS.n141 33.2722
R52 VSS.n171 VSS.t65 27.7269
R53 VSS.t81 VSS.n88 27.7269
R54 VSS.t53 VSS.t54 6.87982
R55 VSS.n170 VSS.t63 22.1816
R56 VSS.t83 VSS.n138 22.1816
R57 VSS.t111 VSS.n44 14.4672
R58 VSS.t25 VSS.t53 16.2715
R59 VSS.t22 VSS.t53 18.7993
R60 VSS.t17 VSS.t53 19.8815
R61 VSS.t16 VSS.t53 19.5023
R62 VSS.t11 VSS.t53 19.882
R63 VSS.t53 VSS.t8 18.799
R64 VSS.t4 VSS.t53 14.4658
R65 VSS.t56 VSS.n112 0.008067
R66 VSS.t53 VSS.n112 8.49747
R67 VSS.n123 VSS.t53 17.0005
R68 VSS.t58 VSS.n122 17.0005
R69 VSS.n129 VSS.t58 17.0005
R70 VSS.n128 VSS.t30 17.0005
R71 VSS.n129 VSS.t30 17.0005
R72 VSS.t58 VSS.n128 17.0005
R73 VSS.n122 VSS.t30 17.0005
R74 VSS.t0 VSS.t53 9.76939
R75 VSS.t53 VSS.n84 1.31633
R76 VSS.n131 VSS.t1 17.0005
R77 VSS.t1 VSS.n130 17.0005
R78 VSS.t1 VSS.n121 17.0005
R79 VSS.n130 VSS.t55 17.0005
R80 VSS.t55 VSS.n121 17.0005
R81 VSS.n131 VSS.t55 17.0005
R82 VSS.n40 VSS.n39 0.848734
R83 VSS.n46 VSS.n199 17.0005
R84 VSS.n46 VSS.n132 17.0005
R85 VSS.n59 VSS.n2 14.4044
R86 VSS.n46 VSS.n49 0.650675
R87 VSS.n49 VSS.n3 14.4044
R88 VSS.n46 VSS.n133 8.49558
R89 VSS.n46 VSS.n196 8.49905
R90 VSS.n54 VSS.n4 14.4044
R91 VSS.n46 VSS.n54 0.650675
R92 VSS.n46 VSS.n134 8.49583
R93 VSS.n46 VSS.n193 8.49955
R94 VSS.n46 VSS.n55 0.650675
R95 VSS.n55 VSS.n7 14.4044
R96 VSS.n46 VSS.n109 17.0005
R97 VSS.n46 VSS.n135 8.49726
R98 VSS.n46 VSS.n192 8.49608
R99 VSS.n68 VSS.n9 14.4044
R100 VSS.n46 VSS.n138 8.49775
R101 VSS.n69 VSS.n87 7.20256
R102 VSS.n46 VSS.n69 0.650675
R103 VSS.n46 VSS.n102 17.0005
R104 VSS.n53 VSS.n88 7.20256
R105 VSS.n46 VSS.n190 8.49632
R106 VSS.n46 VSS.n189 17.0005
R107 VSS.n60 VSS.n12 14.4044
R108 VSS.n46 VSS.n141 8.49956
R109 VSS.n46 VSS.n188 8.49657
R110 VSS.n46 VSS.n81 4.24736
R111 VSS.n65 VSS.n14 14.4044
R112 VSS.n46 VSS.n76 5.65906
R113 VSS.n72 VSS.n89 7.20256
R114 VSS.n46 VSS.n72 0.650675
R115 VSS.n46 VSS.n62 0.650675
R116 VSS.n62 VSS.n90 7.20256
R117 VSS.n46 VSS.n47 0.650675
R118 VSS.n47 VSS.n17 14.4044
R119 VSS.n46 VSS.n184 17.0005
R120 VSS.n46 VSS.n143 8.49855
R121 VSS.n46 VSS.n144 17.0005
R122 VSS.n46 VSS.n183 8.49682
R123 VSS.n46 VSS.n48 0.650675
R124 VSS.n48 VSS.n19 14.4044
R125 VSS.n46 VSS.n145 8.49707
R126 VSS.n66 VSS.n20 14.6203
R127 VSS.n46 VSS.n66 0.542754
R128 VSS.n46 VSS.n106 17.0005
R129 VSS.n46 VSS.n146 8.49732
R130 VSS.n51 VSS.n23 14.4044
R131 VSS.n46 VSS.n149 8.49756
R132 VSS.n56 VSS.n91 7.20256
R133 VSS.n46 VSS.n151 17.0005
R134 VSS.n46 VSS.n67 0.650675
R135 VSS.n46 VSS.n177 17.0005
R136 VSS.n67 VSS.n92 7.20256
R137 VSS.n46 VSS.n152 17.0005
R138 VSS.n46 VSS.n176 8.49707
R139 VSS.n46 VSS.n61 0.650675
R140 VSS.n61 VSS.n26 14.4044
R141 VSS.n46 VSS.n174 17.0005
R142 VSS.n46 VSS.n173 8.49781
R143 VSS.n46 VSS.n50 0.650675
R144 VSS.n50 VSS.n28 14.4044
R145 VSS.n46 VSS.n79 4.24736
R146 VSS.n46 VSS.n154 8.49806
R147 VSS.n46 VSS.n57 0.650675
R148 VSS.n57 VSS.n30 14.4044
R149 VSS.n46 VSS.n156 8.49831
R150 VSS.n46 VSS.n171 8.49856
R151 VSS.n46 VSS.n98 17.0005
R152 VSS.n64 VSS.n32 14.4044
R153 VSS.n46 VSS.n158 8.49881
R154 VSS.n46 VSS.n170 8.49906
R155 VSS.n46 VSS.n169 17.0005
R156 VSS.n71 VSS.n33 14.4044
R157 VSS.n46 VSS.n71 0.650675
R158 VSS.n58 VSS.n35 14.4044
R159 VSS.n46 VSS.n63 0.650675
R160 VSS.n46 VSS.n107 8.49879
R161 VSS.n63 VSS.n94 7.20256
R162 VSS.n70 VSS.n95 7.20256
R163 VSS.n46 VSS.n70 0.650675
R164 VSS.n46 VSS.n52 0.650675
R165 VSS.n52 VSS.n96 7.20256
R166 VSS.n46 VSS.n168 8.49931
R167 VSS.n46 VSS.n74 1.20771
R168 VSS.n46 VSS.n167 17.0005
R169 VSS.n142 VSS.n46 8.4988
R170 VSS.n186 VSS.n46 8.49837
R171 VSS.n180 VSS.n46 8.49751
R172 VSS.n178 VSS.n46 8.49965
R173 VSS.n153 VSS.n46 8.499
R174 VSS.n172 VSS.n46 8.4993
R175 VSS.n160 VSS.n46 8.49891
R176 VSS.n73 VSS.n46 1.20771
R177 VSS.n39 VSS.n201 17.0005
R178 VSS.n39 VSS.n111 17.0005
R179 VSS.n39 VSS.n101 17.0005
R180 VSS.n39 VSS.n211 17.0005
R181 VSS.n39 VSS.n75 2.42302
R182 VSS.n39 VSS.n214 17.0005
R183 VSS.n39 VSS.n216 17.0005
R184 VSS.n39 VSS.n105 17.0005
R185 VSS.n39 VSS.n224 17.0005
R186 VSS.n39 VSS.n78 3.39239
R187 VSS.n39 VSS.n100 17.0005
R188 VSS.n39 VSS.n307 17.0005
R189 VSS.n44 VSS.n283 17.0005
R190 VSS.n44 VSS.n272 17.0005
R191 VSS.n44 VSS.n103 1.31087
R192 VSS.n44 VSS.n104 1.27652
R193 VSS.n44 VSS.n261 17.0005
R194 VSS.n44 VSS.n260 17.0005
R195 VSS.n271 VSS.t38 17.0005
R196 VSS.t38 VSS.n262 17.0005
R197 VSS.t38 VSS.n270 17.0005
R198 VSS.n270 VSS.t37 17.0005
R199 VSS.n262 VSS.t37 17.0005
R200 VSS.n271 VSS.t37 17.0005
R201 VSS.n282 VSS.t34 17.0005
R202 VSS.t34 VSS.n273 17.0005
R203 VSS.t34 VSS.n281 17.0005
R204 VSS.n273 VSS.t33 17.0005
R205 VSS.n281 VSS.t33 17.0005
R206 VSS.n282 VSS.t33 17.0005
R207 VSS.n93 VSS.t62 16.6364
R208 VSS.t84 VSS.n135 16.6364
R209 VSS.t109 VSS.n44 12.3005
R210 VSS.t47 VSS.n295 15.0005
R211 VSS.n300 VSS.t39 15.0005
R212 VSS.t43 VSS.n235 15.0005
R213 VSS.t50 VSS.n238 15.0005
R214 VSS.n21 VSS.n66 14.6209
R215 VSS.n314 VSS.n73 13.3823
R216 VSS.n59 VSS.t44 7.20324
R217 VSS.n68 VSS.n8 14.4051
R218 VSS.n65 VSS.n13 14.4051
R219 VSS.n51 VSS.n22 14.4051
R220 VSS.n64 VSS.n31 14.4051
R221 VSS.t40 VSS.n41 7.66709
R222 VSS.n38 VSS.n73 13.8932
R223 VSS.n70 VSS.n36 14.4051
R224 VSS.n93 VSS.n58 7.20324
R225 VSS.n34 VSS.n71 14.4051
R226 VSS.n56 VSS.n24 14.4051
R227 VSS.n72 VSS.n15 14.4051
R228 VSS.n69 VSS.n10 14.4051
R229 VSS.n5 VSS.n54 14.4051
R230 VSS.t108 VSS.n44 9.77299
R231 VSS.t19 VSS.t53 19.882
R232 VSS.t53 VSS.t2 12.2979
R233 VSS.t5 VSS.t53 16.2716
R234 VSS.t7 VSS.t53 17.7156
R235 VSS.t53 VSS.t10 19.521
R236 VSS.t53 VSS.t13 19.8816
R237 VSS.t53 VSS.t14 19.5615
R238 VSS.t53 VSS.t23 17.7155
R239 VSS.t53 VSS.t26 14.4657
R240 VSS.t57 VSS.t53 6.87996
R241 VSS.n95 VSS.t60 11.0911
R242 VSS.t86 VSS.n134 11.0911
R243 VSS.n317 VSS.n46 1.70021
R244 VSS.n39 VSS.n87 8.5005
R245 VSS.n39 VSS.n88 8.5005
R246 VSS.n39 VSS.n89 8.5005
R247 VSS.n39 VSS.n90 8.5005
R248 VSS.n39 VSS.n91 8.5005
R249 VSS.n39 VSS.n92 8.5005
R250 VSS.n39 VSS.n93 8.5005
R251 VSS.n39 VSS.n94 8.5005
R252 VSS.n39 VSS.n95 8.5005
R253 VSS.n39 VSS.n96 8.5005
R254 VSS.n39 VSS.n314 8.5005
R255 VSS.n46 VSS.n198 8.4984
R256 VSS.n46 VSS.n197 8.4984
R257 VSS.n46 VSS.n195 8.4984
R258 VSS.n46 VSS.n194 8.4984
R259 VSS.n46 VSS.n110 8.4984
R260 VSS.n46 VSS.n136 8.4984
R261 VSS.n46 VSS.n137 8.4984
R262 VSS.n46 VSS.n139 8.4984
R263 VSS.n46 VSS.n191 8.4984
R264 VSS.n46 VSS.n140 8.4984
R265 VSS.n81 VSS.n212 0.0180744
R266 VSS.n76 VSS.n75 0.016264
R267 VSS.n46 VSS.n187 8.4984
R268 VSS.n46 VSS.n185 8.4984
R269 VSS.n46 VSS.n182 8.4984
R270 VSS.n46 VSS.n181 8.4984
R271 VSS.n46 VSS.n179 8.4984
R272 VSS.n46 VSS.n147 8.4984
R273 VSS.n46 VSS.n148 8.4984
R274 VSS.n46 VSS.n150 8.4984
R275 VSS.n46 VSS.n175 8.4984
R276 VSS.n46 VSS.n77 8.4984
R277 VSS.n46 VSS.n155 8.4984
R278 VSS.n46 VSS.n157 8.4984
R279 VSS.n46 VSS.n99 8.4984
R280 VSS.n46 VSS.n159 8.4984
R281 VSS.n46 VSS.n161 8.4984
R282 VSS.n46 VSS.n162 8.4984
R283 VSS.n46 VSS.n163 8.4984
R284 VSS.n46 VSS.n164 8.4984
R285 VSS.n46 VSS.n165 8.4984
R286 VSS.n46 VSS.n166 8.4984
R287 VSS.n39 VSS.n200 8.4984
R288 VSS.n39 VSS.n202 8.4984
R289 VSS.n39 VSS.n203 8.4984
R290 VSS.n39 VSS.n204 8.4984
R291 VSS.n39 VSS.n205 8.4984
R292 VSS.n39 VSS.n206 8.4984
R293 VSS.n39 VSS.n207 8.4984
R294 VSS.n39 VSS.n208 8.4984
R295 VSS.n39 VSS.n209 8.4984
R296 VSS.n39 VSS.n210 8.4984
R297 VSS.n39 VSS.n212 8.4984
R298 VSS.n76 VSS.n82 0.035915
R299 VSS.n39 VSS.n213 8.4984
R300 VSS.n39 VSS.n215 8.4984
R301 VSS.n39 VSS.n217 8.4984
R302 VSS.n39 VSS.n218 8.4984
R303 VSS.n39 VSS.n219 8.4984
R304 VSS.n39 VSS.n220 8.4984
R305 VSS.n39 VSS.n221 8.4984
R306 VSS.n39 VSS.n222 8.4984
R307 VSS.n39 VSS.n223 8.4984
R308 VSS.n39 VSS.n225 8.4984
R309 VSS.n78 VSS.n77 0.00677534
R310 VSS.n77 VSS.n80 0.0123715
R311 VSS.n39 VSS.n226 8.4984
R312 VSS.n39 VSS.n227 8.4984
R313 VSS.n39 VSS.n228 8.4984
R314 VSS.n39 VSS.n306 8.4984
R315 VSS.n39 VSS.n308 8.4984
R316 VSS.n39 VSS.n309 8.4984
R317 VSS.n39 VSS.n310 8.4984
R318 VSS.n39 VSS.n311 8.4984
R319 VSS.n39 VSS.n312 8.4984
R320 VSS.n39 VSS.n313 8.4984
R321 VSS.n39 VSS.n315 8.4984
R322 VSS.n39 VSS.n316 8.4984
R323 VSS.n336 VSS.n115 8.22525
R324 VSS.n286 VSS.n285 8.22525
R325 VSS.n285 VSS.n248 8.22525
R326 VSS.n337 VSS.n336 8.22525
R327 VSS.n297 VSS.t47 7.49606
R328 VSS.t39 VSS.n294 7.49606
R329 VSS.n236 VSS.t43 7.49606
R330 VSS.n239 VSS.t50 7.49606
R331 VSS.n39 VSS.t44 7.66688
R332 VSS.n3 VSS.n133 7.20236
R333 VSS.n5 VSS.n134 7.20236
R334 VSS.n6 VSS.n55 14.4051
R335 VSS.n11 VSS.n190 7.20236
R336 VSS.n16 VSS.n186 7.20236
R337 VSS.n18 VSS.n183 7.20236
R338 VSS.n19 VSS.n145 7.20236
R339 VSS.n21 VSS.n146 7.20236
R340 VSS.n23 VSS.n149 7.20236
R341 VSS.n25 VSS.n61 14.4051
R342 VSS.n27 VSS.n173 7.20236
R343 VSS.n29 VSS.n57 14.4051
R344 VSS.n30 VSS.n156 7.20236
R345 VSS.n37 VSS.n168 7.20236
R346 VSS.n41 VSS.n39 3.99348
R347 VSS.n38 VSS.t40 7.20236
R348 VSS.n37 VSS.n74 13.8932
R349 VSS.n36 VSS.n52 14.4051
R350 VSS.n35 VSS.n63 14.4051
R351 VSS.n34 VSS.n160 7.20236
R352 VSS.n33 VSS.n170 7.20236
R353 VSS.n32 VSS.n158 7.20236
R354 VSS.n31 VSS.n171 7.20236
R355 VSS.n29 VSS.n172 7.20236
R356 VSS.n28 VSS.n154 7.20236
R357 VSS.n27 VSS.n50 14.4051
R358 VSS.n26 VSS.n153 7.20236
R359 VSS.n25 VSS.n176 7.20236
R360 VSS.n24 VSS.n67 14.4051
R361 VSS.n22 VSS.n178 7.20236
R362 VSS.n20 VSS.n180 7.20236
R363 VSS.n18 VSS.n48 14.4051
R364 VSS.n17 VSS.n143 7.20236
R365 VSS.n16 VSS.n47 14.4051
R366 VSS.n15 VSS.n62 14.4051
R367 VSS.n14 VSS.n142 7.20236
R368 VSS.n13 VSS.n188 7.20236
R369 VSS.n12 VSS.n141 7.20236
R370 VSS.n11 VSS.n60 14.4051
R371 VSS.n10 VSS.n53 14.4051
R372 VSS.n9 VSS.n138 7.20236
R373 VSS.n8 VSS.n192 7.20236
R374 VSS.n7 VSS.n135 7.20236
R375 VSS.n6 VSS.n193 7.20236
R376 VSS.n4 VSS.n196 7.20236
R377 VSS.n2 VSS.n49 14.4051
R378 VSS.n168 VSS.t59 5.54579
R379 VSS.t87 VSS.n133 5.54579
R380 VSS.n298 VSS.t49 4.5005
R381 VSS.t42 VSS.n293 4.5005
R382 VSS.t51 VSS.n232 4.5005
R383 VSS.t45 VSS.n234 4.5005
R384 VSS.n39 VSS.n97 4.25219
R385 VSS.n39 VSS.n86 4.25206
R386 VSS.n46 VSS.n86 4.25175
R387 VSS.n46 VSS.n97 4.25169
R388 VSS.n40 VSS.n46 0.940145
R389 VSS.n288 VSS.n287 4.11287
R390 VSS.n288 VSS.n116 4.11287
R391 VSS.n127 VSS.t56 3.0005
R392 VSS.n332 VSS.t53 3.0005
R393 VSS.n269 VSS.t35 3.0005
R394 VSS.n280 VSS.t31 3.0005
R395 VSS.n296 VSS.n292 3.0005
R396 VSS.n302 VSS.n301 3.0005
R397 VSS.n241 VSS.n240 3.0005
R398 VSS.n233 VSS.n231 3.0005
R399 VSS.n248 VSS.n247 2.71193
R400 VSS.n339 VSS.n338 2.6297
R401 VSS.n333 VSS.t3 2.4821
R402 VSS.n334 VSS.t6 2.4821
R403 VSS.n335 VSS.t9 2.4821
R404 VSS.n120 VSS.t12 2.4821
R405 VSS.t18 VSS.n119 2.4821
R406 VSS.n124 VSS.t21 2.4821
R407 VSS.n125 VSS.t24 2.4821
R408 VSS.n126 VSS.t27 2.4821
R409 VSS.n268 VSS.t134 2.4821
R410 VSS.n266 VSS.t131 2.4821
R411 VSS.n265 VSS.t128 2.4821
R412 VSS.t125 VSS.n249 2.4821
R413 VSS.t119 VSS.n250 2.4821
R414 VSS.n277 VSS.t116 2.4821
R415 VSS.n278 VSS.t113 2.4821
R416 VSS.n279 VSS.t110 2.4821
R417 VSS.n304 VSS.t89 2.4821
R418 VSS.n304 VSS.t61 2.4821
R419 VSS.t91 VSS.n305 2.4821
R420 VSS.n305 VSS.t64 2.4821
R421 VSS.n291 VSS.t93 2.4821
R422 VSS.n291 VSS.t67 2.4821
R423 VSS.n290 VSS.t95 2.4821
R424 VSS.n290 VSS.t70 2.4821
R425 VSS.n246 VSS.t99 2.4821
R426 VSS.n246 VSS.t76 2.4821
R427 VSS.n245 VSS.t101 2.4821
R428 VSS.n245 VSS.t79 2.4821
R429 VSS.n244 VSS.t103 2.4821
R430 VSS.n244 VSS.t82 2.4821
R431 VSS.n243 VSS.t105 2.4821
R432 VSS.n243 VSS.t85 2.4821
R433 VSS.n46 VSS.n41 0.16648
R434 VSS.n59 VSS.n46 0.650675
R435 VSS.n68 VSS.n46 0.650675
R436 VSS.n53 VSS.n46 0.650675
R437 VSS.n60 VSS.n46 0.650675
R438 VSS.n65 VSS.n46 0.650675
R439 VSS.n51 VSS.n46 0.650675
R440 VSS.n56 VSS.n46 0.650675
R441 VSS.n64 VSS.n46 0.650675
R442 VSS.n58 VSS.n46 0.650675
R443 VSS.n314 VSS.n74 13.3823
R444 VSS.t48 VSS.n298 2.2505
R445 VSS.t41 VSS.n293 2.2505
R446 VSS.t52 VSS.n232 2.2505
R447 VSS.n234 VSS.t46 2.2505
R448 VSS.n320 VSS.t53 2.09947
R449 VSS.n322 VSS.t53 2.09947
R450 VSS.n324 VSS.t53 2.09947
R451 VSS.n117 VSS.t53 2.09947
R452 VSS.n326 VSS.t53 2.09947
R453 VSS.n328 VSS.t53 2.09947
R454 VSS.n330 VSS.t53 2.09947
R455 VSS.n1 VSS.t53 0.129982
R456 VSS.n44 VSS.n258 2.09887
R457 VSS.n284 VSS.n44 2.09887
R458 VSS.n44 VSS.n254 2.09885
R459 VSS.n44 VSS.n253 2.09874
R460 VSS.n44 VSS.n259 2.09868
R461 VSS.n44 VSS.n114 2.09865
R462 VSS.n44 VSS.n255 2.09862
R463 VSS.n44 VSS.n257 2.09859
R464 VSS.t53 VSS.n83 1.27552
R465 VSS.n317 VSS.n39 1.53502
R466 VSS.n332 VSS.n121 1.52811
R467 VSS.n270 VSS.n269 1.52811
R468 VSS.n281 VSS.n280 1.52811
R469 VSS.n128 VSS.n127 1.52811
R470 VSS.n273 VSS.n103 0.00154475
R471 VSS.n104 VSS.n271 0.00153046
R472 VSS.n85 VSS.t53 6777.49
R473 VSS.t48 VSS.n39 1.08339
R474 VSS.t52 VSS.n39 1.03685
R475 VSS.n318 VSS.t53 0.96569
R476 VSS.n44 VSS.n42 0.910334
R477 VSS.n44 VSS.n43 0.909648
R478 VSS.n39 VSS.n3 0.650322
R479 VSS.n39 VSS.n4 0.650322
R480 VSS.n39 VSS.n5 0.650322
R481 VSS.n39 VSS.n6 0.650322
R482 VSS.n39 VSS.n7 0.650322
R483 VSS.n39 VSS.n8 0.650322
R484 VSS.n39 VSS.n9 0.650322
R485 VSS.n39 VSS.n10 0.650322
R486 VSS.n39 VSS.n11 0.650322
R487 VSS.n39 VSS.n12 0.650322
R488 VSS.n39 VSS.n13 0.650322
R489 VSS.n39 VSS.n14 0.650322
R490 VSS.n39 VSS.n15 0.650322
R491 VSS.n39 VSS.n16 0.650322
R492 VSS.n39 VSS.n17 0.650322
R493 VSS.n39 VSS.n18 0.650322
R494 VSS.n39 VSS.n19 0.650322
R495 VSS.n39 VSS.n20 0.650322
R496 VSS.n39 VSS.n21 0.650322
R497 VSS.n39 VSS.n22 0.650322
R498 VSS.n39 VSS.n23 0.650322
R499 VSS.n39 VSS.n24 0.650322
R500 VSS.n39 VSS.n25 0.650322
R501 VSS.n39 VSS.n26 0.650322
R502 VSS.n39 VSS.n27 0.650322
R503 VSS.n39 VSS.n28 0.650322
R504 VSS.n39 VSS.n29 0.650322
R505 VSS.n39 VSS.n30 0.650322
R506 VSS.n39 VSS.n31 0.650322
R507 VSS.n39 VSS.n32 0.650322
R508 VSS.n39 VSS.n33 0.650322
R509 VSS.n39 VSS.n34 0.650322
R510 VSS.n39 VSS.n35 0.650322
R511 VSS.n39 VSS.n36 0.650322
R512 VSS.n39 VSS.n37 0.650322
R513 VSS.n39 VSS.n38 0.650322
R514 VSS.n286 VSS.n247 0.632727
R515 VSS.n340 VSS.n339 0.5505
R516 VSS.n287 VSS.n115 0.2444
R517 VSS.n287 VSS.n286 0.2444
R518 VSS.n337 VSS.n116 0.2444
R519 VSS.n248 VSS.n116 0.2444
R520 VSS.n333 VSS.n332 0.209825
R521 VSS.n269 VSS.n268 0.209825
R522 VSS.n280 VSS.n279 0.209825
R523 VSS.n127 VSS.n126 0.209825
R524 VSS.n331 VSS.t6 0.201663
R525 VSS.n329 VSS.t9 0.201663
R526 VSS.n327 VSS.t12 0.201663
R527 VSS.n325 VSS.t18 0.201663
R528 VSS.n323 VSS.t21 0.201663
R529 VSS.n321 VSS.t24 0.201663
R530 VSS.n319 VSS.t27 0.201663
R531 VSS.t134 VSS.n267 0.201663
R532 VSS.t131 VSS.n263 0.201663
R533 VSS.t128 VSS.n264 0.201663
R534 VSS.n256 VSS.t125 0.201663
R535 VSS.n252 VSS.t119 0.201663
R536 VSS.t116 VSS.n276 0.201663
R537 VSS.t113 VSS.n275 0.201663
R538 VSS.t110 VSS.n274 0.201663
R539 VSS.n108 VSS.t89 0.201663
R540 VSS.t61 VSS.n108 0.201663
R541 VSS.n100 VSS.t91 0.201663
R542 VSS.n100 VSS.t64 0.201663
R543 VSS.n80 VSS.t93 0.201663
R544 VSS.t67 VSS.n80 0.201663
R545 VSS.n229 VSS.t95 0.201663
R546 VSS.t70 VSS.n229 0.201663
R547 VSS.n230 VSS.t99 0.201663
R548 VSS.t76 VSS.n230 0.201663
R549 VSS.n82 VSS.t101 0.201663
R550 VSS.t79 VSS.n82 0.201663
R551 VSS.n102 VSS.t103 0.201663
R552 VSS.t82 VSS.n102 0.201663
R553 VSS.n111 VSS.t105 0.201663
R554 VSS.t85 VSS.n111 0.201663
R555 VSS.t73 VSS.t97 0.185696
R556 VSS.n334 VSS.n333 0.16242
R557 VSS.n335 VSS.n334 0.16242
R558 VSS.n120 VSS.n335 0.16242
R559 VSS.n118 VSS.n120 0.16242
R560 VSS.n118 VSS.n119 0.16242
R561 VSS.n124 VSS.n119 0.16242
R562 VSS.n125 VSS.n124 0.16242
R563 VSS.n126 VSS.n125 0.16242
R564 VSS.n279 VSS.n278 0.16242
R565 VSS.n278 VSS.n277 0.16242
R566 VSS.n277 VSS.n250 0.16242
R567 VSS.n251 VSS.n250 0.16242
R568 VSS.n251 VSS.n249 0.16242
R569 VSS.n265 VSS.n249 0.16242
R570 VSS.n266 VSS.n265 0.16242
R571 VSS.n268 VSS.n266 0.16242
R572 VSS.n267 VSS.n43 0.146666
R573 VSS.n274 VSS.n42 0.145358
R574 VSS.n1 VSS.t3 0.207983
R575 VSS.n319 VSS.n318 0.143085
R576 VSS.n304 VSS.n303 0.117247
R577 VSS.n243 VSS.n242 0.1171
R578 VSS.n1 VSS.n331 0.165903
R579 VSS.n274 VSS.n253 0.0943283
R580 VSS.n267 VSS.n259 0.0935007
R581 VSS.n331 VSS.n330 0.0927738
R582 VSS.n320 VSS.n319 0.0925656
R583 VSS.n275 VSS.n254 0.0918813
R584 VSS.n263 VSS.n258 0.0908667
R585 VSS.n329 VSS.n328 0.0903294
R586 VSS.t15 VSS.n117 0.0903294
R587 VSS.n322 VSS.n321 0.0901212
R588 VSS.n276 VSS.n255 0.08912
R589 VSS.t122 VSS.n114 0.0889238
R590 VSS.n264 VSS.n257 0.088736
R591 VSS.t122 VSS.n284 0.0884233
R592 VSS.n327 VSS.n326 0.0878849
R593 VSS.n325 VSS.n324 0.0878849
R594 VSS.n326 VSS.t15 0.0876767
R595 VSS.n324 VSS.n323 0.0876767
R596 VSS.n284 VSS.n252 0.0871171
R597 VSS.n257 VSS.n256 0.0868001
R598 VSS.n256 VSS.n114 0.0866128
R599 VSS.n255 VSS.n252 0.0864173
R600 VSS.n323 VSS.n322 0.0854405
R601 VSS.n328 VSS.n327 0.0852323
R602 VSS.n117 VSS.n325 0.0852323
R603 VSS.n318 VSS.t56 0.0849321
R604 VSS.n264 VSS.n258 0.0846738
R605 VSS.n276 VSS.n254 0.0836579
R606 VSS.t31 VSS.n42 0.0834709
R607 VSS.t35 VSS.n43 0.0831129
R608 VSS.n321 VSS.n320 0.082996
R609 VSS.n330 VSS.n329 0.0827878
R610 VSS.n340 VSS.n115 0.0827273
R611 VSS.n338 VSS.n337 0.0827273
R612 VSS.n263 VSS.n259 0.0820417
R613 VSS.n305 VSS.n304 0.08146
R614 VSS.n305 VSS.n291 0.08146
R615 VSS.n291 VSS.n290 0.08146
R616 VSS.n290 VSS.n289 0.08146
R617 VSS.n289 VSS.n246 0.08146
R618 VSS.n246 VSS.n245 0.08146
R619 VSS.n245 VSS.n244 0.08146
R620 VSS.n244 VSS.n243 0.08146
R621 VSS.n275 VSS.n253 0.081216
R622 VSS.t41 VSS.n46 1.05343
R623 VSS.n339 VSS 0.0445
R624 VSS.n247 VSS 0.0445
R625 VSS.n251 VSS.t122 0.0394179
R626 VSS.t15 VSS.n118 0.0394179
R627 VSS.n336 VSS.n118 0.0389615
R628 VSS.n285 VSS.n251 0.0389615
R629 VSS.t49 VSS.n297 0.031258
R630 VSS.n294 VSS.t42 0.031258
R631 VSS.n239 VSS.t51 0.031258
R632 VSS.n303 VSS.n302 0.0291125
R633 VSS.n242 VSS.n241 0.0291125
R634 VSS.n242 VSS.n231 0.0291125
R635 VSS.n303 VSS.n292 0.0291125
R636 VSS.n302 VSS.n293 0.0281144
R637 VSS.n241 VSS.n232 0.0281144
R638 VSS.n234 VSS.n231 0.0281144
R639 VSS.n298 VSS.n292 0.0281144
R640 VSS.n237 VSS.n236 0.0216549
R641 VSS.n235 VSS.t45 0.0208704
R642 VSS.n296 VSS.n295 0.0202884
R643 VSS.n301 VSS.n300 0.0202884
R644 VSS.n235 VSS.n233 0.0202884
R645 VSS.n240 VSS.n238 0.0202884
R646 VSS.n289 VSS.n288 0.0197308
R647 VSS.n289 VSS.t97 0.019449
R648 VSS.n237 VSS.n86 0.0162424
R649 VSS.n299 VSS.n97 0.0159649
R650 VSS.n84 VSS.n131 0.00154702
R651 VSS.t35 VSS.n260 0.0133922
R652 VSS.n283 VSS.t31 0.0133922
R653 VSS.n202 VSS.n198 0.0118857
R654 VSS.n203 VSS.n197 0.0118857
R655 VSS.n204 VSS.n194 0.0118857
R656 VSS.n205 VSS.n194 0.0118857
R657 VSS.n206 VSS.n136 0.0118857
R658 VSS.n207 VSS.n136 0.0118857
R659 VSS.n208 VSS.n137 0.0118857
R660 VSS.n209 VSS.n139 0.0118857
R661 VSS.n210 VSS.n191 0.0118857
R662 VSS.n212 VSS.n140 0.0118857
R663 VSS.n82 VSS.n81 0.00668938
R664 VSS.n213 VSS.n185 0.0118857
R665 VSS.n217 VSS.n182 0.0118857
R666 VSS.n218 VSS.n181 0.0118857
R667 VSS.n220 VSS.n147 0.0118857
R668 VSS.n221 VSS.n150 0.0118857
R669 VSS.n222 VSS.n150 0.0118857
R670 VSS.n225 VSS.n175 0.0118857
R671 VSS.n226 VSS.n79 0.0180744
R672 VSS.n227 VSS.n157 0.0118857
R673 VSS.n228 VSS.n157 0.0118857
R674 VSS.n306 VSS.n99 0.0118857
R675 VSS.n308 VSS.n159 0.0118857
R676 VSS.n311 VSS.n162 0.0118857
R677 VSS.n312 VSS.n163 0.0118857
R678 VSS.n313 VSS.n164 0.0118857
R679 VSS.n315 VSS.n165 0.0118857
R680 VSS.n316 VSS.n166 0.0118857
R681 VSS.n315 VSS.n166 0.0118857
R682 VSS.n313 VSS.n165 0.0118857
R683 VSS.n312 VSS.n164 0.0118857
R684 VSS.n311 VSS.n163 0.0118857
R685 VSS.n310 VSS.n162 0.0118857
R686 VSS.n309 VSS.n161 0.0118857
R687 VSS.n308 VSS.n161 0.0118857
R688 VSS.n227 VSS.n155 0.0118857
R689 VSS.n226 VSS.n155 0.0118857
R690 VSS.n80 VSS.n79 0.00668938
R691 VSS.n221 VSS.n148 0.0118857
R692 VSS.n220 VSS.n148 0.0118857
R693 VSS.n219 VSS.n147 0.0118857
R694 VSS.n218 VSS.n179 0.0118857
R695 VSS.n217 VSS.n181 0.0118857
R696 VSS.n213 VSS.n187 0.0118857
R697 VSS.n75 VSS.n187 0.0205155
R698 VSS.n208 VSS.n139 0.0118857
R699 VSS.n207 VSS.n137 0.0118857
R700 VSS.n205 VSS.n110 0.0118857
R701 VSS.n204 VSS.n195 0.0118857
R702 VSS.n203 VSS.n195 0.0118857
R703 VSS.n202 VSS.n197 0.0118857
R704 VSS.n299 VSS.n295 0.0115582
R705 VSS.n300 VSS.n299 0.0115582
R706 VSS.n238 VSS.n237 0.0112672
R707 VSS.n44 VSS.t127 19.5212
R708 VSS.n44 VSS.t130 17.7154
R709 VSS.n44 VSS.t133 14.4648
R710 VSS.n44 VSS.t136 9.76925
R711 VSS.n307 VSS.n169 0.0108889
R712 VSS.n78 VSS.n174 0.0345242
R713 VSS.n224 VSS.n152 0.0108889
R714 VSS.n216 VSS.n144 0.0108889
R715 VSS.n211 VSS.n189 0.0108889
R716 VSS.n201 VSS.n132 0.0108889
R717 VSS.n297 VSS.n296 0.0108877
R718 VSS.n301 VSS.n294 0.0108877
R719 VSS.n236 VSS.n233 0.0108877
R720 VSS.n240 VSS.n239 0.0108877
R721 VSS.n237 VSS.t46 0.0101032
R722 VSS.n237 VSS.t52 0.0101032
R723 VSS.n299 VSS.t48 0.00981217
R724 VSS.n299 VSS.t41 0.00981217
R725 VSS.n45 VSS.t121 19.5044
R726 VSS VSS.n340 0.0095
R727 VSS.n338 VSS 0.0095
R728 VSS.n108 VSS.n107 0.0054294
R729 VSS.n111 VSS.n109 0.00936111
R730 VSS.n100 VSS.n98 0.00813889
R731 VSS.n102 VSS.n101 0.00813889
R732 VSS.n128 VSS.n123 0.00798582
R733 VSS.n128 VSS.n83 0.015023
R734 VSS.n0 VSS.n121 0.0155446
R735 VSS.n270 VSS.n104 0.0150226
R736 VSS.n270 VSS.n261 0.00798582
R737 VSS.n281 VSS.n103 0.0150083
R738 VSS.n281 VSS.n272 0.00798582
R739 VSS.n122 VSS.n112 0.0151369
R740 VSS.n123 VSS.n122 0.00756994
R741 VSS.n129 VSS.n83 0.00153005
R742 VSS.n130 VSS.n0 0.00100818
R743 VSS.n84 VSS.n121 0.015006
R744 VSS.n262 VSS.n261 0.00756994
R745 VSS.n262 VSS.n260 0.00756994
R746 VSS.n282 VSS.n272 0.00756994
R747 VSS.n283 VSS.n282 0.00756994
R748 VSS.t97 VSS.n106 0.00691667
R749 VSS.n299 VSS.n167 0.00630556
R750 VSS.n214 VSS.n185 0.00619286
R751 VSS.n105 VSS.n179 0.00619286
R752 VSS.n200 VSS.n132 0.00619286
R753 VSS.n215 VSS.n184 0.00619286
R754 VSS.n219 VSS.n106 0.00619286
R755 VSS.n223 VSS.n152 0.00619286
R756 VSS.n309 VSS.n107 0.0111223
R757 VSS.n209 VSS.n102 0.00894286
R758 VSS.n100 VSS.n99 0.00894286
R759 VSS.n316 VSS.n167 0.00619286
R760 VSS.n307 VSS.n159 0.00619286
R761 VSS.n306 VSS.n169 0.00619286
R762 VSS.n228 VSS.n98 0.00619286
R763 VSS.n225 VSS.n174 0.00619286
R764 VSS.n224 VSS.n175 0.00619286
R765 VSS.n223 VSS.n177 0.00619286
R766 VSS.n222 VSS.n151 0.00619286
R767 VSS.n216 VSS.n182 0.00619286
R768 VSS.n215 VSS.n144 0.00619286
R769 VSS.n211 VSS.n140 0.00619286
R770 VSS.n210 VSS.n189 0.00619286
R771 VSS.n101 VSS.n191 0.00619286
R772 VSS.n206 VSS.n109 0.00619286
R773 VSS.n201 VSS.n198 0.00619286
R774 VSS.n200 VSS.n199 0.00619286
R775 VSS.n237 VSS.n199 0.00615278
R776 VSS.n229 VSS.n177 0.00569444
R777 VSS.n229 VSS.n151 0.00569444
R778 VSS.n230 VSS.n184 0.00569444
R779 VSS.n230 VSS.n214 0.00569444
R780 VSS.t97 VSS.n105 0.00891217
R781 VSS.n111 VSS.n110 0.00772064
R782 VSS.n310 VSS.n108 0.00772064
R783 VSS.n44 VSS.n85 6777.49
R784 VSS.n39 VSS.n2 1.09674
R785 VSS.t46 VSS.n46 1.06027
R786 VSS.t53 VSS.n0 1.00976
C15 vout1 VSS 5.54899f
C16 vin1 VSS 16.0542f
C17 vout2 VSS 5.54814f
C18 vin2 VSS 16.0189f
C19 vout3 VSS 5.54814f
C20 vin3 VSS 16.0189f
C21 vout4 VSS 5.54899f
C22 vin4 VSS 16.0542f
C23 VDD VSS 21.8873f
.ends

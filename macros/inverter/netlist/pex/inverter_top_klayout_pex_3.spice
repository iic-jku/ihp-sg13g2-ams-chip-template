*********************************************************
*** NGSPICE file created by KLayout-PEX 0.7.0
*** -----------------------------------------------------
***     Extraction Engine: KPEX/2.5D
***     Technology: ihp_sg13g2
***     Date: 2026-11-06 18:11:23
*********************************************************

.SUBCKT inverter_top_pex VDD vin4 vout4 VSS vin3 vout3 vin2 vout2 vout1 vin1
X$1 VSS.P1.nSD VSS.P0.GatPoly VSS.P0.nSD VSS sg13_lv_nmos w=1e-06 l=1e-06
+ as=3.4e-13 ad=1.9e-13 ps=2.68e-06 pd=1.38e-06
X$2 vout4.P0.nSD vin4.P0.GatPoly VSS.P1.nSD VSS sg13_lv_nmos w=1e-06 l=1e-06
+ as=1.9e-13 ad=1.9e-13 ps=1.38e-06 pd=1.38e-06
X$3 VSS.P3.nSD vin4.P1.GatPoly vout4.P0.nSD VSS sg13_lv_nmos w=1e-06 l=1e-06
+ as=1.9e-13 ad=1.9e-13 ps=1.38e-06 pd=1.38e-06
X$4 vout4.P2.nSD vin4.P2.GatPoly VSS.P3.nSD VSS sg13_lv_nmos w=1e-06 l=1e-06
+ as=1.9e-13 ad=1.9e-13 ps=1.38e-06 pd=1.38e-06
X$5 VSS.P5.nSD vin4.P3.GatPoly vout4.P2.nSD VSS sg13_lv_nmos w=1e-06 l=1e-06
+ as=1.9e-13 ad=1.9e-13 ps=1.38e-06 pd=1.38e-06
X$6 vout4.P4.nSD vin4.P4.GatPoly VSS.P5.nSD VSS sg13_lv_nmos w=1e-06 l=1e-06
+ as=1.9e-13 ad=1.9e-13 ps=1.38e-06 pd=1.38e-06
X$7 VSS.P7.nSD vin4.P5.GatPoly vout4.P4.nSD VSS sg13_lv_nmos w=1e-06 l=1e-06
+ as=1.9e-13 ad=1.9e-13 ps=1.38e-06 pd=1.38e-06
X$8 vout4.P6.nSD vin4.P6.GatPoly VSS.P7.nSD VSS sg13_lv_nmos w=1e-06 l=1e-06
+ as=1.9e-13 ad=1.9e-13 ps=1.38e-06 pd=1.38e-06
X$9 VSS.P10.nSD vin4.P7.GatPoly vout4.P6.nSD VSS sg13_lv_nmos w=1e-06 l=1e-06
+ as=1.9e-13 ad=1.9e-13 ps=1.38e-06 pd=1.38e-06
X$10 vout4.P8.nSD vin4.P8.GatPoly VSS.P10.nSD VSS sg13_lv_nmos w=1e-06 l=1e-06
+ as=1.9e-13 ad=1.9e-13 ps=1.38e-06 pd=1.38e-06
X$11 VSS.P11.nSD vin4.P9.GatPoly vout4.P8.nSD VSS sg13_lv_nmos w=1e-06 l=1e-06
+ as=1.9e-13 ad=1.9e-13 ps=1.38e-06 pd=1.38e-06
X$12 vout4.P10.nSD vin4.P10.GatPoly VSS.P11.nSD VSS sg13_lv_nmos w=1e-06
+ l=1e-06 as=1.9e-13 ad=1.9e-13 ps=1.38e-06 pd=1.38e-06
X$13 VSS.P13.nSD vin4.P11.GatPoly vout4.P10.nSD VSS sg13_lv_nmos w=1e-06
+ l=1e-06 as=1.9e-13 ad=1.9e-13 ps=1.38e-06 pd=1.38e-06
X$14 vout4.P12.nSD vin4.P12.GatPoly VSS.P13.nSD VSS sg13_lv_nmos w=1e-06
+ l=1e-06 as=1.9e-13 ad=1.9e-13 ps=1.38e-06 pd=1.38e-06
X$15 VSS.P15.nSD vin4.P13.GatPoly vout4.P12.nSD VSS sg13_lv_nmos w=1e-06
+ l=1e-06 as=1.9e-13 ad=1.9e-13 ps=1.38e-06 pd=1.38e-06
X$16 vout4.P14.nSD vin4.P14.GatPoly VSS.P15.nSD VSS sg13_lv_nmos w=1e-06
+ l=1e-06 as=1.9e-13 ad=1.9e-13 ps=1.38e-06 pd=1.38e-06
X$17 VSS.P17.nSD vin4.P15.GatPoly vout4.P14.nSD VSS sg13_lv_nmos w=1e-06
+ l=1e-06 as=1.9e-13 ad=1.9e-13 ps=1.38e-06 pd=1.38e-06
X$18 vout4.P16.nSD vin4.P16.GatPoly VSS.P17.nSD VSS sg13_lv_nmos w=1e-06
+ l=1e-06 as=1.9e-13 ad=1.9e-13 ps=1.38e-06 pd=1.38e-06
X$19 VSS.P19.nSD vin4.P17.GatPoly vout4.P16.nSD VSS sg13_lv_nmos w=1e-06
+ l=1e-06 as=1.9e-13 ad=1.9e-13 ps=1.38e-06 pd=1.38e-06
X$20 vout4.P18.nSD vin4.P18.GatPoly VSS.P19.nSD VSS sg13_lv_nmos w=1e-06
+ l=1e-06 as=1.9e-13 ad=1.9e-13 ps=1.38e-06 pd=1.38e-06
X$21 VSS.P21.nSD vin4.P19.GatPoly vout4.P18.nSD VSS sg13_lv_nmos w=1e-06
+ l=1e-06 as=1.9e-13 ad=1.9e-13 ps=1.38e-06 pd=1.38e-06
X$22 VSS.P23.nSD VSS.P1.GatPoly VSS.P21.nSD VSS sg13_lv_nmos w=1e-06 l=1e-06
+ as=1.9e-13 ad=3.4e-13 ps=1.38e-06 pd=2.68e-06
X$23 VSS.P0.pSD VSS ptap1
X$24 VSS.P25.nSD VSS.P2.GatPoly VSS.P24.nSD VSS sg13_lv_nmos w=1e-06 l=1e-06
+ as=3.4e-13 ad=1.9e-13 ps=2.68e-06 pd=1.38e-06
X$25 vout1.P0.nSD vin1.P0.GatPoly VSS.P25.nSD VSS sg13_lv_nmos w=1e-06 l=1e-06
+ as=1.9e-13 ad=1.9e-13 ps=1.38e-06 pd=1.38e-06
X$26 VSS.P27.nSD vin1.P1.GatPoly vout1.P0.nSD VSS sg13_lv_nmos w=1e-06 l=1e-06
+ as=1.9e-13 ad=1.9e-13 ps=1.38e-06 pd=1.38e-06
X$27 vout1.P2.nSD vin1.P2.GatPoly VSS.P27.nSD VSS sg13_lv_nmos w=1e-06 l=1e-06
+ as=1.9e-13 ad=1.9e-13 ps=1.38e-06 pd=1.38e-06
X$28 VSS.P29.nSD vin1.P3.GatPoly vout1.P2.nSD VSS sg13_lv_nmos w=1e-06 l=1e-06
+ as=1.9e-13 ad=1.9e-13 ps=1.38e-06 pd=1.38e-06
X$29 vout1.P4.nSD vin1.P4.GatPoly VSS.P29.nSD VSS sg13_lv_nmos w=1e-06 l=1e-06
+ as=1.9e-13 ad=1.9e-13 ps=1.38e-06 pd=1.38e-06
X$30 VSS.P31.nSD vin1.P5.GatPoly vout1.P4.nSD VSS sg13_lv_nmos w=1e-06 l=1e-06
+ as=1.9e-13 ad=1.9e-13 ps=1.38e-06 pd=1.38e-06
X$31 vout1.P6.nSD vin1.P6.GatPoly VSS.P31.nSD VSS sg13_lv_nmos w=1e-06 l=1e-06
+ as=1.9e-13 ad=1.9e-13 ps=1.38e-06 pd=1.38e-06
X$32 VSS.P33.nSD vin1.P7.GatPoly vout1.P6.nSD VSS sg13_lv_nmos w=1e-06 l=1e-06
+ as=1.9e-13 ad=1.9e-13 ps=1.38e-06 pd=1.38e-06
X$33 vout1.P8.nSD vin1.P8.GatPoly VSS.P33.nSD VSS sg13_lv_nmos w=1e-06 l=1e-06
+ as=1.9e-13 ad=1.9e-13 ps=1.38e-06 pd=1.38e-06
X$34 VSS.P35.nSD vin1.P9.GatPoly vout1.P8.nSD VSS sg13_lv_nmos w=1e-06 l=1e-06
+ as=1.9e-13 ad=1.9e-13 ps=1.38e-06 pd=1.38e-06
X$35 vout1.P10.nSD vin1.P10.GatPoly VSS.P35.nSD VSS sg13_lv_nmos w=1e-06
+ l=1e-06 as=1.9e-13 ad=1.9e-13 ps=1.38e-06 pd=1.38e-06
X$36 VSS.P37.nSD vin1.P11.GatPoly vout1.P10.nSD VSS sg13_lv_nmos w=1e-06
+ l=1e-06 as=1.9e-13 ad=1.9e-13 ps=1.38e-06 pd=1.38e-06
X$37 vout1.P12.nSD vin1.P12.GatPoly VSS.P37.nSD VSS sg13_lv_nmos w=1e-06
+ l=1e-06 as=1.9e-13 ad=1.9e-13 ps=1.38e-06 pd=1.38e-06
X$38 VSS.P39.nSD vin1.P13.GatPoly vout1.P12.nSD VSS sg13_lv_nmos w=1e-06
+ l=1e-06 as=1.9e-13 ad=1.9e-13 ps=1.38e-06 pd=1.38e-06
X$39 vout1.P14.nSD vin1.P14.GatPoly VSS.P39.nSD VSS sg13_lv_nmos w=1e-06
+ l=1e-06 as=1.9e-13 ad=1.9e-13 ps=1.38e-06 pd=1.38e-06
X$40 VSS.P41.nSD vin1.P15.GatPoly vout1.P14.nSD VSS sg13_lv_nmos w=1e-06
+ l=1e-06 as=1.9e-13 ad=1.9e-13 ps=1.38e-06 pd=1.38e-06
X$41 vout1.P16.nSD vin1.P16.GatPoly VSS.P41.nSD VSS sg13_lv_nmos w=1e-06
+ l=1e-06 as=1.9e-13 ad=1.9e-13 ps=1.38e-06 pd=1.38e-06
X$42 VSS.P43.nSD vin1.P17.GatPoly vout1.P16.nSD VSS sg13_lv_nmos w=1e-06
+ l=1e-06 as=1.9e-13 ad=1.9e-13 ps=1.38e-06 pd=1.38e-06
X$43 vout1.P18.nSD vin1.P18.GatPoly VSS.P43.nSD VSS sg13_lv_nmos w=1e-06
+ l=1e-06 as=1.9e-13 ad=1.9e-13 ps=1.38e-06 pd=1.38e-06
X$44 VSS.P45.nSD vin1.P19.GatPoly vout1.P18.nSD VSS sg13_lv_nmos w=1e-06
+ l=1e-06 as=1.9e-13 ad=1.9e-13 ps=1.38e-06 pd=1.38e-06
X$45 VSS.P47.nSD VSS.P3.GatPoly VSS.P45.nSD VSS sg13_lv_nmos w=1e-06 l=1e-06
+ as=1.9e-13 ad=3.4e-13 ps=1.38e-06 pd=2.68e-06
X$46 VSS.P1.pSD VSS ptap1
X$47 VSS.P49.nSD VSS.P4.GatPoly VSS.P48.nSD VSS sg13_lv_nmos w=1e-06 l=1e-06
+ as=3.4e-13 ad=1.9e-13 ps=2.68e-06 pd=1.38e-06
X$48 vout3.P0.nSD vin3.P0.GatPoly VSS.P49.nSD VSS sg13_lv_nmos w=1e-06 l=1e-06
+ as=1.9e-13 ad=1.9e-13 ps=1.38e-06 pd=1.38e-06
X$49 VSS.P51.nSD vin3.P1.GatPoly vout3.P0.nSD VSS sg13_lv_nmos w=1e-06 l=1e-06
+ as=1.9e-13 ad=1.9e-13 ps=1.38e-06 pd=1.38e-06
X$50 vout3.P2.nSD vin3.P2.GatPoly VSS.P51.nSD VSS sg13_lv_nmos w=1e-06 l=1e-06
+ as=1.9e-13 ad=1.9e-13 ps=1.38e-06 pd=1.38e-06
X$51 VSS.P53.nSD vin3.P3.GatPoly vout3.P2.nSD VSS sg13_lv_nmos w=1e-06 l=1e-06
+ as=1.9e-13 ad=1.9e-13 ps=1.38e-06 pd=1.38e-06
X$52 vout3.P4.nSD vin3.P4.GatPoly VSS.P53.nSD VSS sg13_lv_nmos w=1e-06 l=1e-06
+ as=1.9e-13 ad=1.9e-13 ps=1.38e-06 pd=1.38e-06
X$53 VSS.P55.nSD vin3.P5.GatPoly vout3.P4.nSD VSS sg13_lv_nmos w=1e-06 l=1e-06
+ as=1.9e-13 ad=1.9e-13 ps=1.38e-06 pd=1.38e-06
X$54 vout3.P6.nSD vin3.P6.GatPoly VSS.P55.nSD VSS sg13_lv_nmos w=1e-06 l=1e-06
+ as=1.9e-13 ad=1.9e-13 ps=1.38e-06 pd=1.38e-06
X$55 VSS.P57.nSD vin3.P7.GatPoly vout3.P6.nSD VSS sg13_lv_nmos w=1e-06 l=1e-06
+ as=1.9e-13 ad=1.9e-13 ps=1.38e-06 pd=1.38e-06
X$56 vout3.P8.nSD vin3.P8.GatPoly VSS.P57.nSD VSS sg13_lv_nmos w=1e-06 l=1e-06
+ as=1.9e-13 ad=1.9e-13 ps=1.38e-06 pd=1.38e-06
X$57 VSS.P59.nSD vin3.P9.GatPoly vout3.P8.nSD VSS sg13_lv_nmos w=1e-06 l=1e-06
+ as=1.9e-13 ad=1.9e-13 ps=1.38e-06 pd=1.38e-06
X$58 vout3.P10.nSD vin3.P10.GatPoly VSS.P59.nSD VSS sg13_lv_nmos w=1e-06
+ l=1e-06 as=1.9e-13 ad=1.9e-13 ps=1.38e-06 pd=1.38e-06
X$59 VSS.P61.nSD vin3.P11.GatPoly vout3.P10.nSD VSS sg13_lv_nmos w=1e-06
+ l=1e-06 as=1.9e-13 ad=1.9e-13 ps=1.38e-06 pd=1.38e-06
X$60 vout3.P12.nSD vin3.P12.GatPoly VSS.P61.nSD VSS sg13_lv_nmos w=1e-06
+ l=1e-06 as=1.9e-13 ad=1.9e-13 ps=1.38e-06 pd=1.38e-06
X$61 VSS.P63.nSD vin3.P13.GatPoly vout3.P12.nSD VSS sg13_lv_nmos w=1e-06
+ l=1e-06 as=1.9e-13 ad=1.9e-13 ps=1.38e-06 pd=1.38e-06
X$62 vout3.P14.nSD vin3.P14.GatPoly VSS.P63.nSD VSS sg13_lv_nmos w=1e-06
+ l=1e-06 as=1.9e-13 ad=1.9e-13 ps=1.38e-06 pd=1.38e-06
X$63 VSS.P65.nSD vin3.P15.GatPoly vout3.P14.nSD VSS sg13_lv_nmos w=1e-06
+ l=1e-06 as=1.9e-13 ad=1.9e-13 ps=1.38e-06 pd=1.38e-06
X$64 vout3.P16.nSD vin3.P16.GatPoly VSS.P65.nSD VSS sg13_lv_nmos w=1e-06
+ l=1e-06 as=1.9e-13 ad=1.9e-13 ps=1.38e-06 pd=1.38e-06
X$65 VSS.P67.nSD vin3.P17.GatPoly vout3.P16.nSD VSS sg13_lv_nmos w=1e-06
+ l=1e-06 as=1.9e-13 ad=1.9e-13 ps=1.38e-06 pd=1.38e-06
X$66 vout3.P18.nSD vin3.P18.GatPoly VSS.P67.nSD VSS sg13_lv_nmos w=1e-06
+ l=1e-06 as=1.9e-13 ad=1.9e-13 ps=1.38e-06 pd=1.38e-06
X$67 VSS.P69.nSD vin3.P19.GatPoly vout3.P18.nSD VSS sg13_lv_nmos w=1e-06
+ l=1e-06 as=1.9e-13 ad=1.9e-13 ps=1.38e-06 pd=1.38e-06
X$68 VSS.P71.nSD VSS.P5.GatPoly VSS.P69.nSD VSS sg13_lv_nmos w=1e-06 l=1e-06
+ as=1.9e-13 ad=3.4e-13 ps=1.38e-06 pd=2.68e-06
X$69 VSS.P2.pSD VSS ptap1
X$70 VSS.P73.nSD VSS.P6.GatPoly VSS.P72.nSD VSS sg13_lv_nmos w=1e-06 l=1e-06
+ as=3.4e-13 ad=1.9e-13 ps=2.68e-06 pd=1.38e-06
X$71 vout2.P0.nSD vin2.P0.GatPoly VSS.P73.nSD VSS sg13_lv_nmos w=1e-06 l=1e-06
+ as=1.9e-13 ad=1.9e-13 ps=1.38e-06 pd=1.38e-06
X$72 VSS.P75.nSD vin2.P1.GatPoly vout2.P0.nSD VSS sg13_lv_nmos w=1e-06 l=1e-06
+ as=1.9e-13 ad=1.9e-13 ps=1.38e-06 pd=1.38e-06
X$73 vout2.P2.nSD vin2.P2.GatPoly VSS.P75.nSD VSS sg13_lv_nmos w=1e-06 l=1e-06
+ as=1.9e-13 ad=1.9e-13 ps=1.38e-06 pd=1.38e-06
X$74 VSS.P77.nSD vin2.P3.GatPoly vout2.P2.nSD VSS sg13_lv_nmos w=1e-06 l=1e-06
+ as=1.9e-13 ad=1.9e-13 ps=1.38e-06 pd=1.38e-06
X$75 vout2.P4.nSD vin2.P4.GatPoly VSS.P77.nSD VSS sg13_lv_nmos w=1e-06 l=1e-06
+ as=1.9e-13 ad=1.9e-13 ps=1.38e-06 pd=1.38e-06
X$76 VSS.P79.nSD vin2.P5.GatPoly vout2.P4.nSD VSS sg13_lv_nmos w=1e-06 l=1e-06
+ as=1.9e-13 ad=1.9e-13 ps=1.38e-06 pd=1.38e-06
X$77 vout2.P6.nSD vin2.P6.GatPoly VSS.P79.nSD VSS sg13_lv_nmos w=1e-06 l=1e-06
+ as=1.9e-13 ad=1.9e-13 ps=1.38e-06 pd=1.38e-06
X$78 VSS.P81.nSD vin2.P7.GatPoly vout2.P6.nSD VSS sg13_lv_nmos w=1e-06 l=1e-06
+ as=1.9e-13 ad=1.9e-13 ps=1.38e-06 pd=1.38e-06
X$79 vout2.P8.nSD vin2.P8.GatPoly VSS.P81.nSD VSS sg13_lv_nmos w=1e-06 l=1e-06
+ as=1.9e-13 ad=1.9e-13 ps=1.38e-06 pd=1.38e-06
X$80 VSS.P83.nSD vin2.P9.GatPoly vout2.P8.nSD VSS sg13_lv_nmos w=1e-06 l=1e-06
+ as=1.9e-13 ad=1.9e-13 ps=1.38e-06 pd=1.38e-06
X$81 vout2.P10.nSD vin2.P10.GatPoly VSS.P83.nSD VSS sg13_lv_nmos w=1e-06
+ l=1e-06 as=1.9e-13 ad=1.9e-13 ps=1.38e-06 pd=1.38e-06
X$82 VSS.P85.nSD vin2.P11.GatPoly vout2.P10.nSD VSS sg13_lv_nmos w=1e-06
+ l=1e-06 as=1.9e-13 ad=1.9e-13 ps=1.38e-06 pd=1.38e-06
X$83 vout2.P12.nSD vin2.P12.GatPoly VSS.P85.nSD VSS sg13_lv_nmos w=1e-06
+ l=1e-06 as=1.9e-13 ad=1.9e-13 ps=1.38e-06 pd=1.38e-06
X$84 VSS.P87.nSD vin2.P13.GatPoly vout2.P12.nSD VSS sg13_lv_nmos w=1e-06
+ l=1e-06 as=1.9e-13 ad=1.9e-13 ps=1.38e-06 pd=1.38e-06
X$85 vout2.P14.nSD vin2.P14.GatPoly VSS.P87.nSD VSS sg13_lv_nmos w=1e-06
+ l=1e-06 as=1.9e-13 ad=1.9e-13 ps=1.38e-06 pd=1.38e-06
X$86 VSS.P89.nSD vin2.P15.GatPoly vout2.P14.nSD VSS sg13_lv_nmos w=1e-06
+ l=1e-06 as=1.9e-13 ad=1.9e-13 ps=1.38e-06 pd=1.38e-06
X$87 vout2.P16.nSD vin2.P16.GatPoly VSS.P89.nSD VSS sg13_lv_nmos w=1e-06
+ l=1e-06 as=1.9e-13 ad=1.9e-13 ps=1.38e-06 pd=1.38e-06
X$88 VSS.P91.nSD vin2.P17.GatPoly vout2.P16.nSD VSS sg13_lv_nmos w=1e-06
+ l=1e-06 as=1.9e-13 ad=1.9e-13 ps=1.38e-06 pd=1.38e-06
X$89 vout2.P18.nSD vin2.P18.GatPoly VSS.P91.nSD VSS sg13_lv_nmos w=1e-06
+ l=1e-06 as=1.9e-13 ad=1.9e-13 ps=1.38e-06 pd=1.38e-06
X$90 VSS.P93.nSD vin2.P19.GatPoly vout2.P18.nSD VSS sg13_lv_nmos w=1e-06
+ l=1e-06 as=1.9e-13 ad=1.9e-13 ps=1.38e-06 pd=1.38e-06
X$91 VSS.P95.nSD VSS.P7.GatPoly VSS.P93.nSD VSS sg13_lv_nmos w=1e-06 l=1e-06
+ as=1.9e-13 ad=3.4e-13 ps=1.38e-06 pd=2.68e-06
X$92 VSS.P3.pSD VSS ptap1
X$93 VDD.P1.pSD VDD.P0.GatPoly VDD.P0.pSD \$25 sg13_lv_pmos w=6e-06 l=1e-06
+ as=2.04e-12 ad=1.14e-12 ps=1.268e-05 pd=6.38e-06
X$94 vout4.P0.pSD vin4.P20.GatPoly VDD.P1.pSD \$25 sg13_lv_pmos w=6e-06 l=1e-06
+ as=1.14e-12 ad=1.14e-12 ps=6.38e-06 pd=6.38e-06
X$95 VDD.P3.pSD vin4.P21.GatPoly vout4.P0.pSD \$25 sg13_lv_pmos w=6e-06 l=1e-06
+ as=1.14e-12 ad=1.14e-12 ps=6.38e-06 pd=6.38e-06
X$96 vout4.P2.pSD vin4.P22.GatPoly VDD.P3.pSD \$25 sg13_lv_pmos w=6e-06 l=1e-06
+ as=1.14e-12 ad=1.14e-12 ps=6.38e-06 pd=6.38e-06
X$97 VDD.P5.pSD vin4.P23.GatPoly vout4.P2.pSD \$25 sg13_lv_pmos w=6e-06 l=1e-06
+ as=1.14e-12 ad=1.14e-12 ps=6.38e-06 pd=6.38e-06
X$98 vout4.P4.pSD vin4.P24.GatPoly VDD.P5.pSD \$25 sg13_lv_pmos w=6e-06 l=1e-06
+ as=1.14e-12 ad=1.14e-12 ps=6.38e-06 pd=6.38e-06
X$99 VDD.P7.pSD vin4.P25.GatPoly vout4.P4.pSD \$25 sg13_lv_pmos w=6e-06 l=1e-06
+ as=1.14e-12 ad=1.14e-12 ps=6.38e-06 pd=6.38e-06
X$100 vout4.P6.pSD vin4.P26.GatPoly VDD.P7.pSD \$25 sg13_lv_pmos w=6e-06
+ l=1e-06 as=1.14e-12 ad=1.14e-12 ps=6.38e-06 pd=6.38e-06
X$101 VDD.P10.pSD vin4.P27.GatPoly vout4.P6.pSD \$25 sg13_lv_pmos w=6e-06
+ l=1e-06 as=1.14e-12 ad=1.14e-12 ps=6.38e-06 pd=6.38e-06
X$102 vout4.P8.pSD vin4.P28.GatPoly VDD.P10.pSD \$25 sg13_lv_pmos w=6e-06
+ l=1e-06 as=1.14e-12 ad=1.14e-12 ps=6.38e-06 pd=6.38e-06
X$103 VDD.P11.pSD vin4.P29.GatPoly vout4.P8.pSD \$25 sg13_lv_pmos w=6e-06
+ l=1e-06 as=1.14e-12 ad=1.14e-12 ps=6.38e-06 pd=6.38e-06
X$104 vout4.P10.pSD vin4.P30.GatPoly VDD.P11.pSD \$25 sg13_lv_pmos w=6e-06
+ l=1e-06 as=1.14e-12 ad=1.14e-12 ps=6.38e-06 pd=6.38e-06
X$105 VDD.P13.pSD vin4.P31.GatPoly vout4.P10.pSD \$25 sg13_lv_pmos w=6e-06
+ l=1e-06 as=1.14e-12 ad=1.14e-12 ps=6.38e-06 pd=6.38e-06
X$106 vout4.P12.pSD vin4.P32.GatPoly VDD.P13.pSD \$25 sg13_lv_pmos w=6e-06
+ l=1e-06 as=1.14e-12 ad=1.14e-12 ps=6.38e-06 pd=6.38e-06
X$107 VDD.P15.pSD vin4.P33.GatPoly vout4.P12.pSD \$25 sg13_lv_pmos w=6e-06
+ l=1e-06 as=1.14e-12 ad=1.14e-12 ps=6.38e-06 pd=6.38e-06
X$108 vout4.P14.pSD vin4.P34.GatPoly VDD.P15.pSD \$25 sg13_lv_pmos w=6e-06
+ l=1e-06 as=1.14e-12 ad=1.14e-12 ps=6.38e-06 pd=6.38e-06
X$109 VDD.P17.pSD vin4.P35.GatPoly vout4.P14.pSD \$25 sg13_lv_pmos w=6e-06
+ l=1e-06 as=1.14e-12 ad=1.14e-12 ps=6.38e-06 pd=6.38e-06
X$110 vout4.P16.pSD vin4.P36.GatPoly VDD.P17.pSD \$25 sg13_lv_pmos w=6e-06
+ l=1e-06 as=1.14e-12 ad=1.14e-12 ps=6.38e-06 pd=6.38e-06
X$111 VDD.P19.pSD vin4.P37.GatPoly vout4.P16.pSD \$25 sg13_lv_pmos w=6e-06
+ l=1e-06 as=1.14e-12 ad=1.14e-12 ps=6.38e-06 pd=6.38e-06
X$112 vout4.P18.pSD vin4.P38.GatPoly VDD.P19.pSD \$25 sg13_lv_pmos w=6e-06
+ l=1e-06 as=1.14e-12 ad=1.14e-12 ps=6.38e-06 pd=6.38e-06
X$113 VDD.P21.pSD vin4.P39.GatPoly vout4.P18.pSD \$25 sg13_lv_pmos w=6e-06
+ l=1e-06 as=1.14e-12 ad=1.14e-12 ps=6.38e-06 pd=6.38e-06
X$114 VDD.P23.pSD VDD.P1.GatPoly VDD.P21.pSD \$25 sg13_lv_pmos w=6e-06 l=1e-06
+ as=1.14e-12 ad=2.04e-12 ps=6.38e-06 pd=1.268e-05
X$115 VDD.P0.nSD \$25 ntap1
X$116 VDD.P25.pSD VDD.P2.GatPoly VDD.P24.pSD \$14 sg13_lv_pmos w=6e-06 l=1e-06
+ as=2.04e-12 ad=1.14e-12 ps=1.268e-05 pd=6.38e-06
X$117 vout1.P0.pSD vin1.P20.GatPoly VDD.P25.pSD \$14 sg13_lv_pmos w=6e-06
+ l=1e-06 as=1.14e-12 ad=1.14e-12 ps=6.38e-06 pd=6.38e-06
X$118 VDD.P27.pSD vin1.P21.GatPoly vout1.P0.pSD \$14 sg13_lv_pmos w=6e-06
+ l=1e-06 as=1.14e-12 ad=1.14e-12 ps=6.38e-06 pd=6.38e-06
X$119 vout1.P2.pSD vin1.P22.GatPoly VDD.P27.pSD \$14 sg13_lv_pmos w=6e-06
+ l=1e-06 as=1.14e-12 ad=1.14e-12 ps=6.38e-06 pd=6.38e-06
X$120 VDD.P29.pSD vin1.P23.GatPoly vout1.P2.pSD \$14 sg13_lv_pmos w=6e-06
+ l=1e-06 as=1.14e-12 ad=1.14e-12 ps=6.38e-06 pd=6.38e-06
X$121 vout1.P4.pSD vin1.P24.GatPoly VDD.P29.pSD \$14 sg13_lv_pmos w=6e-06
+ l=1e-06 as=1.14e-12 ad=1.14e-12 ps=6.38e-06 pd=6.38e-06
X$122 VDD.P31.pSD vin1.P25.GatPoly vout1.P4.pSD \$14 sg13_lv_pmos w=6e-06
+ l=1e-06 as=1.14e-12 ad=1.14e-12 ps=6.38e-06 pd=6.38e-06
X$123 vout1.P6.pSD vin1.P26.GatPoly VDD.P31.pSD \$14 sg13_lv_pmos w=6e-06
+ l=1e-06 as=1.14e-12 ad=1.14e-12 ps=6.38e-06 pd=6.38e-06
X$124 VDD.P33.pSD vin1.P27.GatPoly vout1.P6.pSD \$14 sg13_lv_pmos w=6e-06
+ l=1e-06 as=1.14e-12 ad=1.14e-12 ps=6.38e-06 pd=6.38e-06
X$125 vout1.P8.pSD vin1.P28.GatPoly VDD.P33.pSD \$14 sg13_lv_pmos w=6e-06
+ l=1e-06 as=1.14e-12 ad=1.14e-12 ps=6.38e-06 pd=6.38e-06
X$126 VDD.P35.pSD vin1.P29.GatPoly vout1.P8.pSD \$14 sg13_lv_pmos w=6e-06
+ l=1e-06 as=1.14e-12 ad=1.14e-12 ps=6.38e-06 pd=6.38e-06
X$127 vout1.P10.pSD vin1.P30.GatPoly VDD.P35.pSD \$14 sg13_lv_pmos w=6e-06
+ l=1e-06 as=1.14e-12 ad=1.14e-12 ps=6.38e-06 pd=6.38e-06
X$128 VDD.P37.pSD vin1.P31.GatPoly vout1.P10.pSD \$14 sg13_lv_pmos w=6e-06
+ l=1e-06 as=1.14e-12 ad=1.14e-12 ps=6.38e-06 pd=6.38e-06
X$129 vout1.P12.pSD vin1.P32.GatPoly VDD.P37.pSD \$14 sg13_lv_pmos w=6e-06
+ l=1e-06 as=1.14e-12 ad=1.14e-12 ps=6.38e-06 pd=6.38e-06
X$130 VDD.P39.pSD vin1.P33.GatPoly vout1.P12.pSD \$14 sg13_lv_pmos w=6e-06
+ l=1e-06 as=1.14e-12 ad=1.14e-12 ps=6.38e-06 pd=6.38e-06
X$131 vout1.P14.pSD vin1.P34.GatPoly VDD.P39.pSD \$14 sg13_lv_pmos w=6e-06
+ l=1e-06 as=1.14e-12 ad=1.14e-12 ps=6.38e-06 pd=6.38e-06
X$132 VDD.P41.pSD vin1.P35.GatPoly vout1.P14.pSD \$14 sg13_lv_pmos w=6e-06
+ l=1e-06 as=1.14e-12 ad=1.14e-12 ps=6.38e-06 pd=6.38e-06
X$133 vout1.P16.pSD vin1.P36.GatPoly VDD.P41.pSD \$14 sg13_lv_pmos w=6e-06
+ l=1e-06 as=1.14e-12 ad=1.14e-12 ps=6.38e-06 pd=6.38e-06
X$134 VDD.P43.pSD vin1.P37.GatPoly vout1.P16.pSD \$14 sg13_lv_pmos w=6e-06
+ l=1e-06 as=1.14e-12 ad=1.14e-12 ps=6.38e-06 pd=6.38e-06
X$135 vout1.P18.pSD vin1.P38.GatPoly VDD.P43.pSD \$14 sg13_lv_pmos w=6e-06
+ l=1e-06 as=1.14e-12 ad=1.14e-12 ps=6.38e-06 pd=6.38e-06
X$136 VDD.P45.pSD vin1.P39.GatPoly vout1.P18.pSD \$14 sg13_lv_pmos w=6e-06
+ l=1e-06 as=1.14e-12 ad=1.14e-12 ps=6.38e-06 pd=6.38e-06
X$137 VDD.P47.pSD VDD.P3.GatPoly VDD.P45.pSD \$14 sg13_lv_pmos w=6e-06 l=1e-06
+ as=1.14e-12 ad=2.04e-12 ps=6.38e-06 pd=1.268e-05
X$138 VDD.P1.nSD \$14 ntap1
X$139 VDD.P49.pSD VDD.P4.GatPoly VDD.P48.pSD \$25 sg13_lv_pmos w=6e-06 l=1e-06
+ as=2.04e-12 ad=1.14e-12 ps=1.268e-05 pd=6.38e-06
X$140 vout3.P0.pSD vin3.P20.GatPoly VDD.P49.pSD \$25 sg13_lv_pmos w=6e-06
+ l=1e-06 as=1.14e-12 ad=1.14e-12 ps=6.38e-06 pd=6.38e-06
X$141 VDD.P51.pSD vin3.P21.GatPoly vout3.P0.pSD \$25 sg13_lv_pmos w=6e-06
+ l=1e-06 as=1.14e-12 ad=1.14e-12 ps=6.38e-06 pd=6.38e-06
X$142 vout3.P2.pSD vin3.P22.GatPoly VDD.P51.pSD \$25 sg13_lv_pmos w=6e-06
+ l=1e-06 as=1.14e-12 ad=1.14e-12 ps=6.38e-06 pd=6.38e-06
X$143 VDD.P53.pSD vin3.P23.GatPoly vout3.P2.pSD \$25 sg13_lv_pmos w=6e-06
+ l=1e-06 as=1.14e-12 ad=1.14e-12 ps=6.38e-06 pd=6.38e-06
X$144 vout3.P4.pSD vin3.P24.GatPoly VDD.P53.pSD \$25 sg13_lv_pmos w=6e-06
+ l=1e-06 as=1.14e-12 ad=1.14e-12 ps=6.38e-06 pd=6.38e-06
X$145 VDD.P55.pSD vin3.P25.GatPoly vout3.P4.pSD \$25 sg13_lv_pmos w=6e-06
+ l=1e-06 as=1.14e-12 ad=1.14e-12 ps=6.38e-06 pd=6.38e-06
X$146 vout3.P6.pSD vin3.P26.GatPoly VDD.P55.pSD \$25 sg13_lv_pmos w=6e-06
+ l=1e-06 as=1.14e-12 ad=1.14e-12 ps=6.38e-06 pd=6.38e-06
X$147 VDD.P57.pSD vin3.P27.GatPoly vout3.P6.pSD \$25 sg13_lv_pmos w=6e-06
+ l=1e-06 as=1.14e-12 ad=1.14e-12 ps=6.38e-06 pd=6.38e-06
X$148 vout3.P8.pSD vin3.P28.GatPoly VDD.P57.pSD \$25 sg13_lv_pmos w=6e-06
+ l=1e-06 as=1.14e-12 ad=1.14e-12 ps=6.38e-06 pd=6.38e-06
X$149 VDD.P59.pSD vin3.P29.GatPoly vout3.P8.pSD \$25 sg13_lv_pmos w=6e-06
+ l=1e-06 as=1.14e-12 ad=1.14e-12 ps=6.38e-06 pd=6.38e-06
X$150 vout3.P10.pSD vin3.P30.GatPoly VDD.P59.pSD \$25 sg13_lv_pmos w=6e-06
+ l=1e-06 as=1.14e-12 ad=1.14e-12 ps=6.38e-06 pd=6.38e-06
X$151 VDD.P61.pSD vin3.P31.GatPoly vout3.P10.pSD \$25 sg13_lv_pmos w=6e-06
+ l=1e-06 as=1.14e-12 ad=1.14e-12 ps=6.38e-06 pd=6.38e-06
X$152 vout3.P12.pSD vin3.P32.GatPoly VDD.P61.pSD \$25 sg13_lv_pmos w=6e-06
+ l=1e-06 as=1.14e-12 ad=1.14e-12 ps=6.38e-06 pd=6.38e-06
X$153 VDD.P63.pSD vin3.P33.GatPoly vout3.P12.pSD \$25 sg13_lv_pmos w=6e-06
+ l=1e-06 as=1.14e-12 ad=1.14e-12 ps=6.38e-06 pd=6.38e-06
X$154 vout3.P14.pSD vin3.P34.GatPoly VDD.P63.pSD \$25 sg13_lv_pmos w=6e-06
+ l=1e-06 as=1.14e-12 ad=1.14e-12 ps=6.38e-06 pd=6.38e-06
X$155 VDD.P65.pSD vin3.P35.GatPoly vout3.P14.pSD \$25 sg13_lv_pmos w=6e-06
+ l=1e-06 as=1.14e-12 ad=1.14e-12 ps=6.38e-06 pd=6.38e-06
X$156 vout3.P16.pSD vin3.P36.GatPoly VDD.P65.pSD \$25 sg13_lv_pmos w=6e-06
+ l=1e-06 as=1.14e-12 ad=1.14e-12 ps=6.38e-06 pd=6.38e-06
X$157 VDD.P67.pSD vin3.P37.GatPoly vout3.P16.pSD \$25 sg13_lv_pmos w=6e-06
+ l=1e-06 as=1.14e-12 ad=1.14e-12 ps=6.38e-06 pd=6.38e-06
X$158 vout3.P18.pSD vin3.P38.GatPoly VDD.P67.pSD \$25 sg13_lv_pmos w=6e-06
+ l=1e-06 as=1.14e-12 ad=1.14e-12 ps=6.38e-06 pd=6.38e-06
X$159 VDD.P69.pSD vin3.P39.GatPoly vout3.P18.pSD \$25 sg13_lv_pmos w=6e-06
+ l=1e-06 as=1.14e-12 ad=1.14e-12 ps=6.38e-06 pd=6.38e-06
X$160 VDD.P71.pSD VDD.P5.GatPoly VDD.P69.pSD \$25 sg13_lv_pmos w=6e-06 l=1e-06
+ as=1.14e-12 ad=2.04e-12 ps=6.38e-06 pd=1.268e-05
X$161 VDD.P2.nSD \$25 ntap1
X$162 VDD.P73.pSD VDD.P6.GatPoly VDD.P72.pSD \$14 sg13_lv_pmos w=6e-06 l=1e-06
+ as=2.04e-12 ad=1.14e-12 ps=1.268e-05 pd=6.38e-06
X$163 vout2.P0.pSD vin2.P20.GatPoly VDD.P73.pSD \$14 sg13_lv_pmos w=6e-06
+ l=1e-06 as=1.14e-12 ad=1.14e-12 ps=6.38e-06 pd=6.38e-06
X$164 VDD.P75.pSD vin2.P21.GatPoly vout2.P0.pSD \$14 sg13_lv_pmos w=6e-06
+ l=1e-06 as=1.14e-12 ad=1.14e-12 ps=6.38e-06 pd=6.38e-06
X$165 vout2.P2.pSD vin2.P22.GatPoly VDD.P75.pSD \$14 sg13_lv_pmos w=6e-06
+ l=1e-06 as=1.14e-12 ad=1.14e-12 ps=6.38e-06 pd=6.38e-06
X$166 VDD.P77.pSD vin2.P23.GatPoly vout2.P2.pSD \$14 sg13_lv_pmos w=6e-06
+ l=1e-06 as=1.14e-12 ad=1.14e-12 ps=6.38e-06 pd=6.38e-06
X$167 vout2.P4.pSD vin2.P24.GatPoly VDD.P77.pSD \$14 sg13_lv_pmos w=6e-06
+ l=1e-06 as=1.14e-12 ad=1.14e-12 ps=6.38e-06 pd=6.38e-06
X$168 VDD.P79.pSD vin2.P25.GatPoly vout2.P4.pSD \$14 sg13_lv_pmos w=6e-06
+ l=1e-06 as=1.14e-12 ad=1.14e-12 ps=6.38e-06 pd=6.38e-06
X$169 vout2.P6.pSD vin2.P26.GatPoly VDD.P79.pSD \$14 sg13_lv_pmos w=6e-06
+ l=1e-06 as=1.14e-12 ad=1.14e-12 ps=6.38e-06 pd=6.38e-06
X$170 VDD.P81.pSD vin2.P27.GatPoly vout2.P6.pSD \$14 sg13_lv_pmos w=6e-06
+ l=1e-06 as=1.14e-12 ad=1.14e-12 ps=6.38e-06 pd=6.38e-06
X$171 vout2.P8.pSD vin2.P28.GatPoly VDD.P81.pSD \$14 sg13_lv_pmos w=6e-06
+ l=1e-06 as=1.14e-12 ad=1.14e-12 ps=6.38e-06 pd=6.38e-06
X$172 VDD.P83.pSD vin2.P29.GatPoly vout2.P8.pSD \$14 sg13_lv_pmos w=6e-06
+ l=1e-06 as=1.14e-12 ad=1.14e-12 ps=6.38e-06 pd=6.38e-06
X$173 vout2.P10.pSD vin2.P30.GatPoly VDD.P83.pSD \$14 sg13_lv_pmos w=6e-06
+ l=1e-06 as=1.14e-12 ad=1.14e-12 ps=6.38e-06 pd=6.38e-06
X$174 VDD.P85.pSD vin2.P31.GatPoly vout2.P10.pSD \$14 sg13_lv_pmos w=6e-06
+ l=1e-06 as=1.14e-12 ad=1.14e-12 ps=6.38e-06 pd=6.38e-06
X$175 vout2.P12.pSD vin2.P32.GatPoly VDD.P85.pSD \$14 sg13_lv_pmos w=6e-06
+ l=1e-06 as=1.14e-12 ad=1.14e-12 ps=6.38e-06 pd=6.38e-06
X$176 VDD.P87.pSD vin2.P33.GatPoly vout2.P12.pSD \$14 sg13_lv_pmos w=6e-06
+ l=1e-06 as=1.14e-12 ad=1.14e-12 ps=6.38e-06 pd=6.38e-06
X$177 vout2.P14.pSD vin2.P34.GatPoly VDD.P87.pSD \$14 sg13_lv_pmos w=6e-06
+ l=1e-06 as=1.14e-12 ad=1.14e-12 ps=6.38e-06 pd=6.38e-06
X$178 VDD.P89.pSD vin2.P35.GatPoly vout2.P14.pSD \$14 sg13_lv_pmos w=6e-06
+ l=1e-06 as=1.14e-12 ad=1.14e-12 ps=6.38e-06 pd=6.38e-06
X$179 vout2.P16.pSD vin2.P36.GatPoly VDD.P89.pSD \$14 sg13_lv_pmos w=6e-06
+ l=1e-06 as=1.14e-12 ad=1.14e-12 ps=6.38e-06 pd=6.38e-06
X$180 VDD.P91.pSD vin2.P37.GatPoly vout2.P16.pSD \$14 sg13_lv_pmos w=6e-06
+ l=1e-06 as=1.14e-12 ad=1.14e-12 ps=6.38e-06 pd=6.38e-06
X$181 vout2.P18.pSD vin2.P38.GatPoly VDD.P91.pSD \$14 sg13_lv_pmos w=6e-06
+ l=1e-06 as=1.14e-12 ad=1.14e-12 ps=6.38e-06 pd=6.38e-06
X$182 VDD.P93.pSD vin2.P39.GatPoly vout2.P18.pSD \$14 sg13_lv_pmos w=6e-06
+ l=1e-06 as=1.14e-12 ad=1.14e-12 ps=6.38e-06 pd=6.38e-06
X$183 VDD.P95.pSD VDD.P7.GatPoly VDD.P93.pSD \$14 sg13_lv_pmos w=6e-06 l=1e-06
+ as=1.14e-12 ad=2.04e-12 ps=6.38e-06 pd=1.268e-05
X$184 VDD.P3.nSD \$14 ntap1
* netlist reduce (TICER tau=0.1ps max degree 5, floating max degree 64): 18653 R, 39779 C, 11068 nodes -> 7763 R, 28419 C, 2233 nodes
Cred_1 \$14 VDD 0.208722f
Cred_2 \$14 VDD.$1017.Metal1 0.0720345f
Cred_3 \$14 VDD.$1024.Metal1 0.108331f
Cred_4 \$14 VDD.$116.Metal1 0.158195f
Cred_5 \$14 VDD.$117.Metal1 0.0179219f
Cred_6 \$14 VDD.$1247.Metal1 0.0692596f
Cred_7 \$14 VDD.$1267.Metal1 0.0411504f
Cred_8 \$14 VDD.$1287.Metal1 0.0426544f
Cred_9 \$14 VDD.$129.Metal1 0.0746742f
Cred_10 \$14 VDD.$1307.Metal1 0.0650391f
Cred_11 \$14 VDD.$132.Metal1 0.09215f
Cred_12 \$14 VDD.$1335.Metal1 0.0884238f
Cred_13 \$14 VDD.$1354.Metal1 0.067345f
Cred_14 \$14 VDD.$1413.Metal1 0.0203531f
Cred_15 \$14 VDD.$1557.Metal1 0.0508775f
Cred_16 \$14 VDD.$157.Metal1 0.019204f
Cred_17 \$14 VDD.$1577.Metal1 0.0406414f
Cred_18 \$14 VDD.$158.Metal1 0.00921626f
Cred_19 \$14 VDD.$1597.Metal1 0.0411163f
Cred_20 \$14 VDD.$1617.Metal1 0.0707858f
Cred_21 \$14 VDD.$1645.Metal1 0.0630078f
Cred_22 \$14 VDD.$1665.Metal1 0.0586679f
Cred_23 \$14 VDD.$1684.Metal1 0.0885106f
Cred_24 \$14 VDD.$1831.Metal1 0.0775559f
Cred_25 \$14 VDD.$1915.Metal1 0.0659047f
Cred_26 \$14 VDD.$1935.Metal1 0.0421632f
Cred_27 \$14 VDD.$1955.Metal1 0.0424114f
Cred_28 \$14 VDD.$1975.Metal1 0.0411397f
Cred_29 \$14 VDD.$1995.Metal1 0.0683695f
Cred_30 \$14 VDD.$2223.Metal1 0.0683695f
Cred_31 \$14 VDD.$2243.Metal1 0.0411397f
Cred_32 \$14 VDD.$225.Metal1 0.049224f
Cred_33 \$14 VDD.$226.Metal1 1.68074e-06f
Cred_34 \$14 VDD.$2263.Metal1 0.0424199f
Cred_35 \$14 VDD.$2283.Metal1 0.0629397f
Cred_36 \$14 VDD.$2323.Metal1 0.0694127f
Cred_37 \$14 VDD.$2330.Metal1 0.0518631f
Cred_38 \$14 VDD.$2389.Metal1 0.0533655f
Cred_39 \$14 VDD.$2477.Metal1 0.054931f
Cred_40 \$14 VDD.$2553.Metal1 0.0404245f
Cred_41 \$14 VDD.$2573.Metal1 0.0411363f
Cred_42 \$14 VDD.$2593.Metal1 0.068267f
Cred_43 \$14 VDD.$2621.Metal1 0.0654703f
Cred_44 \$14 VDD.$2641.Metal1 0.0599889f
Cred_45 \$14 VDD.$2660.Metal1 0.0987693f
Cred_46 \$14 VDD.$2807.Metal1 0.0203531f
Cred_47 \$14 VDD.$2883.Metal1 0.0884238f
Cred_48 \$14 VDD.$2911.Metal1 0.0650391f
Cred_49 \$14 VDD.$2931.Metal1 0.0426544f
Cred_50 \$14 VDD.$2951.Metal1 0.0411504f
Cred_51 \$14 VDD.$2971.Metal1 0.0692596f
Cred_52 \$14 VDD.$2998.Metal1 0.108331f
Cred_53 \$14 VDD.$3201.Metal1 0.0720345f
Cred_54 \$14 VDD.$3221.Metal1 0.0411152f
Cred_55 \$14 VDD.$3241.Metal1 0.0416916f
Cred_56 \$14 VDD.$3261.Metal1 0.0660034f
Cred_57 \$14 VDD.$3289.Metal1 0.0672005f
Cred_58 \$14 VDD.$3309.Metal1 0.0602357f
Cred_59 \$14 VDD.$3316.Metal1 0.0745816f
Cred_60 \$14 VDD.$3531.Metal1 0.0670759f
Cred_61 \$14 VDD.$3551.Metal1 0.0649906f
Cred_62 \$14 VDD.$3579.Metal1 0.0687522f
Cred_63 \$14 VDD.$3599.Metal1 0.0411366f
Cred_64 \$14 VDD.$360.Metal1 0.0682928f
Cred_65 \$14 VDD.$361.Metal1 0.225161f
Cred_66 \$14 VDD.$3619.Metal1 0.0406432f
Cred_67 \$14 VDD.$3639.Metal1 0.0484836f
Cred_68 \$14 VDD.$3646.Metal1 0.0321233f
Cred_69 \$14 VDD.$3649.Metal1 0.018258f
Cred_70 \$14 VDD.$3658.Metal1 0.0179219f
Cred_71 \$14 VDD.$3727.Metal1 0.0496442f
Cred_72 \$14 VDD.$3728.Metal1 1.68074e-06f
Cred_73 \$14 VDD.$3730.Metal1 2.14238e-06f
Cred_74 \$14 VDD.$3731.Metal1 6.0205e-08f
Cred_75 \$14 VDD.$3736.Metal1 0.0141296f
Cred_76 \$14 VDD.$3737.Metal1 0.00545331f
Cred_77 \$14 VDD.$3738.Metal1 0.00551091f
Cred_78 \$14 VDD.$3739.Metal1 0.00921447f
Cred_79 \$14 VDD.$3741.Metal1 0.00836079f
Cred_80 \$14 VDD.$3742.Metal1 0.00543382f
Cred_81 \$14 VDD.$3743.Metal1 0.00558119f
Cred_82 \$14 VDD.$3744.Metal1 0.00561336f
Cred_83 \$14 VDD.$3745.Metal1 0.00546054f
Cred_84 \$14 VDD.$3746.Metal1 0.0447637f
Cred_85 \$14 VDD.$3794.Metal1 0.080975f
Cred_86 \$14 VDD.$3795.Metal1 0.14348f
Cred_87 \$14 VDD.$3802.Metal1 0.09215f
Cred_88 \$14 VDD.$3839.Metal1 0.0746742f
Cred_89 \$14 VDD.$3851.Metal1 0.0615023f
Cred_90 \$14 VDD.$388.Metal1 0.0945559f
Cred_91 \$14 VDD.$4031.Metal1 0.019204f
Cred_92 \$14 VDD.$4032.Metal1 0.00921626f
Cred_93 \$14 VDD.$404.Metal1 0.0321233f
Cred_94 \$14 VDD.$4106.Metal1 0.158195f
Cred_95 \$14 VDD.$4200.Metal2 0.00996603f
Cred_96 \$14 VDD.$4202.Metal2 0.00166516f
Cred_97 \$14 VDD.$4204.Metal2 0.00233125f
Cred_98 \$14 VDD.$4206.Metal2 0.00216251f
Cred_99 \$14 VDD.$4208.Metal2 0.00166416f
Cred_100 \$14 VDD.$4210.Metal2 0.0623949f
Cred_101 \$14 VDD.$4231.Metal2 0.0300963f
Cred_102 \$14 VDD.$4233.Metal2 0.00294683f
Cred_103 \$14 VDD.$4235.Metal2 0.00220898f
Cred_104 \$14 VDD.$4236.Metal2 0.00148409f
Cred_105 \$14 VDD.$4237.Metal2 0.0101009f
Cred_106 \$14 VDD.$4526.Metal2 0.00663068f
Cred_107 \$14 VDD.$4574.Metal2 0.00981622f
Cred_108 \$14 VDD.$4622.Metal2 0.00653703f
Cred_109 \$14 VDD.$4646.Metal2 0.0207674f
Cred_110 \$14 VDD.$4728.Metal2 0.0233379f
Cred_111 \$14 VDD.$4808.Metal2 0.00655823f
Cred_112 \$14 VDD.$4856.Metal2 0.00768394f
Cred_113 \$14 VDD.$4880.Metal2 0.00647636f
Cred_114 \$14 VDD.$4986.Metal2 0.027643f
Cred_115 \$14 VDD.$5066.Metal2 0.0197146f
Cred_116 \$14 VDD.$508.Metal1 2.14238e-06f
Cred_117 \$14 VDD.$509.Metal1 6.0205e-08f
Cred_118 \$14 VDD.$5114.Metal2 0.00941929f
Cred_119 \$14 VDD.$5162.Metal2 0.0123611f
Cred_120 \$14 VDD.$5210.Metal2 0.0312632f
Cred_121 \$14 VDD.$5268.Metal2 0.00538551f
Cred_122 \$14 VDD.$5372.Metal2 0.0119739f
Cred_123 \$14 VDD.$5420.Metal2 0.00954551f
Cred_124 \$14 VDD.$5468.Metal2 0.018116f
Cred_125 \$14 VDD.$5550.Metal2 0.0199819f
Cred_126 \$14 VDD.$5630.Metal2 0.0136803f
Cred_127 \$14 VDD.$567.Metal1 0.018258f
Cred_128 \$14 VDD.$5678.Metal2 0.0075906f
Cred_129 \$14 VDD.$5702.Metal2 0.00659766f
Cred_130 \$14 VDD.$5766.Metal2 0.0237073f
Cred_131 \$14 VDD.$579.Metal1 0.0484836f
Cred_132 \$14 VDD.$5846.Metal2 0.0237073f
Cred_133 \$14 VDD.$5936.Metal2 0.00927978f
Cred_134 \$14 VDD.$5984.Metal2 0.012751f
Cred_135 \$14 VDD.$599.Metal1 0.0406495f
Cred_136 \$14 VDD.$6032.Metal2 0.031605f
Cred_137 \$14 VDD.$6090.Metal2 0.00566822f
Cred_138 \$14 VDD.$619.Metal1 0.0634875f
Cred_139 \$14 VDD.$6194.Metal2 0.0109555f
Cred_140 \$14 VDD.$6242.Metal2 0.00969443f
Cred_141 \$14 VDD.$6290.Metal2 0.0137809f
Cred_142 \$14 VDD.$6372.Metal2 0.0303143f
Cred_143 \$14 VDD.$647.Metal1 0.0703006f
Cred_144 \$14 VDD.$6476.Metal2 0.0123611f
Cred_145 \$14 VDD.$6524.Metal2 0.00941929f
Cred_146 \$14 VDD.$6572.Metal2 0.0197146f
Cred_147 \$14 VDD.$6654.Metal2 0.027643f
Cred_148 \$14 VDD.$667.Metal1 0.0411162f
Cred_149 \$14 VDD.$6758.Metal2 0.00920228f
Cred_150 \$14 VDD.$6806.Metal2 0.00931977f
Cred_151 \$14 VDD.$687.Metal1 0.0670716f
Cred_152 \$14 VDD.$6912.Metal2 0.0254538f
Cred_153 \$14 VDD.$6992.Metal2 0.0229046f
Cred_154 \$14 VDD.$7040.Metal2 0.00942342f
Cred_155 \$14 VDD.$706.Metal1 0.0745816f
Cred_156 \$14 VDD.$7088.Metal2 0.0069677f
Cred_157 \$14 VDD.$7112.Metal2 0.00450518f
Cred_158 \$14 VDD.$7136.Metal2 0.00996603f
Cred_159 \$14 VDD.$7138.Metal2 0.00166516f
Cred_160 \$14 VDD.$7140.Metal2 0.00233125f
Cred_161 \$14 VDD.$7142.Metal2 0.00216251f
Cred_162 \$14 VDD.$7144.Metal2 0.00166416f
Cred_163 \$14 VDD.$7146.Metal2 0.0104192f
Cred_164 \$14 VDD.$7169.Metal2 0.0343979f
Cred_165 \$14 VDD.$7171.Metal2 0.00294683f
Cred_166 \$14 VDD.$7173.Metal2 0.00220898f
Cred_167 \$14 VDD.$7174.Metal2 0.00148409f
Cred_168 \$14 VDD.$7175.Metal2 0.0101009f
Cred_169 \$14 VDD.$7176.Metal2 0.0107812f
Cred_170 \$14 VDD.$7178.Metal2 0.00292017f
Cred_171 \$14 VDD.$7180.Metal2 0.00365965f
Cred_172 \$14 VDD.$7183.Metal2 0.00438062f
Cred_173 \$14 VDD.$7186.Metal2 0.0237118f
Cred_174 \$14 VDD.$7478.Metal3 0.0367132f
Cred_175 \$14 VDD.$7538.Metal3 0.00384185f
Cred_176 \$14 VDD.$7562.Metal3 0.00654682f
Cred_177 \$14 VDD.$7586.Metal3 0.00658861f
Cred_178 \$14 VDD.$7610.Metal3 0.00370986f
Cred_179 \$14 VDD.$7646.Metal3 0.00872285f
Cred_180 \$14 VDD.$7682.Metal3 0.00699998f
Cred_181 \$14 VDD.$7718.Metal3 0.00579049f
Cred_182 \$14 VDD.$7742.Metal3 0.00673667f
Cred_183 \$14 VDD.$7766.Metal3 0.00412751f
Cred_184 \$14 VDD.$7790.Metal3 0.00389975f
Cred_185 \$14 VDD.$7814.Metal3 0.0067114f
Cred_186 \$14 VDD.$7838.Metal3 0.00686978f
Cred_187 \$14 VDD.$7886.Metal3 0.00933254f
Cred_188 \$14 VDD.$7922.Metal3 0.00653118f
Cred_189 \$14 VDD.$7958.Metal3 0.00479055f
Cred_190 \$14 VDD.$7982.Metal3 0.00682553f
Cred_191 \$14 VDD.$8006.Metal3 0.00473266f
Cred_192 \$14 VDD.$8030.Metal3 0.00328937f
Cred_193 \$14 VDD.$8054.Metal3 0.00664458f
Cred_194 \$14 VDD.$8078.Metal3 0.00641524f
Cred_195 \$14 VDD.$8114.Metal3 0.00488341f
Cred_196 \$14 VDD.$8138.Metal3 0.00673667f
Cred_197 \$14 VDD.$8162.Metal3 0.00579049f
Cred_198 \$14 VDD.$8198.Metal3 0.00524185f
Cred_199 \$14 VDD.$8222.Metal3 0.00686154f
Cred_200 \$14 VDD.$8246.Metal3 0.00510495f
Cred_201 \$14 VDD.$8282.Metal3 0.00549543f
Cred_202 \$14 VDD.$8306.Metal3 0.00836498f
Cred_203 \$14 VDD.$8342.Metal3 0.00539197f
Cred_204 \$14 VDD.$8402.Metal3 0.036475f
Cred_205 \$14 VDD.$909.Metal1 0.0821722f
Cred_206 \$14 VDD.$937.Metal1 0.0684018f
Cred_207 \$14 VDD.$957.Metal1 0.0428678f
Cred_208 \$14 VDD.$977.Metal1 0.0416855f
Cred_209 \$14 VDD.$997.Metal1 0.0411152f
Cred_210 \$14 VDD.P1.nSD 0.598289f
Cred_211 \$14 VDD.P2.GatPoly 0.0748418f
Cred_212 \$14 VDD.P24.pSD 0.00229849f
Cred_213 \$14 VDD.P25.pSD 0.00227208f
Cred_214 \$14 VDD.P27.pSD 0.00230508f
Cred_215 \$14 VDD.P29.pSD 0.00228278f
Cred_216 \$14 VDD.P3.GatPoly 0.0704722f
Cred_217 \$14 VDD.P3.nSD 0.598369f
Cred_218 \$14 VDD.P31.pSD 0.00227802f
Cred_219 \$14 VDD.P33.pSD 0.002302f
Cred_220 \$14 VDD.P35.pSD 0.00227922f
Cred_221 \$14 VDD.P37.pSD 0.00228646f
Cred_222 \$14 VDD.P39.pSD 0.00228108f
Cred_223 \$14 VDD.P41.pSD 0.00228278f
Cred_224 \$14 VDD.P43.pSD 0.00230508f
Cred_225 \$14 VDD.P45.pSD 0.00229279f
Cred_226 \$14 VDD.P47.pSD 0.00231919f
Cred_227 \$14 VDD.P6.GatPoly 0.0704722f
Cred_228 \$14 VDD.P7.GatPoly 0.0704722f
Cred_229 \$14 VDD.P72.pSD 0.00875255f
Cred_230 \$14 VDD.P73.pSD 0.00875255f
Cred_231 \$14 VDD.P75.pSD 0.00230508f
Cred_232 \$14 VDD.P77.pSD 0.00228278f
Cred_233 \$14 VDD.P79.pSD 0.00227802f
Cred_234 \$14 VDD.P81.pSD 0.002302f
Cred_235 \$14 VDD.P83.pSD 0.00227922f
Cred_236 \$14 VDD.P85.pSD 0.00228646f
Cred_237 \$14 VDD.P87.pSD 0.00228108f
Cred_238 \$14 VDD.P89.pSD 0.00228278f
Cred_239 \$14 VDD.P91.pSD 0.00230508f
Cred_240 \$14 VDD.P93.pSD 0.000475184f
Cred_241 \$14 VDD.P95.pSD 0.000475184f
Cred_242 \$14 vin1.$10.GatPoly 0.00187831f
Cred_243 \$14 vin1.$102.GatPoly 0.00209816f
Cred_244 \$14 vin1.$105.GatPoly 0.0395235f
Cred_245 \$14 vin1.$107.GatPoly 0.034766f
Cred_246 \$14 vin1.$108.GatPoly 0.00162127f
Cred_247 \$14 vin1.$110.GatPoly 0.00190757f
Cred_248 \$14 vin1.$115.GatPoly 0.0461296f
Cred_249 \$14 vin1.$118.GatPoly 0.00219009f
Cred_250 \$14 vin1.$122.GatPoly 0.00222086f
Cred_251 \$14 vin1.$123.GatPoly 0.0475351f
Cred_252 \$14 vin1.$127.GatPoly 0.0417679f
Cred_253 \$14 vin1.$130.GatPoly 0.00215885f
Cred_254 \$14 vin1.$134.GatPoly 0.00196193f
Cred_255 \$14 vin1.$135.GatPoly 0.0394474f
Cred_256 \$14 vin1.$136.GatPoly 0.00182557f
Cred_257 \$14 vin1.$137.GatPoly 0.036143f
Cred_258 \$14 vin1.$144.GatPoly 0.00227689f
Cred_259 \$14 vin1.$145.GatPoly 0.044997f
Cred_260 \$14 vin1.$15.GatPoly 0.0354764f
Cred_261 \$14 vin1.$152.GatPoly 0.00232243f
Cred_262 \$14 vin1.$153.GatPoly 0.0481543f
Cred_263 \$14 vin1.$156.GatPoly 0.00224944f
Cred_264 \$14 vin1.$157.GatPoly 0.0349032f
Cred_265 \$14 vin1.$16.GatPoly 0.00203206f
Cred_266 \$14 vin1.$163.GatPoly 0.0375976f
Cred_267 \$14 vin1.$164.GatPoly 0.00222366f
Cred_268 \$14 vin1.$167.GatPoly 0.0354764f
Cred_269 \$14 vin1.$17.GatPoly 0.0363484f
Cred_270 \$14 vin1.$172.GatPoly 0.00203206f
Cred_271 \$14 vin1.$173.GatPoly 0.0363484f
Cred_272 \$14 vin1.$176.GatPoly 0.00187831f
Cred_273 \$14 vin1.$179.GatPoly 0.0589988f
Cred_274 \$14 vin1.$180.GatPoly 0.00249429f
Cred_275 \$14 vin1.$202.Metal1 0.00186644f
Cred_276 \$14 vin1.$203.Metal1 0.082159f
Cred_277 \$14 vin1.$207.Metal1 0.00935973f
Cred_278 \$14 vin1.$210.Metal1 0.000223024f
Cred_279 \$14 vin1.$211.Metal1 0.00971519f
Cred_280 \$14 vin1.$218.Metal1 0.000240046f
Cred_281 \$14 vin1.$219.Metal1 0.00588183f
Cred_282 \$14 vin1.$22.GatPoly 0.00222366f
Cred_283 \$14 vin1.$222.Metal1 0.000333732f
Cred_284 \$14 vin1.$227.Metal1 0.0130305f
Cred_285 \$14 vin1.$228.Metal1 0.00027357f
Cred_286 \$14 vin1.$232.Metal1 8.96946e-05f
Cred_287 \$14 vin1.$233.Metal1 0.00217557f
Cred_288 \$14 vin1.$236.Metal1 0.000377029f
Cred_289 \$14 vin1.$237.Metal1 0.00663819f
Cred_290 \$14 vin1.$24.GatPoly 0.00224944f
Cred_291 \$14 vin1.$240.Metal1 0.000377767f
Cred_292 \$14 vin1.$241.Metal1 0.0101154f
Cred_293 \$14 vin1.$246.Metal1 0.000257941f
Cred_294 \$14 vin1.$247.Metal1 0.00784507f
Cred_295 \$14 vin1.$25.GatPoly 0.0349032f
Cred_296 \$14 vin1.$250.Metal1 0.000324278f
Cred_297 \$14 vin1.$251.Metal1 0.00761718f
Cred_298 \$14 vin1.$258.Metal1 0.00029449f
Cred_299 \$14 vin1.$259.Metal1 0.00753178f
Cred_300 \$14 vin1.$262.Metal1 0.000162477f
Cred_301 \$14 vin1.$263.Metal1 0.0032873f
Cred_302 \$14 vin1.$264.Metal1 0.000217448f
Cred_303 \$14 vin1.$265.Metal1 0.00454978f
Cred_304 \$14 vin1.$27.GatPoly 0.0375976f
Cred_305 \$14 vin1.$272.Metal1 0.000231506f
Cred_306 \$14 vin1.$273.Metal1 0.00856607f
Cred_307 \$14 vin1.$277.Metal1 0.00373913f
Cred_308 \$14 vin1.$280.Metal1 0.000382703f
Cred_309 \$14 vin1.$281.Metal1 0.00548296f
Cred_310 \$14 vin1.$284.Metal1 0.000382839f
Cred_311 \$14 vin1.$285.Metal1 0.00900476f
Cred_312 \$14 vin1.$290.Metal1 0.000206296f
Cred_313 \$14 vin1.$291.Metal1 0.00689173f
Cred_314 \$14 vin1.$295.Metal1 0.00843597f
Cred_315 \$14 vin1.$298.Metal1 0.000382927f
Cred_316 \$14 vin1.$302.Metal1 0.000382927f
Cred_317 \$14 vin1.$303.Metal1 0.00914292f
Cred_318 \$14 vin1.$307.Metal1 0.00492576f
Cred_319 \$14 vin1.$312.Metal1 0.000231506f
Cred_320 \$14 vin1.$313.Metal1 0.00358784f
Cred_321 \$14 vin1.$317.Metal1 0.00806706f
Cred_322 \$14 vin1.$320.Metal1 0.000218949f
Cred_323 \$14 vin1.$321.Metal1 0.00399077f
Cred_324 \$14 vin1.$325.Metal1 0.00427514f
Cred_325 \$14 vin1.$328.Metal1 0.000231506f
Cred_326 \$14 vin1.$331.Metal1 0.00870275f
Cred_327 \$14 vin1.$334.Metal1 0.000298532f
Cred_328 \$14 vin1.$335.Metal1 0.00541898f
Cred_329 \$14 vin1.$338.Metal1 0.000292732f
Cred_330 \$14 vin1.$339.Metal1 0.00399077f
Cred_331 \$14 vin1.$343.Metal1 0.00806706f
Cred_332 \$14 vin1.$346.Metal1 0.000231506f
Cred_333 \$14 vin1.$347.Metal1 0.00358784f
Cred_334 \$14 vin1.$353.Metal1 0.00492576f
Cred_335 \$14 vin1.$356.Metal1 0.000382927f
Cred_336 \$14 vin1.$357.Metal1 0.00914292f
Cred_337 \$14 vin1.$36.GatPoly 0.00232243f
Cred_338 \$14 vin1.$360.Metal1 0.000382927f
Cred_339 \$14 vin1.$365.Metal1 0.00843597f
Cred_340 \$14 vin1.$368.Metal1 0.000206296f
Cred_341 \$14 vin1.$369.Metal1 0.00689173f
Cred_342 \$14 vin1.$37.GatPoly 0.0481543f
Cred_343 \$14 vin1.$374.Metal1 0.000382839f
Cred_344 \$14 vin1.$375.Metal1 0.00900476f
Cred_345 \$14 vin1.$378.Metal1 0.000382703f
Cred_346 \$14 vin1.$379.Metal1 0.00548296f
Cred_347 \$14 vin1.$383.Metal1 0.00373913f
Cred_348 \$14 vin1.$386.Metal1 0.000231506f
Cred_349 \$14 vin1.$387.Metal1 0.00856607f
Cred_350 \$14 vin1.$392.Metal1 0.000217448f
Cred_351 \$14 vin1.$393.Metal1 0.00454978f
Cred_352 \$14 vin1.$396.Metal1 0.000162477f
Cred_353 \$14 vin1.$397.Metal1 0.0032873f
Cred_354 \$14 vin1.$400.Metal1 0.00029449f
Cred_355 \$14 vin1.$401.Metal1 0.00753178f
Cred_356 \$14 vin1.$408.Metal1 0.000324278f
Cred_357 \$14 vin1.$409.Metal1 0.00761718f
Cred_358 \$14 vin1.$412.Metal1 0.000257941f
Cred_359 \$14 vin1.$413.Metal1 0.00784507f
Cred_360 \$14 vin1.$418.Metal1 0.000377767f
Cred_361 \$14 vin1.$419.Metal1 0.0101154f
Cred_362 \$14 vin1.$42.GatPoly 0.00227689f
Cred_363 \$14 vin1.$422.Metal1 0.000377029f
Cred_364 \$14 vin1.$423.Metal1 0.00663819f
Cred_365 \$14 vin1.$426.Metal1 8.96946e-05f
Cred_366 \$14 vin1.$427.Metal1 0.00217557f
Cred_367 \$14 vin1.$43.GatPoly 0.044997f
Cred_368 \$14 vin1.$430.Metal1 0.00027357f
Cred_369 \$14 vin1.$433.Metal1 0.0130305f
Cred_370 \$14 vin1.$437.Metal1 0.000333732f
Cred_371 \$14 vin1.$44.GatPoly 0.00182557f
Cred_372 \$14 vin1.$440.Metal1 0.000240046f
Cred_373 \$14 vin1.$441.Metal1 0.00588183f
Cred_374 \$14 vin1.$448.Metal1 0.000223024f
Cred_375 \$14 vin1.$449.Metal1 0.00971519f
Cred_376 \$14 vin1.$453.Metal1 0.00935973f
Cred_377 \$14 vin1.$456.Metal1 0.00189652f
Cred_378 \$14 vin1.$457.Metal1 0.0797995f
Cred_379 \$14 vin1.$47.GatPoly 0.036143f
Cred_380 \$14 vin1.$477.Metal2 0.0370623f
Cred_381 \$14 vin1.$479.Metal2 0.000147714f
Cred_382 \$14 vin1.$480.Metal2 0.0500232f
Cred_383 \$14 vin1.$484.Metal2 0.00462294f
Cred_384 \$14 vin1.$486.Metal2 0.0114253f
Cred_385 \$14 vin1.$489.Metal2 0.00529723f
Cred_386 \$14 vin1.$493.Metal2 0.00520449f
Cred_387 \$14 vin1.$495.Metal2 0.0121395f
Cred_388 \$14 vin1.$500.Metal2 0.00504892f
Cred_389 \$14 vin1.$504.Metal2 0.00589792f
Cred_390 \$14 vin1.$506.Metal2 0.0113466f
Cred_391 \$14 vin1.$509.Metal2 0.00405261f
Cred_392 \$14 vin1.$513.Metal2 0.00412776f
Cred_393 \$14 vin1.$515.Metal2 0.0148484f
Cred_394 \$14 vin1.$518.Metal2 0.00467127f
Cred_395 \$14 vin1.$52.GatPoly 0.00196193f
Cred_396 \$14 vin1.$520.Metal2 0.00301828f
Cred_397 \$14 vin1.$523.Metal2 0.00162091f
Cred_398 \$14 vin1.$527.Metal2 0.010855f
Cred_399 \$14 vin1.$528.Metal2 6.15536e-05f
Cred_400 \$14 vin1.$53.GatPoly 0.0394474f
Cred_401 \$14 vin1.$533.Metal2 0.00619595f
Cred_402 \$14 vin1.$535.Metal2 0.0148954f
Cred_403 \$14 vin1.$538.Metal2 0.00447878f
Cred_404 \$14 vin1.$542.Metal2 0.00369713f
Cred_405 \$14 vin1.$544.Metal2 0.0112653f
Cred_406 \$14 vin1.$547.Metal2 0.00631762f
Cred_407 \$14 vin1.$551.Metal2 0.00490436f
Cred_408 \$14 vin1.$555.Metal2 0.0120706f
Cred_409 \$14 vin1.$558.Metal2 0.00510643f
Cred_410 \$14 vin1.$562.Metal2 0.00496692f
Cred_411 \$14 vin1.$564.Metal2 0.0114378f
Cred_412 \$14 vin1.$567.Metal2 0.00495373f
Cred_413 \$14 vin1.$57.GatPoly 0.0417679f
Cred_414 \$14 vin1.$571.Metal2 0.00510643f
Cred_415 \$14 vin1.$573.Metal2 0.0120706f
Cred_416 \$14 vin1.$578.Metal2 0.00490436f
Cred_417 \$14 vin1.$58.GatPoly 0.00215885f
Cred_418 \$14 vin1.$582.Metal2 0.00631762f
Cred_419 \$14 vin1.$584.Metal2 0.0112653f
Cred_420 \$14 vin1.$587.Metal2 0.00369713f
Cred_421 \$14 vin1.$591.Metal2 0.00447878f
Cred_422 \$14 vin1.$593.Metal2 0.0148954f
Cred_423 \$14 vin1.$596.Metal2 0.00619595f
Cred_424 \$14 vin1.$599.Metal2 6.15536e-05f
Cred_425 \$14 vin1.$6.GatPoly 0.00249321f
Cred_426 \$14 vin1.$603.Metal2 0.010855f
Cred_427 \$14 vin1.$604.Metal2 0.00162091f
Cred_428 \$14 vin1.$609.Metal2 0.00301828f
Cred_429 \$14 vin1.$611.Metal2 0.00467127f
Cred_430 \$14 vin1.$613.Metal2 0.0148484f
Cred_431 \$14 vin1.$616.Metal2 0.00412776f
Cred_432 \$14 vin1.$620.Metal2 0.00405261f
Cred_433 \$14 vin1.$622.Metal2 0.0113466f
Cred_434 \$14 vin1.$625.Metal2 0.00589792f
Cred_435 \$14 vin1.$629.Metal2 0.00504892f
Cred_436 \$14 vin1.$633.Metal2 0.0121395f
Cred_437 \$14 vin1.$636.Metal2 0.00520449f
Cred_438 \$14 vin1.$64.GatPoly 0.00222086f
Cred_439 \$14 vin1.$640.Metal2 0.00529723f
Cred_440 \$14 vin1.$642.Metal2 0.0216999f
Cred_441 \$14 vin1.$645.Metal2 0.00462294f
Cred_442 \$14 vin1.$648.Metal2 0.000720258f
Cred_443 \$14 vin1.$649.Metal2 0.00669697f
Cred_444 \$14 vin1.$65.GatPoly 0.0475351f
Cred_445 \$14 vin1.$653.Metal2 0.00494089f
Cred_446 \$14 vin1.$654.Metal2 0.026511f
Cred_447 \$14 vin1.$70.GatPoly 0.00219009f
Cred_448 \$14 vin1.$73.GatPoly 0.0461296f
Cred_449 \$14 vin1.$77.GatPoly 0.034766f
Cred_450 \$14 vin1.$78.GatPoly 0.00190757f
Cred_451 \$14 vin1.$80.GatPoly 0.00162127f
Cred_452 \$14 vin1.$83.GatPoly 0.0395235f
Cred_453 \$14 vin1.$84.GatPoly 0.00195865f
Cred_454 \$14 vin1.$87.GatPoly 0.0344622f
Cred_455 \$14 vin1.$9.GatPoly 0.0590415f
Cred_456 \$14 vin1.$90.GatPoly 0.00191379f
Cred_457 \$14 vin1.$93.GatPoly 0.0394701f
Cred_458 \$14 vin1.$94.GatPoly 0.00210912f
Cred_459 \$14 vin1.$97.GatPoly 0.0412011f
Cred_460 \$14 vin1.P0.GatPoly 0.00166352f
Cred_461 \$14 vin1.P1.GatPoly 0.00047016f
Cred_462 \$14 vin1.P10.GatPoly 0.0006579f
Cred_463 \$14 vin1.P12.GatPoly 0.000304679f
Cred_464 \$14 vin1.P13.GatPoly 0.000263521f
Cred_465 \$14 vin1.P15.GatPoly 0.000684045f
Cred_466 \$14 vin1.P17.GatPoly 0.000708445f
Cred_467 \$14 vin1.P18.GatPoly 0.00047016f
Cred_468 \$14 vin1.P19.GatPoly 0.00166452f
Cred_469 \$14 vin1.P2.GatPoly 0.000708445f
Cred_470 \$14 vin1.P20.GatPoly 0.0773389f
Cred_471 \$14 vin1.P21.GatPoly 0.0579889f
Cred_472 \$14 vin1.P22.GatPoly 0.0579889f
Cred_473 \$14 vin1.P23.GatPoly 0.0579889f
Cred_474 \$14 vin1.P24.GatPoly 0.0625567f
Cred_475 \$14 vin1.P25.GatPoly 0.0579889f
Cred_476 \$14 vin1.P26.GatPoly 0.0579889f
Cred_477 \$14 vin1.P27.GatPoly 0.0626564f
Cred_478 \$14 vin1.P28.GatPoly 0.0579889f
Cred_479 \$14 vin1.P29.GatPoly 0.0579889f
Cred_480 \$14 vin1.P30.GatPoly 0.0579889f
Cred_481 \$14 vin1.P31.GatPoly 0.0579889f
Cred_482 \$14 vin1.P32.GatPoly 0.0626564f
Cred_483 \$14 vin1.P33.GatPoly 0.0579889f
Cred_484 \$14 vin1.P34.GatPoly 0.0579889f
Cred_485 \$14 vin1.P35.GatPoly 0.0625567f
Cred_486 \$14 vin1.P36.GatPoly 0.0579889f
Cred_487 \$14 vin1.P37.GatPoly 0.0579889f
Cred_488 \$14 vin1.P38.GatPoly 0.0579889f
Cred_489 \$14 vin1.P39.GatPoly 0.147623f
Cred_490 \$14 vin1.P4.GatPoly 0.000684045f
Cred_491 \$14 vin1.P6.GatPoly 0.000263521f
Cred_492 \$14 vin1.P7.GatPoly 0.000304679f
Cred_493 \$14 vin1.P9.GatPoly 0.000258104f
Cred_494 \$14 vin2.$101.GatPoly 0.00220776f
Cred_495 \$14 vin2.$104.GatPoly 0.0395235f
Cred_496 \$14 vin2.$106.GatPoly 0.034766f
Cred_497 \$14 vin2.$109.GatPoly 0.00190859f
Cred_498 \$14 vin2.$11.GatPoly 0.00187831f
Cred_499 \$14 vin2.$111.GatPoly 0.00190757f
Cred_500 \$14 vin2.$114.GatPoly 0.0461296f
Cred_501 \$14 vin2.$119.GatPoly 0.00219009f
Cred_502 \$14 vin2.$122.GatPoly 0.0475351f
Cred_503 \$14 vin2.$123.GatPoly 0.00222086f
Cred_504 \$14 vin2.$126.GatPoly 0.0417679f
Cred_505 \$14 vin2.$131.GatPoly 0.00215885f
Cred_506 \$14 vin2.$134.GatPoly 0.0394474f
Cred_507 \$14 vin2.$135.GatPoly 0.00196193f
Cred_508 \$14 vin2.$136.GatPoly 0.036143f
Cred_509 \$14 vin2.$137.GatPoly 0.00182557f
Cred_510 \$14 vin2.$14.GatPoly 0.0354764f
Cred_511 \$14 vin2.$144.GatPoly 0.044997f
Cred_512 \$14 vin2.$145.GatPoly 0.00227689f
Cred_513 \$14 vin2.$152.GatPoly 0.0481543f
Cred_514 \$14 vin2.$153.GatPoly 0.00232243f
Cred_515 \$14 vin2.$156.GatPoly 0.0349032f
Cred_516 \$14 vin2.$157.GatPoly 0.00224944f
Cred_517 \$14 vin2.$16.GatPoly 0.0363484f
Cred_518 \$14 vin2.$162.GatPoly 0.0375976f
Cred_519 \$14 vin2.$165.GatPoly 0.00222366f
Cred_520 \$14 vin2.$166.GatPoly 0.0354764f
Cred_521 \$14 vin2.$17.GatPoly 0.00203206f
Cred_522 \$14 vin2.$172.GatPoly 0.0363484f
Cred_523 \$14 vin2.$173.GatPoly 0.00203206f
Cred_524 \$14 vin2.$177.GatPoly 0.00187831f
Cred_525 \$14 vin2.$178.GatPoly 0.0589988f
Cred_526 \$14 vin2.$181.GatPoly 0.00249429f
Cred_527 \$14 vin2.$202.Metal1 0.082159f
Cred_528 \$14 vin2.$203.Metal1 0.00186644f
Cred_529 \$14 vin2.$206.Metal1 0.00935973f
Cred_530 \$14 vin2.$210.Metal1 0.00971519f
Cred_531 \$14 vin2.$211.Metal1 0.000223024f
Cred_532 \$14 vin2.$218.Metal1 0.00588183f
Cred_533 \$14 vin2.$219.Metal1 0.000240046f
Cred_534 \$14 vin2.$223.Metal1 0.000333732f
Cred_535 \$14 vin2.$226.Metal1 0.0130305f
Cred_536 \$14 vin2.$229.Metal1 0.00027357f
Cred_537 \$14 vin2.$23.GatPoly 0.00222366f
Cred_538 \$14 vin2.$232.Metal1 0.00217557f
Cred_539 \$14 vin2.$233.Metal1 8.96946e-05f
Cred_540 \$14 vin2.$236.Metal1 0.00663819f
Cred_541 \$14 vin2.$237.Metal1 0.000377029f
Cred_542 \$14 vin2.$24.GatPoly 0.0349032f
Cred_543 \$14 vin2.$240.Metal1 0.0101154f
Cred_544 \$14 vin2.$241.Metal1 0.000377767f
Cred_545 \$14 vin2.$246.Metal1 0.00784507f
Cred_546 \$14 vin2.$247.Metal1 0.000257941f
Cred_547 \$14 vin2.$25.GatPoly 0.00224944f
Cred_548 \$14 vin2.$250.Metal1 0.00761718f
Cred_549 \$14 vin2.$251.Metal1 0.000324278f
Cred_550 \$14 vin2.$258.Metal1 0.00753178f
Cred_551 \$14 vin2.$259.Metal1 0.00029449f
Cred_552 \$14 vin2.$26.GatPoly 0.0375976f
Cred_553 \$14 vin2.$262.Metal1 0.0032873f
Cred_554 \$14 vin2.$263.Metal1 0.000162477f
Cred_555 \$14 vin2.$264.Metal1 0.00454978f
Cred_556 \$14 vin2.$265.Metal1 0.000217448f
Cred_557 \$14 vin2.$272.Metal1 0.00856607f
Cred_558 \$14 vin2.$273.Metal1 0.000231506f
Cred_559 \$14 vin2.$276.Metal1 0.00373913f
Cred_560 \$14 vin2.$280.Metal1 0.00548296f
Cred_561 \$14 vin2.$281.Metal1 0.000382703f
Cred_562 \$14 vin2.$284.Metal1 0.00900476f
Cred_563 \$14 vin2.$285.Metal1 0.000382839f
Cred_564 \$14 vin2.$290.Metal1 0.00689173f
Cred_565 \$14 vin2.$291.Metal1 0.000206296f
Cred_566 \$14 vin2.$294.Metal1 0.00843597f
Cred_567 \$14 vin2.$299.Metal1 0.000382927f
Cred_568 \$14 vin2.$302.Metal1 0.00914292f
Cred_569 \$14 vin2.$303.Metal1 0.000382927f
Cred_570 \$14 vin2.$306.Metal1 0.00492576f
Cred_571 \$14 vin2.$312.Metal1 0.00358784f
Cred_572 \$14 vin2.$316.Metal1 0.00806706f
Cred_573 \$14 vin2.$317.Metal1 0.000369142f
Cred_574 \$14 vin2.$320.Metal1 0.00399077f
Cred_575 \$14 vin2.$321.Metal1 0.000348066f
Cred_576 \$14 vin2.$324.Metal1 0.00427514f
Cred_577 \$14 vin2.$329.Metal1 0.000231506f
Cred_578 \$14 vin2.$330.Metal1 0.00870275f
Cred_579 \$14 vin2.$334.Metal1 0.00541898f
Cred_580 \$14 vin2.$335.Metal1 0.000224386f
Cred_581 \$14 vin2.$338.Metal1 0.00399077f
Cred_582 \$14 vin2.$342.Metal1 0.00806706f
Cred_583 \$14 vin2.$343.Metal1 0.00056489f
Cred_584 \$14 vin2.$346.Metal1 0.00358784f
Cred_585 \$14 vin2.$349.Metal1 0.000196956f
Cred_586 \$14 vin2.$352.Metal1 0.00492576f
Cred_587 \$14 vin2.$356.Metal1 0.00914292f
Cred_588 \$14 vin2.$357.Metal1 0.000382927f
Cred_589 \$14 vin2.$36.GatPoly 0.0481543f
Cred_590 \$14 vin2.$361.Metal1 0.000382927f
Cred_591 \$14 vin2.$364.Metal1 0.00843597f
Cred_592 \$14 vin2.$368.Metal1 0.00689173f
Cred_593 \$14 vin2.$369.Metal1 0.000206296f
Cred_594 \$14 vin2.$37.GatPoly 0.00232243f
Cred_595 \$14 vin2.$374.Metal1 0.00900476f
Cred_596 \$14 vin2.$375.Metal1 0.000382839f
Cred_597 \$14 vin2.$378.Metal1 0.00548296f
Cred_598 \$14 vin2.$379.Metal1 0.000382703f
Cred_599 \$14 vin2.$382.Metal1 0.00373913f
Cred_600 \$14 vin2.$386.Metal1 0.00856607f
Cred_601 \$14 vin2.$387.Metal1 0.000231506f
Cred_602 \$14 vin2.$392.Metal1 0.00454978f
Cred_603 \$14 vin2.$393.Metal1 0.000217448f
Cred_604 \$14 vin2.$396.Metal1 0.0032873f
Cred_605 \$14 vin2.$397.Metal1 0.000162477f
Cred_606 \$14 vin2.$400.Metal1 0.00753178f
Cred_607 \$14 vin2.$401.Metal1 0.00029449f
Cred_608 \$14 vin2.$408.Metal1 0.00761718f
Cred_609 \$14 vin2.$409.Metal1 0.000324278f
Cred_610 \$14 vin2.$412.Metal1 0.00784507f
Cred_611 \$14 vin2.$413.Metal1 0.000257941f
Cred_612 \$14 vin2.$418.Metal1 0.0101154f
Cred_613 \$14 vin2.$419.Metal1 0.000377767f
Cred_614 \$14 vin2.$42.GatPoly 0.044997f
Cred_615 \$14 vin2.$422.Metal1 0.00663819f
Cred_616 \$14 vin2.$423.Metal1 0.000377029f
Cred_617 \$14 vin2.$426.Metal1 0.00217557f
Cred_618 \$14 vin2.$427.Metal1 8.96946e-05f
Cred_619 \$14 vin2.$43.GatPoly 0.00227689f
Cred_620 \$14 vin2.$431.Metal1 0.00027357f
Cred_621 \$14 vin2.$432.Metal1 0.0130305f
Cred_622 \$14 vin2.$439.Metal1 0.000333732f
Cred_623 \$14 vin2.$44.GatPoly 0.036143f
Cred_624 \$14 vin2.$440.Metal1 0.00588183f
Cred_625 \$14 vin2.$441.Metal1 0.000240046f
Cred_626 \$14 vin2.$448.Metal1 0.00971519f
Cred_627 \$14 vin2.$449.Metal1 0.000223024f
Cred_628 \$14 vin2.$452.Metal1 0.00935973f
Cred_629 \$14 vin2.$456.Metal1 0.0797995f
Cred_630 \$14 vin2.$457.Metal1 0.00189652f
Cred_631 \$14 vin2.$47.GatPoly 0.00182557f
Cred_632 \$14 vin2.$477.Metal2 0.0370623f
Cred_633 \$14 vin2.$479.Metal2 0.0500232f
Cred_634 \$14 vin2.$480.Metal2 0.000147714f
Cred_635 \$14 vin2.$483.Metal2 0.00462294f
Cred_636 \$14 vin2.$486.Metal2 0.0114253f
Cred_637 \$14 vin2.$488.Metal2 0.00529723f
Cred_638 \$14 vin2.$492.Metal2 0.00520449f
Cred_639 \$14 vin2.$495.Metal2 0.0121395f
Cred_640 \$14 vin2.$499.Metal2 0.00504892f
Cred_641 \$14 vin2.$503.Metal2 0.00589792f
Cred_642 \$14 vin2.$506.Metal2 0.0113466f
Cred_643 \$14 vin2.$508.Metal2 0.00405261f
Cred_644 \$14 vin2.$512.Metal2 0.00412776f
Cred_645 \$14 vin2.$515.Metal2 0.0148484f
Cred_646 \$14 vin2.$517.Metal2 0.00467127f
Cred_647 \$14 vin2.$519.Metal2 0.00301828f
Cred_648 \$14 vin2.$52.GatPoly 0.0394474f
Cred_649 \$14 vin2.$524.Metal2 0.00162091f
Cred_650 \$14 vin2.$525.Metal2 0.010855f
Cred_651 \$14 vin2.$529.Metal2 6.15536e-05f
Cred_652 \$14 vin2.$53.GatPoly 0.00196193f
Cred_653 \$14 vin2.$532.Metal2 0.00619595f
Cred_654 \$14 vin2.$535.Metal2 0.0148954f
Cred_655 \$14 vin2.$537.Metal2 0.00447878f
Cred_656 \$14 vin2.$541.Metal2 0.00369713f
Cred_657 \$14 vin2.$544.Metal2 0.0112653f
Cred_658 \$14 vin2.$546.Metal2 0.00631762f
Cred_659 \$14 vin2.$550.Metal2 0.00490436f
Cred_660 \$14 vin2.$555.Metal2 0.0120706f
Cred_661 \$14 vin2.$557.Metal2 0.00510643f
Cred_662 \$14 vin2.$56.GatPoly 0.0417679f
Cred_663 \$14 vin2.$561.Metal2 0.00496692f
Cred_664 \$14 vin2.$564.Metal2 0.0114378f
Cred_665 \$14 vin2.$566.Metal2 0.00495373f
Cred_666 \$14 vin2.$570.Metal2 0.00510643f
Cred_667 \$14 vin2.$573.Metal2 0.0120706f
Cred_668 \$14 vin2.$576.Metal2 2.59162e-06f
Cred_669 \$14 vin2.$577.Metal2 0.00490436f
Cred_670 \$14 vin2.$581.Metal2 0.00631762f
Cred_671 \$14 vin2.$584.Metal2 0.0112653f
Cred_672 \$14 vin2.$586.Metal2 0.00369713f
Cred_673 \$14 vin2.$59.GatPoly 0.00215885f
Cred_674 \$14 vin2.$590.Metal2 0.00447878f
Cred_675 \$14 vin2.$593.Metal2 0.0148954f
Cred_676 \$14 vin2.$595.Metal2 0.00619595f
Cred_677 \$14 vin2.$600.Metal2 6.15536e-05f
Cred_678 \$14 vin2.$601.Metal2 0.010855f
Cred_679 \$14 vin2.$605.Metal2 0.00162091f
Cred_680 \$14 vin2.$608.Metal2 0.00301828f
Cred_681 \$14 vin2.$610.Metal2 0.00467127f
Cred_682 \$14 vin2.$613.Metal2 0.0148484f
Cred_683 \$14 vin2.$615.Metal2 0.00412776f
Cred_684 \$14 vin2.$619.Metal2 0.00405261f
Cred_685 \$14 vin2.$622.Metal2 0.0113466f
Cred_686 \$14 vin2.$624.Metal2 0.00589792f
Cred_687 \$14 vin2.$628.Metal2 0.00504892f
Cred_688 \$14 vin2.$633.Metal2 0.0121395f
Cred_689 \$14 vin2.$635.Metal2 0.00520449f
Cred_690 \$14 vin2.$639.Metal2 0.00529723f
Cred_691 \$14 vin2.$64.GatPoly 0.0475351f
Cred_692 \$14 vin2.$642.Metal2 0.0217778f
Cred_693 \$14 vin2.$644.Metal2 0.00462294f
Cred_694 \$14 vin2.$648.Metal2 0.00678589f
Cred_695 \$14 vin2.$649.Metal2 0.000615178f
Cred_696 \$14 vin2.$65.GatPoly 0.00222086f
Cred_697 \$14 vin2.$653.Metal2 0.026851f
Cred_698 \$14 vin2.$654.Metal2 0.00453912f
Cred_699 \$14 vin2.$7.GatPoly 0.00249321f
Cred_700 \$14 vin2.$71.GatPoly 0.00219009f
Cred_701 \$14 vin2.$72.GatPoly 0.0461296f
Cred_702 \$14 vin2.$76.GatPoly 0.034766f
Cred_703 \$14 vin2.$79.GatPoly 0.00190757f
Cred_704 \$14 vin2.$8.GatPoly 0.0590415f
Cred_705 \$14 vin2.$81.GatPoly 0.00118355f
Cred_706 \$14 vin2.$82.GatPoly 0.0395235f
Cred_707 \$14 vin2.$83.GatPoly 0.00180491f
Cred_708 \$14 vin2.$86.GatPoly 0.0344622f
Cred_709 \$14 vin2.$91.GatPoly 0.00208629f
Cred_710 \$14 vin2.$92.GatPoly 0.0394701f
Cred_711 \$14 vin2.$95.GatPoly 0.00196893f
Cred_712 \$14 vin2.$96.GatPoly 0.0412011f
Cred_713 \$14 vin2.P0.GatPoly 0.00166352f
Cred_714 \$14 vin2.P1.GatPoly 0.00047016f
Cred_715 \$14 vin2.P10.GatPoly 0.000235123f
Cred_716 \$14 vin2.P12.GatPoly 0.000304679f
Cred_717 \$14 vin2.P13.GatPoly 0.000263521f
Cred_718 \$14 vin2.P15.GatPoly 0.000684045f
Cred_719 \$14 vin2.P17.GatPoly 0.000708445f
Cred_720 \$14 vin2.P18.GatPoly 0.00047016f
Cred_721 \$14 vin2.P19.GatPoly 0.00166452f
Cred_722 \$14 vin2.P2.GatPoly 0.000708445f
Cred_723 \$14 vin2.P20.GatPoly 0.147656f
Cred_724 \$14 vin2.P21.GatPoly 0.0579889f
Cred_725 \$14 vin2.P22.GatPoly 0.0579889f
Cred_726 \$14 vin2.P23.GatPoly 0.0579889f
Cred_727 \$14 vin2.P24.GatPoly 0.0625567f
Cred_728 \$14 vin2.P25.GatPoly 0.0579889f
Cred_729 \$14 vin2.P26.GatPoly 0.0579889f
Cred_730 \$14 vin2.P27.GatPoly 0.0626564f
Cred_731 \$14 vin2.P28.GatPoly 0.0579889f
Cred_732 \$14 vin2.P29.GatPoly 0.0579889f
Cred_733 \$14 vin2.P30.GatPoly 0.0579889f
Cred_734 \$14 vin2.P31.GatPoly 0.0579889f
Cred_735 \$14 vin2.P32.GatPoly 0.0626564f
Cred_736 \$14 vin2.P33.GatPoly 0.0579889f
Cred_737 \$14 vin2.P34.GatPoly 0.0579889f
Cred_738 \$14 vin2.P35.GatPoly 0.0625567f
Cred_739 \$14 vin2.P36.GatPoly 0.0579889f
Cred_740 \$14 vin2.P37.GatPoly 0.0579889f
Cred_741 \$14 vin2.P38.GatPoly 0.0579889f
Cred_742 \$14 vin2.P39.GatPoly 0.0773056f
Cred_743 \$14 vin2.P4.GatPoly 0.000684045f
Cred_744 \$14 vin2.P6.GatPoly 0.000263521f
Cred_745 \$14 vin2.P7.GatPoly 0.000304679f
Cred_746 \$14 vin2.P9.GatPoly 0.000410312f
Cred_747 \$14 vout1 0.0111029f
Cred_748 \$14 vout1.$1226.Metal3 0.0652818f
Cred_749 \$14 vout1.$1292.Metal3 0.038615f
Cred_750 \$14 vout1.$1358.Metal3 0.0387555f
Cred_751 \$14 vout1.$1424.Metal3 0.0853028f
Cred_752 \$14 vout1.P0.nSD 0.000828685f
Cred_753 \$14 vout1.P0.pSD 0.00999565f
Cred_754 \$14 vout1.P10.nSD 0.000148877f
Cred_755 \$14 vout1.P10.pSD 0.0051617f
Cred_756 \$14 vout1.P12.pSD 0.00435537f
Cred_757 \$14 vout1.P14.nSD 0.000148877f
Cred_758 \$14 vout1.P14.pSD 0.0051617f
Cred_759 \$14 vout1.P16.pSD 0.00435537f
Cred_760 \$14 vout1.P18.nSD 0.000882187f
Cred_761 \$14 vout1.P18.pSD 0.010405f
Cred_762 \$14 vout1.P2.nSD 0.000568987f
Cred_763 \$14 vout1.P2.pSD 0.00755786f
Cred_764 \$14 vout1.P4.pSD 0.00444821f
Cred_765 \$14 vout1.P6.nSD 0.000148126f
Cred_766 \$14 vout1.P6.pSD 0.00525775f
Cred_767 \$14 vout1.P8.pSD 0.00444821f
Cred_768 \$14 vout2 0.0111029f
Cred_769 \$14 vout2.$1226.Metal3 0.0652818f
Cred_770 \$14 vout2.$1292.Metal3 0.038615f
Cred_771 \$14 vout2.$1358.Metal3 0.0387555f
Cred_772 \$14 vout2.$1424.Metal3 0.0853028f
Cred_773 \$14 vout2.P0.nSD 0.000828685f
Cred_774 \$14 vout2.P0.pSD 0.00999565f
Cred_775 \$14 vout2.P10.nSD 0.000148877f
Cred_776 \$14 vout2.P10.pSD 0.0051617f
Cred_777 \$14 vout2.P12.pSD 0.00435537f
Cred_778 \$14 vout2.P14.nSD 0.000148877f
Cred_779 \$14 vout2.P14.pSD 0.0051617f
Cred_780 \$14 vout2.P16.pSD 0.00435537f
Cred_781 \$14 vout2.P18.nSD 0.000882187f
Cred_782 \$14 vout2.P18.pSD 0.010405f
Cred_783 \$14 vout2.P2.nSD 0.000568987f
Cred_784 \$14 vout2.P2.pSD 0.00755786f
Cred_785 \$14 vout2.P4.pSD 0.00444821f
Cred_786 \$14 vout2.P6.nSD 0.000148126f
Cred_787 \$14 vout2.P6.pSD 0.00525775f
Cred_788 \$14 vout2.P8.pSD 0.00444821f
Cred_789 \$14 VSS.$1989.Metal1 0.00265367f
Cred_790 \$14 VSS.$1990.Metal1 0.00731168f
Cred_791 \$14 VSS.$2020.Metal1 0.00713843f
Cred_792 \$14 VSS.$2021.Metal1 0.00101774f
Cred_793 \$14 VSS.$29.Metal1 0.0100816f
Cred_794 \$14 VSS.$4164.Metal2 0.0178061f
Cred_795 \$14 VSS.$4227.Metal2 0.00843684f
Cred_796 \$14 VSS.$4355.Metal3 0.00394088f
Cred_797 \$14 VSS.$4358.Metal3 0.00394088f
Cred_798 \$14 VSS.$68.Metal1 0.00731168f
Cred_799 \$14 VSS.P1.pSD 0.163299f
Cred_800 \$14 VSS.P2.GatPoly 0.00326544f
Cred_801 \$14 VSS.P3.GatPoly 0.00326544f
Cred_802 \$14 VSS.P3.pSD 0.168073f
Cred_803 \$14 VSS.P45.nSD 2.08702e-06f
Cred_804 \$14 VSS.P47.nSD 2.08702e-06f
Cred_805 \$14 VSS.P6.GatPoly 0.00326544f
Cred_806 \$14 VSS.P7.GatPoly 0.00326544f
Cred_807 \$14 VSS.P93.nSD 4.45615e-06f
Cred_808 \$14 VSS.P95.nSD 4.45615e-06f
Cred_809 \$25 VDD 0.208722f
Cred_810 \$25 VDD.$1001.Metal1 0.0411152f
Cred_811 \$25 VDD.$1021.Metal1 0.0720345f
Cred_812 \$25 VDD.$1025.Metal1 0.108331f
Cred_813 \$25 VDD.$118.Metal1 0.158195f
Cred_814 \$25 VDD.$119.Metal1 0.0179219f
Cred_815 \$25 VDD.$1251.Metal1 0.0692596f
Cred_816 \$25 VDD.$1271.Metal1 0.0411504f
Cred_817 \$25 VDD.$1291.Metal1 0.0426544f
Cred_818 \$25 VDD.$1311.Metal1 0.0650391f
Cred_819 \$25 VDD.$1339.Metal1 0.0884238f
Cred_820 \$25 VDD.$135.Metal1 0.0746742f
Cred_821 \$25 VDD.$1355.Metal1 0.067345f
Cred_822 \$25 VDD.$138.Metal1 0.09215f
Cred_823 \$25 VDD.$1417.Metal1 0.0203531f
Cred_824 \$25 VDD.$1561.Metal1 0.0508775f
Cred_825 \$25 VDD.$1581.Metal1 0.0406414f
Cred_826 \$25 VDD.$1601.Metal1 0.0411163f
Cred_827 \$25 VDD.$1621.Metal1 0.0707858f
Cred_828 \$25 VDD.$1649.Metal1 0.0630078f
Cred_829 \$25 VDD.$1669.Metal1 0.0586679f
Cred_830 \$25 VDD.$1685.Metal1 0.0885106f
Cred_831 \$25 VDD.$1835.Metal1 0.0775559f
Cred_832 \$25 VDD.$185.Metal1 0.019204f
Cred_833 \$25 VDD.$186.Metal1 0.00921626f
Cred_834 \$25 VDD.$1919.Metal1 0.0659047f
Cred_835 \$25 VDD.$1939.Metal1 0.0421632f
Cred_836 \$25 VDD.$1959.Metal1 0.0424114f
Cred_837 \$25 VDD.$1979.Metal1 0.0411397f
Cred_838 \$25 VDD.$1999.Metal1 0.0683695f
Cred_839 \$25 VDD.$2227.Metal1 0.0683695f
Cred_840 \$25 VDD.$2247.Metal1 0.0411397f
Cred_841 \$25 VDD.$2267.Metal1 0.0424199f
Cred_842 \$25 VDD.$2287.Metal1 0.0629397f
Cred_843 \$25 VDD.$2327.Metal1 0.0694127f
Cred_844 \$25 VDD.$2331.Metal1 0.0518631f
Cred_845 \$25 VDD.$2393.Metal1 0.0533655f
Cred_846 \$25 VDD.$2481.Metal1 0.054931f
Cred_847 \$25 VDD.$2557.Metal1 0.0404245f
Cred_848 \$25 VDD.$2577.Metal1 0.0411363f
Cred_849 \$25 VDD.$259.Metal1 0.049224f
Cred_850 \$25 VDD.$2597.Metal1 0.068267f
Cred_851 \$25 VDD.$260.Metal1 1.68074e-06f
Cred_852 \$25 VDD.$2625.Metal1 0.0654703f
Cred_853 \$25 VDD.$2645.Metal1 0.0599889f
Cred_854 \$25 VDD.$2661.Metal1 0.0987693f
Cred_855 \$25 VDD.$2811.Metal1 0.0203531f
Cred_856 \$25 VDD.$2887.Metal1 0.0884238f
Cred_857 \$25 VDD.$2915.Metal1 0.0650391f
Cred_858 \$25 VDD.$2935.Metal1 0.0426544f
Cred_859 \$25 VDD.$2955.Metal1 0.0411504f
Cred_860 \$25 VDD.$2975.Metal1 0.0692596f
Cred_861 \$25 VDD.$2999.Metal1 0.108331f
Cred_862 \$25 VDD.$3205.Metal1 0.0720345f
Cred_863 \$25 VDD.$3225.Metal1 0.0411152f
Cred_864 \$25 VDD.$3245.Metal1 0.0416916f
Cred_865 \$25 VDD.$3265.Metal1 0.0660034f
Cred_866 \$25 VDD.$3293.Metal1 0.0672005f
Cred_867 \$25 VDD.$3313.Metal1 0.0602357f
Cred_868 \$25 VDD.$3317.Metal1 0.0745816f
Cred_869 \$25 VDD.$3535.Metal1 0.0670759f
Cred_870 \$25 VDD.$3555.Metal1 0.0649906f
Cred_871 \$25 VDD.$3583.Metal1 0.0687522f
Cred_872 \$25 VDD.$3603.Metal1 0.0411366f
Cred_873 \$25 VDD.$362.Metal1 0.0682928f
Cred_874 \$25 VDD.$3623.Metal1 0.0406432f
Cred_875 \$25 VDD.$363.Metal1 0.225161f
Cred_876 \$25 VDD.$3643.Metal1 0.0484836f
Cred_877 \$25 VDD.$3652.Metal1 0.0321233f
Cred_878 \$25 VDD.$3655.Metal1 0.018258f
Cred_879 \$25 VDD.$3660.Metal1 0.0179219f
Cred_880 \$25 VDD.$3761.Metal1 0.0496442f
Cred_881 \$25 VDD.$3762.Metal1 1.68074e-06f
Cred_882 \$25 VDD.$3764.Metal1 2.14238e-06f
Cred_883 \$25 VDD.$3765.Metal1 6.0205e-08f
Cred_884 \$25 VDD.$3770.Metal1 0.0141296f
Cred_885 \$25 VDD.$3771.Metal1 0.00545331f
Cred_886 \$25 VDD.$3772.Metal1 0.00551091f
Cred_887 \$25 VDD.$3773.Metal1 0.00921447f
Cred_888 \$25 VDD.$3775.Metal1 0.00836079f
Cred_889 \$25 VDD.$3776.Metal1 0.00543382f
Cred_890 \$25 VDD.$3777.Metal1 0.00558119f
Cred_891 \$25 VDD.$3778.Metal1 0.00561336f
Cred_892 \$25 VDD.$3779.Metal1 0.00546054f
Cred_893 \$25 VDD.$3780.Metal1 0.0447637f
Cred_894 \$25 VDD.$3796.Metal1 0.080975f
Cred_895 \$25 VDD.$3797.Metal1 0.14348f
Cred_896 \$25 VDD.$3808.Metal1 0.09215f
Cred_897 \$25 VDD.$3845.Metal1 0.0746742f
Cred_898 \$25 VDD.$3857.Metal1 0.0615023f
Cred_899 \$25 VDD.$390.Metal1 0.0945559f
Cred_900 \$25 VDD.$4059.Metal1 0.019204f
Cred_901 \$25 VDD.$4060.Metal1 0.00921626f
Cred_902 \$25 VDD.$410.Metal1 0.0321233f
Cred_903 \$25 VDD.$4107.Metal1 0.158195f
Cred_904 \$25 VDD.$4212.Metal2 0.00996603f
Cred_905 \$25 VDD.$4214.Metal2 0.00166516f
Cred_906 \$25 VDD.$4216.Metal2 0.00233125f
Cred_907 \$25 VDD.$4218.Metal2 0.00216251f
Cred_908 \$25 VDD.$4220.Metal2 0.00166416f
Cred_909 \$25 VDD.$4222.Metal2 0.0623949f
Cred_910 \$25 VDD.$4259.Metal2 0.0300963f
Cred_911 \$25 VDD.$4261.Metal2 0.00294683f
Cred_912 \$25 VDD.$4263.Metal2 0.00220898f
Cred_913 \$25 VDD.$4264.Metal2 0.00148409f
Cred_914 \$25 VDD.$4265.Metal2 0.0101009f
Cred_915 \$25 VDD.$4538.Metal2 0.00663068f
Cred_916 \$25 VDD.$4586.Metal2 0.00981622f
Cred_917 \$25 VDD.$4634.Metal2 0.00653703f
Cred_918 \$25 VDD.$4658.Metal2 0.0207674f
Cred_919 \$25 VDD.$4740.Metal2 0.0233379f
Cred_920 \$25 VDD.$4820.Metal2 0.00655823f
Cred_921 \$25 VDD.$4868.Metal2 0.00768394f
Cred_922 \$25 VDD.$4892.Metal2 0.00647636f
Cred_923 \$25 VDD.$4998.Metal2 0.027643f
Cred_924 \$25 VDD.$5078.Metal2 0.0197146f
Cred_925 \$25 VDD.$5126.Metal2 0.00941929f
Cred_926 \$25 VDD.$5174.Metal2 0.0123611f
Cred_927 \$25 VDD.$5211.Metal2 0.0312632f
Cred_928 \$25 VDD.$5280.Metal2 0.00538551f
Cred_929 \$25 VDD.$5384.Metal2 0.0119739f
Cred_930 \$25 VDD.$542.Metal1 2.14238e-06f
Cred_931 \$25 VDD.$543.Metal1 6.0205e-08f
Cred_932 \$25 VDD.$5432.Metal2 0.00954551f
Cred_933 \$25 VDD.$5480.Metal2 0.018116f
Cred_934 \$25 VDD.$5562.Metal2 0.0199819f
Cred_935 \$25 VDD.$5642.Metal2 0.0136803f
Cred_936 \$25 VDD.$5690.Metal2 0.0075906f
Cred_937 \$25 VDD.$5714.Metal2 0.00659766f
Cred_938 \$25 VDD.$573.Metal1 0.018258f
Cred_939 \$25 VDD.$5806.Metal2 0.0237073f
Cred_940 \$25 VDD.$583.Metal1 0.0484836f
Cred_941 \$25 VDD.$5886.Metal2 0.0237073f
Cred_942 \$25 VDD.$5948.Metal2 0.00927978f
Cred_943 \$25 VDD.$5996.Metal2 0.012751f
Cred_944 \$25 VDD.$603.Metal1 0.0406495f
Cred_945 \$25 VDD.$6033.Metal2 0.031605f
Cred_946 \$25 VDD.$6102.Metal2 0.00566822f
Cred_947 \$25 VDD.$6206.Metal2 0.0109555f
Cred_948 \$25 VDD.$623.Metal1 0.0634875f
Cred_949 \$25 VDD.$6254.Metal2 0.00969443f
Cred_950 \$25 VDD.$6302.Metal2 0.0137809f
Cred_951 \$25 VDD.$6384.Metal2 0.0303143f
Cred_952 \$25 VDD.$6488.Metal2 0.0123611f
Cred_953 \$25 VDD.$6536.Metal2 0.00941929f
Cred_954 \$25 VDD.$657.Metal1 0.0703006f
Cred_955 \$25 VDD.$6584.Metal2 0.0197146f
Cred_956 \$25 VDD.$6666.Metal2 0.027643f
Cred_957 \$25 VDD.$671.Metal1 0.0411162f
Cred_958 \$25 VDD.$6770.Metal2 0.00920228f
Cred_959 \$25 VDD.$6818.Metal2 0.00931977f
Cred_960 \$25 VDD.$691.Metal1 0.0670716f
Cred_961 \$25 VDD.$6924.Metal2 0.0254538f
Cred_962 \$25 VDD.$7004.Metal2 0.0229046f
Cred_963 \$25 VDD.$7052.Metal2 0.00942342f
Cred_964 \$25 VDD.$707.Metal1 0.0745816f
Cred_965 \$25 VDD.$7100.Metal2 0.0069677f
Cred_966 \$25 VDD.$7124.Metal2 0.00450518f
Cred_967 \$25 VDD.$7148.Metal2 0.00996603f
Cred_968 \$25 VDD.$7150.Metal2 0.00166516f
Cred_969 \$25 VDD.$7152.Metal2 0.00233125f
Cred_970 \$25 VDD.$7154.Metal2 0.00216251f
Cred_971 \$25 VDD.$7156.Metal2 0.00166416f
Cred_972 \$25 VDD.$7158.Metal2 0.0104192f
Cred_973 \$25 VDD.$7197.Metal2 0.0343979f
Cred_974 \$25 VDD.$7199.Metal2 0.00294683f
Cred_975 \$25 VDD.$7201.Metal2 0.00220898f
Cred_976 \$25 VDD.$7202.Metal2 0.00148409f
Cred_977 \$25 VDD.$7203.Metal2 0.0101009f
Cred_978 \$25 VDD.$7204.Metal2 0.0107812f
Cred_979 \$25 VDD.$7206.Metal2 0.00292017f
Cred_980 \$25 VDD.$7208.Metal2 0.00365965f
Cred_981 \$25 VDD.$7211.Metal2 0.00438062f
Cred_982 \$25 VDD.$7214.Metal2 0.0237118f
Cred_983 \$25 VDD.$7484.Metal3 0.0367132f
Cred_984 \$25 VDD.$7544.Metal3 0.00384185f
Cred_985 \$25 VDD.$7568.Metal3 0.00654682f
Cred_986 \$25 VDD.$7592.Metal3 0.00658861f
Cred_987 \$25 VDD.$7616.Metal3 0.00370986f
Cred_988 \$25 VDD.$7652.Metal3 0.00872285f
Cred_989 \$25 VDD.$7688.Metal3 0.00699998f
Cred_990 \$25 VDD.$7724.Metal3 0.00579049f
Cred_991 \$25 VDD.$7748.Metal3 0.00673667f
Cred_992 \$25 VDD.$7772.Metal3 0.00412751f
Cred_993 \$25 VDD.$7796.Metal3 0.00389975f
Cred_994 \$25 VDD.$7820.Metal3 0.0067114f
Cred_995 \$25 VDD.$7844.Metal3 0.00686978f
Cred_996 \$25 VDD.$7892.Metal3 0.00933254f
Cred_997 \$25 VDD.$7928.Metal3 0.00653118f
Cred_998 \$25 VDD.$7964.Metal3 0.00479055f
Cred_999 \$25 VDD.$7988.Metal3 0.00682553f
Cred_1000 \$25 VDD.$8012.Metal3 0.00473266f
Cred_1001 \$25 VDD.$8036.Metal3 0.00328937f
Cred_1002 \$25 VDD.$8060.Metal3 0.00664458f
Cred_1003 \$25 VDD.$8084.Metal3 0.00641524f
Cred_1004 \$25 VDD.$8120.Metal3 0.00488341f
Cred_1005 \$25 VDD.$8144.Metal3 0.00673667f
Cred_1006 \$25 VDD.$8168.Metal3 0.00579049f
Cred_1007 \$25 VDD.$8204.Metal3 0.00524185f
Cred_1008 \$25 VDD.$8228.Metal3 0.00686154f
Cred_1009 \$25 VDD.$8252.Metal3 0.00510495f
Cred_1010 \$25 VDD.$8288.Metal3 0.00549543f
Cred_1011 \$25 VDD.$8312.Metal3 0.00836498f
Cred_1012 \$25 VDD.$8348.Metal3 0.00539197f
Cred_1013 \$25 VDD.$8408.Metal3 0.036475f
Cred_1014 \$25 VDD.$913.Metal1 0.0821722f
Cred_1015 \$25 VDD.$941.Metal1 0.0684018f
Cred_1016 \$25 VDD.$961.Metal1 0.0428678f
Cred_1017 \$25 VDD.$981.Metal1 0.0416855f
Cred_1018 \$25 VDD.P0.GatPoly 0.0704722f
Cred_1019 \$25 VDD.P0.nSD 0.598369f
Cred_1020 \$25 VDD.P0.pSD 0.00875255f
Cred_1021 \$25 VDD.P1.GatPoly 0.0704722f
Cred_1022 \$25 VDD.P1.pSD 0.00875255f
Cred_1023 \$25 VDD.P10.pSD 0.002302f
Cred_1024 \$25 VDD.P11.pSD 0.00227922f
Cred_1025 \$25 VDD.P13.pSD 0.00228646f
Cred_1026 \$25 VDD.P15.pSD 0.00228108f
Cred_1027 \$25 VDD.P17.pSD 0.00228278f
Cred_1028 \$25 VDD.P19.pSD 0.00230508f
Cred_1029 \$25 VDD.P2.nSD 0.598289f
Cred_1030 \$25 VDD.P21.pSD 0.000475184f
Cred_1031 \$25 VDD.P23.pSD 0.000475184f
Cred_1032 \$25 VDD.P3.pSD 0.00230508f
Cred_1033 \$25 VDD.P4.GatPoly 0.0748418f
Cred_1034 \$25 VDD.P48.pSD 0.00229849f
Cred_1035 \$25 VDD.P49.pSD 0.00227208f
Cred_1036 \$25 VDD.P5.GatPoly 0.0704722f
Cred_1037 \$25 VDD.P5.pSD 0.00228278f
Cred_1038 \$25 VDD.P51.pSD 0.00230508f
Cred_1039 \$25 VDD.P53.pSD 0.00228278f
Cred_1040 \$25 VDD.P55.pSD 0.00227802f
Cred_1041 \$25 VDD.P57.pSD 0.002302f
Cred_1042 \$25 VDD.P59.pSD 0.00227922f
Cred_1043 \$25 VDD.P61.pSD 0.00228646f
Cred_1044 \$25 VDD.P63.pSD 0.00228108f
Cred_1045 \$25 VDD.P65.pSD 0.00228278f
Cred_1046 \$25 VDD.P67.pSD 0.00230508f
Cred_1047 \$25 VDD.P69.pSD 0.00229279f
Cred_1048 \$25 VDD.P7.pSD 0.00227802f
Cred_1049 \$25 VDD.P71.pSD 0.00231919f
Cred_1050 \$25 vin3.$10.GatPoly 0.00187831f
Cred_1051 \$25 vin3.$100.GatPoly 0.00220776f
Cred_1052 \$25 vin3.$105.GatPoly 0.0395235f
Cred_1053 \$25 vin3.$107.GatPoly 0.034766f
Cred_1054 \$25 vin3.$108.GatPoly 0.00190859f
Cred_1055 \$25 vin3.$110.GatPoly 0.00190757f
Cred_1056 \$25 vin3.$115.GatPoly 0.0461296f
Cred_1057 \$25 vin3.$118.GatPoly 0.00219009f
Cred_1058 \$25 vin3.$122.GatPoly 0.00222086f
Cred_1059 \$25 vin3.$123.GatPoly 0.0475351f
Cred_1060 \$25 vin3.$127.GatPoly 0.0417679f
Cred_1061 \$25 vin3.$130.GatPoly 0.00215885f
Cred_1062 \$25 vin3.$134.GatPoly 0.00196193f
Cred_1063 \$25 vin3.$135.GatPoly 0.0394474f
Cred_1064 \$25 vin3.$136.GatPoly 0.00182557f
Cred_1065 \$25 vin3.$137.GatPoly 0.036143f
Cred_1066 \$25 vin3.$144.GatPoly 0.00227689f
Cred_1067 \$25 vin3.$145.GatPoly 0.044997f
Cred_1068 \$25 vin3.$15.GatPoly 0.0354764f
Cred_1069 \$25 vin3.$152.GatPoly 0.00232243f
Cred_1070 \$25 vin3.$153.GatPoly 0.0481543f
Cred_1071 \$25 vin3.$156.GatPoly 0.00224944f
Cred_1072 \$25 vin3.$157.GatPoly 0.0349032f
Cred_1073 \$25 vin3.$16.GatPoly 0.00203206f
Cred_1074 \$25 vin3.$163.GatPoly 0.0375976f
Cred_1075 \$25 vin3.$164.GatPoly 0.00222366f
Cred_1076 \$25 vin3.$167.GatPoly 0.0354764f
Cred_1077 \$25 vin3.$17.GatPoly 0.0363484f
Cred_1078 \$25 vin3.$172.GatPoly 0.00203206f
Cred_1079 \$25 vin3.$173.GatPoly 0.0363484f
Cred_1080 \$25 vin3.$176.GatPoly 0.00187831f
Cred_1081 \$25 vin3.$179.GatPoly 0.0589988f
Cred_1082 \$25 vin3.$180.GatPoly 0.00249429f
Cred_1083 \$25 vin3.$202.Metal1 0.00186644f
Cred_1084 \$25 vin3.$203.Metal1 0.082159f
Cred_1085 \$25 vin3.$207.Metal1 0.00935973f
Cred_1086 \$25 vin3.$210.Metal1 0.000223024f
Cred_1087 \$25 vin3.$211.Metal1 0.00971519f
Cred_1088 \$25 vin3.$218.Metal1 0.000240046f
Cred_1089 \$25 vin3.$219.Metal1 0.00588183f
Cred_1090 \$25 vin3.$22.GatPoly 0.00222366f
Cred_1091 \$25 vin3.$222.Metal1 0.000333732f
Cred_1092 \$25 vin3.$227.Metal1 0.0130305f
Cred_1093 \$25 vin3.$228.Metal1 0.00027357f
Cred_1094 \$25 vin3.$232.Metal1 8.96946e-05f
Cred_1095 \$25 vin3.$233.Metal1 0.00217557f
Cred_1096 \$25 vin3.$236.Metal1 0.000377029f
Cred_1097 \$25 vin3.$237.Metal1 0.00663819f
Cred_1098 \$25 vin3.$24.GatPoly 0.00224944f
Cred_1099 \$25 vin3.$240.Metal1 0.000377767f
Cred_1100 \$25 vin3.$241.Metal1 0.0101154f
Cred_1101 \$25 vin3.$246.Metal1 0.000257941f
Cred_1102 \$25 vin3.$247.Metal1 0.00784507f
Cred_1103 \$25 vin3.$25.GatPoly 0.0349032f
Cred_1104 \$25 vin3.$250.Metal1 0.000324278f
Cred_1105 \$25 vin3.$251.Metal1 0.00761718f
Cred_1106 \$25 vin3.$258.Metal1 0.00029449f
Cred_1107 \$25 vin3.$259.Metal1 0.00753178f
Cred_1108 \$25 vin3.$262.Metal1 0.000162477f
Cred_1109 \$25 vin3.$263.Metal1 0.0032873f
Cred_1110 \$25 vin3.$264.Metal1 0.000217448f
Cred_1111 \$25 vin3.$265.Metal1 0.00454978f
Cred_1112 \$25 vin3.$27.GatPoly 0.0375976f
Cred_1113 \$25 vin3.$272.Metal1 0.000231506f
Cred_1114 \$25 vin3.$273.Metal1 0.00856607f
Cred_1115 \$25 vin3.$277.Metal1 0.00373913f
Cred_1116 \$25 vin3.$280.Metal1 0.000382703f
Cred_1117 \$25 vin3.$281.Metal1 0.00548296f
Cred_1118 \$25 vin3.$284.Metal1 0.000382839f
Cred_1119 \$25 vin3.$285.Metal1 0.00900476f
Cred_1120 \$25 vin3.$290.Metal1 0.000206296f
Cred_1121 \$25 vin3.$291.Metal1 0.00689173f
Cred_1122 \$25 vin3.$295.Metal1 0.00843597f
Cred_1123 \$25 vin3.$298.Metal1 0.000382927f
Cred_1124 \$25 vin3.$302.Metal1 0.000382927f
Cred_1125 \$25 vin3.$303.Metal1 0.00914292f
Cred_1126 \$25 vin3.$307.Metal1 0.00492576f
Cred_1127 \$25 vin3.$313.Metal1 0.00358784f
Cred_1128 \$25 vin3.$316.Metal1 0.000369142f
Cred_1129 \$25 vin3.$317.Metal1 0.00806706f
Cred_1130 \$25 vin3.$320.Metal1 0.000348066f
Cred_1131 \$25 vin3.$321.Metal1 0.00399077f
Cred_1132 \$25 vin3.$325.Metal1 0.00427514f
Cred_1133 \$25 vin3.$328.Metal1 0.000231506f
Cred_1134 \$25 vin3.$331.Metal1 0.00870275f
Cred_1135 \$25 vin3.$334.Metal1 0.000224386f
Cred_1136 \$25 vin3.$335.Metal1 0.00541898f
Cred_1137 \$25 vin3.$339.Metal1 0.00399077f
Cred_1138 \$25 vin3.$342.Metal1 0.00056489f
Cred_1139 \$25 vin3.$343.Metal1 0.00806706f
Cred_1140 \$25 vin3.$347.Metal1 0.00358784f
Cred_1141 \$25 vin3.$348.Metal1 0.000196956f
Cred_1142 \$25 vin3.$353.Metal1 0.00492576f
Cred_1143 \$25 vin3.$356.Metal1 0.000382927f
Cred_1144 \$25 vin3.$357.Metal1 0.00914292f
Cred_1145 \$25 vin3.$36.GatPoly 0.00232243f
Cred_1146 \$25 vin3.$360.Metal1 0.000382927f
Cred_1147 \$25 vin3.$365.Metal1 0.00843597f
Cred_1148 \$25 vin3.$368.Metal1 0.000206296f
Cred_1149 \$25 vin3.$369.Metal1 0.00689173f
Cred_1150 \$25 vin3.$37.GatPoly 0.0481543f
Cred_1151 \$25 vin3.$374.Metal1 0.000382839f
Cred_1152 \$25 vin3.$375.Metal1 0.00900476f
Cred_1153 \$25 vin3.$378.Metal1 0.000382703f
Cred_1154 \$25 vin3.$379.Metal1 0.00548296f
Cred_1155 \$25 vin3.$383.Metal1 0.00373913f
Cred_1156 \$25 vin3.$386.Metal1 0.000231506f
Cred_1157 \$25 vin3.$387.Metal1 0.00856607f
Cred_1158 \$25 vin3.$392.Metal1 0.000217448f
Cred_1159 \$25 vin3.$393.Metal1 0.00454978f
Cred_1160 \$25 vin3.$396.Metal1 0.000162477f
Cred_1161 \$25 vin3.$397.Metal1 0.0032873f
Cred_1162 \$25 vin3.$400.Metal1 0.00029449f
Cred_1163 \$25 vin3.$401.Metal1 0.00753178f
Cred_1164 \$25 vin3.$408.Metal1 0.000324278f
Cred_1165 \$25 vin3.$409.Metal1 0.00761718f
Cred_1166 \$25 vin3.$412.Metal1 0.000257941f
Cred_1167 \$25 vin3.$413.Metal1 0.00784507f
Cred_1168 \$25 vin3.$418.Metal1 0.000377767f
Cred_1169 \$25 vin3.$419.Metal1 0.0101154f
Cred_1170 \$25 vin3.$42.GatPoly 0.00227689f
Cred_1171 \$25 vin3.$422.Metal1 0.000377029f
Cred_1172 \$25 vin3.$423.Metal1 0.00663819f
Cred_1173 \$25 vin3.$426.Metal1 8.96946e-05f
Cred_1174 \$25 vin3.$427.Metal1 0.00217557f
Cred_1175 \$25 vin3.$43.GatPoly 0.044997f
Cred_1176 \$25 vin3.$430.Metal1 0.00027357f
Cred_1177 \$25 vin3.$433.Metal1 0.0130305f
Cred_1178 \$25 vin3.$437.Metal1 0.000333732f
Cred_1179 \$25 vin3.$44.GatPoly 0.00182557f
Cred_1180 \$25 vin3.$440.Metal1 0.000240046f
Cred_1181 \$25 vin3.$441.Metal1 0.00588183f
Cred_1182 \$25 vin3.$448.Metal1 0.000223024f
Cred_1183 \$25 vin3.$449.Metal1 0.00971519f
Cred_1184 \$25 vin3.$453.Metal1 0.00935973f
Cred_1185 \$25 vin3.$456.Metal1 0.00189652f
Cred_1186 \$25 vin3.$457.Metal1 0.0797995f
Cred_1187 \$25 vin3.$47.GatPoly 0.036143f
Cred_1188 \$25 vin3.$477.Metal2 0.0370623f
Cred_1189 \$25 vin3.$479.Metal2 0.000147714f
Cred_1190 \$25 vin3.$480.Metal2 0.0500232f
Cred_1191 \$25 vin3.$484.Metal2 0.00462294f
Cred_1192 \$25 vin3.$486.Metal2 0.0114253f
Cred_1193 \$25 vin3.$489.Metal2 0.00529723f
Cred_1194 \$25 vin3.$493.Metal2 0.00520449f
Cred_1195 \$25 vin3.$495.Metal2 0.0121395f
Cred_1196 \$25 vin3.$500.Metal2 0.00504892f
Cred_1197 \$25 vin3.$504.Metal2 0.00589792f
Cred_1198 \$25 vin3.$506.Metal2 0.0113466f
Cred_1199 \$25 vin3.$509.Metal2 0.00405261f
Cred_1200 \$25 vin3.$513.Metal2 0.00412776f
Cred_1201 \$25 vin3.$515.Metal2 0.0148484f
Cred_1202 \$25 vin3.$518.Metal2 0.00467127f
Cred_1203 \$25 vin3.$52.GatPoly 0.00196193f
Cred_1204 \$25 vin3.$520.Metal2 0.00301828f
Cred_1205 \$25 vin3.$523.Metal2 0.00162091f
Cred_1206 \$25 vin3.$527.Metal2 0.010855f
Cred_1207 \$25 vin3.$528.Metal2 6.15536e-05f
Cred_1208 \$25 vin3.$53.GatPoly 0.0394474f
Cred_1209 \$25 vin3.$533.Metal2 0.00619595f
Cred_1210 \$25 vin3.$535.Metal2 0.0148954f
Cred_1211 \$25 vin3.$538.Metal2 0.00447878f
Cred_1212 \$25 vin3.$542.Metal2 0.00369713f
Cred_1213 \$25 vin3.$544.Metal2 0.0112653f
Cred_1214 \$25 vin3.$547.Metal2 0.00631762f
Cred_1215 \$25 vin3.$551.Metal2 0.00490436f
Cred_1216 \$25 vin3.$555.Metal2 0.0120706f
Cred_1217 \$25 vin3.$558.Metal2 0.00510643f
Cred_1218 \$25 vin3.$562.Metal2 0.00496692f
Cred_1219 \$25 vin3.$564.Metal2 0.0114378f
Cred_1220 \$25 vin3.$567.Metal2 0.00495373f
Cred_1221 \$25 vin3.$57.GatPoly 0.0417679f
Cred_1222 \$25 vin3.$571.Metal2 0.00510643f
Cred_1223 \$25 vin3.$573.Metal2 0.0120706f
Cred_1224 \$25 vin3.$575.Metal2 2.59162e-06f
Cred_1225 \$25 vin3.$578.Metal2 0.00490436f
Cred_1226 \$25 vin3.$58.GatPoly 0.00215885f
Cred_1227 \$25 vin3.$582.Metal2 0.00631762f
Cred_1228 \$25 vin3.$584.Metal2 0.0112653f
Cred_1229 \$25 vin3.$587.Metal2 0.00369713f
Cred_1230 \$25 vin3.$591.Metal2 0.00447878f
Cred_1231 \$25 vin3.$593.Metal2 0.0148954f
Cred_1232 \$25 vin3.$596.Metal2 0.00619595f
Cred_1233 \$25 vin3.$599.Metal2 6.15536e-05f
Cred_1234 \$25 vin3.$6.GatPoly 0.00249321f
Cred_1235 \$25 vin3.$603.Metal2 0.010855f
Cred_1236 \$25 vin3.$604.Metal2 0.00162091f
Cred_1237 \$25 vin3.$609.Metal2 0.00301828f
Cred_1238 \$25 vin3.$611.Metal2 0.00467127f
Cred_1239 \$25 vin3.$613.Metal2 0.0148484f
Cred_1240 \$25 vin3.$616.Metal2 0.00412776f
Cred_1241 \$25 vin3.$620.Metal2 0.00405261f
Cred_1242 \$25 vin3.$622.Metal2 0.0113466f
Cred_1243 \$25 vin3.$625.Metal2 0.00589792f
Cred_1244 \$25 vin3.$629.Metal2 0.00504892f
Cred_1245 \$25 vin3.$633.Metal2 0.0121395f
Cred_1246 \$25 vin3.$636.Metal2 0.00520449f
Cred_1247 \$25 vin3.$64.GatPoly 0.00222086f
Cred_1248 \$25 vin3.$640.Metal2 0.00529723f
Cred_1249 \$25 vin3.$642.Metal2 0.0216999f
Cred_1250 \$25 vin3.$645.Metal2 0.00462294f
Cred_1251 \$25 vin3.$648.Metal2 0.000720258f
Cred_1252 \$25 vin3.$649.Metal2 0.00669697f
Cred_1253 \$25 vin3.$65.GatPoly 0.0475351f
Cred_1254 \$25 vin3.$653.Metal2 0.00494089f
Cred_1255 \$25 vin3.$654.Metal2 0.026511f
Cred_1256 \$25 vin3.$70.GatPoly 0.00219009f
Cred_1257 \$25 vin3.$73.GatPoly 0.0461296f
Cred_1258 \$25 vin3.$77.GatPoly 0.034766f
Cred_1259 \$25 vin3.$78.GatPoly 0.00190757f
Cred_1260 \$25 vin3.$80.GatPoly 0.00118355f
Cred_1261 \$25 vin3.$82.GatPoly 0.00180491f
Cred_1262 \$25 vin3.$83.GatPoly 0.0395235f
Cred_1263 \$25 vin3.$87.GatPoly 0.0344622f
Cred_1264 \$25 vin3.$9.GatPoly 0.0590415f
Cred_1265 \$25 vin3.$90.GatPoly 0.00208629f
Cred_1266 \$25 vin3.$93.GatPoly 0.0394701f
Cred_1267 \$25 vin3.$94.GatPoly 0.00196893f
Cred_1268 \$25 vin3.$97.GatPoly 0.0412011f
Cred_1269 \$25 vin3.P0.GatPoly 0.00166352f
Cred_1270 \$25 vin3.P1.GatPoly 0.00047016f
Cred_1271 \$25 vin3.P10.GatPoly 0.000235123f
Cred_1272 \$25 vin3.P12.GatPoly 0.000304679f
Cred_1273 \$25 vin3.P13.GatPoly 0.000263521f
Cred_1274 \$25 vin3.P15.GatPoly 0.000684045f
Cred_1275 \$25 vin3.P17.GatPoly 0.000708445f
Cred_1276 \$25 vin3.P18.GatPoly 0.00047016f
Cred_1277 \$25 vin3.P19.GatPoly 0.00166452f
Cred_1278 \$25 vin3.P2.GatPoly 0.000708445f
Cred_1279 \$25 vin3.P20.GatPoly 0.0773389f
Cred_1280 \$25 vin3.P21.GatPoly 0.0579889f
Cred_1281 \$25 vin3.P22.GatPoly 0.0579889f
Cred_1282 \$25 vin3.P23.GatPoly 0.0579889f
Cred_1283 \$25 vin3.P24.GatPoly 0.0625567f
Cred_1284 \$25 vin3.P25.GatPoly 0.0579889f
Cred_1285 \$25 vin3.P26.GatPoly 0.0579889f
Cred_1286 \$25 vin3.P27.GatPoly 0.0626564f
Cred_1287 \$25 vin3.P28.GatPoly 0.0579889f
Cred_1288 \$25 vin3.P29.GatPoly 0.0579889f
Cred_1289 \$25 vin3.P30.GatPoly 0.0579889f
Cred_1290 \$25 vin3.P31.GatPoly 0.0579889f
Cred_1291 \$25 vin3.P32.GatPoly 0.0626564f
Cred_1292 \$25 vin3.P33.GatPoly 0.0579889f
Cred_1293 \$25 vin3.P34.GatPoly 0.0579889f
Cred_1294 \$25 vin3.P35.GatPoly 0.0625567f
Cred_1295 \$25 vin3.P36.GatPoly 0.0579889f
Cred_1296 \$25 vin3.P37.GatPoly 0.0579889f
Cred_1297 \$25 vin3.P38.GatPoly 0.0579889f
Cred_1298 \$25 vin3.P39.GatPoly 0.147623f
Cred_1299 \$25 vin3.P4.GatPoly 0.000684045f
Cred_1300 \$25 vin3.P6.GatPoly 0.000263521f
Cred_1301 \$25 vin3.P7.GatPoly 0.000304679f
Cred_1302 \$25 vin3.P9.GatPoly 0.000410312f
Cred_1303 \$25 vin4.$103.GatPoly 0.00209816f
Cred_1304 \$25 vin4.$104.GatPoly 0.0395235f
Cred_1305 \$25 vin4.$106.GatPoly 0.034766f
Cred_1306 \$25 vin4.$109.GatPoly 0.00162127f
Cred_1307 \$25 vin4.$11.GatPoly 0.00187831f
Cred_1308 \$25 vin4.$111.GatPoly 0.00190757f
Cred_1309 \$25 vin4.$114.GatPoly 0.0461296f
Cred_1310 \$25 vin4.$119.GatPoly 0.00219009f
Cred_1311 \$25 vin4.$122.GatPoly 0.0475351f
Cred_1312 \$25 vin4.$123.GatPoly 0.00222086f
Cred_1313 \$25 vin4.$126.GatPoly 0.0417679f
Cred_1314 \$25 vin4.$131.GatPoly 0.00215885f
Cred_1315 \$25 vin4.$134.GatPoly 0.0394474f
Cred_1316 \$25 vin4.$135.GatPoly 0.00196193f
Cred_1317 \$25 vin4.$136.GatPoly 0.036143f
Cred_1318 \$25 vin4.$137.GatPoly 0.00182557f
Cred_1319 \$25 vin4.$14.GatPoly 0.0354764f
Cred_1320 \$25 vin4.$144.GatPoly 0.044997f
Cred_1321 \$25 vin4.$145.GatPoly 0.00227689f
Cred_1322 \$25 vin4.$152.GatPoly 0.0481543f
Cred_1323 \$25 vin4.$153.GatPoly 0.00232243f
Cred_1324 \$25 vin4.$156.GatPoly 0.0349032f
Cred_1325 \$25 vin4.$157.GatPoly 0.00224944f
Cred_1326 \$25 vin4.$16.GatPoly 0.0363484f
Cred_1327 \$25 vin4.$162.GatPoly 0.0375976f
Cred_1328 \$25 vin4.$165.GatPoly 0.00222366f
Cred_1329 \$25 vin4.$166.GatPoly 0.0354764f
Cred_1330 \$25 vin4.$17.GatPoly 0.00203206f
Cred_1331 \$25 vin4.$172.GatPoly 0.0363484f
Cred_1332 \$25 vin4.$173.GatPoly 0.00203206f
Cred_1333 \$25 vin4.$177.GatPoly 0.00187831f
Cred_1334 \$25 vin4.$178.GatPoly 0.0589988f
Cred_1335 \$25 vin4.$181.GatPoly 0.00249429f
Cred_1336 \$25 vin4.$202.Metal1 0.082159f
Cred_1337 \$25 vin4.$203.Metal1 0.00186644f
Cred_1338 \$25 vin4.$206.Metal1 0.00935973f
Cred_1339 \$25 vin4.$210.Metal1 0.00971519f
Cred_1340 \$25 vin4.$211.Metal1 0.000223024f
Cred_1341 \$25 vin4.$218.Metal1 0.00588183f
Cred_1342 \$25 vin4.$219.Metal1 0.000240046f
Cred_1343 \$25 vin4.$223.Metal1 0.000333732f
Cred_1344 \$25 vin4.$226.Metal1 0.0130305f
Cred_1345 \$25 vin4.$229.Metal1 0.00027357f
Cred_1346 \$25 vin4.$23.GatPoly 0.00222366f
Cred_1347 \$25 vin4.$232.Metal1 0.00217557f
Cred_1348 \$25 vin4.$233.Metal1 8.96946e-05f
Cred_1349 \$25 vin4.$236.Metal1 0.00663819f
Cred_1350 \$25 vin4.$237.Metal1 0.000377029f
Cred_1351 \$25 vin4.$24.GatPoly 0.0349032f
Cred_1352 \$25 vin4.$240.Metal1 0.0101154f
Cred_1353 \$25 vin4.$241.Metal1 0.000377767f
Cred_1354 \$25 vin4.$246.Metal1 0.00784507f
Cred_1355 \$25 vin4.$247.Metal1 0.000257941f
Cred_1356 \$25 vin4.$25.GatPoly 0.00224944f
Cred_1357 \$25 vin4.$250.Metal1 0.00761718f
Cred_1358 \$25 vin4.$251.Metal1 0.000324278f
Cred_1359 \$25 vin4.$258.Metal1 0.00753178f
Cred_1360 \$25 vin4.$259.Metal1 0.00029449f
Cred_1361 \$25 vin4.$26.GatPoly 0.0375976f
Cred_1362 \$25 vin4.$262.Metal1 0.0032873f
Cred_1363 \$25 vin4.$263.Metal1 0.000162477f
Cred_1364 \$25 vin4.$264.Metal1 0.00454978f
Cred_1365 \$25 vin4.$265.Metal1 0.000217448f
Cred_1366 \$25 vin4.$272.Metal1 0.00856607f
Cred_1367 \$25 vin4.$273.Metal1 0.000231506f
Cred_1368 \$25 vin4.$276.Metal1 0.00373913f
Cred_1369 \$25 vin4.$280.Metal1 0.00548296f
Cred_1370 \$25 vin4.$281.Metal1 0.000382703f
Cred_1371 \$25 vin4.$284.Metal1 0.00900476f
Cred_1372 \$25 vin4.$285.Metal1 0.000382839f
Cred_1373 \$25 vin4.$290.Metal1 0.00689173f
Cred_1374 \$25 vin4.$291.Metal1 0.000206296f
Cred_1375 \$25 vin4.$294.Metal1 0.00843597f
Cred_1376 \$25 vin4.$299.Metal1 0.000382927f
Cred_1377 \$25 vin4.$302.Metal1 0.00914292f
Cred_1378 \$25 vin4.$303.Metal1 0.000382927f
Cred_1379 \$25 vin4.$306.Metal1 0.00492576f
Cred_1380 \$25 vin4.$312.Metal1 0.00358784f
Cred_1381 \$25 vin4.$313.Metal1 0.000231506f
Cred_1382 \$25 vin4.$316.Metal1 0.00806706f
Cred_1383 \$25 vin4.$320.Metal1 0.00399077f
Cred_1384 \$25 vin4.$321.Metal1 0.000218949f
Cred_1385 \$25 vin4.$324.Metal1 0.00427514f
Cred_1386 \$25 vin4.$329.Metal1 0.000231506f
Cred_1387 \$25 vin4.$330.Metal1 0.00870275f
Cred_1388 \$25 vin4.$334.Metal1 0.00541898f
Cred_1389 \$25 vin4.$335.Metal1 0.000298532f
Cred_1390 \$25 vin4.$338.Metal1 0.00399077f
Cred_1391 \$25 vin4.$339.Metal1 0.000292732f
Cred_1392 \$25 vin4.$342.Metal1 0.00806706f
Cred_1393 \$25 vin4.$346.Metal1 0.00358784f
Cred_1394 \$25 vin4.$347.Metal1 0.000231506f
Cred_1395 \$25 vin4.$352.Metal1 0.00492576f
Cred_1396 \$25 vin4.$356.Metal1 0.00914292f
Cred_1397 \$25 vin4.$357.Metal1 0.000382927f
Cred_1398 \$25 vin4.$36.GatPoly 0.0481543f
Cred_1399 \$25 vin4.$361.Metal1 0.000382927f
Cred_1400 \$25 vin4.$364.Metal1 0.00843597f
Cred_1401 \$25 vin4.$368.Metal1 0.00689173f
Cred_1402 \$25 vin4.$369.Metal1 0.000206296f
Cred_1403 \$25 vin4.$37.GatPoly 0.00232243f
Cred_1404 \$25 vin4.$374.Metal1 0.00900476f
Cred_1405 \$25 vin4.$375.Metal1 0.000382839f
Cred_1406 \$25 vin4.$378.Metal1 0.00548296f
Cred_1407 \$25 vin4.$379.Metal1 0.000382703f
Cred_1408 \$25 vin4.$382.Metal1 0.00373913f
Cred_1409 \$25 vin4.$386.Metal1 0.00856607f
Cred_1410 \$25 vin4.$387.Metal1 0.000231506f
Cred_1411 \$25 vin4.$392.Metal1 0.00454978f
Cred_1412 \$25 vin4.$393.Metal1 0.000217448f
Cred_1413 \$25 vin4.$396.Metal1 0.0032873f
Cred_1414 \$25 vin4.$397.Metal1 0.000162477f
Cred_1415 \$25 vin4.$400.Metal1 0.00753178f
Cred_1416 \$25 vin4.$401.Metal1 0.00029449f
Cred_1417 \$25 vin4.$408.Metal1 0.00761718f
Cred_1418 \$25 vin4.$409.Metal1 0.000324278f
Cred_1419 \$25 vin4.$412.Metal1 0.00784507f
Cred_1420 \$25 vin4.$413.Metal1 0.000257941f
Cred_1421 \$25 vin4.$418.Metal1 0.0101154f
Cred_1422 \$25 vin4.$419.Metal1 0.000377767f
Cred_1423 \$25 vin4.$42.GatPoly 0.044997f
Cred_1424 \$25 vin4.$422.Metal1 0.00663819f
Cred_1425 \$25 vin4.$423.Metal1 0.000377029f
Cred_1426 \$25 vin4.$426.Metal1 0.00217557f
Cred_1427 \$25 vin4.$427.Metal1 8.96946e-05f
Cred_1428 \$25 vin4.$43.GatPoly 0.00227689f
Cred_1429 \$25 vin4.$431.Metal1 0.00027357f
Cred_1430 \$25 vin4.$432.Metal1 0.0130305f
Cred_1431 \$25 vin4.$439.Metal1 0.000333732f
Cred_1432 \$25 vin4.$44.GatPoly 0.036143f
Cred_1433 \$25 vin4.$440.Metal1 0.00588183f
Cred_1434 \$25 vin4.$441.Metal1 0.000240046f
Cred_1435 \$25 vin4.$448.Metal1 0.00971519f
Cred_1436 \$25 vin4.$449.Metal1 0.000223024f
Cred_1437 \$25 vin4.$452.Metal1 0.00935973f
Cred_1438 \$25 vin4.$456.Metal1 0.0797995f
Cred_1439 \$25 vin4.$457.Metal1 0.00189652f
Cred_1440 \$25 vin4.$47.GatPoly 0.00182557f
Cred_1441 \$25 vin4.$477.Metal2 0.0370623f
Cred_1442 \$25 vin4.$479.Metal2 0.0500232f
Cred_1443 \$25 vin4.$480.Metal2 0.000147714f
Cred_1444 \$25 vin4.$483.Metal2 0.00462294f
Cred_1445 \$25 vin4.$486.Metal2 0.0114253f
Cred_1446 \$25 vin4.$488.Metal2 0.00529723f
Cred_1447 \$25 vin4.$492.Metal2 0.00520449f
Cred_1448 \$25 vin4.$495.Metal2 0.0121395f
Cred_1449 \$25 vin4.$499.Metal2 0.00504892f
Cred_1450 \$25 vin4.$503.Metal2 0.00589792f
Cred_1451 \$25 vin4.$506.Metal2 0.0113466f
Cred_1452 \$25 vin4.$508.Metal2 0.00405261f
Cred_1453 \$25 vin4.$512.Metal2 0.00412776f
Cred_1454 \$25 vin4.$515.Metal2 0.0148484f
Cred_1455 \$25 vin4.$517.Metal2 0.00467127f
Cred_1456 \$25 vin4.$519.Metal2 0.00301828f
Cred_1457 \$25 vin4.$52.GatPoly 0.0394474f
Cred_1458 \$25 vin4.$524.Metal2 0.00162091f
Cred_1459 \$25 vin4.$525.Metal2 0.010855f
Cred_1460 \$25 vin4.$529.Metal2 6.15536e-05f
Cred_1461 \$25 vin4.$53.GatPoly 0.00196193f
Cred_1462 \$25 vin4.$532.Metal2 0.00619595f
Cred_1463 \$25 vin4.$535.Metal2 0.0148954f
Cred_1464 \$25 vin4.$537.Metal2 0.00447878f
Cred_1465 \$25 vin4.$541.Metal2 0.00369713f
Cred_1466 \$25 vin4.$544.Metal2 0.0112653f
Cred_1467 \$25 vin4.$546.Metal2 0.00631762f
Cred_1468 \$25 vin4.$550.Metal2 0.00490436f
Cred_1469 \$25 vin4.$555.Metal2 0.0120706f
Cred_1470 \$25 vin4.$557.Metal2 0.00510643f
Cred_1471 \$25 vin4.$56.GatPoly 0.0417679f
Cred_1472 \$25 vin4.$561.Metal2 0.00496692f
Cred_1473 \$25 vin4.$564.Metal2 0.0114378f
Cred_1474 \$25 vin4.$566.Metal2 0.00495373f
Cred_1475 \$25 vin4.$570.Metal2 0.00510643f
Cred_1476 \$25 vin4.$573.Metal2 0.0120706f
Cred_1477 \$25 vin4.$577.Metal2 0.00490436f
Cred_1478 \$25 vin4.$581.Metal2 0.00631762f
Cred_1479 \$25 vin4.$584.Metal2 0.0112653f
Cred_1480 \$25 vin4.$586.Metal2 0.00369713f
Cred_1481 \$25 vin4.$59.GatPoly 0.00215885f
Cred_1482 \$25 vin4.$590.Metal2 0.00447878f
Cred_1483 \$25 vin4.$593.Metal2 0.0148954f
Cred_1484 \$25 vin4.$595.Metal2 0.00619595f
Cred_1485 \$25 vin4.$600.Metal2 6.15536e-05f
Cred_1486 \$25 vin4.$601.Metal2 0.010855f
Cred_1487 \$25 vin4.$605.Metal2 0.00162091f
Cred_1488 \$25 vin4.$608.Metal2 0.00301828f
Cred_1489 \$25 vin4.$610.Metal2 0.00467127f
Cred_1490 \$25 vin4.$613.Metal2 0.0148484f
Cred_1491 \$25 vin4.$615.Metal2 0.00412776f
Cred_1492 \$25 vin4.$619.Metal2 0.00405261f
Cred_1493 \$25 vin4.$622.Metal2 0.0113466f
Cred_1494 \$25 vin4.$624.Metal2 0.00589792f
Cred_1495 \$25 vin4.$628.Metal2 0.00504892f
Cred_1496 \$25 vin4.$633.Metal2 0.0121395f
Cred_1497 \$25 vin4.$635.Metal2 0.00520449f
Cred_1498 \$25 vin4.$639.Metal2 0.00529723f
Cred_1499 \$25 vin4.$64.GatPoly 0.0475351f
Cred_1500 \$25 vin4.$642.Metal2 0.0217778f
Cred_1501 \$25 vin4.$644.Metal2 0.00462294f
Cred_1502 \$25 vin4.$648.Metal2 0.00678589f
Cred_1503 \$25 vin4.$649.Metal2 0.000615178f
Cred_1504 \$25 vin4.$65.GatPoly 0.00222086f
Cred_1505 \$25 vin4.$653.Metal2 0.026851f
Cred_1506 \$25 vin4.$654.Metal2 0.00453912f
Cred_1507 \$25 vin4.$7.GatPoly 0.00249321f
Cred_1508 \$25 vin4.$71.GatPoly 0.00219009f
Cred_1509 \$25 vin4.$72.GatPoly 0.0461296f
Cred_1510 \$25 vin4.$76.GatPoly 0.034766f
Cred_1511 \$25 vin4.$79.GatPoly 0.00190757f
Cred_1512 \$25 vin4.$8.GatPoly 0.0590415f
Cred_1513 \$25 vin4.$81.GatPoly 0.00162127f
Cred_1514 \$25 vin4.$82.GatPoly 0.0395235f
Cred_1515 \$25 vin4.$85.GatPoly 0.00195865f
Cred_1516 \$25 vin4.$86.GatPoly 0.0344622f
Cred_1517 \$25 vin4.$91.GatPoly 0.00191379f
Cred_1518 \$25 vin4.$92.GatPoly 0.0394701f
Cred_1519 \$25 vin4.$95.GatPoly 0.00210912f
Cred_1520 \$25 vin4.$96.GatPoly 0.0412011f
Cred_1521 \$25 vin4.P0.GatPoly 0.00166352f
Cred_1522 \$25 vin4.P1.GatPoly 0.00047016f
Cred_1523 \$25 vin4.P10.GatPoly 0.0006579f
Cred_1524 \$25 vin4.P12.GatPoly 0.000304679f
Cred_1525 \$25 vin4.P13.GatPoly 0.000263521f
Cred_1526 \$25 vin4.P15.GatPoly 0.000684045f
Cred_1527 \$25 vin4.P17.GatPoly 0.000708445f
Cred_1528 \$25 vin4.P18.GatPoly 0.00047016f
Cred_1529 \$25 vin4.P19.GatPoly 0.00166452f
Cred_1530 \$25 vin4.P2.GatPoly 0.000708445f
Cred_1531 \$25 vin4.P20.GatPoly 0.147656f
Cred_1532 \$25 vin4.P21.GatPoly 0.0579889f
Cred_1533 \$25 vin4.P22.GatPoly 0.0579889f
Cred_1534 \$25 vin4.P23.GatPoly 0.0579889f
Cred_1535 \$25 vin4.P24.GatPoly 0.0625567f
Cred_1536 \$25 vin4.P25.GatPoly 0.0579889f
Cred_1537 \$25 vin4.P26.GatPoly 0.0579889f
Cred_1538 \$25 vin4.P27.GatPoly 0.0626564f
Cred_1539 \$25 vin4.P28.GatPoly 0.0579889f
Cred_1540 \$25 vin4.P29.GatPoly 0.0579889f
Cred_1541 \$25 vin4.P30.GatPoly 0.0579889f
Cred_1542 \$25 vin4.P31.GatPoly 0.0579889f
Cred_1543 \$25 vin4.P32.GatPoly 0.0626564f
Cred_1544 \$25 vin4.P33.GatPoly 0.0579889f
Cred_1545 \$25 vin4.P34.GatPoly 0.0579889f
Cred_1546 \$25 vin4.P35.GatPoly 0.0625567f
Cred_1547 \$25 vin4.P36.GatPoly 0.0579889f
Cred_1548 \$25 vin4.P37.GatPoly 0.0579889f
Cred_1549 \$25 vin4.P38.GatPoly 0.0579889f
Cred_1550 \$25 vin4.P39.GatPoly 0.0773056f
Cred_1551 \$25 vin4.P4.GatPoly 0.000684045f
Cred_1552 \$25 vin4.P6.GatPoly 0.000263521f
Cred_1553 \$25 vin4.P7.GatPoly 0.000304679f
Cred_1554 \$25 vin4.P9.GatPoly 0.000258104f
Cred_1555 \$25 vout3 0.0111029f
Cred_1556 \$25 vout3.$1226.Metal3 0.0652818f
Cred_1557 \$25 vout3.$1292.Metal3 0.038615f
Cred_1558 \$25 vout3.$1358.Metal3 0.0387555f
Cred_1559 \$25 vout3.$1424.Metal3 0.0853028f
Cred_1560 \$25 vout3.P0.nSD 0.000828685f
Cred_1561 \$25 vout3.P0.pSD 0.00999565f
Cred_1562 \$25 vout3.P10.nSD 0.000148877f
Cred_1563 \$25 vout3.P10.pSD 0.0051617f
Cred_1564 \$25 vout3.P12.pSD 0.00435537f
Cred_1565 \$25 vout3.P14.nSD 0.000148877f
Cred_1566 \$25 vout3.P14.pSD 0.0051617f
Cred_1567 \$25 vout3.P16.pSD 0.00435537f
Cred_1568 \$25 vout3.P18.nSD 0.000882187f
Cred_1569 \$25 vout3.P18.pSD 0.010405f
Cred_1570 \$25 vout3.P2.nSD 0.000568987f
Cred_1571 \$25 vout3.P2.pSD 0.00755786f
Cred_1572 \$25 vout3.P4.pSD 0.00444821f
Cred_1573 \$25 vout3.P6.nSD 0.000148126f
Cred_1574 \$25 vout3.P6.pSD 0.00525775f
Cred_1575 \$25 vout3.P8.pSD 0.00444821f
Cred_1576 \$25 vout4 0.0111029f
Cred_1577 \$25 vout4.$1226.Metal3 0.0652818f
Cred_1578 \$25 vout4.$1292.Metal3 0.038615f
Cred_1579 \$25 vout4.$1358.Metal3 0.0387555f
Cred_1580 \$25 vout4.$1424.Metal3 0.0853028f
Cred_1581 \$25 vout4.P0.nSD 0.000828685f
Cred_1582 \$25 vout4.P0.pSD 0.00999565f
Cred_1583 \$25 vout4.P10.nSD 0.000148877f
Cred_1584 \$25 vout4.P10.pSD 0.0051617f
Cred_1585 \$25 vout4.P12.pSD 0.00435537f
Cred_1586 \$25 vout4.P14.nSD 0.000148877f
Cred_1587 \$25 vout4.P14.pSD 0.0051617f
Cred_1588 \$25 vout4.P16.pSD 0.00435537f
Cred_1589 \$25 vout4.P18.nSD 0.000882187f
Cred_1590 \$25 vout4.P18.pSD 0.010405f
Cred_1591 \$25 vout4.P2.nSD 0.000568987f
Cred_1592 \$25 vout4.P2.pSD 0.00755786f
Cred_1593 \$25 vout4.P4.pSD 0.00444821f
Cred_1594 \$25 vout4.P6.nSD 0.000148126f
Cred_1595 \$25 vout4.P6.pSD 0.00525775f
Cred_1596 \$25 vout4.P8.pSD 0.00444821f
Cred_1597 \$25 VSS.$1990.Metal1 0.00731168f
Cred_1598 \$25 VSS.$1991.Metal1 0.00265367f
Cred_1599 \$25 VSS.$2022.Metal1 0.000481903f
Cred_1600 \$25 VSS.$2023.Metal1 0.00768792f
Cred_1601 \$25 VSS.$4174.Metal2 0.00843129f
Cred_1602 \$25 VSS.$4241.Metal2 0.0177981f
Cred_1603 \$25 VSS.$4358.Metal3 0.00394088f
Cred_1604 \$25 VSS.$4364.Metal3 0.00394088f
Cred_1605 \$25 VSS.$66.Metal1 0.0100816f
Cred_1606 \$25 VSS.$68.Metal1 0.00731168f
Cred_1607 \$25 VSS.P0.GatPoly 0.00326544f
Cred_1608 \$25 VSS.P0.pSD 0.163299f
Cred_1609 \$25 VSS.P1.GatPoly 0.00326544f
Cred_1610 \$25 VSS.P2.pSD 0.168073f
Cred_1611 \$25 VSS.P21.nSD 4.40761e-06f
Cred_1612 \$25 VSS.P23.nSD 4.40761e-06f
Cred_1613 \$25 VSS.P4.GatPoly 0.00326544f
Cred_1614 \$25 VSS.P5.GatPoly 0.00326544f
Cred_1615 \$25 VSS.P69.nSD 2.11001e-06f
Cred_1616 \$25 VSS.P71.nSD 2.11001e-06f
Cred_1617 VSS VDD 10.0393f
Cred_1618 VSS VDD.$116.Metal1 0.225586f
Cred_1619 VSS VDD.$118.Metal1 0.225586f
Cred_1620 VSS VDD.$129.Metal1 0.0179895f
Cred_1621 VSS VDD.$132.Metal1 0.0178555f
Cred_1622 VSS VDD.$135.Metal1 0.0179895f
Cred_1623 VSS VDD.$138.Metal1 0.0178555f
Cred_1624 VSS VDD.$157.Metal1 9.57653e-06f
Cred_1625 VSS VDD.$158.Metal1 9.68669e-06f
Cred_1626 VSS VDD.$185.Metal1 9.57653e-06f
Cred_1627 VSS VDD.$186.Metal1 9.68669e-06f
Cred_1628 VSS VDD.$225.Metal1 0.00609402f
Cred_1629 VSS VDD.$226.Metal1 1.4073e-05f
Cred_1630 VSS VDD.$259.Metal1 0.00609402f
Cred_1631 VSS VDD.$260.Metal1 1.4073e-05f
Cred_1632 VSS VDD.$360.Metal1 0.0023546f
Cred_1633 VSS VDD.$361.Metal1 0.0472598f
Cred_1634 VSS VDD.$362.Metal1 0.0023546f
Cred_1635 VSS VDD.$363.Metal1 0.0472598f
Cred_1636 VSS VDD.$3727.Metal1 0.00724024f
Cred_1637 VSS VDD.$3728.Metal1 1.4073e-05f
Cred_1638 VSS VDD.$3730.Metal1 1.88405e-05f
Cred_1639 VSS VDD.$3731.Metal1 5.29454e-07f
Cred_1640 VSS VDD.$3736.Metal1 9.81096e-06f
Cred_1641 VSS VDD.$3737.Metal1 1.92131e-05f
Cred_1642 VSS VDD.$3738.Metal1 8.18469e-07f
Cred_1643 VSS VDD.$3739.Metal1 2.82372e-05f
Cred_1644 VSS VDD.$3741.Metal1 4.24246e-05f
Cred_1645 VSS VDD.$3742.Metal1 4.89426e-05f
Cred_1646 VSS VDD.$3743.Metal1 2.44692e-05f
Cred_1647 VSS VDD.$3744.Metal1 1.63166e-05f
Cred_1648 VSS VDD.$3745.Metal1 4.89534e-05f
Cred_1649 VSS VDD.$3746.Metal1 0.00120994f
Cred_1650 VSS VDD.$3761.Metal1 0.00724024f
Cred_1651 VSS VDD.$3762.Metal1 1.4073e-05f
Cred_1652 VSS VDD.$3764.Metal1 1.88405e-05f
Cred_1653 VSS VDD.$3765.Metal1 5.29454e-07f
Cred_1654 VSS VDD.$3770.Metal1 9.81096e-06f
Cred_1655 VSS VDD.$3771.Metal1 1.92131e-05f
Cred_1656 VSS VDD.$3772.Metal1 8.18469e-07f
Cred_1657 VSS VDD.$3773.Metal1 2.82372e-05f
Cred_1658 VSS VDD.$3775.Metal1 4.24246e-05f
Cred_1659 VSS VDD.$3776.Metal1 4.89426e-05f
Cred_1660 VSS VDD.$3777.Metal1 2.44692e-05f
Cred_1661 VSS VDD.$3778.Metal1 1.63166e-05f
Cred_1662 VSS VDD.$3779.Metal1 4.89534e-05f
Cred_1663 VSS VDD.$3780.Metal1 0.00120994f
Cred_1664 VSS VDD.$3794.Metal1 0.00198123f
Cred_1665 VSS VDD.$3795.Metal1 0.00450996f
Cred_1666 VSS VDD.$3796.Metal1 0.00198123f
Cred_1667 VSS VDD.$3797.Metal1 0.00450996f
Cred_1668 VSS VDD.$3802.Metal1 0.0178555f
Cred_1669 VSS VDD.$3808.Metal1 0.0178555f
Cred_1670 VSS VDD.$3839.Metal1 0.0179895f
Cred_1671 VSS VDD.$3845.Metal1 0.0179895f
Cred_1672 VSS VDD.$3851.Metal1 0.0023546f
Cred_1673 VSS VDD.$3857.Metal1 0.0023546f
Cred_1674 VSS VDD.$388.Metal1 0.00198123f
Cred_1675 VSS VDD.$390.Metal1 0.00198123f
Cred_1676 VSS VDD.$4031.Metal1 9.57653e-06f
Cred_1677 VSS VDD.$4032.Metal1 9.68669e-06f
Cred_1678 VSS VDD.$4059.Metal1 9.57653e-06f
Cred_1679 VSS VDD.$4060.Metal1 9.68669e-06f
Cred_1680 VSS VDD.$4106.Metal1 0.225586f
Cred_1681 VSS VDD.$4107.Metal1 0.225586f
Cred_1682 VSS VDD.$4200.Metal2 0.0383756f
Cred_1683 VSS VDD.$4202.Metal2 0.0128113f
Cred_1684 VSS VDD.$4204.Metal2 0.0170383f
Cred_1685 VSS VDD.$4206.Metal2 0.0170396f
Cred_1686 VSS VDD.$4208.Metal2 0.0128113f
Cred_1687 VSS VDD.$4210.Metal2 0.183883f
Cred_1688 VSS VDD.$4212.Metal2 0.0383756f
Cred_1689 VSS VDD.$4214.Metal2 0.0128113f
Cred_1690 VSS VDD.$4216.Metal2 0.0170383f
Cred_1691 VSS VDD.$4218.Metal2 0.0170396f
Cred_1692 VSS VDD.$4220.Metal2 0.0128113f
Cred_1693 VSS VDD.$4222.Metal2 0.183883f
Cred_1694 VSS VDD.$4231.Metal2 0.10628f
Cred_1695 VSS VDD.$4233.Metal2 0.0255936f
Cred_1696 VSS VDD.$4235.Metal2 0.0192024f
Cred_1697 VSS VDD.$4236.Metal2 0.0128113f
Cred_1698 VSS VDD.$4237.Metal2 0.0271309f
Cred_1699 VSS VDD.$4259.Metal2 0.10628f
Cred_1700 VSS VDD.$4261.Metal2 0.0255936f
Cred_1701 VSS VDD.$4263.Metal2 0.0192024f
Cred_1702 VSS VDD.$4264.Metal2 0.0128113f
Cred_1703 VSS VDD.$4265.Metal2 0.0271309f
Cred_1704 VSS VDD.$508.Metal1 1.88405e-05f
Cred_1705 VSS VDD.$509.Metal1 5.29454e-07f
Cred_1706 VSS VDD.$542.Metal1 1.88405e-05f
Cred_1707 VSS VDD.$543.Metal1 5.29454e-07f
Cred_1708 VSS VDD.$7136.Metal2 0.0383756f
Cred_1709 VSS VDD.$7138.Metal2 0.0128113f
Cred_1710 VSS VDD.$7140.Metal2 0.0170383f
Cred_1711 VSS VDD.$7142.Metal2 0.0170396f
Cred_1712 VSS VDD.$7144.Metal2 0.0128113f
Cred_1713 VSS VDD.$7146.Metal2 0.0383735f
Cred_1714 VSS VDD.$7148.Metal2 0.0383756f
Cred_1715 VSS VDD.$7150.Metal2 0.0128113f
Cred_1716 VSS VDD.$7152.Metal2 0.0170383f
Cred_1717 VSS VDD.$7154.Metal2 0.0170396f
Cred_1718 VSS VDD.$7156.Metal2 0.0128113f
Cred_1719 VSS VDD.$7158.Metal2 0.0383735f
Cred_1720 VSS VDD.$7169.Metal2 0.118013f
Cred_1721 VSS VDD.$7171.Metal2 0.0255936f
Cred_1722 VSS VDD.$7173.Metal2 0.0192024f
Cred_1723 VSS VDD.$7174.Metal2 0.0128113f
Cred_1724 VSS VDD.$7175.Metal2 0.0271309f
Cred_1725 VSS VDD.$7176.Metal2 0.033522f
Cred_1726 VSS VDD.$7178.Metal2 0.0255936f
Cred_1727 VSS VDD.$7180.Metal2 0.0319558f
Cred_1728 VSS VDD.$7183.Metal2 0.0383181f
Cred_1729 VSS VDD.$7186.Metal2 0.0798645f
Cred_1730 VSS VDD.$7197.Metal2 0.118013f
Cred_1731 VSS VDD.$7199.Metal2 0.0255936f
Cred_1732 VSS VDD.$7201.Metal2 0.0192024f
Cred_1733 VSS VDD.$7202.Metal2 0.0128113f
Cred_1734 VSS VDD.$7203.Metal2 0.0271309f
Cred_1735 VSS VDD.$7204.Metal2 0.033522f
Cred_1736 VSS VDD.$7206.Metal2 0.0255936f
Cred_1737 VSS VDD.$7208.Metal2 0.0319558f
Cred_1738 VSS VDD.$7211.Metal2 0.0383181f
Cred_1739 VSS VDD.$7214.Metal2 0.0798645f
Cred_1740 VSS VDD.$7478.Metal3 0.794302f
Cred_1741 VSS VDD.$7484.Metal3 0.794302f
Cred_1742 VSS VDD.$8402.Metal3 0.789931f
Cred_1743 VSS VDD.$8408.Metal3 0.789931f
Cred_1744 VSS VDD.P0.GatPoly 0.00788706f
Cred_1745 VSS VDD.P0.nSD 0.649088f
Cred_1746 VSS VDD.P0.pSD 0.00474021f
Cred_1747 VSS VDD.P1.GatPoly 0.00788706f
Cred_1748 VSS VDD.P1.nSD 0.648463f
Cred_1749 VSS VDD.P1.pSD 0.00474021f
Cred_1750 VSS VDD.P2.GatPoly 0.00788706f
Cred_1751 VSS VDD.P2.nSD 0.648463f
Cred_1752 VSS VDD.P21.pSD 1.47484e-05f
Cred_1753 VSS VDD.P23.pSD 1.47484e-05f
Cred_1754 VSS VDD.P24.pSD 0.000287607f
Cred_1755 VSS VDD.P25.pSD 0.000287607f
Cred_1756 VSS VDD.P3.GatPoly 0.00788706f
Cred_1757 VSS VDD.P3.nSD 0.649088f
Cred_1758 VSS VDD.P4.GatPoly 0.00788706f
Cred_1759 VSS VDD.P45.pSD 0.000344088f
Cred_1760 VSS VDD.P47.pSD 0.000344088f
Cred_1761 VSS VDD.P48.pSD 0.000287607f
Cred_1762 VSS VDD.P49.pSD 0.000287607f
Cred_1763 VSS VDD.P5.GatPoly 0.00788706f
Cred_1764 VSS VDD.P6.GatPoly 0.00788706f
Cred_1765 VSS VDD.P69.pSD 0.000344088f
Cred_1766 VSS VDD.P7.GatPoly 0.00788706f
Cred_1767 VSS VDD.P71.pSD 0.000344088f
Cred_1768 VSS VDD.P72.pSD 0.00474021f
Cred_1769 VSS VDD.P73.pSD 0.00474021f
Cred_1770 VSS VDD.P93.pSD 1.47484e-05f
Cred_1771 VSS VDD.P95.pSD 1.47484e-05f
Cred_1772 VSS vin1 0.682852f
Cred_1773 VSS vin1.$10.GatPoly 0.0413156f
Cred_1774 VSS vin1.$102.GatPoly 0.0475528f
Cred_1775 VSS vin1.$105.GatPoly 0.00473739f
Cred_1776 VSS vin1.$107.GatPoly 0.00373578f
Cred_1777 VSS vin1.$108.GatPoly 0.0325349f
Cred_1778 VSS vin1.$110.GatPoly 0.0389814f
Cred_1779 VSS vin1.$115.GatPoly 0.00543054f
Cred_1780 VSS vin1.$118.GatPoly 0.0447656f
Cred_1781 VSS vin1.$122.GatPoly 0.0501571f
Cred_1782 VSS vin1.$123.GatPoly 0.00554504f
Cred_1783 VSS vin1.$127.GatPoly 0.00460339f
Cred_1784 VSS vin1.$130.GatPoly 0.0429479f
Cred_1785 VSS vin1.$134.GatPoly 0.0447943f
Cred_1786 VSS vin1.$135.GatPoly 0.00472455f
Cred_1787 VSS vin1.$136.GatPoly 0.0401879f
Cred_1788 VSS vin1.$137.GatPoly 0.00394869f
Cred_1789 VSS vin1.$144.GatPoly 0.0510568f
Cred_1790 VSS vin1.$145.GatPoly 0.00532136f
Cred_1791 VSS vin1.$15.GatPoly 0.00402788f
Cred_1792 VSS vin1.$152.GatPoly 0.0515261f
Cred_1793 VSS vin1.$153.GatPoly 0.00558667f
Cred_1794 VSS vin1.$156.GatPoly 0.048725f
Cred_1795 VSS vin1.$157.GatPoly 0.00390465f
Cred_1796 VSS vin1.$16.GatPoly 0.0439768f
Cred_1797 VSS vin1.$163.GatPoly 0.00441521f
Cred_1798 VSS vin1.$164.GatPoly 0.0505391f
Cred_1799 VSS vin1.$167.GatPoly 0.00402788f
Cred_1800 VSS vin1.$17.GatPoly 0.00431606f
Cred_1801 VSS vin1.$172.GatPoly 0.0439768f
Cred_1802 VSS vin1.$173.GatPoly 0.00431606f
Cred_1803 VSS vin1.$176.GatPoly 0.0413156f
Cred_1804 VSS vin1.$179.GatPoly 0.00685663f
Cred_1805 VSS vin1.$180.GatPoly 0.0565216f
Cred_1806 VSS vin1.$202.Metal1 0.0764354f
Cred_1807 VSS vin1.$203.Metal1 0.013734f
Cred_1808 VSS vin1.$207.Metal1 0.000874135f
Cred_1809 VSS vin1.$210.Metal1 0.0124361f
Cred_1810 VSS vin1.$211.Metal1 0.000874135f
Cred_1811 VSS vin1.$218.Metal1 0.0112606f
Cred_1812 VSS vin1.$219.Metal1 0.000585335f
Cred_1813 VSS vin1.$22.GatPoly 0.0505391f
Cred_1814 VSS vin1.$222.Metal1 0.0119673f
Cred_1815 VSS vin1.$227.Metal1 0.00118509f
Cred_1816 VSS vin1.$228.Metal1 0.0114373f
Cred_1817 VSS vin1.$232.Metal1 0.00606853f
Cred_1818 VSS vin1.$233.Metal1 0.00013326f
Cred_1819 VSS vin1.$236.Metal1 0.0114323f
Cred_1820 VSS vin1.$237.Metal1 0.000822718f
Cred_1821 VSS vin1.$24.GatPoly 0.048725f
Cred_1822 VSS vin1.$240.Metal1 0.0140838f
Cred_1823 VSS vin1.$241.Metal1 0.000853803f
Cred_1824 VSS vin1.$246.Metal1 0.0112588f
Cred_1825 VSS vin1.$247.Metal1 0.00076447f
Cred_1826 VSS vin1.$25.GatPoly 0.00390465f
Cred_1827 VSS vin1.$250.Metal1 0.0119062f
Cred_1828 VSS vin1.$251.Metal1 0.000812493f
Cred_1829 VSS vin1.$258.Metal1 0.0118264f
Cred_1830 VSS vin1.$259.Metal1 0.00066546f
Cred_1831 VSS vin1.$262.Metal1 0.00734796f
Cred_1832 VSS vin1.$263.Metal1 0.000353246f
Cred_1833 VSS vin1.$264.Metal1 0.00969053f
Cred_1834 VSS vin1.$265.Metal1 0.000464257f
Cred_1835 VSS vin1.$27.GatPoly 0.00441521f
Cred_1836 VSS vin1.$272.Metal1 0.0130424f
Cred_1837 VSS vin1.$273.Metal1 0.000691143f
Cred_1838 VSS vin1.$277.Metal1 0.00041137f
Cred_1839 VSS vin1.$280.Metal1 0.0142455f
Cred_1840 VSS vin1.$281.Metal1 0.000731309f
Cred_1841 VSS vin1.$284.Metal1 0.0139497f
Cred_1842 VSS vin1.$285.Metal1 0.000817657f
Cred_1843 VSS vin1.$290.Metal1 0.012115f
Cred_1844 VSS vin1.$291.Metal1 0.000778597f
Cred_1845 VSS vin1.$295.Metal1 0.000800193f
Cred_1846 VSS vin1.$298.Metal1 0.0150053f
Cred_1847 VSS vin1.$302.Metal1 0.0151111f
Cred_1848 VSS vin1.$303.Metal1 0.000735506f
Cred_1849 VSS vin1.$307.Metal1 0.000727765f
Cred_1850 VSS vin1.$310.Metal1 0.00666126f
Cred_1851 VSS vin1.$312.Metal1 0.0106928f
Cred_1852 VSS vin1.$313.Metal1 0.000203932f
Cred_1853 VSS vin1.$317.Metal1 0.000754794f
Cred_1854 VSS vin1.$320.Metal1 0.0123601f
Cred_1855 VSS vin1.$321.Metal1 0.000572335f
Cred_1856 VSS vin1.$325.Metal1 0.00039103f
Cred_1857 VSS vin1.$328.Metal1 0.0129056f
Cred_1858 VSS vin1.$331.Metal1 0.000772474f
Cred_1859 VSS vin1.$334.Metal1 0.0116676f
Cred_1860 VSS vin1.$335.Metal1 0.000617047f
Cred_1861 VSS vin1.$338.Metal1 0.0114787f
Cred_1862 VSS vin1.$339.Metal1 0.000572335f
Cred_1863 VSS vin1.$343.Metal1 0.000754794f
Cred_1864 VSS vin1.$346.Metal1 0.0106928f
Cred_1865 VSS vin1.$347.Metal1 0.000203932f
Cred_1866 VSS vin1.$348.Metal1 0.00666126f
Cred_1867 VSS vin1.$353.Metal1 0.000727765f
Cred_1868 VSS vin1.$356.Metal1 0.0151111f
Cred_1869 VSS vin1.$357.Metal1 0.000735506f
Cred_1870 VSS vin1.$36.GatPoly 0.0515261f
Cred_1871 VSS vin1.$360.Metal1 0.0150053f
Cred_1872 VSS vin1.$365.Metal1 0.000800193f
Cred_1873 VSS vin1.$368.Metal1 0.012115f
Cred_1874 VSS vin1.$369.Metal1 0.000778597f
Cred_1875 VSS vin1.$37.GatPoly 0.00558667f
Cred_1876 VSS vin1.$374.Metal1 0.0139497f
Cred_1877 VSS vin1.$375.Metal1 0.000817657f
Cred_1878 VSS vin1.$378.Metal1 0.0142455f
Cred_1879 VSS vin1.$379.Metal1 0.000731309f
Cred_1880 VSS vin1.$383.Metal1 0.00041137f
Cred_1881 VSS vin1.$386.Metal1 0.0130424f
Cred_1882 VSS vin1.$387.Metal1 0.000691143f
Cred_1883 VSS vin1.$392.Metal1 0.00969053f
Cred_1884 VSS vin1.$393.Metal1 0.000464257f
Cred_1885 VSS vin1.$396.Metal1 0.00734796f
Cred_1886 VSS vin1.$397.Metal1 0.000353246f
Cred_1887 VSS vin1.$400.Metal1 0.0118264f
Cred_1888 VSS vin1.$401.Metal1 0.00066546f
Cred_1889 VSS vin1.$408.Metal1 0.0119062f
Cred_1890 VSS vin1.$409.Metal1 0.000812493f
Cred_1891 VSS vin1.$412.Metal1 0.0112588f
Cred_1892 VSS vin1.$413.Metal1 0.00076447f
Cred_1893 VSS vin1.$418.Metal1 0.0140838f
Cred_1894 VSS vin1.$419.Metal1 0.000853803f
Cred_1895 VSS vin1.$42.GatPoly 0.0510568f
Cred_1896 VSS vin1.$422.Metal1 0.0114323f
Cred_1897 VSS vin1.$423.Metal1 0.000822718f
Cred_1898 VSS vin1.$426.Metal1 0.00606853f
Cred_1899 VSS vin1.$427.Metal1 0.00013326f
Cred_1900 VSS vin1.$43.GatPoly 0.00532136f
Cred_1901 VSS vin1.$430.Metal1 0.0114373f
Cred_1902 VSS vin1.$433.Metal1 0.00118509f
Cred_1903 VSS vin1.$437.Metal1 0.0119673f
Cred_1904 VSS vin1.$44.GatPoly 0.0401879f
Cred_1905 VSS vin1.$440.Metal1 0.0112606f
Cred_1906 VSS vin1.$441.Metal1 0.000585335f
Cred_1907 VSS vin1.$448.Metal1 0.0124361f
Cred_1908 VSS vin1.$449.Metal1 0.000874135f
Cred_1909 VSS vin1.$453.Metal1 0.000874135f
Cred_1910 VSS vin1.$456.Metal1 0.0685685f
Cred_1911 VSS vin1.$457.Metal1 0.00813767f
Cred_1912 VSS vin1.$47.GatPoly 0.00394869f
Cred_1913 VSS vin1.$477.Metal2 0.151503f
Cred_1914 VSS vin1.$479.Metal2 0.150324f
Cred_1915 VSS vin1.$480.Metal2 0.0936472f
Cred_1916 VSS vin1.$483.Metal2 0.00860312f
Cred_1917 VSS vin1.$486.Metal2 0.018242f
Cred_1918 VSS vin1.$488.Metal2 0.00954933f
Cred_1919 VSS vin1.$492.Metal2 0.00627543f
Cred_1920 VSS vin1.$493.Metal2 9.70748e-06f
Cred_1921 VSS vin1.$495.Metal2 0.0171142f
Cred_1922 VSS vin1.$497.Metal2 0.0146444f
Cred_1923 VSS vin1.$503.Metal2 0.0124367f
Cred_1924 VSS vin1.$506.Metal2 0.018081f
Cred_1925 VSS vin1.$508.Metal2 0.00780893f
Cred_1926 VSS vin1.$512.Metal2 0.00795384f
Cred_1927 VSS vin1.$515.Metal2 0.0238751f
Cred_1928 VSS vin1.$517.Metal2 0.0122053f
Cred_1929 VSS vin1.$52.GatPoly 0.0447943f
Cred_1930 VSS vin1.$523.Metal2 0.0176085f
Cred_1931 VSS vin1.$527.Metal2 0.0027541f
Cred_1932 VSS vin1.$528.Metal2 0.00622792f
Cred_1933 VSS vin1.$53.GatPoly 0.00472455f
Cred_1934 VSS vin1.$532.Metal2 0.00969695f
Cred_1935 VSS vin1.$535.Metal2 0.0239715f
Cred_1936 VSS vin1.$537.Metal2 0.00844897f
Cred_1937 VSS vin1.$541.Metal2 0.0107013f
Cred_1938 VSS vin1.$544.Metal2 0.0196685f
Cred_1939 VSS vin1.$548.Metal2 0.0102159f
Cred_1940 VSS vin1.$551.Metal2 3.73876e-06f
Cred_1941 VSS vin1.$552.Metal2 0.0122351f
Cred_1942 VSS vin1.$555.Metal2 0.0175352f
Cred_1943 VSS vin1.$557.Metal2 0.00673351f
Cred_1944 VSS vin1.$561.Metal2 0.00906322f
Cred_1945 VSS vin1.$564.Metal2 0.0182677f
Cred_1946 VSS vin1.$566.Metal2 0.00907308f
Cred_1947 VSS vin1.$57.GatPoly 0.00460339f
Cred_1948 VSS vin1.$570.Metal2 0.00671838f
Cred_1949 VSS vin1.$573.Metal2 0.0175352f
Cred_1950 VSS vin1.$575.Metal2 0.0122351f
Cred_1951 VSS vin1.$578.Metal2 3.73876e-06f
Cred_1952 VSS vin1.$579.Metal2 0.0102159f
Cred_1953 VSS vin1.$58.GatPoly 0.0429479f
Cred_1954 VSS vin1.$584.Metal2 0.0196685f
Cred_1955 VSS vin1.$586.Metal2 0.0107013f
Cred_1956 VSS vin1.$590.Metal2 0.00844897f
Cred_1957 VSS vin1.$593.Metal2 0.0239715f
Cred_1958 VSS vin1.$595.Metal2 0.00969695f
Cred_1959 VSS vin1.$599.Metal2 0.00622792f
Cred_1960 VSS vin1.$6.GatPoly 0.056794f
Cred_1961 VSS vin1.$603.Metal2 0.0027541f
Cred_1962 VSS vin1.$604.Metal2 0.0176085f
Cred_1963 VSS vin1.$610.Metal2 0.0122053f
Cred_1964 VSS vin1.$613.Metal2 0.0238751f
Cred_1965 VSS vin1.$615.Metal2 0.00795384f
Cred_1966 VSS vin1.$619.Metal2 0.00780893f
Cred_1967 VSS vin1.$622.Metal2 0.018081f
Cred_1968 VSS vin1.$624.Metal2 0.0124367f
Cred_1969 VSS vin1.$630.Metal2 0.0146444f
Cred_1970 VSS vin1.$633.Metal2 0.0171142f
Cred_1971 VSS vin1.$635.Metal2 0.00627543f
Cred_1972 VSS vin1.$636.Metal2 9.70748e-06f
Cred_1973 VSS vin1.$639.Metal2 0.00954933f
Cred_1974 VSS vin1.$64.GatPoly 0.0501571f
Cred_1975 VSS vin1.$642.Metal2 0.0396561f
Cred_1976 VSS vin1.$644.Metal2 0.00860312f
Cred_1977 VSS vin1.$648.Metal2 0.0119929f
Cred_1978 VSS vin1.$649.Metal2 0.00213259f
Cred_1979 VSS vin1.$65.GatPoly 0.00554504f
Cred_1980 VSS vin1.$653.Metal2 0.0426341f
Cred_1981 VSS vin1.$654.Metal2 0.015216f
Cred_1982 VSS vin1.$70.GatPoly 0.0447656f
Cred_1983 VSS vin1.$73.GatPoly 0.00543054f
Cred_1984 VSS vin1.$77.GatPoly 0.00373578f
Cred_1985 VSS vin1.$78.GatPoly 0.0389814f
Cred_1986 VSS vin1.$80.GatPoly 0.0325349f
Cred_1987 VSS vin1.$83.GatPoly 0.00473739f
Cred_1988 VSS vin1.$84.GatPoly 0.0449968f
Cred_1989 VSS vin1.$87.GatPoly 0.0036961f
Cred_1990 VSS vin1.$9.GatPoly 0.00695851f
Cred_1991 VSS vin1.$90.GatPoly 0.0376923f
Cred_1992 VSS vin1.$93.GatPoly 0.00472681f
Cred_1993 VSS vin1.$94.GatPoly 0.0478429f
Cred_1994 VSS vin1.$97.GatPoly 0.0045033f
Cred_1995 VSS vin1.P0.GatPoly 0.104845f
Cred_1996 VSS vin1.P1.GatPoly 0.0708599f
Cred_1997 VSS vin1.P10.GatPoly 0.0765331f
Cred_1998 VSS vin1.P11.GatPoly 0.064479f
Cred_1999 VSS vin1.P12.GatPoly 0.0699124f
Cred_2000 VSS vin1.P13.GatPoly 0.0695719f
Cred_2001 VSS vin1.P14.GatPoly 0.0617096f
Cred_2002 VSS vin1.P15.GatPoly 0.0765727f
Cred_2003 VSS vin1.P16.GatPoly 0.0617096f
Cred_2004 VSS vin1.P17.GatPoly 0.0766326f
Cred_2005 VSS vin1.P18.GatPoly 0.0708599f
Cred_2006 VSS vin1.P19.GatPoly 0.104616f
Cred_2007 VSS vin1.P2.GatPoly 0.0766326f
Cred_2008 VSS vin1.P20.GatPoly 0.00216301f
Cred_2009 VSS vin1.P24.GatPoly 0.000495203f
Cred_2010 VSS vin1.P27.GatPoly 0.000489922f
Cred_2011 VSS vin1.P3.GatPoly 0.0617096f
Cred_2012 VSS vin1.P32.GatPoly 0.000489922f
Cred_2013 VSS vin1.P35.GatPoly 0.000495203f
Cred_2014 VSS vin1.P39.GatPoly 0.00208292f
Cred_2015 VSS vin1.P4.GatPoly 0.0765727f
Cred_2016 VSS vin1.P5.GatPoly 0.0617096f
Cred_2017 VSS vin1.P6.GatPoly 0.0695719f
Cred_2018 VSS vin1.P7.GatPoly 0.0699124f
Cred_2019 VSS vin1.P8.GatPoly 0.064479f
Cred_2020 VSS vin1.P9.GatPoly 0.0692081f
Cred_2021 VSS vin2 0.682852f
Cred_2022 VSS vin2.$101.GatPoly 0.0445181f
Cred_2023 VSS vin2.$104.GatPoly 0.00473739f
Cred_2024 VSS vin2.$106.GatPoly 0.00373578f
Cred_2025 VSS vin2.$109.GatPoly 0.0393729f
Cred_2026 VSS vin2.$11.GatPoly 0.0411664f
Cred_2027 VSS vin2.$111.GatPoly 0.0388649f
Cred_2028 VSS vin2.$114.GatPoly 0.00543054f
Cred_2029 VSS vin2.$119.GatPoly 0.0446257f
Cred_2030 VSS vin2.$122.GatPoly 0.00554504f
Cred_2031 VSS vin2.$123.GatPoly 0.049903f
Cred_2032 VSS vin2.$126.GatPoly 0.00460339f
Cred_2033 VSS vin2.$131.GatPoly 0.0428691f
Cred_2034 VSS vin2.$134.GatPoly 0.00472455f
Cred_2035 VSS vin2.$135.GatPoly 0.0444706f
Cred_2036 VSS vin2.$136.GatPoly 0.00394869f
Cred_2037 VSS vin2.$137.GatPoly 0.0401589f
Cred_2038 VSS vin2.$14.GatPoly 0.00402788f
Cred_2039 VSS vin2.$144.GatPoly 0.00532136f
Cred_2040 VSS vin2.$145.GatPoly 0.050718f
Cred_2041 VSS vin2.$152.GatPoly 0.00558667f
Cred_2042 VSS vin2.$153.GatPoly 0.0513052f
Cred_2043 VSS vin2.$156.GatPoly 0.00390465f
Cred_2044 VSS vin2.$157.GatPoly 0.0486437f
Cred_2045 VSS vin2.$16.GatPoly 0.00431606f
Cred_2046 VSS vin2.$162.GatPoly 0.00441521f
Cred_2047 VSS vin2.$165.GatPoly 0.0501773f
Cred_2048 VSS vin2.$166.GatPoly 0.00402788f
Cred_2049 VSS vin2.$17.GatPoly 0.043807f
Cred_2050 VSS vin2.$172.GatPoly 0.00431606f
Cred_2051 VSS vin2.$173.GatPoly 0.043807f
Cred_2052 VSS vin2.$177.GatPoly 0.0411664f
Cred_2053 VSS vin2.$178.GatPoly 0.00685663f
Cred_2054 VSS vin2.$181.GatPoly 0.0563254f
Cred_2055 VSS vin2.$202.Metal1 0.013734f
Cred_2056 VSS vin2.$203.Metal1 0.0762921f
Cred_2057 VSS vin2.$206.Metal1 0.000874135f
Cred_2058 VSS vin2.$210.Metal1 0.000874135f
Cred_2059 VSS vin2.$211.Metal1 0.0123626f
Cred_2060 VSS vin2.$218.Metal1 0.000585335f
Cred_2061 VSS vin2.$219.Metal1 0.0112606f
Cred_2062 VSS vin2.$223.Metal1 0.0119673f
Cred_2063 VSS vin2.$226.Metal1 0.00118509f
Cred_2064 VSS vin2.$229.Metal1 0.0114261f
Cred_2065 VSS vin2.$23.GatPoly 0.0501773f
Cred_2066 VSS vin2.$232.Metal1 0.00013326f
Cred_2067 VSS vin2.$233.Metal1 0.00606741f
Cred_2068 VSS vin2.$236.Metal1 0.000822718f
Cred_2069 VSS vin2.$237.Metal1 0.0114027f
Cred_2070 VSS vin2.$24.GatPoly 0.00390465f
Cred_2071 VSS vin2.$240.Metal1 0.000853803f
Cred_2072 VSS vin2.$241.Metal1 0.0140052f
Cred_2073 VSS vin2.$246.Metal1 0.00076447f
Cred_2074 VSS vin2.$247.Metal1 0.0112588f
Cred_2075 VSS vin2.$25.GatPoly 0.0486437f
Cred_2076 VSS vin2.$250.Metal1 0.000812493f
Cred_2077 VSS vin2.$251.Metal1 0.0119062f
Cred_2078 VSS vin2.$258.Metal1 0.00066546f
Cred_2079 VSS vin2.$259.Metal1 0.0118055f
Cred_2080 VSS vin2.$26.GatPoly 0.00441521f
Cred_2081 VSS vin2.$262.Metal1 0.000353246f
Cred_2082 VSS vin2.$263.Metal1 0.00734435f
Cred_2083 VSS vin2.$264.Metal1 0.000464257f
Cred_2084 VSS vin2.$265.Metal1 0.00969053f
Cred_2085 VSS vin2.$272.Metal1 0.000691143f
Cred_2086 VSS vin2.$273.Metal1 0.0130187f
Cred_2087 VSS vin2.$276.Metal1 0.00041137f
Cred_2088 VSS vin2.$280.Metal1 0.000731309f
Cred_2089 VSS vin2.$281.Metal1 0.0142214f
Cred_2090 VSS vin2.$284.Metal1 0.000817657f
Cred_2091 VSS vin2.$285.Metal1 0.0138862f
Cred_2092 VSS vin2.$290.Metal1 0.000778597f
Cred_2093 VSS vin2.$291.Metal1 0.012115f
Cred_2094 VSS vin2.$294.Metal1 0.000800193f
Cred_2095 VSS vin2.$299.Metal1 0.0149313f
Cred_2096 VSS vin2.$302.Metal1 0.000735506f
Cred_2097 VSS vin2.$303.Metal1 0.0150494f
Cred_2098 VSS vin2.$306.Metal1 0.000727765f
Cred_2099 VSS vin2.$311.Metal1 0.00836335f
Cred_2100 VSS vin2.$312.Metal1 0.000203932f
Cred_2101 VSS vin2.$316.Metal1 0.000754794f
Cred_2102 VSS vin2.$317.Metal1 0.0133984f
Cred_2103 VSS vin2.$320.Metal1 0.000572335f
Cred_2104 VSS vin2.$321.Metal1 0.0135148f
Cred_2105 VSS vin2.$324.Metal1 0.00039103f
Cred_2106 VSS vin2.$329.Metal1 0.0128646f
Cred_2107 VSS vin2.$330.Metal1 0.000772474f
Cred_2108 VSS vin2.$334.Metal1 0.000617047f
Cred_2109 VSS vin2.$335.Metal1 0.0124838f
Cred_2110 VSS vin2.$338.Metal1 0.000572335f
Cred_2111 VSS vin2.$342.Metal1 0.000754794f
Cred_2112 VSS vin2.$343.Metal1 0.0208834f
Cred_2113 VSS vin2.$346.Metal1 0.000203932f
Cred_2114 VSS vin2.$349.Metal1 0.013114f
Cred_2115 VSS vin2.$352.Metal1 0.000727765f
Cred_2116 VSS vin2.$356.Metal1 0.000735506f
Cred_2117 VSS vin2.$357.Metal1 0.0150494f
Cred_2118 VSS vin2.$36.GatPoly 0.00558667f
Cred_2119 VSS vin2.$361.Metal1 0.0149313f
Cred_2120 VSS vin2.$364.Metal1 0.000800193f
Cred_2121 VSS vin2.$368.Metal1 0.000778597f
Cred_2122 VSS vin2.$369.Metal1 0.012115f
Cred_2123 VSS vin2.$37.GatPoly 0.0513052f
Cred_2124 VSS vin2.$374.Metal1 0.000817657f
Cred_2125 VSS vin2.$375.Metal1 0.0138862f
Cred_2126 VSS vin2.$378.Metal1 0.000731309f
Cred_2127 VSS vin2.$379.Metal1 0.0142214f
Cred_2128 VSS vin2.$382.Metal1 0.00041137f
Cred_2129 VSS vin2.$386.Metal1 0.000691143f
Cred_2130 VSS vin2.$387.Metal1 0.0130187f
Cred_2131 VSS vin2.$392.Metal1 0.000464257f
Cred_2132 VSS vin2.$393.Metal1 0.00969053f
Cred_2133 VSS vin2.$396.Metal1 0.000353246f
Cred_2134 VSS vin2.$397.Metal1 0.00734435f
Cred_2135 VSS vin2.$400.Metal1 0.00066546f
Cred_2136 VSS vin2.$401.Metal1 0.0118055f
Cred_2137 VSS vin2.$408.Metal1 0.000812493f
Cred_2138 VSS vin2.$409.Metal1 0.0119062f
Cred_2139 VSS vin2.$412.Metal1 0.00076447f
Cred_2140 VSS vin2.$413.Metal1 0.0112588f
Cred_2141 VSS vin2.$418.Metal1 0.000853803f
Cred_2142 VSS vin2.$419.Metal1 0.0140052f
Cred_2143 VSS vin2.$42.GatPoly 0.00532136f
Cred_2144 VSS vin2.$422.Metal1 0.000822718f
Cred_2145 VSS vin2.$423.Metal1 0.0114027f
Cred_2146 VSS vin2.$426.Metal1 0.00013326f
Cred_2147 VSS vin2.$427.Metal1 0.00606741f
Cred_2148 VSS vin2.$43.GatPoly 0.050718f
Cred_2149 VSS vin2.$431.Metal1 0.0114261f
Cred_2150 VSS vin2.$432.Metal1 0.00118509f
Cred_2151 VSS vin2.$439.Metal1 0.0119673f
Cred_2152 VSS vin2.$44.GatPoly 0.00394869f
Cred_2153 VSS vin2.$440.Metal1 0.000585335f
Cred_2154 VSS vin2.$441.Metal1 0.0112606f
Cred_2155 VSS vin2.$448.Metal1 0.000874135f
Cred_2156 VSS vin2.$449.Metal1 0.0123626f
Cred_2157 VSS vin2.$452.Metal1 0.000874135f
Cred_2158 VSS vin2.$456.Metal1 0.00813767f
Cred_2159 VSS vin2.$457.Metal1 0.0684254f
Cred_2160 VSS vin2.$47.GatPoly 0.0401589f
Cred_2161 VSS vin2.$477.Metal2 0.151498f
Cred_2162 VSS vin2.$479.Metal2 0.0936472f
Cred_2163 VSS vin2.$480.Metal2 0.150313f
Cred_2164 VSS vin2.$484.Metal2 0.00860312f
Cred_2165 VSS vin2.$486.Metal2 0.018242f
Cred_2166 VSS vin2.$489.Metal2 0.00954933f
Cred_2167 VSS vin2.$492.Metal2 9.70748e-06f
Cred_2168 VSS vin2.$493.Metal2 0.00627543f
Cred_2169 VSS vin2.$495.Metal2 0.0171142f
Cred_2170 VSS vin2.$498.Metal2 0.0146444f
Cred_2171 VSS vin2.$504.Metal2 0.0124367f
Cred_2172 VSS vin2.$506.Metal2 0.018081f
Cred_2173 VSS vin2.$509.Metal2 0.00780893f
Cred_2174 VSS vin2.$513.Metal2 0.00795384f
Cred_2175 VSS vin2.$515.Metal2 0.0238751f
Cred_2176 VSS vin2.$518.Metal2 0.0122053f
Cred_2177 VSS vin2.$52.GatPoly 0.00472455f
Cred_2178 VSS vin2.$524.Metal2 0.0176085f
Cred_2179 VSS vin2.$525.Metal2 0.0027541f
Cred_2180 VSS vin2.$529.Metal2 0.00622792f
Cred_2181 VSS vin2.$53.GatPoly 0.0444706f
Cred_2182 VSS vin2.$533.Metal2 0.00969695f
Cred_2183 VSS vin2.$535.Metal2 0.0239715f
Cred_2184 VSS vin2.$538.Metal2 0.00844897f
Cred_2185 VSS vin2.$542.Metal2 0.0107013f
Cred_2186 VSS vin2.$544.Metal2 0.0196685f
Cred_2187 VSS vin2.$549.Metal2 0.0102159f
Cred_2188 VSS vin2.$550.Metal2 3.73876e-06f
Cred_2189 VSS vin2.$553.Metal2 0.0122479f
Cred_2190 VSS vin2.$555.Metal2 0.0175352f
Cred_2191 VSS vin2.$558.Metal2 0.00671574f
Cred_2192 VSS vin2.$56.GatPoly 0.00460339f
Cred_2193 VSS vin2.$562.Metal2 0.00906322f
Cred_2194 VSS vin2.$564.Metal2 0.0182677f
Cred_2195 VSS vin2.$567.Metal2 0.00907964f
Cred_2196 VSS vin2.$571.Metal2 0.00672798f
Cred_2197 VSS vin2.$573.Metal2 0.0175352f
Cred_2198 VSS vin2.$576.Metal2 0.0123104f
Cred_2199 VSS vin2.$577.Metal2 3.73876e-06f
Cred_2200 VSS vin2.$580.Metal2 0.0102159f
Cred_2201 VSS vin2.$584.Metal2 0.0196685f
Cred_2202 VSS vin2.$587.Metal2 0.0107013f
Cred_2203 VSS vin2.$59.GatPoly 0.0428691f
Cred_2204 VSS vin2.$591.Metal2 0.00844897f
Cred_2205 VSS vin2.$593.Metal2 0.0239715f
Cred_2206 VSS vin2.$596.Metal2 0.00969695f
Cred_2207 VSS vin2.$600.Metal2 0.00622792f
Cred_2208 VSS vin2.$601.Metal2 0.0027541f
Cred_2209 VSS vin2.$605.Metal2 0.0176085f
Cred_2210 VSS vin2.$611.Metal2 0.0122053f
Cred_2211 VSS vin2.$613.Metal2 0.0238751f
Cred_2212 VSS vin2.$616.Metal2 0.00795384f
Cred_2213 VSS vin2.$620.Metal2 0.00780893f
Cred_2214 VSS vin2.$622.Metal2 0.018081f
Cred_2215 VSS vin2.$625.Metal2 0.0124367f
Cred_2216 VSS vin2.$631.Metal2 0.0146444f
Cred_2217 VSS vin2.$633.Metal2 0.0171142f
Cred_2218 VSS vin2.$635.Metal2 9.70748e-06f
Cred_2219 VSS vin2.$636.Metal2 0.00627543f
Cred_2220 VSS vin2.$64.GatPoly 0.00554504f
Cred_2221 VSS vin2.$640.Metal2 0.00954933f
Cred_2222 VSS vin2.$642.Metal2 0.0395229f
Cred_2223 VSS vin2.$645.Metal2 0.00860312f
Cred_2224 VSS vin2.$648.Metal2 0.00234234f
Cred_2225 VSS vin2.$649.Metal2 0.0118078f
Cred_2226 VSS vin2.$65.GatPoly 0.049903f
Cred_2227 VSS vin2.$653.Metal2 0.016018f
Cred_2228 VSS vin2.$654.Metal2 0.0419248f
Cred_2229 VSS vin2.$7.GatPoly 0.0565979f
Cred_2230 VSS vin2.$71.GatPoly 0.0446257f
Cred_2231 VSS vin2.$72.GatPoly 0.00543054f
Cred_2232 VSS vin2.$76.GatPoly 0.00373578f
Cred_2233 VSS vin2.$79.GatPoly 0.0388649f
Cred_2234 VSS vin2.$8.GatPoly 0.00695851f
Cred_2235 VSS vin2.$81.GatPoly 0.0218849f
Cred_2236 VSS vin2.$82.GatPoly 0.00473739f
Cred_2237 VSS vin2.$83.GatPoly 0.0424063f
Cred_2238 VSS vin2.$86.GatPoly 0.0036961f
Cred_2239 VSS vin2.$91.GatPoly 0.0414881f
Cred_2240 VSS vin2.$92.GatPoly 0.00472681f
Cred_2241 VSS vin2.$95.GatPoly 0.0450123f
Cred_2242 VSS vin2.$96.GatPoly 0.0045033f
Cred_2243 VSS vin2.P0.GatPoly 0.103099f
Cred_2244 VSS vin2.P1.GatPoly 0.0690625f
Cred_2245 VSS vin2.P10.GatPoly 0.0670249f
Cred_2246 VSS vin2.P11.GatPoly 0.0626816f
Cred_2247 VSS vin2.P12.GatPoly 0.068115f
Cred_2248 VSS vin2.P13.GatPoly 0.0677579f
Cred_2249 VSS vin2.P14.GatPoly 0.0599122f
Cred_2250 VSS vin2.P15.GatPoly 0.0747753f
Cred_2251 VSS vin2.P16.GatPoly 0.0599122f
Cred_2252 VSS vin2.P17.GatPoly 0.0748352f
Cred_2253 VSS vin2.P18.GatPoly 0.0690625f
Cred_2254 VSS vin2.P19.GatPoly 0.10287f
Cred_2255 VSS vin2.P2.GatPoly 0.0748352f
Cred_2256 VSS vin2.P20.GatPoly 0.00216301f
Cred_2257 VSS vin2.P24.GatPoly 0.000495203f
Cred_2258 VSS vin2.P27.GatPoly 0.000489922f
Cred_2259 VSS vin2.P3.GatPoly 0.0599122f
Cred_2260 VSS vin2.P32.GatPoly 0.000489922f
Cred_2261 VSS vin2.P35.GatPoly 0.000495203f
Cred_2262 VSS vin2.P39.GatPoly 0.00208292f
Cred_2263 VSS vin2.P4.GatPoly 0.0747753f
Cred_2264 VSS vin2.P5.GatPoly 0.0599122f
Cred_2265 VSS vin2.P6.GatPoly 0.0677579f
Cred_2266 VSS vin2.P7.GatPoly 0.068115f
Cred_2267 VSS vin2.P8.GatPoly 0.0626816f
Cred_2268 VSS vin2.P9.GatPoly 0.0708283f
Cred_2269 VSS vin3 0.682852f
Cred_2270 VSS vin3.$10.GatPoly 0.0411664f
Cred_2271 VSS vin3.$100.GatPoly 0.0445181f
Cred_2272 VSS vin3.$105.GatPoly 0.00473739f
Cred_2273 VSS vin3.$107.GatPoly 0.00373578f
Cred_2274 VSS vin3.$108.GatPoly 0.0393729f
Cred_2275 VSS vin3.$110.GatPoly 0.0388649f
Cred_2276 VSS vin3.$115.GatPoly 0.00543054f
Cred_2277 VSS vin3.$118.GatPoly 0.0446257f
Cred_2278 VSS vin3.$122.GatPoly 0.049903f
Cred_2279 VSS vin3.$123.GatPoly 0.00554504f
Cred_2280 VSS vin3.$127.GatPoly 0.00460339f
Cred_2281 VSS vin3.$130.GatPoly 0.0428691f
Cred_2282 VSS vin3.$134.GatPoly 0.0444706f
Cred_2283 VSS vin3.$135.GatPoly 0.00472455f
Cred_2284 VSS vin3.$136.GatPoly 0.0401589f
Cred_2285 VSS vin3.$137.GatPoly 0.00394869f
Cred_2286 VSS vin3.$144.GatPoly 0.050718f
Cred_2287 VSS vin3.$145.GatPoly 0.00532136f
Cred_2288 VSS vin3.$15.GatPoly 0.00402788f
Cred_2289 VSS vin3.$152.GatPoly 0.0513052f
Cred_2290 VSS vin3.$153.GatPoly 0.00558667f
Cred_2291 VSS vin3.$156.GatPoly 0.0486437f
Cred_2292 VSS vin3.$157.GatPoly 0.00390465f
Cred_2293 VSS vin3.$16.GatPoly 0.043807f
Cred_2294 VSS vin3.$163.GatPoly 0.00441521f
Cred_2295 VSS vin3.$164.GatPoly 0.0501773f
Cred_2296 VSS vin3.$167.GatPoly 0.00402788f
Cred_2297 VSS vin3.$17.GatPoly 0.00431606f
Cred_2298 VSS vin3.$172.GatPoly 0.043807f
Cred_2299 VSS vin3.$173.GatPoly 0.00431606f
Cred_2300 VSS vin3.$176.GatPoly 0.0411664f
Cred_2301 VSS vin3.$179.GatPoly 0.00685663f
Cred_2302 VSS vin3.$180.GatPoly 0.0563254f
Cred_2303 VSS vin3.$202.Metal1 0.0762921f
Cred_2304 VSS vin3.$203.Metal1 0.013734f
Cred_2305 VSS vin3.$207.Metal1 0.000874135f
Cred_2306 VSS vin3.$210.Metal1 0.0123626f
Cred_2307 VSS vin3.$211.Metal1 0.000874135f
Cred_2308 VSS vin3.$218.Metal1 0.0112606f
Cred_2309 VSS vin3.$219.Metal1 0.000585335f
Cred_2310 VSS vin3.$22.GatPoly 0.0501773f
Cred_2311 VSS vin3.$222.Metal1 0.0119673f
Cred_2312 VSS vin3.$227.Metal1 0.00118509f
Cred_2313 VSS vin3.$228.Metal1 0.0114261f
Cred_2314 VSS vin3.$232.Metal1 0.00606741f
Cred_2315 VSS vin3.$233.Metal1 0.00013326f
Cred_2316 VSS vin3.$236.Metal1 0.0114027f
Cred_2317 VSS vin3.$237.Metal1 0.000822718f
Cred_2318 VSS vin3.$24.GatPoly 0.0486437f
Cred_2319 VSS vin3.$240.Metal1 0.0140052f
Cred_2320 VSS vin3.$241.Metal1 0.000853803f
Cred_2321 VSS vin3.$246.Metal1 0.0112588f
Cred_2322 VSS vin3.$247.Metal1 0.00076447f
Cred_2323 VSS vin3.$25.GatPoly 0.00390465f
Cred_2324 VSS vin3.$250.Metal1 0.0119062f
Cred_2325 VSS vin3.$251.Metal1 0.000812493f
Cred_2326 VSS vin3.$258.Metal1 0.0118055f
Cred_2327 VSS vin3.$259.Metal1 0.00066546f
Cred_2328 VSS vin3.$262.Metal1 0.00734435f
Cred_2329 VSS vin3.$263.Metal1 0.000353246f
Cred_2330 VSS vin3.$264.Metal1 0.00969053f
Cred_2331 VSS vin3.$265.Metal1 0.000464257f
Cred_2332 VSS vin3.$27.GatPoly 0.00441521f
Cred_2333 VSS vin3.$272.Metal1 0.0130187f
Cred_2334 VSS vin3.$273.Metal1 0.000691143f
Cred_2335 VSS vin3.$277.Metal1 0.00041137f
Cred_2336 VSS vin3.$280.Metal1 0.0142214f
Cred_2337 VSS vin3.$281.Metal1 0.000731309f
Cred_2338 VSS vin3.$284.Metal1 0.0138862f
Cred_2339 VSS vin3.$285.Metal1 0.000817657f
Cred_2340 VSS vin3.$290.Metal1 0.012115f
Cred_2341 VSS vin3.$291.Metal1 0.000778597f
Cred_2342 VSS vin3.$295.Metal1 0.000800193f
Cred_2343 VSS vin3.$298.Metal1 0.0149313f
Cred_2344 VSS vin3.$302.Metal1 0.0150494f
Cred_2345 VSS vin3.$303.Metal1 0.000735506f
Cred_2346 VSS vin3.$307.Metal1 0.000727765f
Cred_2347 VSS vin3.$310.Metal1 0.00836335f
Cred_2348 VSS vin3.$313.Metal1 0.000203932f
Cred_2349 VSS vin3.$316.Metal1 0.0133984f
Cred_2350 VSS vin3.$317.Metal1 0.000754794f
Cred_2351 VSS vin3.$320.Metal1 0.0135148f
Cred_2352 VSS vin3.$321.Metal1 0.000572335f
Cred_2353 VSS vin3.$325.Metal1 0.00039103f
Cred_2354 VSS vin3.$328.Metal1 0.0128646f
Cred_2355 VSS vin3.$331.Metal1 0.000772474f
Cred_2356 VSS vin3.$334.Metal1 0.0124838f
Cred_2357 VSS vin3.$335.Metal1 0.000617047f
Cred_2358 VSS vin3.$339.Metal1 0.000572335f
Cred_2359 VSS vin3.$342.Metal1 0.0208834f
Cred_2360 VSS vin3.$343.Metal1 0.000754794f
Cred_2361 VSS vin3.$347.Metal1 0.000203932f
Cred_2362 VSS vin3.$348.Metal1 0.013114f
Cred_2363 VSS vin3.$353.Metal1 0.000727765f
Cred_2364 VSS vin3.$356.Metal1 0.0150494f
Cred_2365 VSS vin3.$357.Metal1 0.000735506f
Cred_2366 VSS vin3.$36.GatPoly 0.0513052f
Cred_2367 VSS vin3.$360.Metal1 0.0149313f
Cred_2368 VSS vin3.$365.Metal1 0.000800193f
Cred_2369 VSS vin3.$368.Metal1 0.012115f
Cred_2370 VSS vin3.$369.Metal1 0.000778597f
Cred_2371 VSS vin3.$37.GatPoly 0.00558667f
Cred_2372 VSS vin3.$374.Metal1 0.0138862f
Cred_2373 VSS vin3.$375.Metal1 0.000817657f
Cred_2374 VSS vin3.$378.Metal1 0.0142214f
Cred_2375 VSS vin3.$379.Metal1 0.000731309f
Cred_2376 VSS vin3.$383.Metal1 0.00041137f
Cred_2377 VSS vin3.$386.Metal1 0.0130187f
Cred_2378 VSS vin3.$387.Metal1 0.000691143f
Cred_2379 VSS vin3.$392.Metal1 0.00969053f
Cred_2380 VSS vin3.$393.Metal1 0.000464257f
Cred_2381 VSS vin3.$396.Metal1 0.00734435f
Cred_2382 VSS vin3.$397.Metal1 0.000353246f
Cred_2383 VSS vin3.$400.Metal1 0.0118055f
Cred_2384 VSS vin3.$401.Metal1 0.00066546f
Cred_2385 VSS vin3.$408.Metal1 0.0119062f
Cred_2386 VSS vin3.$409.Metal1 0.000812493f
Cred_2387 VSS vin3.$412.Metal1 0.0112588f
Cred_2388 VSS vin3.$413.Metal1 0.00076447f
Cred_2389 VSS vin3.$418.Metal1 0.0140052f
Cred_2390 VSS vin3.$419.Metal1 0.000853803f
Cred_2391 VSS vin3.$42.GatPoly 0.050718f
Cred_2392 VSS vin3.$422.Metal1 0.0114027f
Cred_2393 VSS vin3.$423.Metal1 0.000822718f
Cred_2394 VSS vin3.$426.Metal1 0.00606741f
Cred_2395 VSS vin3.$427.Metal1 0.00013326f
Cred_2396 VSS vin3.$43.GatPoly 0.00532136f
Cred_2397 VSS vin3.$430.Metal1 0.0114261f
Cred_2398 VSS vin3.$433.Metal1 0.00118509f
Cred_2399 VSS vin3.$437.Metal1 0.0119673f
Cred_2400 VSS vin3.$44.GatPoly 0.0401589f
Cred_2401 VSS vin3.$440.Metal1 0.0112606f
Cred_2402 VSS vin3.$441.Metal1 0.000585335f
Cred_2403 VSS vin3.$448.Metal1 0.0123626f
Cred_2404 VSS vin3.$449.Metal1 0.000874135f
Cred_2405 VSS vin3.$453.Metal1 0.000874135f
Cred_2406 VSS vin3.$456.Metal1 0.0684254f
Cred_2407 VSS vin3.$457.Metal1 0.00813767f
Cred_2408 VSS vin3.$47.GatPoly 0.00394869f
Cred_2409 VSS vin3.$477.Metal2 0.151498f
Cred_2410 VSS vin3.$479.Metal2 0.150313f
Cred_2411 VSS vin3.$480.Metal2 0.0936472f
Cred_2412 VSS vin3.$483.Metal2 0.00860312f
Cred_2413 VSS vin3.$486.Metal2 0.018242f
Cred_2414 VSS vin3.$488.Metal2 0.00954933f
Cred_2415 VSS vin3.$492.Metal2 0.00627543f
Cred_2416 VSS vin3.$493.Metal2 9.70748e-06f
Cred_2417 VSS vin3.$495.Metal2 0.0171142f
Cred_2418 VSS vin3.$497.Metal2 0.0146444f
Cred_2419 VSS vin3.$503.Metal2 0.0124367f
Cred_2420 VSS vin3.$506.Metal2 0.018081f
Cred_2421 VSS vin3.$508.Metal2 0.00780893f
Cred_2422 VSS vin3.$512.Metal2 0.00795384f
Cred_2423 VSS vin3.$515.Metal2 0.0238751f
Cred_2424 VSS vin3.$517.Metal2 0.0122053f
Cred_2425 VSS vin3.$52.GatPoly 0.0444706f
Cred_2426 VSS vin3.$523.Metal2 0.0176085f
Cred_2427 VSS vin3.$527.Metal2 0.0027541f
Cred_2428 VSS vin3.$528.Metal2 0.00622792f
Cred_2429 VSS vin3.$53.GatPoly 0.00472455f
Cred_2430 VSS vin3.$532.Metal2 0.00969695f
Cred_2431 VSS vin3.$535.Metal2 0.0239715f
Cred_2432 VSS vin3.$537.Metal2 0.00844897f
Cred_2433 VSS vin3.$541.Metal2 0.0107013f
Cred_2434 VSS vin3.$544.Metal2 0.0196685f
Cred_2435 VSS vin3.$548.Metal2 0.0102159f
Cred_2436 VSS vin3.$551.Metal2 3.73876e-06f
Cred_2437 VSS vin3.$552.Metal2 0.0122479f
Cred_2438 VSS vin3.$555.Metal2 0.0175352f
Cred_2439 VSS vin3.$557.Metal2 0.00671574f
Cred_2440 VSS vin3.$561.Metal2 0.00906322f
Cred_2441 VSS vin3.$564.Metal2 0.0182677f
Cred_2442 VSS vin3.$566.Metal2 0.00907964f
Cred_2443 VSS vin3.$57.GatPoly 0.00460339f
Cred_2444 VSS vin3.$570.Metal2 0.00672798f
Cred_2445 VSS vin3.$573.Metal2 0.0175352f
Cred_2446 VSS vin3.$575.Metal2 0.0123104f
Cred_2447 VSS vin3.$578.Metal2 3.73876e-06f
Cred_2448 VSS vin3.$579.Metal2 0.0102159f
Cred_2449 VSS vin3.$58.GatPoly 0.0428691f
Cred_2450 VSS vin3.$584.Metal2 0.0196685f
Cred_2451 VSS vin3.$586.Metal2 0.0107013f
Cred_2452 VSS vin3.$590.Metal2 0.00844897f
Cred_2453 VSS vin3.$593.Metal2 0.0239715f
Cred_2454 VSS vin3.$595.Metal2 0.00969695f
Cred_2455 VSS vin3.$599.Metal2 0.00622792f
Cred_2456 VSS vin3.$6.GatPoly 0.0565979f
Cred_2457 VSS vin3.$603.Metal2 0.0027541f
Cred_2458 VSS vin3.$604.Metal2 0.0176085f
Cred_2459 VSS vin3.$610.Metal2 0.0122053f
Cred_2460 VSS vin3.$613.Metal2 0.0238751f
Cred_2461 VSS vin3.$615.Metal2 0.00795384f
Cred_2462 VSS vin3.$619.Metal2 0.00780893f
Cred_2463 VSS vin3.$622.Metal2 0.018081f
Cred_2464 VSS vin3.$624.Metal2 0.0124367f
Cred_2465 VSS vin3.$630.Metal2 0.0146444f
Cred_2466 VSS vin3.$633.Metal2 0.0171142f
Cred_2467 VSS vin3.$635.Metal2 0.00627543f
Cred_2468 VSS vin3.$636.Metal2 9.70748e-06f
Cred_2469 VSS vin3.$639.Metal2 0.00954933f
Cred_2470 VSS vin3.$64.GatPoly 0.049903f
Cred_2471 VSS vin3.$642.Metal2 0.0396561f
Cred_2472 VSS vin3.$644.Metal2 0.00860312f
Cred_2473 VSS vin3.$648.Metal2 0.0119899f
Cred_2474 VSS vin3.$649.Metal2 0.00213259f
Cred_2475 VSS vin3.$65.GatPoly 0.00554504f
Cred_2476 VSS vin3.$653.Metal2 0.0426212f
Cred_2477 VSS vin3.$654.Metal2 0.015216f
Cred_2478 VSS vin3.$70.GatPoly 0.0446257f
Cred_2479 VSS vin3.$73.GatPoly 0.00543054f
Cred_2480 VSS vin3.$77.GatPoly 0.00373578f
Cred_2481 VSS vin3.$78.GatPoly 0.0388649f
Cred_2482 VSS vin3.$80.GatPoly 0.0218849f
Cred_2483 VSS vin3.$82.GatPoly 0.0424063f
Cred_2484 VSS vin3.$83.GatPoly 0.00473739f
Cred_2485 VSS vin3.$87.GatPoly 0.0036961f
Cred_2486 VSS vin3.$9.GatPoly 0.00695851f
Cred_2487 VSS vin3.$90.GatPoly 0.0414881f
Cred_2488 VSS vin3.$93.GatPoly 0.00472681f
Cred_2489 VSS vin3.$94.GatPoly 0.0450123f
Cred_2490 VSS vin3.$97.GatPoly 0.0045033f
Cred_2491 VSS vin3.P0.GatPoly 0.103099f
Cred_2492 VSS vin3.P1.GatPoly 0.0690625f
Cred_2493 VSS vin3.P10.GatPoly 0.0670249f
Cred_2494 VSS vin3.P11.GatPoly 0.0626816f
Cred_2495 VSS vin3.P12.GatPoly 0.068115f
Cred_2496 VSS vin3.P13.GatPoly 0.0677579f
Cred_2497 VSS vin3.P14.GatPoly 0.0599122f
Cred_2498 VSS vin3.P15.GatPoly 0.0747753f
Cred_2499 VSS vin3.P16.GatPoly 0.0599122f
Cred_2500 VSS vin3.P17.GatPoly 0.0748352f
Cred_2501 VSS vin3.P18.GatPoly 0.0690625f
Cred_2502 VSS vin3.P19.GatPoly 0.10287f
Cred_2503 VSS vin3.P2.GatPoly 0.0748352f
Cred_2504 VSS vin3.P20.GatPoly 0.00216301f
Cred_2505 VSS vin3.P24.GatPoly 0.000495203f
Cred_2506 VSS vin3.P27.GatPoly 0.000489922f
Cred_2507 VSS vin3.P3.GatPoly 0.0599122f
Cred_2508 VSS vin3.P32.GatPoly 0.000489922f
Cred_2509 VSS vin3.P35.GatPoly 0.000495203f
Cred_2510 VSS vin3.P39.GatPoly 0.00208292f
Cred_2511 VSS vin3.P4.GatPoly 0.0747753f
Cred_2512 VSS vin3.P5.GatPoly 0.0599122f
Cred_2513 VSS vin3.P6.GatPoly 0.0677579f
Cred_2514 VSS vin3.P7.GatPoly 0.068115f
Cred_2515 VSS vin3.P8.GatPoly 0.0626816f
Cred_2516 VSS vin3.P9.GatPoly 0.0708283f
Cred_2517 VSS vin4 0.682852f
Cred_2518 VSS vin4.$103.GatPoly 0.0475528f
Cred_2519 VSS vin4.$104.GatPoly 0.00473739f
Cred_2520 VSS vin4.$106.GatPoly 0.00373578f
Cred_2521 VSS vin4.$109.GatPoly 0.0325349f
Cred_2522 VSS vin4.$11.GatPoly 0.0413156f
Cred_2523 VSS vin4.$111.GatPoly 0.0389814f
Cred_2524 VSS vin4.$114.GatPoly 0.00543054f
Cred_2525 VSS vin4.$119.GatPoly 0.0447656f
Cred_2526 VSS vin4.$122.GatPoly 0.00554504f
Cred_2527 VSS vin4.$123.GatPoly 0.0501571f
Cred_2528 VSS vin4.$126.GatPoly 0.00460339f
Cred_2529 VSS vin4.$131.GatPoly 0.0429479f
Cred_2530 VSS vin4.$134.GatPoly 0.00472455f
Cred_2531 VSS vin4.$135.GatPoly 0.0447943f
Cred_2532 VSS vin4.$136.GatPoly 0.00394869f
Cred_2533 VSS vin4.$137.GatPoly 0.0401879f
Cred_2534 VSS vin4.$14.GatPoly 0.00402788f
Cred_2535 VSS vin4.$144.GatPoly 0.00532136f
Cred_2536 VSS vin4.$145.GatPoly 0.0510568f
Cred_2537 VSS vin4.$152.GatPoly 0.00558667f
Cred_2538 VSS vin4.$153.GatPoly 0.0515261f
Cred_2539 VSS vin4.$156.GatPoly 0.00390465f
Cred_2540 VSS vin4.$157.GatPoly 0.048725f
Cred_2541 VSS vin4.$16.GatPoly 0.00431606f
Cred_2542 VSS vin4.$162.GatPoly 0.00441521f
Cred_2543 VSS vin4.$165.GatPoly 0.0505391f
Cred_2544 VSS vin4.$166.GatPoly 0.00402788f
Cred_2545 VSS vin4.$17.GatPoly 0.0439768f
Cred_2546 VSS vin4.$172.GatPoly 0.00431606f
Cred_2547 VSS vin4.$173.GatPoly 0.0439768f
Cred_2548 VSS vin4.$177.GatPoly 0.0413156f
Cred_2549 VSS vin4.$178.GatPoly 0.00685663f
Cred_2550 VSS vin4.$181.GatPoly 0.0565216f
Cred_2551 VSS vin4.$202.Metal1 0.013734f
Cred_2552 VSS vin4.$203.Metal1 0.0764354f
Cred_2553 VSS vin4.$206.Metal1 0.000874135f
Cred_2554 VSS vin4.$210.Metal1 0.000874135f
Cred_2555 VSS vin4.$211.Metal1 0.0124361f
Cred_2556 VSS vin4.$218.Metal1 0.000585335f
Cred_2557 VSS vin4.$219.Metal1 0.0112606f
Cred_2558 VSS vin4.$223.Metal1 0.0119673f
Cred_2559 VSS vin4.$226.Metal1 0.00118509f
Cred_2560 VSS vin4.$229.Metal1 0.0114373f
Cred_2561 VSS vin4.$23.GatPoly 0.0505391f
Cred_2562 VSS vin4.$232.Metal1 0.00013326f
Cred_2563 VSS vin4.$233.Metal1 0.00606853f
Cred_2564 VSS vin4.$236.Metal1 0.000822718f
Cred_2565 VSS vin4.$237.Metal1 0.0114323f
Cred_2566 VSS vin4.$24.GatPoly 0.00390465f
Cred_2567 VSS vin4.$240.Metal1 0.000853803f
Cred_2568 VSS vin4.$241.Metal1 0.0140838f
Cred_2569 VSS vin4.$246.Metal1 0.00076447f
Cred_2570 VSS vin4.$247.Metal1 0.0112588f
Cred_2571 VSS vin4.$25.GatPoly 0.048725f
Cred_2572 VSS vin4.$250.Metal1 0.000812493f
Cred_2573 VSS vin4.$251.Metal1 0.0119062f
Cred_2574 VSS vin4.$258.Metal1 0.00066546f
Cred_2575 VSS vin4.$259.Metal1 0.0118264f
Cred_2576 VSS vin4.$26.GatPoly 0.00441521f
Cred_2577 VSS vin4.$262.Metal1 0.000353246f
Cred_2578 VSS vin4.$263.Metal1 0.00734796f
Cred_2579 VSS vin4.$264.Metal1 0.000464257f
Cred_2580 VSS vin4.$265.Metal1 0.00969053f
Cred_2581 VSS vin4.$272.Metal1 0.000691143f
Cred_2582 VSS vin4.$273.Metal1 0.0130424f
Cred_2583 VSS vin4.$276.Metal1 0.00041137f
Cred_2584 VSS vin4.$280.Metal1 0.000731309f
Cred_2585 VSS vin4.$281.Metal1 0.0142455f
Cred_2586 VSS vin4.$284.Metal1 0.000817657f
Cred_2587 VSS vin4.$285.Metal1 0.0139497f
Cred_2588 VSS vin4.$290.Metal1 0.000778597f
Cred_2589 VSS vin4.$291.Metal1 0.012115f
Cred_2590 VSS vin4.$294.Metal1 0.000800193f
Cred_2591 VSS vin4.$299.Metal1 0.0150053f
Cred_2592 VSS vin4.$302.Metal1 0.000735506f
Cred_2593 VSS vin4.$303.Metal1 0.0151111f
Cred_2594 VSS vin4.$306.Metal1 0.000727765f
Cred_2595 VSS vin4.$311.Metal1 0.00666126f
Cred_2596 VSS vin4.$312.Metal1 0.000203932f
Cred_2597 VSS vin4.$313.Metal1 0.0106928f
Cred_2598 VSS vin4.$316.Metal1 0.000754794f
Cred_2599 VSS vin4.$320.Metal1 0.000572335f
Cred_2600 VSS vin4.$321.Metal1 0.0123601f
Cred_2601 VSS vin4.$324.Metal1 0.00039103f
Cred_2602 VSS vin4.$329.Metal1 0.0129056f
Cred_2603 VSS vin4.$330.Metal1 0.000772474f
Cred_2604 VSS vin4.$334.Metal1 0.000617047f
Cred_2605 VSS vin4.$335.Metal1 0.0116676f
Cred_2606 VSS vin4.$338.Metal1 0.000572335f
Cred_2607 VSS vin4.$339.Metal1 0.0114787f
Cred_2608 VSS vin4.$342.Metal1 0.000754794f
Cred_2609 VSS vin4.$346.Metal1 0.000203932f
Cred_2610 VSS vin4.$347.Metal1 0.0106928f
Cred_2611 VSS vin4.$349.Metal1 0.00666126f
Cred_2612 VSS vin4.$352.Metal1 0.000727765f
Cred_2613 VSS vin4.$356.Metal1 0.000735506f
Cred_2614 VSS vin4.$357.Metal1 0.0151111f
Cred_2615 VSS vin4.$36.GatPoly 0.00558667f
Cred_2616 VSS vin4.$361.Metal1 0.0150053f
Cred_2617 VSS vin4.$364.Metal1 0.000800193f
Cred_2618 VSS vin4.$368.Metal1 0.000778597f
Cred_2619 VSS vin4.$369.Metal1 0.012115f
Cred_2620 VSS vin4.$37.GatPoly 0.0515261f
Cred_2621 VSS vin4.$374.Metal1 0.000817657f
Cred_2622 VSS vin4.$375.Metal1 0.0139497f
Cred_2623 VSS vin4.$378.Metal1 0.000731309f
Cred_2624 VSS vin4.$379.Metal1 0.0142455f
Cred_2625 VSS vin4.$382.Metal1 0.00041137f
Cred_2626 VSS vin4.$386.Metal1 0.000691143f
Cred_2627 VSS vin4.$387.Metal1 0.0130424f
Cred_2628 VSS vin4.$392.Metal1 0.000464257f
Cred_2629 VSS vin4.$393.Metal1 0.00969053f
Cred_2630 VSS vin4.$396.Metal1 0.000353246f
Cred_2631 VSS vin4.$397.Metal1 0.00734796f
Cred_2632 VSS vin4.$400.Metal1 0.00066546f
Cred_2633 VSS vin4.$401.Metal1 0.0118264f
Cred_2634 VSS vin4.$408.Metal1 0.000812493f
Cred_2635 VSS vin4.$409.Metal1 0.0119062f
Cred_2636 VSS vin4.$412.Metal1 0.00076447f
Cred_2637 VSS vin4.$413.Metal1 0.0112588f
Cred_2638 VSS vin4.$418.Metal1 0.000853803f
Cred_2639 VSS vin4.$419.Metal1 0.0140838f
Cred_2640 VSS vin4.$42.GatPoly 0.00532136f
Cred_2641 VSS vin4.$422.Metal1 0.000822718f
Cred_2642 VSS vin4.$423.Metal1 0.0114323f
Cred_2643 VSS vin4.$426.Metal1 0.00013326f
Cred_2644 VSS vin4.$427.Metal1 0.00606853f
Cred_2645 VSS vin4.$43.GatPoly 0.0510568f
Cred_2646 VSS vin4.$431.Metal1 0.0114373f
Cred_2647 VSS vin4.$432.Metal1 0.00118509f
Cred_2648 VSS vin4.$439.Metal1 0.0119673f
Cred_2649 VSS vin4.$44.GatPoly 0.00394869f
Cred_2650 VSS vin4.$440.Metal1 0.000585335f
Cred_2651 VSS vin4.$441.Metal1 0.0112606f
Cred_2652 VSS vin4.$448.Metal1 0.000874135f
Cred_2653 VSS vin4.$449.Metal1 0.0124361f
Cred_2654 VSS vin4.$452.Metal1 0.000874135f
Cred_2655 VSS vin4.$456.Metal1 0.00813767f
Cred_2656 VSS vin4.$457.Metal1 0.0685685f
Cred_2657 VSS vin4.$47.GatPoly 0.0401879f
Cred_2658 VSS vin4.$477.Metal2 0.151503f
Cred_2659 VSS vin4.$479.Metal2 0.0936472f
Cred_2660 VSS vin4.$480.Metal2 0.150324f
Cred_2661 VSS vin4.$484.Metal2 0.00860312f
Cred_2662 VSS vin4.$486.Metal2 0.018242f
Cred_2663 VSS vin4.$489.Metal2 0.00954933f
Cred_2664 VSS vin4.$492.Metal2 9.70748e-06f
Cred_2665 VSS vin4.$493.Metal2 0.00627543f
Cred_2666 VSS vin4.$495.Metal2 0.0171142f
Cred_2667 VSS vin4.$498.Metal2 0.0146444f
Cred_2668 VSS vin4.$504.Metal2 0.0124367f
Cred_2669 VSS vin4.$506.Metal2 0.018081f
Cred_2670 VSS vin4.$509.Metal2 0.00780893f
Cred_2671 VSS vin4.$513.Metal2 0.00795384f
Cred_2672 VSS vin4.$515.Metal2 0.0238751f
Cred_2673 VSS vin4.$518.Metal2 0.0122053f
Cred_2674 VSS vin4.$52.GatPoly 0.00472455f
Cred_2675 VSS vin4.$524.Metal2 0.0176085f
Cred_2676 VSS vin4.$525.Metal2 0.0027541f
Cred_2677 VSS vin4.$529.Metal2 0.00622792f
Cred_2678 VSS vin4.$53.GatPoly 0.0447943f
Cred_2679 VSS vin4.$533.Metal2 0.00969695f
Cred_2680 VSS vin4.$535.Metal2 0.0239715f
Cred_2681 VSS vin4.$538.Metal2 0.00844897f
Cred_2682 VSS vin4.$542.Metal2 0.0107013f
Cred_2683 VSS vin4.$544.Metal2 0.0196685f
Cred_2684 VSS vin4.$549.Metal2 0.0102159f
Cred_2685 VSS vin4.$550.Metal2 3.73876e-06f
Cred_2686 VSS vin4.$553.Metal2 0.0122351f
Cred_2687 VSS vin4.$555.Metal2 0.0175352f
Cred_2688 VSS vin4.$558.Metal2 0.00673351f
Cred_2689 VSS vin4.$56.GatPoly 0.00460339f
Cred_2690 VSS vin4.$562.Metal2 0.00906322f
Cred_2691 VSS vin4.$564.Metal2 0.0182677f
Cred_2692 VSS vin4.$567.Metal2 0.00907308f
Cred_2693 VSS vin4.$571.Metal2 0.00671838f
Cred_2694 VSS vin4.$573.Metal2 0.0175352f
Cred_2695 VSS vin4.$576.Metal2 0.0122351f
Cred_2696 VSS vin4.$577.Metal2 3.73876e-06f
Cred_2697 VSS vin4.$580.Metal2 0.0102159f
Cred_2698 VSS vin4.$584.Metal2 0.0196685f
Cred_2699 VSS vin4.$587.Metal2 0.0107013f
Cred_2700 VSS vin4.$59.GatPoly 0.0429479f
Cred_2701 VSS vin4.$591.Metal2 0.00844897f
Cred_2702 VSS vin4.$593.Metal2 0.0239715f
Cred_2703 VSS vin4.$596.Metal2 0.00969695f
Cred_2704 VSS vin4.$600.Metal2 0.00622792f
Cred_2705 VSS vin4.$601.Metal2 0.0027541f
Cred_2706 VSS vin4.$605.Metal2 0.0176085f
Cred_2707 VSS vin4.$611.Metal2 0.0122053f
Cred_2708 VSS vin4.$613.Metal2 0.0238751f
Cred_2709 VSS vin4.$616.Metal2 0.00795384f
Cred_2710 VSS vin4.$620.Metal2 0.00780893f
Cred_2711 VSS vin4.$622.Metal2 0.018081f
Cred_2712 VSS vin4.$625.Metal2 0.0124367f
Cred_2713 VSS vin4.$631.Metal2 0.0146444f
Cred_2714 VSS vin4.$633.Metal2 0.0171142f
Cred_2715 VSS vin4.$635.Metal2 9.70748e-06f
Cred_2716 VSS vin4.$636.Metal2 0.00627543f
Cred_2717 VSS vin4.$64.GatPoly 0.00554504f
Cred_2718 VSS vin4.$640.Metal2 0.00954933f
Cred_2719 VSS vin4.$642.Metal2 0.0395229f
Cred_2720 VSS vin4.$645.Metal2 0.00860312f
Cred_2721 VSS vin4.$648.Metal2 0.00234234f
Cred_2722 VSS vin4.$649.Metal2 0.0118108f
Cred_2723 VSS vin4.$65.GatPoly 0.0501571f
Cred_2724 VSS vin4.$653.Metal2 0.016018f
Cred_2725 VSS vin4.$654.Metal2 0.0419376f
Cred_2726 VSS vin4.$7.GatPoly 0.056794f
Cred_2727 VSS vin4.$71.GatPoly 0.0447656f
Cred_2728 VSS vin4.$72.GatPoly 0.00543054f
Cred_2729 VSS vin4.$76.GatPoly 0.00373578f
Cred_2730 VSS vin4.$79.GatPoly 0.0389814f
Cred_2731 VSS vin4.$8.GatPoly 0.00695851f
Cred_2732 VSS vin4.$81.GatPoly 0.0325349f
Cred_2733 VSS vin4.$82.GatPoly 0.00473739f
Cred_2734 VSS vin4.$85.GatPoly 0.0449968f
Cred_2735 VSS vin4.$86.GatPoly 0.0036961f
Cred_2736 VSS vin4.$91.GatPoly 0.0376923f
Cred_2737 VSS vin4.$92.GatPoly 0.00472681f
Cred_2738 VSS vin4.$95.GatPoly 0.0478429f
Cred_2739 VSS vin4.$96.GatPoly 0.0045033f
Cred_2740 VSS vin4.P0.GatPoly 0.104845f
Cred_2741 VSS vin4.P1.GatPoly 0.0708599f
Cred_2742 VSS vin4.P10.GatPoly 0.0765331f
Cred_2743 VSS vin4.P11.GatPoly 0.064479f
Cred_2744 VSS vin4.P12.GatPoly 0.0699124f
Cred_2745 VSS vin4.P13.GatPoly 0.0695719f
Cred_2746 VSS vin4.P14.GatPoly 0.0617096f
Cred_2747 VSS vin4.P15.GatPoly 0.0765727f
Cred_2748 VSS vin4.P16.GatPoly 0.0617096f
Cred_2749 VSS vin4.P17.GatPoly 0.0766326f
Cred_2750 VSS vin4.P18.GatPoly 0.0708599f
Cred_2751 VSS vin4.P19.GatPoly 0.104616f
Cred_2752 VSS vin4.P2.GatPoly 0.0766326f
Cred_2753 VSS vin4.P20.GatPoly 0.00216301f
Cred_2754 VSS vin4.P24.GatPoly 0.000495203f
Cred_2755 VSS vin4.P27.GatPoly 0.000489922f
Cred_2756 VSS vin4.P3.GatPoly 0.0617096f
Cred_2757 VSS vin4.P32.GatPoly 0.000489922f
Cred_2758 VSS vin4.P35.GatPoly 0.000495203f
Cred_2759 VSS vin4.P39.GatPoly 0.00208292f
Cred_2760 VSS vin4.P4.GatPoly 0.0765727f
Cred_2761 VSS vin4.P5.GatPoly 0.0617096f
Cred_2762 VSS vin4.P6.GatPoly 0.0695719f
Cred_2763 VSS vin4.P7.GatPoly 0.0699124f
Cred_2764 VSS vin4.P8.GatPoly 0.064479f
Cred_2765 VSS vin4.P9.GatPoly 0.0692081f
Cred_2766 VSS vout1 0.61021f
Cred_2767 VSS vout1.$1226.Metal3 0.113896f
Cred_2768 VSS vout1.$1292.Metal3 0.0591296f
Cred_2769 VSS vout1.$1358.Metal3 0.0591349f
Cred_2770 VSS vout1.$1424.Metal3 0.261393f
Cred_2771 VSS vout1.P0.nSD 0.00626328f
Cred_2772 VSS vout1.P0.pSD 0.00966477f
Cred_2773 VSS vout1.P10.nSD 0.00438845f
Cred_2774 VSS vout1.P10.pSD 0.00123033f
Cred_2775 VSS vout1.P12.nSD 0.00416129f
Cred_2776 VSS vout1.P14.nSD 0.00438845f
Cred_2777 VSS vout1.P14.pSD 0.00123033f
Cred_2778 VSS vout1.P16.nSD 0.00416129f
Cred_2779 VSS vout1.P18.nSD 0.00848104f
Cred_2780 VSS vout1.P18.pSD 0.0245654f
Cred_2781 VSS vout1.P2.nSD 0.00525125f
Cred_2782 VSS vout1.P2.pSD 0.00595686f
Cred_2783 VSS vout1.P4.nSD 0.00416129f
Cred_2784 VSS vout1.P6.nSD 0.00438837f
Cred_2785 VSS vout1.P6.pSD 0.00124104f
Cred_2786 VSS vout1.P8.nSD 0.00416129f
Cred_2787 VSS vout2 0.610032f
Cred_2788 VSS vout2.$1226.Metal3 0.113896f
Cred_2789 VSS vout2.$1292.Metal3 0.0591296f
Cred_2790 VSS vout2.$1358.Metal3 0.0591349f
Cred_2791 VSS vout2.$1424.Metal3 0.261393f
Cred_2792 VSS vout2.P0.nSD 0.00626328f
Cred_2793 VSS vout2.P0.pSD 0.00966477f
Cred_2794 VSS vout2.P10.nSD 0.00438845f
Cred_2795 VSS vout2.P10.pSD 0.00123033f
Cred_2796 VSS vout2.P12.nSD 0.00416129f
Cred_2797 VSS vout2.P14.nSD 0.00438845f
Cred_2798 VSS vout2.P14.pSD 0.00123033f
Cred_2799 VSS vout2.P16.nSD 0.00416129f
Cred_2800 VSS vout2.P18.nSD 0.00848104f
Cred_2801 VSS vout2.P18.pSD 0.0245654f
Cred_2802 VSS vout2.P2.nSD 0.00525125f
Cred_2803 VSS vout2.P2.pSD 0.00595686f
Cred_2804 VSS vout2.P4.nSD 0.00416129f
Cred_2805 VSS vout2.P6.nSD 0.00438837f
Cred_2806 VSS vout2.P6.pSD 0.00124104f
Cred_2807 VSS vout2.P8.nSD 0.00416129f
Cred_2808 VSS vout3 0.610032f
Cred_2809 VSS vout3.$1226.Metal3 0.113896f
Cred_2810 VSS vout3.$1292.Metal3 0.0591296f
Cred_2811 VSS vout3.$1358.Metal3 0.0591349f
Cred_2812 VSS vout3.$1424.Metal3 0.261393f
Cred_2813 VSS vout3.P0.nSD 0.00626328f
Cred_2814 VSS vout3.P0.pSD 0.00966477f
Cred_2815 VSS vout3.P10.nSD 0.00438845f
Cred_2816 VSS vout3.P10.pSD 0.00123033f
Cred_2817 VSS vout3.P12.nSD 0.00416129f
Cred_2818 VSS vout3.P14.nSD 0.00438845f
Cred_2819 VSS vout3.P14.pSD 0.00123033f
Cred_2820 VSS vout3.P16.nSD 0.00416129f
Cred_2821 VSS vout3.P18.nSD 0.00848104f
Cred_2822 VSS vout3.P18.pSD 0.0245654f
Cred_2823 VSS vout3.P2.nSD 0.00525125f
Cred_2824 VSS vout3.P2.pSD 0.00595686f
Cred_2825 VSS vout3.P4.nSD 0.00416129f
Cred_2826 VSS vout3.P6.nSD 0.00438837f
Cred_2827 VSS vout3.P6.pSD 0.00124104f
Cred_2828 VSS vout3.P8.nSD 0.00416129f
Cred_2829 VSS vout4 0.61021f
Cred_2830 VSS vout4.$1226.Metal3 0.113896f
Cred_2831 VSS vout4.$1292.Metal3 0.0591296f
Cred_2832 VSS vout4.$1358.Metal3 0.0591349f
Cred_2833 VSS vout4.$1424.Metal3 0.261393f
Cred_2834 VSS vout4.P0.nSD 0.00626328f
Cred_2835 VSS vout4.P0.pSD 0.00966477f
Cred_2836 VSS vout4.P10.nSD 0.00438845f
Cred_2837 VSS vout4.P10.pSD 0.00123033f
Cred_2838 VSS vout4.P12.nSD 0.00416129f
Cred_2839 VSS vout4.P14.nSD 0.00438845f
Cred_2840 VSS vout4.P14.pSD 0.00123033f
Cred_2841 VSS vout4.P16.nSD 0.00416129f
Cred_2842 VSS vout4.P18.nSD 0.00848104f
Cred_2843 VSS vout4.P18.pSD 0.0245654f
Cred_2844 VSS vout4.P2.nSD 0.00525125f
Cred_2845 VSS vout4.P2.pSD 0.00595686f
Cred_2846 VSS vout4.P4.nSD 0.00416129f
Cred_2847 VSS vout4.P6.nSD 0.00438837f
Cred_2848 VSS vout4.P6.pSD 0.00124104f
Cred_2849 VSS vout4.P8.nSD 0.00416129f
Cred_2851 VSS VSS.$1024.Metal1 0.0659118f
Cred_2852 VSS VSS.$1029.Metal1 0.0866314f
Cred_2853 VSS VSS.$1038.Metal1 0.0866314f
Cred_2854 VSS VSS.$1044.Metal1 0.0443487f
Cred_2855 VSS VSS.$1064.Metal1 0.0431877f
Cred_2856 VSS VSS.$1069.Metal1 0.0832277f
Cred_2857 VSS VSS.$1078.Metal1 0.0832277f
Cred_2858 VSS VSS.$1084.Metal1 0.0729106f
Cred_2859 VSS VSS.$109.Metal1 0.141147f
Cred_2860 VSS VSS.$112.Metal1 0.141147f
Cred_2861 VSS VSS.$1160.Metal1 0.0729106f
Cred_2862 VSS VSS.$1165.Metal1 0.0832277f
Cred_2863 VSS VSS.$1174.Metal1 0.0832277f
Cred_2864 VSS VSS.$1180.Metal1 0.0431877f
Cred_2865 VSS VSS.$1200.Metal1 0.0443487f
Cred_2866 VSS VSS.$1205.Metal1 0.0866314f
Cred_2867 VSS VSS.$1214.Metal1 0.0866314f
Cred_2868 VSS VSS.$1220.Metal1 0.0659118f
Cred_2869 VSS VSS.$1245.Metal1 0.0784728f
Cred_2870 VSS VSS.$1254.Metal1 0.0784728f
Cred_2871 VSS VSS.$1260.Metal1 0.0991773f
Cred_2872 VSS VSS.$1265.Metal1 0.125247f
Cred_2873 VSS VSS.$1266.Metal1 0.0683106f
Cred_2874 VSS VSS.$1267.Metal1 0.125247f
Cred_2875 VSS VSS.$1279.Metal1 0.0337656f
Cred_2876 VSS VSS.$1311.Metal1 0.0353359f
Cred_2877 VSS VSS.$1339.Metal1 0.0691592f
Cred_2878 VSS VSS.$1359.Metal1 0.0431841f
Cred_2879 VSS VSS.$1364.Metal1 0.106943f
Cred_2880 VSS VSS.$1373.Metal1 0.106943f
Cred_2881 VSS VSS.$1379.Metal1 0.0711808f
Cred_2882 VSS VSS.$1407.Metal1 0.0684808f
Cred_2883 VSS VSS.$1412.Metal1 0.0879849f
Cred_2884 VSS VSS.$1421.Metal1 0.0879849f
Cred_2885 VSS VSS.$1427.Metal1 0.0646854f
Cred_2886 VSS VSS.$1445.Metal1 0.119223f
Cred_2887 VSS VSS.$1463.Metal1 0.0881226f
Cred_2888 VSS VSS.$1466.Metal1 0.0217448f
Cred_2889 VSS VSS.$1483.Metal1 0.0217448f
Cred_2890 VSS VSS.$1484.Metal1 0.0881226f
Cred_2891 VSS VSS.$1490.Metal1 0.0224675f
Cred_2892 VSS VSS.$1503.Metal1 0.0925606f
Cred_2893 VSS VSS.$1512.Metal1 0.0925606f
Cred_2894 VSS VSS.$1518.Metal1 0.096918f
Cred_2895 VSS VSS.$1546.Metal1 0.0680162f
Cred_2896 VSS VSS.$1566.Metal1 0.0445649f
Cred_2897 VSS VSS.$157.Metal1 0.173199f
Cred_2898 VSS VSS.$1571.Metal1 0.125747f
Cred_2899 VSS VSS.$158.Metal1 0.167772f
Cred_2900 VSS VSS.$1580.Metal1 0.125747f
Cred_2901 VSS VSS.$1586.Metal1 0.0432038f
Cred_2902 VSS VSS.$159.Metal1 0.167772f
Cred_2903 VSS VSS.$160.Metal1 0.173199f
Cred_2904 VSS VSS.$1606.Metal1 0.0429638f
Cred_2905 VSS VSS.$1623.Metal1 0.126279f
Cred_2906 VSS VSS.$1624.Metal1 0.0875201f
Cred_2907 VSS VSS.$1625.Metal1 0.126279f
Cred_2908 VSS VSS.$1629.Metal1 0.0741373f
Cred_2909 VSS VSS.$1685.Metal1 0.0798578f
Cred_2910 VSS VSS.$1690.Metal1 0.079849f
Cred_2911 VSS VSS.$1699.Metal1 0.079849f
Cred_2912 VSS VSS.$1705.Metal1 0.0431754f
Cred_2913 VSS VSS.$1725.Metal1 0.0436885f
Cred_2914 VSS VSS.$173.Metal1 0.0574897f
Cred_2915 VSS VSS.$1730.Metal1 0.0869072f
Cred_2916 VSS VSS.$1739.Metal1 0.0869072f
Cred_2917 VSS VSS.$1745.Metal1 0.0689074f
Cred_2918 VSS VSS.$1773.Metal1 0.0702719f
Cred_2919 VSS VSS.$1778.Metal1 0.0804609f
Cred_2920 VSS VSS.$1787.Metal1 0.0804609f
Cred_2921 VSS VSS.$1793.Metal1 0.067288f
Cred_2922 VSS VSS.$1798.Metal1 0.103338f
Cred_2923 VSS VSS.$1799.Metal1 0.0928954f
Cred_2924 VSS VSS.$1800.Metal1 0.103338f
Cred_2925 VSS VSS.$182.Metal1 0.0574897f
Cred_2926 VSS VSS.$1864.Metal1 0.0751081f
Cred_2927 VSS VSS.$1869.Metal1 0.0845356f
Cred_2928 VSS VSS.$1878.Metal1 0.0845356f
Cred_2929 VSS VSS.$1884.Metal1 0.0680467f
Cred_2930 VSS VSS.$1912.Metal1 0.07162f
Cred_2931 VSS VSS.$1917.Metal1 0.108621f
Cred_2932 VSS VSS.$1926.Metal1 0.108621f
Cred_2933 VSS VSS.$1932.Metal1 0.0431844f
Cred_2934 VSS VSS.$1952.Metal1 0.0577845f
Cred_2935 VSS VSS.$1977.Metal1 0.113806f
Cred_2936 VSS VSS.$1981.Metal1 0.141147f
Cred_2937 VSS VSS.$1984.Metal1 0.141147f
Cred_2938 VSS VSS.$1986.Metal1 0.113806f
Cred_2939 VSS VSS.$1989.Metal1 0.23127f
Cred_2940 VSS VSS.$1990.Metal1 0.362876f
Cred_2941 VSS VSS.$1991.Metal1 0.23127f
Cred_2942 VSS VSS.$2020.Metal1 0.275818f
Cred_2943 VSS VSS.$2021.Metal1 0.168148f
Cred_2944 VSS VSS.$2022.Metal1 0.168148f
Cred_2945 VSS VSS.$2023.Metal1 0.275818f
Cred_2946 VSS VSS.$2064.Metal1 0.057428f
Cred_2947 VSS VSS.$2073.Metal1 0.057428f
Cred_2948 VSS VSS.$2226.Metal2 0.134888f
Cred_2949 VSS VSS.$2228.Metal2 0.121177f
Cred_2950 VSS VSS.$2230.Metal2 0.0142681f
Cred_2951 VSS VSS.$2232.Metal2 0.019382f
Cred_2952 VSS VSS.$2234.Metal2 0.019382f
Cred_2953 VSS VSS.$2236.Metal2 0.0142681f
Cred_2954 VSS VSS.$2238.Metal2 0.121177f
Cred_2955 VSS VSS.$2240.Metal2 0.134888f
Cred_2956 VSS VSS.$2286.Metal2 0.0791469f
Cred_2957 VSS VSS.$2306.Metal2 0.0791469f
Cred_2958 VSS VSS.$2342.Metal2 0.0301974f
Cred_2959 VSS VSS.$2360.Metal2 0.0301974f
Cred_2960 VSS VSS.$2403.Metal2 0.0267595f
Cred_2961 VSS VSS.$2409.Metal2 0.00700719f
Cred_2962 VSS VSS.$2421.Metal2 0.0267595f
Cred_2963 VSS VSS.$2427.Metal2 0.0262571f
Cred_2964 VSS VSS.$2433.Metal2 0.00898757f
Cred_2965 VSS VSS.$2445.Metal2 0.0262571f
Cred_2966 VSS VSS.$2475.Metal2 0.034597f
Cred_2967 VSS VSS.$2481.Metal2 0.012102f
Cred_2968 VSS VSS.$2493.Metal2 0.034597f
Cred_2969 VSS VSS.$25.Metal1 0.190381f
Cred_2970 VSS VSS.$2526.Metal2 0.0357303f
Cred_2971 VSS VSS.$2532.Metal2 0.0301243f
Cred_2972 VSS VSS.$2544.Metal2 0.0357303f
Cred_2973 VSS VSS.$2558.Metal2 0.0393356f
Cred_2974 VSS VSS.$2564.Metal2 0.0334807f
Cred_2975 VSS VSS.$257.Metal1 0.113805f
Cred_2976 VSS VSS.$2576.Metal2 0.0393356f
Cred_2977 VSS VSS.$2614.Metal2 0.0347482f
Cred_2978 VSS VSS.$2620.Metal2 0.0120029f
Cred_2979 VSS VSS.$2632.Metal2 0.0347482f
Cred_2980 VSS VSS.$266.Metal1 0.113805f
Cred_2981 VSS VSS.$2662.Metal2 0.034614f
Cred_2982 VSS VSS.$2668.Metal2 0.0165588f
Cred_2983 VSS VSS.$2680.Metal2 0.034614f
Cred_2984 VSS VSS.$27.Metal1 0.190381f
Cred_2985 VSS VSS.$2711.Metal2 0.0414835f
Cred_2986 VSS VSS.$2721.Metal2 0.0418595f
Cred_2987 VSS VSS.$2727.Metal2 0.00756704f
Cred_2988 VSS VSS.$2739.Metal2 0.0418595f
Cred_2989 VSS VSS.$2753.Metal2 0.024093f
Cred_2990 VSS VSS.$2771.Metal2 0.024093f
Cred_2991 VSS VSS.$2777.Metal2 0.0261273f
Cred_2992 VSS VSS.$2783.Metal2 0.0135437f
Cred_2993 VSS VSS.$2795.Metal2 0.0261273f
Cred_2994 VSS VSS.$2825.Metal2 0.026523f
Cred_2995 VSS VSS.$2831.Metal2 0.00951653f
Cred_2996 VSS VSS.$2843.Metal2 0.026523f
Cred_2997 VSS VSS.$2849.Metal2 0.0255794f
Cred_2998 VSS VSS.$2855.Metal2 0.0126771f
Cred_2999 VSS VSS.$2867.Metal2 0.0255794f
Cred_3000 VSS VSS.$29.Metal1 0.155125f
Cred_3001 VSS VSS.$2908.Metal2 0.047425f
Cred_3002 VSS VSS.$2914.Metal2 0.0398509f
Cred_3003 VSS VSS.$292.Metal1 0.0577845f
Cred_3004 VSS VSS.$2926.Metal2 0.047425f
Cred_3005 VSS VSS.$2940.Metal2 0.0256962f
Cred_3006 VSS VSS.$2946.Metal2 0.0176482f
Cred_3007 VSS VSS.$2958.Metal2 0.0256962f
Cred_3008 VSS VSS.$2988.Metal2 0.0347267f
Cred_3009 VSS VSS.$2994.Metal2 0.0123614f
Cred_3010 VSS VSS.$3006.Metal2 0.0347267f
Cred_3011 VSS VSS.$3036.Metal2 0.0261707f
Cred_3012 VSS VSS.$3042.Metal2 0.0140747f
Cred_3013 VSS VSS.$3054.Metal2 0.0261707f
Cred_3014 VSS VSS.$3060.Metal2 0.022296f
Cred_3015 VSS VSS.$3078.Metal2 0.022296f
Cred_3016 VSS VSS.$3085.Metal2 0.0413881f
Cred_3017 VSS VSS.$3095.Metal2 0.0437329f
Cred_3018 VSS VSS.$3101.Metal2 0.00733511f
Cred_3019 VSS VSS.$3113.Metal2 0.0437329f
Cred_3020 VSS VSS.$312.Metal1 0.0431844f
Cred_3021 VSS VSS.$3151.Metal2 0.0345185f
Cred_3022 VSS VSS.$3157.Metal2 0.0164324f
Cred_3023 VSS VSS.$3169.Metal2 0.0345185f
Cred_3024 VSS VSS.$317.Metal1 0.108621f
Cred_3025 VSS VSS.$3199.Metal2 0.0348083f
Cred_3026 VSS VSS.$3205.Metal2 0.0119541f
Cred_3027 VSS VSS.$3217.Metal2 0.0348083f
Cred_3028 VSS VSS.$3250.Metal2 0.037102f
Cred_3029 VSS VSS.$326.Metal1 0.108621f
Cred_3030 VSS VSS.$3260.Metal2 0.0309006f
Cred_3031 VSS VSS.$3276.Metal2 0.037102f
Cred_3032 VSS VSS.$3282.Metal2 0.037102f
Cred_3033 VSS VSS.$3292.Metal2 0.0309006f
Cred_3034 VSS VSS.$3308.Metal2 0.037102f
Cred_3035 VSS VSS.$332.Metal1 0.07162f
Cred_3036 VSS VSS.$3338.Metal2 0.0348083f
Cred_3037 VSS VSS.$3344.Metal2 0.0119541f
Cred_3038 VSS VSS.$3356.Metal2 0.0348083f
Cred_3039 VSS VSS.$3386.Metal2 0.0345185f
Cred_3040 VSS VSS.$3392.Metal2 0.0164324f
Cred_3041 VSS VSS.$3404.Metal2 0.0345185f
Cred_3042 VSS VSS.$3435.Metal2 0.0413881f
Cred_3043 VSS VSS.$3445.Metal2 0.0437329f
Cred_3044 VSS VSS.$3451.Metal2 0.00733511f
Cred_3045 VSS VSS.$3463.Metal2 0.0437329f
Cred_3046 VSS VSS.$3477.Metal2 0.022296f
Cred_3047 VSS VSS.$3495.Metal2 0.022296f
Cred_3048 VSS VSS.$3501.Metal2 0.0261707f
Cred_3049 VSS VSS.$3507.Metal2 0.0140747f
Cred_3050 VSS VSS.$3519.Metal2 0.0261707f
Cred_3051 VSS VSS.$3549.Metal2 0.0347267f
Cred_3052 VSS VSS.$3555.Metal2 0.0123614f
Cred_3053 VSS VSS.$3567.Metal2 0.0347267f
Cred_3054 VSS VSS.$3597.Metal2 0.0256962f
Cred_3055 VSS VSS.$360.Metal1 0.0680467f
Cred_3056 VSS VSS.$3603.Metal2 0.0176482f
Cred_3057 VSS VSS.$3615.Metal2 0.0256962f
Cred_3058 VSS VSS.$3632.Metal2 0.047425f
Cred_3059 VSS VSS.$3638.Metal2 0.0398509f
Cred_3060 VSS VSS.$365.Metal1 0.0845356f
Cred_3061 VSS VSS.$3650.Metal2 0.047425f
Cred_3062 VSS VSS.$3688.Metal2 0.0255794f
Cred_3063 VSS VSS.$3694.Metal2 0.0126771f
Cred_3064 VSS VSS.$3706.Metal2 0.0255794f
Cred_3065 VSS VSS.$3712.Metal2 0.026523f
Cred_3066 VSS VSS.$3718.Metal2 0.00951653f
Cred_3067 VSS VSS.$3730.Metal2 0.026523f
Cred_3068 VSS VSS.$374.Metal1 0.0845356f
Cred_3069 VSS VSS.$3760.Metal2 0.0261273f
Cred_3070 VSS VSS.$3766.Metal2 0.0135437f
Cred_3071 VSS VSS.$3778.Metal2 0.0261273f
Cred_3072 VSS VSS.$3784.Metal2 0.024093f
Cred_3073 VSS VSS.$380.Metal1 0.0751081f
Cred_3074 VSS VSS.$3802.Metal2 0.024093f
Cred_3075 VSS VSS.$3809.Metal2 0.0414835f
Cred_3076 VSS VSS.$3819.Metal2 0.0418595f
Cred_3077 VSS VSS.$3825.Metal2 0.00756704f
Cred_3078 VSS VSS.$3837.Metal2 0.0418595f
Cred_3079 VSS VSS.$385.Metal1 0.103338f
Cred_3080 VSS VSS.$386.Metal1 0.0928954f
Cred_3081 VSS VSS.$387.Metal1 0.103338f
Cred_3082 VSS VSS.$3875.Metal2 0.034614f
Cred_3083 VSS VSS.$3881.Metal2 0.0165588f
Cred_3084 VSS VSS.$3893.Metal2 0.034614f
Cred_3085 VSS VSS.$3923.Metal2 0.0347482f
Cred_3086 VSS VSS.$3929.Metal2 0.0120029f
Cred_3087 VSS VSS.$3941.Metal2 0.0347482f
Cred_3088 VSS VSS.$3982.Metal2 0.0393356f
Cred_3089 VSS VSS.$3988.Metal2 0.0334807f
Cred_3090 VSS VSS.$4000.Metal2 0.0393356f
Cred_3091 VSS VSS.$4014.Metal2 0.0357303f
Cred_3092 VSS VSS.$4020.Metal2 0.0301243f
Cred_3093 VSS VSS.$4032.Metal2 0.0357303f
Cred_3094 VSS VSS.$4062.Metal2 0.034597f
Cred_3095 VSS VSS.$4068.Metal2 0.012102f
Cred_3096 VSS VSS.$4080.Metal2 0.034597f
Cred_3097 VSS VSS.$4110.Metal2 0.0262561f
Cred_3098 VSS VSS.$4116.Metal2 0.00898563f
Cred_3099 VSS VSS.$4128.Metal2 0.0262561f
Cred_3100 VSS VSS.$4134.Metal2 0.0275365f
Cred_3101 VSS VSS.$4140.Metal2 0.00822357f
Cred_3102 VSS VSS.$4152.Metal2 0.0275365f
Cred_3103 VSS VSS.$4164.Metal2 0.128073f
Cred_3104 VSS VSS.$4166.Metal2 0.0142681f
Cred_3105 VSS VSS.$4168.Metal2 0.019382f
Cred_3106 VSS VSS.$4170.Metal2 0.019382f
Cred_3107 VSS VSS.$4172.Metal2 0.0142681f
Cred_3108 VSS VSS.$4174.Metal2 0.128073f
Cred_3109 VSS VSS.$4195.Metal2 0.0303496f
Cred_3110 VSS VSS.$4213.Metal2 0.0303496f
Cred_3111 VSS VSS.$4227.Metal2 0.141476f
Cred_3112 VSS VSS.$4241.Metal2 0.141476f
Cred_3113 VSS VSS.$4251.Metal2 0.0793973f
Cred_3114 VSS VSS.$4271.Metal2 0.0793973f
Cred_3115 VSS VSS.$4355.Metal3 0.976668f
Cred_3116 VSS VSS.$4358.Metal3 1.0775f
Cred_3117 VSS VSS.$4364.Metal3 0.976668f
Cred_3118 VSS VSS.$4370.Metal3 0.0035979f
Cred_3119 VSS VSS.$4382.Metal3 0.00315832f
Cred_3120 VSS VSS.$4391.Metal3 0.0358903f
Cred_3121 VSS VSS.$4394.Metal3 0.0028143f
Cred_3122 VSS VSS.$4400.Metal3 0.0358903f
Cred_3123 VSS VSS.$4406.Metal3 0.00290986f
Cred_3124 VSS VSS.$4415.Metal3 0.0378777f
Cred_3125 VSS VSS.$4418.Metal3 0.0101465f
Cred_3126 VSS VSS.$4424.Metal3 0.0378777f
Cred_3127 VSS VSS.$4451.Metal3 0.0378845f
Cred_3128 VSS VSS.$4454.Metal3 0.0116338f
Cred_3129 VSS VSS.$4460.Metal3 0.0378845f
Cred_3130 VSS VSS.$4475.Metal3 0.0364921f
Cred_3131 VSS VSS.$4478.Metal3 0.00884914f
Cred_3132 VSS VSS.$4484.Metal3 0.0364921f
Cred_3133 VSS VSS.$451.Metal1 0.067288f
Cred_3134 VSS VSS.$4511.Metal3 0.0512748f
Cred_3135 VSS VSS.$4514.Metal3 0.0086567f
Cred_3136 VSS VSS.$4520.Metal3 0.0512748f
Cred_3137 VSS VSS.$4538.Metal3 0.00903844f
Cred_3138 VSS VSS.$4559.Metal3 0.0583026f
Cred_3139 VSS VSS.$456.Metal1 0.0804609f
Cred_3140 VSS VSS.$4562.Metal3 0.0070744f
Cred_3141 VSS VSS.$4568.Metal3 0.0583026f
Cred_3142 VSS VSS.$4586.Metal3 0.00494974f
Cred_3143 VSS VSS.$4607.Metal3 0.0516448f
Cred_3144 VSS VSS.$4610.Metal3 0.0112502f
Cred_3145 VSS VSS.$4616.Metal3 0.0516448f
Cred_3146 VSS VSS.$4643.Metal3 0.0434847f
Cred_3147 VSS VSS.$4646.Metal3 0.00951752f
Cred_3148 VSS VSS.$465.Metal1 0.0804609f
Cred_3149 VSS VSS.$4652.Metal3 0.0434847f
Cred_3150 VSS VSS.$4679.Metal3 0.0368623f
Cred_3151 VSS VSS.$4682.Metal3 0.00926394f
Cred_3152 VSS VSS.$4688.Metal3 0.0368623f
Cred_3153 VSS VSS.$4703.Metal3 0.0442231f
Cred_3154 VSS VSS.$4706.Metal3 0.008969f
Cred_3155 VSS VSS.$471.Metal1 0.0702719f
Cred_3156 VSS VSS.$4712.Metal3 0.0442231f
Cred_3157 VSS VSS.$4730.Metal3 0.00522155f
Cred_3158 VSS VSS.$4751.Metal3 0.0582211f
Cred_3159 VSS VSS.$4754.Metal3 0.006772f
Cred_3160 VSS VSS.$4760.Metal3 0.0582211f
Cred_3161 VSS VSS.$4778.Metal3 0.00900315f
Cred_3162 VSS VSS.$4799.Metal3 0.0513145f
Cred_3163 VSS VSS.$4802.Metal3 0.00875292f
Cred_3164 VSS VSS.$4808.Metal3 0.0513145f
Cred_3165 VSS VSS.$4835.Metal3 0.0513145f
Cred_3166 VSS VSS.$4838.Metal3 0.00875292f
Cred_3167 VSS VSS.$4844.Metal3 0.0513145f
Cred_3168 VSS VSS.$4862.Metal3 0.00900315f
Cred_3169 VSS VSS.$4883.Metal3 0.0582211f
Cred_3170 VSS VSS.$4886.Metal3 0.006772f
Cred_3171 VSS VSS.$4892.Metal3 0.0582211f
Cred_3172 VSS VSS.$4910.Metal3 0.00522155f
Cred_3173 VSS VSS.$4931.Metal3 0.0442231f
Cred_3174 VSS VSS.$4934.Metal3 0.008969f
Cred_3175 VSS VSS.$4940.Metal3 0.0442231f
Cred_3176 VSS VSS.$4955.Metal3 0.0368623f
Cred_3177 VSS VSS.$4958.Metal3 0.00926394f
Cred_3178 VSS VSS.$4964.Metal3 0.0368623f
Cred_3179 VSS VSS.$499.Metal1 0.0689074f
Cred_3180 VSS VSS.$4991.Metal3 0.0434847f
Cred_3181 VSS VSS.$4994.Metal3 0.00951752f
Cred_3182 VSS VSS.$5000.Metal3 0.0434847f
Cred_3183 VSS VSS.$5027.Metal3 0.0516448f
Cred_3184 VSS VSS.$5030.Metal3 0.0112502f
Cred_3185 VSS VSS.$5036.Metal3 0.0516448f
Cred_3186 VSS VSS.$504.Metal1 0.0869072f
Cred_3187 VSS VSS.$5054.Metal3 0.00494974f
Cred_3188 VSS VSS.$5075.Metal3 0.0583026f
Cred_3189 VSS VSS.$5078.Metal3 0.0070744f
Cred_3190 VSS VSS.$5084.Metal3 0.0583026f
Cred_3191 VSS VSS.$5102.Metal3 0.00903844f
Cred_3192 VSS VSS.$5123.Metal3 0.0512748f
Cred_3193 VSS VSS.$5126.Metal3 0.0086567f
Cred_3194 VSS VSS.$513.Metal1 0.0869072f
Cred_3195 VSS VSS.$5132.Metal3 0.0512748f
Cred_3196 VSS VSS.$5159.Metal3 0.0364921f
Cred_3197 VSS VSS.$5162.Metal3 0.00884914f
Cred_3198 VSS VSS.$5168.Metal3 0.0364921f
Cred_3199 VSS VSS.$5183.Metal3 0.0377636f
Cred_3200 VSS VSS.$5186.Metal3 0.0113922f
Cred_3201 VSS VSS.$519.Metal1 0.0436885f
Cred_3202 VSS VSS.$5192.Metal3 0.0377636f
Cred_3203 VSS VSS.$5219.Metal3 0.0374495f
Cred_3204 VSS VSS.$5222.Metal3 0.00947185f
Cred_3205 VSS VSS.$5228.Metal3 0.0374495f
Cred_3206 VSS VSS.$5234.Metal3 0.00253979f
Cred_3207 VSS VSS.$5243.Metal3 0.0354291f
Cred_3208 VSS VSS.$5246.Metal3 0.00244423f
Cred_3209 VSS VSS.$5252.Metal3 0.0354291f
Cred_3210 VSS VSS.$5258.Metal3 0.00278825f
Cred_3211 VSS VSS.$5270.Metal3 0.00322784f
Cred_3212 VSS VSS.$5279.Metal3 0.878576f
Cred_3213 VSS VSS.$5282.Metal3 0.883013f
Cred_3214 VSS VSS.$5288.Metal3 0.878576f
Cred_3215 VSS VSS.$539.Metal1 0.0431754f
Cred_3216 VSS VSS.$544.Metal1 0.079849f
Cred_3217 VSS VSS.$553.Metal1 0.079849f
Cred_3218 VSS VSS.$559.Metal1 0.0798578f
Cred_3219 VSS VSS.$564.Metal1 0.126279f
Cred_3220 VSS VSS.$565.Metal1 0.0875201f
Cred_3221 VSS VSS.$566.Metal1 0.126279f
Cred_3222 VSS VSS.$618.Metal1 0.0741373f
Cred_3223 VSS VSS.$638.Metal1 0.0429638f
Cred_3224 VSS VSS.$658.Metal1 0.0432038f
Cred_3225 VSS VSS.$66.Metal1 0.155125f
Cred_3226 VSS VSS.$663.Metal1 0.125747f
Cred_3227 VSS VSS.$672.Metal1 0.125747f
Cred_3228 VSS VSS.$678.Metal1 0.0445649f
Cred_3229 VSS VSS.$68.Metal1 0.362876f
Cred_3230 VSS VSS.$698.Metal1 0.0680162f
Cred_3231 VSS VSS.$726.Metal1 0.096918f
Cred_3232 VSS VSS.$731.Metal1 0.0925606f
Cred_3233 VSS VSS.$740.Metal1 0.0925606f
Cred_3234 VSS VSS.$744.Metal1 0.119223f
Cred_3235 VSS VSS.$757.Metal1 0.0224675f
Cred_3236 VSS VSS.$762.Metal1 0.0881226f
Cred_3237 VSS VSS.$771.Metal1 0.0881226f
Cred_3238 VSS VSS.$774.Metal1 0.0217448f
Cred_3239 VSS VSS.$785.Metal1 0.0217448f
Cred_3240 VSS VSS.$817.Metal1 0.0646854f
Cred_3241 VSS VSS.$822.Metal1 0.0879849f
Cred_3242 VSS VSS.$831.Metal1 0.0879849f
Cred_3243 VSS VSS.$837.Metal1 0.0684808f
Cred_3244 VSS VSS.$865.Metal1 0.0711808f
Cred_3245 VSS VSS.$870.Metal1 0.106943f
Cred_3246 VSS VSS.$879.Metal1 0.106943f
Cred_3247 VSS VSS.$885.Metal1 0.0431841f
Cred_3248 VSS VSS.$905.Metal1 0.0691592f
Cred_3249 VSS VSS.$922.Metal1 0.125247f
Cred_3250 VSS VSS.$923.Metal1 0.0683106f
Cred_3251 VSS VSS.$924.Metal1 0.125247f
Cred_3252 VSS VSS.$936.Metal1 0.0353359f
Cred_3253 VSS VSS.$968.Metal1 0.0337656f
Cred_3254 VSS VSS.$981.Metal1 0.0784728f
Cred_3255 VSS VSS.$990.Metal1 0.0784728f
Cred_3256 VSS VSS.$996.Metal1 0.0991773f
Cred_3257 VSS VSS.P0.GatPoly 0.110789f
Cred_3258 VSS VSS.P0.nSD 0.000239797f
Cred_3259 VSS VSS.P0.pSD 0.681828f
Cred_3260 VSS VSS.P1.GatPoly 0.110789f
Cred_3261 VSS VSS.P1.nSD 0.000239797f
Cred_3262 VSS VSS.P1.pSD 0.681828f
Cred_3263 VSS VSS.P10.nSD 0.00057823f
Cred_3264 VSS VSS.P11.nSD 0.00066195f
Cred_3265 VSS VSS.P13.nSD 0.00057823f
Cred_3266 VSS VSS.P15.nSD 2.11087e-05f
Cred_3267 VSS VSS.P17.nSD 0.000578513f
Cred_3268 VSS VSS.P19.nSD 0.000587156f
Cred_3269 VSS VSS.P2.GatPoly 0.110789f
Cred_3270 VSS VSS.P2.pSD 0.775014f
Cred_3271 VSS VSS.P21.nSD 0.000241423f
Cred_3272 VSS VSS.P23.nSD 0.000241423f
Cred_3273 VSS VSS.P24.nSD 0.000239797f
Cred_3274 VSS VSS.P25.nSD 0.000239797f
Cred_3275 VSS VSS.P27.nSD 0.000587156f
Cred_3276 VSS VSS.P29.nSD 0.000578513f
Cred_3277 VSS VSS.P3.GatPoly 0.110789f
Cred_3278 VSS VSS.P3.nSD 0.000587156f
Cred_3279 VSS VSS.P3.pSD 0.775014f
Cred_3280 VSS VSS.P31.nSD 2.11087e-05f
Cred_3281 VSS VSS.P33.nSD 0.00057823f
Cred_3282 VSS VSS.P35.nSD 0.00066195f
Cred_3283 VSS VSS.P37.nSD 0.00057823f
Cred_3284 VSS VSS.P39.nSD 2.11087e-05f
Cred_3285 VSS VSS.P4.GatPoly 0.109847f
Cred_3286 VSS VSS.P41.nSD 0.000578513f
Cred_3287 VSS VSS.P43.nSD 0.000587156f
Cred_3288 VSS VSS.P45.nSD 0.000241423f
Cred_3289 VSS VSS.P47.nSD 0.000241423f
Cred_3290 VSS VSS.P48.nSD 0.000246985f
Cred_3291 VSS VSS.P49.nSD 0.000246985f
Cred_3292 VSS VSS.P5.GatPoly 0.109847f
Cred_3293 VSS VSS.P5.nSD 0.000578513f
Cred_3294 VSS VSS.P51.nSD 0.000673439f
Cred_3295 VSS VSS.P53.nSD 0.000665764f
Cred_3296 VSS VSS.P55.nSD 0.000670902f
Cred_3297 VSS VSS.P57.nSD 0.000676131f
Cred_3298 VSS VSS.P59.nSD 0.000672628f
Cred_3299 VSS VSS.P6.GatPoly 0.109847f
Cred_3300 VSS VSS.P61.nSD 0.000676131f
Cred_3301 VSS VSS.P63.nSD 0.000670902f
Cred_3302 VSS VSS.P65.nSD 0.000665764f
Cred_3303 VSS VSS.P67.nSD 0.000673439f
Cred_3304 VSS VSS.P69.nSD 0.00024863f
Cred_3305 VSS VSS.P7.GatPoly 0.109847f
Cred_3306 VSS VSS.P7.nSD 2.11087e-05f
Cred_3307 VSS VSS.P71.nSD 0.00024863f
Cred_3308 VSS VSS.P72.nSD 0.000246985f
Cred_3309 VSS VSS.P73.nSD 0.000246985f
Cred_3310 VSS VSS.P75.nSD 0.000673439f
Cred_3311 VSS VSS.P77.nSD 0.000665764f
Cred_3312 VSS VSS.P79.nSD 0.000670902f
Cred_3313 VSS VSS.P81.nSD 0.000676131f
Cred_3314 VSS VSS.P83.nSD 0.000672628f
Cred_3315 VSS VSS.P85.nSD 0.000676131f
Cred_3316 VSS VSS.P87.nSD 0.000670902f
Cred_3317 VSS VSS.P89.nSD 0.000665764f
Cred_3318 VSS VSS.P91.nSD 0.000673439f
Cred_3319 VSS VSS.P93.nSD 0.00024863f
Cred_3320 VSS VSS.P95.nSD 0.00024863f
Cred_3321 VDD vin1 0.0834902f
Cred_3322 VDD vin1.$179.GatPoly 0.000255863f
Cred_3323 VDD vin1.$180.GatPoly 8.57399e-05f
Cred_3324 VDD vin1.$202.Metal1 0.00110781f
Cred_3325 VDD vin1.$203.Metal1 0.00304693f
Cred_3326 VDD vin1.$325.Metal1 0.00503056f
Cred_3327 VDD vin1.$331.Metal1 0.0153903f
Cred_3328 VDD vin1.$335.Metal1 0.000790626f
Cred_3329 VDD vin1.$456.Metal1 0.000338982f
Cred_3330 VDD vin1.$457.Metal1 0.00225411f
Cred_3331 VDD vin1.$477.Metal2 0.0137475f
Cred_3332 VDD vin1.$479.Metal2 0.0127715f
Cred_3333 VDD vin1.$480.Metal2 0.0129082f
Cred_3334 VDD vin1.$562.Metal2 0.0110584f
Cred_3335 VDD vin1.$564.Metal2 0.00148262f
Cred_3336 VDD vin1.$567.Metal2 0.0102054f
Cred_3337 VDD vin1.$6.GatPoly 0.000112426f
Cred_3338 VDD vin1.$648.Metal2 7.20699e-06f
Cred_3339 VDD vin1.$649.Metal2 4.77271e-05f
Cred_3340 VDD vin1.$653.Metal2 3.72982e-05f
Cred_3341 VDD vin1.$654.Metal2 0.000236794f
Cred_3342 VDD vin1.$87.GatPoly 0.0262185f
Cred_3343 VDD vin1.$9.GatPoly 0.000270307f
Cred_3344 VDD vin1.$93.GatPoly 0.00825489f
Cred_3345 VDD vin1.$97.GatPoly 0.0276107f
Cred_3346 VDD vin1.P0.GatPoly 0.00578677f
Cred_3347 VDD vin1.P1.GatPoly 0.00195564f
Cred_3348 VDD vin1.P10.GatPoly 0.0019899f
Cred_3349 VDD vin1.P11.GatPoly 0.0019899f
Cred_3350 VDD vin1.P12.GatPoly 0.0019899f
Cred_3351 VDD vin1.P13.GatPoly 0.0019899f
Cred_3352 VDD vin1.P14.GatPoly 0.0019899f
Cred_3353 VDD vin1.P15.GatPoly 0.0019899f
Cred_3354 VDD vin1.P16.GatPoly 0.0019899f
Cred_3355 VDD vin1.P17.GatPoly 0.00191845f
Cred_3356 VDD vin1.P18.GatPoly 0.00195564f
Cred_3357 VDD vin1.P19.GatPoly 0.00592881f
Cred_3358 VDD vin1.P2.GatPoly 0.00191845f
Cred_3359 VDD vin1.P20.GatPoly 0.0118114f
Cred_3360 VDD vin1.P28.GatPoly 0.00105313f
Cred_3361 VDD vin1.P29.GatPoly 0.139246f
Cred_3362 VDD vin1.P3.GatPoly 0.0019899f
Cred_3363 VDD vin1.P30.GatPoly 0.139246f
Cred_3364 VDD vin1.P31.GatPoly 0.00105313f
Cred_3365 VDD vin1.P39.GatPoly 0.0119641f
Cred_3366 VDD vin1.P4.GatPoly 0.0019899f
Cred_3367 VDD vin1.P5.GatPoly 0.0019899f
Cred_3368 VDD vin1.P6.GatPoly 0.0019899f
Cred_3369 VDD vin1.P7.GatPoly 0.0019899f
Cred_3370 VDD vin1.P8.GatPoly 0.0019899f
Cred_3371 VDD vin1.P9.GatPoly 0.0019899f
Cred_3372 VDD vin2 0.0816644f
Cred_3373 VDD vin2.$178.GatPoly 0.000261051f
Cred_3374 VDD vin2.$181.GatPoly 8.82547e-05f
Cred_3375 VDD vin2.$202.Metal1 0.00311854f
Cred_3376 VDD vin2.$203.Metal1 0.00114093f
Cred_3377 VDD vin2.$324.Metal1 0.00503056f
Cred_3378 VDD vin2.$330.Metal1 0.0153903f
Cred_3379 VDD vin2.$334.Metal1 0.000790626f
Cred_3380 VDD vin2.$456.Metal1 0.00229983f
Cred_3381 VDD vin2.$457.Metal1 0.000348925f
Cred_3382 VDD vin2.$477.Metal2 0.014179f
Cred_3383 VDD vin2.$479.Metal2 0.0133285f
Cred_3384 VDD vin2.$480.Metal2 0.0131566f
Cred_3385 VDD vin2.$561.Metal2 0.0110584f
Cred_3386 VDD vin2.$564.Metal2 0.00148262f
Cred_3387 VDD vin2.$566.Metal2 0.0102054f
Cred_3388 VDD vin2.$648.Metal2 4.86949e-05f
Cred_3389 VDD vin2.$649.Metal2 7.41837e-06f
Cred_3390 VDD vin2.$653.Metal2 0.000241596f
Cred_3391 VDD vin2.$654.Metal2 3.83921e-05f
Cred_3392 VDD vin2.$7.GatPoly 0.000115746f
Cred_3393 VDD vin2.$8.GatPoly 0.000275968f
Cred_3394 VDD vin2.$86.GatPoly 0.0262185f
Cred_3395 VDD vin2.$92.GatPoly 0.00825489f
Cred_3396 VDD vin2.$96.GatPoly 0.0276107f
Cred_3397 VDD vin2.P0.GatPoly 0.00324251f
Cred_3398 VDD vin2.P19.GatPoly 0.00321928f
Cred_3399 VDD vin2.P20.GatPoly 0.0118411f
Cred_3400 VDD vin2.P28.GatPoly 0.00105313f
Cred_3401 VDD vin2.P29.GatPoly 0.139246f
Cred_3402 VDD vin2.P30.GatPoly 0.139246f
Cred_3403 VDD vin2.P31.GatPoly 0.00105313f
Cred_3404 VDD vin2.P39.GatPoly 0.0118293f
Cred_3405 VDD vin3 0.0816644f
Cred_3406 VDD vin3.$179.GatPoly 0.000261051f
Cred_3407 VDD vin3.$180.GatPoly 8.82547e-05f
Cred_3408 VDD vin3.$202.Metal1 0.00114093f
Cred_3409 VDD vin3.$203.Metal1 0.00311854f
Cred_3410 VDD vin3.$325.Metal1 0.00503056f
Cred_3411 VDD vin3.$331.Metal1 0.0153903f
Cred_3412 VDD vin3.$335.Metal1 0.000790626f
Cred_3413 VDD vin3.$456.Metal1 0.000348925f
Cred_3414 VDD vin3.$457.Metal1 0.00229983f
Cred_3415 VDD vin3.$477.Metal2 0.014179f
Cred_3416 VDD vin3.$479.Metal2 0.0131566f
Cred_3417 VDD vin3.$480.Metal2 0.0133285f
Cred_3418 VDD vin3.$562.Metal2 0.0102876f
Cred_3419 VDD vin3.$564.Metal2 0.00148262f
Cred_3420 VDD vin3.$567.Metal2 0.0109762f
Cred_3421 VDD vin3.$6.GatPoly 0.000115746f
Cred_3422 VDD vin3.$648.Metal2 7.41837e-06f
Cred_3423 VDD vin3.$649.Metal2 4.86949e-05f
Cred_3424 VDD vin3.$653.Metal2 3.83921e-05f
Cred_3425 VDD vin3.$654.Metal2 0.000241596f
Cred_3426 VDD vin3.$87.GatPoly 0.0262185f
Cred_3427 VDD vin3.$9.GatPoly 0.000275968f
Cred_3428 VDD vin3.$93.GatPoly 0.00825489f
Cred_3429 VDD vin3.$97.GatPoly 0.0276107f
Cred_3430 VDD vin3.P0.GatPoly 0.00324251f
Cred_3431 VDD vin3.P19.GatPoly 0.00321928f
Cred_3432 VDD vin3.P20.GatPoly 0.0118411f
Cred_3433 VDD vin3.P28.GatPoly 0.00105313f
Cred_3434 VDD vin3.P29.GatPoly 0.139246f
Cred_3435 VDD vin3.P30.GatPoly 0.139246f
Cred_3436 VDD vin3.P31.GatPoly 0.00105313f
Cred_3437 VDD vin3.P39.GatPoly 0.0118293f
Cred_3438 VDD vin4 0.0834902f
Cred_3439 VDD vin4.$178.GatPoly 0.000255863f
Cred_3440 VDD vin4.$181.GatPoly 8.57399e-05f
Cred_3441 VDD vin4.$202.Metal1 0.00304693f
Cred_3442 VDD vin4.$203.Metal1 0.00110781f
Cred_3443 VDD vin4.$324.Metal1 0.00503056f
Cred_3444 VDD vin4.$330.Metal1 0.0153903f
Cred_3445 VDD vin4.$334.Metal1 0.000790626f
Cred_3446 VDD vin4.$456.Metal1 0.00225411f
Cred_3447 VDD vin4.$457.Metal1 0.000338982f
Cred_3448 VDD vin4.$477.Metal2 0.0137475f
Cred_3449 VDD vin4.$479.Metal2 0.0129082f
Cred_3450 VDD vin4.$480.Metal2 0.0127715f
Cred_3451 VDD vin4.$561.Metal2 0.0110584f
Cred_3452 VDD vin4.$564.Metal2 0.00148262f
Cred_3453 VDD vin4.$566.Metal2 0.0102054f
Cred_3454 VDD vin4.$648.Metal2 4.77271e-05f
Cred_3455 VDD vin4.$649.Metal2 7.20699e-06f
Cred_3456 VDD vin4.$653.Metal2 0.000236794f
Cred_3457 VDD vin4.$654.Metal2 3.72982e-05f
Cred_3458 VDD vin4.$7.GatPoly 0.000112426f
Cred_3459 VDD vin4.$8.GatPoly 0.000270307f
Cred_3460 VDD vin4.$86.GatPoly 0.0262185f
Cred_3461 VDD vin4.$92.GatPoly 0.00825489f
Cred_3462 VDD vin4.$96.GatPoly 0.0276107f
Cred_3463 VDD vin4.P0.GatPoly 0.00578677f
Cred_3464 VDD vin4.P1.GatPoly 0.00195564f
Cred_3465 VDD vin4.P10.GatPoly 0.0019899f
Cred_3466 VDD vin4.P11.GatPoly 0.0019899f
Cred_3467 VDD vin4.P12.GatPoly 0.0019899f
Cred_3468 VDD vin4.P13.GatPoly 0.0019899f
Cred_3469 VDD vin4.P14.GatPoly 0.0019899f
Cred_3470 VDD vin4.P15.GatPoly 0.0019899f
Cred_3471 VDD vin4.P16.GatPoly 0.0019899f
Cred_3472 VDD vin4.P17.GatPoly 0.00191845f
Cred_3473 VDD vin4.P18.GatPoly 0.00195564f
Cred_3474 VDD vin4.P19.GatPoly 0.00592881f
Cred_3475 VDD vin4.P2.GatPoly 0.00191845f
Cred_3476 VDD vin4.P20.GatPoly 0.0118114f
Cred_3477 VDD vin4.P28.GatPoly 0.00105313f
Cred_3478 VDD vin4.P29.GatPoly 0.139246f
Cred_3479 VDD vin4.P3.GatPoly 0.0019899f
Cred_3480 VDD vin4.P30.GatPoly 0.139246f
Cred_3481 VDD vin4.P31.GatPoly 0.00105313f
Cred_3482 VDD vin4.P39.GatPoly 0.0119641f
Cred_3483 VDD vin4.P4.GatPoly 0.0019899f
Cred_3484 VDD vin4.P5.GatPoly 0.0019899f
Cred_3485 VDD vin4.P6.GatPoly 0.0019899f
Cred_3486 VDD vin4.P7.GatPoly 0.0019899f
Cred_3487 VDD vin4.P8.GatPoly 0.0019899f
Cred_3488 VDD vin4.P9.GatPoly 0.0019899f
Cred_3489 VDD vout1 0.145536f
Cred_3490 VDD vout1.$1226.Metal3 0.00466052f
Cred_3491 VDD vout1.$1292.Metal3 0.13437f
Cred_3492 VDD vout1.$1358.Metal3 0.0445092f
Cred_3493 VDD vout1.$1424.Metal3 0.0559213f
Cred_3494 VDD vout1.P0.nSD 9.20216e-05f
Cred_3495 VDD vout1.P0.pSD 0.00032571f
Cred_3496 VDD vout1.P10.nSD 0.000682261f
Cred_3497 VDD vout1.P10.pSD 0.0489244f
Cred_3498 VDD vout1.P12.nSD 1.27996e-05f
Cred_3499 VDD vout1.P14.nSD 2.30347e-05f
Cred_3500 VDD vout1.P14.pSD 5.54337e-05f
Cred_3501 VDD vout1.P16.nSD 1.27996e-05f
Cred_3502 VDD vout1.P18.nSD 0.000992654f
Cred_3503 VDD vout1.P18.pSD 0.00500301f
Cred_3504 VDD vout1.P2.nSD 5.44858e-05f
Cred_3505 VDD vout1.P2.pSD 0.000227824f
Cred_3506 VDD vout1.P4.nSD 1.27996e-05f
Cred_3507 VDD vout1.P6.nSD 2.30309e-05f
Cred_3508 VDD vout1.P6.pSD 5.59162e-05f
Cred_3509 VDD vout1.P8.nSD 1.27996e-05f
Cred_3510 VDD vout1.P8.pSD 0.0474004f
Cred_3511 VDD vout2 0.152142f
Cred_3512 VDD vout2.$1292.Metal3 0.131827f
Cred_3513 VDD vout2.$1358.Metal3 0.041709f
Cred_3514 VDD vout2.$1424.Metal3 0.0621436f
Cred_3515 VDD vout2.P10.nSD 0.000657086f
Cred_3516 VDD vout2.P10.pSD 0.0488389f
Cred_3517 VDD vout2.P18.nSD 0.00111368f
Cred_3518 VDD vout2.P18.pSD 0.00571593f
Cred_3519 VDD vout2.P8.pSD 0.0473956f
Cred_3520 VDD vout3 0.152142f
Cred_3521 VDD vout3.$1292.Metal3 0.131706f
Cred_3522 VDD vout3.$1358.Metal3 0.0418448f
Cred_3523 VDD vout3.$1424.Metal3 0.0621436f
Cred_3524 VDD vout3.P10.nSD 0.000659226f
Cred_3525 VDD vout3.P10.pSD 0.048869f
Cred_3526 VDD vout3.P18.nSD 0.00111368f
Cred_3527 VDD vout3.P18.pSD 0.00571593f
Cred_3528 VDD vout3.P8.pSD 0.0474004f
Cred_3529 VDD vout4 0.145536f
Cred_3530 VDD vout4.$1226.Metal3 0.00466052f
Cred_3531 VDD vout4.$1292.Metal3 0.134491f
Cred_3532 VDD vout4.$1358.Metal3 0.0443734f
Cred_3533 VDD vout4.$1424.Metal3 0.0559213f
Cred_3534 VDD vout4.P0.nSD 9.20216e-05f
Cred_3535 VDD vout4.P0.pSD 0.00032571f
Cred_3536 VDD vout4.P10.nSD 0.000680121f
Cred_3537 VDD vout4.P10.pSD 0.0488943f
Cred_3538 VDD vout4.P12.nSD 1.27996e-05f
Cred_3539 VDD vout4.P14.nSD 2.30347e-05f
Cred_3540 VDD vout4.P14.pSD 5.54337e-05f
Cred_3541 VDD vout4.P16.nSD 1.27996e-05f
Cred_3542 VDD vout4.P18.nSD 0.000992654f
Cred_3543 VDD vout4.P18.pSD 0.00500301f
Cred_3544 VDD vout4.P2.nSD 5.44858e-05f
Cred_3545 VDD vout4.P2.pSD 0.000227824f
Cred_3546 VDD vout4.P4.nSD 1.27996e-05f
Cred_3547 VDD vout4.P6.nSD 2.30309e-05f
Cred_3548 VDD vout4.P6.pSD 5.59162e-05f
Cred_3549 VDD vout4.P8.nSD 1.27996e-05f
Cred_3550 VDD vout4.P8.pSD 0.0473956f
Cred_3551 VDD VSS 6.57792f
Cred_3552 VDD VSS.$1029.Metal1 5.00618e-06f
Cred_3553 VDD VSS.$1038.Metal1 5.00618e-06f
Cred_3554 VDD VSS.$1069.Metal1 4.83949e-06f
Cred_3555 VDD VSS.$1078.Metal1 4.83949e-06f
Cred_3556 VDD VSS.$1165.Metal1 4.83949e-06f
Cred_3557 VDD VSS.$1174.Metal1 4.83949e-06f
Cred_3558 VDD VSS.$1205.Metal1 5.00618e-06f
Cred_3559 VDD VSS.$1214.Metal1 5.00618e-06f
Cred_3560 VDD VSS.$1245.Metal1 4.83949e-06f
Cred_3561 VDD VSS.$1254.Metal1 4.83949e-06f
Cred_3562 VDD VSS.$1265.Metal1 0.000192572f
Cred_3563 VDD VSS.$1267.Metal1 0.000192572f
Cred_3564 VDD VSS.$1364.Metal1 4.83949e-06f
Cred_3565 VDD VSS.$1373.Metal1 4.83949e-06f
Cred_3566 VDD VSS.$1412.Metal1 4.83949e-06f
Cred_3567 VDD VSS.$1421.Metal1 4.83949e-06f
Cred_3568 VDD VSS.$1466.Metal1 0.000207087f
Cred_3569 VDD VSS.$1483.Metal1 0.000207087f
Cred_3570 VDD VSS.$1503.Metal1 4.83949e-06f
Cred_3571 VDD VSS.$1512.Metal1 4.83949e-06f
Cred_3572 VDD VSS.$157.Metal1 0.00153568f
Cred_3573 VDD VSS.$1571.Metal1 4.83949e-06f
Cred_3574 VDD VSS.$158.Metal1 0.00108148f
Cred_3575 VDD VSS.$1580.Metal1 4.83949e-06f
Cred_3576 VDD VSS.$159.Metal1 0.00108148f
Cred_3577 VDD VSS.$160.Metal1 0.00153568f
Cred_3578 VDD VSS.$1623.Metal1 0.000193335f
Cred_3579 VDD VSS.$1625.Metal1 0.000193335f
Cred_3580 VDD VSS.$1690.Metal1 4.83949e-06f
Cred_3581 VDD VSS.$1699.Metal1 4.83949e-06f
Cred_3582 VDD VSS.$173.Metal1 4.71984e-06f
Cred_3583 VDD VSS.$1730.Metal1 5.00618e-06f
Cred_3584 VDD VSS.$1739.Metal1 5.00618e-06f
Cred_3585 VDD VSS.$1778.Metal1 4.83949e-06f
Cred_3586 VDD VSS.$1787.Metal1 4.83949e-06f
Cred_3587 VDD VSS.$1798.Metal1 0.00019073f
Cred_3588 VDD VSS.$1800.Metal1 0.00019073f
Cred_3589 VDD VSS.$182.Metal1 4.71984e-06f
Cred_3590 VDD VSS.$1869.Metal1 4.75618e-06f
Cred_3591 VDD VSS.$1878.Metal1 4.75618e-06f
Cred_3592 VDD VSS.$1917.Metal1 4.75618e-06f
Cred_3593 VDD VSS.$1926.Metal1 4.75618e-06f
Cred_3594 VDD VSS.$1952.Metal1 0.00184643f
Cred_3595 VDD VSS.$1977.Metal1 6.24089e-06f
Cred_3596 VDD VSS.$1986.Metal1 6.24089e-06f
Cred_3597 VDD VSS.$1989.Metal1 0.00155061f
Cred_3598 VDD VSS.$1990.Metal1 6.94193e-07f
Cred_3599 VDD VSS.$1991.Metal1 0.00155061f
Cred_3600 VDD VSS.$2020.Metal1 0.00153597f
Cred_3601 VDD VSS.$2021.Metal1 0.00108148f
Cred_3602 VDD VSS.$2022.Metal1 0.00108148f
Cred_3603 VDD VSS.$2023.Metal1 0.00153597f
Cred_3604 VDD VSS.$2064.Metal1 4.71984e-06f
Cred_3605 VDD VSS.$2073.Metal1 4.71984e-06f
Cred_3606 VDD VSS.$2226.Metal2 0.0367949f
Cred_3607 VDD VSS.$2228.Metal2 0.0270269f
Cred_3608 VDD VSS.$2238.Metal2 0.0270269f
Cred_3609 VDD VSS.$2240.Metal2 0.0367949f
Cred_3610 VDD VSS.$2286.Metal2 0.00440629f
Cred_3611 VDD VSS.$2306.Metal2 0.00440629f
Cred_3612 VDD VSS.$2342.Metal2 0.00243516f
Cred_3613 VDD VSS.$2360.Metal2 0.00243516f
Cred_3614 VDD VSS.$2403.Metal2 0.00183888f
Cred_3615 VDD VSS.$2421.Metal2 0.00183888f
Cred_3616 VDD VSS.$2427.Metal2 0.00180982f
Cred_3617 VDD VSS.$2445.Metal2 0.00180982f
Cred_3618 VDD VSS.$2475.Metal2 0.00239272f
Cred_3619 VDD VSS.$2493.Metal2 0.00239272f
Cred_3620 VDD VSS.$25.Metal1 0.00155064f
Cred_3621 VDD VSS.$2526.Metal2 0.00288443f
Cred_3622 VDD VSS.$2544.Metal2 0.00288443f
Cred_3623 VDD VSS.$2558.Metal2 0.0031781f
Cred_3624 VDD VSS.$257.Metal1 4.9929e-06f
Cred_3625 VDD VSS.$2576.Metal2 0.0031781f
Cred_3626 VDD VSS.$2614.Metal2 0.00247629f
Cred_3627 VDD VSS.$2632.Metal2 0.00247629f
Cred_3628 VDD VSS.$266.Metal1 4.9929e-06f
Cred_3629 VDD VSS.$2662.Metal2 0.00247629f
Cred_3630 VDD VSS.$2680.Metal2 0.00247629f
Cred_3631 VDD VSS.$27.Metal1 0.00155064f
Cred_3632 VDD VSS.$2721.Metal2 0.00363365f
Cred_3633 VDD VSS.$2739.Metal2 0.00363365f
Cred_3634 VDD VSS.$2753.Metal2 0.00204021f
Cred_3635 VDD VSS.$2771.Metal2 0.00204021f
Cred_3636 VDD VSS.$2777.Metal2 0.00185189f
Cred_3637 VDD VSS.$2795.Metal2 0.00185189f
Cred_3638 VDD VSS.$2825.Metal2 0.00184153f
Cred_3639 VDD VSS.$2843.Metal2 0.00184153f
Cred_3640 VDD VSS.$2849.Metal2 0.00184153f
Cred_3641 VDD VSS.$2867.Metal2 0.00184153f
Cred_3642 VDD VSS.$29.Metal1 0.00104888f
Cred_3643 VDD VSS.$2908.Metal2 0.00430303f
Cred_3644 VDD VSS.$292.Metal1 0.00184643f
Cred_3645 VDD VSS.$2926.Metal2 0.00430303f
Cred_3646 VDD VSS.$2940.Metal2 0.001935f
Cred_3647 VDD VSS.$2958.Metal2 0.001935f
Cred_3648 VDD VSS.$2988.Metal2 0.00243463f
Cred_3649 VDD VSS.$3006.Metal2 0.00243463f
Cred_3650 VDD VSS.$3036.Metal2 0.00185189f
Cred_3651 VDD VSS.$3054.Metal2 0.00185189f
Cred_3652 VDD VSS.$3060.Metal2 0.00185284f
Cred_3653 VDD VSS.$3078.Metal2 0.00185284f
Cred_3654 VDD VSS.$3095.Metal2 0.00382181f
Cred_3655 VDD VSS.$3113.Metal2 0.00382181f
Cred_3656 VDD VSS.$3151.Metal2 0.00247629f
Cred_3657 VDD VSS.$3169.Metal2 0.00247629f
Cred_3658 VDD VSS.$317.Metal1 4.75618e-06f
Cred_3659 VDD VSS.$3199.Metal2 0.00247629f
Cred_3660 VDD VSS.$3217.Metal2 0.00247629f
Cred_3661 VDD VSS.$3250.Metal2 0.0031227f
Cred_3662 VDD VSS.$326.Metal1 4.75618e-06f
Cred_3663 VDD VSS.$3276.Metal2 0.0031227f
Cred_3664 VDD VSS.$3282.Metal2 0.0031227f
Cred_3665 VDD VSS.$3308.Metal2 0.0031227f
Cred_3666 VDD VSS.$3338.Metal2 0.00247629f
Cred_3667 VDD VSS.$3356.Metal2 0.00247629f
Cred_3668 VDD VSS.$3386.Metal2 0.00247629f
Cred_3669 VDD VSS.$3404.Metal2 0.00247629f
Cred_3670 VDD VSS.$3445.Metal2 0.00382181f
Cred_3671 VDD VSS.$3463.Metal2 0.00382181f
Cred_3672 VDD VSS.$3477.Metal2 0.00185284f
Cred_3673 VDD VSS.$3495.Metal2 0.00185284f
Cred_3674 VDD VSS.$3501.Metal2 0.00185189f
Cred_3675 VDD VSS.$3519.Metal2 0.00185189f
Cred_3676 VDD VSS.$3549.Metal2 0.00243463f
Cred_3677 VDD VSS.$3567.Metal2 0.00243463f
Cred_3678 VDD VSS.$3597.Metal2 0.001935f
Cred_3679 VDD VSS.$3615.Metal2 0.001935f
Cred_3680 VDD VSS.$3632.Metal2 0.00430303f
Cred_3681 VDD VSS.$365.Metal1 4.75618e-06f
Cred_3682 VDD VSS.$3650.Metal2 0.00430303f
Cred_3683 VDD VSS.$3688.Metal2 0.00184153f
Cred_3684 VDD VSS.$3706.Metal2 0.00184153f
Cred_3685 VDD VSS.$3712.Metal2 0.00184153f
Cred_3686 VDD VSS.$3730.Metal2 0.00184153f
Cred_3687 VDD VSS.$374.Metal1 4.75618e-06f
Cred_3688 VDD VSS.$3760.Metal2 0.00185189f
Cred_3689 VDD VSS.$3778.Metal2 0.00185189f
Cred_3690 VDD VSS.$3784.Metal2 0.00204021f
Cred_3691 VDD VSS.$3802.Metal2 0.00204021f
Cred_3692 VDD VSS.$3819.Metal2 0.00363365f
Cred_3693 VDD VSS.$3837.Metal2 0.00363365f
Cred_3694 VDD VSS.$385.Metal1 0.00019073f
Cred_3695 VDD VSS.$387.Metal1 0.00019073f
Cred_3696 VDD VSS.$3875.Metal2 0.00247629f
Cred_3697 VDD VSS.$3893.Metal2 0.00247629f
Cred_3698 VDD VSS.$3923.Metal2 0.00247629f
Cred_3699 VDD VSS.$3941.Metal2 0.00247629f
Cred_3700 VDD VSS.$3982.Metal2 0.0031781f
Cred_3701 VDD VSS.$4000.Metal2 0.0031781f
Cred_3702 VDD VSS.$4014.Metal2 0.00288443f
Cred_3703 VDD VSS.$4032.Metal2 0.00288443f
Cred_3704 VDD VSS.$4062.Metal2 0.00239272f
Cred_3705 VDD VSS.$4080.Metal2 0.00239272f
Cred_3706 VDD VSS.$4110.Metal2 0.00180982f
Cred_3707 VDD VSS.$4128.Metal2 0.00180982f
Cred_3708 VDD VSS.$4134.Metal2 0.00199442f
Cred_3709 VDD VSS.$4152.Metal2 0.00199442f
Cred_3710 VDD VSS.$4164.Metal2 0.0273311f
Cred_3711 VDD VSS.$4174.Metal2 0.0273311f
Cred_3712 VDD VSS.$4195.Metal2 0.00257286f
Cred_3713 VDD VSS.$4213.Metal2 0.00257286f
Cred_3714 VDD VSS.$4227.Metal2 0.0367792f
Cred_3715 VDD VSS.$4241.Metal2 0.0367792f
Cred_3716 VDD VSS.$4251.Metal2 0.00441121f
Cred_3717 VDD VSS.$4271.Metal2 0.00441121f
Cred_3718 VDD VSS.$4355.Metal3 0.26799f
Cred_3719 VDD VSS.$4358.Metal3 0.352361f
Cred_3720 VDD VSS.$4364.Metal3 0.26799f
Cred_3721 VDD VSS.$4391.Metal3 0.0084103f
Cred_3722 VDD VSS.$4400.Metal3 0.0084103f
Cred_3723 VDD VSS.$4415.Metal3 0.00768094f
Cred_3724 VDD VSS.$4424.Metal3 0.00768094f
Cred_3725 VDD VSS.$4451.Metal3 0.00648452f
Cred_3726 VDD VSS.$4460.Metal3 0.00648452f
Cred_3727 VDD VSS.$4475.Metal3 0.00644754f
Cred_3728 VDD VSS.$4484.Metal3 0.00644754f
Cred_3729 VDD VSS.$4511.Metal3 0.00908187f
Cred_3730 VDD VSS.$4520.Metal3 0.00908187f
Cred_3731 VDD VSS.$4559.Metal3 0.010494f
Cred_3732 VDD VSS.$456.Metal1 4.83949e-06f
Cred_3733 VDD VSS.$4568.Metal3 0.010494f
Cred_3734 VDD VSS.$4607.Metal3 0.00919889f
Cred_3735 VDD VSS.$4616.Metal3 0.00919889f
Cred_3736 VDD VSS.$4643.Metal3 0.00790627f
Cred_3737 VDD VSS.$465.Metal1 4.83949e-06f
Cred_3738 VDD VSS.$4652.Metal3 0.00790627f
Cred_3739 VDD VSS.$4679.Metal3 0.00659812f
Cred_3740 VDD VSS.$4688.Metal3 0.00659812f
Cred_3741 VDD VSS.$4703.Metal3 0.00789074f
Cred_3742 VDD VSS.$4712.Metal3 0.00789074f
Cred_3743 VDD VSS.$4751.Metal3 0.010494f
Cred_3744 VDD VSS.$4760.Metal3 0.010494f
Cred_3745 VDD VSS.$4799.Metal3 0.00920136f
Cred_3746 VDD VSS.$4808.Metal3 0.00920136f
Cred_3747 VDD VSS.$4835.Metal3 0.00920136f
Cred_3748 VDD VSS.$4844.Metal3 0.00920136f
Cred_3749 VDD VSS.$4883.Metal3 0.010494f
Cred_3750 VDD VSS.$4892.Metal3 0.010494f
Cred_3751 VDD VSS.$4931.Metal3 0.00789074f
Cred_3752 VDD VSS.$4940.Metal3 0.00789074f
Cred_3753 VDD VSS.$4955.Metal3 0.00659812f
Cred_3754 VDD VSS.$4964.Metal3 0.00659812f
Cred_3755 VDD VSS.$4991.Metal3 0.00790627f
Cred_3756 VDD VSS.$5000.Metal3 0.00790627f
Cred_3757 VDD VSS.$5027.Metal3 0.00919889f
Cred_3758 VDD VSS.$5036.Metal3 0.00919889f
Cred_3759 VDD VSS.$504.Metal1 5.00618e-06f
Cred_3760 VDD VSS.$5075.Metal3 0.010494f
Cred_3761 VDD VSS.$5084.Metal3 0.010494f
Cred_3762 VDD VSS.$5123.Metal3 0.00908187f
Cred_3763 VDD VSS.$513.Metal1 5.00618e-06f
Cred_3764 VDD VSS.$5132.Metal3 0.00908187f
Cred_3765 VDD VSS.$5159.Metal3 0.00644754f
Cred_3766 VDD VSS.$5168.Metal3 0.00644754f
Cred_3767 VDD VSS.$5183.Metal3 0.00648452f
Cred_3768 VDD VSS.$5192.Metal3 0.00648452f
Cred_3769 VDD VSS.$5219.Metal3 0.00648601f
Cred_3770 VDD VSS.$5228.Metal3 0.00648601f
Cred_3771 VDD VSS.$5243.Metal3 0.0064878f
Cred_3772 VDD VSS.$5252.Metal3 0.0064878f
Cred_3773 VDD VSS.$5279.Metal3 0.251537f
Cred_3774 VDD VSS.$5282.Metal3 0.319643f
Cred_3775 VDD VSS.$5288.Metal3 0.251537f
Cred_3776 VDD VSS.$544.Metal1 4.83949e-06f
Cred_3777 VDD VSS.$553.Metal1 4.83949e-06f
Cred_3778 VDD VSS.$564.Metal1 0.000193335f
Cred_3779 VDD VSS.$566.Metal1 0.000193335f
Cred_3780 VDD VSS.$66.Metal1 0.00104888f
Cred_3781 VDD VSS.$663.Metal1 4.83949e-06f
Cred_3782 VDD VSS.$672.Metal1 4.83949e-06f
Cred_3783 VDD VSS.$68.Metal1 0.00156599f
Cred_3784 VDD VSS.$731.Metal1 4.83949e-06f
Cred_3785 VDD VSS.$740.Metal1 4.83949e-06f
Cred_3786 VDD VSS.$774.Metal1 0.000207087f
Cred_3787 VDD VSS.$785.Metal1 0.000207087f
Cred_3788 VDD VSS.$822.Metal1 4.83949e-06f
Cred_3789 VDD VSS.$831.Metal1 4.83949e-06f
Cred_3790 VDD VSS.$870.Metal1 4.83949e-06f
Cred_3791 VDD VSS.$879.Metal1 4.83949e-06f
Cred_3792 VDD VSS.$922.Metal1 0.000192572f
Cred_3793 VDD VSS.$924.Metal1 0.000192572f
Cred_3794 VDD VSS.$981.Metal1 4.83949e-06f
Cred_3795 VDD VSS.$990.Metal1 4.83949e-06f
Cred_3796 VDD VSS.P0.GatPoly 0.00130168f
Cred_3797 VDD VSS.P0.nSD 6.00282e-06f
Cred_3798 VDD VSS.P0.pSD 0.00188712f
Cred_3799 VDD VSS.P1.GatPoly 0.00130168f
Cred_3800 VDD VSS.P1.nSD 6.00282e-06f
Cred_3801 VDD VSS.P1.pSD 0.00188712f
Cred_3802 VDD VSS.P10.nSD 6.60813e-06f
Cred_3803 VDD VSS.P11.nSD 6.66369e-06f
Cred_3804 VDD VSS.P13.nSD 6.60813e-06f
Cred_3805 VDD VSS.P15.nSD 1.13305e-06f
Cred_3806 VDD VSS.P17.nSD 6.63431e-06f
Cred_3807 VDD VSS.P19.nSD 6.54491e-06f
Cred_3808 VDD VSS.P2.GatPoly 0.00130168f
Cred_3809 VDD VSS.P2.pSD 0.00223919f
Cred_3810 VDD VSS.P21.nSD 6.00282e-06f
Cred_3811 VDD VSS.P23.nSD 6.00282e-06f
Cred_3812 VDD VSS.P24.nSD 6.00282e-06f
Cred_3813 VDD VSS.P25.nSD 6.00282e-06f
Cred_3814 VDD VSS.P27.nSD 6.54491e-06f
Cred_3815 VDD VSS.P29.nSD 6.63431e-06f
Cred_3816 VDD VSS.P3.GatPoly 0.00130168f
Cred_3817 VDD VSS.P3.nSD 6.54491e-06f
Cred_3818 VDD VSS.P3.pSD 0.00223919f
Cred_3819 VDD VSS.P31.nSD 1.13305e-06f
Cred_3820 VDD VSS.P33.nSD 6.60813e-06f
Cred_3821 VDD VSS.P35.nSD 6.66369e-06f
Cred_3822 VDD VSS.P37.nSD 6.60813e-06f
Cred_3823 VDD VSS.P39.nSD 1.13305e-06f
Cred_3824 VDD VSS.P4.GatPoly 0.00133986f
Cred_3825 VDD VSS.P41.nSD 6.63431e-06f
Cred_3826 VDD VSS.P43.nSD 6.54491e-06f
Cred_3827 VDD VSS.P45.nSD 6.00282e-06f
Cred_3828 VDD VSS.P47.nSD 6.00282e-06f
Cred_3829 VDD VSS.P48.nSD 4.42468e-06f
Cred_3830 VDD VSS.P49.nSD 4.42468e-06f
Cred_3831 VDD VSS.P5.GatPoly 0.00133986f
Cred_3832 VDD VSS.P5.nSD 6.63431e-06f
Cred_3833 VDD VSS.P6.GatPoly 0.00133986f
Cred_3834 VDD VSS.P69.nSD 4.42468e-06f
Cred_3835 VDD VSS.P7.GatPoly 0.00133986f
Cred_3836 VDD VSS.P7.nSD 1.13305e-06f
Cred_3837 VDD VSS.P71.nSD 4.42468e-06f
Cred_3838 VDD VSS.P72.nSD 4.42468e-06f
Cred_3839 VDD VSS.P73.nSD 4.42468e-06f
Cred_3840 VDD VSS.P93.nSD 4.42468e-06f
Cred_3841 VDD VSS.P95.nSD 4.42468e-06f
Cred_3842 VDD.$1001.Metal1 vin3.$233.Metal1 5.74081e-09f
Cred_3843 VDD.$1001.Metal1 vin3.$237.Metal1 7.72039e-09f
Cred_3844 VDD.$1001.Metal1 vin3.$500.Metal2 7.08559e-07f
Cred_3845 VDD.$1001.Metal1 vin3.$504.Metal2 7.08559e-07f
Cred_3846 VDD.$1001.Metal1 vin3.P23.GatPoly 0.0125591f
Cred_3847 VDD.$1001.Metal1 vin4.$232.Metal1 5.74081e-09f
Cred_3848 VDD.$1001.Metal1 vin4.$236.Metal1 7.72039e-09f
Cred_3849 VDD.$1001.Metal1 vin4.$499.Metal2 7.08559e-07f
Cred_3850 VDD.$1001.Metal1 vin4.$503.Metal2 7.08559e-07f
Cred_3851 VDD.$1001.Metal1 vin4.P23.GatPoly 0.0125591f
Cred_3852 VDD.$1017.Metal1 vin1.$233.Metal1 1.28485e-08f
Cred_3853 VDD.$1017.Metal1 vin1.$237.Metal1 1.7279e-08f
Cred_3854 VDD.$1017.Metal1 vin1.$500.Metal2 1.58582e-06f
Cred_3855 VDD.$1017.Metal1 vin1.$504.Metal2 1.58582e-06f
Cred_3856 VDD.$1017.Metal1 vin1.P23.GatPoly 0.0103926f
Cred_3857 VDD.$1017.Metal1 vin2.$232.Metal1 1.28485e-08f
Cred_3858 VDD.$1017.Metal1 vin2.$236.Metal1 1.7279e-08f
Cred_3859 VDD.$1017.Metal1 vin2.$499.Metal2 1.58582e-06f
Cred_3860 VDD.$1017.Metal1 vin2.$503.Metal2 1.58582e-06f
Cred_3861 VDD.$1017.Metal1 vin2.P23.GatPoly 0.0103926f
Cred_3862 VDD.$1021.Metal1 vin3.$233.Metal1 1.28485e-08f
Cred_3863 VDD.$1021.Metal1 vin3.$237.Metal1 1.7279e-08f
Cred_3864 VDD.$1021.Metal1 vin3.$500.Metal2 1.58582e-06f
Cred_3865 VDD.$1021.Metal1 vin3.$504.Metal2 1.58582e-06f
Cred_3866 VDD.$1021.Metal1 vin3.P23.GatPoly 0.0103926f
Cred_3867 VDD.$1021.Metal1 vin4.$232.Metal1 1.28485e-08f
Cred_3868 VDD.$1021.Metal1 vin4.$236.Metal1 1.7279e-08f
Cred_3869 VDD.$1021.Metal1 vin4.$499.Metal2 1.58582e-06f
Cred_3870 VDD.$1021.Metal1 vin4.$503.Metal2 1.58582e-06f
Cred_3871 VDD.$1021.Metal1 vin4.P23.GatPoly 0.0103926f
Cred_3872 VDD.$1024.Metal1 vin1.$237.Metal1 0.00359453f
Cred_3873 VDD.$1024.Metal1 vin1.$241.Metal1 0.0153629f
Cred_3874 VDD.$1024.Metal1 vin1.$247.Metal1 0.00781892f
Cred_3875 VDD.$1024.Metal1 vin1.$25.GatPoly 0.0282708f
Cred_3876 VDD.$1024.Metal1 vin1.$251.Metal1 0.00273151f
Cred_3877 VDD.$1024.Metal1 vin1.$37.GatPoly 0.0161598f
Cred_3878 VDD.$1024.Metal1 vin1.$43.GatPoly 0.00516462f
Cred_3879 VDD.$1024.Metal1 vin1.$504.Metal2 0.0137f
Cred_3880 VDD.$1024.Metal1 vin1.$506.Metal2 0.00133475f
Cred_3881 VDD.$1024.Metal1 vin1.$509.Metal2 0.0079159f
Cred_3882 VDD.$1024.Metal1 vin1.P22.GatPoly 0.00105234f
Cred_3883 VDD.$1024.Metal1 vin1.P23.GatPoly 0.139694f
Cred_3884 VDD.$1024.Metal1 vin1.P24.GatPoly 0.145402f
Cred_3885 VDD.$1024.Metal1 vin1.P25.GatPoly 0.00105234f
Cred_3886 VDD.$1024.Metal1 vin2.$236.Metal1 0.00359453f
Cred_3887 VDD.$1024.Metal1 vin2.$24.GatPoly 0.0282708f
Cred_3888 VDD.$1024.Metal1 vin2.$240.Metal1 0.0153629f
Cred_3889 VDD.$1024.Metal1 vin2.$246.Metal1 0.00781892f
Cred_3890 VDD.$1024.Metal1 vin2.$250.Metal1 0.00273151f
Cred_3891 VDD.$1024.Metal1 vin2.$36.GatPoly 0.0161598f
Cred_3892 VDD.$1024.Metal1 vin2.$42.GatPoly 0.00516462f
Cred_3893 VDD.$1024.Metal1 vin2.$503.Metal2 0.0137f
Cred_3894 VDD.$1024.Metal1 vin2.$506.Metal2 0.00133475f
Cred_3895 VDD.$1024.Metal1 vin2.$508.Metal2 0.0079159f
Cred_3896 VDD.$1024.Metal1 vin2.P22.GatPoly 0.00105234f
Cred_3897 VDD.$1024.Metal1 vin2.P23.GatPoly 0.139694f
Cred_3898 VDD.$1024.Metal1 vin2.P24.GatPoly 0.145402f
Cred_3899 VDD.$1024.Metal1 vin2.P25.GatPoly 0.00105234f
Cred_3900 VDD.$1024.Metal1 vout1.$1226.Metal3 0.165399f
Cred_3901 VDD.$1024.Metal1 vout1.P0.nSD 0.00108727f
Cred_3902 VDD.$1024.Metal1 vout1.P0.pSD 0.00577759f
Cred_3903 VDD.$1024.Metal1 vout1.P2.nSD 0.00118281f
Cred_3904 VDD.$1024.Metal1 vout1.P2.pSD 0.0520725f
Cred_3905 VDD.$1024.Metal1 vout1.P4.pSD 0.0462192f
Cred_3906 VDD.$1024.Metal1 vout2.$1226.Metal3 0.165585f
Cred_3907 VDD.$1024.Metal1 vout2.P0.nSD 0.00107931f
Cred_3908 VDD.$1024.Metal1 vout2.P0.pSD 0.00573526f
Cred_3909 VDD.$1024.Metal1 vout2.P2.nSD 0.00117415f
Cred_3910 VDD.$1024.Metal1 vout2.P2.pSD 0.051178f
Cred_3911 VDD.$1024.Metal1 vout2.P4.pSD 0.0470776f
Cred_3912 VDD.$1025.Metal1 vin3.$237.Metal1 0.00359453f
Cred_3913 VDD.$1025.Metal1 vin3.$241.Metal1 0.0153629f
Cred_3914 VDD.$1025.Metal1 vin3.$247.Metal1 0.00781892f
Cred_3915 VDD.$1025.Metal1 vin3.$25.GatPoly 0.0282708f
Cred_3916 VDD.$1025.Metal1 vin3.$251.Metal1 0.00273151f
Cred_3917 VDD.$1025.Metal1 vin3.$37.GatPoly 0.0161598f
Cred_3918 VDD.$1025.Metal1 vin3.$43.GatPoly 0.00516462f
Cred_3919 VDD.$1025.Metal1 vin3.$504.Metal2 0.0137f
Cred_3920 VDD.$1025.Metal1 vin3.$506.Metal2 0.00133475f
Cred_3921 VDD.$1025.Metal1 vin3.$509.Metal2 0.0079159f
Cred_3922 VDD.$1025.Metal1 vin3.P22.GatPoly 0.00105234f
Cred_3923 VDD.$1025.Metal1 vin3.P23.GatPoly 0.139694f
Cred_3924 VDD.$1025.Metal1 vin3.P24.GatPoly 0.145402f
Cred_3925 VDD.$1025.Metal1 vin3.P25.GatPoly 0.00105234f
Cred_3926 VDD.$1025.Metal1 vin4.$236.Metal1 0.00359453f
Cred_3927 VDD.$1025.Metal1 vin4.$24.GatPoly 0.0282708f
Cred_3928 VDD.$1025.Metal1 vin4.$240.Metal1 0.0153629f
Cred_3929 VDD.$1025.Metal1 vin4.$246.Metal1 0.00781892f
Cred_3930 VDD.$1025.Metal1 vin4.$250.Metal1 0.00273151f
Cred_3931 VDD.$1025.Metal1 vin4.$36.GatPoly 0.0161598f
Cred_3932 VDD.$1025.Metal1 vin4.$42.GatPoly 0.00516462f
Cred_3933 VDD.$1025.Metal1 vin4.$503.Metal2 0.0137f
Cred_3934 VDD.$1025.Metal1 vin4.$506.Metal2 0.00133475f
Cred_3935 VDD.$1025.Metal1 vin4.$508.Metal2 0.0079159f
Cred_3936 VDD.$1025.Metal1 vin4.P22.GatPoly 0.00105234f
Cred_3937 VDD.$1025.Metal1 vin4.P23.GatPoly 0.139694f
Cred_3938 VDD.$1025.Metal1 vin4.P24.GatPoly 0.145402f
Cred_3939 VDD.$1025.Metal1 vin4.P25.GatPoly 0.00105234f
Cred_3940 VDD.$1025.Metal1 vout3.$1226.Metal3 0.165399f
Cred_3941 VDD.$1025.Metal1 vout3.P0.nSD 0.00108727f
Cred_3942 VDD.$1025.Metal1 vout3.P0.pSD 0.00577759f
Cred_3943 VDD.$1025.Metal1 vout3.P2.nSD 0.00118281f
Cred_3944 VDD.$1025.Metal1 vout3.P2.pSD 0.0520725f
Cred_3945 VDD.$1025.Metal1 vout3.P4.pSD 0.0462192f
Cred_3946 VDD.$1025.Metal1 vout4.$1226.Metal3 0.165585f
Cred_3947 VDD.$1025.Metal1 vout4.P0.nSD 0.00107931f
Cred_3948 VDD.$1025.Metal1 vout4.P0.pSD 0.00573526f
Cred_3949 VDD.$1025.Metal1 vout4.P2.nSD 0.00117415f
Cred_3950 VDD.$1025.Metal1 vout4.P2.pSD 0.051178f
Cred_3951 VDD.$1025.Metal1 vout4.P4.pSD 0.0470776f
Cred_3952 VDD.$116.Metal1 vin1.$105.GatPoly 4.78618e-06f
Cred_3953 VDD.$116.Metal1 vin1.$107.GatPoly 3.22043e-06f
Cred_3954 VDD.$116.Metal1 vin1.$115.GatPoly 3.88898e-06f
Cred_3955 VDD.$116.Metal1 vin1.$123.GatPoly 3.07829e-06f
Cred_3956 VDD.$116.Metal1 vin1.$127.GatPoly 1.98881e-06f
Cred_3957 VDD.$116.Metal1 vin1.$135.GatPoly 1.73806e-06f
Cred_3958 VDD.$116.Metal1 vin1.$137.GatPoly 1.18098e-06f
Cred_3959 VDD.$116.Metal1 vin1.$145.GatPoly 1.35971e-06f
Cred_3960 VDD.$116.Metal1 vin1.$15.GatPoly 7.81108e-05f
Cred_3961 VDD.$116.Metal1 vin1.$153.GatPoly 1.10873e-06f
Cred_3962 VDD.$116.Metal1 vin1.$157.GatPoly 6.14114e-07f
Cred_3963 VDD.$116.Metal1 vin1.$163.GatPoly 6.10537e-07f
Cred_3964 VDD.$116.Metal1 vin1.$167.GatPoly 4.60498e-07f
Cred_3965 VDD.$116.Metal1 vin1.$17.GatPoly 0.000100649f
Cred_3966 VDD.$116.Metal1 vin1.$173.GatPoly 4.21591e-07f
Cred_3967 VDD.$116.Metal1 vin1.$179.GatPoly 5.89137e-07f
Cred_3968 VDD.$116.Metal1 vin1.$203.Metal1 0.00449232f
Cred_3969 VDD.$116.Metal1 vin1.$207.Metal1 0.000684341f
Cred_3970 VDD.$116.Metal1 vin1.$211.Metal1 0.000916582f
Cred_3971 VDD.$116.Metal1 vin1.$219.Metal1 0.00110526f
Cred_3972 VDD.$116.Metal1 vin1.$227.Metal1 0.0008856f
Cred_3973 VDD.$116.Metal1 vin1.$233.Metal1 0.000539082f
Cred_3974 VDD.$116.Metal1 vin1.$237.Metal1 0.000354792f
Cred_3975 VDD.$116.Metal1 vin1.$241.Metal1 0.000452768f
Cred_3976 VDD.$116.Metal1 vin1.$247.Metal1 0.000408653f
Cred_3977 VDD.$116.Metal1 vin1.$25.GatPoly 5.24185e-05f
Cred_3978 VDD.$116.Metal1 vin1.$251.Metal1 0.000355297f
Cred_3979 VDD.$116.Metal1 vin1.$259.Metal1 0.000320357f
Cred_3980 VDD.$116.Metal1 vin1.$263.Metal1 0.000191641f
Cred_3981 VDD.$116.Metal1 vin1.$265.Metal1 0.000253781f
Cred_3982 VDD.$116.Metal1 vin1.$27.GatPoly 7.32856e-05f
Cred_3983 VDD.$116.Metal1 vin1.$273.Metal1 0.000222176f
Cred_3984 VDD.$116.Metal1 vin1.$277.Metal1 0.000136326f
Cred_3985 VDD.$116.Metal1 vin1.$281.Metal1 0.000130267f
Cred_3986 VDD.$116.Metal1 vin1.$285.Metal1 0.00016193f
Cred_3987 VDD.$116.Metal1 vin1.$291.Metal1 0.000153754f
Cred_3988 VDD.$116.Metal1 vin1.$295.Metal1 0.00012767f
Cred_3989 VDD.$116.Metal1 vin1.$303.Metal1 0.000113588f
Cred_3990 VDD.$116.Metal1 vin1.$307.Metal1 0.000101961f
Cred_3991 VDD.$116.Metal1 vin1.$313.Metal1 8.8244e-05f
Cred_3992 VDD.$116.Metal1 vin1.$317.Metal1 5.23457e-05f
Cred_3993 VDD.$116.Metal1 vin1.$321.Metal1 5.0335e-05f
Cred_3994 VDD.$116.Metal1 vin1.$325.Metal1 6.36551e-05f
Cred_3995 VDD.$116.Metal1 vin1.$331.Metal1 5.69124e-05f
Cred_3996 VDD.$116.Metal1 vin1.$335.Metal1 3.43903e-05f
Cred_3997 VDD.$116.Metal1 vin1.$339.Metal1 3.26447e-05f
Cred_3998 VDD.$116.Metal1 vin1.$343.Metal1 2.88794e-05f
Cred_3999 VDD.$116.Metal1 vin1.$347.Metal1 3.88644e-05f
Cred_4000 VDD.$116.Metal1 vin1.$353.Metal1 3.57261e-05f
Cred_4001 VDD.$116.Metal1 vin1.$357.Metal1 2.98384e-05f
Cred_4002 VDD.$116.Metal1 vin1.$365.Metal1 2.66367e-05f
Cred_4003 VDD.$116.Metal1 vin1.$369.Metal1 2.4502e-05f
Cred_4004 VDD.$116.Metal1 vin1.$37.GatPoly 6.29334e-05f
Cred_4005 VDD.$116.Metal1 vin1.$375.Metal1 2.03027e-05f
Cred_4006 VDD.$116.Metal1 vin1.$379.Metal1 1.28688e-05f
Cred_4007 VDD.$116.Metal1 vin1.$383.Metal1 1.14268e-05f
Cred_4008 VDD.$116.Metal1 vin1.$387.Metal1 1.4997e-05f
Cred_4009 VDD.$116.Metal1 vin1.$393.Metal1 1.35838e-05f
Cred_4010 VDD.$116.Metal1 vin1.$397.Metal1 8.14582e-06f
Cred_4011 VDD.$116.Metal1 vin1.$401.Metal1 1.07827e-05f
Cred_4012 VDD.$116.Metal1 vin1.$409.Metal1 9.53833e-06f
Cred_4013 VDD.$116.Metal1 vin1.$413.Metal1 8.34687e-06f
Cred_4014 VDD.$116.Metal1 vin1.$419.Metal1 7.28259e-06f
Cred_4015 VDD.$116.Metal1 vin1.$423.Metal1 4.51491e-06f
Cred_4016 VDD.$116.Metal1 vin1.$427.Metal1 5.56781e-06f
Cred_4017 VDD.$116.Metal1 vin1.$43.GatPoly 4.661e-05f
Cred_4018 VDD.$116.Metal1 vin1.$433.Metal1 6.87998e-06f
Cred_4019 VDD.$116.Metal1 vin1.$441.Metal1 6.0837e-06f
Cred_4020 VDD.$116.Metal1 vin1.$449.Metal1 3.74752e-06f
Cred_4021 VDD.$116.Metal1 vin1.$453.Metal1 2.25307e-06f
Cred_4022 VDD.$116.Metal1 vin1.$457.Metal1 8.40318e-06f
Cred_4023 VDD.$116.Metal1 vin1.$47.GatPoly 2.78717e-05f
Cred_4024 VDD.$116.Metal1 vin1.$477.Metal2 0.00502497f
Cred_4025 VDD.$116.Metal1 vin1.$480.Metal2 0.00569759f
Cred_4026 VDD.$116.Metal1 vin1.$484.Metal2 0.000436769f
Cred_4027 VDD.$116.Metal1 vin1.$486.Metal2 0.00105784f
Cred_4028 VDD.$116.Metal1 vin1.$489.Metal2 0.000474085f
Cred_4029 VDD.$116.Metal1 vin1.$493.Metal2 0.000368504f
Cred_4030 VDD.$116.Metal1 vin1.$495.Metal2 0.000807797f
Cred_4031 VDD.$116.Metal1 vin1.$500.Metal2 0.000328691f
Cred_4032 VDD.$116.Metal1 vin1.$504.Metal2 0.000279431f
Cred_4033 VDD.$116.Metal1 vin1.$506.Metal2 0.000523434f
Cred_4034 VDD.$116.Metal1 vin1.$509.Metal2 0.000169712f
Cred_4035 VDD.$116.Metal1 vin1.$513.Metal2 0.000147723f
Cred_4036 VDD.$116.Metal1 vin1.$515.Metal2 0.000453279f
Cred_4037 VDD.$116.Metal1 vin1.$518.Metal2 0.000161374f
Cred_4038 VDD.$116.Metal1 vin1.$520.Metal2 7.00837e-05f
Cred_4039 VDD.$116.Metal1 vin1.$523.Metal2 3.67621e-05f
Cred_4040 VDD.$116.Metal1 vin1.$527.Metal2 0.000270985f
Cred_4041 VDD.$116.Metal1 vin1.$528.Metal2 1.39603e-06f
Cred_4042 VDD.$116.Metal1 vin1.$53.GatPoly 2.89328e-05f
Cred_4043 VDD.$116.Metal1 vin1.$533.Metal2 0.000108638f
Cred_4044 VDD.$116.Metal1 vin1.$535.Metal2 0.000268149f
Cred_4045 VDD.$116.Metal1 vin1.$538.Metal2 6.79435e-05f
Cred_4046 VDD.$116.Metal1 vin1.$542.Metal2 4.63792e-05f
Cred_4047 VDD.$116.Metal1 vin1.$544.Metal2 0.000123442f
Cred_4048 VDD.$116.Metal1 vin1.$547.Metal2 7.1803e-05f
Cred_4049 VDD.$116.Metal1 vin1.$551.Metal2 4.51304e-05f
Cred_4050 VDD.$116.Metal1 vin1.$555.Metal2 0.000100158f
Cred_4051 VDD.$116.Metal1 vin1.$558.Metal2 4.21121e-05f
Cred_4052 VDD.$116.Metal1 vin1.$562.Metal2 3.0082e-05f
Cred_4053 VDD.$116.Metal1 vin1.$564.Metal2 6.61997e-05f
Cred_4054 VDD.$116.Metal1 vin1.$567.Metal2 2.7149e-05f
Cred_4055 VDD.$116.Metal1 vin1.$57.GatPoly 2.25395e-05f
Cred_4056 VDD.$116.Metal1 vin1.$571.Metal2 2.44561e-05f
Cred_4057 VDD.$116.Metal1 vin1.$573.Metal2 5.09057e-05f
Cred_4058 VDD.$116.Metal1 vin1.$578.Metal2 1.98884e-05f
Cred_4059 VDD.$116.Metal1 vin1.$582.Metal2 1.87259e-05f
Cred_4060 VDD.$116.Metal1 vin1.$584.Metal2 3.08908e-05f
Cred_4061 VDD.$116.Metal1 vin1.$587.Metal2 9.90597e-06f
Cred_4062 VDD.$116.Metal1 vin1.$591.Metal2 9.1819e-06f
Cred_4063 VDD.$116.Metal1 vin1.$593.Metal2 2.83417e-05f
Cred_4064 VDD.$116.Metal1 vin1.$596.Metal2 1.17541e-05f
Cred_4065 VDD.$116.Metal1 vin1.$599.Metal2 8.73101e-08f
Cred_4066 VDD.$116.Metal1 vin1.$603.Metal2 1.6923e-05f
Cred_4067 VDD.$116.Metal1 vin1.$604.Metal2 2.29917e-06f
Cred_4068 VDD.$116.Metal1 vin1.$609.Metal2 3.06265e-06f
Cred_4069 VDD.$116.Metal1 vin1.$611.Metal2 4.93269e-06f
Cred_4070 VDD.$116.Metal1 vin1.$613.Metal2 1.66498e-05f
Cred_4071 VDD.$116.Metal1 vin1.$616.Metal2 3.95582e-06f
Cred_4072 VDD.$116.Metal1 vin1.$620.Metal2 2.97317e-06f
Cred_4073 VDD.$116.Metal1 vin1.$622.Metal2 8.16824e-06f
Cred_4074 VDD.$116.Metal1 vin1.$625.Metal2 4.02174e-06f
Cred_4075 VDD.$116.Metal1 vin1.$629.Metal2 2.95204e-06f
Cred_4076 VDD.$116.Metal1 vin1.$633.Metal2 6.27688e-06f
Cred_4077 VDD.$116.Metal1 vin1.$636.Metal2 2.51297e-06f
Cred_4078 VDD.$116.Metal1 vin1.$640.Metal2 1.97454e-06f
Cred_4079 VDD.$116.Metal1 vin1.$642.Metal2 5.23915e-06f
Cred_4080 VDD.$116.Metal1 vin1.$645.Metal2 1.49701e-06f
Cred_4081 VDD.$116.Metal1 vin1.$648.Metal2 7.44339e-08f
Cred_4082 VDD.$116.Metal1 vin1.$649.Metal2 1.14484e-06f
Cred_4083 VDD.$116.Metal1 vin1.$65.GatPoly 2.23396e-05f
Cred_4084 VDD.$116.Metal1 vin1.$653.Metal2 2.846e-07f
Cred_4085 VDD.$116.Metal1 vin1.$654.Metal2 2.43483e-06f
Cred_4086 VDD.$116.Metal1 vin1.$73.GatPoly 1.69877e-05f
Cred_4087 VDD.$116.Metal1 vin1.$77.GatPoly 9.60472e-06f
Cred_4088 VDD.$116.Metal1 vin1.$83.GatPoly 1.01608e-05f
Cred_4089 VDD.$116.Metal1 vin1.$87.GatPoly 6.6114e-06f
Cred_4090 VDD.$116.Metal1 vin1.$9.GatPoly 0.000254356f
Cred_4091 VDD.$116.Metal1 vin1.$93.GatPoly 8.05101e-06f
Cred_4092 VDD.$116.Metal1 vin1.$97.GatPoly 5.59618e-06f
Cred_4093 VDD.$116.Metal1 vin1.P20.GatPoly 0.000816756f
Cred_4094 VDD.$116.Metal1 vin1.P24.GatPoly 4.80575e-06f
Cred_4095 VDD.$116.Metal1 vin1.P27.GatPoly 1.6936e-06f
Cred_4096 VDD.$116.Metal1 vin1.P32.GatPoly 2.98815e-07f
Cred_4097 VDD.$116.Metal1 vin1.P35.GatPoly 1.07473e-07f
Cred_4098 VDD.$116.Metal1 vin1.P39.GatPoly 1.00704e-06f
Cred_4099 VDD.$116.Metal1 vin2.$104.GatPoly 5.039e-06f
Cred_4100 VDD.$116.Metal1 vin2.$106.GatPoly 3.39051e-06f
Cred_4101 VDD.$116.Metal1 vin2.$114.GatPoly 4.0943e-06f
Cred_4102 VDD.$116.Metal1 vin2.$122.GatPoly 3.24069e-06f
Cred_4103 VDD.$116.Metal1 vin2.$126.GatPoly 2.09364e-06f
Cred_4104 VDD.$116.Metal1 vin2.$134.GatPoly 1.82954e-06f
Cred_4105 VDD.$116.Metal1 vin2.$136.GatPoly 1.24304e-06f
Cred_4106 VDD.$116.Metal1 vin2.$14.GatPoly 8.2239e-05f
Cred_4107 VDD.$116.Metal1 vin2.$144.GatPoly 1.43098e-06f
Cred_4108 VDD.$116.Metal1 vin2.$152.GatPoly 1.16652e-06f
Cred_4109 VDD.$116.Metal1 vin2.$156.GatPoly 6.45901e-07f
Cred_4110 VDD.$116.Metal1 vin2.$16.GatPoly 0.000105969f
Cred_4111 VDD.$116.Metal1 vin2.$162.GatPoly 6.41868e-07f
Cred_4112 VDD.$116.Metal1 vin2.$166.GatPoly 4.83838e-07f
Cred_4113 VDD.$116.Metal1 vin2.$172.GatPoly 4.42586e-07f
Cred_4114 VDD.$116.Metal1 vin2.$178.GatPoly 6.1708e-07f
Cred_4115 VDD.$116.Metal1 vin2.$202.Metal1 0.00472767f
Cred_4116 VDD.$116.Metal1 vin2.$206.Metal1 0.000720509f
Cred_4117 VDD.$116.Metal1 vin2.$210.Metal1 0.000965024f
Cred_4118 VDD.$116.Metal1 vin2.$218.Metal1 0.00116367f
Cred_4119 VDD.$116.Metal1 vin2.$226.Metal1 0.000932404f
Cred_4120 VDD.$116.Metal1 vin2.$232.Metal1 0.000567573f
Cred_4121 VDD.$116.Metal1 vin2.$236.Metal1 0.000373543f
Cred_4122 VDD.$116.Metal1 vin2.$24.GatPoly 5.51888e-05f
Cred_4123 VDD.$116.Metal1 vin2.$240.Metal1 0.000476697f
Cred_4124 VDD.$116.Metal1 vin2.$246.Metal1 0.000430251f
Cred_4125 VDD.$116.Metal1 vin2.$250.Metal1 0.000374075f
Cred_4126 VDD.$116.Metal1 vin2.$258.Metal1 0.000337288f
Cred_4127 VDD.$116.Metal1 vin2.$26.GatPoly 7.71588e-05f
Cred_4128 VDD.$116.Metal1 vin2.$262.Metal1 0.000201769f
Cred_4129 VDD.$116.Metal1 vin2.$264.Metal1 0.000267194f
Cred_4130 VDD.$116.Metal1 vin2.$272.Metal1 0.000233918f
Cred_4131 VDD.$116.Metal1 vin2.$276.Metal1 0.000143531f
Cred_4132 VDD.$116.Metal1 vin2.$280.Metal1 0.000137151f
Cred_4133 VDD.$116.Metal1 vin2.$284.Metal1 0.000170488f
Cred_4134 VDD.$116.Metal1 vin2.$290.Metal1 0.00016188f
Cred_4135 VDD.$116.Metal1 vin2.$294.Metal1 0.000134417f
Cred_4136 VDD.$116.Metal1 vin2.$302.Metal1 0.000119591f
Cred_4137 VDD.$116.Metal1 vin2.$306.Metal1 0.000107349f
Cred_4138 VDD.$116.Metal1 vin2.$312.Metal1 9.29072e-05f
Cred_4139 VDD.$116.Metal1 vin2.$316.Metal1 5.51118e-05f
Cred_4140 VDD.$116.Metal1 vin2.$320.Metal1 5.29948e-05f
Cred_4141 VDD.$116.Metal1 vin2.$324.Metal1 6.70186e-05f
Cred_4142 VDD.$116.Metal1 vin2.$330.Metal1 5.99195e-05f
Cred_4143 VDD.$116.Metal1 vin2.$334.Metal1 3.62072e-05f
Cred_4144 VDD.$116.Metal1 vin2.$338.Metal1 3.43694e-05f
Cred_4145 VDD.$116.Metal1 vin2.$342.Metal1 3.0405e-05f
Cred_4146 VDD.$116.Metal1 vin2.$346.Metal1 4.09173e-05f
Cred_4147 VDD.$116.Metal1 vin2.$352.Metal1 3.76129e-05f
Cred_4148 VDD.$116.Metal1 vin2.$356.Metal1 3.1414e-05f
Cred_4149 VDD.$116.Metal1 vin2.$36.GatPoly 6.62595e-05f
Cred_4150 VDD.$116.Metal1 vin2.$364.Metal1 2.80428e-05f
Cred_4151 VDD.$116.Metal1 vin2.$368.Metal1 2.5795e-05f
Cred_4152 VDD.$116.Metal1 vin2.$374.Metal1 2.13737e-05f
Cred_4153 VDD.$116.Metal1 vin2.$378.Metal1 1.35473e-05f
Cred_4154 VDD.$116.Metal1 vin2.$382.Metal1 1.2029e-05f
Cred_4155 VDD.$116.Metal1 vin2.$386.Metal1 1.57868e-05f
Cred_4156 VDD.$116.Metal1 vin2.$392.Metal1 1.42985e-05f
Cred_4157 VDD.$116.Metal1 vin2.$396.Metal1 8.57389e-06f
Cred_4158 VDD.$116.Metal1 vin2.$400.Metal1 1.13485e-05f
Cred_4159 VDD.$116.Metal1 vin2.$408.Metal1 1.00379e-05f
Cred_4160 VDD.$116.Metal1 vin2.$412.Metal1 8.78279e-06f
Cred_4161 VDD.$116.Metal1 vin2.$418.Metal1 7.6617e-06f
Cred_4162 VDD.$116.Metal1 vin2.$42.GatPoly 4.90734e-05f
Cred_4163 VDD.$116.Metal1 vin2.$422.Metal1 4.749e-06f
Cred_4164 VDD.$116.Metal1 vin2.$426.Metal1 5.85519e-06f
Cred_4165 VDD.$116.Metal1 vin2.$432.Metal1 7.23228e-06f
Cred_4166 VDD.$116.Metal1 vin2.$44.GatPoly 2.93447e-05f
Cred_4167 VDD.$116.Metal1 vin2.$440.Metal1 6.39111e-06f
Cred_4168 VDD.$116.Metal1 vin2.$448.Metal1 3.93387e-06f
Cred_4169 VDD.$116.Metal1 vin2.$452.Metal1 2.3634e-06f
Cred_4170 VDD.$116.Metal1 vin2.$456.Metal1 8.79302e-06f
Cred_4171 VDD.$116.Metal1 vin2.$477.Metal2 0.00527255f
Cred_4172 VDD.$116.Metal1 vin2.$479.Metal2 0.00596517f
Cred_4173 VDD.$116.Metal1 vin2.$483.Metal2 0.000459853f
Cred_4174 VDD.$116.Metal1 vin2.$486.Metal2 0.00111375f
Cred_4175 VDD.$116.Metal1 vin2.$488.Metal2 0.000499141f
Cred_4176 VDD.$116.Metal1 vin2.$492.Metal2 0.000387979f
Cred_4177 VDD.$116.Metal1 vin2.$495.Metal2 0.000850489f
Cred_4178 VDD.$116.Metal1 vin2.$499.Metal2 0.000346062f
Cred_4179 VDD.$116.Metal1 vin2.$503.Metal2 0.000294199f
Cred_4180 VDD.$116.Metal1 vin2.$506.Metal2 0.000551098f
Cred_4181 VDD.$116.Metal1 vin2.$508.Metal2 0.000178682f
Cred_4182 VDD.$116.Metal1 vin2.$512.Metal2 0.00015553f
Cred_4183 VDD.$116.Metal1 vin2.$515.Metal2 0.000477235f
Cred_4184 VDD.$116.Metal1 vin2.$517.Metal2 0.000169903f
Cred_4185 VDD.$116.Metal1 vin2.$519.Metal2 7.37876e-05f
Cred_4186 VDD.$116.Metal1 vin2.$52.GatPoly 3.04619e-05f
Cred_4187 VDD.$116.Metal1 vin2.$524.Metal2 3.87049e-05f
Cred_4188 VDD.$116.Metal1 vin2.$525.Metal2 0.000285306f
Cred_4189 VDD.$116.Metal1 vin2.$529.Metal2 1.46981e-06f
Cred_4190 VDD.$116.Metal1 vin2.$532.Metal2 0.000114379f
Cred_4191 VDD.$116.Metal1 vin2.$535.Metal2 0.000282321f
Cred_4192 VDD.$116.Metal1 vin2.$537.Metal2 7.15342e-05f
Cred_4193 VDD.$116.Metal1 vin2.$541.Metal2 4.88303e-05f
Cred_4194 VDD.$116.Metal1 vin2.$544.Metal2 0.000129965f
Cred_4195 VDD.$116.Metal1 vin2.$546.Metal2 7.55976e-05f
Cred_4196 VDD.$116.Metal1 vin2.$550.Metal2 4.75153e-05f
Cred_4197 VDD.$116.Metal1 vin2.$555.Metal2 0.000105451f
Cred_4198 VDD.$116.Metal1 vin2.$557.Metal2 4.43375e-05f
Cred_4199 VDD.$116.Metal1 vin2.$56.GatPoly 2.37307e-05f
Cred_4200 VDD.$116.Metal1 vin2.$561.Metal2 3.16715e-05f
Cred_4201 VDD.$116.Metal1 vin2.$564.Metal2 6.96976e-05f
Cred_4202 VDD.$116.Metal1 vin2.$566.Metal2 2.85834e-05f
Cred_4203 VDD.$116.Metal1 vin2.$570.Metal2 2.5748e-05f
Cred_4204 VDD.$116.Metal1 vin2.$573.Metal2 5.35948e-05f
Cred_4205 VDD.$116.Metal1 vin2.$577.Metal2 2.09389e-05f
Cred_4206 VDD.$116.Metal1 vin2.$581.Metal2 1.97147e-05f
Cred_4207 VDD.$116.Metal1 vin2.$584.Metal2 3.25219e-05f
Cred_4208 VDD.$116.Metal1 vin2.$586.Metal2 1.04289e-05f
Cred_4209 VDD.$116.Metal1 vin2.$590.Metal2 9.66631e-06f
Cred_4210 VDD.$116.Metal1 vin2.$593.Metal2 2.98362e-05f
Cred_4211 VDD.$116.Metal1 vin2.$595.Metal2 1.23739e-05f
Cred_4212 VDD.$116.Metal1 vin2.$600.Metal2 9.19067e-08f
Cred_4213 VDD.$116.Metal1 vin2.$601.Metal2 1.78139e-05f
Cred_4214 VDD.$116.Metal1 vin2.$605.Metal2 2.42021e-06f
Cred_4215 VDD.$116.Metal1 vin2.$608.Metal2 3.22362e-06f
Cred_4216 VDD.$116.Metal1 vin2.$610.Metal2 5.19132e-06f
Cred_4217 VDD.$116.Metal1 vin2.$613.Metal2 1.75239e-05f
Cred_4218 VDD.$116.Metal1 vin2.$615.Metal2 4.163e-06f
Cred_4219 VDD.$116.Metal1 vin2.$619.Metal2 3.12814e-06f
Cred_4220 VDD.$116.Metal1 vin2.$622.Metal2 8.59324e-06f
Cred_4221 VDD.$116.Metal1 vin2.$624.Metal2 4.23072e-06f
Cred_4222 VDD.$116.Metal1 vin2.$628.Metal2 3.10386e-06f
Cred_4223 VDD.$116.Metal1 vin2.$633.Metal2 6.5983e-06f
Cred_4224 VDD.$116.Metal1 vin2.$635.Metal2 2.64108e-06f
Cred_4225 VDD.$116.Metal1 vin2.$639.Metal2 2.07284e-06f
Cred_4226 VDD.$116.Metal1 vin2.$64.GatPoly 2.35202e-05f
Cred_4227 VDD.$116.Metal1 vin2.$642.Metal2 5.5094e-06f
Cred_4228 VDD.$116.Metal1 vin2.$644.Metal2 1.57055e-06f
Cred_4229 VDD.$116.Metal1 vin2.$648.Metal2 1.20654e-06f
Cred_4230 VDD.$116.Metal1 vin2.$649.Metal2 6.61975e-08f
Cred_4231 VDD.$116.Metal1 vin2.$653.Metal2 2.57628e-06f
Cred_4232 VDD.$116.Metal1 vin2.$654.Metal2 2.53108e-07f
Cred_4233 VDD.$116.Metal1 vin2.$72.GatPoly 1.78855e-05f
Cred_4234 VDD.$116.Metal1 vin2.$76.GatPoly 1.01123e-05f
Cred_4235 VDD.$116.Metal1 vin2.$8.GatPoly 0.000267761f
Cred_4236 VDD.$116.Metal1 vin2.$82.GatPoly 1.06977e-05f
Cred_4237 VDD.$116.Metal1 vin2.$86.GatPoly 6.96077e-06f
Cred_4238 VDD.$116.Metal1 vin2.$92.GatPoly 8.47642e-06f
Cred_4239 VDD.$116.Metal1 vin2.$96.GatPoly 5.89184e-06f
Cred_4240 VDD.$116.Metal1 vin2.P20.GatPoly 0.000859893f
Cred_4241 VDD.$116.Metal1 vin2.P24.GatPoly 5.05974e-06f
Cred_4242 VDD.$116.Metal1 vin2.P27.GatPoly 1.7831e-06f
Cred_4243 VDD.$116.Metal1 vin2.P32.GatPoly 3.14586e-07f
Cred_4244 VDD.$116.Metal1 vin2.P35.GatPoly 1.13091e-07f
Cred_4245 VDD.$116.Metal1 vin2.P39.GatPoly 1.04987e-06f
Cred_4246 VDD.$116.Metal1 vout1 5.47583e-07f
Cred_4247 VDD.$116.Metal1 vout1.$1226.Metal3 0.00106633f
Cred_4248 VDD.$116.Metal1 vout1.$1292.Metal3 8.54714e-05f
Cred_4249 VDD.$116.Metal1 vout1.$1358.Metal3 2.29505e-05f
Cred_4250 VDD.$116.Metal1 vout1.$1424.Metal3 7.14263e-06f
Cred_4251 VDD.$116.Metal1 vout1.P0.nSD 2.27409e-05f
Cred_4252 VDD.$116.Metal1 vout1.P0.pSD 0.000145108f
Cred_4253 VDD.$116.Metal1 vout1.P10.nSD 1.5713e-07f
Cred_4254 VDD.$116.Metal1 vout1.P10.pSD 8.51027e-07f
Cred_4255 VDD.$116.Metal1 vout1.P14.nSD 3.93139e-08f
Cred_4256 VDD.$116.Metal1 vout1.P14.pSD 2.12927e-07f
Cred_4257 VDD.$116.Metal1 vout1.P18.nSD 3.47047e-08f
Cred_4258 VDD.$116.Metal1 vout1.P18.pSD 1.92897e-07f
Cred_4259 VDD.$116.Metal1 vout1.P2.nSD 1.37906e-05f
Cred_4260 VDD.$116.Metal1 vout1.P2.pSD 7.5369e-05f
Cred_4261 VDD.$116.Metal1 vout1.P6.nSD 5.78726e-07f
Cred_4262 VDD.$116.Metal1 vout1.P6.pSD 3.16287e-06f
Cred_4263 VDD.$116.Metal1 vout2 5.65907e-07f
Cred_4264 VDD.$116.Metal1 vout2.$1226.Metal3 0.00112269f
Cred_4265 VDD.$116.Metal1 vout2.$1292.Metal3 8.9988e-05f
Cred_4266 VDD.$116.Metal1 vout2.$1358.Metal3 2.41612e-05f
Cred_4267 VDD.$116.Metal1 vout2.$1424.Metal3 7.48548e-06f
Cred_4268 VDD.$116.Metal1 vout2.P0.nSD 2.39427e-05f
Cred_4269 VDD.$116.Metal1 vout2.P0.pSD 0.000152777f
Cred_4270 VDD.$116.Metal1 vout2.P10.nSD 1.6543e-07f
Cred_4271 VDD.$116.Metal1 vout2.P10.pSD 8.95983e-07f
Cred_4272 VDD.$116.Metal1 vout2.P14.nSD 4.13758e-08f
Cred_4273 VDD.$116.Metal1 vout2.P14.pSD 2.24094e-07f
Cred_4274 VDD.$116.Metal1 vout2.P18.nSD 3.60733e-08f
Cred_4275 VDD.$116.Metal1 vout2.P18.pSD 2.0058e-07f
Cred_4276 VDD.$116.Metal1 vout2.P2.nSD 1.45195e-05f
Cred_4277 VDD.$116.Metal1 vout2.P2.pSD 7.93523e-05f
Cred_4278 VDD.$116.Metal1 vout2.P6.nSD 6.09311e-07f
Cred_4279 VDD.$116.Metal1 vout2.P6.pSD 3.33003e-06f
Cred_4280 VDD.$116.Metal1 VSS.$157.Metal1 0.000206199f
Cred_4281 VDD.$116.Metal1 VSS.$158.Metal1 0.000216852f
Cred_4282 VDD.$116.Metal1 VSS.$1989.Metal1 1.90965e-06f
Cred_4283 VDD.$116.Metal1 VSS.$1990.Metal1 5.56177e-06f
Cred_4284 VDD.$116.Metal1 VSS.$2020.Metal1 4.93296e-06f
Cred_4285 VDD.$116.Metal1 VSS.$2021.Metal1 1.56761e-07f
Cred_4286 VDD.$116.Metal1 VSS.$2226.Metal2 4.92334e-06f
Cred_4287 VDD.$116.Metal1 VSS.$2228.Metal2 5.34514e-06f
Cred_4288 VDD.$116.Metal1 VSS.$29.Metal1 0.00195663f
Cred_4289 VDD.$116.Metal1 VSS.$4164.Metal2 3.10505e-08f
Cred_4290 VDD.$116.Metal1 VSS.$4227.Metal2 4.21554e-08f
Cred_4291 VDD.$116.Metal1 VSS.$68.Metal1 0.00149009f
Cred_4292 VDD.$116.Metal1 VSS.P1.pSD 0.00605845f
Cred_4293 VDD.$116.Metal1 VSS.P24.nSD 1.38257e-06f
Cred_4294 VDD.$116.Metal1 VSS.P25.nSD 1.38257e-06f
Cred_4295 VDD.$116.Metal1 VSS.P3.pSD 0.00693651f
Cred_4296 VDD.$116.Metal1 VSS.P45.nSD 1.0127e-09f
Cred_4297 VDD.$116.Metal1 VSS.P47.nSD 1.0127e-09f
Cred_4298 VDD.$116.Metal1 VSS.P72.nSD 1.49764e-06f
Cred_4299 VDD.$116.Metal1 VSS.P73.nSD 1.49764e-06f
Cred_4300 VDD.$116.Metal1 VSS.P93.nSD 1.0787e-09f
Cred_4301 VDD.$116.Metal1 VSS.P95.nSD 1.0787e-09f
Cred_4302 VDD.$117.Metal1 vin1.P20.GatPoly 0.0287869f
Cred_4303 VDD.$117.Metal1 vout1.$1226.Metal3 0.00432211f
Cred_4304 VDD.$117.Metal1 vout1.P0.nSD 0.000128699f
Cred_4305 VDD.$117.Metal1 vout1.P0.pSD 0.00600988f
Cred_4306 VDD.$117.Metal1 vout1.P2.nSD 6.80907e-05f
Cred_4307 VDD.$117.Metal1 vout1.P2.pSD 0.000372131f
Cred_4308 VDD.$118.Metal1 vin3.$105.GatPoly 4.78618e-06f
Cred_4309 VDD.$118.Metal1 vin3.$107.GatPoly 3.22043e-06f
Cred_4310 VDD.$118.Metal1 vin3.$115.GatPoly 3.88898e-06f
Cred_4311 VDD.$118.Metal1 vin3.$123.GatPoly 3.07829e-06f
Cred_4312 VDD.$118.Metal1 vin3.$127.GatPoly 1.98881e-06f
Cred_4313 VDD.$118.Metal1 vin3.$135.GatPoly 1.73806e-06f
Cred_4314 VDD.$118.Metal1 vin3.$137.GatPoly 1.18098e-06f
Cred_4315 VDD.$118.Metal1 vin3.$145.GatPoly 1.35971e-06f
Cred_4316 VDD.$118.Metal1 vin3.$15.GatPoly 7.81108e-05f
Cred_4317 VDD.$118.Metal1 vin3.$153.GatPoly 1.10873e-06f
Cred_4318 VDD.$118.Metal1 vin3.$157.GatPoly 6.14114e-07f
Cred_4319 VDD.$118.Metal1 vin3.$163.GatPoly 6.10537e-07f
Cred_4320 VDD.$118.Metal1 vin3.$167.GatPoly 4.60498e-07f
Cred_4321 VDD.$118.Metal1 vin3.$17.GatPoly 0.000100649f
Cred_4322 VDD.$118.Metal1 vin3.$173.GatPoly 4.21591e-07f
Cred_4323 VDD.$118.Metal1 vin3.$179.GatPoly 5.89137e-07f
Cred_4324 VDD.$118.Metal1 vin3.$203.Metal1 0.00449232f
Cred_4325 VDD.$118.Metal1 vin3.$207.Metal1 0.000684341f
Cred_4326 VDD.$118.Metal1 vin3.$211.Metal1 0.000916582f
Cred_4327 VDD.$118.Metal1 vin3.$219.Metal1 0.00110526f
Cred_4328 VDD.$118.Metal1 vin3.$227.Metal1 0.0008856f
Cred_4329 VDD.$118.Metal1 vin3.$233.Metal1 0.000539082f
Cred_4330 VDD.$118.Metal1 vin3.$237.Metal1 0.000354792f
Cred_4331 VDD.$118.Metal1 vin3.$241.Metal1 0.000452768f
Cred_4332 VDD.$118.Metal1 vin3.$247.Metal1 0.000408653f
Cred_4333 VDD.$118.Metal1 vin3.$25.GatPoly 5.24185e-05f
Cred_4334 VDD.$118.Metal1 vin3.$251.Metal1 0.000355297f
Cred_4335 VDD.$118.Metal1 vin3.$259.Metal1 0.000320357f
Cred_4336 VDD.$118.Metal1 vin3.$263.Metal1 0.000191641f
Cred_4337 VDD.$118.Metal1 vin3.$265.Metal1 0.000253781f
Cred_4338 VDD.$118.Metal1 vin3.$27.GatPoly 7.32856e-05f
Cred_4339 VDD.$118.Metal1 vin3.$273.Metal1 0.000222176f
Cred_4340 VDD.$118.Metal1 vin3.$277.Metal1 0.000136326f
Cred_4341 VDD.$118.Metal1 vin3.$281.Metal1 0.000130267f
Cred_4342 VDD.$118.Metal1 vin3.$285.Metal1 0.00016193f
Cred_4343 VDD.$118.Metal1 vin3.$291.Metal1 0.000153754f
Cred_4344 VDD.$118.Metal1 vin3.$295.Metal1 0.00012767f
Cred_4345 VDD.$118.Metal1 vin3.$303.Metal1 0.000113588f
Cred_4346 VDD.$118.Metal1 vin3.$307.Metal1 0.000101961f
Cred_4347 VDD.$118.Metal1 vin3.$313.Metal1 8.8244e-05f
Cred_4348 VDD.$118.Metal1 vin3.$317.Metal1 5.23457e-05f
Cred_4349 VDD.$118.Metal1 vin3.$321.Metal1 5.0335e-05f
Cred_4350 VDD.$118.Metal1 vin3.$325.Metal1 6.36551e-05f
Cred_4351 VDD.$118.Metal1 vin3.$331.Metal1 5.69124e-05f
Cred_4352 VDD.$118.Metal1 vin3.$335.Metal1 3.43903e-05f
Cred_4353 VDD.$118.Metal1 vin3.$339.Metal1 3.26447e-05f
Cred_4354 VDD.$118.Metal1 vin3.$343.Metal1 2.88794e-05f
Cred_4355 VDD.$118.Metal1 vin3.$347.Metal1 3.88644e-05f
Cred_4356 VDD.$118.Metal1 vin3.$353.Metal1 3.57261e-05f
Cred_4357 VDD.$118.Metal1 vin3.$357.Metal1 2.98384e-05f
Cred_4358 VDD.$118.Metal1 vin3.$365.Metal1 2.66367e-05f
Cred_4359 VDD.$118.Metal1 vin3.$369.Metal1 2.4502e-05f
Cred_4360 VDD.$118.Metal1 vin3.$37.GatPoly 6.29334e-05f
Cred_4361 VDD.$118.Metal1 vin3.$375.Metal1 2.03027e-05f
Cred_4362 VDD.$118.Metal1 vin3.$379.Metal1 1.28688e-05f
Cred_4363 VDD.$118.Metal1 vin3.$383.Metal1 1.14268e-05f
Cred_4364 VDD.$118.Metal1 vin3.$387.Metal1 1.4997e-05f
Cred_4365 VDD.$118.Metal1 vin3.$393.Metal1 1.35838e-05f
Cred_4366 VDD.$118.Metal1 vin3.$397.Metal1 8.14582e-06f
Cred_4367 VDD.$118.Metal1 vin3.$401.Metal1 1.07827e-05f
Cred_4368 VDD.$118.Metal1 vin3.$409.Metal1 9.53833e-06f
Cred_4369 VDD.$118.Metal1 vin3.$413.Metal1 8.34687e-06f
Cred_4370 VDD.$118.Metal1 vin3.$419.Metal1 7.28259e-06f
Cred_4371 VDD.$118.Metal1 vin3.$423.Metal1 4.51491e-06f
Cred_4372 VDD.$118.Metal1 vin3.$427.Metal1 5.56781e-06f
Cred_4373 VDD.$118.Metal1 vin3.$43.GatPoly 4.661e-05f
Cred_4374 VDD.$118.Metal1 vin3.$433.Metal1 6.87998e-06f
Cred_4375 VDD.$118.Metal1 vin3.$441.Metal1 6.0837e-06f
Cred_4376 VDD.$118.Metal1 vin3.$449.Metal1 3.74752e-06f
Cred_4377 VDD.$118.Metal1 vin3.$453.Metal1 2.25307e-06f
Cred_4378 VDD.$118.Metal1 vin3.$457.Metal1 8.40318e-06f
Cred_4379 VDD.$118.Metal1 vin3.$47.GatPoly 2.78717e-05f
Cred_4380 VDD.$118.Metal1 vin3.$477.Metal2 0.00502497f
Cred_4381 VDD.$118.Metal1 vin3.$480.Metal2 0.00569759f
Cred_4382 VDD.$118.Metal1 vin3.$484.Metal2 0.000436769f
Cred_4383 VDD.$118.Metal1 vin3.$486.Metal2 0.00105784f
Cred_4384 VDD.$118.Metal1 vin3.$489.Metal2 0.000474085f
Cred_4385 VDD.$118.Metal1 vin3.$493.Metal2 0.000368504f
Cred_4386 VDD.$118.Metal1 vin3.$495.Metal2 0.000807797f
Cred_4387 VDD.$118.Metal1 vin3.$500.Metal2 0.000328691f
Cred_4388 VDD.$118.Metal1 vin3.$504.Metal2 0.000279431f
Cred_4389 VDD.$118.Metal1 vin3.$506.Metal2 0.000523434f
Cred_4390 VDD.$118.Metal1 vin3.$509.Metal2 0.000169712f
Cred_4391 VDD.$118.Metal1 vin3.$513.Metal2 0.000147723f
Cred_4392 VDD.$118.Metal1 vin3.$515.Metal2 0.000453279f
Cred_4393 VDD.$118.Metal1 vin3.$518.Metal2 0.000161374f
Cred_4394 VDD.$118.Metal1 vin3.$520.Metal2 7.00837e-05f
Cred_4395 VDD.$118.Metal1 vin3.$523.Metal2 3.67621e-05f
Cred_4396 VDD.$118.Metal1 vin3.$527.Metal2 0.000270985f
Cred_4397 VDD.$118.Metal1 vin3.$528.Metal2 1.39603e-06f
Cred_4398 VDD.$118.Metal1 vin3.$53.GatPoly 2.89328e-05f
Cred_4399 VDD.$118.Metal1 vin3.$533.Metal2 0.000108638f
Cred_4400 VDD.$118.Metal1 vin3.$535.Metal2 0.000268149f
Cred_4401 VDD.$118.Metal1 vin3.$538.Metal2 6.79435e-05f
Cred_4402 VDD.$118.Metal1 vin3.$542.Metal2 4.63792e-05f
Cred_4403 VDD.$118.Metal1 vin3.$544.Metal2 0.000123442f
Cred_4404 VDD.$118.Metal1 vin3.$547.Metal2 7.1803e-05f
Cred_4405 VDD.$118.Metal1 vin3.$551.Metal2 4.51304e-05f
Cred_4406 VDD.$118.Metal1 vin3.$555.Metal2 0.000100158f
Cred_4407 VDD.$118.Metal1 vin3.$558.Metal2 4.21121e-05f
Cred_4408 VDD.$118.Metal1 vin3.$562.Metal2 3.0082e-05f
Cred_4409 VDD.$118.Metal1 vin3.$564.Metal2 6.61997e-05f
Cred_4410 VDD.$118.Metal1 vin3.$567.Metal2 2.7149e-05f
Cred_4411 VDD.$118.Metal1 vin3.$57.GatPoly 2.25395e-05f
Cred_4412 VDD.$118.Metal1 vin3.$571.Metal2 2.44561e-05f
Cred_4413 VDD.$118.Metal1 vin3.$573.Metal2 5.09057e-05f
Cred_4414 VDD.$118.Metal1 vin3.$578.Metal2 1.98884e-05f
Cred_4415 VDD.$118.Metal1 vin3.$582.Metal2 1.87259e-05f
Cred_4416 VDD.$118.Metal1 vin3.$584.Metal2 3.08908e-05f
Cred_4417 VDD.$118.Metal1 vin3.$587.Metal2 9.90597e-06f
Cred_4418 VDD.$118.Metal1 vin3.$591.Metal2 9.1819e-06f
Cred_4419 VDD.$118.Metal1 vin3.$593.Metal2 2.83417e-05f
Cred_4420 VDD.$118.Metal1 vin3.$596.Metal2 1.17541e-05f
Cred_4421 VDD.$118.Metal1 vin3.$599.Metal2 8.73101e-08f
Cred_4422 VDD.$118.Metal1 vin3.$603.Metal2 1.6923e-05f
Cred_4423 VDD.$118.Metal1 vin3.$604.Metal2 2.29917e-06f
Cred_4424 VDD.$118.Metal1 vin3.$609.Metal2 3.06265e-06f
Cred_4425 VDD.$118.Metal1 vin3.$611.Metal2 4.93269e-06f
Cred_4426 VDD.$118.Metal1 vin3.$613.Metal2 1.66498e-05f
Cred_4427 VDD.$118.Metal1 vin3.$616.Metal2 3.95582e-06f
Cred_4428 VDD.$118.Metal1 vin3.$620.Metal2 2.97317e-06f
Cred_4429 VDD.$118.Metal1 vin3.$622.Metal2 8.16824e-06f
Cred_4430 VDD.$118.Metal1 vin3.$625.Metal2 4.02174e-06f
Cred_4431 VDD.$118.Metal1 vin3.$629.Metal2 2.95204e-06f
Cred_4432 VDD.$118.Metal1 vin3.$633.Metal2 6.27688e-06f
Cred_4433 VDD.$118.Metal1 vin3.$636.Metal2 2.51297e-06f
Cred_4434 VDD.$118.Metal1 vin3.$640.Metal2 1.97454e-06f
Cred_4435 VDD.$118.Metal1 vin3.$642.Metal2 5.23915e-06f
Cred_4436 VDD.$118.Metal1 vin3.$645.Metal2 1.49701e-06f
Cred_4437 VDD.$118.Metal1 vin3.$648.Metal2 7.44339e-08f
Cred_4438 VDD.$118.Metal1 vin3.$649.Metal2 1.14484e-06f
Cred_4439 VDD.$118.Metal1 vin3.$65.GatPoly 2.23396e-05f
Cred_4440 VDD.$118.Metal1 vin3.$653.Metal2 2.846e-07f
Cred_4441 VDD.$118.Metal1 vin3.$654.Metal2 2.43483e-06f
Cred_4442 VDD.$118.Metal1 vin3.$73.GatPoly 1.69877e-05f
Cred_4443 VDD.$118.Metal1 vin3.$77.GatPoly 9.60472e-06f
Cred_4444 VDD.$118.Metal1 vin3.$83.GatPoly 1.01608e-05f
Cred_4445 VDD.$118.Metal1 vin3.$87.GatPoly 6.6114e-06f
Cred_4446 VDD.$118.Metal1 vin3.$9.GatPoly 0.000254356f
Cred_4447 VDD.$118.Metal1 vin3.$93.GatPoly 8.05101e-06f
Cred_4448 VDD.$118.Metal1 vin3.$97.GatPoly 5.59618e-06f
Cred_4449 VDD.$118.Metal1 vin3.P20.GatPoly 0.000816756f
Cred_4450 VDD.$118.Metal1 vin3.P24.GatPoly 4.80575e-06f
Cred_4451 VDD.$118.Metal1 vin3.P27.GatPoly 1.6936e-06f
Cred_4452 VDD.$118.Metal1 vin3.P32.GatPoly 2.98815e-07f
Cred_4453 VDD.$118.Metal1 vin3.P35.GatPoly 1.07473e-07f
Cred_4454 VDD.$118.Metal1 vin3.P39.GatPoly 1.00704e-06f
Cred_4455 VDD.$118.Metal1 vin4.$104.GatPoly 5.039e-06f
Cred_4456 VDD.$118.Metal1 vin4.$106.GatPoly 3.39051e-06f
Cred_4457 VDD.$118.Metal1 vin4.$114.GatPoly 4.0943e-06f
Cred_4458 VDD.$118.Metal1 vin4.$122.GatPoly 3.24069e-06f
Cred_4459 VDD.$118.Metal1 vin4.$126.GatPoly 2.09364e-06f
Cred_4460 VDD.$118.Metal1 vin4.$134.GatPoly 1.82954e-06f
Cred_4461 VDD.$118.Metal1 vin4.$136.GatPoly 1.24304e-06f
Cred_4462 VDD.$118.Metal1 vin4.$14.GatPoly 8.2239e-05f
Cred_4463 VDD.$118.Metal1 vin4.$144.GatPoly 1.43098e-06f
Cred_4464 VDD.$118.Metal1 vin4.$152.GatPoly 1.16652e-06f
Cred_4465 VDD.$118.Metal1 vin4.$156.GatPoly 6.45901e-07f
Cred_4466 VDD.$118.Metal1 vin4.$16.GatPoly 0.000105969f
Cred_4467 VDD.$118.Metal1 vin4.$162.GatPoly 6.41868e-07f
Cred_4468 VDD.$118.Metal1 vin4.$166.GatPoly 4.83838e-07f
Cred_4469 VDD.$118.Metal1 vin4.$172.GatPoly 4.42586e-07f
Cred_4470 VDD.$118.Metal1 vin4.$178.GatPoly 6.1708e-07f
Cred_4471 VDD.$118.Metal1 vin4.$202.Metal1 0.00472767f
Cred_4472 VDD.$118.Metal1 vin4.$206.Metal1 0.000720509f
Cred_4473 VDD.$118.Metal1 vin4.$210.Metal1 0.000965024f
Cred_4474 VDD.$118.Metal1 vin4.$218.Metal1 0.00116367f
Cred_4475 VDD.$118.Metal1 vin4.$226.Metal1 0.000932404f
Cred_4476 VDD.$118.Metal1 vin4.$232.Metal1 0.000567573f
Cred_4477 VDD.$118.Metal1 vin4.$236.Metal1 0.000373543f
Cred_4478 VDD.$118.Metal1 vin4.$24.GatPoly 5.51888e-05f
Cred_4479 VDD.$118.Metal1 vin4.$240.Metal1 0.000476697f
Cred_4480 VDD.$118.Metal1 vin4.$246.Metal1 0.000430251f
Cred_4481 VDD.$118.Metal1 vin4.$250.Metal1 0.000374075f
Cred_4482 VDD.$118.Metal1 vin4.$258.Metal1 0.000337288f
Cred_4483 VDD.$118.Metal1 vin4.$26.GatPoly 7.71588e-05f
Cred_4484 VDD.$118.Metal1 vin4.$262.Metal1 0.000201769f
Cred_4485 VDD.$118.Metal1 vin4.$264.Metal1 0.000267194f
Cred_4486 VDD.$118.Metal1 vin4.$272.Metal1 0.000233918f
Cred_4487 VDD.$118.Metal1 vin4.$276.Metal1 0.000143531f
Cred_4488 VDD.$118.Metal1 vin4.$280.Metal1 0.000137151f
Cred_4489 VDD.$118.Metal1 vin4.$284.Metal1 0.000170488f
Cred_4490 VDD.$118.Metal1 vin4.$290.Metal1 0.00016188f
Cred_4491 VDD.$118.Metal1 vin4.$294.Metal1 0.000134417f
Cred_4492 VDD.$118.Metal1 vin4.$302.Metal1 0.000119591f
Cred_4493 VDD.$118.Metal1 vin4.$306.Metal1 0.000107349f
Cred_4494 VDD.$118.Metal1 vin4.$312.Metal1 9.29072e-05f
Cred_4495 VDD.$118.Metal1 vin4.$316.Metal1 5.51118e-05f
Cred_4496 VDD.$118.Metal1 vin4.$320.Metal1 5.29948e-05f
Cred_4497 VDD.$118.Metal1 vin4.$324.Metal1 6.70186e-05f
Cred_4498 VDD.$118.Metal1 vin4.$330.Metal1 5.99195e-05f
Cred_4499 VDD.$118.Metal1 vin4.$334.Metal1 3.62072e-05f
Cred_4500 VDD.$118.Metal1 vin4.$338.Metal1 3.43694e-05f
Cred_4501 VDD.$118.Metal1 vin4.$342.Metal1 3.0405e-05f
Cred_4502 VDD.$118.Metal1 vin4.$346.Metal1 4.09173e-05f
Cred_4503 VDD.$118.Metal1 vin4.$352.Metal1 3.76129e-05f
Cred_4504 VDD.$118.Metal1 vin4.$356.Metal1 3.1414e-05f
Cred_4505 VDD.$118.Metal1 vin4.$36.GatPoly 6.62595e-05f
Cred_4506 VDD.$118.Metal1 vin4.$364.Metal1 2.80428e-05f
Cred_4507 VDD.$118.Metal1 vin4.$368.Metal1 2.5795e-05f
Cred_4508 VDD.$118.Metal1 vin4.$374.Metal1 2.13737e-05f
Cred_4509 VDD.$118.Metal1 vin4.$378.Metal1 1.35473e-05f
Cred_4510 VDD.$118.Metal1 vin4.$382.Metal1 1.2029e-05f
Cred_4511 VDD.$118.Metal1 vin4.$386.Metal1 1.57868e-05f
Cred_4512 VDD.$118.Metal1 vin4.$392.Metal1 1.42985e-05f
Cred_4513 VDD.$118.Metal1 vin4.$396.Metal1 8.57389e-06f
Cred_4514 VDD.$118.Metal1 vin4.$400.Metal1 1.13485e-05f
Cred_4515 VDD.$118.Metal1 vin4.$408.Metal1 1.00379e-05f
Cred_4516 VDD.$118.Metal1 vin4.$412.Metal1 8.78279e-06f
Cred_4517 VDD.$118.Metal1 vin4.$418.Metal1 7.6617e-06f
Cred_4518 VDD.$118.Metal1 vin4.$42.GatPoly 4.90734e-05f
Cred_4519 VDD.$118.Metal1 vin4.$422.Metal1 4.749e-06f
Cred_4520 VDD.$118.Metal1 vin4.$426.Metal1 5.85519e-06f
Cred_4521 VDD.$118.Metal1 vin4.$432.Metal1 7.23228e-06f
Cred_4522 VDD.$118.Metal1 vin4.$44.GatPoly 2.93447e-05f
Cred_4523 VDD.$118.Metal1 vin4.$440.Metal1 6.39111e-06f
Cred_4524 VDD.$118.Metal1 vin4.$448.Metal1 3.93387e-06f
Cred_4525 VDD.$118.Metal1 vin4.$452.Metal1 2.3634e-06f
Cred_4526 VDD.$118.Metal1 vin4.$456.Metal1 8.79302e-06f
Cred_4527 VDD.$118.Metal1 vin4.$477.Metal2 0.00527255f
Cred_4528 VDD.$118.Metal1 vin4.$479.Metal2 0.00596517f
Cred_4529 VDD.$118.Metal1 vin4.$483.Metal2 0.000459853f
Cred_4530 VDD.$118.Metal1 vin4.$486.Metal2 0.00111375f
Cred_4531 VDD.$118.Metal1 vin4.$488.Metal2 0.000499141f
Cred_4532 VDD.$118.Metal1 vin4.$492.Metal2 0.000387979f
Cred_4533 VDD.$118.Metal1 vin4.$495.Metal2 0.000850489f
Cred_4534 VDD.$118.Metal1 vin4.$499.Metal2 0.000346062f
Cred_4535 VDD.$118.Metal1 vin4.$503.Metal2 0.000294199f
Cred_4536 VDD.$118.Metal1 vin4.$506.Metal2 0.000551098f
Cred_4537 VDD.$118.Metal1 vin4.$508.Metal2 0.000178682f
Cred_4538 VDD.$118.Metal1 vin4.$512.Metal2 0.00015553f
Cred_4539 VDD.$118.Metal1 vin4.$515.Metal2 0.000477235f
Cred_4540 VDD.$118.Metal1 vin4.$517.Metal2 0.000169903f
Cred_4541 VDD.$118.Metal1 vin4.$519.Metal2 7.37876e-05f
Cred_4542 VDD.$118.Metal1 vin4.$52.GatPoly 3.04619e-05f
Cred_4543 VDD.$118.Metal1 vin4.$524.Metal2 3.87049e-05f
Cred_4544 VDD.$118.Metal1 vin4.$525.Metal2 0.000285306f
Cred_4545 VDD.$118.Metal1 vin4.$529.Metal2 1.46981e-06f
Cred_4546 VDD.$118.Metal1 vin4.$532.Metal2 0.000114379f
Cred_4547 VDD.$118.Metal1 vin4.$535.Metal2 0.000282321f
Cred_4548 VDD.$118.Metal1 vin4.$537.Metal2 7.15342e-05f
Cred_4549 VDD.$118.Metal1 vin4.$541.Metal2 4.88303e-05f
Cred_4550 VDD.$118.Metal1 vin4.$544.Metal2 0.000129965f
Cred_4551 VDD.$118.Metal1 vin4.$546.Metal2 7.55976e-05f
Cred_4552 VDD.$118.Metal1 vin4.$550.Metal2 4.75153e-05f
Cred_4553 VDD.$118.Metal1 vin4.$555.Metal2 0.000105451f
Cred_4554 VDD.$118.Metal1 vin4.$557.Metal2 4.43375e-05f
Cred_4555 VDD.$118.Metal1 vin4.$56.GatPoly 2.37307e-05f
Cred_4556 VDD.$118.Metal1 vin4.$561.Metal2 3.16715e-05f
Cred_4557 VDD.$118.Metal1 vin4.$564.Metal2 6.96976e-05f
Cred_4558 VDD.$118.Metal1 vin4.$566.Metal2 2.85834e-05f
Cred_4559 VDD.$118.Metal1 vin4.$570.Metal2 2.5748e-05f
Cred_4560 VDD.$118.Metal1 vin4.$573.Metal2 5.35948e-05f
Cred_4561 VDD.$118.Metal1 vin4.$577.Metal2 2.09389e-05f
Cred_4562 VDD.$118.Metal1 vin4.$581.Metal2 1.97147e-05f
Cred_4563 VDD.$118.Metal1 vin4.$584.Metal2 3.25219e-05f
Cred_4564 VDD.$118.Metal1 vin4.$586.Metal2 1.04289e-05f
Cred_4565 VDD.$118.Metal1 vin4.$590.Metal2 9.66631e-06f
Cred_4566 VDD.$118.Metal1 vin4.$593.Metal2 2.98362e-05f
Cred_4567 VDD.$118.Metal1 vin4.$595.Metal2 1.23739e-05f
Cred_4568 VDD.$118.Metal1 vin4.$600.Metal2 9.19067e-08f
Cred_4569 VDD.$118.Metal1 vin4.$601.Metal2 1.78139e-05f
Cred_4570 VDD.$118.Metal1 vin4.$605.Metal2 2.42021e-06f
Cred_4571 VDD.$118.Metal1 vin4.$608.Metal2 3.22362e-06f
Cred_4572 VDD.$118.Metal1 vin4.$610.Metal2 5.19132e-06f
Cred_4573 VDD.$118.Metal1 vin4.$613.Metal2 1.75239e-05f
Cred_4574 VDD.$118.Metal1 vin4.$615.Metal2 4.163e-06f
Cred_4575 VDD.$118.Metal1 vin4.$619.Metal2 3.12814e-06f
Cred_4576 VDD.$118.Metal1 vin4.$622.Metal2 8.59324e-06f
Cred_4577 VDD.$118.Metal1 vin4.$624.Metal2 4.23072e-06f
Cred_4578 VDD.$118.Metal1 vin4.$628.Metal2 3.10386e-06f
Cred_4579 VDD.$118.Metal1 vin4.$633.Metal2 6.5983e-06f
Cred_4580 VDD.$118.Metal1 vin4.$635.Metal2 2.64108e-06f
Cred_4581 VDD.$118.Metal1 vin4.$639.Metal2 2.07284e-06f
Cred_4582 VDD.$118.Metal1 vin4.$64.GatPoly 2.35202e-05f
Cred_4583 VDD.$118.Metal1 vin4.$642.Metal2 5.5094e-06f
Cred_4584 VDD.$118.Metal1 vin4.$644.Metal2 1.57055e-06f
Cred_4585 VDD.$118.Metal1 vin4.$648.Metal2 1.20654e-06f
Cred_4586 VDD.$118.Metal1 vin4.$649.Metal2 6.61975e-08f
Cred_4587 VDD.$118.Metal1 vin4.$653.Metal2 2.57628e-06f
Cred_4588 VDD.$118.Metal1 vin4.$654.Metal2 2.53108e-07f
Cred_4589 VDD.$118.Metal1 vin4.$72.GatPoly 1.78855e-05f
Cred_4590 VDD.$118.Metal1 vin4.$76.GatPoly 1.01123e-05f
Cred_4591 VDD.$118.Metal1 vin4.$8.GatPoly 0.000267761f
Cred_4592 VDD.$118.Metal1 vin4.$82.GatPoly 1.06977e-05f
Cred_4593 VDD.$118.Metal1 vin4.$86.GatPoly 6.96077e-06f
Cred_4594 VDD.$118.Metal1 vin4.$92.GatPoly 8.47642e-06f
Cred_4595 VDD.$118.Metal1 vin4.$96.GatPoly 5.89184e-06f
Cred_4596 VDD.$118.Metal1 vin4.P20.GatPoly 0.000859893f
Cred_4597 VDD.$118.Metal1 vin4.P24.GatPoly 5.05974e-06f
Cred_4598 VDD.$118.Metal1 vin4.P27.GatPoly 1.7831e-06f
Cred_4599 VDD.$118.Metal1 vin4.P32.GatPoly 3.14586e-07f
Cred_4600 VDD.$118.Metal1 vin4.P35.GatPoly 1.13091e-07f
Cred_4601 VDD.$118.Metal1 vin4.P39.GatPoly 1.04987e-06f
Cred_4602 VDD.$118.Metal1 vout3 5.47583e-07f
Cred_4603 VDD.$118.Metal1 vout3.$1226.Metal3 0.00106633f
Cred_4604 VDD.$118.Metal1 vout3.$1292.Metal3 8.54714e-05f
Cred_4605 VDD.$118.Metal1 vout3.$1358.Metal3 2.29505e-05f
Cred_4606 VDD.$118.Metal1 vout3.$1424.Metal3 7.14263e-06f
Cred_4607 VDD.$118.Metal1 vout3.P0.nSD 2.27409e-05f
Cred_4608 VDD.$118.Metal1 vout3.P0.pSD 0.000145108f
Cred_4609 VDD.$118.Metal1 vout3.P10.nSD 1.5713e-07f
Cred_4610 VDD.$118.Metal1 vout3.P10.pSD 8.51027e-07f
Cred_4611 VDD.$118.Metal1 vout3.P14.nSD 3.93139e-08f
Cred_4612 VDD.$118.Metal1 vout3.P14.pSD 2.12927e-07f
Cred_4613 VDD.$118.Metal1 vout3.P18.nSD 3.47047e-08f
Cred_4614 VDD.$118.Metal1 vout3.P18.pSD 1.92897e-07f
Cred_4615 VDD.$118.Metal1 vout3.P2.nSD 1.37906e-05f
Cred_4616 VDD.$118.Metal1 vout3.P2.pSD 7.5369e-05f
Cred_4617 VDD.$118.Metal1 vout3.P6.nSD 5.78726e-07f
Cred_4618 VDD.$118.Metal1 vout3.P6.pSD 3.16287e-06f
Cred_4619 VDD.$118.Metal1 vout4 5.65907e-07f
Cred_4620 VDD.$118.Metal1 vout4.$1226.Metal3 0.00112269f
Cred_4621 VDD.$118.Metal1 vout4.$1292.Metal3 8.9988e-05f
Cred_4622 VDD.$118.Metal1 vout4.$1358.Metal3 2.41612e-05f
Cred_4623 VDD.$118.Metal1 vout4.$1424.Metal3 7.48548e-06f
Cred_4624 VDD.$118.Metal1 vout4.P0.nSD 2.39427e-05f
Cred_4625 VDD.$118.Metal1 vout4.P0.pSD 0.000152777f
Cred_4626 VDD.$118.Metal1 vout4.P10.nSD 1.6543e-07f
Cred_4627 VDD.$118.Metal1 vout4.P10.pSD 8.95983e-07f
Cred_4628 VDD.$118.Metal1 vout4.P14.nSD 4.13758e-08f
Cred_4629 VDD.$118.Metal1 vout4.P14.pSD 2.24094e-07f
Cred_4630 VDD.$118.Metal1 vout4.P18.nSD 3.60733e-08f
Cred_4631 VDD.$118.Metal1 vout4.P18.pSD 2.0058e-07f
Cred_4632 VDD.$118.Metal1 vout4.P2.nSD 1.45195e-05f
Cred_4633 VDD.$118.Metal1 vout4.P2.pSD 7.93523e-05f
Cred_4634 VDD.$118.Metal1 vout4.P6.nSD 6.09311e-07f
Cred_4635 VDD.$118.Metal1 vout4.P6.pSD 3.33003e-06f
Cred_4636 VDD.$118.Metal1 VSS.$159.Metal1 0.000205966f
Cred_4637 VDD.$118.Metal1 VSS.$160.Metal1 0.000217097f
Cred_4638 VDD.$118.Metal1 VSS.$1990.Metal1 5.29983e-06f
Cred_4639 VDD.$118.Metal1 VSS.$1991.Metal1 2.00402e-06f
Cred_4640 VDD.$118.Metal1 VSS.$2022.Metal1 1.51388e-07f
Cred_4641 VDD.$118.Metal1 VSS.$2023.Metal1 5.17464e-06f
Cred_4642 VDD.$118.Metal1 VSS.$2238.Metal2 5.07683e-06f
Cred_4643 VDD.$118.Metal1 VSS.$2240.Metal2 5.18354e-06f
Cred_4644 VDD.$118.Metal1 VSS.$4174.Metal2 2.95034e-08f
Cred_4645 VDD.$118.Metal1 VSS.$4241.Metal2 4.43291e-08f
Cred_4646 VDD.$118.Metal1 VSS.$66.Metal1 0.00205463f
Cred_4647 VDD.$118.Metal1 VSS.$68.Metal1 0.00141902f
Cred_4648 VDD.$118.Metal1 VSS.P0.nSD 1.45564e-06f
Cred_4649 VDD.$118.Metal1 VSS.P0.pSD 0.0063705f
Cred_4650 VDD.$118.Metal1 VSS.P1.nSD 1.45564e-06f
Cred_4651 VDD.$118.Metal1 VSS.P2.pSD 0.00659747f
Cred_4652 VDD.$118.Metal1 VSS.P21.nSD 1.04857e-09f
Cred_4653 VDD.$118.Metal1 VSS.P23.nSD 1.04857e-09f
Cred_4654 VDD.$118.Metal1 VSS.P48.nSD 1.42246e-06f
Cred_4655 VDD.$118.Metal1 VSS.P49.nSD 1.42246e-06f
Cred_4656 VDD.$118.Metal1 VSS.P69.nSD 1.0418e-09f
Cred_4657 VDD.$118.Metal1 VSS.P71.nSD 1.0418e-09f
Cred_4658 VDD.$119.Metal1 vin3.P20.GatPoly 0.0287869f
Cred_4659 VDD.$119.Metal1 vout3.$1226.Metal3 0.00432211f
Cred_4660 VDD.$119.Metal1 vout3.P0.nSD 0.000128699f
Cred_4661 VDD.$119.Metal1 vout3.P0.pSD 0.00600988f
Cred_4662 VDD.$119.Metal1 vout3.P2.nSD 6.80907e-05f
Cred_4663 VDD.$119.Metal1 vout3.P2.pSD 0.000372131f
Cred_4664 VDD.$1247.Metal1 vin1.$247.Metal1 2.44106e-08f
Cred_4665 VDD.$1247.Metal1 vin1.$251.Metal1 5.76979e-09f
Cred_4666 VDD.$1247.Metal1 vin1.$509.Metal2 1.5858e-06f
Cred_4667 VDD.$1247.Metal1 vin1.$513.Metal2 1.5858e-06f
Cred_4668 VDD.$1247.Metal1 vin1.P24.GatPoly 0.0143229f
Cred_4669 VDD.$1247.Metal1 vin2.$246.Metal1 2.44106e-08f
Cred_4670 VDD.$1247.Metal1 vin2.$250.Metal1 5.76979e-09f
Cred_4671 VDD.$1247.Metal1 vin2.$508.Metal2 1.5858e-06f
Cred_4672 VDD.$1247.Metal1 vin2.$512.Metal2 1.5858e-06f
Cred_4673 VDD.$1247.Metal1 vin2.P24.GatPoly 0.0143229f
Cred_4674 VDD.$1251.Metal1 vin3.$247.Metal1 2.44106e-08f
Cred_4675 VDD.$1251.Metal1 vin3.$251.Metal1 5.76979e-09f
Cred_4676 VDD.$1251.Metal1 vin3.$509.Metal2 1.5858e-06f
Cred_4677 VDD.$1251.Metal1 vin3.$513.Metal2 1.5858e-06f
Cred_4678 VDD.$1251.Metal1 vin3.P24.GatPoly 0.0143229f
Cred_4679 VDD.$1251.Metal1 vin4.$246.Metal1 2.44106e-08f
Cred_4680 VDD.$1251.Metal1 vin4.$250.Metal1 5.76979e-09f
Cred_4681 VDD.$1251.Metal1 vin4.$508.Metal2 1.5858e-06f
Cred_4682 VDD.$1251.Metal1 vin4.$512.Metal2 1.5858e-06f
Cred_4683 VDD.$1251.Metal1 vin4.P24.GatPoly 0.0143229f
Cred_4684 VDD.$1267.Metal1 vin1.$247.Metal1 1.09069e-08f
Cred_4685 VDD.$1267.Metal1 vin1.$251.Metal1 2.57799e-09f
Cred_4686 VDD.$1267.Metal1 vin1.$509.Metal2 7.08547e-07f
Cred_4687 VDD.$1267.Metal1 vin1.$513.Metal2 7.08547e-07f
Cred_4688 VDD.$1267.Metal1 vin1.P24.GatPoly 0.0114333f
Cred_4689 VDD.$1267.Metal1 vin2.$246.Metal1 1.09069e-08f
Cred_4690 VDD.$1267.Metal1 vin2.$250.Metal1 2.57799e-09f
Cred_4691 VDD.$1267.Metal1 vin2.$508.Metal2 7.08547e-07f
Cred_4692 VDD.$1267.Metal1 vin2.$512.Metal2 7.08547e-07f
Cred_4693 VDD.$1267.Metal1 vin2.P24.GatPoly 0.0114333f
Cred_4694 VDD.$1267.Metal1 vout1.$1226.Metal3 0.00208216f
Cred_4695 VDD.$1267.Metal1 vout1.P4.pSD 0.000317412f
Cred_4696 VDD.$1267.Metal1 vout2.$1226.Metal3 0.00208216f
Cred_4697 VDD.$1267.Metal1 vout2.P4.pSD 0.000317412f
Cred_4698 VDD.$1271.Metal1 vin3.$247.Metal1 1.09069e-08f
Cred_4699 VDD.$1271.Metal1 vin3.$251.Metal1 2.57799e-09f
Cred_4700 VDD.$1271.Metal1 vin3.$509.Metal2 7.08547e-07f
Cred_4701 VDD.$1271.Metal1 vin3.$513.Metal2 7.08547e-07f
Cred_4702 VDD.$1271.Metal1 vin3.P24.GatPoly 0.0114333f
Cred_4703 VDD.$1271.Metal1 vin4.$246.Metal1 1.09069e-08f
Cred_4704 VDD.$1271.Metal1 vin4.$250.Metal1 2.57799e-09f
Cred_4705 VDD.$1271.Metal1 vin4.$508.Metal2 7.08547e-07f
Cred_4706 VDD.$1271.Metal1 vin4.$512.Metal2 7.08547e-07f
Cred_4707 VDD.$1271.Metal1 vin4.P24.GatPoly 0.0114333f
Cred_4708 VDD.$1271.Metal1 vout3.$1226.Metal3 0.00208216f
Cred_4709 VDD.$1271.Metal1 vout3.P4.pSD 0.000317412f
Cred_4710 VDD.$1271.Metal1 vout4.$1226.Metal3 0.00208216f
Cred_4711 VDD.$1271.Metal1 vout4.P4.pSD 0.000317412f
Cred_4712 VDD.$1287.Metal1 vin1.P24.GatPoly 0.00167809f
Cred_4713 VDD.$1287.Metal1 vin1.P25.GatPoly 0.000472483f
Cred_4714 VDD.$1287.Metal1 vin2.P24.GatPoly 0.00167809f
Cred_4715 VDD.$1287.Metal1 vin2.P25.GatPoly 0.000472483f
Cred_4716 VDD.$1287.Metal1 vout1.$1226.Metal3 0.00691526f
Cred_4717 VDD.$1287.Metal1 vout1.P4.pSD 0.00488282f
Cred_4718 VDD.$1287.Metal1 vout2.$1226.Metal3 0.00691526f
Cred_4719 VDD.$1287.Metal1 vout2.P4.pSD 0.00488282f
Cred_4720 VDD.$1291.Metal1 vin3.P24.GatPoly 0.00167809f
Cred_4721 VDD.$1291.Metal1 vin3.P25.GatPoly 0.000472483f
Cred_4722 VDD.$1291.Metal1 vin4.P24.GatPoly 0.00167809f
Cred_4723 VDD.$1291.Metal1 vin4.P25.GatPoly 0.000472483f
Cred_4724 VDD.$1291.Metal1 vout3.$1226.Metal3 0.00691526f
Cred_4725 VDD.$1291.Metal1 vout3.P4.pSD 0.00488282f
Cred_4726 VDD.$1291.Metal1 vout4.$1226.Metal3 0.00691526f
Cred_4727 VDD.$1291.Metal1 vout4.P4.pSD 0.00488282f
Cred_4728 VDD.$1307.Metal1 vin1.P25.GatPoly 0.0109997f
Cred_4729 VDD.$1307.Metal1 vin2.P25.GatPoly 0.0109997f
Cred_4730 VDD.$1307.Metal1 vout1.$1226.Metal3 0.00642803f
Cred_4731 VDD.$1307.Metal1 vout1.P4.pSD 0.00347176f
Cred_4732 VDD.$1307.Metal1 vout2.$1226.Metal3 0.00642803f
Cred_4733 VDD.$1307.Metal1 vout2.P4.pSD 0.00347176f
Cred_4734 VDD.$1311.Metal1 vin3.P25.GatPoly 0.0109997f
Cred_4735 VDD.$1311.Metal1 vin4.P25.GatPoly 0.0109997f
Cred_4736 VDD.$1311.Metal1 vout3.$1226.Metal3 0.00642803f
Cred_4737 VDD.$1311.Metal1 vout3.P4.pSD 0.00347176f
Cred_4738 VDD.$1311.Metal1 vout4.$1226.Metal3 0.00642803f
Cred_4739 VDD.$1311.Metal1 vout4.P4.pSD 0.00347176f
Cred_4740 VDD.$1335.Metal1 vin1.P25.GatPoly 0.0181212f
Cred_4741 VDD.$1335.Metal1 vin2.P25.GatPoly 0.0181212f
Cred_4742 VDD.$1335.Metal1 vout1.$1226.Metal3 0.00054598f
Cred_4743 VDD.$1335.Metal1 vout1.P4.pSD 8.32313e-05f
Cred_4744 VDD.$1335.Metal1 vout2.$1226.Metal3 0.00054598f
Cred_4745 VDD.$1335.Metal1 vout2.P4.pSD 8.32313e-05f
Cred_4746 VDD.$1339.Metal1 vin3.P25.GatPoly 0.0181212f
Cred_4747 VDD.$1339.Metal1 vin4.P25.GatPoly 0.0181212f
Cred_4748 VDD.$1339.Metal1 vout3.$1226.Metal3 0.00054598f
Cred_4749 VDD.$1339.Metal1 vout3.P4.pSD 8.32313e-05f
Cred_4750 VDD.$1339.Metal1 vout4.$1226.Metal3 0.00054598f
Cred_4751 VDD.$1339.Metal1 vout4.P4.pSD 8.32313e-05f
Cred_4752 VDD.$1354.Metal1 vin1.$265.Metal1 0.00725203f
Cred_4753 VDD.$1354.Metal1 vin1.$273.Metal1 0.0138443f
Cred_4754 VDD.$1354.Metal1 vin1.$277.Metal1 0.000252626f
Cred_4755 VDD.$1354.Metal1 vin1.$281.Metal1 1.57726e-05f
Cred_4756 VDD.$1354.Metal1 vin1.$47.GatPoly 0.0264619f
Cred_4757 VDD.$1354.Metal1 vin1.$515.Metal2 0.000429768f
Cred_4758 VDD.$1354.Metal1 vin1.$520.Metal2 0.00186091f
Cred_4759 VDD.$1354.Metal1 vin1.$523.Metal2 0.000193704f
Cred_4760 VDD.$1354.Metal1 vin1.$527.Metal2 0.018394f
Cred_4761 VDD.$1354.Metal1 vin1.$528.Metal2 7.35585e-06f
Cred_4762 VDD.$1354.Metal1 vin1.$53.GatPoly 0.0078925f
Cred_4763 VDD.$1354.Metal1 vin1.$533.Metal2 0.0013126f
Cred_4764 VDD.$1354.Metal1 vin1.$535.Metal2 0.000429768f
Cred_4765 VDD.$1354.Metal1 vin1.$57.GatPoly 0.0273409f
Cred_4766 VDD.$1354.Metal1 vin1.P24.GatPoly 0.0010479f
Cred_4767 VDD.$1354.Metal1 vin1.P25.GatPoly 0.137974f
Cred_4768 VDD.$1354.Metal1 vin1.P26.GatPoly 0.1386f
Cred_4769 VDD.$1354.Metal1 vin1.P27.GatPoly 0.0010479f
Cred_4770 VDD.$1354.Metal1 vin2.$264.Metal1 0.00725203f
Cred_4771 VDD.$1354.Metal1 vin2.$272.Metal1 0.0138443f
Cred_4772 VDD.$1354.Metal1 vin2.$276.Metal1 0.000252626f
Cred_4773 VDD.$1354.Metal1 vin2.$280.Metal1 1.57726e-05f
Cred_4774 VDD.$1354.Metal1 vin2.$44.GatPoly 0.0264619f
Cred_4775 VDD.$1354.Metal1 vin2.$515.Metal2 0.000429768f
Cred_4776 VDD.$1354.Metal1 vin2.$519.Metal2 0.00186091f
Cred_4777 VDD.$1354.Metal1 vin2.$52.GatPoly 0.0078925f
Cred_4778 VDD.$1354.Metal1 vin2.$524.Metal2 0.000193704f
Cred_4779 VDD.$1354.Metal1 vin2.$525.Metal2 0.018394f
Cred_4780 VDD.$1354.Metal1 vin2.$529.Metal2 7.35585e-06f
Cred_4781 VDD.$1354.Metal1 vin2.$532.Metal2 0.0013126f
Cred_4782 VDD.$1354.Metal1 vin2.$535.Metal2 0.000429768f
Cred_4783 VDD.$1354.Metal1 vin2.$56.GatPoly 0.0273409f
Cred_4784 VDD.$1354.Metal1 vin2.P24.GatPoly 0.0010479f
Cred_4785 VDD.$1354.Metal1 vin2.P25.GatPoly 0.137974f
Cred_4786 VDD.$1354.Metal1 vin2.P26.GatPoly 0.1386f
Cred_4787 VDD.$1354.Metal1 vin2.P27.GatPoly 0.0010479f
Cred_4788 VDD.$1354.Metal1 vout1.$1226.Metal3 0.131058f
Cred_4789 VDD.$1354.Metal1 vout1.$1292.Metal3 0.0417682f
Cred_4790 VDD.$1354.Metal1 vout1.P4.pSD 0.0471949f
Cred_4791 VDD.$1354.Metal1 vout1.P6.nSD 0.000658019f
Cred_4792 VDD.$1354.Metal1 vout1.P6.pSD 0.0478274f
Cred_4793 VDD.$1354.Metal1 vout2.$1226.Metal3 0.131202f
Cred_4794 VDD.$1354.Metal1 vout2.$1292.Metal3 0.0417007f
Cred_4795 VDD.$1354.Metal1 vout2.P4.pSD 0.0471814f
Cred_4796 VDD.$1354.Metal1 vout2.P6.nSD 0.000656956f
Cred_4797 VDD.$1354.Metal1 vout2.P6.pSD 0.0478487f
Cred_4798 VDD.$1355.Metal1 vin3.$265.Metal1 0.00725203f
Cred_4799 VDD.$1355.Metal1 vin3.$273.Metal1 0.0138443f
Cred_4800 VDD.$1355.Metal1 vin3.$277.Metal1 0.000252626f
Cred_4801 VDD.$1355.Metal1 vin3.$281.Metal1 1.57726e-05f
Cred_4802 VDD.$1355.Metal1 vin3.$47.GatPoly 0.0264619f
Cred_4803 VDD.$1355.Metal1 vin3.$515.Metal2 0.000429768f
Cred_4804 VDD.$1355.Metal1 vin3.$520.Metal2 0.00186091f
Cred_4805 VDD.$1355.Metal1 vin3.$523.Metal2 0.000193704f
Cred_4806 VDD.$1355.Metal1 vin3.$527.Metal2 0.018394f
Cred_4807 VDD.$1355.Metal1 vin3.$528.Metal2 7.35585e-06f
Cred_4808 VDD.$1355.Metal1 vin3.$53.GatPoly 0.0078925f
Cred_4809 VDD.$1355.Metal1 vin3.$533.Metal2 0.0013126f
Cred_4810 VDD.$1355.Metal1 vin3.$535.Metal2 0.000429768f
Cred_4811 VDD.$1355.Metal1 vin3.$57.GatPoly 0.0273409f
Cred_4812 VDD.$1355.Metal1 vin3.P24.GatPoly 0.0010479f
Cred_4813 VDD.$1355.Metal1 vin3.P25.GatPoly 0.137974f
Cred_4814 VDD.$1355.Metal1 vin3.P26.GatPoly 0.1386f
Cred_4815 VDD.$1355.Metal1 vin3.P27.GatPoly 0.0010479f
Cred_4816 VDD.$1355.Metal1 vin4.$264.Metal1 0.00725203f
Cred_4817 VDD.$1355.Metal1 vin4.$272.Metal1 0.0138443f
Cred_4818 VDD.$1355.Metal1 vin4.$276.Metal1 0.000252626f
Cred_4819 VDD.$1355.Metal1 vin4.$280.Metal1 1.57726e-05f
Cred_4820 VDD.$1355.Metal1 vin4.$44.GatPoly 0.0264619f
Cred_4821 VDD.$1355.Metal1 vin4.$515.Metal2 0.000429768f
Cred_4822 VDD.$1355.Metal1 vin4.$519.Metal2 0.00186091f
Cred_4823 VDD.$1355.Metal1 vin4.$52.GatPoly 0.0078925f
Cred_4824 VDD.$1355.Metal1 vin4.$524.Metal2 0.000193704f
Cred_4825 VDD.$1355.Metal1 vin4.$525.Metal2 0.018394f
Cred_4826 VDD.$1355.Metal1 vin4.$529.Metal2 7.35585e-06f
Cred_4827 VDD.$1355.Metal1 vin4.$532.Metal2 0.0013126f
Cred_4828 VDD.$1355.Metal1 vin4.$535.Metal2 0.000429768f
Cred_4829 VDD.$1355.Metal1 vin4.$56.GatPoly 0.0273409f
Cred_4830 VDD.$1355.Metal1 vin4.P24.GatPoly 0.0010479f
Cred_4831 VDD.$1355.Metal1 vin4.P25.GatPoly 0.137974f
Cred_4832 VDD.$1355.Metal1 vin4.P26.GatPoly 0.1386f
Cred_4833 VDD.$1355.Metal1 vin4.P27.GatPoly 0.0010479f
Cred_4834 VDD.$1355.Metal1 vout3.$1226.Metal3 0.131058f
Cred_4835 VDD.$1355.Metal1 vout3.$1292.Metal3 0.0417682f
Cred_4836 VDD.$1355.Metal1 vout3.P4.pSD 0.0471949f
Cred_4837 VDD.$1355.Metal1 vout3.P6.nSD 0.000658019f
Cred_4838 VDD.$1355.Metal1 vout3.P6.pSD 0.0478274f
Cred_4839 VDD.$1355.Metal1 vout4.$1226.Metal3 0.131202f
Cred_4840 VDD.$1355.Metal1 vout4.$1292.Metal3 0.0417007f
Cred_4841 VDD.$1355.Metal1 vout4.P4.pSD 0.0471814f
Cred_4842 VDD.$1355.Metal1 vout4.P6.nSD 0.000656956f
Cred_4843 VDD.$1355.Metal1 vout4.P6.pSD 0.0478487f
Cred_4844 VDD.$1413.Metal1 vin1.P25.GatPoly 0.000423561f
Cred_4845 VDD.$1413.Metal1 vin2.P25.GatPoly 0.000423561f
Cred_4846 VDD.$1417.Metal1 vin3.P25.GatPoly 0.000423561f
Cred_4847 VDD.$1417.Metal1 vin4.P25.GatPoly 0.000423561f
Cred_4848 VDD.$1557.Metal1 vin1.P26.GatPoly 0.00314398f
Cred_4849 VDD.$1557.Metal1 vin2.P26.GatPoly 0.00314398f
Cred_4850 VDD.$1561.Metal1 vin3.P26.GatPoly 0.00314398f
Cred_4851 VDD.$1561.Metal1 vin4.P26.GatPoly 0.00314398f
Cred_4852 VDD.$157.Metal1 vin1.P20.GatPoly 3.59626e-06f
Cred_4853 VDD.$157.Metal1 vout1.$1226.Metal3 8.33916e-06f
Cred_4854 VDD.$157.Metal1 vout1.P0.nSD 2.48314e-07f
Cred_4855 VDD.$157.Metal1 vout1.P0.pSD 4.82954e-06f
Cred_4856 VDD.$157.Metal1 vout1.P2.nSD 1.31376e-07f
Cred_4857 VDD.$157.Metal1 vout1.P2.pSD 7.17998e-07f
Cred_4858 VDD.$1577.Metal1 vin1.P26.GatPoly 0.0118002f
Cred_4859 VDD.$1577.Metal1 vin2.P26.GatPoly 0.0118002f
Cred_4860 VDD.$158.Metal1 vin1.P20.GatPoly 3.63327e-06f
Cred_4861 VDD.$158.Metal1 vout1.$1226.Metal3 8.36165e-06f
Cred_4862 VDD.$158.Metal1 vout1.P0.nSD 2.48984e-07f
Cred_4863 VDD.$158.Metal1 vout1.P0.pSD 4.9662e-06f
Cred_4864 VDD.$158.Metal1 vout1.P2.nSD 1.3173e-07f
Cred_4865 VDD.$158.Metal1 vout1.P2.pSD 7.19934e-07f
Cred_4866 VDD.$1581.Metal1 vin3.P26.GatPoly 0.0118002f
Cred_4867 VDD.$1581.Metal1 vin4.P26.GatPoly 0.0118002f
Cred_4868 VDD.$1597.Metal1 vin1.P26.GatPoly 0.0123778f
Cred_4869 VDD.$1597.Metal1 vin2.P26.GatPoly 0.0123778f
Cred_4870 VDD.$1597.Metal1 vout1.$1226.Metal3 0.00093896f
Cred_4871 VDD.$1597.Metal1 vout1.$1292.Metal3 0.00093896f
Cred_4872 VDD.$1597.Metal1 vout1.P6.nSD 1.47924e-05f
Cred_4873 VDD.$1597.Metal1 vout1.P6.pSD 0.000381985f
Cred_4874 VDD.$1597.Metal1 vout2.$1226.Metal3 0.00093896f
Cred_4875 VDD.$1597.Metal1 vout2.$1292.Metal3 0.00093896f
Cred_4876 VDD.$1597.Metal1 vout2.P6.nSD 1.47924e-05f
Cred_4877 VDD.$1597.Metal1 vout2.P6.pSD 0.000381985f
Cred_4878 VDD.$1601.Metal1 vin3.P26.GatPoly 0.0123778f
Cred_4879 VDD.$1601.Metal1 vin4.P26.GatPoly 0.0123778f
Cred_4880 VDD.$1601.Metal1 vout3.$1226.Metal3 0.00093896f
Cred_4881 VDD.$1601.Metal1 vout3.$1292.Metal3 0.00093896f
Cred_4882 VDD.$1601.Metal1 vout3.P6.nSD 1.47924e-05f
Cred_4883 VDD.$1601.Metal1 vout3.P6.pSD 0.000381985f
Cred_4884 VDD.$1601.Metal1 vout4.$1226.Metal3 0.00093896f
Cred_4885 VDD.$1601.Metal1 vout4.$1292.Metal3 0.00093896f
Cred_4886 VDD.$1601.Metal1 vout4.P6.nSD 1.47924e-05f
Cred_4887 VDD.$1601.Metal1 vout4.P6.pSD 0.000381985f
Cred_4888 VDD.$1617.Metal1 vin1.P26.GatPoly 0.00194394f
Cred_4889 VDD.$1617.Metal1 vin1.P27.GatPoly 0.0021579f
Cred_4890 VDD.$1617.Metal1 vin2.P26.GatPoly 0.00194394f
Cred_4891 VDD.$1617.Metal1 vin2.P27.GatPoly 0.0021579f
Cred_4892 VDD.$1617.Metal1 vout1.$1226.Metal3 0.00447353f
Cred_4893 VDD.$1617.Metal1 vout1.$1292.Metal3 0.00447353f
Cred_4894 VDD.$1617.Metal1 vout1.P6.nSD 7.04762e-05f
Cred_4895 VDD.$1617.Metal1 vout1.P6.pSD 0.00690265f
Cred_4896 VDD.$1617.Metal1 vout2.$1226.Metal3 0.00447353f
Cred_4897 VDD.$1617.Metal1 vout2.$1292.Metal3 0.00447353f
Cred_4898 VDD.$1617.Metal1 vout2.P6.nSD 7.04762e-05f
Cred_4899 VDD.$1617.Metal1 vout2.P6.pSD 0.00690265f
Cred_4900 VDD.$1621.Metal1 vin3.P26.GatPoly 0.00194394f
Cred_4901 VDD.$1621.Metal1 vin3.P27.GatPoly 0.0021579f
Cred_4902 VDD.$1621.Metal1 vin4.P26.GatPoly 0.00194394f
Cred_4903 VDD.$1621.Metal1 vin4.P27.GatPoly 0.0021579f
Cred_4904 VDD.$1621.Metal1 vout3.$1226.Metal3 0.00447353f
Cred_4905 VDD.$1621.Metal1 vout3.$1292.Metal3 0.00447353f
Cred_4906 VDD.$1621.Metal1 vout3.P6.nSD 7.04762e-05f
Cred_4907 VDD.$1621.Metal1 vout3.P6.pSD 0.00690265f
Cred_4908 VDD.$1621.Metal1 vout4.$1226.Metal3 0.00447353f
Cred_4909 VDD.$1621.Metal1 vout4.$1292.Metal3 0.00447353f
Cred_4910 VDD.$1621.Metal1 vout4.P6.nSD 7.04762e-05f
Cred_4911 VDD.$1621.Metal1 vout4.P6.pSD 0.00690265f
Cred_4912 VDD.$1645.Metal1 vin1.$291.Metal1 2.06929e-08f
Cred_4913 VDD.$1645.Metal1 vin1.$295.Metal1 6.89763e-09f
Cred_4914 VDD.$1645.Metal1 vin1.$538.Metal2 1.45065e-06f
Cred_4915 VDD.$1645.Metal1 vin1.$542.Metal2 1.45065e-06f
Cred_4916 VDD.$1645.Metal1 vin1.P27.GatPoly 0.0146821f
Cred_4917 VDD.$1645.Metal1 vin2.$290.Metal1 2.06929e-08f
Cred_4918 VDD.$1645.Metal1 vin2.$294.Metal1 6.89763e-09f
Cred_4919 VDD.$1645.Metal1 vin2.$537.Metal2 1.45065e-06f
Cred_4920 VDD.$1645.Metal1 vin2.$541.Metal2 1.45065e-06f
Cred_4921 VDD.$1645.Metal1 vin2.P27.GatPoly 0.0146821f
Cred_4922 VDD.$1645.Metal1 vout1.$1226.Metal3 0.0021135f
Cred_4923 VDD.$1645.Metal1 vout1.$1292.Metal3 0.0021135f
Cred_4924 VDD.$1645.Metal1 vout1.P6.nSD 3.32963e-05f
Cred_4925 VDD.$1645.Metal1 vout1.P6.pSD 0.00241573f
Cred_4926 VDD.$1645.Metal1 vout2.$1226.Metal3 0.0021135f
Cred_4927 VDD.$1645.Metal1 vout2.$1292.Metal3 0.0021135f
Cred_4928 VDD.$1645.Metal1 vout2.P6.nSD 3.32963e-05f
Cred_4929 VDD.$1645.Metal1 vout2.P6.pSD 0.00241573f
Cred_4930 VDD.$1649.Metal1 vin3.$291.Metal1 2.06929e-08f
Cred_4931 VDD.$1649.Metal1 vin3.$295.Metal1 6.89763e-09f
Cred_4932 VDD.$1649.Metal1 vin3.$538.Metal2 1.45065e-06f
Cred_4933 VDD.$1649.Metal1 vin3.$542.Metal2 1.45065e-06f
Cred_4934 VDD.$1649.Metal1 vin3.P27.GatPoly 0.0146821f
Cred_4935 VDD.$1649.Metal1 vin4.$290.Metal1 2.06929e-08f
Cred_4936 VDD.$1649.Metal1 vin4.$294.Metal1 6.89763e-09f
Cred_4937 VDD.$1649.Metal1 vin4.$537.Metal2 1.45065e-06f
Cred_4938 VDD.$1649.Metal1 vin4.$541.Metal2 1.45065e-06f
Cred_4939 VDD.$1649.Metal1 vin4.P27.GatPoly 0.0146821f
Cred_4940 VDD.$1649.Metal1 vout3.$1226.Metal3 0.0021135f
Cred_4941 VDD.$1649.Metal1 vout3.$1292.Metal3 0.0021135f
Cred_4942 VDD.$1649.Metal1 vout3.P6.nSD 3.32963e-05f
Cred_4943 VDD.$1649.Metal1 vout3.P6.pSD 0.00241573f
Cred_4944 VDD.$1649.Metal1 vout4.$1226.Metal3 0.0021135f
Cred_4945 VDD.$1649.Metal1 vout4.$1292.Metal3 0.0021135f
Cred_4946 VDD.$1649.Metal1 vout4.P6.nSD 3.32963e-05f
Cred_4947 VDD.$1649.Metal1 vout4.P6.pSD 0.00241573f
Cred_4948 VDD.$1665.Metal1 vin1.$291.Metal1 1.20308e-08f
Cred_4949 VDD.$1665.Metal1 vin1.$295.Metal1 4.01025e-09f
Cred_4950 VDD.$1665.Metal1 vin1.$538.Metal2 8.43403e-07f
Cred_4951 VDD.$1665.Metal1 vin1.$542.Metal2 8.43403e-07f
Cred_4952 VDD.$1665.Metal1 vin1.P27.GatPoly 0.0120636f
Cred_4953 VDD.$1665.Metal1 vin2.$290.Metal1 1.20308e-08f
Cred_4954 VDD.$1665.Metal1 vin2.$294.Metal1 4.01025e-09f
Cred_4955 VDD.$1665.Metal1 vin2.$537.Metal2 8.43403e-07f
Cred_4956 VDD.$1665.Metal1 vin2.$541.Metal2 8.43403e-07f
Cred_4957 VDD.$1665.Metal1 vin2.P27.GatPoly 0.0120636f
Cred_4958 VDD.$1669.Metal1 vin3.$291.Metal1 1.20308e-08f
Cred_4959 VDD.$1669.Metal1 vin3.$295.Metal1 4.01025e-09f
Cred_4960 VDD.$1669.Metal1 vin3.$538.Metal2 8.43403e-07f
Cred_4961 VDD.$1669.Metal1 vin3.$542.Metal2 8.43403e-07f
Cred_4962 VDD.$1669.Metal1 vin3.P27.GatPoly 0.0120636f
Cred_4963 VDD.$1669.Metal1 vin4.$290.Metal1 1.20308e-08f
Cred_4964 VDD.$1669.Metal1 vin4.$294.Metal1 4.01025e-09f
Cred_4965 VDD.$1669.Metal1 vin4.$537.Metal2 8.43403e-07f
Cred_4966 VDD.$1669.Metal1 vin4.$541.Metal2 8.43403e-07f
Cred_4967 VDD.$1669.Metal1 vin4.P27.GatPoly 0.0120636f
Cred_4968 VDD.$1684.Metal1 vin1.$291.Metal1 0.00425071f
Cred_4969 VDD.$1684.Metal1 vin1.$295.Metal1 0.00965228f
Cred_4970 VDD.$1684.Metal1 vin1.$303.Metal1 0.0146255f
Cred_4971 VDD.$1684.Metal1 vin1.$307.Metal1 0.000305593f
Cred_4972 VDD.$1684.Metal1 vin1.$542.Metal2 0.00675532f
Cred_4973 VDD.$1684.Metal1 vin1.$544.Metal2 0.00127335f
Cred_4974 VDD.$1684.Metal1 vin1.$547.Metal2 0.0143436f
Cred_4975 VDD.$1684.Metal1 vin1.$551.Metal2 0.000161352f
Cred_4976 VDD.$1684.Metal1 vin1.$65.GatPoly 0.00803706f
Cred_4977 VDD.$1684.Metal1 vin1.$73.GatPoly 0.01444f
Cred_4978 VDD.$1684.Metal1 vin1.$77.GatPoly 0.027376f
Cred_4979 VDD.$1684.Metal1 vin1.P26.GatPoly 0.00105163f
Cred_4980 VDD.$1684.Metal1 vin1.P27.GatPoly 0.144072f
Cred_4981 VDD.$1684.Metal1 vin1.P28.GatPoly 0.139706f
Cred_4982 VDD.$1684.Metal1 vin1.P29.GatPoly 0.00105163f
Cred_4983 VDD.$1684.Metal1 vin2.$290.Metal1 0.00425071f
Cred_4984 VDD.$1684.Metal1 vin2.$294.Metal1 0.00965228f
Cred_4985 VDD.$1684.Metal1 vin2.$302.Metal1 0.0146255f
Cred_4986 VDD.$1684.Metal1 vin2.$306.Metal1 0.000305593f
Cred_4987 VDD.$1684.Metal1 vin2.$541.Metal2 0.00675532f
Cred_4988 VDD.$1684.Metal1 vin2.$544.Metal2 0.00127335f
Cred_4989 VDD.$1684.Metal1 vin2.$546.Metal2 0.0143436f
Cred_4990 VDD.$1684.Metal1 vin2.$550.Metal2 0.000161352f
Cred_4991 VDD.$1684.Metal1 vin2.$64.GatPoly 0.00803706f
Cred_4992 VDD.$1684.Metal1 vin2.$72.GatPoly 0.01444f
Cred_4993 VDD.$1684.Metal1 vin2.$76.GatPoly 0.027376f
Cred_4994 VDD.$1684.Metal1 vin2.P26.GatPoly 0.00105163f
Cred_4995 VDD.$1684.Metal1 vin2.P27.GatPoly 0.144072f
Cred_4996 VDD.$1684.Metal1 vin2.P28.GatPoly 0.139706f
Cred_4997 VDD.$1684.Metal1 vin2.P29.GatPoly 0.00105163f
Cred_4998 VDD.$1684.Metal1 vout1.$1226.Metal3 0.0427388f
Cred_4999 VDD.$1684.Metal1 vout1.$1292.Metal3 0.130841f
Cred_5000 VDD.$1684.Metal1 vout1.P6.nSD 0.00067331f
Cred_5001 VDD.$1684.Metal1 vout1.P6.pSD 0.0510671f
Cred_5002 VDD.$1684.Metal1 vout1.P8.pSD 0.0443791f
Cred_5003 VDD.$1684.Metal1 vout2.$1226.Metal3 0.0428052f
Cred_5004 VDD.$1684.Metal1 vout2.$1292.Metal3 0.13065f
Cred_5005 VDD.$1684.Metal1 vout2.P6.nSD 0.000674356f
Cred_5006 VDD.$1684.Metal1 vout2.P6.pSD 0.051045f
Cred_5007 VDD.$1684.Metal1 vout2.P8.pSD 0.0443838f
Cred_5008 VDD.$1685.Metal1 vin3.$291.Metal1 0.00425071f
Cred_5009 VDD.$1685.Metal1 vin3.$295.Metal1 0.00965228f
Cred_5010 VDD.$1685.Metal1 vin3.$303.Metal1 0.0146255f
Cred_5011 VDD.$1685.Metal1 vin3.$307.Metal1 0.000305593f
Cred_5012 VDD.$1685.Metal1 vin3.$542.Metal2 0.00675532f
Cred_5013 VDD.$1685.Metal1 vin3.$544.Metal2 0.00127335f
Cred_5014 VDD.$1685.Metal1 vin3.$547.Metal2 0.0143436f
Cred_5015 VDD.$1685.Metal1 vin3.$551.Metal2 0.000161352f
Cred_5016 VDD.$1685.Metal1 vin3.$65.GatPoly 0.00803706f
Cred_5017 VDD.$1685.Metal1 vin3.$73.GatPoly 0.01444f
Cred_5018 VDD.$1685.Metal1 vin3.$77.GatPoly 0.027376f
Cred_5019 VDD.$1685.Metal1 vin3.P26.GatPoly 0.00105163f
Cred_5020 VDD.$1685.Metal1 vin3.P27.GatPoly 0.144072f
Cred_5021 VDD.$1685.Metal1 vin3.P28.GatPoly 0.139706f
Cred_5022 VDD.$1685.Metal1 vin3.P29.GatPoly 0.00105163f
Cred_5023 VDD.$1685.Metal1 vin4.$290.Metal1 0.00425071f
Cred_5024 VDD.$1685.Metal1 vin4.$294.Metal1 0.00965228f
Cred_5025 VDD.$1685.Metal1 vin4.$302.Metal1 0.0146255f
Cred_5026 VDD.$1685.Metal1 vin4.$306.Metal1 0.000305593f
Cred_5027 VDD.$1685.Metal1 vin4.$541.Metal2 0.00675532f
Cred_5028 VDD.$1685.Metal1 vin4.$544.Metal2 0.00127335f
Cred_5029 VDD.$1685.Metal1 vin4.$546.Metal2 0.0143436f
Cred_5030 VDD.$1685.Metal1 vin4.$550.Metal2 0.000161352f
Cred_5031 VDD.$1685.Metal1 vin4.$64.GatPoly 0.00803706f
Cred_5032 VDD.$1685.Metal1 vin4.$72.GatPoly 0.01444f
Cred_5033 VDD.$1685.Metal1 vin4.$76.GatPoly 0.027376f
Cred_5034 VDD.$1685.Metal1 vin4.P26.GatPoly 0.00105163f
Cred_5035 VDD.$1685.Metal1 vin4.P27.GatPoly 0.144072f
Cred_5036 VDD.$1685.Metal1 vin4.P28.GatPoly 0.139706f
Cred_5037 VDD.$1685.Metal1 vin4.P29.GatPoly 0.00105163f
Cred_5038 VDD.$1685.Metal1 vout3.$1226.Metal3 0.0427388f
Cred_5039 VDD.$1685.Metal1 vout3.$1292.Metal3 0.130841f
Cred_5040 VDD.$1685.Metal1 vout3.P6.nSD 0.00067331f
Cred_5041 VDD.$1685.Metal1 vout3.P6.pSD 0.0510671f
Cred_5042 VDD.$1685.Metal1 vout3.P8.pSD 0.0443791f
Cred_5043 VDD.$1685.Metal1 vout4.$1226.Metal3 0.0428052f
Cred_5044 VDD.$1685.Metal1 vout4.$1292.Metal3 0.13065f
Cred_5045 VDD.$1685.Metal1 vout4.P6.nSD 0.000674356f
Cred_5046 VDD.$1685.Metal1 vout4.P6.pSD 0.051045f
Cred_5047 VDD.$1685.Metal1 vout4.P8.pSD 0.0443838f
Cred_5048 VDD.$1831.Metal1 vin1.P28.GatPoly 0.00634899f
Cred_5049 VDD.$1831.Metal1 vin2.P28.GatPoly 0.00634899f
Cred_5050 VDD.$1835.Metal1 vin3.P28.GatPoly 0.00634899f
Cred_5051 VDD.$1835.Metal1 vin4.P28.GatPoly 0.00634899f
Cred_5052 VDD.$185.Metal1 vin3.P20.GatPoly 3.59626e-06f
Cred_5053 VDD.$185.Metal1 vout3.$1226.Metal3 8.33916e-06f
Cred_5054 VDD.$185.Metal1 vout3.P0.nSD 2.48314e-07f
Cred_5055 VDD.$185.Metal1 vout3.P0.pSD 4.82954e-06f
Cred_5056 VDD.$185.Metal1 vout3.P2.nSD 1.31376e-07f
Cred_5057 VDD.$185.Metal1 vout3.P2.pSD 7.17998e-07f
Cred_5058 VDD.$186.Metal1 vin3.P20.GatPoly 3.63327e-06f
Cred_5059 VDD.$186.Metal1 vout3.$1226.Metal3 8.36165e-06f
Cred_5060 VDD.$186.Metal1 vout3.P0.nSD 2.48984e-07f
Cred_5061 VDD.$186.Metal1 vout3.P0.pSD 4.9662e-06f
Cred_5062 VDD.$186.Metal1 vout3.P2.nSD 1.3173e-07f
Cred_5063 VDD.$186.Metal1 vout3.P2.pSD 7.19934e-07f
Cred_5064 VDD.$1915.Metal1 vin1.$551.Metal2 3.29115e-06f
Cred_5065 VDD.$1915.Metal1 vin1.P28.GatPoly 0.0191284f
Cred_5066 VDD.$1915.Metal1 vin2.$550.Metal2 3.29115e-06f
Cred_5067 VDD.$1915.Metal1 vin2.P28.GatPoly 0.0191284f
Cred_5068 VDD.$1915.Metal1 vout1.$1292.Metal3 0.0015436f
Cred_5069 VDD.$1915.Metal1 vout1.P8.pSD 0.000235982f
Cred_5070 VDD.$1915.Metal1 vout2.$1292.Metal3 0.0015436f
Cred_5071 VDD.$1915.Metal1 vout2.P8.pSD 0.000235982f
Cred_5072 VDD.$1919.Metal1 vin3.$551.Metal2 3.29115e-06f
Cred_5073 VDD.$1919.Metal1 vin3.P28.GatPoly 0.0191284f
Cred_5074 VDD.$1919.Metal1 vin4.$550.Metal2 3.29115e-06f
Cred_5075 VDD.$1919.Metal1 vin4.P28.GatPoly 0.0191284f
Cred_5076 VDD.$1919.Metal1 vout3.$1292.Metal3 0.0015436f
Cred_5077 VDD.$1919.Metal1 vout3.P8.pSD 0.000235982f
Cred_5078 VDD.$1919.Metal1 vout4.$1292.Metal3 0.0015436f
Cred_5079 VDD.$1919.Metal1 vout4.P8.pSD 0.000235982f
Cred_5080 VDD.$1935.Metal1 vin1.$551.Metal2 7.77909e-07f
Cred_5081 VDD.$1935.Metal1 vin1.P28.GatPoly 0.0027657f
Cred_5082 VDD.$1935.Metal1 vin2.$550.Metal2 7.77909e-07f
Cred_5083 VDD.$1935.Metal1 vin2.P28.GatPoly 0.0027657f
Cred_5084 VDD.$1935.Metal1 vout1.$1292.Metal3 0.00584151f
Cred_5085 VDD.$1935.Metal1 vout1.P8.pSD 0.00401618f
Cred_5086 VDD.$1935.Metal1 vout2.$1292.Metal3 0.00584151f
Cred_5087 VDD.$1935.Metal1 vout2.P8.pSD 0.00401618f
Cred_5088 VDD.$1939.Metal1 vin3.$551.Metal2 7.77909e-07f
Cred_5089 VDD.$1939.Metal1 vin3.P28.GatPoly 0.0027657f
Cred_5090 VDD.$1939.Metal1 vin4.$550.Metal2 7.77909e-07f
Cred_5091 VDD.$1939.Metal1 vin4.P28.GatPoly 0.0027657f
Cred_5092 VDD.$1939.Metal1 vout3.$1292.Metal3 0.00584151f
Cred_5093 VDD.$1939.Metal1 vout3.P8.pSD 0.00401618f
Cred_5094 VDD.$1939.Metal1 vout4.$1292.Metal3 0.00584151f
Cred_5095 VDD.$1939.Metal1 vout4.P8.pSD 0.00401618f
Cred_5096 VDD.$1955.Metal1 vin1.P29.GatPoly 0.00165175f
Cred_5097 VDD.$1955.Metal1 vin2.P29.GatPoly 0.00165175f
Cred_5098 VDD.$1955.Metal1 vout1.$1292.Metal3 0.00647041f
Cred_5099 VDD.$1955.Metal1 vout1.P8.pSD 0.0045063f
Cred_5100 VDD.$1955.Metal1 vout2.$1292.Metal3 0.00647041f
Cred_5101 VDD.$1955.Metal1 vout2.P8.pSD 0.0045063f
Cred_5102 VDD.$1959.Metal1 vin3.P29.GatPoly 0.00165175f
Cred_5103 VDD.$1959.Metal1 vin4.P29.GatPoly 0.00165175f
Cred_5104 VDD.$1959.Metal1 vout3.$1292.Metal3 0.00647041f
Cred_5105 VDD.$1959.Metal1 vout3.P8.pSD 0.0045063f
Cred_5106 VDD.$1959.Metal1 vout4.$1292.Metal3 0.00647041f
Cred_5107 VDD.$1959.Metal1 vout4.P8.pSD 0.0045063f
Cred_5108 VDD.$1975.Metal1 vin1.$321.Metal1 2.57607e-09f
Cred_5109 VDD.$1975.Metal1 vin1.$325.Metal1 5.7655e-09f
Cred_5110 VDD.$1975.Metal1 vin1.$558.Metal2 4.38807e-07f
Cred_5111 VDD.$1975.Metal1 vin1.$562.Metal2 4.38807e-07f
Cred_5112 VDD.$1975.Metal1 vin1.P29.GatPoly 0.0124834f
Cred_5113 VDD.$1975.Metal1 vin2.$320.Metal1 2.57607e-09f
Cred_5114 VDD.$1975.Metal1 vin2.$324.Metal1 5.7655e-09f
Cred_5115 VDD.$1975.Metal1 vin2.$557.Metal2 4.38807e-07f
Cred_5116 VDD.$1975.Metal1 vin2.$561.Metal2 4.38807e-07f
Cred_5117 VDD.$1975.Metal1 vin2.P29.GatPoly 0.0124834f
Cred_5118 VDD.$1975.Metal1 vout1.$1292.Metal3 0.00197256f
Cred_5119 VDD.$1975.Metal1 vout1.P8.pSD 0.000300706f
Cred_5120 VDD.$1975.Metal1 vout2.$1292.Metal3 0.00197256f
Cred_5121 VDD.$1975.Metal1 vout2.P8.pSD 0.000300706f
Cred_5122 VDD.$1979.Metal1 vin3.$321.Metal1 2.57607e-09f
Cred_5123 VDD.$1979.Metal1 vin3.$325.Metal1 5.7655e-09f
Cred_5124 VDD.$1979.Metal1 vin3.$558.Metal2 4.38807e-07f
Cred_5125 VDD.$1979.Metal1 vin3.$562.Metal2 4.38807e-07f
Cred_5126 VDD.$1979.Metal1 vin3.P29.GatPoly 0.0124834f
Cred_5127 VDD.$1979.Metal1 vin4.$320.Metal1 2.57607e-09f
Cred_5128 VDD.$1979.Metal1 vin4.$324.Metal1 5.7655e-09f
Cred_5129 VDD.$1979.Metal1 vin4.$557.Metal2 4.38807e-07f
Cred_5130 VDD.$1979.Metal1 vin4.$561.Metal2 4.38807e-07f
Cred_5131 VDD.$1979.Metal1 vin4.P29.GatPoly 0.0124834f
Cred_5132 VDD.$1979.Metal1 vout3.$1292.Metal3 0.00197256f
Cred_5133 VDD.$1979.Metal1 vout3.P8.pSD 0.000300706f
Cred_5134 VDD.$1979.Metal1 vout4.$1292.Metal3 0.00197256f
Cred_5135 VDD.$1979.Metal1 vout4.P8.pSD 0.000300706f
Cred_5136 VDD.$1995.Metal1 vin1.$321.Metal1 1.08988e-08f
Cred_5137 VDD.$1995.Metal1 vin1.$325.Metal1 2.43925e-08f
Cred_5138 VDD.$1995.Metal1 vin1.$558.Metal2 1.85649e-06f
Cred_5139 VDD.$1995.Metal1 vin1.$562.Metal2 1.85649e-06f
Cred_5140 VDD.$1995.Metal1 vin1.P29.GatPoly 0.014701f
Cred_5141 VDD.$1995.Metal1 vin2.$320.Metal1 1.08988e-08f
Cred_5142 VDD.$1995.Metal1 vin2.$324.Metal1 2.43925e-08f
Cred_5143 VDD.$1995.Metal1 vin2.$557.Metal2 1.85649e-06f
Cred_5144 VDD.$1995.Metal1 vin2.$561.Metal2 1.85649e-06f
Cred_5145 VDD.$1995.Metal1 vin2.P29.GatPoly 0.014701f
Cred_5146 VDD.$1999.Metal1 vin3.$321.Metal1 1.08988e-08f
Cred_5147 VDD.$1999.Metal1 vin3.$325.Metal1 2.43925e-08f
Cred_5148 VDD.$1999.Metal1 vin3.$558.Metal2 1.85649e-06f
Cred_5149 VDD.$1999.Metal1 vin3.$562.Metal2 1.85649e-06f
Cred_5150 VDD.$1999.Metal1 vin3.P29.GatPoly 0.014701f
Cred_5151 VDD.$1999.Metal1 vin4.$320.Metal1 1.08988e-08f
Cred_5152 VDD.$1999.Metal1 vin4.$324.Metal1 2.43925e-08f
Cred_5153 VDD.$1999.Metal1 vin4.$557.Metal2 1.85649e-06f
Cred_5154 VDD.$1999.Metal1 vin4.$561.Metal2 1.85649e-06f
Cred_5155 VDD.$1999.Metal1 vin4.P29.GatPoly 0.014701f
Cred_5156 VDD.$2223.Metal1 vin1.$335.Metal1 2.43925e-08f
Cred_5157 VDD.$2223.Metal1 vin1.$339.Metal1 1.08988e-08f
Cred_5158 VDD.$2223.Metal1 vin1.$567.Metal2 1.85649e-06f
Cred_5159 VDD.$2223.Metal1 vin1.$571.Metal2 1.85649e-06f
Cred_5160 VDD.$2223.Metal1 vin1.P30.GatPoly 0.014701f
Cred_5161 VDD.$2223.Metal1 vin2.$334.Metal1 2.43925e-08f
Cred_5162 VDD.$2223.Metal1 vin2.$338.Metal1 1.08988e-08f
Cred_5163 VDD.$2223.Metal1 vin2.$566.Metal2 1.85649e-06f
Cred_5164 VDD.$2223.Metal1 vin2.$570.Metal2 1.85649e-06f
Cred_5165 VDD.$2223.Metal1 vin2.P30.GatPoly 0.014701f
Cred_5166 VDD.$2227.Metal1 vin3.$335.Metal1 2.43925e-08f
Cred_5167 VDD.$2227.Metal1 vin3.$339.Metal1 1.08988e-08f
Cred_5168 VDD.$2227.Metal1 vin3.$567.Metal2 1.85649e-06f
Cred_5169 VDD.$2227.Metal1 vin3.$571.Metal2 1.85649e-06f
Cred_5170 VDD.$2227.Metal1 vin3.P30.GatPoly 0.014701f
Cred_5171 VDD.$2227.Metal1 vin4.$334.Metal1 2.43925e-08f
Cred_5172 VDD.$2227.Metal1 vin4.$338.Metal1 1.08988e-08f
Cred_5173 VDD.$2227.Metal1 vin4.$566.Metal2 1.85649e-06f
Cred_5174 VDD.$2227.Metal1 vin4.$570.Metal2 1.85649e-06f
Cred_5175 VDD.$2227.Metal1 vin4.P30.GatPoly 0.014701f
Cred_5176 VDD.$2243.Metal1 vin1.$335.Metal1 5.7655e-09f
Cred_5177 VDD.$2243.Metal1 vin1.$339.Metal1 2.57607e-09f
Cred_5178 VDD.$2243.Metal1 vin1.$567.Metal2 4.38807e-07f
Cred_5179 VDD.$2243.Metal1 vin1.$571.Metal2 4.38807e-07f
Cred_5180 VDD.$2243.Metal1 vin1.P30.GatPoly 0.0124834f
Cred_5181 VDD.$2243.Metal1 vin2.$334.Metal1 5.7655e-09f
Cred_5182 VDD.$2243.Metal1 vin2.$338.Metal1 2.57607e-09f
Cred_5183 VDD.$2243.Metal1 vin2.$566.Metal2 4.38807e-07f
Cred_5184 VDD.$2243.Metal1 vin2.$570.Metal2 4.38807e-07f
Cred_5185 VDD.$2243.Metal1 vin2.P30.GatPoly 0.0124834f
Cred_5186 VDD.$2243.Metal1 vout1.$1292.Metal3 0.000930701f
Cred_5187 VDD.$2243.Metal1 vout1.$1358.Metal3 0.000930701f
Cred_5188 VDD.$2243.Metal1 vout1.P10.nSD 1.46623e-05f
Cred_5189 VDD.$2243.Metal1 vout1.P10.pSD 0.000397205f
Cred_5190 VDD.$2243.Metal1 vout2.$1292.Metal3 0.000930701f
Cred_5191 VDD.$2243.Metal1 vout2.$1358.Metal3 0.000930701f
Cred_5192 VDD.$2243.Metal1 vout2.P10.nSD 1.46623e-05f
Cred_5193 VDD.$2243.Metal1 vout2.P10.pSD 0.000397205f
Cred_5194 VDD.$2247.Metal1 vin3.$335.Metal1 5.7655e-09f
Cred_5195 VDD.$2247.Metal1 vin3.$339.Metal1 2.57607e-09f
Cred_5196 VDD.$2247.Metal1 vin3.$567.Metal2 4.38807e-07f
Cred_5197 VDD.$2247.Metal1 vin3.$571.Metal2 4.38807e-07f
Cred_5198 VDD.$2247.Metal1 vin3.P30.GatPoly 0.0124834f
Cred_5199 VDD.$2247.Metal1 vin4.$334.Metal1 5.7655e-09f
Cred_5200 VDD.$2247.Metal1 vin4.$338.Metal1 2.57607e-09f
Cred_5201 VDD.$2247.Metal1 vin4.$566.Metal2 4.38807e-07f
Cred_5202 VDD.$2247.Metal1 vin4.$570.Metal2 4.38807e-07f
Cred_5203 VDD.$2247.Metal1 vin4.P30.GatPoly 0.0124834f
Cred_5204 VDD.$2247.Metal1 vout3.$1292.Metal3 0.000930701f
Cred_5205 VDD.$2247.Metal1 vout3.$1358.Metal3 0.000930701f
Cred_5206 VDD.$2247.Metal1 vout3.P10.nSD 1.46623e-05f
Cred_5207 VDD.$2247.Metal1 vout3.P10.pSD 0.000397205f
Cred_5208 VDD.$2247.Metal1 vout4.$1292.Metal3 0.000930701f
Cred_5209 VDD.$2247.Metal1 vout4.$1358.Metal3 0.000930701f
Cred_5210 VDD.$2247.Metal1 vout4.P10.nSD 1.46623e-05f
Cred_5211 VDD.$2247.Metal1 vout4.P10.pSD 0.000397205f
Cred_5212 VDD.$225.Metal1 vin1.$203.Metal1 0.0213752f
Cred_5213 VDD.$225.Metal1 vin1.$477.Metal2 0.00236011f
Cred_5214 VDD.$225.Metal1 vin1.$480.Metal2 0.00484604f
Cred_5215 VDD.$225.Metal1 vin1.$9.GatPoly 0.00240373f
Cred_5216 VDD.$225.Metal1 vin1.P20.GatPoly 0.0766044f
Cred_5217 VDD.$225.Metal1 vout1.$1226.Metal3 0.0232915f
Cred_5218 VDD.$225.Metal1 vout1.P0.nSD 0.000693546f
Cred_5219 VDD.$225.Metal1 vout1.P0.pSD 0.0269419f
Cred_5220 VDD.$225.Metal1 vout1.P2.nSD 0.000366935f
Cred_5221 VDD.$225.Metal1 vout1.P2.pSD 0.00200538f
Cred_5222 VDD.$225.Metal1 VSS.$1989.Metal1 1.36818e-07f
Cred_5223 VDD.$225.Metal1 VSS.$2020.Metal1 3.42565e-07f
Cred_5224 VDD.$225.Metal1 VSS.$29.Metal1 0.000781591f
Cred_5225 VDD.$225.Metal1 VSS.$4227.Metal2 9.17147e-10f
Cred_5226 VDD.$225.Metal1 VSS.$4355.Metal3 8.51971e-05f
Cred_5227 VDD.$225.Metal1 VSS.P1.pSD 0.00198979f
Cred_5228 VDD.$226.Metal1 vin1.P20.GatPoly 0.0186593f
Cred_5229 VDD.$226.Metal1 vout1.$1226.Metal3 0.00306088f
Cred_5230 VDD.$226.Metal1 vout1.P0.nSD 9.11433e-05f
Cred_5231 VDD.$226.Metal1 vout1.P0.pSD 0.00420443f
Cred_5232 VDD.$226.Metal1 vout1.P2.nSD 4.82213e-05f
Cred_5233 VDD.$226.Metal1 vout1.P2.pSD 0.00026354f
Cred_5234 VDD.$2263.Metal1 vin1.P30.GatPoly 0.00165175f
Cred_5235 VDD.$2263.Metal1 vin2.P30.GatPoly 0.00165175f
Cred_5236 VDD.$2263.Metal1 vout1.$1292.Metal3 0.00295429f
Cred_5237 VDD.$2263.Metal1 vout1.$1358.Metal3 0.00295429f
Cred_5238 VDD.$2263.Metal1 vout1.P10.nSD 4.6542e-05f
Cred_5239 VDD.$2263.Metal1 vout1.P10.pSD 0.00452145f
Cred_5240 VDD.$2263.Metal1 vout2.$1292.Metal3 0.00295429f
Cred_5241 VDD.$2263.Metal1 vout2.$1358.Metal3 0.00295429f
Cred_5242 VDD.$2263.Metal1 vout2.P10.nSD 4.6542e-05f
Cred_5243 VDD.$2263.Metal1 vout2.P10.pSD 0.00452145f
Cred_5244 VDD.$2267.Metal1 vin3.P30.GatPoly 0.00165175f
Cred_5245 VDD.$2267.Metal1 vin4.P30.GatPoly 0.00165175f
Cred_5246 VDD.$2267.Metal1 vout3.$1292.Metal3 0.00295429f
Cred_5247 VDD.$2267.Metal1 vout3.$1358.Metal3 0.00295429f
Cred_5248 VDD.$2267.Metal1 vout3.P10.nSD 4.6542e-05f
Cred_5249 VDD.$2267.Metal1 vout3.P10.pSD 0.00452145f
Cred_5250 VDD.$2267.Metal1 vout4.$1292.Metal3 0.00295429f
Cred_5251 VDD.$2267.Metal1 vout4.$1358.Metal3 0.00295429f
Cred_5252 VDD.$2267.Metal1 vout4.P10.nSD 4.6542e-05f
Cred_5253 VDD.$2267.Metal1 vout4.P10.pSD 0.00452145f
Cred_5254 VDD.$2283.Metal1 vin1.P31.GatPoly 0.00913622f
Cred_5255 VDD.$2283.Metal1 vin2.P31.GatPoly 0.00913622f
Cred_5256 VDD.$2283.Metal1 vout1.$1292.Metal3 0.00314596f
Cred_5257 VDD.$2283.Metal1 vout1.$1358.Metal3 0.00314596f
Cred_5258 VDD.$2283.Metal1 vout1.P10.nSD 4.95616e-05f
Cred_5259 VDD.$2283.Metal1 vout1.P10.pSD 0.00441465f
Cred_5260 VDD.$2283.Metal1 vout2.$1292.Metal3 0.00314596f
Cred_5261 VDD.$2283.Metal1 vout2.$1358.Metal3 0.00314596f
Cred_5262 VDD.$2283.Metal1 vout2.P10.nSD 4.95616e-05f
Cred_5263 VDD.$2283.Metal1 vout2.P10.pSD 0.00441465f
Cred_5264 VDD.$2287.Metal1 vin3.P31.GatPoly 0.00913622f
Cred_5265 VDD.$2287.Metal1 vin4.P31.GatPoly 0.00913622f
Cred_5266 VDD.$2287.Metal1 vout3.$1292.Metal3 0.00314596f
Cred_5267 VDD.$2287.Metal1 vout3.$1358.Metal3 0.00314596f
Cred_5268 VDD.$2287.Metal1 vout3.P10.nSD 4.95616e-05f
Cred_5269 VDD.$2287.Metal1 vout3.P10.pSD 0.00441465f
Cred_5270 VDD.$2287.Metal1 vout4.$1292.Metal3 0.00314596f
Cred_5271 VDD.$2287.Metal1 vout4.$1358.Metal3 0.00314596f
Cred_5272 VDD.$2287.Metal1 vout4.P10.nSD 4.95616e-05f
Cred_5273 VDD.$2287.Metal1 vout4.P10.pSD 0.00441465f
Cred_5274 VDD.$2323.Metal1 vin1.$353.Metal1 3.64965e-08f
Cred_5275 VDD.$2323.Metal1 vin1.$357.Metal1 5.56727e-09f
Cred_5276 VDD.$2323.Metal1 vin1.$578.Metal2 2.20846e-06f
Cred_5277 VDD.$2323.Metal1 vin1.$582.Metal2 2.20846e-06f
Cred_5278 VDD.$2323.Metal1 vin1.P31.GatPoly 0.0190602f
Cred_5279 VDD.$2323.Metal1 vin2.$352.Metal1 3.64965e-08f
Cred_5280 VDD.$2323.Metal1 vin2.$356.Metal1 5.56727e-09f
Cred_5281 VDD.$2323.Metal1 vin2.$577.Metal2 2.20846e-06f
Cred_5282 VDD.$2323.Metal1 vin2.$581.Metal2 2.20846e-06f
Cred_5283 VDD.$2323.Metal1 vin2.P31.GatPoly 0.0190602f
Cred_5284 VDD.$2323.Metal1 vout1.$1292.Metal3 0.000360902f
Cred_5285 VDD.$2323.Metal1 vout1.$1358.Metal3 0.000360902f
Cred_5286 VDD.$2323.Metal1 vout1.P10.nSD 5.68568e-06f
Cred_5287 VDD.$2323.Metal1 vout1.P10.pSD 0.000154026f
Cred_5288 VDD.$2323.Metal1 vout2.$1292.Metal3 0.000360902f
Cred_5289 VDD.$2323.Metal1 vout2.$1358.Metal3 0.000360902f
Cred_5290 VDD.$2323.Metal1 vout2.P10.nSD 5.68568e-06f
Cred_5291 VDD.$2323.Metal1 vout2.P10.pSD 0.000154026f
Cred_5292 VDD.$2327.Metal1 vin3.$353.Metal1 3.64965e-08f
Cred_5293 VDD.$2327.Metal1 vin3.$357.Metal1 5.56727e-09f
Cred_5294 VDD.$2327.Metal1 vin3.$578.Metal2 2.20846e-06f
Cred_5295 VDD.$2327.Metal1 vin3.$582.Metal2 2.20846e-06f
Cred_5296 VDD.$2327.Metal1 vin3.P31.GatPoly 0.0190602f
Cred_5297 VDD.$2327.Metal1 vin4.$352.Metal1 3.64965e-08f
Cred_5298 VDD.$2327.Metal1 vin4.$356.Metal1 5.56727e-09f
Cred_5299 VDD.$2327.Metal1 vin4.$577.Metal2 2.20846e-06f
Cred_5300 VDD.$2327.Metal1 vin4.$581.Metal2 2.20846e-06f
Cred_5301 VDD.$2327.Metal1 vin4.P31.GatPoly 0.0190602f
Cred_5302 VDD.$2327.Metal1 vout3.$1292.Metal3 0.000360902f
Cred_5303 VDD.$2327.Metal1 vout3.$1358.Metal3 0.000360902f
Cred_5304 VDD.$2327.Metal1 vout3.P10.nSD 5.68568e-06f
Cred_5305 VDD.$2327.Metal1 vout3.P10.pSD 0.000154026f
Cred_5306 VDD.$2327.Metal1 vout4.$1292.Metal3 0.000360902f
Cred_5307 VDD.$2327.Metal1 vout4.$1358.Metal3 0.000360902f
Cred_5308 VDD.$2327.Metal1 vout4.P10.nSD 5.68568e-06f
Cred_5309 VDD.$2327.Metal1 vout4.P10.pSD 0.000154026f
Cred_5310 VDD.$2330.Metal1 vin1.$107.GatPoly 0.0272867f
Cred_5311 VDD.$2330.Metal1 vin1.$115.GatPoly 0.0143994f
Cred_5312 VDD.$2330.Metal1 vin1.$123.GatPoly 0.00801059f
Cred_5313 VDD.$2330.Metal1 vin1.$353.Metal1 0.000304785f
Cred_5314 VDD.$2330.Metal1 vin1.$357.Metal1 0.0145832f
Cred_5315 VDD.$2330.Metal1 vin1.$365.Metal1 0.00962289f
Cred_5316 VDD.$2330.Metal1 vin1.$369.Metal1 0.00423671f
Cred_5317 VDD.$2330.Metal1 vin1.$578.Metal2 0.000160479f
Cred_5318 VDD.$2330.Metal1 vin1.$582.Metal2 0.0142661f
Cred_5319 VDD.$2330.Metal1 vin1.$584.Metal2 0.00126646f
Cred_5320 VDD.$2330.Metal1 vin1.$587.Metal2 0.00671893f
Cred_5321 VDD.$2330.Metal1 vin1.P30.GatPoly 0.0010479f
Cred_5322 VDD.$2330.Metal1 vin1.P31.GatPoly 0.139419f
Cred_5323 VDD.$2330.Metal1 vin1.P32.GatPoly 0.143003f
Cred_5324 VDD.$2330.Metal1 vin1.P33.GatPoly 0.0010479f
Cred_5325 VDD.$2330.Metal1 vin2.$106.GatPoly 0.0272867f
Cred_5326 VDD.$2330.Metal1 vin2.$114.GatPoly 0.0143994f
Cred_5327 VDD.$2330.Metal1 vin2.$122.GatPoly 0.00801059f
Cred_5328 VDD.$2330.Metal1 vin2.$352.Metal1 0.000304785f
Cred_5329 VDD.$2330.Metal1 vin2.$356.Metal1 0.0145832f
Cred_5330 VDD.$2330.Metal1 vin2.$364.Metal1 0.00962289f
Cred_5331 VDD.$2330.Metal1 vin2.$368.Metal1 0.00423671f
Cred_5332 VDD.$2330.Metal1 vin2.$577.Metal2 0.000160479f
Cred_5333 VDD.$2330.Metal1 vin2.$581.Metal2 0.0142661f
Cred_5334 VDD.$2330.Metal1 vin2.$584.Metal2 0.00126646f
Cred_5335 VDD.$2330.Metal1 vin2.$586.Metal2 0.00671893f
Cred_5336 VDD.$2330.Metal1 vin2.P30.GatPoly 0.0010479f
Cred_5337 VDD.$2330.Metal1 vin2.P31.GatPoly 0.139419f
Cred_5338 VDD.$2330.Metal1 vin2.P32.GatPoly 0.143003f
Cred_5339 VDD.$2330.Metal1 vin2.P33.GatPoly 0.0010479f
Cred_5340 VDD.$2330.Metal1 vout1.$1292.Metal3 0.041849f
Cred_5341 VDD.$2330.Metal1 vout1.$1358.Metal3 0.129429f
Cred_5342 VDD.$2330.Metal1 vout1.P10.nSD 0.000659291f
Cred_5343 VDD.$2330.Metal1 vout1.P10.pSD 0.050794f
Cred_5344 VDD.$2330.Metal1 vout1.P12.pSD 0.0450881f
Cred_5345 VDD.$2330.Metal1 vout2.$1292.Metal3 0.0419838f
Cred_5346 VDD.$2330.Metal1 vout2.$1358.Metal3 0.12896f
Cred_5347 VDD.$2330.Metal1 vout2.P10.nSD 0.000661415f
Cred_5348 VDD.$2330.Metal1 vout2.P10.pSD 0.0508239f
Cred_5349 VDD.$2330.Metal1 vout2.P12.pSD 0.0450332f
Cred_5350 VDD.$2331.Metal1 vin3.$107.GatPoly 0.0272867f
Cred_5351 VDD.$2331.Metal1 vin3.$115.GatPoly 0.0143994f
Cred_5352 VDD.$2331.Metal1 vin3.$123.GatPoly 0.00801059f
Cred_5353 VDD.$2331.Metal1 vin3.$353.Metal1 0.000304785f
Cred_5354 VDD.$2331.Metal1 vin3.$357.Metal1 0.0145832f
Cred_5355 VDD.$2331.Metal1 vin3.$365.Metal1 0.00962289f
Cred_5356 VDD.$2331.Metal1 vin3.$369.Metal1 0.00423671f
Cred_5357 VDD.$2331.Metal1 vin3.$578.Metal2 0.000160479f
Cred_5358 VDD.$2331.Metal1 vin3.$582.Metal2 0.0142661f
Cred_5359 VDD.$2331.Metal1 vin3.$584.Metal2 0.00126646f
Cred_5360 VDD.$2331.Metal1 vin3.$587.Metal2 0.00671893f
Cred_5361 VDD.$2331.Metal1 vin3.P30.GatPoly 0.0010479f
Cred_5362 VDD.$2331.Metal1 vin3.P31.GatPoly 0.139419f
Cred_5363 VDD.$2331.Metal1 vin3.P32.GatPoly 0.143003f
Cred_5364 VDD.$2331.Metal1 vin3.P33.GatPoly 0.0010479f
Cred_5365 VDD.$2331.Metal1 vin4.$106.GatPoly 0.0272867f
Cred_5366 VDD.$2331.Metal1 vin4.$114.GatPoly 0.0143994f
Cred_5367 VDD.$2331.Metal1 vin4.$122.GatPoly 0.00801059f
Cred_5368 VDD.$2331.Metal1 vin4.$352.Metal1 0.000304785f
Cred_5369 VDD.$2331.Metal1 vin4.$356.Metal1 0.0145832f
Cred_5370 VDD.$2331.Metal1 vin4.$364.Metal1 0.00962289f
Cred_5371 VDD.$2331.Metal1 vin4.$368.Metal1 0.00423671f
Cred_5372 VDD.$2331.Metal1 vin4.$577.Metal2 0.000160479f
Cred_5373 VDD.$2331.Metal1 vin4.$581.Metal2 0.0142661f
Cred_5374 VDD.$2331.Metal1 vin4.$584.Metal2 0.00126646f
Cred_5375 VDD.$2331.Metal1 vin4.$586.Metal2 0.00671893f
Cred_5376 VDD.$2331.Metal1 vin4.P30.GatPoly 0.0010479f
Cred_5377 VDD.$2331.Metal1 vin4.P31.GatPoly 0.139419f
Cred_5378 VDD.$2331.Metal1 vin4.P32.GatPoly 0.143003f
Cred_5379 VDD.$2331.Metal1 vin4.P33.GatPoly 0.0010479f
Cred_5380 VDD.$2331.Metal1 vout3.$1292.Metal3 0.041849f
Cred_5381 VDD.$2331.Metal1 vout3.$1358.Metal3 0.129429f
Cred_5382 VDD.$2331.Metal1 vout3.P10.nSD 0.000659291f
Cred_5383 VDD.$2331.Metal1 vout3.P10.pSD 0.050794f
Cred_5384 VDD.$2331.Metal1 vout3.P12.pSD 0.0450881f
Cred_5385 VDD.$2331.Metal1 vout4.$1292.Metal3 0.0419838f
Cred_5386 VDD.$2331.Metal1 vout4.$1358.Metal3 0.12896f
Cred_5387 VDD.$2331.Metal1 vout4.P10.nSD 0.000661415f
Cred_5388 VDD.$2331.Metal1 vout4.P10.pSD 0.0508239f
Cred_5389 VDD.$2331.Metal1 vout4.P12.pSD 0.0450332f
Cred_5390 VDD.$2389.Metal1 vin1.$353.Metal1 5.44724e-10f
Cred_5391 VDD.$2389.Metal1 vin1.$357.Metal1 8.30935e-11f
Cred_5392 VDD.$2389.Metal1 vin1.$578.Metal2 3.29621e-08f
Cred_5393 VDD.$2389.Metal1 vin1.$582.Metal2 3.29621e-08f
Cred_5394 VDD.$2389.Metal1 vin1.P31.GatPoly 5.74063e-05f
Cred_5395 VDD.$2389.Metal1 vin2.$352.Metal1 5.44724e-10f
Cred_5396 VDD.$2389.Metal1 vin2.$356.Metal1 8.30935e-11f
Cred_5397 VDD.$2389.Metal1 vin2.$577.Metal2 3.29621e-08f
Cred_5398 VDD.$2389.Metal1 vin2.$581.Metal2 3.29621e-08f
Cred_5399 VDD.$2389.Metal1 vin2.P31.GatPoly 5.74063e-05f
Cred_5400 VDD.$2393.Metal1 vin3.$353.Metal1 5.44724e-10f
Cred_5401 VDD.$2393.Metal1 vin3.$357.Metal1 8.30935e-11f
Cred_5402 VDD.$2393.Metal1 vin3.$578.Metal2 3.29621e-08f
Cred_5403 VDD.$2393.Metal1 vin3.$582.Metal2 3.29621e-08f
Cred_5404 VDD.$2393.Metal1 vin3.P31.GatPoly 5.74063e-05f
Cred_5405 VDD.$2393.Metal1 vin4.$352.Metal1 5.44724e-10f
Cred_5406 VDD.$2393.Metal1 vin4.$356.Metal1 8.30935e-11f
Cred_5407 VDD.$2393.Metal1 vin4.$577.Metal2 3.29621e-08f
Cred_5408 VDD.$2393.Metal1 vin4.$581.Metal2 3.29621e-08f
Cred_5409 VDD.$2393.Metal1 vin4.P31.GatPoly 5.74063e-05f
Cred_5410 VDD.$2477.Metal1 vin1.P32.GatPoly 0.00116491f
Cred_5411 VDD.$2477.Metal1 vin2.P32.GatPoly 0.00116491f
Cred_5412 VDD.$2481.Metal1 vin3.P32.GatPoly 0.00116491f
Cred_5413 VDD.$2481.Metal1 vin4.P32.GatPoly 0.00116491f
Cred_5414 VDD.$2553.Metal1 vin1.P32.GatPoly 0.0116726f
Cred_5415 VDD.$2553.Metal1 vin2.P32.GatPoly 0.0116726f
Cred_5416 VDD.$2557.Metal1 vin3.P32.GatPoly 0.0116726f
Cred_5417 VDD.$2557.Metal1 vin4.P32.GatPoly 0.0116726f
Cred_5418 VDD.$2573.Metal1 vin1.P32.GatPoly 0.0125026f
Cred_5419 VDD.$2573.Metal1 vin2.P32.GatPoly 0.0125026f
Cred_5420 VDD.$2573.Metal1 vout1.$1358.Metal3 0.00152447f
Cred_5421 VDD.$2573.Metal1 vout1.P12.pSD 0.000248467f
Cred_5422 VDD.$2573.Metal1 vout2.$1358.Metal3 0.00152447f
Cred_5423 VDD.$2573.Metal1 vout2.P12.pSD 0.000248467f
Cred_5424 VDD.$2577.Metal1 vin3.P32.GatPoly 0.0125026f
Cred_5425 VDD.$2577.Metal1 vin4.P32.GatPoly 0.0125026f
Cred_5426 VDD.$2577.Metal1 vout3.$1358.Metal3 0.00152447f
Cred_5427 VDD.$2577.Metal1 vout3.P12.pSD 0.000248467f
Cred_5428 VDD.$2577.Metal1 vout4.$1358.Metal3 0.00152447f
Cred_5429 VDD.$2577.Metal1 vout4.P12.pSD 0.000248467f
Cred_5430 VDD.$259.Metal1 vin3.$203.Metal1 0.0213752f
Cred_5431 VDD.$259.Metal1 vin3.$477.Metal2 0.00236011f
Cred_5432 VDD.$259.Metal1 vin3.$480.Metal2 0.00484604f
Cred_5433 VDD.$259.Metal1 vin3.$9.GatPoly 0.00240373f
Cred_5434 VDD.$259.Metal1 vin3.P20.GatPoly 0.0766044f
Cred_5435 VDD.$259.Metal1 vout3.$1226.Metal3 0.0232464f
Cred_5436 VDD.$259.Metal1 vout3.P0.nSD 0.000692205f
Cred_5437 VDD.$259.Metal1 vout3.P0.pSD 0.0269292f
Cred_5438 VDD.$259.Metal1 vout3.P2.nSD 0.000366226f
Cred_5439 VDD.$259.Metal1 vout3.P2.pSD 0.00200151f
Cred_5440 VDD.$259.Metal1 VSS.$1990.Metal1 3.92268e-07f
Cred_5441 VDD.$259.Metal1 VSS.$4358.Metal3 0.000296509f
Cred_5442 VDD.$259.Metal1 VSS.$68.Metal1 0.000566838f
Cred_5443 VDD.$259.Metal1 VSS.P2.pSD 0.00220463f
Cred_5444 VDD.$2593.Metal1 vin1.P32.GatPoly 0.00434306f
Cred_5445 VDD.$2593.Metal1 vin1.P33.GatPoly 0.000964924f
Cred_5446 VDD.$2593.Metal1 vin2.P32.GatPoly 0.00434306f
Cred_5447 VDD.$2593.Metal1 vin2.P33.GatPoly 0.000964924f
Cred_5448 VDD.$2593.Metal1 vout1.$1358.Metal3 0.00894384f
Cred_5449 VDD.$2593.Metal1 vout1.P12.pSD 0.00614802f
Cred_5450 VDD.$2593.Metal1 vout2.$1358.Metal3 0.00894384f
Cred_5451 VDD.$2593.Metal1 vout2.P12.pSD 0.00614802f
Cred_5452 VDD.$2597.Metal1 vin3.P32.GatPoly 0.00434306f
Cred_5453 VDD.$2597.Metal1 vin3.P33.GatPoly 0.000964924f
Cred_5454 VDD.$2597.Metal1 vin4.P32.GatPoly 0.00434306f
Cred_5455 VDD.$2597.Metal1 vin4.P33.GatPoly 0.000964924f
Cred_5456 VDD.$2597.Metal1 vout3.$1358.Metal3 0.00894384f
Cred_5457 VDD.$2597.Metal1 vout3.P12.pSD 0.00614802f
Cred_5458 VDD.$2597.Metal1 vout4.$1358.Metal3 0.00894384f
Cred_5459 VDD.$2597.Metal1 vout4.P12.pSD 0.00614802f
Cred_5460 VDD.$260.Metal1 vin3.P20.GatPoly 0.0186593f
Cred_5461 VDD.$260.Metal1 vout3.$1226.Metal3 0.00306088f
Cred_5462 VDD.$260.Metal1 vout3.P0.nSD 9.11433e-05f
Cred_5463 VDD.$260.Metal1 vout3.P0.pSD 0.00420443f
Cred_5464 VDD.$260.Metal1 vout3.P2.nSD 4.82213e-05f
Cred_5465 VDD.$260.Metal1 vout3.P2.pSD 0.00026354f
Cred_5466 VDD.$2621.Metal1 vin1.$379.Metal1 2.72403e-08f
Cred_5467 VDD.$2621.Metal1 vin1.$383.Metal1 2.47665e-08f
Cred_5468 VDD.$2621.Metal1 vin1.$387.Metal1 1.20081e-08f
Cred_5469 VDD.$2621.Metal1 vin1.$596.Metal2 2.26694e-06f
Cred_5470 VDD.$2621.Metal1 vin1.$603.Metal2 1.14393e-06f
Cred_5471 VDD.$2621.Metal1 vin1.P33.GatPoly 0.0133734f
Cred_5472 VDD.$2621.Metal1 vin2.$378.Metal1 2.72403e-08f
Cred_5473 VDD.$2621.Metal1 vin2.$382.Metal1 2.47665e-08f
Cred_5474 VDD.$2621.Metal1 vin2.$386.Metal1 1.20081e-08f
Cred_5475 VDD.$2621.Metal1 vin2.$595.Metal2 2.26694e-06f
Cred_5476 VDD.$2621.Metal1 vin2.$601.Metal2 1.14393e-06f
Cred_5477 VDD.$2621.Metal1 vin2.P33.GatPoly 0.0133734f
Cred_5478 VDD.$2621.Metal1 vout1.$1358.Metal3 0.00504627f
Cred_5479 VDD.$2621.Metal1 vout1.P12.pSD 0.00244246f
Cred_5480 VDD.$2621.Metal1 vout2.$1358.Metal3 0.00504627f
Cred_5481 VDD.$2621.Metal1 vout2.P12.pSD 0.00244246f
Cred_5482 VDD.$2625.Metal1 vin3.$379.Metal1 2.72403e-08f
Cred_5483 VDD.$2625.Metal1 vin3.$383.Metal1 2.47665e-08f
Cred_5484 VDD.$2625.Metal1 vin3.$387.Metal1 1.20081e-08f
Cred_5485 VDD.$2625.Metal1 vin3.$596.Metal2 2.26694e-06f
Cred_5486 VDD.$2625.Metal1 vin3.$603.Metal2 1.14393e-06f
Cred_5487 VDD.$2625.Metal1 vin3.P33.GatPoly 0.0133734f
Cred_5488 VDD.$2625.Metal1 vin4.$378.Metal1 2.72403e-08f
Cred_5489 VDD.$2625.Metal1 vin4.$382.Metal1 2.47665e-08f
Cred_5490 VDD.$2625.Metal1 vin4.$386.Metal1 1.20081e-08f
Cred_5491 VDD.$2625.Metal1 vin4.$595.Metal2 2.26694e-06f
Cred_5492 VDD.$2625.Metal1 vin4.$601.Metal2 1.14393e-06f
Cred_5493 VDD.$2625.Metal1 vin4.P33.GatPoly 0.0133734f
Cred_5494 VDD.$2625.Metal1 vout3.$1358.Metal3 0.00504627f
Cred_5495 VDD.$2625.Metal1 vout3.P12.pSD 0.00244246f
Cred_5496 VDD.$2625.Metal1 vout4.$1358.Metal3 0.00504627f
Cred_5497 VDD.$2625.Metal1 vout4.P12.pSD 0.00244246f
Cred_5498 VDD.$2641.Metal1 vin1.$379.Metal1 9.08009e-09f
Cred_5499 VDD.$2641.Metal1 vin1.$383.Metal1 8.2555e-09f
Cred_5500 VDD.$2641.Metal1 vin1.$387.Metal1 4.00271e-09f
Cred_5501 VDD.$2641.Metal1 vin1.$596.Metal2 7.55647e-07f
Cred_5502 VDD.$2641.Metal1 vin1.$603.Metal2 3.81309e-07f
Cred_5503 VDD.$2641.Metal1 vin1.P33.GatPoly 0.012987f
Cred_5504 VDD.$2641.Metal1 vin2.$378.Metal1 9.08009e-09f
Cred_5505 VDD.$2641.Metal1 vin2.$382.Metal1 8.2555e-09f
Cred_5506 VDD.$2641.Metal1 vin2.$386.Metal1 4.00271e-09f
Cred_5507 VDD.$2641.Metal1 vin2.$595.Metal2 7.55647e-07f
Cred_5508 VDD.$2641.Metal1 vin2.$601.Metal2 3.81309e-07f
Cred_5509 VDD.$2641.Metal1 vin2.P33.GatPoly 0.012987f
Cred_5510 VDD.$2641.Metal1 vout1.$1358.Metal3 1.47586e-06f
Cred_5511 VDD.$2641.Metal1 vout1.P12.pSD 2.39848e-07f
Cred_5512 VDD.$2641.Metal1 vout2.$1358.Metal3 1.47586e-06f
Cred_5513 VDD.$2641.Metal1 vout2.P12.pSD 2.39848e-07f
Cred_5514 VDD.$2645.Metal1 vin3.$379.Metal1 9.08009e-09f
Cred_5515 VDD.$2645.Metal1 vin3.$383.Metal1 8.2555e-09f
Cred_5516 VDD.$2645.Metal1 vin3.$387.Metal1 4.00271e-09f
Cred_5517 VDD.$2645.Metal1 vin3.$596.Metal2 7.55647e-07f
Cred_5518 VDD.$2645.Metal1 vin3.$603.Metal2 3.81309e-07f
Cred_5519 VDD.$2645.Metal1 vin3.P33.GatPoly 0.012987f
Cred_5520 VDD.$2645.Metal1 vin4.$378.Metal1 9.08009e-09f
Cred_5521 VDD.$2645.Metal1 vin4.$382.Metal1 8.2555e-09f
Cred_5522 VDD.$2645.Metal1 vin4.$386.Metal1 4.00271e-09f
Cred_5523 VDD.$2645.Metal1 vin4.$595.Metal2 7.55647e-07f
Cred_5524 VDD.$2645.Metal1 vin4.$601.Metal2 3.81309e-07f
Cred_5525 VDD.$2645.Metal1 vin4.P33.GatPoly 0.012987f
Cred_5526 VDD.$2645.Metal1 vout3.$1358.Metal3 1.47586e-06f
Cred_5527 VDD.$2645.Metal1 vout3.P12.pSD 2.39848e-07f
Cred_5528 VDD.$2645.Metal1 vout4.$1358.Metal3 1.47586e-06f
Cred_5529 VDD.$2645.Metal1 vout4.P12.pSD 2.39848e-07f
Cred_5530 VDD.$2660.Metal1 vin1.$127.GatPoly 0.0273587f
Cred_5531 VDD.$2660.Metal1 vin1.$135.GatPoly 0.00789623f
Cred_5532 VDD.$2660.Metal1 vin1.$137.GatPoly 0.0264793f
Cred_5533 VDD.$2660.Metal1 vin1.$379.Metal1 1.57897e-05f
Cred_5534 VDD.$2660.Metal1 vin1.$383.Metal1 0.000252775f
Cred_5535 VDD.$2660.Metal1 vin1.$387.Metal1 0.0138523f
Cred_5536 VDD.$2660.Metal1 vin1.$393.Metal1 0.00725627f
Cred_5537 VDD.$2660.Metal1 vin1.$593.Metal2 0.000430233f
Cred_5538 VDD.$2660.Metal1 vin1.$596.Metal2 0.00131402f
Cred_5539 VDD.$2660.Metal1 vin1.$599.Metal2 7.3638e-06f
Cred_5540 VDD.$2660.Metal1 vin1.$603.Metal2 0.0184138f
Cred_5541 VDD.$2660.Metal1 vin1.$604.Metal2 0.000193913f
Cred_5542 VDD.$2660.Metal1 vin1.$609.Metal2 0.00186292f
Cred_5543 VDD.$2660.Metal1 vin1.$613.Metal2 0.000430233f
Cred_5544 VDD.$2660.Metal1 vin1.P32.GatPoly 0.00104864f
Cred_5545 VDD.$2660.Metal1 vin1.P33.GatPoly 0.14059f
Cred_5546 VDD.$2660.Metal1 vin1.P34.GatPoly 0.138031f
Cred_5547 VDD.$2660.Metal1 vin1.P35.GatPoly 0.00104864f
Cred_5548 VDD.$2660.Metal1 vin2.$126.GatPoly 0.0273587f
Cred_5549 VDD.$2660.Metal1 vin2.$134.GatPoly 0.00789623f
Cred_5550 VDD.$2660.Metal1 vin2.$136.GatPoly 0.0264793f
Cred_5551 VDD.$2660.Metal1 vin2.$378.Metal1 1.57897e-05f
Cred_5552 VDD.$2660.Metal1 vin2.$382.Metal1 0.000252775f
Cred_5553 VDD.$2660.Metal1 vin2.$386.Metal1 0.0138523f
Cred_5554 VDD.$2660.Metal1 vin2.$392.Metal1 0.00725627f
Cred_5555 VDD.$2660.Metal1 vin2.$593.Metal2 0.000430233f
Cred_5556 VDD.$2660.Metal1 vin2.$595.Metal2 0.00131402f
Cred_5557 VDD.$2660.Metal1 vin2.$600.Metal2 7.3638e-06f
Cred_5558 VDD.$2660.Metal1 vin2.$601.Metal2 0.0184138f
Cred_5559 VDD.$2660.Metal1 vin2.$605.Metal2 0.000193913f
Cred_5560 VDD.$2660.Metal1 vin2.$608.Metal2 0.00186292f
Cred_5561 VDD.$2660.Metal1 vin2.$613.Metal2 0.000430233f
Cred_5562 VDD.$2660.Metal1 vin2.P32.GatPoly 0.00104864f
Cred_5563 VDD.$2660.Metal1 vin2.P33.GatPoly 0.14059f
Cred_5564 VDD.$2660.Metal1 vin2.P34.GatPoly 0.138031f
Cred_5565 VDD.$2660.Metal1 vin2.P35.GatPoly 0.00104864f
Cred_5566 VDD.$2660.Metal1 vout1.$1358.Metal3 0.129839f
Cred_5567 VDD.$2660.Metal1 vout1.$1424.Metal3 0.0418187f
Cred_5568 VDD.$2660.Metal1 vout1.P12.pSD 0.047259f
Cred_5569 VDD.$2660.Metal1 vout1.P14.nSD 0.000658815f
Cred_5570 VDD.$2660.Metal1 vout1.P14.pSD 0.0489225f
Cred_5571 VDD.$2660.Metal1 vout2.$1358.Metal3 0.130202f
Cred_5572 VDD.$2660.Metal1 vout2.$1424.Metal3 0.0415767f
Cred_5573 VDD.$2660.Metal1 vout2.P12.pSD 0.0473141f
Cred_5574 VDD.$2660.Metal1 vout2.P14.nSD 0.000655003f
Cred_5575 VDD.$2660.Metal1 vout2.P14.pSD 0.0488625f
Cred_5576 VDD.$2661.Metal1 vin3.$127.GatPoly 0.0273587f
Cred_5577 VDD.$2661.Metal1 vin3.$135.GatPoly 0.00789623f
Cred_5578 VDD.$2661.Metal1 vin3.$137.GatPoly 0.0264793f
Cred_5579 VDD.$2661.Metal1 vin3.$379.Metal1 1.57897e-05f
Cred_5580 VDD.$2661.Metal1 vin3.$383.Metal1 0.000252775f
Cred_5581 VDD.$2661.Metal1 vin3.$387.Metal1 0.0138523f
Cred_5582 VDD.$2661.Metal1 vin3.$393.Metal1 0.00725627f
Cred_5583 VDD.$2661.Metal1 vin3.$593.Metal2 0.000430233f
Cred_5584 VDD.$2661.Metal1 vin3.$596.Metal2 0.00131402f
Cred_5585 VDD.$2661.Metal1 vin3.$599.Metal2 7.3638e-06f
Cred_5586 VDD.$2661.Metal1 vin3.$603.Metal2 0.0184138f
Cred_5587 VDD.$2661.Metal1 vin3.$604.Metal2 0.000193913f
Cred_5588 VDD.$2661.Metal1 vin3.$609.Metal2 0.00186292f
Cred_5589 VDD.$2661.Metal1 vin3.$613.Metal2 0.000430233f
Cred_5590 VDD.$2661.Metal1 vin3.P32.GatPoly 0.00104864f
Cred_5591 VDD.$2661.Metal1 vin3.P33.GatPoly 0.14059f
Cred_5592 VDD.$2661.Metal1 vin3.P34.GatPoly 0.138031f
Cred_5593 VDD.$2661.Metal1 vin3.P35.GatPoly 0.00104864f
Cred_5594 VDD.$2661.Metal1 vin4.$126.GatPoly 0.0273587f
Cred_5595 VDD.$2661.Metal1 vin4.$134.GatPoly 0.00789623f
Cred_5596 VDD.$2661.Metal1 vin4.$136.GatPoly 0.0264793f
Cred_5597 VDD.$2661.Metal1 vin4.$378.Metal1 1.57897e-05f
Cred_5598 VDD.$2661.Metal1 vin4.$382.Metal1 0.000252775f
Cred_5599 VDD.$2661.Metal1 vin4.$386.Metal1 0.0138523f
Cred_5600 VDD.$2661.Metal1 vin4.$392.Metal1 0.00725627f
Cred_5601 VDD.$2661.Metal1 vin4.$593.Metal2 0.000430233f
Cred_5602 VDD.$2661.Metal1 vin4.$595.Metal2 0.00131402f
Cred_5603 VDD.$2661.Metal1 vin4.$600.Metal2 7.3638e-06f
Cred_5604 VDD.$2661.Metal1 vin4.$601.Metal2 0.0184138f
Cred_5605 VDD.$2661.Metal1 vin4.$605.Metal2 0.000193913f
Cred_5606 VDD.$2661.Metal1 vin4.$608.Metal2 0.00186292f
Cred_5607 VDD.$2661.Metal1 vin4.$613.Metal2 0.000430233f
Cred_5608 VDD.$2661.Metal1 vin4.P32.GatPoly 0.00104864f
Cred_5609 VDD.$2661.Metal1 vin4.P33.GatPoly 0.14059f
Cred_5610 VDD.$2661.Metal1 vin4.P34.GatPoly 0.138031f
Cred_5611 VDD.$2661.Metal1 vin4.P35.GatPoly 0.00104864f
Cred_5612 VDD.$2661.Metal1 vout3.$1358.Metal3 0.129839f
Cred_5613 VDD.$2661.Metal1 vout3.$1424.Metal3 0.0418187f
Cred_5614 VDD.$2661.Metal1 vout3.P12.pSD 0.047259f
Cred_5615 VDD.$2661.Metal1 vout3.P14.nSD 0.000658815f
Cred_5616 VDD.$2661.Metal1 vout3.P14.pSD 0.0489225f
Cred_5617 VDD.$2661.Metal1 vout4.$1358.Metal3 0.130202f
Cred_5618 VDD.$2661.Metal1 vout4.$1424.Metal3 0.0415767f
Cred_5619 VDD.$2661.Metal1 vout4.P12.pSD 0.0473141f
Cred_5620 VDD.$2661.Metal1 vout4.P14.nSD 0.000655003f
Cred_5621 VDD.$2661.Metal1 vout4.P14.pSD 0.0488625f
Cred_5622 VDD.$2807.Metal1 vin1.P34.GatPoly 0.000423561f
Cred_5623 VDD.$2807.Metal1 vin2.P34.GatPoly 0.000423561f
Cred_5624 VDD.$2811.Metal1 vin3.P34.GatPoly 0.000423561f
Cred_5625 VDD.$2811.Metal1 vin4.P34.GatPoly 0.000423561f
Cred_5626 VDD.$2883.Metal1 vin1.P34.GatPoly 0.0181212f
Cred_5627 VDD.$2883.Metal1 vin2.P34.GatPoly 0.0181212f
Cred_5628 VDD.$2883.Metal1 vout1.$1358.Metal3 0.000257606f
Cred_5629 VDD.$2883.Metal1 vout1.$1424.Metal3 0.000257606f
Cred_5630 VDD.$2883.Metal1 vout1.P14.nSD 4.05834e-06f
Cred_5631 VDD.$2883.Metal1 vout1.P14.pSD 0.000109941f
Cred_5632 VDD.$2883.Metal1 vout2.$1358.Metal3 0.000257606f
Cred_5633 VDD.$2883.Metal1 vout2.$1424.Metal3 0.000257606f
Cred_5634 VDD.$2883.Metal1 vout2.P14.nSD 4.05834e-06f
Cred_5635 VDD.$2883.Metal1 vout2.P14.pSD 0.000109941f
Cred_5636 VDD.$2887.Metal1 vin3.P34.GatPoly 0.0181212f
Cred_5637 VDD.$2887.Metal1 vin4.P34.GatPoly 0.0181212f
Cred_5638 VDD.$2887.Metal1 vout3.$1358.Metal3 0.000257606f
Cred_5639 VDD.$2887.Metal1 vout3.$1424.Metal3 0.000257606f
Cred_5640 VDD.$2887.Metal1 vout3.P14.nSD 4.05834e-06f
Cred_5641 VDD.$2887.Metal1 vout3.P14.pSD 0.000109941f
Cred_5642 VDD.$2887.Metal1 vout4.$1358.Metal3 0.000257606f
Cred_5643 VDD.$2887.Metal1 vout4.$1424.Metal3 0.000257606f
Cred_5644 VDD.$2887.Metal1 vout4.P14.nSD 4.05834e-06f
Cred_5645 VDD.$2887.Metal1 vout4.P14.pSD 0.000109941f
Cred_5646 VDD.$2911.Metal1 vin1.P34.GatPoly 0.0109997f
Cred_5647 VDD.$2911.Metal1 vin2.P34.GatPoly 0.0109997f
Cred_5648 VDD.$2911.Metal1 vout1.$1358.Metal3 0.00305149f
Cred_5649 VDD.$2911.Metal1 vout1.$1424.Metal3 0.00305149f
Cred_5650 VDD.$2911.Metal1 vout1.P14.nSD 4.80733e-05f
Cred_5651 VDD.$2911.Metal1 vout1.P14.pSD 0.00374874f
Cred_5652 VDD.$2911.Metal1 vout2.$1358.Metal3 0.00305149f
Cred_5653 VDD.$2911.Metal1 vout2.$1424.Metal3 0.00305149f
Cred_5654 VDD.$2911.Metal1 vout2.P14.nSD 4.80733e-05f
Cred_5655 VDD.$2911.Metal1 vout2.P14.pSD 0.00374874f
Cred_5656 VDD.$2915.Metal1 vin3.P34.GatPoly 0.0109997f
Cred_5657 VDD.$2915.Metal1 vin4.P34.GatPoly 0.0109997f
Cred_5658 VDD.$2915.Metal1 vout3.$1358.Metal3 0.00305149f
Cred_5659 VDD.$2915.Metal1 vout3.$1424.Metal3 0.00305149f
Cred_5660 VDD.$2915.Metal1 vout3.P14.nSD 4.80733e-05f
Cred_5661 VDD.$2915.Metal1 vout3.P14.pSD 0.00374874f
Cred_5662 VDD.$2915.Metal1 vout4.$1358.Metal3 0.00305149f
Cred_5663 VDD.$2915.Metal1 vout4.$1424.Metal3 0.00305149f
Cred_5664 VDD.$2915.Metal1 vout4.P14.nSD 4.80733e-05f
Cred_5665 VDD.$2915.Metal1 vout4.P14.pSD 0.00374874f
Cred_5666 VDD.$2931.Metal1 vin1.P34.GatPoly 0.000472483f
Cred_5667 VDD.$2931.Metal1 vin1.P35.GatPoly 0.00167809f
Cred_5668 VDD.$2931.Metal1 vin2.P34.GatPoly 0.000472483f
Cred_5669 VDD.$2931.Metal1 vin2.P35.GatPoly 0.00167809f
Cred_5670 VDD.$2931.Metal1 vout1.$1358.Metal3 0.00299566f
Cred_5671 VDD.$2931.Metal1 vout1.$1424.Metal3 0.00299566f
Cred_5672 VDD.$2931.Metal1 vout1.P14.nSD 4.71939e-05f
Cred_5673 VDD.$2931.Metal1 vout1.P14.pSD 0.00458579f
Cred_5674 VDD.$2931.Metal1 vout2.$1358.Metal3 0.00299566f
Cred_5675 VDD.$2931.Metal1 vout2.$1424.Metal3 0.00299566f
Cred_5676 VDD.$2931.Metal1 vout2.P14.nSD 4.71939e-05f
Cred_5677 VDD.$2931.Metal1 vout2.P14.pSD 0.00458579f
Cred_5678 VDD.$2935.Metal1 vin3.P34.GatPoly 0.000472483f
Cred_5679 VDD.$2935.Metal1 vin3.P35.GatPoly 0.00167809f
Cred_5680 VDD.$2935.Metal1 vin4.P34.GatPoly 0.000472483f
Cred_5681 VDD.$2935.Metal1 vin4.P35.GatPoly 0.00167809f
Cred_5682 VDD.$2935.Metal1 vout3.$1358.Metal3 0.00299566f
Cred_5683 VDD.$2935.Metal1 vout3.$1424.Metal3 0.00299566f
Cred_5684 VDD.$2935.Metal1 vout3.P14.nSD 4.71939e-05f
Cred_5685 VDD.$2935.Metal1 vout3.P14.pSD 0.00458579f
Cred_5686 VDD.$2935.Metal1 vout4.$1358.Metal3 0.00299566f
Cred_5687 VDD.$2935.Metal1 vout4.$1424.Metal3 0.00299566f
Cred_5688 VDD.$2935.Metal1 vout4.P14.nSD 4.71939e-05f
Cred_5689 VDD.$2935.Metal1 vout4.P14.pSD 0.00458579f
Cred_5690 VDD.$2951.Metal1 vin1.$409.Metal1 2.57799e-09f
Cred_5691 VDD.$2951.Metal1 vin1.$413.Metal1 1.09069e-08f
Cred_5692 VDD.$2951.Metal1 vin1.$616.Metal2 7.08547e-07f
Cred_5693 VDD.$2951.Metal1 vin1.$620.Metal2 7.08547e-07f
Cred_5694 VDD.$2951.Metal1 vin1.P35.GatPoly 0.0114333f
Cred_5695 VDD.$2951.Metal1 vin2.$408.Metal1 2.57799e-09f
Cred_5696 VDD.$2951.Metal1 vin2.$412.Metal1 1.09069e-08f
Cred_5697 VDD.$2951.Metal1 vin2.$615.Metal2 7.08547e-07f
Cred_5698 VDD.$2951.Metal1 vin2.$619.Metal2 7.08547e-07f
Cred_5699 VDD.$2951.Metal1 vin2.P35.GatPoly 0.0114333f
Cred_5700 VDD.$2951.Metal1 vout1.$1358.Metal3 0.00098241f
Cred_5701 VDD.$2951.Metal1 vout1.$1424.Metal3 0.00098241f
Cred_5702 VDD.$2951.Metal1 vout1.P14.nSD 1.54769e-05f
Cred_5703 VDD.$2951.Metal1 vout1.P14.pSD 0.000419273f
Cred_5704 VDD.$2951.Metal1 vout2.$1358.Metal3 0.00098241f
Cred_5705 VDD.$2951.Metal1 vout2.$1424.Metal3 0.00098241f
Cred_5706 VDD.$2951.Metal1 vout2.P14.nSD 1.54769e-05f
Cred_5707 VDD.$2951.Metal1 vout2.P14.pSD 0.000419273f
Cred_5708 VDD.$2955.Metal1 vin3.$409.Metal1 2.57799e-09f
Cred_5709 VDD.$2955.Metal1 vin3.$413.Metal1 1.09069e-08f
Cred_5710 VDD.$2955.Metal1 vin3.$616.Metal2 7.08547e-07f
Cred_5711 VDD.$2955.Metal1 vin3.$620.Metal2 7.08547e-07f
Cred_5712 VDD.$2955.Metal1 vin3.P35.GatPoly 0.0114333f
Cred_5713 VDD.$2955.Metal1 vin4.$408.Metal1 2.57799e-09f
Cred_5714 VDD.$2955.Metal1 vin4.$412.Metal1 1.09069e-08f
Cred_5715 VDD.$2955.Metal1 vin4.$615.Metal2 7.08547e-07f
Cred_5716 VDD.$2955.Metal1 vin4.$619.Metal2 7.08547e-07f
Cred_5717 VDD.$2955.Metal1 vin4.P35.GatPoly 0.0114333f
Cred_5718 VDD.$2955.Metal1 vout3.$1358.Metal3 0.00098241f
Cred_5719 VDD.$2955.Metal1 vout3.$1424.Metal3 0.00098241f
Cred_5720 VDD.$2955.Metal1 vout3.P14.nSD 1.54769e-05f
Cred_5721 VDD.$2955.Metal1 vout3.P14.pSD 0.000419273f
Cred_5722 VDD.$2955.Metal1 vout4.$1358.Metal3 0.00098241f
Cred_5723 VDD.$2955.Metal1 vout4.$1424.Metal3 0.00098241f
Cred_5724 VDD.$2955.Metal1 vout4.P14.nSD 1.54769e-05f
Cred_5725 VDD.$2955.Metal1 vout4.P14.pSD 0.000419273f
Cred_5726 VDD.$2971.Metal1 vin1.$409.Metal1 5.76979e-09f
Cred_5727 VDD.$2971.Metal1 vin1.$413.Metal1 2.44106e-08f
Cred_5728 VDD.$2971.Metal1 vin1.$616.Metal2 1.5858e-06f
Cred_5729 VDD.$2971.Metal1 vin1.$620.Metal2 1.5858e-06f
Cred_5730 VDD.$2971.Metal1 vin1.P35.GatPoly 0.0143229f
Cred_5731 VDD.$2971.Metal1 vin2.$408.Metal1 5.76979e-09f
Cred_5732 VDD.$2971.Metal1 vin2.$412.Metal1 2.44106e-08f
Cred_5733 VDD.$2971.Metal1 vin2.$615.Metal2 1.5858e-06f
Cred_5734 VDD.$2971.Metal1 vin2.$619.Metal2 1.5858e-06f
Cred_5735 VDD.$2971.Metal1 vin2.P35.GatPoly 0.0143229f
Cred_5736 VDD.$2975.Metal1 vin3.$409.Metal1 5.76979e-09f
Cred_5737 VDD.$2975.Metal1 vin3.$413.Metal1 2.44106e-08f
Cred_5738 VDD.$2975.Metal1 vin3.$616.Metal2 1.5858e-06f
Cred_5739 VDD.$2975.Metal1 vin3.$620.Metal2 1.5858e-06f
Cred_5740 VDD.$2975.Metal1 vin3.P35.GatPoly 0.0143229f
Cred_5741 VDD.$2975.Metal1 vin4.$408.Metal1 5.76979e-09f
Cred_5742 VDD.$2975.Metal1 vin4.$412.Metal1 2.44106e-08f
Cred_5743 VDD.$2975.Metal1 vin4.$615.Metal2 1.5858e-06f
Cred_5744 VDD.$2975.Metal1 vin4.$619.Metal2 1.5858e-06f
Cred_5745 VDD.$2975.Metal1 vin4.P35.GatPoly 0.0143229f
Cred_5746 VDD.$2998.Metal1 vin1.$145.GatPoly 0.00516462f
Cred_5747 VDD.$2998.Metal1 vin1.$153.GatPoly 0.0161598f
Cred_5748 VDD.$2998.Metal1 vin1.$157.GatPoly 0.0282708f
Cred_5749 VDD.$2998.Metal1 vin1.$409.Metal1 0.00273151f
Cred_5750 VDD.$2998.Metal1 vin1.$413.Metal1 0.00781892f
Cred_5751 VDD.$2998.Metal1 vin1.$419.Metal1 0.0153629f
Cred_5752 VDD.$2998.Metal1 vin1.$423.Metal1 0.00359453f
Cred_5753 VDD.$2998.Metal1 vin1.$620.Metal2 0.0079159f
Cred_5754 VDD.$2998.Metal1 vin1.$622.Metal2 0.00133475f
Cred_5755 VDD.$2998.Metal1 vin1.$625.Metal2 0.0137f
Cred_5756 VDD.$2998.Metal1 vin1.P34.GatPoly 0.00105234f
Cred_5757 VDD.$2998.Metal1 vin1.P35.GatPoly 0.145402f
Cred_5758 VDD.$2998.Metal1 vin1.P36.GatPoly 0.139694f
Cred_5759 VDD.$2998.Metal1 vin1.P37.GatPoly 0.00105234f
Cred_5760 VDD.$2998.Metal1 vin2.$144.GatPoly 0.00516462f
Cred_5761 VDD.$2998.Metal1 vin2.$152.GatPoly 0.0161598f
Cred_5762 VDD.$2998.Metal1 vin2.$156.GatPoly 0.0282708f
Cred_5763 VDD.$2998.Metal1 vin2.$408.Metal1 0.00273151f
Cred_5764 VDD.$2998.Metal1 vin2.$412.Metal1 0.00781892f
Cred_5765 VDD.$2998.Metal1 vin2.$418.Metal1 0.0153629f
Cred_5766 VDD.$2998.Metal1 vin2.$422.Metal1 0.00359453f
Cred_5767 VDD.$2998.Metal1 vin2.$619.Metal2 0.0079159f
Cred_5768 VDD.$2998.Metal1 vin2.$622.Metal2 0.00133475f
Cred_5769 VDD.$2998.Metal1 vin2.$624.Metal2 0.0137f
Cred_5770 VDD.$2998.Metal1 vin2.P34.GatPoly 0.00105234f
Cred_5771 VDD.$2998.Metal1 vin2.P35.GatPoly 0.145402f
Cred_5772 VDD.$2998.Metal1 vin2.P36.GatPoly 0.139694f
Cred_5773 VDD.$2998.Metal1 vin2.P37.GatPoly 0.00105234f
Cred_5774 VDD.$2998.Metal1 vout1.$1358.Metal3 0.0421109f
Cred_5775 VDD.$2998.Metal1 vout1.$1424.Metal3 0.130597f
Cred_5776 VDD.$2998.Metal1 vout1.P14.nSD 0.000663418f
Cred_5777 VDD.$2998.Metal1 vout1.P14.pSD 0.0510307f
Cred_5778 VDD.$2998.Metal1 vout1.P16.pSD 0.0453222f
Cred_5779 VDD.$2998.Metal1 vout2.$1358.Metal3 0.0423542f
Cred_5780 VDD.$2998.Metal1 vout2.$1424.Metal3 0.130177f
Cred_5781 VDD.$2998.Metal1 vout2.P14.nSD 0.000667251f
Cred_5782 VDD.$2998.Metal1 vout2.P14.pSD 0.051091f
Cred_5783 VDD.$2998.Metal1 vout2.P16.pSD 0.045261f
Cred_5784 VDD.$2999.Metal1 vin3.$145.GatPoly 0.00516462f
Cred_5785 VDD.$2999.Metal1 vin3.$153.GatPoly 0.0161598f
Cred_5786 VDD.$2999.Metal1 vin3.$157.GatPoly 0.0282708f
Cred_5787 VDD.$2999.Metal1 vin3.$409.Metal1 0.00273151f
Cred_5788 VDD.$2999.Metal1 vin3.$413.Metal1 0.00781892f
Cred_5789 VDD.$2999.Metal1 vin3.$419.Metal1 0.0153629f
Cred_5790 VDD.$2999.Metal1 vin3.$423.Metal1 0.00359453f
Cred_5791 VDD.$2999.Metal1 vin3.$620.Metal2 0.0079159f
Cred_5792 VDD.$2999.Metal1 vin3.$622.Metal2 0.00133475f
Cred_5793 VDD.$2999.Metal1 vin3.$625.Metal2 0.0137f
Cred_5794 VDD.$2999.Metal1 vin3.P34.GatPoly 0.00105234f
Cred_5795 VDD.$2999.Metal1 vin3.P35.GatPoly 0.145402f
Cred_5796 VDD.$2999.Metal1 vin3.P36.GatPoly 0.139694f
Cred_5797 VDD.$2999.Metal1 vin3.P37.GatPoly 0.00105234f
Cred_5798 VDD.$2999.Metal1 vin4.$144.GatPoly 0.00516462f
Cred_5799 VDD.$2999.Metal1 vin4.$152.GatPoly 0.0161598f
Cred_5800 VDD.$2999.Metal1 vin4.$156.GatPoly 0.0282708f
Cred_5801 VDD.$2999.Metal1 vin4.$408.Metal1 0.00273151f
Cred_5802 VDD.$2999.Metal1 vin4.$412.Metal1 0.00781892f
Cred_5803 VDD.$2999.Metal1 vin4.$418.Metal1 0.0153629f
Cred_5804 VDD.$2999.Metal1 vin4.$422.Metal1 0.00359453f
Cred_5805 VDD.$2999.Metal1 vin4.$619.Metal2 0.0079159f
Cred_5806 VDD.$2999.Metal1 vin4.$622.Metal2 0.00133475f
Cred_5807 VDD.$2999.Metal1 vin4.$624.Metal2 0.0137f
Cred_5808 VDD.$2999.Metal1 vin4.P34.GatPoly 0.00105234f
Cred_5809 VDD.$2999.Metal1 vin4.P35.GatPoly 0.145402f
Cred_5810 VDD.$2999.Metal1 vin4.P36.GatPoly 0.139694f
Cred_5811 VDD.$2999.Metal1 vin4.P37.GatPoly 0.00105234f
Cred_5812 VDD.$2999.Metal1 vout3.$1358.Metal3 0.0421109f
Cred_5813 VDD.$2999.Metal1 vout3.$1424.Metal3 0.130597f
Cred_5814 VDD.$2999.Metal1 vout3.P14.nSD 0.000663418f
Cred_5815 VDD.$2999.Metal1 vout3.P14.pSD 0.0510307f
Cred_5816 VDD.$2999.Metal1 vout3.P16.pSD 0.0453222f
Cred_5817 VDD.$2999.Metal1 vout4.$1358.Metal3 0.0423542f
Cred_5818 VDD.$2999.Metal1 vout4.$1424.Metal3 0.130177f
Cred_5819 VDD.$2999.Metal1 vout4.P14.nSD 0.000667251f
Cred_5820 VDD.$2999.Metal1 vout4.P14.pSD 0.051091f
Cred_5821 VDD.$2999.Metal1 vout4.P16.pSD 0.045261f
Cred_5822 VDD.$3201.Metal1 vin1.$423.Metal1 1.7279e-08f
Cred_5823 VDD.$3201.Metal1 vin1.$427.Metal1 1.28485e-08f
Cred_5824 VDD.$3201.Metal1 vin1.$625.Metal2 1.58582e-06f
Cred_5825 VDD.$3201.Metal1 vin1.$629.Metal2 1.58582e-06f
Cred_5826 VDD.$3201.Metal1 vin1.P36.GatPoly 0.0103926f
Cred_5827 VDD.$3201.Metal1 vin2.$422.Metal1 1.7279e-08f
Cred_5828 VDD.$3201.Metal1 vin2.$426.Metal1 1.28485e-08f
Cred_5829 VDD.$3201.Metal1 vin2.$624.Metal2 1.58582e-06f
Cred_5830 VDD.$3201.Metal1 vin2.$628.Metal2 1.58582e-06f
Cred_5831 VDD.$3201.Metal1 vin2.P36.GatPoly 0.0103926f
Cred_5832 VDD.$3205.Metal1 vin3.$423.Metal1 1.7279e-08f
Cred_5833 VDD.$3205.Metal1 vin3.$427.Metal1 1.28485e-08f
Cred_5834 VDD.$3205.Metal1 vin3.$625.Metal2 1.58582e-06f
Cred_5835 VDD.$3205.Metal1 vin3.$629.Metal2 1.58582e-06f
Cred_5836 VDD.$3205.Metal1 vin3.P36.GatPoly 0.0103926f
Cred_5837 VDD.$3205.Metal1 vin4.$422.Metal1 1.7279e-08f
Cred_5838 VDD.$3205.Metal1 vin4.$426.Metal1 1.28485e-08f
Cred_5839 VDD.$3205.Metal1 vin4.$624.Metal2 1.58582e-06f
Cred_5840 VDD.$3205.Metal1 vin4.$628.Metal2 1.58582e-06f
Cred_5841 VDD.$3205.Metal1 vin4.P36.GatPoly 0.0103926f
Cred_5842 VDD.$3221.Metal1 vin1.$423.Metal1 7.72039e-09f
Cred_5843 VDD.$3221.Metal1 vin1.$427.Metal1 5.74081e-09f
Cred_5844 VDD.$3221.Metal1 vin1.$625.Metal2 7.08559e-07f
Cred_5845 VDD.$3221.Metal1 vin1.$629.Metal2 7.08559e-07f
Cred_5846 VDD.$3221.Metal1 vin1.P36.GatPoly 0.0125591f
Cred_5847 VDD.$3221.Metal1 vin2.$422.Metal1 7.72039e-09f
Cred_5848 VDD.$3221.Metal1 vin2.$426.Metal1 5.74081e-09f
Cred_5849 VDD.$3221.Metal1 vin2.$624.Metal2 7.08559e-07f
Cred_5850 VDD.$3221.Metal1 vin2.$628.Metal2 7.08559e-07f
Cred_5851 VDD.$3221.Metal1 vin2.P36.GatPoly 0.0125591f
Cred_5852 VDD.$3225.Metal1 vin3.$423.Metal1 7.72039e-09f
Cred_5853 VDD.$3225.Metal1 vin3.$427.Metal1 5.74081e-09f
Cred_5854 VDD.$3225.Metal1 vin3.$625.Metal2 7.08559e-07f
Cred_5855 VDD.$3225.Metal1 vin3.$629.Metal2 7.08559e-07f
Cred_5856 VDD.$3225.Metal1 vin3.P36.GatPoly 0.0125591f
Cred_5857 VDD.$3225.Metal1 vin4.$422.Metal1 7.72039e-09f
Cred_5858 VDD.$3225.Metal1 vin4.$426.Metal1 5.74081e-09f
Cred_5859 VDD.$3225.Metal1 vin4.$624.Metal2 7.08559e-07f
Cred_5860 VDD.$3225.Metal1 vin4.$628.Metal2 7.08559e-07f
Cred_5861 VDD.$3225.Metal1 vin4.P36.GatPoly 0.0125591f
Cred_5862 VDD.$3241.Metal1 vin1.P36.GatPoly 0.00632683f
Cred_5863 VDD.$3241.Metal1 vin2.P36.GatPoly 0.00632683f
Cred_5864 VDD.$3241.Metal1 vout1.$1424.Metal3 0.00566761f
Cred_5865 VDD.$3241.Metal1 vout1.P16.pSD 0.00298081f
Cred_5866 VDD.$3241.Metal1 vout2.$1424.Metal3 0.00566761f
Cred_5867 VDD.$3241.Metal1 vout2.P16.pSD 0.00298081f
Cred_5868 VDD.$3245.Metal1 vin3.P36.GatPoly 0.00632683f
Cred_5869 VDD.$3245.Metal1 vin4.P36.GatPoly 0.00632683f
Cred_5870 VDD.$3245.Metal1 vout3.$1424.Metal3 0.00566761f
Cred_5871 VDD.$3245.Metal1 vout3.P16.pSD 0.00298081f
Cred_5872 VDD.$3245.Metal1 vout4.$1424.Metal3 0.00566761f
Cred_5873 VDD.$3245.Metal1 vout4.P16.pSD 0.00298081f
Cred_5874 VDD.$3261.Metal1 vin1.P37.GatPoly 0.0060681f
Cred_5875 VDD.$3261.Metal1 vin2.P37.GatPoly 0.0060681f
Cred_5876 VDD.$3261.Metal1 vout1.$1424.Metal3 0.00773911f
Cred_5877 VDD.$3261.Metal1 vout1.P16.pSD 0.00486242f
Cred_5878 VDD.$3261.Metal1 vout2.$1424.Metal3 0.00773911f
Cred_5879 VDD.$3261.Metal1 vout2.P16.pSD 0.00486242f
Cred_5880 VDD.$3265.Metal1 vin3.P37.GatPoly 0.0060681f
Cred_5881 VDD.$3265.Metal1 vin4.P37.GatPoly 0.0060681f
Cred_5882 VDD.$3265.Metal1 vout3.$1424.Metal3 0.00773911f
Cred_5883 VDD.$3265.Metal1 vout3.P16.pSD 0.00486242f
Cred_5884 VDD.$3265.Metal1 vout4.$1424.Metal3 0.00773911f
Cred_5885 VDD.$3265.Metal1 vout4.P16.pSD 0.00486242f
Cred_5886 VDD.$3289.Metal1 vin1.$173.GatPoly 5.57028e-11f
Cred_5887 VDD.$3289.Metal1 vin1.$441.Metal1 3.309e-08f
Cred_5888 VDD.$3289.Metal1 vin1.$449.Metal1 4.66863e-09f
Cred_5889 VDD.$3289.Metal1 vin1.$636.Metal2 1.99206e-06f
Cred_5890 VDD.$3289.Metal1 vin1.$640.Metal2 1.99211e-06f
Cred_5891 VDD.$3289.Metal1 vin1.P37.GatPoly 0.0184981f
Cred_5892 VDD.$3289.Metal1 vin2.$172.GatPoly 5.57028e-11f
Cred_5893 VDD.$3289.Metal1 vin2.$440.Metal1 3.309e-08f
Cred_5894 VDD.$3289.Metal1 vin2.$448.Metal1 4.66863e-09f
Cred_5895 VDD.$3289.Metal1 vin2.$635.Metal2 1.99206e-06f
Cred_5896 VDD.$3289.Metal1 vin2.$639.Metal2 1.99211e-06f
Cred_5897 VDD.$3289.Metal1 vin2.P37.GatPoly 0.0184981f
Cred_5898 VDD.$3289.Metal1 vout1.$1424.Metal3 0.00143511f
Cred_5899 VDD.$3289.Metal1 vout1.P16.pSD 0.00052772f
Cred_5900 VDD.$3289.Metal1 vout2.$1424.Metal3 0.00143511f
Cred_5901 VDD.$3289.Metal1 vout2.P16.pSD 0.00052772f
Cred_5902 VDD.$3293.Metal1 vin3.$173.GatPoly 5.57028e-11f
Cred_5903 VDD.$3293.Metal1 vin3.$441.Metal1 3.309e-08f
Cred_5904 VDD.$3293.Metal1 vin3.$449.Metal1 4.66863e-09f
Cred_5905 VDD.$3293.Metal1 vin3.$636.Metal2 1.99206e-06f
Cred_5906 VDD.$3293.Metal1 vin3.$640.Metal2 1.99211e-06f
Cred_5907 VDD.$3293.Metal1 vin3.P37.GatPoly 0.0184981f
Cred_5908 VDD.$3293.Metal1 vin4.$172.GatPoly 5.57028e-11f
Cred_5909 VDD.$3293.Metal1 vin4.$440.Metal1 3.309e-08f
Cred_5910 VDD.$3293.Metal1 vin4.$448.Metal1 4.66863e-09f
Cred_5911 VDD.$3293.Metal1 vin4.$635.Metal2 1.99206e-06f
Cred_5912 VDD.$3293.Metal1 vin4.$639.Metal2 1.99211e-06f
Cred_5913 VDD.$3293.Metal1 vin4.P37.GatPoly 0.0184981f
Cred_5914 VDD.$3293.Metal1 vout3.$1424.Metal3 0.00143511f
Cred_5915 VDD.$3293.Metal1 vout3.P16.pSD 0.00052772f
Cred_5916 VDD.$3293.Metal1 vout4.$1424.Metal3 0.00143511f
Cred_5917 VDD.$3293.Metal1 vout4.P16.pSD 0.00052772f
Cred_5918 VDD.$3309.Metal1 vin1.$173.GatPoly 8.49703e-12f
Cred_5919 VDD.$3309.Metal1 vin1.$441.Metal1 5.04762e-09f
Cred_5920 VDD.$3309.Metal1 vin1.$449.Metal1 7.12163e-10f
Cred_5921 VDD.$3309.Metal1 vin1.$636.Metal2 3.03873e-07f
Cred_5922 VDD.$3309.Metal1 vin1.$640.Metal2 3.03881e-07f
Cred_5923 VDD.$3309.Metal1 vin1.P37.GatPoly 0.00449469f
Cred_5924 VDD.$3309.Metal1 vin2.$172.GatPoly 8.49703e-12f
Cred_5925 VDD.$3309.Metal1 vin2.$440.Metal1 5.04762e-09f
Cred_5926 VDD.$3309.Metal1 vin2.$448.Metal1 7.12163e-10f
Cred_5927 VDD.$3309.Metal1 vin2.$635.Metal2 3.03873e-07f
Cred_5928 VDD.$3309.Metal1 vin2.$639.Metal2 3.03881e-07f
Cred_5929 VDD.$3309.Metal1 vin2.P37.GatPoly 0.00449469f
Cred_5930 VDD.$3313.Metal1 vin3.$173.GatPoly 8.49703e-12f
Cred_5931 VDD.$3313.Metal1 vin3.$441.Metal1 5.04762e-09f
Cred_5932 VDD.$3313.Metal1 vin3.$449.Metal1 7.12163e-10f
Cred_5933 VDD.$3313.Metal1 vin3.$636.Metal2 3.03873e-07f
Cred_5934 VDD.$3313.Metal1 vin3.$640.Metal2 3.03881e-07f
Cred_5935 VDD.$3313.Metal1 vin3.P37.GatPoly 0.00449469f
Cred_5936 VDD.$3313.Metal1 vin4.$172.GatPoly 8.49703e-12f
Cred_5937 VDD.$3313.Metal1 vin4.$440.Metal1 5.04762e-09f
Cred_5938 VDD.$3313.Metal1 vin4.$448.Metal1 7.12163e-10f
Cred_5939 VDD.$3313.Metal1 vin4.$635.Metal2 3.03873e-07f
Cred_5940 VDD.$3313.Metal1 vin4.$639.Metal2 3.03881e-07f
Cred_5941 VDD.$3313.Metal1 vin4.P37.GatPoly 0.00449469f
Cred_5942 VDD.$3316.Metal1 vin1.$167.GatPoly 0.0263169f
Cred_5943 VDD.$3316.Metal1 vin1.$173.GatPoly 0.00703995f
Cred_5944 VDD.$3316.Metal1 vin1.$179.GatPoly 0.0239497f
Cred_5945 VDD.$3316.Metal1 vin1.$441.Metal1 0.00233656f
Cred_5946 VDD.$3316.Metal1 vin1.$449.Metal1 0.0154163f
Cred_5947 VDD.$3316.Metal1 vin1.$453.Metal1 0.00682577f
Cred_5948 VDD.$3316.Metal1 vin1.$636.Metal2 5.72493e-06f
Cred_5949 VDD.$3316.Metal1 vin1.$640.Metal2 0.0118837f
Cred_5950 VDD.$3316.Metal1 vin1.$642.Metal2 0.0014622f
Cred_5951 VDD.$3316.Metal1 vin1.$645.Metal2 0.00944382f
Cred_5952 VDD.$3316.Metal1 vin1.P36.GatPoly 0.00105302f
Cred_5953 VDD.$3316.Metal1 vin1.P37.GatPoly 0.138873f
Cred_5954 VDD.$3316.Metal1 vin1.P38.GatPoly 0.142913f
Cred_5955 VDD.$3316.Metal1 vin1.P39.GatPoly 0.00114336f
Cred_5956 VDD.$3316.Metal1 vin2.$166.GatPoly 0.0263169f
Cred_5957 VDD.$3316.Metal1 vin2.$172.GatPoly 0.00703995f
Cred_5958 VDD.$3316.Metal1 vin2.$178.GatPoly 0.0239497f
Cred_5959 VDD.$3316.Metal1 vin2.$440.Metal1 0.00233656f
Cred_5960 VDD.$3316.Metal1 vin2.$448.Metal1 0.0154163f
Cred_5961 VDD.$3316.Metal1 vin2.$452.Metal1 0.00682577f
Cred_5962 VDD.$3316.Metal1 vin2.$635.Metal2 5.72493e-06f
Cred_5963 VDD.$3316.Metal1 vin2.$639.Metal2 0.0118837f
Cred_5964 VDD.$3316.Metal1 vin2.$642.Metal2 0.0014622f
Cred_5965 VDD.$3316.Metal1 vin2.$644.Metal2 0.00944382f
Cred_5966 VDD.$3316.Metal1 vin2.P36.GatPoly 0.00105302f
Cred_5967 VDD.$3316.Metal1 vin2.P37.GatPoly 0.139279f
Cred_5968 VDD.$3316.Metal1 vin2.P38.GatPoly 0.142507f
Cred_5969 VDD.$3316.Metal1 vin2.P39.GatPoly 0.00114336f
Cred_5970 VDD.$3316.Metal1 vout1 0.0138516f
Cred_5971 VDD.$3316.Metal1 vout1.$1424.Metal3 0.157119f
Cred_5972 VDD.$3316.Metal1 vout1.P16.pSD 0.0463072f
Cred_5973 VDD.$3316.Metal1 vout1.P18.nSD 0.00110058f
Cred_5974 VDD.$3316.Metal1 vout1.P18.pSD 0.0548436f
Cred_5975 VDD.$3316.Metal1 vout2 0.0138516f
Cred_5976 VDD.$3316.Metal1 vout2.$1424.Metal3 0.157784f
Cred_5977 VDD.$3316.Metal1 vout2.P16.pSD 0.0463684f
Cred_5978 VDD.$3316.Metal1 vout2.P18.nSD 0.00110058f
Cred_5979 VDD.$3316.Metal1 vout2.P18.pSD 0.0548436f
Cred_5980 VDD.$3317.Metal1 vin3.$167.GatPoly 0.0263169f
Cred_5981 VDD.$3317.Metal1 vin3.$173.GatPoly 0.00703995f
Cred_5982 VDD.$3317.Metal1 vin3.$179.GatPoly 0.0239497f
Cred_5983 VDD.$3317.Metal1 vin3.$441.Metal1 0.00233656f
Cred_5984 VDD.$3317.Metal1 vin3.$449.Metal1 0.0154163f
Cred_5985 VDD.$3317.Metal1 vin3.$453.Metal1 0.00682577f
Cred_5986 VDD.$3317.Metal1 vin3.$636.Metal2 5.72493e-06f
Cred_5987 VDD.$3317.Metal1 vin3.$640.Metal2 0.0118837f
Cred_5988 VDD.$3317.Metal1 vin3.$642.Metal2 0.0014622f
Cred_5989 VDD.$3317.Metal1 vin3.$645.Metal2 0.00944382f
Cred_5990 VDD.$3317.Metal1 vin3.P36.GatPoly 0.00105302f
Cred_5991 VDD.$3317.Metal1 vin3.P37.GatPoly 0.138873f
Cred_5992 VDD.$3317.Metal1 vin3.P38.GatPoly 0.142913f
Cred_5993 VDD.$3317.Metal1 vin3.P39.GatPoly 0.00114336f
Cred_5994 VDD.$3317.Metal1 vin4.$166.GatPoly 0.0263169f
Cred_5995 VDD.$3317.Metal1 vin4.$172.GatPoly 0.00703995f
Cred_5996 VDD.$3317.Metal1 vin4.$178.GatPoly 0.0239497f
Cred_5997 VDD.$3317.Metal1 vin4.$440.Metal1 0.00233656f
Cred_5998 VDD.$3317.Metal1 vin4.$448.Metal1 0.0154163f
Cred_5999 VDD.$3317.Metal1 vin4.$452.Metal1 0.00682577f
Cred_6000 VDD.$3317.Metal1 vin4.$635.Metal2 5.72493e-06f
Cred_6001 VDD.$3317.Metal1 vin4.$639.Metal2 0.0118837f
Cred_6002 VDD.$3317.Metal1 vin4.$642.Metal2 0.0014622f
Cred_6003 VDD.$3317.Metal1 vin4.$644.Metal2 0.00944382f
Cred_6004 VDD.$3317.Metal1 vin4.P36.GatPoly 0.00105302f
Cred_6005 VDD.$3317.Metal1 vin4.P37.GatPoly 0.139279f
Cred_6006 VDD.$3317.Metal1 vin4.P38.GatPoly 0.142507f
Cred_6007 VDD.$3317.Metal1 vin4.P39.GatPoly 0.00114336f
Cred_6008 VDD.$3317.Metal1 vout3 0.0138516f
Cred_6009 VDD.$3317.Metal1 vout3.$1424.Metal3 0.157119f
Cred_6010 VDD.$3317.Metal1 vout3.P16.pSD 0.0463072f
Cred_6011 VDD.$3317.Metal1 vout3.P18.nSD 0.00110058f
Cred_6012 VDD.$3317.Metal1 vout3.P18.pSD 0.0548436f
Cred_6013 VDD.$3317.Metal1 vout4 0.0138516f
Cred_6014 VDD.$3317.Metal1 vout4.$1424.Metal3 0.157784f
Cred_6015 VDD.$3317.Metal1 vout4.P16.pSD 0.0463684f
Cred_6016 VDD.$3317.Metal1 vout4.P18.nSD 0.00110058f
Cred_6017 VDD.$3317.Metal1 vout4.P18.pSD 0.0548436f
Cred_6018 VDD.$3531.Metal1 vin1.$453.Metal1 1.44619e-09f
Cred_6019 VDD.$3531.Metal1 vin1.$457.Metal1 9.48058e-09f
Cred_6020 VDD.$3531.Metal1 vin1.$645.Metal2 5.73684e-07f
Cred_6021 VDD.$3531.Metal1 vin1.$649.Metal2 5.73684e-07f
Cred_6022 VDD.$3531.Metal1 vin1.P38.GatPoly 0.00765555f
Cred_6023 VDD.$3531.Metal1 vin2.$452.Metal1 1.44619e-09f
Cred_6024 VDD.$3531.Metal1 vin2.$456.Metal1 9.48058e-09f
Cred_6025 VDD.$3531.Metal1 vin2.$644.Metal2 5.73684e-07f
Cred_6026 VDD.$3531.Metal1 vin2.$648.Metal2 5.73684e-07f
Cred_6027 VDD.$3531.Metal1 vin2.P38.GatPoly 0.00765555f
Cred_6028 VDD.$3535.Metal1 vin3.$453.Metal1 1.44619e-09f
Cred_6029 VDD.$3535.Metal1 vin3.$457.Metal1 9.48058e-09f
Cred_6030 VDD.$3535.Metal1 vin3.$645.Metal2 5.73684e-07f
Cred_6031 VDD.$3535.Metal1 vin3.$649.Metal2 5.73684e-07f
Cred_6032 VDD.$3535.Metal1 vin3.P38.GatPoly 0.00765555f
Cred_6033 VDD.$3535.Metal1 vin4.$452.Metal1 1.44619e-09f
Cred_6034 VDD.$3535.Metal1 vin4.$456.Metal1 9.48058e-09f
Cred_6035 VDD.$3535.Metal1 vin4.$644.Metal2 5.73684e-07f
Cred_6036 VDD.$3535.Metal1 vin4.$648.Metal2 5.73684e-07f
Cred_6037 VDD.$3535.Metal1 vin4.P38.GatPoly 0.00765555f
Cred_6038 VDD.$3551.Metal1 vin1.$453.Metal1 4.33857e-09f
Cred_6039 VDD.$3551.Metal1 vin1.$457.Metal1 2.84417e-08f
Cred_6040 VDD.$3551.Metal1 vin1.$645.Metal2 1.72105e-06f
Cred_6041 VDD.$3551.Metal1 vin1.$649.Metal2 1.72105e-06f
Cred_6042 VDD.$3551.Metal1 vin1.P38.GatPoly 0.0170213f
Cred_6043 VDD.$3551.Metal1 vin2.$452.Metal1 4.33857e-09f
Cred_6044 VDD.$3551.Metal1 vin2.$456.Metal1 2.84417e-08f
Cred_6045 VDD.$3551.Metal1 vin2.$644.Metal2 1.72105e-06f
Cred_6046 VDD.$3551.Metal1 vin2.$648.Metal2 1.72105e-06f
Cred_6047 VDD.$3551.Metal1 vin2.P38.GatPoly 0.0170213f
Cred_6048 VDD.$3551.Metal1 vout1 0.000363554f
Cred_6049 VDD.$3551.Metal1 vout1.$1424.Metal3 0.00183358f
Cred_6050 VDD.$3551.Metal1 vout1.P18.nSD 2.88863e-05f
Cred_6051 VDD.$3551.Metal1 vout1.P18.pSD 0.00127975f
Cred_6052 VDD.$3551.Metal1 vout2 0.000363554f
Cred_6053 VDD.$3551.Metal1 vout2.$1424.Metal3 0.00183358f
Cred_6054 VDD.$3551.Metal1 vout2.P18.nSD 2.88863e-05f
Cred_6055 VDD.$3551.Metal1 vout2.P18.pSD 0.00127975f
Cred_6056 VDD.$3555.Metal1 vin3.$453.Metal1 4.33857e-09f
Cred_6057 VDD.$3555.Metal1 vin3.$457.Metal1 2.84417e-08f
Cred_6058 VDD.$3555.Metal1 vin3.$645.Metal2 1.72105e-06f
Cred_6059 VDD.$3555.Metal1 vin3.$649.Metal2 1.72105e-06f
Cred_6060 VDD.$3555.Metal1 vin3.P38.GatPoly 0.0170213f
Cred_6061 VDD.$3555.Metal1 vin4.$452.Metal1 4.33857e-09f
Cred_6062 VDD.$3555.Metal1 vin4.$456.Metal1 2.84417e-08f
Cred_6063 VDD.$3555.Metal1 vin4.$644.Metal2 1.72105e-06f
Cred_6064 VDD.$3555.Metal1 vin4.$648.Metal2 1.72105e-06f
Cred_6065 VDD.$3555.Metal1 vin4.P38.GatPoly 0.0170213f
Cred_6066 VDD.$3555.Metal1 vout3 0.000363554f
Cred_6067 VDD.$3555.Metal1 vout3.$1424.Metal3 0.00183358f
Cred_6068 VDD.$3555.Metal1 vout3.P18.nSD 2.88863e-05f
Cred_6069 VDD.$3555.Metal1 vout3.P18.pSD 0.00127975f
Cred_6070 VDD.$3555.Metal1 vout4 0.000363554f
Cred_6071 VDD.$3555.Metal1 vout4.$1424.Metal3 0.00183358f
Cred_6072 VDD.$3555.Metal1 vout4.P18.nSD 2.88863e-05f
Cred_6073 VDD.$3555.Metal1 vout4.P18.pSD 0.00127975f
Cred_6074 VDD.$3579.Metal1 vin1.P38.GatPoly 0.00430981f
Cred_6075 VDD.$3579.Metal1 vin1.P39.GatPoly 0.000943122f
Cred_6076 VDD.$3579.Metal1 vin2.P38.GatPoly 0.00430981f
Cred_6077 VDD.$3579.Metal1 vin2.P39.GatPoly 0.000943122f
Cred_6078 VDD.$3579.Metal1 vout1 0.00132615f
Cred_6079 VDD.$3579.Metal1 vout1.$1424.Metal3 0.00668841f
Cred_6080 VDD.$3579.Metal1 vout1.P18.nSD 0.00010537f
Cred_6081 VDD.$3579.Metal1 vout1.P18.pSD 0.00603052f
Cred_6082 VDD.$3579.Metal1 vout2 0.00132615f
Cred_6083 VDD.$3579.Metal1 vout2.$1424.Metal3 0.00668841f
Cred_6084 VDD.$3579.Metal1 vout2.P18.nSD 0.00010537f
Cred_6085 VDD.$3579.Metal1 vout2.P18.pSD 0.00603052f
Cred_6086 VDD.$3583.Metal1 vin3.P38.GatPoly 0.00430981f
Cred_6087 VDD.$3583.Metal1 vin3.P39.GatPoly 0.000943122f
Cred_6088 VDD.$3583.Metal1 vin4.P38.GatPoly 0.00430981f
Cred_6089 VDD.$3583.Metal1 vin4.P39.GatPoly 0.000943122f
Cred_6090 VDD.$3583.Metal1 vout3 0.00132615f
Cred_6091 VDD.$3583.Metal1 vout3.$1424.Metal3 0.00668841f
Cred_6092 VDD.$3583.Metal1 vout3.P18.nSD 0.00010537f
Cred_6093 VDD.$3583.Metal1 vout3.P18.pSD 0.00603052f
Cred_6094 VDD.$3583.Metal1 vout4 0.00132615f
Cred_6095 VDD.$3583.Metal1 vout4.$1424.Metal3 0.00668841f
Cred_6096 VDD.$3583.Metal1 vout4.P18.nSD 0.00010537f
Cred_6097 VDD.$3583.Metal1 vout4.P18.pSD 0.00603052f
Cred_6098 VDD.$3599.Metal1 vin1.P39.GatPoly 0.00960018f
Cred_6099 VDD.$3599.Metal1 vin2.P39.GatPoly 0.00960018f
Cred_6100 VDD.$3599.Metal1 vout1 0.000639881f
Cred_6101 VDD.$3599.Metal1 vout1.$1424.Metal3 0.00322723f
Cred_6102 VDD.$3599.Metal1 vout1.P18.nSD 5.08419e-05f
Cred_6103 VDD.$3599.Metal1 vout1.P18.pSD 0.00192447f
Cred_6104 VDD.$3599.Metal1 vout2 0.000639881f
Cred_6105 VDD.$3599.Metal1 vout2.$1424.Metal3 0.00322723f
Cred_6106 VDD.$3599.Metal1 vout2.P18.nSD 5.08419e-05f
Cred_6107 VDD.$3599.Metal1 vout2.P18.pSD 0.00192447f
Cred_6108 VDD.$360.Metal1 vin1.P20.GatPoly 0.00736344f
Cred_6109 VDD.$360.Metal1 vin1.P21.GatPoly 0.000717115f
Cred_6110 VDD.$360.Metal1 vin1.P22.GatPoly 0.000399624f
Cred_6111 VDD.$360.Metal1 vin1.P23.GatPoly 0.000276992f
Cred_6112 VDD.$3603.Metal1 vin3.P39.GatPoly 0.00960018f
Cred_6113 VDD.$3603.Metal1 vin4.P39.GatPoly 0.00960018f
Cred_6114 VDD.$3603.Metal1 vout3 0.000639881f
Cred_6115 VDD.$3603.Metal1 vout3.$1424.Metal3 0.00322723f
Cred_6116 VDD.$3603.Metal1 vout3.P18.nSD 5.08419e-05f
Cred_6117 VDD.$3603.Metal1 vout3.P18.pSD 0.00192447f
Cred_6118 VDD.$3603.Metal1 vout4 0.000639881f
Cred_6119 VDD.$3603.Metal1 vout4.$1424.Metal3 0.00322723f
Cred_6120 VDD.$3603.Metal1 vout4.P18.nSD 5.08419e-05f
Cred_6121 VDD.$3603.Metal1 vout4.P18.pSD 0.00192447f
Cred_6122 VDD.$361.Metal1 vin2.$202.Metal1 0.0181177f
Cred_6123 VDD.$361.Metal1 vin2.$477.Metal2 0.00552562f
Cred_6124 VDD.$361.Metal1 vin2.$479.Metal2 0.0106698f
Cred_6125 VDD.$361.Metal1 vin2.$8.GatPoly 0.00199856f
Cred_6126 VDD.$361.Metal1 vin2.P20.GatPoly 0.160428f
Cred_6127 VDD.$361.Metal1 vin2.P21.GatPoly 0.00215135f
Cred_6128 VDD.$361.Metal1 vin2.P22.GatPoly 0.00119887f
Cred_6129 VDD.$361.Metal1 vin2.P23.GatPoly 0.000830976f
Cred_6130 VDD.$361.Metal1 vout2.$1226.Metal3 0.0610965f
Cred_6131 VDD.$361.Metal1 vout2.P0.nSD 0.00181926f
Cred_6132 VDD.$361.Metal1 vout2.P0.pSD 0.0529516f
Cred_6133 VDD.$361.Metal1 vout2.P2.nSD 0.000962518f
Cred_6134 VDD.$361.Metal1 vout2.P2.pSD 0.00526038f
Cred_6135 VDD.$361.Metal1 VSS.$1990.Metal1 2.90618e-07f
Cred_6136 VDD.$361.Metal1 VSS.$4358.Metal3 0.0011038f
Cred_6137 VDD.$361.Metal1 VSS.$68.Metal1 0.000419951f
Cred_6138 VDD.$361.Metal1 VSS.P3.pSD 0.00163334f
Cred_6139 VDD.$3619.Metal1 vin1.P39.GatPoly 0.0117426f
Cred_6140 VDD.$3619.Metal1 vin2.P39.GatPoly 0.0117426f
Cred_6141 VDD.$362.Metal1 vin3.P20.GatPoly 0.00736344f
Cred_6142 VDD.$362.Metal1 vin3.P21.GatPoly 0.000717115f
Cred_6143 VDD.$362.Metal1 vin3.P22.GatPoly 0.000399624f
Cred_6144 VDD.$362.Metal1 vin3.P23.GatPoly 0.000276992f
Cred_6145 VDD.$3623.Metal1 vin3.P39.GatPoly 0.0117426f
Cred_6146 VDD.$3623.Metal1 vin4.P39.GatPoly 0.0117426f
Cred_6147 VDD.$363.Metal1 vin4.$202.Metal1 0.0181177f
Cred_6148 VDD.$363.Metal1 vin4.$477.Metal2 0.00552562f
Cred_6149 VDD.$363.Metal1 vin4.$479.Metal2 0.0106698f
Cred_6150 VDD.$363.Metal1 vin4.$8.GatPoly 0.00199856f
Cred_6151 VDD.$363.Metal1 vin4.P20.GatPoly 0.160428f
Cred_6152 VDD.$363.Metal1 vin4.P21.GatPoly 0.00215135f
Cred_6153 VDD.$363.Metal1 vin4.P22.GatPoly 0.00119887f
Cred_6154 VDD.$363.Metal1 vin4.P23.GatPoly 0.000830976f
Cred_6155 VDD.$363.Metal1 vout4.$1226.Metal3 0.0612345f
Cred_6156 VDD.$363.Metal1 vout4.P0.nSD 0.00182337f
Cred_6157 VDD.$363.Metal1 vout4.P0.pSD 0.0529903f
Cred_6158 VDD.$363.Metal1 vout4.P2.nSD 0.000964693f
Cred_6159 VDD.$363.Metal1 vout4.P2.pSD 0.00527227f
Cred_6160 VDD.$363.Metal1 VSS.$1991.Metal1 1.01364e-07f
Cred_6161 VDD.$363.Metal1 VSS.$2023.Metal1 2.53795e-07f
Cred_6162 VDD.$363.Metal1 VSS.$4241.Metal2 6.79483e-10f
Cred_6163 VDD.$363.Metal1 VSS.$4364.Metal3 0.000317158f
Cred_6164 VDD.$363.Metal1 VSS.$66.Metal1 0.000579054f
Cred_6165 VDD.$363.Metal1 VSS.P0.pSD 0.00147417f
Cred_6166 VDD.$3639.Metal1 vin1.P39.GatPoly 0.0122207f
Cred_6167 VDD.$3639.Metal1 vin2.P39.GatPoly 0.0122207f
Cred_6168 VDD.$3643.Metal1 vin3.P39.GatPoly 0.0122207f
Cred_6169 VDD.$3643.Metal1 vin4.P39.GatPoly 0.0122207f
Cred_6170 VDD.$3646.Metal1 vin1.P39.GatPoly 7.34336e-05f
Cred_6171 VDD.$3646.Metal1 vin2.P39.GatPoly 7.34336e-05f
Cred_6172 VDD.$3649.Metal1 vin1.P39.GatPoly 0.000178565f
Cred_6173 VDD.$3649.Metal1 vin2.P39.GatPoly 0.000178565f
Cred_6174 VDD.$3652.Metal1 vin3.P39.GatPoly 7.34336e-05f
Cred_6175 VDD.$3652.Metal1 vin4.P39.GatPoly 7.34336e-05f
Cred_6176 VDD.$3655.Metal1 vin3.P39.GatPoly 0.000178565f
Cred_6177 VDD.$3655.Metal1 vin4.P39.GatPoly 0.000178565f
Cred_6178 VDD.$3658.Metal1 vin1.P39.GatPoly 0.0287869f
Cred_6179 VDD.$3658.Metal1 vout1 0.000904221f
Cred_6180 VDD.$3658.Metal1 vout1.$1424.Metal3 0.00456042f
Cred_6181 VDD.$3658.Metal1 vout1.P18.nSD 7.18451e-05f
Cred_6182 VDD.$3658.Metal1 vout1.P18.pSD 0.00564472f
Cred_6183 VDD.$3660.Metal1 vin3.P39.GatPoly 0.0287869f
Cred_6184 VDD.$3660.Metal1 vout3 0.000904221f
Cred_6185 VDD.$3660.Metal1 vout3.$1424.Metal3 0.00456042f
Cred_6186 VDD.$3660.Metal1 vout3.P18.nSD 7.18451e-05f
Cred_6187 VDD.$3660.Metal1 vout3.P18.pSD 0.00564472f
Cred_6188 VDD.$3727.Metal1 vin1.$179.GatPoly 0.00239944f
Cred_6189 VDD.$3727.Metal1 vin1.$457.Metal1 0.0211388f
Cred_6190 VDD.$3727.Metal1 vin1.$649.Metal2 0.000447578f
Cred_6191 VDD.$3727.Metal1 vin1.$654.Metal2 0.00222062f
Cred_6192 VDD.$3727.Metal1 vin1.P39.GatPoly 0.0766011f
Cred_6193 VDD.$3727.Metal1 vout1 0.00495343f
Cred_6194 VDD.$3727.Metal1 vout1.$1424.Metal3 0.0249825f
Cred_6195 VDD.$3727.Metal1 vout1.P18.nSD 0.000393576f
Cred_6196 VDD.$3727.Metal1 vout1.P18.pSD 0.0242934f
Cred_6197 VDD.$3727.Metal1 VSS.$1989.Metal1 0.000221474f
Cred_6198 VDD.$3727.Metal1 VSS.$2020.Metal1 0.000683072f
Cred_6199 VDD.$3727.Metal1 VSS.$29.Metal1 5.37821e-07f
Cred_6200 VDD.$3727.Metal1 VSS.$4227.Metal2 0.00219144f
Cred_6201 VDD.$3727.Metal1 VSS.P1.pSD 0.00211623f
Cred_6202 VDD.$3727.Metal1 VSS.P45.nSD 5.42875e-07f
Cred_6203 VDD.$3727.Metal1 VSS.P47.nSD 5.42875e-07f
Cred_6204 VDD.$3728.Metal1 vin1.P39.GatPoly 0.0186593f
Cred_6205 VDD.$3728.Metal1 vout1 0.000619098f
Cred_6206 VDD.$3728.Metal1 vout1.$1424.Metal3 0.00312241f
Cred_6207 VDD.$3728.Metal1 vout1.P18.nSD 4.91906e-05f
Cred_6208 VDD.$3728.Metal1 vout1.P18.pSD 0.00379703f
Cred_6209 VDD.$3730.Metal1 vin1.P39.GatPoly 0.0183365f
Cred_6210 VDD.$3730.Metal1 vout1 0.000648074f
Cred_6211 VDD.$3730.Metal1 vout1.$1424.Metal3 0.00326855f
Cred_6212 VDD.$3730.Metal1 vout1.P18.nSD 5.14929e-05f
Cred_6213 VDD.$3730.Metal1 vout1.P18.pSD 0.00403902f
Cred_6214 VDD.$3731.Metal1 vin1.P39.GatPoly 0.0127709f
Cred_6215 VDD.$3731.Metal1 vout1 0.000453107f
Cred_6216 VDD.$3731.Metal1 vout1.$1424.Metal3 0.00228524f
Cred_6217 VDD.$3731.Metal1 vout1.P18.nSD 3.60018e-05f
Cred_6218 VDD.$3731.Metal1 vout1.P18.pSD 0.00283002f
Cred_6219 VDD.$3736.Metal1 vin2.P39.GatPoly 0.0224991f
Cred_6220 VDD.$3736.Metal1 vout2 0.000679897f
Cred_6221 VDD.$3736.Metal1 vout2.$1424.Metal3 0.00342905f
Cred_6222 VDD.$3736.Metal1 vout2.P18.nSD 5.40214e-05f
Cred_6223 VDD.$3736.Metal1 vout2.P18.pSD 0.00423734f
Cred_6224 VDD.$3737.Metal1 vin2.P39.GatPoly 0.012298f
Cred_6225 VDD.$3737.Metal1 vout2 0.000415073f
Cred_6226 VDD.$3737.Metal1 vout2.$1424.Metal3 0.00209341f
Cred_6227 VDD.$3737.Metal1 vout2.P18.nSD 3.29797e-05f
Cred_6228 VDD.$3737.Metal1 vout2.P18.pSD 0.00257951f
Cred_6229 VDD.$3738.Metal1 vin2.P39.GatPoly 0.0122929f
Cred_6230 VDD.$3738.Metal1 vout2 0.000435831f
Cred_6231 VDD.$3738.Metal1 vout2.$1424.Metal3 0.00219811f
Cred_6232 VDD.$3738.Metal1 vout2.P18.nSD 3.46291e-05f
Cred_6233 VDD.$3738.Metal1 vout2.P18.pSD 0.00272195f
Cred_6234 VDD.$3739.Metal1 vin2.P39.GatPoly 0.0185204f
Cred_6235 VDD.$3739.Metal1 vout2 0.000655717f
Cred_6236 VDD.$3739.Metal1 vout2.$1424.Metal3 0.0033071f
Cred_6237 VDD.$3739.Metal1 vout2.P18.nSD 5.21002e-05f
Cred_6238 VDD.$3739.Metal1 vout2.P18.pSD 0.00408062f
Cred_6239 VDD.$3741.Metal1 vin2.P39.GatPoly 0.0185176f
Cred_6240 VDD.$3741.Metal1 vout2 0.000627435f
Cred_6241 VDD.$3741.Metal1 vout2.$1424.Metal3 0.00316445f
Cred_6242 VDD.$3741.Metal1 vout2.P18.nSD 4.9853e-05f
Cred_6243 VDD.$3741.Metal1 vout2.P18.pSD 0.00378018f
Cred_6244 VDD.$3742.Metal1 vin2.P39.GatPoly 0.0123086f
Cred_6245 VDD.$3742.Metal1 vout2 0.000456038f
Cred_6246 VDD.$3742.Metal1 vout2.$1424.Metal3 0.00230002f
Cred_6247 VDD.$3742.Metal1 vout2.P18.nSD 3.62346e-05f
Cred_6248 VDD.$3742.Metal1 vout2.P18.pSD 0.00273577f
Cred_6249 VDD.$3743.Metal1 vin2.P39.GatPoly 0.0123853f
Cred_6250 VDD.$3743.Metal1 vout2 0.000431895f
Cred_6251 VDD.$3743.Metal1 vout2.$1424.Metal3 0.00217826f
Cred_6252 VDD.$3743.Metal1 vout2.P18.nSD 3.43164e-05f
Cred_6253 VDD.$3743.Metal1 vout2.P18.pSD 0.00266008f
Cred_6254 VDD.$3744.Metal1 vin2.P39.GatPoly 0.0123827f
Cred_6255 VDD.$3744.Metal1 vout2 0.000400635f
Cred_6256 VDD.$3744.Metal1 vout2.$1424.Metal3 0.0020206f
Cred_6257 VDD.$3744.Metal1 vout2.P18.nSD 3.18326e-05f
Cred_6258 VDD.$3744.Metal1 vout2.P18.pSD 0.00250636f
Cred_6259 VDD.$3745.Metal1 vin2.P39.GatPoly 0.0123097f
Cred_6260 VDD.$3745.Metal1 vout2 0.000427534f
Cred_6261 VDD.$3745.Metal1 vout2.$1424.Metal3 0.00215626f
Cred_6262 VDD.$3745.Metal1 vout2.P18.nSD 3.39698e-05f
Cred_6263 VDD.$3745.Metal1 vout2.P18.pSD 0.00265644f
Cred_6264 VDD.$3746.Metal1 vin2.$178.GatPoly 0.00291008f
Cred_6265 VDD.$3746.Metal1 vin2.$456.Metal1 0.0256374f
Cred_6266 VDD.$3746.Metal1 vin2.$648.Metal2 0.000542828f
Cred_6267 VDD.$3746.Metal1 vin2.$653.Metal2 0.0026932f
Cred_6268 VDD.$3746.Metal1 vin2.P39.GatPoly 0.0377404f
Cred_6269 VDD.$3746.Metal1 vout2 0.00268785f
Cred_6270 VDD.$3746.Metal1 vout2.$1424.Metal3 0.0135561f
Cred_6271 VDD.$3746.Metal1 vout2.P18.nSD 0.000213564f
Cred_6272 VDD.$3746.Metal1 vout2.P18.pSD 0.0157886f
Cred_6273 VDD.$3746.Metal1 VSS.$1990.Metal1 0.000721123f
Cred_6274 VDD.$3746.Metal1 VSS.$2021.Metal1 3.50349e-05f
Cred_6275 VDD.$3746.Metal1 VSS.$4164.Metal2 0.000612963f
Cred_6276 VDD.$3746.Metal1 VSS.$68.Metal1 4.93198e-07f
Cred_6277 VDD.$3746.Metal1 VSS.P3.pSD 0.00277964f
Cred_6278 VDD.$3746.Metal1 VSS.P93.nSD 1.534e-07f
Cred_6279 VDD.$3746.Metal1 VSS.P95.nSD 1.534e-07f
Cred_6280 VDD.$3761.Metal1 vin3.$179.GatPoly 0.00239944f
Cred_6281 VDD.$3761.Metal1 vin3.$457.Metal1 0.0211388f
Cred_6282 VDD.$3761.Metal1 vin3.$649.Metal2 0.000447578f
Cred_6283 VDD.$3761.Metal1 vin3.$654.Metal2 0.00222062f
Cred_6284 VDD.$3761.Metal1 vin3.P39.GatPoly 0.0766011f
Cred_6285 VDD.$3761.Metal1 vout3 0.00495281f
Cred_6286 VDD.$3761.Metal1 vout3.$1424.Metal3 0.0249794f
Cred_6287 VDD.$3761.Metal1 vout3.P18.nSD 0.000393527f
Cred_6288 VDD.$3761.Metal1 vout3.P18.pSD 0.0242931f
Cred_6289 VDD.$3761.Metal1 VSS.$1990.Metal1 0.000610213f
Cred_6290 VDD.$3761.Metal1 VSS.$2022.Metal1 0.000125352f
Cred_6291 VDD.$3761.Metal1 VSS.$4174.Metal2 0.00219314f
Cred_6292 VDD.$3761.Metal1 VSS.$68.Metal1 4.01389e-07f
Cred_6293 VDD.$3761.Metal1 VSS.P2.pSD 0.00228364f
Cred_6294 VDD.$3761.Metal1 VSS.P69.nSD 5.48853e-07f
Cred_6295 VDD.$3761.Metal1 VSS.P71.nSD 5.48853e-07f
Cred_6296 VDD.$3762.Metal1 vin3.P39.GatPoly 0.0186593f
Cred_6297 VDD.$3762.Metal1 vout3 0.000617432f
Cred_6298 VDD.$3762.Metal1 vout3.$1424.Metal3 0.003114f
Cred_6299 VDD.$3762.Metal1 vout3.P18.nSD 4.90582e-05f
Cred_6300 VDD.$3762.Metal1 vout3.P18.pSD 0.00379632f
Cred_6301 VDD.$3764.Metal1 vin3.P39.GatPoly 0.0183365f
Cred_6302 VDD.$3764.Metal1 vout3 0.000648074f
Cred_6303 VDD.$3764.Metal1 vout3.$1424.Metal3 0.00326855f
Cred_6304 VDD.$3764.Metal1 vout3.P18.nSD 5.14929e-05f
Cred_6305 VDD.$3764.Metal1 vout3.P18.pSD 0.00403902f
Cred_6306 VDD.$3765.Metal1 vin3.P39.GatPoly 0.0127709f
Cred_6307 VDD.$3765.Metal1 vout3 0.000453107f
Cred_6308 VDD.$3765.Metal1 vout3.$1424.Metal3 0.00228524f
Cred_6309 VDD.$3765.Metal1 vout3.P18.nSD 3.60018e-05f
Cred_6310 VDD.$3765.Metal1 vout3.P18.pSD 0.00283002f
Cred_6311 VDD.$3770.Metal1 vin4.P39.GatPoly 0.0224991f
Cred_6312 VDD.$3770.Metal1 vout4 0.000679897f
Cred_6313 VDD.$3770.Metal1 vout4.$1424.Metal3 0.00342905f
Cred_6314 VDD.$3770.Metal1 vout4.P18.nSD 5.40214e-05f
Cred_6315 VDD.$3770.Metal1 vout4.P18.pSD 0.00423734f
Cred_6316 VDD.$3771.Metal1 vin4.P39.GatPoly 0.012298f
Cred_6317 VDD.$3771.Metal1 vout4 0.000415073f
Cred_6318 VDD.$3771.Metal1 vout4.$1424.Metal3 0.00209341f
Cred_6319 VDD.$3771.Metal1 vout4.P18.nSD 3.29797e-05f
Cred_6320 VDD.$3771.Metal1 vout4.P18.pSD 0.00257951f
Cred_6321 VDD.$3772.Metal1 vin4.P39.GatPoly 0.0122929f
Cred_6322 VDD.$3772.Metal1 vout4 0.000435831f
Cred_6323 VDD.$3772.Metal1 vout4.$1424.Metal3 0.00219811f
Cred_6324 VDD.$3772.Metal1 vout4.P18.nSD 3.46291e-05f
Cred_6325 VDD.$3772.Metal1 vout4.P18.pSD 0.00272195f
Cred_6326 VDD.$3773.Metal1 vin4.P39.GatPoly 0.0185204f
Cred_6327 VDD.$3773.Metal1 vout4 0.000655717f
Cred_6328 VDD.$3773.Metal1 vout4.$1424.Metal3 0.0033071f
Cred_6329 VDD.$3773.Metal1 vout4.P18.nSD 5.21002e-05f
Cred_6330 VDD.$3773.Metal1 vout4.P18.pSD 0.00408062f
Cred_6331 VDD.$3775.Metal1 vin4.P39.GatPoly 0.0185176f
Cred_6332 VDD.$3775.Metal1 vout4 0.000630786f
Cred_6333 VDD.$3775.Metal1 vout4.$1424.Metal3 0.00318136f
Cred_6334 VDD.$3775.Metal1 vout4.P18.nSD 5.01193e-05f
Cred_6335 VDD.$3775.Metal1 vout4.P18.pSD 0.00378162f
Cred_6336 VDD.$3776.Metal1 vin4.P39.GatPoly 0.0123086f
Cred_6337 VDD.$3776.Metal1 vout4 0.00045858f
Cred_6338 VDD.$3776.Metal1 vout4.$1424.Metal3 0.00231284f
Cred_6339 VDD.$3776.Metal1 vout4.P18.nSD 3.64366e-05f
Cred_6340 VDD.$3776.Metal1 vout4.P18.pSD 0.00273686f
Cred_6341 VDD.$3777.Metal1 vin4.P39.GatPoly 0.0123853f
Cred_6342 VDD.$3777.Metal1 vout4 0.00043286f
Cred_6343 VDD.$3777.Metal1 vout4.$1424.Metal3 0.00218312f
Cred_6344 VDD.$3777.Metal1 vout4.P18.nSD 3.4393e-05f
Cred_6345 VDD.$3777.Metal1 vout4.P18.pSD 0.00266049f
Cred_6346 VDD.$3778.Metal1 vin4.P39.GatPoly 0.0123827f
Cred_6347 VDD.$3778.Metal1 vout4 0.000400635f
Cred_6348 VDD.$3778.Metal1 vout4.$1424.Metal3 0.0020206f
Cred_6349 VDD.$3778.Metal1 vout4.P18.nSD 3.18326e-05f
Cred_6350 VDD.$3778.Metal1 vout4.P18.pSD 0.00250636f
Cred_6351 VDD.$3779.Metal1 vin4.P39.GatPoly 0.0123097f
Cred_6352 VDD.$3779.Metal1 vout4 0.000427534f
Cred_6353 VDD.$3779.Metal1 vout4.$1424.Metal3 0.00215626f
Cred_6354 VDD.$3779.Metal1 vout4.P18.nSD 3.39698e-05f
Cred_6355 VDD.$3779.Metal1 vout4.P18.pSD 0.00265644f
Cred_6356 VDD.$3780.Metal1 vin4.$178.GatPoly 0.00291008f
Cred_6357 VDD.$3780.Metal1 vin4.$456.Metal1 0.0256374f
Cred_6358 VDD.$3780.Metal1 vin4.$648.Metal2 0.000542828f
Cred_6359 VDD.$3780.Metal1 vin4.$653.Metal2 0.0026932f
Cred_6360 VDD.$3780.Metal1 vin4.P39.GatPoly 0.0377404f
Cred_6361 VDD.$3780.Metal1 vout4 0.00268785f
Cred_6362 VDD.$3780.Metal1 vout4.$1424.Metal3 0.0135561f
Cred_6363 VDD.$3780.Metal1 vout4.P18.nSD 0.000213564f
Cred_6364 VDD.$3780.Metal1 vout4.P18.pSD 0.0157886f
Cred_6365 VDD.$3780.Metal1 VSS.$1991.Metal1 0.000261729f
Cred_6366 VDD.$3780.Metal1 VSS.$2023.Metal1 0.000691243f
Cred_6367 VDD.$3780.Metal1 VSS.$4241.Metal2 0.000613828f
Cred_6368 VDD.$3780.Metal1 VSS.$66.Metal1 6.6157e-07f
Cred_6369 VDD.$3780.Metal1 VSS.P0.pSD 0.00258179f
Cred_6370 VDD.$3780.Metal1 VSS.P21.nSD 1.51729e-07f
Cred_6371 VDD.$3780.Metal1 VSS.P23.nSD 1.51729e-07f
Cred_6372 VDD.$3794.Metal1 vin1.P36.GatPoly 0.000553984f
Cred_6373 VDD.$3794.Metal1 vin1.P37.GatPoly 0.000799248f
Cred_6374 VDD.$3794.Metal1 vin1.P38.GatPoly 0.00143423f
Cred_6375 VDD.$3794.Metal1 vin1.P39.GatPoly 0.0277357f
Cred_6376 VDD.$3794.Metal1 vout1 0.00034569f
Cred_6377 VDD.$3794.Metal1 vout1.$1424.Metal3 0.00174348f
Cred_6378 VDD.$3794.Metal1 vout1.P18.nSD 2.74669e-05f
Cred_6379 VDD.$3794.Metal1 vout1.P18.pSD 0.00215744f
Cred_6380 VDD.$3795.Metal1 vin2.P36.GatPoly 0.000830976f
Cred_6381 VDD.$3795.Metal1 vin2.P37.GatPoly 0.00119887f
Cred_6382 VDD.$3795.Metal1 vin2.P38.GatPoly 0.00215135f
Cred_6383 VDD.$3795.Metal1 vin2.P39.GatPoly 0.0296903f
Cred_6384 VDD.$3795.Metal1 vout2 0.000180598f
Cred_6385 VDD.$3795.Metal1 vout2.$1424.Metal3 0.000910842f
Cred_6386 VDD.$3795.Metal1 vout2.P18.nSD 1.43495e-05f
Cred_6387 VDD.$3795.Metal1 vout2.P18.pSD 0.00112701f
Cred_6388 VDD.$3796.Metal1 vin3.P36.GatPoly 0.000553984f
Cred_6389 VDD.$3796.Metal1 vin3.P37.GatPoly 0.000799248f
Cred_6390 VDD.$3796.Metal1 vin3.P38.GatPoly 0.00143423f
Cred_6391 VDD.$3796.Metal1 vin3.P39.GatPoly 0.0277357f
Cred_6392 VDD.$3796.Metal1 vout3 0.00034569f
Cred_6393 VDD.$3796.Metal1 vout3.$1424.Metal3 0.00174348f
Cred_6394 VDD.$3796.Metal1 vout3.P18.nSD 2.74669e-05f
Cred_6395 VDD.$3796.Metal1 vout3.P18.pSD 0.00215744f
Cred_6396 VDD.$3797.Metal1 vin4.P36.GatPoly 0.000830976f
Cred_6397 VDD.$3797.Metal1 vin4.P37.GatPoly 0.00119887f
Cred_6398 VDD.$3797.Metal1 vin4.P38.GatPoly 0.00215135f
Cred_6399 VDD.$3797.Metal1 vin4.P39.GatPoly 0.0296903f
Cred_6400 VDD.$3797.Metal1 vout4 0.000180598f
Cred_6401 VDD.$3797.Metal1 vout4.$1424.Metal3 0.000910842f
Cred_6402 VDD.$3797.Metal1 vout4.P18.nSD 1.43495e-05f
Cred_6403 VDD.$3797.Metal1 vout4.P18.pSD 0.00112701f
Cred_6404 VDD.$3851.Metal1 vin1.P36.GatPoly 0.000276992f
Cred_6405 VDD.$3851.Metal1 vin1.P37.GatPoly 0.000399624f
Cred_6406 VDD.$3851.Metal1 vin1.P38.GatPoly 0.000717115f
Cred_6407 VDD.$3851.Metal1 vin1.P39.GatPoly 0.00736344f
Cred_6408 VDD.$3857.Metal1 vin3.P36.GatPoly 0.000276992f
Cred_6409 VDD.$3857.Metal1 vin3.P37.GatPoly 0.000399624f
Cred_6410 VDD.$3857.Metal1 vin3.P38.GatPoly 0.000717115f
Cred_6411 VDD.$3857.Metal1 vin3.P39.GatPoly 0.00736344f
Cred_6412 VDD.$388.Metal1 vin1.P20.GatPoly 0.0277357f
Cred_6413 VDD.$388.Metal1 vin1.P21.GatPoly 0.00143423f
Cred_6414 VDD.$388.Metal1 vin1.P22.GatPoly 0.000799248f
Cred_6415 VDD.$388.Metal1 vin1.P23.GatPoly 0.000553984f
Cred_6416 VDD.$388.Metal1 vout1.$1226.Metal3 0.00167059f
Cred_6417 VDD.$388.Metal1 vout1.P0.nSD 4.97448e-05f
Cred_6418 VDD.$388.Metal1 vout1.P0.pSD 0.00232623f
Cred_6419 VDD.$388.Metal1 vout1.P2.nSD 2.63185e-05f
Cred_6420 VDD.$388.Metal1 vout1.P2.pSD 0.000143837f
Cred_6421 VDD.$390.Metal1 vin3.P20.GatPoly 0.0277357f
Cred_6422 VDD.$390.Metal1 vin3.P21.GatPoly 0.00143423f
Cred_6423 VDD.$390.Metal1 vin3.P22.GatPoly 0.000799248f
Cred_6424 VDD.$390.Metal1 vin3.P23.GatPoly 0.000553984f
Cred_6425 VDD.$390.Metal1 vout3.$1226.Metal3 0.00167059f
Cred_6426 VDD.$390.Metal1 vout3.P0.nSD 4.97448e-05f
Cred_6427 VDD.$390.Metal1 vout3.P0.pSD 0.00232623f
Cred_6428 VDD.$390.Metal1 vout3.P2.nSD 2.63185e-05f
Cred_6429 VDD.$390.Metal1 vout3.P2.pSD 0.000143837f
Cred_6430 VDD.$4031.Metal1 vin1.P39.GatPoly 3.59626e-06f
Cred_6431 VDD.$4031.Metal1 vout1 9.8497e-06f
Cred_6432 VDD.$4031.Metal1 vout1.$1424.Metal3 4.96767e-05f
Cred_6433 VDD.$4031.Metal1 vout1.P18.nSD 7.8261e-07f
Cred_6434 VDD.$4031.Metal1 vout1.P18.pSD 8.61157e-06f
Cred_6435 VDD.$4032.Metal1 vin1.P39.GatPoly 3.63327e-06f
Cred_6436 VDD.$4032.Metal1 vout1 1.66486e-06f
Cred_6437 VDD.$4032.Metal1 vout1.$1424.Metal3 8.3967e-06f
Cred_6438 VDD.$4032.Metal1 vout1.P18.nSD 1.32282e-07f
Cred_6439 VDD.$4032.Metal1 vout1.P18.pSD 4.01999e-06f
Cred_6440 VDD.$404.Metal1 vin1.P20.GatPoly 7.34336e-05f
Cred_6441 VDD.$404.Metal1 vin2.P20.GatPoly 7.34336e-05f
Cred_6442 VDD.$4059.Metal1 vin3.P39.GatPoly 3.59626e-06f
Cred_6443 VDD.$4059.Metal1 vout3 8.71574e-06f
Cred_6444 VDD.$4059.Metal1 vout3.$1424.Metal3 4.39577e-05f
Cred_6445 VDD.$4059.Metal1 vout3.P18.nSD 6.92512e-07f
Cred_6446 VDD.$4059.Metal1 vout3.P18.pSD 8.12359e-06f
Cred_6447 VDD.$4060.Metal1 vin3.P39.GatPoly 3.63327e-06f
Cred_6448 VDD.$4060.Metal1 vout3 1.66486e-06f
Cred_6449 VDD.$4060.Metal1 vout3.$1424.Metal3 8.3967e-06f
Cred_6450 VDD.$4060.Metal1 vout3.P18.nSD 1.32282e-07f
Cred_6451 VDD.$4060.Metal1 vout3.P18.pSD 4.01999e-06f
Cred_6452 VDD.$410.Metal1 vin3.P20.GatPoly 7.34336e-05f
Cred_6453 VDD.$410.Metal1 vin4.P20.GatPoly 7.34336e-05f
Cred_6454 VDD.$4106.Metal1 vin1.$105.GatPoly 1.01608e-05f
Cred_6455 VDD.$4106.Metal1 vin1.$107.GatPoly 9.60472e-06f
Cred_6456 VDD.$4106.Metal1 vin1.$115.GatPoly 1.69877e-05f
Cred_6457 VDD.$4106.Metal1 vin1.$123.GatPoly 2.23396e-05f
Cred_6458 VDD.$4106.Metal1 vin1.$127.GatPoly 2.25395e-05f
Cred_6459 VDD.$4106.Metal1 vin1.$135.GatPoly 2.89328e-05f
Cred_6460 VDD.$4106.Metal1 vin1.$137.GatPoly 2.78717e-05f
Cred_6461 VDD.$4106.Metal1 vin1.$145.GatPoly 4.661e-05f
Cred_6462 VDD.$4106.Metal1 vin1.$15.GatPoly 4.60498e-07f
Cred_6463 VDD.$4106.Metal1 vin1.$153.GatPoly 6.29334e-05f
Cred_6464 VDD.$4106.Metal1 vin1.$157.GatPoly 5.24185e-05f
Cred_6465 VDD.$4106.Metal1 vin1.$163.GatPoly 7.32856e-05f
Cred_6466 VDD.$4106.Metal1 vin1.$167.GatPoly 7.81108e-05f
Cred_6467 VDD.$4106.Metal1 vin1.$17.GatPoly 4.21591e-07f
Cred_6468 VDD.$4106.Metal1 vin1.$173.GatPoly 0.000100649f
Cred_6469 VDD.$4106.Metal1 vin1.$179.GatPoly 0.000249939f
Cred_6470 VDD.$4106.Metal1 vin1.$203.Metal1 8.51219e-06f
Cred_6471 VDD.$4106.Metal1 vin1.$207.Metal1 2.25307e-06f
Cred_6472 VDD.$4106.Metal1 vin1.$211.Metal1 3.74752e-06f
Cred_6473 VDD.$4106.Metal1 vin1.$219.Metal1 6.0837e-06f
Cred_6474 VDD.$4106.Metal1 vin1.$227.Metal1 6.87998e-06f
Cred_6475 VDD.$4106.Metal1 vin1.$233.Metal1 5.56781e-06f
Cred_6476 VDD.$4106.Metal1 vin1.$237.Metal1 4.51491e-06f
Cred_6477 VDD.$4106.Metal1 vin1.$241.Metal1 7.28259e-06f
Cred_6478 VDD.$4106.Metal1 vin1.$247.Metal1 8.34687e-06f
Cred_6479 VDD.$4106.Metal1 vin1.$25.GatPoly 6.14114e-07f
Cred_6480 VDD.$4106.Metal1 vin1.$251.Metal1 9.53833e-06f
Cred_6481 VDD.$4106.Metal1 vin1.$259.Metal1 1.07827e-05f
Cred_6482 VDD.$4106.Metal1 vin1.$263.Metal1 8.14582e-06f
Cred_6483 VDD.$4106.Metal1 vin1.$265.Metal1 1.35838e-05f
Cred_6484 VDD.$4106.Metal1 vin1.$27.GatPoly 6.10537e-07f
Cred_6485 VDD.$4106.Metal1 vin1.$273.Metal1 1.4997e-05f
Cred_6486 VDD.$4106.Metal1 vin1.$277.Metal1 1.14268e-05f
Cred_6487 VDD.$4106.Metal1 vin1.$281.Metal1 1.28688e-05f
Cred_6488 VDD.$4106.Metal1 vin1.$285.Metal1 2.03027e-05f
Cred_6489 VDD.$4106.Metal1 vin1.$291.Metal1 2.4502e-05f
Cred_6490 VDD.$4106.Metal1 vin1.$295.Metal1 2.66367e-05f
Cred_6491 VDD.$4106.Metal1 vin1.$303.Metal1 2.98384e-05f
Cred_6492 VDD.$4106.Metal1 vin1.$307.Metal1 3.57261e-05f
Cred_6493 VDD.$4106.Metal1 vin1.$313.Metal1 3.88644e-05f
Cred_6494 VDD.$4106.Metal1 vin1.$317.Metal1 2.88794e-05f
Cred_6495 VDD.$4106.Metal1 vin1.$321.Metal1 3.26447e-05f
Cred_6496 VDD.$4106.Metal1 vin1.$325.Metal1 5.17857e-05f
Cred_6497 VDD.$4106.Metal1 vin1.$331.Metal1 5.91018e-05f
Cred_6498 VDD.$4106.Metal1 vin1.$335.Metal1 4.43523e-05f
Cred_6499 VDD.$4106.Metal1 vin1.$339.Metal1 5.0335e-05f
Cred_6500 VDD.$4106.Metal1 vin1.$343.Metal1 5.23457e-05f
Cred_6501 VDD.$4106.Metal1 vin1.$347.Metal1 8.8244e-05f
Cred_6502 VDD.$4106.Metal1 vin1.$353.Metal1 0.000101961f
Cred_6503 VDD.$4106.Metal1 vin1.$357.Metal1 0.000113588f
Cred_6504 VDD.$4106.Metal1 vin1.$365.Metal1 0.00012767f
Cred_6505 VDD.$4106.Metal1 vin1.$369.Metal1 0.000153754f
Cred_6506 VDD.$4106.Metal1 vin1.$37.GatPoly 1.10873e-06f
Cred_6507 VDD.$4106.Metal1 vin1.$375.Metal1 0.00016193f
Cred_6508 VDD.$4106.Metal1 vin1.$379.Metal1 0.000130267f
Cred_6509 VDD.$4106.Metal1 vin1.$383.Metal1 0.000136326f
Cred_6510 VDD.$4106.Metal1 vin1.$387.Metal1 0.000222176f
Cred_6511 VDD.$4106.Metal1 vin1.$393.Metal1 0.000253781f
Cred_6512 VDD.$4106.Metal1 vin1.$397.Metal1 0.000191641f
Cred_6513 VDD.$4106.Metal1 vin1.$401.Metal1 0.000320357f
Cred_6514 VDD.$4106.Metal1 vin1.$409.Metal1 0.000355297f
Cred_6515 VDD.$4106.Metal1 vin1.$413.Metal1 0.000408653f
Cred_6516 VDD.$4106.Metal1 vin1.$419.Metal1 0.000452768f
Cred_6517 VDD.$4106.Metal1 vin1.$423.Metal1 0.000354792f
Cred_6518 VDD.$4106.Metal1 vin1.$427.Metal1 0.000539082f
Cred_6519 VDD.$4106.Metal1 vin1.$43.GatPoly 1.35971e-06f
Cred_6520 VDD.$4106.Metal1 vin1.$433.Metal1 0.0008856f
Cred_6521 VDD.$4106.Metal1 vin1.$441.Metal1 0.00110526f
Cred_6522 VDD.$4106.Metal1 vin1.$449.Metal1 0.000916582f
Cred_6523 VDD.$4106.Metal1 vin1.$453.Metal1 0.000684341f
Cred_6524 VDD.$4106.Metal1 vin1.$457.Metal1 0.00424835f
Cred_6525 VDD.$4106.Metal1 vin1.$47.GatPoly 1.18098e-06f
Cred_6526 VDD.$4106.Metal1 vin1.$477.Metal2 5.61966e-06f
Cred_6527 VDD.$4106.Metal1 vin1.$480.Metal2 4.65469e-06f
Cred_6528 VDD.$4106.Metal1 vin1.$484.Metal2 1.49701e-06f
Cred_6529 VDD.$4106.Metal1 vin1.$486.Metal2 4.11959e-06f
Cred_6530 VDD.$4106.Metal1 vin1.$489.Metal2 1.97454e-06f
Cred_6531 VDD.$4106.Metal1 vin1.$493.Metal2 2.51297e-06f
Cred_6532 VDD.$4106.Metal1 vin1.$495.Metal2 6.27688e-06f
Cred_6533 VDD.$4106.Metal1 vin1.$500.Metal2 2.95204e-06f
Cred_6534 VDD.$4106.Metal1 vin1.$504.Metal2 4.02174e-06f
Cred_6535 VDD.$4106.Metal1 vin1.$506.Metal2 8.16824e-06f
Cred_6536 VDD.$4106.Metal1 vin1.$509.Metal2 2.97317e-06f
Cred_6537 VDD.$4106.Metal1 vin1.$513.Metal2 3.95582e-06f
Cred_6538 VDD.$4106.Metal1 vin1.$515.Metal2 1.66498e-05f
Cred_6539 VDD.$4106.Metal1 vin1.$518.Metal2 4.93269e-06f
Cred_6540 VDD.$4106.Metal1 vin1.$520.Metal2 3.06265e-06f
Cred_6541 VDD.$4106.Metal1 vin1.$523.Metal2 2.29917e-06f
Cred_6542 VDD.$4106.Metal1 vin1.$527.Metal2 1.6923e-05f
Cred_6543 VDD.$4106.Metal1 vin1.$528.Metal2 8.73101e-08f
Cred_6544 VDD.$4106.Metal1 vin1.$53.GatPoly 1.73806e-06f
Cred_6545 VDD.$4106.Metal1 vin1.$533.Metal2 1.17541e-05f
Cred_6546 VDD.$4106.Metal1 vin1.$535.Metal2 2.83417e-05f
Cred_6547 VDD.$4106.Metal1 vin1.$538.Metal2 9.1819e-06f
Cred_6548 VDD.$4106.Metal1 vin1.$542.Metal2 9.90597e-06f
Cred_6549 VDD.$4106.Metal1 vin1.$544.Metal2 3.08908e-05f
Cred_6550 VDD.$4106.Metal1 vin1.$547.Metal2 1.87259e-05f
Cred_6551 VDD.$4106.Metal1 vin1.$551.Metal2 1.98884e-05f
Cred_6552 VDD.$4106.Metal1 vin1.$555.Metal2 5.09057e-05f
Cred_6553 VDD.$4106.Metal1 vin1.$558.Metal2 2.44561e-05f
Cred_6554 VDD.$4106.Metal1 vin1.$562.Metal2 2.74638e-05f
Cred_6555 VDD.$4106.Metal1 vin1.$564.Metal2 6.61997e-05f
Cred_6556 VDD.$4106.Metal1 vin1.$567.Metal2 2.97324e-05f
Cred_6557 VDD.$4106.Metal1 vin1.$57.GatPoly 1.98881e-06f
Cred_6558 VDD.$4106.Metal1 vin1.$571.Metal2 4.21121e-05f
Cred_6559 VDD.$4106.Metal1 vin1.$573.Metal2 0.000100158f
Cred_6560 VDD.$4106.Metal1 vin1.$578.Metal2 4.51304e-05f
Cred_6561 VDD.$4106.Metal1 vin1.$582.Metal2 7.1803e-05f
Cred_6562 VDD.$4106.Metal1 vin1.$584.Metal2 0.000123442f
Cred_6563 VDD.$4106.Metal1 vin1.$587.Metal2 4.63792e-05f
Cred_6564 VDD.$4106.Metal1 vin1.$591.Metal2 6.79435e-05f
Cred_6565 VDD.$4106.Metal1 vin1.$593.Metal2 0.000268149f
Cred_6566 VDD.$4106.Metal1 vin1.$596.Metal2 0.000108638f
Cred_6567 VDD.$4106.Metal1 vin1.$599.Metal2 1.39603e-06f
Cred_6568 VDD.$4106.Metal1 vin1.$603.Metal2 0.000270985f
Cred_6569 VDD.$4106.Metal1 vin1.$604.Metal2 3.67621e-05f
Cred_6570 VDD.$4106.Metal1 vin1.$609.Metal2 7.00837e-05f
Cred_6571 VDD.$4106.Metal1 vin1.$611.Metal2 0.000161374f
Cred_6572 VDD.$4106.Metal1 vin1.$613.Metal2 0.000453279f
Cred_6573 VDD.$4106.Metal1 vin1.$616.Metal2 0.000147723f
Cred_6574 VDD.$4106.Metal1 vin1.$620.Metal2 0.000169712f
Cred_6575 VDD.$4106.Metal1 vin1.$622.Metal2 0.000523434f
Cred_6576 VDD.$4106.Metal1 vin1.$625.Metal2 0.000279431f
Cred_6577 VDD.$4106.Metal1 vin1.$629.Metal2 0.000328691f
Cred_6578 VDD.$4106.Metal1 vin1.$633.Metal2 0.000807797f
Cred_6579 VDD.$4106.Metal1 vin1.$636.Metal2 0.000368504f
Cred_6580 VDD.$4106.Metal1 vin1.$640.Metal2 0.000474085f
Cred_6581 VDD.$4106.Metal1 vin1.$642.Metal2 0.00159788f
Cred_6582 VDD.$4106.Metal1 vin1.$645.Metal2 0.000436769f
Cred_6583 VDD.$4106.Metal1 vin1.$648.Metal2 3.59045e-05f
Cred_6584 VDD.$4106.Metal1 vin1.$649.Metal2 0.000599485f
Cred_6585 VDD.$4106.Metal1 vin1.$65.GatPoly 3.07829e-06f
Cred_6586 VDD.$4106.Metal1 vin1.$653.Metal2 0.000137282f
Cred_6587 VDD.$4106.Metal1 vin1.$654.Metal2 0.0016508f
Cred_6588 VDD.$4106.Metal1 vin1.$73.GatPoly 3.88898e-06f
Cred_6589 VDD.$4106.Metal1 vin1.$77.GatPoly 3.22043e-06f
Cred_6590 VDD.$4106.Metal1 vin1.$83.GatPoly 4.78618e-06f
Cred_6591 VDD.$4106.Metal1 vin1.$87.GatPoly 4.3865e-06f
Cred_6592 VDD.$4106.Metal1 vin1.$9.GatPoly 5.91089e-07f
Cred_6593 VDD.$4106.Metal1 vin1.$93.GatPoly 7.62243e-06f
Cred_6594 VDD.$4106.Metal1 vin1.$97.GatPoly 8.00227e-06f
Cred_6595 VDD.$4106.Metal1 vin1.P20.GatPoly 1.00852e-06f
Cred_6596 VDD.$4106.Metal1 vin1.P24.GatPoly 1.07473e-07f
Cred_6597 VDD.$4106.Metal1 vin1.P27.GatPoly 2.98815e-07f
Cred_6598 VDD.$4106.Metal1 vin1.P32.GatPoly 1.6936e-06f
Cred_6599 VDD.$4106.Metal1 vin1.P35.GatPoly 4.80575e-06f
Cred_6600 VDD.$4106.Metal1 vin1.P39.GatPoly 0.000813324f
Cred_6601 VDD.$4106.Metal1 vin2.$104.GatPoly 1.06977e-05f
Cred_6602 VDD.$4106.Metal1 vin2.$106.GatPoly 1.01123e-05f
Cred_6603 VDD.$4106.Metal1 vin2.$114.GatPoly 1.78855e-05f
Cred_6604 VDD.$4106.Metal1 vin2.$122.GatPoly 2.35202e-05f
Cred_6605 VDD.$4106.Metal1 vin2.$126.GatPoly 2.37307e-05f
Cred_6606 VDD.$4106.Metal1 vin2.$134.GatPoly 3.04619e-05f
Cred_6607 VDD.$4106.Metal1 vin2.$136.GatPoly 2.93447e-05f
Cred_6608 VDD.$4106.Metal1 vin2.$14.GatPoly 4.83838e-07f
Cred_6609 VDD.$4106.Metal1 vin2.$144.GatPoly 4.90734e-05f
Cred_6610 VDD.$4106.Metal1 vin2.$152.GatPoly 6.62595e-05f
Cred_6611 VDD.$4106.Metal1 vin2.$156.GatPoly 5.51888e-05f
Cred_6612 VDD.$4106.Metal1 vin2.$16.GatPoly 4.42586e-07f
Cred_6613 VDD.$4106.Metal1 vin2.$162.GatPoly 7.71588e-05f
Cred_6614 VDD.$4106.Metal1 vin2.$166.GatPoly 8.2239e-05f
Cred_6615 VDD.$4106.Metal1 vin2.$172.GatPoly 0.000105969f
Cred_6616 VDD.$4106.Metal1 vin2.$178.GatPoly 0.000263148f
Cred_6617 VDD.$4106.Metal1 vin2.$202.Metal1 8.90522e-06f
Cred_6618 VDD.$4106.Metal1 vin2.$206.Metal1 2.3634e-06f
Cred_6619 VDD.$4106.Metal1 vin2.$210.Metal1 3.93387e-06f
Cred_6620 VDD.$4106.Metal1 vin2.$218.Metal1 6.39111e-06f
Cred_6621 VDD.$4106.Metal1 vin2.$226.Metal1 7.23228e-06f
Cred_6622 VDD.$4106.Metal1 vin2.$232.Metal1 5.85519e-06f
Cred_6623 VDD.$4106.Metal1 vin2.$236.Metal1 4.749e-06f
Cred_6624 VDD.$4106.Metal1 vin2.$24.GatPoly 6.45901e-07f
Cred_6625 VDD.$4106.Metal1 vin2.$240.Metal1 7.6617e-06f
Cred_6626 VDD.$4106.Metal1 vin2.$246.Metal1 8.78279e-06f
Cred_6627 VDD.$4106.Metal1 vin2.$250.Metal1 1.00379e-05f
Cred_6628 VDD.$4106.Metal1 vin2.$258.Metal1 1.13485e-05f
Cred_6629 VDD.$4106.Metal1 vin2.$26.GatPoly 6.41868e-07f
Cred_6630 VDD.$4106.Metal1 vin2.$262.Metal1 8.57389e-06f
Cred_6631 VDD.$4106.Metal1 vin2.$264.Metal1 1.42985e-05f
Cred_6632 VDD.$4106.Metal1 vin2.$272.Metal1 1.57868e-05f
Cred_6633 VDD.$4106.Metal1 vin2.$276.Metal1 1.2029e-05f
Cred_6634 VDD.$4106.Metal1 vin2.$280.Metal1 1.35473e-05f
Cred_6635 VDD.$4106.Metal1 vin2.$284.Metal1 2.13737e-05f
Cred_6636 VDD.$4106.Metal1 vin2.$290.Metal1 2.5795e-05f
Cred_6637 VDD.$4106.Metal1 vin2.$294.Metal1 2.80428e-05f
Cred_6638 VDD.$4106.Metal1 vin2.$302.Metal1 3.1414e-05f
Cred_6639 VDD.$4106.Metal1 vin2.$306.Metal1 3.76129e-05f
Cred_6640 VDD.$4106.Metal1 vin2.$312.Metal1 4.09173e-05f
Cred_6641 VDD.$4106.Metal1 vin2.$316.Metal1 3.0405e-05f
Cred_6642 VDD.$4106.Metal1 vin2.$320.Metal1 3.43694e-05f
Cred_6643 VDD.$4106.Metal1 vin2.$324.Metal1 5.45218e-05f
Cred_6644 VDD.$4106.Metal1 vin2.$330.Metal1 6.22246e-05f
Cred_6645 VDD.$4106.Metal1 vin2.$334.Metal1 4.6696e-05f
Cred_6646 VDD.$4106.Metal1 vin2.$338.Metal1 5.29948e-05f
Cred_6647 VDD.$4106.Metal1 vin2.$342.Metal1 5.51118e-05f
Cred_6648 VDD.$4106.Metal1 vin2.$346.Metal1 9.29072e-05f
Cred_6649 VDD.$4106.Metal1 vin2.$352.Metal1 0.000107349f
Cred_6650 VDD.$4106.Metal1 vin2.$356.Metal1 0.000119591f
Cred_6651 VDD.$4106.Metal1 vin2.$36.GatPoly 1.16652e-06f
Cred_6652 VDD.$4106.Metal1 vin2.$364.Metal1 0.000134417f
Cred_6653 VDD.$4106.Metal1 vin2.$368.Metal1 0.00016188f
Cred_6654 VDD.$4106.Metal1 vin2.$374.Metal1 0.000170488f
Cred_6655 VDD.$4106.Metal1 vin2.$378.Metal1 0.000137151f
Cred_6656 VDD.$4106.Metal1 vin2.$382.Metal1 0.000143531f
Cred_6657 VDD.$4106.Metal1 vin2.$386.Metal1 0.000233918f
Cred_6658 VDD.$4106.Metal1 vin2.$392.Metal1 0.000267194f
Cred_6659 VDD.$4106.Metal1 vin2.$396.Metal1 0.000201769f
Cred_6660 VDD.$4106.Metal1 vin2.$400.Metal1 0.000337288f
Cred_6661 VDD.$4106.Metal1 vin2.$408.Metal1 0.000374075f
Cred_6662 VDD.$4106.Metal1 vin2.$412.Metal1 0.000430251f
Cred_6663 VDD.$4106.Metal1 vin2.$418.Metal1 0.000476697f
Cred_6664 VDD.$4106.Metal1 vin2.$42.GatPoly 1.43098e-06f
Cred_6665 VDD.$4106.Metal1 vin2.$422.Metal1 0.000373543f
Cred_6666 VDD.$4106.Metal1 vin2.$426.Metal1 0.000567573f
Cred_6667 VDD.$4106.Metal1 vin2.$432.Metal1 0.000932404f
Cred_6668 VDD.$4106.Metal1 vin2.$44.GatPoly 1.24304e-06f
Cred_6669 VDD.$4106.Metal1 vin2.$440.Metal1 0.00116367f
Cred_6670 VDD.$4106.Metal1 vin2.$448.Metal1 0.000965024f
Cred_6671 VDD.$4106.Metal1 vin2.$452.Metal1 0.000720509f
Cred_6672 VDD.$4106.Metal1 vin2.$456.Metal1 0.00447288f
Cred_6673 VDD.$4106.Metal1 vin2.$477.Metal2 5.85722e-06f
Cred_6674 VDD.$4106.Metal1 vin2.$479.Metal2 4.83676e-06f
Cred_6675 VDD.$4106.Metal1 vin2.$483.Metal2 1.57055e-06f
Cred_6676 VDD.$4106.Metal1 vin2.$486.Metal2 4.3238e-06f
Cred_6677 VDD.$4106.Metal1 vin2.$488.Metal2 2.07284e-06f
Cred_6678 VDD.$4106.Metal1 vin2.$492.Metal2 2.64108e-06f
Cred_6679 VDD.$4106.Metal1 vin2.$495.Metal2 6.5983e-06f
Cred_6680 VDD.$4106.Metal1 vin2.$499.Metal2 3.10386e-06f
Cred_6681 VDD.$4106.Metal1 vin2.$503.Metal2 4.23072e-06f
Cred_6682 VDD.$4106.Metal1 vin2.$506.Metal2 8.59324e-06f
Cred_6683 VDD.$4106.Metal1 vin2.$508.Metal2 3.12814e-06f
Cred_6684 VDD.$4106.Metal1 vin2.$512.Metal2 4.163e-06f
Cred_6685 VDD.$4106.Metal1 vin2.$515.Metal2 1.75239e-05f
Cred_6686 VDD.$4106.Metal1 vin2.$517.Metal2 5.19132e-06f
Cred_6687 VDD.$4106.Metal1 vin2.$519.Metal2 3.22362e-06f
Cred_6688 VDD.$4106.Metal1 vin2.$52.GatPoly 1.82954e-06f
Cred_6689 VDD.$4106.Metal1 vin2.$524.Metal2 2.42021e-06f
Cred_6690 VDD.$4106.Metal1 vin2.$525.Metal2 1.78139e-05f
Cred_6691 VDD.$4106.Metal1 vin2.$529.Metal2 9.19067e-08f
Cred_6692 VDD.$4106.Metal1 vin2.$532.Metal2 1.23739e-05f
Cred_6693 VDD.$4106.Metal1 vin2.$535.Metal2 2.98362e-05f
Cred_6694 VDD.$4106.Metal1 vin2.$537.Metal2 9.66631e-06f
Cred_6695 VDD.$4106.Metal1 vin2.$541.Metal2 1.04289e-05f
Cred_6696 VDD.$4106.Metal1 vin2.$544.Metal2 3.25219e-05f
Cred_6697 VDD.$4106.Metal1 vin2.$546.Metal2 1.97147e-05f
Cred_6698 VDD.$4106.Metal1 vin2.$550.Metal2 2.09389e-05f
Cred_6699 VDD.$4106.Metal1 vin2.$555.Metal2 5.35948e-05f
Cred_6700 VDD.$4106.Metal1 vin2.$557.Metal2 2.5748e-05f
Cred_6701 VDD.$4106.Metal1 vin2.$56.GatPoly 2.09364e-06f
Cred_6702 VDD.$4106.Metal1 vin2.$561.Metal2 2.89149e-05f
Cred_6703 VDD.$4106.Metal1 vin2.$564.Metal2 6.96976e-05f
Cred_6704 VDD.$4106.Metal1 vin2.$566.Metal2 3.13035e-05f
Cred_6705 VDD.$4106.Metal1 vin2.$570.Metal2 4.43375e-05f
Cred_6706 VDD.$4106.Metal1 vin2.$573.Metal2 0.000105451f
Cred_6707 VDD.$4106.Metal1 vin2.$577.Metal2 4.75153e-05f
Cred_6708 VDD.$4106.Metal1 vin2.$581.Metal2 7.55976e-05f
Cred_6709 VDD.$4106.Metal1 vin2.$584.Metal2 0.000129965f
Cred_6710 VDD.$4106.Metal1 vin2.$586.Metal2 4.88303e-05f
Cred_6711 VDD.$4106.Metal1 vin2.$590.Metal2 7.15342e-05f
Cred_6712 VDD.$4106.Metal1 vin2.$593.Metal2 0.000282321f
Cred_6713 VDD.$4106.Metal1 vin2.$595.Metal2 0.000114379f
Cred_6714 VDD.$4106.Metal1 vin2.$600.Metal2 1.46981e-06f
Cred_6715 VDD.$4106.Metal1 vin2.$601.Metal2 0.000285306f
Cred_6716 VDD.$4106.Metal1 vin2.$605.Metal2 3.87049e-05f
Cred_6717 VDD.$4106.Metal1 vin2.$608.Metal2 7.37876e-05f
Cred_6718 VDD.$4106.Metal1 vin2.$610.Metal2 0.000169903f
Cred_6719 VDD.$4106.Metal1 vin2.$613.Metal2 0.000477235f
Cred_6720 VDD.$4106.Metal1 vin2.$615.Metal2 0.00015553f
Cred_6721 VDD.$4106.Metal1 vin2.$619.Metal2 0.000178682f
Cred_6722 VDD.$4106.Metal1 vin2.$622.Metal2 0.000551098f
Cred_6723 VDD.$4106.Metal1 vin2.$624.Metal2 0.000294199f
Cred_6724 VDD.$4106.Metal1 vin2.$628.Metal2 0.000346062f
Cred_6725 VDD.$4106.Metal1 vin2.$633.Metal2 0.000850489f
Cred_6726 VDD.$4106.Metal1 vin2.$635.Metal2 0.000387979f
Cred_6727 VDD.$4106.Metal1 vin2.$639.Metal2 0.000499141f
Cred_6728 VDD.$4106.Metal1 vin2.$64.GatPoly 3.24069e-06f
Cred_6729 VDD.$4106.Metal1 vin2.$642.Metal2 0.00169272f
Cred_6730 VDD.$4106.Metal1 vin2.$644.Metal2 0.000459853f
Cred_6731 VDD.$4106.Metal1 vin2.$648.Metal2 0.00063449f
Cred_6732 VDD.$4106.Metal1 vin2.$649.Metal2 3.23264e-05f
Cred_6733 VDD.$4106.Metal1 vin2.$653.Metal2 0.00175075f
Cred_6734 VDD.$4106.Metal1 vin2.$654.Metal2 0.000123601f
Cred_6735 VDD.$4106.Metal1 vin2.$72.GatPoly 4.0943e-06f
Cred_6736 VDD.$4106.Metal1 vin2.$76.GatPoly 3.39051e-06f
Cred_6737 VDD.$4106.Metal1 vin2.$8.GatPoly 6.19089e-07f
Cred_6738 VDD.$4106.Metal1 vin2.$82.GatPoly 5.039e-06f
Cred_6739 VDD.$4106.Metal1 vin2.$86.GatPoly 4.61824e-06f
Cred_6740 VDD.$4106.Metal1 vin2.$92.GatPoly 8.02518e-06f
Cred_6741 VDD.$4106.Metal1 vin2.$96.GatPoly 8.42512e-06f
Cred_6742 VDD.$4106.Metal1 vin2.P20.GatPoly 1.0514e-06f
Cred_6743 VDD.$4106.Metal1 vin2.P24.GatPoly 1.13091e-07f
Cred_6744 VDD.$4106.Metal1 vin2.P27.GatPoly 3.14586e-07f
Cred_6745 VDD.$4106.Metal1 vin2.P32.GatPoly 1.7831e-06f
Cred_6746 VDD.$4106.Metal1 vin2.P35.GatPoly 5.05974e-06f
Cred_6747 VDD.$4106.Metal1 vin2.P39.GatPoly 0.000856308f
Cred_6748 VDD.$4106.Metal1 vout1 0.000884981f
Cred_6749 VDD.$4106.Metal1 vout1.$1226.Metal3 1.20794e-05f
Cred_6750 VDD.$4106.Metal1 vout1.$1292.Metal3 4.39453e-05f
Cred_6751 VDD.$4106.Metal1 vout1.$1358.Metal3 0.000182575f
Cred_6752 VDD.$4106.Metal1 vout1.$1424.Metal3 0.00298408f
Cred_6753 VDD.$4106.Metal1 vout1.P0.nSD 5.14834e-08f
Cred_6754 VDD.$4106.Metal1 vout1.P0.pSD 2.93942e-07f
Cred_6755 VDD.$4106.Metal1 vout1.P10.nSD 3.13851e-07f
Cred_6756 VDD.$4106.Metal1 vout1.P10.pSD 1.69984e-06f
Cred_6757 VDD.$4106.Metal1 vout1.P14.nSD 1.24887e-06f
Cred_6758 VDD.$4106.Metal1 vout1.P14.pSD 6.76394e-06f
Cred_6759 VDD.$4106.Metal1 vout1.P18.nSD 4.07294e-05f
Cred_6760 VDD.$4106.Metal1 vout1.P18.pSD 0.000242776f
Cred_6761 VDD.$4106.Metal1 vout1.P2.nSD 4.10511e-08f
Cred_6762 VDD.$4106.Metal1 vout1.P2.pSD 2.24354e-07f
Cred_6763 VDD.$4106.Metal1 vout1.P6.nSD 7.27504e-08f
Cred_6764 VDD.$4106.Metal1 vout1.P6.pSD 3.97598e-07f
Cred_6765 VDD.$4106.Metal1 vout2 0.000929141f
Cred_6766 VDD.$4106.Metal1 vout2.$1226.Metal3 1.27041e-05f
Cred_6767 VDD.$4106.Metal1 vout2.$1292.Metal3 4.62668e-05f
Cred_6768 VDD.$4106.Metal1 vout2.$1358.Metal3 0.000192224f
Cred_6769 VDD.$4106.Metal1 vout2.$1424.Metal3 0.00312862f
Cred_6770 VDD.$4106.Metal1 vout2.P0.nSD 5.39138e-08f
Cred_6771 VDD.$4106.Metal1 vout2.P0.pSD 3.07624e-07f
Cred_6772 VDD.$4106.Metal1 vout2.P10.nSD 3.30436e-07f
Cred_6773 VDD.$4106.Metal1 vout2.P10.pSD 1.78966e-06f
Cred_6774 VDD.$4106.Metal1 vout2.P14.nSD 1.31487e-06f
Cred_6775 VDD.$4106.Metal1 vout2.P14.pSD 7.12142e-06f
Cred_6776 VDD.$4106.Metal1 vout2.P18.nSD 4.26745e-05f
Cred_6777 VDD.$4106.Metal1 vout2.P18.pSD 0.000253371f
Cred_6778 VDD.$4106.Metal1 vout2.P2.nSD 4.30445e-08f
Cred_6779 VDD.$4106.Metal1 vout2.P2.pSD 2.35248e-07f
Cred_6780 VDD.$4106.Metal1 vout2.P6.nSD 7.65879e-08f
Cred_6781 VDD.$4106.Metal1 vout2.P6.pSD 4.18571e-07f
Cred_6782 VDD.$4106.Metal1 VSS.$157.Metal1 1.50083e-07f
Cred_6783 VDD.$4106.Metal1 VSS.$158.Metal1 1.55205e-07f
Cred_6784 VDD.$4106.Metal1 VSS.$1989.Metal1 0.000506519f
Cred_6785 VDD.$4106.Metal1 VSS.$1990.Metal1 0.00146542f
Cred_6786 VDD.$4106.Metal1 VSS.$2020.Metal1 0.00148122f
Cred_6787 VDD.$4106.Metal1 VSS.$2021.Metal1 0.000223502f
Cred_6788 VDD.$4106.Metal1 VSS.$2226.Metal2 3.58346e-09f
Cred_6789 VDD.$4106.Metal1 VSS.$2228.Metal2 3.82562e-09f
Cred_6790 VDD.$4106.Metal1 VSS.$29.Metal1 7.27312e-06f
Cred_6791 VDD.$4106.Metal1 VSS.$4164.Metal2 0.0001217f
Cred_6792 VDD.$4106.Metal1 VSS.$4227.Metal2 0.000124187f
Cred_6793 VDD.$4106.Metal1 VSS.$68.Metal1 5.56235e-06f
Cred_6794 VDD.$4106.Metal1 VSS.P1.pSD 0.00612473f
Cred_6795 VDD.$4106.Metal1 VSS.P24.nSD 1.00631e-09f
Cred_6796 VDD.$4106.Metal1 VSS.P25.nSD 1.00631e-09f
Cred_6797 VDD.$4106.Metal1 VSS.P3.pSD 0.00684364f
Cred_6798 VDD.$4106.Metal1 VSS.P45.nSD 1.41129e-06f
Cred_6799 VDD.$4106.Metal1 VSS.P47.nSD 1.41129e-06f
Cred_6800 VDD.$4106.Metal1 VSS.P72.nSD 1.07189e-09f
Cred_6801 VDD.$4106.Metal1 VSS.P73.nSD 1.07189e-09f
Cred_6802 VDD.$4106.Metal1 VSS.P93.nSD 1.52676e-06f
Cred_6803 VDD.$4106.Metal1 VSS.P95.nSD 1.52676e-06f
Cred_6804 VDD.$4107.Metal1 vin3.$105.GatPoly 1.01608e-05f
Cred_6805 VDD.$4107.Metal1 vin3.$107.GatPoly 9.60472e-06f
Cred_6806 VDD.$4107.Metal1 vin3.$115.GatPoly 1.69877e-05f
Cred_6807 VDD.$4107.Metal1 vin3.$123.GatPoly 2.23396e-05f
Cred_6808 VDD.$4107.Metal1 vin3.$127.GatPoly 2.25395e-05f
Cred_6809 VDD.$4107.Metal1 vin3.$135.GatPoly 2.89328e-05f
Cred_6810 VDD.$4107.Metal1 vin3.$137.GatPoly 2.78717e-05f
Cred_6811 VDD.$4107.Metal1 vin3.$145.GatPoly 4.661e-05f
Cred_6812 VDD.$4107.Metal1 vin3.$15.GatPoly 4.60498e-07f
Cred_6813 VDD.$4107.Metal1 vin3.$153.GatPoly 6.29334e-05f
Cred_6814 VDD.$4107.Metal1 vin3.$157.GatPoly 5.24185e-05f
Cred_6815 VDD.$4107.Metal1 vin3.$163.GatPoly 7.32856e-05f
Cred_6816 VDD.$4107.Metal1 vin3.$167.GatPoly 7.81108e-05f
Cred_6817 VDD.$4107.Metal1 vin3.$17.GatPoly 4.21591e-07f
Cred_6818 VDD.$4107.Metal1 vin3.$173.GatPoly 0.000100649f
Cred_6819 VDD.$4107.Metal1 vin3.$179.GatPoly 0.000249939f
Cred_6820 VDD.$4107.Metal1 vin3.$203.Metal1 8.51219e-06f
Cred_6821 VDD.$4107.Metal1 vin3.$207.Metal1 2.25307e-06f
Cred_6822 VDD.$4107.Metal1 vin3.$211.Metal1 3.74752e-06f
Cred_6823 VDD.$4107.Metal1 vin3.$219.Metal1 6.0837e-06f
Cred_6824 VDD.$4107.Metal1 vin3.$227.Metal1 6.87998e-06f
Cred_6825 VDD.$4107.Metal1 vin3.$233.Metal1 5.56781e-06f
Cred_6826 VDD.$4107.Metal1 vin3.$237.Metal1 4.51491e-06f
Cred_6827 VDD.$4107.Metal1 vin3.$241.Metal1 7.28259e-06f
Cred_6828 VDD.$4107.Metal1 vin3.$247.Metal1 8.34687e-06f
Cred_6829 VDD.$4107.Metal1 vin3.$25.GatPoly 6.14114e-07f
Cred_6830 VDD.$4107.Metal1 vin3.$251.Metal1 9.53833e-06f
Cred_6831 VDD.$4107.Metal1 vin3.$259.Metal1 1.07827e-05f
Cred_6832 VDD.$4107.Metal1 vin3.$263.Metal1 8.14582e-06f
Cred_6833 VDD.$4107.Metal1 vin3.$265.Metal1 1.35838e-05f
Cred_6834 VDD.$4107.Metal1 vin3.$27.GatPoly 6.10537e-07f
Cred_6835 VDD.$4107.Metal1 vin3.$273.Metal1 1.4997e-05f
Cred_6836 VDD.$4107.Metal1 vin3.$277.Metal1 1.14268e-05f
Cred_6837 VDD.$4107.Metal1 vin3.$281.Metal1 1.28688e-05f
Cred_6838 VDD.$4107.Metal1 vin3.$285.Metal1 2.03027e-05f
Cred_6839 VDD.$4107.Metal1 vin3.$291.Metal1 2.4502e-05f
Cred_6840 VDD.$4107.Metal1 vin3.$295.Metal1 2.66367e-05f
Cred_6841 VDD.$4107.Metal1 vin3.$303.Metal1 2.98384e-05f
Cred_6842 VDD.$4107.Metal1 vin3.$307.Metal1 3.57261e-05f
Cred_6843 VDD.$4107.Metal1 vin3.$313.Metal1 3.88644e-05f
Cred_6844 VDD.$4107.Metal1 vin3.$317.Metal1 2.88794e-05f
Cred_6845 VDD.$4107.Metal1 vin3.$321.Metal1 3.26447e-05f
Cred_6846 VDD.$4107.Metal1 vin3.$325.Metal1 5.17857e-05f
Cred_6847 VDD.$4107.Metal1 vin3.$331.Metal1 5.91018e-05f
Cred_6848 VDD.$4107.Metal1 vin3.$335.Metal1 4.43523e-05f
Cred_6849 VDD.$4107.Metal1 vin3.$339.Metal1 5.0335e-05f
Cred_6850 VDD.$4107.Metal1 vin3.$343.Metal1 5.23457e-05f
Cred_6851 VDD.$4107.Metal1 vin3.$347.Metal1 8.8244e-05f
Cred_6852 VDD.$4107.Metal1 vin3.$353.Metal1 0.000101961f
Cred_6853 VDD.$4107.Metal1 vin3.$357.Metal1 0.000113588f
Cred_6854 VDD.$4107.Metal1 vin3.$365.Metal1 0.00012767f
Cred_6855 VDD.$4107.Metal1 vin3.$369.Metal1 0.000153754f
Cred_6856 VDD.$4107.Metal1 vin3.$37.GatPoly 1.10873e-06f
Cred_6857 VDD.$4107.Metal1 vin3.$375.Metal1 0.00016193f
Cred_6858 VDD.$4107.Metal1 vin3.$379.Metal1 0.000130267f
Cred_6859 VDD.$4107.Metal1 vin3.$383.Metal1 0.000136326f
Cred_6860 VDD.$4107.Metal1 vin3.$387.Metal1 0.000222176f
Cred_6861 VDD.$4107.Metal1 vin3.$393.Metal1 0.000253781f
Cred_6862 VDD.$4107.Metal1 vin3.$397.Metal1 0.000191641f
Cred_6863 VDD.$4107.Metal1 vin3.$401.Metal1 0.000320357f
Cred_6864 VDD.$4107.Metal1 vin3.$409.Metal1 0.000355297f
Cred_6865 VDD.$4107.Metal1 vin3.$413.Metal1 0.000408653f
Cred_6866 VDD.$4107.Metal1 vin3.$419.Metal1 0.000452768f
Cred_6867 VDD.$4107.Metal1 vin3.$423.Metal1 0.000354792f
Cred_6868 VDD.$4107.Metal1 vin3.$427.Metal1 0.000539082f
Cred_6869 VDD.$4107.Metal1 vin3.$43.GatPoly 1.35971e-06f
Cred_6870 VDD.$4107.Metal1 vin3.$433.Metal1 0.0008856f
Cred_6871 VDD.$4107.Metal1 vin3.$441.Metal1 0.00110526f
Cred_6872 VDD.$4107.Metal1 vin3.$449.Metal1 0.000916582f
Cred_6873 VDD.$4107.Metal1 vin3.$453.Metal1 0.000684341f
Cred_6874 VDD.$4107.Metal1 vin3.$457.Metal1 0.00424835f
Cred_6875 VDD.$4107.Metal1 vin3.$47.GatPoly 1.18098e-06f
Cred_6876 VDD.$4107.Metal1 vin3.$477.Metal2 5.61966e-06f
Cred_6877 VDD.$4107.Metal1 vin3.$480.Metal2 4.65469e-06f
Cred_6878 VDD.$4107.Metal1 vin3.$484.Metal2 1.49701e-06f
Cred_6879 VDD.$4107.Metal1 vin3.$486.Metal2 4.11959e-06f
Cred_6880 VDD.$4107.Metal1 vin3.$489.Metal2 1.97454e-06f
Cred_6881 VDD.$4107.Metal1 vin3.$493.Metal2 2.51297e-06f
Cred_6882 VDD.$4107.Metal1 vin3.$495.Metal2 6.27688e-06f
Cred_6883 VDD.$4107.Metal1 vin3.$500.Metal2 2.95204e-06f
Cred_6884 VDD.$4107.Metal1 vin3.$504.Metal2 4.02174e-06f
Cred_6885 VDD.$4107.Metal1 vin3.$506.Metal2 8.16824e-06f
Cred_6886 VDD.$4107.Metal1 vin3.$509.Metal2 2.97317e-06f
Cred_6887 VDD.$4107.Metal1 vin3.$513.Metal2 3.95582e-06f
Cred_6888 VDD.$4107.Metal1 vin3.$515.Metal2 1.66498e-05f
Cred_6889 VDD.$4107.Metal1 vin3.$518.Metal2 4.93269e-06f
Cred_6890 VDD.$4107.Metal1 vin3.$520.Metal2 3.06265e-06f
Cred_6891 VDD.$4107.Metal1 vin3.$523.Metal2 2.29917e-06f
Cred_6892 VDD.$4107.Metal1 vin3.$527.Metal2 1.6923e-05f
Cred_6893 VDD.$4107.Metal1 vin3.$528.Metal2 8.73101e-08f
Cred_6894 VDD.$4107.Metal1 vin3.$53.GatPoly 1.73806e-06f
Cred_6895 VDD.$4107.Metal1 vin3.$533.Metal2 1.17541e-05f
Cred_6896 VDD.$4107.Metal1 vin3.$535.Metal2 2.83417e-05f
Cred_6897 VDD.$4107.Metal1 vin3.$538.Metal2 9.1819e-06f
Cred_6898 VDD.$4107.Metal1 vin3.$542.Metal2 9.90597e-06f
Cred_6899 VDD.$4107.Metal1 vin3.$544.Metal2 3.08908e-05f
Cred_6900 VDD.$4107.Metal1 vin3.$547.Metal2 1.87259e-05f
Cred_6901 VDD.$4107.Metal1 vin3.$551.Metal2 1.98884e-05f
Cred_6902 VDD.$4107.Metal1 vin3.$555.Metal2 5.09057e-05f
Cred_6903 VDD.$4107.Metal1 vin3.$558.Metal2 2.44561e-05f
Cred_6904 VDD.$4107.Metal1 vin3.$562.Metal2 2.74638e-05f
Cred_6905 VDD.$4107.Metal1 vin3.$564.Metal2 6.61997e-05f
Cred_6906 VDD.$4107.Metal1 vin3.$567.Metal2 2.97324e-05f
Cred_6907 VDD.$4107.Metal1 vin3.$57.GatPoly 1.98881e-06f
Cred_6908 VDD.$4107.Metal1 vin3.$571.Metal2 4.21121e-05f
Cred_6909 VDD.$4107.Metal1 vin3.$573.Metal2 0.000100158f
Cred_6910 VDD.$4107.Metal1 vin3.$578.Metal2 4.51304e-05f
Cred_6911 VDD.$4107.Metal1 vin3.$582.Metal2 7.1803e-05f
Cred_6912 VDD.$4107.Metal1 vin3.$584.Metal2 0.000123442f
Cred_6913 VDD.$4107.Metal1 vin3.$587.Metal2 4.63792e-05f
Cred_6914 VDD.$4107.Metal1 vin3.$591.Metal2 6.79435e-05f
Cred_6915 VDD.$4107.Metal1 vin3.$593.Metal2 0.000268149f
Cred_6916 VDD.$4107.Metal1 vin3.$596.Metal2 0.000108638f
Cred_6917 VDD.$4107.Metal1 vin3.$599.Metal2 1.39603e-06f
Cred_6918 VDD.$4107.Metal1 vin3.$603.Metal2 0.000270985f
Cred_6919 VDD.$4107.Metal1 vin3.$604.Metal2 3.67621e-05f
Cred_6920 VDD.$4107.Metal1 vin3.$609.Metal2 7.00837e-05f
Cred_6921 VDD.$4107.Metal1 vin3.$611.Metal2 0.000161374f
Cred_6922 VDD.$4107.Metal1 vin3.$613.Metal2 0.000453279f
Cred_6923 VDD.$4107.Metal1 vin3.$616.Metal2 0.000147723f
Cred_6924 VDD.$4107.Metal1 vin3.$620.Metal2 0.000169712f
Cred_6925 VDD.$4107.Metal1 vin3.$622.Metal2 0.000523434f
Cred_6926 VDD.$4107.Metal1 vin3.$625.Metal2 0.000279431f
Cred_6927 VDD.$4107.Metal1 vin3.$629.Metal2 0.000328691f
Cred_6928 VDD.$4107.Metal1 vin3.$633.Metal2 0.000807797f
Cred_6929 VDD.$4107.Metal1 vin3.$636.Metal2 0.000368504f
Cred_6930 VDD.$4107.Metal1 vin3.$640.Metal2 0.000474085f
Cred_6931 VDD.$4107.Metal1 vin3.$642.Metal2 0.00159788f
Cred_6932 VDD.$4107.Metal1 vin3.$645.Metal2 0.000436769f
Cred_6933 VDD.$4107.Metal1 vin3.$648.Metal2 3.59045e-05f
Cred_6934 VDD.$4107.Metal1 vin3.$649.Metal2 0.000599485f
Cred_6935 VDD.$4107.Metal1 vin3.$65.GatPoly 3.07829e-06f
Cred_6936 VDD.$4107.Metal1 vin3.$653.Metal2 0.000137282f
Cred_6937 VDD.$4107.Metal1 vin3.$654.Metal2 0.0016508f
Cred_6938 VDD.$4107.Metal1 vin3.$73.GatPoly 3.88898e-06f
Cred_6939 VDD.$4107.Metal1 vin3.$77.GatPoly 3.22043e-06f
Cred_6940 VDD.$4107.Metal1 vin3.$83.GatPoly 4.78618e-06f
Cred_6941 VDD.$4107.Metal1 vin3.$87.GatPoly 4.3865e-06f
Cred_6942 VDD.$4107.Metal1 vin3.$9.GatPoly 5.91089e-07f
Cred_6943 VDD.$4107.Metal1 vin3.$93.GatPoly 7.62243e-06f
Cred_6944 VDD.$4107.Metal1 vin3.$97.GatPoly 8.00227e-06f
Cred_6945 VDD.$4107.Metal1 vin3.P20.GatPoly 1.00852e-06f
Cred_6946 VDD.$4107.Metal1 vin3.P24.GatPoly 1.07473e-07f
Cred_6947 VDD.$4107.Metal1 vin3.P27.GatPoly 2.98815e-07f
Cred_6948 VDD.$4107.Metal1 vin3.P32.GatPoly 1.6936e-06f
Cred_6949 VDD.$4107.Metal1 vin3.P35.GatPoly 4.80575e-06f
Cred_6950 VDD.$4107.Metal1 vin3.P39.GatPoly 0.000813324f
Cred_6951 VDD.$4107.Metal1 vin4.$104.GatPoly 1.06977e-05f
Cred_6952 VDD.$4107.Metal1 vin4.$106.GatPoly 1.01123e-05f
Cred_6953 VDD.$4107.Metal1 vin4.$114.GatPoly 1.78855e-05f
Cred_6954 VDD.$4107.Metal1 vin4.$122.GatPoly 2.35202e-05f
Cred_6955 VDD.$4107.Metal1 vin4.$126.GatPoly 2.37307e-05f
Cred_6956 VDD.$4107.Metal1 vin4.$134.GatPoly 3.04619e-05f
Cred_6957 VDD.$4107.Metal1 vin4.$136.GatPoly 2.93447e-05f
Cred_6958 VDD.$4107.Metal1 vin4.$14.GatPoly 4.83838e-07f
Cred_6959 VDD.$4107.Metal1 vin4.$144.GatPoly 4.90734e-05f
Cred_6960 VDD.$4107.Metal1 vin4.$152.GatPoly 6.62595e-05f
Cred_6961 VDD.$4107.Metal1 vin4.$156.GatPoly 5.51888e-05f
Cred_6962 VDD.$4107.Metal1 vin4.$16.GatPoly 4.42586e-07f
Cred_6963 VDD.$4107.Metal1 vin4.$162.GatPoly 7.71588e-05f
Cred_6964 VDD.$4107.Metal1 vin4.$166.GatPoly 8.2239e-05f
Cred_6965 VDD.$4107.Metal1 vin4.$172.GatPoly 0.000105969f
Cred_6966 VDD.$4107.Metal1 vin4.$178.GatPoly 0.000263148f
Cred_6967 VDD.$4107.Metal1 vin4.$202.Metal1 8.90522e-06f
Cred_6968 VDD.$4107.Metal1 vin4.$206.Metal1 2.3634e-06f
Cred_6969 VDD.$4107.Metal1 vin4.$210.Metal1 3.93387e-06f
Cred_6970 VDD.$4107.Metal1 vin4.$218.Metal1 6.39111e-06f
Cred_6971 VDD.$4107.Metal1 vin4.$226.Metal1 7.23228e-06f
Cred_6972 VDD.$4107.Metal1 vin4.$232.Metal1 5.85519e-06f
Cred_6973 VDD.$4107.Metal1 vin4.$236.Metal1 4.749e-06f
Cred_6974 VDD.$4107.Metal1 vin4.$24.GatPoly 6.45901e-07f
Cred_6975 VDD.$4107.Metal1 vin4.$240.Metal1 7.6617e-06f
Cred_6976 VDD.$4107.Metal1 vin4.$246.Metal1 8.78279e-06f
Cred_6977 VDD.$4107.Metal1 vin4.$250.Metal1 1.00379e-05f
Cred_6978 VDD.$4107.Metal1 vin4.$258.Metal1 1.13485e-05f
Cred_6979 VDD.$4107.Metal1 vin4.$26.GatPoly 6.41868e-07f
Cred_6980 VDD.$4107.Metal1 vin4.$262.Metal1 8.57389e-06f
Cred_6981 VDD.$4107.Metal1 vin4.$264.Metal1 1.42985e-05f
Cred_6982 VDD.$4107.Metal1 vin4.$272.Metal1 1.57868e-05f
Cred_6983 VDD.$4107.Metal1 vin4.$276.Metal1 1.2029e-05f
Cred_6984 VDD.$4107.Metal1 vin4.$280.Metal1 1.35473e-05f
Cred_6985 VDD.$4107.Metal1 vin4.$284.Metal1 2.13737e-05f
Cred_6986 VDD.$4107.Metal1 vin4.$290.Metal1 2.5795e-05f
Cred_6987 VDD.$4107.Metal1 vin4.$294.Metal1 2.80428e-05f
Cred_6988 VDD.$4107.Metal1 vin4.$302.Metal1 3.1414e-05f
Cred_6989 VDD.$4107.Metal1 vin4.$306.Metal1 3.76129e-05f
Cred_6990 VDD.$4107.Metal1 vin4.$312.Metal1 4.09173e-05f
Cred_6991 VDD.$4107.Metal1 vin4.$316.Metal1 3.0405e-05f
Cred_6992 VDD.$4107.Metal1 vin4.$320.Metal1 3.43694e-05f
Cred_6993 VDD.$4107.Metal1 vin4.$324.Metal1 5.45218e-05f
Cred_6994 VDD.$4107.Metal1 vin4.$330.Metal1 6.22246e-05f
Cred_6995 VDD.$4107.Metal1 vin4.$334.Metal1 4.6696e-05f
Cred_6996 VDD.$4107.Metal1 vin4.$338.Metal1 5.29948e-05f
Cred_6997 VDD.$4107.Metal1 vin4.$342.Metal1 5.51118e-05f
Cred_6998 VDD.$4107.Metal1 vin4.$346.Metal1 9.29072e-05f
Cred_6999 VDD.$4107.Metal1 vin4.$352.Metal1 0.000107349f
Cred_7000 VDD.$4107.Metal1 vin4.$356.Metal1 0.000119591f
Cred_7001 VDD.$4107.Metal1 vin4.$36.GatPoly 1.16652e-06f
Cred_7002 VDD.$4107.Metal1 vin4.$364.Metal1 0.000134417f
Cred_7003 VDD.$4107.Metal1 vin4.$368.Metal1 0.00016188f
Cred_7004 VDD.$4107.Metal1 vin4.$374.Metal1 0.000170488f
Cred_7005 VDD.$4107.Metal1 vin4.$378.Metal1 0.000137151f
Cred_7006 VDD.$4107.Metal1 vin4.$382.Metal1 0.000143531f
Cred_7007 VDD.$4107.Metal1 vin4.$386.Metal1 0.000233918f
Cred_7008 VDD.$4107.Metal1 vin4.$392.Metal1 0.000267194f
Cred_7009 VDD.$4107.Metal1 vin4.$396.Metal1 0.000201769f
Cred_7010 VDD.$4107.Metal1 vin4.$400.Metal1 0.000337288f
Cred_7011 VDD.$4107.Metal1 vin4.$408.Metal1 0.000374075f
Cred_7012 VDD.$4107.Metal1 vin4.$412.Metal1 0.000430251f
Cred_7013 VDD.$4107.Metal1 vin4.$418.Metal1 0.000476697f
Cred_7014 VDD.$4107.Metal1 vin4.$42.GatPoly 1.43098e-06f
Cred_7015 VDD.$4107.Metal1 vin4.$422.Metal1 0.000373543f
Cred_7016 VDD.$4107.Metal1 vin4.$426.Metal1 0.000567573f
Cred_7017 VDD.$4107.Metal1 vin4.$432.Metal1 0.000932404f
Cred_7018 VDD.$4107.Metal1 vin4.$44.GatPoly 1.24304e-06f
Cred_7019 VDD.$4107.Metal1 vin4.$440.Metal1 0.00116367f
Cred_7020 VDD.$4107.Metal1 vin4.$448.Metal1 0.000965024f
Cred_7021 VDD.$4107.Metal1 vin4.$452.Metal1 0.000720509f
Cred_7022 VDD.$4107.Metal1 vin4.$456.Metal1 0.00447288f
Cred_7023 VDD.$4107.Metal1 vin4.$477.Metal2 5.85722e-06f
Cred_7024 VDD.$4107.Metal1 vin4.$479.Metal2 4.83676e-06f
Cred_7025 VDD.$4107.Metal1 vin4.$483.Metal2 1.57055e-06f
Cred_7026 VDD.$4107.Metal1 vin4.$486.Metal2 4.3238e-06f
Cred_7027 VDD.$4107.Metal1 vin4.$488.Metal2 2.07284e-06f
Cred_7028 VDD.$4107.Metal1 vin4.$492.Metal2 2.64108e-06f
Cred_7029 VDD.$4107.Metal1 vin4.$495.Metal2 6.5983e-06f
Cred_7030 VDD.$4107.Metal1 vin4.$499.Metal2 3.10386e-06f
Cred_7031 VDD.$4107.Metal1 vin4.$503.Metal2 4.23072e-06f
Cred_7032 VDD.$4107.Metal1 vin4.$506.Metal2 8.59324e-06f
Cred_7033 VDD.$4107.Metal1 vin4.$508.Metal2 3.12814e-06f
Cred_7034 VDD.$4107.Metal1 vin4.$512.Metal2 4.163e-06f
Cred_7035 VDD.$4107.Metal1 vin4.$515.Metal2 1.75239e-05f
Cred_7036 VDD.$4107.Metal1 vin4.$517.Metal2 5.19132e-06f
Cred_7037 VDD.$4107.Metal1 vin4.$519.Metal2 3.22362e-06f
Cred_7038 VDD.$4107.Metal1 vin4.$52.GatPoly 1.82954e-06f
Cred_7039 VDD.$4107.Metal1 vin4.$524.Metal2 2.42021e-06f
Cred_7040 VDD.$4107.Metal1 vin4.$525.Metal2 1.78139e-05f
Cred_7041 VDD.$4107.Metal1 vin4.$529.Metal2 9.19067e-08f
Cred_7042 VDD.$4107.Metal1 vin4.$532.Metal2 1.23739e-05f
Cred_7043 VDD.$4107.Metal1 vin4.$535.Metal2 2.98362e-05f
Cred_7044 VDD.$4107.Metal1 vin4.$537.Metal2 9.66631e-06f
Cred_7045 VDD.$4107.Metal1 vin4.$541.Metal2 1.04289e-05f
Cred_7046 VDD.$4107.Metal1 vin4.$544.Metal2 3.25219e-05f
Cred_7047 VDD.$4107.Metal1 vin4.$546.Metal2 1.97147e-05f
Cred_7048 VDD.$4107.Metal1 vin4.$550.Metal2 2.09389e-05f
Cred_7049 VDD.$4107.Metal1 vin4.$555.Metal2 5.35948e-05f
Cred_7050 VDD.$4107.Metal1 vin4.$557.Metal2 2.5748e-05f
Cred_7051 VDD.$4107.Metal1 vin4.$56.GatPoly 2.09364e-06f
Cred_7052 VDD.$4107.Metal1 vin4.$561.Metal2 2.89149e-05f
Cred_7053 VDD.$4107.Metal1 vin4.$564.Metal2 6.96976e-05f
Cred_7054 VDD.$4107.Metal1 vin4.$566.Metal2 3.13035e-05f
Cred_7055 VDD.$4107.Metal1 vin4.$570.Metal2 4.43375e-05f
Cred_7056 VDD.$4107.Metal1 vin4.$573.Metal2 0.000105451f
Cred_7057 VDD.$4107.Metal1 vin4.$577.Metal2 4.75153e-05f
Cred_7058 VDD.$4107.Metal1 vin4.$581.Metal2 7.55976e-05f
Cred_7059 VDD.$4107.Metal1 vin4.$584.Metal2 0.000129965f
Cred_7060 VDD.$4107.Metal1 vin4.$586.Metal2 4.88303e-05f
Cred_7061 VDD.$4107.Metal1 vin4.$590.Metal2 7.15342e-05f
Cred_7062 VDD.$4107.Metal1 vin4.$593.Metal2 0.000282321f
Cred_7063 VDD.$4107.Metal1 vin4.$595.Metal2 0.000114379f
Cred_7064 VDD.$4107.Metal1 vin4.$600.Metal2 1.46981e-06f
Cred_7065 VDD.$4107.Metal1 vin4.$601.Metal2 0.000285306f
Cred_7066 VDD.$4107.Metal1 vin4.$605.Metal2 3.87049e-05f
Cred_7067 VDD.$4107.Metal1 vin4.$608.Metal2 7.37876e-05f
Cred_7068 VDD.$4107.Metal1 vin4.$610.Metal2 0.000169903f
Cred_7069 VDD.$4107.Metal1 vin4.$613.Metal2 0.000477235f
Cred_7070 VDD.$4107.Metal1 vin4.$615.Metal2 0.00015553f
Cred_7071 VDD.$4107.Metal1 vin4.$619.Metal2 0.000178682f
Cred_7072 VDD.$4107.Metal1 vin4.$622.Metal2 0.000551098f
Cred_7073 VDD.$4107.Metal1 vin4.$624.Metal2 0.000294199f
Cred_7074 VDD.$4107.Metal1 vin4.$628.Metal2 0.000346062f
Cred_7075 VDD.$4107.Metal1 vin4.$633.Metal2 0.000850489f
Cred_7076 VDD.$4107.Metal1 vin4.$635.Metal2 0.000387979f
Cred_7077 VDD.$4107.Metal1 vin4.$639.Metal2 0.000499141f
Cred_7078 VDD.$4107.Metal1 vin4.$64.GatPoly 3.24069e-06f
Cred_7079 VDD.$4107.Metal1 vin4.$642.Metal2 0.00169272f
Cred_7080 VDD.$4107.Metal1 vin4.$644.Metal2 0.000459853f
Cred_7081 VDD.$4107.Metal1 vin4.$648.Metal2 0.00063449f
Cred_7082 VDD.$4107.Metal1 vin4.$649.Metal2 3.23264e-05f
Cred_7083 VDD.$4107.Metal1 vin4.$653.Metal2 0.00175075f
Cred_7084 VDD.$4107.Metal1 vin4.$654.Metal2 0.000123601f
Cred_7085 VDD.$4107.Metal1 vin4.$72.GatPoly 4.0943e-06f
Cred_7086 VDD.$4107.Metal1 vin4.$76.GatPoly 3.39051e-06f
Cred_7087 VDD.$4107.Metal1 vin4.$8.GatPoly 6.19089e-07f
Cred_7088 VDD.$4107.Metal1 vin4.$82.GatPoly 5.039e-06f
Cred_7089 VDD.$4107.Metal1 vin4.$86.GatPoly 4.61824e-06f
Cred_7090 VDD.$4107.Metal1 vin4.$92.GatPoly 8.02518e-06f
Cred_7091 VDD.$4107.Metal1 vin4.$96.GatPoly 8.42512e-06f
Cred_7092 VDD.$4107.Metal1 vin4.P20.GatPoly 1.0514e-06f
Cred_7093 VDD.$4107.Metal1 vin4.P24.GatPoly 1.13091e-07f
Cred_7094 VDD.$4107.Metal1 vin4.P27.GatPoly 3.14586e-07f
Cred_7095 VDD.$4107.Metal1 vin4.P32.GatPoly 1.7831e-06f
Cred_7096 VDD.$4107.Metal1 vin4.P35.GatPoly 5.05974e-06f
Cred_7097 VDD.$4107.Metal1 vin4.P39.GatPoly 0.000856308f
Cred_7098 VDD.$4107.Metal1 vout3 0.000884981f
Cred_7099 VDD.$4107.Metal1 vout3.$1226.Metal3 1.20794e-05f
Cred_7100 VDD.$4107.Metal1 vout3.$1292.Metal3 4.39453e-05f
Cred_7101 VDD.$4107.Metal1 vout3.$1358.Metal3 0.000182575f
Cred_7102 VDD.$4107.Metal1 vout3.$1424.Metal3 0.00298408f
Cred_7103 VDD.$4107.Metal1 vout3.P0.nSD 5.14834e-08f
Cred_7104 VDD.$4107.Metal1 vout3.P0.pSD 2.93942e-07f
Cred_7105 VDD.$4107.Metal1 vout3.P10.nSD 3.13851e-07f
Cred_7106 VDD.$4107.Metal1 vout3.P10.pSD 1.69984e-06f
Cred_7107 VDD.$4107.Metal1 vout3.P14.nSD 1.24887e-06f
Cred_7108 VDD.$4107.Metal1 vout3.P14.pSD 6.76394e-06f
Cred_7109 VDD.$4107.Metal1 vout3.P18.nSD 4.07294e-05f
Cred_7110 VDD.$4107.Metal1 vout3.P18.pSD 0.000242776f
Cred_7111 VDD.$4107.Metal1 vout3.P2.nSD 4.10511e-08f
Cred_7112 VDD.$4107.Metal1 vout3.P2.pSD 2.24354e-07f
Cred_7113 VDD.$4107.Metal1 vout3.P6.nSD 7.27504e-08f
Cred_7114 VDD.$4107.Metal1 vout3.P6.pSD 3.97598e-07f
Cred_7115 VDD.$4107.Metal1 vout4 0.000929141f
Cred_7116 VDD.$4107.Metal1 vout4.$1226.Metal3 1.27041e-05f
Cred_7117 VDD.$4107.Metal1 vout4.$1292.Metal3 4.62668e-05f
Cred_7118 VDD.$4107.Metal1 vout4.$1358.Metal3 0.000192224f
Cred_7119 VDD.$4107.Metal1 vout4.$1424.Metal3 0.00312862f
Cred_7120 VDD.$4107.Metal1 vout4.P0.nSD 5.39138e-08f
Cred_7121 VDD.$4107.Metal1 vout4.P0.pSD 3.07624e-07f
Cred_7122 VDD.$4107.Metal1 vout4.P10.nSD 3.30436e-07f
Cred_7123 VDD.$4107.Metal1 vout4.P10.pSD 1.78966e-06f
Cred_7124 VDD.$4107.Metal1 vout4.P14.nSD 1.31487e-06f
Cred_7125 VDD.$4107.Metal1 vout4.P14.pSD 7.12142e-06f
Cred_7126 VDD.$4107.Metal1 vout4.P18.nSD 4.26745e-05f
Cred_7127 VDD.$4107.Metal1 vout4.P18.pSD 0.000253371f
Cred_7128 VDD.$4107.Metal1 vout4.P2.nSD 4.30445e-08f
Cred_7129 VDD.$4107.Metal1 vout4.P2.pSD 2.35248e-07f
Cred_7130 VDD.$4107.Metal1 vout4.P6.nSD 7.65879e-08f
Cred_7131 VDD.$4107.Metal1 vout4.P6.pSD 4.18571e-07f
Cred_7132 VDD.$4107.Metal1 VSS.$159.Metal1 1.49913e-07f
Cred_7133 VDD.$4107.Metal1 VSS.$160.Metal1 1.55381e-07f
Cred_7134 VDD.$4107.Metal1 VSS.$1990.Metal1 0.00139558f
Cred_7135 VDD.$4107.Metal1 VSS.$1991.Metal1 0.000531866f
Cred_7136 VDD.$4107.Metal1 VSS.$2022.Metal1 0.000212598f
Cred_7137 VDD.$4107.Metal1 VSS.$2023.Metal1 0.0015556f
Cred_7138 VDD.$4107.Metal1 VSS.$2238.Metal2 3.69519e-09f
Cred_7139 VDD.$4107.Metal1 VSS.$2240.Metal2 3.70995e-09f
Cred_7140 VDD.$4107.Metal1 VSS.$4174.Metal2 0.000121114f
Cred_7141 VDD.$4107.Metal1 VSS.$4241.Metal2 0.000124935f
Cred_7142 VDD.$4107.Metal1 VSS.$66.Metal1 7.63216e-06f
Cred_7143 VDD.$4107.Metal1 VSS.$68.Metal1 5.30067e-06f
Cred_7144 VDD.$4107.Metal1 VSS.P0.nSD 1.04183e-09f
Cred_7145 VDD.$4107.Metal1 VSS.P0.pSD 0.00643987f
Cred_7146 VDD.$4107.Metal1 VSS.P1.nSD 1.04183e-09f
Cred_7147 VDD.$4107.Metal1 VSS.P2.pSD 0.00650926f
Cred_7148 VDD.$4107.Metal1 VSS.P21.nSD 1.48444e-06f
Cred_7149 VDD.$4107.Metal1 VSS.P23.nSD 1.48444e-06f
Cred_7150 VDD.$4107.Metal1 VSS.P48.nSD 1.03534e-09f
Cred_7151 VDD.$4107.Metal1 VSS.P49.nSD 1.03534e-09f
Cred_7152 VDD.$4107.Metal1 VSS.P69.nSD 1.4515e-06f
Cred_7153 VDD.$4107.Metal1 VSS.P71.nSD 1.4515e-06f
Cred_7154 VDD.$4200.Metal2 vin1.P20.GatPoly 0.00247486f
Cred_7155 VDD.$4202.Metal2 vin1.P20.GatPoly 1.17668e-06f
Cred_7156 VDD.$4202.Metal2 vin2.P20.GatPoly 1.17668e-06f
Cred_7157 VDD.$4204.Metal2 vin1.P20.GatPoly 2.58222e-06f
Cred_7158 VDD.$4204.Metal2 vin2.P20.GatPoly 2.58222e-06f
Cred_7159 VDD.$4210.Metal2 vin2.$202.Metal1 0.0149203f
Cred_7160 VDD.$4210.Metal2 vin2.$477.Metal2 0.0125554f
Cred_7161 VDD.$4210.Metal2 vin2.$479.Metal2 0.0236883f
Cred_7162 VDD.$4210.Metal2 vin2.$8.GatPoly 0.00155763f
Cred_7163 VDD.$4210.Metal2 vin2.P20.GatPoly 0.0802087f
Cred_7164 VDD.$4210.Metal2 vout2.$1226.Metal3 0.128953f
Cred_7165 VDD.$4210.Metal2 vout2.P0.nSD 0.0038398f
Cred_7166 VDD.$4210.Metal2 vout2.P0.pSD 0.0770439f
Cred_7167 VDD.$4210.Metal2 vout2.P2.nSD 0.00203153f
Cred_7168 VDD.$4210.Metal2 vout2.P2.pSD 0.0111028f
Cred_7169 VDD.$4210.Metal2 VSS.$1990.Metal1 1.43601e-07f
Cred_7170 VDD.$4210.Metal2 VSS.$4358.Metal3 0.00284484f
Cred_7171 VDD.$4210.Metal2 VSS.$68.Metal1 0.000207507f
Cred_7172 VDD.$4210.Metal2 VSS.P3.pSD 0.000807069f
Cred_7173 VDD.$4212.Metal2 vin3.P20.GatPoly 0.00247486f
Cred_7174 VDD.$4214.Metal2 vin3.P20.GatPoly 1.17668e-06f
Cred_7175 VDD.$4214.Metal2 vin4.P20.GatPoly 1.17668e-06f
Cred_7176 VDD.$4216.Metal2 vin3.P20.GatPoly 2.58222e-06f
Cred_7177 VDD.$4216.Metal2 vin4.P20.GatPoly 2.58222e-06f
Cred_7178 VDD.$4222.Metal2 vin4.$202.Metal1 0.0149203f
Cred_7179 VDD.$4222.Metal2 vin4.$477.Metal2 0.0125554f
Cred_7180 VDD.$4222.Metal2 vin4.$479.Metal2 0.0236883f
Cred_7181 VDD.$4222.Metal2 vin4.$8.GatPoly 0.00155763f
Cred_7182 VDD.$4222.Metal2 vin4.P20.GatPoly 0.0802087f
Cred_7183 VDD.$4222.Metal2 vout4.$1226.Metal3 0.129293f
Cred_7184 VDD.$4222.Metal2 vout4.P0.nSD 0.00384994f
Cred_7185 VDD.$4222.Metal2 vout4.P0.pSD 0.0771394f
Cred_7186 VDD.$4222.Metal2 vout4.P2.nSD 0.00203689f
Cred_7187 VDD.$4222.Metal2 vout4.P2.pSD 0.0111321f
Cred_7188 VDD.$4222.Metal2 VSS.$1991.Metal1 5.00861e-08f
Cred_7189 VDD.$4222.Metal2 VSS.$2023.Metal1 1.25406e-07f
Cred_7190 VDD.$4222.Metal2 VSS.$4241.Metal2 3.35748e-10f
Cred_7191 VDD.$4222.Metal2 VSS.$4364.Metal3 0.000817417f
Cred_7192 VDD.$4222.Metal2 VSS.$66.Metal1 0.000286124f
Cred_7193 VDD.$4222.Metal2 VSS.P0.pSD 0.00072842f
Cred_7194 VDD.$4231.Metal2 vin1.$203.Metal1 0.0151015f
Cred_7195 VDD.$4231.Metal2 vin1.$477.Metal2 0.016881f
Cred_7196 VDD.$4231.Metal2 vin1.$480.Metal2 0.0317444f
Cred_7197 VDD.$4231.Metal2 vin1.$9.GatPoly 0.00153056f
Cred_7198 VDD.$4231.Metal2 vin1.P20.GatPoly 0.0380441f
Cred_7199 VDD.$4231.Metal2 vout1.$1226.Metal3 0.0999205f
Cred_7200 VDD.$4231.Metal2 vout1.P0.nSD 0.00297532f
Cred_7201 VDD.$4231.Metal2 vout1.P0.pSD 0.0540137f
Cred_7202 VDD.$4231.Metal2 vout1.P2.nSD 0.00157415f
Cred_7203 VDD.$4231.Metal2 vout1.P2.pSD 0.00860311f
Cred_7204 VDD.$4231.Metal2 VSS.$1989.Metal1 3.33606e-08f
Cred_7205 VDD.$4231.Metal2 VSS.$2020.Metal1 8.35281e-08f
Cred_7206 VDD.$4231.Metal2 VSS.$29.Metal1 0.000190577f
Cred_7207 VDD.$4231.Metal2 VSS.$4227.Metal2 2.23629e-10f
Cred_7208 VDD.$4231.Metal2 VSS.$4355.Metal3 0.00111731f
Cred_7209 VDD.$4231.Metal2 VSS.P1.pSD 0.000485174f
Cred_7210 VDD.$4233.Metal2 vin1.P20.GatPoly 0.00963863f
Cred_7211 VDD.$4233.Metal2 vout1.$1226.Metal3 0.0221902f
Cred_7212 VDD.$4233.Metal2 vout1.P0.nSD 0.000660753f
Cred_7213 VDD.$4233.Metal2 vout1.P0.pSD 0.0130282f
Cred_7214 VDD.$4233.Metal2 vout1.P2.nSD 0.000349585f
Cred_7215 VDD.$4233.Metal2 vout1.P2.pSD 0.00191056f
Cred_7216 VDD.$4235.Metal2 vin1.P20.GatPoly 0.00720482f
Cred_7217 VDD.$4235.Metal2 vout1.$1226.Metal3 0.016544f
Cred_7218 VDD.$4235.Metal2 vout1.P0.nSD 0.000492629f
Cred_7219 VDD.$4235.Metal2 vout1.P0.pSD 0.0098817f
Cred_7220 VDD.$4235.Metal2 vout1.P2.nSD 0.000260636f
Cred_7221 VDD.$4235.Metal2 vout1.P2.pSD 0.00142443f
Cred_7222 VDD.$4236.Metal2 vin1.P20.GatPoly 0.0048263f
Cred_7223 VDD.$4236.Metal2 vout1.$1226.Metal3 0.0110085f
Cred_7224 VDD.$4236.Metal2 vout1.P0.nSD 0.000327798f
Cred_7225 VDD.$4236.Metal2 vout1.P0.pSD 0.00663332f
Cred_7226 VDD.$4236.Metal2 vout1.P2.nSD 0.000173428f
Cred_7227 VDD.$4236.Metal2 vout1.P2.pSD 0.000947826f
Cred_7228 VDD.$4237.Metal2 vin1.P20.GatPoly 0.00834493f
Cred_7229 VDD.$4237.Metal2 vout1.$1226.Metal3 0.0145334f
Cred_7230 VDD.$4237.Metal2 vout1.P0.nSD 0.000432759f
Cred_7231 VDD.$4237.Metal2 vout1.P0.pSD 0.00878104f
Cred_7232 VDD.$4237.Metal2 vout1.P2.nSD 0.00022896f
Cred_7233 VDD.$4237.Metal2 vout1.P2.pSD 0.00125132f
Cred_7234 VDD.$4259.Metal2 vin3.$203.Metal1 0.0151015f
Cred_7235 VDD.$4259.Metal2 vin3.$477.Metal2 0.016881f
Cred_7236 VDD.$4259.Metal2 vin3.$480.Metal2 0.0317444f
Cred_7237 VDD.$4259.Metal2 vin3.$9.GatPoly 0.00153056f
Cred_7238 VDD.$4259.Metal2 vin3.P20.GatPoly 0.0380441f
Cred_7239 VDD.$4259.Metal2 vout3.$1226.Metal3 0.0994576f
Cred_7240 VDD.$4259.Metal2 vout3.P0.nSD 0.00296153f
Cred_7241 VDD.$4259.Metal2 vout3.P0.pSD 0.0538838f
Cred_7242 VDD.$4259.Metal2 vout3.P2.nSD 0.00156686f
Cred_7243 VDD.$4259.Metal2 vout3.P2.pSD 0.00856326f
Cred_7244 VDD.$4259.Metal2 VSS.$1990.Metal1 9.56473e-08f
Cred_7245 VDD.$4259.Metal2 VSS.$4358.Metal3 0.00388855f
Cred_7246 VDD.$4259.Metal2 VSS.$68.Metal1 0.000138213f
Cred_7247 VDD.$4259.Metal2 VSS.P2.pSD 0.000537559f
Cred_7248 VDD.$4261.Metal2 vin3.P20.GatPoly 0.00963863f
Cred_7249 VDD.$4261.Metal2 vout3.$1226.Metal3 0.0221902f
Cred_7250 VDD.$4261.Metal2 vout3.P0.nSD 0.000660753f
Cred_7251 VDD.$4261.Metal2 vout3.P0.pSD 0.0130282f
Cred_7252 VDD.$4261.Metal2 vout3.P2.nSD 0.000349585f
Cred_7253 VDD.$4261.Metal2 vout3.P2.pSD 0.00191056f
Cred_7254 VDD.$4263.Metal2 vin3.P20.GatPoly 0.00720482f
Cred_7255 VDD.$4263.Metal2 vout3.$1226.Metal3 0.016544f
Cred_7256 VDD.$4263.Metal2 vout3.P0.nSD 0.000492629f
Cred_7257 VDD.$4263.Metal2 vout3.P0.pSD 0.0098817f
Cred_7258 VDD.$4263.Metal2 vout3.P2.nSD 0.000260636f
Cred_7259 VDD.$4263.Metal2 vout3.P2.pSD 0.00142443f
Cred_7260 VDD.$4264.Metal2 vin3.P20.GatPoly 0.0048263f
Cred_7261 VDD.$4264.Metal2 vout3.$1226.Metal3 0.0110085f
Cred_7262 VDD.$4264.Metal2 vout3.P0.nSD 0.000327798f
Cred_7263 VDD.$4264.Metal2 vout3.P0.pSD 0.00663332f
Cred_7264 VDD.$4264.Metal2 vout3.P2.nSD 0.000173428f
Cred_7265 VDD.$4264.Metal2 vout3.P2.pSD 0.000947826f
Cred_7266 VDD.$4265.Metal2 vin3.P20.GatPoly 0.00834493f
Cred_7267 VDD.$4265.Metal2 vout3.$1226.Metal3 0.0145334f
Cred_7268 VDD.$4265.Metal2 vout3.P0.nSD 0.000432759f
Cred_7269 VDD.$4265.Metal2 vout3.P0.pSD 0.00878104f
Cred_7270 VDD.$4265.Metal2 vout3.P2.nSD 0.00022896f
Cred_7271 VDD.$4265.Metal2 vout3.P2.pSD 0.00125132f
Cred_7272 VDD.$4526.Metal2 vin1.$203.Metal1 2.13032e-05f
Cred_7273 VDD.$4526.Metal2 vin1.$477.Metal2 0.000184494f
Cred_7274 VDD.$4526.Metal2 vin1.$480.Metal2 0.000343895f
Cred_7275 VDD.$4526.Metal2 vin1.$9.GatPoly 3.88191e-07f
Cred_7276 VDD.$4526.Metal2 vin1.P20.GatPoly 0.0155926f
Cred_7277 VDD.$4526.Metal2 vin2.$202.Metal1 2.13032e-05f
Cred_7278 VDD.$4526.Metal2 vin2.$477.Metal2 0.000184494f
Cred_7279 VDD.$4526.Metal2 vin2.$479.Metal2 0.000343895f
Cred_7280 VDD.$4526.Metal2 vin2.$8.GatPoly 3.88191e-07f
Cred_7281 VDD.$4526.Metal2 vin2.P20.GatPoly 0.0155926f
Cred_7282 VDD.$4526.Metal2 vout1.$1226.Metal3 0.000814108f
Cred_7283 VDD.$4526.Metal2 vout1.P0.nSD 2.42416e-05f
Cred_7284 VDD.$4526.Metal2 vout1.P0.pSD 0.000331365f
Cred_7285 VDD.$4526.Metal2 vout1.P2.nSD 1.28255e-05f
Cred_7286 VDD.$4526.Metal2 vout1.P2.pSD 7.00943e-05f
Cred_7287 VDD.$4526.Metal2 vout2.$1226.Metal3 0.000814108f
Cred_7288 VDD.$4526.Metal2 vout2.P0.nSD 2.42416e-05f
Cred_7289 VDD.$4526.Metal2 vout2.P0.pSD 0.000331365f
Cred_7290 VDD.$4526.Metal2 vout2.P2.nSD 1.28255e-05f
Cred_7291 VDD.$4526.Metal2 vout2.P2.pSD 7.00943e-05f
Cred_7292 VDD.$4538.Metal2 vin3.$203.Metal1 2.13032e-05f
Cred_7293 VDD.$4538.Metal2 vin3.$477.Metal2 0.000184494f
Cred_7294 VDD.$4538.Metal2 vin3.$480.Metal2 0.000343895f
Cred_7295 VDD.$4538.Metal2 vin3.$9.GatPoly 3.88191e-07f
Cred_7296 VDD.$4538.Metal2 vin3.P20.GatPoly 0.0155926f
Cred_7297 VDD.$4538.Metal2 vin4.$202.Metal1 2.13032e-05f
Cred_7298 VDD.$4538.Metal2 vin4.$477.Metal2 0.000184494f
Cred_7299 VDD.$4538.Metal2 vin4.$479.Metal2 0.000343895f
Cred_7300 VDD.$4538.Metal2 vin4.$8.GatPoly 3.88191e-07f
Cred_7301 VDD.$4538.Metal2 vin4.P20.GatPoly 0.0155926f
Cred_7302 VDD.$4538.Metal2 vout3.$1226.Metal3 0.000814108f
Cred_7303 VDD.$4538.Metal2 vout3.P0.nSD 2.42416e-05f
Cred_7304 VDD.$4538.Metal2 vout3.P0.pSD 0.000331365f
Cred_7305 VDD.$4538.Metal2 vout3.P2.nSD 1.28255e-05f
Cred_7306 VDD.$4538.Metal2 vout3.P2.pSD 7.00943e-05f
Cred_7307 VDD.$4538.Metal2 vout4.$1226.Metal3 0.000814108f
Cred_7308 VDD.$4538.Metal2 vout4.P0.nSD 2.42416e-05f
Cred_7309 VDD.$4538.Metal2 vout4.P0.pSD 0.000331365f
Cred_7310 VDD.$4538.Metal2 vout4.P2.nSD 1.28255e-05f
Cred_7311 VDD.$4538.Metal2 vout4.P2.pSD 7.00943e-05f
Cred_7312 VDD.$4574.Metal2 vin1.$203.Metal1 2.13032e-05f
Cred_7313 VDD.$4574.Metal2 vin1.$477.Metal2 0.000184494f
Cred_7314 VDD.$4574.Metal2 vin1.$480.Metal2 0.000343895f
Cred_7315 VDD.$4574.Metal2 vin1.$9.GatPoly 3.88191e-07f
Cred_7316 VDD.$4574.Metal2 vin1.P20.GatPoly 0.00498058f
Cred_7317 VDD.$4574.Metal2 vin1.P21.GatPoly 0.00323095f
Cred_7318 VDD.$4574.Metal2 vin2.$202.Metal1 2.13032e-05f
Cred_7319 VDD.$4574.Metal2 vin2.$477.Metal2 0.000184494f
Cred_7320 VDD.$4574.Metal2 vin2.$479.Metal2 0.000343895f
Cred_7321 VDD.$4574.Metal2 vin2.$8.GatPoly 3.88191e-07f
Cred_7322 VDD.$4574.Metal2 vin2.P20.GatPoly 0.00498058f
Cred_7323 VDD.$4574.Metal2 vin2.P21.GatPoly 0.00323095f
Cred_7324 VDD.$4574.Metal2 vout1.$1226.Metal3 0.0071698f
Cred_7325 VDD.$4574.Metal2 vout1.P0.nSD 0.000213494f
Cred_7326 VDD.$4574.Metal2 vout1.P0.pSD 0.00503118f
Cred_7327 VDD.$4574.Metal2 vout1.P2.nSD 0.000112953f
Cred_7328 VDD.$4574.Metal2 vout1.P2.pSD 0.000617317f
Cred_7329 VDD.$4574.Metal2 vout2.$1226.Metal3 0.0071698f
Cred_7330 VDD.$4574.Metal2 vout2.P0.nSD 0.000213494f
Cred_7331 VDD.$4574.Metal2 vout2.P0.pSD 0.00503118f
Cred_7332 VDD.$4574.Metal2 vout2.P2.nSD 0.000112953f
Cred_7333 VDD.$4574.Metal2 vout2.P2.pSD 0.000617317f
Cred_7334 VDD.$4586.Metal2 vin3.$203.Metal1 2.13032e-05f
Cred_7335 VDD.$4586.Metal2 vin3.$477.Metal2 0.000184494f
Cred_7336 VDD.$4586.Metal2 vin3.$480.Metal2 0.000343895f
Cred_7337 VDD.$4586.Metal2 vin3.$9.GatPoly 3.88191e-07f
Cred_7338 VDD.$4586.Metal2 vin3.P20.GatPoly 0.00498058f
Cred_7339 VDD.$4586.Metal2 vin3.P21.GatPoly 0.00323095f
Cred_7340 VDD.$4586.Metal2 vin4.$202.Metal1 2.13032e-05f
Cred_7341 VDD.$4586.Metal2 vin4.$477.Metal2 0.000184494f
Cred_7342 VDD.$4586.Metal2 vin4.$479.Metal2 0.000343895f
Cred_7343 VDD.$4586.Metal2 vin4.$8.GatPoly 3.88191e-07f
Cred_7344 VDD.$4586.Metal2 vin4.P20.GatPoly 0.00498058f
Cred_7345 VDD.$4586.Metal2 vin4.P21.GatPoly 0.00323095f
Cred_7346 VDD.$4586.Metal2 vout3.$1226.Metal3 0.0071698f
Cred_7347 VDD.$4586.Metal2 vout3.P0.nSD 0.000213494f
Cred_7348 VDD.$4586.Metal2 vout3.P0.pSD 0.00503118f
Cred_7349 VDD.$4586.Metal2 vout3.P2.nSD 0.000112953f
Cred_7350 VDD.$4586.Metal2 vout3.P2.pSD 0.000617317f
Cred_7351 VDD.$4586.Metal2 vout4.$1226.Metal3 0.0071698f
Cred_7352 VDD.$4586.Metal2 vout4.P0.nSD 0.000213494f
Cred_7353 VDD.$4586.Metal2 vout4.P0.pSD 0.00503118f
Cred_7354 VDD.$4586.Metal2 vout4.P2.nSD 0.000112953f
Cred_7355 VDD.$4586.Metal2 vout4.P2.pSD 0.000617317f
Cred_7356 VDD.$4622.Metal2 vin1.$203.Metal1 9.54774e-06f
Cred_7357 VDD.$4622.Metal2 vin1.$207.Metal1 1.45643e-06f
Cred_7358 VDD.$4622.Metal2 vin1.$480.Metal2 0.000577748f
Cred_7359 VDD.$4622.Metal2 vin1.$484.Metal2 0.000577748f
Cred_7360 VDD.$4622.Metal2 vin1.P21.GatPoly 0.0137725f
Cred_7361 VDD.$4622.Metal2 vin2.$202.Metal1 9.54774e-06f
Cred_7362 VDD.$4622.Metal2 vin2.$206.Metal1 1.45643e-06f
Cred_7363 VDD.$4622.Metal2 vin2.$479.Metal2 0.000577748f
Cred_7364 VDD.$4622.Metal2 vin2.$483.Metal2 0.000577748f
Cred_7365 VDD.$4622.Metal2 vin2.P21.GatPoly 0.0137725f
Cred_7366 VDD.$4622.Metal2 vout1.$1226.Metal3 0.00184346f
Cred_7367 VDD.$4622.Metal2 vout1.P0.nSD 5.48923e-05f
Cred_7368 VDD.$4622.Metal2 vout1.P0.pSD 0.0011431f
Cred_7369 VDD.$4622.Metal2 vout1.P2.nSD 2.90419e-05f
Cred_7370 VDD.$4622.Metal2 vout1.P2.pSD 0.000158721f
Cred_7371 VDD.$4622.Metal2 vout2.$1226.Metal3 0.00184346f
Cred_7372 VDD.$4622.Metal2 vout2.P0.nSD 5.48923e-05f
Cred_7373 VDD.$4622.Metal2 vout2.P0.pSD 0.0011431f
Cred_7374 VDD.$4622.Metal2 vout2.P2.nSD 2.90419e-05f
Cred_7375 VDD.$4622.Metal2 vout2.P2.pSD 0.000158721f
Cred_7376 VDD.$4634.Metal2 vin3.$203.Metal1 9.54774e-06f
Cred_7377 VDD.$4634.Metal2 vin3.$207.Metal1 1.45643e-06f
Cred_7378 VDD.$4634.Metal2 vin3.$480.Metal2 0.000577748f
Cred_7379 VDD.$4634.Metal2 vin3.$484.Metal2 0.000577748f
Cred_7380 VDD.$4634.Metal2 vin3.P21.GatPoly 0.0137725f
Cred_7381 VDD.$4634.Metal2 vin4.$202.Metal1 9.54774e-06f
Cred_7382 VDD.$4634.Metal2 vin4.$206.Metal1 1.45643e-06f
Cred_7383 VDD.$4634.Metal2 vin4.$479.Metal2 0.000577748f
Cred_7384 VDD.$4634.Metal2 vin4.$483.Metal2 0.000577748f
Cred_7385 VDD.$4634.Metal2 vin4.P21.GatPoly 0.0137725f
Cred_7386 VDD.$4634.Metal2 vout3.$1226.Metal3 0.00184346f
Cred_7387 VDD.$4634.Metal2 vout3.P0.nSD 5.48923e-05f
Cred_7388 VDD.$4634.Metal2 vout3.P0.pSD 0.0011431f
Cred_7389 VDD.$4634.Metal2 vout3.P2.nSD 2.90419e-05f
Cred_7390 VDD.$4634.Metal2 vout3.P2.pSD 0.000158721f
Cred_7391 VDD.$4634.Metal2 vout4.$1226.Metal3 0.00184346f
Cred_7392 VDD.$4634.Metal2 vout4.P0.nSD 5.48923e-05f
Cred_7393 VDD.$4634.Metal2 vout4.P0.pSD 0.0011431f
Cred_7394 VDD.$4634.Metal2 vout4.P2.nSD 2.90419e-05f
Cred_7395 VDD.$4634.Metal2 vout4.P2.pSD 0.000158721f
Cred_7396 VDD.$4646.Metal2 vin1.$15.GatPoly 0.0115885f
Cred_7397 VDD.$4646.Metal2 vin1.$17.GatPoly 0.00240959f
Cred_7398 VDD.$4646.Metal2 vin1.$207.Metal1 0.00258982f
Cred_7399 VDD.$4646.Metal2 vin1.$211.Metal1 0.00585667f
Cred_7400 VDD.$4646.Metal2 vin1.$219.Metal1 0.000911526f
Cred_7401 VDD.$4646.Metal2 vin1.$484.Metal2 0.00681958f
Cred_7402 VDD.$4646.Metal2 vin1.$486.Metal2 0.00105711f
Cred_7403 VDD.$4646.Metal2 vin1.$489.Metal2 0.00857241f
Cred_7404 VDD.$4646.Metal2 vin1.$493.Metal2 2.23338e-06f
Cred_7405 VDD.$4646.Metal2 vin1.$9.GatPoly 0.010574f
Cred_7406 VDD.$4646.Metal2 vin1.P20.GatPoly 0.000550551f
Cred_7407 VDD.$4646.Metal2 vin1.P21.GatPoly 0.0422227f
Cred_7408 VDD.$4646.Metal2 vin1.P22.GatPoly 0.0383451f
Cred_7409 VDD.$4646.Metal2 vin1.P23.GatPoly 0.000499317f
Cred_7410 VDD.$4646.Metal2 vin2.$14.GatPoly 0.0115885f
Cred_7411 VDD.$4646.Metal2 vin2.$16.GatPoly 0.00240959f
Cred_7412 VDD.$4646.Metal2 vin2.$206.Metal1 0.00258982f
Cred_7413 VDD.$4646.Metal2 vin2.$210.Metal1 0.00585667f
Cred_7414 VDD.$4646.Metal2 vin2.$218.Metal1 0.000911526f
Cred_7415 VDD.$4646.Metal2 vin2.$483.Metal2 0.00681958f
Cred_7416 VDD.$4646.Metal2 vin2.$486.Metal2 0.00105711f
Cred_7417 VDD.$4646.Metal2 vin2.$488.Metal2 0.00857241f
Cred_7418 VDD.$4646.Metal2 vin2.$492.Metal2 2.23338e-06f
Cred_7419 VDD.$4646.Metal2 vin2.$8.GatPoly 0.010574f
Cred_7420 VDD.$4646.Metal2 vin2.P20.GatPoly 0.000550551f
Cred_7421 VDD.$4646.Metal2 vin2.P21.GatPoly 0.0423094f
Cred_7422 VDD.$4646.Metal2 vin2.P22.GatPoly 0.0382584f
Cred_7423 VDD.$4646.Metal2 vin2.P23.GatPoly 0.000499317f
Cred_7424 VDD.$4646.Metal2 vout1.$1226.Metal3 0.101803f
Cred_7425 VDD.$4646.Metal2 vout1.P0.nSD 0.00225031f
Cred_7426 VDD.$4646.Metal2 vout1.P0.pSD 0.0388761f
Cred_7427 VDD.$4646.Metal2 vout1.P2.nSD 0.0016038f
Cred_7428 VDD.$4646.Metal2 vout1.P2.pSD 0.0320316f
Cred_7429 VDD.$4646.Metal2 vout2.$1226.Metal3 0.101676f
Cred_7430 VDD.$4646.Metal2 vout2.P0.nSD 0.00224647f
Cred_7431 VDD.$4646.Metal2 vout2.P0.pSD 0.0388602f
Cred_7432 VDD.$4646.Metal2 vout2.P2.nSD 0.00160181f
Cred_7433 VDD.$4646.Metal2 vout2.P2.pSD 0.0320618f
Cred_7434 VDD.$4658.Metal2 vin3.$15.GatPoly 0.0115885f
Cred_7435 VDD.$4658.Metal2 vin3.$17.GatPoly 0.00240959f
Cred_7436 VDD.$4658.Metal2 vin3.$207.Metal1 0.00258982f
Cred_7437 VDD.$4658.Metal2 vin3.$211.Metal1 0.00585667f
Cred_7438 VDD.$4658.Metal2 vin3.$219.Metal1 0.000911526f
Cred_7439 VDD.$4658.Metal2 vin3.$484.Metal2 0.00681958f
Cred_7440 VDD.$4658.Metal2 vin3.$486.Metal2 0.00105711f
Cred_7441 VDD.$4658.Metal2 vin3.$489.Metal2 0.00857241f
Cred_7442 VDD.$4658.Metal2 vin3.$493.Metal2 2.23338e-06f
Cred_7443 VDD.$4658.Metal2 vin3.$9.GatPoly 0.010574f
Cred_7444 VDD.$4658.Metal2 vin3.P20.GatPoly 0.000550551f
Cred_7445 VDD.$4658.Metal2 vin3.P21.GatPoly 0.0422227f
Cred_7446 VDD.$4658.Metal2 vin3.P22.GatPoly 0.0383451f
Cred_7447 VDD.$4658.Metal2 vin3.P23.GatPoly 0.000499317f
Cred_7448 VDD.$4658.Metal2 vin4.$14.GatPoly 0.0115885f
Cred_7449 VDD.$4658.Metal2 vin4.$16.GatPoly 0.00240959f
Cred_7450 VDD.$4658.Metal2 vin4.$206.Metal1 0.00258982f
Cred_7451 VDD.$4658.Metal2 vin4.$210.Metal1 0.00585667f
Cred_7452 VDD.$4658.Metal2 vin4.$218.Metal1 0.000911526f
Cred_7453 VDD.$4658.Metal2 vin4.$483.Metal2 0.00681958f
Cred_7454 VDD.$4658.Metal2 vin4.$486.Metal2 0.00105711f
Cred_7455 VDD.$4658.Metal2 vin4.$488.Metal2 0.00857241f
Cred_7456 VDD.$4658.Metal2 vin4.$492.Metal2 2.23338e-06f
Cred_7457 VDD.$4658.Metal2 vin4.$8.GatPoly 0.010574f
Cred_7458 VDD.$4658.Metal2 vin4.P20.GatPoly 0.000550551f
Cred_7459 VDD.$4658.Metal2 vin4.P21.GatPoly 0.0423094f
Cred_7460 VDD.$4658.Metal2 vin4.P22.GatPoly 0.0382584f
Cred_7461 VDD.$4658.Metal2 vin4.P23.GatPoly 0.000499317f
Cred_7462 VDD.$4658.Metal2 vout3.$1226.Metal3 0.101669f
Cred_7463 VDD.$4658.Metal2 vout3.P0.nSD 0.00224632f
Cred_7464 VDD.$4658.Metal2 vout3.P0.pSD 0.0388549f
Cred_7465 VDD.$4658.Metal2 vout3.P2.nSD 0.00160169f
Cred_7466 VDD.$4658.Metal2 vout3.P2.pSD 0.0320201f
Cred_7467 VDD.$4658.Metal2 vout4.$1226.Metal3 0.10181f
Cred_7468 VDD.$4658.Metal2 vout4.P0.nSD 0.00225046f
Cred_7469 VDD.$4658.Metal2 vout4.P0.pSD 0.0388814f
Cred_7470 VDD.$4658.Metal2 vout4.P2.nSD 0.00160392f
Cred_7471 VDD.$4658.Metal2 vout4.P2.pSD 0.0320733f
Cred_7472 VDD.$4728.Metal2 vin1.$15.GatPoly 0.0155617f
Cred_7473 VDD.$4728.Metal2 vin1.$17.GatPoly 0.00323574f
Cred_7474 VDD.$4728.Metal2 vin1.$207.Metal1 0.00347776f
Cred_7475 VDD.$4728.Metal2 vin1.$211.Metal1 0.00786468f
Cred_7476 VDD.$4728.Metal2 vin1.$219.Metal1 0.00122405f
Cred_7477 VDD.$4728.Metal2 vin1.$484.Metal2 0.00915772f
Cred_7478 VDD.$4728.Metal2 vin1.$486.Metal2 0.00141954f
Cred_7479 VDD.$4728.Metal2 vin1.$489.Metal2 0.0115115f
Cred_7480 VDD.$4728.Metal2 vin1.$493.Metal2 2.99911e-06f
Cred_7481 VDD.$4728.Metal2 vin1.$9.GatPoly 0.0141994f
Cred_7482 VDD.$4728.Metal2 vin1.P20.GatPoly 0.000739311f
Cred_7483 VDD.$4728.Metal2 vin1.P21.GatPoly 0.0522306f
Cred_7484 VDD.$4728.Metal2 vin1.P22.GatPoly 0.0533202f
Cred_7485 VDD.$4728.Metal2 vin1.P23.GatPoly 0.000670511f
Cred_7486 VDD.$4728.Metal2 vin2.$14.GatPoly 0.0155617f
Cred_7487 VDD.$4728.Metal2 vin2.$16.GatPoly 0.00323574f
Cred_7488 VDD.$4728.Metal2 vin2.$206.Metal1 0.00347776f
Cred_7489 VDD.$4728.Metal2 vin2.$210.Metal1 0.00786468f
Cred_7490 VDD.$4728.Metal2 vin2.$218.Metal1 0.00122405f
Cred_7491 VDD.$4728.Metal2 vin2.$483.Metal2 0.00915772f
Cred_7492 VDD.$4728.Metal2 vin2.$486.Metal2 0.00141954f
Cred_7493 VDD.$4728.Metal2 vin2.$488.Metal2 0.0115115f
Cred_7494 VDD.$4728.Metal2 vin2.$492.Metal2 2.99911e-06f
Cred_7495 VDD.$4728.Metal2 vin2.$8.GatPoly 0.0141994f
Cred_7496 VDD.$4728.Metal2 vin2.P20.GatPoly 0.000739311f
Cred_7497 VDD.$4728.Metal2 vin2.P21.GatPoly 0.0523471f
Cred_7498 VDD.$4728.Metal2 vin2.P22.GatPoly 0.0532037f
Cred_7499 VDD.$4728.Metal2 vin2.P23.GatPoly 0.000670511f
Cred_7500 VDD.$4728.Metal2 vout1.$1226.Metal3 0.136706f
Cred_7501 VDD.$4728.Metal2 vout1.P0.nSD 0.00302184f
Cred_7502 VDD.$4728.Metal2 vout1.P0.pSD 0.052205f
Cred_7503 VDD.$4728.Metal2 vout1.P2.nSD 0.00215368f
Cred_7504 VDD.$4728.Metal2 vout1.P2.pSD 0.0430139f
Cred_7505 VDD.$4728.Metal2 vout2.$1226.Metal3 0.136537f
Cred_7506 VDD.$4728.Metal2 vout2.P0.nSD 0.00301669f
Cred_7507 VDD.$4728.Metal2 vout2.P0.pSD 0.0521836f
Cred_7508 VDD.$4728.Metal2 vout2.P2.nSD 0.00215101f
Cred_7509 VDD.$4728.Metal2 vout2.P2.pSD 0.0430544f
Cred_7510 VDD.$4740.Metal2 vin3.$15.GatPoly 0.0155617f
Cred_7511 VDD.$4740.Metal2 vin3.$17.GatPoly 0.00323574f
Cred_7512 VDD.$4740.Metal2 vin3.$207.Metal1 0.00347776f
Cred_7513 VDD.$4740.Metal2 vin3.$211.Metal1 0.00786468f
Cred_7514 VDD.$4740.Metal2 vin3.$219.Metal1 0.00122405f
Cred_7515 VDD.$4740.Metal2 vin3.$484.Metal2 0.00915772f
Cred_7516 VDD.$4740.Metal2 vin3.$486.Metal2 0.00141954f
Cred_7517 VDD.$4740.Metal2 vin3.$489.Metal2 0.0115115f
Cred_7518 VDD.$4740.Metal2 vin3.$493.Metal2 2.99911e-06f
Cred_7519 VDD.$4740.Metal2 vin3.$9.GatPoly 0.0141994f
Cred_7520 VDD.$4740.Metal2 vin3.P20.GatPoly 0.000739311f
Cred_7521 VDD.$4740.Metal2 vin3.P21.GatPoly 0.0522306f
Cred_7522 VDD.$4740.Metal2 vin3.P22.GatPoly 0.0533202f
Cred_7523 VDD.$4740.Metal2 vin3.P23.GatPoly 0.000670511f
Cred_7524 VDD.$4740.Metal2 vin4.$14.GatPoly 0.0155617f
Cred_7525 VDD.$4740.Metal2 vin4.$16.GatPoly 0.00323574f
Cred_7526 VDD.$4740.Metal2 vin4.$206.Metal1 0.00347776f
Cred_7527 VDD.$4740.Metal2 vin4.$210.Metal1 0.00786468f
Cred_7528 VDD.$4740.Metal2 vin4.$218.Metal1 0.00122405f
Cred_7529 VDD.$4740.Metal2 vin4.$483.Metal2 0.00915772f
Cred_7530 VDD.$4740.Metal2 vin4.$486.Metal2 0.00141954f
Cred_7531 VDD.$4740.Metal2 vin4.$488.Metal2 0.0115115f
Cred_7532 VDD.$4740.Metal2 vin4.$492.Metal2 2.99911e-06f
Cred_7533 VDD.$4740.Metal2 vin4.$8.GatPoly 0.0141994f
Cred_7534 VDD.$4740.Metal2 vin4.P20.GatPoly 0.000739311f
Cred_7535 VDD.$4740.Metal2 vin4.P21.GatPoly 0.0523471f
Cred_7536 VDD.$4740.Metal2 vin4.P22.GatPoly 0.0532037f
Cred_7537 VDD.$4740.Metal2 vin4.P23.GatPoly 0.000670511f
Cred_7538 VDD.$4740.Metal2 vout3.$1226.Metal3 0.136526f
Cred_7539 VDD.$4740.Metal2 vout3.P0.nSD 0.00301648f
Cred_7540 VDD.$4740.Metal2 vout3.P0.pSD 0.0521765f
Cred_7541 VDD.$4740.Metal2 vout3.P2.nSD 0.00215084f
Cred_7542 VDD.$4740.Metal2 vout3.P2.pSD 0.0429984f
Cred_7543 VDD.$4740.Metal2 vout4.$1226.Metal3 0.136717f
Cred_7544 VDD.$4740.Metal2 vout4.P0.nSD 0.00302205f
Cred_7545 VDD.$4740.Metal2 vout4.P0.pSD 0.0522121f
Cred_7546 VDD.$4740.Metal2 vout4.P2.nSD 0.00215384f
Cred_7547 VDD.$4740.Metal2 vout4.P2.pSD 0.0430699f
Cred_7548 VDD.$4808.Metal2 vin1.$17.GatPoly 1.61556e-08f
Cred_7549 VDD.$4808.Metal2 vin1.$211.Metal1 1.35405e-06f
Cred_7550 VDD.$4808.Metal2 vin1.$219.Metal1 9.59713e-06f
Cred_7551 VDD.$4808.Metal2 vin1.$489.Metal2 0.000577774f
Cred_7552 VDD.$4808.Metal2 vin1.$493.Metal2 0.000577759f
Cred_7553 VDD.$4808.Metal2 vin1.P22.GatPoly 0.0146732f
Cred_7554 VDD.$4808.Metal2 vin2.$16.GatPoly 1.61556e-08f
Cred_7555 VDD.$4808.Metal2 vin2.$210.Metal1 1.35405e-06f
Cred_7556 VDD.$4808.Metal2 vin2.$218.Metal1 9.59713e-06f
Cred_7557 VDD.$4808.Metal2 vin2.$488.Metal2 0.000577774f
Cred_7558 VDD.$4808.Metal2 vin2.$492.Metal2 0.000577759f
Cred_7559 VDD.$4808.Metal2 vin2.P22.GatPoly 0.0146732f
Cred_7560 VDD.$4808.Metal2 vout1.$1226.Metal3 0.00169888f
Cred_7561 VDD.$4808.Metal2 vout1.P0.nSD 2.46024e-05f
Cred_7562 VDD.$4808.Metal2 vout1.P0.pSD 0.000130733f
Cred_7563 VDD.$4808.Metal2 vout1.P2.nSD 2.67643e-05f
Cred_7564 VDD.$4808.Metal2 vout1.P2.pSD 0.000724044f
Cred_7565 VDD.$4808.Metal2 vout2.$1226.Metal3 0.00169888f
Cred_7566 VDD.$4808.Metal2 vout2.P0.nSD 2.46024e-05f
Cred_7567 VDD.$4808.Metal2 vout2.P0.pSD 0.000130733f
Cred_7568 VDD.$4808.Metal2 vout2.P2.nSD 2.67643e-05f
Cred_7569 VDD.$4808.Metal2 vout2.P2.pSD 0.000724044f
Cred_7570 VDD.$4820.Metal2 vin3.$17.GatPoly 1.61556e-08f
Cred_7571 VDD.$4820.Metal2 vin3.$211.Metal1 1.35405e-06f
Cred_7572 VDD.$4820.Metal2 vin3.$219.Metal1 9.59713e-06f
Cred_7573 VDD.$4820.Metal2 vin3.$489.Metal2 0.000577774f
Cred_7574 VDD.$4820.Metal2 vin3.$493.Metal2 0.000577759f
Cred_7575 VDD.$4820.Metal2 vin3.P22.GatPoly 0.0146732f
Cred_7576 VDD.$4820.Metal2 vin4.$16.GatPoly 1.61556e-08f
Cred_7577 VDD.$4820.Metal2 vin4.$210.Metal1 1.35405e-06f
Cred_7578 VDD.$4820.Metal2 vin4.$218.Metal1 9.59713e-06f
Cred_7579 VDD.$4820.Metal2 vin4.$488.Metal2 0.000577774f
Cred_7580 VDD.$4820.Metal2 vin4.$492.Metal2 0.000577759f
Cred_7581 VDD.$4820.Metal2 vin4.P22.GatPoly 0.0146732f
Cred_7582 VDD.$4820.Metal2 vout3.$1226.Metal3 0.00169888f
Cred_7583 VDD.$4820.Metal2 vout3.P0.nSD 2.46024e-05f
Cred_7584 VDD.$4820.Metal2 vout3.P0.pSD 0.000130733f
Cred_7585 VDD.$4820.Metal2 vout3.P2.nSD 2.67643e-05f
Cred_7586 VDD.$4820.Metal2 vout3.P2.pSD 0.000724044f
Cred_7587 VDD.$4820.Metal2 vout4.$1226.Metal3 0.00169888f
Cred_7588 VDD.$4820.Metal2 vout4.P0.nSD 2.46024e-05f
Cred_7589 VDD.$4820.Metal2 vout4.P0.pSD 0.000130733f
Cred_7590 VDD.$4820.Metal2 vout4.P2.nSD 2.67643e-05f
Cred_7591 VDD.$4820.Metal2 vout4.P2.pSD 0.000724044f
Cred_7592 VDD.$4856.Metal2 vin1.P22.GatPoly 0.00407792f
Cred_7593 VDD.$4856.Metal2 vin1.P23.GatPoly 1.0248e-05f
Cred_7594 VDD.$4856.Metal2 vin2.P22.GatPoly 0.00407792f
Cred_7595 VDD.$4856.Metal2 vin2.P23.GatPoly 1.0248e-05f
Cred_7596 VDD.$4856.Metal2 vout1.$1226.Metal3 0.00674875f
Cred_7597 VDD.$4856.Metal2 vout1.P0.nSD 9.77325e-05f
Cred_7598 VDD.$4856.Metal2 vout1.P0.pSD 0.000519334f
Cred_7599 VDD.$4856.Metal2 vout1.P2.nSD 0.00010632f
Cred_7600 VDD.$4856.Metal2 vout1.P2.pSD 0.0037882f
Cred_7601 VDD.$4856.Metal2 vout2.$1226.Metal3 0.00674875f
Cred_7602 VDD.$4856.Metal2 vout2.P0.nSD 9.77325e-05f
Cred_7603 VDD.$4856.Metal2 vout2.P0.pSD 0.000519334f
Cred_7604 VDD.$4856.Metal2 vout2.P2.nSD 0.00010632f
Cred_7605 VDD.$4856.Metal2 vout2.P2.pSD 0.0037882f
Cred_7606 VDD.$4868.Metal2 vin3.P22.GatPoly 0.00407792f
Cred_7607 VDD.$4868.Metal2 vin3.P23.GatPoly 1.0248e-05f
Cred_7608 VDD.$4868.Metal2 vin4.P22.GatPoly 0.00407792f
Cred_7609 VDD.$4868.Metal2 vin4.P23.GatPoly 1.0248e-05f
Cred_7610 VDD.$4868.Metal2 vout3.$1226.Metal3 0.00674875f
Cred_7611 VDD.$4868.Metal2 vout3.P0.nSD 9.77325e-05f
Cred_7612 VDD.$4868.Metal2 vout3.P0.pSD 0.000519334f
Cred_7613 VDD.$4868.Metal2 vout3.P2.nSD 0.00010632f
Cred_7614 VDD.$4868.Metal2 vout3.P2.pSD 0.0037882f
Cred_7615 VDD.$4868.Metal2 vout4.$1226.Metal3 0.00674875f
Cred_7616 VDD.$4868.Metal2 vout4.P0.nSD 9.77325e-05f
Cred_7617 VDD.$4868.Metal2 vout4.P0.pSD 0.000519334f
Cred_7618 VDD.$4868.Metal2 vout4.P2.nSD 0.00010632f
Cred_7619 VDD.$4868.Metal2 vout4.P2.pSD 0.0037882f
Cred_7620 VDD.$4880.Metal2 vin1.$233.Metal1 2.32194e-06f
Cred_7621 VDD.$4880.Metal2 vin1.$237.Metal1 3.1226e-06f
Cred_7622 VDD.$4880.Metal2 vin1.$500.Metal2 0.000286585f
Cred_7623 VDD.$4880.Metal2 vin1.$504.Metal2 0.000286585f
Cred_7624 VDD.$4880.Metal2 vin1.P23.GatPoly 0.0147932f
Cred_7625 VDD.$4880.Metal2 vin2.$232.Metal1 2.32194e-06f
Cred_7626 VDD.$4880.Metal2 vin2.$236.Metal1 3.1226e-06f
Cred_7627 VDD.$4880.Metal2 vin2.$499.Metal2 0.000286585f
Cred_7628 VDD.$4880.Metal2 vin2.$503.Metal2 0.000286585f
Cred_7629 VDD.$4880.Metal2 vin2.P23.GatPoly 0.0147932f
Cred_7630 VDD.$4880.Metal2 vout1.$1226.Metal3 0.00284839f
Cred_7631 VDD.$4880.Metal2 vout1.P0.nSD 4.12492e-05f
Cred_7632 VDD.$4880.Metal2 vout1.P0.pSD 0.000219191f
Cred_7633 VDD.$4880.Metal2 vout1.P2.nSD 4.48737e-05f
Cred_7634 VDD.$4880.Metal2 vout1.P2.pSD 0.00109862f
Cred_7635 VDD.$4880.Metal2 vout2.$1226.Metal3 0.00284839f
Cred_7636 VDD.$4880.Metal2 vout2.P0.nSD 4.12492e-05f
Cred_7637 VDD.$4880.Metal2 vout2.P0.pSD 0.000219191f
Cred_7638 VDD.$4880.Metal2 vout2.P2.nSD 4.48737e-05f
Cred_7639 VDD.$4880.Metal2 vout2.P2.pSD 0.00109862f
Cred_7640 VDD.$4892.Metal2 vin3.$233.Metal1 2.32194e-06f
Cred_7641 VDD.$4892.Metal2 vin3.$237.Metal1 3.1226e-06f
Cred_7642 VDD.$4892.Metal2 vin3.$500.Metal2 0.000286585f
Cred_7643 VDD.$4892.Metal2 vin3.$504.Metal2 0.000286585f
Cred_7644 VDD.$4892.Metal2 vin3.P23.GatPoly 0.0147932f
Cred_7645 VDD.$4892.Metal2 vin4.$232.Metal1 2.32194e-06f
Cred_7646 VDD.$4892.Metal2 vin4.$236.Metal1 3.1226e-06f
Cred_7647 VDD.$4892.Metal2 vin4.$499.Metal2 0.000286585f
Cred_7648 VDD.$4892.Metal2 vin4.$503.Metal2 0.000286585f
Cred_7649 VDD.$4892.Metal2 vin4.P23.GatPoly 0.0147932f
Cred_7650 VDD.$4892.Metal2 vout3.$1226.Metal3 0.00284839f
Cred_7651 VDD.$4892.Metal2 vout3.P0.nSD 4.12492e-05f
Cred_7652 VDD.$4892.Metal2 vout3.P0.pSD 0.000219191f
Cred_7653 VDD.$4892.Metal2 vout3.P2.nSD 4.48737e-05f
Cred_7654 VDD.$4892.Metal2 vout3.P2.pSD 0.00109862f
Cred_7655 VDD.$4892.Metal2 vout4.$1226.Metal3 0.00284839f
Cred_7656 VDD.$4892.Metal2 vout4.P0.nSD 4.12492e-05f
Cred_7657 VDD.$4892.Metal2 vout4.P0.pSD 0.000219191f
Cred_7658 VDD.$4892.Metal2 vout4.P2.nSD 4.48737e-05f
Cred_7659 VDD.$4892.Metal2 vout4.P2.pSD 0.00109862f
Cred_7660 VDD.$4986.Metal2 vin1.$233.Metal1 2.32194e-06f
Cred_7661 VDD.$4986.Metal2 vin1.$237.Metal1 0.00220527f
Cred_7662 VDD.$4986.Metal2 vin1.$241.Metal1 0.00954827f
Cred_7663 VDD.$4986.Metal2 vin1.$247.Metal1 0.0053756f
Cred_7664 VDD.$4986.Metal2 vin1.$25.GatPoly 0.0199595f
Cred_7665 VDD.$4986.Metal2 vin1.$251.Metal1 0.00196334f
Cred_7666 VDD.$4986.Metal2 vin1.$37.GatPoly 0.0104076f
Cred_7667 VDD.$4986.Metal2 vin1.$43.GatPoly 0.00371219f
Cred_7668 VDD.$4986.Metal2 vin1.$500.Metal2 0.000286585f
Cred_7669 VDD.$4986.Metal2 vin1.$504.Metal2 0.0164357f
Cred_7670 VDD.$4986.Metal2 vin1.$506.Metal2 0.00157433f
Cred_7671 VDD.$4986.Metal2 vin1.$509.Metal2 0.00930457f
Cred_7672 VDD.$4986.Metal2 vin1.P22.GatPoly 0.000813824f
Cred_7673 VDD.$4986.Metal2 vin1.P23.GatPoly 0.067695f
Cred_7674 VDD.$4986.Metal2 vin1.P24.GatPoly 0.0654139f
Cred_7675 VDD.$4986.Metal2 vin1.P25.GatPoly 0.000813824f
Cred_7676 VDD.$4986.Metal2 vin2.$232.Metal1 2.32194e-06f
Cred_7677 VDD.$4986.Metal2 vin2.$236.Metal1 0.00220527f
Cred_7678 VDD.$4986.Metal2 vin2.$24.GatPoly 0.0199595f
Cred_7679 VDD.$4986.Metal2 vin2.$240.Metal1 0.00954827f
Cred_7680 VDD.$4986.Metal2 vin2.$246.Metal1 0.0053756f
Cred_7681 VDD.$4986.Metal2 vin2.$250.Metal1 0.00196334f
Cred_7682 VDD.$4986.Metal2 vin2.$36.GatPoly 0.0104076f
Cred_7683 VDD.$4986.Metal2 vin2.$42.GatPoly 0.00371219f
Cred_7684 VDD.$4986.Metal2 vin2.$499.Metal2 0.000286585f
Cred_7685 VDD.$4986.Metal2 vin2.$503.Metal2 0.0164357f
Cred_7686 VDD.$4986.Metal2 vin2.$506.Metal2 0.00157433f
Cred_7687 VDD.$4986.Metal2 vin2.$508.Metal2 0.00930457f
Cred_7688 VDD.$4986.Metal2 vin2.P22.GatPoly 0.000813824f
Cred_7689 VDD.$4986.Metal2 vin2.P23.GatPoly 0.067695f
Cred_7690 VDD.$4986.Metal2 vin2.P24.GatPoly 0.0654139f
Cred_7691 VDD.$4986.Metal2 vin2.P25.GatPoly 0.000813824f
Cred_7692 VDD.$4986.Metal2 vout1.$1226.Metal3 0.192197f
Cred_7693 VDD.$4986.Metal2 vout1.P0.nSD 0.00126642f
Cred_7694 VDD.$4986.Metal2 vout1.P0.pSD 0.00672957f
Cred_7695 VDD.$4986.Metal2 vout1.P2.nSD 0.00137771f
Cred_7696 VDD.$4986.Metal2 vout1.P2.pSD 0.045533f
Cred_7697 VDD.$4986.Metal2 vout1.P4.pSD 0.038663f
Cred_7698 VDD.$4986.Metal2 vout2.$1226.Metal3 0.192422f
Cred_7699 VDD.$4986.Metal2 vout2.P0.nSD 0.00126608f
Cred_7700 VDD.$4986.Metal2 vout2.P0.pSD 0.00672771f
Cred_7701 VDD.$4986.Metal2 vout2.P2.nSD 0.00137733f
Cred_7702 VDD.$4986.Metal2 vout2.P2.pSD 0.0454429f
Cred_7703 VDD.$4986.Metal2 vout2.P4.pSD 0.038789f
Cred_7704 VDD.$4998.Metal2 vin3.$233.Metal1 2.32194e-06f
Cred_7705 VDD.$4998.Metal2 vin3.$237.Metal1 0.00220527f
Cred_7706 VDD.$4998.Metal2 vin3.$241.Metal1 0.00954827f
Cred_7707 VDD.$4998.Metal2 vin3.$247.Metal1 0.0053756f
Cred_7708 VDD.$4998.Metal2 vin3.$25.GatPoly 0.0199595f
Cred_7709 VDD.$4998.Metal2 vin3.$251.Metal1 0.00196334f
Cred_7710 VDD.$4998.Metal2 vin3.$37.GatPoly 0.0104076f
Cred_7711 VDD.$4998.Metal2 vin3.$43.GatPoly 0.00371219f
Cred_7712 VDD.$4998.Metal2 vin3.$500.Metal2 0.000286585f
Cred_7713 VDD.$4998.Metal2 vin3.$504.Metal2 0.0164357f
Cred_7714 VDD.$4998.Metal2 vin3.$506.Metal2 0.00157433f
Cred_7715 VDD.$4998.Metal2 vin3.$509.Metal2 0.00930457f
Cred_7716 VDD.$4998.Metal2 vin3.P22.GatPoly 0.000813824f
Cred_7717 VDD.$4998.Metal2 vin3.P23.GatPoly 0.067695f
Cred_7718 VDD.$4998.Metal2 vin3.P24.GatPoly 0.0654139f
Cred_7719 VDD.$4998.Metal2 vin3.P25.GatPoly 0.000813824f
Cred_7720 VDD.$4998.Metal2 vin4.$232.Metal1 2.32194e-06f
Cred_7721 VDD.$4998.Metal2 vin4.$236.Metal1 0.00220527f
Cred_7722 VDD.$4998.Metal2 vin4.$24.GatPoly 0.0199595f
Cred_7723 VDD.$4998.Metal2 vin4.$240.Metal1 0.00954827f
Cred_7724 VDD.$4998.Metal2 vin4.$246.Metal1 0.0053756f
Cred_7725 VDD.$4998.Metal2 vin4.$250.Metal1 0.00196334f
Cred_7726 VDD.$4998.Metal2 vin4.$36.GatPoly 0.0104076f
Cred_7727 VDD.$4998.Metal2 vin4.$42.GatPoly 0.00371219f
Cred_7728 VDD.$4998.Metal2 vin4.$499.Metal2 0.000286585f
Cred_7729 VDD.$4998.Metal2 vin4.$503.Metal2 0.0164357f
Cred_7730 VDD.$4998.Metal2 vin4.$506.Metal2 0.00157433f
Cred_7731 VDD.$4998.Metal2 vin4.$508.Metal2 0.00930457f
Cred_7732 VDD.$4998.Metal2 vin4.P22.GatPoly 0.000813824f
Cred_7733 VDD.$4998.Metal2 vin4.P23.GatPoly 0.067695f
Cred_7734 VDD.$4998.Metal2 vin4.P24.GatPoly 0.0654139f
Cred_7735 VDD.$4998.Metal2 vin4.P25.GatPoly 0.000813824f
Cred_7736 VDD.$4998.Metal2 vout3.$1226.Metal3 0.192197f
Cred_7737 VDD.$4998.Metal2 vout3.P0.nSD 0.00126642f
Cred_7738 VDD.$4998.Metal2 vout3.P0.pSD 0.00672957f
Cred_7739 VDD.$4998.Metal2 vout3.P2.nSD 0.00137771f
Cred_7740 VDD.$4998.Metal2 vout3.P2.pSD 0.045533f
Cred_7741 VDD.$4998.Metal2 vout3.P4.pSD 0.038663f
Cred_7742 VDD.$4998.Metal2 vout4.$1226.Metal3 0.192422f
Cred_7743 VDD.$4998.Metal2 vout4.P0.nSD 0.00126608f
Cred_7744 VDD.$4998.Metal2 vout4.P0.pSD 0.00672771f
Cred_7745 VDD.$4998.Metal2 vout4.P2.nSD 0.00137733f
Cred_7746 VDD.$4998.Metal2 vout4.P2.pSD 0.0454429f
Cred_7747 VDD.$4998.Metal2 vout4.P4.pSD 0.038789f
Cred_7748 VDD.$5066.Metal2 vin1.$237.Metal1 0.000965854f
Cred_7749 VDD.$5066.Metal2 vin1.$241.Metal1 0.00418784f
Cred_7750 VDD.$5066.Metal2 vin1.$247.Metal1 0.00236213f
Cred_7751 VDD.$5066.Metal2 vin1.$25.GatPoly 0.00875418f
Cred_7752 VDD.$5066.Metal2 vin1.$251.Metal1 0.000862155f
Cred_7753 VDD.$5066.Metal2 vin1.$37.GatPoly 0.00456472f
Cred_7754 VDD.$5066.Metal2 vin1.$43.GatPoly 0.00162815f
Cred_7755 VDD.$5066.Metal2 vin1.$504.Metal2 0.00708295f
Cred_7756 VDD.$5066.Metal2 vin1.$506.Metal2 0.000690494f
Cred_7757 VDD.$5066.Metal2 vin1.$509.Metal2 0.00436753f
Cred_7758 VDD.$5066.Metal2 vin1.$513.Metal2 0.00028658f
Cred_7759 VDD.$5066.Metal2 vin1.P22.GatPoly 0.00035694f
Cred_7760 VDD.$5066.Metal2 vin1.P23.GatPoly 0.0274063f
Cred_7761 VDD.$5066.Metal2 vin1.P24.GatPoly 0.0385377f
Cred_7762 VDD.$5066.Metal2 vin1.P25.GatPoly 0.00035694f
Cred_7763 VDD.$5066.Metal2 vin2.$236.Metal1 0.000965854f
Cred_7764 VDD.$5066.Metal2 vin2.$24.GatPoly 0.00875418f
Cred_7765 VDD.$5066.Metal2 vin2.$240.Metal1 0.00418784f
Cred_7766 VDD.$5066.Metal2 vin2.$246.Metal1 0.00236213f
Cred_7767 VDD.$5066.Metal2 vin2.$250.Metal1 0.000862155f
Cred_7768 VDD.$5066.Metal2 vin2.$36.GatPoly 0.00456472f
Cred_7769 VDD.$5066.Metal2 vin2.$42.GatPoly 0.00162815f
Cred_7770 VDD.$5066.Metal2 vin2.$503.Metal2 0.00708295f
Cred_7771 VDD.$5066.Metal2 vin2.$506.Metal2 0.000690494f
Cred_7772 VDD.$5066.Metal2 vin2.$508.Metal2 0.00436753f
Cred_7773 VDD.$5066.Metal2 vin2.$512.Metal2 0.00028658f
Cred_7774 VDD.$5066.Metal2 vin2.P22.GatPoly 0.00035694f
Cred_7775 VDD.$5066.Metal2 vin2.P23.GatPoly 0.0274063f
Cred_7776 VDD.$5066.Metal2 vin2.P24.GatPoly 0.0385377f
Cred_7777 VDD.$5066.Metal2 vin2.P25.GatPoly 0.00035694f
Cred_7778 VDD.$5066.Metal2 vout1.$1226.Metal3 0.0842968f
Cred_7779 VDD.$5066.Metal2 vout1.P0.nSD 0.00055545f
Cred_7780 VDD.$5066.Metal2 vout1.P0.pSD 0.00295157f
Cred_7781 VDD.$5066.Metal2 vout1.P2.nSD 0.000604257f
Cred_7782 VDD.$5066.Metal2 vout1.P2.pSD 0.0199706f
Cred_7783 VDD.$5066.Metal2 vout1.P4.pSD 0.0169575f
Cred_7784 VDD.$5066.Metal2 vout2.$1226.Metal3 0.0843956f
Cred_7785 VDD.$5066.Metal2 vout2.P0.nSD 0.000555296f
Cred_7786 VDD.$5066.Metal2 vout2.P0.pSD 0.00295075f
Cred_7787 VDD.$5066.Metal2 vout2.P2.nSD 0.00060409f
Cred_7788 VDD.$5066.Metal2 vout2.P2.pSD 0.0199311f
Cred_7789 VDD.$5066.Metal2 vout2.P4.pSD 0.0170127f
Cred_7790 VDD.$5078.Metal2 vin3.$237.Metal1 0.000965854f
Cred_7791 VDD.$5078.Metal2 vin3.$241.Metal1 0.00418784f
Cred_7792 VDD.$5078.Metal2 vin3.$247.Metal1 0.00236213f
Cred_7793 VDD.$5078.Metal2 vin3.$25.GatPoly 0.00875418f
Cred_7794 VDD.$5078.Metal2 vin3.$251.Metal1 0.000862155f
Cred_7795 VDD.$5078.Metal2 vin3.$37.GatPoly 0.00456472f
Cred_7796 VDD.$5078.Metal2 vin3.$43.GatPoly 0.00162815f
Cred_7797 VDD.$5078.Metal2 vin3.$504.Metal2 0.00708295f
Cred_7798 VDD.$5078.Metal2 vin3.$506.Metal2 0.000690494f
Cred_7799 VDD.$5078.Metal2 vin3.$509.Metal2 0.00436753f
Cred_7800 VDD.$5078.Metal2 vin3.$513.Metal2 0.00028658f
Cred_7801 VDD.$5078.Metal2 vin3.P22.GatPoly 0.00035694f
Cred_7802 VDD.$5078.Metal2 vin3.P23.GatPoly 0.0274063f
Cred_7803 VDD.$5078.Metal2 vin3.P24.GatPoly 0.0385377f
Cred_7804 VDD.$5078.Metal2 vin3.P25.GatPoly 0.00035694f
Cred_7805 VDD.$5078.Metal2 vin4.$236.Metal1 0.000965854f
Cred_7806 VDD.$5078.Metal2 vin4.$24.GatPoly 0.00875418f
Cred_7807 VDD.$5078.Metal2 vin4.$240.Metal1 0.00418784f
Cred_7808 VDD.$5078.Metal2 vin4.$246.Metal1 0.00236213f
Cred_7809 VDD.$5078.Metal2 vin4.$250.Metal1 0.000862155f
Cred_7810 VDD.$5078.Metal2 vin4.$36.GatPoly 0.00456472f
Cred_7811 VDD.$5078.Metal2 vin4.$42.GatPoly 0.00162815f
Cred_7812 VDD.$5078.Metal2 vin4.$503.Metal2 0.00708295f
Cred_7813 VDD.$5078.Metal2 vin4.$506.Metal2 0.000690494f
Cred_7814 VDD.$5078.Metal2 vin4.$508.Metal2 0.00436753f
Cred_7815 VDD.$5078.Metal2 vin4.$512.Metal2 0.00028658f
Cred_7816 VDD.$5078.Metal2 vin4.P22.GatPoly 0.00035694f
Cred_7817 VDD.$5078.Metal2 vin4.P23.GatPoly 0.0274063f
Cred_7818 VDD.$5078.Metal2 vin4.P24.GatPoly 0.0385377f
Cred_7819 VDD.$5078.Metal2 vin4.P25.GatPoly 0.00035694f
Cred_7820 VDD.$5078.Metal2 vout3.$1226.Metal3 0.0842968f
Cred_7821 VDD.$5078.Metal2 vout3.P0.nSD 0.00055545f
Cred_7822 VDD.$5078.Metal2 vout3.P0.pSD 0.00295157f
Cred_7823 VDD.$5078.Metal2 vout3.P2.nSD 0.000604257f
Cred_7824 VDD.$5078.Metal2 vout3.P2.pSD 0.0199706f
Cred_7825 VDD.$5078.Metal2 vout3.P4.pSD 0.0169575f
Cred_7826 VDD.$5078.Metal2 vout4.$1226.Metal3 0.0843956f
Cred_7827 VDD.$5078.Metal2 vout4.P0.nSD 0.000555296f
Cred_7828 VDD.$5078.Metal2 vout4.P0.pSD 0.00295075f
Cred_7829 VDD.$5078.Metal2 vout4.P2.nSD 0.00060409f
Cred_7830 VDD.$5078.Metal2 vout4.P2.pSD 0.0199311f
Cred_7831 VDD.$5078.Metal2 vout4.P4.pSD 0.0170127f
Cred_7832 VDD.$508.Metal1 vin1.P20.GatPoly 0.0183365f
Cred_7833 VDD.$508.Metal1 vout1.$1226.Metal3 0.003303f
Cred_7834 VDD.$508.Metal1 vout1.P0.nSD 9.8353e-05f
Cred_7835 VDD.$508.Metal1 vout1.P0.pSD 0.00454922f
Cred_7836 VDD.$508.Metal1 vout1.P2.nSD 5.20357e-05f
Cred_7837 VDD.$508.Metal1 vout1.P2.pSD 0.000284387f
Cred_7838 VDD.$509.Metal1 vin1.P20.GatPoly 0.0127709f
Cred_7839 VDD.$509.Metal1 vout1.$1226.Metal3 0.00209309f
Cred_7840 VDD.$509.Metal1 vout1.P0.nSD 6.23257e-05f
Cred_7841 VDD.$509.Metal1 vout1.P0.pSD 0.00289936f
Cred_7842 VDD.$509.Metal1 vout1.P2.nSD 3.29747e-05f
Cred_7843 VDD.$509.Metal1 vout1.P2.pSD 0.000180214f
Cred_7844 VDD.$5114.Metal2 vin1.$247.Metal1 4.41141e-06f
Cred_7845 VDD.$5114.Metal2 vin1.$251.Metal1 1.0427e-06f
Cred_7846 VDD.$5114.Metal2 vin1.$509.Metal2 0.00028658f
Cred_7847 VDD.$5114.Metal2 vin1.$513.Metal2 0.00028658f
Cred_7848 VDD.$5114.Metal2 vin1.P24.GatPoly 0.0103051f
Cred_7849 VDD.$5114.Metal2 vin1.P25.GatPoly 0.00050875f
Cred_7850 VDD.$5114.Metal2 vin2.$246.Metal1 4.41141e-06f
Cred_7851 VDD.$5114.Metal2 vin2.$250.Metal1 1.0427e-06f
Cred_7852 VDD.$5114.Metal2 vin2.$508.Metal2 0.00028658f
Cred_7853 VDD.$5114.Metal2 vin2.$512.Metal2 0.00028658f
Cred_7854 VDD.$5114.Metal2 vin2.P24.GatPoly 0.0103051f
Cred_7855 VDD.$5114.Metal2 vin2.P25.GatPoly 0.00050875f
Cred_7856 VDD.$5114.Metal2 vout1.$1226.Metal3 0.00837327f
Cred_7857 VDD.$5114.Metal2 vout1.P4.pSD 0.00310265f
Cred_7858 VDD.$5114.Metal2 vout2.$1226.Metal3 0.00837327f
Cred_7859 VDD.$5114.Metal2 vout2.P4.pSD 0.00310265f
Cred_7860 VDD.$5126.Metal2 vin3.$247.Metal1 4.41141e-06f
Cred_7861 VDD.$5126.Metal2 vin3.$251.Metal1 1.0427e-06f
Cred_7862 VDD.$5126.Metal2 vin3.$509.Metal2 0.00028658f
Cred_7863 VDD.$5126.Metal2 vin3.$513.Metal2 0.00028658f
Cred_7864 VDD.$5126.Metal2 vin3.P24.GatPoly 0.0103051f
Cred_7865 VDD.$5126.Metal2 vin3.P25.GatPoly 0.00050875f
Cred_7866 VDD.$5126.Metal2 vin4.$246.Metal1 4.41141e-06f
Cred_7867 VDD.$5126.Metal2 vin4.$250.Metal1 1.0427e-06f
Cred_7868 VDD.$5126.Metal2 vin4.$508.Metal2 0.00028658f
Cred_7869 VDD.$5126.Metal2 vin4.$512.Metal2 0.00028658f
Cred_7870 VDD.$5126.Metal2 vin4.P24.GatPoly 0.0103051f
Cred_7871 VDD.$5126.Metal2 vin4.P25.GatPoly 0.00050875f
Cred_7872 VDD.$5126.Metal2 vout3.$1226.Metal3 0.00837327f
Cred_7873 VDD.$5126.Metal2 vout3.P4.pSD 0.00310265f
Cred_7874 VDD.$5126.Metal2 vout4.$1226.Metal3 0.00837327f
Cred_7875 VDD.$5126.Metal2 vout4.P4.pSD 0.00310265f
Cred_7876 VDD.$5162.Metal2 vin1.$520.Metal2 0.0011665f
Cred_7877 VDD.$5162.Metal2 vin1.P25.GatPoly 0.0151374f
Cred_7878 VDD.$5162.Metal2 vin2.$519.Metal2 0.0011665f
Cred_7879 VDD.$5162.Metal2 vin2.P25.GatPoly 0.0151374f
Cred_7880 VDD.$5162.Metal2 vout1.$1226.Metal3 0.00474538f
Cred_7881 VDD.$5162.Metal2 vout1.P4.pSD 0.00154869f
Cred_7882 VDD.$5162.Metal2 vout2.$1226.Metal3 0.00474538f
Cred_7883 VDD.$5162.Metal2 vout2.P4.pSD 0.00154869f
Cred_7884 VDD.$5174.Metal2 vin3.$520.Metal2 0.0011665f
Cred_7885 VDD.$5174.Metal2 vin3.P25.GatPoly 0.0151374f
Cred_7886 VDD.$5174.Metal2 vin4.$519.Metal2 0.0011665f
Cred_7887 VDD.$5174.Metal2 vin4.P25.GatPoly 0.0151374f
Cred_7888 VDD.$5174.Metal2 vout3.$1226.Metal3 0.00474538f
Cred_7889 VDD.$5174.Metal2 vout3.P4.pSD 0.00154869f
Cred_7890 VDD.$5174.Metal2 vout4.$1226.Metal3 0.00474538f
Cred_7891 VDD.$5174.Metal2 vout4.P4.pSD 0.00154869f
Cred_7892 VDD.$5210.Metal2 vin1.$265.Metal1 0.00672635f
Cred_7893 VDD.$5210.Metal2 vin1.$273.Metal1 0.0127023f
Cred_7894 VDD.$5210.Metal2 vin1.$277.Metal1 0.000235934f
Cred_7895 VDD.$5210.Metal2 vin1.$281.Metal1 2.70768e-05f
Cred_7896 VDD.$5210.Metal2 vin1.$47.GatPoly 0.0275575f
Cred_7897 VDD.$5210.Metal2 vin1.$515.Metal2 0.000737782f
Cred_7898 VDD.$5210.Metal2 vin1.$520.Metal2 0.00319318f
Cred_7899 VDD.$5210.Metal2 vin1.$523.Metal2 0.000332531f
Cred_7900 VDD.$5210.Metal2 vin1.$527.Metal2 0.0314972f
Cred_7901 VDD.$5210.Metal2 vin1.$528.Metal2 1.26278e-05f
Cred_7902 VDD.$5210.Metal2 vin1.$53.GatPoly 0.00592276f
Cred_7903 VDD.$5210.Metal2 vin1.$533.Metal2 0.00225334f
Cred_7904 VDD.$5210.Metal2 vin1.$535.Metal2 0.000737782f
Cred_7905 VDD.$5210.Metal2 vin1.$57.GatPoly 0.028232f
Cred_7906 VDD.$5210.Metal2 vin1.P24.GatPoly 0.00117687f
Cred_7907 VDD.$5210.Metal2 vin1.P25.GatPoly 0.090169f
Cred_7908 VDD.$5210.Metal2 vin1.P26.GatPoly 0.0940441f
Cred_7909 VDD.$5210.Metal2 vin1.P27.GatPoly 0.00117687f
Cred_7910 VDD.$5210.Metal2 vin2.$264.Metal1 0.00672635f
Cred_7911 VDD.$5210.Metal2 vin2.$272.Metal1 0.0127023f
Cred_7912 VDD.$5210.Metal2 vin2.$276.Metal1 0.000235934f
Cred_7913 VDD.$5210.Metal2 vin2.$280.Metal1 2.70768e-05f
Cred_7914 VDD.$5210.Metal2 vin2.$44.GatPoly 0.0275575f
Cred_7915 VDD.$5210.Metal2 vin2.$515.Metal2 0.000737782f
Cred_7916 VDD.$5210.Metal2 vin2.$519.Metal2 0.00319318f
Cred_7917 VDD.$5210.Metal2 vin2.$52.GatPoly 0.00592276f
Cred_7918 VDD.$5210.Metal2 vin2.$524.Metal2 0.000332531f
Cred_7919 VDD.$5210.Metal2 vin2.$525.Metal2 0.0314972f
Cred_7920 VDD.$5210.Metal2 vin2.$529.Metal2 1.26278e-05f
Cred_7921 VDD.$5210.Metal2 vin2.$532.Metal2 0.00225334f
Cred_7922 VDD.$5210.Metal2 vin2.$535.Metal2 0.000737782f
Cred_7923 VDD.$5210.Metal2 vin2.$56.GatPoly 0.028232f
Cred_7924 VDD.$5210.Metal2 vin2.P24.GatPoly 0.00117687f
Cred_7925 VDD.$5210.Metal2 vin2.P25.GatPoly 0.090169f
Cred_7926 VDD.$5210.Metal2 vin2.P26.GatPoly 0.0940441f
Cred_7927 VDD.$5210.Metal2 vin2.P27.GatPoly 0.00117687f
Cred_7928 VDD.$5210.Metal2 vout1.$1226.Metal3 0.219808f
Cred_7929 VDD.$5210.Metal2 vout1.$1292.Metal3 0.0713865f
Cred_7930 VDD.$5210.Metal2 vout1.P4.pSD 0.0563476f
Cred_7931 VDD.$5210.Metal2 vout1.P6.nSD 0.00112463f
Cred_7932 VDD.$5210.Metal2 vout1.P6.pSD 0.0607051f
Cred_7933 VDD.$5210.Metal2 vout2.$1226.Metal3 0.219817f
Cred_7934 VDD.$5210.Metal2 vout2.$1292.Metal3 0.0717363f
Cred_7935 VDD.$5210.Metal2 vout2.P4.pSD 0.0561859f
Cred_7936 VDD.$5210.Metal2 vout2.P6.nSD 0.00113014f
Cred_7937 VDD.$5210.Metal2 vout2.P6.pSD 0.0609746f
Cred_7938 VDD.$5211.Metal2 vin3.$265.Metal1 0.00672635f
Cred_7939 VDD.$5211.Metal2 vin3.$273.Metal1 0.0127023f
Cred_7940 VDD.$5211.Metal2 vin3.$277.Metal1 0.000235934f
Cred_7941 VDD.$5211.Metal2 vin3.$281.Metal1 2.70768e-05f
Cred_7942 VDD.$5211.Metal2 vin3.$47.GatPoly 0.0275575f
Cred_7943 VDD.$5211.Metal2 vin3.$515.Metal2 0.000737782f
Cred_7944 VDD.$5211.Metal2 vin3.$520.Metal2 0.00319318f
Cred_7945 VDD.$5211.Metal2 vin3.$523.Metal2 0.000332531f
Cred_7946 VDD.$5211.Metal2 vin3.$527.Metal2 0.0314972f
Cred_7947 VDD.$5211.Metal2 vin3.$528.Metal2 1.26278e-05f
Cred_7948 VDD.$5211.Metal2 vin3.$53.GatPoly 0.00592276f
Cred_7949 VDD.$5211.Metal2 vin3.$533.Metal2 0.00225334f
Cred_7950 VDD.$5211.Metal2 vin3.$535.Metal2 0.000737782f
Cred_7951 VDD.$5211.Metal2 vin3.$57.GatPoly 0.028232f
Cred_7952 VDD.$5211.Metal2 vin3.P24.GatPoly 0.00117687f
Cred_7953 VDD.$5211.Metal2 vin3.P25.GatPoly 0.090169f
Cred_7954 VDD.$5211.Metal2 vin3.P26.GatPoly 0.0940441f
Cred_7955 VDD.$5211.Metal2 vin3.P27.GatPoly 0.00117687f
Cred_7956 VDD.$5211.Metal2 vin4.$264.Metal1 0.00672635f
Cred_7957 VDD.$5211.Metal2 vin4.$272.Metal1 0.0127023f
Cred_7958 VDD.$5211.Metal2 vin4.$276.Metal1 0.000235934f
Cred_7959 VDD.$5211.Metal2 vin4.$280.Metal1 2.70768e-05f
Cred_7960 VDD.$5211.Metal2 vin4.$44.GatPoly 0.0275575f
Cred_7961 VDD.$5211.Metal2 vin4.$515.Metal2 0.000737782f
Cred_7962 VDD.$5211.Metal2 vin4.$519.Metal2 0.00319318f
Cred_7963 VDD.$5211.Metal2 vin4.$52.GatPoly 0.00592276f
Cred_7964 VDD.$5211.Metal2 vin4.$524.Metal2 0.000332531f
Cred_7965 VDD.$5211.Metal2 vin4.$525.Metal2 0.0314972f
Cred_7966 VDD.$5211.Metal2 vin4.$529.Metal2 1.26278e-05f
Cred_7967 VDD.$5211.Metal2 vin4.$532.Metal2 0.00225334f
Cred_7968 VDD.$5211.Metal2 vin4.$535.Metal2 0.000737782f
Cred_7969 VDD.$5211.Metal2 vin4.$56.GatPoly 0.028232f
Cred_7970 VDD.$5211.Metal2 vin4.P24.GatPoly 0.00117687f
Cred_7971 VDD.$5211.Metal2 vin4.P25.GatPoly 0.090169f
Cred_7972 VDD.$5211.Metal2 vin4.P26.GatPoly 0.0940441f
Cred_7973 VDD.$5211.Metal2 vin4.P27.GatPoly 0.00117687f
Cred_7974 VDD.$5211.Metal2 vout3.$1226.Metal3 0.219808f
Cred_7975 VDD.$5211.Metal2 vout3.$1292.Metal3 0.0713865f
Cred_7976 VDD.$5211.Metal2 vout3.P4.pSD 0.0563476f
Cred_7977 VDD.$5211.Metal2 vout3.P6.nSD 0.00112463f
Cred_7978 VDD.$5211.Metal2 vout3.P6.pSD 0.0607051f
Cred_7979 VDD.$5211.Metal2 vout4.$1226.Metal3 0.219817f
Cred_7980 VDD.$5211.Metal2 vout4.$1292.Metal3 0.0717363f
Cred_7981 VDD.$5211.Metal2 vout4.P4.pSD 0.0561859f
Cred_7982 VDD.$5211.Metal2 vout4.P6.nSD 0.00113014f
Cred_7983 VDD.$5211.Metal2 vout4.P6.pSD 0.0609746f
Cred_7984 VDD.$5268.Metal2 vin1.P25.GatPoly 0.00406416f
Cred_7985 VDD.$5268.Metal2 vin2.P25.GatPoly 0.00406416f
Cred_7986 VDD.$5280.Metal2 vin3.P25.GatPoly 0.00406416f
Cred_7987 VDD.$5280.Metal2 vin4.P25.GatPoly 0.00406416f
Cred_7988 VDD.$5372.Metal2 vin1.$273.Metal1 4.03106e-06f
Cred_7989 VDD.$5372.Metal2 vin1.$277.Metal1 8.31397e-06f
Cred_7990 VDD.$5372.Metal2 vin1.$281.Metal1 9.14441e-06f
Cred_7991 VDD.$5372.Metal2 vin1.$527.Metal2 0.00038401f
Cred_7992 VDD.$5372.Metal2 vin1.$533.Metal2 0.000761f
Cred_7993 VDD.$5372.Metal2 vin1.P26.GatPoly 0.0150344f
Cred_7994 VDD.$5372.Metal2 vin2.$272.Metal1 4.03106e-06f
Cred_7995 VDD.$5372.Metal2 vin2.$276.Metal1 8.31397e-06f
Cred_7996 VDD.$5372.Metal2 vin2.$280.Metal1 9.14441e-06f
Cred_7997 VDD.$5372.Metal2 vin2.$525.Metal2 0.00038401f
Cred_7998 VDD.$5372.Metal2 vin2.$532.Metal2 0.000761f
Cred_7999 VDD.$5372.Metal2 vin2.P26.GatPoly 0.0150344f
Cred_8000 VDD.$5372.Metal2 vout1.$1226.Metal3 0.00205268f
Cred_8001 VDD.$5372.Metal2 vout1.$1292.Metal3 0.00205268f
Cred_8002 VDD.$5372.Metal2 vout1.P6.nSD 3.23381e-05f
Cred_8003 VDD.$5372.Metal2 vout1.P6.pSD 0.00163692f
Cred_8004 VDD.$5372.Metal2 vout2.$1226.Metal3 0.00205268f
Cred_8005 VDD.$5372.Metal2 vout2.$1292.Metal3 0.00205268f
Cred_8006 VDD.$5372.Metal2 vout2.P6.nSD 3.23381e-05f
Cred_8007 VDD.$5372.Metal2 vout2.P6.pSD 0.00163692f
Cred_8008 VDD.$5384.Metal2 vin3.$273.Metal1 4.03106e-06f
Cred_8009 VDD.$5384.Metal2 vin3.$277.Metal1 8.31397e-06f
Cred_8010 VDD.$5384.Metal2 vin3.$281.Metal1 9.14441e-06f
Cred_8011 VDD.$5384.Metal2 vin3.$527.Metal2 0.00038401f
Cred_8012 VDD.$5384.Metal2 vin3.$533.Metal2 0.000761f
Cred_8013 VDD.$5384.Metal2 vin3.P26.GatPoly 0.0150344f
Cred_8014 VDD.$5384.Metal2 vin4.$272.Metal1 4.03106e-06f
Cred_8015 VDD.$5384.Metal2 vin4.$276.Metal1 8.31397e-06f
Cred_8016 VDD.$5384.Metal2 vin4.$280.Metal1 9.14441e-06f
Cred_8017 VDD.$5384.Metal2 vin4.$525.Metal2 0.00038401f
Cred_8018 VDD.$5384.Metal2 vin4.$532.Metal2 0.000761f
Cred_8019 VDD.$5384.Metal2 vin4.P26.GatPoly 0.0150344f
Cred_8020 VDD.$5384.Metal2 vout3.$1226.Metal3 0.00205268f
Cred_8021 VDD.$5384.Metal2 vout3.$1292.Metal3 0.00205268f
Cred_8022 VDD.$5384.Metal2 vout3.P6.nSD 3.23381e-05f
Cred_8023 VDD.$5384.Metal2 vout3.P6.pSD 0.00163692f
Cred_8024 VDD.$5384.Metal2 vout4.$1226.Metal3 0.00205268f
Cred_8025 VDD.$5384.Metal2 vout4.$1292.Metal3 0.00205268f
Cred_8026 VDD.$5384.Metal2 vout4.P6.nSD 3.23381e-05f
Cred_8027 VDD.$5384.Metal2 vout4.P6.pSD 0.00163692f
Cred_8028 VDD.$542.Metal1 vin3.P20.GatPoly 0.0183365f
Cred_8029 VDD.$542.Metal1 vout3.$1226.Metal3 0.003303f
Cred_8030 VDD.$542.Metal1 vout3.P0.nSD 9.8353e-05f
Cred_8031 VDD.$542.Metal1 vout3.P0.pSD 0.00454922f
Cred_8032 VDD.$542.Metal1 vout3.P2.nSD 5.20357e-05f
Cred_8033 VDD.$542.Metal1 vout3.P2.pSD 0.000284387f
Cred_8034 VDD.$5420.Metal2 vin1.$291.Metal1 4.08796e-06f
Cred_8035 VDD.$5420.Metal2 vin1.$295.Metal1 1.36265e-06f
Cred_8036 VDD.$5420.Metal2 vin1.$538.Metal2 0.000286582f
Cred_8037 VDD.$5420.Metal2 vin1.$542.Metal2 0.000286582f
Cred_8038 VDD.$5420.Metal2 vin1.P26.GatPoly 0.000888771f
Cred_8039 VDD.$5420.Metal2 vin1.P27.GatPoly 0.00946179f
Cred_8040 VDD.$5420.Metal2 vin2.$290.Metal1 4.08796e-06f
Cred_8041 VDD.$5420.Metal2 vin2.$294.Metal1 1.36265e-06f
Cred_8042 VDD.$5420.Metal2 vin2.$537.Metal2 0.000286582f
Cred_8043 VDD.$5420.Metal2 vin2.$541.Metal2 0.000286582f
Cred_8044 VDD.$5420.Metal2 vin2.P26.GatPoly 0.000888771f
Cred_8045 VDD.$5420.Metal2 vin2.P27.GatPoly 0.00946179f
Cred_8046 VDD.$5420.Metal2 vout1.$1226.Metal3 0.0039975f
Cred_8047 VDD.$5420.Metal2 vout1.$1292.Metal3 0.0039975f
Cred_8048 VDD.$5420.Metal2 vout1.P6.nSD 6.29768e-05f
Cred_8049 VDD.$5420.Metal2 vout1.P6.pSD 0.00356257f
Cred_8050 VDD.$5420.Metal2 vout2.$1226.Metal3 0.0039975f
Cred_8051 VDD.$5420.Metal2 vout2.$1292.Metal3 0.0039975f
Cred_8052 VDD.$5420.Metal2 vout2.P6.nSD 6.29768e-05f
Cred_8053 VDD.$5420.Metal2 vout2.P6.pSD 0.00356257f
Cred_8054 VDD.$543.Metal1 vin3.P20.GatPoly 0.0127709f
Cred_8055 VDD.$543.Metal1 vout3.$1226.Metal3 0.00209309f
Cred_8056 VDD.$543.Metal1 vout3.P0.nSD 6.23257e-05f
Cred_8057 VDD.$543.Metal1 vout3.P0.pSD 0.00289936f
Cred_8058 VDD.$543.Metal1 vout3.P2.nSD 3.29747e-05f
Cred_8059 VDD.$543.Metal1 vout3.P2.pSD 0.000180214f
Cred_8060 VDD.$5432.Metal2 vin3.$291.Metal1 4.08796e-06f
Cred_8061 VDD.$5432.Metal2 vin3.$295.Metal1 1.36265e-06f
Cred_8062 VDD.$5432.Metal2 vin3.$538.Metal2 0.000286582f
Cred_8063 VDD.$5432.Metal2 vin3.$542.Metal2 0.000286582f
Cred_8064 VDD.$5432.Metal2 vin3.P26.GatPoly 0.000888771f
Cred_8065 VDD.$5432.Metal2 vin3.P27.GatPoly 0.00946179f
Cred_8066 VDD.$5432.Metal2 vin4.$290.Metal1 4.08796e-06f
Cred_8067 VDD.$5432.Metal2 vin4.$294.Metal1 1.36265e-06f
Cred_8068 VDD.$5432.Metal2 vin4.$537.Metal2 0.000286582f
Cred_8069 VDD.$5432.Metal2 vin4.$541.Metal2 0.000286582f
Cred_8070 VDD.$5432.Metal2 vin4.P26.GatPoly 0.000888771f
Cred_8071 VDD.$5432.Metal2 vin4.P27.GatPoly 0.00946179f
Cred_8072 VDD.$5432.Metal2 vout3.$1226.Metal3 0.0039975f
Cred_8073 VDD.$5432.Metal2 vout3.$1292.Metal3 0.0039975f
Cred_8074 VDD.$5432.Metal2 vout3.P6.nSD 6.29768e-05f
Cred_8075 VDD.$5432.Metal2 vout3.P6.pSD 0.00356257f
Cred_8076 VDD.$5432.Metal2 vout4.$1226.Metal3 0.0039975f
Cred_8077 VDD.$5432.Metal2 vout4.$1292.Metal3 0.0039975f
Cred_8078 VDD.$5432.Metal2 vout4.P6.nSD 6.29768e-05f
Cred_8079 VDD.$5432.Metal2 vout4.P6.pSD 0.00356257f
Cred_8080 VDD.$5468.Metal2 vin1.$291.Metal1 0.00102353f
Cred_8081 VDD.$5468.Metal2 vin1.$295.Metal1 0.00214144f
Cred_8082 VDD.$5468.Metal2 vin1.$303.Metal1 0.00307999f
Cred_8083 VDD.$5468.Metal2 vin1.$307.Metal1 5.88438e-05f
Cred_8084 VDD.$5468.Metal2 vin1.$538.Metal2 0.000286582f
Cred_8085 VDD.$5468.Metal2 vin1.$542.Metal2 0.00293705f
Cred_8086 VDD.$5468.Metal2 vin1.$544.Metal2 0.000501564f
Cred_8087 VDD.$5468.Metal2 vin1.$547.Metal2 0.00563964f
Cred_8088 VDD.$5468.Metal2 vin1.$551.Metal2 6.35555e-05f
Cred_8089 VDD.$5468.Metal2 vin1.$65.GatPoly 0.00192751f
Cred_8090 VDD.$5468.Metal2 vin1.$73.GatPoly 0.00296087f
Cred_8091 VDD.$5468.Metal2 vin1.$77.GatPoly 0.00650345f
Cred_8092 VDD.$5468.Metal2 vin1.P26.GatPoly 0.0002715f
Cred_8093 VDD.$5468.Metal2 vin1.P27.GatPoly 0.0325098f
Cred_8094 VDD.$5468.Metal2 vin1.P28.GatPoly 0.0208724f
Cred_8095 VDD.$5468.Metal2 vin1.P29.GatPoly 0.0002715f
Cred_8096 VDD.$5468.Metal2 vin2.$290.Metal1 0.00102353f
Cred_8097 VDD.$5468.Metal2 vin2.$294.Metal1 0.00214144f
Cred_8098 VDD.$5468.Metal2 vin2.$302.Metal1 0.00307999f
Cred_8099 VDD.$5468.Metal2 vin2.$306.Metal1 5.88438e-05f
Cred_8100 VDD.$5468.Metal2 vin2.$537.Metal2 0.000286582f
Cred_8101 VDD.$5468.Metal2 vin2.$541.Metal2 0.00293705f
Cred_8102 VDD.$5468.Metal2 vin2.$544.Metal2 0.000501564f
Cred_8103 VDD.$5468.Metal2 vin2.$546.Metal2 0.00563964f
Cred_8104 VDD.$5468.Metal2 vin2.$550.Metal2 6.35555e-05f
Cred_8105 VDD.$5468.Metal2 vin2.$64.GatPoly 0.00192751f
Cred_8106 VDD.$5468.Metal2 vin2.$72.GatPoly 0.00296087f
Cred_8107 VDD.$5468.Metal2 vin2.$76.GatPoly 0.00650345f
Cred_8108 VDD.$5468.Metal2 vin2.P26.GatPoly 0.0002715f
Cred_8109 VDD.$5468.Metal2 vin2.P27.GatPoly 0.0325098f
Cred_8110 VDD.$5468.Metal2 vin2.P28.GatPoly 0.0208724f
Cred_8111 VDD.$5468.Metal2 vin2.P29.GatPoly 0.0002715f
Cred_8112 VDD.$5468.Metal2 vout1.$1226.Metal3 0.0163338f
Cred_8113 VDD.$5468.Metal2 vout1.$1292.Metal3 0.0508722f
Cred_8114 VDD.$5468.Metal2 vout1.P6.nSD 0.000257324f
Cred_8115 VDD.$5468.Metal2 vout1.P6.pSD 0.0144234f
Cred_8116 VDD.$5468.Metal2 vout1.P8.pSD 0.0125749f
Cred_8117 VDD.$5468.Metal2 vout2.$1226.Metal3 0.0162531f
Cred_8118 VDD.$5468.Metal2 vout2.$1292.Metal3 0.0508098f
Cred_8119 VDD.$5468.Metal2 vout2.P6.nSD 0.000256053f
Cred_8120 VDD.$5468.Metal2 vout2.P6.pSD 0.0143613f
Cred_8121 VDD.$5468.Metal2 vout2.P8.pSD 0.0126003f
Cred_8122 VDD.$5480.Metal2 vin3.$291.Metal1 0.00102353f
Cred_8123 VDD.$5480.Metal2 vin3.$295.Metal1 0.00214144f
Cred_8124 VDD.$5480.Metal2 vin3.$303.Metal1 0.00307999f
Cred_8125 VDD.$5480.Metal2 vin3.$307.Metal1 5.88438e-05f
Cred_8126 VDD.$5480.Metal2 vin3.$538.Metal2 0.000286582f
Cred_8127 VDD.$5480.Metal2 vin3.$542.Metal2 0.00293705f
Cred_8128 VDD.$5480.Metal2 vin3.$544.Metal2 0.000501564f
Cred_8129 VDD.$5480.Metal2 vin3.$547.Metal2 0.00563964f
Cred_8130 VDD.$5480.Metal2 vin3.$551.Metal2 6.35555e-05f
Cred_8131 VDD.$5480.Metal2 vin3.$65.GatPoly 0.00192751f
Cred_8132 VDD.$5480.Metal2 vin3.$73.GatPoly 0.00296087f
Cred_8133 VDD.$5480.Metal2 vin3.$77.GatPoly 0.00650345f
Cred_8134 VDD.$5480.Metal2 vin3.P26.GatPoly 0.0002715f
Cred_8135 VDD.$5480.Metal2 vin3.P27.GatPoly 0.0325098f
Cred_8136 VDD.$5480.Metal2 vin3.P28.GatPoly 0.0208724f
Cred_8137 VDD.$5480.Metal2 vin3.P29.GatPoly 0.0002715f
Cred_8138 VDD.$5480.Metal2 vin4.$290.Metal1 0.00102353f
Cred_8139 VDD.$5480.Metal2 vin4.$294.Metal1 0.00214144f
Cred_8140 VDD.$5480.Metal2 vin4.$302.Metal1 0.00307999f
Cred_8141 VDD.$5480.Metal2 vin4.$306.Metal1 5.88438e-05f
Cred_8142 VDD.$5480.Metal2 vin4.$537.Metal2 0.000286582f
Cred_8143 VDD.$5480.Metal2 vin4.$541.Metal2 0.00293705f
Cred_8144 VDD.$5480.Metal2 vin4.$544.Metal2 0.000501564f
Cred_8145 VDD.$5480.Metal2 vin4.$546.Metal2 0.00563964f
Cred_8146 VDD.$5480.Metal2 vin4.$550.Metal2 6.35555e-05f
Cred_8147 VDD.$5480.Metal2 vin4.$64.GatPoly 0.00192751f
Cred_8148 VDD.$5480.Metal2 vin4.$72.GatPoly 0.00296087f
Cred_8149 VDD.$5480.Metal2 vin4.$76.GatPoly 0.00650345f
Cred_8150 VDD.$5480.Metal2 vin4.P26.GatPoly 0.0002715f
Cred_8151 VDD.$5480.Metal2 vin4.P27.GatPoly 0.0325098f
Cred_8152 VDD.$5480.Metal2 vin4.P28.GatPoly 0.0208724f
Cred_8153 VDD.$5480.Metal2 vin4.P29.GatPoly 0.0002715f
Cred_8154 VDD.$5480.Metal2 vout3.$1226.Metal3 0.0163338f
Cred_8155 VDD.$5480.Metal2 vout3.$1292.Metal3 0.0508722f
Cred_8156 VDD.$5480.Metal2 vout3.P6.nSD 0.000257324f
Cred_8157 VDD.$5480.Metal2 vout3.P6.pSD 0.0144234f
Cred_8158 VDD.$5480.Metal2 vout3.P8.pSD 0.0125749f
Cred_8159 VDD.$5480.Metal2 vout4.$1226.Metal3 0.0162531f
Cred_8160 VDD.$5480.Metal2 vout4.$1292.Metal3 0.0508098f
Cred_8161 VDD.$5480.Metal2 vout4.P6.nSD 0.000256053f
Cred_8162 VDD.$5480.Metal2 vout4.P6.pSD 0.0143613f
Cred_8163 VDD.$5480.Metal2 vout4.P8.pSD 0.0126003f
Cred_8164 VDD.$5550.Metal2 vin1.$291.Metal1 0.00338024f
Cred_8165 VDD.$5550.Metal2 vin1.$295.Metal1 0.00709604f
Cred_8166 VDD.$5550.Metal2 vin1.$303.Metal1 0.0102126f
Cred_8167 VDD.$5550.Metal2 vin1.$307.Metal1 0.000195114f
Cred_8168 VDD.$5550.Metal2 vin1.$542.Metal2 0.00878838f
Cred_8169 VDD.$5550.Metal2 vin1.$544.Metal2 0.00166308f
Cred_8170 VDD.$5550.Metal2 vin1.$547.Metal2 0.0186998f
Cred_8171 VDD.$5550.Metal2 vin1.$551.Metal2 0.000210737f
Cred_8172 VDD.$5550.Metal2 vin1.$65.GatPoly 0.00639121f
Cred_8173 VDD.$5550.Metal2 vin1.$73.GatPoly 0.00981762f
Cred_8174 VDD.$5550.Metal2 vin1.$77.GatPoly 0.0215641f
Cred_8175 VDD.$5550.Metal2 vin1.P26.GatPoly 0.000900237f
Cred_8176 VDD.$5550.Metal2 vin1.P27.GatPoly 0.0726f
Cred_8177 VDD.$5550.Metal2 vin1.P28.GatPoly 0.0691829f
Cred_8178 VDD.$5550.Metal2 vin1.P29.GatPoly 0.000900237f
Cred_8179 VDD.$5550.Metal2 vin2.$290.Metal1 0.00338024f
Cred_8180 VDD.$5550.Metal2 vin2.$294.Metal1 0.00709604f
Cred_8181 VDD.$5550.Metal2 vin2.$302.Metal1 0.0102126f
Cred_8182 VDD.$5550.Metal2 vin2.$306.Metal1 0.000195114f
Cred_8183 VDD.$5550.Metal2 vin2.$541.Metal2 0.00878838f
Cred_8184 VDD.$5550.Metal2 vin2.$544.Metal2 0.00166308f
Cred_8185 VDD.$5550.Metal2 vin2.$546.Metal2 0.0186998f
Cred_8186 VDD.$5550.Metal2 vin2.$550.Metal2 0.000210737f
Cred_8187 VDD.$5550.Metal2 vin2.$64.GatPoly 0.00639121f
Cred_8188 VDD.$5550.Metal2 vin2.$72.GatPoly 0.00981762f
Cred_8189 VDD.$5550.Metal2 vin2.$76.GatPoly 0.0215641f
Cred_8190 VDD.$5550.Metal2 vin2.P26.GatPoly 0.000900237f
Cred_8191 VDD.$5550.Metal2 vin2.P27.GatPoly 0.0726f
Cred_8192 VDD.$5550.Metal2 vin2.P28.GatPoly 0.0691829f
Cred_8193 VDD.$5550.Metal2 vin2.P29.GatPoly 0.000900237f
Cred_8194 VDD.$5550.Metal2 vout1.$1226.Metal3 0.0541595f
Cred_8195 VDD.$5550.Metal2 vout1.$1292.Metal3 0.168682f
Cred_8196 VDD.$5550.Metal2 vout1.P6.nSD 0.000853233f
Cred_8197 VDD.$5550.Metal2 vout1.P6.pSD 0.0478251f
Cred_8198 VDD.$5550.Metal2 vout1.P8.pSD 0.0416958f
Cred_8199 VDD.$5550.Metal2 vout2.$1226.Metal3 0.0538919f
Cred_8200 VDD.$5550.Metal2 vout2.$1292.Metal3 0.168474f
Cred_8201 VDD.$5550.Metal2 vout2.P6.nSD 0.000849017f
Cred_8202 VDD.$5550.Metal2 vout2.P6.pSD 0.047619f
Cred_8203 VDD.$5550.Metal2 vout2.P8.pSD 0.04178f
Cred_8204 VDD.$5562.Metal2 vin3.$291.Metal1 0.00338024f
Cred_8205 VDD.$5562.Metal2 vin3.$295.Metal1 0.00709604f
Cred_8206 VDD.$5562.Metal2 vin3.$303.Metal1 0.0102126f
Cred_8207 VDD.$5562.Metal2 vin3.$307.Metal1 0.000195114f
Cred_8208 VDD.$5562.Metal2 vin3.$542.Metal2 0.00878838f
Cred_8209 VDD.$5562.Metal2 vin3.$544.Metal2 0.00166308f
Cred_8210 VDD.$5562.Metal2 vin3.$547.Metal2 0.0186998f
Cred_8211 VDD.$5562.Metal2 vin3.$551.Metal2 0.000210737f
Cred_8212 VDD.$5562.Metal2 vin3.$65.GatPoly 0.00639121f
Cred_8213 VDD.$5562.Metal2 vin3.$73.GatPoly 0.00981762f
Cred_8214 VDD.$5562.Metal2 vin3.$77.GatPoly 0.0215641f
Cred_8215 VDD.$5562.Metal2 vin3.P26.GatPoly 0.000900237f
Cred_8216 VDD.$5562.Metal2 vin3.P27.GatPoly 0.0726f
Cred_8217 VDD.$5562.Metal2 vin3.P28.GatPoly 0.0691829f
Cred_8218 VDD.$5562.Metal2 vin3.P29.GatPoly 0.000900237f
Cred_8219 VDD.$5562.Metal2 vin4.$290.Metal1 0.00338024f
Cred_8220 VDD.$5562.Metal2 vin4.$294.Metal1 0.00709604f
Cred_8221 VDD.$5562.Metal2 vin4.$302.Metal1 0.0102126f
Cred_8222 VDD.$5562.Metal2 vin4.$306.Metal1 0.000195114f
Cred_8223 VDD.$5562.Metal2 vin4.$541.Metal2 0.00878838f
Cred_8224 VDD.$5562.Metal2 vin4.$544.Metal2 0.00166308f
Cred_8225 VDD.$5562.Metal2 vin4.$546.Metal2 0.0186998f
Cred_8226 VDD.$5562.Metal2 vin4.$550.Metal2 0.000210737f
Cred_8227 VDD.$5562.Metal2 vin4.$64.GatPoly 0.00639121f
Cred_8228 VDD.$5562.Metal2 vin4.$72.GatPoly 0.00981762f
Cred_8229 VDD.$5562.Metal2 vin4.$76.GatPoly 0.0215641f
Cred_8230 VDD.$5562.Metal2 vin4.P26.GatPoly 0.000900237f
Cred_8231 VDD.$5562.Metal2 vin4.P27.GatPoly 0.0726f
Cred_8232 VDD.$5562.Metal2 vin4.P28.GatPoly 0.0691829f
Cred_8233 VDD.$5562.Metal2 vin4.P29.GatPoly 0.000900237f
Cred_8234 VDD.$5562.Metal2 vout3.$1226.Metal3 0.0541595f
Cred_8235 VDD.$5562.Metal2 vout3.$1292.Metal3 0.168682f
Cred_8236 VDD.$5562.Metal2 vout3.P6.nSD 0.000853233f
Cred_8237 VDD.$5562.Metal2 vout3.P6.pSD 0.0478251f
Cred_8238 VDD.$5562.Metal2 vout3.P8.pSD 0.0416958f
Cred_8239 VDD.$5562.Metal2 vout4.$1226.Metal3 0.0538919f
Cred_8240 VDD.$5562.Metal2 vout4.$1292.Metal3 0.168474f
Cred_8241 VDD.$5562.Metal2 vout4.P6.nSD 0.000849017f
Cred_8242 VDD.$5562.Metal2 vout4.P6.pSD 0.047619f
Cred_8243 VDD.$5562.Metal2 vout4.P8.pSD 0.04178f
Cred_8244 VDD.$5630.Metal2 vin1.$303.Metal1 1.4209e-06f
Cred_8245 VDD.$5630.Metal2 vin1.$307.Metal1 9.31479e-06f
Cred_8246 VDD.$5630.Metal2 vin1.$547.Metal2 0.000563652f
Cred_8247 VDD.$5630.Metal2 vin1.$551.Metal2 0.0010717f
Cred_8248 VDD.$5630.Metal2 vin1.P27.GatPoly 1.03171e-05f
Cred_8249 VDD.$5630.Metal2 vin1.P28.GatPoly 0.0149676f
Cred_8250 VDD.$5630.Metal2 vin2.$302.Metal1 1.4209e-06f
Cred_8251 VDD.$5630.Metal2 vin2.$306.Metal1 9.31479e-06f
Cred_8252 VDD.$5630.Metal2 vin2.$546.Metal2 0.000563652f
Cred_8253 VDD.$5630.Metal2 vin2.$550.Metal2 0.0010717f
Cred_8254 VDD.$5630.Metal2 vin2.P27.GatPoly 1.03171e-05f
Cred_8255 VDD.$5630.Metal2 vin2.P28.GatPoly 0.0149676f
Cred_8256 VDD.$5630.Metal2 vout1.$1292.Metal3 0.0014486f
Cred_8257 VDD.$5630.Metal2 vout1.P8.pSD 0.000324187f
Cred_8258 VDD.$5630.Metal2 vout2.$1292.Metal3 0.0014486f
Cred_8259 VDD.$5630.Metal2 vout2.P8.pSD 0.000324187f
Cred_8260 VDD.$5642.Metal2 vin3.$303.Metal1 1.4209e-06f
Cred_8261 VDD.$5642.Metal2 vin3.$307.Metal1 9.31479e-06f
Cred_8262 VDD.$5642.Metal2 vin3.$547.Metal2 0.000563652f
Cred_8263 VDD.$5642.Metal2 vin3.$551.Metal2 0.0010717f
Cred_8264 VDD.$5642.Metal2 vin3.P27.GatPoly 1.03171e-05f
Cred_8265 VDD.$5642.Metal2 vin3.P28.GatPoly 0.0149676f
Cred_8266 VDD.$5642.Metal2 vin4.$302.Metal1 1.4209e-06f
Cred_8267 VDD.$5642.Metal2 vin4.$306.Metal1 9.31479e-06f
Cred_8268 VDD.$5642.Metal2 vin4.$546.Metal2 0.000563652f
Cred_8269 VDD.$5642.Metal2 vin4.$550.Metal2 0.0010717f
Cred_8270 VDD.$5642.Metal2 vin4.P27.GatPoly 1.03171e-05f
Cred_8271 VDD.$5642.Metal2 vin4.P28.GatPoly 0.0149676f
Cred_8272 VDD.$5642.Metal2 vout3.$1292.Metal3 0.0014486f
Cred_8273 VDD.$5642.Metal2 vout3.P8.pSD 0.000324187f
Cred_8274 VDD.$5642.Metal2 vout4.$1292.Metal3 0.0014486f
Cred_8275 VDD.$5642.Metal2 vout4.P8.pSD 0.000324187f
Cred_8276 VDD.$567.Metal1 vin1.P20.GatPoly 0.000178565f
Cred_8277 VDD.$567.Metal1 vin2.P20.GatPoly 0.000178565f
Cred_8278 VDD.$5678.Metal2 vin1.$551.Metal2 0.000508049f
Cred_8279 VDD.$5678.Metal2 vin1.P28.GatPoly 0.00462601f
Cred_8280 VDD.$5678.Metal2 vin1.P29.GatPoly 5.10563e-06f
Cred_8281 VDD.$5678.Metal2 vin2.$550.Metal2 0.000508049f
Cred_8282 VDD.$5678.Metal2 vin2.P28.GatPoly 0.00462601f
Cred_8283 VDD.$5678.Metal2 vin2.P29.GatPoly 5.10563e-06f
Cred_8284 VDD.$5678.Metal2 vout1.$1292.Metal3 0.007478f
Cred_8285 VDD.$5678.Metal2 vout1.P8.pSD 0.00295423f
Cred_8286 VDD.$5678.Metal2 vout2.$1292.Metal3 0.007478f
Cred_8287 VDD.$5678.Metal2 vout2.P8.pSD 0.00295423f
Cred_8288 VDD.$5690.Metal2 vin3.$551.Metal2 0.000508049f
Cred_8289 VDD.$5690.Metal2 vin3.P28.GatPoly 0.00462601f
Cred_8290 VDD.$5690.Metal2 vin3.P29.GatPoly 5.10563e-06f
Cred_8291 VDD.$5690.Metal2 vin4.$550.Metal2 0.000508049f
Cred_8292 VDD.$5690.Metal2 vin4.P28.GatPoly 0.00462601f
Cred_8293 VDD.$5690.Metal2 vin4.P29.GatPoly 5.10563e-06f
Cred_8294 VDD.$5690.Metal2 vout3.$1292.Metal3 0.007478f
Cred_8295 VDD.$5690.Metal2 vout3.P8.pSD 0.00295423f
Cred_8296 VDD.$5690.Metal2 vout4.$1292.Metal3 0.007478f
Cred_8297 VDD.$5690.Metal2 vout4.P8.pSD 0.00295423f
Cred_8298 VDD.$5702.Metal2 vin1.$321.Metal1 1.68242e-06f
Cred_8299 VDD.$5702.Metal2 vin1.$325.Metal1 3.76542e-06f
Cred_8300 VDD.$5702.Metal2 vin1.$558.Metal2 0.000286583f
Cred_8301 VDD.$5702.Metal2 vin1.$562.Metal2 0.000286583f
Cred_8302 VDD.$5702.Metal2 vin1.P29.GatPoly 0.012591f
Cred_8303 VDD.$5702.Metal2 vin2.$320.Metal1 1.68242e-06f
Cred_8304 VDD.$5702.Metal2 vin2.$324.Metal1 3.76542e-06f
Cred_8305 VDD.$5702.Metal2 vin2.$557.Metal2 0.000286583f
Cred_8306 VDD.$5702.Metal2 vin2.$561.Metal2 0.000286583f
Cred_8307 VDD.$5702.Metal2 vin2.P29.GatPoly 0.012591f
Cred_8308 VDD.$5702.Metal2 vout1.$1292.Metal3 0.00457247f
Cred_8309 VDD.$5702.Metal2 vout1.P8.pSD 0.00136597f
Cred_8310 VDD.$5702.Metal2 vout2.$1292.Metal3 0.00457247f
Cred_8311 VDD.$5702.Metal2 vout2.P8.pSD 0.00136597f
Cred_8312 VDD.$5714.Metal2 vin3.$321.Metal1 1.68242e-06f
Cred_8313 VDD.$5714.Metal2 vin3.$325.Metal1 3.76542e-06f
Cred_8314 VDD.$5714.Metal2 vin3.$558.Metal2 0.000286583f
Cred_8315 VDD.$5714.Metal2 vin3.$562.Metal2 0.000286583f
Cred_8316 VDD.$5714.Metal2 vin3.P29.GatPoly 0.012591f
Cred_8317 VDD.$5714.Metal2 vin4.$320.Metal1 1.68242e-06f
Cred_8318 VDD.$5714.Metal2 vin4.$324.Metal1 3.76542e-06f
Cred_8319 VDD.$5714.Metal2 vin4.$557.Metal2 0.000286583f
Cred_8320 VDD.$5714.Metal2 vin4.$561.Metal2 0.000286583f
Cred_8321 VDD.$5714.Metal2 vin4.P29.GatPoly 0.012591f
Cred_8322 VDD.$5714.Metal2 vout3.$1292.Metal3 0.00457247f
Cred_8323 VDD.$5714.Metal2 vout3.P8.pSD 0.00136597f
Cred_8324 VDD.$5714.Metal2 vout4.$1292.Metal3 0.00457247f
Cred_8325 VDD.$5714.Metal2 vout4.P8.pSD 0.00136597f
Cred_8326 VDD.$573.Metal1 vin3.P20.GatPoly 0.000178565f
Cred_8327 VDD.$573.Metal1 vin4.P20.GatPoly 0.000178565f
Cred_8328 VDD.$5766.Metal2 vin1.$321.Metal1 1.68242e-06f
Cred_8329 VDD.$5766.Metal2 vin1.$325.Metal1 0.00230219f
Cred_8330 VDD.$5766.Metal2 vin1.$331.Metal1 0.00693627f
Cred_8331 VDD.$5766.Metal2 vin1.$335.Metal1 0.000333304f
Cred_8332 VDD.$5766.Metal2 vin1.$558.Metal2 0.000286583f
Cred_8333 VDD.$5766.Metal2 vin1.$562.Metal2 0.00961432f
Cred_8334 VDD.$5766.Metal2 vin1.$564.Metal2 0.00125525f
Cred_8335 VDD.$5766.Metal2 vin1.$567.Metal2 0.00863762f
Cred_8336 VDD.$5766.Metal2 vin1.$87.GatPoly 0.0135283f
Cred_8337 VDD.$5766.Metal2 vin1.$93.GatPoly 0.00318753f
Cred_8338 VDD.$5766.Metal2 vin1.$97.GatPoly 0.0140647f
Cred_8339 VDD.$5766.Metal2 vin1.P28.GatPoly 0.000584837f
Cred_8340 VDD.$5766.Metal2 vin1.P29.GatPoly 0.0526476f
Cred_8341 VDD.$5766.Metal2 vin1.P30.GatPoly 0.0448586f
Cred_8342 VDD.$5766.Metal2 vin1.P31.GatPoly 0.000584837f
Cred_8343 VDD.$5766.Metal2 vin2.$320.Metal1 1.68242e-06f
Cred_8344 VDD.$5766.Metal2 vin2.$324.Metal1 0.00230219f
Cred_8345 VDD.$5766.Metal2 vin2.$330.Metal1 0.00693627f
Cred_8346 VDD.$5766.Metal2 vin2.$334.Metal1 0.000333304f
Cred_8347 VDD.$5766.Metal2 vin2.$557.Metal2 0.000286583f
Cred_8348 VDD.$5766.Metal2 vin2.$561.Metal2 0.00961432f
Cred_8349 VDD.$5766.Metal2 vin2.$564.Metal2 0.00125525f
Cred_8350 VDD.$5766.Metal2 vin2.$566.Metal2 0.00863762f
Cred_8351 VDD.$5766.Metal2 vin2.$86.GatPoly 0.0135283f
Cred_8352 VDD.$5766.Metal2 vin2.$92.GatPoly 0.00318753f
Cred_8353 VDD.$5766.Metal2 vin2.$96.GatPoly 0.0140647f
Cred_8354 VDD.$5766.Metal2 vin2.P28.GatPoly 0.000584837f
Cred_8355 VDD.$5766.Metal2 vin2.P29.GatPoly 0.0526476f
Cred_8356 VDD.$5766.Metal2 vin2.P30.GatPoly 0.0448586f
Cred_8357 VDD.$5766.Metal2 vin2.P31.GatPoly 0.000584837f
Cred_8358 VDD.$5766.Metal2 vout1.$1292.Metal3 0.108768f
Cred_8359 VDD.$5766.Metal2 vout1.$1358.Metal3 0.0351593f
Cred_8360 VDD.$5766.Metal2 vout1.P10.nSD 0.000553901f
Cred_8361 VDD.$5766.Metal2 vout1.P10.pSD 0.030643f
Cred_8362 VDD.$5766.Metal2 vout1.P8.pSD 0.0279599f
Cred_8363 VDD.$5766.Metal2 vout2.$1292.Metal3 0.108614f
Cred_8364 VDD.$5766.Metal2 vout2.$1358.Metal3 0.0350443f
Cred_8365 VDD.$5766.Metal2 vout2.P10.nSD 0.000552089f
Cred_8366 VDD.$5766.Metal2 vout2.P10.pSD 0.0306175f
Cred_8367 VDD.$5766.Metal2 vout2.P8.pSD 0.0279052f
Cred_8368 VDD.$579.Metal1 vin1.P20.GatPoly 0.0122207f
Cred_8369 VDD.$579.Metal1 vin2.P20.GatPoly 0.0122207f
Cred_8370 VDD.$5806.Metal2 vin3.$321.Metal1 1.68242e-06f
Cred_8371 VDD.$5806.Metal2 vin3.$325.Metal1 0.00230219f
Cred_8372 VDD.$5806.Metal2 vin3.$331.Metal1 0.00693627f
Cred_8373 VDD.$5806.Metal2 vin3.$335.Metal1 0.000333304f
Cred_8374 VDD.$5806.Metal2 vin3.$558.Metal2 0.000286583f
Cred_8375 VDD.$5806.Metal2 vin3.$562.Metal2 0.00896177f
Cred_8376 VDD.$5806.Metal2 vin3.$564.Metal2 0.00125525f
Cred_8377 VDD.$5806.Metal2 vin3.$567.Metal2 0.00929017f
Cred_8378 VDD.$5806.Metal2 vin3.$87.GatPoly 0.0135283f
Cred_8379 VDD.$5806.Metal2 vin3.$93.GatPoly 0.00318753f
Cred_8380 VDD.$5806.Metal2 vin3.$97.GatPoly 0.0140647f
Cred_8381 VDD.$5806.Metal2 vin3.P28.GatPoly 0.000584837f
Cred_8382 VDD.$5806.Metal2 vin3.P29.GatPoly 0.0526476f
Cred_8383 VDD.$5806.Metal2 vin3.P30.GatPoly 0.0448586f
Cred_8384 VDD.$5806.Metal2 vin3.P31.GatPoly 0.000584837f
Cred_8385 VDD.$5806.Metal2 vin4.$320.Metal1 1.68242e-06f
Cred_8386 VDD.$5806.Metal2 vin4.$324.Metal1 0.00230219f
Cred_8387 VDD.$5806.Metal2 vin4.$330.Metal1 0.00693627f
Cred_8388 VDD.$5806.Metal2 vin4.$334.Metal1 0.000333304f
Cred_8389 VDD.$5806.Metal2 vin4.$557.Metal2 0.000286583f
Cred_8390 VDD.$5806.Metal2 vin4.$561.Metal2 0.00961432f
Cred_8391 VDD.$5806.Metal2 vin4.$564.Metal2 0.00125525f
Cred_8392 VDD.$5806.Metal2 vin4.$566.Metal2 0.00863762f
Cred_8393 VDD.$5806.Metal2 vin4.$86.GatPoly 0.0135283f
Cred_8394 VDD.$5806.Metal2 vin4.$92.GatPoly 0.00318753f
Cred_8395 VDD.$5806.Metal2 vin4.$96.GatPoly 0.0140647f
Cred_8396 VDD.$5806.Metal2 vin4.P28.GatPoly 0.000584837f
Cred_8397 VDD.$5806.Metal2 vin4.P29.GatPoly 0.0526476f
Cred_8398 VDD.$5806.Metal2 vin4.P30.GatPoly 0.0448586f
Cred_8399 VDD.$5806.Metal2 vin4.P31.GatPoly 0.000584837f
Cred_8400 VDD.$5806.Metal2 vout3.$1292.Metal3 0.108768f
Cred_8401 VDD.$5806.Metal2 vout3.$1358.Metal3 0.0351593f
Cred_8402 VDD.$5806.Metal2 vout3.P10.nSD 0.000553901f
Cred_8403 VDD.$5806.Metal2 vout3.P10.pSD 0.030643f
Cred_8404 VDD.$5806.Metal2 vout3.P8.pSD 0.0279599f
Cred_8405 VDD.$5806.Metal2 vout4.$1292.Metal3 0.108614f
Cred_8406 VDD.$5806.Metal2 vout4.$1358.Metal3 0.0350443f
Cred_8407 VDD.$5806.Metal2 vout4.P10.nSD 0.000552089f
Cred_8408 VDD.$5806.Metal2 vout4.P10.pSD 0.0306175f
Cred_8409 VDD.$5806.Metal2 vout4.P8.pSD 0.0279052f
Cred_8410 VDD.$583.Metal1 vin3.P20.GatPoly 0.0122207f
Cred_8411 VDD.$583.Metal1 vin4.P20.GatPoly 0.0122207f
Cred_8412 VDD.$5846.Metal2 vin1.$325.Metal1 0.00229842f
Cred_8413 VDD.$5846.Metal2 vin1.$331.Metal1 0.00693627f
Cred_8414 VDD.$5846.Metal2 vin1.$335.Metal1 0.000337069f
Cred_8415 VDD.$5846.Metal2 vin1.$339.Metal1 1.68242e-06f
Cred_8416 VDD.$5846.Metal2 vin1.$562.Metal2 0.00932774f
Cred_8417 VDD.$5846.Metal2 vin1.$564.Metal2 0.00125525f
Cred_8418 VDD.$5846.Metal2 vin1.$567.Metal2 0.0089242f
Cred_8419 VDD.$5846.Metal2 vin1.$571.Metal2 0.000286583f
Cred_8420 VDD.$5846.Metal2 vin1.$87.GatPoly 0.0135283f
Cred_8421 VDD.$5846.Metal2 vin1.$93.GatPoly 0.00318753f
Cred_8422 VDD.$5846.Metal2 vin1.$97.GatPoly 0.0140647f
Cred_8423 VDD.$5846.Metal2 vin1.P28.GatPoly 0.000584837f
Cred_8424 VDD.$5846.Metal2 vin1.P29.GatPoly 0.0448586f
Cred_8425 VDD.$5846.Metal2 vin1.P30.GatPoly 0.0526476f
Cred_8426 VDD.$5846.Metal2 vin1.P31.GatPoly 0.000584837f
Cred_8427 VDD.$5846.Metal2 vin2.$324.Metal1 0.00229842f
Cred_8428 VDD.$5846.Metal2 vin2.$330.Metal1 0.00693627f
Cred_8429 VDD.$5846.Metal2 vin2.$334.Metal1 0.000337069f
Cred_8430 VDD.$5846.Metal2 vin2.$338.Metal1 1.68242e-06f
Cred_8431 VDD.$5846.Metal2 vin2.$561.Metal2 0.00932774f
Cred_8432 VDD.$5846.Metal2 vin2.$564.Metal2 0.00125525f
Cred_8433 VDD.$5846.Metal2 vin2.$566.Metal2 0.0089242f
Cred_8434 VDD.$5846.Metal2 vin2.$570.Metal2 0.000286583f
Cred_8435 VDD.$5846.Metal2 vin2.$86.GatPoly 0.0135283f
Cred_8436 VDD.$5846.Metal2 vin2.$92.GatPoly 0.00318753f
Cred_8437 VDD.$5846.Metal2 vin2.$96.GatPoly 0.0140647f
Cred_8438 VDD.$5846.Metal2 vin2.P28.GatPoly 0.000584837f
Cred_8439 VDD.$5846.Metal2 vin2.P29.GatPoly 0.0448586f
Cred_8440 VDD.$5846.Metal2 vin2.P30.GatPoly 0.0526476f
Cred_8441 VDD.$5846.Metal2 vin2.P31.GatPoly 0.000584837f
Cred_8442 VDD.$5846.Metal2 vout1.$1292.Metal3 0.108768f
Cred_8443 VDD.$5846.Metal2 vout1.$1358.Metal3 0.0351593f
Cred_8444 VDD.$5846.Metal2 vout1.P10.nSD 0.000553901f
Cred_8445 VDD.$5846.Metal2 vout1.P10.pSD 0.030643f
Cred_8446 VDD.$5846.Metal2 vout1.P8.pSD 0.0279599f
Cred_8447 VDD.$5846.Metal2 vout2.$1292.Metal3 0.108614f
Cred_8448 VDD.$5846.Metal2 vout2.$1358.Metal3 0.0350443f
Cred_8449 VDD.$5846.Metal2 vout2.P10.nSD 0.000552089f
Cred_8450 VDD.$5846.Metal2 vout2.P10.pSD 0.0306175f
Cred_8451 VDD.$5846.Metal2 vout2.P8.pSD 0.0279052f
Cred_8452 VDD.$5886.Metal2 vin3.$325.Metal1 0.00229842f
Cred_8453 VDD.$5886.Metal2 vin3.$331.Metal1 0.00693627f
Cred_8454 VDD.$5886.Metal2 vin3.$335.Metal1 0.000337069f
Cred_8455 VDD.$5886.Metal2 vin3.$339.Metal1 1.68242e-06f
Cred_8456 VDD.$5886.Metal2 vin3.$562.Metal2 0.00867519f
Cred_8457 VDD.$5886.Metal2 vin3.$564.Metal2 0.00125525f
Cred_8458 VDD.$5886.Metal2 vin3.$567.Metal2 0.00957675f
Cred_8459 VDD.$5886.Metal2 vin3.$571.Metal2 0.000286583f
Cred_8460 VDD.$5886.Metal2 vin3.$87.GatPoly 0.0135283f
Cred_8461 VDD.$5886.Metal2 vin3.$93.GatPoly 0.00318753f
Cred_8462 VDD.$5886.Metal2 vin3.$97.GatPoly 0.0140647f
Cred_8463 VDD.$5886.Metal2 vin3.P28.GatPoly 0.000584837f
Cred_8464 VDD.$5886.Metal2 vin3.P29.GatPoly 0.0448586f
Cred_8465 VDD.$5886.Metal2 vin3.P30.GatPoly 0.0526476f
Cred_8466 VDD.$5886.Metal2 vin3.P31.GatPoly 0.000584837f
Cred_8467 VDD.$5886.Metal2 vin4.$324.Metal1 0.00229842f
Cred_8468 VDD.$5886.Metal2 vin4.$330.Metal1 0.00693627f
Cred_8469 VDD.$5886.Metal2 vin4.$334.Metal1 0.000337069f
Cred_8470 VDD.$5886.Metal2 vin4.$338.Metal1 1.68242e-06f
Cred_8471 VDD.$5886.Metal2 vin4.$561.Metal2 0.00932774f
Cred_8472 VDD.$5886.Metal2 vin4.$564.Metal2 0.00125525f
Cred_8473 VDD.$5886.Metal2 vin4.$566.Metal2 0.0089242f
Cred_8474 VDD.$5886.Metal2 vin4.$570.Metal2 0.000286583f
Cred_8475 VDD.$5886.Metal2 vin4.$86.GatPoly 0.0135283f
Cred_8476 VDD.$5886.Metal2 vin4.$92.GatPoly 0.00318753f
Cred_8477 VDD.$5886.Metal2 vin4.$96.GatPoly 0.0140647f
Cred_8478 VDD.$5886.Metal2 vin4.P28.GatPoly 0.000584837f
Cred_8479 VDD.$5886.Metal2 vin4.P29.GatPoly 0.0448586f
Cred_8480 VDD.$5886.Metal2 vin4.P30.GatPoly 0.0526476f
Cred_8481 VDD.$5886.Metal2 vin4.P31.GatPoly 0.000584837f
Cred_8482 VDD.$5886.Metal2 vout3.$1292.Metal3 0.108768f
Cred_8483 VDD.$5886.Metal2 vout3.$1358.Metal3 0.0351593f
Cred_8484 VDD.$5886.Metal2 vout3.P10.nSD 0.000553901f
Cred_8485 VDD.$5886.Metal2 vout3.P10.pSD 0.030643f
Cred_8486 VDD.$5886.Metal2 vout3.P8.pSD 0.0279599f
Cred_8487 VDD.$5886.Metal2 vout4.$1292.Metal3 0.108614f
Cred_8488 VDD.$5886.Metal2 vout4.$1358.Metal3 0.0350443f
Cred_8489 VDD.$5886.Metal2 vout4.P10.nSD 0.000552089f
Cred_8490 VDD.$5886.Metal2 vout4.P10.pSD 0.0306175f
Cred_8491 VDD.$5886.Metal2 vout4.P8.pSD 0.0279052f
Cred_8492 VDD.$5936.Metal2 vin1.$335.Metal1 3.76542e-06f
Cred_8493 VDD.$5936.Metal2 vin1.$339.Metal1 1.68242e-06f
Cred_8494 VDD.$5936.Metal2 vin1.$567.Metal2 0.000286583f
Cred_8495 VDD.$5936.Metal2 vin1.$571.Metal2 0.000286583f
Cred_8496 VDD.$5936.Metal2 vin1.P30.GatPoly 0.0125885f
Cred_8497 VDD.$5936.Metal2 vin2.$334.Metal1 3.76542e-06f
Cred_8498 VDD.$5936.Metal2 vin2.$338.Metal1 1.68242e-06f
Cred_8499 VDD.$5936.Metal2 vin2.$566.Metal2 0.000286583f
Cred_8500 VDD.$5936.Metal2 vin2.$570.Metal2 0.000286583f
Cred_8501 VDD.$5936.Metal2 vin2.P30.GatPoly 0.0125885f
Cred_8502 VDD.$5936.Metal2 vout1.$1292.Metal3 0.00354817f
Cred_8503 VDD.$5936.Metal2 vout1.$1358.Metal3 0.00354817f
Cred_8504 VDD.$5936.Metal2 vout1.P10.nSD 5.58981e-05f
Cred_8505 VDD.$5936.Metal2 vout1.P10.pSD 0.00302132f
Cred_8506 VDD.$5936.Metal2 vout2.$1292.Metal3 0.00354817f
Cred_8507 VDD.$5936.Metal2 vout2.$1358.Metal3 0.00354817f
Cred_8508 VDD.$5936.Metal2 vout2.P10.nSD 5.58981e-05f
Cred_8509 VDD.$5936.Metal2 vout2.P10.pSD 0.00302132f
Cred_8510 VDD.$5948.Metal2 vin3.$335.Metal1 3.76542e-06f
Cred_8511 VDD.$5948.Metal2 vin3.$339.Metal1 1.68242e-06f
Cred_8512 VDD.$5948.Metal2 vin3.$567.Metal2 0.000286583f
Cred_8513 VDD.$5948.Metal2 vin3.$571.Metal2 0.000286583f
Cred_8514 VDD.$5948.Metal2 vin3.P30.GatPoly 0.0125885f
Cred_8515 VDD.$5948.Metal2 vin4.$334.Metal1 3.76542e-06f
Cred_8516 VDD.$5948.Metal2 vin4.$338.Metal1 1.68242e-06f
Cred_8517 VDD.$5948.Metal2 vin4.$566.Metal2 0.000286583f
Cred_8518 VDD.$5948.Metal2 vin4.$570.Metal2 0.000286583f
Cred_8519 VDD.$5948.Metal2 vin4.P30.GatPoly 0.0125885f
Cred_8520 VDD.$5948.Metal2 vout3.$1292.Metal3 0.00354817f
Cred_8521 VDD.$5948.Metal2 vout3.$1358.Metal3 0.00354817f
Cred_8522 VDD.$5948.Metal2 vout3.P10.nSD 5.58981e-05f
Cred_8523 VDD.$5948.Metal2 vout3.P10.pSD 0.00302132f
Cred_8524 VDD.$5948.Metal2 vout4.$1292.Metal3 0.00354817f
Cred_8525 VDD.$5948.Metal2 vout4.$1358.Metal3 0.00354817f
Cred_8526 VDD.$5948.Metal2 vout4.P10.nSD 5.58981e-05f
Cred_8527 VDD.$5948.Metal2 vout4.P10.pSD 0.00302132f
Cred_8528 VDD.$5984.Metal2 vin1.$353.Metal1 4.62035e-06f
Cred_8529 VDD.$5984.Metal2 vin1.$357.Metal1 7.048e-07f
Cred_8530 VDD.$5984.Metal2 vin1.$578.Metal2 0.00130382f
Cred_8531 VDD.$5984.Metal2 vin1.$582.Metal2 0.000279585f
Cred_8532 VDD.$5984.Metal2 vin1.P31.GatPoly 0.014459f
Cred_8533 VDD.$5984.Metal2 vin2.$352.Metal1 4.62035e-06f
Cred_8534 VDD.$5984.Metal2 vin2.$356.Metal1 7.048e-07f
Cred_8535 VDD.$5984.Metal2 vin2.$577.Metal2 0.00130382f
Cred_8536 VDD.$5984.Metal2 vin2.$581.Metal2 0.000279585f
Cred_8537 VDD.$5984.Metal2 vin2.P31.GatPoly 0.014459f
Cred_8538 VDD.$5984.Metal2 vout1.$1292.Metal3 0.00278894f
Cred_8539 VDD.$5984.Metal2 vout1.$1358.Metal3 0.00278894f
Cred_8540 VDD.$5984.Metal2 vout1.P10.nSD 4.39372e-05f
Cred_8541 VDD.$5984.Metal2 vout1.P10.pSD 0.00224107f
Cred_8542 VDD.$5984.Metal2 vout2.$1292.Metal3 0.00278894f
Cred_8543 VDD.$5984.Metal2 vout2.$1358.Metal3 0.00278894f
Cred_8544 VDD.$5984.Metal2 vout2.P10.nSD 4.39372e-05f
Cred_8545 VDD.$5984.Metal2 vout2.P10.pSD 0.00224107f
Cred_8546 VDD.$599.Metal1 vin1.$203.Metal1 6.26948e-08f
Cred_8547 VDD.$599.Metal1 vin1.$477.Metal2 5.4296e-07f
Cred_8548 VDD.$599.Metal1 vin1.$480.Metal2 1.01207e-06f
Cred_8549 VDD.$599.Metal1 vin1.$9.GatPoly 1.14244e-09f
Cred_8550 VDD.$599.Metal1 vin1.P20.GatPoly 0.0117572f
Cred_8551 VDD.$599.Metal1 vin2.$202.Metal1 6.26948e-08f
Cred_8552 VDD.$599.Metal1 vin2.$477.Metal2 5.4296e-07f
Cred_8553 VDD.$599.Metal1 vin2.$479.Metal2 1.01207e-06f
Cred_8554 VDD.$599.Metal1 vin2.$8.GatPoly 1.14244e-09f
Cred_8555 VDD.$599.Metal1 vin2.P20.GatPoly 0.0117572f
Cred_8556 VDD.$599.Metal1 vout1.$1226.Metal3 2.3959e-06f
Cred_8557 VDD.$599.Metal1 vout1.P0.nSD 7.13423e-08f
Cred_8558 VDD.$599.Metal1 vout1.P0.pSD 9.752e-07f
Cred_8559 VDD.$599.Metal1 vout1.P2.nSD 3.77451e-08f
Cred_8560 VDD.$599.Metal1 vout1.P2.pSD 2.06286e-07f
Cred_8561 VDD.$599.Metal1 vout2.$1226.Metal3 2.3959e-06f
Cred_8562 VDD.$599.Metal1 vout2.P0.nSD 7.13423e-08f
Cred_8563 VDD.$599.Metal1 vout2.P0.pSD 9.752e-07f
Cred_8564 VDD.$599.Metal1 vout2.P2.nSD 3.77451e-08f
Cred_8565 VDD.$599.Metal1 vout2.P2.pSD 2.06286e-07f
Cred_8566 VDD.$5996.Metal2 vin3.$353.Metal1 4.62035e-06f
Cred_8567 VDD.$5996.Metal2 vin3.$357.Metal1 7.048e-07f
Cred_8568 VDD.$5996.Metal2 vin3.$578.Metal2 0.00130382f
Cred_8569 VDD.$5996.Metal2 vin3.$582.Metal2 0.000279585f
Cred_8570 VDD.$5996.Metal2 vin3.P31.GatPoly 0.014459f
Cred_8571 VDD.$5996.Metal2 vin4.$352.Metal1 4.62035e-06f
Cred_8572 VDD.$5996.Metal2 vin4.$356.Metal1 7.048e-07f
Cred_8573 VDD.$5996.Metal2 vin4.$577.Metal2 0.00130382f
Cred_8574 VDD.$5996.Metal2 vin4.$581.Metal2 0.000279585f
Cred_8575 VDD.$5996.Metal2 vin4.P31.GatPoly 0.014459f
Cred_8576 VDD.$5996.Metal2 vout3.$1292.Metal3 0.00278894f
Cred_8577 VDD.$5996.Metal2 vout3.$1358.Metal3 0.00278894f
Cred_8578 VDD.$5996.Metal2 vout3.P10.nSD 4.39372e-05f
Cred_8579 VDD.$5996.Metal2 vout3.P10.pSD 0.00224107f
Cred_8580 VDD.$5996.Metal2 vout4.$1292.Metal3 0.00278894f
Cred_8581 VDD.$5996.Metal2 vout4.$1358.Metal3 0.00278894f
Cred_8582 VDD.$5996.Metal2 vout4.P10.nSD 4.39372e-05f
Cred_8583 VDD.$5996.Metal2 vout4.P10.pSD 0.00224107f
Cred_8584 VDD.$603.Metal1 vin3.$203.Metal1 6.26948e-08f
Cred_8585 VDD.$603.Metal1 vin3.$477.Metal2 5.4296e-07f
Cred_8586 VDD.$603.Metal1 vin3.$480.Metal2 1.01207e-06f
Cred_8587 VDD.$603.Metal1 vin3.$9.GatPoly 1.14244e-09f
Cred_8588 VDD.$603.Metal1 vin3.P20.GatPoly 0.0117572f
Cred_8589 VDD.$603.Metal1 vin4.$202.Metal1 6.26948e-08f
Cred_8590 VDD.$603.Metal1 vin4.$477.Metal2 5.4296e-07f
Cred_8591 VDD.$603.Metal1 vin4.$479.Metal2 1.01207e-06f
Cred_8592 VDD.$603.Metal1 vin4.$8.GatPoly 1.14244e-09f
Cred_8593 VDD.$603.Metal1 vin4.P20.GatPoly 0.0117572f
Cred_8594 VDD.$603.Metal1 vout3.$1226.Metal3 2.3959e-06f
Cred_8595 VDD.$603.Metal1 vout3.P0.nSD 7.13423e-08f
Cred_8596 VDD.$603.Metal1 vout3.P0.pSD 9.752e-07f
Cred_8597 VDD.$603.Metal1 vout3.P2.nSD 3.77451e-08f
Cred_8598 VDD.$603.Metal1 vout3.P2.pSD 2.06286e-07f
Cred_8599 VDD.$603.Metal1 vout4.$1226.Metal3 2.3959e-06f
Cred_8600 VDD.$603.Metal1 vout4.P0.nSD 7.13423e-08f
Cred_8601 VDD.$603.Metal1 vout4.P0.pSD 9.752e-07f
Cred_8602 VDD.$603.Metal1 vout4.P2.nSD 3.77451e-08f
Cred_8603 VDD.$603.Metal1 vout4.P2.pSD 2.06286e-07f
Cred_8604 VDD.$6032.Metal2 vin1.$107.GatPoly 0.0281905f
Cred_8605 VDD.$6032.Metal2 vin1.$115.GatPoly 0.0128345f
Cred_8606 VDD.$6032.Metal2 vin1.$123.GatPoly 0.00835516f
Cred_8607 VDD.$6032.Metal2 vin1.$353.Metal1 0.00025507f
Cred_8608 VDD.$6032.Metal2 vin1.$357.Metal1 0.0133508f
Cred_8609 VDD.$6032.Metal2 vin1.$365.Metal1 0.00927657f
Cred_8610 VDD.$6032.Metal2 vin1.$369.Metal1 0.00441895f
Cred_8611 VDD.$6032.Metal2 vin1.$578.Metal2 0.000275494f
Cred_8612 VDD.$6032.Metal2 vin1.$582.Metal2 0.0244461f
Cred_8613 VDD.$6032.Metal2 vin1.$584.Metal2 0.00217413f
Cred_8614 VDD.$6032.Metal2 vin1.$587.Metal2 0.0114889f
Cred_8615 VDD.$6032.Metal2 vin1.P30.GatPoly 0.00117687f
Cred_8616 VDD.$6032.Metal2 vin1.P31.GatPoly 0.0903905f
Cred_8617 VDD.$6032.Metal2 vin1.P32.GatPoly 0.0979028f
Cred_8618 VDD.$6032.Metal2 vin1.P33.GatPoly 0.00117687f
Cred_8619 VDD.$6032.Metal2 vin2.$106.GatPoly 0.0281905f
Cred_8620 VDD.$6032.Metal2 vin2.$114.GatPoly 0.0128345f
Cred_8621 VDD.$6032.Metal2 vin2.$122.GatPoly 0.00835516f
Cred_8622 VDD.$6032.Metal2 vin2.$352.Metal1 0.00025507f
Cred_8623 VDD.$6032.Metal2 vin2.$356.Metal1 0.0133508f
Cred_8624 VDD.$6032.Metal2 vin2.$364.Metal1 0.00927657f
Cred_8625 VDD.$6032.Metal2 vin2.$368.Metal1 0.00441895f
Cred_8626 VDD.$6032.Metal2 vin2.$577.Metal2 0.000275494f
Cred_8627 VDD.$6032.Metal2 vin2.$581.Metal2 0.0244461f
Cred_8628 VDD.$6032.Metal2 vin2.$584.Metal2 0.00217413f
Cred_8629 VDD.$6032.Metal2 vin2.$586.Metal2 0.0114889f
Cred_8630 VDD.$6032.Metal2 vin2.P30.GatPoly 0.00117687f
Cred_8631 VDD.$6032.Metal2 vin2.P31.GatPoly 0.0903905f
Cred_8632 VDD.$6032.Metal2 vin2.P32.GatPoly 0.0979028f
Cred_8633 VDD.$6032.Metal2 vin2.P33.GatPoly 0.00117687f
Cred_8634 VDD.$6032.Metal2 vout1.$1292.Metal3 0.0695177f
Cred_8635 VDD.$6032.Metal2 vout1.$1358.Metal3 0.218774f
Cred_8636 VDD.$6032.Metal2 vout1.P10.nSD 0.00109519f
Cred_8637 VDD.$6032.Metal2 vout1.P10.pSD 0.0628097f
Cred_8638 VDD.$6032.Metal2 vout1.P12.pSD 0.0556972f
Cred_8639 VDD.$6032.Metal2 vout2.$1292.Metal3 0.0697491f
Cred_8640 VDD.$6032.Metal2 vout2.$1358.Metal3 0.217916f
Cred_8641 VDD.$6032.Metal2 vout2.P10.nSD 0.00109883f
Cred_8642 VDD.$6032.Metal2 vout2.P10.pSD 0.062861f
Cred_8643 VDD.$6032.Metal2 vout2.P12.pSD 0.0555946f
Cred_8644 VDD.$6033.Metal2 vin3.$107.GatPoly 0.0281905f
Cred_8645 VDD.$6033.Metal2 vin3.$115.GatPoly 0.0128345f
Cred_8646 VDD.$6033.Metal2 vin3.$123.GatPoly 0.00835516f
Cred_8647 VDD.$6033.Metal2 vin3.$353.Metal1 0.00025507f
Cred_8648 VDD.$6033.Metal2 vin3.$357.Metal1 0.0133508f
Cred_8649 VDD.$6033.Metal2 vin3.$365.Metal1 0.00927657f
Cred_8650 VDD.$6033.Metal2 vin3.$369.Metal1 0.00441895f
Cred_8651 VDD.$6033.Metal2 vin3.$578.Metal2 0.000275494f
Cred_8652 VDD.$6033.Metal2 vin3.$582.Metal2 0.0244461f
Cred_8653 VDD.$6033.Metal2 vin3.$584.Metal2 0.00217413f
Cred_8654 VDD.$6033.Metal2 vin3.$587.Metal2 0.0114889f
Cred_8655 VDD.$6033.Metal2 vin3.P30.GatPoly 0.00117687f
Cred_8656 VDD.$6033.Metal2 vin3.P31.GatPoly 0.0903905f
Cred_8657 VDD.$6033.Metal2 vin3.P32.GatPoly 0.0979028f
Cred_8658 VDD.$6033.Metal2 vin3.P33.GatPoly 0.00117687f
Cred_8659 VDD.$6033.Metal2 vin4.$106.GatPoly 0.0281905f
Cred_8660 VDD.$6033.Metal2 vin4.$114.GatPoly 0.0128345f
Cred_8661 VDD.$6033.Metal2 vin4.$122.GatPoly 0.00835516f
Cred_8662 VDD.$6033.Metal2 vin4.$352.Metal1 0.00025507f
Cred_8663 VDD.$6033.Metal2 vin4.$356.Metal1 0.0133508f
Cred_8664 VDD.$6033.Metal2 vin4.$364.Metal1 0.00927657f
Cred_8665 VDD.$6033.Metal2 vin4.$368.Metal1 0.00441895f
Cred_8666 VDD.$6033.Metal2 vin4.$577.Metal2 0.000275494f
Cred_8667 VDD.$6033.Metal2 vin4.$581.Metal2 0.0244461f
Cred_8668 VDD.$6033.Metal2 vin4.$584.Metal2 0.00217413f
Cred_8669 VDD.$6033.Metal2 vin4.$586.Metal2 0.0114889f
Cred_8670 VDD.$6033.Metal2 vin4.P30.GatPoly 0.00117687f
Cred_8671 VDD.$6033.Metal2 vin4.P31.GatPoly 0.0903905f
Cred_8672 VDD.$6033.Metal2 vin4.P32.GatPoly 0.0979028f
Cred_8673 VDD.$6033.Metal2 vin4.P33.GatPoly 0.00117687f
Cred_8674 VDD.$6033.Metal2 vout3.$1292.Metal3 0.0695177f
Cred_8675 VDD.$6033.Metal2 vout3.$1358.Metal3 0.218774f
Cred_8676 VDD.$6033.Metal2 vout3.P10.nSD 0.00109519f
Cred_8677 VDD.$6033.Metal2 vout3.P10.pSD 0.0628097f
Cred_8678 VDD.$6033.Metal2 vout3.P12.pSD 0.0556972f
Cred_8679 VDD.$6033.Metal2 vout4.$1292.Metal3 0.0697491f
Cred_8680 VDD.$6033.Metal2 vout4.$1358.Metal3 0.217916f
Cred_8681 VDD.$6033.Metal2 vout4.P10.nSD 0.00109883f
Cred_8682 VDD.$6033.Metal2 vout4.P10.pSD 0.062861f
Cred_8683 VDD.$6033.Metal2 vout4.P12.pSD 0.0555946f
Cred_8684 VDD.$6090.Metal2 vin1.$353.Metal1 4.62035e-06f
Cred_8685 VDD.$6090.Metal2 vin1.$357.Metal1 7.048e-07f
Cred_8686 VDD.$6090.Metal2 vin1.$578.Metal2 0.000279585f
Cred_8687 VDD.$6090.Metal2 vin1.$582.Metal2 0.000279585f
Cred_8688 VDD.$6090.Metal2 vin1.P31.GatPoly 0.00507882f
Cred_8689 VDD.$6090.Metal2 vin2.$352.Metal1 4.62035e-06f
Cred_8690 VDD.$6090.Metal2 vin2.$356.Metal1 7.048e-07f
Cred_8691 VDD.$6090.Metal2 vin2.$577.Metal2 0.000279585f
Cred_8692 VDD.$6090.Metal2 vin2.$581.Metal2 0.000279585f
Cred_8693 VDD.$6090.Metal2 vin2.P31.GatPoly 0.00507882f
Cred_8694 VDD.$6102.Metal2 vin3.$353.Metal1 4.62035e-06f
Cred_8695 VDD.$6102.Metal2 vin3.$357.Metal1 7.048e-07f
Cred_8696 VDD.$6102.Metal2 vin3.$578.Metal2 0.000279585f
Cred_8697 VDD.$6102.Metal2 vin3.$582.Metal2 0.000279585f
Cred_8698 VDD.$6102.Metal2 vin3.P31.GatPoly 0.00507882f
Cred_8699 VDD.$6102.Metal2 vin4.$352.Metal1 4.62035e-06f
Cred_8700 VDD.$6102.Metal2 vin4.$356.Metal1 7.048e-07f
Cred_8701 VDD.$6102.Metal2 vin4.$577.Metal2 0.000279585f
Cred_8702 VDD.$6102.Metal2 vin4.$581.Metal2 0.000279585f
Cred_8703 VDD.$6102.Metal2 vin4.P31.GatPoly 0.00507882f
Cred_8704 VDD.$619.Metal1 vin1.$203.Metal1 1.07835e-07f
Cred_8705 VDD.$619.Metal1 vin1.$477.Metal2 9.33892e-07f
Cred_8706 VDD.$619.Metal1 vin1.$480.Metal2 1.74077e-06f
Cred_8707 VDD.$619.Metal1 vin1.$9.GatPoly 1.96499e-09f
Cred_8708 VDD.$619.Metal1 vin1.P20.GatPoly 0.0100951f
Cred_8709 VDD.$619.Metal1 vin2.$202.Metal1 1.07835e-07f
Cred_8710 VDD.$619.Metal1 vin2.$477.Metal2 9.33892e-07f
Cred_8711 VDD.$619.Metal1 vin2.$479.Metal2 1.74077e-06f
Cred_8712 VDD.$619.Metal1 vin2.$8.GatPoly 1.96499e-09f
Cred_8713 VDD.$619.Metal1 vin2.P20.GatPoly 0.0100951f
Cred_8714 VDD.$619.Metal1 vout1.$1226.Metal3 0.00559602f
Cred_8715 VDD.$619.Metal1 vout1.P0.nSD 0.000166632f
Cred_8716 VDD.$619.Metal1 vout1.P0.pSD 0.0050328f
Cred_8717 VDD.$619.Metal1 vout1.P2.nSD 8.816e-05f
Cred_8718 VDD.$619.Metal1 vout1.P2.pSD 0.000481814f
Cred_8719 VDD.$619.Metal1 vout2.$1226.Metal3 0.00559602f
Cred_8720 VDD.$619.Metal1 vout2.P0.nSD 0.000166632f
Cred_8721 VDD.$619.Metal1 vout2.P0.pSD 0.0050328f
Cred_8722 VDD.$619.Metal1 vout2.P2.nSD 8.816e-05f
Cred_8723 VDD.$619.Metal1 vout2.P2.pSD 0.000481814f
Cred_8724 VDD.$6194.Metal2 vin1.$365.Metal1 2.74714e-06f
Cred_8725 VDD.$6194.Metal2 vin1.$369.Metal1 8.24142e-06f
Cred_8726 VDD.$6194.Metal2 vin1.$587.Metal2 0.000577756f
Cred_8727 VDD.$6194.Metal2 vin1.$591.Metal2 0.000577756f
Cred_8728 VDD.$6194.Metal2 vin1.P32.GatPoly 0.0149622f
Cred_8729 VDD.$6194.Metal2 vin2.$364.Metal1 2.74714e-06f
Cred_8730 VDD.$6194.Metal2 vin2.$368.Metal1 8.24142e-06f
Cred_8731 VDD.$6194.Metal2 vin2.$586.Metal2 0.000577756f
Cred_8732 VDD.$6194.Metal2 vin2.$590.Metal2 0.000577756f
Cred_8733 VDD.$6194.Metal2 vin2.P32.GatPoly 0.0149622f
Cred_8734 VDD.$6194.Metal2 vout1.$1358.Metal3 0.00273266f
Cred_8735 VDD.$6194.Metal2 vout1.P12.pSD 0.000999166f
Cred_8736 VDD.$6194.Metal2 vout2.$1358.Metal3 0.00273266f
Cred_8737 VDD.$6194.Metal2 vout2.P12.pSD 0.000999166f
Cred_8738 VDD.$6206.Metal2 vin3.$365.Metal1 2.74714e-06f
Cred_8739 VDD.$6206.Metal2 vin3.$369.Metal1 8.24142e-06f
Cred_8740 VDD.$6206.Metal2 vin3.$587.Metal2 0.000577756f
Cred_8741 VDD.$6206.Metal2 vin3.$591.Metal2 0.000577756f
Cred_8742 VDD.$6206.Metal2 vin3.P32.GatPoly 0.0149622f
Cred_8743 VDD.$6206.Metal2 vin4.$364.Metal1 2.74714e-06f
Cred_8744 VDD.$6206.Metal2 vin4.$368.Metal1 8.24142e-06f
Cred_8745 VDD.$6206.Metal2 vin4.$586.Metal2 0.000577756f
Cred_8746 VDD.$6206.Metal2 vin4.$590.Metal2 0.000577756f
Cred_8747 VDD.$6206.Metal2 vin4.P32.GatPoly 0.0149622f
Cred_8748 VDD.$6206.Metal2 vout3.$1358.Metal3 0.00273266f
Cred_8749 VDD.$6206.Metal2 vout3.P12.pSD 0.000999166f
Cred_8750 VDD.$6206.Metal2 vout4.$1358.Metal3 0.00273266f
Cred_8751 VDD.$6206.Metal2 vout4.P12.pSD 0.000999166f
Cred_8752 VDD.$623.Metal1 vin3.$203.Metal1 1.07835e-07f
Cred_8753 VDD.$623.Metal1 vin3.$477.Metal2 9.33892e-07f
Cred_8754 VDD.$623.Metal1 vin3.$480.Metal2 1.74077e-06f
Cred_8755 VDD.$623.Metal1 vin3.$9.GatPoly 1.96499e-09f
Cred_8756 VDD.$623.Metal1 vin3.P20.GatPoly 0.0100951f
Cred_8757 VDD.$623.Metal1 vin4.$202.Metal1 1.07835e-07f
Cred_8758 VDD.$623.Metal1 vin4.$477.Metal2 9.33892e-07f
Cred_8759 VDD.$623.Metal1 vin4.$479.Metal2 1.74077e-06f
Cred_8760 VDD.$623.Metal1 vin4.$8.GatPoly 1.96499e-09f
Cred_8761 VDD.$623.Metal1 vin4.P20.GatPoly 0.0100951f
Cred_8762 VDD.$623.Metal1 vout3.$1226.Metal3 0.00559602f
Cred_8763 VDD.$623.Metal1 vout3.P0.nSD 0.000166632f
Cred_8764 VDD.$623.Metal1 vout3.P0.pSD 0.0050328f
Cred_8765 VDD.$623.Metal1 vout3.P2.nSD 8.816e-05f
Cred_8766 VDD.$623.Metal1 vout3.P2.pSD 0.000481814f
Cred_8767 VDD.$623.Metal1 vout4.$1226.Metal3 0.00559602f
Cred_8768 VDD.$623.Metal1 vout4.P0.nSD 0.000166632f
Cred_8769 VDD.$623.Metal1 vout4.P0.pSD 0.0050328f
Cred_8770 VDD.$623.Metal1 vout4.P2.nSD 8.816e-05f
Cred_8771 VDD.$623.Metal1 vout4.P2.pSD 0.000481814f
Cred_8772 VDD.$6242.Metal2 vin1.$379.Metal1 4.53586e-06f
Cred_8773 VDD.$6242.Metal2 vin1.$383.Metal1 4.12394e-06f
Cred_8774 VDD.$6242.Metal2 vin1.$387.Metal1 1.99951e-06f
Cred_8775 VDD.$6242.Metal2 vin1.$596.Metal2 0.000377476f
Cred_8776 VDD.$6242.Metal2 vin1.$603.Metal2 0.000190479f
Cred_8777 VDD.$6242.Metal2 vin1.P32.GatPoly 0.00210314f
Cred_8778 VDD.$6242.Metal2 vin1.P33.GatPoly 0.00700674f
Cred_8779 VDD.$6242.Metal2 vin2.$378.Metal1 4.53586e-06f
Cred_8780 VDD.$6242.Metal2 vin2.$382.Metal1 4.12394e-06f
Cred_8781 VDD.$6242.Metal2 vin2.$386.Metal1 1.99951e-06f
Cred_8782 VDD.$6242.Metal2 vin2.$595.Metal2 0.000377476f
Cred_8783 VDD.$6242.Metal2 vin2.$601.Metal2 0.000190479f
Cred_8784 VDD.$6242.Metal2 vin2.P32.GatPoly 0.00210314f
Cred_8785 VDD.$6242.Metal2 vin2.P33.GatPoly 0.00700674f
Cred_8786 VDD.$6242.Metal2 vout1.$1358.Metal3 0.00913376f
Cred_8787 VDD.$6242.Metal2 vout1.P12.pSD 0.00365956f
Cred_8788 VDD.$6242.Metal2 vout2.$1358.Metal3 0.00913376f
Cred_8789 VDD.$6242.Metal2 vout2.P12.pSD 0.00365956f
Cred_8790 VDD.$6254.Metal2 vin3.$379.Metal1 4.53586e-06f
Cred_8791 VDD.$6254.Metal2 vin3.$383.Metal1 4.12394e-06f
Cred_8792 VDD.$6254.Metal2 vin3.$387.Metal1 1.99951e-06f
Cred_8793 VDD.$6254.Metal2 vin3.$596.Metal2 0.000377476f
Cred_8794 VDD.$6254.Metal2 vin3.$603.Metal2 0.000190479f
Cred_8795 VDD.$6254.Metal2 vin3.P32.GatPoly 0.00210314f
Cred_8796 VDD.$6254.Metal2 vin3.P33.GatPoly 0.00700674f
Cred_8797 VDD.$6254.Metal2 vin4.$378.Metal1 4.53586e-06f
Cred_8798 VDD.$6254.Metal2 vin4.$382.Metal1 4.12394e-06f
Cred_8799 VDD.$6254.Metal2 vin4.$386.Metal1 1.99951e-06f
Cred_8800 VDD.$6254.Metal2 vin4.$595.Metal2 0.000377476f
Cred_8801 VDD.$6254.Metal2 vin4.$601.Metal2 0.000190479f
Cred_8802 VDD.$6254.Metal2 vin4.P32.GatPoly 0.00210314f
Cred_8803 VDD.$6254.Metal2 vin4.P33.GatPoly 0.00700674f
Cred_8804 VDD.$6254.Metal2 vout3.$1358.Metal3 0.00913376f
Cred_8805 VDD.$6254.Metal2 vout3.P12.pSD 0.00365956f
Cred_8806 VDD.$6254.Metal2 vout4.$1358.Metal3 0.00913376f
Cred_8807 VDD.$6254.Metal2 vout4.P12.pSD 0.00365956f
Cred_8808 VDD.$6290.Metal2 vin1.$127.GatPoly 0.00103198f
Cred_8809 VDD.$6290.Metal2 vin1.$135.GatPoly 0.000216499f
Cred_8810 VDD.$6290.Metal2 vin1.$137.GatPoly 0.00100733f
Cred_8811 VDD.$6290.Metal2 vin1.$379.Metal1 5.52562e-06f
Cred_8812 VDD.$6290.Metal2 vin1.$383.Metal1 1.27482e-05f
Cred_8813 VDD.$6290.Metal2 vin1.$387.Metal1 0.000466315f
Cred_8814 VDD.$6290.Metal2 vin1.$393.Metal1 0.000245873f
Cred_8815 VDD.$6290.Metal2 vin1.$593.Metal2 2.69686e-05f
Cred_8816 VDD.$6290.Metal2 vin1.$596.Metal2 0.000459843f
Cred_8817 VDD.$6290.Metal2 vin1.$599.Metal2 4.61591e-07f
Cred_8818 VDD.$6290.Metal2 vin1.$603.Metal2 0.00134182f
Cred_8819 VDD.$6290.Metal2 vin1.$604.Metal2 1.21552e-05f
Cred_8820 VDD.$6290.Metal2 vin1.$609.Metal2 0.000116722f
Cred_8821 VDD.$6290.Metal2 vin1.$613.Metal2 2.69686e-05f
Cred_8822 VDD.$6290.Metal2 vin1.P32.GatPoly 4.30189e-05f
Cred_8823 VDD.$6290.Metal2 vin1.P33.GatPoly 0.0159793f
Cred_8824 VDD.$6290.Metal2 vin1.P34.GatPoly 0.00329601f
Cred_8825 VDD.$6290.Metal2 vin1.P35.GatPoly 4.30189e-05f
Cred_8826 VDD.$6290.Metal2 vin2.$126.GatPoly 0.00103198f
Cred_8827 VDD.$6290.Metal2 vin2.$134.GatPoly 0.000216499f
Cred_8828 VDD.$6290.Metal2 vin2.$136.GatPoly 0.00100733f
Cred_8829 VDD.$6290.Metal2 vin2.$378.Metal1 5.52562e-06f
Cred_8830 VDD.$6290.Metal2 vin2.$382.Metal1 1.27482e-05f
Cred_8831 VDD.$6290.Metal2 vin2.$386.Metal1 0.000466315f
Cred_8832 VDD.$6290.Metal2 vin2.$392.Metal1 0.000245873f
Cred_8833 VDD.$6290.Metal2 vin2.$593.Metal2 2.69686e-05f
Cred_8834 VDD.$6290.Metal2 vin2.$595.Metal2 0.000459843f
Cred_8835 VDD.$6290.Metal2 vin2.$600.Metal2 4.61591e-07f
Cred_8836 VDD.$6290.Metal2 vin2.$601.Metal2 0.00134182f
Cred_8837 VDD.$6290.Metal2 vin2.$605.Metal2 1.21552e-05f
Cred_8838 VDD.$6290.Metal2 vin2.$608.Metal2 0.000116722f
Cred_8839 VDD.$6290.Metal2 vin2.$613.Metal2 2.69686e-05f
Cred_8840 VDD.$6290.Metal2 vin2.P32.GatPoly 4.30189e-05f
Cred_8841 VDD.$6290.Metal2 vin2.P33.GatPoly 0.0159793f
Cred_8842 VDD.$6290.Metal2 vin2.P34.GatPoly 0.00329601f
Cred_8843 VDD.$6290.Metal2 vin2.P35.GatPoly 4.30189e-05f
Cred_8844 VDD.$6290.Metal2 vout1.$1358.Metal3 0.00867216f
Cred_8845 VDD.$6290.Metal2 vout1.$1424.Metal3 0.0025958f
Cred_8846 VDD.$6290.Metal2 vout1.P12.pSD 0.00219891f
Cred_8847 VDD.$6290.Metal2 vout1.P14.nSD 4.08945e-05f
Cred_8848 VDD.$6290.Metal2 vout1.P14.pSD 0.00225942f
Cred_8849 VDD.$6290.Metal2 vout2.$1358.Metal3 0.00869644f
Cred_8850 VDD.$6290.Metal2 vout2.$1424.Metal3 0.00258028f
Cred_8851 VDD.$6290.Metal2 vout2.P12.pSD 0.00220267f
Cred_8852 VDD.$6290.Metal2 vout2.P14.nSD 4.06499e-05f
Cred_8853 VDD.$6290.Metal2 vout2.P14.pSD 0.00225551f
Cred_8854 VDD.$6302.Metal2 vin3.$127.GatPoly 0.00103198f
Cred_8855 VDD.$6302.Metal2 vin3.$135.GatPoly 0.000216499f
Cred_8856 VDD.$6302.Metal2 vin3.$137.GatPoly 0.00100733f
Cred_8857 VDD.$6302.Metal2 vin3.$379.Metal1 5.52562e-06f
Cred_8858 VDD.$6302.Metal2 vin3.$383.Metal1 1.27482e-05f
Cred_8859 VDD.$6302.Metal2 vin3.$387.Metal1 0.000466315f
Cred_8860 VDD.$6302.Metal2 vin3.$393.Metal1 0.000245873f
Cred_8861 VDD.$6302.Metal2 vin3.$593.Metal2 2.69686e-05f
Cred_8862 VDD.$6302.Metal2 vin3.$596.Metal2 0.000459843f
Cred_8863 VDD.$6302.Metal2 vin3.$599.Metal2 4.61591e-07f
Cred_8864 VDD.$6302.Metal2 vin3.$603.Metal2 0.00134182f
Cred_8865 VDD.$6302.Metal2 vin3.$604.Metal2 1.21552e-05f
Cred_8866 VDD.$6302.Metal2 vin3.$609.Metal2 0.000116722f
Cred_8867 VDD.$6302.Metal2 vin3.$613.Metal2 2.69686e-05f
Cred_8868 VDD.$6302.Metal2 vin3.P32.GatPoly 4.30189e-05f
Cred_8869 VDD.$6302.Metal2 vin3.P33.GatPoly 0.0159793f
Cred_8870 VDD.$6302.Metal2 vin3.P34.GatPoly 0.00329601f
Cred_8871 VDD.$6302.Metal2 vin3.P35.GatPoly 4.30189e-05f
Cred_8872 VDD.$6302.Metal2 vin4.$126.GatPoly 0.00103198f
Cred_8873 VDD.$6302.Metal2 vin4.$134.GatPoly 0.000216499f
Cred_8874 VDD.$6302.Metal2 vin4.$136.GatPoly 0.00100733f
Cred_8875 VDD.$6302.Metal2 vin4.$378.Metal1 5.52562e-06f
Cred_8876 VDD.$6302.Metal2 vin4.$382.Metal1 1.27482e-05f
Cred_8877 VDD.$6302.Metal2 vin4.$386.Metal1 0.000466315f
Cred_8878 VDD.$6302.Metal2 vin4.$392.Metal1 0.000245873f
Cred_8879 VDD.$6302.Metal2 vin4.$593.Metal2 2.69686e-05f
Cred_8880 VDD.$6302.Metal2 vin4.$595.Metal2 0.000459843f
Cred_8881 VDD.$6302.Metal2 vin4.$600.Metal2 4.61591e-07f
Cred_8882 VDD.$6302.Metal2 vin4.$601.Metal2 0.00134182f
Cred_8883 VDD.$6302.Metal2 vin4.$605.Metal2 1.21552e-05f
Cred_8884 VDD.$6302.Metal2 vin4.$608.Metal2 0.000116722f
Cred_8885 VDD.$6302.Metal2 vin4.$613.Metal2 2.69686e-05f
Cred_8886 VDD.$6302.Metal2 vin4.P32.GatPoly 4.30189e-05f
Cred_8887 VDD.$6302.Metal2 vin4.P33.GatPoly 0.0159793f
Cred_8888 VDD.$6302.Metal2 vin4.P34.GatPoly 0.00329601f
Cred_8889 VDD.$6302.Metal2 vin4.P35.GatPoly 4.30189e-05f
Cred_8890 VDD.$6302.Metal2 vout3.$1358.Metal3 0.00867216f
Cred_8891 VDD.$6302.Metal2 vout3.$1424.Metal3 0.0025958f
Cred_8892 VDD.$6302.Metal2 vout3.P12.pSD 0.00219891f
Cred_8893 VDD.$6302.Metal2 vout3.P14.nSD 4.08945e-05f
Cred_8894 VDD.$6302.Metal2 vout3.P14.pSD 0.00225942f
Cred_8895 VDD.$6302.Metal2 vout4.$1358.Metal3 0.00869644f
Cred_8896 VDD.$6302.Metal2 vout4.$1424.Metal3 0.00258028f
Cred_8897 VDD.$6302.Metal2 vout4.P12.pSD 0.00220267f
Cred_8898 VDD.$6302.Metal2 vout4.P14.nSD 4.06499e-05f
Cred_8899 VDD.$6302.Metal2 vout4.P14.pSD 0.00225551f
Cred_8900 VDD.$6372.Metal2 vin1.$127.GatPoly 0.0271756f
Cred_8901 VDD.$6372.Metal2 vin1.$135.GatPoly 0.00570113f
Cred_8902 VDD.$6372.Metal2 vin1.$137.GatPoly 0.0265263f
Cred_8903 VDD.$6372.Metal2 vin1.$379.Metal1 2.60636e-05f
Cred_8904 VDD.$6372.Metal2 vin1.$383.Metal1 0.000227105f
Cred_8905 VDD.$6372.Metal2 vin1.$387.Metal1 0.012227f
Cred_8906 VDD.$6372.Metal2 vin1.$393.Metal1 0.00647465f
Cred_8907 VDD.$6372.Metal2 vin1.$593.Metal2 0.000710174f
Cred_8908 VDD.$6372.Metal2 vin1.$596.Metal2 0.00216902f
Cred_8909 VDD.$6372.Metal2 vin1.$599.Metal2 1.21552e-05f
Cred_8910 VDD.$6372.Metal2 vin1.$603.Metal2 0.0303186f
Cred_8911 VDD.$6372.Metal2 vin1.$604.Metal2 0.000320088f
Cred_8912 VDD.$6372.Metal2 vin1.$609.Metal2 0.00307369f
Cred_8913 VDD.$6372.Metal2 vin1.$613.Metal2 0.000710174f
Cred_8914 VDD.$6372.Metal2 vin1.P32.GatPoly 0.00113283f
Cred_8915 VDD.$6372.Metal2 vin1.P33.GatPoly 0.0869309f
Cred_8916 VDD.$6372.Metal2 vin1.P34.GatPoly 0.090859f
Cred_8917 VDD.$6372.Metal2 vin1.P35.GatPoly 0.00113283f
Cred_8918 VDD.$6372.Metal2 vin2.$126.GatPoly 0.0271756f
Cred_8919 VDD.$6372.Metal2 vin2.$134.GatPoly 0.00570113f
Cred_8920 VDD.$6372.Metal2 vin2.$136.GatPoly 0.0265263f
Cred_8921 VDD.$6372.Metal2 vin2.$378.Metal1 2.60636e-05f
Cred_8922 VDD.$6372.Metal2 vin2.$382.Metal1 0.000227105f
Cred_8923 VDD.$6372.Metal2 vin2.$386.Metal1 0.012227f
Cred_8924 VDD.$6372.Metal2 vin2.$392.Metal1 0.00647465f
Cred_8925 VDD.$6372.Metal2 vin2.$593.Metal2 0.000710174f
Cred_8926 VDD.$6372.Metal2 vin2.$595.Metal2 0.00216902f
Cred_8927 VDD.$6372.Metal2 vin2.$600.Metal2 1.21552e-05f
Cred_8928 VDD.$6372.Metal2 vin2.$601.Metal2 0.0303186f
Cred_8929 VDD.$6372.Metal2 vin2.$605.Metal2 0.000320088f
Cred_8930 VDD.$6372.Metal2 vin2.$608.Metal2 0.00307369f
Cred_8931 VDD.$6372.Metal2 vin2.$613.Metal2 0.000710174f
Cred_8932 VDD.$6372.Metal2 vin2.P32.GatPoly 0.00113283f
Cred_8933 VDD.$6372.Metal2 vin2.P33.GatPoly 0.0869309f
Cred_8934 VDD.$6372.Metal2 vin2.P34.GatPoly 0.090859f
Cred_8935 VDD.$6372.Metal2 vin2.P35.GatPoly 0.00113283f
Cred_8936 VDD.$6372.Metal2 vout1.$1358.Metal3 0.208953f
Cred_8937 VDD.$6372.Metal2 vout1.$1424.Metal3 0.0683562f
Cred_8938 VDD.$6372.Metal2 vout1.P12.pSD 0.0547497f
Cred_8939 VDD.$6372.Metal2 vout1.P14.nSD 0.00107689f
Cred_8940 VDD.$6372.Metal2 vout1.P14.pSD 0.0594979f
Cred_8941 VDD.$6372.Metal2 vout2.$1358.Metal3 0.209592f
Cred_8942 VDD.$6372.Metal2 vout2.$1424.Metal3 0.0679474f
Cred_8943 VDD.$6372.Metal2 vout2.P12.pSD 0.0548485f
Cred_8944 VDD.$6372.Metal2 vout2.P14.nSD 0.00107045f
Cred_8945 VDD.$6372.Metal2 vout2.P14.pSD 0.059395f
Cred_8946 VDD.$6384.Metal2 vin3.$127.GatPoly 0.0271756f
Cred_8947 VDD.$6384.Metal2 vin3.$135.GatPoly 0.00570113f
Cred_8948 VDD.$6384.Metal2 vin3.$137.GatPoly 0.0265263f
Cred_8949 VDD.$6384.Metal2 vin3.$379.Metal1 2.60636e-05f
Cred_8950 VDD.$6384.Metal2 vin3.$383.Metal1 0.000227105f
Cred_8951 VDD.$6384.Metal2 vin3.$387.Metal1 0.012227f
Cred_8952 VDD.$6384.Metal2 vin3.$393.Metal1 0.00647465f
Cred_8953 VDD.$6384.Metal2 vin3.$593.Metal2 0.000710174f
Cred_8954 VDD.$6384.Metal2 vin3.$596.Metal2 0.00216902f
Cred_8955 VDD.$6384.Metal2 vin3.$599.Metal2 1.21552e-05f
Cred_8956 VDD.$6384.Metal2 vin3.$603.Metal2 0.0303186f
Cred_8957 VDD.$6384.Metal2 vin3.$604.Metal2 0.000320088f
Cred_8958 VDD.$6384.Metal2 vin3.$609.Metal2 0.00307369f
Cred_8959 VDD.$6384.Metal2 vin3.$613.Metal2 0.000710174f
Cred_8960 VDD.$6384.Metal2 vin3.P32.GatPoly 0.00113283f
Cred_8961 VDD.$6384.Metal2 vin3.P33.GatPoly 0.0869309f
Cred_8962 VDD.$6384.Metal2 vin3.P34.GatPoly 0.090859f
Cred_8963 VDD.$6384.Metal2 vin3.P35.GatPoly 0.00113283f
Cred_8964 VDD.$6384.Metal2 vin4.$126.GatPoly 0.0271756f
Cred_8965 VDD.$6384.Metal2 vin4.$134.GatPoly 0.00570113f
Cred_8966 VDD.$6384.Metal2 vin4.$136.GatPoly 0.0265263f
Cred_8967 VDD.$6384.Metal2 vin4.$378.Metal1 2.60636e-05f
Cred_8968 VDD.$6384.Metal2 vin4.$382.Metal1 0.000227105f
Cred_8969 VDD.$6384.Metal2 vin4.$386.Metal1 0.012227f
Cred_8970 VDD.$6384.Metal2 vin4.$392.Metal1 0.00647465f
Cred_8971 VDD.$6384.Metal2 vin4.$593.Metal2 0.000710174f
Cred_8972 VDD.$6384.Metal2 vin4.$595.Metal2 0.00216902f
Cred_8973 VDD.$6384.Metal2 vin4.$600.Metal2 1.21552e-05f
Cred_8974 VDD.$6384.Metal2 vin4.$601.Metal2 0.0303186f
Cred_8975 VDD.$6384.Metal2 vin4.$605.Metal2 0.000320088f
Cred_8976 VDD.$6384.Metal2 vin4.$608.Metal2 0.00307369f
Cred_8977 VDD.$6384.Metal2 vin4.$613.Metal2 0.000710174f
Cred_8978 VDD.$6384.Metal2 vin4.P32.GatPoly 0.00113283f
Cred_8979 VDD.$6384.Metal2 vin4.P33.GatPoly 0.0869309f
Cred_8980 VDD.$6384.Metal2 vin4.P34.GatPoly 0.090859f
Cred_8981 VDD.$6384.Metal2 vin4.P35.GatPoly 0.00113283f
Cred_8982 VDD.$6384.Metal2 vout3.$1358.Metal3 0.208953f
Cred_8983 VDD.$6384.Metal2 vout3.$1424.Metal3 0.0683562f
Cred_8984 VDD.$6384.Metal2 vout3.P12.pSD 0.0547497f
Cred_8985 VDD.$6384.Metal2 vout3.P14.nSD 0.00107689f
Cred_8986 VDD.$6384.Metal2 vout3.P14.pSD 0.0594979f
Cred_8987 VDD.$6384.Metal2 vout4.$1358.Metal3 0.209592f
Cred_8988 VDD.$6384.Metal2 vout4.$1424.Metal3 0.0679474f
Cred_8989 VDD.$6384.Metal2 vout4.P12.pSD 0.0548485f
Cred_8990 VDD.$6384.Metal2 vout4.P14.nSD 0.00107045f
Cred_8991 VDD.$6384.Metal2 vout4.P14.pSD 0.059395f
Cred_8992 VDD.$647.Metal1 vin1.P20.GatPoly 0.000470129f
Cred_8993 VDD.$647.Metal1 vin1.P21.GatPoly 0.0086769f
Cred_8994 VDD.$647.Metal1 vin2.P20.GatPoly 0.000470129f
Cred_8995 VDD.$647.Metal1 vin2.P21.GatPoly 0.0086769f
Cred_8996 VDD.$647.Metal1 vout1.$1226.Metal3 0.0060509f
Cred_8997 VDD.$647.Metal1 vout1.P0.nSD 0.000180177f
Cred_8998 VDD.$647.Metal1 vout1.P0.pSD 0.00574479f
Cred_8999 VDD.$647.Metal1 vout1.P2.nSD 9.53262e-05f
Cred_9000 VDD.$647.Metal1 vout1.P2.pSD 0.00052098f
Cred_9001 VDD.$647.Metal1 vout2.$1226.Metal3 0.0060509f
Cred_9002 VDD.$647.Metal1 vout2.P0.nSD 0.000180177f
Cred_9003 VDD.$647.Metal1 vout2.P0.pSD 0.00574479f
Cred_9004 VDD.$647.Metal1 vout2.P2.nSD 9.53262e-05f
Cred_9005 VDD.$647.Metal1 vout2.P2.pSD 0.00052098f
Cred_9006 VDD.$6476.Metal2 vin1.$609.Metal2 0.0011665f
Cred_9007 VDD.$6476.Metal2 vin1.P34.GatPoly 0.0151374f
Cred_9008 VDD.$6476.Metal2 vin2.$608.Metal2 0.0011665f
Cred_9009 VDD.$6476.Metal2 vin2.P34.GatPoly 0.0151374f
Cred_9010 VDD.$6476.Metal2 vout1.$1358.Metal3 0.00224083f
Cred_9011 VDD.$6476.Metal2 vout1.$1424.Metal3 0.00224083f
Cred_9012 VDD.$6476.Metal2 vout1.P14.nSD 3.53022e-05f
Cred_9013 VDD.$6476.Metal2 vout1.P14.pSD 0.0017771f
Cred_9014 VDD.$6476.Metal2 vout2.$1358.Metal3 0.00224083f
Cred_9015 VDD.$6476.Metal2 vout2.$1424.Metal3 0.00224083f
Cred_9016 VDD.$6476.Metal2 vout2.P14.nSD 3.53022e-05f
Cred_9017 VDD.$6476.Metal2 vout2.P14.pSD 0.0017771f
Cred_9018 VDD.$6488.Metal2 vin3.$609.Metal2 0.0011665f
Cred_9019 VDD.$6488.Metal2 vin3.P34.GatPoly 0.0151374f
Cred_9020 VDD.$6488.Metal2 vin4.$608.Metal2 0.0011665f
Cred_9021 VDD.$6488.Metal2 vin4.P34.GatPoly 0.0151374f
Cred_9022 VDD.$6488.Metal2 vout3.$1358.Metal3 0.00224083f
Cred_9023 VDD.$6488.Metal2 vout3.$1424.Metal3 0.00224083f
Cred_9024 VDD.$6488.Metal2 vout3.P14.nSD 3.53022e-05f
Cred_9025 VDD.$6488.Metal2 vout3.P14.pSD 0.0017771f
Cred_9026 VDD.$6488.Metal2 vout4.$1358.Metal3 0.00224083f
Cred_9027 VDD.$6488.Metal2 vout4.$1424.Metal3 0.00224083f
Cred_9028 VDD.$6488.Metal2 vout4.P14.nSD 3.53022e-05f
Cred_9029 VDD.$6488.Metal2 vout4.P14.pSD 0.0017771f
Cred_9030 VDD.$6524.Metal2 vin1.$409.Metal1 1.0427e-06f
Cred_9031 VDD.$6524.Metal2 vin1.$413.Metal1 4.41141e-06f
Cred_9032 VDD.$6524.Metal2 vin1.$616.Metal2 0.00028658f
Cred_9033 VDD.$6524.Metal2 vin1.$620.Metal2 0.00028658f
Cred_9034 VDD.$6524.Metal2 vin1.P34.GatPoly 0.00050875f
Cred_9035 VDD.$6524.Metal2 vin1.P35.GatPoly 0.0103051f
Cred_9036 VDD.$6524.Metal2 vin2.$408.Metal1 1.0427e-06f
Cred_9037 VDD.$6524.Metal2 vin2.$412.Metal1 4.41141e-06f
Cred_9038 VDD.$6524.Metal2 vin2.$615.Metal2 0.00028658f
Cred_9039 VDD.$6524.Metal2 vin2.$619.Metal2 0.00028658f
Cred_9040 VDD.$6524.Metal2 vin2.P34.GatPoly 0.00050875f
Cred_9041 VDD.$6524.Metal2 vin2.P35.GatPoly 0.0103051f
Cred_9042 VDD.$6524.Metal2 vout1.$1358.Metal3 0.0039548f
Cred_9043 VDD.$6524.Metal2 vout1.$1424.Metal3 0.0039548f
Cred_9044 VDD.$6524.Metal2 vout1.P14.nSD 6.23042e-05f
Cred_9045 VDD.$6524.Metal2 vout1.P14.pSD 0.00350401f
Cred_9046 VDD.$6524.Metal2 vout2.$1358.Metal3 0.0039548f
Cred_9047 VDD.$6524.Metal2 vout2.$1424.Metal3 0.0039548f
Cred_9048 VDD.$6524.Metal2 vout2.P14.nSD 6.23042e-05f
Cred_9049 VDD.$6524.Metal2 vout2.P14.pSD 0.00350401f
Cred_9050 VDD.$6536.Metal2 vin3.$409.Metal1 1.0427e-06f
Cred_9051 VDD.$6536.Metal2 vin3.$413.Metal1 4.41141e-06f
Cred_9052 VDD.$6536.Metal2 vin3.$616.Metal2 0.00028658f
Cred_9053 VDD.$6536.Metal2 vin3.$620.Metal2 0.00028658f
Cred_9054 VDD.$6536.Metal2 vin3.P34.GatPoly 0.00050875f
Cred_9055 VDD.$6536.Metal2 vin3.P35.GatPoly 0.0103051f
Cred_9056 VDD.$6536.Metal2 vin4.$408.Metal1 1.0427e-06f
Cred_9057 VDD.$6536.Metal2 vin4.$412.Metal1 4.41141e-06f
Cred_9058 VDD.$6536.Metal2 vin4.$615.Metal2 0.00028658f
Cred_9059 VDD.$6536.Metal2 vin4.$619.Metal2 0.00028658f
Cred_9060 VDD.$6536.Metal2 vin4.P34.GatPoly 0.00050875f
Cred_9061 VDD.$6536.Metal2 vin4.P35.GatPoly 0.0103051f
Cred_9062 VDD.$6536.Metal2 vout3.$1358.Metal3 0.0039548f
Cred_9063 VDD.$6536.Metal2 vout3.$1424.Metal3 0.0039548f
Cred_9064 VDD.$6536.Metal2 vout3.P14.nSD 6.23042e-05f
Cred_9065 VDD.$6536.Metal2 vout3.P14.pSD 0.00350401f
Cred_9066 VDD.$6536.Metal2 vout4.$1358.Metal3 0.0039548f
Cred_9067 VDD.$6536.Metal2 vout4.$1424.Metal3 0.0039548f
Cred_9068 VDD.$6536.Metal2 vout4.P14.nSD 6.23042e-05f
Cred_9069 VDD.$6536.Metal2 vout4.P14.pSD 0.00350401f
Cred_9070 VDD.$657.Metal1 vin3.P20.GatPoly 0.000470129f
Cred_9071 VDD.$657.Metal1 vin3.P21.GatPoly 0.0086769f
Cred_9072 VDD.$657.Metal1 vin4.P20.GatPoly 0.000470129f
Cred_9073 VDD.$657.Metal1 vin4.P21.GatPoly 0.0086769f
Cred_9074 VDD.$657.Metal1 vout3.$1226.Metal3 0.0060509f
Cred_9075 VDD.$657.Metal1 vout3.P0.nSD 0.000180177f
Cred_9076 VDD.$657.Metal1 vout3.P0.pSD 0.00574479f
Cred_9077 VDD.$657.Metal1 vout3.P2.nSD 9.53262e-05f
Cred_9078 VDD.$657.Metal1 vout3.P2.pSD 0.00052098f
Cred_9079 VDD.$657.Metal1 vout4.$1226.Metal3 0.0060509f
Cred_9080 VDD.$657.Metal1 vout4.P0.nSD 0.000180177f
Cred_9081 VDD.$657.Metal1 vout4.P0.pSD 0.00574479f
Cred_9082 VDD.$657.Metal1 vout4.P2.nSD 9.53262e-05f
Cred_9083 VDD.$657.Metal1 vout4.P2.pSD 0.00052098f
Cred_9084 VDD.$6572.Metal2 vin1.$145.GatPoly 0.00162815f
Cred_9085 VDD.$6572.Metal2 vin1.$153.GatPoly 0.00456472f
Cred_9086 VDD.$6572.Metal2 vin1.$157.GatPoly 0.00875418f
Cred_9087 VDD.$6572.Metal2 vin1.$409.Metal1 0.000862155f
Cred_9088 VDD.$6572.Metal2 vin1.$413.Metal1 0.00236213f
Cred_9089 VDD.$6572.Metal2 vin1.$419.Metal1 0.00418784f
Cred_9090 VDD.$6572.Metal2 vin1.$423.Metal1 0.000965854f
Cred_9091 VDD.$6572.Metal2 vin1.$616.Metal2 0.00028658f
Cred_9092 VDD.$6572.Metal2 vin1.$620.Metal2 0.00436753f
Cred_9093 VDD.$6572.Metal2 vin1.$622.Metal2 0.000690494f
Cred_9094 VDD.$6572.Metal2 vin1.$625.Metal2 0.00708295f
Cred_9095 VDD.$6572.Metal2 vin1.P34.GatPoly 0.00035694f
Cred_9096 VDD.$6572.Metal2 vin1.P35.GatPoly 0.0385377f
Cred_9097 VDD.$6572.Metal2 vin1.P36.GatPoly 0.0274063f
Cred_9098 VDD.$6572.Metal2 vin1.P37.GatPoly 0.00035694f
Cred_9099 VDD.$6572.Metal2 vin2.$144.GatPoly 0.00162815f
Cred_9100 VDD.$6572.Metal2 vin2.$152.GatPoly 0.00456472f
Cred_9101 VDD.$6572.Metal2 vin2.$156.GatPoly 0.00875418f
Cred_9102 VDD.$6572.Metal2 vin2.$408.Metal1 0.000862155f
Cred_9103 VDD.$6572.Metal2 vin2.$412.Metal1 0.00236213f
Cred_9104 VDD.$6572.Metal2 vin2.$418.Metal1 0.00418784f
Cred_9105 VDD.$6572.Metal2 vin2.$422.Metal1 0.000965854f
Cred_9106 VDD.$6572.Metal2 vin2.$615.Metal2 0.00028658f
Cred_9107 VDD.$6572.Metal2 vin2.$619.Metal2 0.00436753f
Cred_9108 VDD.$6572.Metal2 vin2.$622.Metal2 0.000690494f
Cred_9109 VDD.$6572.Metal2 vin2.$624.Metal2 0.00708295f
Cred_9110 VDD.$6572.Metal2 vin2.P34.GatPoly 0.00035694f
Cred_9111 VDD.$6572.Metal2 vin2.P35.GatPoly 0.0385377f
Cred_9112 VDD.$6572.Metal2 vin2.P36.GatPoly 0.0274063f
Cred_9113 VDD.$6572.Metal2 vin2.P37.GatPoly 0.00035694f
Cred_9114 VDD.$6572.Metal2 vout1.$1358.Metal3 0.0210845f
Cred_9115 VDD.$6572.Metal2 vout1.$1424.Metal3 0.0666279f
Cred_9116 VDD.$6572.Metal2 vout1.P14.nSD 0.000332166f
Cred_9117 VDD.$6572.Metal2 vout1.P14.pSD 0.0190499f
Cred_9118 VDD.$6572.Metal2 vout1.P16.pSD 0.016927f
Cred_9119 VDD.$6572.Metal2 vout2.$1358.Metal3 0.0212133f
Cred_9120 VDD.$6572.Metal2 vout2.$1424.Metal3 0.0663955f
Cred_9121 VDD.$6572.Metal2 vout2.P14.nSD 0.000334195f
Cred_9122 VDD.$6572.Metal2 vout2.P14.pSD 0.0190824f
Cred_9123 VDD.$6572.Metal2 vout2.P16.pSD 0.0168925f
Cred_9124 VDD.$6584.Metal2 vin3.$145.GatPoly 0.00162815f
Cred_9125 VDD.$6584.Metal2 vin3.$153.GatPoly 0.00456472f
Cred_9126 VDD.$6584.Metal2 vin3.$157.GatPoly 0.00875418f
Cred_9127 VDD.$6584.Metal2 vin3.$409.Metal1 0.000862155f
Cred_9128 VDD.$6584.Metal2 vin3.$413.Metal1 0.00236213f
Cred_9129 VDD.$6584.Metal2 vin3.$419.Metal1 0.00418784f
Cred_9130 VDD.$6584.Metal2 vin3.$423.Metal1 0.000965854f
Cred_9131 VDD.$6584.Metal2 vin3.$616.Metal2 0.00028658f
Cred_9132 VDD.$6584.Metal2 vin3.$620.Metal2 0.00436753f
Cred_9133 VDD.$6584.Metal2 vin3.$622.Metal2 0.000690494f
Cred_9134 VDD.$6584.Metal2 vin3.$625.Metal2 0.00708295f
Cred_9135 VDD.$6584.Metal2 vin3.P34.GatPoly 0.00035694f
Cred_9136 VDD.$6584.Metal2 vin3.P35.GatPoly 0.0385377f
Cred_9137 VDD.$6584.Metal2 vin3.P36.GatPoly 0.0274063f
Cred_9138 VDD.$6584.Metal2 vin3.P37.GatPoly 0.00035694f
Cred_9139 VDD.$6584.Metal2 vin4.$144.GatPoly 0.00162815f
Cred_9140 VDD.$6584.Metal2 vin4.$152.GatPoly 0.00456472f
Cred_9141 VDD.$6584.Metal2 vin4.$156.GatPoly 0.00875418f
Cred_9142 VDD.$6584.Metal2 vin4.$408.Metal1 0.000862155f
Cred_9143 VDD.$6584.Metal2 vin4.$412.Metal1 0.00236213f
Cred_9144 VDD.$6584.Metal2 vin4.$418.Metal1 0.00418784f
Cred_9145 VDD.$6584.Metal2 vin4.$422.Metal1 0.000965854f
Cred_9146 VDD.$6584.Metal2 vin4.$615.Metal2 0.00028658f
Cred_9147 VDD.$6584.Metal2 vin4.$619.Metal2 0.00436753f
Cred_9148 VDD.$6584.Metal2 vin4.$622.Metal2 0.000690494f
Cred_9149 VDD.$6584.Metal2 vin4.$624.Metal2 0.00708295f
Cred_9150 VDD.$6584.Metal2 vin4.P34.GatPoly 0.00035694f
Cred_9151 VDD.$6584.Metal2 vin4.P35.GatPoly 0.0385377f
Cred_9152 VDD.$6584.Metal2 vin4.P36.GatPoly 0.0274063f
Cred_9153 VDD.$6584.Metal2 vin4.P37.GatPoly 0.00035694f
Cred_9154 VDD.$6584.Metal2 vout3.$1358.Metal3 0.0210845f
Cred_9155 VDD.$6584.Metal2 vout3.$1424.Metal3 0.0666279f
Cred_9156 VDD.$6584.Metal2 vout3.P14.nSD 0.000332166f
Cred_9157 VDD.$6584.Metal2 vout3.P14.pSD 0.0190499f
Cred_9158 VDD.$6584.Metal2 vout3.P16.pSD 0.016927f
Cred_9159 VDD.$6584.Metal2 vout4.$1358.Metal3 0.0212133f
Cred_9160 VDD.$6584.Metal2 vout4.$1424.Metal3 0.0663955f
Cred_9161 VDD.$6584.Metal2 vout4.P14.nSD 0.000334195f
Cred_9162 VDD.$6584.Metal2 vout4.P14.pSD 0.0190824f
Cred_9163 VDD.$6584.Metal2 vout4.P16.pSD 0.0168925f
Cred_9164 VDD.$6654.Metal2 vin1.$145.GatPoly 0.00371219f
Cred_9165 VDD.$6654.Metal2 vin1.$153.GatPoly 0.0104076f
Cred_9166 VDD.$6654.Metal2 vin1.$157.GatPoly 0.0199595f
Cred_9167 VDD.$6654.Metal2 vin1.$409.Metal1 0.00196334f
Cred_9168 VDD.$6654.Metal2 vin1.$413.Metal1 0.0053756f
Cred_9169 VDD.$6654.Metal2 vin1.$419.Metal1 0.00954827f
Cred_9170 VDD.$6654.Metal2 vin1.$423.Metal1 0.00220527f
Cred_9171 VDD.$6654.Metal2 vin1.$427.Metal1 2.32194e-06f
Cred_9172 VDD.$6654.Metal2 vin1.$620.Metal2 0.00930457f
Cred_9173 VDD.$6654.Metal2 vin1.$622.Metal2 0.00157433f
Cred_9174 VDD.$6654.Metal2 vin1.$625.Metal2 0.0164357f
Cred_9175 VDD.$6654.Metal2 vin1.$629.Metal2 0.000286585f
Cred_9176 VDD.$6654.Metal2 vin1.P34.GatPoly 0.000813824f
Cred_9177 VDD.$6654.Metal2 vin1.P35.GatPoly 0.0654139f
Cred_9178 VDD.$6654.Metal2 vin1.P36.GatPoly 0.067695f
Cred_9179 VDD.$6654.Metal2 vin1.P37.GatPoly 0.000813824f
Cred_9180 VDD.$6654.Metal2 vin2.$144.GatPoly 0.00371219f
Cred_9181 VDD.$6654.Metal2 vin2.$152.GatPoly 0.0104076f
Cred_9182 VDD.$6654.Metal2 vin2.$156.GatPoly 0.0199595f
Cred_9183 VDD.$6654.Metal2 vin2.$408.Metal1 0.00196334f
Cred_9184 VDD.$6654.Metal2 vin2.$412.Metal1 0.0053756f
Cred_9185 VDD.$6654.Metal2 vin2.$418.Metal1 0.00954827f
Cred_9186 VDD.$6654.Metal2 vin2.$422.Metal1 0.00220527f
Cred_9187 VDD.$6654.Metal2 vin2.$426.Metal1 2.32194e-06f
Cred_9188 VDD.$6654.Metal2 vin2.$619.Metal2 0.00930457f
Cred_9189 VDD.$6654.Metal2 vin2.$622.Metal2 0.00157433f
Cred_9190 VDD.$6654.Metal2 vin2.$624.Metal2 0.0164357f
Cred_9191 VDD.$6654.Metal2 vin2.$628.Metal2 0.000286585f
Cred_9192 VDD.$6654.Metal2 vin2.P34.GatPoly 0.000813824f
Cred_9193 VDD.$6654.Metal2 vin2.P35.GatPoly 0.0654139f
Cred_9194 VDD.$6654.Metal2 vin2.P36.GatPoly 0.067695f
Cred_9195 VDD.$6654.Metal2 vin2.P37.GatPoly 0.000813824f
Cred_9196 VDD.$6654.Metal2 vout1.$1358.Metal3 0.0480726f
Cred_9197 VDD.$6654.Metal2 vout1.$1424.Metal3 0.151912f
Cred_9198 VDD.$6654.Metal2 vout1.P14.nSD 0.000757338f
Cred_9199 VDD.$6654.Metal2 vout1.P14.pSD 0.0434339f
Cred_9200 VDD.$6654.Metal2 vout1.P16.pSD 0.0385935f
Cred_9201 VDD.$6654.Metal2 vout2.$1358.Metal3 0.0483662f
Cred_9202 VDD.$6654.Metal2 vout2.$1424.Metal3 0.151382f
Cred_9203 VDD.$6654.Metal2 vout2.P14.nSD 0.000761965f
Cred_9204 VDD.$6654.Metal2 vout2.P14.pSD 0.0435078f
Cred_9205 VDD.$6654.Metal2 vout2.P16.pSD 0.0385148f
Cred_9206 VDD.$6666.Metal2 vin3.$145.GatPoly 0.00371219f
Cred_9207 VDD.$6666.Metal2 vin3.$153.GatPoly 0.0104076f
Cred_9208 VDD.$6666.Metal2 vin3.$157.GatPoly 0.0199595f
Cred_9209 VDD.$6666.Metal2 vin3.$409.Metal1 0.00196334f
Cred_9210 VDD.$6666.Metal2 vin3.$413.Metal1 0.0053756f
Cred_9211 VDD.$6666.Metal2 vin3.$419.Metal1 0.00954827f
Cred_9212 VDD.$6666.Metal2 vin3.$423.Metal1 0.00220527f
Cred_9213 VDD.$6666.Metal2 vin3.$427.Metal1 2.32194e-06f
Cred_9214 VDD.$6666.Metal2 vin3.$620.Metal2 0.00930457f
Cred_9215 VDD.$6666.Metal2 vin3.$622.Metal2 0.00157433f
Cred_9216 VDD.$6666.Metal2 vin3.$625.Metal2 0.0164357f
Cred_9217 VDD.$6666.Metal2 vin3.$629.Metal2 0.000286585f
Cred_9218 VDD.$6666.Metal2 vin3.P34.GatPoly 0.000813824f
Cred_9219 VDD.$6666.Metal2 vin3.P35.GatPoly 0.0654139f
Cred_9220 VDD.$6666.Metal2 vin3.P36.GatPoly 0.067695f
Cred_9221 VDD.$6666.Metal2 vin3.P37.GatPoly 0.000813824f
Cred_9222 VDD.$6666.Metal2 vin4.$144.GatPoly 0.00371219f
Cred_9223 VDD.$6666.Metal2 vin4.$152.GatPoly 0.0104076f
Cred_9224 VDD.$6666.Metal2 vin4.$156.GatPoly 0.0199595f
Cred_9225 VDD.$6666.Metal2 vin4.$408.Metal1 0.00196334f
Cred_9226 VDD.$6666.Metal2 vin4.$412.Metal1 0.0053756f
Cred_9227 VDD.$6666.Metal2 vin4.$418.Metal1 0.00954827f
Cred_9228 VDD.$6666.Metal2 vin4.$422.Metal1 0.00220527f
Cred_9229 VDD.$6666.Metal2 vin4.$426.Metal1 2.32194e-06f
Cred_9230 VDD.$6666.Metal2 vin4.$619.Metal2 0.00930457f
Cred_9231 VDD.$6666.Metal2 vin4.$622.Metal2 0.00157433f
Cred_9232 VDD.$6666.Metal2 vin4.$624.Metal2 0.0164357f
Cred_9233 VDD.$6666.Metal2 vin4.$628.Metal2 0.000286585f
Cred_9234 VDD.$6666.Metal2 vin4.P34.GatPoly 0.000813824f
Cred_9235 VDD.$6666.Metal2 vin4.P35.GatPoly 0.0654139f
Cred_9236 VDD.$6666.Metal2 vin4.P36.GatPoly 0.067695f
Cred_9237 VDD.$6666.Metal2 vin4.P37.GatPoly 0.000813824f
Cred_9238 VDD.$6666.Metal2 vout3.$1358.Metal3 0.0480726f
Cred_9239 VDD.$6666.Metal2 vout3.$1424.Metal3 0.151912f
Cred_9240 VDD.$6666.Metal2 vout3.P14.nSD 0.000757338f
Cred_9241 VDD.$6666.Metal2 vout3.P14.pSD 0.0434339f
Cred_9242 VDD.$6666.Metal2 vout3.P16.pSD 0.0385935f
Cred_9243 VDD.$6666.Metal2 vout4.$1358.Metal3 0.0483662f
Cred_9244 VDD.$6666.Metal2 vout4.$1424.Metal3 0.151382f
Cred_9245 VDD.$6666.Metal2 vout4.P14.nSD 0.000761965f
Cred_9246 VDD.$6666.Metal2 vout4.P14.pSD 0.0435078f
Cred_9247 VDD.$6666.Metal2 vout4.P16.pSD 0.0385148f
Cred_9248 VDD.$667.Metal1 vin1.P21.GatPoly 0.0126826f
Cred_9249 VDD.$667.Metal1 vin2.P21.GatPoly 0.0126826f
Cred_9250 VDD.$667.Metal1 vout1.$1226.Metal3 6.51887e-07f
Cred_9251 VDD.$667.Metal1 vout1.P0.nSD 1.94111e-08f
Cred_9252 VDD.$667.Metal1 vout1.P0.pSD 4.04225e-07f
Cred_9253 VDD.$667.Metal1 vout1.P2.nSD 1.02699e-08f
Cred_9254 VDD.$667.Metal1 vout1.P2.pSD 5.61272e-08f
Cred_9255 VDD.$667.Metal1 vout2.$1226.Metal3 6.51887e-07f
Cred_9256 VDD.$667.Metal1 vout2.P0.nSD 1.94111e-08f
Cred_9257 VDD.$667.Metal1 vout2.P0.pSD 4.04225e-07f
Cred_9258 VDD.$667.Metal1 vout2.P2.nSD 1.02699e-08f
Cred_9259 VDD.$667.Metal1 vout2.P2.pSD 5.61272e-08f
Cred_9260 VDD.$671.Metal1 vin3.P21.GatPoly 0.0126826f
Cred_9261 VDD.$671.Metal1 vin4.P21.GatPoly 0.0126826f
Cred_9262 VDD.$671.Metal1 vout3.$1226.Metal3 6.51887e-07f
Cred_9263 VDD.$671.Metal1 vout3.P0.nSD 1.94111e-08f
Cred_9264 VDD.$671.Metal1 vout3.P0.pSD 4.04225e-07f
Cred_9265 VDD.$671.Metal1 vout3.P2.nSD 1.02699e-08f
Cred_9266 VDD.$671.Metal1 vout3.P2.pSD 5.61272e-08f
Cred_9267 VDD.$671.Metal1 vout4.$1226.Metal3 6.51887e-07f
Cred_9268 VDD.$671.Metal1 vout4.P0.nSD 1.94111e-08f
Cred_9269 VDD.$671.Metal1 vout4.P0.pSD 4.04225e-07f
Cred_9270 VDD.$671.Metal1 vout4.P2.nSD 1.02699e-08f
Cred_9271 VDD.$671.Metal1 vout4.P2.pSD 5.61272e-08f
Cred_9272 VDD.$6758.Metal2 vin1.$423.Metal1 3.1226e-06f
Cred_9273 VDD.$6758.Metal2 vin1.$427.Metal1 2.32194e-06f
Cred_9274 VDD.$6758.Metal2 vin1.$625.Metal2 0.000286585f
Cred_9275 VDD.$6758.Metal2 vin1.$629.Metal2 0.000286585f
Cred_9276 VDD.$6758.Metal2 vin1.P36.GatPoly 0.0147881f
Cred_9277 VDD.$6758.Metal2 vin2.$422.Metal1 3.1226e-06f
Cred_9278 VDD.$6758.Metal2 vin2.$426.Metal1 2.32194e-06f
Cred_9279 VDD.$6758.Metal2 vin2.$624.Metal2 0.000286585f
Cred_9280 VDD.$6758.Metal2 vin2.$628.Metal2 0.000286585f
Cred_9281 VDD.$6758.Metal2 vin2.P36.GatPoly 0.0147881f
Cred_9282 VDD.$6758.Metal2 vout1.$1424.Metal3 0.00629175f
Cred_9283 VDD.$6758.Metal2 vout1.P16.pSD 0.00219773f
Cred_9284 VDD.$6758.Metal2 vout2.$1424.Metal3 0.00629175f
Cred_9285 VDD.$6758.Metal2 vout2.P16.pSD 0.00219773f
Cred_9286 VDD.$6770.Metal2 vin3.$423.Metal1 3.1226e-06f
Cred_9287 VDD.$6770.Metal2 vin3.$427.Metal1 2.32194e-06f
Cred_9288 VDD.$6770.Metal2 vin3.$625.Metal2 0.000286585f
Cred_9289 VDD.$6770.Metal2 vin3.$629.Metal2 0.000286585f
Cred_9290 VDD.$6770.Metal2 vin3.P36.GatPoly 0.0147881f
Cred_9291 VDD.$6770.Metal2 vin4.$422.Metal1 3.1226e-06f
Cred_9292 VDD.$6770.Metal2 vin4.$426.Metal1 2.32194e-06f
Cred_9293 VDD.$6770.Metal2 vin4.$624.Metal2 0.000286585f
Cred_9294 VDD.$6770.Metal2 vin4.$628.Metal2 0.000286585f
Cred_9295 VDD.$6770.Metal2 vin4.P36.GatPoly 0.0147881f
Cred_9296 VDD.$6770.Metal2 vout3.$1424.Metal3 0.00629175f
Cred_9297 VDD.$6770.Metal2 vout3.P16.pSD 0.00219773f
Cred_9298 VDD.$6770.Metal2 vout4.$1424.Metal3 0.00629175f
Cred_9299 VDD.$6770.Metal2 vout4.P16.pSD 0.00219773f
Cred_9300 VDD.$6806.Metal2 vin1.$173.GatPoly 8.01355e-09f
Cred_9301 VDD.$6806.Metal2 vin1.$441.Metal1 4.76041e-06f
Cred_9302 VDD.$6806.Metal2 vin1.$449.Metal1 6.71641e-07f
Cred_9303 VDD.$6806.Metal2 vin1.$636.Metal2 0.000286583f
Cred_9304 VDD.$6806.Metal2 vin1.$640.Metal2 0.00028659f
Cred_9305 VDD.$6806.Metal2 vin1.P37.GatPoly 0.0134761f
Cred_9306 VDD.$6806.Metal2 vin2.$172.GatPoly 8.01355e-09f
Cred_9307 VDD.$6806.Metal2 vin2.$440.Metal1 4.76041e-06f
Cred_9308 VDD.$6806.Metal2 vin2.$448.Metal1 6.71641e-07f
Cred_9309 VDD.$6806.Metal2 vin2.$635.Metal2 0.000286583f
Cred_9310 VDD.$6806.Metal2 vin2.$639.Metal2 0.00028659f
Cred_9311 VDD.$6806.Metal2 vin2.P37.GatPoly 0.0134761f
Cred_9312 VDD.$6806.Metal2 vout1.$1424.Metal3 0.00702797f
Cred_9313 VDD.$6806.Metal2 vout1.P16.pSD 0.00252664f
Cred_9314 VDD.$6806.Metal2 vout2.$1424.Metal3 0.00702797f
Cred_9315 VDD.$6806.Metal2 vout2.P16.pSD 0.00252664f
Cred_9316 VDD.$6818.Metal2 vin3.$173.GatPoly 8.01355e-09f
Cred_9317 VDD.$6818.Metal2 vin3.$441.Metal1 4.76041e-06f
Cred_9318 VDD.$6818.Metal2 vin3.$449.Metal1 6.71641e-07f
Cred_9319 VDD.$6818.Metal2 vin3.$636.Metal2 0.000286583f
Cred_9320 VDD.$6818.Metal2 vin3.$640.Metal2 0.00028659f
Cred_9321 VDD.$6818.Metal2 vin3.P37.GatPoly 0.0134761f
Cred_9322 VDD.$6818.Metal2 vin4.$172.GatPoly 8.01355e-09f
Cred_9323 VDD.$6818.Metal2 vin4.$440.Metal1 4.76041e-06f
Cred_9324 VDD.$6818.Metal2 vin4.$448.Metal1 6.71641e-07f
Cred_9325 VDD.$6818.Metal2 vin4.$635.Metal2 0.000286583f
Cred_9326 VDD.$6818.Metal2 vin4.$639.Metal2 0.00028659f
Cred_9327 VDD.$6818.Metal2 vin4.P37.GatPoly 0.0134761f
Cred_9328 VDD.$6818.Metal2 vout3.$1424.Metal3 0.00702797f
Cred_9329 VDD.$6818.Metal2 vout3.P16.pSD 0.00252664f
Cred_9330 VDD.$6818.Metal2 vout4.$1424.Metal3 0.00702797f
Cred_9331 VDD.$6818.Metal2 vout4.P16.pSD 0.00252664f
Cred_9332 VDD.$687.Metal1 vin1.P21.GatPoly 0.00764513f
Cred_9333 VDD.$687.Metal1 vin2.P21.GatPoly 0.00764513f
Cred_9334 VDD.$691.Metal1 vin3.P21.GatPoly 0.00764513f
Cred_9335 VDD.$691.Metal1 vin4.P21.GatPoly 0.00764513f
Cred_9336 VDD.$6912.Metal2 vin1.$167.GatPoly 0.0155617f
Cred_9337 VDD.$6912.Metal2 vin1.$173.GatPoly 0.00328677f
Cred_9338 VDD.$6912.Metal2 vin1.$179.GatPoly 0.0141994f
Cred_9339 VDD.$6912.Metal2 vin1.$441.Metal1 0.00122881f
Cred_9340 VDD.$6912.Metal2 vin1.$449.Metal1 0.00786535f
Cred_9341 VDD.$6912.Metal2 vin1.$453.Metal1 0.00347776f
Cred_9342 VDD.$6912.Metal2 vin1.$636.Metal2 0.000289582f
Cred_9343 VDD.$6912.Metal2 vin1.$640.Metal2 0.0117981f
Cred_9344 VDD.$6912.Metal2 vin1.$642.Metal2 0.00141954f
Cred_9345 VDD.$6912.Metal2 vin1.$645.Metal2 0.00915772f
Cred_9346 VDD.$6912.Metal2 vin1.P36.GatPoly 0.000670511f
Cred_9347 VDD.$6912.Metal2 vin1.P37.GatPoly 0.0583839f
Cred_9348 VDD.$6912.Metal2 vin1.P38.GatPoly 0.0523557f
Cred_9349 VDD.$6912.Metal2 vin1.P39.GatPoly 0.000739311f
Cred_9350 VDD.$6912.Metal2 vin2.$166.GatPoly 0.0155617f
Cred_9351 VDD.$6912.Metal2 vin2.$172.GatPoly 0.00328677f
Cred_9352 VDD.$6912.Metal2 vin2.$178.GatPoly 0.0141994f
Cred_9353 VDD.$6912.Metal2 vin2.$440.Metal1 0.00122881f
Cred_9354 VDD.$6912.Metal2 vin2.$448.Metal1 0.00786535f
Cred_9355 VDD.$6912.Metal2 vin2.$452.Metal1 0.00347776f
Cred_9356 VDD.$6912.Metal2 vin2.$635.Metal2 0.000289582f
Cred_9357 VDD.$6912.Metal2 vin2.$639.Metal2 0.0117981f
Cred_9358 VDD.$6912.Metal2 vin2.$642.Metal2 0.00141954f
Cred_9359 VDD.$6912.Metal2 vin2.$644.Metal2 0.00915772f
Cred_9360 VDD.$6912.Metal2 vin2.P36.GatPoly 0.000670511f
Cred_9361 VDD.$6912.Metal2 vin2.P37.GatPoly 0.0585004f
Cred_9362 VDD.$6912.Metal2 vin2.P38.GatPoly 0.0522392f
Cred_9363 VDD.$6912.Metal2 vin2.P39.GatPoly 0.000739311f
Cred_9364 VDD.$6912.Metal2 vout1 0.0130619f
Cred_9365 VDD.$6912.Metal2 vout1.$1424.Metal3 0.148657f
Cred_9366 VDD.$6912.Metal2 vout1.P16.pSD 0.0320142f
Cred_9367 VDD.$6912.Metal2 vout1.P18.nSD 0.00103783f
Cred_9368 VDD.$6912.Metal2 vout1.P18.pSD 0.0392496f
Cred_9369 VDD.$6912.Metal2 vout2 0.0130619f
Cred_9370 VDD.$6912.Metal2 vout2.$1424.Metal3 0.149335f
Cred_9371 VDD.$6912.Metal2 vout2.P16.pSD 0.032079f
Cred_9372 VDD.$6912.Metal2 vout2.P18.nSD 0.00103783f
Cred_9373 VDD.$6912.Metal2 vout2.P18.pSD 0.0392496f
Cred_9374 VDD.$6924.Metal2 vin3.$167.GatPoly 0.0155617f
Cred_9375 VDD.$6924.Metal2 vin3.$173.GatPoly 0.00328677f
Cred_9376 VDD.$6924.Metal2 vin3.$179.GatPoly 0.0141994f
Cred_9377 VDD.$6924.Metal2 vin3.$441.Metal1 0.00122881f
Cred_9378 VDD.$6924.Metal2 vin3.$449.Metal1 0.00786535f
Cred_9379 VDD.$6924.Metal2 vin3.$453.Metal1 0.00347776f
Cred_9380 VDD.$6924.Metal2 vin3.$636.Metal2 0.000289582f
Cred_9381 VDD.$6924.Metal2 vin3.$640.Metal2 0.0117981f
Cred_9382 VDD.$6924.Metal2 vin3.$642.Metal2 0.00141954f
Cred_9383 VDD.$6924.Metal2 vin3.$645.Metal2 0.00915772f
Cred_9384 VDD.$6924.Metal2 vin3.P36.GatPoly 0.000670511f
Cred_9385 VDD.$6924.Metal2 vin3.P37.GatPoly 0.0583839f
Cred_9386 VDD.$6924.Metal2 vin3.P38.GatPoly 0.0523557f
Cred_9387 VDD.$6924.Metal2 vin3.P39.GatPoly 0.000739311f
Cred_9388 VDD.$6924.Metal2 vin4.$166.GatPoly 0.0155617f
Cred_9389 VDD.$6924.Metal2 vin4.$172.GatPoly 0.00328677f
Cred_9390 VDD.$6924.Metal2 vin4.$178.GatPoly 0.0141994f
Cred_9391 VDD.$6924.Metal2 vin4.$440.Metal1 0.00122881f
Cred_9392 VDD.$6924.Metal2 vin4.$448.Metal1 0.00786535f
Cred_9393 VDD.$6924.Metal2 vin4.$452.Metal1 0.00347776f
Cred_9394 VDD.$6924.Metal2 vin4.$635.Metal2 0.000289582f
Cred_9395 VDD.$6924.Metal2 vin4.$639.Metal2 0.0117981f
Cred_9396 VDD.$6924.Metal2 vin4.$642.Metal2 0.00141954f
Cred_9397 VDD.$6924.Metal2 vin4.$644.Metal2 0.00915772f
Cred_9398 VDD.$6924.Metal2 vin4.P36.GatPoly 0.000670511f
Cred_9399 VDD.$6924.Metal2 vin4.P37.GatPoly 0.0585004f
Cred_9400 VDD.$6924.Metal2 vin4.P38.GatPoly 0.0522392f
Cred_9401 VDD.$6924.Metal2 vin4.P39.GatPoly 0.000739311f
Cred_9402 VDD.$6924.Metal2 vout3 0.0130619f
Cred_9403 VDD.$6924.Metal2 vout3.$1424.Metal3 0.148657f
Cred_9404 VDD.$6924.Metal2 vout3.P16.pSD 0.0320142f
Cred_9405 VDD.$6924.Metal2 vout3.P18.nSD 0.00103783f
Cred_9406 VDD.$6924.Metal2 vout3.P18.pSD 0.0392496f
Cred_9407 VDD.$6924.Metal2 vout4 0.0130619f
Cred_9408 VDD.$6924.Metal2 vout4.$1424.Metal3 0.149335f
Cred_9409 VDD.$6924.Metal2 vout4.P16.pSD 0.032079f
Cred_9410 VDD.$6924.Metal2 vout4.P18.nSD 0.00103783f
Cred_9411 VDD.$6924.Metal2 vout4.P18.pSD 0.0392496f
Cred_9412 VDD.$6992.Metal2 vin1.$167.GatPoly 0.0115885f
Cred_9413 VDD.$6992.Metal2 vin1.$173.GatPoly 0.00244759f
Cred_9414 VDD.$6992.Metal2 vin1.$179.GatPoly 0.010574f
Cred_9415 VDD.$6992.Metal2 vin1.$441.Metal1 0.000911526f
Cred_9416 VDD.$6992.Metal2 vin1.$449.Metal1 0.00585667f
Cred_9417 VDD.$6992.Metal2 vin1.$453.Metal1 0.00259054f
Cred_9418 VDD.$6992.Metal2 vin1.$457.Metal1 4.73592e-06f
Cred_9419 VDD.$6992.Metal2 vin1.$636.Metal2 2.23338e-06f
Cred_9420 VDD.$6992.Metal2 vin1.$640.Metal2 0.00857241f
Cred_9421 VDD.$6992.Metal2 vin1.$642.Metal2 0.00105711f
Cred_9422 VDD.$6992.Metal2 vin1.$645.Metal2 0.00710616f
Cred_9423 VDD.$6992.Metal2 vin1.$649.Metal2 0.000286578f
Cred_9424 VDD.$6992.Metal2 vin1.P36.GatPoly 0.000499317f
Cred_9425 VDD.$6992.Metal2 vin1.P37.GatPoly 0.038263f
Cred_9426 VDD.$6992.Metal2 vin1.P38.GatPoly 0.0475353f
Cred_9427 VDD.$6992.Metal2 vin1.P39.GatPoly 0.000550551f
Cred_9428 VDD.$6992.Metal2 vin2.$166.GatPoly 0.0115885f
Cred_9429 VDD.$6992.Metal2 vin2.$172.GatPoly 0.00244759f
Cred_9430 VDD.$6992.Metal2 vin2.$178.GatPoly 0.010574f
Cred_9431 VDD.$6992.Metal2 vin2.$440.Metal1 0.000911526f
Cred_9432 VDD.$6992.Metal2 vin2.$448.Metal1 0.00585667f
Cred_9433 VDD.$6992.Metal2 vin2.$452.Metal1 0.00259054f
Cred_9434 VDD.$6992.Metal2 vin2.$456.Metal1 4.73592e-06f
Cred_9435 VDD.$6992.Metal2 vin2.$635.Metal2 2.23338e-06f
Cred_9436 VDD.$6992.Metal2 vin2.$639.Metal2 0.00857241f
Cred_9437 VDD.$6992.Metal2 vin2.$642.Metal2 0.00105711f
Cred_9438 VDD.$6992.Metal2 vin2.$644.Metal2 0.00710616f
Cred_9439 VDD.$6992.Metal2 vin2.$648.Metal2 0.000286578f
Cred_9440 VDD.$6992.Metal2 vin2.P36.GatPoly 0.000499317f
Cred_9441 VDD.$6992.Metal2 vin2.P37.GatPoly 0.0383498f
Cred_9442 VDD.$6992.Metal2 vin2.P38.GatPoly 0.0474485f
Cred_9443 VDD.$6992.Metal2 vin2.P39.GatPoly 0.000550551f
Cred_9444 VDD.$6992.Metal2 vout1 0.00972692f
Cred_9445 VDD.$6992.Metal2 vout1.$1424.Metal3 0.110702f
Cred_9446 VDD.$6992.Metal2 vout1.P16.pSD 0.0238403f
Cred_9447 VDD.$6992.Metal2 vout1.P18.nSD 0.000772855f
Cred_9448 VDD.$6992.Metal2 vout1.P18.pSD 0.0292284f
Cred_9449 VDD.$6992.Metal2 vout2 0.00972692f
Cred_9450 VDD.$6992.Metal2 vout2.$1424.Metal3 0.111207f
Cred_9451 VDD.$6992.Metal2 vout2.P16.pSD 0.0238886f
Cred_9452 VDD.$6992.Metal2 vout2.P18.nSD 0.000772855f
Cred_9453 VDD.$6992.Metal2 vout2.P18.pSD 0.0292284f
Cred_9454 VDD.$7004.Metal2 vin3.$167.GatPoly 0.0115885f
Cred_9455 VDD.$7004.Metal2 vin3.$173.GatPoly 0.00244759f
Cred_9456 VDD.$7004.Metal2 vin3.$179.GatPoly 0.010574f
Cred_9457 VDD.$7004.Metal2 vin3.$441.Metal1 0.000911526f
Cred_9458 VDD.$7004.Metal2 vin3.$449.Metal1 0.00585667f
Cred_9459 VDD.$7004.Metal2 vin3.$453.Metal1 0.00259054f
Cred_9460 VDD.$7004.Metal2 vin3.$457.Metal1 4.73592e-06f
Cred_9461 VDD.$7004.Metal2 vin3.$636.Metal2 2.23338e-06f
Cred_9462 VDD.$7004.Metal2 vin3.$640.Metal2 0.00857241f
Cred_9463 VDD.$7004.Metal2 vin3.$642.Metal2 0.00105711f
Cred_9464 VDD.$7004.Metal2 vin3.$645.Metal2 0.00710616f
Cred_9465 VDD.$7004.Metal2 vin3.$649.Metal2 0.000286578f
Cred_9466 VDD.$7004.Metal2 vin3.P36.GatPoly 0.000499317f
Cred_9467 VDD.$7004.Metal2 vin3.P37.GatPoly 0.038263f
Cred_9468 VDD.$7004.Metal2 vin3.P38.GatPoly 0.0475353f
Cred_9469 VDD.$7004.Metal2 vin3.P39.GatPoly 0.000550551f
Cred_9470 VDD.$7004.Metal2 vin4.$166.GatPoly 0.0115885f
Cred_9471 VDD.$7004.Metal2 vin4.$172.GatPoly 0.00244759f
Cred_9472 VDD.$7004.Metal2 vin4.$178.GatPoly 0.010574f
Cred_9473 VDD.$7004.Metal2 vin4.$440.Metal1 0.000911526f
Cred_9474 VDD.$7004.Metal2 vin4.$448.Metal1 0.00585667f
Cred_9475 VDD.$7004.Metal2 vin4.$452.Metal1 0.00259054f
Cred_9476 VDD.$7004.Metal2 vin4.$456.Metal1 4.73592e-06f
Cred_9477 VDD.$7004.Metal2 vin4.$635.Metal2 2.23338e-06f
Cred_9478 VDD.$7004.Metal2 vin4.$639.Metal2 0.00857241f
Cred_9479 VDD.$7004.Metal2 vin4.$642.Metal2 0.00105711f
Cred_9480 VDD.$7004.Metal2 vin4.$644.Metal2 0.00710616f
Cred_9481 VDD.$7004.Metal2 vin4.$648.Metal2 0.000286578f
Cred_9482 VDD.$7004.Metal2 vin4.P36.GatPoly 0.000499317f
Cred_9483 VDD.$7004.Metal2 vin4.P37.GatPoly 0.0383498f
Cred_9484 VDD.$7004.Metal2 vin4.P38.GatPoly 0.0474485f
Cred_9485 VDD.$7004.Metal2 vin4.P39.GatPoly 0.000550551f
Cred_9486 VDD.$7004.Metal2 vout3 0.00972692f
Cred_9487 VDD.$7004.Metal2 vout3.$1424.Metal3 0.110702f
Cred_9488 VDD.$7004.Metal2 vout3.P16.pSD 0.0238403f
Cred_9489 VDD.$7004.Metal2 vout3.P18.nSD 0.000772855f
Cred_9490 VDD.$7004.Metal2 vout3.P18.pSD 0.0292284f
Cred_9491 VDD.$7004.Metal2 vout4 0.00972692f
Cred_9492 VDD.$7004.Metal2 vout4.$1424.Metal3 0.111207f
Cred_9493 VDD.$7004.Metal2 vout4.P16.pSD 0.0238886f
Cred_9494 VDD.$7004.Metal2 vout4.P18.nSD 0.000772855f
Cred_9495 VDD.$7004.Metal2 vout4.P18.pSD 0.0292284f
Cred_9496 VDD.$7040.Metal2 vin1.$453.Metal1 7.22429e-07f
Cred_9497 VDD.$7040.Metal2 vin1.$457.Metal1 4.73592e-06f
Cred_9498 VDD.$7040.Metal2 vin1.$645.Metal2 0.000286578f
Cred_9499 VDD.$7040.Metal2 vin1.$649.Metal2 0.000286578f
Cred_9500 VDD.$7040.Metal2 vin1.P38.GatPoly 0.0117555f
Cred_9501 VDD.$7040.Metal2 vin1.P39.GatPoly 5.2412e-07f
Cred_9502 VDD.$7040.Metal2 vin2.$452.Metal1 7.22429e-07f
Cred_9503 VDD.$7040.Metal2 vin2.$456.Metal1 4.73592e-06f
Cred_9504 VDD.$7040.Metal2 vin2.$644.Metal2 0.000286578f
Cred_9505 VDD.$7040.Metal2 vin2.$648.Metal2 0.000286578f
Cred_9506 VDD.$7040.Metal2 vin2.P38.GatPoly 0.0117555f
Cred_9507 VDD.$7040.Metal2 vin2.P39.GatPoly 5.2412e-07f
Cred_9508 VDD.$7040.Metal2 vout1 0.00120657f
Cred_9509 VDD.$7040.Metal2 vout1.$1424.Metal3 0.0060853f
Cred_9510 VDD.$7040.Metal2 vout1.P18.nSD 9.58681e-05f
Cred_9511 VDD.$7040.Metal2 vout1.P18.pSD 0.00344055f
Cred_9512 VDD.$7040.Metal2 vout2 0.00120657f
Cred_9513 VDD.$7040.Metal2 vout2.$1424.Metal3 0.0060853f
Cred_9514 VDD.$7040.Metal2 vout2.P18.nSD 9.58681e-05f
Cred_9515 VDD.$7040.Metal2 vout2.P18.pSD 0.00344055f
Cred_9516 VDD.$7052.Metal2 vin3.$453.Metal1 7.22429e-07f
Cred_9517 VDD.$7052.Metal2 vin3.$457.Metal1 4.73592e-06f
Cred_9518 VDD.$7052.Metal2 vin3.$645.Metal2 0.000286578f
Cred_9519 VDD.$7052.Metal2 vin3.$649.Metal2 0.000286578f
Cred_9520 VDD.$7052.Metal2 vin3.P38.GatPoly 0.0117555f
Cred_9521 VDD.$7052.Metal2 vin3.P39.GatPoly 5.2412e-07f
Cred_9522 VDD.$7052.Metal2 vin4.$452.Metal1 7.22429e-07f
Cred_9523 VDD.$7052.Metal2 vin4.$456.Metal1 4.73592e-06f
Cred_9524 VDD.$7052.Metal2 vin4.$644.Metal2 0.000286578f
Cred_9525 VDD.$7052.Metal2 vin4.$648.Metal2 0.000286578f
Cred_9526 VDD.$7052.Metal2 vin4.P38.GatPoly 0.0117555f
Cred_9527 VDD.$7052.Metal2 vin4.P39.GatPoly 5.2412e-07f
Cred_9528 VDD.$7052.Metal2 vout3 0.00120657f
Cred_9529 VDD.$7052.Metal2 vout3.$1424.Metal3 0.0060853f
Cred_9530 VDD.$7052.Metal2 vout3.P18.nSD 9.58681e-05f
Cred_9531 VDD.$7052.Metal2 vout3.P18.pSD 0.00344055f
Cred_9532 VDD.$7052.Metal2 vout4 0.00120657f
Cred_9533 VDD.$7052.Metal2 vout4.$1424.Metal3 0.0060853f
Cred_9534 VDD.$7052.Metal2 vout4.P18.nSD 9.58681e-05f
Cred_9535 VDD.$7052.Metal2 vout4.P18.pSD 0.00344055f
Cred_9536 VDD.$706.Metal1 vin1.$15.GatPoly 0.0263169f
Cred_9537 VDD.$706.Metal1 vin1.$17.GatPoly 0.00694255f
Cred_9538 VDD.$706.Metal1 vin1.$207.Metal1 0.00682577f
Cred_9539 VDD.$706.Metal1 vin1.$211.Metal1 0.0154163f
Cred_9540 VDD.$706.Metal1 vin1.$219.Metal1 0.00233656f
Cred_9541 VDD.$706.Metal1 vin1.$484.Metal2 0.00944382f
Cred_9542 VDD.$706.Metal1 vin1.$486.Metal2 0.0014622f
Cred_9543 VDD.$706.Metal1 vin1.$489.Metal2 0.0118837f
Cred_9544 VDD.$706.Metal1 vin1.$493.Metal2 5.72493e-06f
Cred_9545 VDD.$706.Metal1 vin1.$9.GatPoly 0.0239497f
Cred_9546 VDD.$706.Metal1 vin1.P20.GatPoly 0.00114336f
Cred_9547 VDD.$706.Metal1 vin1.P21.GatPoly 0.142507f
Cred_9548 VDD.$706.Metal1 vin1.P22.GatPoly 0.139279f
Cred_9549 VDD.$706.Metal1 vin1.P23.GatPoly 0.00105302f
Cred_9550 VDD.$706.Metal1 vin2.$14.GatPoly 0.0263169f
Cred_9551 VDD.$706.Metal1 vin2.$16.GatPoly 0.00694255f
Cred_9552 VDD.$706.Metal1 vin2.$206.Metal1 0.00682577f
Cred_9553 VDD.$706.Metal1 vin2.$210.Metal1 0.0154163f
Cred_9554 VDD.$706.Metal1 vin2.$218.Metal1 0.00233656f
Cred_9555 VDD.$706.Metal1 vin2.$483.Metal2 0.00944382f
Cred_9556 VDD.$706.Metal1 vin2.$486.Metal2 0.0014622f
Cred_9557 VDD.$706.Metal1 vin2.$488.Metal2 0.0118837f
Cred_9558 VDD.$706.Metal1 vin2.$492.Metal2 5.72493e-06f
Cred_9559 VDD.$706.Metal1 vin2.$8.GatPoly 0.0239497f
Cred_9560 VDD.$706.Metal1 vin2.P20.GatPoly 0.00114336f
Cred_9561 VDD.$706.Metal1 vin2.P21.GatPoly 0.142913f
Cred_9562 VDD.$706.Metal1 vin2.P22.GatPoly 0.138873f
Cred_9563 VDD.$706.Metal1 vin2.P23.GatPoly 0.00105302f
Cred_9564 VDD.$706.Metal1 vout1.$1226.Metal3 0.143778f
Cred_9565 VDD.$706.Metal1 vout1.P0.nSD 0.00317598f
Cred_9566 VDD.$706.Metal1 vout1.P0.pSD 0.0688659f
Cred_9567 VDD.$706.Metal1 vout1.P2.nSD 0.00226509f
Cred_9568 VDD.$706.Metal1 vout1.P2.pSD 0.0574669f
Cred_9569 VDD.$706.Metal1 vout2.$1226.Metal3 0.143357f
Cred_9570 VDD.$706.Metal1 vout2.P0.nSD 0.00317323f
Cred_9571 VDD.$706.Metal1 vout2.P0.pSD 0.0692895f
Cred_9572 VDD.$706.Metal1 vout2.P2.nSD 0.00225846f
Cred_9573 VDD.$706.Metal1 vout2.P2.pSD 0.0570114f
Cred_9574 VDD.$707.Metal1 vin3.$15.GatPoly 0.0263169f
Cred_9575 VDD.$707.Metal1 vin3.$17.GatPoly 0.00694255f
Cred_9576 VDD.$707.Metal1 vin3.$207.Metal1 0.00682577f
Cred_9577 VDD.$707.Metal1 vin3.$211.Metal1 0.0154163f
Cred_9578 VDD.$707.Metal1 vin3.$219.Metal1 0.00233656f
Cred_9579 VDD.$707.Metal1 vin3.$484.Metal2 0.00944382f
Cred_9580 VDD.$707.Metal1 vin3.$486.Metal2 0.0014622f
Cred_9581 VDD.$707.Metal1 vin3.$489.Metal2 0.0118837f
Cred_9582 VDD.$707.Metal1 vin3.$493.Metal2 5.72493e-06f
Cred_9583 VDD.$707.Metal1 vin3.$9.GatPoly 0.0239497f
Cred_9584 VDD.$707.Metal1 vin3.P20.GatPoly 0.00114336f
Cred_9585 VDD.$707.Metal1 vin3.P21.GatPoly 0.142507f
Cred_9586 VDD.$707.Metal1 vin3.P22.GatPoly 0.139279f
Cred_9587 VDD.$707.Metal1 vin3.P23.GatPoly 0.00105302f
Cred_9588 VDD.$707.Metal1 vin4.$14.GatPoly 0.0263169f
Cred_9589 VDD.$707.Metal1 vin4.$16.GatPoly 0.00694255f
Cred_9590 VDD.$707.Metal1 vin4.$206.Metal1 0.00682577f
Cred_9591 VDD.$707.Metal1 vin4.$210.Metal1 0.0154163f
Cred_9592 VDD.$707.Metal1 vin4.$218.Metal1 0.00233656f
Cred_9593 VDD.$707.Metal1 vin4.$483.Metal2 0.00944382f
Cred_9594 VDD.$707.Metal1 vin4.$486.Metal2 0.0014622f
Cred_9595 VDD.$707.Metal1 vin4.$488.Metal2 0.0118837f
Cred_9596 VDD.$707.Metal1 vin4.$492.Metal2 5.72493e-06f
Cred_9597 VDD.$707.Metal1 vin4.$8.GatPoly 0.0239497f
Cred_9598 VDD.$707.Metal1 vin4.P20.GatPoly 0.00114336f
Cred_9599 VDD.$707.Metal1 vin4.P21.GatPoly 0.142913f
Cred_9600 VDD.$707.Metal1 vin4.P22.GatPoly 0.138873f
Cred_9601 VDD.$707.Metal1 vin4.P23.GatPoly 0.00105302f
Cred_9602 VDD.$707.Metal1 vout3.$1226.Metal3 0.143642f
Cred_9603 VDD.$707.Metal1 vout3.P0.nSD 0.00317194f
Cred_9604 VDD.$707.Metal1 vout3.P0.pSD 0.0688445f
Cred_9605 VDD.$707.Metal1 vout3.P2.nSD 0.00226295f
Cred_9606 VDD.$707.Metal1 vout3.P2.pSD 0.0574552f
Cred_9607 VDD.$707.Metal1 vout4.$1226.Metal3 0.143493f
Cred_9608 VDD.$707.Metal1 vout4.P0.nSD 0.00317727f
Cred_9609 VDD.$707.Metal1 vout4.P0.pSD 0.069311f
Cred_9610 VDD.$707.Metal1 vout4.P2.nSD 0.00226059f
Cred_9611 VDD.$707.Metal1 vout4.P2.pSD 0.0570231f
Cred_9612 VDD.$7088.Metal2 vin1.$179.GatPoly 3.3467e-07f
Cred_9613 VDD.$7088.Metal2 vin1.$457.Metal1 1.77384e-05f
Cred_9614 VDD.$7088.Metal2 vin1.$649.Metal2 3.76872e-07f
Cred_9615 VDD.$7088.Metal2 vin1.$654.Metal2 0.00109086f
Cred_9616 VDD.$7088.Metal2 vin1.P39.GatPoly 0.010089f
Cred_9617 VDD.$7088.Metal2 vin2.$178.GatPoly 3.3467e-07f
Cred_9618 VDD.$7088.Metal2 vin2.$456.Metal1 1.77384e-05f
Cred_9619 VDD.$7088.Metal2 vin2.$648.Metal2 3.76872e-07f
Cred_9620 VDD.$7088.Metal2 vin2.$653.Metal2 0.00109086f
Cred_9621 VDD.$7088.Metal2 vin2.P39.GatPoly 0.010089f
Cred_9622 VDD.$7088.Metal2 vout1 0.000783469f
Cred_9623 VDD.$7088.Metal2 vout1.$1424.Metal3 0.00395141f
Cred_9624 VDD.$7088.Metal2 vout1.P18.nSD 6.22507e-05f
Cred_9625 VDD.$7088.Metal2 vout1.P18.pSD 0.00201524f
Cred_9626 VDD.$7088.Metal2 vout2 0.000783469f
Cred_9627 VDD.$7088.Metal2 vout2.$1424.Metal3 0.00395141f
Cred_9628 VDD.$7088.Metal2 vout2.P18.nSD 6.22507e-05f
Cred_9629 VDD.$7088.Metal2 vout2.P18.pSD 0.00201524f
Cred_9630 VDD.$7100.Metal2 vin3.$179.GatPoly 3.3467e-07f
Cred_9631 VDD.$7100.Metal2 vin3.$457.Metal1 1.77384e-05f
Cred_9632 VDD.$7100.Metal2 vin3.$649.Metal2 3.76872e-07f
Cred_9633 VDD.$7100.Metal2 vin3.$654.Metal2 0.00109086f
Cred_9634 VDD.$7100.Metal2 vin3.P39.GatPoly 0.010089f
Cred_9635 VDD.$7100.Metal2 vin4.$178.GatPoly 3.3467e-07f
Cred_9636 VDD.$7100.Metal2 vin4.$456.Metal1 1.77384e-05f
Cred_9637 VDD.$7100.Metal2 vin4.$648.Metal2 3.76872e-07f
Cred_9638 VDD.$7100.Metal2 vin4.$653.Metal2 0.00109086f
Cred_9639 VDD.$7100.Metal2 vin4.P39.GatPoly 0.010089f
Cred_9640 VDD.$7100.Metal2 vout3 0.000783469f
Cred_9641 VDD.$7100.Metal2 vout3.$1424.Metal3 0.00395141f
Cred_9642 VDD.$7100.Metal2 vout3.P18.nSD 6.22507e-05f
Cred_9643 VDD.$7100.Metal2 vout3.P18.pSD 0.00201524f
Cred_9644 VDD.$7100.Metal2 vout4 0.000783469f
Cred_9645 VDD.$7100.Metal2 vout4.$1424.Metal3 0.00395141f
Cred_9646 VDD.$7100.Metal2 vout4.P18.nSD 6.22507e-05f
Cred_9647 VDD.$7100.Metal2 vout4.P18.pSD 0.00201524f
Cred_9648 VDD.$7112.Metal2 vin1.P39.GatPoly 0.0109281f
Cred_9649 VDD.$7112.Metal2 vin2.P39.GatPoly 0.0109281f
Cred_9650 VDD.$7112.Metal2 vout1 1.37031e-06f
Cred_9651 VDD.$7112.Metal2 vout1.$1424.Metal3 6.91113e-06f
Cred_9652 VDD.$7112.Metal2 vout1.P18.nSD 1.08878e-07f
Cred_9653 VDD.$7112.Metal2 vout1.P18.pSD 2.45063e-06f
Cred_9654 VDD.$7112.Metal2 vout2 1.37031e-06f
Cred_9655 VDD.$7112.Metal2 vout2.$1424.Metal3 6.91113e-06f
Cred_9656 VDD.$7112.Metal2 vout2.P18.nSD 1.08878e-07f
Cred_9657 VDD.$7112.Metal2 vout2.P18.pSD 2.45063e-06f
Cred_9658 VDD.$7124.Metal2 vin3.P39.GatPoly 0.0109281f
Cred_9659 VDD.$7124.Metal2 vin4.P39.GatPoly 0.0109281f
Cred_9660 VDD.$7124.Metal2 vout3 1.37031e-06f
Cred_9661 VDD.$7124.Metal2 vout3.$1424.Metal3 6.91113e-06f
Cred_9662 VDD.$7124.Metal2 vout3.P18.nSD 1.08878e-07f
Cred_9663 VDD.$7124.Metal2 vout3.P18.pSD 2.45063e-06f
Cred_9664 VDD.$7124.Metal2 vout4 1.37031e-06f
Cred_9665 VDD.$7124.Metal2 vout4.$1424.Metal3 6.91113e-06f
Cred_9666 VDD.$7124.Metal2 vout4.P18.nSD 1.08878e-07f
Cred_9667 VDD.$7124.Metal2 vout4.P18.pSD 2.45063e-06f
Cred_9668 VDD.$7136.Metal2 vin1.P39.GatPoly 0.00247486f
Cred_9669 VDD.$7138.Metal2 vin1.P39.GatPoly 1.17668e-06f
Cred_9670 VDD.$7138.Metal2 vin2.P39.GatPoly 1.17668e-06f
Cred_9671 VDD.$7140.Metal2 vin1.P39.GatPoly 2.58222e-06f
Cred_9672 VDD.$7140.Metal2 vin2.P39.GatPoly 2.58222e-06f
Cred_9673 VDD.$7146.Metal2 vin2.P39.GatPoly 0.00247486f
Cred_9674 VDD.$7148.Metal2 vin3.P39.GatPoly 0.00247486f
Cred_9675 VDD.$7150.Metal2 vin3.P39.GatPoly 1.17668e-06f
Cred_9676 VDD.$7150.Metal2 vin4.P39.GatPoly 1.17668e-06f
Cred_9677 VDD.$7152.Metal2 vin3.P39.GatPoly 2.58222e-06f
Cred_9678 VDD.$7152.Metal2 vin4.P39.GatPoly 2.58222e-06f
Cred_9679 VDD.$7158.Metal2 vin4.P39.GatPoly 0.00247486f
Cred_9680 VDD.$7169.Metal2 vin1.$179.GatPoly 0.00149547f
Cred_9681 VDD.$7169.Metal2 vin1.$457.Metal1 0.0131748f
Cred_9682 VDD.$7169.Metal2 vin1.$649.Metal2 0.000278955f
Cred_9683 VDD.$7169.Metal2 vin1.$654.Metal2 0.00138401f
Cred_9684 VDD.$7169.Metal2 vin1.P39.GatPoly 0.0380165f
Cred_9685 VDD.$7169.Metal2 vout1 0.0288948f
Cred_9686 VDD.$7169.Metal2 vout1.$1424.Metal3 0.14573f
Cred_9687 VDD.$7169.Metal2 vout1.P18.nSD 0.00229584f
Cred_9688 VDD.$7169.Metal2 vout1.P18.pSD 0.0472756f
Cred_9689 VDD.$7169.Metal2 VSS.$1989.Metal1 0.000211317f
Cred_9690 VDD.$7169.Metal2 VSS.$2020.Metal1 0.00184499f
Cred_9691 VDD.$7169.Metal2 VSS.$29.Metal1 2.4571e-07f
Cred_9692 VDD.$7169.Metal2 VSS.$4227.Metal2 0.0224194f
Cred_9693 VDD.$7169.Metal2 VSS.P1.pSD 0.00118668f
Cred_9694 VDD.$7169.Metal2 VSS.P45.nSD 5.55726e-06f
Cred_9695 VDD.$7169.Metal2 VSS.P47.nSD 5.55726e-06f
Cred_9696 VDD.$7171.Metal2 vin1.P39.GatPoly 0.00963863f
Cred_9697 VDD.$7171.Metal2 vout1 0.00988406f
Cred_9698 VDD.$7171.Metal2 vout1.$1424.Metal3 0.04985f
Cred_9699 VDD.$7171.Metal2 vout1.P18.nSD 0.000785341f
Cred_9700 VDD.$7171.Metal2 vout1.P18.pSD 0.0136683f
Cred_9701 VDD.$7173.Metal2 vin1.P39.GatPoly 0.00720482f
Cred_9702 VDD.$7173.Metal2 vout1 0.00329342f
Cred_9703 VDD.$7173.Metal2 vout1.$1424.Metal3 0.0166103f
Cred_9704 VDD.$7173.Metal2 vout1.P18.nSD 0.000261679f
Cred_9705 VDD.$7173.Metal2 vout1.P18.pSD 0.00801239f
Cred_9706 VDD.$7174.Metal2 vin1.P39.GatPoly 0.0048263f
Cred_9707 VDD.$7174.Metal2 vout1 0.00216493f
Cred_9708 VDD.$7174.Metal2 vout1.$1424.Metal3 0.0109188f
Cred_9709 VDD.$7174.Metal2 vout1.P18.nSD 0.000172015f
Cred_9710 VDD.$7174.Metal2 vout1.P18.pSD 0.00534821f
Cred_9711 VDD.$7175.Metal2 vin1.P39.GatPoly 0.00834493f
Cred_9712 VDD.$7175.Metal2 vout1 0.00269763f
Cred_9713 VDD.$7175.Metal2 vout1.$1424.Metal3 0.0136054f
Cred_9714 VDD.$7175.Metal2 vout1.P18.nSD 0.000214341f
Cred_9715 VDD.$7175.Metal2 vout1.P18.pSD 0.00680704f
Cred_9716 VDD.$7176.Metal2 vin2.P39.GatPoly 0.0107059f
Cred_9717 VDD.$7176.Metal2 vout2 0.00377621f
Cred_9718 VDD.$7176.Metal2 vout2.$1424.Metal3 0.0190452f
Cred_9719 VDD.$7176.Metal2 vout2.P18.nSD 0.00030004f
Cred_9720 VDD.$7176.Metal2 vout2.P18.pSD 0.00946613f
Cred_9721 VDD.$7178.Metal2 vin2.P39.GatPoly 0.00960678f
Cred_9722 VDD.$7178.Metal2 vout2 0.00437326f
Cred_9723 VDD.$7178.Metal2 vout2.$1424.Metal3 0.0220564f
Cred_9724 VDD.$7178.Metal2 vout2.P18.nSD 0.000347479f
Cred_9725 VDD.$7178.Metal2 vout2.P18.pSD 0.0106794f
Cred_9726 VDD.$7180.Metal2 vin2.P39.GatPoly 0.0120249f
Cred_9727 VDD.$7180.Metal2 vout2 0.011795f
Cred_9728 VDD.$7180.Metal2 vout2.$1424.Metal3 0.059488f
Cred_9729 VDD.$7180.Metal2 vout2.P18.nSD 0.000937177f
Cred_9730 VDD.$7180.Metal2 vout2.P18.pSD 0.0168327f
Cred_9731 VDD.$7183.Metal2 vin2.P39.GatPoly 0.0143912f
Cred_9732 VDD.$7183.Metal2 vout2 0.00989559f
Cred_9733 VDD.$7183.Metal2 vout2.$1424.Metal3 0.0499082f
Cred_9734 VDD.$7183.Metal2 vout2.P18.nSD 0.000786257f
Cred_9735 VDD.$7183.Metal2 vout2.P18.pSD 0.0169209f
Cred_9736 VDD.$7186.Metal2 vin2.$178.GatPoly 0.00118397f
Cred_9737 VDD.$7186.Metal2 vin2.$456.Metal1 0.0104306f
Cred_9738 VDD.$7186.Metal2 vin2.$648.Metal2 0.000220851f
Cred_9739 VDD.$7186.Metal2 vin2.$653.Metal2 0.00109573f
Cred_9740 VDD.$7186.Metal2 vin2.P39.GatPoly 0.0145668f
Cred_9741 VDD.$7186.Metal2 vout2 0.0164538f
Cred_9742 VDD.$7186.Metal2 vout2.$1424.Metal3 0.0829842f
Cred_9743 VDD.$7186.Metal2 vout2.P18.nSD 0.00130734f
Cred_9744 VDD.$7186.Metal2 vout2.P18.pSD 0.0259715f
Cred_9745 VDD.$7186.Metal2 VSS.$1990.Metal1 0.000522367f
Cred_9746 VDD.$7186.Metal2 VSS.$2021.Metal1 0.00138496f
Cred_9747 VDD.$7186.Metal2 VSS.$4164.Metal2 0.0242311f
Cred_9748 VDD.$7186.Metal2 VSS.$68.Metal1 1.30631e-07f
Cred_9749 VDD.$7186.Metal2 VSS.P3.pSD 0.00104071f
Cred_9750 VDD.$7186.Metal2 VSS.P93.nSD 6.06404e-06f
Cred_9751 VDD.$7186.Metal2 VSS.P95.nSD 6.06404e-06f
Cred_9752 VDD.$7197.Metal2 vin3.$179.GatPoly 0.00149547f
Cred_9753 VDD.$7197.Metal2 vin3.$457.Metal1 0.0131748f
Cred_9754 VDD.$7197.Metal2 vin3.$649.Metal2 0.000278955f
Cred_9755 VDD.$7197.Metal2 vin3.$654.Metal2 0.00138401f
Cred_9756 VDD.$7197.Metal2 vin3.P39.GatPoly 0.0380165f
Cred_9757 VDD.$7197.Metal2 vout3 0.028138f
Cred_9758 VDD.$7197.Metal2 vout3.$1424.Metal3 0.141913f
Cred_9759 VDD.$7197.Metal2 vout3.P18.nSD 0.00223571f
Cred_9760 VDD.$7197.Metal2 vout3.P18.pSD 0.0469499f
Cred_9761 VDD.$7197.Metal2 VSS.$1990.Metal1 0.000582227f
Cred_9762 VDD.$7197.Metal2 VSS.$2022.Metal1 0.0012832f
Cred_9763 VDD.$7197.Metal2 VSS.$4174.Metal2 0.0224506f
Cred_9764 VDD.$7197.Metal2 VSS.$68.Metal1 1.89019e-07f
Cred_9765 VDD.$7197.Metal2 VSS.P2.pSD 0.00134634f
Cred_9766 VDD.$7197.Metal2 VSS.P69.nSD 5.61846e-06f
Cred_9767 VDD.$7197.Metal2 VSS.P71.nSD 5.61846e-06f
Cred_9768 VDD.$7199.Metal2 vin3.P39.GatPoly 0.00963863f
Cred_9769 VDD.$7199.Metal2 vout3 0.00912729f
Cred_9770 VDD.$7199.Metal2 vout3.$1424.Metal3 0.0460333f
Cred_9771 VDD.$7199.Metal2 vout3.P18.nSD 0.000725211f
Cred_9772 VDD.$7199.Metal2 vout3.P18.pSD 0.0133426f
Cred_9773 VDD.$7201.Metal2 vin3.P39.GatPoly 0.00720482f
Cred_9774 VDD.$7201.Metal2 vout3 0.00329342f
Cred_9775 VDD.$7201.Metal2 vout3.$1424.Metal3 0.0166103f
Cred_9776 VDD.$7201.Metal2 vout3.P18.nSD 0.000261679f
Cred_9777 VDD.$7201.Metal2 vout3.P18.pSD 0.00801239f
Cred_9778 VDD.$7202.Metal2 vin3.P39.GatPoly 0.0048263f
Cred_9779 VDD.$7202.Metal2 vout3 0.00216493f
Cred_9780 VDD.$7202.Metal2 vout3.$1424.Metal3 0.0109188f
Cred_9781 VDD.$7202.Metal2 vout3.P18.nSD 0.000172015f
Cred_9782 VDD.$7202.Metal2 vout3.P18.pSD 0.00534821f
Cred_9783 VDD.$7203.Metal2 vin3.P39.GatPoly 0.00834493f
Cred_9784 VDD.$7203.Metal2 vout3 0.00269763f
Cred_9785 VDD.$7203.Metal2 vout3.$1424.Metal3 0.0136054f
Cred_9786 VDD.$7203.Metal2 vout3.P18.nSD 0.000214341f
Cred_9787 VDD.$7203.Metal2 vout3.P18.pSD 0.00680704f
Cred_9788 VDD.$7204.Metal2 vin4.P39.GatPoly 0.0107059f
Cred_9789 VDD.$7204.Metal2 vout4 0.00377621f
Cred_9790 VDD.$7204.Metal2 vout4.$1424.Metal3 0.0190452f
Cred_9791 VDD.$7204.Metal2 vout4.P18.nSD 0.00030004f
Cred_9792 VDD.$7204.Metal2 vout4.P18.pSD 0.00946613f
Cred_9793 VDD.$7206.Metal2 vin4.P39.GatPoly 0.00960678f
Cred_9794 VDD.$7206.Metal2 vout4 0.00437326f
Cred_9795 VDD.$7206.Metal2 vout4.$1424.Metal3 0.0220564f
Cred_9796 VDD.$7206.Metal2 vout4.P18.nSD 0.000347479f
Cred_9797 VDD.$7206.Metal2 vout4.P18.pSD 0.0106794f
Cred_9798 VDD.$7208.Metal2 vin4.P39.GatPoly 0.0120249f
Cred_9799 VDD.$7208.Metal2 vout4 0.0128025f
Cred_9800 VDD.$7208.Metal2 vout4.$1424.Metal3 0.0645693f
Cred_9801 VDD.$7208.Metal2 vout4.P18.nSD 0.00101723f
Cred_9802 VDD.$7208.Metal2 vout4.P18.pSD 0.0172662f
Cred_9803 VDD.$7211.Metal2 vin4.P39.GatPoly 0.0143912f
Cred_9804 VDD.$7211.Metal2 vout4 0.0103982f
Cred_9805 VDD.$7211.Metal2 vout4.$1424.Metal3 0.0524431f
Cred_9806 VDD.$7211.Metal2 vout4.P18.nSD 0.000826192f
Cred_9807 VDD.$7211.Metal2 vout4.P18.pSD 0.0171372f
Cred_9808 VDD.$7214.Metal2 vin4.$178.GatPoly 0.00118397f
Cred_9809 VDD.$7214.Metal2 vin4.$456.Metal1 0.0104306f
Cred_9810 VDD.$7214.Metal2 vin4.$648.Metal2 0.000220851f
Cred_9811 VDD.$7214.Metal2 vin4.$653.Metal2 0.00109573f
Cred_9812 VDD.$7214.Metal2 vin4.P39.GatPoly 0.0145668f
Cred_9813 VDD.$7214.Metal2 vout4 0.0164538f
Cred_9814 VDD.$7214.Metal2 vout4.$1424.Metal3 0.0829842f
Cred_9815 VDD.$7214.Metal2 vout4.P18.nSD 0.00130734f
Cred_9816 VDD.$7214.Metal2 vout4.P18.pSD 0.0259715f
Cred_9817 VDD.$7214.Metal2 VSS.$1991.Metal1 0.000189591f
Cred_9818 VDD.$7214.Metal2 VSS.$2023.Metal1 0.00189495f
Cred_9819 VDD.$7214.Metal2 VSS.$4241.Metal2 0.0241972f
Cred_9820 VDD.$7214.Metal2 VSS.$66.Metal1 1.66734e-07f
Cred_9821 VDD.$7214.Metal2 VSS.P0.pSD 0.00089748f
Cred_9822 VDD.$7214.Metal2 VSS.P21.nSD 5.99799e-06f
Cred_9823 VDD.$7214.Metal2 VSS.P23.nSD 5.99799e-06f
Cred_9824 VDD.$7478.Metal3 vin1 0.00261506f
Cred_9825 VDD.$7478.Metal3 vin1.$202.Metal1 3.31212e-05f
Cred_9826 VDD.$7478.Metal3 vin1.$203.Metal1 9.97974e-05f
Cred_9827 VDD.$7478.Metal3 vin1.$477.Metal2 0.000432434f
Cred_9828 VDD.$7478.Metal3 vin1.$479.Metal2 0.000385026f
Cred_9829 VDD.$7478.Metal3 vin1.$480.Metal2 0.000422786f
Cred_9830 VDD.$7478.Metal3 vin1.$6.GatPoly 3.31934e-06f
Cred_9831 VDD.$7478.Metal3 vin1.$9.GatPoly 8.85347e-06f
Cred_9832 VDD.$7478.Metal3 vin1.P0.GatPoly 0.000138601f
Cred_9833 VDD.$7478.Metal3 vin1.P1.GatPoly 3.42585e-05f
Cred_9834 VDD.$7478.Metal3 vin1.P20.GatPoly 0.000386863f
Cred_9835 VDD.$7478.Metal3 vin2 0.000860298f
Cred_9836 VDD.$7478.Metal3 vin2.$202.Metal1 2.81868e-05f
Cred_9837 VDD.$7478.Metal3 vin2.$477.Metal2 1.00716e-06f
Cred_9838 VDD.$7478.Metal3 vin2.$479.Metal2 2.47167e-06f
Cred_9839 VDD.$7478.Metal3 vin2.$8.GatPoly 3.19293e-06f
Cred_9840 VDD.$7478.Metal3 vin2.P20.GatPoly 0.000357182f
Cred_9841 VDD.$7478.Metal3 vout1.$1226.Metal3 2.63142e-05f
Cred_9842 VDD.$7478.Metal3 vout1.P0.nSD 1.32182e-06f
Cred_9843 VDD.$7478.Metal3 vout1.P0.pSD 4.16368e-06f
Cred_9844 VDD.$7478.Metal3 vout1.P2.nSD 4.14556e-07f
Cred_9845 VDD.$7478.Metal3 vout1.P2.pSD 2.26564e-06f
Cred_9846 VDD.$7478.Metal3 VSS 0.0567383f
Cred_9847 VDD.$7478.Metal3 VSS.$157.Metal1 3.96845e-05f
Cred_9848 VDD.$7478.Metal3 VSS.$173.Metal1 8.26812e-08f
Cred_9849 VDD.$7478.Metal3 VSS.$1989.Metal1 3.37107e-09f
Cred_9850 VDD.$7478.Metal3 VSS.$2020.Metal1 8.44049e-09f
Cred_9851 VDD.$7478.Metal3 VSS.$2226.Metal2 0.000954357f
Cred_9852 VDD.$7478.Metal3 VSS.$2286.Metal2 7.71885e-05f
Cred_9853 VDD.$7478.Metal3 VSS.$2342.Metal2 4.26586e-05f
Cred_9854 VDD.$7478.Metal3 VSS.$2403.Metal2 3.22132e-05f
Cred_9855 VDD.$7478.Metal3 VSS.$2427.Metal2 3.17041e-05f
Cred_9856 VDD.$7478.Metal3 VSS.$2475.Metal2 4.19151e-05f
Cred_9857 VDD.$7478.Metal3 VSS.$25.Metal1 2.71638e-05f
Cred_9858 VDD.$7478.Metal3 VSS.$2526.Metal2 5.05289e-05f
Cred_9859 VDD.$7478.Metal3 VSS.$2558.Metal2 4.50997e-05f
Cred_9860 VDD.$7478.Metal3 VSS.$257.Metal1 8.74646e-08f
Cred_9861 VDD.$7478.Metal3 VSS.$29.Metal1 3.07641e-05f
Cred_9862 VDD.$7478.Metal3 VSS.$317.Metal1 8.33177e-08f
Cred_9863 VDD.$7478.Metal3 VSS.$365.Metal1 8.33177e-08f
Cred_9864 VDD.$7478.Metal3 VSS.$385.Metal1 3.34117e-06f
Cred_9865 VDD.$7478.Metal3 VSS.$4227.Metal2 2.25977e-11f
Cred_9866 VDD.$7478.Metal3 VSS.$4355.Metal3 0.00775945f
Cred_9867 VDD.$7478.Metal3 VSS.$4358.Metal3 2.35872e-05f
Cred_9868 VDD.$7478.Metal3 VSS.$4364.Metal3 1.04883e-08f
Cred_9869 VDD.$7478.Metal3 VSS.$4391.Metal3 0.00014733f
Cred_9870 VDD.$7478.Metal3 VSS.$4415.Metal3 0.000134553f
Cred_9871 VDD.$7478.Metal3 VSS.$4451.Metal3 0.000113595f
Cred_9872 VDD.$7478.Metal3 VSS.$4475.Metal3 0.000112947f
Cred_9873 VDD.$7478.Metal3 VSS.$4511.Metal3 4.39224e-05f
Cred_9874 VDD.$7478.Metal3 VSS.P1.pSD 5.53501e-05f
Cred_9875 VDD.$7478.Metal3 VSS.P2.GatPoly 3.81789e-05f
Cred_9876 VDD.$7478.Metal3 VSS.P24.nSD 1.55645e-07f
Cred_9877 VDD.$7478.Metal3 VSS.P25.nSD 1.55645e-07f
Cred_9878 VDD.$7478.Metal3 VSS.P27.nSD 1.14652e-07f
Cred_9879 VDD.$7484.Metal3 vin3 0.000860298f
Cred_9880 VDD.$7484.Metal3 vin3.$203.Metal1 2.81868e-05f
Cred_9881 VDD.$7484.Metal3 vin3.$477.Metal2 1.00716e-06f
Cred_9882 VDD.$7484.Metal3 vin3.$480.Metal2 2.47167e-06f
Cred_9883 VDD.$7484.Metal3 vin3.$9.GatPoly 3.19293e-06f
Cred_9884 VDD.$7484.Metal3 vin3.P20.GatPoly 0.000357182f
Cred_9885 VDD.$7484.Metal3 vin4 0.00261506f
Cred_9886 VDD.$7484.Metal3 vin4.$202.Metal1 9.97974e-05f
Cred_9887 VDD.$7484.Metal3 vin4.$203.Metal1 3.31212e-05f
Cred_9888 VDD.$7484.Metal3 vin4.$477.Metal2 0.000432434f
Cred_9889 VDD.$7484.Metal3 vin4.$479.Metal2 0.000422786f
Cred_9890 VDD.$7484.Metal3 vin4.$480.Metal2 0.000385026f
Cred_9891 VDD.$7484.Metal3 vin4.$7.GatPoly 3.31934e-06f
Cred_9892 VDD.$7484.Metal3 vin4.$8.GatPoly 8.85347e-06f
Cred_9893 VDD.$7484.Metal3 vin4.P0.GatPoly 0.000138601f
Cred_9894 VDD.$7484.Metal3 vin4.P1.GatPoly 3.42585e-05f
Cred_9895 VDD.$7484.Metal3 vin4.P20.GatPoly 0.000386863f
Cred_9896 VDD.$7484.Metal3 vout4.$1226.Metal3 2.63142e-05f
Cred_9897 VDD.$7484.Metal3 vout4.P0.nSD 1.32182e-06f
Cred_9898 VDD.$7484.Metal3 vout4.P0.pSD 4.16368e-06f
Cred_9899 VDD.$7484.Metal3 vout4.P2.nSD 4.14556e-07f
Cred_9900 VDD.$7484.Metal3 vout4.P2.pSD 2.26564e-06f
Cred_9901 VDD.$7484.Metal3 VSS 0.0567383f
Cred_9902 VDD.$7484.Metal3 VSS.$160.Metal1 3.96845e-05f
Cred_9903 VDD.$7484.Metal3 VSS.$182.Metal1 8.26812e-08f
Cred_9904 VDD.$7484.Metal3 VSS.$1991.Metal1 3.37107e-09f
Cred_9905 VDD.$7484.Metal3 VSS.$2023.Metal1 8.44049e-09f
Cred_9906 VDD.$7484.Metal3 VSS.$2240.Metal2 0.000954357f
Cred_9907 VDD.$7484.Metal3 VSS.$2306.Metal2 7.71885e-05f
Cred_9908 VDD.$7484.Metal3 VSS.$2360.Metal2 4.26586e-05f
Cred_9909 VDD.$7484.Metal3 VSS.$2421.Metal2 3.22132e-05f
Cred_9910 VDD.$7484.Metal3 VSS.$2445.Metal2 3.17041e-05f
Cred_9911 VDD.$7484.Metal3 VSS.$2493.Metal2 4.19151e-05f
Cred_9912 VDD.$7484.Metal3 VSS.$2544.Metal2 5.05289e-05f
Cred_9913 VDD.$7484.Metal3 VSS.$2576.Metal2 4.50997e-05f
Cred_9914 VDD.$7484.Metal3 VSS.$266.Metal1 8.74646e-08f
Cred_9915 VDD.$7484.Metal3 VSS.$27.Metal1 2.71638e-05f
Cred_9916 VDD.$7484.Metal3 VSS.$326.Metal1 8.33177e-08f
Cred_9917 VDD.$7484.Metal3 VSS.$374.Metal1 8.33177e-08f
Cred_9918 VDD.$7484.Metal3 VSS.$387.Metal1 3.34117e-06f
Cred_9919 VDD.$7484.Metal3 VSS.$4241.Metal2 2.25977e-11f
Cred_9920 VDD.$7484.Metal3 VSS.$4355.Metal3 1.04883e-08f
Cred_9921 VDD.$7484.Metal3 VSS.$4358.Metal3 2.35872e-05f
Cred_9922 VDD.$7484.Metal3 VSS.$4364.Metal3 0.00775945f
Cred_9923 VDD.$7484.Metal3 VSS.$4400.Metal3 0.00014733f
Cred_9924 VDD.$7484.Metal3 VSS.$4424.Metal3 0.000134553f
Cred_9925 VDD.$7484.Metal3 VSS.$4460.Metal3 0.000113595f
Cred_9926 VDD.$7484.Metal3 VSS.$4484.Metal3 0.000112947f
Cred_9927 VDD.$7484.Metal3 VSS.$4520.Metal3 4.39224e-05f
Cred_9928 VDD.$7484.Metal3 VSS.$66.Metal1 3.07641e-05f
Cred_9929 VDD.$7484.Metal3 VSS.P0.GatPoly 3.81789e-05f
Cred_9930 VDD.$7484.Metal3 VSS.P0.nSD 1.55645e-07f
Cred_9931 VDD.$7484.Metal3 VSS.P0.pSD 5.53501e-05f
Cred_9932 VDD.$7484.Metal3 VSS.P1.nSD 1.55645e-07f
Cred_9933 VDD.$7484.Metal3 VSS.P3.nSD 1.14652e-07f
Cred_9934 VDD.$7538.Metal3 vin1.P20.GatPoly 0.0071917f
Cred_9935 VDD.$7538.Metal3 vin2.P20.GatPoly 0.0071917f
Cred_9936 VDD.$7544.Metal3 vin3.P20.GatPoly 0.0071917f
Cred_9937 VDD.$7544.Metal3 vin4.P20.GatPoly 0.0071917f
Cred_9938 VDD.$7562.Metal3 vin1.$203.Metal1 1.70805e-07f
Cred_9939 VDD.$7562.Metal3 vin1.$477.Metal2 1.47923e-06f
Cred_9940 VDD.$7562.Metal3 vin1.$480.Metal2 2.75727e-06f
Cred_9941 VDD.$7562.Metal3 vin1.$9.GatPoly 3.11243e-09f
Cred_9942 VDD.$7562.Metal3 vin1.P20.GatPoly 0.0104943f
Cred_9943 VDD.$7562.Metal3 vin2.$202.Metal1 1.70805e-07f
Cred_9944 VDD.$7562.Metal3 vin2.$477.Metal2 1.47923e-06f
Cred_9945 VDD.$7562.Metal3 vin2.$479.Metal2 2.75727e-06f
Cred_9946 VDD.$7562.Metal3 vin2.$8.GatPoly 3.11243e-09f
Cred_9947 VDD.$7562.Metal3 vin2.P20.GatPoly 0.0104943f
Cred_9948 VDD.$7562.Metal3 vout1.$1226.Metal3 0.00506622f
Cred_9949 VDD.$7562.Metal3 vout1.P0.nSD 0.000150856f
Cred_9950 VDD.$7562.Metal3 vout1.P0.pSD 0.00236294f
Cred_9951 VDD.$7562.Metal3 vout1.P2.nSD 7.98136e-05f
Cred_9952 VDD.$7562.Metal3 vout1.P2.pSD 0.0004362f
Cred_9953 VDD.$7562.Metal3 vout2.$1226.Metal3 0.00506622f
Cred_9954 VDD.$7562.Metal3 vout2.P0.nSD 0.000150856f
Cred_9955 VDD.$7562.Metal3 vout2.P0.pSD 0.00236294f
Cred_9956 VDD.$7562.Metal3 vout2.P2.nSD 7.98136e-05f
Cred_9957 VDD.$7562.Metal3 vout2.P2.pSD 0.0004362f
Cred_9958 VDD.$7568.Metal3 vin3.$203.Metal1 1.70805e-07f
Cred_9959 VDD.$7568.Metal3 vin3.$477.Metal2 1.47923e-06f
Cred_9960 VDD.$7568.Metal3 vin3.$480.Metal2 2.75727e-06f
Cred_9961 VDD.$7568.Metal3 vin3.$9.GatPoly 3.11243e-09f
Cred_9962 VDD.$7568.Metal3 vin3.P20.GatPoly 0.0104943f
Cred_9963 VDD.$7568.Metal3 vin4.$202.Metal1 1.70805e-07f
Cred_9964 VDD.$7568.Metal3 vin4.$477.Metal2 1.47923e-06f
Cred_9965 VDD.$7568.Metal3 vin4.$479.Metal2 2.75727e-06f
Cred_9966 VDD.$7568.Metal3 vin4.$8.GatPoly 3.11243e-09f
Cred_9967 VDD.$7568.Metal3 vin4.P20.GatPoly 0.0104943f
Cred_9968 VDD.$7568.Metal3 vout3.$1226.Metal3 0.00506622f
Cred_9969 VDD.$7568.Metal3 vout3.P0.nSD 0.000150856f
Cred_9970 VDD.$7568.Metal3 vout3.P0.pSD 0.00236294f
Cred_9971 VDD.$7568.Metal3 vout3.P2.nSD 7.98136e-05f
Cred_9972 VDD.$7568.Metal3 vout3.P2.pSD 0.0004362f
Cred_9973 VDD.$7568.Metal3 vout4.$1226.Metal3 0.00506622f
Cred_9974 VDD.$7568.Metal3 vout4.P0.nSD 0.000150856f
Cred_9975 VDD.$7568.Metal3 vout4.P0.pSD 0.00236294f
Cred_9976 VDD.$7568.Metal3 vout4.P2.nSD 7.98136e-05f
Cred_9977 VDD.$7568.Metal3 vout4.P2.pSD 0.0004362f
Cred_9978 VDD.$7586.Metal3 vin1.P21.GatPoly 0.00631191f
Cred_9979 VDD.$7586.Metal3 vin2.P21.GatPoly 0.00631191f
Cred_9980 VDD.$7586.Metal3 vout1.$1226.Metal3 0.00715121f
Cred_9981 VDD.$7586.Metal3 vout1.P0.nSD 0.000212941f
Cred_9982 VDD.$7586.Metal3 vout1.P0.pSD 0.00333821f
Cred_9983 VDD.$7586.Metal3 vout1.P2.nSD 0.000112661f
Cred_9984 VDD.$7586.Metal3 vout1.P2.pSD 0.000615716f
Cred_9985 VDD.$7586.Metal3 vout2.$1226.Metal3 0.00715121f
Cred_9986 VDD.$7586.Metal3 vout2.P0.nSD 0.000212941f
Cred_9987 VDD.$7586.Metal3 vout2.P0.pSD 0.00333821f
Cred_9988 VDD.$7586.Metal3 vout2.P2.nSD 0.000112661f
Cred_9989 VDD.$7586.Metal3 vout2.P2.pSD 0.000615716f
Cred_9990 VDD.$7592.Metal3 vin3.P21.GatPoly 0.00631191f
Cred_9991 VDD.$7592.Metal3 vin4.P21.GatPoly 0.00631191f
Cred_9992 VDD.$7592.Metal3 vout3.$1226.Metal3 0.00715121f
Cred_9993 VDD.$7592.Metal3 vout3.P0.nSD 0.000212941f
Cred_9994 VDD.$7592.Metal3 vout3.P0.pSD 0.00333821f
Cred_9995 VDD.$7592.Metal3 vout3.P2.nSD 0.000112661f
Cred_9996 VDD.$7592.Metal3 vout3.P2.pSD 0.000615716f
Cred_9997 VDD.$7592.Metal3 vout4.$1226.Metal3 0.00715121f
Cred_9998 VDD.$7592.Metal3 vout4.P0.nSD 0.000212941f
Cred_9999 VDD.$7592.Metal3 vout4.P0.pSD 0.00333821f
Cred_10000 VDD.$7592.Metal3 vout4.P2.nSD 0.000112661f
Cred_10001 VDD.$7592.Metal3 vout4.P2.pSD 0.000615716f
Cred_10002 VDD.$7610.Metal3 vin1.P21.GatPoly 0.00835576f
Cred_10003 VDD.$7610.Metal3 vin1.P22.GatPoly 0.00454005f
Cred_10004 VDD.$7610.Metal3 vin2.P21.GatPoly 0.00835576f
Cred_10005 VDD.$7610.Metal3 vin2.P22.GatPoly 0.00454005f
Cred_10006 VDD.$7616.Metal3 vin3.P21.GatPoly 0.00835576f
Cred_10007 VDD.$7616.Metal3 vin3.P22.GatPoly 0.00454005f
Cred_10008 VDD.$7616.Metal3 vin4.P21.GatPoly 0.00835576f
Cred_10009 VDD.$7616.Metal3 vin4.P22.GatPoly 0.00454005f
Cred_10010 VDD.$7646.Metal3 vin1.P22.GatPoly 0.0100799f
Cred_10011 VDD.$7646.Metal3 vin1.P23.GatPoly 0.00127816f
Cred_10012 VDD.$7646.Metal3 vin2.P22.GatPoly 0.0100799f
Cred_10013 VDD.$7646.Metal3 vin2.P23.GatPoly 0.00127816f
Cred_10014 VDD.$7646.Metal3 vout1.$1226.Metal3 0.00931574f
Cred_10015 VDD.$7646.Metal3 vout1.P0.nSD 0.000134907f
Cred_10016 VDD.$7646.Metal3 vout1.P0.pSD 0.000716871f
Cred_10017 VDD.$7646.Metal3 vout1.P2.nSD 0.000146761f
Cred_10018 VDD.$7646.Metal3 vout1.P2.pSD 0.00299318f
Cred_10019 VDD.$7646.Metal3 vout2.$1226.Metal3 0.00931574f
Cred_10020 VDD.$7646.Metal3 vout2.P0.nSD 0.000134907f
Cred_10021 VDD.$7646.Metal3 vout2.P0.pSD 0.000716871f
Cred_10022 VDD.$7646.Metal3 vout2.P2.nSD 0.000146761f
Cred_10023 VDD.$7646.Metal3 vout2.P2.pSD 0.00299318f
Cred_10024 VDD.$7652.Metal3 vin3.P22.GatPoly 0.0100799f
Cred_10025 VDD.$7652.Metal3 vin3.P23.GatPoly 0.00127816f
Cred_10026 VDD.$7652.Metal3 vin4.P22.GatPoly 0.0100799f
Cred_10027 VDD.$7652.Metal3 vin4.P23.GatPoly 0.00127816f
Cred_10028 VDD.$7652.Metal3 vout3.$1226.Metal3 0.00931574f
Cred_10029 VDD.$7652.Metal3 vout3.P0.nSD 0.000134907f
Cred_10030 VDD.$7652.Metal3 vout3.P0.pSD 0.000716871f
Cred_10031 VDD.$7652.Metal3 vout3.P2.nSD 0.000146761f
Cred_10032 VDD.$7652.Metal3 vout3.P2.pSD 0.00299318f
Cred_10033 VDD.$7652.Metal3 vout4.$1226.Metal3 0.00931574f
Cred_10034 VDD.$7652.Metal3 vout4.P0.nSD 0.000134907f
Cred_10035 VDD.$7652.Metal3 vout4.P0.pSD 0.000716871f
Cred_10036 VDD.$7652.Metal3 vout4.P2.nSD 0.000146761f
Cred_10037 VDD.$7652.Metal3 vout4.P2.pSD 0.00299318f
Cred_10038 VDD.$7682.Metal3 vin1.$233.Metal1 1.86168e-08f
Cred_10039 VDD.$7682.Metal3 vin1.$237.Metal1 2.50363e-08f
Cred_10040 VDD.$7682.Metal3 vin1.$500.Metal2 2.29777e-06f
Cred_10041 VDD.$7682.Metal3 vin1.$504.Metal2 2.29777e-06f
Cred_10042 VDD.$7682.Metal3 vin1.P23.GatPoly 0.0128598f
Cred_10043 VDD.$7682.Metal3 vin1.P24.GatPoly 0.00148432f
Cred_10044 VDD.$7682.Metal3 vin2.$232.Metal1 1.86168e-08f
Cred_10045 VDD.$7682.Metal3 vin2.$236.Metal1 2.50363e-08f
Cred_10046 VDD.$7682.Metal3 vin2.$499.Metal2 2.29777e-06f
Cred_10047 VDD.$7682.Metal3 vin2.$503.Metal2 2.29777e-06f
Cred_10048 VDD.$7682.Metal3 vin2.P23.GatPoly 0.0128598f
Cred_10049 VDD.$7682.Metal3 vin2.P24.GatPoly 0.00148432f
Cred_10050 VDD.$7682.Metal3 vout1.$1226.Metal3 0.00429215f
Cred_10051 VDD.$7682.Metal3 vout1.P0.nSD 6.2157e-05f
Cred_10052 VDD.$7682.Metal3 vout1.P0.pSD 0.000330292f
Cred_10053 VDD.$7682.Metal3 vout1.P2.nSD 6.76188e-05f
Cred_10054 VDD.$7682.Metal3 vout1.P2.pSD 0.00137842f
Cred_10055 VDD.$7682.Metal3 vout2.$1226.Metal3 0.00429215f
Cred_10056 VDD.$7682.Metal3 vout2.P0.nSD 6.2157e-05f
Cred_10057 VDD.$7682.Metal3 vout2.P0.pSD 0.000330292f
Cred_10058 VDD.$7682.Metal3 vout2.P2.nSD 6.76188e-05f
Cred_10059 VDD.$7682.Metal3 vout2.P2.pSD 0.00137842f
Cred_10060 VDD.$7688.Metal3 vin3.$233.Metal1 1.86168e-08f
Cred_10061 VDD.$7688.Metal3 vin3.$237.Metal1 2.50363e-08f
Cred_10062 VDD.$7688.Metal3 vin3.$500.Metal2 2.29777e-06f
Cred_10063 VDD.$7688.Metal3 vin3.$504.Metal2 2.29777e-06f
Cred_10064 VDD.$7688.Metal3 vin3.P23.GatPoly 0.0128598f
Cred_10065 VDD.$7688.Metal3 vin3.P24.GatPoly 0.00148432f
Cred_10066 VDD.$7688.Metal3 vin4.$232.Metal1 1.86168e-08f
Cred_10067 VDD.$7688.Metal3 vin4.$236.Metal1 2.50363e-08f
Cred_10068 VDD.$7688.Metal3 vin4.$499.Metal2 2.29777e-06f
Cred_10069 VDD.$7688.Metal3 vin4.$503.Metal2 2.29777e-06f
Cred_10070 VDD.$7688.Metal3 vin4.P23.GatPoly 0.0128598f
Cred_10071 VDD.$7688.Metal3 vin4.P24.GatPoly 0.00148432f
Cred_10072 VDD.$7688.Metal3 vout3.$1226.Metal3 0.00429215f
Cred_10073 VDD.$7688.Metal3 vout3.P0.nSD 6.2157e-05f
Cred_10074 VDD.$7688.Metal3 vout3.P0.pSD 0.000330292f
Cred_10075 VDD.$7688.Metal3 vout3.P2.nSD 6.76188e-05f
Cred_10076 VDD.$7688.Metal3 vout3.P2.pSD 0.00137842f
Cred_10077 VDD.$7688.Metal3 vout4.$1226.Metal3 0.00429215f
Cred_10078 VDD.$7688.Metal3 vout4.P0.nSD 6.2157e-05f
Cred_10079 VDD.$7688.Metal3 vout4.P0.pSD 0.000330292f
Cred_10080 VDD.$7688.Metal3 vout4.P2.nSD 6.76188e-05f
Cred_10081 VDD.$7688.Metal3 vout4.P2.pSD 0.00137842f
Cred_10082 VDD.$7718.Metal3 vin1.$247.Metal1 3.53697e-08f
Cred_10083 VDD.$7718.Metal3 vin1.$251.Metal1 8.36012e-09f
Cred_10084 VDD.$7718.Metal3 vin1.$509.Metal2 2.29774e-06f
Cred_10085 VDD.$7718.Metal3 vin1.$513.Metal2 2.29774e-06f
Cred_10086 VDD.$7718.Metal3 vin1.P24.GatPoly 0.0128015f
Cred_10087 VDD.$7718.Metal3 vin2.$246.Metal1 3.53697e-08f
Cred_10088 VDD.$7718.Metal3 vin2.$250.Metal1 8.36012e-09f
Cred_10089 VDD.$7718.Metal3 vin2.$508.Metal2 2.29774e-06f
Cred_10090 VDD.$7718.Metal3 vin2.$512.Metal2 2.29774e-06f
Cred_10091 VDD.$7718.Metal3 vin2.P24.GatPoly 0.0128015f
Cred_10092 VDD.$7718.Metal3 vout1.$1226.Metal3 0.00333022f
Cred_10093 VDD.$7718.Metal3 vout1.P4.pSD 0.000655977f
Cred_10094 VDD.$7718.Metal3 vout2.$1226.Metal3 0.00333022f
Cred_10095 VDD.$7718.Metal3 vout2.P4.pSD 0.000655977f
Cred_10096 VDD.$7724.Metal3 vin3.$247.Metal1 3.53697e-08f
Cred_10097 VDD.$7724.Metal3 vin3.$251.Metal1 8.36012e-09f
Cred_10098 VDD.$7724.Metal3 vin3.$509.Metal2 2.29774e-06f
Cred_10099 VDD.$7724.Metal3 vin3.$513.Metal2 2.29774e-06f
Cred_10100 VDD.$7724.Metal3 vin3.P24.GatPoly 0.0128015f
Cred_10101 VDD.$7724.Metal3 vin4.$246.Metal1 3.53697e-08f
Cred_10102 VDD.$7724.Metal3 vin4.$250.Metal1 8.36012e-09f
Cred_10103 VDD.$7724.Metal3 vin4.$508.Metal2 2.29774e-06f
Cred_10104 VDD.$7724.Metal3 vin4.$512.Metal2 2.29774e-06f
Cred_10105 VDD.$7724.Metal3 vin4.P24.GatPoly 0.0128015f
Cred_10106 VDD.$7724.Metal3 vout3.$1226.Metal3 0.00333022f
Cred_10107 VDD.$7724.Metal3 vout3.P4.pSD 0.000655977f
Cred_10108 VDD.$7724.Metal3 vout4.$1226.Metal3 0.00333022f
Cred_10109 VDD.$7724.Metal3 vout4.P4.pSD 0.000655977f
Cred_10110 VDD.$7742.Metal3 vin1.P25.GatPoly 0.00322774f
Cred_10111 VDD.$7742.Metal3 vin2.P25.GatPoly 0.00322774f
Cred_10112 VDD.$7742.Metal3 vout1.$1226.Metal3 0.0113401f
Cred_10113 VDD.$7742.Metal3 vout1.P4.pSD 0.00223932f
Cred_10114 VDD.$7742.Metal3 vout2.$1226.Metal3 0.0113401f
Cred_10115 VDD.$7742.Metal3 vout2.P4.pSD 0.00223932f
Cred_10116 VDD.$7748.Metal3 vin3.P25.GatPoly 0.00322774f
Cred_10117 VDD.$7748.Metal3 vin4.P25.GatPoly 0.00322774f
Cred_10118 VDD.$7748.Metal3 vout3.$1226.Metal3 0.0113401f
Cred_10119 VDD.$7748.Metal3 vout3.P4.pSD 0.00223932f
Cred_10120 VDD.$7748.Metal3 vout4.$1226.Metal3 0.0113401f
Cred_10121 VDD.$7748.Metal3 vout4.P4.pSD 0.00223932f
Cred_10122 VDD.$7766.Metal3 vin1.P25.GatPoly 0.0112574f
Cred_10123 VDD.$7766.Metal3 vin2.P25.GatPoly 0.0112574f
Cred_10124 VDD.$7766.Metal3 vout1.$1226.Metal3 0.0012996f
Cred_10125 VDD.$7766.Metal3 vout1.P4.pSD 0.000255991f
Cred_10126 VDD.$7766.Metal3 vout2.$1226.Metal3 0.0012996f
Cred_10127 VDD.$7766.Metal3 vout2.P4.pSD 0.000255991f
Cred_10128 VDD.$7772.Metal3 vin3.P25.GatPoly 0.0112574f
Cred_10129 VDD.$7772.Metal3 vin4.P25.GatPoly 0.0112574f
Cred_10130 VDD.$7772.Metal3 vout3.$1226.Metal3 0.0012996f
Cred_10131 VDD.$7772.Metal3 vout3.P4.pSD 0.000255991f
Cred_10132 VDD.$7772.Metal3 vout4.$1226.Metal3 0.0012996f
Cred_10133 VDD.$7772.Metal3 vout4.P4.pSD 0.000255991f
Cred_10134 VDD.$7790.Metal3 vin1.P26.GatPoly 0.0108565f
Cred_10135 VDD.$7790.Metal3 vin2.P26.GatPoly 0.0108565f
Cred_10136 VDD.$7790.Metal3 vout1.$1226.Metal3 0.000502376f
Cred_10137 VDD.$7790.Metal3 vout1.$1292.Metal3 0.000502376f
Cred_10138 VDD.$7790.Metal3 vout1.P6.nSD 7.91446e-06f
Cred_10139 VDD.$7790.Metal3 vout1.P6.pSD 0.000251247f
Cred_10140 VDD.$7790.Metal3 vout2.$1226.Metal3 0.000502376f
Cred_10141 VDD.$7790.Metal3 vout2.$1292.Metal3 0.000502376f
Cred_10142 VDD.$7790.Metal3 vout2.P6.nSD 7.91446e-06f
Cred_10143 VDD.$7790.Metal3 vout2.P6.pSD 0.000251247f
Cred_10144 VDD.$7796.Metal3 vin3.P26.GatPoly 0.0108565f
Cred_10145 VDD.$7796.Metal3 vin4.P26.GatPoly 0.0108565f
Cred_10146 VDD.$7796.Metal3 vout3.$1226.Metal3 0.000502376f
Cred_10147 VDD.$7796.Metal3 vout3.$1292.Metal3 0.000502376f
Cred_10148 VDD.$7796.Metal3 vout3.P6.nSD 7.91446e-06f
Cred_10149 VDD.$7796.Metal3 vout3.P6.pSD 0.000251247f
Cred_10150 VDD.$7796.Metal3 vout4.$1226.Metal3 0.000502376f
Cred_10151 VDD.$7796.Metal3 vout4.$1292.Metal3 0.000502376f
Cred_10152 VDD.$7796.Metal3 vout4.P6.nSD 7.91446e-06f
Cred_10153 VDD.$7796.Metal3 vout4.P6.pSD 0.000251247f
Cred_10154 VDD.$7814.Metal3 vin1.P26.GatPoly 0.00358359f
Cred_10155 VDD.$7814.Metal3 vin2.P26.GatPoly 0.00358359f
Cred_10156 VDD.$7814.Metal3 vout1.$1226.Metal3 0.00527904f
Cred_10157 VDD.$7814.Metal3 vout1.$1292.Metal3 0.00527904f
Cred_10158 VDD.$7814.Metal3 vout1.P6.nSD 8.31664e-05f
Cred_10159 VDD.$7814.Metal3 vout1.P6.pSD 0.00264557f
Cred_10160 VDD.$7814.Metal3 vout2.$1226.Metal3 0.00527904f
Cred_10161 VDD.$7814.Metal3 vout2.$1292.Metal3 0.00527904f
Cred_10162 VDD.$7814.Metal3 vout2.P6.nSD 8.31664e-05f
Cred_10163 VDD.$7814.Metal3 vout2.P6.pSD 0.00264557f
Cred_10164 VDD.$7820.Metal3 vin3.P26.GatPoly 0.00358359f
Cred_10165 VDD.$7820.Metal3 vin4.P26.GatPoly 0.00358359f
Cred_10166 VDD.$7820.Metal3 vout3.$1226.Metal3 0.00527904f
Cred_10167 VDD.$7820.Metal3 vout3.$1292.Metal3 0.00527904f
Cred_10168 VDD.$7820.Metal3 vout3.P6.nSD 8.31664e-05f
Cred_10169 VDD.$7820.Metal3 vout3.P6.pSD 0.00264557f
Cred_10170 VDD.$7820.Metal3 vout4.$1226.Metal3 0.00527904f
Cred_10171 VDD.$7820.Metal3 vout4.$1292.Metal3 0.00527904f
Cred_10172 VDD.$7820.Metal3 vout4.P6.nSD 8.31664e-05f
Cred_10173 VDD.$7820.Metal3 vout4.P6.pSD 0.00264557f
Cred_10174 VDD.$7838.Metal3 vin1.$291.Metal1 3.27763e-08f
Cred_10175 VDD.$7838.Metal3 vin1.$295.Metal1 1.09254e-08f
Cred_10176 VDD.$7838.Metal3 vin1.$538.Metal2 2.29775e-06f
Cred_10177 VDD.$7838.Metal3 vin1.$542.Metal2 2.29775e-06f
Cred_10178 VDD.$7838.Metal3 vin1.P27.GatPoly 0.0130142f
Cred_10179 VDD.$7838.Metal3 vin1.P28.GatPoly 0.00245101f
Cred_10180 VDD.$7838.Metal3 vin2.$290.Metal1 3.27763e-08f
Cred_10181 VDD.$7838.Metal3 vin2.$294.Metal1 1.09254e-08f
Cred_10182 VDD.$7838.Metal3 vin2.$537.Metal2 2.29775e-06f
Cred_10183 VDD.$7838.Metal3 vin2.$541.Metal2 2.29775e-06f
Cred_10184 VDD.$7838.Metal3 vin2.P27.GatPoly 0.0130142f
Cred_10185 VDD.$7838.Metal3 vin2.P28.GatPoly 0.00245101f
Cred_10186 VDD.$7838.Metal3 vout1.$1226.Metal3 0.00158442f
Cred_10187 VDD.$7838.Metal3 vout1.$1292.Metal3 0.00158442f
Cred_10188 VDD.$7838.Metal3 vout1.P6.nSD 2.4961e-05f
Cred_10189 VDD.$7838.Metal3 vout1.P6.pSD 0.000792395f
Cred_10190 VDD.$7838.Metal3 vout2.$1226.Metal3 0.00158442f
Cred_10191 VDD.$7838.Metal3 vout2.$1292.Metal3 0.00158442f
Cred_10192 VDD.$7838.Metal3 vout2.P6.nSD 2.4961e-05f
Cred_10193 VDD.$7838.Metal3 vout2.P6.pSD 0.000792395f
Cred_10194 VDD.$7844.Metal3 vin3.$291.Metal1 3.27763e-08f
Cred_10195 VDD.$7844.Metal3 vin3.$295.Metal1 1.09254e-08f
Cred_10196 VDD.$7844.Metal3 vin3.$538.Metal2 2.29775e-06f
Cred_10197 VDD.$7844.Metal3 vin3.$542.Metal2 2.29775e-06f
Cred_10198 VDD.$7844.Metal3 vin3.P27.GatPoly 0.0130142f
Cred_10199 VDD.$7844.Metal3 vin3.P28.GatPoly 0.00245101f
Cred_10200 VDD.$7844.Metal3 vin4.$290.Metal1 3.27763e-08f
Cred_10201 VDD.$7844.Metal3 vin4.$294.Metal1 1.09254e-08f
Cred_10202 VDD.$7844.Metal3 vin4.$537.Metal2 2.29775e-06f
Cred_10203 VDD.$7844.Metal3 vin4.$541.Metal2 2.29775e-06f
Cred_10204 VDD.$7844.Metal3 vin4.P27.GatPoly 0.0130142f
Cred_10205 VDD.$7844.Metal3 vin4.P28.GatPoly 0.00245101f
Cred_10206 VDD.$7844.Metal3 vout3.$1226.Metal3 0.00158442f
Cred_10207 VDD.$7844.Metal3 vout3.$1292.Metal3 0.00158442f
Cred_10208 VDD.$7844.Metal3 vout3.P6.nSD 2.4961e-05f
Cred_10209 VDD.$7844.Metal3 vout3.P6.pSD 0.000792395f
Cred_10210 VDD.$7844.Metal3 vout4.$1226.Metal3 0.00158442f
Cred_10211 VDD.$7844.Metal3 vout4.$1292.Metal3 0.00158442f
Cred_10212 VDD.$7844.Metal3 vout4.P6.nSD 2.4961e-05f
Cred_10213 VDD.$7844.Metal3 vout4.P6.pSD 0.000792395f
Cred_10214 VDD.$7886.Metal3 vin1.$551.Metal2 4.07342e-06f
Cred_10215 VDD.$7886.Metal3 vin1.P27.GatPoly 0.00128678f
Cred_10216 VDD.$7886.Metal3 vin1.P28.GatPoly 0.0120529f
Cred_10217 VDD.$7886.Metal3 vin1.P29.GatPoly 0.000636789f
Cred_10218 VDD.$7886.Metal3 vin2.$550.Metal2 4.07342e-06f
Cred_10219 VDD.$7886.Metal3 vin2.P27.GatPoly 0.00128678f
Cred_10220 VDD.$7886.Metal3 vin2.P28.GatPoly 0.0120529f
Cred_10221 VDD.$7886.Metal3 vin2.P29.GatPoly 0.000636789f
Cred_10222 VDD.$7886.Metal3 vout1.$1292.Metal3 0.0102372f
Cred_10223 VDD.$7886.Metal3 vout1.P8.pSD 0.00201681f
Cred_10224 VDD.$7886.Metal3 vout2.$1292.Metal3 0.0102372f
Cred_10225 VDD.$7886.Metal3 vout2.P8.pSD 0.00201681f
Cred_10226 VDD.$7892.Metal3 vin3.$551.Metal2 4.07342e-06f
Cred_10227 VDD.$7892.Metal3 vin3.P27.GatPoly 0.00128678f
Cred_10228 VDD.$7892.Metal3 vin3.P28.GatPoly 0.0120529f
Cred_10229 VDD.$7892.Metal3 vin3.P29.GatPoly 0.000636789f
Cred_10230 VDD.$7892.Metal3 vin4.$550.Metal2 4.07342e-06f
Cred_10231 VDD.$7892.Metal3 vin4.P27.GatPoly 0.00128678f
Cred_10232 VDD.$7892.Metal3 vin4.P28.GatPoly 0.0120529f
Cred_10233 VDD.$7892.Metal3 vin4.P29.GatPoly 0.000636789f
Cred_10234 VDD.$7892.Metal3 vout3.$1292.Metal3 0.0102372f
Cred_10235 VDD.$7892.Metal3 vout3.P8.pSD 0.00201681f
Cred_10236 VDD.$7892.Metal3 vout4.$1292.Metal3 0.0102372f
Cred_10237 VDD.$7892.Metal3 vout4.P8.pSD 0.00201681f
Cred_10238 VDD.$7922.Metal3 vin1.$321.Metal1 1.34893e-08f
Cred_10239 VDD.$7922.Metal3 vin1.$325.Metal1 3.01903e-08f
Cred_10240 VDD.$7922.Metal3 vin1.$558.Metal2 2.29776e-06f
Cred_10241 VDD.$7922.Metal3 vin1.$562.Metal2 2.29776e-06f
Cred_10242 VDD.$7922.Metal3 vin1.P29.GatPoly 0.0132278f
Cred_10243 VDD.$7922.Metal3 vin1.P30.GatPoly 0.000824623f
Cred_10244 VDD.$7922.Metal3 vin2.$320.Metal1 1.34893e-08f
Cred_10245 VDD.$7922.Metal3 vin2.$324.Metal1 3.01903e-08f
Cred_10246 VDD.$7922.Metal3 vin2.$557.Metal2 2.29776e-06f
Cred_10247 VDD.$7922.Metal3 vin2.$561.Metal2 2.29776e-06f
Cred_10248 VDD.$7922.Metal3 vin2.P29.GatPoly 0.0132278f
Cred_10249 VDD.$7922.Metal3 vin2.P30.GatPoly 0.000824623f
Cred_10250 VDD.$7922.Metal3 vout1.$1292.Metal3 0.00598587f
Cred_10251 VDD.$7922.Metal3 vout1.P8.pSD 0.00117908f
Cred_10252 VDD.$7922.Metal3 vout2.$1292.Metal3 0.00598587f
Cred_10253 VDD.$7922.Metal3 vout2.P8.pSD 0.00117908f
Cred_10254 VDD.$7928.Metal3 vin3.$321.Metal1 1.34893e-08f
Cred_10255 VDD.$7928.Metal3 vin3.$325.Metal1 3.01903e-08f
Cred_10256 VDD.$7928.Metal3 vin3.$558.Metal2 2.29776e-06f
Cred_10257 VDD.$7928.Metal3 vin3.$562.Metal2 2.29776e-06f
Cred_10258 VDD.$7928.Metal3 vin3.P29.GatPoly 0.0132278f
Cred_10259 VDD.$7928.Metal3 vin3.P30.GatPoly 0.000824623f
Cred_10260 VDD.$7928.Metal3 vin4.$320.Metal1 1.34893e-08f
Cred_10261 VDD.$7928.Metal3 vin4.$324.Metal1 3.01903e-08f
Cred_10262 VDD.$7928.Metal3 vin4.$557.Metal2 2.29776e-06f
Cred_10263 VDD.$7928.Metal3 vin4.$561.Metal2 2.29776e-06f
Cred_10264 VDD.$7928.Metal3 vin4.P29.GatPoly 0.0132278f
Cred_10265 VDD.$7928.Metal3 vin4.P30.GatPoly 0.000824623f
Cred_10266 VDD.$7928.Metal3 vout3.$1292.Metal3 0.00598587f
Cred_10267 VDD.$7928.Metal3 vout3.P8.pSD 0.00117908f
Cred_10268 VDD.$7928.Metal3 vout4.$1292.Metal3 0.00598587f
Cred_10269 VDD.$7928.Metal3 vout4.P8.pSD 0.00117908f
Cred_10270 VDD.$7958.Metal3 vin1.$335.Metal1 3.01903e-08f
Cred_10271 VDD.$7958.Metal3 vin1.$339.Metal1 1.34893e-08f
Cred_10272 VDD.$7958.Metal3 vin1.$567.Metal2 2.29776e-06f
Cred_10273 VDD.$7958.Metal3 vin1.$571.Metal2 2.29776e-06f
Cred_10274 VDD.$7958.Metal3 vin1.P29.GatPoly 0.000824623f
Cred_10275 VDD.$7958.Metal3 vin1.P30.GatPoly 0.0129107f
Cred_10276 VDD.$7958.Metal3 vin2.$334.Metal1 3.01903e-08f
Cred_10277 VDD.$7958.Metal3 vin2.$338.Metal1 1.34893e-08f
Cred_10278 VDD.$7958.Metal3 vin2.$566.Metal2 2.29776e-06f
Cred_10279 VDD.$7958.Metal3 vin2.$570.Metal2 2.29776e-06f
Cred_10280 VDD.$7958.Metal3 vin2.P29.GatPoly 0.000824623f
Cred_10281 VDD.$7958.Metal3 vin2.P30.GatPoly 0.0129107f
Cred_10282 VDD.$7958.Metal3 vout1.$1292.Metal3 0.00134156f
Cred_10283 VDD.$7958.Metal3 vout1.$1358.Metal3 0.00134156f
Cred_10284 VDD.$7958.Metal3 vout1.P10.nSD 2.1135e-05f
Cred_10285 VDD.$7958.Metal3 vout1.P10.pSD 0.000698594f
Cred_10286 VDD.$7958.Metal3 vout2.$1292.Metal3 0.00134156f
Cred_10287 VDD.$7958.Metal3 vout2.$1358.Metal3 0.00134156f
Cred_10288 VDD.$7958.Metal3 vout2.P10.nSD 2.1135e-05f
Cred_10289 VDD.$7958.Metal3 vout2.P10.pSD 0.000698594f
Cred_10290 VDD.$7964.Metal3 vin3.$335.Metal1 3.01903e-08f
Cred_10291 VDD.$7964.Metal3 vin3.$339.Metal1 1.34893e-08f
Cred_10292 VDD.$7964.Metal3 vin3.$567.Metal2 2.29776e-06f
Cred_10293 VDD.$7964.Metal3 vin3.$571.Metal2 2.29776e-06f
Cred_10294 VDD.$7964.Metal3 vin3.P29.GatPoly 0.000824623f
Cred_10295 VDD.$7964.Metal3 vin3.P30.GatPoly 0.0129107f
Cred_10296 VDD.$7964.Metal3 vin4.$334.Metal1 3.01903e-08f
Cred_10297 VDD.$7964.Metal3 vin4.$338.Metal1 1.34893e-08f
Cred_10298 VDD.$7964.Metal3 vin4.$566.Metal2 2.29776e-06f
Cred_10299 VDD.$7964.Metal3 vin4.$570.Metal2 2.29776e-06f
Cred_10300 VDD.$7964.Metal3 vin4.P29.GatPoly 0.000824623f
Cred_10301 VDD.$7964.Metal3 vin4.P30.GatPoly 0.0129107f
Cred_10302 VDD.$7964.Metal3 vout3.$1292.Metal3 0.00134156f
Cred_10303 VDD.$7964.Metal3 vout3.$1358.Metal3 0.00134156f
Cred_10304 VDD.$7964.Metal3 vout3.P10.nSD 2.1135e-05f
Cred_10305 VDD.$7964.Metal3 vout3.P10.pSD 0.000698594f
Cred_10306 VDD.$7964.Metal3 vout4.$1292.Metal3 0.00134156f
Cred_10307 VDD.$7964.Metal3 vout4.$1358.Metal3 0.00134156f
Cred_10308 VDD.$7964.Metal3 vout4.P10.nSD 2.1135e-05f
Cred_10309 VDD.$7964.Metal3 vout4.P10.pSD 0.000698594f
Cred_10310 VDD.$7982.Metal3 vin1.P30.GatPoly 0.00096156f
Cred_10311 VDD.$7982.Metal3 vin1.P31.GatPoly 0.00228285f
Cred_10312 VDD.$7982.Metal3 vin2.P30.GatPoly 0.00096156f
Cred_10313 VDD.$7982.Metal3 vin2.P31.GatPoly 0.00228285f
Cred_10314 VDD.$7982.Metal3 vout1.$1292.Metal3 0.00600838f
Cred_10315 VDD.$7982.Metal3 vout1.$1358.Metal3 0.00600838f
Cred_10316 VDD.$7982.Metal3 vout1.P10.nSD 9.46564e-05f
Cred_10317 VDD.$7982.Metal3 vout1.P10.pSD 0.00313447f
Cred_10318 VDD.$7982.Metal3 vout2.$1292.Metal3 0.00600838f
Cred_10319 VDD.$7982.Metal3 vout2.$1358.Metal3 0.00600838f
Cred_10320 VDD.$7982.Metal3 vout2.P10.nSD 9.46564e-05f
Cred_10321 VDD.$7982.Metal3 vout2.P10.pSD 0.00313447f
Cred_10322 VDD.$7988.Metal3 vin3.P30.GatPoly 0.00096156f
Cred_10323 VDD.$7988.Metal3 vin3.P31.GatPoly 0.00228285f
Cred_10324 VDD.$7988.Metal3 vin4.P30.GatPoly 0.00096156f
Cred_10325 VDD.$7988.Metal3 vin4.P31.GatPoly 0.00228285f
Cred_10326 VDD.$7988.Metal3 vout3.$1292.Metal3 0.00600838f
Cred_10327 VDD.$7988.Metal3 vout3.$1358.Metal3 0.00600838f
Cred_10328 VDD.$7988.Metal3 vout3.P10.nSD 9.46564e-05f
Cred_10329 VDD.$7988.Metal3 vout3.P10.pSD 0.00313447f
Cred_10330 VDD.$7988.Metal3 vout4.$1292.Metal3 0.00600838f
Cred_10331 VDD.$7988.Metal3 vout4.$1358.Metal3 0.00600838f
Cred_10332 VDD.$7988.Metal3 vout4.P10.nSD 9.46564e-05f
Cred_10333 VDD.$7988.Metal3 vout4.P10.pSD 0.00313447f
Cred_10334 VDD.$8006.Metal3 vin1.$353.Metal1 3.7045e-08f
Cred_10335 VDD.$8006.Metal3 vin1.$357.Metal1 5.65093e-09f
Cred_10336 VDD.$8006.Metal3 vin1.$578.Metal2 2.24165e-06f
Cred_10337 VDD.$8006.Metal3 vin1.$582.Metal2 2.24165e-06f
Cred_10338 VDD.$8006.Metal3 vin1.P31.GatPoly 0.0123251f
Cred_10339 VDD.$8006.Metal3 vin2.$352.Metal1 3.7045e-08f
Cred_10340 VDD.$8006.Metal3 vin2.$356.Metal1 5.65093e-09f
Cred_10341 VDD.$8006.Metal3 vin2.$577.Metal2 2.24165e-06f
Cred_10342 VDD.$8006.Metal3 vin2.$581.Metal2 2.24165e-06f
Cred_10343 VDD.$8006.Metal3 vin2.P31.GatPoly 0.0123251f
Cred_10344 VDD.$8006.Metal3 vout1.$1292.Metal3 0.000919926f
Cred_10345 VDD.$8006.Metal3 vout1.$1358.Metal3 0.000919926f
Cred_10346 VDD.$8006.Metal3 vout1.P10.nSD 1.44926e-05f
Cred_10347 VDD.$8006.Metal3 vout1.P10.pSD 0.000479036f
Cred_10348 VDD.$8006.Metal3 vout2.$1292.Metal3 0.000919926f
Cred_10349 VDD.$8006.Metal3 vout2.$1358.Metal3 0.000919926f
Cred_10350 VDD.$8006.Metal3 vout2.P10.nSD 1.44926e-05f
Cred_10351 VDD.$8006.Metal3 vout2.P10.pSD 0.000479036f
Cred_10352 VDD.$8012.Metal3 vin3.$353.Metal1 3.7045e-08f
Cred_10353 VDD.$8012.Metal3 vin3.$357.Metal1 5.65093e-09f
Cred_10354 VDD.$8012.Metal3 vin3.$578.Metal2 2.24165e-06f
Cred_10355 VDD.$8012.Metal3 vin3.$582.Metal2 2.24165e-06f
Cred_10356 VDD.$8012.Metal3 vin3.P31.GatPoly 0.0123251f
Cred_10357 VDD.$8012.Metal3 vin4.$352.Metal1 3.7045e-08f
Cred_10358 VDD.$8012.Metal3 vin4.$356.Metal1 5.65093e-09f
Cred_10359 VDD.$8012.Metal3 vin4.$577.Metal2 2.24165e-06f
Cred_10360 VDD.$8012.Metal3 vin4.$581.Metal2 2.24165e-06f
Cred_10361 VDD.$8012.Metal3 vin4.P31.GatPoly 0.0123251f
Cred_10362 VDD.$8012.Metal3 vout3.$1292.Metal3 0.000919926f
Cred_10363 VDD.$8012.Metal3 vout3.$1358.Metal3 0.000919926f
Cred_10364 VDD.$8012.Metal3 vout3.P10.nSD 1.44926e-05f
Cred_10365 VDD.$8012.Metal3 vout3.P10.pSD 0.000479036f
Cred_10366 VDD.$8012.Metal3 vout4.$1292.Metal3 0.000919926f
Cred_10367 VDD.$8012.Metal3 vout4.$1358.Metal3 0.000919926f
Cred_10368 VDD.$8012.Metal3 vout4.P10.nSD 1.44926e-05f
Cred_10369 VDD.$8012.Metal3 vout4.P10.pSD 0.000479036f
Cred_10370 VDD.$8030.Metal3 vin1.P32.GatPoly 0.00978665f
Cred_10371 VDD.$8030.Metal3 vin2.P32.GatPoly 0.00978665f
Cred_10372 VDD.$8036.Metal3 vin3.P32.GatPoly 0.00978665f
Cred_10373 VDD.$8036.Metal3 vin4.P32.GatPoly 0.00978665f
Cred_10374 VDD.$8054.Metal3 vin1.P32.GatPoly 0.00453414f
Cred_10375 VDD.$8054.Metal3 vin2.P32.GatPoly 0.00453414f
Cred_10376 VDD.$8054.Metal3 vout1.$1358.Metal3 0.0122791f
Cred_10377 VDD.$8054.Metal3 vout1.P12.pSD 0.00254808f
Cred_10378 VDD.$8054.Metal3 vout2.$1358.Metal3 0.0122791f
Cred_10379 VDD.$8054.Metal3 vout2.P12.pSD 0.00254808f
Cred_10380 VDD.$8060.Metal3 vin3.P32.GatPoly 0.00453414f
Cred_10381 VDD.$8060.Metal3 vin4.P32.GatPoly 0.00453414f
Cred_10382 VDD.$8060.Metal3 vout3.$1358.Metal3 0.0122791f
Cred_10383 VDD.$8060.Metal3 vout3.P12.pSD 0.00254808f
Cred_10384 VDD.$8060.Metal3 vout4.$1358.Metal3 0.0122791f
Cred_10385 VDD.$8060.Metal3 vout4.P12.pSD 0.00254808f
Cred_10386 VDD.$8078.Metal3 vin1.$379.Metal1 3.63675e-08f
Cred_10387 VDD.$8078.Metal3 vin1.$383.Metal1 3.30649e-08f
Cred_10388 VDD.$8078.Metal3 vin1.$387.Metal1 1.60316e-08f
Cred_10389 VDD.$8078.Metal3 vin1.$596.Metal2 3.02651e-06f
Cred_10390 VDD.$8078.Metal3 vin1.$603.Metal2 1.52722e-06f
Cred_10391 VDD.$8078.Metal3 vin1.P33.GatPoly 0.0120253f
Cred_10392 VDD.$8078.Metal3 vin2.$378.Metal1 3.63675e-08f
Cred_10393 VDD.$8078.Metal3 vin2.$382.Metal1 3.30649e-08f
Cred_10394 VDD.$8078.Metal3 vin2.$386.Metal1 1.60316e-08f
Cred_10395 VDD.$8078.Metal3 vin2.$595.Metal2 3.02651e-06f
Cred_10396 VDD.$8078.Metal3 vin2.$601.Metal2 1.52722e-06f
Cred_10397 VDD.$8078.Metal3 vin2.P33.GatPoly 0.0120253f
Cred_10398 VDD.$8078.Metal3 vout1.$1358.Metal3 0.00541014f
Cred_10399 VDD.$8078.Metal3 vout1.P12.pSD 0.00112088f
Cred_10400 VDD.$8078.Metal3 vout2.$1358.Metal3 0.00541014f
Cred_10401 VDD.$8078.Metal3 vout2.P12.pSD 0.00112088f
Cred_10402 VDD.$8084.Metal3 vin3.$379.Metal1 3.63675e-08f
Cred_10403 VDD.$8084.Metal3 vin3.$383.Metal1 3.30649e-08f
Cred_10404 VDD.$8084.Metal3 vin3.$387.Metal1 1.60316e-08f
Cred_10405 VDD.$8084.Metal3 vin3.$596.Metal2 3.02651e-06f
Cred_10406 VDD.$8084.Metal3 vin3.$603.Metal2 1.52722e-06f
Cred_10407 VDD.$8084.Metal3 vin3.P33.GatPoly 0.0120253f
Cred_10408 VDD.$8084.Metal3 vin4.$378.Metal1 3.63675e-08f
Cred_10409 VDD.$8084.Metal3 vin4.$382.Metal1 3.30649e-08f
Cred_10410 VDD.$8084.Metal3 vin4.$386.Metal1 1.60316e-08f
Cred_10411 VDD.$8084.Metal3 vin4.$595.Metal2 3.02651e-06f
Cred_10412 VDD.$8084.Metal3 vin4.$601.Metal2 1.52722e-06f
Cred_10413 VDD.$8084.Metal3 vin4.P33.GatPoly 0.0120253f
Cred_10414 VDD.$8084.Metal3 vout3.$1358.Metal3 0.00541014f
Cred_10415 VDD.$8084.Metal3 vout3.P12.pSD 0.00112088f
Cred_10416 VDD.$8084.Metal3 vout4.$1358.Metal3 0.00541014f
Cred_10417 VDD.$8084.Metal3 vout4.P12.pSD 0.00112088f
Cred_10418 VDD.$8114.Metal3 vin1.P33.GatPoly 0.0023914f
Cred_10419 VDD.$8114.Metal3 vin1.P34.GatPoly 0.0112574f
Cred_10420 VDD.$8114.Metal3 vin2.P33.GatPoly 0.0023914f
Cred_10421 VDD.$8114.Metal3 vin2.P34.GatPoly 0.0112574f
Cred_10422 VDD.$8114.Metal3 vout1.$1358.Metal3 0.000613285f
Cred_10423 VDD.$8114.Metal3 vout1.$1424.Metal3 0.000613285f
Cred_10424 VDD.$8114.Metal3 vout1.P14.nSD 9.66173e-06f
Cred_10425 VDD.$8114.Metal3 vout1.P14.pSD 0.000319358f
Cred_10426 VDD.$8114.Metal3 vout2.$1358.Metal3 0.000613285f
Cred_10427 VDD.$8114.Metal3 vout2.$1424.Metal3 0.000613285f
Cred_10428 VDD.$8114.Metal3 vout2.P14.nSD 9.66173e-06f
Cred_10429 VDD.$8114.Metal3 vout2.P14.pSD 0.000319358f
Cred_10430 VDD.$8120.Metal3 vin3.P33.GatPoly 0.0023914f
Cred_10431 VDD.$8120.Metal3 vin3.P34.GatPoly 0.0112574f
Cred_10432 VDD.$8120.Metal3 vin4.P33.GatPoly 0.0023914f
Cred_10433 VDD.$8120.Metal3 vin4.P34.GatPoly 0.0112574f
Cred_10434 VDD.$8120.Metal3 vout3.$1358.Metal3 0.000613285f
Cred_10435 VDD.$8120.Metal3 vout3.$1424.Metal3 0.000613285f
Cred_10436 VDD.$8120.Metal3 vout3.P14.nSD 9.66173e-06f
Cred_10437 VDD.$8120.Metal3 vout3.P14.pSD 0.000319358f
Cred_10438 VDD.$8120.Metal3 vout4.$1358.Metal3 0.000613285f
Cred_10439 VDD.$8120.Metal3 vout4.$1424.Metal3 0.000613285f
Cred_10440 VDD.$8120.Metal3 vout4.P14.nSD 9.66173e-06f
Cred_10441 VDD.$8120.Metal3 vout4.P14.pSD 0.000319358f
Cred_10442 VDD.$8138.Metal3 vin1.P34.GatPoly 0.00322774f
Cred_10443 VDD.$8138.Metal3 vin2.P34.GatPoly 0.00322774f
Cred_10444 VDD.$8138.Metal3 vout1.$1358.Metal3 0.00622708f
Cred_10445 VDD.$8138.Metal3 vout1.$1424.Metal3 0.00622708f
Cred_10446 VDD.$8138.Metal3 vout1.P14.nSD 9.81019e-05f
Cred_10447 VDD.$8138.Metal3 vout1.P14.pSD 0.0032482f
Cred_10448 VDD.$8138.Metal3 vout2.$1358.Metal3 0.00622708f
Cred_10449 VDD.$8138.Metal3 vout2.$1424.Metal3 0.00622708f
Cred_10450 VDD.$8138.Metal3 vout2.P14.nSD 9.81019e-05f
Cred_10451 VDD.$8138.Metal3 vout2.P14.pSD 0.0032482f
Cred_10452 VDD.$8144.Metal3 vin3.P34.GatPoly 0.00322774f
Cred_10453 VDD.$8144.Metal3 vin4.P34.GatPoly 0.00322774f
Cred_10454 VDD.$8144.Metal3 vout3.$1358.Metal3 0.00622708f
Cred_10455 VDD.$8144.Metal3 vout3.$1424.Metal3 0.00622708f
Cred_10456 VDD.$8144.Metal3 vout3.P14.nSD 9.81019e-05f
Cred_10457 VDD.$8144.Metal3 vout3.P14.pSD 0.0032482f
Cred_10458 VDD.$8144.Metal3 vout4.$1358.Metal3 0.00622708f
Cred_10459 VDD.$8144.Metal3 vout4.$1424.Metal3 0.00622708f
Cred_10460 VDD.$8144.Metal3 vout4.P14.nSD 9.81019e-05f
Cred_10461 VDD.$8144.Metal3 vout4.P14.pSD 0.0032482f
Cred_10462 VDD.$8162.Metal3 vin1.$409.Metal1 8.36012e-09f
Cred_10463 VDD.$8162.Metal3 vin1.$413.Metal1 3.53697e-08f
Cred_10464 VDD.$8162.Metal3 vin1.$616.Metal2 2.29774e-06f
Cred_10465 VDD.$8162.Metal3 vin1.$620.Metal2 2.29774e-06f
Cred_10466 VDD.$8162.Metal3 vin1.P35.GatPoly 0.0128015f
Cred_10467 VDD.$8162.Metal3 vin2.$408.Metal1 8.36012e-09f
Cred_10468 VDD.$8162.Metal3 vin2.$412.Metal1 3.53697e-08f
Cred_10469 VDD.$8162.Metal3 vin2.$615.Metal2 2.29774e-06f
Cred_10470 VDD.$8162.Metal3 vin2.$619.Metal2 2.29774e-06f
Cred_10471 VDD.$8162.Metal3 vin2.P35.GatPoly 0.0128015f
Cred_10472 VDD.$8162.Metal3 vout1.$1358.Metal3 0.00157154f
Cred_10473 VDD.$8162.Metal3 vout1.$1424.Metal3 0.00157154f
Cred_10474 VDD.$8162.Metal3 vout1.P14.nSD 2.47582e-05f
Cred_10475 VDD.$8162.Metal3 vout1.P14.pSD 0.000818354f
Cred_10476 VDD.$8162.Metal3 vout2.$1358.Metal3 0.00157154f
Cred_10477 VDD.$8162.Metal3 vout2.$1424.Metal3 0.00157154f
Cred_10478 VDD.$8162.Metal3 vout2.P14.nSD 2.47582e-05f
Cred_10479 VDD.$8162.Metal3 vout2.P14.pSD 0.000818354f
Cred_10480 VDD.$8168.Metal3 vin3.$409.Metal1 8.36012e-09f
Cred_10481 VDD.$8168.Metal3 vin3.$413.Metal1 3.53697e-08f
Cred_10482 VDD.$8168.Metal3 vin3.$616.Metal2 2.29774e-06f
Cred_10483 VDD.$8168.Metal3 vin3.$620.Metal2 2.29774e-06f
Cred_10484 VDD.$8168.Metal3 vin3.P35.GatPoly 0.0128015f
Cred_10485 VDD.$8168.Metal3 vin4.$408.Metal1 8.36012e-09f
Cred_10486 VDD.$8168.Metal3 vin4.$412.Metal1 3.53697e-08f
Cred_10487 VDD.$8168.Metal3 vin4.$615.Metal2 2.29774e-06f
Cred_10488 VDD.$8168.Metal3 vin4.$619.Metal2 2.29774e-06f
Cred_10489 VDD.$8168.Metal3 vin4.P35.GatPoly 0.0128015f
Cred_10490 VDD.$8168.Metal3 vout3.$1358.Metal3 0.00157154f
Cred_10491 VDD.$8168.Metal3 vout3.$1424.Metal3 0.00157154f
Cred_10492 VDD.$8168.Metal3 vout3.P14.nSD 2.47582e-05f
Cred_10493 VDD.$8168.Metal3 vout3.P14.pSD 0.000818354f
Cred_10494 VDD.$8168.Metal3 vout4.$1358.Metal3 0.00157154f
Cred_10495 VDD.$8168.Metal3 vout4.$1424.Metal3 0.00157154f
Cred_10496 VDD.$8168.Metal3 vout4.P14.nSD 2.47582e-05f
Cred_10497 VDD.$8168.Metal3 vout4.P14.pSD 0.000818354f
Cred_10498 VDD.$8198.Metal3 vin1.$423.Metal1 2.50363e-08f
Cred_10499 VDD.$8198.Metal3 vin1.$427.Metal1 1.86168e-08f
Cred_10500 VDD.$8198.Metal3 vin1.$625.Metal2 2.29777e-06f
Cred_10501 VDD.$8198.Metal3 vin1.$629.Metal2 2.29777e-06f
Cred_10502 VDD.$8198.Metal3 vin1.P35.GatPoly 0.00148432f
Cred_10503 VDD.$8198.Metal3 vin1.P36.GatPoly 0.0122233f
Cred_10504 VDD.$8198.Metal3 vin2.$422.Metal1 2.50363e-08f
Cred_10505 VDD.$8198.Metal3 vin2.$426.Metal1 1.86168e-08f
Cred_10506 VDD.$8198.Metal3 vin2.$624.Metal2 2.29777e-06f
Cred_10507 VDD.$8198.Metal3 vin2.$628.Metal2 2.29777e-06f
Cred_10508 VDD.$8198.Metal3 vin2.P35.GatPoly 0.00148432f
Cred_10509 VDD.$8198.Metal3 vin2.P36.GatPoly 0.0122233f
Cred_10510 VDD.$8198.Metal3 vout1.$1424.Metal3 0.00217444f
Cred_10511 VDD.$8198.Metal3 vout1.P16.pSD 0.000450612f
Cred_10512 VDD.$8198.Metal3 vout2.$1424.Metal3 0.00217444f
Cred_10513 VDD.$8198.Metal3 vout2.P16.pSD 0.000450612f
Cred_10514 VDD.$8204.Metal3 vin3.$423.Metal1 2.50363e-08f
Cred_10515 VDD.$8204.Metal3 vin3.$427.Metal1 1.86168e-08f
Cred_10516 VDD.$8204.Metal3 vin3.$625.Metal2 2.29777e-06f
Cred_10517 VDD.$8204.Metal3 vin3.$629.Metal2 2.29777e-06f
Cred_10518 VDD.$8204.Metal3 vin3.P35.GatPoly 0.00148432f
Cred_10519 VDD.$8204.Metal3 vin3.P36.GatPoly 0.0122233f
Cred_10520 VDD.$8204.Metal3 vin4.$422.Metal1 2.50363e-08f
Cred_10521 VDD.$8204.Metal3 vin4.$426.Metal1 1.86168e-08f
Cred_10522 VDD.$8204.Metal3 vin4.$624.Metal2 2.29777e-06f
Cred_10523 VDD.$8204.Metal3 vin4.$628.Metal2 2.29777e-06f
Cred_10524 VDD.$8204.Metal3 vin4.P35.GatPoly 0.00148432f
Cred_10525 VDD.$8204.Metal3 vin4.P36.GatPoly 0.0122233f
Cred_10526 VDD.$8204.Metal3 vout3.$1424.Metal3 0.00217444f
Cred_10527 VDD.$8204.Metal3 vout3.P16.pSD 0.000450612f
Cred_10528 VDD.$8204.Metal3 vout4.$1424.Metal3 0.00217444f
Cred_10529 VDD.$8204.Metal3 vout4.P16.pSD 0.000450612f
Cred_10530 VDD.$8222.Metal3 vin1.P36.GatPoly 0.00193004f
Cred_10531 VDD.$8222.Metal3 vin1.P37.GatPoly 0.00133512f
Cred_10532 VDD.$8222.Metal3 vin2.P36.GatPoly 0.00193004f
Cred_10533 VDD.$8222.Metal3 vin2.P37.GatPoly 0.00133512f
Cred_10534 VDD.$8222.Metal3 vout1.$1424.Metal3 0.0129218f
Cred_10535 VDD.$8222.Metal3 vout1.P16.pSD 0.0026835f
Cred_10536 VDD.$8222.Metal3 vout2.$1424.Metal3 0.0129218f
Cred_10537 VDD.$8222.Metal3 vout2.P16.pSD 0.0026835f
Cred_10538 VDD.$8228.Metal3 vin3.P36.GatPoly 0.00193004f
Cred_10539 VDD.$8228.Metal3 vin3.P37.GatPoly 0.00133512f
Cred_10540 VDD.$8228.Metal3 vin4.P36.GatPoly 0.00193004f
Cred_10541 VDD.$8228.Metal3 vin4.P37.GatPoly 0.00133512f
Cred_10542 VDD.$8228.Metal3 vout3.$1424.Metal3 0.0129218f
Cred_10543 VDD.$8228.Metal3 vout3.P16.pSD 0.0026835f
Cred_10544 VDD.$8228.Metal3 vout4.$1424.Metal3 0.0129218f
Cred_10545 VDD.$8228.Metal3 vout4.P16.pSD 0.0026835f
Cred_10546 VDD.$8246.Metal3 vin1.$173.GatPoly 6.42509e-11f
Cred_10547 VDD.$8246.Metal3 vin1.$441.Metal1 3.81679e-08f
Cred_10548 VDD.$8246.Metal3 vin1.$449.Metal1 5.38507e-09f
Cred_10549 VDD.$8246.Metal3 vin1.$636.Metal2 2.29776e-06f
Cred_10550 VDD.$8246.Metal3 vin1.$640.Metal2 2.29781e-06f
Cred_10551 VDD.$8246.Metal3 vin1.P37.GatPoly 0.0127875f
Cred_10552 VDD.$8246.Metal3 vin1.P38.GatPoly 0.00107201f
Cred_10553 VDD.$8246.Metal3 vin2.$172.GatPoly 6.42509e-11f
Cred_10554 VDD.$8246.Metal3 vin2.$440.Metal1 3.81679e-08f
Cred_10555 VDD.$8246.Metal3 vin2.$448.Metal1 5.38507e-09f
Cred_10556 VDD.$8246.Metal3 vin2.$635.Metal2 2.29776e-06f
Cred_10557 VDD.$8246.Metal3 vin2.$639.Metal2 2.29781e-06f
Cred_10558 VDD.$8246.Metal3 vin2.P37.GatPoly 0.0127875f
Cred_10559 VDD.$8246.Metal3 vin2.P38.GatPoly 0.00107201f
Cred_10560 VDD.$8246.Metal3 vout1.$1424.Metal3 0.00257712f
Cred_10561 VDD.$8246.Metal3 vout1.P16.pSD 0.000534058f
Cred_10562 VDD.$8246.Metal3 vout2.$1424.Metal3 0.00257712f
Cred_10563 VDD.$8246.Metal3 vout2.P16.pSD 0.000534058f
Cred_10564 VDD.$8252.Metal3 vin3.$173.GatPoly 6.42509e-11f
Cred_10565 VDD.$8252.Metal3 vin3.$441.Metal1 3.81679e-08f
Cred_10566 VDD.$8252.Metal3 vin3.$449.Metal1 5.38507e-09f
Cred_10567 VDD.$8252.Metal3 vin3.$636.Metal2 2.29776e-06f
Cred_10568 VDD.$8252.Metal3 vin3.$640.Metal2 2.29781e-06f
Cred_10569 VDD.$8252.Metal3 vin3.P37.GatPoly 0.0127875f
Cred_10570 VDD.$8252.Metal3 vin3.P38.GatPoly 0.00107201f
Cred_10571 VDD.$8252.Metal3 vin4.$172.GatPoly 6.42509e-11f
Cred_10572 VDD.$8252.Metal3 vin4.$440.Metal1 3.81679e-08f
Cred_10573 VDD.$8252.Metal3 vin4.$448.Metal1 5.38507e-09f
Cred_10574 VDD.$8252.Metal3 vin4.$635.Metal2 2.29776e-06f
Cred_10575 VDD.$8252.Metal3 vin4.$639.Metal2 2.29781e-06f
Cred_10576 VDD.$8252.Metal3 vin4.P37.GatPoly 0.0127875f
Cred_10577 VDD.$8252.Metal3 vin4.P38.GatPoly 0.00107201f
Cred_10578 VDD.$8252.Metal3 vout3.$1424.Metal3 0.00257712f
Cred_10579 VDD.$8252.Metal3 vout3.P16.pSD 0.000534058f
Cred_10580 VDD.$8252.Metal3 vout4.$1424.Metal3 0.00257712f
Cred_10581 VDD.$8252.Metal3 vout4.P16.pSD 0.000534058f
Cred_10582 VDD.$8282.Metal3 vin1.$453.Metal1 5.79227e-09f
Cred_10583 VDD.$8282.Metal3 vin1.$457.Metal1 3.79716e-08f
Cred_10584 VDD.$8282.Metal3 vin1.$645.Metal2 2.29772e-06f
Cred_10585 VDD.$8282.Metal3 vin1.$649.Metal2 2.29772e-06f
Cred_10586 VDD.$8282.Metal3 vin1.P37.GatPoly 0.000577237f
Cred_10587 VDD.$8282.Metal3 vin1.P38.GatPoly 0.0130339f
Cred_10588 VDD.$8282.Metal3 vin2.$452.Metal1 5.79227e-09f
Cred_10589 VDD.$8282.Metal3 vin2.$456.Metal1 3.79716e-08f
Cred_10590 VDD.$8282.Metal3 vin2.$644.Metal2 2.29772e-06f
Cred_10591 VDD.$8282.Metal3 vin2.$648.Metal2 2.29772e-06f
Cred_10592 VDD.$8282.Metal3 vin2.P37.GatPoly 0.000577237f
Cred_10593 VDD.$8282.Metal3 vin2.P38.GatPoly 0.0130339f
Cred_10594 VDD.$8282.Metal3 vout1 0.000466992f
Cred_10595 VDD.$8282.Metal3 vout1.$1424.Metal3 0.00235527f
Cred_10596 VDD.$8282.Metal3 vout1.P18.nSD 3.7105e-05f
Cred_10597 VDD.$8282.Metal3 vout1.P18.pSD 0.000835156f
Cred_10598 VDD.$8282.Metal3 vout2 0.000466992f
Cred_10599 VDD.$8282.Metal3 vout2.$1424.Metal3 0.00235527f
Cred_10600 VDD.$8282.Metal3 vout2.P18.nSD 3.7105e-05f
Cred_10601 VDD.$8282.Metal3 vout2.P18.pSD 0.000835156f
Cred_10602 VDD.$8288.Metal3 vin3.$453.Metal1 5.79227e-09f
Cred_10603 VDD.$8288.Metal3 vin3.$457.Metal1 3.79716e-08f
Cred_10604 VDD.$8288.Metal3 vin3.$645.Metal2 2.29772e-06f
Cred_10605 VDD.$8288.Metal3 vin3.$649.Metal2 2.29772e-06f
Cred_10606 VDD.$8288.Metal3 vin3.P37.GatPoly 0.000577237f
Cred_10607 VDD.$8288.Metal3 vin3.P38.GatPoly 0.0130339f
Cred_10608 VDD.$8288.Metal3 vin4.$452.Metal1 5.79227e-09f
Cred_10609 VDD.$8288.Metal3 vin4.$456.Metal1 3.79716e-08f
Cred_10610 VDD.$8288.Metal3 vin4.$644.Metal2 2.29772e-06f
Cred_10611 VDD.$8288.Metal3 vin4.$648.Metal2 2.29772e-06f
Cred_10612 VDD.$8288.Metal3 vin4.P37.GatPoly 0.000577237f
Cred_10613 VDD.$8288.Metal3 vin4.P38.GatPoly 0.0130339f
Cred_10614 VDD.$8288.Metal3 vout3 0.000466992f
Cred_10615 VDD.$8288.Metal3 vout3.$1424.Metal3 0.00235527f
Cred_10616 VDD.$8288.Metal3 vout3.P18.nSD 3.7105e-05f
Cred_10617 VDD.$8288.Metal3 vout3.P18.pSD 0.000835156f
Cred_10618 VDD.$8288.Metal3 vout4 0.000466992f
Cred_10619 VDD.$8288.Metal3 vout4.$1424.Metal3 0.00235527f
Cred_10620 VDD.$8288.Metal3 vout4.P18.nSD 3.7105e-05f
Cred_10621 VDD.$8288.Metal3 vout4.P18.pSD 0.000835156f
Cred_10622 VDD.$8306.Metal3 vin1.P38.GatPoly 0.000588003f
Cred_10623 VDD.$8306.Metal3 vin1.P39.GatPoly 0.00692341f
Cred_10624 VDD.$8306.Metal3 vin2.P38.GatPoly 0.000588003f
Cred_10625 VDD.$8306.Metal3 vin2.P39.GatPoly 0.00692341f
Cred_10626 VDD.$8306.Metal3 vout1 0.00195384f
Cred_10627 VDD.$8306.Metal3 vout1.$1424.Metal3 0.00985415f
Cred_10628 VDD.$8306.Metal3 vout1.P18.nSD 0.000155243f
Cred_10629 VDD.$8306.Metal3 vout1.P18.pSD 0.0034999f
Cred_10630 VDD.$8306.Metal3 vout2 0.00195384f
Cred_10631 VDD.$8306.Metal3 vout2.$1424.Metal3 0.00985415f
Cred_10632 VDD.$8306.Metal3 vout2.P18.nSD 0.000155243f
Cred_10633 VDD.$8306.Metal3 vout2.P18.pSD 0.0034999f
Cred_10634 VDD.$8312.Metal3 vin3.P38.GatPoly 0.000588003f
Cred_10635 VDD.$8312.Metal3 vin3.P39.GatPoly 0.00692341f
Cred_10636 VDD.$8312.Metal3 vin4.P38.GatPoly 0.000588003f
Cred_10637 VDD.$8312.Metal3 vin4.P39.GatPoly 0.00692341f
Cred_10638 VDD.$8312.Metal3 vout3 0.00195384f
Cred_10639 VDD.$8312.Metal3 vout3.$1424.Metal3 0.00985415f
Cred_10640 VDD.$8312.Metal3 vout3.P18.nSD 0.000155243f
Cred_10641 VDD.$8312.Metal3 vout3.P18.pSD 0.0034999f
Cred_10642 VDD.$8312.Metal3 vout4 0.00195384f
Cred_10643 VDD.$8312.Metal3 vout4.$1424.Metal3 0.00985415f
Cred_10644 VDD.$8312.Metal3 vout4.P18.nSD 0.000155243f
Cred_10645 VDD.$8312.Metal3 vout4.P18.pSD 0.0034999f
Cred_10646 VDD.$8342.Metal3 vin1.P39.GatPoly 0.0106396f
Cred_10647 VDD.$8342.Metal3 vin2.P39.GatPoly 0.0106396f
Cred_10648 VDD.$8342.Metal3 vout1 0.000170909f
Cred_10649 VDD.$8342.Metal3 vout1.$1424.Metal3 0.000861976f
Cred_10650 VDD.$8342.Metal3 vout1.P18.nSD 1.35796e-05f
Cred_10651 VDD.$8342.Metal3 vout1.P18.pSD 0.000305649f
Cred_10652 VDD.$8342.Metal3 vout2 0.000170909f
Cred_10653 VDD.$8342.Metal3 vout2.$1424.Metal3 0.000861976f
Cred_10654 VDD.$8342.Metal3 vout2.P18.nSD 1.35796e-05f
Cred_10655 VDD.$8342.Metal3 vout2.P18.pSD 0.000305649f
Cred_10656 VDD.$8348.Metal3 vin3.P39.GatPoly 0.0106396f
Cred_10657 VDD.$8348.Metal3 vin4.P39.GatPoly 0.0106396f
Cred_10658 VDD.$8348.Metal3 vout3 0.000170909f
Cred_10659 VDD.$8348.Metal3 vout3.$1424.Metal3 0.000861976f
Cred_10660 VDD.$8348.Metal3 vout3.P18.nSD 1.35796e-05f
Cred_10661 VDD.$8348.Metal3 vout3.P18.pSD 0.000305649f
Cred_10662 VDD.$8348.Metal3 vout4 0.000170909f
Cred_10663 VDD.$8348.Metal3 vout4.$1424.Metal3 0.000861976f
Cred_10664 VDD.$8348.Metal3 vout4.P18.nSD 1.35796e-05f
Cred_10665 VDD.$8348.Metal3 vout4.P18.pSD 0.000305649f
Cred_10666 VDD.$8402.Metal3 vin1.$179.GatPoly 8.38037e-06f
Cred_10667 VDD.$8402.Metal3 vin1.$180.GatPoly 2.51479e-06f
Cred_10668 VDD.$8402.Metal3 vin1.$456.Metal1 9.9425e-06f
Cred_10669 VDD.$8402.Metal3 vin1.$457.Metal1 7.38299e-05f
Cred_10670 VDD.$8402.Metal3 vin1.$648.Metal2 2.11384e-07f
Cred_10671 VDD.$8402.Metal3 vin1.$649.Metal2 1.56322e-06f
Cred_10672 VDD.$8402.Metal3 vin1.$653.Metal2 1.09397e-06f
Cred_10673 VDD.$8402.Metal3 vin1.$654.Metal2 7.75581e-06f
Cred_10674 VDD.$8402.Metal3 vin1.P18.GatPoly 3.42585e-05f
Cred_10675 VDD.$8402.Metal3 vin1.P19.GatPoly 0.000142749f
Cred_10676 VDD.$8402.Metal3 vin1.P39.GatPoly 0.000391866f
Cred_10677 VDD.$8402.Metal3 vin2.$178.GatPoly 3.19172e-06f
Cred_10678 VDD.$8402.Metal3 vin2.$456.Metal1 2.81186e-05f
Cred_10679 VDD.$8402.Metal3 vin2.$648.Metal2 5.95363e-07f
Cred_10680 VDD.$8402.Metal3 vin2.$653.Metal2 2.95385e-06f
Cred_10681 VDD.$8402.Metal3 vin2.P39.GatPoly 0.000357181f
Cred_10682 VDD.$8402.Metal3 vout1 0.0138794f
Cred_10683 VDD.$8402.Metal3 vout1.$1424.Metal3 0.00839113f
Cred_10684 VDD.$8402.Metal3 vout1.P18.nSD 0.000136252f
Cred_10685 VDD.$8402.Metal3 vout1.P18.pSD 0.00129602f
Cred_10686 VDD.$8402.Metal3 vout2 0.0106348f
Cred_10687 VDD.$8402.Metal3 vout2.$1424.Metal3 0.00671955f
Cred_10688 VDD.$8402.Metal3 vout2.P18.nSD 0.00010586f
Cred_10689 VDD.$8402.Metal3 vout2.P18.pSD 0.00114034f
Cred_10690 VDD.$8402.Metal3 VSS 0.0567075f
Cred_10691 VDD.$8402.Metal3 VSS.$1798.Metal1 3.34117e-06f
Cred_10692 VDD.$8402.Metal3 VSS.$1869.Metal1 8.33177e-08f
Cred_10693 VDD.$8402.Metal3 VSS.$1917.Metal1 8.33177e-08f
Cred_10694 VDD.$8402.Metal3 VSS.$1977.Metal1 1.09327e-07f
Cred_10695 VDD.$8402.Metal3 VSS.$1989.Metal1 2.71612e-05f
Cred_10696 VDD.$8402.Metal3 VSS.$2020.Metal1 3.96845e-05f
Cred_10697 VDD.$8402.Metal3 VSS.$2064.Metal1 8.26812e-08f
Cred_10698 VDD.$8402.Metal3 VSS.$3982.Metal2 4.50997e-05f
Cred_10699 VDD.$8402.Metal3 VSS.$4014.Metal2 5.05289e-05f
Cred_10700 VDD.$8402.Metal3 VSS.$4062.Metal2 4.19151e-05f
Cred_10701 VDD.$8402.Metal3 VSS.$4110.Metal2 3.17041e-05f
Cred_10702 VDD.$8402.Metal3 VSS.$4134.Metal2 3.49378e-05f
Cred_10703 VDD.$8402.Metal3 VSS.$4195.Metal2 4.50708e-05f
Cred_10704 VDD.$8402.Metal3 VSS.$4227.Metal2 0.000954082f
Cred_10705 VDD.$8402.Metal3 VSS.$4251.Metal2 7.72747e-05f
Cred_10706 VDD.$8402.Metal3 VSS.$5123.Metal3 4.39224e-05f
Cred_10707 VDD.$8402.Metal3 VSS.$5159.Metal3 0.000112947f
Cred_10708 VDD.$8402.Metal3 VSS.$5183.Metal3 0.000113595f
Cred_10709 VDD.$8402.Metal3 VSS.$5219.Metal3 0.000113621f
Cred_10710 VDD.$8402.Metal3 VSS.$5243.Metal3 0.000113652f
Cred_10711 VDD.$8402.Metal3 VSS.$5279.Metal3 0.00716435f
Cred_10712 VDD.$8402.Metal3 VSS.$5282.Metal3 2.35746e-05f
Cred_10713 VDD.$8402.Metal3 VSS.$5288.Metal3 1.04827e-08f
Cred_10714 VDD.$8402.Metal3 VSS.P3.GatPoly 3.81789e-05f
Cred_10715 VDD.$8402.Metal3 VSS.P43.nSD 1.14652e-07f
Cred_10716 VDD.$8402.Metal3 VSS.P45.nSD 1.55645e-07f
Cred_10717 VDD.$8402.Metal3 VSS.P47.nSD 1.55645e-07f
Cred_10718 VDD.$8408.Metal3 vin3.$179.GatPoly 3.19172e-06f
Cred_10719 VDD.$8408.Metal3 vin3.$457.Metal1 2.81186e-05f
Cred_10720 VDD.$8408.Metal3 vin3.$649.Metal2 5.95363e-07f
Cred_10721 VDD.$8408.Metal3 vin3.$654.Metal2 2.95385e-06f
Cred_10722 VDD.$8408.Metal3 vin3.P39.GatPoly 0.000357181f
Cred_10723 VDD.$8408.Metal3 vin4.$178.GatPoly 8.38037e-06f
Cred_10724 VDD.$8408.Metal3 vin4.$181.GatPoly 2.51479e-06f
Cred_10725 VDD.$8408.Metal3 vin4.$456.Metal1 7.38299e-05f
Cred_10726 VDD.$8408.Metal3 vin4.$457.Metal1 9.9425e-06f
Cred_10727 VDD.$8408.Metal3 vin4.$648.Metal2 1.56322e-06f
Cred_10728 VDD.$8408.Metal3 vin4.$649.Metal2 2.11384e-07f
Cred_10729 VDD.$8408.Metal3 vin4.$653.Metal2 7.75581e-06f
Cred_10730 VDD.$8408.Metal3 vin4.$654.Metal2 1.09397e-06f
Cred_10731 VDD.$8408.Metal3 vin4.P18.GatPoly 3.42585e-05f
Cred_10732 VDD.$8408.Metal3 vin4.P19.GatPoly 0.000142749f
Cred_10733 VDD.$8408.Metal3 vin4.P39.GatPoly 0.000391866f
Cred_10734 VDD.$8408.Metal3 vout3 0.0106348f
Cred_10735 VDD.$8408.Metal3 vout3.$1424.Metal3 0.00671955f
Cred_10736 VDD.$8408.Metal3 vout3.P18.nSD 0.00010586f
Cred_10737 VDD.$8408.Metal3 vout3.P18.pSD 0.00114034f
Cred_10738 VDD.$8408.Metal3 vout4 0.0138794f
Cred_10739 VDD.$8408.Metal3 vout4.$1424.Metal3 0.00839113f
Cred_10740 VDD.$8408.Metal3 vout4.P18.nSD 0.000136252f
Cred_10741 VDD.$8408.Metal3 vout4.P18.pSD 0.00129602f
Cred_10742 VDD.$8408.Metal3 VSS 0.0567075f
Cred_10743 VDD.$8408.Metal3 VSS.$1800.Metal1 3.34117e-06f
Cred_10744 VDD.$8408.Metal3 VSS.$1878.Metal1 8.33177e-08f
Cred_10745 VDD.$8408.Metal3 VSS.$1926.Metal1 8.33177e-08f
Cred_10746 VDD.$8408.Metal3 VSS.$1986.Metal1 1.09327e-07f
Cred_10747 VDD.$8408.Metal3 VSS.$1991.Metal1 2.71612e-05f
Cred_10748 VDD.$8408.Metal3 VSS.$2023.Metal1 3.96845e-05f
Cred_10749 VDD.$8408.Metal3 VSS.$2073.Metal1 8.26812e-08f
Cred_10750 VDD.$8408.Metal3 VSS.$4000.Metal2 4.50997e-05f
Cred_10751 VDD.$8408.Metal3 VSS.$4032.Metal2 5.05289e-05f
Cred_10752 VDD.$8408.Metal3 VSS.$4080.Metal2 4.19151e-05f
Cred_10753 VDD.$8408.Metal3 VSS.$4128.Metal2 3.17041e-05f
Cred_10754 VDD.$8408.Metal3 VSS.$4152.Metal2 3.49378e-05f
Cred_10755 VDD.$8408.Metal3 VSS.$4213.Metal2 4.50708e-05f
Cred_10756 VDD.$8408.Metal3 VSS.$4241.Metal2 0.000954082f
Cred_10757 VDD.$8408.Metal3 VSS.$4271.Metal2 7.72747e-05f
Cred_10758 VDD.$8408.Metal3 VSS.$5132.Metal3 4.39224e-05f
Cred_10759 VDD.$8408.Metal3 VSS.$5168.Metal3 0.000112947f
Cred_10760 VDD.$8408.Metal3 VSS.$5192.Metal3 0.000113595f
Cred_10761 VDD.$8408.Metal3 VSS.$5228.Metal3 0.000113621f
Cred_10762 VDD.$8408.Metal3 VSS.$5252.Metal3 0.000113652f
Cred_10763 VDD.$8408.Metal3 VSS.$5279.Metal3 1.04827e-08f
Cred_10764 VDD.$8408.Metal3 VSS.$5282.Metal3 2.35746e-05f
Cred_10765 VDD.$8408.Metal3 VSS.$5288.Metal3 0.00716435f
Cred_10766 VDD.$8408.Metal3 VSS.P1.GatPoly 3.81789e-05f
Cred_10767 VDD.$8408.Metal3 VSS.P19.nSD 1.14652e-07f
Cred_10768 VDD.$8408.Metal3 VSS.P21.nSD 1.55645e-07f
Cred_10769 VDD.$8408.Metal3 VSS.P23.nSD 1.55645e-07f
Cred_10770 VDD.$909.Metal1 vin1.P22.GatPoly 0.0108248f
Cred_10771 VDD.$909.Metal1 vin2.P22.GatPoly 0.0108248f
Cred_10772 VDD.$913.Metal1 vin3.P22.GatPoly 0.0108248f
Cred_10773 VDD.$913.Metal1 vin4.P22.GatPoly 0.0108248f
Cred_10774 VDD.$937.Metal1 vin1.P22.GatPoly 0.0178916f
Cred_10775 VDD.$937.Metal1 vin2.P22.GatPoly 0.0178916f
Cred_10776 VDD.$937.Metal1 vout1.$1226.Metal3 0.00243875f
Cred_10777 VDD.$937.Metal1 vout1.P0.nSD 3.53169e-05f
Cred_10778 VDD.$937.Metal1 vout1.P0.pSD 0.000187668f
Cred_10779 VDD.$937.Metal1 vout1.P2.nSD 3.84203e-05f
Cred_10780 VDD.$937.Metal1 vout1.P2.pSD 0.00125891f
Cred_10781 VDD.$937.Metal1 vout2.$1226.Metal3 0.00243875f
Cred_10782 VDD.$937.Metal1 vout2.P0.nSD 3.53169e-05f
Cred_10783 VDD.$937.Metal1 vout2.P0.pSD 0.000187668f
Cred_10784 VDD.$937.Metal1 vout2.P2.nSD 3.84203e-05f
Cred_10785 VDD.$937.Metal1 vout2.P2.pSD 0.00125891f
Cred_10786 VDD.$941.Metal1 vin3.P22.GatPoly 0.0178916f
Cred_10787 VDD.$941.Metal1 vin4.P22.GatPoly 0.0178916f
Cred_10788 VDD.$941.Metal1 vout3.$1226.Metal3 0.00243875f
Cred_10789 VDD.$941.Metal1 vout3.P0.nSD 3.53169e-05f
Cred_10790 VDD.$941.Metal1 vout3.P0.pSD 0.000187668f
Cred_10791 VDD.$941.Metal1 vout3.P2.nSD 3.84203e-05f
Cred_10792 VDD.$941.Metal1 vout3.P2.pSD 0.00125891f
Cred_10793 VDD.$941.Metal1 vout4.$1226.Metal3 0.00243875f
Cred_10794 VDD.$941.Metal1 vout4.P0.nSD 3.53169e-05f
Cred_10795 VDD.$941.Metal1 vout4.P0.pSD 0.000187668f
Cred_10796 VDD.$941.Metal1 vout4.P2.nSD 3.84203e-05f
Cred_10797 VDD.$941.Metal1 vout4.P2.pSD 0.00125891f
Cred_10798 VDD.$957.Metal1 vin1.P22.GatPoly 0.000333476f
Cred_10799 VDD.$957.Metal1 vin2.P22.GatPoly 0.000333476f
Cred_10800 VDD.$957.Metal1 vout1.$1226.Metal3 0.00549875f
Cred_10801 VDD.$957.Metal1 vout1.P0.nSD 7.96306e-05f
Cred_10802 VDD.$957.Metal1 vout1.P0.pSD 0.000423144f
Cred_10803 VDD.$957.Metal1 vout1.P2.nSD 8.66277e-05f
Cred_10804 VDD.$957.Metal1 vout1.P2.pSD 0.0050421f
Cred_10805 VDD.$957.Metal1 vout2.$1226.Metal3 0.00549875f
Cred_10806 VDD.$957.Metal1 vout2.P0.nSD 7.96306e-05f
Cred_10807 VDD.$957.Metal1 vout2.P0.pSD 0.000423144f
Cred_10808 VDD.$957.Metal1 vout2.P2.nSD 8.66277e-05f
Cred_10809 VDD.$957.Metal1 vout2.P2.pSD 0.0050421f
Cred_10810 VDD.$961.Metal1 vin3.P22.GatPoly 0.000333476f
Cred_10811 VDD.$961.Metal1 vin4.P22.GatPoly 0.000333476f
Cred_10812 VDD.$961.Metal1 vout3.$1226.Metal3 0.00549875f
Cred_10813 VDD.$961.Metal1 vout3.P0.nSD 7.96306e-05f
Cred_10814 VDD.$961.Metal1 vout3.P0.pSD 0.000423144f
Cred_10815 VDD.$961.Metal1 vout3.P2.nSD 8.66277e-05f
Cred_10816 VDD.$961.Metal1 vout3.P2.pSD 0.0050421f
Cred_10817 VDD.$961.Metal1 vout4.$1226.Metal3 0.00549875f
Cred_10818 VDD.$961.Metal1 vout4.P0.nSD 7.96306e-05f
Cred_10819 VDD.$961.Metal1 vout4.P0.pSD 0.000423144f
Cred_10820 VDD.$961.Metal1 vout4.P2.nSD 8.66277e-05f
Cred_10821 VDD.$961.Metal1 vout4.P2.pSD 0.0050421f
Cred_10822 VDD.$977.Metal1 vin1.P23.GatPoly 0.00632683f
Cred_10823 VDD.$977.Metal1 vin2.P23.GatPoly 0.00632683f
Cred_10824 VDD.$977.Metal1 vout1.$1226.Metal3 0.00475777f
Cred_10825 VDD.$977.Metal1 vout1.P0.nSD 6.88999e-05f
Cred_10826 VDD.$977.Metal1 vout1.P0.pSD 0.000366123f
Cred_10827 VDD.$977.Metal1 vout1.P2.nSD 7.49541e-05f
Cred_10828 VDD.$977.Metal1 vout1.P2.pSD 0.00337114f
Cred_10829 VDD.$977.Metal1 vout2.$1226.Metal3 0.00475777f
Cred_10830 VDD.$977.Metal1 vout2.P0.nSD 6.88999e-05f
Cred_10831 VDD.$977.Metal1 vout2.P0.pSD 0.000366123f
Cred_10832 VDD.$977.Metal1 vout2.P2.nSD 7.49541e-05f
Cred_10833 VDD.$977.Metal1 vout2.P2.pSD 0.00337114f
Cred_10834 VDD.$981.Metal1 vin3.P23.GatPoly 0.00632683f
Cred_10835 VDD.$981.Metal1 vin4.P23.GatPoly 0.00632683f
Cred_10836 VDD.$981.Metal1 vout3.$1226.Metal3 0.00475777f
Cred_10837 VDD.$981.Metal1 vout3.P0.nSD 6.88999e-05f
Cred_10838 VDD.$981.Metal1 vout3.P0.pSD 0.000366123f
Cred_10839 VDD.$981.Metal1 vout3.P2.nSD 7.49541e-05f
Cred_10840 VDD.$981.Metal1 vout3.P2.pSD 0.00337114f
Cred_10841 VDD.$981.Metal1 vout4.$1226.Metal3 0.00475777f
Cred_10842 VDD.$981.Metal1 vout4.P0.nSD 6.88999e-05f
Cred_10843 VDD.$981.Metal1 vout4.P0.pSD 0.000366123f
Cred_10844 VDD.$981.Metal1 vout4.P2.nSD 7.49541e-05f
Cred_10845 VDD.$981.Metal1 vout4.P2.pSD 0.00337114f
Cred_10846 VDD.$997.Metal1 vin1.$233.Metal1 5.74081e-09f
Cred_10847 VDD.$997.Metal1 vin1.$237.Metal1 7.72039e-09f
Cred_10848 VDD.$997.Metal1 vin1.$500.Metal2 7.08559e-07f
Cred_10849 VDD.$997.Metal1 vin1.$504.Metal2 7.08559e-07f
Cred_10850 VDD.$997.Metal1 vin1.P23.GatPoly 0.0125591f
Cred_10851 VDD.$997.Metal1 vin2.$232.Metal1 5.74081e-09f
Cred_10852 VDD.$997.Metal1 vin2.$236.Metal1 7.72039e-09f
Cred_10853 VDD.$997.Metal1 vin2.$499.Metal2 7.08559e-07f
Cred_10854 VDD.$997.Metal1 vin2.$503.Metal2 7.08559e-07f
Cred_10855 VDD.$997.Metal1 vin2.P23.GatPoly 0.0125591f
Cred_10856 VDD.P0.GatPoly vin4.$202.Metal1 0.016755f
Cred_10857 VDD.P0.GatPoly vin4.$477.Metal2 0.00210703f
Cred_10858 VDD.P0.GatPoly vin4.$479.Metal2 0.00427619f
Cred_10859 VDD.P0.GatPoly vin4.$8.GatPoly 0.00305381f
Cred_10860 VDD.P0.GatPoly vin4.P20.GatPoly 0.0706836f
Cred_10861 VDD.P0.GatPoly vin4.P21.GatPoly 0.00596583f
Cred_10862 VDD.P0.GatPoly vin4.P22.GatPoly 0.00328573f
Cred_10863 VDD.P0.GatPoly vin4.P23.GatPoly 0.00227743f
Cred_10864 VDD.P0.GatPoly vin4.P24.GatPoly 0.00160627f
Cred_10865 VDD.P0.GatPoly vin4.P25.GatPoly 0.00130082f
Cred_10866 VDD.P0.GatPoly vout4.$1226.Metal3 0.000869187f
Cred_10867 VDD.P0.GatPoly vout4.P0.nSD 2.58816e-05f
Cred_10868 VDD.P0.GatPoly vout4.P0.pSD 0.000241362f
Cred_10869 VDD.P0.GatPoly vout4.P2.nSD 1.36932e-05f
Cred_10870 VDD.P0.GatPoly vout4.P2.pSD 7.48366e-05f
Cred_10871 VDD.P0.GatPoly VSS.P0.GatPoly 0.00217316f
Cred_10872 VDD.P0.nSD vin3.P20.GatPoly 2.87301e-07f
Cred_10873 VDD.P0.nSD vin3.P22.GatPoly 3.87488e-06f
Cred_10874 VDD.P0.nSD vin3.P24.GatPoly 1.11477e-06f
Cred_10875 VDD.P0.nSD vin3.P25.GatPoly 3.99011e-06f
Cred_10876 VDD.P0.nSD vin3.P27.GatPoly 1.55357e-06f
Cred_10877 VDD.P0.nSD vin3.P28.GatPoly 3.84561e-06f
Cred_10878 VDD.P0.nSD vin3.P29.GatPoly 1.28772e-06f
Cred_10879 VDD.P0.nSD vin3.P30.GatPoly 1.28772e-06f
Cred_10880 VDD.P0.nSD vin3.P31.GatPoly 3.9016e-06f
Cred_10881 VDD.P0.nSD vin3.P33.GatPoly 1.31945e-06f
Cred_10882 VDD.P0.nSD vin3.P34.GatPoly 3.99011e-06f
Cred_10883 VDD.P0.nSD vin3.P35.GatPoly 1.11477e-06f
Cred_10884 VDD.P0.nSD vin3.P37.GatPoly 3.50761e-06f
Cred_10885 VDD.P0.nSD vin3.P38.GatPoly 2.63377e-06f
Cred_10886 VDD.P0.nSD vin4.$104.GatPoly 0.00421471f
Cred_10887 VDD.P0.nSD vin4.$106.GatPoly 0.00336399f
Cred_10888 VDD.P0.nSD vin4.$114.GatPoly 0.0049101f
Cred_10889 VDD.P0.nSD vin4.$122.GatPoly 0.00500629f
Cred_10890 VDD.P0.nSD vin4.$126.GatPoly 0.00404075f
Cred_10891 VDD.P0.nSD vin4.$134.GatPoly 0.0042789f
Cred_10892 VDD.P0.nSD vin4.$136.GatPoly 0.00345863f
Cred_10893 VDD.P0.nSD vin4.$14.GatPoly 0.00356132f
Cred_10894 VDD.P0.nSD vin4.$144.GatPoly 0.00478496f
Cred_10895 VDD.P0.nSD vin4.$152.GatPoly 0.00500307f
Cred_10896 VDD.P0.nSD vin4.$156.GatPoly 0.00339349f
Cred_10897 VDD.P0.nSD vin4.$16.GatPoly 0.00384897f
Cred_10898 VDD.P0.nSD vin4.$162.GatPoly 0.00398664f
Cred_10899 VDD.P0.nSD vin4.$166.GatPoly 0.00356132f
Cred_10900 VDD.P0.nSD vin4.$172.GatPoly 0.00384897f
Cred_10901 VDD.P0.nSD vin4.$178.GatPoly 0.00703546f
Cred_10902 VDD.P0.nSD vin4.$202.Metal1 0.112116f
Cred_10903 VDD.P0.nSD vin4.$206.Metal1 0.0231364f
Cred_10904 VDD.P0.nSD vin4.$210.Metal1 0.0346299f
Cred_10905 VDD.P0.nSD vin4.$218.Metal1 0.0486079f
Cred_10906 VDD.P0.nSD vin4.$226.Metal1 0.0464702f
Cred_10907 VDD.P0.nSD vin4.$232.Metal1 0.0327464f
Cred_10908 VDD.P0.nSD vin4.$236.Metal1 0.0239851f
Cred_10909 VDD.P0.nSD vin4.$24.GatPoly 0.00339349f
Cred_10910 VDD.P0.nSD vin4.$240.Metal1 0.0344523f
Cred_10911 VDD.P0.nSD vin4.$246.Metal1 0.0350925f
Cred_10912 VDD.P0.nSD vin4.$250.Metal1 0.0350268f
Cred_10913 VDD.P0.nSD vin4.$258.Metal1 0.0354111f
Cred_10914 VDD.P0.nSD vin4.$26.GatPoly 0.00398664f
Cred_10915 VDD.P0.nSD vin4.$262.Metal1 0.0238519f
Cred_10916 VDD.P0.nSD vin4.$264.Metal1 0.0354424f
Cred_10917 VDD.P0.nSD vin4.$272.Metal1 0.0348641f
Cred_10918 VDD.P0.nSD vin4.$276.Metal1 0.0238686f
Cred_10919 VDD.P0.nSD vin4.$280.Metal1 0.0247786f
Cred_10920 VDD.P0.nSD vin4.$284.Metal1 0.0346872f
Cred_10921 VDD.P0.nSD vin4.$290.Metal1 0.0371403f
Cred_10922 VDD.P0.nSD vin4.$294.Metal1 0.0352858f
Cred_10923 VDD.P0.nSD vin4.$302.Metal1 0.035234f
Cred_10924 VDD.P0.nSD vin4.$306.Metal1 0.0365289f
Cred_10925 VDD.P0.nSD vin4.$312.Metal1 0.0354259f
Cred_10926 VDD.P0.nSD vin4.$316.Metal1 0.0235251f
Cred_10927 VDD.P0.nSD vin4.$320.Metal1 0.02452f
Cred_10928 VDD.P0.nSD vin4.$324.Metal1 0.0346972f
Cred_10929 VDD.P0.nSD vin4.$330.Metal1 0.0350222f
Cred_10930 VDD.P0.nSD vin4.$334.Metal1 0.0236181f
Cred_10931 VDD.P0.nSD vin4.$338.Metal1 0.02452f
Cred_10932 VDD.P0.nSD vin4.$342.Metal1 0.0235251f
Cred_10933 VDD.P0.nSD vin4.$346.Metal1 0.0354259f
Cred_10934 VDD.P0.nSD vin4.$352.Metal1 0.0365289f
Cred_10935 VDD.P0.nSD vin4.$356.Metal1 0.035234f
Cred_10936 VDD.P0.nSD vin4.$36.GatPoly 0.00500307f
Cred_10937 VDD.P0.nSD vin4.$364.Metal1 0.0352858f
Cred_10938 VDD.P0.nSD vin4.$368.Metal1 0.0371403f
Cred_10939 VDD.P0.nSD vin4.$374.Metal1 0.0346872f
Cred_10940 VDD.P0.nSD vin4.$378.Metal1 0.0247786f
Cred_10941 VDD.P0.nSD vin4.$382.Metal1 0.0238686f
Cred_10942 VDD.P0.nSD vin4.$386.Metal1 0.0348641f
Cred_10943 VDD.P0.nSD vin4.$392.Metal1 0.0354424f
Cred_10944 VDD.P0.nSD vin4.$396.Metal1 0.0238519f
Cred_10945 VDD.P0.nSD vin4.$400.Metal1 0.0354111f
Cred_10946 VDD.P0.nSD vin4.$408.Metal1 0.0350268f
Cred_10947 VDD.P0.nSD vin4.$412.Metal1 0.0350925f
Cred_10948 VDD.P0.nSD vin4.$418.Metal1 0.0344523f
Cred_10949 VDD.P0.nSD vin4.$42.GatPoly 0.00478496f
Cred_10950 VDD.P0.nSD vin4.$422.Metal1 0.0239851f
Cred_10951 VDD.P0.nSD vin4.$426.Metal1 0.0327464f
Cred_10952 VDD.P0.nSD vin4.$432.Metal1 0.0464702f
Cred_10953 VDD.P0.nSD vin4.$44.GatPoly 0.00345863f
Cred_10954 VDD.P0.nSD vin4.$440.Metal1 0.0486079f
Cred_10955 VDD.P0.nSD vin4.$448.Metal1 0.0346299f
Cred_10956 VDD.P0.nSD vin4.$452.Metal1 0.0231364f
Cred_10957 VDD.P0.nSD vin4.$456.Metal1 0.109324f
Cred_10958 VDD.P0.nSD vin4.$477.Metal2 0.0908133f
Cred_10959 VDD.P0.nSD vin4.$479.Metal2 0.08567f
Cred_10960 VDD.P0.nSD vin4.$483.Metal2 0.0149513f
Cred_10961 VDD.P0.nSD vin4.$486.Metal2 0.0388047f
Cred_10962 VDD.P0.nSD vin4.$488.Metal2 0.017935f
Cred_10963 VDD.P0.nSD vin4.$492.Metal2 0.0179809f
Cred_10964 VDD.P0.nSD vin4.$495.Metal2 0.0422344f
Cred_10965 VDD.P0.nSD vin4.$499.Metal2 0.0184429f
Cred_10966 VDD.P0.nSD vin4.$503.Metal2 0.0199247f
Cred_10967 VDD.P0.nSD vin4.$506.Metal2 0.039041f
Cred_10968 VDD.P0.nSD vin4.$508.Metal2 0.0133764f
Cred_10969 VDD.P0.nSD vin4.$512.Metal2 0.0144528f
Cred_10970 VDD.P0.nSD vin4.$515.Metal2 0.051558f
Cred_10971 VDD.P0.nSD vin4.$517.Metal2 0.0168442f
Cred_10972 VDD.P0.nSD vin4.$519.Metal2 0.00884236f
Cred_10973 VDD.P0.nSD vin4.$52.GatPoly 0.0042789f
Cred_10974 VDD.P0.nSD vin4.$524.Metal2 0.00553104f
Cred_10975 VDD.P0.nSD vin4.$525.Metal2 0.0405423f
Cred_10976 VDD.P0.nSD vin4.$529.Metal2 0.000210039f
Cred_10977 VDD.P0.nSD vin4.$532.Metal2 0.0214362f
Cred_10978 VDD.P0.nSD vin4.$535.Metal2 0.0519332f
Cred_10979 VDD.P0.nSD vin4.$537.Metal2 0.0149744f
Cred_10980 VDD.P0.nSD vin4.$541.Metal2 0.012857f
Cred_10981 VDD.P0.nSD vin4.$544.Metal2 0.0372266f
Cred_10982 VDD.P0.nSD vin4.$546.Metal2 0.0219041f
Cred_10983 VDD.P0.nSD vin4.$550.Metal2 0.0179759f
Cred_10984 VDD.P0.nSD vin4.$555.Metal2 0.0429912f
Cred_10985 VDD.P0.nSD vin4.$557.Metal2 0.0192661f
Cred_10986 VDD.P0.nSD vin4.$56.GatPoly 0.00404075f
Cred_10987 VDD.P0.nSD vin4.$561.Metal2 0.0172678f
Cred_10988 VDD.P0.nSD vin4.$564.Metal2 0.0398348f
Cred_10989 VDD.P0.nSD vin4.$566.Metal2 0.0170672f
Cred_10990 VDD.P0.nSD vin4.$570.Metal2 0.0192661f
Cred_10991 VDD.P0.nSD vin4.$573.Metal2 0.0429912f
Cred_10992 VDD.P0.nSD vin4.$577.Metal2 0.0179759f
Cred_10993 VDD.P0.nSD vin4.$581.Metal2 0.0219041f
Cred_10994 VDD.P0.nSD vin4.$584.Metal2 0.0372266f
Cred_10995 VDD.P0.nSD vin4.$586.Metal2 0.012857f
Cred_10996 VDD.P0.nSD vin4.$590.Metal2 0.0149744f
Cred_10997 VDD.P0.nSD vin4.$593.Metal2 0.0519332f
Cred_10998 VDD.P0.nSD vin4.$595.Metal2 0.0214362f
Cred_10999 VDD.P0.nSD vin4.$600.Metal2 0.000210039f
Cred_11000 VDD.P0.nSD vin4.$601.Metal2 0.0405423f
Cred_11001 VDD.P0.nSD vin4.$605.Metal2 0.00553104f
Cred_11002 VDD.P0.nSD vin4.$608.Metal2 0.00884236f
Cred_11003 VDD.P0.nSD vin4.$610.Metal2 0.0168442f
Cred_11004 VDD.P0.nSD vin4.$613.Metal2 0.051558f
Cred_11005 VDD.P0.nSD vin4.$615.Metal2 0.0144528f
Cred_11006 VDD.P0.nSD vin4.$619.Metal2 0.0133764f
Cred_11007 VDD.P0.nSD vin4.$622.Metal2 0.039041f
Cred_11008 VDD.P0.nSD vin4.$624.Metal2 0.0199247f
Cred_11009 VDD.P0.nSD vin4.$628.Metal2 0.0184429f
Cred_11010 VDD.P0.nSD vin4.$633.Metal2 0.0422344f
Cred_11011 VDD.P0.nSD vin4.$635.Metal2 0.0179809f
Cred_11012 VDD.P0.nSD vin4.$639.Metal2 0.017935f
Cred_11013 VDD.P0.nSD vin4.$64.GatPoly 0.00500629f
Cred_11014 VDD.P0.nSD vin4.$642.Metal2 0.053141f
Cred_11015 VDD.P0.nSD vin4.$644.Metal2 0.0149513f
Cred_11016 VDD.P0.nSD vin4.$648.Metal2 0.0148821f
Cred_11017 VDD.P0.nSD vin4.$649.Metal2 0.000800456f
Cred_11018 VDD.P0.nSD vin4.$653.Metal2 0.0358397f
Cred_11019 VDD.P0.nSD vin4.$654.Metal2 0.00306057f
Cred_11020 VDD.P0.nSD vin4.$72.GatPoly 0.0049101f
Cred_11021 VDD.P0.nSD vin4.$76.GatPoly 0.00336399f
Cred_11022 VDD.P0.nSD vin4.$8.GatPoly 0.00708578f
Cred_11023 VDD.P0.nSD vin4.$82.GatPoly 0.00421471f
Cred_11024 VDD.P0.nSD vin4.$86.GatPoly 0.00325351f
Cred_11025 VDD.P0.nSD vin4.$92.GatPoly 0.0047247f
Cred_11026 VDD.P0.nSD vin4.$96.GatPoly 0.0040374f
Cred_11027 VDD.P0.nSD vin4.P20.GatPoly 0.0164833f
Cred_11028 VDD.P0.nSD vin4.P22.GatPoly 3.87488e-06f
Cred_11029 VDD.P0.nSD vin4.P24.GatPoly 0.000433398f
Cred_11030 VDD.P0.nSD vin4.P25.GatPoly 3.99011e-06f
Cred_11031 VDD.P0.nSD vin4.P27.GatPoly 0.000432247f
Cred_11032 VDD.P0.nSD vin4.P28.GatPoly 3.84561e-06f
Cred_11033 VDD.P0.nSD vin4.P29.GatPoly 1.28772e-06f
Cred_11034 VDD.P0.nSD vin4.P30.GatPoly 1.28772e-06f
Cred_11035 VDD.P0.nSD vin4.P31.GatPoly 3.9016e-06f
Cred_11036 VDD.P0.nSD vin4.P32.GatPoly 0.000430693f
Cred_11037 VDD.P0.nSD vin4.P33.GatPoly 1.31945e-06f
Cred_11038 VDD.P0.nSD vin4.P34.GatPoly 3.99011e-06f
Cred_11039 VDD.P0.nSD vin4.P35.GatPoly 0.000433398f
Cred_11040 VDD.P0.nSD vin4.P37.GatPoly 3.50761e-06f
Cred_11041 VDD.P0.nSD vin4.P38.GatPoly 2.63377e-06f
Cred_11042 VDD.P0.nSD vin4.P39.GatPoly 0.0164443f
Cred_11043 VDD.P0.nSD vout3 2.22237e-07f
Cred_11044 VDD.P0.nSD vout3.$1226.Metal3 2.67196e-06f
Cred_11045 VDD.P0.nSD vout3.$1292.Metal3 1.06686e-06f
Cred_11046 VDD.P0.nSD vout3.$1358.Metal3 2.26464e-06f
Cred_11047 VDD.P0.nSD vout3.$1424.Metal3 2.15529e-06f
Cred_11048 VDD.P0.nSD vout3.P0.nSD 4.44269e-08f
Cred_11049 VDD.P0.nSD vout3.P0.pSD 1.68946e-06f
Cred_11050 VDD.P0.nSD vout3.P10.nSD 3.47458e-09f
Cred_11051 VDD.P0.nSD vout3.P10.pSD 9.4127e-08f
Cred_11052 VDD.P0.nSD vout3.P12.pSD 1.29835e-06f
Cred_11053 VDD.P0.nSD vout3.P14.nSD 2.4801e-09f
Cred_11054 VDD.P0.nSD vout3.P14.pSD 6.71862e-08f
Cred_11055 VDD.P0.nSD vout3.P16.pSD 3.22496e-07f
Cred_11056 VDD.P0.nSD vout3.P18.nSD 1.76579e-08f
Cred_11057 VDD.P0.nSD vout3.P18.pSD 7.82298e-07f
Cred_11058 VDD.P0.nSD vout3.P2.nSD 2.3505e-08f
Cred_11059 VDD.P0.nSD vout3.P2.pSD 1.2846e-07f
Cred_11060 VDD.P0.nSD vout3.P4.pSD 5.08636e-08f
Cred_11061 VDD.P0.nSD vout3.P6.nSD 1.33328e-08f
Cred_11062 VDD.P0.nSD vout3.P6.pSD 1.29616e-06f
Cred_11063 VDD.P0.nSD vout4 0.0113337f
Cred_11064 VDD.P0.nSD vout4.$1226.Metal3 0.0485558f
Cred_11065 VDD.P0.nSD vout4.$1292.Metal3 0.032444f
Cred_11066 VDD.P0.nSD vout4.$1358.Metal3 0.034326f
Cred_11067 VDD.P0.nSD vout4.$1424.Metal3 0.0646444f
Cred_11068 VDD.P0.nSD vout4.P0.nSD 0.000559791f
Cred_11069 VDD.P0.nSD vout4.P0.pSD 0.00336865f
Cred_11070 VDD.P0.nSD vout4.P10.nSD 0.000132191f
Cred_11071 VDD.P0.nSD vout4.P10.pSD 0.000716033f
Cred_11072 VDD.P0.nSD vout4.P12.pSD 1.29835e-06f
Cred_11073 VDD.P0.nSD vout4.P14.nSD 0.00013133f
Cred_11074 VDD.P0.nSD vout4.P14.pSD 0.000711346f
Cred_11075 VDD.P0.nSD vout4.P16.pSD 3.22496e-07f
Cred_11076 VDD.P0.nSD vout4.P18.nSD 0.000628407f
Cred_11077 VDD.P0.nSD vout4.P18.pSD 0.00357822f
Cred_11078 VDD.P0.nSD vout4.P2.nSD 0.000387687f
Cred_11079 VDD.P0.nSD vout4.P2.pSD 0.0021188f
Cred_11080 VDD.P0.nSD vout4.P4.pSD 5.08636e-08f
Cred_11081 VDD.P0.nSD vout4.P6.nSD 0.000122019f
Cred_11082 VDD.P0.nSD vout4.P6.pSD 0.000668083f
Cred_11083 VDD.P0.nSD VSS.$160.Metal1 0.00310273f
Cred_11084 VDD.P0.nSD VSS.$1991.Metal1 0.00889836f
Cred_11085 VDD.P0.nSD VSS.$2023.Metal1 0.0254358f
Cred_11086 VDD.P0.nSD VSS.$2240.Metal2 7.40825e-05f
Cred_11087 VDD.P0.nSD VSS.$4241.Metal2 0.00104279f
Cred_11088 VDD.P0.nSD VSS.$66.Metal1 0.0342788f
Cred_11089 VDD.P0.nSD VSS.P0.nSD 2.08038e-05f
Cred_11090 VDD.P0.nSD VSS.P0.pSD 0.515622f
Cred_11091 VDD.P0.nSD VSS.P1.nSD 2.08038e-05f
Cred_11092 VDD.P0.nSD VSS.P21.nSD 2.10292e-05f
Cred_11093 VDD.P0.nSD VSS.P23.nSD 2.10292e-05f
Cred_11094 VDD.P0.pSD vin4.$202.Metal1 0.0029278f
Cred_11095 VDD.P0.pSD vin4.$477.Metal2 0.000701873f
Cred_11096 VDD.P0.pSD vin4.$479.Metal2 0.00136856f
Cred_11097 VDD.P0.pSD vin4.$8.GatPoly 0.000325071f
Cred_11098 VDD.P0.pSD vin4.P20.GatPoly 0.0122877f
Cred_11099 VDD.P0.pSD vout4.$1226.Metal3 0.00660132f
Cred_11100 VDD.P0.pSD vout4.P0.nSD 0.000196566f
Cred_11101 VDD.P0.pSD vout4.P0.pSD 0.0055555f
Cred_11102 VDD.P0.pSD vout4.P2.nSD 0.000103998f
Cred_11103 VDD.P0.pSD vout4.P2.pSD 0.00056837f
Cred_11104 VDD.P0.pSD VSS.$1991.Metal1 1.76127e-08f
Cred_11105 VDD.P0.pSD VSS.$2023.Metal1 4.40988e-08f
Cred_11106 VDD.P0.pSD VSS.$4241.Metal2 1.18065e-10f
Cred_11107 VDD.P0.pSD VSS.$4364.Metal3 3.79621e-05f
Cred_11108 VDD.P0.pSD VSS.$66.Metal1 0.000100615f
Cred_11109 VDD.P0.pSD VSS.P0.pSD 0.000256148f
Cred_11110 VDD.P1.GatPoly vin4.$178.GatPoly 0.0030499f
Cred_11111 VDD.P1.GatPoly vin4.$456.Metal1 0.0165391f
Cred_11112 VDD.P1.GatPoly vin4.$648.Metal2 0.000349285f
Cred_11113 VDD.P1.GatPoly vin4.$653.Metal2 0.00168599f
Cred_11114 VDD.P1.GatPoly vin4.P34.GatPoly 0.00130082f
Cred_11115 VDD.P1.GatPoly vin4.P35.GatPoly 0.00160627f
Cred_11116 VDD.P1.GatPoly vin4.P36.GatPoly 0.00227743f
Cred_11117 VDD.P1.GatPoly vin4.P37.GatPoly 0.00328573f
Cred_11118 VDD.P1.GatPoly vin4.P38.GatPoly 0.00596583f
Cred_11119 VDD.P1.GatPoly vin4.P39.GatPoly 0.0706805f
Cred_11120 VDD.P1.GatPoly vout4 0.000613058f
Cred_11121 VDD.P1.GatPoly vout4.$1424.Metal3 0.00309194f
Cred_11122 VDD.P1.GatPoly vout4.P18.nSD 4.87107e-05f
Cred_11123 VDD.P1.GatPoly vout4.P18.pSD 0.000338518f
Cred_11124 VDD.P1.GatPoly VSS.P1.GatPoly 0.00217316f
Cred_11125 VDD.P1.nSD vin1.$105.GatPoly 0.0042155f
Cred_11126 VDD.P1.nSD vin1.$107.GatPoly 0.00336467f
Cred_11127 VDD.P1.nSD vin1.$115.GatPoly 0.0049112f
Cred_11128 VDD.P1.nSD vin1.$123.GatPoly 0.00500763f
Cred_11129 VDD.P1.nSD vin1.$127.GatPoly 0.00404204f
Cred_11130 VDD.P1.nSD vin1.$135.GatPoly 0.00428052f
Cred_11131 VDD.P1.nSD vin1.$137.GatPoly 0.00346016f
Cred_11132 VDD.P1.nSD vin1.$145.GatPoly 0.00478749f
Cred_11133 VDD.P1.nSD vin1.$15.GatPoly 0.00356548f
Cred_11134 VDD.P1.nSD vin1.$153.GatPoly 0.00500646f
Cred_11135 VDD.P1.nSD vin1.$157.GatPoly 0.00339629f
Cred_11136 VDD.P1.nSD vin1.$163.GatPoly 0.00399055f
Cred_11137 VDD.P1.nSD vin1.$167.GatPoly 0.00356548f
Cred_11138 VDD.P1.nSD vin1.$17.GatPoly 0.00385431f
Cred_11139 VDD.P1.nSD vin1.$173.GatPoly 0.00385431f
Cred_11140 VDD.P1.nSD vin1.$179.GatPoly 0.0070487f
Cred_11141 VDD.P1.nSD vin1.$203.Metal1 0.112352f
Cred_11142 VDD.P1.nSD vin1.$207.Metal1 0.0231727f
Cred_11143 VDD.P1.nSD vin1.$211.Metal1 0.0346785f
Cred_11144 VDD.P1.nSD vin1.$219.Metal1 0.0486666f
Cred_11145 VDD.P1.nSD vin1.$227.Metal1 0.0465174f
Cred_11146 VDD.P1.nSD vin1.$233.Metal1 0.0327751f
Cred_11147 VDD.P1.nSD vin1.$237.Metal1 0.024004f
Cred_11148 VDD.P1.nSD vin1.$241.Metal1 0.0344766f
Cred_11149 VDD.P1.nSD vin1.$247.Metal1 0.0351145f
Cred_11150 VDD.P1.nSD vin1.$25.GatPoly 0.00339629f
Cred_11151 VDD.P1.nSD vin1.$251.Metal1 0.0350461f
Cred_11152 VDD.P1.nSD vin1.$259.Metal1 0.0354286f
Cred_11153 VDD.P1.nSD vin1.$263.Metal1 0.0238625f
Cred_11154 VDD.P1.nSD vin1.$265.Metal1 0.0354565f
Cred_11155 VDD.P1.nSD vin1.$27.GatPoly 0.00399055f
Cred_11156 VDD.P1.nSD vin1.$273.Metal1 0.0348767f
Cred_11157 VDD.P1.nSD vin1.$277.Metal1 0.0238764f
Cred_11158 VDD.P1.nSD vin1.$281.Metal1 0.0247862f
Cred_11159 VDD.P1.nSD vin1.$285.Metal1 0.0346968f
Cred_11160 VDD.P1.nSD vin1.$291.Metal1 0.0371498f
Cred_11161 VDD.P1.nSD vin1.$295.Metal1 0.035294f
Cred_11162 VDD.P1.nSD vin1.$303.Metal1 0.0352415f
Cred_11163 VDD.P1.nSD vin1.$307.Metal1 0.0365361f
Cred_11164 VDD.P1.nSD vin1.$313.Metal1 0.0354326f
Cred_11165 VDD.P1.nSD vin1.$317.Metal1 0.0235294f
Cred_11166 VDD.P1.nSD vin1.$321.Metal1 0.0245244f
Cred_11167 VDD.P1.nSD vin1.$325.Metal1 0.0347033f
Cred_11168 VDD.P1.nSD vin1.$331.Metal1 0.0350283f
Cred_11169 VDD.P1.nSD vin1.$335.Metal1 0.0236223f
Cred_11170 VDD.P1.nSD vin1.$339.Metal1 0.0245244f
Cred_11171 VDD.P1.nSD vin1.$343.Metal1 0.0235294f
Cred_11172 VDD.P1.nSD vin1.$347.Metal1 0.0354326f
Cred_11173 VDD.P1.nSD vin1.$353.Metal1 0.0365361f
Cred_11174 VDD.P1.nSD vin1.$357.Metal1 0.0352415f
Cred_11175 VDD.P1.nSD vin1.$365.Metal1 0.035294f
Cred_11176 VDD.P1.nSD vin1.$369.Metal1 0.0371498f
Cred_11177 VDD.P1.nSD vin1.$37.GatPoly 0.00500646f
Cred_11178 VDD.P1.nSD vin1.$375.Metal1 0.0346968f
Cred_11179 VDD.P1.nSD vin1.$379.Metal1 0.0247862f
Cred_11180 VDD.P1.nSD vin1.$383.Metal1 0.0238764f
Cred_11181 VDD.P1.nSD vin1.$387.Metal1 0.0348767f
Cred_11182 VDD.P1.nSD vin1.$393.Metal1 0.0354565f
Cred_11183 VDD.P1.nSD vin1.$397.Metal1 0.0238625f
Cred_11184 VDD.P1.nSD vin1.$401.Metal1 0.0354286f
Cred_11185 VDD.P1.nSD vin1.$409.Metal1 0.0350461f
Cred_11186 VDD.P1.nSD vin1.$413.Metal1 0.0351145f
Cred_11187 VDD.P1.nSD vin1.$419.Metal1 0.0344766f
Cred_11188 VDD.P1.nSD vin1.$423.Metal1 0.024004f
Cred_11189 VDD.P1.nSD vin1.$427.Metal1 0.0327751f
Cred_11190 VDD.P1.nSD vin1.$43.GatPoly 0.00478749f
Cred_11191 VDD.P1.nSD vin1.$433.Metal1 0.0465174f
Cred_11192 VDD.P1.nSD vin1.$441.Metal1 0.0486666f
Cred_11193 VDD.P1.nSD vin1.$449.Metal1 0.0346785f
Cred_11194 VDD.P1.nSD vin1.$453.Metal1 0.0231727f
Cred_11195 VDD.P1.nSD vin1.$457.Metal1 0.109549f
Cred_11196 VDD.P1.nSD vin1.$47.GatPoly 0.00346016f
Cred_11197 VDD.P1.nSD vin1.$477.Metal2 0.0910611f
Cred_11198 VDD.P1.nSD vin1.$480.Metal2 0.0859378f
Cred_11199 VDD.P1.nSD vin1.$484.Metal2 0.0149744f
Cred_11200 VDD.P1.nSD vin1.$486.Metal2 0.0388609f
Cred_11201 VDD.P1.nSD vin1.$489.Metal2 0.0179601f
Cred_11202 VDD.P1.nSD vin1.$493.Metal2 0.0180005f
Cred_11203 VDD.P1.nSD vin1.$495.Metal2 0.0422775f
Cred_11204 VDD.P1.nSD vin1.$500.Metal2 0.0184604f
Cred_11205 VDD.P1.nSD vin1.$504.Metal2 0.0199396f
Cred_11206 VDD.P1.nSD vin1.$506.Metal2 0.0390691f
Cred_11207 VDD.P1.nSD vin1.$509.Metal2 0.0133856f
Cred_11208 VDD.P1.nSD vin1.$513.Metal2 0.0144608f
Cred_11209 VDD.P1.nSD vin1.$515.Metal2 0.0515828f
Cred_11210 VDD.P1.nSD vin1.$518.Metal2 0.016853f
Cred_11211 VDD.P1.nSD vin1.$520.Metal2 0.00884623f
Cred_11212 VDD.P1.nSD vin1.$523.Metal2 0.0055331f
Cred_11213 VDD.P1.nSD vin1.$527.Metal2 0.0405575f
Cred_11214 VDD.P1.nSD vin1.$528.Metal2 0.000210118f
Cred_11215 VDD.P1.nSD vin1.$53.GatPoly 0.00428052f
Cred_11216 VDD.P1.nSD vin1.$533.Metal2 0.0214425f
Cred_11217 VDD.P1.nSD vin1.$535.Metal2 0.0519489f
Cred_11218 VDD.P1.nSD vin1.$538.Metal2 0.0149784f
Cred_11219 VDD.P1.nSD vin1.$542.Metal2 0.0128599f
Cred_11220 VDD.P1.nSD vin1.$544.Metal2 0.0372347f
Cred_11221 VDD.P1.nSD vin1.$547.Metal2 0.0219089f
Cred_11222 VDD.P1.nSD vin1.$551.Metal2 0.0179794f
Cred_11223 VDD.P1.nSD vin1.$555.Metal2 0.0429992f
Cred_11224 VDD.P1.nSD vin1.$558.Metal2 0.0192696f
Cred_11225 VDD.P1.nSD vin1.$562.Metal2 0.0172708f
Cred_11226 VDD.P1.nSD vin1.$564.Metal2 0.0398418f
Cred_11227 VDD.P1.nSD vin1.$567.Metal2 0.0170702f
Cred_11228 VDD.P1.nSD vin1.$57.GatPoly 0.00404204f
Cred_11229 VDD.P1.nSD vin1.$571.Metal2 0.0192696f
Cred_11230 VDD.P1.nSD vin1.$573.Metal2 0.0429992f
Cred_11231 VDD.P1.nSD vin1.$578.Metal2 0.0179794f
Cred_11232 VDD.P1.nSD vin1.$582.Metal2 0.0219089f
Cred_11233 VDD.P1.nSD vin1.$584.Metal2 0.0372347f
Cred_11234 VDD.P1.nSD vin1.$587.Metal2 0.0128599f
Cred_11235 VDD.P1.nSD vin1.$591.Metal2 0.0149784f
Cred_11236 VDD.P1.nSD vin1.$593.Metal2 0.0519489f
Cred_11237 VDD.P1.nSD vin1.$596.Metal2 0.0214425f
Cred_11238 VDD.P1.nSD vin1.$599.Metal2 0.000210118f
Cred_11239 VDD.P1.nSD vin1.$603.Metal2 0.0405575f
Cred_11240 VDD.P1.nSD vin1.$604.Metal2 0.0055331f
Cred_11241 VDD.P1.nSD vin1.$609.Metal2 0.00884623f
Cred_11242 VDD.P1.nSD vin1.$611.Metal2 0.016853f
Cred_11243 VDD.P1.nSD vin1.$613.Metal2 0.0515828f
Cred_11244 VDD.P1.nSD vin1.$616.Metal2 0.0144608f
Cred_11245 VDD.P1.nSD vin1.$620.Metal2 0.0133856f
Cred_11246 VDD.P1.nSD vin1.$622.Metal2 0.0390691f
Cred_11247 VDD.P1.nSD vin1.$625.Metal2 0.0199396f
Cred_11248 VDD.P1.nSD vin1.$629.Metal2 0.0184604f
Cred_11249 VDD.P1.nSD vin1.$633.Metal2 0.0422775f
Cred_11250 VDD.P1.nSD vin1.$636.Metal2 0.0180005f
Cred_11251 VDD.P1.nSD vin1.$640.Metal2 0.0179601f
Cred_11252 VDD.P1.nSD vin1.$642.Metal2 0.0530278f
Cred_11253 VDD.P1.nSD vin1.$645.Metal2 0.0149744f
Cred_11254 VDD.P1.nSD vin1.$648.Metal2 0.000941888f
Cred_11255 VDD.P1.nSD vin1.$649.Metal2 0.0148153f
Cred_11256 VDD.P1.nSD vin1.$65.GatPoly 0.00500763f
Cred_11257 VDD.P1.nSD vin1.$653.Metal2 0.00360134f
Cred_11258 VDD.P1.nSD vin1.$654.Metal2 0.0355504f
Cred_11259 VDD.P1.nSD vin1.$73.GatPoly 0.0049112f
Cred_11260 VDD.P1.nSD vin1.$77.GatPoly 0.00336467f
Cred_11261 VDD.P1.nSD vin1.$83.GatPoly 0.0042155f
Cred_11262 VDD.P1.nSD vin1.$87.GatPoly 0.00325409f
Cred_11263 VDD.P1.nSD vin1.$9.GatPoly 0.00709921f
Cred_11264 VDD.P1.nSD vin1.$93.GatPoly 0.00472553f
Cred_11265 VDD.P1.nSD vin1.$97.GatPoly 0.00403812f
Cred_11266 VDD.P1.nSD vin1.P20.GatPoly 0.0165265f
Cred_11267 VDD.P1.nSD vin1.P22.GatPoly 3.87488e-06f
Cred_11268 VDD.P1.nSD vin1.P24.GatPoly 0.000433658f
Cred_11269 VDD.P1.nSD vin1.P25.GatPoly 3.99011e-06f
Cred_11270 VDD.P1.nSD vin1.P27.GatPoly 0.000432352f
Cred_11271 VDD.P1.nSD vin1.P28.GatPoly 3.84561e-06f
Cred_11272 VDD.P1.nSD vin1.P29.GatPoly 1.28772e-06f
Cred_11273 VDD.P1.nSD vin1.P30.GatPoly 1.28772e-06f
Cred_11274 VDD.P1.nSD vin1.P31.GatPoly 3.9016e-06f
Cred_11275 VDD.P1.nSD vin1.P32.GatPoly 0.000430798f
Cred_11276 VDD.P1.nSD vin1.P33.GatPoly 1.31945e-06f
Cred_11277 VDD.P1.nSD vin1.P34.GatPoly 3.99011e-06f
Cred_11278 VDD.P1.nSD vin1.P35.GatPoly 0.000433658f
Cred_11279 VDD.P1.nSD vin1.P37.GatPoly 3.50761e-06f
Cred_11280 VDD.P1.nSD vin1.P38.GatPoly 2.63377e-06f
Cred_11281 VDD.P1.nSD vin1.P39.GatPoly 0.0164873f
Cred_11282 VDD.P1.nSD vin2.P20.GatPoly 2.87301e-07f
Cred_11283 VDD.P1.nSD vin2.P22.GatPoly 3.87488e-06f
Cred_11284 VDD.P1.nSD vin2.P24.GatPoly 1.11477e-06f
Cred_11285 VDD.P1.nSD vin2.P25.GatPoly 3.99011e-06f
Cred_11286 VDD.P1.nSD vin2.P27.GatPoly 1.55357e-06f
Cred_11287 VDD.P1.nSD vin2.P28.GatPoly 3.84561e-06f
Cred_11288 VDD.P1.nSD vin2.P29.GatPoly 1.28772e-06f
Cred_11289 VDD.P1.nSD vin2.P30.GatPoly 1.28772e-06f
Cred_11290 VDD.P1.nSD vin2.P31.GatPoly 3.9016e-06f
Cred_11291 VDD.P1.nSD vin2.P33.GatPoly 1.31945e-06f
Cred_11292 VDD.P1.nSD vin2.P34.GatPoly 3.99011e-06f
Cred_11293 VDD.P1.nSD vin2.P35.GatPoly 1.11477e-06f
Cred_11294 VDD.P1.nSD vin2.P37.GatPoly 3.50761e-06f
Cred_11295 VDD.P1.nSD vin2.P38.GatPoly 2.63377e-06f
Cred_11296 VDD.P1.nSD vout1 0.0113779f
Cred_11297 VDD.P1.nSD vout1.$1226.Metal3 0.0486128f
Cred_11298 VDD.P1.nSD vout1.$1292.Metal3 0.0324508f
Cred_11299 VDD.P1.nSD vout1.$1358.Metal3 0.0343368f
Cred_11300 VDD.P1.nSD vout1.$1424.Metal3 0.0647893f
Cred_11301 VDD.P1.nSD vout1.P0.nSD 0.000560996f
Cred_11302 VDD.P1.nSD vout1.P0.pSD 0.00337633f
Cred_11303 VDD.P1.nSD vout1.P10.nSD 0.000132216f
Cred_11304 VDD.P1.nSD vout1.P10.pSD 0.000716168f
Cred_11305 VDD.P1.nSD vout1.P12.pSD 1.29835e-06f
Cred_11306 VDD.P1.nSD vout1.P14.nSD 0.000131398f
Cred_11307 VDD.P1.nSD vout1.P14.pSD 0.000711715f
Cred_11308 VDD.P1.nSD vout1.P16.pSD 3.22496e-07f
Cred_11309 VDD.P1.nSD vout1.P18.nSD 0.000630353f
Cred_11310 VDD.P1.nSD vout1.P18.pSD 0.00358882f
Cred_11311 VDD.P1.nSD vout1.P2.nSD 0.000388418f
Cred_11312 VDD.P1.nSD vout1.P2.pSD 0.00212279f
Cred_11313 VDD.P1.nSD vout1.P4.pSD 5.08636e-08f
Cred_11314 VDD.P1.nSD vout1.P6.nSD 0.000122053f
Cred_11315 VDD.P1.nSD vout1.P6.pSD 0.000668271f
Cred_11316 VDD.P1.nSD vout2 2.22237e-07f
Cred_11317 VDD.P1.nSD vout2.$1226.Metal3 2.67196e-06f
Cred_11318 VDD.P1.nSD vout2.$1292.Metal3 1.06686e-06f
Cred_11319 VDD.P1.nSD vout2.$1358.Metal3 2.26464e-06f
Cred_11320 VDD.P1.nSD vout2.$1424.Metal3 2.15529e-06f
Cred_11321 VDD.P1.nSD vout2.P0.nSD 4.44269e-08f
Cred_11322 VDD.P1.nSD vout2.P0.pSD 1.68946e-06f
Cred_11323 VDD.P1.nSD vout2.P10.nSD 3.47458e-09f
Cred_11324 VDD.P1.nSD vout2.P10.pSD 9.4127e-08f
Cred_11325 VDD.P1.nSD vout2.P12.pSD 1.29835e-06f
Cred_11326 VDD.P1.nSD vout2.P14.nSD 2.4801e-09f
Cred_11327 VDD.P1.nSD vout2.P14.pSD 6.71862e-08f
Cred_11328 VDD.P1.nSD vout2.P16.pSD 3.22496e-07f
Cred_11329 VDD.P1.nSD vout2.P18.nSD 1.76579e-08f
Cred_11330 VDD.P1.nSD vout2.P18.pSD 7.82298e-07f
Cred_11331 VDD.P1.nSD vout2.P2.nSD 2.3505e-08f
Cred_11332 VDD.P1.nSD vout2.P2.pSD 1.2846e-07f
Cred_11333 VDD.P1.nSD vout2.P4.pSD 5.08636e-08f
Cred_11334 VDD.P1.nSD vout2.P6.nSD 1.33328e-08f
Cred_11335 VDD.P1.nSD vout2.P6.pSD 1.29616e-06f
Cred_11336 VDD.P1.nSD VSS.$157.Metal1 0.00311363f
Cred_11337 VDD.P1.nSD VSS.$1989.Metal1 0.00892381f
Cred_11338 VDD.P1.nSD VSS.$2020.Metal1 0.0255104f
Cred_11339 VDD.P1.nSD VSS.$2226.Metal2 7.43428e-05f
Cred_11340 VDD.P1.nSD VSS.$29.Metal1 0.0343772f
Cred_11341 VDD.P1.nSD VSS.$4227.Metal2 0.00104354f
Cred_11342 VDD.P1.nSD VSS.P1.pSD 0.516249f
Cred_11343 VDD.P1.nSD VSS.P24.nSD 2.08769e-05f
Cred_11344 VDD.P1.nSD VSS.P25.nSD 2.08769e-05f
Cred_11345 VDD.P1.nSD VSS.P45.nSD 2.11023e-05f
Cred_11346 VDD.P1.nSD VSS.P47.nSD 2.11023e-05f
Cred_11347 VDD.P1.pSD vin4.$202.Metal1 0.00300472f
Cred_11348 VDD.P1.pSD vin4.$477.Metal2 0.00136805f
Cred_11349 VDD.P1.pSD vin4.$479.Metal2 0.00261031f
Cred_11350 VDD.P1.pSD vin4.$8.GatPoly 0.000326472f
Cred_11351 VDD.P1.pSD vin4.P20.GatPoly 0.0122888f
Cred_11352 VDD.P1.pSD vout4.$1226.Metal3 0.00660132f
Cred_11353 VDD.P1.pSD vout4.P0.nSD 0.000196566f
Cred_11354 VDD.P1.pSD vout4.P0.pSD 0.0055555f
Cred_11355 VDD.P1.pSD vout4.P2.nSD 0.000103998f
Cred_11356 VDD.P1.pSD vout4.P2.pSD 0.00056837f
Cred_11357 VDD.P1.pSD VSS.$1991.Metal1 1.76127e-08f
Cred_11358 VDD.P1.pSD VSS.$2023.Metal1 4.40988e-08f
Cred_11359 VDD.P1.pSD VSS.$4241.Metal2 1.18065e-10f
Cred_11360 VDD.P1.pSD VSS.$4364.Metal3 3.79621e-05f
Cred_11361 VDD.P1.pSD VSS.$66.Metal1 0.000100615f
Cred_11362 VDD.P1.pSD VSS.P0.pSD 0.000256148f
Cred_11363 VDD.P10.pSD vin3.$291.Metal1 2.63615e-06f
Cred_11364 VDD.P10.pSD vin3.$295.Metal1 5.53399e-06f
Cred_11365 VDD.P10.pSD vin3.$303.Metal1 7.96451e-06f
Cred_11366 VDD.P10.pSD vin3.$307.Metal1 1.52164e-07f
Cred_11367 VDD.P10.pSD vin3.$542.Metal2 6.8538e-06f
Cred_11368 VDD.P10.pSD vin3.$544.Metal2 1.29699e-06f
Cred_11369 VDD.P10.pSD vin3.$547.Metal2 1.45835e-05f
Cred_11370 VDD.P10.pSD vin3.$551.Metal2 1.64347e-07f
Cred_11371 VDD.P10.pSD vin3.$65.GatPoly 4.98432e-06f
Cred_11372 VDD.P10.pSD vin3.$73.GatPoly 7.65648e-06f
Cred_11373 VDD.P10.pSD vin3.$77.GatPoly 1.68172e-05f
Cred_11374 VDD.P10.pSD vin3.P26.GatPoly 7.02069e-07f
Cred_11375 VDD.P10.pSD vin3.P27.GatPoly 5.66025e-05f
Cred_11376 VDD.P10.pSD vin3.P28.GatPoly 5.3923e-05f
Cred_11377 VDD.P10.pSD vin3.P29.GatPoly 7.02069e-07f
Cred_11378 VDD.P10.pSD vin4.$290.Metal1 0.00310052f
Cred_11379 VDD.P10.pSD vin4.$294.Metal1 0.00740785f
Cred_11380 VDD.P10.pSD vin4.$302.Metal1 0.0113968f
Cred_11381 VDD.P10.pSD vin4.$306.Metal1 0.000210762f
Cred_11382 VDD.P10.pSD vin4.$541.Metal2 0.00389589f
Cred_11383 VDD.P10.pSD vin4.$544.Metal2 0.000732061f
Cred_11384 VDD.P10.pSD vin4.$546.Metal2 0.00825822f
Cred_11385 VDD.P10.pSD vin4.$550.Metal2 9.27628e-05f
Cred_11386 VDD.P10.pSD vin4.$64.GatPoly 0.00586233f
Cred_11387 VDD.P10.pSD vin4.$72.GatPoly 0.00978438f
Cred_11388 VDD.P10.pSD vin4.$76.GatPoly 0.019903f
Cred_11389 VDD.P10.pSD vin4.P26.GatPoly 0.00015227f
Cred_11390 VDD.P10.pSD vin4.P27.GatPoly 0.0522473f
Cred_11391 VDD.P10.pSD vin4.P28.GatPoly 0.0490921f
Cred_11392 VDD.P10.pSD vin4.P29.GatPoly 0.00015227f
Cred_11393 VDD.P10.pSD vout3.$1226.Metal3 4.22375e-05f
Cred_11394 VDD.P10.pSD vout3.$1292.Metal3 0.00013155f
Cred_11395 VDD.P10.pSD vout3.P6.nSD 6.65412e-07f
Cred_11396 VDD.P10.pSD vout3.P6.pSD 3.72974e-05f
Cred_11397 VDD.P10.pSD vout3.P8.pSD 3.25173e-05f
Cred_11398 VDD.P10.pSD vout4.$1226.Metal3 0.0204654f
Cred_11399 VDD.P10.pSD vout4.$1292.Metal3 0.0625377f
Cred_11400 VDD.P10.pSD vout4.P6.nSD 0.000322413f
Cred_11401 VDD.P10.pSD vout4.P6.pSD 0.0234491f
Cred_11402 VDD.P10.pSD vout4.P8.pSD 0.0203811f
Cred_11403 VDD.P11.pSD vin3.$325.Metal1 3.86797e-06f
Cred_11404 VDD.P11.pSD vin3.$331.Metal1 1.16729e-05f
Cred_11405 VDD.P11.pSD vin3.$335.Metal1 5.6091e-07f
Cred_11406 VDD.P11.pSD vin3.$562.Metal2 1.45993e-05f
Cred_11407 VDD.P11.pSD vin3.$564.Metal2 2.11244e-06f
Cred_11408 VDD.P11.pSD vin3.$567.Metal2 1.56342e-05f
Cred_11409 VDD.P11.pSD vin3.$87.GatPoly 2.27665e-05f
Cred_11410 VDD.P11.pSD vin3.$93.GatPoly 5.36423e-06f
Cred_11411 VDD.P11.pSD vin3.$97.GatPoly 2.36692e-05f
Cred_11412 VDD.P11.pSD vin3.P28.GatPoly 9.8421e-07f
Cred_11413 VDD.P11.pSD vin3.P29.GatPoly 7.54806e-05f
Cred_11414 VDD.P11.pSD vin3.P30.GatPoly 7.54806e-05f
Cred_11415 VDD.P11.pSD vin3.P31.GatPoly 9.8421e-07f
Cred_11416 VDD.P11.pSD vin4.$324.Metal1 0.00395628f
Cred_11417 VDD.P11.pSD vin4.$330.Metal1 0.0119074f
Cred_11418 VDD.P11.pSD vin4.$334.Metal1 0.000564352f
Cred_11419 VDD.P11.pSD vin4.$561.Metal2 0.00636728f
Cred_11420 VDD.P11.pSD vin4.$564.Metal2 0.000851131f
Cred_11421 VDD.P11.pSD vin4.$566.Metal2 0.00586015f
Cred_11422 VDD.P11.pSD vin4.$86.GatPoly 0.019104f
Cred_11423 VDD.P11.pSD vin4.$92.GatPoly 0.00529086f
Cred_11424 VDD.P11.pSD vin4.$96.GatPoly 0.019994f
Cred_11425 VDD.P11.pSD vin4.P28.GatPoly 0.000152552f
Cred_11426 VDD.P11.pSD vin4.P29.GatPoly 0.0490247f
Cred_11427 VDD.P11.pSD vin4.P30.GatPoly 0.0490247f
Cred_11428 VDD.P11.pSD vin4.P31.GatPoly 0.000152552f
Cred_11429 VDD.P11.pSD vout3.$1292.Metal3 0.000183043f
Cred_11430 VDD.P11.pSD vout3.$1358.Metal3 5.91688e-05f
Cred_11431 VDD.P11.pSD vout3.P10.nSD 9.32149e-07f
Cred_11432 VDD.P11.pSD vout3.P10.pSD 5.15685e-05f
Cred_11433 VDD.P11.pSD vout3.P8.pSD 4.70531e-05f
Cred_11434 VDD.P11.pSD vout4.$1292.Metal3 0.0629292f
Cred_11435 VDD.P11.pSD vout4.$1358.Metal3 0.0199095f
Cred_11436 VDD.P11.pSD vout4.P10.nSD 0.000313655f
Cred_11437 VDD.P11.pSD vout4.P10.pSD 0.0225054f
Cred_11438 VDD.P11.pSD vout4.P8.pSD 0.0216735f
Cred_11439 VDD.P13.pSD vin4.$106.GatPoly 0.0198862f
Cred_11440 VDD.P13.pSD vin4.$114.GatPoly 0.00977672f
Cred_11441 VDD.P13.pSD vin4.$122.GatPoly 0.00585735f
Cred_11442 VDD.P13.pSD vin4.$352.Metal1 0.00021061f
Cred_11443 VDD.P13.pSD vin4.$356.Metal1 0.0113888f
Cred_11444 VDD.P13.pSD vin4.$364.Metal1 0.00740232f
Cred_11445 VDD.P13.pSD vin4.$368.Metal1 0.00309789f
Cred_11446 VDD.P13.pSD vin4.$577.Metal2 9.25985e-05f
Cred_11447 VDD.P13.pSD vin4.$581.Metal2 0.00824363f
Cred_11448 VDD.P13.pSD vin4.$584.Metal2 0.000730764f
Cred_11449 VDD.P13.pSD vin4.$586.Metal2 0.00388903f
Cred_11450 VDD.P13.pSD vin4.P30.GatPoly 0.000151568f
Cred_11451 VDD.P13.pSD vin4.P31.GatPoly 0.0490382f
Cred_11452 VDD.P13.pSD vin4.P32.GatPoly 0.0521907f
Cred_11453 VDD.P13.pSD vin4.P33.GatPoly 0.000151568f
Cred_11454 VDD.P13.pSD vout4.$1292.Metal3 0.020112f
Cred_11455 VDD.P13.pSD vout4.$1358.Metal3 0.0618195f
Cred_11456 VDD.P13.pSD vout4.P10.nSD 0.000316845f
Cred_11457 VDD.P13.pSD vout4.P10.pSD 0.0234695f
Cred_11458 VDD.P13.pSD vout4.P12.pSD 0.0207601f
Cred_11459 VDD.P15.pSD vin3.$127.GatPoly 3.34634e-06f
Cred_11460 VDD.P15.pSD vin3.$135.GatPoly 7.02023e-07f
Cred_11461 VDD.P15.pSD vin3.$137.GatPoly 3.26638e-06f
Cred_11462 VDD.P15.pSD vin3.$379.Metal1 3.20941e-09f
Cred_11463 VDD.P15.pSD vin3.$383.Metal1 2.79651e-08f
Cred_11464 VDD.P15.pSD vin3.$387.Metal1 1.5056e-06f
Cred_11465 VDD.P15.pSD vin3.$393.Metal1 7.97272e-07f
Cred_11466 VDD.P15.pSD vin3.$593.Metal2 8.74491e-08f
Cred_11467 VDD.P15.pSD vin3.$596.Metal2 2.67088e-07f
Cred_11468 VDD.P15.pSD vin3.$599.Metal2 1.49677e-09f
Cred_11469 VDD.P15.pSD vin3.$603.Metal2 3.73335e-06f
Cred_11470 VDD.P15.pSD vin3.$604.Metal2 3.94148e-08f
Cred_11471 VDD.P15.pSD vin3.$609.Metal2 3.78487e-07f
Cred_11472 VDD.P15.pSD vin3.$613.Metal2 8.74491e-08f
Cred_11473 VDD.P15.pSD vin3.P32.GatPoly 1.39494e-07f
Cred_11474 VDD.P15.pSD vin3.P33.GatPoly 1.07021e-05f
Cred_11475 VDD.P15.pSD vin3.P34.GatPoly 1.06877e-05f
Cred_11476 VDD.P15.pSD vin3.P35.GatPoly 1.39494e-07f
Cred_11477 VDD.P15.pSD vin4.$126.GatPoly 0.0199234f
Cred_11478 VDD.P15.pSD vin4.$134.GatPoly 0.00484083f
Cred_11479 VDD.P15.pSD vin4.$136.GatPoly 0.0193685f
Cred_11480 VDD.P15.pSD vin4.$378.Metal1 9.10422e-06f
Cred_11481 VDD.P15.pSD vin4.$382.Metal1 0.00017056f
Cred_11482 VDD.P15.pSD vin4.$386.Metal1 0.0108061f
Cred_11483 VDD.P15.pSD vin4.$392.Metal1 0.00571355f
Cred_11484 VDD.P15.pSD vin4.$593.Metal2 0.000248069f
Cred_11485 VDD.P15.pSD vin4.$595.Metal2 0.000757655f
Cred_11486 VDD.P15.pSD vin4.$600.Metal2 4.24592e-06f
Cred_11487 VDD.P15.pSD vin4.$601.Metal2 0.0106386f
Cred_11488 VDD.P15.pSD vin4.$605.Metal2 0.000111809f
Cred_11489 VDD.P15.pSD vin4.$608.Metal2 0.00107453f
Cred_11490 VDD.P15.pSD vin4.$613.Metal2 0.000248069f
Cred_11491 VDD.P15.pSD vin4.P32.GatPoly 0.000151708f
Cred_11492 VDD.P15.pSD vin4.P33.GatPoly 0.0489827f
Cred_11493 VDD.P15.pSD vin4.P34.GatPoly 0.0489024f
Cred_11494 VDD.P15.pSD vin4.P35.GatPoly 0.000151708f
Cred_11495 VDD.P15.pSD vout3.$1358.Metal3 2.57299e-05f
Cred_11496 VDD.P15.pSD vout3.$1424.Metal3 8.41721e-06f
Cred_11497 VDD.P15.pSD vout3.P12.pSD 6.74174e-06f
Cred_11498 VDD.P15.pSD vout3.P14.nSD 1.32605e-07f
Cred_11499 VDD.P15.pSD vout3.P14.pSD 7.32643e-06f
Cred_11500 VDD.P15.pSD vout4.$1358.Metal3 0.0623267f
Cred_11501 VDD.P15.pSD vout4.$1424.Metal3 0.0198771f
Cred_11502 VDD.P15.pSD vout4.P12.pSD 0.0217797f
Cred_11503 VDD.P15.pSD vout4.P14.nSD 0.000313146f
Cred_11504 VDD.P15.pSD vout4.P14.pSD 0.0224939f
Cred_11505 VDD.P17.pSD vin3.$145.GatPoly 3.80925e-06f
Cred_11506 VDD.P17.pSD vin3.$153.GatPoly 1.06797e-05f
Cred_11507 VDD.P17.pSD vin3.$157.GatPoly 2.04814e-05f
Cred_11508 VDD.P17.pSD vin3.$409.Metal1 2.01467e-06f
Cred_11509 VDD.P17.pSD vin3.$413.Metal1 5.51615e-06f
Cred_11510 VDD.P17.pSD vin3.$419.Metal1 9.79792e-06f
Cred_11511 VDD.P17.pSD vin3.$423.Metal1 2.25972e-06f
Cred_11512 VDD.P17.pSD vin3.$620.Metal2 9.54785e-06f
Cred_11513 VDD.P17.pSD vin3.$622.Metal2 1.61549e-06f
Cred_11514 VDD.P17.pSD vin3.$625.Metal2 1.65714e-05f
Cred_11515 VDD.P17.pSD vin3.P34.GatPoly 8.35102e-07f
Cred_11516 VDD.P17.pSD vin3.P35.GatPoly 6.7112e-05f
Cred_11517 VDD.P17.pSD vin3.P36.GatPoly 6.41201e-05f
Cred_11518 VDD.P17.pSD vin3.P37.GatPoly 8.35102e-07f
Cred_11519 VDD.P17.pSD vin4.$144.GatPoly 0.00376383f
Cred_11520 VDD.P17.pSD vin4.$152.GatPoly 0.011247f
Cred_11521 VDD.P17.pSD vin4.$156.GatPoly 0.0204585f
Cred_11522 VDD.P17.pSD vin4.$408.Metal1 0.00199065f
Cred_11523 VDD.P17.pSD vin4.$412.Metal1 0.00586999f
Cred_11524 VDD.P17.pSD vin4.$418.Metal1 0.0117577f
Cred_11525 VDD.P17.pSD vin4.$422.Metal1 0.00270362f
Cred_11526 VDD.P17.pSD vin4.$619.Metal2 0.00456037f
Cred_11527 VDD.P17.pSD vin4.$622.Metal2 0.000766832f
Cred_11528 VDD.P17.pSD vin4.$624.Metal2 0.00787471f
Cred_11529 VDD.P17.pSD vin4.P34.GatPoly 0.000152403f
Cred_11530 VDD.P17.pSD vin4.P35.GatPoly 0.0520434f
Cred_11531 VDD.P17.pSD vin4.P36.GatPoly 0.0490831f
Cred_11532 VDD.P17.pSD vin4.P37.GatPoly 0.000152403f
Cred_11533 VDD.P17.pSD vout3.$1358.Metal3 4.93295e-05f
Cred_11534 VDD.P17.pSD vout3.$1424.Metal3 0.000155883f
Cred_11535 VDD.P17.pSD vout3.P14.nSD 7.7714e-07f
Cred_11536 VDD.P17.pSD vout3.P14.pSD 4.45695e-05f
Cred_11537 VDD.P17.pSD vout3.P16.pSD 3.96026e-05f
Cred_11538 VDD.P17.pSD vout4.$1358.Metal3 0.0202214f
Cred_11539 VDD.P17.pSD vout4.$1424.Metal3 0.062166f
Cred_11540 VDD.P17.pSD vout4.P14.nSD 0.000318569f
Cred_11541 VDD.P17.pSD vout4.P14.pSD 0.0235306f
Cred_11542 VDD.P17.pSD vout4.P16.pSD 0.0208064f
Cred_11543 VDD.P19.pSD vin3.$167.GatPoly 2.2356e-05f
Cred_11544 VDD.P19.pSD vin3.$173.GatPoly 4.72178e-06f
Cred_11545 VDD.P19.pSD vin3.$179.GatPoly 2.03989e-05f
Cred_11546 VDD.P19.pSD vin3.$441.Metal1 1.75847e-06f
Cred_11547 VDD.P19.pSD vin3.$449.Metal1 1.12984e-05f
Cred_11548 VDD.P19.pSD vin3.$453.Metal1 4.99616e-06f
Cred_11549 VDD.P19.pSD vin3.$636.Metal2 4.30854e-09f
Cred_11550 VDD.P19.pSD vin3.$640.Metal2 1.65375e-05f
Cred_11551 VDD.P19.pSD vin3.$642.Metal2 2.03932e-06f
Cred_11552 VDD.P19.pSD vin3.$645.Metal2 1.3156e-05f
Cred_11553 VDD.P19.pSD vin3.P36.GatPoly 9.63259e-07f
Cred_11554 VDD.P19.pSD vin3.P37.GatPoly 7.38063e-05f
Cred_11555 VDD.P19.pSD vin3.P38.GatPoly 7.5202e-05f
Cred_11556 VDD.P19.pSD vin3.P39.GatPoly 1.0621e-06f
Cred_11557 VDD.P19.pSD vin4.$166.GatPoly 0.0191806f
Cred_11558 VDD.P19.pSD vin4.$172.GatPoly 0.00480338f
Cred_11559 VDD.P19.pSD vin4.$178.GatPoly 0.0172362f
Cred_11560 VDD.P19.pSD vin4.$440.Metal1 0.00183771f
Cred_11561 VDD.P19.pSD vin4.$448.Metal1 0.0117425f
Cred_11562 VDD.P19.pSD vin4.$452.Metal1 0.00517618f
Cred_11563 VDD.P19.pSD vin4.$635.Metal2 4.50267e-06f
Cred_11564 VDD.P19.pSD vin4.$639.Metal2 0.00683498f
Cred_11565 VDD.P19.pSD vin4.$642.Metal2 0.000839497f
Cred_11566 VDD.P19.pSD vin4.$644.Metal2 0.00542706f
Cred_11567 VDD.P19.pSD vin4.P36.GatPoly 0.000152531f
Cred_11568 VDD.P19.pSD vin4.P37.GatPoly 0.0491168f
Cred_11569 VDD.P19.pSD vin4.P38.GatPoly 0.0499743f
Cred_11570 VDD.P19.pSD vin4.P39.GatPoly 0.000166635f
Cred_11571 VDD.P19.pSD vout3 1.87647e-05f
Cred_11572 VDD.P19.pSD vout3.$1424.Metal3 0.000213561f
Cred_11573 VDD.P19.pSD vout3.P16.pSD 4.59917e-05f
Cred_11574 VDD.P19.pSD vout3.P18.nSD 1.49096e-06f
Cred_11575 VDD.P19.pSD vout3.P18.pSD 5.63861e-05f
Cred_11576 VDD.P19.pSD vout4 0.00661564f
Cred_11577 VDD.P19.pSD vout4.$1424.Metal3 0.0753563f
Cred_11578 VDD.P19.pSD vout4.P16.pSD 0.0212927f
Cred_11579 VDD.P19.pSD vout4.P18.nSD 0.000525648f
Cred_11580 VDD.P19.pSD vout4.P18.pSD 0.0253849f
Cred_11581 VDD.P2.GatPoly vin1.$203.Metal1 0.016755f
Cred_11582 VDD.P2.GatPoly vin1.$477.Metal2 0.00210703f
Cred_11583 VDD.P2.GatPoly vin1.$480.Metal2 0.00427619f
Cred_11584 VDD.P2.GatPoly vin1.$9.GatPoly 0.00305381f
Cred_11585 VDD.P2.GatPoly vin1.P20.GatPoly 0.0706836f
Cred_11586 VDD.P2.GatPoly vin1.P21.GatPoly 0.00596583f
Cred_11587 VDD.P2.GatPoly vin1.P22.GatPoly 0.00328573f
Cred_11588 VDD.P2.GatPoly vin1.P23.GatPoly 0.00227743f
Cred_11589 VDD.P2.GatPoly vin1.P24.GatPoly 0.00160627f
Cred_11590 VDD.P2.GatPoly vin1.P25.GatPoly 0.00130082f
Cred_11591 VDD.P2.GatPoly vout1.$1226.Metal3 0.000869187f
Cred_11592 VDD.P2.GatPoly vout1.P0.nSD 2.58816e-05f
Cred_11593 VDD.P2.GatPoly vout1.P0.pSD 0.000241362f
Cred_11594 VDD.P2.GatPoly vout1.P2.nSD 1.36932e-05f
Cred_11595 VDD.P2.GatPoly vout1.P2.pSD 7.48366e-05f
Cred_11596 VDD.P2.GatPoly VSS.P2.GatPoly 0.00217316f
Cred_11597 VDD.P2.nSD vin3.$105.GatPoly 0.0042155f
Cred_11598 VDD.P2.nSD vin3.$107.GatPoly 0.00336467f
Cred_11599 VDD.P2.nSD vin3.$115.GatPoly 0.0049112f
Cred_11600 VDD.P2.nSD vin3.$123.GatPoly 0.00500763f
Cred_11601 VDD.P2.nSD vin3.$127.GatPoly 0.00404204f
Cred_11602 VDD.P2.nSD vin3.$135.GatPoly 0.00428052f
Cred_11603 VDD.P2.nSD vin3.$137.GatPoly 0.00346016f
Cred_11604 VDD.P2.nSD vin3.$145.GatPoly 0.00478749f
Cred_11605 VDD.P2.nSD vin3.$15.GatPoly 0.00356548f
Cred_11606 VDD.P2.nSD vin3.$153.GatPoly 0.00500646f
Cred_11607 VDD.P2.nSD vin3.$157.GatPoly 0.00339629f
Cred_11608 VDD.P2.nSD vin3.$163.GatPoly 0.00399055f
Cred_11609 VDD.P2.nSD vin3.$167.GatPoly 0.00356548f
Cred_11610 VDD.P2.nSD vin3.$17.GatPoly 0.00385431f
Cred_11611 VDD.P2.nSD vin3.$173.GatPoly 0.00385431f
Cred_11612 VDD.P2.nSD vin3.$179.GatPoly 0.0070487f
Cred_11613 VDD.P2.nSD vin3.$203.Metal1 0.112352f
Cred_11614 VDD.P2.nSD vin3.$207.Metal1 0.0231727f
Cred_11615 VDD.P2.nSD vin3.$211.Metal1 0.0346785f
Cred_11616 VDD.P2.nSD vin3.$219.Metal1 0.0486666f
Cred_11617 VDD.P2.nSD vin3.$227.Metal1 0.0465174f
Cred_11618 VDD.P2.nSD vin3.$233.Metal1 0.0327751f
Cred_11619 VDD.P2.nSD vin3.$237.Metal1 0.024004f
Cred_11620 VDD.P2.nSD vin3.$241.Metal1 0.0344766f
Cred_11621 VDD.P2.nSD vin3.$247.Metal1 0.0351145f
Cred_11622 VDD.P2.nSD vin3.$25.GatPoly 0.00339629f
Cred_11623 VDD.P2.nSD vin3.$251.Metal1 0.0350461f
Cred_11624 VDD.P2.nSD vin3.$259.Metal1 0.0354286f
Cred_11625 VDD.P2.nSD vin3.$263.Metal1 0.0238625f
Cred_11626 VDD.P2.nSD vin3.$265.Metal1 0.0354565f
Cred_11627 VDD.P2.nSD vin3.$27.GatPoly 0.00399055f
Cred_11628 VDD.P2.nSD vin3.$273.Metal1 0.0348767f
Cred_11629 VDD.P2.nSD vin3.$277.Metal1 0.0238764f
Cred_11630 VDD.P2.nSD vin3.$281.Metal1 0.0247862f
Cred_11631 VDD.P2.nSD vin3.$285.Metal1 0.0346968f
Cred_11632 VDD.P2.nSD vin3.$291.Metal1 0.0371498f
Cred_11633 VDD.P2.nSD vin3.$295.Metal1 0.035294f
Cred_11634 VDD.P2.nSD vin3.$303.Metal1 0.0352415f
Cred_11635 VDD.P2.nSD vin3.$307.Metal1 0.0365361f
Cred_11636 VDD.P2.nSD vin3.$313.Metal1 0.0354326f
Cred_11637 VDD.P2.nSD vin3.$317.Metal1 0.0235294f
Cred_11638 VDD.P2.nSD vin3.$321.Metal1 0.0245244f
Cred_11639 VDD.P2.nSD vin3.$325.Metal1 0.0347033f
Cred_11640 VDD.P2.nSD vin3.$331.Metal1 0.0350283f
Cred_11641 VDD.P2.nSD vin3.$335.Metal1 0.0236223f
Cred_11642 VDD.P2.nSD vin3.$339.Metal1 0.0245244f
Cred_11643 VDD.P2.nSD vin3.$343.Metal1 0.0235294f
Cred_11644 VDD.P2.nSD vin3.$347.Metal1 0.0354326f
Cred_11645 VDD.P2.nSD vin3.$353.Metal1 0.0365361f
Cred_11646 VDD.P2.nSD vin3.$357.Metal1 0.0352415f
Cred_11647 VDD.P2.nSD vin3.$365.Metal1 0.035294f
Cred_11648 VDD.P2.nSD vin3.$369.Metal1 0.0371498f
Cred_11649 VDD.P2.nSD vin3.$37.GatPoly 0.00500646f
Cred_11650 VDD.P2.nSD vin3.$375.Metal1 0.0346968f
Cred_11651 VDD.P2.nSD vin3.$379.Metal1 0.0247862f
Cred_11652 VDD.P2.nSD vin3.$383.Metal1 0.0238764f
Cred_11653 VDD.P2.nSD vin3.$387.Metal1 0.0348767f
Cred_11654 VDD.P2.nSD vin3.$393.Metal1 0.0354565f
Cred_11655 VDD.P2.nSD vin3.$397.Metal1 0.0238625f
Cred_11656 VDD.P2.nSD vin3.$401.Metal1 0.0354286f
Cred_11657 VDD.P2.nSD vin3.$409.Metal1 0.0350461f
Cred_11658 VDD.P2.nSD vin3.$413.Metal1 0.0351145f
Cred_11659 VDD.P2.nSD vin3.$419.Metal1 0.0344766f
Cred_11660 VDD.P2.nSD vin3.$423.Metal1 0.024004f
Cred_11661 VDD.P2.nSD vin3.$427.Metal1 0.0327751f
Cred_11662 VDD.P2.nSD vin3.$43.GatPoly 0.00478749f
Cred_11663 VDD.P2.nSD vin3.$433.Metal1 0.0465174f
Cred_11664 VDD.P2.nSD vin3.$441.Metal1 0.0486666f
Cred_11665 VDD.P2.nSD vin3.$449.Metal1 0.0346785f
Cred_11666 VDD.P2.nSD vin3.$453.Metal1 0.0231727f
Cred_11667 VDD.P2.nSD vin3.$457.Metal1 0.109549f
Cred_11668 VDD.P2.nSD vin3.$47.GatPoly 0.00346016f
Cred_11669 VDD.P2.nSD vin3.$477.Metal2 0.0910611f
Cred_11670 VDD.P2.nSD vin3.$480.Metal2 0.0859378f
Cred_11671 VDD.P2.nSD vin3.$484.Metal2 0.0149744f
Cred_11672 VDD.P2.nSD vin3.$486.Metal2 0.0388609f
Cred_11673 VDD.P2.nSD vin3.$489.Metal2 0.0179601f
Cred_11674 VDD.P2.nSD vin3.$493.Metal2 0.0180005f
Cred_11675 VDD.P2.nSD vin3.$495.Metal2 0.0422775f
Cred_11676 VDD.P2.nSD vin3.$500.Metal2 0.0184604f
Cred_11677 VDD.P2.nSD vin3.$504.Metal2 0.0199396f
Cred_11678 VDD.P2.nSD vin3.$506.Metal2 0.0390691f
Cred_11679 VDD.P2.nSD vin3.$509.Metal2 0.0133856f
Cred_11680 VDD.P2.nSD vin3.$513.Metal2 0.0144608f
Cred_11681 VDD.P2.nSD vin3.$515.Metal2 0.0515828f
Cred_11682 VDD.P2.nSD vin3.$518.Metal2 0.016853f
Cred_11683 VDD.P2.nSD vin3.$520.Metal2 0.00884623f
Cred_11684 VDD.P2.nSD vin3.$523.Metal2 0.0055331f
Cred_11685 VDD.P2.nSD vin3.$527.Metal2 0.0405575f
Cred_11686 VDD.P2.nSD vin3.$528.Metal2 0.000210118f
Cred_11687 VDD.P2.nSD vin3.$53.GatPoly 0.00428052f
Cred_11688 VDD.P2.nSD vin3.$533.Metal2 0.0214425f
Cred_11689 VDD.P2.nSD vin3.$535.Metal2 0.0519489f
Cred_11690 VDD.P2.nSD vin3.$538.Metal2 0.0149784f
Cred_11691 VDD.P2.nSD vin3.$542.Metal2 0.0128599f
Cred_11692 VDD.P2.nSD vin3.$544.Metal2 0.0372347f
Cred_11693 VDD.P2.nSD vin3.$547.Metal2 0.0219089f
Cred_11694 VDD.P2.nSD vin3.$551.Metal2 0.0179794f
Cred_11695 VDD.P2.nSD vin3.$555.Metal2 0.0429992f
Cred_11696 VDD.P2.nSD vin3.$558.Metal2 0.0192696f
Cred_11697 VDD.P2.nSD vin3.$562.Metal2 0.0172708f
Cred_11698 VDD.P2.nSD vin3.$564.Metal2 0.0398418f
Cred_11699 VDD.P2.nSD vin3.$567.Metal2 0.0170702f
Cred_11700 VDD.P2.nSD vin3.$57.GatPoly 0.00404204f
Cred_11701 VDD.P2.nSD vin3.$571.Metal2 0.0192696f
Cred_11702 VDD.P2.nSD vin3.$573.Metal2 0.0429992f
Cred_11703 VDD.P2.nSD vin3.$578.Metal2 0.0179794f
Cred_11704 VDD.P2.nSD vin3.$582.Metal2 0.0219089f
Cred_11705 VDD.P2.nSD vin3.$584.Metal2 0.0372347f
Cred_11706 VDD.P2.nSD vin3.$587.Metal2 0.0128599f
Cred_11707 VDD.P2.nSD vin3.$591.Metal2 0.0149784f
Cred_11708 VDD.P2.nSD vin3.$593.Metal2 0.0519489f
Cred_11709 VDD.P2.nSD vin3.$596.Metal2 0.0214425f
Cred_11710 VDD.P2.nSD vin3.$599.Metal2 0.000210118f
Cred_11711 VDD.P2.nSD vin3.$603.Metal2 0.0405575f
Cred_11712 VDD.P2.nSD vin3.$604.Metal2 0.0055331f
Cred_11713 VDD.P2.nSD vin3.$609.Metal2 0.00884623f
Cred_11714 VDD.P2.nSD vin3.$611.Metal2 0.016853f
Cred_11715 VDD.P2.nSD vin3.$613.Metal2 0.0515828f
Cred_11716 VDD.P2.nSD vin3.$616.Metal2 0.0144608f
Cred_11717 VDD.P2.nSD vin3.$620.Metal2 0.0133856f
Cred_11718 VDD.P2.nSD vin3.$622.Metal2 0.0390691f
Cred_11719 VDD.P2.nSD vin3.$625.Metal2 0.0199396f
Cred_11720 VDD.P2.nSD vin3.$629.Metal2 0.0184604f
Cred_11721 VDD.P2.nSD vin3.$633.Metal2 0.0422775f
Cred_11722 VDD.P2.nSD vin3.$636.Metal2 0.0180005f
Cred_11723 VDD.P2.nSD vin3.$640.Metal2 0.0179601f
Cred_11724 VDD.P2.nSD vin3.$642.Metal2 0.0530278f
Cred_11725 VDD.P2.nSD vin3.$645.Metal2 0.0149744f
Cred_11726 VDD.P2.nSD vin3.$648.Metal2 0.000941888f
Cred_11727 VDD.P2.nSD vin3.$649.Metal2 0.0148153f
Cred_11728 VDD.P2.nSD vin3.$65.GatPoly 0.00500763f
Cred_11729 VDD.P2.nSD vin3.$653.Metal2 0.00360134f
Cred_11730 VDD.P2.nSD vin3.$654.Metal2 0.0355504f
Cred_11731 VDD.P2.nSD vin3.$73.GatPoly 0.0049112f
Cred_11732 VDD.P2.nSD vin3.$77.GatPoly 0.00336467f
Cred_11733 VDD.P2.nSD vin3.$83.GatPoly 0.0042155f
Cred_11734 VDD.P2.nSD vin3.$87.GatPoly 0.00325409f
Cred_11735 VDD.P2.nSD vin3.$9.GatPoly 0.00709921f
Cred_11736 VDD.P2.nSD vin3.$93.GatPoly 0.00472553f
Cred_11737 VDD.P2.nSD vin3.$97.GatPoly 0.00403812f
Cred_11738 VDD.P2.nSD vin3.P20.GatPoly 0.0165265f
Cred_11739 VDD.P2.nSD vin3.P22.GatPoly 3.87488e-06f
Cred_11740 VDD.P2.nSD vin3.P24.GatPoly 0.000433658f
Cred_11741 VDD.P2.nSD vin3.P25.GatPoly 3.99011e-06f
Cred_11742 VDD.P2.nSD vin3.P27.GatPoly 0.000432352f
Cred_11743 VDD.P2.nSD vin3.P28.GatPoly 3.84561e-06f
Cred_11744 VDD.P2.nSD vin3.P29.GatPoly 1.28772e-06f
Cred_11745 VDD.P2.nSD vin3.P30.GatPoly 1.28772e-06f
Cred_11746 VDD.P2.nSD vin3.P31.GatPoly 3.9016e-06f
Cred_11747 VDD.P2.nSD vin3.P32.GatPoly 0.000430798f
Cred_11748 VDD.P2.nSD vin3.P33.GatPoly 1.31945e-06f
Cred_11749 VDD.P2.nSD vin3.P34.GatPoly 3.99011e-06f
Cred_11750 VDD.P2.nSD vin3.P35.GatPoly 0.000433658f
Cred_11751 VDD.P2.nSD vin3.P37.GatPoly 3.50761e-06f
Cred_11752 VDD.P2.nSD vin3.P38.GatPoly 2.63377e-06f
Cred_11753 VDD.P2.nSD vin3.P39.GatPoly 0.0164873f
Cred_11754 VDD.P2.nSD vin4.P20.GatPoly 2.87301e-07f
Cred_11755 VDD.P2.nSD vin4.P22.GatPoly 3.87488e-06f
Cred_11756 VDD.P2.nSD vin4.P24.GatPoly 1.11477e-06f
Cred_11757 VDD.P2.nSD vin4.P25.GatPoly 3.99011e-06f
Cred_11758 VDD.P2.nSD vin4.P27.GatPoly 1.55357e-06f
Cred_11759 VDD.P2.nSD vin4.P28.GatPoly 3.84561e-06f
Cred_11760 VDD.P2.nSD vin4.P29.GatPoly 1.28772e-06f
Cred_11761 VDD.P2.nSD vin4.P30.GatPoly 1.28772e-06f
Cred_11762 VDD.P2.nSD vin4.P31.GatPoly 3.9016e-06f
Cred_11763 VDD.P2.nSD vin4.P33.GatPoly 1.31945e-06f
Cred_11764 VDD.P2.nSD vin4.P34.GatPoly 3.99011e-06f
Cred_11765 VDD.P2.nSD vin4.P35.GatPoly 1.11477e-06f
Cred_11766 VDD.P2.nSD vin4.P37.GatPoly 3.50761e-06f
Cred_11767 VDD.P2.nSD vin4.P38.GatPoly 2.63377e-06f
Cred_11768 VDD.P2.nSD vout3 0.0113779f
Cred_11769 VDD.P2.nSD vout3.$1226.Metal3 0.0486128f
Cred_11770 VDD.P2.nSD vout3.$1292.Metal3 0.0324508f
Cred_11771 VDD.P2.nSD vout3.$1358.Metal3 0.0343368f
Cred_11772 VDD.P2.nSD vout3.$1424.Metal3 0.0647893f
Cred_11773 VDD.P2.nSD vout3.P0.nSD 0.000560996f
Cred_11774 VDD.P2.nSD vout3.P0.pSD 0.00337633f
Cred_11775 VDD.P2.nSD vout3.P10.nSD 0.000132216f
Cred_11776 VDD.P2.nSD vout3.P10.pSD 0.000716168f
Cred_11777 VDD.P2.nSD vout3.P12.pSD 1.29835e-06f
Cred_11778 VDD.P2.nSD vout3.P14.nSD 0.000131398f
Cred_11779 VDD.P2.nSD vout3.P14.pSD 0.000711715f
Cred_11780 VDD.P2.nSD vout3.P16.pSD 3.22496e-07f
Cred_11781 VDD.P2.nSD vout3.P18.nSD 0.000630353f
Cred_11782 VDD.P2.nSD vout3.P18.pSD 0.00358882f
Cred_11783 VDD.P2.nSD vout3.P2.nSD 0.000388418f
Cred_11784 VDD.P2.nSD vout3.P2.pSD 0.00212279f
Cred_11785 VDD.P2.nSD vout3.P4.pSD 5.08636e-08f
Cred_11786 VDD.P2.nSD vout3.P6.nSD 0.000122053f
Cred_11787 VDD.P2.nSD vout3.P6.pSD 0.000668271f
Cred_11788 VDD.P2.nSD vout4 2.22237e-07f
Cred_11789 VDD.P2.nSD vout4.$1226.Metal3 2.67196e-06f
Cred_11790 VDD.P2.nSD vout4.$1292.Metal3 1.06686e-06f
Cred_11791 VDD.P2.nSD vout4.$1358.Metal3 2.26464e-06f
Cred_11792 VDD.P2.nSD vout4.$1424.Metal3 2.15529e-06f
Cred_11793 VDD.P2.nSD vout4.P0.nSD 4.44269e-08f
Cred_11794 VDD.P2.nSD vout4.P0.pSD 1.68946e-06f
Cred_11795 VDD.P2.nSD vout4.P10.nSD 3.47458e-09f
Cred_11796 VDD.P2.nSD vout4.P10.pSD 9.4127e-08f
Cred_11797 VDD.P2.nSD vout4.P12.pSD 1.29835e-06f
Cred_11798 VDD.P2.nSD vout4.P14.nSD 2.4801e-09f
Cred_11799 VDD.P2.nSD vout4.P14.pSD 6.71862e-08f
Cred_11800 VDD.P2.nSD vout4.P16.pSD 3.22496e-07f
Cred_11801 VDD.P2.nSD vout4.P18.nSD 1.76579e-08f
Cred_11802 VDD.P2.nSD vout4.P18.pSD 7.82298e-07f
Cred_11803 VDD.P2.nSD vout4.P2.nSD 2.3505e-08f
Cred_11804 VDD.P2.nSD vout4.P2.pSD 1.2846e-07f
Cred_11805 VDD.P2.nSD vout4.P4.pSD 5.08636e-08f
Cred_11806 VDD.P2.nSD vout4.P6.nSD 1.33328e-08f
Cred_11807 VDD.P2.nSD vout4.P6.pSD 1.29616e-06f
Cred_11808 VDD.P2.nSD VSS.$159.Metal1 0.00311011f
Cred_11809 VDD.P2.nSD VSS.$1990.Metal1 0.0245879f
Cred_11810 VDD.P2.nSD VSS.$2022.Metal1 0.00316216f
Cred_11811 VDD.P2.nSD VSS.$2238.Metal2 7.66606e-05f
Cred_11812 VDD.P2.nSD VSS.$4174.Metal2 0.000987358f
Cred_11813 VDD.P2.nSD VSS.$68.Metal1 0.024932f
Cred_11814 VDD.P2.nSD VSS.P2.pSD 0.532434f
Cred_11815 VDD.P2.nSD VSS.P48.nSD 2.14793e-05f
Cred_11816 VDD.P2.nSD VSS.P49.nSD 2.14793e-05f
Cred_11817 VDD.P2.nSD VSS.P69.nSD 2.17072e-05f
Cred_11818 VDD.P2.nSD VSS.P71.nSD 2.17072e-05f
Cred_11819 VDD.P21.pSD vin4.$178.GatPoly 3.62309e-05f
Cred_11820 VDD.P21.pSD vin4.$456.Metal1 0.000319189f
Cred_11821 VDD.P21.pSD vin4.$648.Metal2 6.75829e-06f
Cred_11822 VDD.P21.pSD vin4.$653.Metal2 3.35307e-05f
Cred_11823 VDD.P21.pSD vin4.P39.GatPoly 0.000232595f
Cred_11824 VDD.P21.pSD vout4 0.000341215f
Cred_11825 VDD.P21.pSD vout4.$1424.Metal3 0.00172091f
Cred_11826 VDD.P21.pSD vout4.P18.nSD 2.71113e-05f
Cred_11827 VDD.P21.pSD vout4.P18.pSD 0.000279145f
Cred_11828 VDD.P21.pSD VSS.$1991.Metal1 3.91445e-06f
Cred_11829 VDD.P21.pSD VSS.$2023.Metal1 1.02649e-05f
Cred_11830 VDD.P21.pSD VSS.$4241.Metal2 7.92998e-06f
Cred_11831 VDD.P21.pSD VSS.$66.Metal1 9.91098e-09f
Cred_11832 VDD.P21.pSD VSS.P0.pSD 3.86649e-05f
Cred_11833 VDD.P21.pSD VSS.P21.nSD 1.95928e-09f
Cred_11834 VDD.P21.pSD VSS.P23.nSD 1.95928e-09f
Cred_11835 VDD.P23.pSD vin4.$178.GatPoly 3.62309e-05f
Cred_11836 VDD.P23.pSD vin4.$456.Metal1 0.000319189f
Cred_11837 VDD.P23.pSD vin4.$648.Metal2 6.75829e-06f
Cred_11838 VDD.P23.pSD vin4.$653.Metal2 3.35307e-05f
Cred_11839 VDD.P23.pSD vin4.P39.GatPoly 0.000232595f
Cred_11840 VDD.P23.pSD vout4 2.49785e-05f
Cred_11841 VDD.P23.pSD vout4.$1424.Metal3 0.000125979f
Cred_11842 VDD.P23.pSD vout4.P18.nSD 1.98467e-06f
Cred_11843 VDD.P23.pSD vout4.P18.pSD 0.000143058f
Cred_11844 VDD.P23.pSD VSS.$1991.Metal1 3.91445e-06f
Cred_11845 VDD.P23.pSD VSS.$2023.Metal1 1.02649e-05f
Cred_11846 VDD.P23.pSD VSS.$4241.Metal2 7.92998e-06f
Cred_11847 VDD.P23.pSD VSS.$66.Metal1 9.91098e-09f
Cred_11848 VDD.P23.pSD VSS.P0.pSD 3.86649e-05f
Cred_11849 VDD.P23.pSD VSS.P21.nSD 1.95928e-09f
Cred_11850 VDD.P23.pSD VSS.P23.nSD 1.95928e-09f
Cred_11851 VDD.P24.pSD vin1.$203.Metal1 0.00120842f
Cred_11852 VDD.P24.pSD vin1.$477.Metal2 0.00012184f
Cred_11853 VDD.P24.pSD vin1.$480.Metal2 0.000252397f
Cred_11854 VDD.P24.pSD vin1.$9.GatPoly 0.000136019f
Cred_11855 VDD.P24.pSD vin1.P20.GatPoly 0.00216443f
Cred_11856 VDD.P24.pSD vout1.$1226.Metal3 0.00088195f
Cred_11857 VDD.P24.pSD vout1.P0.nSD 2.62617e-05f
Cred_11858 VDD.P24.pSD vout1.P0.pSD 0.000972644f
Cred_11859 VDD.P24.pSD vout1.P2.nSD 1.38943e-05f
Cred_11860 VDD.P24.pSD vout1.P2.pSD 7.59355e-05f
Cred_11861 VDD.P24.pSD VSS.$1989.Metal1 8.24843e-09f
Cred_11862 VDD.P24.pSD VSS.$2020.Metal1 2.06524e-08f
Cred_11863 VDD.P24.pSD VSS.$29.Metal1 4.71203e-05f
Cred_11864 VDD.P24.pSD VSS.$4227.Metal2 5.52926e-11f
Cred_11865 VDD.P24.pSD VSS.$4355.Metal3 3.99567e-06f
Cred_11866 VDD.P24.pSD VSS.P1.pSD 0.00011996f
Cred_11867 VDD.P25.pSD vin1.$203.Metal1 0.00128534f
Cred_11868 VDD.P25.pSD vin1.$477.Metal2 0.000788016f
Cred_11869 VDD.P25.pSD vin1.$480.Metal2 0.00149414f
Cred_11870 VDD.P25.pSD vin1.$9.GatPoly 0.000137421f
Cred_11871 VDD.P25.pSD vin1.P20.GatPoly 0.0022505f
Cred_11872 VDD.P25.pSD vout1.$1226.Metal3 0.000893981f
Cred_11873 VDD.P25.pSD vout1.P0.nSD 2.66199e-05f
Cred_11874 VDD.P25.pSD vout1.P0.pSD 0.00098937f
Cred_11875 VDD.P25.pSD vout1.P2.nSD 1.40838e-05f
Cred_11876 VDD.P25.pSD vout1.P2.pSD 7.69714e-05f
Cred_11877 VDD.P25.pSD VSS.$1989.Metal1 8.24843e-09f
Cred_11878 VDD.P25.pSD VSS.$2020.Metal1 2.06524e-08f
Cred_11879 VDD.P25.pSD VSS.$29.Metal1 4.71203e-05f
Cred_11880 VDD.P25.pSD VSS.$4227.Metal2 5.52926e-11f
Cred_11881 VDD.P25.pSD VSS.$4355.Metal3 3.99567e-06f
Cred_11882 VDD.P25.pSD VSS.P1.pSD 0.00011996f
Cred_11883 VDD.P27.pSD vin1.$15.GatPoly 0.0191806f
Cred_11884 VDD.P27.pSD vin1.$17.GatPoly 0.00472678f
Cred_11885 VDD.P27.pSD vin1.$207.Metal1 0.00517618f
Cred_11886 VDD.P27.pSD vin1.$211.Metal1 0.0117425f
Cred_11887 VDD.P27.pSD vin1.$219.Metal1 0.00183771f
Cred_11888 VDD.P27.pSD vin1.$484.Metal2 0.00542706f
Cred_11889 VDD.P27.pSD vin1.$486.Metal2 0.000839497f
Cred_11890 VDD.P27.pSD vin1.$489.Metal2 0.00683498f
Cred_11891 VDD.P27.pSD vin1.$493.Metal2 4.50267e-06f
Cred_11892 VDD.P27.pSD vin1.$9.GatPoly 0.0172362f
Cred_11893 VDD.P27.pSD vin1.P20.GatPoly 0.000166635f
Cred_11894 VDD.P27.pSD vin1.P21.GatPoly 0.0499743f
Cred_11895 VDD.P27.pSD vin1.P22.GatPoly 0.0491168f
Cred_11896 VDD.P27.pSD vin1.P23.GatPoly 0.000152531f
Cred_11897 VDD.P27.pSD vin2.$14.GatPoly 2.2356e-05f
Cred_11898 VDD.P27.pSD vin2.$16.GatPoly 4.64848e-06f
Cred_11899 VDD.P27.pSD vin2.$206.Metal1 4.99616e-06f
Cred_11900 VDD.P27.pSD vin2.$210.Metal1 1.12984e-05f
Cred_11901 VDD.P27.pSD vin2.$218.Metal1 1.75847e-06f
Cred_11902 VDD.P27.pSD vin2.$483.Metal2 1.3156e-05f
Cred_11903 VDD.P27.pSD vin2.$486.Metal2 2.03932e-06f
Cred_11904 VDD.P27.pSD vin2.$488.Metal2 1.65375e-05f
Cred_11905 VDD.P27.pSD vin2.$492.Metal2 4.30854e-09f
Cred_11906 VDD.P27.pSD vin2.$8.GatPoly 2.03989e-05f
Cred_11907 VDD.P27.pSD vin2.P20.GatPoly 1.0621e-06f
Cred_11908 VDD.P27.pSD vin2.P21.GatPoly 7.5202e-05f
Cred_11909 VDD.P27.pSD vin2.P22.GatPoly 7.38063e-05f
Cred_11910 VDD.P27.pSD vin2.P23.GatPoly 9.63259e-07f
Cred_11911 VDD.P27.pSD vout1.$1226.Metal3 0.0686911f
Cred_11912 VDD.P27.pSD vout1.P0.nSD 0.00151816f
Cred_11913 VDD.P27.pSD vout1.P0.pSD 0.0320745f
Cred_11914 VDD.P27.pSD vout1.P2.nSD 0.00108216f
Cred_11915 VDD.P27.pSD vout1.P2.pSD 0.0264483f
Cred_11916 VDD.P27.pSD vout2.$1226.Metal3 0.000196149f
Cred_11917 VDD.P27.pSD vout2.P0.nSD 4.33379e-06f
Cred_11918 VDD.P27.pSD vout2.P0.pSD 7.49673e-05f
Cred_11919 VDD.P27.pSD vout2.P2.nSD 3.09015e-06f
Cred_11920 VDD.P27.pSD vout2.P2.pSD 6.18522e-05f
Cred_11921 VDD.P29.pSD vin1.$237.Metal1 0.00270362f
Cred_11922 VDD.P29.pSD vin1.$241.Metal1 0.0117577f
Cred_11923 VDD.P29.pSD vin1.$247.Metal1 0.00586999f
Cred_11924 VDD.P29.pSD vin1.$25.GatPoly 0.0204585f
Cred_11925 VDD.P29.pSD vin1.$251.Metal1 0.00199065f
Cred_11926 VDD.P29.pSD vin1.$37.GatPoly 0.011247f
Cred_11927 VDD.P29.pSD vin1.$43.GatPoly 0.00376383f
Cred_11928 VDD.P29.pSD vin1.$504.Metal2 0.00787471f
Cred_11929 VDD.P29.pSD vin1.$506.Metal2 0.000766832f
Cred_11930 VDD.P29.pSD vin1.$509.Metal2 0.00456037f
Cred_11931 VDD.P29.pSD vin1.P22.GatPoly 0.000152403f
Cred_11932 VDD.P29.pSD vin1.P23.GatPoly 0.0490831f
Cred_11933 VDD.P29.pSD vin1.P24.GatPoly 0.0520434f
Cred_11934 VDD.P29.pSD vin1.P25.GatPoly 0.000152403f
Cred_11935 VDD.P29.pSD vin2.$236.Metal1 2.25972e-06f
Cred_11936 VDD.P29.pSD vin2.$24.GatPoly 2.04814e-05f
Cred_11937 VDD.P29.pSD vin2.$240.Metal1 9.79792e-06f
Cred_11938 VDD.P29.pSD vin2.$246.Metal1 5.51615e-06f
Cred_11939 VDD.P29.pSD vin2.$250.Metal1 2.01467e-06f
Cred_11940 VDD.P29.pSD vin2.$36.GatPoly 1.06797e-05f
Cred_11941 VDD.P29.pSD vin2.$42.GatPoly 3.80925e-06f
Cred_11942 VDD.P29.pSD vin2.$503.Metal2 1.65714e-05f
Cred_11943 VDD.P29.pSD vin2.$506.Metal2 1.61549e-06f
Cred_11944 VDD.P29.pSD vin2.$508.Metal2 9.54785e-06f
Cred_11945 VDD.P29.pSD vin2.P22.GatPoly 8.35102e-07f
Cred_11946 VDD.P29.pSD vin2.P23.GatPoly 6.41201e-05f
Cred_11947 VDD.P29.pSD vin2.P24.GatPoly 6.7112e-05f
Cred_11948 VDD.P29.pSD vin2.P25.GatPoly 8.35102e-07f
Cred_11949 VDD.P29.pSD vout1.$1226.Metal3 0.0791437f
Cred_11950 VDD.P29.pSD vout1.P0.nSD 0.00051576f
Cred_11951 VDD.P29.pSD vout1.P0.pSD 0.00274066f
Cred_11952 VDD.P29.pSD vout1.P2.nSD 0.00056108f
Cred_11953 VDD.P29.pSD vout1.P2.pSD 0.0236853f
Cred_11954 VDD.P29.pSD vout1.P4.pSD 0.0214699f
Cred_11955 VDD.P29.pSD vout2.$1226.Metal3 0.000197453f
Cred_11956 VDD.P29.pSD vout2.P0.nSD 1.29918e-06f
Cred_11957 VDD.P29.pSD vout2.P0.pSD 6.90362e-06f
Cred_11958 VDD.P29.pSD vout2.P2.nSD 1.41334e-06f
Cred_11959 VDD.P29.pSD vout2.P2.pSD 4.6631e-05f
Cred_11960 VDD.P29.pSD vout2.P4.pSD 3.98032e-05f
Cred_11961 VDD.P3.GatPoly vin1.$179.GatPoly 0.0030499f
Cred_11962 VDD.P3.GatPoly vin1.$457.Metal1 0.0165391f
Cred_11963 VDD.P3.GatPoly vin1.$649.Metal2 0.000349285f
Cred_11964 VDD.P3.GatPoly vin1.$654.Metal2 0.00168599f
Cred_11965 VDD.P3.GatPoly vin1.P34.GatPoly 0.00130082f
Cred_11966 VDD.P3.GatPoly vin1.P35.GatPoly 0.00160627f
Cred_11967 VDD.P3.GatPoly vin1.P36.GatPoly 0.00227743f
Cred_11968 VDD.P3.GatPoly vin1.P37.GatPoly 0.00328573f
Cred_11969 VDD.P3.GatPoly vin1.P38.GatPoly 0.00596583f
Cred_11970 VDD.P3.GatPoly vin1.P39.GatPoly 0.0706805f
Cred_11971 VDD.P3.GatPoly vout1 0.000613058f
Cred_11972 VDD.P3.GatPoly vout1.$1424.Metal3 0.00309194f
Cred_11973 VDD.P3.GatPoly vout1.P18.nSD 4.87107e-05f
Cred_11974 VDD.P3.GatPoly vout1.P18.pSD 0.000338518f
Cred_11975 VDD.P3.GatPoly VSS.P3.GatPoly 0.00217316f
Cred_11976 VDD.P3.nSD vin1.P20.GatPoly 2.87301e-07f
Cred_11977 VDD.P3.nSD vin1.P22.GatPoly 3.87488e-06f
Cred_11978 VDD.P3.nSD vin1.P24.GatPoly 1.11477e-06f
Cred_11979 VDD.P3.nSD vin1.P25.GatPoly 3.99011e-06f
Cred_11980 VDD.P3.nSD vin1.P27.GatPoly 1.55357e-06f
Cred_11981 VDD.P3.nSD vin1.P28.GatPoly 3.84561e-06f
Cred_11982 VDD.P3.nSD vin1.P29.GatPoly 1.28772e-06f
Cred_11983 VDD.P3.nSD vin1.P30.GatPoly 1.28772e-06f
Cred_11984 VDD.P3.nSD vin1.P31.GatPoly 3.9016e-06f
Cred_11985 VDD.P3.nSD vin1.P33.GatPoly 1.31945e-06f
Cred_11986 VDD.P3.nSD vin1.P34.GatPoly 3.99011e-06f
Cred_11987 VDD.P3.nSD vin1.P35.GatPoly 1.11477e-06f
Cred_11988 VDD.P3.nSD vin1.P37.GatPoly 3.50761e-06f
Cred_11989 VDD.P3.nSD vin1.P38.GatPoly 2.63377e-06f
Cred_11990 VDD.P3.nSD vin2.$104.GatPoly 0.00421471f
Cred_11991 VDD.P3.nSD vin2.$106.GatPoly 0.00336399f
Cred_11992 VDD.P3.nSD vin2.$114.GatPoly 0.0049101f
Cred_11993 VDD.P3.nSD vin2.$122.GatPoly 0.00500629f
Cred_11994 VDD.P3.nSD vin2.$126.GatPoly 0.00404075f
Cred_11995 VDD.P3.nSD vin2.$134.GatPoly 0.0042789f
Cred_11996 VDD.P3.nSD vin2.$136.GatPoly 0.00345863f
Cred_11997 VDD.P3.nSD vin2.$14.GatPoly 0.00356132f
Cred_11998 VDD.P3.nSD vin2.$144.GatPoly 0.00478496f
Cred_11999 VDD.P3.nSD vin2.$152.GatPoly 0.00500307f
Cred_12000 VDD.P3.nSD vin2.$156.GatPoly 0.00339349f
Cred_12001 VDD.P3.nSD vin2.$16.GatPoly 0.00384897f
Cred_12002 VDD.P3.nSD vin2.$162.GatPoly 0.00398664f
Cred_12003 VDD.P3.nSD vin2.$166.GatPoly 0.00356132f
Cred_12004 VDD.P3.nSD vin2.$172.GatPoly 0.00384897f
Cred_12005 VDD.P3.nSD vin2.$178.GatPoly 0.00703546f
Cred_12006 VDD.P3.nSD vin2.$202.Metal1 0.112116f
Cred_12007 VDD.P3.nSD vin2.$206.Metal1 0.0231364f
Cred_12008 VDD.P3.nSD vin2.$210.Metal1 0.0346299f
Cred_12009 VDD.P3.nSD vin2.$218.Metal1 0.0486079f
Cred_12010 VDD.P3.nSD vin2.$226.Metal1 0.0464702f
Cred_12011 VDD.P3.nSD vin2.$232.Metal1 0.0327464f
Cred_12012 VDD.P3.nSD vin2.$236.Metal1 0.0239851f
Cred_12013 VDD.P3.nSD vin2.$24.GatPoly 0.00339349f
Cred_12014 VDD.P3.nSD vin2.$240.Metal1 0.0344523f
Cred_12015 VDD.P3.nSD vin2.$246.Metal1 0.0350925f
Cred_12016 VDD.P3.nSD vin2.$250.Metal1 0.0350268f
Cred_12017 VDD.P3.nSD vin2.$258.Metal1 0.0354111f
Cred_12018 VDD.P3.nSD vin2.$26.GatPoly 0.00398664f
Cred_12019 VDD.P3.nSD vin2.$262.Metal1 0.0238519f
Cred_12020 VDD.P3.nSD vin2.$264.Metal1 0.0354424f
Cred_12021 VDD.P3.nSD vin2.$272.Metal1 0.0348641f
Cred_12022 VDD.P3.nSD vin2.$276.Metal1 0.0238686f
Cred_12023 VDD.P3.nSD vin2.$280.Metal1 0.0247786f
Cred_12024 VDD.P3.nSD vin2.$284.Metal1 0.0346872f
Cred_12025 VDD.P3.nSD vin2.$290.Metal1 0.0371403f
Cred_12026 VDD.P3.nSD vin2.$294.Metal1 0.0352858f
Cred_12027 VDD.P3.nSD vin2.$302.Metal1 0.035234f
Cred_12028 VDD.P3.nSD vin2.$306.Metal1 0.0365289f
Cred_12029 VDD.P3.nSD vin2.$312.Metal1 0.0354259f
Cred_12030 VDD.P3.nSD vin2.$316.Metal1 0.0235251f
Cred_12031 VDD.P3.nSD vin2.$320.Metal1 0.02452f
Cred_12032 VDD.P3.nSD vin2.$324.Metal1 0.0346972f
Cred_12033 VDD.P3.nSD vin2.$330.Metal1 0.0350222f
Cred_12034 VDD.P3.nSD vin2.$334.Metal1 0.0236181f
Cred_12035 VDD.P3.nSD vin2.$338.Metal1 0.02452f
Cred_12036 VDD.P3.nSD vin2.$342.Metal1 0.0235251f
Cred_12037 VDD.P3.nSD vin2.$346.Metal1 0.0354259f
Cred_12038 VDD.P3.nSD vin2.$352.Metal1 0.0365289f
Cred_12039 VDD.P3.nSD vin2.$356.Metal1 0.035234f
Cred_12040 VDD.P3.nSD vin2.$36.GatPoly 0.00500307f
Cred_12041 VDD.P3.nSD vin2.$364.Metal1 0.0352858f
Cred_12042 VDD.P3.nSD vin2.$368.Metal1 0.0371403f
Cred_12043 VDD.P3.nSD vin2.$374.Metal1 0.0346872f
Cred_12044 VDD.P3.nSD vin2.$378.Metal1 0.0247786f
Cred_12045 VDD.P3.nSD vin2.$382.Metal1 0.0238686f
Cred_12046 VDD.P3.nSD vin2.$386.Metal1 0.0348641f
Cred_12047 VDD.P3.nSD vin2.$392.Metal1 0.0354424f
Cred_12048 VDD.P3.nSD vin2.$396.Metal1 0.0238519f
Cred_12049 VDD.P3.nSD vin2.$400.Metal1 0.0354111f
Cred_12050 VDD.P3.nSD vin2.$408.Metal1 0.0350268f
Cred_12051 VDD.P3.nSD vin2.$412.Metal1 0.0350925f
Cred_12052 VDD.P3.nSD vin2.$418.Metal1 0.0344523f
Cred_12053 VDD.P3.nSD vin2.$42.GatPoly 0.00478496f
Cred_12054 VDD.P3.nSD vin2.$422.Metal1 0.0239851f
Cred_12055 VDD.P3.nSD vin2.$426.Metal1 0.0327464f
Cred_12056 VDD.P3.nSD vin2.$432.Metal1 0.0464702f
Cred_12057 VDD.P3.nSD vin2.$44.GatPoly 0.00345863f
Cred_12058 VDD.P3.nSD vin2.$440.Metal1 0.0486079f
Cred_12059 VDD.P3.nSD vin2.$448.Metal1 0.0346299f
Cred_12060 VDD.P3.nSD vin2.$452.Metal1 0.0231364f
Cred_12061 VDD.P3.nSD vin2.$456.Metal1 0.109324f
Cred_12062 VDD.P3.nSD vin2.$477.Metal2 0.0908133f
Cred_12063 VDD.P3.nSD vin2.$479.Metal2 0.08567f
Cred_12064 VDD.P3.nSD vin2.$483.Metal2 0.0149513f
Cred_12065 VDD.P3.nSD vin2.$486.Metal2 0.0388047f
Cred_12066 VDD.P3.nSD vin2.$488.Metal2 0.017935f
Cred_12067 VDD.P3.nSD vin2.$492.Metal2 0.0179809f
Cred_12068 VDD.P3.nSD vin2.$495.Metal2 0.0422344f
Cred_12069 VDD.P3.nSD vin2.$499.Metal2 0.0184429f
Cred_12070 VDD.P3.nSD vin2.$503.Metal2 0.0199247f
Cred_12071 VDD.P3.nSD vin2.$506.Metal2 0.039041f
Cred_12072 VDD.P3.nSD vin2.$508.Metal2 0.0133764f
Cred_12073 VDD.P3.nSD vin2.$512.Metal2 0.0144528f
Cred_12074 VDD.P3.nSD vin2.$515.Metal2 0.051558f
Cred_12075 VDD.P3.nSD vin2.$517.Metal2 0.0168442f
Cred_12076 VDD.P3.nSD vin2.$519.Metal2 0.00884236f
Cred_12077 VDD.P3.nSD vin2.$52.GatPoly 0.0042789f
Cred_12078 VDD.P3.nSD vin2.$524.Metal2 0.00553104f
Cred_12079 VDD.P3.nSD vin2.$525.Metal2 0.0405423f
Cred_12080 VDD.P3.nSD vin2.$529.Metal2 0.000210039f
Cred_12081 VDD.P3.nSD vin2.$532.Metal2 0.0214362f
Cred_12082 VDD.P3.nSD vin2.$535.Metal2 0.0519332f
Cred_12083 VDD.P3.nSD vin2.$537.Metal2 0.0149744f
Cred_12084 VDD.P3.nSD vin2.$541.Metal2 0.012857f
Cred_12085 VDD.P3.nSD vin2.$544.Metal2 0.0372266f
Cred_12086 VDD.P3.nSD vin2.$546.Metal2 0.0219041f
Cred_12087 VDD.P3.nSD vin2.$550.Metal2 0.0179759f
Cred_12088 VDD.P3.nSD vin2.$555.Metal2 0.0429912f
Cred_12089 VDD.P3.nSD vin2.$557.Metal2 0.0192661f
Cred_12090 VDD.P3.nSD vin2.$56.GatPoly 0.00404075f
Cred_12091 VDD.P3.nSD vin2.$561.Metal2 0.0172678f
Cred_12092 VDD.P3.nSD vin2.$564.Metal2 0.0398348f
Cred_12093 VDD.P3.nSD vin2.$566.Metal2 0.0170672f
Cred_12094 VDD.P3.nSD vin2.$570.Metal2 0.0192661f
Cred_12095 VDD.P3.nSD vin2.$573.Metal2 0.0429912f
Cred_12096 VDD.P3.nSD vin2.$577.Metal2 0.0179759f
Cred_12097 VDD.P3.nSD vin2.$581.Metal2 0.0219041f
Cred_12098 VDD.P3.nSD vin2.$584.Metal2 0.0372266f
Cred_12099 VDD.P3.nSD vin2.$586.Metal2 0.012857f
Cred_12100 VDD.P3.nSD vin2.$590.Metal2 0.0149744f
Cred_12101 VDD.P3.nSD vin2.$593.Metal2 0.0519332f
Cred_12102 VDD.P3.nSD vin2.$595.Metal2 0.0214362f
Cred_12103 VDD.P3.nSD vin2.$600.Metal2 0.000210039f
Cred_12104 VDD.P3.nSD vin2.$601.Metal2 0.0405423f
Cred_12105 VDD.P3.nSD vin2.$605.Metal2 0.00553104f
Cred_12106 VDD.P3.nSD vin2.$608.Metal2 0.00884236f
Cred_12107 VDD.P3.nSD vin2.$610.Metal2 0.0168442f
Cred_12108 VDD.P3.nSD vin2.$613.Metal2 0.051558f
Cred_12109 VDD.P3.nSD vin2.$615.Metal2 0.0144528f
Cred_12110 VDD.P3.nSD vin2.$619.Metal2 0.0133764f
Cred_12111 VDD.P3.nSD vin2.$622.Metal2 0.039041f
Cred_12112 VDD.P3.nSD vin2.$624.Metal2 0.0199247f
Cred_12113 VDD.P3.nSD vin2.$628.Metal2 0.0184429f
Cred_12114 VDD.P3.nSD vin2.$633.Metal2 0.0422344f
Cred_12115 VDD.P3.nSD vin2.$635.Metal2 0.0179809f
Cred_12116 VDD.P3.nSD vin2.$639.Metal2 0.017935f
Cred_12117 VDD.P3.nSD vin2.$64.GatPoly 0.00500629f
Cred_12118 VDD.P3.nSD vin2.$642.Metal2 0.053141f
Cred_12119 VDD.P3.nSD vin2.$644.Metal2 0.0149513f
Cred_12120 VDD.P3.nSD vin2.$648.Metal2 0.0148821f
Cred_12121 VDD.P3.nSD vin2.$649.Metal2 0.000800456f
Cred_12122 VDD.P3.nSD vin2.$653.Metal2 0.0358397f
Cred_12123 VDD.P3.nSD vin2.$654.Metal2 0.00306057f
Cred_12124 VDD.P3.nSD vin2.$72.GatPoly 0.0049101f
Cred_12125 VDD.P3.nSD vin2.$76.GatPoly 0.00336399f
Cred_12126 VDD.P3.nSD vin2.$8.GatPoly 0.00708578f
Cred_12127 VDD.P3.nSD vin2.$82.GatPoly 0.00421471f
Cred_12128 VDD.P3.nSD vin2.$86.GatPoly 0.00325351f
Cred_12129 VDD.P3.nSD vin2.$92.GatPoly 0.0047247f
Cred_12130 VDD.P3.nSD vin2.$96.GatPoly 0.0040374f
Cred_12131 VDD.P3.nSD vin2.P20.GatPoly 0.0164833f
Cred_12132 VDD.P3.nSD vin2.P22.GatPoly 3.87488e-06f
Cred_12133 VDD.P3.nSD vin2.P24.GatPoly 0.000433398f
Cred_12134 VDD.P3.nSD vin2.P25.GatPoly 3.99011e-06f
Cred_12135 VDD.P3.nSD vin2.P27.GatPoly 0.000432247f
Cred_12136 VDD.P3.nSD vin2.P28.GatPoly 3.84561e-06f
Cred_12137 VDD.P3.nSD vin2.P29.GatPoly 1.28772e-06f
Cred_12138 VDD.P3.nSD vin2.P30.GatPoly 1.28772e-06f
Cred_12139 VDD.P3.nSD vin2.P31.GatPoly 3.9016e-06f
Cred_12140 VDD.P3.nSD vin2.P32.GatPoly 0.000430693f
Cred_12141 VDD.P3.nSD vin2.P33.GatPoly 1.31945e-06f
Cred_12142 VDD.P3.nSD vin2.P34.GatPoly 3.99011e-06f
Cred_12143 VDD.P3.nSD vin2.P35.GatPoly 0.000433398f
Cred_12144 VDD.P3.nSD vin2.P37.GatPoly 3.50761e-06f
Cred_12145 VDD.P3.nSD vin2.P38.GatPoly 2.63377e-06f
Cred_12146 VDD.P3.nSD vin2.P39.GatPoly 0.0164443f
Cred_12147 VDD.P3.nSD vout1 2.22237e-07f
Cred_12148 VDD.P3.nSD vout1.$1226.Metal3 2.67196e-06f
Cred_12149 VDD.P3.nSD vout1.$1292.Metal3 1.06686e-06f
Cred_12150 VDD.P3.nSD vout1.$1358.Metal3 2.26464e-06f
Cred_12151 VDD.P3.nSD vout1.$1424.Metal3 2.15529e-06f
Cred_12152 VDD.P3.nSD vout1.P0.nSD 4.44269e-08f
Cred_12153 VDD.P3.nSD vout1.P0.pSD 1.68946e-06f
Cred_12154 VDD.P3.nSD vout1.P10.nSD 3.47458e-09f
Cred_12155 VDD.P3.nSD vout1.P10.pSD 9.4127e-08f
Cred_12156 VDD.P3.nSD vout1.P12.pSD 1.29835e-06f
Cred_12157 VDD.P3.nSD vout1.P14.nSD 2.4801e-09f
Cred_12158 VDD.P3.nSD vout1.P14.pSD 6.71862e-08f
Cred_12159 VDD.P3.nSD vout1.P16.pSD 3.22496e-07f
Cred_12160 VDD.P3.nSD vout1.P18.nSD 1.76579e-08f
Cred_12161 VDD.P3.nSD vout1.P18.pSD 7.82298e-07f
Cred_12162 VDD.P3.nSD vout1.P2.nSD 2.3505e-08f
Cred_12163 VDD.P3.nSD vout1.P2.pSD 1.2846e-07f
Cred_12164 VDD.P3.nSD vout1.P4.pSD 5.08636e-08f
Cred_12165 VDD.P3.nSD vout1.P6.nSD 1.33328e-08f
Cred_12166 VDD.P3.nSD vout1.P6.pSD 1.29616e-06f
Cred_12167 VDD.P3.nSD vout2 0.0113337f
Cred_12168 VDD.P3.nSD vout2.$1226.Metal3 0.0485558f
Cred_12169 VDD.P3.nSD vout2.$1292.Metal3 0.032444f
Cred_12170 VDD.P3.nSD vout2.$1358.Metal3 0.034326f
Cred_12171 VDD.P3.nSD vout2.$1424.Metal3 0.0646444f
Cred_12172 VDD.P3.nSD vout2.P0.nSD 0.000559791f
Cred_12173 VDD.P3.nSD vout2.P0.pSD 0.00336865f
Cred_12174 VDD.P3.nSD vout2.P10.nSD 0.000132191f
Cred_12175 VDD.P3.nSD vout2.P10.pSD 0.000716033f
Cred_12176 VDD.P3.nSD vout2.P12.pSD 1.29835e-06f
Cred_12177 VDD.P3.nSD vout2.P14.nSD 0.00013133f
Cred_12178 VDD.P3.nSD vout2.P14.pSD 0.000711346f
Cred_12179 VDD.P3.nSD vout2.P16.pSD 3.22496e-07f
Cred_12180 VDD.P3.nSD vout2.P18.nSD 0.000628407f
Cred_12181 VDD.P3.nSD vout2.P18.pSD 0.00357822f
Cred_12182 VDD.P3.nSD vout2.P2.nSD 0.000387687f
Cred_12183 VDD.P3.nSD vout2.P2.pSD 0.0021188f
Cred_12184 VDD.P3.nSD vout2.P4.pSD 5.08636e-08f
Cred_12185 VDD.P3.nSD vout2.P6.nSD 0.000122019f
Cred_12186 VDD.P3.nSD vout2.P6.pSD 0.000668083f
Cred_12187 VDD.P3.nSD VSS.$158.Metal1 0.00309922f
Cred_12188 VDD.P3.nSD VSS.$1990.Metal1 0.0245178f
Cred_12189 VDD.P3.nSD VSS.$2021.Metal1 0.00315125f
Cred_12190 VDD.P3.nSD VSS.$2228.Metal2 7.63921e-05f
Cred_12191 VDD.P3.nSD VSS.$4164.Metal2 0.00098677f
Cred_12192 VDD.P3.nSD VSS.$68.Metal1 0.0248607f
Cred_12193 VDD.P3.nSD VSS.P3.pSD 0.53176f
Cred_12194 VDD.P3.nSD VSS.P72.nSD 2.1404e-05f
Cred_12195 VDD.P3.nSD VSS.P73.nSD 2.1404e-05f
Cred_12196 VDD.P3.nSD VSS.P93.nSD 2.16319e-05f
Cred_12197 VDD.P3.nSD VSS.P95.nSD 2.16319e-05f
Cred_12198 VDD.P3.pSD vin3.$15.GatPoly 2.2356e-05f
Cred_12199 VDD.P3.pSD vin3.$17.GatPoly 4.64848e-06f
Cred_12200 VDD.P3.pSD vin3.$207.Metal1 4.99616e-06f
Cred_12201 VDD.P3.pSD vin3.$211.Metal1 1.12984e-05f
Cred_12202 VDD.P3.pSD vin3.$219.Metal1 1.75847e-06f
Cred_12203 VDD.P3.pSD vin3.$484.Metal2 1.3156e-05f
Cred_12204 VDD.P3.pSD vin3.$486.Metal2 2.03932e-06f
Cred_12205 VDD.P3.pSD vin3.$489.Metal2 1.65375e-05f
Cred_12206 VDD.P3.pSD vin3.$493.Metal2 4.30854e-09f
Cred_12207 VDD.P3.pSD vin3.$9.GatPoly 2.03989e-05f
Cred_12208 VDD.P3.pSD vin3.P20.GatPoly 1.0621e-06f
Cred_12209 VDD.P3.pSD vin3.P21.GatPoly 7.50347e-05f
Cred_12210 VDD.P3.pSD vin3.P22.GatPoly 7.39737e-05f
Cred_12211 VDD.P3.pSD vin3.P23.GatPoly 9.63259e-07f
Cred_12212 VDD.P3.pSD vin4.$14.GatPoly 0.0191806f
Cred_12213 VDD.P3.pSD vin4.$16.GatPoly 0.00472678f
Cred_12214 VDD.P3.pSD vin4.$206.Metal1 0.00517618f
Cred_12215 VDD.P3.pSD vin4.$210.Metal1 0.0117425f
Cred_12216 VDD.P3.pSD vin4.$218.Metal1 0.00183771f
Cred_12217 VDD.P3.pSD vin4.$483.Metal2 0.00542706f
Cred_12218 VDD.P3.pSD vin4.$486.Metal2 0.000839497f
Cred_12219 VDD.P3.pSD vin4.$488.Metal2 0.00683498f
Cred_12220 VDD.P3.pSD vin4.$492.Metal2 4.50267e-06f
Cred_12221 VDD.P3.pSD vin4.$8.GatPoly 0.0172362f
Cred_12222 VDD.P3.pSD vin4.P20.GatPoly 0.000166635f
Cred_12223 VDD.P3.pSD vin4.P21.GatPoly 0.0501226f
Cred_12224 VDD.P3.pSD vin4.P22.GatPoly 0.0489685f
Cred_12225 VDD.P3.pSD vin4.P23.GatPoly 0.000152531f
Cred_12226 VDD.P3.pSD vout3.$1226.Metal3 0.000196134f
Cred_12227 VDD.P3.pSD vout3.P0.nSD 4.33349e-06f
Cred_12228 VDD.P3.pSD vout3.P0.pSD 7.4957e-05f
Cred_12229 VDD.P3.pSD vout3.P2.nSD 3.08991e-06f
Cred_12230 VDD.P3.pSD vout3.P2.pSD 6.17717e-05f
Cred_12231 VDD.P3.pSD vout4.$1226.Metal3 0.0685306f
Cred_12232 VDD.P3.pSD vout4.P0.nSD 0.00151558f
Cred_12233 VDD.P3.pSD vout4.P0.pSD 0.0320412f
Cred_12234 VDD.P3.pSD vout4.P2.nSD 0.00107963f
Cred_12235 VDD.P3.pSD vout4.P2.pSD 0.0264496f
Cred_12236 VDD.P31.pSD vin1.$265.Metal1 0.00571275f
Cred_12237 VDD.P31.pSD vin1.$273.Metal1 0.0108046f
Cred_12238 VDD.P31.pSD vin1.$277.Metal1 0.000170532f
Cred_12239 VDD.P31.pSD vin1.$281.Metal1 9.10101e-06f
Cred_12240 VDD.P31.pSD vin1.$47.GatPoly 0.0193653f
Cred_12241 VDD.P31.pSD vin1.$515.Metal2 0.000247982f
Cred_12242 VDD.P31.pSD vin1.$520.Metal2 0.00107416f
Cred_12243 VDD.P31.pSD vin1.$523.Metal2 0.00011177f
Cred_12244 VDD.P31.pSD vin1.$527.Metal2 0.0106348f
Cred_12245 VDD.P31.pSD vin1.$528.Metal2 4.24442e-06f
Cred_12246 VDD.P31.pSD vin1.$53.GatPoly 0.00484013f
Cred_12247 VDD.P31.pSD vin1.$533.Metal2 0.000757388f
Cred_12248 VDD.P31.pSD vin1.$535.Metal2 0.000247982f
Cred_12249 VDD.P31.pSD vin1.$57.GatPoly 0.01992f
Cred_12250 VDD.P31.pSD vin1.P24.GatPoly 0.000151568f
Cred_12251 VDD.P31.pSD vin1.P25.GatPoly 0.0488917f
Cred_12252 VDD.P31.pSD vin1.P26.GatPoly 0.048972f
Cred_12253 VDD.P31.pSD vin1.P27.GatPoly 0.000151568f
Cred_12254 VDD.P31.pSD vout1.$1226.Metal3 0.0628666f
Cred_12255 VDD.P31.pSD vout1.$1292.Metal3 0.0200973f
Cred_12256 VDD.P31.pSD vout1.P4.pSD 0.0216543f
Cred_12257 VDD.P31.pSD vout1.P6.nSD 0.000316614f
Cred_12258 VDD.P31.pSD vout1.P6.pSD 0.0220944f
Cred_12259 VDD.P33.pSD vin1.$291.Metal1 0.00310052f
Cred_12260 VDD.P33.pSD vin1.$295.Metal1 0.00740785f
Cred_12261 VDD.P33.pSD vin1.$303.Metal1 0.0113968f
Cred_12262 VDD.P33.pSD vin1.$307.Metal1 0.000210762f
Cred_12263 VDD.P33.pSD vin1.$542.Metal2 0.00389589f
Cred_12264 VDD.P33.pSD vin1.$544.Metal2 0.000732061f
Cred_12265 VDD.P33.pSD vin1.$547.Metal2 0.00825822f
Cred_12266 VDD.P33.pSD vin1.$551.Metal2 9.27628e-05f
Cred_12267 VDD.P33.pSD vin1.$65.GatPoly 0.00586233f
Cred_12268 VDD.P33.pSD vin1.$73.GatPoly 0.00978438f
Cred_12269 VDD.P33.pSD vin1.$77.GatPoly 0.019903f
Cred_12270 VDD.P33.pSD vin1.P26.GatPoly 0.00015227f
Cred_12271 VDD.P33.pSD vin1.P27.GatPoly 0.0522473f
Cred_12272 VDD.P33.pSD vin1.P28.GatPoly 0.0490921f
Cred_12273 VDD.P33.pSD vin1.P29.GatPoly 0.00015227f
Cred_12274 VDD.P33.pSD vin2.$290.Metal1 2.63615e-06f
Cred_12275 VDD.P33.pSD vin2.$294.Metal1 5.53399e-06f
Cred_12276 VDD.P33.pSD vin2.$302.Metal1 7.96451e-06f
Cred_12277 VDD.P33.pSD vin2.$306.Metal1 1.52164e-07f
Cred_12278 VDD.P33.pSD vin2.$541.Metal2 6.8538e-06f
Cred_12279 VDD.P33.pSD vin2.$544.Metal2 1.29699e-06f
Cred_12280 VDD.P33.pSD vin2.$546.Metal2 1.45835e-05f
Cred_12281 VDD.P33.pSD vin2.$550.Metal2 1.64347e-07f
Cred_12282 VDD.P33.pSD vin2.$64.GatPoly 4.98432e-06f
Cred_12283 VDD.P33.pSD vin2.$72.GatPoly 7.65648e-06f
Cred_12284 VDD.P33.pSD vin2.$76.GatPoly 1.68172e-05f
Cred_12285 VDD.P33.pSD vin2.P26.GatPoly 7.02069e-07f
Cred_12286 VDD.P33.pSD vin2.P27.GatPoly 5.66025e-05f
Cred_12287 VDD.P33.pSD vin2.P28.GatPoly 5.3923e-05f
Cred_12288 VDD.P33.pSD vin2.P29.GatPoly 7.02069e-07f
Cred_12289 VDD.P33.pSD vout1.$1226.Metal3 0.020403f
Cred_12290 VDD.P33.pSD vout1.$1292.Metal3 0.0626504f
Cred_12291 VDD.P33.pSD vout1.P6.nSD 0.000321431f
Cred_12292 VDD.P33.pSD vout1.P6.pSD 0.0234498f
Cred_12293 VDD.P33.pSD vout1.P8.pSD 0.0203838f
Cred_12294 VDD.P33.pSD vout2.$1226.Metal3 4.20288e-05f
Cred_12295 VDD.P33.pSD vout2.$1292.Metal3 0.000131388f
Cred_12296 VDD.P33.pSD vout2.P6.nSD 6.62124e-07f
Cred_12297 VDD.P33.pSD vout2.P6.pSD 3.71367e-05f
Cred_12298 VDD.P33.pSD vout2.P8.pSD 3.2583e-05f
Cred_12299 VDD.P35.pSD vin1.$325.Metal1 0.00395628f
Cred_12300 VDD.P35.pSD vin1.$331.Metal1 0.0119074f
Cred_12301 VDD.P35.pSD vin1.$335.Metal1 0.000564352f
Cred_12302 VDD.P35.pSD vin1.$562.Metal2 0.00636728f
Cred_12303 VDD.P35.pSD vin1.$564.Metal2 0.000851131f
Cred_12304 VDD.P35.pSD vin1.$567.Metal2 0.00586015f
Cred_12305 VDD.P35.pSD vin1.$87.GatPoly 0.019104f
Cred_12306 VDD.P35.pSD vin1.$93.GatPoly 0.00529086f
Cred_12307 VDD.P35.pSD vin1.$97.GatPoly 0.019994f
Cred_12308 VDD.P35.pSD vin1.P28.GatPoly 0.000152552f
Cred_12309 VDD.P35.pSD vin1.P29.GatPoly 0.0490247f
Cred_12310 VDD.P35.pSD vin1.P30.GatPoly 0.0490247f
Cred_12311 VDD.P35.pSD vin1.P31.GatPoly 0.000152552f
Cred_12312 VDD.P35.pSD vin2.$324.Metal1 3.86797e-06f
Cred_12313 VDD.P35.pSD vin2.$330.Metal1 1.16729e-05f
Cred_12314 VDD.P35.pSD vin2.$334.Metal1 5.6091e-07f
Cred_12315 VDD.P35.pSD vin2.$561.Metal2 1.56975e-05f
Cred_12316 VDD.P35.pSD vin2.$564.Metal2 2.11244e-06f
Cred_12317 VDD.P35.pSD vin2.$566.Metal2 1.45361e-05f
Cred_12318 VDD.P35.pSD vin2.$86.GatPoly 2.27665e-05f
Cred_12319 VDD.P35.pSD vin2.$92.GatPoly 5.36423e-06f
Cred_12320 VDD.P35.pSD vin2.$96.GatPoly 2.36692e-05f
Cred_12321 VDD.P35.pSD vin2.P28.GatPoly 9.8421e-07f
Cred_12322 VDD.P35.pSD vin2.P29.GatPoly 7.54806e-05f
Cred_12323 VDD.P35.pSD vin2.P30.GatPoly 7.54806e-05f
Cred_12324 VDD.P35.pSD vin2.P31.GatPoly 9.8421e-07f
Cred_12325 VDD.P35.pSD vout1.$1292.Metal3 0.0628323f
Cred_12326 VDD.P35.pSD vout1.$1358.Metal3 0.0199875f
Cred_12327 VDD.P35.pSD vout1.P10.nSD 0.000314884f
Cred_12328 VDD.P35.pSD vout1.P10.pSD 0.0225227f
Cred_12329 VDD.P35.pSD vout1.P8.pSD 0.0216708f
Cred_12330 VDD.P35.pSD vout2.$1292.Metal3 0.000182784f
Cred_12331 VDD.P35.pSD vout2.$1358.Metal3 5.89753e-05f
Cred_12332 VDD.P35.pSD vout2.P10.nSD 9.291e-07f
Cred_12333 VDD.P35.pSD vout2.P10.pSD 5.15255e-05f
Cred_12334 VDD.P35.pSD vout2.P8.pSD 4.69611e-05f
Cred_12335 VDD.P37.pSD vin1.$107.GatPoly 0.0198862f
Cred_12336 VDD.P37.pSD vin1.$115.GatPoly 0.00977672f
Cred_12337 VDD.P37.pSD vin1.$123.GatPoly 0.00585735f
Cred_12338 VDD.P37.pSD vin1.$353.Metal1 0.00021061f
Cred_12339 VDD.P37.pSD vin1.$357.Metal1 0.0113888f
Cred_12340 VDD.P37.pSD vin1.$365.Metal1 0.00740232f
Cred_12341 VDD.P37.pSD vin1.$369.Metal1 0.00309789f
Cred_12342 VDD.P37.pSD vin1.$578.Metal2 9.25985e-05f
Cred_12343 VDD.P37.pSD vin1.$582.Metal2 0.00824363f
Cred_12344 VDD.P37.pSD vin1.$584.Metal2 0.000730764f
Cred_12345 VDD.P37.pSD vin1.$587.Metal2 0.00388903f
Cred_12346 VDD.P37.pSD vin1.P30.GatPoly 0.000151568f
Cred_12347 VDD.P37.pSD vin1.P31.GatPoly 0.0490382f
Cred_12348 VDD.P37.pSD vin1.P32.GatPoly 0.0521907f
Cred_12349 VDD.P37.pSD vin1.P33.GatPoly 0.000151568f
Cred_12350 VDD.P37.pSD vout1.$1292.Metal3 0.0200342f
Cred_12351 VDD.P37.pSD vout1.$1358.Metal3 0.0620804f
Cred_12352 VDD.P37.pSD vout1.P10.nSD 0.00031562f
Cred_12353 VDD.P37.pSD vout1.P10.pSD 0.0234523f
Cred_12354 VDD.P37.pSD vout1.P12.pSD 0.0207902f
Cred_12355 VDD.P39.pSD vin1.$127.GatPoly 0.0199234f
Cred_12356 VDD.P39.pSD vin1.$135.GatPoly 0.00484083f
Cred_12357 VDD.P39.pSD vin1.$137.GatPoly 0.0193685f
Cred_12358 VDD.P39.pSD vin1.$379.Metal1 9.10422e-06f
Cred_12359 VDD.P39.pSD vin1.$383.Metal1 0.00017056f
Cred_12360 VDD.P39.pSD vin1.$387.Metal1 0.0108061f
Cred_12361 VDD.P39.pSD vin1.$393.Metal1 0.00571355f
Cred_12362 VDD.P39.pSD vin1.$593.Metal2 0.000248069f
Cred_12363 VDD.P39.pSD vin1.$596.Metal2 0.000757655f
Cred_12364 VDD.P39.pSD vin1.$599.Metal2 4.24592e-06f
Cred_12365 VDD.P39.pSD vin1.$603.Metal2 0.0106386f
Cred_12366 VDD.P39.pSD vin1.$604.Metal2 0.000111809f
Cred_12367 VDD.P39.pSD vin1.$609.Metal2 0.00107453f
Cred_12368 VDD.P39.pSD vin1.$613.Metal2 0.000248069f
Cred_12369 VDD.P39.pSD vin1.P32.GatPoly 0.000151708f
Cred_12370 VDD.P39.pSD vin1.P33.GatPoly 0.0489827f
Cred_12371 VDD.P39.pSD vin1.P34.GatPoly 0.0489024f
Cred_12372 VDD.P39.pSD vin1.P35.GatPoly 0.000151708f
Cred_12373 VDD.P39.pSD vin2.$126.GatPoly 3.34634e-06f
Cred_12374 VDD.P39.pSD vin2.$134.GatPoly 7.02023e-07f
Cred_12375 VDD.P39.pSD vin2.$136.GatPoly 3.26638e-06f
Cred_12376 VDD.P39.pSD vin2.$378.Metal1 3.20941e-09f
Cred_12377 VDD.P39.pSD vin2.$382.Metal1 2.79651e-08f
Cred_12378 VDD.P39.pSD vin2.$386.Metal1 1.5056e-06f
Cred_12379 VDD.P39.pSD vin2.$392.Metal1 7.97272e-07f
Cred_12380 VDD.P39.pSD vin2.$593.Metal2 8.74491e-08f
Cred_12381 VDD.P39.pSD vin2.$595.Metal2 2.67088e-07f
Cred_12382 VDD.P39.pSD vin2.$600.Metal2 1.49677e-09f
Cred_12383 VDD.P39.pSD vin2.$601.Metal2 3.73335e-06f
Cred_12384 VDD.P39.pSD vin2.$605.Metal2 3.94148e-08f
Cred_12385 VDD.P39.pSD vin2.$608.Metal2 3.78487e-07f
Cred_12386 VDD.P39.pSD vin2.$613.Metal2 8.74491e-08f
Cred_12387 VDD.P39.pSD vin2.P32.GatPoly 1.39494e-07f
Cred_12388 VDD.P39.pSD vin2.P33.GatPoly 1.07021e-05f
Cred_12389 VDD.P39.pSD vin2.P34.GatPoly 1.06877e-05f
Cred_12390 VDD.P39.pSD vin2.P35.GatPoly 1.39494e-07f
Cred_12391 VDD.P39.pSD vout1.$1358.Metal3 0.0621255f
Cred_12392 VDD.P39.pSD vout1.$1424.Metal3 0.0200147f
Cred_12393 VDD.P39.pSD vout1.P12.pSD 0.0217496f
Cred_12394 VDD.P39.pSD vout1.P14.nSD 0.000315314f
Cred_12395 VDD.P39.pSD vout1.P14.pSD 0.0225277f
Cred_12396 VDD.P39.pSD vout2.$1358.Metal3 2.58086e-05f
Cred_12397 VDD.P39.pSD vout2.$1424.Metal3 8.36688e-06f
Cred_12398 VDD.P39.pSD vout2.P12.pSD 6.75391e-06f
Cred_12399 VDD.P39.pSD vout2.P14.nSD 1.31812e-07f
Cred_12400 VDD.P39.pSD vout2.P14.pSD 7.31375e-06f
Cred_12401 VDD.P4.GatPoly vin3.$203.Metal1 0.016755f
Cred_12402 VDD.P4.GatPoly vin3.$477.Metal2 0.00210703f
Cred_12403 VDD.P4.GatPoly vin3.$480.Metal2 0.00427619f
Cred_12404 VDD.P4.GatPoly vin3.$9.GatPoly 0.00305381f
Cred_12405 VDD.P4.GatPoly vin3.P20.GatPoly 0.0706836f
Cred_12406 VDD.P4.GatPoly vin3.P21.GatPoly 0.00596583f
Cred_12407 VDD.P4.GatPoly vin3.P22.GatPoly 0.00328573f
Cred_12408 VDD.P4.GatPoly vin3.P23.GatPoly 0.00227743f
Cred_12409 VDD.P4.GatPoly vin3.P24.GatPoly 0.00160627f
Cred_12410 VDD.P4.GatPoly vin3.P25.GatPoly 0.00130082f
Cred_12411 VDD.P4.GatPoly vout3.$1226.Metal3 0.000869187f
Cred_12412 VDD.P4.GatPoly vout3.P0.nSD 2.58816e-05f
Cred_12413 VDD.P4.GatPoly vout3.P0.pSD 0.000241362f
Cred_12414 VDD.P4.GatPoly vout3.P2.nSD 1.36932e-05f
Cred_12415 VDD.P4.GatPoly vout3.P2.pSD 7.48366e-05f
Cred_12416 VDD.P4.GatPoly VSS.P4.GatPoly 0.00261825f
Cred_12417 VDD.P41.pSD vin1.$145.GatPoly 0.00376383f
Cred_12418 VDD.P41.pSD vin1.$153.GatPoly 0.011247f
Cred_12419 VDD.P41.pSD vin1.$157.GatPoly 0.0204585f
Cred_12420 VDD.P41.pSD vin1.$409.Metal1 0.00199065f
Cred_12421 VDD.P41.pSD vin1.$413.Metal1 0.00586999f
Cred_12422 VDD.P41.pSD vin1.$419.Metal1 0.0117577f
Cred_12423 VDD.P41.pSD vin1.$423.Metal1 0.00270362f
Cred_12424 VDD.P41.pSD vin1.$620.Metal2 0.00456037f
Cred_12425 VDD.P41.pSD vin1.$622.Metal2 0.000766832f
Cred_12426 VDD.P41.pSD vin1.$625.Metal2 0.00787471f
Cred_12427 VDD.P41.pSD vin1.P34.GatPoly 0.000152403f
Cred_12428 VDD.P41.pSD vin1.P35.GatPoly 0.0520434f
Cred_12429 VDD.P41.pSD vin1.P36.GatPoly 0.0490831f
Cred_12430 VDD.P41.pSD vin1.P37.GatPoly 0.000152403f
Cred_12431 VDD.P41.pSD vin2.$144.GatPoly 3.80925e-06f
Cred_12432 VDD.P41.pSD vin2.$152.GatPoly 1.06797e-05f
Cred_12433 VDD.P41.pSD vin2.$156.GatPoly 2.04814e-05f
Cred_12434 VDD.P41.pSD vin2.$408.Metal1 2.01467e-06f
Cred_12435 VDD.P41.pSD vin2.$412.Metal1 5.51615e-06f
Cred_12436 VDD.P41.pSD vin2.$418.Metal1 9.79792e-06f
Cred_12437 VDD.P41.pSD vin2.$422.Metal1 2.25972e-06f
Cred_12438 VDD.P41.pSD vin2.$619.Metal2 9.54785e-06f
Cred_12439 VDD.P41.pSD vin2.$622.Metal2 1.61549e-06f
Cred_12440 VDD.P41.pSD vin2.$624.Metal2 1.65714e-05f
Cred_12441 VDD.P41.pSD vin2.P34.GatPoly 8.35102e-07f
Cred_12442 VDD.P41.pSD vin2.P35.GatPoly 6.7112e-05f
Cred_12443 VDD.P41.pSD vin2.P36.GatPoly 6.41201e-05f
Cred_12444 VDD.P41.pSD vin2.P37.GatPoly 8.35102e-07f
Cred_12445 VDD.P41.pSD vout1.$1358.Metal3 0.0200835f
Cred_12446 VDD.P41.pSD vout1.$1424.Metal3 0.0623982f
Cred_12447 VDD.P41.pSD vout1.P14.nSD 0.000316397f
Cred_12448 VDD.P41.pSD vout1.P14.pSD 0.0234968f
Cred_12449 VDD.P41.pSD vout1.P16.pSD 0.0208397f
Cred_12450 VDD.P41.pSD vout2.$1358.Metal3 4.96308e-05f
Cred_12451 VDD.P41.pSD vout2.$1424.Metal3 0.00015534f
Cred_12452 VDD.P41.pSD vout2.P14.nSD 7.81887e-07f
Cred_12453 VDD.P41.pSD vout2.P14.pSD 4.46454e-05f
Cred_12454 VDD.P41.pSD vout2.P16.pSD 3.95219e-05f
Cred_12455 VDD.P43.pSD vin1.$167.GatPoly 0.0191806f
Cred_12456 VDD.P43.pSD vin1.$173.GatPoly 0.00480338f
Cred_12457 VDD.P43.pSD vin1.$179.GatPoly 0.0172362f
Cred_12458 VDD.P43.pSD vin1.$441.Metal1 0.00183771f
Cred_12459 VDD.P43.pSD vin1.$449.Metal1 0.0117425f
Cred_12460 VDD.P43.pSD vin1.$453.Metal1 0.00517618f
Cred_12461 VDD.P43.pSD vin1.$636.Metal2 4.50267e-06f
Cred_12462 VDD.P43.pSD vin1.$640.Metal2 0.00683498f
Cred_12463 VDD.P43.pSD vin1.$642.Metal2 0.000839497f
Cred_12464 VDD.P43.pSD vin1.$645.Metal2 0.00542706f
Cred_12465 VDD.P43.pSD vin1.P36.GatPoly 0.000152531f
Cred_12466 VDD.P43.pSD vin1.P37.GatPoly 0.0489685f
Cred_12467 VDD.P43.pSD vin1.P38.GatPoly 0.0501226f
Cred_12468 VDD.P43.pSD vin1.P39.GatPoly 0.000166635f
Cred_12469 VDD.P43.pSD vin2.$166.GatPoly 2.2356e-05f
Cred_12470 VDD.P43.pSD vin2.$172.GatPoly 4.72178e-06f
Cred_12471 VDD.P43.pSD vin2.$178.GatPoly 2.03989e-05f
Cred_12472 VDD.P43.pSD vin2.$440.Metal1 1.75847e-06f
Cred_12473 VDD.P43.pSD vin2.$448.Metal1 1.12984e-05f
Cred_12474 VDD.P43.pSD vin2.$452.Metal1 4.99616e-06f
Cred_12475 VDD.P43.pSD vin2.$635.Metal2 4.30854e-09f
Cred_12476 VDD.P43.pSD vin2.$639.Metal2 1.65375e-05f
Cred_12477 VDD.P43.pSD vin2.$642.Metal2 2.03932e-06f
Cred_12478 VDD.P43.pSD vin2.$644.Metal2 1.3156e-05f
Cred_12479 VDD.P43.pSD vin2.P36.GatPoly 9.63259e-07f
Cred_12480 VDD.P43.pSD vin2.P37.GatPoly 7.39737e-05f
Cred_12481 VDD.P43.pSD vin2.P38.GatPoly 7.50347e-05f
Cred_12482 VDD.P43.pSD vin2.P39.GatPoly 1.0621e-06f
Cred_12483 VDD.P43.pSD vout1 0.00661564f
Cred_12484 VDD.P43.pSD vout1.$1424.Metal3 0.0749862f
Cred_12485 VDD.P43.pSD vout1.P16.pSD 0.0212594f
Cred_12486 VDD.P43.pSD vout1.P18.nSD 0.000525648f
Cred_12487 VDD.P43.pSD vout1.P18.pSD 0.0253849f
Cred_12488 VDD.P43.pSD vout2 1.87647e-05f
Cred_12489 VDD.P43.pSD vout2.$1424.Metal3 0.000214536f
Cred_12490 VDD.P43.pSD vout2.P16.pSD 4.60848e-05f
Cred_12491 VDD.P43.pSD vout2.P18.nSD 1.49096e-06f
Cred_12492 VDD.P43.pSD vout2.P18.pSD 5.63861e-05f
Cred_12493 VDD.P45.pSD vin1.$179.GatPoly 0.000135802f
Cred_12494 VDD.P45.pSD vin1.$457.Metal1 0.00119639f
Cred_12495 VDD.P45.pSD vin1.$649.Metal2 2.53316e-05f
Cred_12496 VDD.P45.pSD vin1.$654.Metal2 0.000125681f
Cred_12497 VDD.P45.pSD vin1.P39.GatPoly 0.00224922f
Cred_12498 VDD.P45.pSD vout1 0.000512144f
Cred_12499 VDD.P45.pSD vout1.$1424.Metal3 0.00258299f
Cred_12500 VDD.P45.pSD vout1.P18.nSD 4.06925e-05f
Cred_12501 VDD.P45.pSD vout1.P18.pSD 0.00104255f
Cred_12502 VDD.P45.pSD VSS.$1989.Metal1 1.31788e-05f
Cred_12503 VDD.P45.pSD VSS.$2020.Metal1 3.93313e-05f
Cred_12504 VDD.P45.pSD VSS.$29.Metal1 3.22977e-08f
Cred_12505 VDD.P45.pSD VSS.$4227.Metal2 0.000108001f
Cred_12506 VDD.P45.pSD VSS.P1.pSD 0.000126844f
Cred_12507 VDD.P45.pSD VSS.P45.nSD 2.67507e-08f
Cred_12508 VDD.P45.pSD VSS.P47.nSD 2.67507e-08f
Cred_12509 VDD.P47.pSD vin1.$179.GatPoly 0.000135802f
Cred_12510 VDD.P47.pSD vin1.$457.Metal1 0.00119639f
Cred_12511 VDD.P47.pSD vin1.$649.Metal2 2.53316e-05f
Cred_12512 VDD.P47.pSD vin1.$654.Metal2 0.000125681f
Cred_12513 VDD.P47.pSD vin1.P39.GatPoly 0.00216426f
Cred_12514 VDD.P47.pSD vout1 0.000193458f
Cred_12515 VDD.P47.pSD vout1.$1424.Metal3 0.000975702f
Cred_12516 VDD.P47.pSD vout1.P18.nSD 1.53713e-05f
Cred_12517 VDD.P47.pSD vout1.P18.pSD 0.000891166f
Cred_12518 VDD.P47.pSD VSS.$1989.Metal1 1.31788e-05f
Cred_12519 VDD.P47.pSD VSS.$2020.Metal1 3.93313e-05f
Cred_12520 VDD.P47.pSD VSS.$29.Metal1 3.22977e-08f
Cred_12521 VDD.P47.pSD VSS.$4227.Metal2 0.000108001f
Cred_12522 VDD.P47.pSD VSS.P1.pSD 0.000126844f
Cred_12523 VDD.P47.pSD VSS.P45.nSD 2.67507e-08f
Cred_12524 VDD.P47.pSD VSS.P47.nSD 2.67507e-08f
Cred_12525 VDD.P48.pSD vin3.$203.Metal1 0.00120842f
Cred_12526 VDD.P48.pSD vin3.$477.Metal2 0.00012184f
Cred_12527 VDD.P48.pSD vin3.$480.Metal2 0.000252397f
Cred_12528 VDD.P48.pSD vin3.$9.GatPoly 0.000136019f
Cred_12529 VDD.P48.pSD vin3.P20.GatPoly 0.00216443f
Cred_12530 VDD.P48.pSD vout3.$1226.Metal3 0.000879733f
Cred_12531 VDD.P48.pSD vout3.P0.nSD 2.61957e-05f
Cred_12532 VDD.P48.pSD vout3.P0.pSD 0.000972022f
Cred_12533 VDD.P48.pSD vout3.P2.nSD 1.38594e-05f
Cred_12534 VDD.P48.pSD vout3.P2.pSD 7.57446e-05f
Cred_12535 VDD.P48.pSD VSS.$1990.Metal1 2.36489e-08f
Cred_12536 VDD.P48.pSD VSS.$4358.Metal3 1.3906e-05f
Cred_12537 VDD.P48.pSD VSS.$68.Metal1 3.41733e-05f
Cred_12538 VDD.P48.pSD VSS.P2.pSD 0.000132912f
Cred_12539 VDD.P49.pSD vin3.$203.Metal1 0.00128534f
Cred_12540 VDD.P49.pSD vin3.$477.Metal2 0.000788016f
Cred_12541 VDD.P49.pSD vin3.$480.Metal2 0.00149414f
Cred_12542 VDD.P49.pSD vin3.$9.GatPoly 0.000137421f
Cred_12543 VDD.P49.pSD vin3.P20.GatPoly 0.0022505f
Cred_12544 VDD.P49.pSD vout3.$1226.Metal3 0.000891764f
Cred_12545 VDD.P49.pSD vout3.P0.nSD 2.65539e-05f
Cred_12546 VDD.P49.pSD vout3.P0.pSD 0.000988748f
Cred_12547 VDD.P49.pSD vout3.P2.nSD 1.40489e-05f
Cred_12548 VDD.P49.pSD vout3.P2.pSD 7.67805e-05f
Cred_12549 VDD.P49.pSD VSS.$1990.Metal1 2.36489e-08f
Cred_12550 VDD.P49.pSD VSS.$4358.Metal3 1.3906e-05f
Cred_12551 VDD.P49.pSD VSS.$68.Metal1 3.41733e-05f
Cred_12552 VDD.P49.pSD VSS.P2.pSD 0.000132912f
Cred_12553 VDD.P5.GatPoly vin3.$179.GatPoly 0.0030499f
Cred_12554 VDD.P5.GatPoly vin3.$457.Metal1 0.0165391f
Cred_12555 VDD.P5.GatPoly vin3.$649.Metal2 0.000349285f
Cred_12556 VDD.P5.GatPoly vin3.$654.Metal2 0.00168599f
Cred_12557 VDD.P5.GatPoly vin3.P34.GatPoly 0.00130082f
Cred_12558 VDD.P5.GatPoly vin3.P35.GatPoly 0.00160627f
Cred_12559 VDD.P5.GatPoly vin3.P36.GatPoly 0.00227743f
Cred_12560 VDD.P5.GatPoly vin3.P37.GatPoly 0.00328573f
Cred_12561 VDD.P5.GatPoly vin3.P38.GatPoly 0.00596583f
Cred_12562 VDD.P5.GatPoly vin3.P39.GatPoly 0.0706805f
Cred_12563 VDD.P5.GatPoly vout3 0.000613058f
Cred_12564 VDD.P5.GatPoly vout3.$1424.Metal3 0.00309194f
Cred_12565 VDD.P5.GatPoly vout3.P18.nSD 4.87107e-05f
Cred_12566 VDD.P5.GatPoly vout3.P18.pSD 0.000338518f
Cred_12567 VDD.P5.GatPoly VSS.P5.GatPoly 0.00217316f
Cred_12568 VDD.P5.pSD vin3.$237.Metal1 2.25972e-06f
Cred_12569 VDD.P5.pSD vin3.$241.Metal1 9.79792e-06f
Cred_12570 VDD.P5.pSD vin3.$247.Metal1 5.51615e-06f
Cred_12571 VDD.P5.pSD vin3.$25.GatPoly 2.04814e-05f
Cred_12572 VDD.P5.pSD vin3.$251.Metal1 2.01467e-06f
Cred_12573 VDD.P5.pSD vin3.$37.GatPoly 1.06797e-05f
Cred_12574 VDD.P5.pSD vin3.$43.GatPoly 3.80925e-06f
Cred_12575 VDD.P5.pSD vin3.$504.Metal2 1.65714e-05f
Cred_12576 VDD.P5.pSD vin3.$506.Metal2 1.61549e-06f
Cred_12577 VDD.P5.pSD vin3.$509.Metal2 9.54785e-06f
Cred_12578 VDD.P5.pSD vin3.P22.GatPoly 8.35102e-07f
Cred_12579 VDD.P5.pSD vin3.P23.GatPoly 6.41201e-05f
Cred_12580 VDD.P5.pSD vin3.P24.GatPoly 6.7112e-05f
Cred_12581 VDD.P5.pSD vin3.P25.GatPoly 8.35102e-07f
Cred_12582 VDD.P5.pSD vin4.$236.Metal1 0.00270362f
Cred_12583 VDD.P5.pSD vin4.$24.GatPoly 0.0204585f
Cred_12584 VDD.P5.pSD vin4.$240.Metal1 0.0117577f
Cred_12585 VDD.P5.pSD vin4.$246.Metal1 0.00586999f
Cred_12586 VDD.P5.pSD vin4.$250.Metal1 0.00199065f
Cred_12587 VDD.P5.pSD vin4.$36.GatPoly 0.011247f
Cred_12588 VDD.P5.pSD vin4.$42.GatPoly 0.00376383f
Cred_12589 VDD.P5.pSD vin4.$503.Metal2 0.00787471f
Cred_12590 VDD.P5.pSD vin4.$506.Metal2 0.000766832f
Cred_12591 VDD.P5.pSD vin4.$508.Metal2 0.00456037f
Cred_12592 VDD.P5.pSD vin4.P22.GatPoly 0.000152403f
Cred_12593 VDD.P5.pSD vin4.P23.GatPoly 0.0490831f
Cred_12594 VDD.P5.pSD vin4.P24.GatPoly 0.0520434f
Cred_12595 VDD.P5.pSD vin4.P25.GatPoly 0.000152403f
Cred_12596 VDD.P5.pSD vout3.$1226.Metal3 0.000197222f
Cred_12597 VDD.P5.pSD vout3.P0.nSD 1.29954e-06f
Cred_12598 VDD.P5.pSD vout3.P0.pSD 6.90552e-06f
Cred_12599 VDD.P5.pSD vout3.P2.nSD 1.41373e-06f
Cred_12600 VDD.P5.pSD vout3.P2.pSD 4.67235e-05f
Cred_12601 VDD.P5.pSD vout3.P4.pSD 3.96739e-05f
Cred_12602 VDD.P5.pSD vout4.$1226.Metal3 0.0791415f
Cred_12603 VDD.P5.pSD vout4.P0.nSD 0.000518669f
Cred_12604 VDD.P5.pSD vout4.P0.pSD 0.00275612f
Cred_12605 VDD.P5.pSD vout4.P2.nSD 0.000564244f
Cred_12606 VDD.P5.pSD vout4.P2.pSD 0.0237439f
Cred_12607 VDD.P5.pSD vout4.P4.pSD 0.0214331f
Cred_12608 VDD.P51.pSD vin3.$15.GatPoly 0.0191806f
Cred_12609 VDD.P51.pSD vin3.$17.GatPoly 0.00472678f
Cred_12610 VDD.P51.pSD vin3.$207.Metal1 0.00517618f
Cred_12611 VDD.P51.pSD vin3.$211.Metal1 0.0117425f
Cred_12612 VDD.P51.pSD vin3.$219.Metal1 0.00183771f
Cred_12613 VDD.P51.pSD vin3.$484.Metal2 0.00542706f
Cred_12614 VDD.P51.pSD vin3.$486.Metal2 0.000839497f
Cred_12615 VDD.P51.pSD vin3.$489.Metal2 0.00683498f
Cred_12616 VDD.P51.pSD vin3.$493.Metal2 4.50267e-06f
Cred_12617 VDD.P51.pSD vin3.$9.GatPoly 0.0172362f
Cred_12618 VDD.P51.pSD vin3.P20.GatPoly 0.000166635f
Cred_12619 VDD.P51.pSD vin3.P21.GatPoly 0.0499743f
Cred_12620 VDD.P51.pSD vin3.P22.GatPoly 0.0491168f
Cred_12621 VDD.P51.pSD vin3.P23.GatPoly 0.000152531f
Cred_12622 VDD.P51.pSD vin4.$14.GatPoly 2.2356e-05f
Cred_12623 VDD.P51.pSD vin4.$16.GatPoly 4.64848e-06f
Cred_12624 VDD.P51.pSD vin4.$206.Metal1 4.99616e-06f
Cred_12625 VDD.P51.pSD vin4.$210.Metal1 1.12984e-05f
Cred_12626 VDD.P51.pSD vin4.$218.Metal1 1.75847e-06f
Cred_12627 VDD.P51.pSD vin4.$483.Metal2 1.3156e-05f
Cred_12628 VDD.P51.pSD vin4.$486.Metal2 2.03932e-06f
Cred_12629 VDD.P51.pSD vin4.$488.Metal2 1.65375e-05f
Cred_12630 VDD.P51.pSD vin4.$492.Metal2 4.30854e-09f
Cred_12631 VDD.P51.pSD vin4.$8.GatPoly 2.03989e-05f
Cred_12632 VDD.P51.pSD vin4.P20.GatPoly 1.0621e-06f
Cred_12633 VDD.P51.pSD vin4.P21.GatPoly 7.5202e-05f
Cred_12634 VDD.P51.pSD vin4.P22.GatPoly 7.38063e-05f
Cred_12635 VDD.P51.pSD vin4.P23.GatPoly 9.63259e-07f
Cred_12636 VDD.P51.pSD vout3.$1226.Metal3 0.068627f
Cred_12637 VDD.P51.pSD vout3.P0.nSD 0.00151626f
Cred_12638 VDD.P51.pSD vout3.P0.pSD 0.0320644f
Cred_12639 VDD.P51.pSD vout3.P2.nSD 0.00108115f
Cred_12640 VDD.P51.pSD vout3.P2.pSD 0.0264428f
Cred_12641 VDD.P51.pSD vout4.$1226.Metal3 0.000196408f
Cred_12642 VDD.P51.pSD vout4.P0.nSD 4.34149e-06f
Cred_12643 VDD.P51.pSD vout4.P0.pSD 7.50082e-05f
Cred_12644 VDD.P51.pSD vout4.P2.nSD 3.09422e-06f
Cred_12645 VDD.P51.pSD vout4.P2.pSD 6.18744e-05f
Cred_12646 VDD.P53.pSD vin3.$237.Metal1 0.00270362f
Cred_12647 VDD.P53.pSD vin3.$241.Metal1 0.0117577f
Cred_12648 VDD.P53.pSD vin3.$247.Metal1 0.00586999f
Cred_12649 VDD.P53.pSD vin3.$25.GatPoly 0.0204585f
Cred_12650 VDD.P53.pSD vin3.$251.Metal1 0.00199065f
Cred_12651 VDD.P53.pSD vin3.$37.GatPoly 0.011247f
Cred_12652 VDD.P53.pSD vin3.$43.GatPoly 0.00376383f
Cred_12653 VDD.P53.pSD vin3.$504.Metal2 0.00787471f
Cred_12654 VDD.P53.pSD vin3.$506.Metal2 0.000766832f
Cred_12655 VDD.P53.pSD vin3.$509.Metal2 0.00456037f
Cred_12656 VDD.P53.pSD vin3.P22.GatPoly 0.000152403f
Cred_12657 VDD.P53.pSD vin3.P23.GatPoly 0.0490831f
Cred_12658 VDD.P53.pSD vin3.P24.GatPoly 0.0520434f
Cred_12659 VDD.P53.pSD vin3.P25.GatPoly 0.000152403f
Cred_12660 VDD.P53.pSD vin4.$236.Metal1 2.25972e-06f
Cred_12661 VDD.P53.pSD vin4.$24.GatPoly 2.04814e-05f
Cred_12662 VDD.P53.pSD vin4.$240.Metal1 9.79792e-06f
Cred_12663 VDD.P53.pSD vin4.$246.Metal1 5.51615e-06f
Cred_12664 VDD.P53.pSD vin4.$250.Metal1 2.01467e-06f
Cred_12665 VDD.P53.pSD vin4.$36.GatPoly 1.06797e-05f
Cred_12666 VDD.P53.pSD vin4.$42.GatPoly 3.80925e-06f
Cred_12667 VDD.P53.pSD vin4.$503.Metal2 1.65714e-05f
Cred_12668 VDD.P53.pSD vin4.$506.Metal2 1.61549e-06f
Cred_12669 VDD.P53.pSD vin4.$508.Metal2 9.54785e-06f
Cred_12670 VDD.P53.pSD vin4.P22.GatPoly 8.35102e-07f
Cred_12671 VDD.P53.pSD vin4.P23.GatPoly 6.41201e-05f
Cred_12672 VDD.P53.pSD vin4.P24.GatPoly 6.7112e-05f
Cred_12673 VDD.P53.pSD vin4.P25.GatPoly 8.35102e-07f
Cred_12674 VDD.P53.pSD vout3.$1226.Metal3 0.0791437f
Cred_12675 VDD.P53.pSD vout3.P0.nSD 0.00051576f
Cred_12676 VDD.P53.pSD vout3.P0.pSD 0.00274066f
Cred_12677 VDD.P53.pSD vout3.P2.nSD 0.00056108f
Cred_12678 VDD.P53.pSD vout3.P2.pSD 0.0236853f
Cred_12679 VDD.P53.pSD vout3.P4.pSD 0.0214699f
Cred_12680 VDD.P53.pSD vout4.$1226.Metal3 0.000197453f
Cred_12681 VDD.P53.pSD vout4.P0.nSD 1.29918e-06f
Cred_12682 VDD.P53.pSD vout4.P0.pSD 6.90362e-06f
Cred_12683 VDD.P53.pSD vout4.P2.nSD 1.41334e-06f
Cred_12684 VDD.P53.pSD vout4.P2.pSD 4.6631e-05f
Cred_12685 VDD.P53.pSD vout4.P4.pSD 3.98032e-05f
Cred_12686 VDD.P55.pSD vin3.$265.Metal1 0.00571275f
Cred_12687 VDD.P55.pSD vin3.$273.Metal1 0.0108046f
Cred_12688 VDD.P55.pSD vin3.$277.Metal1 0.000170532f
Cred_12689 VDD.P55.pSD vin3.$281.Metal1 9.10101e-06f
Cred_12690 VDD.P55.pSD vin3.$47.GatPoly 0.0193653f
Cred_12691 VDD.P55.pSD vin3.$515.Metal2 0.000247982f
Cred_12692 VDD.P55.pSD vin3.$520.Metal2 0.00107416f
Cred_12693 VDD.P55.pSD vin3.$523.Metal2 0.00011177f
Cred_12694 VDD.P55.pSD vin3.$527.Metal2 0.0106348f
Cred_12695 VDD.P55.pSD vin3.$528.Metal2 4.24442e-06f
Cred_12696 VDD.P55.pSD vin3.$53.GatPoly 0.00484013f
Cred_12697 VDD.P55.pSD vin3.$533.Metal2 0.000757388f
Cred_12698 VDD.P55.pSD vin3.$535.Metal2 0.000247982f
Cred_12699 VDD.P55.pSD vin3.$57.GatPoly 0.01992f
Cred_12700 VDD.P55.pSD vin3.P24.GatPoly 0.000151568f
Cred_12701 VDD.P55.pSD vin3.P25.GatPoly 0.0488917f
Cred_12702 VDD.P55.pSD vin3.P26.GatPoly 0.048972f
Cred_12703 VDD.P55.pSD vin3.P27.GatPoly 0.000151568f
Cred_12704 VDD.P55.pSD vout3.$1226.Metal3 0.0628666f
Cred_12705 VDD.P55.pSD vout3.$1292.Metal3 0.0200973f
Cred_12706 VDD.P55.pSD vout3.P4.pSD 0.0216543f
Cred_12707 VDD.P55.pSD vout3.P6.nSD 0.000316614f
Cred_12708 VDD.P55.pSD vout3.P6.pSD 0.0220944f
Cred_12709 VDD.P57.pSD vin3.$291.Metal1 0.00310052f
Cred_12710 VDD.P57.pSD vin3.$295.Metal1 0.00740785f
Cred_12711 VDD.P57.pSD vin3.$303.Metal1 0.0113968f
Cred_12712 VDD.P57.pSD vin3.$307.Metal1 0.000210762f
Cred_12713 VDD.P57.pSD vin3.$542.Metal2 0.00389589f
Cred_12714 VDD.P57.pSD vin3.$544.Metal2 0.000732061f
Cred_12715 VDD.P57.pSD vin3.$547.Metal2 0.00825822f
Cred_12716 VDD.P57.pSD vin3.$551.Metal2 9.27628e-05f
Cred_12717 VDD.P57.pSD vin3.$65.GatPoly 0.00586233f
Cred_12718 VDD.P57.pSD vin3.$73.GatPoly 0.00978438f
Cred_12719 VDD.P57.pSD vin3.$77.GatPoly 0.019903f
Cred_12720 VDD.P57.pSD vin3.P26.GatPoly 0.00015227f
Cred_12721 VDD.P57.pSD vin3.P27.GatPoly 0.0522473f
Cred_12722 VDD.P57.pSD vin3.P28.GatPoly 0.0490921f
Cred_12723 VDD.P57.pSD vin3.P29.GatPoly 0.00015227f
Cred_12724 VDD.P57.pSD vin4.$290.Metal1 2.63615e-06f
Cred_12725 VDD.P57.pSD vin4.$294.Metal1 5.53399e-06f
Cred_12726 VDD.P57.pSD vin4.$302.Metal1 7.96451e-06f
Cred_12727 VDD.P57.pSD vin4.$306.Metal1 1.52164e-07f
Cred_12728 VDD.P57.pSD vin4.$541.Metal2 6.8538e-06f
Cred_12729 VDD.P57.pSD vin4.$544.Metal2 1.29699e-06f
Cred_12730 VDD.P57.pSD vin4.$546.Metal2 1.45835e-05f
Cred_12731 VDD.P57.pSD vin4.$550.Metal2 1.64347e-07f
Cred_12732 VDD.P57.pSD vin4.$64.GatPoly 4.98432e-06f
Cred_12733 VDD.P57.pSD vin4.$72.GatPoly 7.65648e-06f
Cred_12734 VDD.P57.pSD vin4.$76.GatPoly 1.68172e-05f
Cred_12735 VDD.P57.pSD vin4.P26.GatPoly 7.02069e-07f
Cred_12736 VDD.P57.pSD vin4.P27.GatPoly 5.66025e-05f
Cred_12737 VDD.P57.pSD vin4.P28.GatPoly 5.3923e-05f
Cred_12738 VDD.P57.pSD vin4.P29.GatPoly 7.02069e-07f
Cred_12739 VDD.P57.pSD vout3.$1226.Metal3 0.020403f
Cred_12740 VDD.P57.pSD vout3.$1292.Metal3 0.0626504f
Cred_12741 VDD.P57.pSD vout3.P6.nSD 0.000321431f
Cred_12742 VDD.P57.pSD vout3.P6.pSD 0.0234498f
Cred_12743 VDD.P57.pSD vout3.P8.pSD 0.0203838f
Cred_12744 VDD.P57.pSD vout4.$1226.Metal3 4.20288e-05f
Cred_12745 VDD.P57.pSD vout4.$1292.Metal3 0.000131388f
Cred_12746 VDD.P57.pSD vout4.P6.nSD 6.62124e-07f
Cred_12747 VDD.P57.pSD vout4.P6.pSD 3.71367e-05f
Cred_12748 VDD.P57.pSD vout4.P8.pSD 3.2583e-05f
Cred_12749 VDD.P59.pSD vin3.$325.Metal1 0.00395628f
Cred_12750 VDD.P59.pSD vin3.$331.Metal1 0.0119074f
Cred_12751 VDD.P59.pSD vin3.$335.Metal1 0.000564352f
Cred_12752 VDD.P59.pSD vin3.$562.Metal2 0.00592481f
Cred_12753 VDD.P59.pSD vin3.$564.Metal2 0.000851131f
Cred_12754 VDD.P59.pSD vin3.$567.Metal2 0.00630261f
Cred_12755 VDD.P59.pSD vin3.$87.GatPoly 0.019104f
Cred_12756 VDD.P59.pSD vin3.$93.GatPoly 0.00529086f
Cred_12757 VDD.P59.pSD vin3.$97.GatPoly 0.019994f
Cred_12758 VDD.P59.pSD vin3.P28.GatPoly 0.000152552f
Cred_12759 VDD.P59.pSD vin3.P29.GatPoly 0.0490247f
Cred_12760 VDD.P59.pSD vin3.P30.GatPoly 0.0490247f
Cred_12761 VDD.P59.pSD vin3.P31.GatPoly 0.000152552f
Cred_12762 VDD.P59.pSD vin4.$324.Metal1 3.86797e-06f
Cred_12763 VDD.P59.pSD vin4.$330.Metal1 1.16729e-05f
Cred_12764 VDD.P59.pSD vin4.$334.Metal1 5.6091e-07f
Cred_12765 VDD.P59.pSD vin4.$561.Metal2 1.56975e-05f
Cred_12766 VDD.P59.pSD vin4.$564.Metal2 2.11244e-06f
Cred_12767 VDD.P59.pSD vin4.$566.Metal2 1.45361e-05f
Cred_12768 VDD.P59.pSD vin4.$86.GatPoly 2.27665e-05f
Cred_12769 VDD.P59.pSD vin4.$92.GatPoly 5.36423e-06f
Cred_12770 VDD.P59.pSD vin4.$96.GatPoly 2.36692e-05f
Cred_12771 VDD.P59.pSD vin4.P28.GatPoly 9.8421e-07f
Cred_12772 VDD.P59.pSD vin4.P29.GatPoly 7.54806e-05f
Cred_12773 VDD.P59.pSD vin4.P30.GatPoly 7.54806e-05f
Cred_12774 VDD.P59.pSD vin4.P31.GatPoly 9.8421e-07f
Cred_12775 VDD.P59.pSD vout3.$1292.Metal3 0.0628323f
Cred_12776 VDD.P59.pSD vout3.$1358.Metal3 0.0199875f
Cred_12777 VDD.P59.pSD vout3.P10.nSD 0.000314884f
Cred_12778 VDD.P59.pSD vout3.P10.pSD 0.0225227f
Cred_12779 VDD.P59.pSD vout3.P8.pSD 0.0216708f
Cred_12780 VDD.P59.pSD vout4.$1292.Metal3 0.000182784f
Cred_12781 VDD.P59.pSD vout4.$1358.Metal3 5.89753e-05f
Cred_12782 VDD.P59.pSD vout4.P10.nSD 9.291e-07f
Cred_12783 VDD.P59.pSD vout4.P10.pSD 5.15255e-05f
Cred_12784 VDD.P59.pSD vout4.P8.pSD 4.69611e-05f
Cred_12785 VDD.P6.GatPoly vin2.$202.Metal1 0.016755f
Cred_12786 VDD.P6.GatPoly vin2.$477.Metal2 0.00210703f
Cred_12787 VDD.P6.GatPoly vin2.$479.Metal2 0.00427619f
Cred_12788 VDD.P6.GatPoly vin2.$8.GatPoly 0.00305381f
Cred_12789 VDD.P6.GatPoly vin2.P20.GatPoly 0.0706836f
Cred_12790 VDD.P6.GatPoly vin2.P21.GatPoly 0.00596583f
Cred_12791 VDD.P6.GatPoly vin2.P22.GatPoly 0.00328573f
Cred_12792 VDD.P6.GatPoly vin2.P23.GatPoly 0.00227743f
Cred_12793 VDD.P6.GatPoly vin2.P24.GatPoly 0.00160627f
Cred_12794 VDD.P6.GatPoly vin2.P25.GatPoly 0.00130082f
Cred_12795 VDD.P6.GatPoly vout2.$1226.Metal3 0.000869187f
Cred_12796 VDD.P6.GatPoly vout2.P0.nSD 2.58816e-05f
Cred_12797 VDD.P6.GatPoly vout2.P0.pSD 0.000241362f
Cred_12798 VDD.P6.GatPoly vout2.P2.nSD 1.36932e-05f
Cred_12799 VDD.P6.GatPoly vout2.P2.pSD 7.48366e-05f
Cred_12800 VDD.P6.GatPoly VSS.P6.GatPoly 0.00261825f
Cred_12801 VDD.P61.pSD vin3.$107.GatPoly 0.0198862f
Cred_12802 VDD.P61.pSD vin3.$115.GatPoly 0.00977672f
Cred_12803 VDD.P61.pSD vin3.$123.GatPoly 0.00585735f
Cred_12804 VDD.P61.pSD vin3.$353.Metal1 0.00021061f
Cred_12805 VDD.P61.pSD vin3.$357.Metal1 0.0113888f
Cred_12806 VDD.P61.pSD vin3.$365.Metal1 0.00740232f
Cred_12807 VDD.P61.pSD vin3.$369.Metal1 0.00309789f
Cred_12808 VDD.P61.pSD vin3.$578.Metal2 9.25985e-05f
Cred_12809 VDD.P61.pSD vin3.$582.Metal2 0.00824363f
Cred_12810 VDD.P61.pSD vin3.$584.Metal2 0.000730764f
Cred_12811 VDD.P61.pSD vin3.$587.Metal2 0.00388903f
Cred_12812 VDD.P61.pSD vin3.P30.GatPoly 0.000151568f
Cred_12813 VDD.P61.pSD vin3.P31.GatPoly 0.0490382f
Cred_12814 VDD.P61.pSD vin3.P32.GatPoly 0.0521907f
Cred_12815 VDD.P61.pSD vin3.P33.GatPoly 0.000151568f
Cred_12816 VDD.P61.pSD vout3.$1292.Metal3 0.0200342f
Cred_12817 VDD.P61.pSD vout3.$1358.Metal3 0.0620804f
Cred_12818 VDD.P61.pSD vout3.P10.nSD 0.00031562f
Cred_12819 VDD.P61.pSD vout3.P10.pSD 0.0234523f
Cred_12820 VDD.P61.pSD vout3.P12.pSD 0.0207902f
Cred_12821 VDD.P63.pSD vin3.$127.GatPoly 0.0199234f
Cred_12822 VDD.P63.pSD vin3.$135.GatPoly 0.00484083f
Cred_12823 VDD.P63.pSD vin3.$137.GatPoly 0.0193685f
Cred_12824 VDD.P63.pSD vin3.$379.Metal1 9.10422e-06f
Cred_12825 VDD.P63.pSD vin3.$383.Metal1 0.00017056f
Cred_12826 VDD.P63.pSD vin3.$387.Metal1 0.0108061f
Cred_12827 VDD.P63.pSD vin3.$393.Metal1 0.00571355f
Cred_12828 VDD.P63.pSD vin3.$593.Metal2 0.000248069f
Cred_12829 VDD.P63.pSD vin3.$596.Metal2 0.000757655f
Cred_12830 VDD.P63.pSD vin3.$599.Metal2 4.24592e-06f
Cred_12831 VDD.P63.pSD vin3.$603.Metal2 0.0106386f
Cred_12832 VDD.P63.pSD vin3.$604.Metal2 0.000111809f
Cred_12833 VDD.P63.pSD vin3.$609.Metal2 0.00107453f
Cred_12834 VDD.P63.pSD vin3.$613.Metal2 0.000248069f
Cred_12835 VDD.P63.pSD vin3.P32.GatPoly 0.000151708f
Cred_12836 VDD.P63.pSD vin3.P33.GatPoly 0.0489827f
Cred_12837 VDD.P63.pSD vin3.P34.GatPoly 0.0489024f
Cred_12838 VDD.P63.pSD vin3.P35.GatPoly 0.000151708f
Cred_12839 VDD.P63.pSD vin4.$126.GatPoly 3.34634e-06f
Cred_12840 VDD.P63.pSD vin4.$134.GatPoly 7.02023e-07f
Cred_12841 VDD.P63.pSD vin4.$136.GatPoly 3.26638e-06f
Cred_12842 VDD.P63.pSD vin4.$378.Metal1 3.20941e-09f
Cred_12843 VDD.P63.pSD vin4.$382.Metal1 2.79651e-08f
Cred_12844 VDD.P63.pSD vin4.$386.Metal1 1.5056e-06f
Cred_12845 VDD.P63.pSD vin4.$392.Metal1 7.97272e-07f
Cred_12846 VDD.P63.pSD vin4.$593.Metal2 8.74491e-08f
Cred_12847 VDD.P63.pSD vin4.$595.Metal2 2.67088e-07f
Cred_12848 VDD.P63.pSD vin4.$600.Metal2 1.49677e-09f
Cred_12849 VDD.P63.pSD vin4.$601.Metal2 3.73335e-06f
Cred_12850 VDD.P63.pSD vin4.$605.Metal2 3.94148e-08f
Cred_12851 VDD.P63.pSD vin4.$608.Metal2 3.78487e-07f
Cred_12852 VDD.P63.pSD vin4.$613.Metal2 8.74491e-08f
Cred_12853 VDD.P63.pSD vin4.P32.GatPoly 1.39494e-07f
Cred_12854 VDD.P63.pSD vin4.P33.GatPoly 1.07021e-05f
Cred_12855 VDD.P63.pSD vin4.P34.GatPoly 1.06877e-05f
Cred_12856 VDD.P63.pSD vin4.P35.GatPoly 1.39494e-07f
Cred_12857 VDD.P63.pSD vout3.$1358.Metal3 0.0621255f
Cred_12858 VDD.P63.pSD vout3.$1424.Metal3 0.0200147f
Cred_12859 VDD.P63.pSD vout3.P12.pSD 0.0217496f
Cred_12860 VDD.P63.pSD vout3.P14.nSD 0.000315314f
Cred_12861 VDD.P63.pSD vout3.P14.pSD 0.0225277f
Cred_12862 VDD.P63.pSD vout4.$1358.Metal3 2.58086e-05f
Cred_12863 VDD.P63.pSD vout4.$1424.Metal3 8.36688e-06f
Cred_12864 VDD.P63.pSD vout4.P12.pSD 6.75391e-06f
Cred_12865 VDD.P63.pSD vout4.P14.nSD 1.31812e-07f
Cred_12866 VDD.P63.pSD vout4.P14.pSD 7.31375e-06f
Cred_12867 VDD.P65.pSD vin3.$145.GatPoly 0.00376383f
Cred_12868 VDD.P65.pSD vin3.$153.GatPoly 0.011247f
Cred_12869 VDD.P65.pSD vin3.$157.GatPoly 0.0204585f
Cred_12870 VDD.P65.pSD vin3.$409.Metal1 0.00199065f
Cred_12871 VDD.P65.pSD vin3.$413.Metal1 0.00586999f
Cred_12872 VDD.P65.pSD vin3.$419.Metal1 0.0117577f
Cred_12873 VDD.P65.pSD vin3.$423.Metal1 0.00270362f
Cred_12874 VDD.P65.pSD vin3.$620.Metal2 0.00456037f
Cred_12875 VDD.P65.pSD vin3.$622.Metal2 0.000766832f
Cred_12876 VDD.P65.pSD vin3.$625.Metal2 0.00787471f
Cred_12877 VDD.P65.pSD vin3.P34.GatPoly 0.000152403f
Cred_12878 VDD.P65.pSD vin3.P35.GatPoly 0.0520434f
Cred_12879 VDD.P65.pSD vin3.P36.GatPoly 0.0490831f
Cred_12880 VDD.P65.pSD vin3.P37.GatPoly 0.000152403f
Cred_12881 VDD.P65.pSD vin4.$144.GatPoly 3.80925e-06f
Cred_12882 VDD.P65.pSD vin4.$152.GatPoly 1.06797e-05f
Cred_12883 VDD.P65.pSD vin4.$156.GatPoly 2.04814e-05f
Cred_12884 VDD.P65.pSD vin4.$408.Metal1 2.01467e-06f
Cred_12885 VDD.P65.pSD vin4.$412.Metal1 5.51615e-06f
Cred_12886 VDD.P65.pSD vin4.$418.Metal1 9.79792e-06f
Cred_12887 VDD.P65.pSD vin4.$422.Metal1 2.25972e-06f
Cred_12888 VDD.P65.pSD vin4.$619.Metal2 9.54785e-06f
Cred_12889 VDD.P65.pSD vin4.$622.Metal2 1.61549e-06f
Cred_12890 VDD.P65.pSD vin4.$624.Metal2 1.65714e-05f
Cred_12891 VDD.P65.pSD vin4.P34.GatPoly 8.35102e-07f
Cred_12892 VDD.P65.pSD vin4.P35.GatPoly 6.7112e-05f
Cred_12893 VDD.P65.pSD vin4.P36.GatPoly 6.41201e-05f
Cred_12894 VDD.P65.pSD vin4.P37.GatPoly 8.35102e-07f
Cred_12895 VDD.P65.pSD vout3.$1358.Metal3 0.0200835f
Cred_12896 VDD.P65.pSD vout3.$1424.Metal3 0.0623982f
Cred_12897 VDD.P65.pSD vout3.P14.nSD 0.000316397f
Cred_12898 VDD.P65.pSD vout3.P14.pSD 0.0234968f
Cred_12899 VDD.P65.pSD vout3.P16.pSD 0.0208397f
Cred_12900 VDD.P65.pSD vout4.$1358.Metal3 4.96308e-05f
Cred_12901 VDD.P65.pSD vout4.$1424.Metal3 0.00015534f
Cred_12902 VDD.P65.pSD vout4.P14.nSD 7.81887e-07f
Cred_12903 VDD.P65.pSD vout4.P14.pSD 4.46454e-05f
Cred_12904 VDD.P65.pSD vout4.P16.pSD 3.95219e-05f
Cred_12905 VDD.P67.pSD vin3.$167.GatPoly 0.0191806f
Cred_12906 VDD.P67.pSD vin3.$173.GatPoly 0.00480338f
Cred_12907 VDD.P67.pSD vin3.$179.GatPoly 0.0172362f
Cred_12908 VDD.P67.pSD vin3.$441.Metal1 0.00183771f
Cred_12909 VDD.P67.pSD vin3.$449.Metal1 0.0117425f
Cred_12910 VDD.P67.pSD vin3.$453.Metal1 0.00517618f
Cred_12911 VDD.P67.pSD vin3.$636.Metal2 4.50267e-06f
Cred_12912 VDD.P67.pSD vin3.$640.Metal2 0.00683498f
Cred_12913 VDD.P67.pSD vin3.$642.Metal2 0.000839497f
Cred_12914 VDD.P67.pSD vin3.$645.Metal2 0.00542706f
Cred_12915 VDD.P67.pSD vin3.P36.GatPoly 0.000152531f
Cred_12916 VDD.P67.pSD vin3.P37.GatPoly 0.0489685f
Cred_12917 VDD.P67.pSD vin3.P38.GatPoly 0.0501226f
Cred_12918 VDD.P67.pSD vin3.P39.GatPoly 0.000166635f
Cred_12919 VDD.P67.pSD vin4.$166.GatPoly 2.2356e-05f
Cred_12920 VDD.P67.pSD vin4.$172.GatPoly 4.72178e-06f
Cred_12921 VDD.P67.pSD vin4.$178.GatPoly 2.03989e-05f
Cred_12922 VDD.P67.pSD vin4.$440.Metal1 1.75847e-06f
Cred_12923 VDD.P67.pSD vin4.$448.Metal1 1.12984e-05f
Cred_12924 VDD.P67.pSD vin4.$452.Metal1 4.99616e-06f
Cred_12925 VDD.P67.pSD vin4.$635.Metal2 4.30854e-09f
Cred_12926 VDD.P67.pSD vin4.$639.Metal2 1.65375e-05f
Cred_12927 VDD.P67.pSD vin4.$642.Metal2 2.03932e-06f
Cred_12928 VDD.P67.pSD vin4.$644.Metal2 1.3156e-05f
Cred_12929 VDD.P67.pSD vin4.P36.GatPoly 9.63259e-07f
Cred_12930 VDD.P67.pSD vin4.P37.GatPoly 7.39737e-05f
Cred_12931 VDD.P67.pSD vin4.P38.GatPoly 7.50347e-05f
Cred_12932 VDD.P67.pSD vin4.P39.GatPoly 1.0621e-06f
Cred_12933 VDD.P67.pSD vout3 0.00661564f
Cred_12934 VDD.P67.pSD vout3.$1424.Metal3 0.0749862f
Cred_12935 VDD.P67.pSD vout3.P16.pSD 0.0212594f
Cred_12936 VDD.P67.pSD vout3.P18.nSD 0.000525648f
Cred_12937 VDD.P67.pSD vout3.P18.pSD 0.0253849f
Cred_12938 VDD.P67.pSD vout4 1.87647e-05f
Cred_12939 VDD.P67.pSD vout4.$1424.Metal3 0.000214536f
Cred_12940 VDD.P67.pSD vout4.P16.pSD 4.60848e-05f
Cred_12941 VDD.P67.pSD vout4.P18.nSD 1.49096e-06f
Cred_12942 VDD.P67.pSD vout4.P18.pSD 5.63861e-05f
Cred_12943 VDD.P69.pSD vin3.$179.GatPoly 0.000135802f
Cred_12944 VDD.P69.pSD vin3.$457.Metal1 0.00119639f
Cred_12945 VDD.P69.pSD vin3.$649.Metal2 2.53316e-05f
Cred_12946 VDD.P69.pSD vin3.$654.Metal2 0.000125681f
Cred_12947 VDD.P69.pSD vin3.P39.GatPoly 0.00224922f
Cred_12948 VDD.P69.pSD vout3 0.000512144f
Cred_12949 VDD.P69.pSD vout3.$1424.Metal3 0.00258299f
Cred_12950 VDD.P69.pSD vout3.P18.nSD 4.06925e-05f
Cred_12951 VDD.P69.pSD vout3.P18.pSD 0.00104255f
Cred_12952 VDD.P69.pSD VSS.$1990.Metal1 3.63106e-05f
Cred_12953 VDD.P69.pSD VSS.$2022.Metal1 6.17686e-06f
Cred_12954 VDD.P69.pSD VSS.$4174.Metal2 0.000108069f
Cred_12955 VDD.P69.pSD VSS.$68.Metal1 2.40983e-08f
Cred_12956 VDD.P69.pSD VSS.P2.pSD 0.000136805f
Cred_12957 VDD.P69.pSD VSS.P69.nSD 2.70453e-08f
Cred_12958 VDD.P69.pSD VSS.P71.nSD 2.70453e-08f
Cred_12959 VDD.P7.GatPoly vin2.$178.GatPoly 0.0030499f
Cred_12960 VDD.P7.GatPoly vin2.$456.Metal1 0.0165391f
Cred_12961 VDD.P7.GatPoly vin2.$648.Metal2 0.000349285f
Cred_12962 VDD.P7.GatPoly vin2.$653.Metal2 0.00168599f
Cred_12963 VDD.P7.GatPoly vin2.P34.GatPoly 0.00130082f
Cred_12964 VDD.P7.GatPoly vin2.P35.GatPoly 0.00160627f
Cred_12965 VDD.P7.GatPoly vin2.P36.GatPoly 0.00227743f
Cred_12966 VDD.P7.GatPoly vin2.P37.GatPoly 0.00328573f
Cred_12967 VDD.P7.GatPoly vin2.P38.GatPoly 0.00596583f
Cred_12968 VDD.P7.GatPoly vin2.P39.GatPoly 0.0706805f
Cred_12969 VDD.P7.GatPoly vout2 0.000613058f
Cred_12970 VDD.P7.GatPoly vout2.$1424.Metal3 0.00309194f
Cred_12971 VDD.P7.GatPoly vout2.P18.nSD 4.87107e-05f
Cred_12972 VDD.P7.GatPoly vout2.P18.pSD 0.000338518f
Cred_12973 VDD.P7.GatPoly VSS.P7.GatPoly 0.00217316f
Cred_12974 VDD.P7.pSD vin4.$264.Metal1 0.00571275f
Cred_12975 VDD.P7.pSD vin4.$272.Metal1 0.0108046f
Cred_12976 VDD.P7.pSD vin4.$276.Metal1 0.000170532f
Cred_12977 VDD.P7.pSD vin4.$280.Metal1 9.10101e-06f
Cred_12978 VDD.P7.pSD vin4.$44.GatPoly 0.0193653f
Cred_12979 VDD.P7.pSD vin4.$515.Metal2 0.000247982f
Cred_12980 VDD.P7.pSD vin4.$519.Metal2 0.00107416f
Cred_12981 VDD.P7.pSD vin4.$52.GatPoly 0.00484013f
Cred_12982 VDD.P7.pSD vin4.$524.Metal2 0.00011177f
Cred_12983 VDD.P7.pSD vin4.$525.Metal2 0.0106348f
Cred_12984 VDD.P7.pSD vin4.$529.Metal2 4.24442e-06f
Cred_12985 VDD.P7.pSD vin4.$532.Metal2 0.000757388f
Cred_12986 VDD.P7.pSD vin4.$535.Metal2 0.000247982f
Cred_12987 VDD.P7.pSD vin4.$56.GatPoly 0.01992f
Cred_12988 VDD.P7.pSD vin4.P24.GatPoly 0.000151568f
Cred_12989 VDD.P7.pSD vin4.P25.GatPoly 0.0488917f
Cred_12990 VDD.P7.pSD vin4.P26.GatPoly 0.048972f
Cred_12991 VDD.P7.pSD vin4.P27.GatPoly 0.000151568f
Cred_12992 VDD.P7.pSD vout4.$1226.Metal3 0.0629616f
Cred_12993 VDD.P7.pSD vout4.$1292.Metal3 0.0200348f
Cred_12994 VDD.P7.pSD vout4.P4.pSD 0.0216536f
Cred_12995 VDD.P7.pSD vout4.P6.nSD 0.000315629f
Cred_12996 VDD.P7.pSD vout4.P6.pSD 0.0220948f
Cred_12997 VDD.P71.pSD vin3.$179.GatPoly 0.000135802f
Cred_12998 VDD.P71.pSD vin3.$457.Metal1 0.00119639f
Cred_12999 VDD.P71.pSD vin3.$649.Metal2 2.53316e-05f
Cred_13000 VDD.P71.pSD vin3.$654.Metal2 0.000125681f
Cred_13001 VDD.P71.pSD vin3.P39.GatPoly 0.00216426f
Cred_13002 VDD.P71.pSD vout3 0.000193458f
Cred_13003 VDD.P71.pSD vout3.$1424.Metal3 0.000975702f
Cred_13004 VDD.P71.pSD vout3.P18.nSD 1.53713e-05f
Cred_13005 VDD.P71.pSD vout3.P18.pSD 0.000891166f
Cred_13006 VDD.P71.pSD VSS.$1990.Metal1 3.63106e-05f
Cred_13007 VDD.P71.pSD VSS.$2022.Metal1 6.17686e-06f
Cred_13008 VDD.P71.pSD VSS.$4174.Metal2 0.000108069f
Cred_13009 VDD.P71.pSD VSS.$68.Metal1 2.40983e-08f
Cred_13010 VDD.P71.pSD VSS.P2.pSD 0.000136805f
Cred_13011 VDD.P71.pSD VSS.P69.nSD 2.70453e-08f
Cred_13012 VDD.P71.pSD VSS.P71.nSD 2.70453e-08f
Cred_13013 VDD.P72.pSD vin2.$202.Metal1 0.0029278f
Cred_13014 VDD.P72.pSD vin2.$477.Metal2 0.000701873f
Cred_13015 VDD.P72.pSD vin2.$479.Metal2 0.00136856f
Cred_13016 VDD.P72.pSD vin2.$8.GatPoly 0.000325071f
Cred_13017 VDD.P72.pSD vin2.P20.GatPoly 0.0122877f
Cred_13018 VDD.P72.pSD vout2.$1226.Metal3 0.00658442f
Cred_13019 VDD.P72.pSD vout2.P0.nSD 0.000196063f
Cred_13020 VDD.P72.pSD vout2.P0.pSD 0.00555076f
Cred_13021 VDD.P72.pSD vout2.P2.nSD 0.000103731f
Cred_13022 VDD.P72.pSD vout2.P2.pSD 0.000566916f
Cred_13023 VDD.P72.pSD VSS.$1990.Metal1 5.04971e-08f
Cred_13024 VDD.P72.pSD VSS.$4358.Metal3 0.000132118f
Cred_13025 VDD.P72.pSD VSS.$68.Metal1 7.29697e-05f
Cred_13026 VDD.P72.pSD VSS.P3.pSD 0.000283805f
Cred_13027 VDD.P73.pSD vin2.$202.Metal1 0.00300472f
Cred_13028 VDD.P73.pSD vin2.$477.Metal2 0.00136805f
Cred_13029 VDD.P73.pSD vin2.$479.Metal2 0.00261031f
Cred_13030 VDD.P73.pSD vin2.$8.GatPoly 0.000326472f
Cred_13031 VDD.P73.pSD vin2.P20.GatPoly 0.0122888f
Cred_13032 VDD.P73.pSD vout2.$1226.Metal3 0.00658442f
Cred_13033 VDD.P73.pSD vout2.P0.nSD 0.000196063f
Cred_13034 VDD.P73.pSD vout2.P0.pSD 0.00555076f
Cred_13035 VDD.P73.pSD vout2.P2.nSD 0.000103731f
Cred_13036 VDD.P73.pSD vout2.P2.pSD 0.000566916f
Cred_13037 VDD.P73.pSD VSS.$1990.Metal1 5.04971e-08f
Cred_13038 VDD.P73.pSD VSS.$4358.Metal3 0.000132118f
Cred_13039 VDD.P73.pSD VSS.$68.Metal1 7.29697e-05f
Cred_13040 VDD.P73.pSD VSS.P3.pSD 0.000283805f
Cred_13041 VDD.P75.pSD vin1.$15.GatPoly 2.2356e-05f
Cred_13042 VDD.P75.pSD vin1.$17.GatPoly 4.64848e-06f
Cred_13043 VDD.P75.pSD vin1.$207.Metal1 4.99616e-06f
Cred_13044 VDD.P75.pSD vin1.$211.Metal1 1.12984e-05f
Cred_13045 VDD.P75.pSD vin1.$219.Metal1 1.75847e-06f
Cred_13046 VDD.P75.pSD vin1.$484.Metal2 1.3156e-05f
Cred_13047 VDD.P75.pSD vin1.$486.Metal2 2.03932e-06f
Cred_13048 VDD.P75.pSD vin1.$489.Metal2 1.65375e-05f
Cred_13049 VDD.P75.pSD vin1.$493.Metal2 4.30854e-09f
Cred_13050 VDD.P75.pSD vin1.$9.GatPoly 2.03989e-05f
Cred_13051 VDD.P75.pSD vin1.P20.GatPoly 1.0621e-06f
Cred_13052 VDD.P75.pSD vin1.P21.GatPoly 7.50347e-05f
Cred_13053 VDD.P75.pSD vin1.P22.GatPoly 7.39737e-05f
Cred_13054 VDD.P75.pSD vin1.P23.GatPoly 9.63259e-07f
Cred_13055 VDD.P75.pSD vin2.$14.GatPoly 0.0191806f
Cred_13056 VDD.P75.pSD vin2.$16.GatPoly 0.00472678f
Cred_13057 VDD.P75.pSD vin2.$206.Metal1 0.00517618f
Cred_13058 VDD.P75.pSD vin2.$210.Metal1 0.0117425f
Cred_13059 VDD.P75.pSD vin2.$218.Metal1 0.00183771f
Cred_13060 VDD.P75.pSD vin2.$483.Metal2 0.00542706f
Cred_13061 VDD.P75.pSD vin2.$486.Metal2 0.000839497f
Cred_13062 VDD.P75.pSD vin2.$488.Metal2 0.00683498f
Cred_13063 VDD.P75.pSD vin2.$492.Metal2 4.50267e-06f
Cred_13064 VDD.P75.pSD vin2.$8.GatPoly 0.0172362f
Cred_13065 VDD.P75.pSD vin2.P20.GatPoly 0.000166635f
Cred_13066 VDD.P75.pSD vin2.P21.GatPoly 0.0501226f
Cred_13067 VDD.P75.pSD vin2.P22.GatPoly 0.0489685f
Cred_13068 VDD.P75.pSD vin2.P23.GatPoly 0.000152531f
Cred_13069 VDD.P75.pSD vout1.$1226.Metal3 0.000196393f
Cred_13070 VDD.P75.pSD vout1.P0.nSD 4.34119e-06f
Cred_13071 VDD.P75.pSD vout1.P0.pSD 7.49979e-05f
Cred_13072 VDD.P75.pSD vout1.P2.nSD 3.09399e-06f
Cred_13073 VDD.P75.pSD vout1.P2.pSD 6.1794e-05f
Cred_13074 VDD.P75.pSD vout2.$1226.Metal3 0.0684665f
Cred_13075 VDD.P75.pSD vout2.P0.nSD 0.00151367f
Cred_13076 VDD.P75.pSD vout2.P0.pSD 0.0320311f
Cred_13077 VDD.P75.pSD vout2.P2.nSD 0.00107863f
Cred_13078 VDD.P75.pSD vout2.P2.pSD 0.0264441f
Cred_13079 VDD.P77.pSD vin1.$237.Metal1 2.25972e-06f
Cred_13080 VDD.P77.pSD vin1.$241.Metal1 9.79792e-06f
Cred_13081 VDD.P77.pSD vin1.$247.Metal1 5.51615e-06f
Cred_13082 VDD.P77.pSD vin1.$25.GatPoly 2.04814e-05f
Cred_13083 VDD.P77.pSD vin1.$251.Metal1 2.01467e-06f
Cred_13084 VDD.P77.pSD vin1.$37.GatPoly 1.06797e-05f
Cred_13085 VDD.P77.pSD vin1.$43.GatPoly 3.80925e-06f
Cred_13086 VDD.P77.pSD vin1.$504.Metal2 1.65714e-05f
Cred_13087 VDD.P77.pSD vin1.$506.Metal2 1.61549e-06f
Cred_13088 VDD.P77.pSD vin1.$509.Metal2 9.54785e-06f
Cred_13089 VDD.P77.pSD vin1.P22.GatPoly 8.35102e-07f
Cred_13090 VDD.P77.pSD vin1.P23.GatPoly 6.41201e-05f
Cred_13091 VDD.P77.pSD vin1.P24.GatPoly 6.7112e-05f
Cred_13092 VDD.P77.pSD vin1.P25.GatPoly 8.35102e-07f
Cred_13093 VDD.P77.pSD vin2.$236.Metal1 0.00270362f
Cred_13094 VDD.P77.pSD vin2.$24.GatPoly 0.0204585f
Cred_13095 VDD.P77.pSD vin2.$240.Metal1 0.0117577f
Cred_13096 VDD.P77.pSD vin2.$246.Metal1 0.00586999f
Cred_13097 VDD.P77.pSD vin2.$250.Metal1 0.00199065f
Cred_13098 VDD.P77.pSD vin2.$36.GatPoly 0.011247f
Cred_13099 VDD.P77.pSD vin2.$42.GatPoly 0.00376383f
Cred_13100 VDD.P77.pSD vin2.$503.Metal2 0.00787471f
Cred_13101 VDD.P77.pSD vin2.$506.Metal2 0.000766832f
Cred_13102 VDD.P77.pSD vin2.$508.Metal2 0.00456037f
Cred_13103 VDD.P77.pSD vin2.P22.GatPoly 0.000152403f
Cred_13104 VDD.P77.pSD vin2.P23.GatPoly 0.0490831f
Cred_13105 VDD.P77.pSD vin2.P24.GatPoly 0.0520434f
Cred_13106 VDD.P77.pSD vin2.P25.GatPoly 0.000152403f
Cred_13107 VDD.P77.pSD vout1.$1226.Metal3 0.000197222f
Cred_13108 VDD.P77.pSD vout1.P0.nSD 1.29954e-06f
Cred_13109 VDD.P77.pSD vout1.P0.pSD 6.90552e-06f
Cred_13110 VDD.P77.pSD vout1.P2.nSD 1.41373e-06f
Cred_13111 VDD.P77.pSD vout1.P2.pSD 4.67235e-05f
Cred_13112 VDD.P77.pSD vout1.P4.pSD 3.96739e-05f
Cred_13113 VDD.P77.pSD vout2.$1226.Metal3 0.0791415f
Cred_13114 VDD.P77.pSD vout2.P0.nSD 0.000518669f
Cred_13115 VDD.P77.pSD vout2.P0.pSD 0.00275612f
Cred_13116 VDD.P77.pSD vout2.P2.nSD 0.000564244f
Cred_13117 VDD.P77.pSD vout2.P2.pSD 0.0237439f
Cred_13118 VDD.P77.pSD vout2.P4.pSD 0.0214331f
Cred_13119 VDD.P79.pSD vin2.$264.Metal1 0.00571275f
Cred_13120 VDD.P79.pSD vin2.$272.Metal1 0.0108046f
Cred_13121 VDD.P79.pSD vin2.$276.Metal1 0.000170532f
Cred_13122 VDD.P79.pSD vin2.$280.Metal1 9.10101e-06f
Cred_13123 VDD.P79.pSD vin2.$44.GatPoly 0.0193653f
Cred_13124 VDD.P79.pSD vin2.$515.Metal2 0.000247982f
Cred_13125 VDD.P79.pSD vin2.$519.Metal2 0.00107416f
Cred_13126 VDD.P79.pSD vin2.$52.GatPoly 0.00484013f
Cred_13127 VDD.P79.pSD vin2.$524.Metal2 0.00011177f
Cred_13128 VDD.P79.pSD vin2.$525.Metal2 0.0106348f
Cred_13129 VDD.P79.pSD vin2.$529.Metal2 4.24442e-06f
Cred_13130 VDD.P79.pSD vin2.$532.Metal2 0.000757388f
Cred_13131 VDD.P79.pSD vin2.$535.Metal2 0.000247982f
Cred_13132 VDD.P79.pSD vin2.$56.GatPoly 0.01992f
Cred_13133 VDD.P79.pSD vin2.P24.GatPoly 0.000151568f
Cred_13134 VDD.P79.pSD vin2.P25.GatPoly 0.0488917f
Cred_13135 VDD.P79.pSD vin2.P26.GatPoly 0.048972f
Cred_13136 VDD.P79.pSD vin2.P27.GatPoly 0.000151568f
Cred_13137 VDD.P79.pSD vout2.$1226.Metal3 0.0629616f
Cred_13138 VDD.P79.pSD vout2.$1292.Metal3 0.0200348f
Cred_13139 VDD.P79.pSD vout2.P4.pSD 0.0216536f
Cred_13140 VDD.P79.pSD vout2.P6.nSD 0.000315629f
Cred_13141 VDD.P79.pSD vout2.P6.pSD 0.0220948f
Cred_13142 VDD.P81.pSD vin1.$291.Metal1 2.63615e-06f
Cred_13143 VDD.P81.pSD vin1.$295.Metal1 5.53399e-06f
Cred_13144 VDD.P81.pSD vin1.$303.Metal1 7.96451e-06f
Cred_13145 VDD.P81.pSD vin1.$307.Metal1 1.52164e-07f
Cred_13146 VDD.P81.pSD vin1.$542.Metal2 6.8538e-06f
Cred_13147 VDD.P81.pSD vin1.$544.Metal2 1.29699e-06f
Cred_13148 VDD.P81.pSD vin1.$547.Metal2 1.45835e-05f
Cred_13149 VDD.P81.pSD vin1.$551.Metal2 1.64347e-07f
Cred_13150 VDD.P81.pSD vin1.$65.GatPoly 4.98432e-06f
Cred_13151 VDD.P81.pSD vin1.$73.GatPoly 7.65648e-06f
Cred_13152 VDD.P81.pSD vin1.$77.GatPoly 1.68172e-05f
Cred_13153 VDD.P81.pSD vin1.P26.GatPoly 7.02069e-07f
Cred_13154 VDD.P81.pSD vin1.P27.GatPoly 5.66025e-05f
Cred_13155 VDD.P81.pSD vin1.P28.GatPoly 5.3923e-05f
Cred_13156 VDD.P81.pSD vin1.P29.GatPoly 7.02069e-07f
Cred_13157 VDD.P81.pSD vin2.$290.Metal1 0.00310052f
Cred_13158 VDD.P81.pSD vin2.$294.Metal1 0.00740785f
Cred_13159 VDD.P81.pSD vin2.$302.Metal1 0.0113968f
Cred_13160 VDD.P81.pSD vin2.$306.Metal1 0.000210762f
Cred_13161 VDD.P81.pSD vin2.$541.Metal2 0.00389589f
Cred_13162 VDD.P81.pSD vin2.$544.Metal2 0.000732061f
Cred_13163 VDD.P81.pSD vin2.$546.Metal2 0.00825822f
Cred_13164 VDD.P81.pSD vin2.$550.Metal2 9.27628e-05f
Cred_13165 VDD.P81.pSD vin2.$64.GatPoly 0.00586233f
Cred_13166 VDD.P81.pSD vin2.$72.GatPoly 0.00978438f
Cred_13167 VDD.P81.pSD vin2.$76.GatPoly 0.019903f
Cred_13168 VDD.P81.pSD vin2.P26.GatPoly 0.00015227f
Cred_13169 VDD.P81.pSD vin2.P27.GatPoly 0.0522473f
Cred_13170 VDD.P81.pSD vin2.P28.GatPoly 0.0490921f
Cred_13171 VDD.P81.pSD vin2.P29.GatPoly 0.00015227f
Cred_13172 VDD.P81.pSD vout1.$1226.Metal3 4.22375e-05f
Cred_13173 VDD.P81.pSD vout1.$1292.Metal3 0.00013155f
Cred_13174 VDD.P81.pSD vout1.P6.nSD 6.65412e-07f
Cred_13175 VDD.P81.pSD vout1.P6.pSD 3.72974e-05f
Cred_13176 VDD.P81.pSD vout1.P8.pSD 3.25173e-05f
Cred_13177 VDD.P81.pSD vout2.$1226.Metal3 0.0204654f
Cred_13178 VDD.P81.pSD vout2.$1292.Metal3 0.0625377f
Cred_13179 VDD.P81.pSD vout2.P6.nSD 0.000322413f
Cred_13180 VDD.P81.pSD vout2.P6.pSD 0.0234491f
Cred_13181 VDD.P81.pSD vout2.P8.pSD 0.0203811f
Cred_13182 VDD.P83.pSD vin1.$325.Metal1 3.86797e-06f
Cred_13183 VDD.P83.pSD vin1.$331.Metal1 1.16729e-05f
Cred_13184 VDD.P83.pSD vin1.$335.Metal1 5.6091e-07f
Cred_13185 VDD.P83.pSD vin1.$562.Metal2 1.56975e-05f
Cred_13186 VDD.P83.pSD vin1.$564.Metal2 2.11244e-06f
Cred_13187 VDD.P83.pSD vin1.$567.Metal2 1.45361e-05f
Cred_13188 VDD.P83.pSD vin1.$87.GatPoly 2.27665e-05f
Cred_13189 VDD.P83.pSD vin1.$93.GatPoly 5.36423e-06f
Cred_13190 VDD.P83.pSD vin1.$97.GatPoly 2.36692e-05f
Cred_13191 VDD.P83.pSD vin1.P28.GatPoly 9.8421e-07f
Cred_13192 VDD.P83.pSD vin1.P29.GatPoly 7.54806e-05f
Cred_13193 VDD.P83.pSD vin1.P30.GatPoly 7.54806e-05f
Cred_13194 VDD.P83.pSD vin1.P31.GatPoly 9.8421e-07f
Cred_13195 VDD.P83.pSD vin2.$324.Metal1 0.00395628f
Cred_13196 VDD.P83.pSD vin2.$330.Metal1 0.0119074f
Cred_13197 VDD.P83.pSD vin2.$334.Metal1 0.000564352f
Cred_13198 VDD.P83.pSD vin2.$561.Metal2 0.00636728f
Cred_13199 VDD.P83.pSD vin2.$564.Metal2 0.000851131f
Cred_13200 VDD.P83.pSD vin2.$566.Metal2 0.00586015f
Cred_13201 VDD.P83.pSD vin2.$86.GatPoly 0.019104f
Cred_13202 VDD.P83.pSD vin2.$92.GatPoly 0.00529086f
Cred_13203 VDD.P83.pSD vin2.$96.GatPoly 0.019994f
Cred_13204 VDD.P83.pSD vin2.P28.GatPoly 0.000152552f
Cred_13205 VDD.P83.pSD vin2.P29.GatPoly 0.0490247f
Cred_13206 VDD.P83.pSD vin2.P30.GatPoly 0.0490247f
Cred_13207 VDD.P83.pSD vin2.P31.GatPoly 0.000152552f
Cred_13208 VDD.P83.pSD vout1.$1292.Metal3 0.000183043f
Cred_13209 VDD.P83.pSD vout1.$1358.Metal3 5.91688e-05f
Cred_13210 VDD.P83.pSD vout1.P10.nSD 9.32149e-07f
Cred_13211 VDD.P83.pSD vout1.P10.pSD 5.15685e-05f
Cred_13212 VDD.P83.pSD vout1.P8.pSD 4.70531e-05f
Cred_13213 VDD.P83.pSD vout2.$1292.Metal3 0.0629292f
Cred_13214 VDD.P83.pSD vout2.$1358.Metal3 0.0199095f
Cred_13215 VDD.P83.pSD vout2.P10.nSD 0.000313655f
Cred_13216 VDD.P83.pSD vout2.P10.pSD 0.0225054f
Cred_13217 VDD.P83.pSD vout2.P8.pSD 0.0216735f
Cred_13218 VDD.P85.pSD vin2.$106.GatPoly 0.0198862f
Cred_13219 VDD.P85.pSD vin2.$114.GatPoly 0.00977672f
Cred_13220 VDD.P85.pSD vin2.$122.GatPoly 0.00585735f
Cred_13221 VDD.P85.pSD vin2.$352.Metal1 0.00021061f
Cred_13222 VDD.P85.pSD vin2.$356.Metal1 0.0113888f
Cred_13223 VDD.P85.pSD vin2.$364.Metal1 0.00740232f
Cred_13224 VDD.P85.pSD vin2.$368.Metal1 0.00309789f
Cred_13225 VDD.P85.pSD vin2.$577.Metal2 9.25985e-05f
Cred_13226 VDD.P85.pSD vin2.$581.Metal2 0.00824363f
Cred_13227 VDD.P85.pSD vin2.$584.Metal2 0.000730764f
Cred_13228 VDD.P85.pSD vin2.$586.Metal2 0.00388903f
Cred_13229 VDD.P85.pSD vin2.P30.GatPoly 0.000151568f
Cred_13230 VDD.P85.pSD vin2.P31.GatPoly 0.0490382f
Cred_13231 VDD.P85.pSD vin2.P32.GatPoly 0.0521907f
Cred_13232 VDD.P85.pSD vin2.P33.GatPoly 0.000151568f
Cred_13233 VDD.P85.pSD vout2.$1292.Metal3 0.020112f
Cred_13234 VDD.P85.pSD vout2.$1358.Metal3 0.0618195f
Cred_13235 VDD.P85.pSD vout2.P10.nSD 0.000316845f
Cred_13236 VDD.P85.pSD vout2.P10.pSD 0.0234695f
Cred_13237 VDD.P85.pSD vout2.P12.pSD 0.0207601f
Cred_13238 VDD.P87.pSD vin1.$127.GatPoly 3.34634e-06f
Cred_13239 VDD.P87.pSD vin1.$135.GatPoly 7.02023e-07f
Cred_13240 VDD.P87.pSD vin1.$137.GatPoly 3.26638e-06f
Cred_13241 VDD.P87.pSD vin1.$379.Metal1 3.20941e-09f
Cred_13242 VDD.P87.pSD vin1.$383.Metal1 2.79651e-08f
Cred_13243 VDD.P87.pSD vin1.$387.Metal1 1.5056e-06f
Cred_13244 VDD.P87.pSD vin1.$393.Metal1 7.97272e-07f
Cred_13245 VDD.P87.pSD vin1.$593.Metal2 8.74491e-08f
Cred_13246 VDD.P87.pSD vin1.$596.Metal2 2.67088e-07f
Cred_13247 VDD.P87.pSD vin1.$599.Metal2 1.49677e-09f
Cred_13248 VDD.P87.pSD vin1.$603.Metal2 3.73335e-06f
Cred_13249 VDD.P87.pSD vin1.$604.Metal2 3.94148e-08f
Cred_13250 VDD.P87.pSD vin1.$609.Metal2 3.78487e-07f
Cred_13251 VDD.P87.pSD vin1.$613.Metal2 8.74491e-08f
Cred_13252 VDD.P87.pSD vin1.P32.GatPoly 1.39494e-07f
Cred_13253 VDD.P87.pSD vin1.P33.GatPoly 1.07021e-05f
Cred_13254 VDD.P87.pSD vin1.P34.GatPoly 1.06877e-05f
Cred_13255 VDD.P87.pSD vin1.P35.GatPoly 1.39494e-07f
Cred_13256 VDD.P87.pSD vin2.$126.GatPoly 0.0199234f
Cred_13257 VDD.P87.pSD vin2.$134.GatPoly 0.00484083f
Cred_13258 VDD.P87.pSD vin2.$136.GatPoly 0.0193685f
Cred_13259 VDD.P87.pSD vin2.$378.Metal1 9.10422e-06f
Cred_13260 VDD.P87.pSD vin2.$382.Metal1 0.00017056f
Cred_13261 VDD.P87.pSD vin2.$386.Metal1 0.0108061f
Cred_13262 VDD.P87.pSD vin2.$392.Metal1 0.00571355f
Cred_13263 VDD.P87.pSD vin2.$593.Metal2 0.000248069f
Cred_13264 VDD.P87.pSD vin2.$595.Metal2 0.000757655f
Cred_13265 VDD.P87.pSD vin2.$600.Metal2 4.24592e-06f
Cred_13266 VDD.P87.pSD vin2.$601.Metal2 0.0106386f
Cred_13267 VDD.P87.pSD vin2.$605.Metal2 0.000111809f
Cred_13268 VDD.P87.pSD vin2.$608.Metal2 0.00107453f
Cred_13269 VDD.P87.pSD vin2.$613.Metal2 0.000248069f
Cred_13270 VDD.P87.pSD vin2.P32.GatPoly 0.000151708f
Cred_13271 VDD.P87.pSD vin2.P33.GatPoly 0.0489827f
Cred_13272 VDD.P87.pSD vin2.P34.GatPoly 0.0489024f
Cred_13273 VDD.P87.pSD vin2.P35.GatPoly 0.000151708f
Cred_13274 VDD.P87.pSD vout1.$1358.Metal3 2.57299e-05f
Cred_13275 VDD.P87.pSD vout1.$1424.Metal3 8.41721e-06f
Cred_13276 VDD.P87.pSD vout1.P12.pSD 6.74174e-06f
Cred_13277 VDD.P87.pSD vout1.P14.nSD 1.32605e-07f
Cred_13278 VDD.P87.pSD vout1.P14.pSD 7.32643e-06f
Cred_13279 VDD.P87.pSD vout2.$1358.Metal3 0.0623267f
Cred_13280 VDD.P87.pSD vout2.$1424.Metal3 0.0198771f
Cred_13281 VDD.P87.pSD vout2.P12.pSD 0.0217797f
Cred_13282 VDD.P87.pSD vout2.P14.nSD 0.000313146f
Cred_13283 VDD.P87.pSD vout2.P14.pSD 0.0224939f
Cred_13284 VDD.P89.pSD vin1.$145.GatPoly 3.80925e-06f
Cred_13285 VDD.P89.pSD vin1.$153.GatPoly 1.06797e-05f
Cred_13286 VDD.P89.pSD vin1.$157.GatPoly 2.04814e-05f
Cred_13287 VDD.P89.pSD vin1.$409.Metal1 2.01467e-06f
Cred_13288 VDD.P89.pSD vin1.$413.Metal1 5.51615e-06f
Cred_13289 VDD.P89.pSD vin1.$419.Metal1 9.79792e-06f
Cred_13290 VDD.P89.pSD vin1.$423.Metal1 2.25972e-06f
Cred_13291 VDD.P89.pSD vin1.$620.Metal2 9.54785e-06f
Cred_13292 VDD.P89.pSD vin1.$622.Metal2 1.61549e-06f
Cred_13293 VDD.P89.pSD vin1.$625.Metal2 1.65714e-05f
Cred_13294 VDD.P89.pSD vin1.P34.GatPoly 8.35102e-07f
Cred_13295 VDD.P89.pSD vin1.P35.GatPoly 6.7112e-05f
Cred_13296 VDD.P89.pSD vin1.P36.GatPoly 6.41201e-05f
Cred_13297 VDD.P89.pSD vin1.P37.GatPoly 8.35102e-07f
Cred_13298 VDD.P89.pSD vin2.$144.GatPoly 0.00376383f
Cred_13299 VDD.P89.pSD vin2.$152.GatPoly 0.011247f
Cred_13300 VDD.P89.pSD vin2.$156.GatPoly 0.0204585f
Cred_13301 VDD.P89.pSD vin2.$408.Metal1 0.00199065f
Cred_13302 VDD.P89.pSD vin2.$412.Metal1 0.00586999f
Cred_13303 VDD.P89.pSD vin2.$418.Metal1 0.0117577f
Cred_13304 VDD.P89.pSD vin2.$422.Metal1 0.00270362f
Cred_13305 VDD.P89.pSD vin2.$619.Metal2 0.00456037f
Cred_13306 VDD.P89.pSD vin2.$622.Metal2 0.000766832f
Cred_13307 VDD.P89.pSD vin2.$624.Metal2 0.00787471f
Cred_13308 VDD.P89.pSD vin2.P34.GatPoly 0.000152403f
Cred_13309 VDD.P89.pSD vin2.P35.GatPoly 0.0520434f
Cred_13310 VDD.P89.pSD vin2.P36.GatPoly 0.0490831f
Cred_13311 VDD.P89.pSD vin2.P37.GatPoly 0.000152403f
Cred_13312 VDD.P89.pSD vout1.$1358.Metal3 4.93295e-05f
Cred_13313 VDD.P89.pSD vout1.$1424.Metal3 0.000155883f
Cred_13314 VDD.P89.pSD vout1.P14.nSD 7.7714e-07f
Cred_13315 VDD.P89.pSD vout1.P14.pSD 4.45695e-05f
Cred_13316 VDD.P89.pSD vout1.P16.pSD 3.96026e-05f
Cred_13317 VDD.P89.pSD vout2.$1358.Metal3 0.0202214f
Cred_13318 VDD.P89.pSD vout2.$1424.Metal3 0.062166f
Cred_13319 VDD.P89.pSD vout2.P14.nSD 0.000318569f
Cred_13320 VDD.P89.pSD vout2.P14.pSD 0.0235306f
Cred_13321 VDD.P89.pSD vout2.P16.pSD 0.0208064f
Cred_13322 VDD.P91.pSD vin1.$167.GatPoly 2.2356e-05f
Cred_13323 VDD.P91.pSD vin1.$173.GatPoly 4.72178e-06f
Cred_13324 VDD.P91.pSD vin1.$179.GatPoly 2.03989e-05f
Cred_13325 VDD.P91.pSD vin1.$441.Metal1 1.75847e-06f
Cred_13326 VDD.P91.pSD vin1.$449.Metal1 1.12984e-05f
Cred_13327 VDD.P91.pSD vin1.$453.Metal1 4.99616e-06f
Cred_13328 VDD.P91.pSD vin1.$636.Metal2 4.30854e-09f
Cred_13329 VDD.P91.pSD vin1.$640.Metal2 1.65375e-05f
Cred_13330 VDD.P91.pSD vin1.$642.Metal2 2.03932e-06f
Cred_13331 VDD.P91.pSD vin1.$645.Metal2 1.3156e-05f
Cred_13332 VDD.P91.pSD vin1.P36.GatPoly 9.63259e-07f
Cred_13333 VDD.P91.pSD vin1.P37.GatPoly 7.38063e-05f
Cred_13334 VDD.P91.pSD vin1.P38.GatPoly 7.5202e-05f
Cred_13335 VDD.P91.pSD vin1.P39.GatPoly 1.0621e-06f
Cred_13336 VDD.P91.pSD vin2.$166.GatPoly 0.0191806f
Cred_13337 VDD.P91.pSD vin2.$172.GatPoly 0.00480338f
Cred_13338 VDD.P91.pSD vin2.$178.GatPoly 0.0172362f
Cred_13339 VDD.P91.pSD vin2.$440.Metal1 0.00183771f
Cred_13340 VDD.P91.pSD vin2.$448.Metal1 0.0117425f
Cred_13341 VDD.P91.pSD vin2.$452.Metal1 0.00517618f
Cred_13342 VDD.P91.pSD vin2.$635.Metal2 4.50267e-06f
Cred_13343 VDD.P91.pSD vin2.$639.Metal2 0.00683498f
Cred_13344 VDD.P91.pSD vin2.$642.Metal2 0.000839497f
Cred_13345 VDD.P91.pSD vin2.$644.Metal2 0.00542706f
Cred_13346 VDD.P91.pSD vin2.P36.GatPoly 0.000152531f
Cred_13347 VDD.P91.pSD vin2.P37.GatPoly 0.0491168f
Cred_13348 VDD.P91.pSD vin2.P38.GatPoly 0.0499743f
Cred_13349 VDD.P91.pSD vin2.P39.GatPoly 0.000166635f
Cred_13350 VDD.P91.pSD vout1 1.87647e-05f
Cred_13351 VDD.P91.pSD vout1.$1424.Metal3 0.000213561f
Cred_13352 VDD.P91.pSD vout1.P16.pSD 4.59917e-05f
Cred_13353 VDD.P91.pSD vout1.P18.nSD 1.49096e-06f
Cred_13354 VDD.P91.pSD vout1.P18.pSD 5.63861e-05f
Cred_13355 VDD.P91.pSD vout2 0.00661564f
Cred_13356 VDD.P91.pSD vout2.$1424.Metal3 0.0753563f
Cred_13357 VDD.P91.pSD vout2.P16.pSD 0.0212927f
Cred_13358 VDD.P91.pSD vout2.P18.nSD 0.000525648f
Cred_13359 VDD.P91.pSD vout2.P18.pSD 0.0253849f
Cred_13360 VDD.P93.pSD vin2.$178.GatPoly 3.62309e-05f
Cred_13361 VDD.P93.pSD vin2.$456.Metal1 0.000319189f
Cred_13362 VDD.P93.pSD vin2.$648.Metal2 6.75829e-06f
Cred_13363 VDD.P93.pSD vin2.$653.Metal2 3.35307e-05f
Cred_13364 VDD.P93.pSD vin2.P39.GatPoly 0.000232595f
Cred_13365 VDD.P93.pSD vout2 0.000341215f
Cred_13366 VDD.P93.pSD vout2.$1424.Metal3 0.00172091f
Cred_13367 VDD.P93.pSD vout2.P18.nSD 2.71113e-05f
Cred_13368 VDD.P93.pSD vout2.P18.pSD 0.000279145f
Cred_13369 VDD.P93.pSD VSS.$1990.Metal1 1.07852e-05f
Cred_13370 VDD.P93.pSD VSS.$2021.Metal1 4.52407e-07f
Cred_13371 VDD.P93.pSD VSS.$4164.Metal2 7.91523e-06f
Cred_13372 VDD.P93.pSD VSS.$68.Metal1 7.38826e-09f
Cred_13373 VDD.P93.pSD VSS.P3.pSD 4.16238e-05f
Cred_13374 VDD.P93.pSD VSS.P93.nSD 1.98086e-09f
Cred_13375 VDD.P93.pSD VSS.P95.nSD 1.98086e-09f
Cred_13376 VDD.P95.pSD vin2.$178.GatPoly 3.62309e-05f
Cred_13377 VDD.P95.pSD vin2.$456.Metal1 0.000319189f
Cred_13378 VDD.P95.pSD vin2.$648.Metal2 6.75829e-06f
Cred_13379 VDD.P95.pSD vin2.$653.Metal2 3.35307e-05f
Cred_13380 VDD.P95.pSD vin2.P39.GatPoly 0.000232595f
Cred_13381 VDD.P95.pSD vout2 2.49785e-05f
Cred_13382 VDD.P95.pSD vout2.$1424.Metal3 0.000125979f
Cred_13383 VDD.P95.pSD vout2.P18.nSD 1.98467e-06f
Cred_13384 VDD.P95.pSD vout2.P18.pSD 0.000143058f
Cred_13385 VDD.P95.pSD VSS.$1990.Metal1 1.07852e-05f
Cred_13386 VDD.P95.pSD VSS.$2021.Metal1 4.52407e-07f
Cred_13387 VDD.P95.pSD VSS.$4164.Metal2 7.91523e-06f
Cred_13388 VDD.P95.pSD VSS.$68.Metal1 7.38826e-09f
Cred_13389 VDD.P95.pSD VSS.P3.pSD 4.16238e-05f
Cred_13390 VDD.P95.pSD VSS.P93.nSD 1.98086e-09f
Cred_13391 VDD.P95.pSD VSS.P95.nSD 1.98086e-09f
Cred_13392 vin1 VSS 0.090216f
Cred_13393 vin1 VSS.$1989.Metal1 1.27553e-07f
Cred_13394 vin1 VSS.$2020.Metal1 3.19367e-07f
Cred_13395 vin1 VSS.$29.Metal1 0.00206442f
Cred_13396 vin1 VSS.$4227.Metal2 8.5504e-10f
Cred_13397 vin1 VSS.$4355.Metal3 0.0274051f
Cred_13398 vin1 VSS.$4358.Metal3 3.69932e-05f
Cred_13399 vin1 VSS.$4364.Metal3 1.64493e-08f
Cred_13400 vin1 VSS.P1.pSD 0.00259616f
Cred_13401 vin1.$10.GatPoly vout1.$1226.Metal3 0.000720713f
Cred_13402 vin1.$10.GatPoly vout1.P0.nSD 0.000271067f
Cred_13403 vin1.$10.GatPoly vout1.P0.pSD 9.49465e-05f
Cred_13404 vin1.$10.GatPoly vout1.P2.nSD 1.39824e-05f
Cred_13405 vin1.$10.GatPoly vout1.P2.pSD 6.2053e-05f
Cred_13406 vin1.$10.GatPoly VSS.$1989.Metal1 3.19973e-07f
Cred_13407 vin1.$10.GatPoly VSS.$2020.Metal1 8.01147e-07f
Cred_13408 vin1.$10.GatPoly VSS.$2475.Metal2 1.82757e-08f
Cred_13409 vin1.$10.GatPoly VSS.$2526.Metal2 0.000233724f
Cred_13410 vin1.$10.GatPoly VSS.$2558.Metal2 0.000313817f
Cred_13411 vin1.$10.GatPoly VSS.$29.Metal1 0.000379633f
Cred_13412 vin1.$10.GatPoly VSS.$365.Metal1 3.65208e-06f
Cred_13413 vin1.$10.GatPoly VSS.$385.Metal1 0.00875726f
Cred_13414 vin1.$10.GatPoly VSS.$4227.Metal2 2.1449e-09f
Cred_13415 vin1.$10.GatPoly VSS.$4475.Metal3 1.46531e-10f
Cred_13416 vin1.$10.GatPoly VSS.P1.pSD 0.00252058f
Cred_13417 vin1.$10.GatPoly VSS.P27.nSD 0.000232966f
Cred_13418 vin1.$102.GatPoly vout1.$1292.Metal3 0.00434755f
Cred_13419 vin1.$102.GatPoly vout1.$1358.Metal3 0.00410225f
Cred_13420 vin1.$102.GatPoly vout1.P10.nSD 0.00585196f
Cred_13421 vin1.$102.GatPoly vout1.P10.pSD 0.000350025f
Cred_13422 vin1.$102.GatPoly vout1.P8.nSD 2.30011e-06f
Cred_13423 vin1.$102.GatPoly VSS 0.000710053f
Cred_13424 vin1.$102.GatPoly VSS.$1989.Metal1 1.00251e-05f
Cred_13425 vin1.$102.GatPoly VSS.$2020.Metal1 2.51007e-05f
Cred_13426 vin1.$102.GatPoly VSS.$29.Metal1 2.07184e-05f
Cred_13427 vin1.$102.GatPoly VSS.$3250.Metal2 0.000149541f
Cred_13428 vin1.$102.GatPoly VSS.$3282.Metal2 0.000149541f
Cred_13429 vin1.$102.GatPoly VSS.$4227.Metal2 6.7202e-08f
Cred_13430 vin1.$102.GatPoly VSS.P1.pSD 0.00369707f
Cred_13431 vin1.$102.GatPoly VSS.P35.nSD 2.65729e-05f
Cred_13432 vin1.$105.GatPoly vout1.$1292.Metal3 0.00513649f
Cred_13433 vin1.$105.GatPoly vout1.$1358.Metal3 0.00513649f
Cred_13434 vin1.$105.GatPoly vout1.P10.nSD 8.09205e-05f
Cred_13435 vin1.$105.GatPoly vout1.P10.pSD 0.00990689f
Cred_13436 vin1.$107.GatPoly vout1.$1292.Metal3 0.0244564f
Cred_13437 vin1.$107.GatPoly vout1.$1358.Metal3 0.0304463f
Cred_13438 vin1.$107.GatPoly vout1.P10.nSD 0.000385287f
Cred_13439 vin1.$107.GatPoly vout1.P10.pSD 0.0348187f
Cred_13440 vin1.$107.GatPoly vout1.P12.pSD 0.000455774f
Cred_13441 vin1.$108.GatPoly vout1.$1292.Metal3 0.00168266f
Cred_13442 vin1.$108.GatPoly vout1.$1358.Metal3 0.00210155f
Cred_13443 vin1.$108.GatPoly vout1.P10.nSD 0.002228f
Cred_13444 vin1.$108.GatPoly vout1.P10.pSD 0.000143573f
Cred_13445 vin1.$108.GatPoly vout1.P12.nSD 3.92785e-06f
Cred_13446 vin1.$108.GatPoly VSS.$1205.Metal1 4.53682e-07f
Cred_13447 vin1.$108.GatPoly VSS.$1245.Metal1 1.48102e-06f
Cred_13448 vin1.$108.GatPoly VSS.$1265.Metal1 0.0011929f
Cred_13449 vin1.$108.GatPoly VSS.$1989.Metal1 8.02145e-06f
Cred_13450 vin1.$108.GatPoly VSS.$2020.Metal1 2.00841e-05f
Cred_13451 vin1.$108.GatPoly VSS.$29.Metal1 1.23946e-05f
Cred_13452 vin1.$108.GatPoly VSS.$3386.Metal2 3.79032e-09f
Cred_13453 vin1.$108.GatPoly VSS.$3445.Metal2 0.000392707f
Cred_13454 vin1.$108.GatPoly VSS.$3477.Metal2 0.000118436f
Cred_13455 vin1.$108.GatPoly VSS.$4227.Metal2 5.3771e-08f
Cred_13456 vin1.$108.GatPoly VSS.P1.pSD 0.00256124f
Cred_13457 vin1.$108.GatPoly VSS.P37.nSD 4.4642e-05f
Cred_13458 vin1.$110.GatPoly vout1.$1292.Metal3 0.00115252f
Cred_13459 vin1.$110.GatPoly vout1.$1358.Metal3 0.00175093f
Cred_13460 vin1.$110.GatPoly vout1.P10.nSD 0.00102547f
Cred_13461 vin1.$110.GatPoly vout1.P10.pSD 9.83392e-05f
Cred_13462 vin1.$110.GatPoly vout1.P12.nSD 5.61121e-06f
Cred_13463 vin1.$110.GatPoly VSS.$1205.Metal1 2.98183e-07f
Cred_13464 vin1.$110.GatPoly VSS.$1245.Metal1 1.29111e-05f
Cred_13465 vin1.$110.GatPoly VSS.$1265.Metal1 0.00732535f
Cred_13466 vin1.$110.GatPoly VSS.$1989.Metal1 1.06001e-05f
Cred_13467 vin1.$110.GatPoly VSS.$2020.Metal1 2.65406e-05f
Cred_13468 vin1.$110.GatPoly VSS.$29.Metal1 1.20084e-05f
Cred_13469 vin1.$110.GatPoly VSS.$3386.Metal2 2.49119e-09f
Cred_13470 vin1.$110.GatPoly VSS.$3445.Metal2 0.000809477f
Cred_13471 vin1.$110.GatPoly VSS.$3477.Metal2 0.000244128f
Cred_13472 vin1.$110.GatPoly VSS.$4227.Metal2 7.10568e-08f
Cred_13473 vin1.$110.GatPoly VSS.P1.pSD 0.00289365f
Cred_13474 vin1.$110.GatPoly VSS.P37.nSD 0.000202016f
Cred_13475 vin1.$115.GatPoly vout1.$1292.Metal3 0.000678878f
Cred_13476 vin1.$115.GatPoly vout1.$1358.Metal3 0.0128531f
Cred_13477 vin1.$115.GatPoly vout1.P10.nSD 1.06951e-05f
Cred_13478 vin1.$115.GatPoly vout1.P10.pSD 0.000166405f
Cred_13479 vin1.$115.GatPoly vout1.P12.pSD 0.0077353f
Cred_13480 vin1.$118.GatPoly vout1.$1292.Metal3 0.000253425f
Cred_13481 vin1.$118.GatPoly vout1.$1358.Metal3 0.00238925f
Cred_13482 vin1.$118.GatPoly vout1.P10.nSD 8.98535e-06f
Cred_13483 vin1.$118.GatPoly vout1.P10.pSD 2.16235e-05f
Cred_13484 vin1.$118.GatPoly vout1.P12.nSD 0.000861929f
Cred_13485 vin1.$118.GatPoly VSS.$1265.Metal1 0.00823109f
Cred_13486 vin1.$118.GatPoly VSS.$1364.Metal1 3.74658e-06f
Cred_13487 vin1.$118.GatPoly VSS.$1989.Metal1 1.47882e-05f
Cred_13488 vin1.$118.GatPoly VSS.$2020.Metal1 3.70266e-05f
Cred_13489 vin1.$118.GatPoly VSS.$29.Metal1 1.15031e-05f
Cred_13490 vin1.$118.GatPoly VSS.$3445.Metal2 0.000786752f
Cred_13491 vin1.$118.GatPoly VSS.$3477.Metal2 0.000237304f
Cred_13492 vin1.$118.GatPoly VSS.$3501.Metal2 9.81705e-08f
Cred_13493 vin1.$118.GatPoly VSS.$4227.Metal2 9.9131e-08f
Cred_13494 vin1.$118.GatPoly VSS.P1.pSD 0.00333817f
Cred_13495 vin1.$118.GatPoly VSS.P37.nSD 0.000219362f
Cred_13496 vin1.$122.GatPoly vout1.$1292.Metal3 0.000106508f
Cred_13497 vin1.$122.GatPoly vout1.$1358.Metal3 0.0090962f
Cred_13498 vin1.$122.GatPoly vout1.$1424.Metal3 2.65924e-05f
Cred_13499 vin1.$122.GatPoly vout1.P10.nSD 3.77632e-06f
Cred_13500 vin1.$122.GatPoly vout1.P10.pSD 9.08784e-06f
Cred_13501 vin1.$122.GatPoly vout1.P12.nSD 0.00591517f
Cred_13502 vin1.$122.GatPoly vout1.P14.nSD 9.42849e-07f
Cred_13503 vin1.$122.GatPoly vout1.P14.pSD 2.269e-06f
Cred_13504 vin1.$122.GatPoly VSS.$1265.Metal1 0.000635031f
Cred_13505 vin1.$122.GatPoly VSS.$1466.Metal1 0.000169257f
Cred_13506 vin1.$122.GatPoly VSS.$1989.Metal1 2.0133e-05f
Cred_13507 vin1.$122.GatPoly VSS.$2020.Metal1 5.04089e-05f
Cred_13508 vin1.$122.GatPoly VSS.$29.Metal1 1.00489e-05f
Cred_13509 vin1.$122.GatPoly VSS.$3445.Metal2 0.000207253f
Cred_13510 vin1.$122.GatPoly VSS.$3477.Metal2 6.25048e-05f
Cred_13511 vin1.$122.GatPoly VSS.$3597.Metal2 2.08531e-06f
Cred_13512 vin1.$122.GatPoly VSS.$3632.Metal2 5.4913e-05f
Cred_13513 vin1.$122.GatPoly VSS.$4227.Metal2 1.34959e-07f
Cred_13514 vin1.$122.GatPoly VSS.P1.pSD 0.00363f
Cred_13515 vin1.$122.GatPoly VSS.P37.nSD 2.37653e-05f
Cred_13516 vin1.$122.GatPoly VSS.P39.nSD 1.40717e-06f
Cred_13517 vin1.$123.GatPoly vout1.$1292.Metal3 0.000877157f
Cred_13518 vin1.$123.GatPoly vout1.$1358.Metal3 0.0274113f
Cred_13519 vin1.$123.GatPoly vout1.P10.nSD 1.38188e-05f
Cred_13520 vin1.$123.GatPoly vout1.P10.pSD 0.000215008f
Cred_13521 vin1.$123.GatPoly vout1.P12.pSD 0.0188942f
Cred_13522 vin1.$127.GatPoly vout1.$1358.Metal3 0.0563073f
Cred_13523 vin1.$127.GatPoly vout1.$1424.Metal3 0.00286031f
Cred_13524 vin1.$127.GatPoly vout1.P12.pSD 0.0346375f
Cred_13525 vin1.$127.GatPoly vout1.P14.nSD 4.50615e-05f
Cred_13526 vin1.$127.GatPoly vout1.P14.pSD 0.000701114f
Cred_13527 vin1.$130.GatPoly vout1.$1358.Metal3 0.00469248f
Cred_13528 vin1.$130.GatPoly vout1.$1424.Metal3 0.000411585f
Cred_13529 vin1.$130.GatPoly vout1.P12.nSD 0.00211167f
Cred_13530 vin1.$130.GatPoly vout1.P14.nSD 1.4593e-05f
Cred_13531 vin1.$130.GatPoly vout1.P14.pSD 3.51185e-05f
Cred_13532 vin1.$130.GatPoly VSS.$1364.Metal1 2.28603e-07f
Cred_13533 vin1.$130.GatPoly VSS.$1412.Metal1 2.16492e-05f
Cred_13534 vin1.$130.GatPoly VSS.$1463.Metal1 0.000751257f
Cred_13535 vin1.$130.GatPoly VSS.$1466.Metal1 0.00513046f
Cred_13536 vin1.$130.GatPoly VSS.$1989.Metal1 2.26569e-05f
Cred_13537 vin1.$130.GatPoly VSS.$2020.Metal1 5.67283e-05f
Cred_13538 vin1.$130.GatPoly VSS.$29.Metal1 7.28406e-06f
Cred_13539 vin1.$130.GatPoly VSS.$3549.Metal2 4.84579e-08f
Cred_13540 vin1.$130.GatPoly VSS.$3597.Metal2 3.45181e-05f
Cred_13541 vin1.$130.GatPoly VSS.$3632.Metal2 0.000904124f
Cred_13542 vin1.$130.GatPoly VSS.$4227.Metal2 1.51878e-07f
Cred_13543 vin1.$130.GatPoly VSS.$4955.Metal3 3.73213e-10f
Cred_13544 vin1.$130.GatPoly VSS.P1.pSD 0.00326543f
Cred_13545 vin1.$130.GatPoly VSS.P39.nSD 4.46155e-05f
Cred_13546 vin1.$134.GatPoly VSS.$1412.Metal1 0.000101628f
Cred_13547 vin1.$134.GatPoly VSS.$1463.Metal1 0.00548286f
Cred_13548 vin1.$134.GatPoly VSS.$1466.Metal1 0.00687275f
Cred_13549 vin1.$134.GatPoly VSS.$1503.Metal1 7.03154e-08f
Cred_13550 vin1.$134.GatPoly VSS.$1571.Metal1 2.63576e-09f
Cred_13551 vin1.$134.GatPoly VSS.$1989.Metal1 2.50615e-05f
Cred_13552 vin1.$134.GatPoly VSS.$2020.Metal1 6.27489e-05f
Cred_13553 vin1.$134.GatPoly VSS.$29.Metal1 5.60979e-06f
Cred_13554 vin1.$134.GatPoly VSS.$3597.Metal2 6.46772e-06f
Cred_13555 vin1.$134.GatPoly VSS.$3632.Metal2 0.000147958f
Cred_13556 vin1.$134.GatPoly VSS.$3688.Metal2 4.42625e-11f
Cred_13557 vin1.$134.GatPoly VSS.$3712.Metal2 2.20213e-11f
Cred_13558 vin1.$134.GatPoly VSS.$4227.Metal2 1.67997e-07f
Cred_13559 vin1.$134.GatPoly VSS.P1.pSD 0.00300467f
Cred_13560 vin1.$134.GatPoly VSS.P39.nSD 6.41932e-05f
Cred_13561 vin1.$135.GatPoly vout1.$1358.Metal3 3.10023e-08f
Cred_13562 vin1.$135.GatPoly vout1.$1424.Metal3 1.31326e-08f
Cred_13563 vin1.$135.GatPoly vout1.P12.pSD 1.16045e-09f
Cred_13564 vin1.$135.GatPoly vout1.P14.nSD 2.06892e-10f
Cred_13565 vin1.$135.GatPoly vout1.P14.pSD 2.28099e-09f
Cred_13566 vin1.$136.GatPoly vout1.$1358.Metal3 0.00499834f
Cred_13567 vin1.$136.GatPoly vout1.$1424.Metal3 0.00354951f
Cred_13568 vin1.$136.GatPoly vout1.P12.nSD 1.35855e-05f
Cred_13569 vin1.$136.GatPoly vout1.P14.nSD 0.00342762f
Cred_13570 vin1.$136.GatPoly vout1.P14.pSD 0.000302862f
Cred_13571 vin1.$136.GatPoly VSS.$1466.Metal1 0.0053483f
Cred_13572 vin1.$136.GatPoly VSS.$1503.Metal1 9.19509e-08f
Cred_13573 vin1.$136.GatPoly VSS.$1571.Metal1 3.44676e-09f
Cred_13574 vin1.$136.GatPoly VSS.$1989.Metal1 2.64529e-05f
Cred_13575 vin1.$136.GatPoly VSS.$2020.Metal1 6.62327e-05f
Cred_13576 vin1.$136.GatPoly VSS.$29.Metal1 4.23571e-06f
Cred_13577 vin1.$136.GatPoly VSS.$3597.Metal2 5.48618e-05f
Cred_13578 vin1.$136.GatPoly VSS.$3632.Metal2 0.00144469f
Cred_13579 vin1.$136.GatPoly VSS.$3688.Metal2 5.78817e-11f
Cred_13580 vin1.$136.GatPoly VSS.$3712.Metal2 2.87971e-11f
Cred_13581 vin1.$136.GatPoly VSS.$4227.Metal2 1.77324e-07f
Cred_13582 vin1.$136.GatPoly VSS.P1.pSD 0.00266835f
Cred_13583 vin1.$136.GatPoly VSS.P39.nSD 4.45362e-05f
Cred_13584 vin1.$137.GatPoly vout1.$1358.Metal3 0.031535f
Cred_13585 vin1.$137.GatPoly vout1.$1424.Metal3 0.0255253f
Cred_13586 vin1.$137.GatPoly vout1.P12.pSD 0.000457058f
Cred_13587 vin1.$137.GatPoly vout1.P14.nSD 0.000402127f
Cred_13588 vin1.$137.GatPoly vout1.P14.pSD 0.0365848f
Cred_13589 vin1.$144.GatPoly vout1.$1358.Metal3 0.00355408f
Cred_13590 vin1.$144.GatPoly vout1.$1424.Metal3 0.00373487f
Cred_13591 vin1.$144.GatPoly vout1.P14.nSD 0.00542225f
Cred_13592 vin1.$144.GatPoly vout1.P14.pSD 0.000303252f
Cred_13593 vin1.$144.GatPoly vout1.P16.nSD 1.69521e-06f
Cred_13594 vin1.$144.GatPoly VSS.$1623.Metal1 0.00049805f
Cred_13595 vin1.$144.GatPoly VSS.$1989.Metal1 4.56998e-05f
Cred_13596 vin1.$144.GatPoly VSS.$2020.Metal1 0.000114423f
Cred_13597 vin1.$144.GatPoly VSS.$29.Metal1 5.13245e-06f
Cred_13598 vin1.$144.GatPoly VSS.$3784.Metal2 6.60099e-05f
Cred_13599 vin1.$144.GatPoly VSS.$3819.Metal2 0.000150503f
Cred_13600 vin1.$144.GatPoly VSS.$4227.Metal2 3.06344e-07f
Cred_13601 vin1.$144.GatPoly VSS.P1.pSD 0.00383389f
Cred_13602 vin1.$144.GatPoly VSS.P41.nSD 1.86375e-05f
Cred_13603 vin1.$145.GatPoly vout1.$1358.Metal3 0.00988551f
Cred_13604 vin1.$145.GatPoly vout1.$1424.Metal3 0.0110746f
Cred_13605 vin1.$145.GatPoly vout1.P14.nSD 0.000155737f
Cred_13606 vin1.$145.GatPoly vout1.P14.pSD 0.0161545f
Cred_13607 vin1.$145.GatPoly vout1.P16.pSD 9.04344e-05f
Cred_13608 vin1.$15.GatPoly vout1.$1226.Metal3 0.0508176f
Cred_13609 vin1.$15.GatPoly vout1.P0.nSD 0.000803016f
Cred_13610 vin1.$15.GatPoly vout1.P0.pSD 0.00487722f
Cred_13611 vin1.$15.GatPoly vout1.P2.nSD 0.000800583f
Cred_13612 vin1.$15.GatPoly vout1.P2.pSD 0.0392747f
Cred_13613 vin1.$152.GatPoly vout1.$1358.Metal3 0.000662949f
Cred_13614 vin1.$152.GatPoly vout1.$1424.Metal3 0.000984583f
Cred_13615 vin1.$152.GatPoly vout1.P14.nSD 0.000634338f
Cred_13616 vin1.$152.GatPoly vout1.P14.pSD 5.65662e-05f
Cred_13617 vin1.$152.GatPoly vout1.P16.nSD 3.01592e-06f
Cred_13618 vin1.$152.GatPoly VSS.$1623.Metal1 0.0121868f
Cred_13619 vin1.$152.GatPoly VSS.$1989.Metal1 5.42463e-05f
Cred_13620 vin1.$152.GatPoly VSS.$2020.Metal1 0.000135822f
Cred_13621 vin1.$152.GatPoly VSS.$29.Metal1 3.55355e-06f
Cred_13622 vin1.$152.GatPoly VSS.$3784.Metal2 0.000322837f
Cred_13623 vin1.$152.GatPoly VSS.$3819.Metal2 0.000736069f
Cred_13624 vin1.$152.GatPoly VSS.$4227.Metal2 3.63635e-07f
Cred_13625 vin1.$152.GatPoly VSS.P1.pSD 0.00343121f
Cred_13626 vin1.$152.GatPoly VSS.P41.nSD 0.000321264f
Cred_13627 vin1.$153.GatPoly vout1.$1358.Metal3 0.00887412f
Cred_13628 vin1.$153.GatPoly vout1.$1424.Metal3 0.0109896f
Cred_13629 vin1.$153.GatPoly vout1.P14.nSD 0.000139803f
Cred_13630 vin1.$153.GatPoly vout1.P14.pSD 0.0126694f
Cred_13631 vin1.$153.GatPoly vout1.P16.pSD 0.00016089f
Cred_13632 vin1.$156.GatPoly vout1.$1358.Metal3 0.000689567f
Cred_13633 vin1.$156.GatPoly vout1.$1424.Metal3 0.00808297f
Cred_13634 vin1.$156.GatPoly vout1.P14.nSD 2.4449e-05f
Cred_13635 vin1.$156.GatPoly vout1.P14.pSD 5.88374e-05f
Cred_13636 vin1.$156.GatPoly vout1.P16.nSD 0.00329172f
Cred_13637 vin1.$156.GatPoly VSS.$1623.Metal1 0.0068704f
Cred_13638 vin1.$156.GatPoly VSS.$1989.Metal1 6.35814e-05f
Cred_13639 vin1.$156.GatPoly VSS.$2020.Metal1 0.000159195f
Cred_13640 vin1.$156.GatPoly VSS.$29.Metal1 2.66958e-06f
Cred_13641 vin1.$156.GatPoly VSS.$3784.Metal2 0.000577984f
Cred_13642 vin1.$156.GatPoly VSS.$3819.Metal2 0.0013178f
Cred_13643 vin1.$156.GatPoly VSS.$4227.Metal2 4.26212e-07f
Cred_13644 vin1.$156.GatPoly VSS.P1.pSD 0.00317942f
Cred_13645 vin1.$156.GatPoly VSS.P41.nSD 0.000217338f
Cred_13646 vin1.$157.GatPoly vout1.$1358.Metal3 0.00286031f
Cred_13647 vin1.$157.GatPoly vout1.$1424.Metal3 0.0543541f
Cred_13648 vin1.$157.GatPoly vout1.P14.nSD 4.50615e-05f
Cred_13649 vin1.$157.GatPoly vout1.P14.pSD 0.000701114f
Cred_13650 vin1.$157.GatPoly vout1.P16.pSD 0.032808f
Cred_13651 vin1.$16.GatPoly vout1.$1226.Metal3 0.00169532f
Cred_13652 vin1.$16.GatPoly vout1.P0.nSD 3.44551e-05f
Cred_13653 vin1.$16.GatPoly vout1.P0.pSD 0.000152976f
Cred_13654 vin1.$16.GatPoly vout1.P2.nSD 0.000738215f
Cred_13655 vin1.$16.GatPoly vout1.P2.pSD 0.000145967f
Cred_13656 vin1.$16.GatPoly VSS.$1989.Metal1 4.13632e-07f
Cred_13657 vin1.$16.GatPoly VSS.$2020.Metal1 1.03565e-06f
Cred_13658 vin1.$16.GatPoly VSS.$2526.Metal2 0.0004027f
Cred_13659 vin1.$16.GatPoly VSS.$2558.Metal2 0.000540801f
Cred_13660 vin1.$16.GatPoly VSS.$2614.Metal2 3.40456e-08f
Cred_13661 vin1.$16.GatPoly VSS.$29.Metal1 0.000349646f
Cred_13662 vin1.$16.GatPoly VSS.$385.Metal1 0.00935976f
Cred_13663 vin1.$16.GatPoly VSS.$4227.Metal2 2.77274e-09f
Cred_13664 vin1.$16.GatPoly VSS.$4511.Metal3 2.66708e-10f
Cred_13665 vin1.$16.GatPoly VSS.$456.Metal1 1.61848e-06f
Cred_13666 vin1.$16.GatPoly VSS.$504.Metal1 9.35005e-08f
Cred_13667 vin1.$16.GatPoly VSS.P1.pSD 0.00280538f
Cred_13668 vin1.$16.GatPoly VSS.P27.nSD 0.000255668f
Cred_13669 vin1.$163.GatPoly vout1.$1424.Metal3 0.00960736f
Cred_13670 vin1.$163.GatPoly vout1.P16.pSD 0.00750068f
Cred_13671 vin1.$164.GatPoly vout1 2.45242e-05f
Cred_13672 vin1.$164.GatPoly vout1.$1424.Metal3 0.00809357f
Cred_13673 vin1.$164.GatPoly vout1.P16.nSD 0.00541443f
Cred_13674 vin1.$164.GatPoly vout1.P18.nSD 3.45556e-06f
Cred_13675 vin1.$164.GatPoly vout1.P18.pSD 1.05536e-05f
Cred_13676 vin1.$164.GatPoly VSS.$1798.Metal1 0.000453293f
Cred_13677 vin1.$164.GatPoly VSS.$1989.Metal1 9.62957e-05f
Cred_13678 vin1.$164.GatPoly VSS.$2020.Metal1 0.000241105f
Cred_13679 vin1.$164.GatPoly VSS.$29.Metal1 2.71637e-06f
Cred_13680 vin1.$164.GatPoly VSS.$3982.Metal2 0.000110826f
Cred_13681 vin1.$164.GatPoly VSS.$4014.Metal2 8.25299e-05f
Cred_13682 vin1.$164.GatPoly VSS.$4227.Metal2 6.45509e-07f
Cred_13683 vin1.$164.GatPoly VSS.P1.pSD 0.00389309f
Cred_13684 vin1.$164.GatPoly VSS.P43.nSD 1.69634e-05f
Cred_13685 vin1.$167.GatPoly vout1 0.000917059f
Cred_13686 vin1.$167.GatPoly vout1.$1424.Metal3 0.0594151f
Cred_13687 vin1.$167.GatPoly vout1.P16.pSD 0.0353919f
Cred_13688 vin1.$167.GatPoly vout1.P18.nSD 7.28651e-05f
Cred_13689 vin1.$167.GatPoly vout1.P18.pSD 0.000851701f
Cred_13690 vin1.$17.GatPoly vout1.$1226.Metal3 9.75242e-08f
Cred_13691 vin1.$17.GatPoly vout1.P0.nSD 1.4123e-09f
Cred_13692 vin1.$17.GatPoly vout1.P0.pSD 7.50474e-09f
Cred_13693 vin1.$17.GatPoly vout1.P2.nSD 1.5364e-09f
Cred_13694 vin1.$17.GatPoly vout1.P2.pSD 8.39679e-09f
Cred_13695 vin1.$172.GatPoly vout1 5.48779e-05f
Cred_13696 vin1.$172.GatPoly vout1.$1424.Metal3 0.0019692f
Cred_13697 vin1.$172.GatPoly vout1.P16.nSD 0.000711506f
Cred_13698 vin1.$172.GatPoly vout1.P18.nSD 7.73254e-06f
Cred_13699 vin1.$172.GatPoly vout1.P18.pSD 2.36159e-05f
Cred_13700 vin1.$172.GatPoly VSS.$1730.Metal1 9.35005e-08f
Cred_13701 vin1.$172.GatPoly VSS.$1778.Metal1 1.61848e-06f
Cred_13702 vin1.$172.GatPoly VSS.$1798.Metal1 0.00977471f
Cred_13703 vin1.$172.GatPoly VSS.$1989.Metal1 9.20342e-05f
Cred_13704 vin1.$172.GatPoly VSS.$2020.Metal1 0.000230435f
Cred_13705 vin1.$172.GatPoly VSS.$29.Metal1 1.57436e-06f
Cred_13706 vin1.$172.GatPoly VSS.$3923.Metal2 3.40456e-08f
Cred_13707 vin1.$172.GatPoly VSS.$3982.Metal2 0.000562129f
Cred_13708 vin1.$172.GatPoly VSS.$4014.Metal2 0.000418582f
Cred_13709 vin1.$172.GatPoly VSS.$4227.Metal2 6.16942e-07f
Cred_13710 vin1.$172.GatPoly VSS.$5123.Metal3 2.66708e-10f
Cred_13711 vin1.$172.GatPoly VSS.P1.pSD 0.00283182f
Cred_13712 vin1.$172.GatPoly VSS.P43.nSD 0.00027123f
Cred_13713 vin1.$173.GatPoly vout1.$1424.Metal3 1.16374e-07f
Cred_13714 vin1.$176.GatPoly vout1 9.62364e-05f
Cred_13715 vin1.$176.GatPoly vout1.$1424.Metal3 0.000765661f
Cred_13716 vin1.$176.GatPoly vout1.P16.nSD 2.62829e-06f
Cred_13717 vin1.$176.GatPoly vout1.P18.nSD 0.000256822f
Cred_13718 vin1.$176.GatPoly vout1.P18.pSD 4.14139e-05f
Cred_13719 vin1.$176.GatPoly VSS.$1798.Metal1 0.00875726f
Cred_13720 vin1.$176.GatPoly VSS.$1869.Metal1 3.65208e-06f
Cred_13721 vin1.$176.GatPoly VSS.$1989.Metal1 9.99276e-05f
Cred_13722 vin1.$176.GatPoly VSS.$2020.Metal1 0.000250198f
Cred_13723 vin1.$176.GatPoly VSS.$29.Metal1 1.2188e-06f
Cred_13724 vin1.$176.GatPoly VSS.$3982.Metal2 0.000313817f
Cred_13725 vin1.$176.GatPoly VSS.$4014.Metal2 0.000233724f
Cred_13726 vin1.$176.GatPoly VSS.$4062.Metal2 1.82757e-08f
Cred_13727 vin1.$176.GatPoly VSS.$4227.Metal2 6.69855e-07f
Cred_13728 vin1.$176.GatPoly VSS.$5159.Metal3 1.46531e-10f
Cred_13729 vin1.$176.GatPoly VSS.P1.pSD 0.00254932f
Cred_13730 vin1.$176.GatPoly VSS.P43.nSD 0.000232966f
Cred_13731 vin1.$179.GatPoly vout1 0.00802799f
Cred_13732 vin1.$179.GatPoly vout1.$1424.Metal3 0.0455281f
Cred_13733 vin1.$179.GatPoly vout1.P16.pSD 0.000356917f
Cred_13734 vin1.$179.GatPoly vout1.P18.nSD 0.000637866f
Cred_13735 vin1.$179.GatPoly vout1.P18.pSD 0.038301f
Cred_13736 vin1.$179.GatPoly VSS.$4134.Metal2 0.000109957f
Cred_13737 vin1.$180.GatPoly vout1 0.00145658f
Cred_13738 vin1.$180.GatPoly vout1.$1424.Metal3 0.00762653f
Cred_13739 vin1.$180.GatPoly vout1.P16.nSD 2.62829e-06f
Cred_13740 vin1.$180.GatPoly vout1.P18.nSD 0.00567469f
Cred_13741 vin1.$180.GatPoly vout1.P18.pSD 0.000626818f
Cred_13742 vin1.$180.GatPoly VSS.$1798.Metal1 0.00053061f
Cred_13743 vin1.$180.GatPoly VSS.$1917.Metal1 2.21677e-05f
Cred_13744 vin1.$180.GatPoly VSS.$1977.Metal1 2.28935e-05f
Cred_13745 vin1.$180.GatPoly VSS.$1989.Metal1 0.000246669f
Cred_13746 vin1.$180.GatPoly VSS.$2020.Metal1 0.000835746f
Cred_13747 vin1.$180.GatPoly VSS.$29.Metal1 1.76328e-06f
Cred_13748 vin1.$180.GatPoly VSS.$3982.Metal2 2.72725e-05f
Cred_13749 vin1.$180.GatPoly VSS.$4014.Metal2 2.03093e-05f
Cred_13750 vin1.$180.GatPoly VSS.$4110.Metal2 2.03611e-06f
Cred_13751 vin1.$180.GatPoly VSS.$4134.Metal2 1.9141e-07f
Cred_13752 vin1.$180.GatPoly VSS.$4227.Metal2 6.8619e-06f
Cred_13753 vin1.$180.GatPoly VSS.P1.pSD 0.00459525f
Cred_13754 vin1.$180.GatPoly VSS.P3.GatPoly 0.000406711f
Cred_13755 vin1.$180.GatPoly VSS.P43.nSD 1.99003e-05f
Cred_13756 vin1.$180.GatPoly VSS.P45.nSD 1.46261e-06f
Cred_13757 vin1.$180.GatPoly VSS.P47.nSD 1.46261e-06f
Cred_13758 vin1.$202.Metal1 vout1.$1226.Metal3 0.0308776f
Cred_13759 vin1.$202.Metal1 vout1.P0.nSD 0.0281766f
Cred_13760 vin1.$202.Metal1 vout1.P0.pSD 0.00487564f
Cred_13761 vin1.$202.Metal1 vout1.P2.nSD 0.000487838f
Cred_13762 vin1.$202.Metal1 vout1.P2.pSD 0.00265855f
Cred_13763 vin1.$202.Metal1 VSS.$157.Metal1 0.000987941f
Cred_13764 vin1.$202.Metal1 VSS.$1989.Metal1 5.81131e-06f
Cred_13765 vin1.$202.Metal1 VSS.$2020.Metal1 1.45504e-05f
Cred_13766 vin1.$202.Metal1 VSS.$2226.Metal2 0.00212247f
Cred_13767 vin1.$202.Metal1 VSS.$2342.Metal2 1.87708e-05f
Cred_13768 vin1.$202.Metal1 VSS.$2403.Metal2 0.000145294f
Cred_13769 vin1.$202.Metal1 VSS.$2427.Metal2 0.00014213f
Cred_13770 vin1.$202.Metal1 VSS.$2475.Metal2 2.30851e-05f
Cred_13771 vin1.$202.Metal1 VSS.$2526.Metal2 0.00027649f
Cred_13772 vin1.$202.Metal1 VSS.$2558.Metal2 0.000340553f
Cred_13773 vin1.$202.Metal1 VSS.$257.Metal1 0.000632286f
Cred_13774 vin1.$202.Metal1 VSS.$29.Metal1 0.0119916f
Cred_13775 vin1.$202.Metal1 VSS.$317.Metal1 0.00075064f
Cred_13776 vin1.$202.Metal1 VSS.$365.Metal1 0.00151066f
Cred_13777 vin1.$202.Metal1 VSS.$385.Metal1 0.006826f
Cred_13778 vin1.$202.Metal1 VSS.$4227.Metal2 3.89556e-08f
Cred_13779 vin1.$202.Metal1 VSS.$4355.Metal3 0.000496882f
Cred_13780 vin1.$202.Metal1 VSS.$4415.Metal3 1.66269e-07f
Cred_13781 vin1.$202.Metal1 VSS.$4475.Metal3 1.75811e-07f
Cred_13782 vin1.$202.Metal1 VSS.P1.pSD 0.0559358f
Cred_13783 vin1.$202.Metal1 VSS.P2.GatPoly 0.00157389f
Cred_13784 vin1.$202.Metal1 VSS.P24.nSD 6.31796e-06f
Cred_13785 vin1.$202.Metal1 VSS.P25.nSD 6.31796e-06f
Cred_13786 vin1.$202.Metal1 VSS.P27.nSD 0.000253611f
Cred_13787 vin1.$203.Metal1 vout1.$1226.Metal3 0.0619989f
Cred_13788 vin1.$203.Metal1 vout1.P0.nSD 0.00184613f
Cred_13789 vin1.$203.Metal1 vout1.P0.pSD 0.0676836f
Cred_13790 vin1.$203.Metal1 vout1.P2.nSD 0.000976734f
Cred_13791 vin1.$203.Metal1 vout1.P2.pSD 0.00533807f
Cred_13792 vin1.$203.Metal1 VSS.$1989.Metal1 6.68733e-08f
Cred_13793 vin1.$203.Metal1 VSS.$2020.Metal1 1.67437e-07f
Cred_13794 vin1.$203.Metal1 VSS.$2403.Metal2 1.07689e-05f
Cred_13795 vin1.$203.Metal1 VSS.$2427.Metal2 7.89696e-06f
Cred_13796 vin1.$203.Metal1 VSS.$29.Metal1 0.0005763f
Cred_13797 vin1.$203.Metal1 VSS.$4227.Metal2 4.48279e-10f
Cred_13798 vin1.$203.Metal1 VSS.$4415.Metal3 0.00134312f
Cred_13799 vin1.$203.Metal1 VSS.$4451.Metal3 0.000984932f
Cred_13800 vin1.$203.Metal1 VSS.P1.pSD 0.0011088f
Cred_13801 vin1.$203.Metal1 VSS.P2.GatPoly 8.90637e-05f
Cred_13802 vin1.$207.Metal1 vout1.$1226.Metal3 8.52779e-06f
Cred_13803 vin1.$207.Metal1 vout1.P0.nSD 2.53931e-07f
Cred_13804 vin1.$207.Metal1 vout1.P0.pSD 1.34935e-06f
Cred_13805 vin1.$207.Metal1 vout1.P2.nSD 1.34347e-07f
Cred_13806 vin1.$207.Metal1 vout1.P2.pSD 7.34239e-07f
Cred_13807 vin1.$210.Metal1 vout1.$1226.Metal3 1.23751e-05f
Cred_13808 vin1.$210.Metal1 vout1.P0.nSD 2.43471e-07f
Cred_13809 vin1.$210.Metal1 vout1.P0.pSD 1.29377e-06f
Cred_13810 vin1.$210.Metal1 vout1.P2.nSD 1.94958e-07f
Cred_13811 vin1.$210.Metal1 vout1.P2.pSD 1.06549e-06f
Cred_13812 vin1.$210.Metal1 VSS.$1989.Metal1 2.98062e-06f
Cred_13813 vin1.$210.Metal1 VSS.$2020.Metal1 7.46286e-06f
Cred_13814 vin1.$210.Metal1 VSS.$2475.Metal2 1.53248e-06f
Cred_13815 vin1.$210.Metal1 VSS.$2526.Metal2 0.00154814f
Cred_13816 vin1.$210.Metal1 VSS.$2558.Metal2 0.00207838f
Cred_13817 vin1.$210.Metal1 VSS.$2614.Metal2 2.85347e-06f
Cred_13818 vin1.$210.Metal1 VSS.$29.Metal1 0.00297087f
Cred_13819 vin1.$210.Metal1 VSS.$365.Metal1 0.000306238f
Cred_13820 vin1.$210.Metal1 VSS.$385.Metal1 0.0419833f
Cred_13821 vin1.$210.Metal1 VSS.$4227.Metal2 1.99803e-08f
Cred_13822 vin1.$210.Metal1 VSS.$4475.Metal3 1.22871e-08f
Cred_13823 vin1.$210.Metal1 VSS.$4511.Metal3 2.23536e-08f
Cred_13824 vin1.$210.Metal1 VSS.$456.Metal1 0.00013565f
Cred_13825 vin1.$210.Metal1 VSS.$504.Metal1 7.83657e-06f
Cred_13826 vin1.$210.Metal1 VSS.P1.pSD 0.0217349f
Cred_13827 vin1.$210.Metal1 VSS.P27.nSD 0.00156422f
Cred_13828 vin1.$211.Metal1 vout1.$1226.Metal3 8.17381e-06f
Cred_13829 vin1.$211.Metal1 vout1.P0.nSD 1.1837e-07f
Cred_13830 vin1.$211.Metal1 vout1.P0.pSD 6.28996e-07f
Cred_13831 vin1.$211.Metal1 vout1.P2.nSD 1.28771e-07f
Cred_13832 vin1.$211.Metal1 vout1.P2.pSD 7.03761e-07f
Cred_13833 vin1.$218.Metal1 vout1.$1226.Metal3 0.00095452f
Cred_13834 vin1.$218.Metal1 vout1.P0.nSD 1.90611e-05f
Cred_13835 vin1.$218.Metal1 vout1.P0.pSD 8.53615e-05f
Cred_13836 vin1.$218.Metal1 vout1.P2.nSD 0.000391345f
Cred_13837 vin1.$218.Metal1 vout1.P2.pSD 8.21837e-05f
Cred_13838 vin1.$218.Metal1 VSS.$1989.Metal1 2.63095e-06f
Cred_13839 vin1.$218.Metal1 VSS.$2020.Metal1 6.58736e-06f
Cred_13840 vin1.$218.Metal1 VSS.$2526.Metal2 0.000371147f
Cred_13841 vin1.$218.Metal1 VSS.$2558.Metal2 0.000518159f
Cred_13842 vin1.$218.Metal1 VSS.$2614.Metal2 2.09779e-05f
Cred_13843 vin1.$218.Metal1 VSS.$29.Metal1 0.00196061f
Cred_13844 vin1.$218.Metal1 VSS.$385.Metal1 0.00768135f
Cred_13845 vin1.$218.Metal1 VSS.$4227.Metal2 1.76363e-08f
Cred_13846 vin1.$218.Metal1 VSS.$4511.Metal3 1.58436e-07f
Cred_13847 vin1.$218.Metal1 VSS.$456.Metal1 0.00212675f
Cred_13848 vin1.$218.Metal1 VSS.$504.Metal1 0.000145714f
Cred_13849 vin1.$218.Metal1 VSS.P1.pSD 0.0168856f
Cred_13850 vin1.$218.Metal1 VSS.P27.nSD 0.000293242f
Cred_13851 vin1.$219.Metal1 vout1.$1226.Metal3 0.00483512f
Cred_13852 vin1.$219.Metal1 vout1.P0.nSD 7.00202e-05f
Cred_13853 vin1.$219.Metal1 vout1.P0.pSD 0.000372076f
Cred_13854 vin1.$219.Metal1 vout1.P2.nSD 7.61729e-05f
Cred_13855 vin1.$219.Metal1 vout1.P2.pSD 0.00423958f
Cred_13856 vin1.$22.GatPoly vout1.$1226.Metal3 0.00680273f
Cred_13857 vin1.$22.GatPoly vout1.P0.nSD 0.00010294f
Cred_13858 vin1.$22.GatPoly vout1.P0.pSD 0.00053355f
Cred_13859 vin1.$22.GatPoly vout1.P2.nSD 0.0055216f
Cred_13860 vin1.$22.GatPoly vout1.P2.pSD 0.000585712f
Cred_13861 vin1.$22.GatPoly VSS.$1989.Metal1 7.14196e-07f
Cred_13862 vin1.$22.GatPoly VSS.$2020.Metal1 1.7882e-06f
Cred_13863 vin1.$22.GatPoly VSS.$2526.Metal2 8.25299e-05f
Cred_13864 vin1.$22.GatPoly VSS.$2558.Metal2 0.000110826f
Cred_13865 vin1.$22.GatPoly VSS.$29.Metal1 0.000365835f
Cred_13866 vin1.$22.GatPoly VSS.$385.Metal1 0.000453293f
Cred_13867 vin1.$22.GatPoly VSS.$4227.Metal2 4.78754e-09f
Cred_13868 vin1.$22.GatPoly VSS.P1.pSD 0.00386551f
Cred_13869 vin1.$22.GatPoly VSS.P27.nSD 1.69634e-05f
Cred_13870 vin1.$222.Metal1 vout1.$1226.Metal3 0.0137326f
Cred_13871 vin1.$222.Metal1 vout1.P0.nSD 0.00020121f
Cred_13872 vin1.$222.Metal1 vout1.P0.pSD 0.00106208f
Cred_13873 vin1.$222.Metal1 vout1.P2.nSD 0.0131392f
Cred_13874 vin1.$222.Metal1 vout1.P2.pSD 0.00118237f
Cred_13875 vin1.$222.Metal1 VSS.$1989.Metal1 3.06394e-06f
Cred_13876 vin1.$222.Metal1 VSS.$2020.Metal1 7.67148e-06f
Cred_13877 vin1.$222.Metal1 VSS.$2526.Metal2 4.36492e-05f
Cred_13878 vin1.$222.Metal1 VSS.$2558.Metal2 5.86146e-05f
Cred_13879 vin1.$222.Metal1 VSS.$2614.Metal2 4.42291e-06f
Cred_13880 vin1.$222.Metal1 VSS.$29.Metal1 0.00171414f
Cred_13881 vin1.$222.Metal1 VSS.$385.Metal1 0.000239742f
Cred_13882 vin1.$222.Metal1 VSS.$4227.Metal2 2.05388e-08f
Cred_13883 vin1.$222.Metal1 VSS.$456.Metal1 0.000598552f
Cred_13884 vin1.$222.Metal1 VSS.$504.Metal1 0.000529433f
Cred_13885 vin1.$222.Metal1 VSS.P1.pSD 0.0172801f
Cred_13886 vin1.$222.Metal1 VSS.P27.nSD 8.97176e-06f
Cred_13887 vin1.$227.Metal1 vout1.$1226.Metal3 0.0232307f
Cred_13888 vin1.$227.Metal1 vout1.P0.nSD 0.000336417f
Cred_13889 vin1.$227.Metal1 vout1.P0.pSD 0.00178766f
Cred_13890 vin1.$227.Metal1 vout1.P2.nSD 0.000365978f
Cred_13891 vin1.$227.Metal1 vout1.P2.pSD 0.0242275f
Cred_13892 vin1.$228.Metal1 vout1.$1226.Metal3 0.0162804f
Cred_13893 vin1.$228.Metal1 vout1.P0.nSD 0.000235765f
Cred_13894 vin1.$228.Metal1 vout1.P0.pSD 0.00125282f
Cred_13895 vin1.$228.Metal1 vout1.P2.nSD 0.0156675f
Cred_13896 vin1.$228.Metal1 vout1.P2.pSD 0.00140173f
Cred_13897 vin1.$228.Metal1 VSS.$1989.Metal1 3.4995e-06f
Cred_13898 vin1.$228.Metal1 VSS.$2020.Metal1 8.76205e-06f
Cred_13899 vin1.$228.Metal1 VSS.$2662.Metal2 3.39178e-05f
Cred_13900 vin1.$228.Metal1 VSS.$2721.Metal2 1.44928e-05f
Cred_13901 vin1.$228.Metal1 VSS.$2753.Metal2 2.33344e-06f
Cred_13902 vin1.$228.Metal1 VSS.$29.Metal1 0.00153691f
Cred_13903 vin1.$228.Metal1 VSS.$4227.Metal2 2.34586e-08f
Cred_13904 vin1.$228.Metal1 VSS.$4559.Metal3 7.35435e-08f
Cred_13905 vin1.$228.Metal1 VSS.$544.Metal1 7.35435e-08f
Cred_13906 vin1.$228.Metal1 VSS.$564.Metal1 6.60482e-07f
Cred_13907 vin1.$228.Metal1 VSS.P1.pSD 0.017664f
Cred_13908 vin1.$228.Metal1 VSS.P29.nSD 2.29316e-08f
Cred_13909 vin1.$232.Metal1 vout1.$1226.Metal3 0.00029252f
Cred_13910 vin1.$232.Metal1 vout1.P0.nSD 4.23614e-06f
Cred_13911 vin1.$232.Metal1 vout1.P0.pSD 2.25102e-05f
Cred_13912 vin1.$232.Metal1 vout1.P2.nSD 8.68854e-05f
Cred_13913 vin1.$232.Metal1 vout1.P2.pSD 2.51858e-05f
Cred_13914 vin1.$232.Metal1 VSS.$1989.Metal1 2.66606e-06f
Cred_13915 vin1.$232.Metal1 VSS.$2020.Metal1 6.67527e-06f
Cred_13916 vin1.$232.Metal1 VSS.$2662.Metal2 4.38787e-05f
Cred_13917 vin1.$232.Metal1 VSS.$2721.Metal2 2.81555e-05f
Cred_13918 vin1.$232.Metal1 VSS.$2753.Metal2 4.53323e-06f
Cred_13919 vin1.$232.Metal1 VSS.$29.Metal1 0.000939203f
Cred_13920 vin1.$232.Metal1 VSS.$4227.Metal2 1.78716e-08f
Cred_13921 vin1.$232.Metal1 VSS.$4559.Metal3 1.42875e-07f
Cred_13922 vin1.$232.Metal1 VSS.$504.Metal1 0.000407947f
Cred_13923 vin1.$232.Metal1 VSS.$544.Metal1 0.00101873f
Cred_13924 vin1.$232.Metal1 VSS.$564.Metal1 1.28313e-06f
Cred_13925 vin1.$232.Metal1 VSS.P1.pSD 0.0121624f
Cred_13926 vin1.$232.Metal1 VSS.P29.nSD 4.45497e-08f
Cred_13927 vin1.$233.Metal1 vout1.$1226.Metal3 0.00390011f
Cred_13928 vin1.$233.Metal1 vout1.P0.nSD 5.64797e-05f
Cred_13929 vin1.$233.Metal1 vout1.P0.pSD 0.000300124f
Cred_13930 vin1.$233.Metal1 vout1.P2.nSD 6.14426e-05f
Cred_13931 vin1.$233.Metal1 vout1.P2.pSD 0.00325896f
Cred_13932 vin1.$236.Metal1 vout1.$1226.Metal3 0.000124248f
Cred_13933 vin1.$236.Metal1 vout1.P0.nSD 1.79931e-06f
Cred_13934 vin1.$236.Metal1 vout1.P0.pSD 9.56121e-06f
Cred_13935 vin1.$236.Metal1 vout1.P2.nSD 1.26286e-05f
Cred_13936 vin1.$236.Metal1 vout1.P2.pSD 1.06977e-05f
Cred_13937 vin1.$236.Metal1 VSS.$1989.Metal1 2.96102e-06f
Cred_13938 vin1.$236.Metal1 VSS.$2020.Metal1 7.41379e-06f
Cred_13939 vin1.$236.Metal1 VSS.$2662.Metal2 2.79061e-05f
Cred_13940 vin1.$236.Metal1 VSS.$2721.Metal2 0.000725046f
Cred_13941 vin1.$236.Metal1 VSS.$2753.Metal2 0.000310638f
Cred_13942 vin1.$236.Metal1 VSS.$29.Metal1 0.000888765f
Cred_13943 vin1.$236.Metal1 VSS.$4227.Metal2 1.98489e-08f
Cred_13944 vin1.$236.Metal1 VSS.$4559.Metal3 1.3464e-07f
Cred_13945 vin1.$236.Metal1 VSS.$544.Metal1 1.3464e-07f
Cred_13946 vin1.$236.Metal1 VSS.$564.Metal1 0.0117113f
Cred_13947 vin1.$236.Metal1 VSS.P1.pSD 0.0125409f
Cred_13948 vin1.$236.Metal1 VSS.P29.nSD 0.000424836f
Cred_13949 vin1.$237.Metal1 vout1.$1226.Metal3 3.55807e-05f
Cred_13950 vin1.$237.Metal1 vout1.P0.nSD 5.15264e-07f
Cred_13951 vin1.$237.Metal1 vout1.P0.pSD 2.73803e-06f
Cred_13952 vin1.$237.Metal1 vout1.P2.nSD 5.60541e-07f
Cred_13953 vin1.$237.Metal1 vout1.P2.pSD 3.06348e-06f
Cred_13954 vin1.$24.GatPoly vout1.$1226.Metal3 0.00764466f
Cred_13955 vin1.$24.GatPoly vout1.P0.nSD 8.97252e-05f
Cred_13956 vin1.$24.GatPoly vout1.P0.pSD 0.000476785f
Cred_13957 vin1.$24.GatPoly vout1.P2.nSD 0.00338933f
Cred_13958 vin1.$24.GatPoly vout1.P2.pSD 0.000533457f
Cred_13959 vin1.$24.GatPoly vout1.P4.nSD 1.35855e-05f
Cred_13960 vin1.$24.GatPoly VSS.$1989.Metal1 7.02156e-07f
Cred_13961 vin1.$24.GatPoly VSS.$2020.Metal1 1.75806e-06f
Cred_13962 vin1.$24.GatPoly VSS.$2721.Metal2 0.0013178f
Cred_13963 vin1.$24.GatPoly VSS.$2753.Metal2 0.000577984f
Cred_13964 vin1.$24.GatPoly VSS.$29.Metal1 0.000241551f
Cred_13965 vin1.$24.GatPoly VSS.$4227.Metal2 4.70684e-09f
Cred_13966 vin1.$24.GatPoly VSS.$564.Metal1 0.0068704f
Cred_13967 vin1.$24.GatPoly VSS.P1.pSD 0.00316128f
Cred_13968 vin1.$24.GatPoly VSS.P29.nSD 0.000217338f
Cred_13969 vin1.$240.Metal1 VSS.$1989.Metal1 4.68251e-06f
Cred_13970 vin1.$240.Metal1 VSS.$2020.Metal1 1.17241e-05f
Cred_13971 vin1.$240.Metal1 VSS.$2721.Metal2 0.00225701f
Cred_13972 vin1.$240.Metal1 VSS.$2753.Metal2 0.000989916f
Cred_13973 vin1.$240.Metal1 VSS.$29.Metal1 0.00111175f
Cred_13974 vin1.$240.Metal1 VSS.$4227.Metal2 3.13888e-08f
Cred_13975 vin1.$240.Metal1 VSS.$564.Metal1 0.0375483f
Cred_13976 vin1.$240.Metal1 VSS.P1.pSD 0.0177548f
Cred_13977 vin1.$240.Metal1 VSS.P29.nSD 0.00140626f
Cred_13978 vin1.$246.Metal1 vout1.$1226.Metal3 0.000947268f
Cred_13979 vin1.$246.Metal1 vout1.P0.nSD 2.06442e-06f
Cred_13980 vin1.$246.Metal1 vout1.P0.pSD 1.097e-05f
Cred_13981 vin1.$246.Metal1 vout1.P2.nSD 3.84091e-06f
Cred_13982 vin1.$246.Metal1 vout1.P2.pSD 1.22739e-05f
Cred_13983 vin1.$246.Metal1 vout1.P4.nSD 0.00032997f
Cred_13984 vin1.$246.Metal1 VSS.$1989.Metal1 5.23995e-06f
Cred_13985 vin1.$246.Metal1 VSS.$2020.Metal1 1.31198e-05f
Cred_13986 vin1.$246.Metal1 VSS.$2721.Metal2 0.000697698f
Cred_13987 vin1.$246.Metal1 VSS.$2753.Metal2 0.000309797f
Cred_13988 vin1.$246.Metal1 VSS.$2777.Metal2 4.46721e-05f
Cred_13989 vin1.$246.Metal1 VSS.$29.Metal1 0.00097707f
Cred_13990 vin1.$246.Metal1 VSS.$4227.Metal2 3.51255e-08f
Cred_13991 vin1.$246.Metal1 VSS.$564.Metal1 0.0100393f
Cred_13992 vin1.$246.Metal1 VSS.$663.Metal1 0.00074865f
Cred_13993 vin1.$246.Metal1 VSS.P1.pSD 0.0177243f
Cred_13994 vin1.$246.Metal1 VSS.P29.nSD 0.000359912f
Cred_13995 vin1.$247.Metal1 vout1.$1226.Metal3 0.010864f
Cred_13996 vin1.$247.Metal1 vout1.P0.nSD 1.32332e-05f
Cred_13997 vin1.$247.Metal1 vout1.P0.pSD 7.0319e-05f
Cred_13998 vin1.$247.Metal1 vout1.P2.nSD 1.4396e-05f
Cred_13999 vin1.$247.Metal1 vout1.P2.pSD 0.000155297f
Cred_14000 vin1.$247.Metal1 vout1.P4.pSD 0.00613201f
Cred_14001 vin1.$25.GatPoly vout1.$1226.Metal3 0.0493491f
Cred_14002 vin1.$25.GatPoly vout1.P0.nSD 0.000629834f
Cred_14003 vin1.$25.GatPoly vout1.P0.pSD 0.00334683f
Cred_14004 vin1.$25.GatPoly vout1.P2.nSD 0.000685178f
Cred_14005 vin1.$25.GatPoly vout1.P2.pSD 0.0359824f
Cred_14006 vin1.$25.GatPoly vout1.P4.pSD 0.000411545f
Cred_14007 vin1.$250.Metal1 vout1.$1226.Metal3 0.0147902f
Cred_14008 vin1.$250.Metal1 vout1.P0.nSD 1.16038e-06f
Cred_14009 vin1.$250.Metal1 vout1.P0.pSD 6.16608e-06f
Cred_14010 vin1.$250.Metal1 vout1.P2.nSD 2.15893e-06f
Cred_14011 vin1.$250.Metal1 vout1.P2.pSD 6.89901e-06f
Cred_14012 vin1.$250.Metal1 vout1.P4.nSD 0.0108783f
Cred_14013 vin1.$250.Metal1 VSS.$1989.Metal1 5.96914e-06f
Cred_14014 vin1.$250.Metal1 VSS.$2020.Metal1 1.49455e-05f
Cred_14015 vin1.$250.Metal1 VSS.$2721.Metal2 7.95992e-05f
Cred_14016 vin1.$250.Metal1 VSS.$2753.Metal2 3.6165e-05f
Cred_14017 vin1.$250.Metal1 VSS.$2777.Metal2 1.2149e-05f
Cred_14018 vin1.$250.Metal1 VSS.$29.Metal1 0.000846518f
Cred_14019 vin1.$250.Metal1 VSS.$4227.Metal2 4.00135e-08f
Cred_14020 vin1.$250.Metal1 VSS.$564.Metal1 0.000479229f
Cred_14021 vin1.$250.Metal1 VSS.$663.Metal1 0.00115729f
Cred_14022 vin1.$250.Metal1 VSS.P1.pSD 0.0177188f
Cred_14023 vin1.$250.Metal1 VSS.P29.nSD 9.85719e-06f
Cred_14024 vin1.$251.Metal1 vout1.$1226.Metal3 0.0205824f
Cred_14025 vin1.$251.Metal1 vout1.P0.nSD 7.43821e-06f
Cred_14026 vin1.$251.Metal1 vout1.P0.pSD 3.95254e-05f
Cred_14027 vin1.$251.Metal1 vout1.P2.nSD 8.09181e-06f
Cred_14028 vin1.$251.Metal1 vout1.P2.pSD 8.72905e-05f
Cred_14029 vin1.$251.Metal1 vout1.P4.pSD 0.0144287f
Cred_14030 vin1.$258.Metal1 vout1.$1226.Metal3 0.0211493f
Cred_14031 vin1.$258.Metal1 vout1.P4.nSD 0.0169439f
Cred_14032 vin1.$258.Metal1 VSS.$1989.Metal1 6.54217e-06f
Cred_14033 vin1.$258.Metal1 VSS.$2020.Metal1 1.63803e-05f
Cred_14034 vin1.$258.Metal1 VSS.$2825.Metal2 5.83555e-07f
Cred_14035 vin1.$258.Metal1 VSS.$2849.Metal2 1.35373e-05f
Cred_14036 vin1.$258.Metal1 VSS.$29.Metal1 0.000736286f
Cred_14037 vin1.$258.Metal1 VSS.$2908.Metal2 1.70451e-05f
Cred_14038 vin1.$258.Metal1 VSS.$2940.Metal2 5.85163e-07f
Cred_14039 vin1.$258.Metal1 VSS.$4227.Metal2 4.38548e-08f
Cred_14040 vin1.$258.Metal1 VSS.$4643.Metal3 1.31152e-08f
Cred_14041 vin1.$258.Metal1 VSS.$663.Metal1 6.98466e-05f
Cred_14042 vin1.$258.Metal1 VSS.$731.Metal1 0.000154212f
Cred_14043 vin1.$258.Metal1 VSS.$774.Metal1 1.48819e-06f
Cred_14044 vin1.$258.Metal1 VSS.P1.pSD 0.0173878f
Cred_14045 vin1.$258.Metal1 VSS.P31.nSD 8.70293e-09f
Cred_14046 vin1.$259.Metal1 vout1.$1226.Metal3 0.0209774f
Cred_14047 vin1.$259.Metal1 vout1.P4.pSD 0.0170573f
Cred_14048 vin1.$262.Metal1 vout1.$1226.Metal3 0.000396588f
Cred_14049 vin1.$262.Metal1 vout1.P4.nSD 0.000133051f
Cred_14050 vin1.$262.Metal1 VSS.$1989.Metal1 5.22282e-06f
Cred_14051 vin1.$262.Metal1 VSS.$2020.Metal1 1.30769e-05f
Cred_14052 vin1.$262.Metal1 VSS.$2825.Metal2 5.40074e-06f
Cred_14053 vin1.$262.Metal1 VSS.$2849.Metal2 6.31661e-05f
Cred_14054 vin1.$262.Metal1 VSS.$29.Metal1 0.000467462f
Cred_14055 vin1.$262.Metal1 VSS.$2908.Metal2 7.22346e-05f
Cred_14056 vin1.$262.Metal1 VSS.$2940.Metal2 2.48028e-06f
Cred_14057 vin1.$262.Metal1 VSS.$4227.Metal2 3.50107e-08f
Cred_14058 vin1.$262.Metal1 VSS.$4643.Metal3 5.54875e-08f
Cred_14059 vin1.$262.Metal1 VSS.$663.Metal1 0.000646423f
Cred_14060 vin1.$262.Metal1 VSS.$731.Metal1 0.00144256f
Cred_14061 vin1.$262.Metal1 VSS.$774.Metal1 1.18852e-05f
Cred_14062 vin1.$262.Metal1 VSS.P1.pSD 0.0124465f
Cred_14063 vin1.$262.Metal1 VSS.P31.nSD 8.37022e-08f
Cred_14064 vin1.$263.Metal1 vout1.$1226.Metal3 0.00135071f
Cred_14065 vin1.$263.Metal1 vout1.P4.pSD 0.000374822f
Cred_14066 vin1.$264.Metal1 vout1.$1226.Metal3 0.000176163f
Cred_14067 vin1.$264.Metal1 vout1.P4.nSD 1.87265e-06f
Cred_14068 vin1.$264.Metal1 VSS.$1989.Metal1 8.48969e-06f
Cred_14069 vin1.$264.Metal1 VSS.$2020.Metal1 2.12565e-05f
Cred_14070 vin1.$264.Metal1 VSS.$2825.Metal2 3.57813e-07f
Cred_14071 vin1.$264.Metal1 VSS.$2849.Metal2 4.59267e-05f
Cred_14072 vin1.$264.Metal1 VSS.$29.Metal1 0.000603133f
Cred_14073 vin1.$264.Metal1 VSS.$2908.Metal2 0.000664556f
Cred_14074 vin1.$264.Metal1 VSS.$2940.Metal2 2.45783e-05f
Cred_14075 vin1.$264.Metal1 VSS.$4227.Metal2 5.69098e-08f
Cred_14076 vin1.$264.Metal1 VSS.$4643.Metal3 1.38935e-07f
Cred_14077 vin1.$264.Metal1 VSS.$663.Metal1 4.28272e-05f
Cred_14078 vin1.$264.Metal1 VSS.$731.Metal1 0.00114249f
Cred_14079 vin1.$264.Metal1 VSS.$774.Metal1 0.022397f
Cred_14080 vin1.$264.Metal1 VSS.P1.pSD 0.0180699f
Cred_14081 vin1.$264.Metal1 VSS.P31.nSD 0.000207174f
Cred_14082 vin1.$265.Metal1 vout1.$1226.Metal3 6.69587e-05f
Cred_14083 vin1.$265.Metal1 vout1.$1292.Metal3 1.67231e-06f
Cred_14084 vin1.$265.Metal1 vout1.P4.pSD 1.95318e-07f
Cred_14085 vin1.$265.Metal1 vout1.P6.nSD 2.63457e-08f
Cred_14086 vin1.$265.Metal1 vout1.P6.pSD 3.39303e-07f
Cred_14087 vin1.$27.GatPoly vout1.$1226.Metal3 0.00841927f
Cred_14088 vin1.$27.GatPoly vout1.P0.nSD 0.000121924f
Cred_14089 vin1.$27.GatPoly vout1.P0.pSD 0.000647885f
Cred_14090 vin1.$27.GatPoly vout1.P2.nSD 0.000132638f
Cred_14091 vin1.$27.GatPoly vout1.P2.pSD 0.00828964f
Cred_14092 vin1.$272.Metal1 vout1.$1226.Metal3 1.13457e-05f
Cred_14093 vin1.$272.Metal1 vout1.$1292.Metal3 1.13457e-05f
Cred_14094 vin1.$272.Metal1 vout1.P6.nSD 2.6058e-07f
Cred_14095 vin1.$272.Metal1 vout1.P6.pSD 9.76862e-07f
Cred_14096 vin1.$272.Metal1 VSS.$1989.Metal1 1.29327e-05f
Cred_14097 vin1.$272.Metal1 VSS.$2020.Metal1 3.23808e-05f
Cred_14098 vin1.$272.Metal1 VSS.$29.Metal1 0.000689859f
Cred_14099 vin1.$272.Metal1 VSS.$2908.Metal2 0.000798763f
Cred_14100 vin1.$272.Metal1 VSS.$2940.Metal2 3.61193e-05f
Cred_14101 vin1.$272.Metal1 VSS.$2988.Metal2 4.06169e-06f
Cred_14102 vin1.$272.Metal1 VSS.$4227.Metal2 8.66929e-08f
Cred_14103 vin1.$272.Metal1 VSS.$4679.Metal3 3.12823e-08f
Cred_14104 vin1.$272.Metal1 VSS.$762.Metal1 0.000613059f
Cred_14105 vin1.$272.Metal1 VSS.$774.Metal1 0.0369406f
Cred_14106 vin1.$272.Metal1 VSS.$822.Metal1 0.0006588f
Cred_14107 vin1.$272.Metal1 VSS.$870.Metal1 1.91613e-05f
Cred_14108 vin1.$272.Metal1 VSS.P1.pSD 0.0239216f
Cred_14109 vin1.$272.Metal1 VSS.P31.nSD 0.000350366f
Cred_14110 vin1.$273.Metal1 vout1.$1226.Metal3 4.83458e-05f
Cred_14111 vin1.$273.Metal1 vout1.$1292.Metal3 4.46677e-05f
Cred_14112 vin1.$273.Metal1 vout1.P4.pSD 1.32775e-07f
Cred_14113 vin1.$273.Metal1 vout1.P6.nSD 7.03698e-07f
Cred_14114 vin1.$273.Metal1 vout1.P6.pSD 6.4668e-06f
Cred_14115 vin1.$277.Metal1 vout1.$1226.Metal3 7.03749e-05f
Cred_14116 vin1.$277.Metal1 vout1.$1292.Metal3 7.03749e-05f
Cred_14117 vin1.$277.Metal1 vout1.P6.nSD 1.10869e-06f
Cred_14118 vin1.$277.Metal1 vout1.P6.pSD 1.1191e-05f
Cred_14119 vin1.$280.Metal1 vout1.$1226.Metal3 0.00270877f
Cred_14120 vin1.$280.Metal1 vout1.$1292.Metal3 0.00263404f
Cred_14121 vin1.$280.Metal1 vout1.P4.nSD 7.00732e-07f
Cred_14122 vin1.$280.Metal1 vout1.P6.nSD 0.00337504f
Cred_14123 vin1.$280.Metal1 vout1.P6.pSD 0.000226789f
Cred_14124 vin1.$280.Metal1 VSS.$1989.Metal1 1.08494e-05f
Cred_14125 vin1.$280.Metal1 VSS.$2020.Metal1 2.71647e-05f
Cred_14126 vin1.$280.Metal1 VSS.$29.Metal1 0.000437913f
Cred_14127 vin1.$280.Metal1 VSS.$2908.Metal2 8.3775e-05f
Cred_14128 vin1.$280.Metal1 VSS.$2940.Metal2 2.25167e-05f
Cred_14129 vin1.$280.Metal1 VSS.$2988.Metal2 1.92068e-05f
Cred_14130 vin1.$280.Metal1 VSS.$4227.Metal2 7.27279e-08f
Cred_14131 vin1.$280.Metal1 VSS.$4679.Metal3 1.40401e-07f
Cred_14132 vin1.$280.Metal1 VSS.$762.Metal1 0.000217158f
Cred_14133 vin1.$280.Metal1 VSS.$774.Metal1 0.000705229f
Cred_14134 vin1.$280.Metal1 VSS.$822.Metal1 0.0022483f
Cred_14135 vin1.$280.Metal1 VSS.$870.Metal1 0.000202968f
Cred_14136 vin1.$280.Metal1 VSS.P1.pSD 0.017534f
Cred_14137 vin1.$280.Metal1 VSS.P31.nSD 5.88858e-06f
Cred_14138 vin1.$281.Metal1 vout1.$1226.Metal3 0.00224909f
Cred_14139 vin1.$281.Metal1 vout1.$1292.Metal3 0.00224909f
Cred_14140 vin1.$281.Metal1 vout1.P6.nSD 3.54323e-05f
Cred_14141 vin1.$281.Metal1 vout1.P6.pSD 0.00227072f
Cred_14142 vin1.$284.Metal1 vout1.$1226.Metal3 0.0115648f
Cred_14143 vin1.$284.Metal1 vout1.$1292.Metal3 0.0115353f
Cred_14144 vin1.$284.Metal1 vout1.P4.nSD 2.77091e-07f
Cred_14145 vin1.$284.Metal1 vout1.P6.nSD 0.0198603f
Cred_14146 vin1.$284.Metal1 vout1.P6.pSD 0.000993182f
Cred_14147 vin1.$284.Metal1 VSS.$1989.Metal1 1.32305e-05f
Cred_14148 vin1.$284.Metal1 VSS.$2020.Metal1 3.31265e-05f
Cred_14149 vin1.$284.Metal1 VSS.$29.Metal1 0.000401699f
Cred_14150 vin1.$284.Metal1 VSS.$2908.Metal2 2.90429e-05f
Cred_14151 vin1.$284.Metal1 VSS.$2940.Metal2 1.10289e-06f
Cred_14152 vin1.$284.Metal1 VSS.$4227.Metal2 8.86893e-08f
Cred_14153 vin1.$284.Metal1 VSS.$774.Metal1 8.95181e-05f
Cred_14154 vin1.$284.Metal1 VSS.P1.pSD 0.0185954f
Cred_14155 vin1.$284.Metal1 VSS.P31.nSD 7.44237e-07f
Cred_14156 vin1.$285.Metal1 vout1.$1226.Metal3 0.0116135f
Cred_14157 vin1.$285.Metal1 vout1.$1292.Metal3 0.0116135f
Cred_14158 vin1.$285.Metal1 vout1.P6.nSD 0.00018296f
Cred_14159 vin1.$285.Metal1 vout1.P6.pSD 0.0220364f
Cred_14160 vin1.$290.Metal1 vout1.$1226.Metal3 0.00355904f
Cred_14161 vin1.$290.Metal1 vout1.$1292.Metal3 0.00367739f
Cred_14162 vin1.$290.Metal1 vout1.P6.nSD 0.00587158f
Cred_14163 vin1.$290.Metal1 vout1.P6.pSD 0.000306431f
Cred_14164 vin1.$290.Metal1 vout1.P8.nSD 1.10981e-06f
Cred_14165 vin1.$290.Metal1 VSS.$1989.Metal1 1.99161e-05f
Cred_14166 vin1.$290.Metal1 VSS.$2020.Metal1 4.98658e-05f
Cred_14167 vin1.$290.Metal1 VSS.$29.Metal1 0.000450924f
Cred_14168 vin1.$290.Metal1 VSS.$3036.Metal2 4.76175e-05f
Cred_14169 vin1.$290.Metal1 VSS.$3060.Metal2 9.29939e-05f
Cred_14170 vin1.$290.Metal1 VSS.$3095.Metal2 0.000292588f
Cred_14171 vin1.$290.Metal1 VSS.$4227.Metal2 1.33505e-07f
Cred_14172 vin1.$290.Metal1 VSS.$870.Metal1 0.00138105f
Cred_14173 vin1.$290.Metal1 VSS.$922.Metal1 0.00373045f
Cred_14174 vin1.$290.Metal1 VSS.P1.pSD 0.0242028f
Cred_14175 vin1.$290.Metal1 VSS.P33.nSD 0.000113253f
Cred_14176 vin1.$291.Metal1 vout1.$1226.Metal3 0.00774494f
Cred_14177 vin1.$291.Metal1 vout1.$1292.Metal3 0.00869489f
Cred_14178 vin1.$291.Metal1 vout1.P6.nSD 0.000122014f
Cred_14179 vin1.$291.Metal1 vout1.P6.pSD 0.0112744f
Cred_14180 vin1.$291.Metal1 vout1.P8.pSD 6.67492e-05f
Cred_14181 vin1.$295.Metal1 vout1.$1226.Metal3 0.0030992f
Cred_14182 vin1.$295.Metal1 vout1.$1292.Metal3 0.00383442f
Cred_14183 vin1.$295.Metal1 vout1.P6.nSD 4.8825e-05f
Cred_14184 vin1.$295.Metal1 vout1.P6.pSD 0.00428749f
Cred_14185 vin1.$295.Metal1 vout1.P8.pSD 5.16607e-05f
Cred_14186 vin1.$298.Metal1 vout1.$1226.Metal3 2.6058e-05f
Cred_14187 vin1.$298.Metal1 vout1.$1292.Metal3 7.35828e-05f
Cred_14188 vin1.$298.Metal1 vout1.P6.nSD 6.43208e-07f
Cred_14189 vin1.$298.Metal1 vout1.P6.pSD 2.24358e-06f
Cred_14190 vin1.$298.Metal1 vout1.P8.nSD 2.11277e-07f
Cred_14191 vin1.$298.Metal1 VSS.$1989.Metal1 1.7318e-05f
Cred_14192 vin1.$298.Metal1 VSS.$2020.Metal1 4.33608e-05f
Cred_14193 vin1.$298.Metal1 VSS.$29.Metal1 0.00029652f
Cred_14194 vin1.$298.Metal1 VSS.$3036.Metal2 8.22798e-06f
Cred_14195 vin1.$298.Metal1 VSS.$3060.Metal2 0.000632215f
Cred_14196 vin1.$298.Metal1 VSS.$3095.Metal2 0.0020881f
Cred_14197 vin1.$298.Metal1 VSS.$4227.Metal2 1.1609e-07f
Cred_14198 vin1.$298.Metal1 VSS.$870.Metal1 0.000314013f
Cred_14199 vin1.$298.Metal1 VSS.$922.Metal1 0.0306613f
Cred_14200 vin1.$298.Metal1 VSS.P1.pSD 0.0183463f
Cred_14201 vin1.$298.Metal1 VSS.P33.nSD 0.00112176f
Cred_14202 vin1.$302.Metal1 vout1.$1226.Metal3 3.90959e-05f
Cred_14203 vin1.$302.Metal1 vout1.$1292.Metal3 0.000132079f
Cred_14204 vin1.$302.Metal1 vout1.P6.nSD 1.02929e-06f
Cred_14205 vin1.$302.Metal1 vout1.P6.pSD 3.36614e-06f
Cred_14206 vin1.$302.Metal1 vout1.P8.nSD 4.13368e-07f
Cred_14207 vin1.$302.Metal1 VSS.$1029.Metal1 2.6008e-05f
Cred_14208 vin1.$302.Metal1 VSS.$1989.Metal1 1.97149e-05f
Cred_14209 vin1.$302.Metal1 VSS.$2020.Metal1 4.93622e-05f
Cred_14210 vin1.$302.Metal1 VSS.$29.Metal1 0.000253982f
Cred_14211 vin1.$302.Metal1 VSS.$3060.Metal2 0.000589775f
Cred_14212 vin1.$302.Metal1 VSS.$3095.Metal2 0.00195557f
Cred_14213 vin1.$302.Metal1 VSS.$3151.Metal2 2.17285e-07f
Cred_14214 vin1.$302.Metal1 VSS.$4227.Metal2 1.32157e-07f
Cred_14215 vin1.$302.Metal1 VSS.$922.Metal1 0.0268674f
Cred_14216 vin1.$302.Metal1 VSS.$981.Metal1 0.00124072f
Cred_14217 vin1.$302.Metal1 VSS.P1.pSD 0.0181414f
Cred_14218 vin1.$302.Metal1 VSS.P33.nSD 0.000994954f
Cred_14219 vin1.$303.Metal1 vout1.$1292.Metal3 9.34686e-06f
Cred_14220 vin1.$307.Metal1 vout1.$1292.Metal3 0.00115034f
Cred_14221 vin1.$307.Metal1 vout1.P8.pSD 0.000166022f
Cred_14222 vin1.$310.Metal1 vout1.$1292.Metal3 0.00222534f
Cred_14223 vin1.$310.Metal1 vout1.P8.nSD 0.00164979f
Cred_14224 vin1.$310.Metal1 VSS.$1029.Metal1 0.000519672f
Cred_14225 vin1.$310.Metal1 VSS.$1989.Metal1 2.22635e-05f
Cred_14226 vin1.$310.Metal1 VSS.$2020.Metal1 5.57432e-05f
Cred_14227 vin1.$310.Metal1 VSS.$29.Metal1 0.000226896f
Cred_14228 vin1.$310.Metal1 VSS.$3151.Metal2 3.66904e-05f
Cred_14229 vin1.$310.Metal1 VSS.$4227.Metal2 1.49241e-07f
Cred_14230 vin1.$310.Metal1 VSS.$981.Metal1 0.00169644f
Cred_14231 vin1.$310.Metal1 VSS.P1.pSD 0.0182363f
Cred_14232 vin1.$312.Metal1 vout1.$1292.Metal3 0.0235303f
Cred_14233 vin1.$312.Metal1 vout1.P8.nSD 0.0191443f
Cred_14234 vin1.$312.Metal1 VSS.$1989.Metal1 2.53728e-05f
Cred_14235 vin1.$312.Metal1 VSS.$2020.Metal1 6.35285e-05f
Cred_14236 vin1.$312.Metal1 VSS.$29.Metal1 0.000194338f
Cred_14237 vin1.$312.Metal1 VSS.$4227.Metal2 1.70084e-07f
Cred_14238 vin1.$312.Metal1 VSS.P1.pSD 0.0180212f
Cred_14239 vin1.$313.Metal1 vout1.$1292.Metal3 0.0169072f
Cred_14240 vin1.$313.Metal1 vout1.P8.pSD 0.0137418f
Cred_14241 vin1.$317.Metal1 vout1.$1292.Metal3 0.0161833f
Cred_14242 vin1.$317.Metal1 vout1.P8.pSD 0.0132623f
Cred_14243 vin1.$320.Metal1 vout1.$1292.Metal3 0.0091509f
Cred_14244 vin1.$320.Metal1 vout1.$1358.Metal3 4.72442e-05f
Cred_14245 vin1.$320.Metal1 vout1.P10.nSD 1.67507e-06f
Cred_14246 vin1.$320.Metal1 vout1.P10.pSD 4.03112e-06f
Cred_14247 vin1.$320.Metal1 vout1.P8.nSD 0.00719773f
Cred_14248 vin1.$320.Metal1 VSS 0.00105442f
Cred_14249 vin1.$320.Metal1 VSS.$1029.Metal1 0.00047739f
Cred_14250 vin1.$320.Metal1 VSS.$1069.Metal1 0.00214531f
Cred_14251 vin1.$320.Metal1 VSS.$1989.Metal1 3.8286e-05f
Cred_14252 vin1.$320.Metal1 VSS.$2020.Metal1 9.58605e-05f
Cred_14253 vin1.$320.Metal1 VSS.$29.Metal1 0.000224436f
Cred_14254 vin1.$320.Metal1 VSS.$3199.Metal2 1.86009e-05f
Cred_14255 vin1.$320.Metal1 VSS.$3250.Metal2 0.000103786f
Cred_14256 vin1.$320.Metal1 VSS.$3282.Metal2 8.85851e-05f
Cred_14257 vin1.$320.Metal1 VSS.$4227.Metal2 2.56647e-07f
Cred_14258 vin1.$320.Metal1 VSS.$4799.Metal3 1.17159e-07f
Cred_14259 vin1.$320.Metal1 VSS.P1.pSD 0.023765f
Cred_14260 vin1.$320.Metal1 VSS.P35.nSD 3.4654e-05f
Cred_14261 vin1.$321.Metal1 vout1.$1292.Metal3 0.00227998f
Cred_14262 vin1.$321.Metal1 vout1.P8.pSD 0.00126704f
Cred_14263 vin1.$325.Metal1 vout1.$1292.Metal3 5.64036e-05f
Cred_14264 vin1.$328.Metal1 vout1.$1292.Metal3 2.78522e-05f
Cred_14265 vin1.$328.Metal1 VSS 0.0402521f
Cred_14266 vin1.$328.Metal1 VSS.$1069.Metal1 0.00100323f
Cred_14267 vin1.$328.Metal1 VSS.$1989.Metal1 4.59296e-05f
Cred_14268 vin1.$328.Metal1 VSS.$2020.Metal1 0.000114998f
Cred_14269 vin1.$328.Metal1 VSS.$29.Metal1 0.000190869f
Cred_14270 vin1.$328.Metal1 VSS.$3199.Metal2 7.68068e-06f
Cred_14271 vin1.$328.Metal1 VSS.$3250.Metal2 0.00178235f
Cred_14272 vin1.$328.Metal1 VSS.$3282.Metal2 0.00177337f
Cred_14273 vin1.$328.Metal1 VSS.$4227.Metal2 3.07884e-07f
Cred_14274 vin1.$328.Metal1 VSS.$4799.Metal3 6.1582e-08f
Cred_14275 vin1.$328.Metal1 VSS.P1.pSD 0.0239902f
Cred_14276 vin1.$328.Metal1 VSS.P35.nSD 0.00152799f
Cred_14277 vin1.$334.Metal1 vout1.$1292.Metal3 0.000387573f
Cred_14278 vin1.$334.Metal1 vout1.$1358.Metal3 0.000264287f
Cred_14279 vin1.$334.Metal1 vout1.P10.nSD 0.000208731f
Cred_14280 vin1.$334.Metal1 vout1.P10.pSD 2.25503e-05f
Cred_14281 vin1.$334.Metal1 vout1.P8.nSD 1.15604e-06f
Cred_14282 vin1.$334.Metal1 VSS 0.0142867f
Cred_14283 vin1.$334.Metal1 VSS.$1165.Metal1 0.00181565f
Cred_14284 vin1.$334.Metal1 VSS.$1989.Metal1 3.91217e-05f
Cred_14285 vin1.$334.Metal1 VSS.$2020.Metal1 9.7953e-05f
Cred_14286 vin1.$334.Metal1 VSS.$29.Metal1 0.000120232f
Cred_14287 vin1.$334.Metal1 VSS.$3250.Metal2 0.000690108f
Cred_14288 vin1.$334.Metal1 VSS.$3282.Metal2 0.000706555f
Cred_14289 vin1.$334.Metal1 VSS.$3338.Metal2 1.55542e-05f
Cred_14290 vin1.$334.Metal1 VSS.$4227.Metal2 2.62249e-07f
Cred_14291 vin1.$334.Metal1 VSS.$4835.Metal3 1.2471e-07f
Cred_14292 vin1.$334.Metal1 VSS.P1.pSD 0.0176008f
Cred_14293 vin1.$334.Metal1 VSS.P35.nSD 0.000542835f
Cred_14294 vin1.$335.Metal1 vout1.$1292.Metal3 2.6845e-05f
Cred_14295 vin1.$335.Metal1 vout1.$1358.Metal3 2.6845e-05f
Cred_14296 vin1.$335.Metal1 vout1.P10.nSD 4.22919e-07f
Cred_14297 vin1.$335.Metal1 vout1.P10.pSD 2.29056e-06f
Cred_14298 vin1.$338.Metal1 vout1.$1292.Metal3 0.00450804f
Cred_14299 vin1.$338.Metal1 vout1.$1358.Metal3 0.00437831f
Cred_14300 vin1.$338.Metal1 vout1.P10.nSD 0.00731727f
Cred_14301 vin1.$338.Metal1 vout1.P10.pSD 0.000373579f
Cred_14302 vin1.$338.Metal1 vout1.P8.nSD 1.2165e-06f
Cred_14303 vin1.$338.Metal1 VSS 0.000411154f
Cred_14304 vin1.$338.Metal1 VSS.$1165.Metal1 0.00125084f
Cred_14305 vin1.$338.Metal1 VSS.$1205.Metal1 0.00047739f
Cred_14306 vin1.$338.Metal1 VSS.$1989.Metal1 4.67235e-05f
Cred_14307 vin1.$338.Metal1 VSS.$2020.Metal1 0.000116986f
Cred_14308 vin1.$338.Metal1 VSS.$29.Metal1 0.000109428f
Cred_14309 vin1.$338.Metal1 VSS.$3250.Metal2 7.90903e-05f
Cred_14310 vin1.$338.Metal1 VSS.$3282.Metal2 8.61888e-05f
Cred_14311 vin1.$338.Metal1 VSS.$3338.Metal2 1.09383e-05f
Cred_14312 vin1.$338.Metal1 VSS.$4227.Metal2 3.13207e-07f
Cred_14313 vin1.$338.Metal1 VSS.$4835.Metal3 5.57214e-08f
Cred_14314 vin1.$338.Metal1 VSS.P1.pSD 0.0183523f
Cred_14315 vin1.$338.Metal1 VSS.P35.nSD 1.40541e-05f
Cred_14316 vin1.$339.Metal1 vout1.$1292.Metal3 0.00106876f
Cred_14317 vin1.$339.Metal1 vout1.$1358.Metal3 0.00106876f
Cred_14318 vin1.$339.Metal1 vout1.P10.nSD 1.68373e-05f
Cred_14319 vin1.$339.Metal1 vout1.P10.pSD 0.00139346f
Cred_14320 vin1.$343.Metal1 vout1.$1292.Metal3 0.00729627f
Cred_14321 vin1.$343.Metal1 vout1.$1358.Metal3 0.00729627f
Cred_14322 vin1.$343.Metal1 vout1.P10.nSD 0.000114946f
Cred_14323 vin1.$343.Metal1 vout1.P10.pSD 0.0137322f
Cred_14324 vin1.$346.Metal1 vout1.$1292.Metal3 0.0111991f
Cred_14325 vin1.$346.Metal1 vout1.$1358.Metal3 0.0111991f
Cred_14326 vin1.$346.Metal1 vout1.P10.nSD 0.0193208f
Cred_14327 vin1.$346.Metal1 vout1.P10.pSD 0.000955568f
Cred_14328 vin1.$346.Metal1 VSS.$1989.Metal1 5.11536e-05f
Cred_14329 vin1.$346.Metal1 VSS.$2020.Metal1 0.000128078f
Cred_14330 vin1.$346.Metal1 VSS.$29.Metal1 9.63952e-05f
Cred_14331 vin1.$346.Metal1 VSS.$4227.Metal2 3.42903e-07f
Cred_14332 vin1.$346.Metal1 VSS.P1.pSD 0.0180287f
Cred_14333 vin1.$347.Metal1 vout1.$1292.Metal3 0.00779742f
Cred_14334 vin1.$347.Metal1 vout1.$1358.Metal3 0.00779742f
Cred_14335 vin1.$347.Metal1 vout1.P10.nSD 0.000122841f
Cred_14336 vin1.$347.Metal1 vout1.P10.pSD 0.0145913f
Cred_14337 vin1.$348.Metal1 vout1.$1292.Metal3 0.00105914f
Cred_14338 vin1.$348.Metal1 vout1.$1358.Metal3 0.00105914f
Cred_14339 vin1.$348.Metal1 vout1.P10.nSD 0.00166647f
Cred_14340 vin1.$348.Metal1 vout1.P10.pSD 9.03714e-05f
Cred_14341 vin1.$348.Metal1 VSS.$1205.Metal1 0.000519672f
Cred_14342 vin1.$348.Metal1 VSS.$1245.Metal1 0.00169644f
Cred_14343 vin1.$348.Metal1 VSS.$1989.Metal1 5.97238e-05f
Cred_14344 vin1.$348.Metal1 VSS.$2020.Metal1 0.000149536f
Cred_14345 vin1.$348.Metal1 VSS.$29.Metal1 8.45828e-05f
Cred_14346 vin1.$348.Metal1 VSS.$3386.Metal2 3.66904e-05f
Cred_14347 vin1.$348.Metal1 VSS.$4227.Metal2 4.00352e-07f
Cred_14348 vin1.$348.Metal1 VSS.P1.pSD 0.0182471f
Cred_14349 vin1.$353.Metal1 vout1.$1292.Metal3 0.00054301f
Cred_14350 vin1.$353.Metal1 vout1.$1358.Metal3 0.00054301f
Cred_14351 vin1.$353.Metal1 vout1.P10.nSD 8.55462e-06f
Cred_14352 vin1.$353.Metal1 vout1.P10.pSD 0.000221788f
Cred_14353 vin1.$356.Metal1 vout1.$1292.Metal3 4.4255e-05f
Cred_14354 vin1.$356.Metal1 vout1.$1358.Metal3 0.000126429f
Cred_14355 vin1.$356.Metal1 vout1.P10.nSD 1.11056e-06f
Cred_14356 vin1.$356.Metal1 vout1.P10.pSD 3.77606e-06f
Cred_14357 vin1.$356.Metal1 vout1.P12.nSD 4.13368e-07f
Cred_14358 vin1.$356.Metal1 VSS.$1205.Metal1 2.6008e-05f
Cred_14359 vin1.$356.Metal1 VSS.$1245.Metal1 0.00124072f
Cred_14360 vin1.$356.Metal1 VSS.$1265.Metal1 0.0268674f
Cred_14361 vin1.$356.Metal1 VSS.$1989.Metal1 6.68532e-05f
Cred_14362 vin1.$356.Metal1 VSS.$2020.Metal1 0.000167387f
Cred_14363 vin1.$356.Metal1 VSS.$29.Metal1 7.49008e-05f
Cred_14364 vin1.$356.Metal1 VSS.$3386.Metal2 2.17285e-07f
Cred_14365 vin1.$356.Metal1 VSS.$3445.Metal2 0.00195557f
Cred_14366 vin1.$356.Metal1 VSS.$3477.Metal2 0.000589775f
Cred_14367 vin1.$356.Metal1 VSS.$4227.Metal2 4.48144e-07f
Cred_14368 vin1.$356.Metal1 VSS.P1.pSD 0.018155f
Cred_14369 vin1.$356.Metal1 VSS.P37.nSD 0.000994954f
Cred_14370 vin1.$357.Metal1 vout1.$1292.Metal3 4.4486e-06f
Cred_14371 vin1.$357.Metal1 vout1.$1358.Metal3 4.4486e-06f
Cred_14372 vin1.$357.Metal1 vout1.P10.nSD 7.00835e-08f
Cred_14373 vin1.$357.Metal1 vout1.P10.pSD 3.79577e-07f
Cred_14374 vin1.$36.GatPoly vout1.$1226.Metal3 0.00166244f
Cred_14375 vin1.$36.GatPoly vout1.P0.nSD 3.90331e-06f
Cred_14376 vin1.$36.GatPoly vout1.P0.pSD 2.07415e-05f
Cred_14377 vin1.$36.GatPoly vout1.P2.nSD 7.26222e-06f
Cred_14378 vin1.$36.GatPoly vout1.P2.pSD 2.3207e-05f
Cred_14379 vin1.$36.GatPoly vout1.P4.nSD 0.000623893f
Cred_14380 vin1.$36.GatPoly VSS.$1989.Metal1 9.34914e-07f
Cred_14381 vin1.$36.GatPoly VSS.$2020.Metal1 2.34084e-06f
Cred_14382 vin1.$36.GatPoly VSS.$2721.Metal2 0.000736069f
Cred_14383 vin1.$36.GatPoly VSS.$2753.Metal2 0.000322837f
Cred_14384 vin1.$36.GatPoly VSS.$29.Metal1 0.000206086f
Cred_14385 vin1.$36.GatPoly VSS.$4227.Metal2 6.26711e-09f
Cred_14386 vin1.$36.GatPoly VSS.$564.Metal1 0.0121868f
Cred_14387 vin1.$36.GatPoly VSS.P1.pSD 0.00341582f
Cred_14388 vin1.$36.GatPoly VSS.P29.nSD 0.000321264f
Cred_14389 vin1.$360.Metal1 vout1.$1292.Metal3 2.26192e-05f
Cred_14390 vin1.$360.Metal1 vout1.$1358.Metal3 7.73893e-05f
Cred_14391 vin1.$360.Metal1 vout1.P10.nSD 5.67622e-07f
Cred_14392 vin1.$360.Metal1 vout1.P10.pSD 1.92999e-06f
Cred_14393 vin1.$360.Metal1 vout1.P12.nSD 2.32689e-07f
Cred_14394 vin1.$360.Metal1 VSS.$1265.Metal1 0.0306613f
Cred_14395 vin1.$360.Metal1 VSS.$1364.Metal1 0.000314013f
Cred_14396 vin1.$360.Metal1 VSS.$1989.Metal1 7.80502e-05f
Cred_14397 vin1.$360.Metal1 VSS.$2020.Metal1 0.000195422f
Cred_14398 vin1.$360.Metal1 VSS.$29.Metal1 6.57951e-05f
Cred_14399 vin1.$360.Metal1 VSS.$3445.Metal2 0.0020881f
Cred_14400 vin1.$360.Metal1 VSS.$3477.Metal2 0.000632215f
Cred_14401 vin1.$360.Metal1 VSS.$3501.Metal2 8.22798e-06f
Cred_14402 vin1.$360.Metal1 VSS.$4227.Metal2 5.23202e-07f
Cred_14403 vin1.$360.Metal1 VSS.P1.pSD 0.0183639f
Cred_14404 vin1.$360.Metal1 VSS.P37.nSD 0.00112176f
Cred_14405 vin1.$365.Metal1 vout1.$1292.Metal3 0.000359051f
Cred_14406 vin1.$365.Metal1 vout1.$1358.Metal3 0.00682448f
Cred_14407 vin1.$365.Metal1 vout1.P10.nSD 5.65651e-06f
Cred_14408 vin1.$365.Metal1 vout1.P10.pSD 8.801e-05f
Cred_14409 vin1.$365.Metal1 vout1.P12.pSD 0.00409171f
Cred_14410 vin1.$368.Metal1 vout1.$1292.Metal3 5.63311e-05f
Cred_14411 vin1.$368.Metal1 vout1.$1358.Metal3 0.0075369f
Cred_14412 vin1.$368.Metal1 vout1.P10.nSD 1.99725e-06f
Cred_14413 vin1.$368.Metal1 vout1.P10.pSD 4.80646e-06f
Cred_14414 vin1.$368.Metal1 vout1.P12.nSD 0.00581551f
Cred_14415 vin1.$368.Metal1 VSS.$1265.Metal1 0.00373045f
Cred_14416 vin1.$368.Metal1 VSS.$1364.Metal1 0.00138105f
Cred_14417 vin1.$368.Metal1 VSS.$1989.Metal1 0.000118693f
Cred_14418 vin1.$368.Metal1 VSS.$2020.Metal1 0.000297182f
Cred_14419 vin1.$368.Metal1 VSS.$29.Metal1 7.56667e-05f
Cred_14420 vin1.$368.Metal1 VSS.$3445.Metal2 0.000292588f
Cred_14421 vin1.$368.Metal1 VSS.$3477.Metal2 9.29939e-05f
Cred_14422 vin1.$368.Metal1 VSS.$3501.Metal2 4.76175e-05f
Cred_14423 vin1.$368.Metal1 VSS.$4227.Metal2 7.95644e-07f
Cred_14424 vin1.$368.Metal1 VSS.P1.pSD 0.0242313f
Cred_14425 vin1.$368.Metal1 VSS.P37.nSD 0.000113253f
Cred_14426 vin1.$369.Metal1 vout1.$1292.Metal3 0.000463919f
Cred_14427 vin1.$369.Metal1 vout1.$1358.Metal3 0.0164812f
Cred_14428 vin1.$369.Metal1 vout1.P10.nSD 7.30861e-06f
Cred_14429 vin1.$369.Metal1 vout1.P10.pSD 0.000113715f
Cred_14430 vin1.$369.Metal1 vout1.P12.pSD 0.0107913f
Cred_14431 vin1.$37.GatPoly vout1.$1226.Metal3 0.0204022f
Cred_14432 vin1.$37.GatPoly vout1.P0.nSD 2.50207e-05f
Cred_14433 vin1.$37.GatPoly vout1.P0.pSD 0.000132956f
Cred_14434 vin1.$37.GatPoly vout1.P2.nSD 2.72193e-05f
Cred_14435 vin1.$37.GatPoly vout1.P2.pSD 0.000293629f
Cred_14436 vin1.$37.GatPoly vout1.P4.pSD 0.0115941f
Cred_14437 vin1.$374.Metal1 vout1.$1358.Metal3 0.0242595f
Cred_14438 vin1.$374.Metal1 vout1.$1424.Metal3 1.40644e-05f
Cred_14439 vin1.$374.Metal1 vout1.P12.nSD 0.0196785f
Cred_14440 vin1.$374.Metal1 vout1.P14.nSD 4.98662e-07f
Cred_14441 vin1.$374.Metal1 vout1.P14.pSD 1.20005e-06f
Cred_14442 vin1.$374.Metal1 VSS.$1466.Metal1 8.95181e-05f
Cred_14443 vin1.$374.Metal1 VSS.$1989.Metal1 0.000105736f
Cred_14444 vin1.$374.Metal1 VSS.$2020.Metal1 0.000264741f
Cred_14445 vin1.$374.Metal1 VSS.$29.Metal1 5.02671e-05f
Cred_14446 vin1.$374.Metal1 VSS.$3597.Metal2 1.10289e-06f
Cred_14447 vin1.$374.Metal1 VSS.$3632.Metal2 2.90429e-05f
Cred_14448 vin1.$374.Metal1 VSS.$4227.Metal2 7.08788e-07f
Cred_14449 vin1.$374.Metal1 VSS.P1.pSD 0.0186221f
Cred_14450 vin1.$374.Metal1 VSS.P39.nSD 7.44237e-07f
Cred_14451 vin1.$375.Metal1 vout1.$1358.Metal3 0.023578f
Cred_14452 vin1.$375.Metal1 vout1.P12.pSD 0.021265f
Cred_14453 vin1.$378.Metal1 vout1.$1358.Metal3 0.00557193f
Cred_14454 vin1.$378.Metal1 vout1.$1424.Metal3 3.55673e-05f
Cred_14455 vin1.$378.Metal1 vout1.P12.nSD 0.00333354f
Cred_14456 vin1.$378.Metal1 vout1.P14.nSD 1.26106e-06f
Cred_14457 vin1.$378.Metal1 vout1.P14.pSD 3.03479e-06f
Cred_14458 vin1.$378.Metal1 VSS.$1364.Metal1 0.000202968f
Cred_14459 vin1.$378.Metal1 VSS.$1412.Metal1 0.0022483f
Cred_14460 vin1.$378.Metal1 VSS.$1463.Metal1 0.000217158f
Cred_14461 vin1.$378.Metal1 VSS.$1466.Metal1 0.000705229f
Cred_14462 vin1.$378.Metal1 VSS.$1989.Metal1 0.000115268f
Cred_14463 vin1.$378.Metal1 VSS.$2020.Metal1 0.000288608f
Cred_14464 vin1.$378.Metal1 VSS.$29.Metal1 4.12215e-05f
Cred_14465 vin1.$378.Metal1 VSS.$3549.Metal2 1.92068e-05f
Cred_14466 vin1.$378.Metal1 VSS.$3597.Metal2 2.25167e-05f
Cred_14467 vin1.$378.Metal1 VSS.$3632.Metal2 8.3775e-05f
Cred_14468 vin1.$378.Metal1 VSS.$4227.Metal2 7.72687e-07f
Cred_14469 vin1.$378.Metal1 VSS.$4955.Metal3 1.40401e-07f
Cred_14470 vin1.$378.Metal1 VSS.P1.pSD 0.0175642f
Cred_14471 vin1.$378.Metal1 VSS.P39.nSD 5.88858e-06f
Cred_14472 vin1.$379.Metal1 vout1.$1358.Metal3 0.00460492f
Cred_14473 vin1.$379.Metal1 vout1.P12.pSD 0.00208398f
Cred_14474 vin1.$383.Metal1 vout1.$1358.Metal3 0.000147556f
Cred_14475 vin1.$383.Metal1 vout1.P12.pSD 5.4933e-06f
Cred_14476 vin1.$386.Metal1 vout1.$1358.Metal3 2.3847e-05f
Cred_14477 vin1.$386.Metal1 vout1.P12.nSD 8.18389e-08f
Cred_14478 vin1.$386.Metal1 VSS.$1364.Metal1 1.91613e-05f
Cred_14479 vin1.$386.Metal1 VSS.$1412.Metal1 0.0006588f
Cred_14480 vin1.$386.Metal1 VSS.$1463.Metal1 0.000613059f
Cred_14481 vin1.$386.Metal1 VSS.$1466.Metal1 0.0369406f
Cred_14482 vin1.$386.Metal1 VSS.$1989.Metal1 0.000181585f
Cred_14483 vin1.$386.Metal1 VSS.$2020.Metal1 0.000454653f
Cred_14484 vin1.$386.Metal1 VSS.$29.Metal1 4.91381e-05f
Cred_14485 vin1.$386.Metal1 VSS.$3549.Metal2 4.06169e-06f
Cred_14486 vin1.$386.Metal1 VSS.$3597.Metal2 3.61193e-05f
Cred_14487 vin1.$386.Metal1 VSS.$3632.Metal2 0.000798763f
Cred_14488 vin1.$386.Metal1 VSS.$4227.Metal2 1.21724e-06f
Cred_14489 vin1.$386.Metal1 VSS.$4955.Metal3 3.12823e-08f
Cred_14490 vin1.$386.Metal1 VSS.P1.pSD 0.0239703f
Cred_14491 vin1.$386.Metal1 VSS.P39.nSD 0.000350366f
Cred_14492 vin1.$387.Metal1 vout1.$1358.Metal3 9.54292e-05f
Cred_14493 vin1.$387.Metal1 vout1.$1424.Metal3 1.74057e-06f
Cred_14494 vin1.$387.Metal1 vout1.P12.pSD 2.81725e-06f
Cred_14495 vin1.$387.Metal1 vout1.P14.nSD 2.7421e-08f
Cred_14496 vin1.$387.Metal1 vout1.P14.pSD 3.02317e-07f
Cred_14497 vin1.$392.Metal1 vout1.$1358.Metal3 8.38441e-05f
Cred_14498 vin1.$392.Metal1 vout1.$1424.Metal3 8.38441e-05f
Cred_14499 vin1.$392.Metal1 vout1.P14.nSD 3.19353e-06f
Cred_14500 vin1.$392.Metal1 vout1.P14.pSD 7.154e-06f
Cred_14501 vin1.$392.Metal1 VSS.$1466.Metal1 0.022397f
Cred_14502 vin1.$392.Metal1 VSS.$1503.Metal1 0.00114249f
Cred_14503 vin1.$392.Metal1 VSS.$1571.Metal1 4.28272e-05f
Cred_14504 vin1.$392.Metal1 VSS.$1989.Metal1 0.000158757f
Cred_14505 vin1.$392.Metal1 VSS.$2020.Metal1 0.000397496f
Cred_14506 vin1.$392.Metal1 VSS.$29.Metal1 3.22581e-05f
Cred_14507 vin1.$392.Metal1 VSS.$3597.Metal2 2.45783e-05f
Cred_14508 vin1.$392.Metal1 VSS.$3632.Metal2 0.000664556f
Cred_14509 vin1.$392.Metal1 VSS.$3688.Metal2 4.59267e-05f
Cred_14510 vin1.$392.Metal1 VSS.$3712.Metal2 3.57813e-07f
Cred_14511 vin1.$392.Metal1 VSS.$4227.Metal2 1.06421e-06f
Cred_14512 vin1.$392.Metal1 VSS.$4991.Metal3 1.38935e-07f
Cred_14513 vin1.$392.Metal1 VSS.P1.pSD 0.0181132f
Cred_14514 vin1.$392.Metal1 VSS.P39.nSD 0.000207174f
Cred_14515 vin1.$393.Metal1 vout1.$1358.Metal3 3.45421e-05f
Cred_14516 vin1.$393.Metal1 vout1.$1424.Metal3 3.10581e-05f
Cred_14517 vin1.$393.Metal1 vout1.P12.pSD 2.26251e-07f
Cred_14518 vin1.$393.Metal1 vout1.P14.nSD 4.89291e-07f
Cred_14519 vin1.$393.Metal1 vout1.P14.pSD 2.87628e-06f
Cred_14520 vin1.$396.Metal1 vout1.$1358.Metal3 0.000188754f
Cred_14521 vin1.$396.Metal1 vout1.$1424.Metal3 0.000188754f
Cred_14522 vin1.$396.Metal1 vout1.P14.nSD 0.000136024f
Cred_14523 vin1.$396.Metal1 vout1.P14.pSD 1.61055e-05f
Cred_14524 vin1.$396.Metal1 VSS.$1466.Metal1 1.18852e-05f
Cred_14525 vin1.$396.Metal1 VSS.$1503.Metal1 0.00144256f
Cred_14526 vin1.$396.Metal1 VSS.$1571.Metal1 0.000646423f
Cred_14527 vin1.$396.Metal1 VSS.$1989.Metal1 0.000123046f
Cred_14528 vin1.$396.Metal1 VSS.$2020.Metal1 0.000308082f
Cred_14529 vin1.$396.Metal1 VSS.$29.Metal1 1.98459e-05f
Cred_14530 vin1.$396.Metal1 VSS.$3597.Metal2 2.48028e-06f
Cred_14531 vin1.$396.Metal1 VSS.$3632.Metal2 7.22346e-05f
Cred_14532 vin1.$396.Metal1 VSS.$3688.Metal2 6.31661e-05f
Cred_14533 vin1.$396.Metal1 VSS.$3712.Metal2 5.40074e-06f
Cred_14534 vin1.$396.Metal1 VSS.$4227.Metal2 8.24826e-07f
Cred_14535 vin1.$396.Metal1 VSS.$4991.Metal3 5.54875e-08f
Cred_14536 vin1.$396.Metal1 VSS.P1.pSD 0.0124805f
Cred_14537 vin1.$396.Metal1 VSS.P39.nSD 8.37022e-08f
Cred_14538 vin1.$397.Metal1 vout1.$1358.Metal3 0.00063605f
Cred_14539 vin1.$397.Metal1 vout1.$1424.Metal3 0.00063605f
Cred_14540 vin1.$397.Metal1 vout1.P14.nSD 1.00204e-05f
Cred_14541 vin1.$397.Metal1 vout1.P14.pSD 0.000443449f
Cred_14542 vin1.$400.Metal1 vout1.$1358.Metal3 0.0100659f
Cred_14543 vin1.$400.Metal1 vout1.$1424.Metal3 0.0100659f
Cred_14544 vin1.$400.Metal1 vout1.P14.nSD 0.0171025f
Cred_14545 vin1.$400.Metal1 vout1.P14.pSD 0.000858876f
Cred_14546 vin1.$400.Metal1 VSS.$1466.Metal1 1.48819e-06f
Cred_14547 vin1.$400.Metal1 VSS.$1503.Metal1 0.000154212f
Cred_14548 vin1.$400.Metal1 VSS.$1571.Metal1 6.98466e-05f
Cred_14549 vin1.$400.Metal1 VSS.$1989.Metal1 0.000193806f
Cred_14550 vin1.$400.Metal1 VSS.$2020.Metal1 0.000485252f
Cred_14551 vin1.$400.Metal1 VSS.$29.Metal1 2.48605e-05f
Cred_14552 vin1.$400.Metal1 VSS.$3597.Metal2 5.85163e-07f
Cred_14553 vin1.$400.Metal1 VSS.$3632.Metal2 1.70451e-05f
Cred_14554 vin1.$400.Metal1 VSS.$3688.Metal2 1.35373e-05f
Cred_14555 vin1.$400.Metal1 VSS.$3712.Metal2 5.83555e-07f
Cred_14556 vin1.$400.Metal1 VSS.$4227.Metal2 1.29916e-06f
Cred_14557 vin1.$400.Metal1 VSS.$4991.Metal3 1.31152e-08f
Cred_14558 vin1.$400.Metal1 VSS.P1.pSD 0.0174418f
Cred_14559 vin1.$400.Metal1 VSS.P39.nSD 8.70293e-09f
Cred_14560 vin1.$401.Metal1 vout1.$1358.Metal3 0.00954509f
Cred_14561 vin1.$401.Metal1 vout1.$1424.Metal3 0.00954509f
Cred_14562 vin1.$401.Metal1 vout1.P14.nSD 0.000150374f
Cred_14563 vin1.$401.Metal1 vout1.P14.pSD 0.0178495f
Cred_14564 vin1.$408.Metal1 vout1.$1358.Metal3 0.00700118f
Cred_14565 vin1.$408.Metal1 vout1.$1424.Metal3 0.00709679f
Cred_14566 vin1.$408.Metal1 vout1.P14.nSD 0.0109886f
Cred_14567 vin1.$408.Metal1 vout1.P14.pSD 0.000597376f
Cred_14568 vin1.$408.Metal1 vout1.P16.nSD 8.9658e-07f
Cred_14569 vin1.$408.Metal1 VSS.$1571.Metal1 0.00115729f
Cred_14570 vin1.$408.Metal1 VSS.$1623.Metal1 0.000479229f
Cred_14571 vin1.$408.Metal1 VSS.$1989.Metal1 0.000222821f
Cred_14572 vin1.$408.Metal1 VSS.$2020.Metal1 0.0005579f
Cred_14573 vin1.$408.Metal1 VSS.$29.Metal1 2.26844e-05f
Cred_14574 vin1.$408.Metal1 VSS.$3760.Metal2 1.2149e-05f
Cred_14575 vin1.$408.Metal1 VSS.$3784.Metal2 3.6165e-05f
Cred_14576 vin1.$408.Metal1 VSS.$3819.Metal2 7.95992e-05f
Cred_14577 vin1.$408.Metal1 VSS.$4227.Metal2 1.49366e-06f
Cred_14578 vin1.$408.Metal1 VSS.P1.pSD 0.0177814f
Cred_14579 vin1.$408.Metal1 VSS.P41.nSD 9.85719e-06f
Cred_14580 vin1.$409.Metal1 vout1.$1358.Metal3 0.00923975f
Cred_14581 vin1.$409.Metal1 vout1.$1424.Metal3 0.00986865f
Cred_14582 vin1.$409.Metal1 vout1.P14.nSD 0.000145564f
Cred_14583 vin1.$409.Metal1 vout1.P14.pSD 0.0152637f
Cred_14584 vin1.$409.Metal1 vout1.P16.pSD 4.78297e-05f
Cred_14585 vin1.$412.Metal1 vout1.$1358.Metal3 0.000383f
Cred_14586 vin1.$412.Metal1 vout1.$1424.Metal3 0.000553109f
Cred_14587 vin1.$412.Metal1 vout1.P14.nSD 0.000336004f
Cred_14588 vin1.$412.Metal1 vout1.P14.pSD 3.26795e-05f
Cred_14589 vin1.$412.Metal1 vout1.P16.nSD 1.59509e-06f
Cred_14590 vin1.$412.Metal1 VSS.$1571.Metal1 0.00074865f
Cred_14591 vin1.$412.Metal1 VSS.$1623.Metal1 0.0100393f
Cred_14592 vin1.$412.Metal1 VSS.$1989.Metal1 0.000257186f
Cred_14593 vin1.$412.Metal1 VSS.$2020.Metal1 0.000643941f
Cred_14594 vin1.$412.Metal1 VSS.$29.Metal1 1.99152e-05f
Cred_14595 vin1.$412.Metal1 VSS.$3760.Metal2 4.46721e-05f
Cred_14596 vin1.$412.Metal1 VSS.$3784.Metal2 0.000309797f
Cred_14597 vin1.$412.Metal1 VSS.$3819.Metal2 0.000697698f
Cred_14598 vin1.$412.Metal1 VSS.$4227.Metal2 1.72402e-06f
Cred_14599 vin1.$412.Metal1 VSS.P1.pSD 0.017797f
Cred_14600 vin1.$412.Metal1 VSS.P41.nSD 0.000359912f
Cred_14601 vin1.$413.Metal1 vout1.$1358.Metal3 0.00472945f
Cred_14602 vin1.$413.Metal1 vout1.$1424.Metal3 0.00584832f
Cred_14603 vin1.$413.Metal1 vout1.P14.nSD 7.45081e-05f
Cred_14604 vin1.$413.Metal1 vout1.P14.pSD 0.0067038f
Cred_14605 vin1.$413.Metal1 vout1.P16.pSD 8.5093e-05f
Cred_14606 vin1.$418.Metal1 VSS.$1623.Metal1 0.0375483f
Cred_14607 vin1.$418.Metal1 VSS.$1989.Metal1 0.000292635f
Cred_14608 vin1.$418.Metal1 VSS.$2020.Metal1 0.0007327f
Cred_14609 vin1.$418.Metal1 VSS.$29.Metal1 1.77986e-05f
Cred_14610 vin1.$418.Metal1 VSS.$3784.Metal2 0.000989916f
Cred_14611 vin1.$418.Metal1 VSS.$3819.Metal2 0.00225701f
Cred_14612 vin1.$418.Metal1 VSS.$4227.Metal2 1.96165e-06f
Cred_14613 vin1.$418.Metal1 VSS.P1.pSD 0.0178378f
Cred_14614 vin1.$418.Metal1 VSS.P41.nSD 0.00140626f
Cred_14615 vin1.$42.GatPoly vout1.$1226.Metal3 0.00761891f
Cred_14616 vin1.$42.GatPoly vout1.P0.nSD 2.194e-06f
Cred_14617 vin1.$42.GatPoly vout1.P0.pSD 1.16586e-05f
Cred_14618 vin1.$42.GatPoly vout1.P2.nSD 4.082e-06f
Cred_14619 vin1.$42.GatPoly vout1.P2.pSD 1.30444e-05f
Cred_14620 vin1.$42.GatPoly vout1.P4.nSD 0.00536626f
Cred_14621 vin1.$42.GatPoly VSS.$1989.Metal1 1.35059e-06f
Cred_14622 vin1.$42.GatPoly VSS.$2020.Metal1 3.38159e-06f
Cred_14623 vin1.$42.GatPoly VSS.$2721.Metal2 0.000150503f
Cred_14624 vin1.$42.GatPoly VSS.$2753.Metal2 6.60099e-05f
Cred_14625 vin1.$42.GatPoly VSS.$29.Metal1 0.000173618f
Cred_14626 vin1.$42.GatPoly VSS.$4227.Metal2 9.05352e-09f
Cred_14627 vin1.$42.GatPoly VSS.$564.Metal1 0.00049805f
Cred_14628 vin1.$42.GatPoly VSS.P1.pSD 0.00382109f
Cred_14629 vin1.$42.GatPoly VSS.P29.nSD 1.86375e-05f
Cred_14630 vin1.$422.Metal1 vout1.$1424.Metal3 0.000148264f
Cred_14631 vin1.$422.Metal1 vout1.P16.nSD 1.06712e-05f
Cred_14632 vin1.$422.Metal1 VSS.$1623.Metal1 0.0117113f
Cred_14633 vin1.$422.Metal1 VSS.$1690.Metal1 1.3464e-07f
Cred_14634 vin1.$422.Metal1 VSS.$1989.Metal1 0.000233942f
Cred_14635 vin1.$422.Metal1 VSS.$2020.Metal1 0.000585743f
Cred_14636 vin1.$422.Metal1 VSS.$29.Metal1 1.12566e-05f
Cred_14637 vin1.$422.Metal1 VSS.$3784.Metal2 0.000310638f
Cred_14638 vin1.$422.Metal1 VSS.$3819.Metal2 0.000725046f
Cred_14639 vin1.$422.Metal1 VSS.$3875.Metal2 2.79061e-05f
Cred_14640 vin1.$422.Metal1 VSS.$4227.Metal2 1.56821e-06f
Cred_14641 vin1.$422.Metal1 VSS.$5075.Metal3 1.3464e-07f
Cred_14642 vin1.$422.Metal1 VSS.P1.pSD 0.0126075f
Cred_14643 vin1.$422.Metal1 VSS.P41.nSD 0.000424836f
Cred_14644 vin1.$423.Metal1 vout1.$1424.Metal3 4.2458e-05f
Cred_14645 vin1.$426.Metal1 vout1.$1424.Metal3 0.00034906f
Cred_14646 vin1.$426.Metal1 vout1.P16.nSD 8.2277e-05f
Cred_14647 vin1.$426.Metal1 VSS.$1623.Metal1 1.28313e-06f
Cred_14648 vin1.$426.Metal1 VSS.$1690.Metal1 0.00101873f
Cred_14649 vin1.$426.Metal1 VSS.$1730.Metal1 0.000407947f
Cred_14650 vin1.$426.Metal1 VSS.$1989.Metal1 0.000247218f
Cred_14651 vin1.$426.Metal1 VSS.$2020.Metal1 0.000618984f
Cred_14652 vin1.$426.Metal1 VSS.$29.Metal1 1.01365e-05f
Cred_14653 vin1.$426.Metal1 VSS.$3784.Metal2 4.53323e-06f
Cred_14654 vin1.$426.Metal1 VSS.$3819.Metal2 2.81555e-05f
Cred_14655 vin1.$426.Metal1 VSS.$3875.Metal2 4.38787e-05f
Cred_14656 vin1.$426.Metal1 VSS.$4227.Metal2 1.6572e-06f
Cred_14657 vin1.$426.Metal1 VSS.$5075.Metal3 1.42875e-07f
Cred_14658 vin1.$426.Metal1 VSS.P1.pSD 0.012233f
Cred_14659 vin1.$426.Metal1 VSS.P41.nSD 4.45497e-08f
Cred_14660 vin1.$427.Metal1 vout1.$1424.Metal3 0.00449306f
Cred_14661 vin1.$427.Metal1 vout1.P16.pSD 0.00292921f
Cred_14662 vin1.$43.GatPoly vout1.$1226.Metal3 0.0222699f
Cred_14663 vin1.$43.GatPoly vout1.P0.nSD 1.40638e-05f
Cred_14664 vin1.$43.GatPoly vout1.P0.pSD 7.4733e-05f
Cred_14665 vin1.$43.GatPoly vout1.P2.nSD 1.52996e-05f
Cred_14666 vin1.$43.GatPoly vout1.P2.pSD 0.000165045f
Cred_14667 vin1.$43.GatPoly vout1.P4.pSD 0.0152604f
Cred_14668 vin1.$430.Metal1 vout1.$1424.Metal3 0.0194272f
Cred_14669 vin1.$430.Metal1 vout1.P16.nSD 0.015411f
Cred_14670 vin1.$430.Metal1 VSS.$1623.Metal1 6.60482e-07f
Cred_14671 vin1.$430.Metal1 VSS.$1690.Metal1 7.35435e-08f
Cred_14672 vin1.$430.Metal1 VSS.$1989.Metal1 0.000404548f
Cred_14673 vin1.$430.Metal1 VSS.$2020.Metal1 0.00101291f
Cred_14674 vin1.$430.Metal1 VSS.$29.Metal1 1.33078e-05f
Cred_14675 vin1.$430.Metal1 VSS.$3784.Metal2 2.33344e-06f
Cred_14676 vin1.$430.Metal1 VSS.$3819.Metal2 1.44928e-05f
Cred_14677 vin1.$430.Metal1 VSS.$3875.Metal2 3.39178e-05f
Cred_14678 vin1.$430.Metal1 VSS.$4227.Metal2 2.71185e-06f
Cred_14679 vin1.$430.Metal1 VSS.$5075.Metal3 7.35435e-08f
Cred_14680 vin1.$430.Metal1 VSS.P1.pSD 0.0177797f
Cred_14681 vin1.$430.Metal1 VSS.P41.nSD 2.29316e-08f
Cred_14682 vin1.$433.Metal1 vout1.$1424.Metal3 0.0266176f
Cred_14683 vin1.$433.Metal1 vout1.P16.pSD 0.0222725f
Cred_14684 vin1.$437.Metal1 vout1 1.29706e-05f
Cred_14685 vin1.$437.Metal1 vout1.$1424.Metal3 0.0163742f
Cred_14686 vin1.$437.Metal1 vout1.P16.nSD 0.0129229f
Cred_14687 vin1.$437.Metal1 vout1.P18.nSD 1.82761e-06f
Cred_14688 vin1.$437.Metal1 vout1.P18.pSD 5.58169e-06f
Cred_14689 vin1.$437.Metal1 VSS.$1730.Metal1 0.000529433f
Cred_14690 vin1.$437.Metal1 VSS.$1778.Metal1 0.000598552f
Cred_14691 vin1.$437.Metal1 VSS.$1798.Metal1 0.000239742f
Cred_14692 vin1.$437.Metal1 VSS.$1989.Metal1 0.000451199f
Cred_14693 vin1.$437.Metal1 VSS.$2020.Metal1 0.00112971f
Cred_14694 vin1.$437.Metal1 VSS.$29.Metal1 1.16546e-05f
Cred_14695 vin1.$437.Metal1 VSS.$3923.Metal2 4.42291e-06f
Cred_14696 vin1.$437.Metal1 VSS.$3982.Metal2 5.86146e-05f
Cred_14697 vin1.$437.Metal1 VSS.$4014.Metal2 4.36492e-05f
Cred_14698 vin1.$437.Metal1 VSS.$4227.Metal2 3.02457e-06f
Cred_14699 vin1.$437.Metal1 VSS.P1.pSD 0.0174094f
Cred_14700 vin1.$437.Metal1 VSS.P43.nSD 8.97176e-06f
Cred_14701 vin1.$44.GatPoly vout1.$1226.Metal3 0.00814711f
Cred_14702 vin1.$44.GatPoly vout1.$1292.Metal3 0.000689313f
Cred_14703 vin1.$44.GatPoly vout1.P4.nSD 0.0033717f
Cred_14704 vin1.$44.GatPoly vout1.P6.nSD 2.4445e-05f
Cred_14705 vin1.$44.GatPoly vout1.P6.pSD 5.93495e-05f
Cred_14706 vin1.$44.GatPoly VSS.$1989.Metal1 1.11471e-06f
Cred_14707 vin1.$44.GatPoly VSS.$2020.Metal1 2.791e-06f
Cred_14708 vin1.$44.GatPoly VSS.$2825.Metal2 2.87971e-11f
Cred_14709 vin1.$44.GatPoly VSS.$2849.Metal2 5.78817e-11f
Cred_14710 vin1.$44.GatPoly VSS.$29.Metal1 0.000100497f
Cred_14711 vin1.$44.GatPoly VSS.$2908.Metal2 0.00144469f
Cred_14712 vin1.$44.GatPoly VSS.$2940.Metal2 5.48618e-05f
Cred_14713 vin1.$44.GatPoly VSS.$4227.Metal2 7.47233e-09f
Cred_14714 vin1.$44.GatPoly VSS.$663.Metal1 3.44676e-09f
Cred_14715 vin1.$44.GatPoly VSS.$731.Metal1 9.19509e-08f
Cred_14716 vin1.$44.GatPoly VSS.$774.Metal1 0.0053483f
Cred_14717 vin1.$44.GatPoly VSS.P1.pSD 0.00266104f
Cred_14718 vin1.$44.GatPoly VSS.P31.nSD 4.45362e-05f
Cred_14719 vin1.$440.Metal1 vout1 2.90243e-05f
Cred_14720 vin1.$440.Metal1 vout1.$1424.Metal3 0.00111056f
Cred_14721 vin1.$440.Metal1 vout1.P16.nSD 0.000376308f
Cred_14722 vin1.$440.Metal1 vout1.P18.nSD 4.08965e-06f
Cred_14723 vin1.$440.Metal1 vout1.P18.pSD 1.24902e-05f
Cred_14724 vin1.$440.Metal1 VSS.$1730.Metal1 0.000145714f
Cred_14725 vin1.$440.Metal1 VSS.$1778.Metal1 0.00212675f
Cred_14726 vin1.$440.Metal1 VSS.$1798.Metal1 0.00768135f
Cred_14727 vin1.$440.Metal1 VSS.$1989.Metal1 0.000516075f
Cred_14728 vin1.$440.Metal1 VSS.$2020.Metal1 0.00129215f
Cred_14729 vin1.$440.Metal1 VSS.$29.Metal1 1.00117e-05f
Cred_14730 vin1.$440.Metal1 VSS.$3923.Metal2 2.09779e-05f
Cred_14731 vin1.$440.Metal1 VSS.$3982.Metal2 0.000518159f
Cred_14732 vin1.$440.Metal1 VSS.$4014.Metal2 0.000371147f
Cred_14733 vin1.$440.Metal1 VSS.$4227.Metal2 3.45946e-06f
Cred_14734 vin1.$440.Metal1 VSS.$5123.Metal3 1.58436e-07f
Cred_14735 vin1.$440.Metal1 VSS.P1.pSD 0.0170337f
Cred_14736 vin1.$440.Metal1 VSS.P43.nSD 0.000293242f
Cred_14737 vin1.$441.Metal1 vout1.$1424.Metal3 0.00561461f
Cred_14738 vin1.$441.Metal1 vout1.P16.pSD 0.00387364f
Cred_14739 vin1.$448.Metal1 vout1 8.26931e-07f
Cred_14740 vin1.$448.Metal1 vout1.$1424.Metal3 1.39243e-05f
Cred_14741 vin1.$448.Metal1 vout1.P18.nSD 6.5704e-08f
Cred_14742 vin1.$448.Metal1 vout1.P18.pSD 3.55857e-07f
Cred_14743 vin1.$448.Metal1 VSS.$1730.Metal1 7.83657e-06f
Cred_14744 vin1.$448.Metal1 VSS.$1778.Metal1 0.00013565f
Cred_14745 vin1.$448.Metal1 VSS.$1798.Metal1 0.0419833f
Cred_14746 vin1.$448.Metal1 VSS.$1869.Metal1 0.000306238f
Cred_14747 vin1.$448.Metal1 VSS.$1989.Metal1 0.000781996f
Cred_14748 vin1.$448.Metal1 VSS.$2020.Metal1 0.00195796f
Cred_14749 vin1.$448.Metal1 VSS.$29.Metal1 1.13486e-05f
Cred_14750 vin1.$448.Metal1 VSS.$3923.Metal2 2.85347e-06f
Cred_14751 vin1.$448.Metal1 VSS.$3982.Metal2 0.00207838f
Cred_14752 vin1.$448.Metal1 VSS.$4014.Metal2 0.00154814f
Cred_14753 vin1.$448.Metal1 VSS.$4062.Metal2 1.53248e-06f
Cred_14754 vin1.$448.Metal1 VSS.$4227.Metal2 5.24203e-06f
Cred_14755 vin1.$448.Metal1 VSS.$5123.Metal3 2.23536e-08f
Cred_14756 vin1.$448.Metal1 VSS.$5159.Metal3 1.22871e-08f
Cred_14757 vin1.$448.Metal1 VSS.P1.pSD 0.0219597f
Cred_14758 vin1.$448.Metal1 VSS.P43.nSD 0.00156422f
Cred_14759 vin1.$449.Metal1 vout1.$1424.Metal3 9.75371e-06f
Cred_14760 vin1.$453.Metal1 vout1 1.6785e-06f
Cred_14761 vin1.$453.Metal1 vout1.$1424.Metal3 8.46547e-06f
Cred_14762 vin1.$453.Metal1 vout1.P18.nSD 1.33366e-07f
Cred_14763 vin1.$453.Metal1 vout1.P18.pSD 7.22317e-07f
Cred_14764 vin1.$456.Metal1 vout1 0.00552697f
Cred_14765 vin1.$456.Metal1 vout1.$1424.Metal3 0.0280234f
Cred_14766 vin1.$456.Metal1 vout1.P16.nSD 1.39007e-06f
Cred_14767 vin1.$456.Metal1 vout1.P18.nSD 0.0269007f
Cred_14768 vin1.$456.Metal1 vout1.P18.pSD 0.00237845f
Cred_14769 vin1.$456.Metal1 VSS.$1798.Metal1 0.006826f
Cred_14770 vin1.$456.Metal1 VSS.$1869.Metal1 0.00151066f
Cred_14771 vin1.$456.Metal1 VSS.$1917.Metal1 0.000749035f
Cred_14772 vin1.$456.Metal1 VSS.$1977.Metal1 0.000630463f
Cred_14773 vin1.$456.Metal1 VSS.$1989.Metal1 0.00305066f
Cred_14774 vin1.$456.Metal1 VSS.$2020.Metal1 0.00850068f
Cred_14775 vin1.$456.Metal1 VSS.$29.Metal1 2.24234e-05f
Cred_14776 vin1.$456.Metal1 VSS.$3982.Metal2 0.000340553f
Cred_14777 vin1.$456.Metal1 VSS.$4014.Metal2 0.00027649f
Cred_14778 vin1.$456.Metal1 VSS.$4062.Metal2 2.30851e-05f
Cred_14779 vin1.$456.Metal1 VSS.$4110.Metal2 5.68117e-05f
Cred_14780 vin1.$456.Metal1 VSS.$4134.Metal2 5.27123e-06f
Cred_14781 vin1.$456.Metal1 VSS.$4227.Metal2 4.10417e-05f
Cred_14782 vin1.$456.Metal1 VSS.$5159.Metal3 1.75811e-07f
Cred_14783 vin1.$456.Metal1 VSS.P1.pSD 0.0570481f
Cred_14784 vin1.$456.Metal1 VSS.P3.GatPoly 0.00160798f
Cred_14785 vin1.$456.Metal1 VSS.P43.nSD 0.000253611f
Cred_14786 vin1.$456.Metal1 VSS.P45.nSD 5.78261e-06f
Cred_14787 vin1.$456.Metal1 VSS.P47.nSD 5.78261e-06f
Cred_14788 vin1.$457.Metal1 vout1 0.011952f
Cred_14789 vin1.$457.Metal1 vout1.$1424.Metal3 0.0602796f
Cred_14790 vin1.$457.Metal1 vout1.P18.nSD 0.000949648f
Cred_14791 vin1.$457.Metal1 vout1.P18.pSD 0.0606796f
Cred_14792 vin1.$457.Metal1 VSS.$4134.Metal2 0.000968708f
Cred_14793 vin1.$47.GatPoly vout1.$1226.Metal3 0.05686f
Cred_14794 vin1.$47.GatPoly vout1.$1292.Metal3 0.00278657f
Cred_14795 vin1.$47.GatPoly vout1.P4.pSD 0.0337983f
Cred_14796 vin1.$47.GatPoly vout1.P6.nSD 4.38997e-05f
Cred_14797 vin1.$47.GatPoly vout1.P6.pSD 0.000651467f
Cred_14798 vin1.$477.Metal2 vout1.$1226.Metal3 0.157549f
Cred_14799 vin1.$477.Metal2 vout1.P0.nSD 0.0112965f
Cred_14800 vin1.$477.Metal2 vout1.P0.pSD 0.0346722f
Cred_14801 vin1.$477.Metal2 vout1.P2.nSD 0.00248204f
Cred_14802 vin1.$477.Metal2 vout1.P2.pSD 0.0135649f
Cred_14803 vin1.$477.Metal2 VSS.$157.Metal1 0.00113043f
Cred_14804 vin1.$477.Metal2 VSS.$1989.Metal1 7.68093e-06f
Cred_14805 vin1.$477.Metal2 VSS.$2020.Metal1 1.92315e-05f
Cred_14806 vin1.$477.Metal2 VSS.$2226.Metal2 0.0187079f
Cred_14807 vin1.$477.Metal2 VSS.$2342.Metal2 0.000167068f
Cred_14808 vin1.$477.Metal2 VSS.$2403.Metal2 0.00124673f
Cred_14809 vin1.$477.Metal2 VSS.$2427.Metal2 0.00121999f
Cred_14810 vin1.$477.Metal2 VSS.$257.Metal1 2.65819e-05f
Cred_14811 vin1.$477.Metal2 VSS.$29.Metal1 0.0267672f
Cred_14812 vin1.$477.Metal2 VSS.$317.Metal1 2.43061e-05f
Cred_14813 vin1.$477.Metal2 VSS.$4227.Metal2 5.14884e-08f
Cred_14814 vin1.$477.Metal2 VSS.$4355.Metal3 0.00442246f
Cred_14815 vin1.$477.Metal2 VSS.$4415.Metal3 4.94716e-05f
Cred_14816 vin1.$477.Metal2 VSS.$4451.Metal3 3.51931e-05f
Cred_14817 vin1.$477.Metal2 VSS.P1.pSD 0.0873513f
Cred_14818 vin1.$477.Metal2 VSS.P2.GatPoly 0.00153218f
Cred_14819 vin1.$477.Metal2 VSS.P24.nSD 4.8543e-06f
Cred_14820 vin1.$477.Metal2 VSS.P25.nSD 4.8543e-06f
Cred_14821 vin1.$479.Metal2 vout1.$1226.Metal3 0.0913809f
Cred_14822 vin1.$479.Metal2 vout1.P0.nSD 0.0191572f
Cred_14823 vin1.$479.Metal2 vout1.P0.pSD 0.0144591f
Cred_14824 vin1.$479.Metal2 vout1.P2.nSD 0.00143962f
Cred_14825 vin1.$479.Metal2 vout1.P2.pSD 0.00786786f
Cred_14826 vin1.$479.Metal2 VSS.$157.Metal1 0.00212534f
Cred_14827 vin1.$479.Metal2 VSS.$1989.Metal1 2.97162e-06f
Cred_14828 vin1.$479.Metal2 VSS.$2020.Metal1 7.44035e-06f
Cred_14829 vin1.$479.Metal2 VSS.$2226.Metal2 0.0348706f
Cred_14830 vin1.$479.Metal2 VSS.$2342.Metal2 0.000311402f
Cred_14831 vin1.$479.Metal2 VSS.$2403.Metal2 0.00232322f
Cred_14832 vin1.$479.Metal2 VSS.$2427.Metal2 0.00227355f
Cred_14833 vin1.$479.Metal2 VSS.$2475.Metal2 0.00280512f
Cred_14834 vin1.$479.Metal2 VSS.$2526.Metal2 0.00123426f
Cred_14835 vin1.$479.Metal2 VSS.$2558.Metal2 4.23036e-07f
Cred_14836 vin1.$479.Metal2 VSS.$257.Metal1 6.2926e-05f
Cred_14837 vin1.$479.Metal2 VSS.$29.Metal1 0.0166472f
Cred_14838 vin1.$479.Metal2 VSS.$317.Metal1 5.82599e-05f
Cred_14839 vin1.$479.Metal2 VSS.$365.Metal1 1.02915e-05f
Cred_14840 vin1.$479.Metal2 VSS.$385.Metal1 8.49027e-06f
Cred_14841 vin1.$479.Metal2 VSS.$4227.Metal2 1.992e-08f
Cred_14842 vin1.$479.Metal2 VSS.$4355.Metal3 0.00824314f
Cred_14843 vin1.$479.Metal2 VSS.$4415.Metal3 2.75835e-06f
Cred_14844 vin1.$479.Metal2 VSS.$4475.Metal3 9.89346e-06f
Cred_14845 vin1.$479.Metal2 VSS.P1.pSD 0.0392125f
Cred_14846 vin1.$479.Metal2 VSS.P2.GatPoly 0.00144983f
Cred_14847 vin1.$479.Metal2 VSS.P24.nSD 9.17079e-06f
Cred_14848 vin1.$479.Metal2 VSS.P25.nSD 9.17079e-06f
Cred_14849 vin1.$479.Metal2 VSS.P27.nSD 3.15318e-07f
Cred_14850 vin1.$480.Metal2 vout1.$1226.Metal3 0.0863808f
Cred_14851 vin1.$480.Metal2 vout1.P0.nSD 0.00257215f
Cred_14852 vin1.$480.Metal2 vout1.P0.pSD 0.0378089f
Cred_14853 vin1.$480.Metal2 vout1.P2.nSD 0.00136085f
Cred_14854 vin1.$480.Metal2 vout1.P2.pSD 0.00743735f
Cred_14855 vin1.$480.Metal2 VSS.$1989.Metal1 1.07953e-06f
Cred_14856 vin1.$480.Metal2 VSS.$2020.Metal1 2.70292e-06f
Cred_14857 vin1.$480.Metal2 VSS.$2403.Metal2 9.4431e-07f
Cred_14858 vin1.$480.Metal2 VSS.$2427.Metal2 6.92477e-07f
Cred_14859 vin1.$480.Metal2 VSS.$29.Metal1 0.00930313f
Cred_14860 vin1.$480.Metal2 VSS.$4227.Metal2 7.2365e-09f
Cred_14861 vin1.$480.Metal2 VSS.$4415.Metal3 0.000117777f
Cred_14862 vin1.$480.Metal2 VSS.$4451.Metal3 8.63677e-05f
Cred_14863 vin1.$480.Metal2 VSS.P1.pSD 0.0178992f
Cred_14864 vin1.$480.Metal2 VSS.P2.GatPoly 0.00143774f
Cred_14865 vin1.$483.Metal2 vout1.$1226.Metal3 0.019879f
Cred_14866 vin1.$483.Metal2 vout1.P0.nSD 0.000543235f
Cred_14867 vin1.$483.Metal2 vout1.P0.pSD 0.00260114f
Cred_14868 vin1.$483.Metal2 vout1.P2.nSD 0.000366959f
Cred_14869 vin1.$483.Metal2 vout1.P2.pSD 0.00171158f
Cred_14870 vin1.$483.Metal2 VSS.$1989.Metal1 6.83783e-07f
Cred_14871 vin1.$483.Metal2 VSS.$2020.Metal1 1.71206e-06f
Cred_14872 vin1.$483.Metal2 VSS.$2475.Metal2 0.00123396f
Cred_14873 vin1.$483.Metal2 VSS.$2526.Metal2 0.0154724f
Cred_14874 vin1.$483.Metal2 VSS.$2558.Metal2 0.0191202f
Cred_14875 vin1.$483.Metal2 VSS.$29.Metal1 0.000781602f
Cred_14876 vin1.$483.Metal2 VSS.$365.Metal1 1.43018e-05f
Cred_14877 vin1.$483.Metal2 VSS.$385.Metal1 0.00303883f
Cred_14878 vin1.$483.Metal2 VSS.$4227.Metal2 4.58368e-09f
Cred_14879 vin1.$483.Metal2 VSS.$4475.Metal3 9.89362e-06f
Cred_14880 vin1.$483.Metal2 VSS.P1.pSD 0.00525331f
Cred_14881 vin1.$483.Metal2 VSS.P27.nSD 0.000105958f
Cred_14882 vin1.$484.Metal2 vout1.$1226.Metal3 0.018944f
Cred_14883 vin1.$484.Metal2 vout1.P0.nSD 0.000473205f
Cred_14884 vin1.$484.Metal2 vout1.P0.pSD 0.00280077f
Cred_14885 vin1.$484.Metal2 vout1.P2.nSD 0.000298445f
Cred_14886 vin1.$484.Metal2 vout1.P2.pSD 0.001896f
Cred_14887 vin1.$486.Metal2 vout1.$1226.Metal3 0.0980332f
Cred_14888 vin1.$486.Metal2 vout1.P0.nSD 0.00241165f
Cred_14889 vin1.$486.Metal2 vout1.P0.pSD 0.0128154f
Cred_14890 vin1.$486.Metal2 vout1.P2.nSD 0.00156531f
Cred_14891 vin1.$486.Metal2 vout1.P2.pSD 0.00854352f
Cred_14892 vin1.$486.Metal2 VSS.$1989.Metal1 6.51159e-06f
Cred_14893 vin1.$486.Metal2 VSS.$2020.Metal1 1.63037e-05f
Cred_14894 vin1.$486.Metal2 VSS.$2526.Metal2 0.00221267f
Cred_14895 vin1.$486.Metal2 VSS.$2558.Metal2 0.0029713f
Cred_14896 vin1.$486.Metal2 VSS.$29.Metal1 0.00642603f
Cred_14897 vin1.$486.Metal2 VSS.$385.Metal1 0.000448976f
Cred_14898 vin1.$486.Metal2 VSS.$4227.Metal2 4.36498e-08f
Cred_14899 vin1.$486.Metal2 VSS.P1.pSD 0.0470997f
Cred_14900 vin1.$486.Metal2 VSS.P27.nSD 1.55876e-05f
Cred_14901 vin1.$488.Metal2 vout1.$1226.Metal3 0.0241692f
Cred_14902 vin1.$488.Metal2 vout1.P0.nSD 0.000579645f
Cred_14903 vin1.$488.Metal2 vout1.P0.pSD 0.00269673f
Cred_14904 vin1.$488.Metal2 vout1.P2.nSD 0.000452987f
Cred_14905 vin1.$488.Metal2 vout1.P2.pSD 0.00208096f
Cred_14906 vin1.$488.Metal2 VSS.$1989.Metal1 1.09271e-06f
Cred_14907 vin1.$488.Metal2 VSS.$2020.Metal1 2.73592e-06f
Cred_14908 vin1.$488.Metal2 VSS.$2526.Metal2 0.0174818f
Cred_14909 vin1.$488.Metal2 VSS.$2558.Metal2 0.0246652f
Cred_14910 vin1.$488.Metal2 VSS.$2614.Metal2 0.00118965f
Cred_14911 vin1.$488.Metal2 VSS.$29.Metal1 0.000992589f
Cred_14912 vin1.$488.Metal2 VSS.$385.Metal1 0.00370329f
Cred_14913 vin1.$488.Metal2 VSS.$4227.Metal2 7.32486e-09f
Cred_14914 vin1.$488.Metal2 VSS.$4511.Metal3 9.53831e-06f
Cred_14915 vin1.$488.Metal2 VSS.$456.Metal1 1.33539e-05f
Cred_14916 vin1.$488.Metal2 VSS.$504.Metal1 2.20468e-07f
Cred_14917 vin1.$488.Metal2 VSS.P1.pSD 0.00759969f
Cred_14918 vin1.$488.Metal2 VSS.P27.nSD 0.000129173f
Cred_14919 vin1.$489.Metal2 vout1.$1226.Metal3 0.0229136f
Cred_14920 vin1.$489.Metal2 vout1.P0.nSD 0.000485607f
Cred_14921 vin1.$489.Metal2 vout1.P0.pSD 0.00296482f
Cred_14922 vin1.$489.Metal2 vout1.P2.nSD 0.000360983f
Cred_14923 vin1.$489.Metal2 vout1.P2.pSD 0.00232861f
Cred_14924 vin1.$492.Metal2 vout1.$1226.Metal3 0.0303152f
Cred_14925 vin1.$492.Metal2 vout1.P0.nSD 0.000439011f
Cred_14926 vin1.$492.Metal2 vout1.P0.pSD 0.00233283f
Cred_14927 vin1.$492.Metal2 vout1.P2.nSD 0.00472695f
Cred_14928 vin1.$492.Metal2 vout1.P2.pSD 0.00261012f
Cred_14929 vin1.$492.Metal2 VSS.$1989.Metal1 7.11529e-07f
Cred_14930 vin1.$492.Metal2 VSS.$2020.Metal1 1.78153e-06f
Cred_14931 vin1.$492.Metal2 VSS.$2526.Metal2 6.70053e-07f
Cred_14932 vin1.$492.Metal2 VSS.$2558.Metal2 0.00119052f
Cred_14933 vin1.$492.Metal2 VSS.$2614.Metal2 0.00353881f
Cred_14934 vin1.$492.Metal2 VSS.$29.Metal1 0.000453989f
Cred_14935 vin1.$492.Metal2 VSS.$385.Metal1 1.75061e-05f
Cred_14936 vin1.$492.Metal2 VSS.$4227.Metal2 4.76967e-09f
Cred_14937 vin1.$492.Metal2 VSS.$4511.Metal3 9.53807e-06f
Cred_14938 vin1.$492.Metal2 VSS.$456.Metal1 1.24159e-05f
Cred_14939 vin1.$492.Metal2 VSS.$504.Metal1 5.98294e-07f
Cred_14940 vin1.$492.Metal2 VSS.P1.pSD 0.00425093f
Cred_14941 vin1.$492.Metal2 VSS.P27.nSD 6.69298e-07f
Cred_14942 vin1.$493.Metal2 vout1.$1226.Metal3 0.0495575f
Cred_14943 vin1.$493.Metal2 vout1.P0.nSD 0.00071767f
Cred_14944 vin1.$493.Metal2 vout1.P0.pSD 0.00381358f
Cred_14945 vin1.$493.Metal2 vout1.P2.nSD 0.000780732f
Cred_14946 vin1.$493.Metal2 vout1.P2.pSD 0.014777f
Cred_14947 vin1.$495.Metal2 vout1.$1226.Metal3 0.130126f
Cred_14948 vin1.$495.Metal2 vout1.P0.nSD 0.00188443f
Cred_14949 vin1.$495.Metal2 vout1.P0.pSD 0.0100136f
Cred_14950 vin1.$495.Metal2 vout1.P2.nSD 0.00319518f
Cred_14951 vin1.$495.Metal2 vout1.P2.pSD 0.015747f
Cred_14952 vin1.$495.Metal2 VSS.$1989.Metal1 9.19956e-06f
Cred_14953 vin1.$495.Metal2 VSS.$2020.Metal1 2.30338e-05f
Cred_14954 vin1.$495.Metal2 VSS.$29.Metal1 0.00448474f
Cred_14955 vin1.$495.Metal2 VSS.$4227.Metal2 6.16684e-08f
Cred_14956 vin1.$495.Metal2 VSS.P1.pSD 0.0484988f
Cred_14957 vin1.$497.Metal2 vout1.$1226.Metal3 0.0769369f
Cred_14958 vin1.$497.Metal2 vout1.P0.nSD 0.00111417f
Cred_14959 vin1.$497.Metal2 vout1.P0.pSD 0.0059205f
Cred_14960 vin1.$497.Metal2 vout1.P2.nSD 0.0141958f
Cred_14961 vin1.$497.Metal2 vout1.P2.pSD 0.00662423f
Cred_14962 vin1.$497.Metal2 VSS.$1989.Metal1 2.22225e-06f
Cred_14963 vin1.$497.Metal2 VSS.$2020.Metal1 5.56408e-06f
Cred_14964 vin1.$497.Metal2 VSS.$2662.Metal2 0.00282265f
Cred_14965 vin1.$497.Metal2 VSS.$2721.Metal2 0.00120609f
Cred_14966 vin1.$497.Metal2 VSS.$2753.Metal2 0.00019419f
Cred_14967 vin1.$497.Metal2 VSS.$29.Metal1 0.00103988f
Cred_14968 vin1.$497.Metal2 VSS.$4227.Metal2 1.48967e-08f
Cred_14969 vin1.$497.Metal2 VSS.$4559.Metal3 6.12031e-06f
Cred_14970 vin1.$497.Metal2 VSS.$544.Metal1 6.12031e-06f
Cred_14971 vin1.$497.Metal2 VSS.$564.Metal1 5.49654e-05f
Cred_14972 vin1.$497.Metal2 VSS.P1.pSD 0.0114396f
Cred_14973 vin1.$497.Metal2 VSS.P29.nSD 1.90837e-06f
Cred_14974 vin1.$500.Metal2 vout1.$1226.Metal3 0.0453728f
Cred_14975 vin1.$500.Metal2 vout1.P0.nSD 0.000657069f
Cred_14976 vin1.$500.Metal2 vout1.P0.pSD 0.00349156f
Cred_14977 vin1.$500.Metal2 vout1.P2.nSD 0.000714806f
Cred_14978 vin1.$500.Metal2 vout1.P2.pSD 0.0129722f
Cred_14979 vin1.$503.Metal2 vout1.$1226.Metal3 0.0387021f
Cred_14980 vin1.$503.Metal2 vout1.P0.nSD 0.00036249f
Cred_14981 vin1.$503.Metal2 vout1.P0.pSD 0.00192621f
Cred_14982 vin1.$503.Metal2 vout1.P2.nSD 0.00144319f
Cred_14983 vin1.$503.Metal2 vout1.P2.pSD 0.00215517f
Cred_14984 vin1.$503.Metal2 vout1.P4.nSD 6.94739e-05f
Cred_14985 vin1.$503.Metal2 VSS.$1989.Metal1 2.21818e-06f
Cred_14986 vin1.$503.Metal2 VSS.$2020.Metal1 5.55388e-06f
Cred_14987 vin1.$503.Metal2 VSS.$2662.Metal2 0.00256115f
Cred_14988 vin1.$503.Metal2 VSS.$2721.Metal2 0.0328856f
Cred_14989 vin1.$503.Metal2 VSS.$2753.Metal2 0.0137476f
Cred_14990 vin1.$503.Metal2 VSS.$29.Metal1 0.000623986f
Cred_14991 vin1.$503.Metal2 VSS.$4227.Metal2 1.48694e-08f
Cred_14992 vin1.$503.Metal2 VSS.$4559.Metal3 1.23569e-05f
Cred_14993 vin1.$503.Metal2 VSS.$544.Metal1 1.23569e-05f
Cred_14994 vin1.$503.Metal2 VSS.$564.Metal1 0.00393458f
Cred_14995 vin1.$503.Metal2 VSS.P1.pSD 0.00903713f
Cred_14996 vin1.$503.Metal2 VSS.P29.nSD 0.000136794f
Cred_14997 vin1.$504.Metal2 vout1.$1226.Metal3 0.0299793f
Cred_14998 vin1.$504.Metal2 vout1.P0.nSD 0.00024078f
Cred_14999 vin1.$504.Metal2 vout1.P0.pSD 0.00127947f
Cred_15000 vin1.$504.Metal2 vout1.P2.nSD 0.000261938f
Cred_15001 vin1.$504.Metal2 vout1.P2.pSD 0.00181934f
Cred_15002 vin1.$504.Metal2 vout1.P4.pSD 0.000387787f
Cred_15003 vin1.$506.Metal2 vout1.$1226.Metal3 0.109705f
Cred_15004 vin1.$506.Metal2 vout1.P0.nSD 0.000720669f
Cred_15005 vin1.$506.Metal2 vout1.P0.pSD 0.00382952f
Cred_15006 vin1.$506.Metal2 vout1.P2.nSD 0.000792089f
Cred_15007 vin1.$506.Metal2 vout1.P2.pSD 0.00432936f
Cred_15008 vin1.$506.Metal2 vout1.P4.nSD 8.09507e-06f
Cred_15009 vin1.$506.Metal2 vout1.P4.pSD 4.46531e-05f
Cred_15010 vin1.$506.Metal2 VSS.$1989.Metal1 1.29956e-05f
Cred_15011 vin1.$506.Metal2 VSS.$2020.Metal1 3.25383e-05f
Cred_15012 vin1.$506.Metal2 VSS.$2721.Metal2 0.00330681f
Cred_15013 vin1.$506.Metal2 VSS.$2753.Metal2 0.00145036f
Cred_15014 vin1.$506.Metal2 VSS.$29.Metal1 0.00316293f
Cred_15015 vin1.$506.Metal2 VSS.$4227.Metal2 8.71145e-08f
Cred_15016 vin1.$506.Metal2 VSS.$564.Metal1 0.000410524f
Cred_15017 vin1.$506.Metal2 VSS.P1.pSD 0.049622f
Cred_15018 vin1.$506.Metal2 VSS.P29.nSD 1.42532e-05f
Cred_15019 vin1.$508.Metal2 vout1.$1226.Metal3 0.0171927f
Cred_15020 vin1.$508.Metal2 vout1.P0.nSD 5.41085e-05f
Cred_15021 vin1.$508.Metal2 vout1.P0.pSD 0.000287524f
Cred_15022 vin1.$508.Metal2 vout1.P2.nSD 7.60473e-05f
Cred_15023 vin1.$508.Metal2 vout1.P2.pSD 0.0003217f
Cred_15024 vin1.$508.Metal2 vout1.P4.nSD 1.71843e-05f
Cred_15025 vin1.$508.Metal2 VSS.$1989.Metal1 1.71427e-06f
Cred_15026 vin1.$508.Metal2 VSS.$2020.Metal1 4.29217e-06f
Cred_15027 vin1.$508.Metal2 VSS.$2721.Metal2 0.0187469f
Cred_15028 vin1.$508.Metal2 VSS.$2753.Metal2 0.00942665f
Cred_15029 vin1.$508.Metal2 VSS.$2777.Metal2 0.00249571f
Cred_15030 vin1.$508.Metal2 VSS.$29.Metal1 0.000364753f
Cred_15031 vin1.$508.Metal2 VSS.$4227.Metal2 1.14914e-08f
Cred_15032 vin1.$508.Metal2 VSS.$564.Metal1 0.00250348f
Cred_15033 vin1.$508.Metal2 VSS.P1.pSD 0.00612796f
Cred_15034 vin1.$508.Metal2 VSS.P29.nSD 8.75729e-05f
Cred_15035 vin1.$509.Metal2 vout1.$1226.Metal3 0.0174091f
Cred_15036 vin1.$509.Metal2 vout1.P0.nSD 5.31665e-05f
Cred_15037 vin1.$509.Metal2 vout1.P0.pSD 0.000282518f
Cred_15038 vin1.$509.Metal2 vout1.P2.nSD 5.78383e-05f
Cred_15039 vin1.$509.Metal2 vout1.P2.pSD 0.000410889f
Cred_15040 vin1.$509.Metal2 vout1.P4.pSD 9.47899e-05f
Cred_15041 vin1.$512.Metal2 vout1.$1226.Metal3 0.0580995f
Cred_15042 vin1.$512.Metal2 vout1.P4.nSD 0.00708686f
Cred_15043 vin1.$512.Metal2 VSS.$1989.Metal1 1.69801e-06f
Cred_15044 vin1.$512.Metal2 VSS.$2020.Metal1 4.25146e-06f
Cred_15045 vin1.$512.Metal2 VSS.$2777.Metal2 0.00305041f
Cred_15046 vin1.$512.Metal2 VSS.$2825.Metal2 0.000554698f
Cred_15047 vin1.$512.Metal2 VSS.$29.Metal1 0.000250088f
Cred_15048 vin1.$512.Metal2 VSS.$4227.Metal2 1.13824e-08f
Cred_15049 vin1.$512.Metal2 VSS.$4607.Metal3 4.44744e-06f
Cred_15050 vin1.$512.Metal2 VSS.$663.Metal1 4.44744e-06f
Cred_15051 vin1.$512.Metal2 VSS.P1.pSD 0.00509649f
Cred_15052 vin1.$513.Metal2 vout1.$1226.Metal3 0.0496893f
Cred_15053 vin1.$513.Metal2 vout1.P4.pSD 0.00878399f
Cred_15054 vin1.$515.Metal2 vout1.$1226.Metal3 0.174793f
Cred_15055 vin1.$515.Metal2 vout1.$1292.Metal3 0.00903794f
Cred_15056 vin1.$515.Metal2 vout1.P4.nSD 0.00122542f
Cred_15057 vin1.$515.Metal2 vout1.P4.pSD 0.00137652f
Cred_15058 vin1.$515.Metal2 vout1.P6.nSD 0.000142683f
Cred_15059 vin1.$515.Metal2 vout1.P6.pSD 0.000778162f
Cred_15060 vin1.$515.Metal2 VSS.$1989.Metal1 2.81179e-05f
Cred_15061 vin1.$515.Metal2 VSS.$2020.Metal1 7.04016e-05f
Cred_15062 vin1.$515.Metal2 VSS.$29.Metal1 0.00289581f
Cred_15063 vin1.$515.Metal2 VSS.$2908.Metal2 0.00149036f
Cred_15064 vin1.$515.Metal2 VSS.$2940.Metal2 5.65961e-05f
Cred_15065 vin1.$515.Metal2 VSS.$4227.Metal2 1.88486e-07f
Cred_15066 vin1.$515.Metal2 VSS.$774.Metal1 0.000143935f
Cred_15067 vin1.$515.Metal2 VSS.P1.pSD 0.0704749f
Cred_15068 vin1.$515.Metal2 VSS.P31.nSD 8.41734e-07f
Cred_15069 vin1.$517.Metal2 vout1.$1226.Metal3 0.0773344f
Cred_15070 vin1.$517.Metal2 vout1.P4.nSD 0.0112674f
Cred_15071 vin1.$517.Metal2 VSS.$1989.Metal1 3.70178e-06f
Cred_15072 vin1.$517.Metal2 VSS.$2020.Metal1 9.2685e-06f
Cred_15073 vin1.$517.Metal2 VSS.$2825.Metal2 6.12933e-09f
Cred_15074 vin1.$517.Metal2 VSS.$2849.Metal2 0.00339829f
Cred_15075 vin1.$517.Metal2 VSS.$29.Metal1 0.000412597f
Cred_15076 vin1.$517.Metal2 VSS.$2908.Metal2 0.00468475f
Cred_15077 vin1.$517.Metal2 VSS.$2940.Metal2 0.000160829f
Cred_15078 vin1.$517.Metal2 VSS.$4227.Metal2 2.48145e-08f
Cred_15079 vin1.$517.Metal2 VSS.$4643.Metal3 3.60466e-06f
Cred_15080 vin1.$517.Metal2 VSS.$663.Metal1 7.33628e-07f
Cred_15081 vin1.$517.Metal2 VSS.$731.Metal1 5.22427e-06f
Cred_15082 vin1.$517.Metal2 VSS.$774.Metal1 0.000409021f
Cred_15083 vin1.$517.Metal2 VSS.P1.pSD 0.00970868f
Cred_15084 vin1.$517.Metal2 VSS.P31.nSD 2.39196e-06f
Cred_15085 vin1.$518.Metal2 vout1.$1226.Metal3 0.0607039f
Cred_15086 vin1.$518.Metal2 vout1.P4.pSD 0.0130944f
Cred_15087 vin1.$52.GatPoly VSS.$1989.Metal1 1.4764e-06f
Cred_15088 vin1.$52.GatPoly VSS.$2020.Metal1 3.69662e-06f
Cred_15089 vin1.$52.GatPoly VSS.$2825.Metal2 2.20213e-11f
Cred_15090 vin1.$52.GatPoly VSS.$2849.Metal2 4.42625e-11f
Cred_15091 vin1.$52.GatPoly VSS.$29.Metal1 9.52108e-05f
Cred_15092 vin1.$52.GatPoly VSS.$2908.Metal2 0.000147958f
Cred_15093 vin1.$52.GatPoly VSS.$2940.Metal2 6.46772e-06f
Cred_15094 vin1.$52.GatPoly VSS.$4227.Metal2 9.89694e-09f
Cred_15095 vin1.$52.GatPoly VSS.$663.Metal1 2.63576e-09f
Cred_15096 vin1.$52.GatPoly VSS.$731.Metal1 7.03154e-08f
Cred_15097 vin1.$52.GatPoly VSS.$762.Metal1 0.00548286f
Cred_15098 vin1.$52.GatPoly VSS.$774.Metal1 0.00687275f
Cred_15099 vin1.$52.GatPoly VSS.$822.Metal1 0.000101628f
Cred_15100 vin1.$52.GatPoly VSS.P1.pSD 0.00299787f
Cred_15101 vin1.$52.GatPoly VSS.P31.nSD 6.41932e-05f
Cred_15102 vin1.$520.Metal2 vout1.$1226.Metal3 0.0191896f
Cred_15103 vin1.$520.Metal2 vout1.$1292.Metal3 4.91937e-05f
Cred_15104 vin1.$520.Metal2 vout1.P4.pSD 0.000892535f
Cred_15105 vin1.$520.Metal2 vout1.P6.nSD 7.75001e-07f
Cred_15106 vin1.$520.Metal2 vout1.P6.pSD 9.98113e-06f
Cred_15107 vin1.$523.Metal2 vout1.$1226.Metal3 0.0510252f
Cred_15108 vin1.$523.Metal2 vout1.$1292.Metal3 0.0134562f
Cred_15109 vin1.$523.Metal2 vout1.P4.nSD 0.000190756f
Cred_15110 vin1.$523.Metal2 vout1.P6.nSD 0.000304649f
Cred_15111 vin1.$523.Metal2 vout1.P6.pSD 0.00115857f
Cred_15112 vin1.$523.Metal2 VSS.$1989.Metal1 1.05223e-05f
Cred_15113 vin1.$523.Metal2 VSS.$2020.Metal1 2.63457e-05f
Cred_15114 vin1.$523.Metal2 VSS.$2825.Metal2 3.03569e-09f
Cred_15115 vin1.$523.Metal2 VSS.$2849.Metal2 0.00236814f
Cred_15116 vin1.$523.Metal2 VSS.$29.Metal1 0.000682296f
Cred_15117 vin1.$523.Metal2 VSS.$2908.Metal2 0.0514072f
Cred_15118 vin1.$523.Metal2 VSS.$2940.Metal2 0.0019177f
Cred_15119 vin1.$523.Metal2 VSS.$4227.Metal2 7.05351e-08f
Cred_15120 vin1.$523.Metal2 VSS.$4643.Metal3 7.27792e-06f
Cred_15121 vin1.$523.Metal2 VSS.$663.Metal1 3.63346e-07f
Cred_15122 vin1.$523.Metal2 VSS.$731.Metal1 8.08006e-06f
Cred_15123 vin1.$523.Metal2 VSS.$774.Metal1 0.00513633f
Cred_15124 vin1.$523.Metal2 VSS.P1.pSD 0.02128f
Cred_15125 vin1.$523.Metal2 VSS.P31.nSD 3.10561e-05f
Cred_15126 vin1.$527.Metal2 vout1.$1226.Metal3 0.0502821f
Cred_15127 vin1.$527.Metal2 vout1.$1292.Metal3 0.0180083f
Cred_15128 vin1.$527.Metal2 vout1.P4.nSD 1.43057e-07f
Cred_15129 vin1.$527.Metal2 vout1.P4.pSD 0.000521155f
Cred_15130 vin1.$527.Metal2 vout1.P6.nSD 0.000283847f
Cred_15131 vin1.$527.Metal2 vout1.P6.pSD 0.00230869f
Cred_15132 vin1.$527.Metal2 VSS.$1989.Metal1 4.18072e-06f
Cred_15133 vin1.$527.Metal2 VSS.$2020.Metal1 1.04677e-05f
Cred_15134 vin1.$527.Metal2 VSS.$29.Metal1 0.000253219f
Cred_15135 vin1.$527.Metal2 VSS.$2908.Metal2 0.000713896f
Cred_15136 vin1.$527.Metal2 VSS.$2940.Metal2 2.711e-05f
Cred_15137 vin1.$527.Metal2 VSS.$4227.Metal2 2.80251e-08f
Cred_15138 vin1.$527.Metal2 VSS.$774.Metal1 6.89462e-05f
Cred_15139 vin1.$527.Metal2 VSS.P1.pSD 0.00819969f
Cred_15140 vin1.$527.Metal2 VSS.P31.nSD 4.03198e-07f
Cred_15141 vin1.$528.Metal2 vout1.$1226.Metal3 0.00731763f
Cred_15142 vin1.$528.Metal2 vout1.$1292.Metal3 0.00647235f
Cred_15143 vin1.$528.Metal2 vout1.P4.nSD 1.35309e-06f
Cred_15144 vin1.$528.Metal2 vout1.P6.nSD 0.000127075f
Cred_15145 vin1.$528.Metal2 vout1.P6.pSD 0.000557266f
Cred_15146 vin1.$528.Metal2 VSS.$1989.Metal1 2.64576e-06f
Cred_15147 vin1.$528.Metal2 VSS.$2020.Metal1 6.62445e-06f
Cred_15148 vin1.$528.Metal2 VSS.$29.Metal1 0.000121608f
Cred_15149 vin1.$528.Metal2 VSS.$2908.Metal2 0.016193f
Cred_15150 vin1.$528.Metal2 VSS.$2940.Metal2 0.00415717f
Cred_15151 vin1.$528.Metal2 VSS.$2988.Metal2 0.00113256f
Cred_15152 vin1.$528.Metal2 VSS.$4227.Metal2 1.77356e-08f
Cred_15153 vin1.$528.Metal2 VSS.$4679.Metal3 9.08056e-06f
Cred_15154 vin1.$528.Metal2 VSS.$762.Metal1 2.61458e-06f
Cred_15155 vin1.$528.Metal2 VSS.$774.Metal1 0.0015806f
Cred_15156 vin1.$528.Metal2 VSS.$822.Metal1 1.90177e-05f
Cred_15157 vin1.$528.Metal2 VSS.$870.Metal1 4.71576e-07f
Cred_15158 vin1.$528.Metal2 VSS.P1.pSD 0.00454296f
Cred_15159 vin1.$528.Metal2 VSS.P31.nSD 9.28578e-06f
Cred_15160 vin1.$53.GatPoly vout1.$1226.Metal3 3.63287e-08f
Cred_15161 vin1.$53.GatPoly vout1.$1292.Metal3 8.57734e-09f
Cred_15162 vin1.$53.GatPoly vout1.P4.pSD 1.00179e-09f
Cred_15163 vin1.$53.GatPoly vout1.P6.nSD 1.35128e-10f
Cred_15164 vin1.$53.GatPoly vout1.P6.pSD 1.7403e-09f
Cred_15165 vin1.$532.Metal2 vout1.$1226.Metal3 0.0341047f
Cred_15166 vin1.$532.Metal2 vout1.$1292.Metal3 0.0341047f
Cred_15167 vin1.$532.Metal2 vout1.P6.nSD 0.0110654f
Cred_15168 vin1.$532.Metal2 vout1.P6.pSD 0.0029364f
Cred_15169 vin1.$532.Metal2 VSS.$1989.Metal1 5.08548e-06f
Cred_15170 vin1.$532.Metal2 VSS.$2020.Metal1 1.2733e-05f
Cred_15171 vin1.$532.Metal2 VSS.$29.Metal1 0.000174871f
Cred_15172 vin1.$532.Metal2 VSS.$2908.Metal2 3.72161e-08f
Cred_15173 vin1.$532.Metal2 VSS.$2940.Metal2 0.00113253f
Cred_15174 vin1.$532.Metal2 VSS.$2988.Metal2 0.00113252f
Cred_15175 vin1.$532.Metal2 VSS.$4227.Metal2 3.40901e-08f
Cred_15176 vin1.$532.Metal2 VSS.$4679.Metal3 9.08029e-06f
Cred_15177 vin1.$532.Metal2 VSS.$762.Metal1 7.82459e-07f
Cred_15178 vin1.$532.Metal2 VSS.$774.Metal1 1.72537e-06f
Cred_15179 vin1.$532.Metal2 VSS.$822.Metal1 1.35199e-05f
Cred_15180 vin1.$532.Metal2 VSS.$870.Metal1 3.09872e-07f
Cred_15181 vin1.$532.Metal2 VSS.P1.pSD 0.00753904f
Cred_15182 vin1.$532.Metal2 VSS.P31.nSD 1.44361e-08f
Cred_15183 vin1.$533.Metal2 vout1.$1226.Metal3 0.0331409f
Cred_15184 vin1.$533.Metal2 vout1.$1292.Metal3 0.0331409f
Cred_15185 vin1.$533.Metal2 vout1.P6.nSD 0.000522104f
Cred_15186 vin1.$533.Metal2 vout1.P6.pSD 0.0155504f
Cred_15187 vin1.$535.Metal2 vout1.$1226.Metal3 0.0985516f
Cred_15188 vin1.$535.Metal2 vout1.$1292.Metal3 0.0796002f
Cred_15189 vin1.$535.Metal2 vout1.P4.nSD 2.98653e-07f
Cred_15190 vin1.$535.Metal2 vout1.P6.nSD 0.0025442f
Cred_15191 vin1.$535.Metal2 vout1.P6.pSD 0.00832419f
Cred_15192 vin1.$535.Metal2 VSS.$1989.Metal1 4.72023e-05f
Cred_15193 vin1.$535.Metal2 VSS.$2020.Metal1 0.000118185f
Cred_15194 vin1.$535.Metal2 VSS.$29.Metal1 0.0016942f
Cred_15195 vin1.$535.Metal2 VSS.$2908.Metal2 0.00149036f
Cred_15196 vin1.$535.Metal2 VSS.$2940.Metal2 5.65961e-05f
Cred_15197 vin1.$535.Metal2 VSS.$4227.Metal2 3.16416e-07f
Cred_15198 vin1.$535.Metal2 VSS.$774.Metal1 0.000143935f
Cred_15199 vin1.$535.Metal2 VSS.P1.pSD 0.0709058f
Cred_15200 vin1.$535.Metal2 VSS.P31.nSD 8.41734e-07f
Cred_15201 vin1.$537.Metal2 vout1.$1226.Metal3 0.0274843f
Cred_15202 vin1.$537.Metal2 vout1.$1292.Metal3 0.0274843f
Cred_15203 vin1.$537.Metal2 vout1.P6.nSD 0.00821533f
Cred_15204 vin1.$537.Metal2 vout1.P6.pSD 0.00236638f
Cred_15205 vin1.$537.Metal2 VSS.$1989.Metal1 4.64494e-06f
Cred_15206 vin1.$537.Metal2 VSS.$2020.Metal1 1.163e-05f
Cred_15207 vin1.$537.Metal2 VSS.$29.Metal1 0.000126348f
Cred_15208 vin1.$537.Metal2 VSS.$3036.Metal2 0.00239142f
Cred_15209 vin1.$537.Metal2 VSS.$3060.Metal2 1.41269e-07f
Cred_15210 vin1.$537.Metal2 VSS.$3095.Metal2 4.48317e-07f
Cred_15211 vin1.$537.Metal2 VSS.$4227.Metal2 3.11369e-08f
Cred_15212 vin1.$537.Metal2 VSS.$870.Metal1 7.70326e-07f
Cred_15213 vin1.$537.Metal2 VSS.$922.Metal1 7.44747e-06f
Cred_15214 vin1.$537.Metal2 VSS.P1.pSD 0.00612765f
Cred_15215 vin1.$537.Metal2 VSS.P33.nSD 2.46691e-07f
Cred_15216 vin1.$538.Metal2 vout1.$1226.Metal3 0.0255876f
Cred_15217 vin1.$538.Metal2 vout1.$1292.Metal3 0.0255876f
Cred_15218 vin1.$538.Metal2 vout1.P6.nSD 0.000403108f
Cred_15219 vin1.$538.Metal2 vout1.P6.pSD 0.0119442f
Cred_15220 vin1.$541.Metal2 vout1.$1226.Metal3 0.00916639f
Cred_15221 vin1.$541.Metal2 vout1.$1292.Metal3 0.0189675f
Cred_15222 vin1.$541.Metal2 vout1.P6.nSD 0.000193831f
Cred_15223 vin1.$541.Metal2 vout1.P6.pSD 0.000789222f
Cred_15224 vin1.$541.Metal2 vout1.P8.nSD 4.02867e-05f
Cred_15225 vin1.$541.Metal2 VSS.$1989.Metal1 7.29726e-06f
Cred_15226 vin1.$541.Metal2 VSS.$2020.Metal1 1.82709e-05f
Cred_15227 vin1.$541.Metal2 VSS.$29.Metal1 0.000123002f
Cred_15228 vin1.$541.Metal2 VSS.$3036.Metal2 0.00239151f
Cred_15229 vin1.$541.Metal2 VSS.$3060.Metal2 0.0111327f
Cred_15230 vin1.$541.Metal2 VSS.$3095.Metal2 0.0320645f
Cred_15231 vin1.$541.Metal2 VSS.$4227.Metal2 4.89165e-08f
Cred_15232 vin1.$541.Metal2 VSS.$870.Metal1 4.15136e-06f
Cred_15233 vin1.$541.Metal2 VSS.$922.Metal1 0.0036981f
Cred_15234 vin1.$541.Metal2 VSS.P1.pSD 0.00757602f
Cred_15235 vin1.$541.Metal2 VSS.P33.nSD 0.000128589f
Cred_15236 vin1.$542.Metal2 vout1.$1226.Metal3 0.00627618f
Cred_15237 vin1.$542.Metal2 vout1.$1292.Metal3 0.00943108f
Cred_15238 vin1.$542.Metal2 vout1.P6.nSD 9.88754e-05f
Cred_15239 vin1.$542.Metal2 vout1.P6.pSD 0.000719226f
Cred_15240 vin1.$542.Metal2 vout1.P8.pSD 6.00928e-05f
Cred_15241 vin1.$544.Metal2 vout1.$1226.Metal3 0.0296503f
Cred_15242 vin1.$544.Metal2 vout1.$1292.Metal3 0.0916487f
Cred_15243 vin1.$544.Metal2 vout1.P6.nSD 0.000488088f
Cred_15244 vin1.$544.Metal2 vout1.P6.pSD 0.00258416f
Cred_15245 vin1.$544.Metal2 vout1.P8.nSD 2.09757e-05f
Cred_15246 vin1.$544.Metal2 vout1.P8.pSD 3.1288e-05f
Cred_15247 vin1.$544.Metal2 VSS.$1989.Metal1 5.38011e-05f
Cred_15248 vin1.$544.Metal2 VSS.$2020.Metal1 0.000134707f
Cred_15249 vin1.$544.Metal2 VSS.$29.Metal1 0.00081361f
Cred_15250 vin1.$544.Metal2 VSS.$3060.Metal2 0.00304655f
Cred_15251 vin1.$544.Metal2 VSS.$3095.Metal2 0.0101017f
Cred_15252 vin1.$544.Metal2 VSS.$4227.Metal2 3.60651e-07f
Cred_15253 vin1.$544.Metal2 VSS.$922.Metal1 0.00114188f
Cred_15254 vin1.$544.Metal2 VSS.P1.pSD 0.0533407f
Cred_15255 vin1.$544.Metal2 VSS.P33.nSD 3.96969e-05f
Cred_15256 vin1.$547.Metal2 vout1.$1226.Metal3 0.00721531f
Cred_15257 vin1.$547.Metal2 vout1.$1292.Metal3 0.0281306f
Cred_15258 vin1.$547.Metal2 vout1.P6.nSD 0.00011367f
Cred_15259 vin1.$547.Metal2 vout1.P6.pSD 0.00105708f
Cred_15260 vin1.$547.Metal2 vout1.P8.pSD 0.000435848f
Cred_15261 vin1.$548.Metal2 vout1.$1226.Metal3 0.00310844f
Cred_15262 vin1.$548.Metal2 vout1.$1292.Metal3 0.0294593f
Cred_15263 vin1.$548.Metal2 vout1.P6.nSD 8.18366e-05f
Cred_15264 vin1.$548.Metal2 vout1.P6.pSD 0.000267635f
Cred_15265 vin1.$548.Metal2 vout1.P8.nSD 0.00115887f
Cred_15266 vin1.$548.Metal2 VSS.$1029.Metal1 4.46539e-07f
Cred_15267 vin1.$548.Metal2 VSS.$1989.Metal1 8.57375e-06f
Cred_15268 vin1.$548.Metal2 VSS.$2020.Metal1 2.14669e-05f
Cred_15269 vin1.$548.Metal2 VSS.$29.Metal1 0.000107679f
Cred_15270 vin1.$548.Metal2 VSS.$3060.Metal2 0.00559985f
Cred_15271 vin1.$548.Metal2 VSS.$3095.Metal2 0.020359f
Cred_15272 vin1.$548.Metal2 VSS.$3151.Metal2 0.0034856f
Cred_15273 vin1.$548.Metal2 VSS.$4227.Metal2 5.74733e-08f
Cred_15274 vin1.$548.Metal2 VSS.$4751.Metal3 1.43603e-05f
Cred_15275 vin1.$548.Metal2 VSS.$922.Metal1 0.0021025f
Cred_15276 vin1.$548.Metal2 VSS.$981.Metal1 3.56627e-05f
Cred_15277 vin1.$548.Metal2 VSS.P1.pSD 0.00772963f
Cred_15278 vin1.$548.Metal2 VSS.P33.nSD 7.31077e-05f
Cred_15279 vin1.$551.Metal2 vout1.$1292.Metal3 0.0524597f
Cred_15280 vin1.$551.Metal2 vout1.P8.pSD 0.00841488f
Cred_15281 vin1.$552.Metal2 vout1.$1292.Metal3 0.081548f
Cred_15282 vin1.$552.Metal2 vout1.P8.nSD 0.0121718f
Cred_15283 vin1.$552.Metal2 VSS.$1989.Metal1 1.43541e-05f
Cred_15284 vin1.$552.Metal2 VSS.$2020.Metal1 3.59398e-05f
Cred_15285 vin1.$552.Metal2 VSS.$29.Metal1 0.000108021f
Cred_15286 vin1.$552.Metal2 VSS.$3151.Metal2 0.00169455f
Cred_15287 vin1.$552.Metal2 VSS.$4227.Metal2 9.62213e-08f
Cred_15288 vin1.$552.Metal2 VSS.P1.pSD 0.0100229f
Cred_15289 vin1.$555.Metal2 vout1.$1292.Metal3 0.155728f
Cred_15290 vin1.$555.Metal2 vout1.P8.nSD 0.00114827f
Cred_15291 vin1.$555.Metal2 vout1.P8.pSD 0.00427509f
Cred_15292 vin1.$555.Metal2 VSS.$1989.Metal1 7.60665e-05f
Cred_15293 vin1.$555.Metal2 VSS.$2020.Metal1 0.000190455f
Cred_15294 vin1.$555.Metal2 VSS.$29.Metal1 0.000574185f
Cred_15295 vin1.$555.Metal2 VSS.$4227.Metal2 5.09904e-07f
Cred_15296 vin1.$555.Metal2 VSS.P1.pSD 0.0534209f
Cred_15297 vin1.$557.Metal2 vout1.$1292.Metal3 0.0406837f
Cred_15298 vin1.$557.Metal2 vout1.P8.nSD 0.00506498f
Cred_15299 vin1.$557.Metal2 VSS 5.19621e-06f
Cred_15300 vin1.$557.Metal2 VSS.$1069.Metal1 1.75984e-05f
Cred_15301 vin1.$557.Metal2 VSS.$1989.Metal1 8.14161e-06f
Cred_15302 vin1.$557.Metal2 VSS.$2020.Metal1 2.0385e-05f
Cred_15303 vin1.$557.Metal2 VSS.$29.Metal1 4.80372e-05f
Cred_15304 vin1.$557.Metal2 VSS.$3199.Metal2 0.00311477f
Cred_15305 vin1.$557.Metal2 VSS.$3250.Metal2 0.00118406f
Cred_15306 vin1.$557.Metal2 VSS.$3282.Metal2 1.90149e-07f
Cred_15307 vin1.$557.Metal2 VSS.$4227.Metal2 5.45765e-08f
Cred_15308 vin1.$557.Metal2 VSS.$4799.Metal3 9.49197e-06f
Cred_15309 vin1.$557.Metal2 VSS.P1.pSD 0.0050557f
Cred_15310 vin1.$557.Metal2 VSS.P35.nSD 1.61903e-07f
Cred_15311 vin1.$558.Metal2 vout1.$1292.Metal3 0.0622962f
Cred_15312 vin1.$558.Metal2 vout1.P8.pSD 0.0113817f
Cred_15313 vin1.$561.Metal2 vout1.$1292.Metal3 0.0249549f
Cred_15314 vin1.$561.Metal2 vout1.$1358.Metal3 0.00545257f
Cred_15315 vin1.$561.Metal2 vout1.P10.nSD 0.000153291f
Cred_15316 vin1.$561.Metal2 vout1.P10.pSD 0.000465241f
Cred_15317 vin1.$561.Metal2 vout1.P8.nSD 6.73912e-05f
Cred_15318 vin1.$561.Metal2 VSS 0.00329353f
Cred_15319 vin1.$561.Metal2 VSS.$1069.Metal1 1.94247e-05f
Cred_15320 vin1.$561.Metal2 VSS.$1989.Metal1 1.52039e-05f
Cred_15321 vin1.$561.Metal2 VSS.$2020.Metal1 3.80674e-05f
Cred_15322 vin1.$561.Metal2 VSS.$29.Metal1 6.4582e-05f
Cred_15323 vin1.$561.Metal2 VSS.$3199.Metal2 0.00118388f
Cred_15324 vin1.$561.Metal2 VSS.$3250.Metal2 0.020019f
Cred_15325 vin1.$561.Metal2 VSS.$3282.Metal2 0.0188351f
Cred_15326 vin1.$561.Metal2 VSS.$4227.Metal2 1.01918e-07f
Cred_15327 vin1.$561.Metal2 VSS.$4799.Metal3 9.4921e-06f
Cred_15328 vin1.$561.Metal2 VSS.P1.pSD 0.00799752f
Cred_15329 vin1.$561.Metal2 VSS.P35.nSD 0.000114401f
Cred_15330 vin1.$562.Metal2 vout1.$1292.Metal3 0.0233645f
Cred_15331 vin1.$562.Metal2 vout1.$1358.Metal3 0.0048384f
Cred_15332 vin1.$562.Metal2 vout1.P10.nSD 7.62245e-05f
Cred_15333 vin1.$562.Metal2 vout1.P10.pSD 0.000766399f
Cred_15334 vin1.$562.Metal2 vout1.P8.pSD 0.000340744f
Cred_15335 vin1.$564.Metal2 vout1.$1292.Metal3 0.0925799f
Cred_15336 vin1.$564.Metal2 vout1.$1358.Metal3 0.0298197f
Cred_15337 vin1.$564.Metal2 vout1.P10.nSD 0.000492617f
Cred_15338 vin1.$564.Metal2 vout1.P10.pSD 0.00266417f
Cred_15339 vin1.$564.Metal2 vout1.P8.nSD 2.2835e-05f
Cred_15340 vin1.$564.Metal2 vout1.P8.pSD 0.000115459f
Cred_15341 vin1.$564.Metal2 VSS 0.000454548f
Cred_15342 vin1.$564.Metal2 VSS.$1989.Metal1 0.000106667f
Cred_15343 vin1.$564.Metal2 VSS.$2020.Metal1 0.000267072f
Cred_15344 vin1.$564.Metal2 VSS.$29.Metal1 0.000404415f
Cred_15345 vin1.$564.Metal2 VSS.$3250.Metal2 0.0026226f
Cred_15346 vin1.$564.Metal2 VSS.$3282.Metal2 0.0026226f
Cred_15347 vin1.$564.Metal2 VSS.$4227.Metal2 7.15031e-07f
Cred_15348 vin1.$564.Metal2 VSS.P1.pSD 0.0530759f
Cred_15349 vin1.$564.Metal2 VSS.P35.nSD 1.5781e-05f
Cred_15350 vin1.$566.Metal2 vout1.$1292.Metal3 0.0207382f
Cred_15351 vin1.$566.Metal2 vout1.$1358.Metal3 0.00928194f
Cred_15352 vin1.$566.Metal2 vout1.P10.nSD 0.00021362f
Cred_15353 vin1.$566.Metal2 vout1.P10.pSD 0.000791983f
Cred_15354 vin1.$566.Metal2 vout1.P8.nSD 6.73912e-05f
Cred_15355 vin1.$566.Metal2 VSS 0.0032621f
Cred_15356 vin1.$566.Metal2 VSS.$1165.Metal1 1.15393e-05f
Cred_15357 vin1.$566.Metal2 VSS.$1989.Metal1 1.71105e-05f
Cred_15358 vin1.$566.Metal2 VSS.$2020.Metal1 4.28413e-05f
Cred_15359 vin1.$566.Metal2 VSS.$29.Metal1 5.81986e-05f
Cred_15360 vin1.$566.Metal2 VSS.$3250.Metal2 0.0174261f
Cred_15361 vin1.$566.Metal2 VSS.$3282.Metal2 0.0186099f
Cred_15362 vin1.$566.Metal2 VSS.$3338.Metal2 0.00118381f
Cred_15363 vin1.$566.Metal2 VSS.$4227.Metal2 1.14699e-07f
Cred_15364 vin1.$566.Metal2 VSS.$4835.Metal3 9.49156e-06f
Cred_15365 vin1.$566.Metal2 VSS.P1.pSD 0.00805495f
Cred_15366 vin1.$566.Metal2 VSS.P35.nSD 0.000114191f
Cred_15367 vin1.$567.Metal2 vout1.$1292.Metal3 0.019148f
Cred_15368 vin1.$567.Metal2 vout1.$1358.Metal3 0.00866777f
Cred_15369 vin1.$567.Metal2 vout1.P10.nSD 0.000136553f
Cred_15370 vin1.$567.Metal2 vout1.P10.pSD 0.00109314f
Cred_15371 vin1.$567.Metal2 vout1.P8.pSD 0.000340744f
Cred_15372 vin1.$57.GatPoly vout1.$1226.Metal3 0.0315155f
Cred_15373 vin1.$57.GatPoly vout1.$1292.Metal3 0.0256585f
Cred_15374 vin1.$57.GatPoly vout1.P4.pSD 0.000411545f
Cred_15375 vin1.$57.GatPoly vout1.P6.nSD 0.000404226f
Cred_15376 vin1.$57.GatPoly vout1.P6.pSD 0.0362783f
Cred_15377 vin1.$570.Metal2 vout1.$1292.Metal3 0.0193631f
Cred_15378 vin1.$570.Metal2 vout1.$1358.Metal3 0.0193631f
Cred_15379 vin1.$570.Metal2 vout1.P10.nSD 0.00537002f
Cred_15380 vin1.$570.Metal2 vout1.P10.pSD 0.00165216f
Cred_15381 vin1.$570.Metal2 VSS 2.41257e-07f
Cred_15382 vin1.$570.Metal2 VSS.$1165.Metal1 1.15393e-05f
Cred_15383 vin1.$570.Metal2 VSS.$1989.Metal1 1.2559e-05f
Cred_15384 vin1.$570.Metal2 VSS.$2020.Metal1 3.14451e-05f
Cred_15385 vin1.$570.Metal2 VSS.$29.Metal1 3.06823e-05f
Cred_15386 vin1.$570.Metal2 VSS.$3282.Metal2 0.00118381f
Cred_15387 vin1.$570.Metal2 VSS.$3338.Metal2 0.00311471f
Cred_15388 vin1.$570.Metal2 VSS.$4227.Metal2 8.41879e-08f
Cred_15389 vin1.$570.Metal2 VSS.$4835.Metal3 9.49156e-06f
Cred_15390 vin1.$570.Metal2 VSS.P1.pSD 0.00501956f
Cred_15391 vin1.$571.Metal2 vout1.$1292.Metal3 0.0300458f
Cred_15392 vin1.$571.Metal2 vout1.$1358.Metal3 0.0300458f
Cred_15393 vin1.$571.Metal2 vout1.P10.nSD 0.000473344f
Cred_15394 vin1.$571.Metal2 vout1.P10.pSD 0.0144261f
Cred_15395 vin1.$573.Metal2 vout1.$1292.Metal3 0.0747144f
Cred_15396 vin1.$573.Metal2 vout1.$1358.Metal3 0.0747144f
Cred_15397 vin1.$573.Metal2 vout1.P10.nSD 0.00232532f
Cred_15398 vin1.$573.Metal2 vout1.P10.pSD 0.0107242f
Cred_15399 vin1.$573.Metal2 VSS.$1989.Metal1 0.000151137f
Cred_15400 vin1.$573.Metal2 VSS.$2020.Metal1 0.000378417f
Cred_15401 vin1.$573.Metal2 VSS.$29.Metal1 0.000288988f
Cred_15402 vin1.$573.Metal2 VSS.$4227.Metal2 1.01313e-06f
Cred_15403 vin1.$573.Metal2 VSS.P1.pSD 0.0534425f
Cred_15404 vin1.$575.Metal2 vout1.$1292.Metal3 0.0388124f
Cred_15405 vin1.$575.Metal2 vout1.$1358.Metal3 0.0388124f
Cred_15406 vin1.$575.Metal2 vout1.P10.nSD 0.0127832f
Cred_15407 vin1.$575.Metal2 vout1.P10.pSD 0.00331167f
Cred_15408 vin1.$575.Metal2 VSS.$1989.Metal1 2.84334e-05f
Cred_15409 vin1.$575.Metal2 VSS.$2020.Metal1 7.11915e-05f
Cred_15410 vin1.$575.Metal2 VSS.$29.Metal1 5.45333e-05f
Cred_15411 vin1.$575.Metal2 VSS.$3386.Metal2 0.00169455f
Cred_15412 vin1.$575.Metal2 VSS.$4227.Metal2 1.90601e-07f
Cred_15413 vin1.$575.Metal2 VSS.P1.pSD 0.0100269f
Cred_15414 vin1.$578.Metal2 vout1.$1292.Metal3 0.024319f
Cred_15415 vin1.$578.Metal2 vout1.$1358.Metal3 0.024319f
Cred_15416 vin1.$578.Metal2 vout1.P10.nSD 0.000383123f
Cred_15417 vin1.$578.Metal2 vout1.P10.pSD 0.0105403f
Cred_15418 vin1.$579.Metal2 vout1.$1292.Metal3 0.0125416f
Cred_15419 vin1.$579.Metal2 vout1.$1358.Metal3 0.0190751f
Cred_15420 vin1.$579.Metal2 vout1.P10.nSD 0.00135645f
Cred_15421 vin1.$579.Metal2 vout1.P10.pSD 0.00107011f
Cred_15422 vin1.$579.Metal2 vout1.P12.nSD 3.28661e-05f
Cred_15423 vin1.$579.Metal2 VSS.$1205.Metal1 4.46539e-07f
Cred_15424 vin1.$579.Metal2 VSS.$1245.Metal1 3.56627e-05f
Cred_15425 vin1.$579.Metal2 VSS.$1265.Metal1 0.0021025f
Cred_15426 vin1.$579.Metal2 VSS.$1989.Metal1 2.83434e-05f
Cred_15427 vin1.$579.Metal2 VSS.$2020.Metal1 7.09661e-05f
Cred_15428 vin1.$579.Metal2 VSS.$29.Metal1 3.25733e-05f
Cred_15429 vin1.$579.Metal2 VSS.$3386.Metal2 0.0034856f
Cred_15430 vin1.$579.Metal2 VSS.$3445.Metal2 0.020359f
Cred_15431 vin1.$579.Metal2 VSS.$3477.Metal2 0.00559985f
Cred_15432 vin1.$579.Metal2 VSS.$4227.Metal2 1.89997e-07f
Cred_15433 vin1.$579.Metal2 VSS.$4883.Metal3 1.43603e-05f
Cred_15434 vin1.$579.Metal2 VSS.P1.pSD 0.00773534f
Cred_15435 vin1.$579.Metal2 VSS.P37.nSD 7.31077e-05f
Cred_15436 vin1.$58.GatPoly vout1.$1226.Metal3 0.0029015f
Cred_15437 vin1.$58.GatPoly vout1.$1292.Metal3 0.00203672f
Cred_15438 vin1.$58.GatPoly vout1.P4.nSD 8.10886e-06f
Cred_15439 vin1.$58.GatPoly vout1.P6.nSD 0.00214376f
Cred_15440 vin1.$58.GatPoly vout1.P6.pSD 0.000175361f
Cred_15441 vin1.$58.GatPoly VSS.$1989.Metal1 1.91713e-06f
Cred_15442 vin1.$58.GatPoly VSS.$2020.Metal1 4.8001e-06f
Cred_15443 vin1.$58.GatPoly VSS.$29.Metal1 8.60755e-05f
Cred_15444 vin1.$58.GatPoly VSS.$2908.Metal2 0.000904124f
Cred_15445 vin1.$58.GatPoly VSS.$2940.Metal2 3.45181e-05f
Cred_15446 vin1.$58.GatPoly VSS.$2988.Metal2 4.84579e-08f
Cred_15447 vin1.$58.GatPoly VSS.$4227.Metal2 1.28513e-08f
Cred_15448 vin1.$58.GatPoly VSS.$4679.Metal3 3.73213e-10f
Cred_15449 vin1.$58.GatPoly VSS.$762.Metal1 0.000751257f
Cred_15450 vin1.$58.GatPoly VSS.$774.Metal1 0.00513046f
Cred_15451 vin1.$58.GatPoly VSS.$822.Metal1 2.16492e-05f
Cred_15452 vin1.$58.GatPoly VSS.$870.Metal1 2.28603e-07f
Cred_15453 vin1.$58.GatPoly VSS.P1.pSD 0.00325944f
Cred_15454 vin1.$58.GatPoly VSS.P31.nSD 4.46155e-05f
Cred_15455 vin1.$582.Metal2 vout1.$1292.Metal3 0.00993907f
Cred_15456 vin1.$582.Metal2 vout1.$1358.Metal3 0.0250721f
Cred_15457 vin1.$582.Metal2 vout1.P10.nSD 0.000156581f
Cred_15458 vin1.$582.Metal2 vout1.P10.pSD 0.00131644f
Cred_15459 vin1.$582.Metal2 vout1.P12.pSD 0.000468386f
Cred_15460 vin1.$584.Metal2 vout1.$1292.Metal3 0.0295083f
Cred_15461 vin1.$584.Metal2 vout1.$1358.Metal3 0.0918296f
Cred_15462 vin1.$584.Metal2 vout1.P10.nSD 0.000485851f
Cred_15463 vin1.$584.Metal2 vout1.P10.pSD 0.00254831f
Cred_15464 vin1.$584.Metal2 vout1.P12.nSD 2.09757e-05f
Cred_15465 vin1.$584.Metal2 vout1.P12.pSD 3.05134e-05f
Cred_15466 vin1.$584.Metal2 VSS.$1265.Metal1 0.00114188f
Cred_15467 vin1.$584.Metal2 VSS.$1989.Metal1 0.000213793f
Cred_15468 vin1.$584.Metal2 VSS.$2020.Metal1 0.000535294f
Cred_15469 vin1.$584.Metal2 VSS.$29.Metal1 0.000204752f
Cred_15470 vin1.$584.Metal2 VSS.$3445.Metal2 0.0101017f
Cred_15471 vin1.$584.Metal2 VSS.$3477.Metal2 0.00304655f
Cred_15472 vin1.$584.Metal2 VSS.$4227.Metal2 1.43314e-06f
Cred_15473 vin1.$584.Metal2 VSS.P1.pSD 0.0533878f
Cred_15474 vin1.$584.Metal2 VSS.P37.nSD 3.96969e-05f
Cred_15475 vin1.$586.Metal2 vout1.$1292.Metal3 0.00466478f
Cred_15476 vin1.$586.Metal2 vout1.$1358.Metal3 0.0239312f
Cred_15477 vin1.$586.Metal2 vout1.P10.nSD 0.000113776f
Cred_15478 vin1.$586.Metal2 vout1.P10.pSD 0.000398023f
Cred_15479 vin1.$586.Metal2 vout1.P12.nSD 4.94234e-05f
Cred_15480 vin1.$586.Metal2 VSS.$1265.Metal1 0.0036981f
Cred_15481 vin1.$586.Metal2 VSS.$1364.Metal1 4.15136e-06f
Cred_15482 vin1.$586.Metal2 VSS.$1989.Metal1 3.23766e-05f
Cred_15483 vin1.$586.Metal2 VSS.$2020.Metal1 8.10644e-05f
Cred_15484 vin1.$586.Metal2 VSS.$29.Metal1 2.7724e-05f
Cred_15485 vin1.$586.Metal2 VSS.$3445.Metal2 0.0320645f
Cred_15486 vin1.$586.Metal2 VSS.$3477.Metal2 0.0111327f
Cred_15487 vin1.$586.Metal2 VSS.$3501.Metal2 0.00239151f
Cred_15488 vin1.$586.Metal2 VSS.$4227.Metal2 2.17033e-07f
Cred_15489 vin1.$586.Metal2 VSS.P1.pSD 0.00758325f
Cred_15490 vin1.$586.Metal2 VSS.P37.nSD 0.000128589f
Cred_15491 vin1.$587.Metal2 vout1.$1292.Metal3 0.00150227f
Cred_15492 vin1.$587.Metal2 vout1.$1358.Metal3 0.0150382f
Cred_15493 vin1.$587.Metal2 vout1.P10.nSD 2.36668e-05f
Cred_15494 vin1.$587.Metal2 vout1.P10.pSD 0.000186786f
Cred_15495 vin1.$587.Metal2 vout1.P12.pSD 0.00018411f
Cred_15496 vin1.$590.Metal2 vout1.$1358.Metal3 0.0577679f
Cred_15497 vin1.$590.Metal2 vout1.P12.nSD 0.00778234f
Cred_15498 vin1.$590.Metal2 VSS.$1265.Metal1 7.44747e-06f
Cred_15499 vin1.$590.Metal2 VSS.$1364.Metal1 7.70326e-07f
Cred_15500 vin1.$590.Metal2 VSS.$1989.Metal1 3.32575e-05f
Cred_15501 vin1.$590.Metal2 VSS.$2020.Metal1 8.327e-05f
Cred_15502 vin1.$590.Metal2 VSS.$29.Metal1 1.76476e-05f
Cred_15503 vin1.$590.Metal2 VSS.$3445.Metal2 4.48317e-07f
Cred_15504 vin1.$590.Metal2 VSS.$3477.Metal2 1.41269e-07f
Cred_15505 vin1.$590.Metal2 VSS.$3501.Metal2 0.00239142f
Cred_15506 vin1.$590.Metal2 VSS.$4227.Metal2 2.22938e-07f
Cred_15507 vin1.$590.Metal2 VSS.P1.pSD 0.00613591f
Cred_15508 vin1.$590.Metal2 VSS.P37.nSD 2.46691e-07f
Cred_15509 vin1.$591.Metal2 vout1.$1358.Metal3 0.0519778f
Cred_15510 vin1.$591.Metal2 vout1.P12.pSD 0.00988711f
Cred_15511 vin1.$593.Metal2 vout1.$1358.Metal3 0.176873f
Cred_15512 vin1.$593.Metal2 vout1.$1424.Metal3 0.00901986f
Cred_15513 vin1.$593.Metal2 vout1.P12.nSD 0.00129017f
Cred_15514 vin1.$593.Metal2 vout1.P12.pSD 0.00144016f
Cred_15515 vin1.$593.Metal2 vout1.P14.nSD 0.000142398f
Cred_15516 vin1.$593.Metal2 vout1.P14.pSD 0.00076962f
Cred_15517 vin1.$593.Metal2 VSS.$1466.Metal1 0.000143935f
Cred_15518 vin1.$593.Metal2 VSS.$1989.Metal1 0.000445942f
Cred_15519 vin1.$593.Metal2 VSS.$2020.Metal1 0.00111655f
Cred_15520 vin1.$593.Metal2 VSS.$29.Metal1 0.000179342f
Cred_15521 vin1.$593.Metal2 VSS.$3597.Metal2 5.65961e-05f
Cred_15522 vin1.$593.Metal2 VSS.$3632.Metal2 0.00149036f
Cred_15523 vin1.$593.Metal2 VSS.$4227.Metal2 2.98933e-06f
Cred_15524 vin1.$593.Metal2 VSS.P1.pSD 0.0710209f
Cred_15525 vin1.$593.Metal2 VSS.P39.nSD 8.41734e-07f
Cred_15526 vin1.$595.Metal2 vout1.$1358.Metal3 0.071683f
Cred_15527 vin1.$595.Metal2 vout1.P12.nSD 0.0105281f
Cred_15528 vin1.$595.Metal2 VSS.$1364.Metal1 3.09872e-07f
Cred_15529 vin1.$595.Metal2 VSS.$1412.Metal1 1.35199e-05f
Cred_15530 vin1.$595.Metal2 VSS.$1463.Metal1 7.82459e-07f
Cred_15531 vin1.$595.Metal2 VSS.$1466.Metal1 1.72537e-06f
Cred_15532 vin1.$595.Metal2 VSS.$1989.Metal1 4.60297e-05f
Cred_15533 vin1.$595.Metal2 VSS.$2020.Metal1 0.000115249f
Cred_15534 vin1.$595.Metal2 VSS.$29.Metal1 1.93217e-05f
Cred_15535 vin1.$595.Metal2 VSS.$3549.Metal2 0.00113252f
Cred_15536 vin1.$595.Metal2 VSS.$3597.Metal2 0.00113253f
Cred_15537 vin1.$595.Metal2 VSS.$3632.Metal2 3.72161e-08f
Cred_15538 vin1.$595.Metal2 VSS.$4227.Metal2 3.08555e-07f
Cred_15539 vin1.$595.Metal2 VSS.$4955.Metal3 9.08029e-06f
Cred_15540 vin1.$595.Metal2 VSS.P1.pSD 0.00755086f
Cred_15541 vin1.$595.Metal2 VSS.P39.nSD 1.44361e-08f
Cred_15542 vin1.$596.Metal2 vout1.$1358.Metal3 0.0705949f
Cred_15543 vin1.$596.Metal2 vout1.P12.pSD 0.0131059f
Cred_15544 vin1.$599.Metal2 vout1.$1358.Metal3 0.0140062f
Cred_15545 vin1.$599.Metal2 vout1.$1424.Metal3 0.000402309f
Cred_15546 vin1.$599.Metal2 vout1.P12.nSD 2.51091e-05f
Cred_15547 vin1.$599.Metal2 vout1.P14.nSD 7.69108e-06f
Cred_15548 vin1.$599.Metal2 vout1.P14.pSD 3.4327e-05f
Cred_15549 vin1.$599.Metal2 VSS.$1364.Metal1 4.71576e-07f
Cred_15550 vin1.$599.Metal2 VSS.$1412.Metal1 1.90177e-05f
Cred_15551 vin1.$599.Metal2 VSS.$1463.Metal1 2.61458e-06f
Cred_15552 vin1.$599.Metal2 VSS.$1466.Metal1 0.0015806f
Cred_15553 vin1.$599.Metal2 VSS.$1989.Metal1 3.19718e-05f
Cred_15554 vin1.$599.Metal2 VSS.$2020.Metal1 8.0051e-05f
Cred_15555 vin1.$599.Metal2 VSS.$29.Metal1 1.0061e-05f
Cred_15556 vin1.$599.Metal2 VSS.$3549.Metal2 0.00113256f
Cred_15557 vin1.$599.Metal2 VSS.$3597.Metal2 0.00415717f
Cred_15558 vin1.$599.Metal2 VSS.$3632.Metal2 0.016193f
Cred_15559 vin1.$599.Metal2 VSS.$4227.Metal2 2.1432e-07f
Cred_15560 vin1.$599.Metal2 VSS.$4955.Metal3 9.08056e-06f
Cred_15561 vin1.$599.Metal2 VSS.P1.pSD 0.00455155f
Cred_15562 vin1.$599.Metal2 VSS.P39.nSD 9.28578e-06f
Cred_15563 vin1.$6.GatPoly vout1.$1226.Metal3 0.00765342f
Cred_15564 vin1.$6.GatPoly vout1.P0.nSD 0.00586314f
Cred_15565 vin1.$6.GatPoly vout1.P0.pSD 0.0011919f
Cred_15566 vin1.$6.GatPoly vout1.P2.nSD 0.000123201f
Cred_15567 vin1.$6.GatPoly vout1.P2.pSD 0.000658956f
Cred_15568 vin1.$6.GatPoly VSS.$157.Metal1 0.000222493f
Cred_15569 vin1.$6.GatPoly VSS.$1989.Metal1 4.59618e-07f
Cred_15570 vin1.$6.GatPoly VSS.$2020.Metal1 1.15079e-06f
Cred_15571 vin1.$6.GatPoly VSS.$2226.Metal2 7.8168e-05f
Cred_15572 vin1.$6.GatPoly VSS.$2342.Metal2 6.51564e-07f
Cred_15573 vin1.$6.GatPoly VSS.$2403.Metal2 5.05183e-06f
Cred_15574 vin1.$6.GatPoly VSS.$2427.Metal2 4.94172e-06f
Cred_15575 vin1.$6.GatPoly VSS.$2526.Metal2 2.03093e-05f
Cred_15576 vin1.$6.GatPoly VSS.$2558.Metal2 2.72725e-05f
Cred_15577 vin1.$6.GatPoly VSS.$257.Metal1 2.29556e-05f
Cred_15578 vin1.$6.GatPoly VSS.$29.Metal1 0.000950616f
Cred_15579 vin1.$6.GatPoly VSS.$317.Metal1 2.22222e-05f
Cred_15580 vin1.$6.GatPoly VSS.$385.Metal1 0.00053061f
Cred_15581 vin1.$6.GatPoly VSS.$4227.Metal2 3.08101e-09f
Cred_15582 vin1.$6.GatPoly VSS.$4355.Metal3 1.72476e-05f
Cred_15583 vin1.$6.GatPoly VSS.$4415.Metal3 5.77146e-09f
Cred_15584 vin1.$6.GatPoly VSS.P1.pSD 0.00451422f
Cred_15585 vin1.$6.GatPoly VSS.P2.GatPoly 0.000379998f
Cred_15586 vin1.$6.GatPoly VSS.P24.nSD 1.48119e-06f
Cred_15587 vin1.$6.GatPoly VSS.P25.nSD 1.48119e-06f
Cred_15588 vin1.$6.GatPoly VSS.P27.nSD 1.99003e-05f
Cred_15589 vin1.$603.Metal2 vout1.$1358.Metal3 0.0531514f
Cred_15590 vin1.$603.Metal2 vout1.$1424.Metal3 0.0153467f
Cred_15591 vin1.$603.Metal2 vout1.P12.nSD 1.43057e-07f
Cred_15592 vin1.$603.Metal2 vout1.P12.pSD 0.000804195f
Cred_15593 vin1.$603.Metal2 vout1.P14.nSD 0.000241915f
Cred_15594 vin1.$603.Metal2 vout1.P14.pSD 0.00185992f
Cred_15595 vin1.$603.Metal2 VSS.$1466.Metal1 6.89462e-05f
Cred_15596 vin1.$603.Metal2 VSS.$1989.Metal1 6.66486e-05f
Cred_15597 vin1.$603.Metal2 VSS.$2020.Metal1 0.000166875f
Cred_15598 vin1.$603.Metal2 VSS.$29.Metal1 1.5886e-05f
Cred_15599 vin1.$603.Metal2 VSS.$3597.Metal2 2.711e-05f
Cred_15600 vin1.$603.Metal2 VSS.$3632.Metal2 0.000713896f
Cred_15601 vin1.$603.Metal2 VSS.$4227.Metal2 4.46772e-07f
Cred_15602 vin1.$603.Metal2 VSS.P1.pSD 0.00821773f
Cred_15603 vin1.$603.Metal2 VSS.P39.nSD 4.03198e-07f
Cred_15604 vin1.$604.Metal2 vout1.$1358.Metal3 0.0461637f
Cred_15605 vin1.$604.Metal2 vout1.$1424.Metal3 0.0178808f
Cred_15606 vin1.$604.Metal2 vout1.P12.nSD 9.26598e-05f
Cred_15607 vin1.$604.Metal2 vout1.P14.nSD 0.000472451f
Cred_15608 vin1.$604.Metal2 vout1.P14.pSD 0.00152568f
Cred_15609 vin1.$604.Metal2 VSS.$1466.Metal1 0.00513633f
Cred_15610 vin1.$604.Metal2 VSS.$1503.Metal1 8.08006e-06f
Cred_15611 vin1.$604.Metal2 VSS.$1571.Metal1 3.63346e-07f
Cred_15612 vin1.$604.Metal2 VSS.$1989.Metal1 0.000178593f
Cred_15613 vin1.$604.Metal2 VSS.$2020.Metal1 0.00044716f
Cred_15614 vin1.$604.Metal2 VSS.$29.Metal1 4.02046e-05f
Cred_15615 vin1.$604.Metal2 VSS.$3597.Metal2 0.0019177f
Cred_15616 vin1.$604.Metal2 VSS.$3632.Metal2 0.0514072f
Cred_15617 vin1.$604.Metal2 VSS.$3688.Metal2 0.00236814f
Cred_15618 vin1.$604.Metal2 VSS.$3712.Metal2 3.03569e-09f
Cred_15619 vin1.$604.Metal2 VSS.$4227.Metal2 1.19718e-06f
Cred_15620 vin1.$604.Metal2 VSS.$4991.Metal3 7.27792e-06f
Cred_15621 vin1.$604.Metal2 VSS.P1.pSD 0.0213321f
Cred_15622 vin1.$604.Metal2 VSS.P39.nSD 3.10561e-05f
Cred_15623 vin1.$609.Metal2 vout1.$1358.Metal3 0.00918213f
Cred_15624 vin1.$609.Metal2 vout1.$1424.Metal3 0.00907964f
Cred_15625 vin1.$609.Metal2 vout1.P12.pSD 6.65553e-06f
Cred_15626 vin1.$609.Metal2 vout1.P14.nSD 0.000143041f
Cred_15627 vin1.$609.Metal2 vout1.P14.pSD 0.00173063f
Cred_15628 vin1.$610.Metal2 vout1.$1358.Metal3 0.036807f
Cred_15629 vin1.$610.Metal2 vout1.$1424.Metal3 0.036807f
Cred_15630 vin1.$610.Metal2 vout1.P14.nSD 0.0118473f
Cred_15631 vin1.$610.Metal2 vout1.P14.pSD 0.00314056f
Cred_15632 vin1.$610.Metal2 VSS.$1466.Metal1 0.000409021f
Cred_15633 vin1.$610.Metal2 VSS.$1503.Metal1 5.22427e-06f
Cred_15634 vin1.$610.Metal2 VSS.$1571.Metal1 7.33628e-07f
Cred_15635 vin1.$610.Metal2 VSS.$1989.Metal1 0.000108604f
Cred_15636 vin1.$610.Metal2 VSS.$2020.Metal1 0.000271923f
Cred_15637 vin1.$610.Metal2 VSS.$29.Metal1 1.40668e-05f
Cred_15638 vin1.$610.Metal2 VSS.$3597.Metal2 0.000160829f
Cred_15639 vin1.$610.Metal2 VSS.$3632.Metal2 0.00468475f
Cred_15640 vin1.$610.Metal2 VSS.$3688.Metal2 0.00339829f
Cred_15641 vin1.$610.Metal2 VSS.$3712.Metal2 6.12933e-09f
Cred_15642 vin1.$610.Metal2 VSS.$4227.Metal2 7.28019e-07f
Cred_15643 vin1.$610.Metal2 VSS.$4991.Metal3 3.60466e-06f
Cred_15644 vin1.$610.Metal2 VSS.P1.pSD 0.00973895f
Cred_15645 vin1.$610.Metal2 VSS.P39.nSD 2.39196e-06f
Cred_15646 vin1.$611.Metal2 vout1.$1358.Metal3 0.0291332f
Cred_15647 vin1.$611.Metal2 vout1.$1424.Metal3 0.0291332f
Cred_15648 vin1.$611.Metal2 vout1.P14.nSD 0.000458966f
Cred_15649 vin1.$611.Metal2 vout1.P14.pSD 0.0159242f
Cred_15650 vin1.$613.Metal2 vout1.$1358.Metal3 0.0982929f
Cred_15651 vin1.$613.Metal2 vout1.$1424.Metal3 0.0792964f
Cred_15652 vin1.$613.Metal2 vout1.P12.nSD 2.98653e-07f
Cred_15653 vin1.$613.Metal2 vout1.P14.nSD 0.00247466f
Cred_15654 vin1.$613.Metal2 vout1.P14.pSD 0.00812867f
Cred_15655 vin1.$613.Metal2 VSS.$1466.Metal1 0.000143935f
Cred_15656 vin1.$613.Metal2 VSS.$1989.Metal1 0.00076223f
Cred_15657 vin1.$613.Metal2 VSS.$2020.Metal1 0.00190847f
Cred_15658 vin1.$613.Metal2 VSS.$29.Metal1 0.000106849f
Cred_15659 vin1.$613.Metal2 VSS.$3597.Metal2 5.65961e-05f
Cred_15660 vin1.$613.Metal2 VSS.$3632.Metal2 0.00149036f
Cred_15661 vin1.$613.Metal2 VSS.$4227.Metal2 5.10954e-06f
Cred_15662 vin1.$613.Metal2 VSS.P1.pSD 0.0706868f
Cred_15663 vin1.$613.Metal2 VSS.P39.nSD 8.41734e-07f
Cred_15664 vin1.$615.Metal2 vout1.$1358.Metal3 0.0276522f
Cred_15665 vin1.$615.Metal2 vout1.$1424.Metal3 0.0276522f
Cred_15666 vin1.$615.Metal2 vout1.P14.nSD 0.00752249f
Cred_15667 vin1.$615.Metal2 vout1.P14.pSD 0.00235943f
Cred_15668 vin1.$615.Metal2 VSS.$1571.Metal1 4.44744e-06f
Cred_15669 vin1.$615.Metal2 VSS.$1989.Metal1 6.58285e-05f
Cred_15670 vin1.$615.Metal2 VSS.$2020.Metal1 0.000164821f
Cred_15671 vin1.$615.Metal2 VSS.$29.Metal1 6.45297e-06f
Cred_15672 vin1.$615.Metal2 VSS.$3712.Metal2 0.000554698f
Cred_15673 vin1.$615.Metal2 VSS.$3760.Metal2 0.00305041f
Cred_15674 vin1.$615.Metal2 VSS.$4227.Metal2 4.41275e-07f
Cred_15675 vin1.$615.Metal2 VSS.$5027.Metal3 4.44744e-06f
Cred_15676 vin1.$615.Metal2 VSS.P1.pSD 0.00511499f
Cred_15677 vin1.$616.Metal2 vout1.$1358.Metal3 0.0231172f
Cred_15678 vin1.$616.Metal2 vout1.$1424.Metal3 0.0231172f
Cred_15679 vin1.$616.Metal2 vout1.P14.nSD 0.00036419f
Cred_15680 vin1.$616.Metal2 vout1.P14.pSD 0.010938f
Cred_15681 vin1.$619.Metal2 vout1.$1358.Metal3 0.00640448f
Cred_15682 vin1.$619.Metal2 vout1.$1424.Metal3 0.010863f
Cred_15683 vin1.$619.Metal2 vout1.P14.nSD 0.000118081f
Cred_15684 vin1.$619.Metal2 vout1.P14.pSD 0.000546463f
Cred_15685 vin1.$619.Metal2 vout1.P16.nSD 1.71843e-05f
Cred_15686 vin1.$619.Metal2 VSS.$1623.Metal1 0.00250348f
Cred_15687 vin1.$619.Metal2 VSS.$1989.Metal1 9.60107e-05f
Cred_15688 vin1.$619.Metal2 VSS.$2020.Metal1 0.000240391f
Cred_15689 vin1.$619.Metal2 VSS.$29.Metal1 6.51571e-06f
Cred_15690 vin1.$619.Metal2 VSS.$3760.Metal2 0.00249571f
Cred_15691 vin1.$619.Metal2 VSS.$3784.Metal2 0.00942665f
Cred_15692 vin1.$619.Metal2 VSS.$3819.Metal2 0.0187469f
Cred_15693 vin1.$619.Metal2 VSS.$4227.Metal2 6.43598e-07f
Cred_15694 vin1.$619.Metal2 VSS.P1.pSD 0.00615517f
Cred_15695 vin1.$619.Metal2 VSS.P41.nSD 8.75729e-05f
Cred_15696 vin1.$620.Metal2 vout1.$1358.Metal3 0.00660463f
Cred_15697 vin1.$620.Metal2 vout1.$1424.Metal3 0.0109848f
Cred_15698 vin1.$620.Metal2 vout1.P14.nSD 0.00010405f
Cred_15699 vin1.$620.Metal2 vout1.P14.pSD 0.000659154f
Cred_15700 vin1.$620.Metal2 vout1.P16.pSD 9.56129e-05f
Cred_15701 vin1.$622.Metal2 vout1.$1358.Metal3 0.028528f
Cred_15702 vin1.$622.Metal2 vout1.$1424.Metal3 0.0879111f
Cred_15703 vin1.$622.Metal2 vout1.P14.nSD 0.000457527f
Cred_15704 vin1.$622.Metal2 vout1.P14.pSD 0.0024792f
Cred_15705 vin1.$622.Metal2 vout1.P16.nSD 8.09507e-06f
Cred_15706 vin1.$622.Metal2 vout1.P16.pSD 4.50408e-05f
Cred_15707 vin1.$622.Metal2 VSS.$1623.Metal1 0.000410524f
Cred_15708 vin1.$622.Metal2 VSS.$1989.Metal1 0.00083255f
Cred_15709 vin1.$622.Metal2 VSS.$2020.Metal1 0.00208454f
Cred_15710 vin1.$622.Metal2 VSS.$29.Metal1 4.93978e-05f
Cred_15711 vin1.$622.Metal2 VSS.$3784.Metal2 0.00145036f
Cred_15712 vin1.$622.Metal2 VSS.$3819.Metal2 0.00330681f
Cred_15713 vin1.$622.Metal2 VSS.$4227.Metal2 5.58092e-06f
Cred_15714 vin1.$622.Metal2 VSS.P1.pSD 0.0498584f
Cred_15715 vin1.$622.Metal2 VSS.P41.nSD 1.42532e-05f
Cred_15716 vin1.$624.Metal2 vout1.$1358.Metal3 0.00650663f
Cred_15717 vin1.$624.Metal2 vout1.$1424.Metal3 0.036376f
Cred_15718 vin1.$624.Metal2 vout1.P14.nSD 0.00017198f
Cred_15719 vin1.$624.Metal2 vout1.P14.pSD 0.000555179f
Cred_15720 vin1.$624.Metal2 vout1.P16.nSD 0.00104885f
Cred_15721 vin1.$624.Metal2 VSS.$1623.Metal1 0.00393458f
Cred_15722 vin1.$624.Metal2 VSS.$1690.Metal1 1.23569e-05f
Cred_15723 vin1.$624.Metal2 VSS.$1989.Metal1 0.000164246f
Cred_15724 vin1.$624.Metal2 VSS.$2020.Metal1 0.00041124f
Cred_15725 vin1.$624.Metal2 VSS.$29.Metal1 8.43231e-06f
Cred_15726 vin1.$624.Metal2 VSS.$3784.Metal2 0.0137476f
Cred_15727 vin1.$624.Metal2 VSS.$3819.Metal2 0.0328856f
Cred_15728 vin1.$624.Metal2 VSS.$3875.Metal2 0.00256115f
Cred_15729 vin1.$624.Metal2 VSS.$4227.Metal2 1.10101e-06f
Cred_15730 vin1.$624.Metal2 VSS.$5075.Metal3 1.23569e-05f
Cred_15731 vin1.$624.Metal2 VSS.P1.pSD 0.00908388f
Cred_15732 vin1.$624.Metal2 VSS.P41.nSD 0.000136794f
Cred_15733 vin1.$625.Metal2 vout1.$1358.Metal3 0.00634131f
Cred_15734 vin1.$625.Metal2 vout1.$1424.Metal3 0.0261527f
Cred_15735 vin1.$625.Metal2 vout1.P14.nSD 9.99013e-05f
Cred_15736 vin1.$625.Metal2 vout1.P14.pSD 0.000957923f
Cred_15737 vin1.$625.Metal2 vout1.P16.pSD 0.000416851f
Cred_15738 vin1.$629.Metal2 vout1.$1424.Metal3 0.0538987f
Cred_15739 vin1.$629.Metal2 vout1.P16.pSD 0.00930781f
Cred_15740 vin1.$630.Metal2 vout1.$1424.Metal3 0.0918079f
Cred_15741 vin1.$630.Metal2 vout1.P16.nSD 0.0129837f
Cred_15742 vin1.$630.Metal2 VSS.$1623.Metal1 5.49654e-05f
Cred_15743 vin1.$630.Metal2 VSS.$1690.Metal1 6.12031e-06f
Cred_15744 vin1.$630.Metal2 VSS.$1989.Metal1 0.000273718f
Cred_15745 vin1.$630.Metal2 VSS.$2020.Metal1 0.000685335f
Cred_15746 vin1.$630.Metal2 VSS.$29.Metal1 8.45128e-06f
Cred_15747 vin1.$630.Metal2 VSS.$3784.Metal2 0.00019419f
Cred_15748 vin1.$630.Metal2 VSS.$3819.Metal2 0.00120609f
Cred_15749 vin1.$630.Metal2 VSS.$3875.Metal2 0.00282265f
Cred_15750 vin1.$630.Metal2 VSS.$4227.Metal2 1.83484e-06f
Cred_15751 vin1.$630.Metal2 VSS.$5075.Metal3 6.12031e-06f
Cred_15752 vin1.$630.Metal2 VSS.P1.pSD 0.011518f
Cred_15753 vin1.$630.Metal2 VSS.P41.nSD 1.90837e-06f
Cred_15754 vin1.$633.Metal2 vout1.$1424.Metal3 0.156738f
Cred_15755 vin1.$633.Metal2 vout1.P16.nSD 0.00114517f
Cred_15756 vin1.$633.Metal2 vout1.P16.pSD 0.0046241f
Cred_15757 vin1.$633.Metal2 VSS.$1989.Metal1 0.00118048f
Cred_15758 vin1.$633.Metal2 VSS.$2020.Metal1 0.00295568f
Cred_15759 vin1.$633.Metal2 VSS.$29.Metal1 3.49876e-05f
Cred_15760 vin1.$633.Metal2 VSS.$4227.Metal2 7.91323e-06f
Cred_15761 vin1.$633.Metal2 VSS.P1.pSD 0.0488368f
Cred_15762 vin1.$635.Metal2 vout1.$1424.Metal3 0.0361747f
Cred_15763 vin1.$635.Metal2 vout1.P16.nSD 0.00424937f
Cred_15764 vin1.$635.Metal2 VSS.$1730.Metal1 5.98294e-07f
Cred_15765 vin1.$635.Metal2 VSS.$1778.Metal1 1.24159e-05f
Cred_15766 vin1.$635.Metal2 VSS.$1798.Metal1 1.75061e-05f
Cred_15767 vin1.$635.Metal2 VSS.$1989.Metal1 0.0001195f
Cred_15768 vin1.$635.Metal2 VSS.$2020.Metal1 0.000299203f
Cred_15769 vin1.$635.Metal2 VSS.$29.Metal1 2.70698e-06f
Cred_15770 vin1.$635.Metal2 VSS.$3923.Metal2 0.00353881f
Cred_15771 vin1.$635.Metal2 VSS.$3982.Metal2 0.00119052f
Cred_15772 vin1.$635.Metal2 VSS.$4014.Metal2 6.70053e-07f
Cred_15773 vin1.$635.Metal2 VSS.$4227.Metal2 8.01054e-07f
Cred_15774 vin1.$635.Metal2 VSS.$5123.Metal3 9.53807e-06f
Cred_15775 vin1.$635.Metal2 VSS.P1.pSD 0.00428521f
Cred_15776 vin1.$635.Metal2 VSS.P43.nSD 6.69298e-07f
Cred_15777 vin1.$636.Metal2 vout1.$1424.Metal3 0.0588585f
Cred_15778 vin1.$636.Metal2 vout1.P16.pSD 0.010786f
Cred_15779 vin1.$639.Metal2 vout1 0.00147839f
Cred_15780 vin1.$639.Metal2 vout1.$1424.Metal3 0.0276307f
Cred_15781 vin1.$639.Metal2 vout1.P16.nSD 7.2224e-05f
Cred_15782 vin1.$639.Metal2 vout1.P18.nSD 0.00016196f
Cred_15783 vin1.$639.Metal2 vout1.P18.pSD 0.000636201f
Cred_15784 vin1.$639.Metal2 VSS.$1730.Metal1 2.20468e-07f
Cred_15785 vin1.$639.Metal2 VSS.$1778.Metal1 1.33539e-05f
Cred_15786 vin1.$639.Metal2 VSS.$1798.Metal1 0.00370329f
Cred_15787 vin1.$639.Metal2 VSS.$1989.Metal1 0.00026127f
Cred_15788 vin1.$639.Metal2 VSS.$2020.Metal1 0.000654168f
Cred_15789 vin1.$639.Metal2 VSS.$29.Metal1 4.15964e-06f
Cred_15790 vin1.$639.Metal2 VSS.$3923.Metal2 0.00118965f
Cred_15791 vin1.$639.Metal2 VSS.$3982.Metal2 0.0246652f
Cred_15792 vin1.$639.Metal2 VSS.$4014.Metal2 0.0174818f
Cred_15793 vin1.$639.Metal2 VSS.$4227.Metal2 1.7514e-06f
Cred_15794 vin1.$639.Metal2 VSS.$5123.Metal3 9.53831e-06f
Cred_15795 vin1.$639.Metal2 VSS.P1.pSD 0.00767477f
Cred_15796 vin1.$639.Metal2 VSS.P43.nSD 0.000129173f
Cred_15797 vin1.$64.GatPoly vout1.$1226.Metal3 0.00432025f
Cred_15798 vin1.$64.GatPoly vout1.$1292.Metal3 0.00448816f
Cred_15799 vin1.$64.GatPoly vout1.P4.nSD 5.23911e-07f
Cred_15800 vin1.$64.GatPoly vout1.P6.nSD 0.00598235f
Cred_15801 vin1.$64.GatPoly vout1.P6.pSD 0.000367161f
Cred_15802 vin1.$64.GatPoly vout1.P8.nSD 2.09838e-06f
Cred_15803 vin1.$64.GatPoly VSS.$1989.Metal1 2.64491e-06f
Cred_15804 vin1.$64.GatPoly VSS.$2020.Metal1 6.62232e-06f
Cred_15805 vin1.$64.GatPoly VSS.$29.Metal1 7.64869e-05f
Cred_15806 vin1.$64.GatPoly VSS.$2908.Metal2 5.4913e-05f
Cred_15807 vin1.$64.GatPoly VSS.$2940.Metal2 2.08531e-06f
Cred_15808 vin1.$64.GatPoly VSS.$3060.Metal2 6.25048e-05f
Cred_15809 vin1.$64.GatPoly VSS.$3095.Metal2 0.000207253f
Cred_15810 vin1.$64.GatPoly VSS.$4227.Metal2 1.77299e-08f
Cred_15811 vin1.$64.GatPoly VSS.$774.Metal1 0.000169257f
Cred_15812 vin1.$64.GatPoly VSS.$922.Metal1 0.000635031f
Cred_15813 vin1.$64.GatPoly VSS.P1.pSD 0.00362495f
Cred_15814 vin1.$64.GatPoly VSS.P31.nSD 1.40717e-06f
Cred_15815 vin1.$64.GatPoly VSS.P33.nSD 2.37653e-05f
Cred_15816 vin1.$640.Metal2 vout1 0.00144545f
Cred_15817 vin1.$640.Metal2 vout1.$1424.Metal3 0.0258238f
Cred_15818 vin1.$640.Metal2 vout1.P16.pSD 0.000359875f
Cred_15819 vin1.$640.Metal2 vout1.P18.nSD 0.000114848f
Cred_15820 vin1.$640.Metal2 vout1.P18.pSD 0.000882401f
Cred_15821 vin1.$642.Metal2 vout1 0.0213675f
Cred_15822 vin1.$642.Metal2 vout1.$1424.Metal3 0.169827f
Cred_15823 vin1.$642.Metal2 vout1.P16.nSD 2.08912e-05f
Cred_15824 vin1.$642.Metal2 vout1.P16.pSD 0.000104096f
Cred_15825 vin1.$642.Metal2 vout1.P18.nSD 0.00209619f
Cred_15826 vin1.$642.Metal2 vout1.P18.pSD 0.00968331f
Cred_15827 vin1.$642.Metal2 VSS.$1798.Metal1 0.000448976f
Cred_15828 vin1.$642.Metal2 VSS.$1989.Metal1 0.00299072f
Cred_15829 vin1.$642.Metal2 VSS.$2020.Metal1 0.00748815f
Cred_15830 vin1.$642.Metal2 VSS.$29.Metal1 3.30107e-05f
Cred_15831 vin1.$642.Metal2 VSS.$3982.Metal2 0.0029713f
Cred_15832 vin1.$642.Metal2 VSS.$4014.Metal2 0.00221267f
Cred_15833 vin1.$642.Metal2 VSS.$4227.Metal2 2.0048e-05f
Cred_15834 vin1.$642.Metal2 VSS.P1.pSD 0.0694838f
Cred_15835 vin1.$642.Metal2 VSS.P43.nSD 1.55876e-05f
Cred_15836 vin1.$644.Metal2 vout1 0.0023875f
Cred_15837 vin1.$644.Metal2 vout1.$1424.Metal3 0.0214104f
Cred_15838 vin1.$644.Metal2 vout1.P16.nSD 5.37838e-05f
Cred_15839 vin1.$644.Metal2 vout1.P18.nSD 0.000222834f
Cred_15840 vin1.$644.Metal2 vout1.P18.pSD 0.00102742f
Cred_15841 vin1.$644.Metal2 VSS.$1798.Metal1 0.00303883f
Cred_15842 vin1.$644.Metal2 VSS.$1869.Metal1 1.43018e-05f
Cred_15843 vin1.$644.Metal2 VSS.$1989.Metal1 0.000205734f
Cred_15844 vin1.$644.Metal2 VSS.$2020.Metal1 0.000515117f
Cred_15845 vin1.$644.Metal2 VSS.$29.Metal1 2.60432e-06f
Cred_15846 vin1.$644.Metal2 VSS.$3982.Metal2 0.0191202f
Cred_15847 vin1.$644.Metal2 VSS.$4014.Metal2 0.0154724f
Cred_15848 vin1.$644.Metal2 VSS.$4062.Metal2 0.00123396f
Cred_15849 vin1.$644.Metal2 VSS.$4227.Metal2 1.37912e-06f
Cred_15850 vin1.$644.Metal2 VSS.$5159.Metal3 9.89362e-06f
Cred_15851 vin1.$644.Metal2 VSS.P1.pSD 0.00531248f
Cred_15852 vin1.$644.Metal2 VSS.P43.nSD 0.000105958f
Cred_15853 vin1.$645.Metal2 vout1 0.00236295f
Cred_15854 vin1.$645.Metal2 vout1.$1424.Metal3 0.0200647f
Cred_15855 vin1.$645.Metal2 vout1.P16.pSD 0.000267992f
Cred_15856 vin1.$645.Metal2 vout1.P18.nSD 0.000187749f
Cred_15857 vin1.$645.Metal2 vout1.P18.pSD 0.00121076f
Cred_15858 vin1.$648.Metal2 vout1 0.00799498f
Cred_15859 vin1.$648.Metal2 vout1.$1424.Metal3 0.0403225f
Cred_15860 vin1.$648.Metal2 vout1.P18.nSD 0.00697728f
Cred_15861 vin1.$648.Metal2 vout1.P18.pSD 0.00346797f
Cred_15862 vin1.$648.Metal2 VSS.$1798.Metal1 8.49027e-06f
Cred_15863 vin1.$648.Metal2 VSS.$1869.Metal1 1.02915e-05f
Cred_15864 vin1.$648.Metal2 VSS.$1917.Metal1 1.29791e-05f
Cred_15865 vin1.$648.Metal2 VSS.$1977.Metal1 1.34041e-05f
Cred_15866 vin1.$648.Metal2 VSS.$1989.Metal1 0.00039461f
Cred_15867 vin1.$648.Metal2 VSS.$2020.Metal1 0.00100636f
Cred_15868 vin1.$648.Metal2 VSS.$29.Metal1 2.76105e-06f
Cred_15869 vin1.$648.Metal2 VSS.$3982.Metal2 4.23036e-07f
Cred_15870 vin1.$648.Metal2 VSS.$4014.Metal2 0.00123426f
Cred_15871 vin1.$648.Metal2 VSS.$4062.Metal2 0.00280512f
Cred_15872 vin1.$648.Metal2 VSS.$4110.Metal2 1.20785e-06f
Cred_15873 vin1.$648.Metal2 VSS.$4134.Metal2 1.1207e-07f
Cred_15874 vin1.$648.Metal2 VSS.$4227.Metal2 3.08303e-06f
Cred_15875 vin1.$648.Metal2 VSS.$5159.Metal3 9.89346e-06f
Cred_15876 vin1.$648.Metal2 VSS.P1.pSD 0.00709394f
Cred_15877 vin1.$648.Metal2 VSS.P3.GatPoly 3.41867e-05f
Cred_15878 vin1.$648.Metal2 VSS.P43.nSD 3.15318e-07f
Cred_15879 vin1.$648.Metal2 VSS.P45.nSD 1.22942e-07f
Cred_15880 vin1.$648.Metal2 VSS.P47.nSD 1.22942e-07f
Cred_15881 vin1.$649.Metal2 vout1 0.00747508f
Cred_15882 vin1.$649.Metal2 vout1.$1424.Metal3 0.0377004f
Cred_15883 vin1.$649.Metal2 vout1.P18.nSD 0.000615462f
Cred_15884 vin1.$649.Metal2 vout1.P18.pSD 0.0118701f
Cred_15885 vin1.$649.Metal2 VSS.$1989.Metal1 7.25429e-05f
Cred_15886 vin1.$649.Metal2 VSS.$2020.Metal1 0.000181633f
Cred_15887 vin1.$649.Metal2 VSS.$29.Metal1 4.5888e-07f
Cred_15888 vin1.$649.Metal2 VSS.$4134.Metal2 2.05108e-05f
Cred_15889 vin1.$649.Metal2 VSS.$4227.Metal2 4.86284e-07f
Cred_15890 vin1.$649.Metal2 VSS.P1.pSD 0.00122266f
Cred_15891 vin1.$65.GatPoly vout1.$1226.Metal3 0.012872f
Cred_15892 vin1.$65.GatPoly vout1.$1292.Metal3 0.0146682f
Cred_15893 vin1.$65.GatPoly vout1.P6.nSD 0.000202787f
Cred_15894 vin1.$65.GatPoly vout1.P6.pSD 0.0198092f
Cred_15895 vin1.$65.GatPoly vout1.P8.pSD 0.000126207f
Cred_15896 vin1.$653.Metal2 vout1 0.0195922f
Cred_15897 vin1.$653.Metal2 vout1.$1424.Metal3 0.098813f
Cred_15898 vin1.$653.Metal2 vout1.P18.nSD 0.0167274f
Cred_15899 vin1.$653.Metal2 vout1.P18.pSD 0.00853617f
Cred_15900 vin1.$653.Metal2 VSS.$1917.Metal1 7.12898e-05f
Cred_15901 vin1.$653.Metal2 VSS.$1977.Metal1 7.36241e-05f
Cred_15902 vin1.$653.Metal2 VSS.$1989.Metal1 0.00123015f
Cred_15903 vin1.$653.Metal2 VSS.$2020.Metal1 0.00317494f
Cred_15904 vin1.$653.Metal2 VSS.$29.Metal1 6.9369e-06f
Cred_15905 vin1.$653.Metal2 VSS.$4110.Metal2 0.00327481f
Cred_15906 vin1.$653.Metal2 VSS.$4134.Metal2 6.15563e-07f
Cred_15907 vin1.$653.Metal2 VSS.$4227.Metal2 1.05119e-05f
Cred_15908 vin1.$653.Metal2 VSS.P1.pSD 0.019448f
Cred_15909 vin1.$653.Metal2 VSS.P3.GatPoly 0.000176926f
Cred_15910 vin1.$653.Metal2 VSS.P45.nSD 6.36259e-07f
Cred_15911 vin1.$653.Metal2 VSS.P47.nSD 6.36259e-07f
Cred_15912 vin1.$654.Metal2 vout1 0.0182747f
Cred_15913 vin1.$654.Metal2 vout1.$1424.Metal3 0.0921679f
Cred_15914 vin1.$654.Metal2 vout1.P18.nSD 0.00153433f
Cred_15915 vin1.$654.Metal2 vout1.P18.pSD 0.028968f
Cred_15916 vin1.$654.Metal2 VSS.$1989.Metal1 0.00027737f
Cred_15917 vin1.$654.Metal2 VSS.$2020.Metal1 0.000694478f
Cred_15918 vin1.$654.Metal2 VSS.$29.Metal1 1.75454e-06f
Cred_15919 vin1.$654.Metal2 VSS.$4134.Metal2 0.000101763f
Cred_15920 vin1.$654.Metal2 VSS.$4227.Metal2 1.85932e-06f
Cred_15921 vin1.$654.Metal2 VSS.P1.pSD 0.00467487f
Cred_15922 vin1.$70.GatPoly vout1.$1226.Metal3 0.00101616f
Cred_15923 vin1.$70.GatPoly vout1.$1292.Metal3 0.00154863f
Cred_15924 vin1.$70.GatPoly vout1.P6.nSD 0.000877937f
Cred_15925 vin1.$70.GatPoly vout1.P6.pSD 8.74912e-05f
Cred_15926 vin1.$70.GatPoly vout1.P8.nSD 4.99287e-06f
Cred_15927 vin1.$70.GatPoly VSS.$1989.Metal1 3.02773e-06f
Cred_15928 vin1.$70.GatPoly VSS.$2020.Metal1 7.58081e-06f
Cred_15929 vin1.$70.GatPoly VSS.$29.Metal1 5.61816e-05f
Cred_15930 vin1.$70.GatPoly VSS.$3036.Metal2 9.81705e-08f
Cred_15931 vin1.$70.GatPoly VSS.$3060.Metal2 0.000237304f
Cred_15932 vin1.$70.GatPoly VSS.$3095.Metal2 0.000786752f
Cred_15933 vin1.$70.GatPoly VSS.$4227.Metal2 2.02961e-08f
Cred_15934 vin1.$70.GatPoly VSS.$870.Metal1 3.74658e-06f
Cred_15935 vin1.$70.GatPoly VSS.$922.Metal1 0.00823109f
Cred_15936 vin1.$70.GatPoly VSS.P1.pSD 0.00333478f
Cred_15937 vin1.$70.GatPoly VSS.P33.nSD 0.000219362f
Cred_15938 vin1.$73.GatPoly vout1.$1226.Metal3 0.00583736f
Cred_15939 vin1.$73.GatPoly vout1.$1292.Metal3 0.00722747f
Cred_15940 vin1.$73.GatPoly vout1.P6.nSD 9.19621e-05f
Cred_15941 vin1.$73.GatPoly vout1.P6.pSD 0.00810359f
Cred_15942 vin1.$73.GatPoly vout1.P8.pSD 9.76778e-05f
Cred_15943 vin1.$77.GatPoly vout1.$1226.Metal3 0.00277707f
Cred_15944 vin1.$77.GatPoly vout1.$1292.Metal3 0.0545756f
Cred_15945 vin1.$77.GatPoly vout1.P6.nSD 4.37501e-05f
Cred_15946 vin1.$77.GatPoly vout1.P6.pSD 0.00064954f
Cred_15947 vin1.$77.GatPoly vout1.P8.pSD 0.0321726f
Cred_15948 vin1.$78.GatPoly vout1.$1226.Metal3 0.000284706f
Cred_15949 vin1.$78.GatPoly vout1.$1292.Metal3 0.00270625f
Cred_15950 vin1.$78.GatPoly vout1.P6.nSD 1.00965e-05f
Cred_15951 vin1.$78.GatPoly vout1.P6.pSD 2.4513e-05f
Cred_15952 vin1.$78.GatPoly vout1.P8.nSD 0.00100732f
Cred_15953 vin1.$78.GatPoly VSS.$1029.Metal1 2.98183e-07f
Cred_15954 vin1.$78.GatPoly VSS.$1989.Metal1 3.16078e-06f
Cred_15955 vin1.$78.GatPoly VSS.$2020.Metal1 7.91396e-06f
Cred_15956 vin1.$78.GatPoly VSS.$29.Metal1 4.02709e-05f
Cred_15957 vin1.$78.GatPoly VSS.$3060.Metal2 0.000244128f
Cred_15958 vin1.$78.GatPoly VSS.$3095.Metal2 0.000809477f
Cred_15959 vin1.$78.GatPoly VSS.$3151.Metal2 2.49119e-09f
Cred_15960 vin1.$78.GatPoly VSS.$4227.Metal2 2.1188e-08f
Cred_15961 vin1.$78.GatPoly VSS.$922.Metal1 0.00732535f
Cred_15962 vin1.$78.GatPoly VSS.$981.Metal1 1.29111e-05f
Cred_15963 vin1.$78.GatPoly VSS.P1.pSD 0.00289151f
Cred_15964 vin1.$78.GatPoly VSS.P33.nSD 0.000202016f
Cred_15965 vin1.$80.GatPoly vout1.$1226.Metal3 0.000199294f
Cred_15966 vin1.$80.GatPoly vout1.$1292.Metal3 0.00373469f
Cred_15967 vin1.$80.GatPoly vout1.P6.nSD 7.06754e-06f
Cred_15968 vin1.$80.GatPoly vout1.P6.pSD 1.71591e-05f
Cred_15969 vin1.$80.GatPoly vout1.P8.nSD 0.00220149f
Cred_15970 vin1.$80.GatPoly VSS.$1029.Metal1 4.53682e-07f
Cred_15971 vin1.$80.GatPoly VSS.$1989.Metal1 3.26246e-06f
Cred_15972 vin1.$80.GatPoly VSS.$2020.Metal1 8.16854e-06f
Cred_15973 vin1.$80.GatPoly VSS.$29.Metal1 3.04743e-05f
Cred_15974 vin1.$80.GatPoly VSS.$3060.Metal2 0.000118436f
Cred_15975 vin1.$80.GatPoly VSS.$3095.Metal2 0.000392707f
Cred_15976 vin1.$80.GatPoly VSS.$3151.Metal2 3.79032e-09f
Cred_15977 vin1.$80.GatPoly VSS.$4227.Metal2 2.18696e-08f
Cred_15978 vin1.$80.GatPoly VSS.$922.Metal1 0.0011929f
Cred_15979 vin1.$80.GatPoly VSS.$981.Metal1 1.48102e-06f
Cred_15980 vin1.$80.GatPoly VSS.P1.pSD 0.00255986f
Cred_15981 vin1.$80.GatPoly VSS.P33.nSD 4.4642e-05f
Cred_15982 vin1.$83.GatPoly vout1.$1292.Metal3 0.0109782f
Cred_15983 vin1.$83.GatPoly vout1.P8.pSD 0.0092696f
Cred_15984 vin1.$84.GatPoly vout1.$1292.Metal3 0.00847535f
Cred_15985 vin1.$84.GatPoly vout1.$1358.Metal3 8.93274e-05f
Cred_15986 vin1.$84.GatPoly vout1.P10.nSD 3.16716e-06f
Cred_15987 vin1.$84.GatPoly vout1.P10.pSD 7.62187e-06f
Cred_15988 vin1.$84.GatPoly vout1.P8.nSD 0.00569174f
Cred_15989 vin1.$84.GatPoly VSS 0.000543284f
Cred_15990 vin1.$84.GatPoly VSS.$1989.Metal1 5.10621e-06f
Cred_15991 vin1.$84.GatPoly VSS.$2020.Metal1 1.27849e-05f
Cred_15992 vin1.$84.GatPoly VSS.$29.Metal1 3.62908e-05f
Cred_15993 vin1.$84.GatPoly VSS.$3250.Metal2 0.000114418f
Cred_15994 vin1.$84.GatPoly VSS.$3282.Metal2 0.000114418f
Cred_15995 vin1.$84.GatPoly VSS.$4227.Metal2 3.4229e-08f
Cred_15996 vin1.$84.GatPoly VSS.P1.pSD 0.00349303f
Cred_15997 vin1.$84.GatPoly VSS.P35.nSD 2.03318e-05f
Cred_15998 vin1.$87.GatPoly vout1.$1292.Metal3 0.0565322f
Cred_15999 vin1.$87.GatPoly vout1.$1358.Metal3 0.00285379f
Cred_16000 vin1.$87.GatPoly vout1.P10.nSD 4.49588e-05f
Cred_16001 vin1.$87.GatPoly vout1.P10.pSD 0.000699669f
Cred_16002 vin1.$87.GatPoly vout1.P8.pSD 0.0335743f
Cred_16003 vin1.$9.GatPoly vout1.$1226.Metal3 0.0447789f
Cred_16004 vin1.$9.GatPoly vout1.P0.nSD 0.00125946f
Cred_16005 vin1.$9.GatPoly vout1.P0.pSD 0.041632f
Cred_16006 vin1.$9.GatPoly vout1.P2.nSD 0.00070545f
Cred_16007 vin1.$9.GatPoly vout1.P2.pSD 0.00425851f
Cred_16008 vin1.$9.GatPoly VSS.$1989.Metal1 1.21858e-09f
Cred_16009 vin1.$9.GatPoly VSS.$2020.Metal1 3.05107e-09f
Cred_16010 vin1.$9.GatPoly VSS.$2403.Metal2 1.21987e-06f
Cred_16011 vin1.$9.GatPoly VSS.$2427.Metal2 8.94547e-07f
Cred_16012 vin1.$9.GatPoly VSS.$29.Metal1 1.05014e-05f
Cred_16013 vin1.$9.GatPoly VSS.$4227.Metal2 8.16861e-12f
Cred_16014 vin1.$9.GatPoly VSS.$4415.Metal3 0.000152145f
Cred_16015 vin1.$9.GatPoly VSS.$4451.Metal3 0.00011157f
Cred_16016 vin1.$9.GatPoly VSS.P1.pSD 2.02048e-05f
Cred_16017 vin1.$9.GatPoly VSS.P2.GatPoly 1.62293e-06f
Cred_16018 vin1.$90.GatPoly vout1.$1292.Metal3 0.00275715f
Cred_16019 vin1.$90.GatPoly vout1.$1358.Metal3 0.000290126f
Cred_16020 vin1.$90.GatPoly vout1.P10.nSD 1.02866e-05f
Cred_16021 vin1.$90.GatPoly vout1.P10.pSD 2.47551e-05f
Cred_16022 vin1.$90.GatPoly vout1.P8.nSD 0.00101147f
Cred_16023 vin1.$90.GatPoly VSS 0.00511851f
Cred_16024 vin1.$90.GatPoly VSS.$1069.Metal1 0.000212333f
Cred_16025 vin1.$90.GatPoly VSS.$1989.Metal1 5.23962e-06f
Cred_16026 vin1.$90.GatPoly VSS.$2020.Metal1 1.3119e-05f
Cred_16027 vin1.$90.GatPoly VSS.$29.Metal1 2.56866e-05f
Cred_16028 vin1.$90.GatPoly VSS.$3199.Metal2 9.13595e-08f
Cred_16029 vin1.$90.GatPoly VSS.$3250.Metal2 0.000473398f
Cred_16030 vin1.$90.GatPoly VSS.$3282.Metal2 0.000471677f
Cred_16031 vin1.$90.GatPoly VSS.$4227.Metal2 3.51233e-08f
Cred_16032 vin1.$90.GatPoly VSS.$4799.Metal3 7.325e-10f
Cred_16033 vin1.$90.GatPoly VSS.P1.pSD 0.00297592f
Cred_16034 vin1.$90.GatPoly VSS.P35.nSD 0.00015164f
Cred_16035 vin1.$94.GatPoly vout1.$1292.Metal3 0.000682049f
Cred_16036 vin1.$94.GatPoly vout1.$1358.Metal3 0.000448945f
Cred_16037 vin1.$94.GatPoly vout1.P10.nSD 0.00039386f
Cred_16038 vin1.$94.GatPoly vout1.P10.pSD 3.83063e-05f
Cred_16039 vin1.$94.GatPoly vout1.P8.nSD 2.18579e-06f
Cred_16040 vin1.$94.GatPoly VSS 0.0126278f
Cred_16041 vin1.$94.GatPoly VSS.$1069.Metal1 0.000201669f
Cred_16042 vin1.$94.GatPoly VSS.$1165.Metal1 0.000509998f
Cred_16043 vin1.$94.GatPoly VSS.$1989.Metal1 7.58449e-06f
Cred_16044 vin1.$94.GatPoly VSS.$2020.Metal1 1.899e-05f
Cred_16045 vin1.$94.GatPoly VSS.$29.Metal1 2.59008e-05f
Cred_16046 vin1.$94.GatPoly VSS.$3250.Metal2 0.000502281f
Cred_16047 vin1.$94.GatPoly VSS.$3282.Metal2 0.000504765f
Cred_16048 vin1.$94.GatPoly VSS.$4227.Metal2 5.08419e-08f
Cred_16049 vin1.$94.GatPoly VSS.P1.pSD 0.00359133f
Cred_16050 vin1.$94.GatPoly VSS.P35.nSD 0.000332057f
Cred_16051 vin1.$97.GatPoly vout1.$1292.Metal3 0.0312837f
Cred_16052 vin1.$97.GatPoly vout1.$1358.Metal3 0.0254406f
Cred_16053 vin1.$97.GatPoly vout1.P10.nSD 0.000400792f
Cred_16054 vin1.$97.GatPoly vout1.P10.pSD 0.0365361f
Cred_16055 vin1.$97.GatPoly vout1.P8.pSD 0.000410777f
Cred_16056 vin1.P0.GatPoly vout1.$1226.Metal3 0.0351948f
Cred_16057 vin1.P0.GatPoly vout1.P0.nSD 0.0265082f
Cred_16058 vin1.P0.GatPoly vout1.P0.pSD 0.00556885f
Cred_16059 vin1.P0.GatPoly vout1.P2.nSD 0.000554462f
Cred_16060 vin1.P0.GatPoly vout1.P2.pSD 0.00303026f
Cred_16061 vin1.P0.GatPoly VSS.$157.Metal1 0.0458998f
Cred_16062 vin1.P0.GatPoly VSS.$1989.Metal1 8.47855e-07f
Cred_16063 vin1.P0.GatPoly VSS.$2020.Metal1 2.12286e-06f
Cred_16064 vin1.P0.GatPoly VSS.$2226.Metal2 0.0121648f
Cred_16065 vin1.P0.GatPoly VSS.$2342.Metal2 0.000492762f
Cred_16066 vin1.P0.GatPoly VSS.$2403.Metal2 0.00586171f
Cred_16067 vin1.P0.GatPoly VSS.$2427.Metal2 0.00422297f
Cred_16068 vin1.P0.GatPoly VSS.$2526.Metal2 0.000585659f
Cred_16069 vin1.P0.GatPoly VSS.$2558.Metal2 0.000786456f
Cred_16070 vin1.P0.GatPoly VSS.$257.Metal1 0.0102494f
Cred_16071 vin1.P0.GatPoly VSS.$29.Metal1 0.00271541f
Cred_16072 vin1.P0.GatPoly VSS.$317.Metal1 0.00920261f
Cred_16073 vin1.P0.GatPoly VSS.$385.Metal1 0.000103919f
Cred_16074 vin1.P0.GatPoly VSS.$4227.Metal2 5.68351e-09f
Cred_16075 vin1.P0.GatPoly VSS.$4355.Metal3 1.45726e-05f
Cred_16076 vin1.P0.GatPoly VSS.$4415.Metal3 0.00347702f
Cred_16077 vin1.P0.GatPoly VSS.$4451.Metal3 0.00276441f
Cred_16078 vin1.P0.GatPoly VSS.P1.pSD 0.0100631f
Cred_16079 vin1.P0.GatPoly VSS.P2.GatPoly 0.0188624f
Cred_16080 vin1.P0.GatPoly VSS.P24.nSD 0.000210613f
Cred_16081 vin1.P0.GatPoly VSS.P25.nSD 0.000210613f
Cred_16082 vin1.P0.GatPoly VSS.P27.nSD 3.56597e-06f
Cred_16083 vin1.P1.GatPoly vout1.$1226.Metal3 0.0367128f
Cred_16084 vin1.P1.GatPoly vout1.P0.nSD 0.0231313f
Cred_16085 vin1.P1.GatPoly vout1.P0.pSD 0.00555071f
Cred_16086 vin1.P1.GatPoly vout1.P2.nSD 0.000617178f
Cred_16087 vin1.P1.GatPoly vout1.P2.pSD 0.00316095f
Cred_16088 vin1.P1.GatPoly VSS.$1989.Metal1 6.87509e-08f
Cred_16089 vin1.P1.GatPoly VSS.$2020.Metal1 1.72138e-07f
Cred_16090 vin1.P1.GatPoly VSS.$2475.Metal2 0.00556066f
Cred_16091 vin1.P1.GatPoly VSS.$2526.Metal2 0.0088377f
Cred_16092 vin1.P1.GatPoly VSS.$2558.Metal2 0.00807083f
Cred_16093 vin1.P1.GatPoly VSS.$29.Metal1 9.87321e-05f
Cred_16094 vin1.P1.GatPoly VSS.$317.Metal1 0.00333774f
Cred_16095 vin1.P1.GatPoly VSS.$365.Metal1 0.0144838f
Cred_16096 vin1.P1.GatPoly VSS.$385.Metal1 0.0581484f
Cred_16097 vin1.P1.GatPoly VSS.$4227.Metal2 4.60865e-10f
Cred_16098 vin1.P1.GatPoly VSS.$4475.Metal3 0.00390769f
Cred_16099 vin1.P1.GatPoly VSS.P1.pSD 0.000600429f
Cred_16100 vin1.P1.GatPoly VSS.P27.nSD 0.00178219f
Cred_16101 vin1.P10.GatPoly vout1.$1292.Metal3 0.0242843f
Cred_16102 vin1.P10.GatPoly vout1.$1358.Metal3 0.0205287f
Cred_16103 vin1.P10.GatPoly vout1.P10.nSD 0.0217703f
Cred_16104 vin1.P10.GatPoly vout1.P10.pSD 0.00175161f
Cred_16105 vin1.P10.GatPoly vout1.P8.nSD 3.84552e-05f
Cred_16106 vin1.P10.GatPoly VSS 0.0550719f
Cred_16107 vin1.P10.GatPoly VSS.$1165.Metal1 0.0142989f
Cred_16108 vin1.P10.GatPoly VSS.$1205.Metal1 0.00331295f
Cred_16109 vin1.P10.GatPoly VSS.$1265.Metal1 8.99087e-05f
Cred_16110 vin1.P10.GatPoly VSS.$1989.Metal1 2.28943e-06f
Cred_16111 vin1.P10.GatPoly VSS.$2020.Metal1 5.73227e-06f
Cred_16112 vin1.P10.GatPoly VSS.$29.Metal1 6.05797e-06f
Cred_16113 vin1.P10.GatPoly VSS.$3250.Metal2 0.00696084f
Cred_16114 vin1.P10.GatPoly VSS.$3282.Metal2 0.0097833f
Cred_16115 vin1.P10.GatPoly VSS.$3338.Metal2 0.00597574f
Cred_16116 vin1.P10.GatPoly VSS.$3445.Metal2 0.00091972f
Cred_16117 vin1.P10.GatPoly VSS.$3477.Metal2 0.000277376f
Cred_16118 vin1.P10.GatPoly VSS.$4227.Metal2 1.5347e-08f
Cred_16119 vin1.P10.GatPoly VSS.$4835.Metal3 0.00390769f
Cred_16120 vin1.P10.GatPoly VSS.P1.pSD 0.000967334f
Cred_16121 vin1.P10.GatPoly VSS.P35.nSD 0.00170404f
Cred_16122 vin1.P10.GatPoly VSS.P37.nSD 3.08522e-06f
Cred_16123 vin1.P11.GatPoly vout1.$1292.Metal3 0.0201189f
Cred_16124 vin1.P11.GatPoly vout1.$1358.Metal3 0.0235822f
Cred_16125 vin1.P11.GatPoly vout1.P10.nSD 0.0215498f
Cred_16126 vin1.P11.GatPoly vout1.P10.pSD 0.00171665f
Cred_16127 vin1.P11.GatPoly vout1.P12.nSD 3.57144e-05f
Cred_16128 vin1.P11.GatPoly VSS 9.06646e-05f
Cred_16129 vin1.P11.GatPoly VSS.$1205.Metal1 0.00413997f
Cred_16130 vin1.P11.GatPoly VSS.$1245.Metal1 0.0140247f
Cred_16131 vin1.P11.GatPoly VSS.$1265.Metal1 0.0500404f
Cred_16132 vin1.P11.GatPoly VSS.$3250.Metal2 0.000598157f
Cred_16133 vin1.P11.GatPoly VSS.$3282.Metal2 0.000598157f
Cred_16134 vin1.P11.GatPoly VSS.$3338.Metal2 7.37632e-06f
Cred_16135 vin1.P11.GatPoly VSS.$3386.Metal2 0.00692018f
Cred_16136 vin1.P11.GatPoly VSS.$3445.Metal2 0.0126099f
Cred_16137 vin1.P11.GatPoly VSS.$3477.Metal2 0.00309293f
Cred_16138 vin1.P11.GatPoly VSS.$4835.Metal3 0.000460914f
Cred_16139 vin1.P11.GatPoly VSS.$4883.Metal3 0.00482079f
Cred_16140 vin1.P11.GatPoly VSS.P1.pSD 9.05855e-06f
Cred_16141 vin1.P11.GatPoly VSS.P35.nSD 3.11116e-06f
Cred_16142 vin1.P11.GatPoly VSS.P37.nSD 0.00157765f
Cred_16143 vin1.P12.GatPoly vout1.$1292.Metal3 0.00172617f
Cred_16144 vin1.P12.GatPoly vout1.$1358.Metal3 0.0443094f
Cred_16145 vin1.P12.GatPoly vout1.P10.nSD 6.44422e-05f
Cred_16146 vin1.P12.GatPoly vout1.P10.pSD 0.000147285f
Cred_16147 vin1.P12.GatPoly vout1.P12.nSD 0.0212036f
Cred_16148 vin1.P12.GatPoly VSS.$1265.Metal1 0.0571382f
Cred_16149 vin1.P12.GatPoly VSS.$1364.Metal1 0.0126797f
Cred_16150 vin1.P12.GatPoly VSS.$1466.Metal1 9.66851e-05f
Cred_16151 vin1.P12.GatPoly VSS.$1989.Metal1 2.16158e-06f
Cred_16152 vin1.P12.GatPoly VSS.$2020.Metal1 5.41216e-06f
Cred_16153 vin1.P12.GatPoly VSS.$29.Metal1 1.34436e-06f
Cred_16154 vin1.P12.GatPoly VSS.$3445.Metal2 0.0103861f
Cred_16155 vin1.P12.GatPoly VSS.$3477.Metal2 0.00556097f
Cred_16156 vin1.P12.GatPoly VSS.$3501.Metal2 0.00699176f
Cred_16157 vin1.P12.GatPoly VSS.$3549.Metal2 0.00122955f
Cred_16158 vin1.P12.GatPoly VSS.$3597.Metal2 4.36418e-05f
Cred_16159 vin1.P12.GatPoly VSS.$3632.Metal2 0.00114923f
Cred_16160 vin1.P12.GatPoly VSS.$4227.Metal2 1.449e-08f
Cred_16161 vin1.P12.GatPoly VSS.$4883.Metal3 0.00162593f
Cred_16162 vin1.P12.GatPoly VSS.$4931.Metal3 0.00336824f
Cred_16163 vin1.P12.GatPoly VSS.P1.pSD 0.000466296f
Cred_16164 vin1.P12.GatPoly VSS.P37.nSD 0.0015791f
Cred_16165 vin1.P12.GatPoly VSS.P39.nSD 5.29002e-07f
Cred_16166 vin1.P13.GatPoly vout1.$1358.Metal3 0.0441012f
Cred_16167 vin1.P13.GatPoly vout1.$1424.Metal3 0.00165462f
Cred_16168 vin1.P13.GatPoly vout1.P12.nSD 0.0213646f
Cred_16169 vin1.P13.GatPoly vout1.P14.nSD 6.19055e-05f
Cred_16170 vin1.P13.GatPoly vout1.P14.pSD 0.000141181f
Cred_16171 vin1.P13.GatPoly VSS.$1265.Metal1 8.99087e-05f
Cred_16172 vin1.P13.GatPoly VSS.$1364.Metal1 0.00118965f
Cred_16173 vin1.P13.GatPoly VSS.$1412.Metal1 0.0148789f
Cred_16174 vin1.P13.GatPoly VSS.$1463.Metal1 0.00436754f
Cred_16175 vin1.P13.GatPoly VSS.$1466.Metal1 0.0526177f
Cred_16176 vin1.P13.GatPoly VSS.$1989.Metal1 2.58246e-06f
Cred_16177 vin1.P13.GatPoly VSS.$2020.Metal1 6.46596e-06f
Cred_16178 vin1.P13.GatPoly VSS.$29.Metal1 1.01834e-06f
Cred_16179 vin1.P13.GatPoly VSS.$3445.Metal2 0.00091972f
Cred_16180 vin1.P13.GatPoly VSS.$3477.Metal2 0.000277376f
Cred_16181 vin1.P13.GatPoly VSS.$3549.Metal2 0.00281966f
Cred_16182 vin1.P13.GatPoly VSS.$3597.Metal2 0.00668692f
Cred_16183 vin1.P13.GatPoly VSS.$3632.Metal2 0.00985657f
Cred_16184 vin1.P13.GatPoly VSS.$4227.Metal2 1.73113e-08f
Cred_16185 vin1.P13.GatPoly VSS.$4955.Metal3 0.00440933f
Cred_16186 vin1.P13.GatPoly VSS.$4991.Metal3 0.000775961f
Cred_16187 vin1.P13.GatPoly VSS.P1.pSD 0.000426885f
Cred_16188 vin1.P13.GatPoly VSS.P37.nSD 3.08522e-06f
Cred_16189 vin1.P13.GatPoly VSS.P39.nSD 0.00021155f
Cred_16190 vin1.P14.GatPoly vout1.$1358.Metal3 0.0222288f
Cred_16191 vin1.P14.GatPoly vout1.$1424.Metal3 0.0191762f
Cred_16192 vin1.P14.GatPoly vout1.P12.nSD 3.18635e-05f
Cred_16193 vin1.P14.GatPoly vout1.P14.nSD 0.0205849f
Cred_16194 vin1.P14.GatPoly vout1.P14.pSD 0.00163622f
Cred_16195 vin1.P14.GatPoly VSS.$1466.Metal1 0.0521114f
Cred_16196 vin1.P14.GatPoly VSS.$1503.Metal1 0.0154523f
Cred_16197 vin1.P14.GatPoly VSS.$1571.Metal1 0.00433478f
Cred_16198 vin1.P14.GatPoly VSS.$1623.Metal1 9.02649e-05f
Cred_16199 vin1.P14.GatPoly VSS.$3597.Metal2 0.000358966f
Cred_16200 vin1.P14.GatPoly VSS.$3632.Metal2 0.0113716f
Cred_16201 vin1.P14.GatPoly VSS.$3688.Metal2 0.00751382f
Cred_16202 vin1.P14.GatPoly VSS.$3712.Metal2 4.30156e-05f
Cred_16203 vin1.P14.GatPoly VSS.$3784.Metal2 0.000364856f
Cred_16204 vin1.P14.GatPoly VSS.$3819.Metal2 0.000831872f
Cred_16205 vin1.P14.GatPoly VSS.$4991.Metal3 0.00443521f
Cred_16206 vin1.P14.GatPoly VSS.$5027.Metal3 0.000848036f
Cred_16207 vin1.P14.GatPoly VSS.P1.pSD 2.14021e-05f
Cred_16208 vin1.P14.GatPoly VSS.P39.nSD 0.000208376f
Cred_16209 vin1.P14.GatPoly VSS.P41.nSD 3.09744e-06f
Cred_16210 vin1.P15.GatPoly vout1.$1358.Metal3 0.0209365f
Cred_16211 vin1.P15.GatPoly vout1.$1424.Metal3 0.0246698f
Cred_16212 vin1.P15.GatPoly vout1.P14.nSD 0.0225422f
Cred_16213 vin1.P15.GatPoly vout1.P14.pSD 0.00178641f
Cred_16214 vin1.P15.GatPoly vout1.P16.nSD 3.82463e-05f
Cred_16215 vin1.P15.GatPoly VSS.$1466.Metal1 9.66851e-05f
Cred_16216 vin1.P15.GatPoly VSS.$1571.Metal1 0.0129289f
Cred_16217 vin1.P15.GatPoly VSS.$1623.Metal1 0.0570885f
Cred_16218 vin1.P15.GatPoly VSS.$1989.Metal1 1.31729e-05f
Cred_16219 vin1.P15.GatPoly VSS.$2020.Metal1 3.29822e-05f
Cred_16220 vin1.P15.GatPoly VSS.$29.Metal1 1.11627e-06f
Cred_16221 vin1.P15.GatPoly VSS.$3597.Metal2 4.36418e-05f
Cred_16222 vin1.P15.GatPoly VSS.$3632.Metal2 0.00114923f
Cred_16223 vin1.P15.GatPoly VSS.$3712.Metal2 0.00100845f
Cred_16224 vin1.P15.GatPoly VSS.$3760.Metal2 0.00676466f
Cred_16225 vin1.P15.GatPoly VSS.$3784.Metal2 0.00616224f
Cred_16226 vin1.P15.GatPoly VSS.$3819.Metal2 0.00948282f
Cred_16227 vin1.P15.GatPoly VSS.$4227.Metal2 8.83032e-08f
Cred_16228 vin1.P15.GatPoly VSS.$5027.Metal3 0.00341116f
Cred_16229 vin1.P15.GatPoly VSS.$5075.Metal3 0.00154919f
Cred_16230 vin1.P15.GatPoly VSS.P1.pSD 0.000982691f
Cred_16231 vin1.P15.GatPoly VSS.P39.nSD 5.29002e-07f
Cred_16232 vin1.P15.GatPoly VSS.P41.nSD 0.00158988f
Cred_16233 vin1.P16.GatPoly vout1.$1358.Metal3 0.00145287f
Cred_16234 vin1.P16.GatPoly vout1.$1424.Metal3 0.0417745f
Cred_16235 vin1.P16.GatPoly vout1.P14.nSD 5.47521e-05f
Cred_16236 vin1.P16.GatPoly vout1.P14.pSD 0.000123966f
Cred_16237 vin1.P16.GatPoly vout1.P16.nSD 0.0203078f
Cred_16238 vin1.P16.GatPoly VSS.$1623.Metal1 0.0500973f
Cred_16239 vin1.P16.GatPoly VSS.$1690.Metal1 0.01338f
Cred_16240 vin1.P16.GatPoly VSS.$1730.Metal1 0.00459092f
Cred_16241 vin1.P16.GatPoly VSS.$1798.Metal1 9.06084e-05f
Cred_16242 vin1.P16.GatPoly VSS.$3784.Metal2 0.00392052f
Cred_16243 vin1.P16.GatPoly VSS.$3819.Metal2 0.0114439f
Cred_16244 vin1.P16.GatPoly VSS.$3875.Metal2 0.00670696f
Cred_16245 vin1.P16.GatPoly VSS.$3923.Metal2 6.29324e-06f
Cred_16246 vin1.P16.GatPoly VSS.$3982.Metal2 0.000685726f
Cred_16247 vin1.P16.GatPoly VSS.$4014.Metal2 0.000510647f
Cred_16248 vin1.P16.GatPoly VSS.$5075.Metal3 0.00490799f
Cred_16249 vin1.P16.GatPoly VSS.$5123.Metal3 0.000393237f
Cred_16250 vin1.P16.GatPoly VSS.P1.pSD 1.17745e-05f
Cred_16251 vin1.P16.GatPoly VSS.P41.nSD 0.00154074f
Cred_16252 vin1.P16.GatPoly VSS.P43.nSD 3.10923e-06f
Cred_16253 vin1.P17.GatPoly vout1 0.0005655f
Cred_16254 vin1.P17.GatPoly vout1.$1424.Metal3 0.0463676f
Cred_16255 vin1.P17.GatPoly vout1.P16.nSD 0.0216974f
Cred_16256 vin1.P17.GatPoly vout1.P18.nSD 8.29213e-05f
Cred_16257 vin1.P17.GatPoly vout1.P18.pSD 0.000243355f
Cred_16258 vin1.P17.GatPoly VSS.$1623.Metal1 9.02649e-05f
Cred_16259 vin1.P17.GatPoly VSS.$1730.Metal1 0.0036862f
Cred_16260 vin1.P17.GatPoly VSS.$1778.Metal1 0.0136645f
Cred_16261 vin1.P17.GatPoly VSS.$1798.Metal1 0.0524707f
Cred_16262 vin1.P17.GatPoly VSS.$1989.Metal1 2.72715e-05f
Cred_16263 vin1.P17.GatPoly VSS.$2020.Metal1 6.82824e-05f
Cred_16264 vin1.P17.GatPoly VSS.$29.Metal1 5.79407e-07f
Cred_16265 vin1.P17.GatPoly VSS.$3784.Metal2 0.000364856f
Cred_16266 vin1.P17.GatPoly VSS.$3819.Metal2 0.000831872f
Cred_16267 vin1.P17.GatPoly VSS.$3875.Metal2 4.69191e-06f
Cred_16268 vin1.P17.GatPoly VSS.$3923.Metal2 0.00632534f
Cred_16269 vin1.P17.GatPoly VSS.$3982.Metal2 0.0105677f
Cred_16270 vin1.P17.GatPoly VSS.$4014.Metal2 0.00582623f
Cred_16271 vin1.P17.GatPoly VSS.$4227.Metal2 1.82812e-07f
Cred_16272 vin1.P17.GatPoly VSS.$5075.Metal3 0.000293177f
Cred_16273 vin1.P17.GatPoly VSS.$5123.Metal3 0.004796f
Cred_16274 vin1.P17.GatPoly VSS.P1.pSD 0.00095676f
Cred_16275 vin1.P17.GatPoly VSS.P41.nSD 3.09744e-06f
Cred_16276 vin1.P17.GatPoly VSS.P43.nSD 0.00161326f
Cred_16277 vin1.P18.GatPoly vout1 0.00663761f
Cred_16278 vin1.P18.GatPoly vout1.$1424.Metal3 0.0372692f
Cred_16279 vin1.P18.GatPoly vout1.P16.nSD 3.88024e-05f
Cred_16280 vin1.P18.GatPoly vout1.P18.nSD 0.0223709f
Cred_16281 vin1.P18.GatPoly vout1.P18.pSD 0.0028564f
Cred_16282 vin1.P18.GatPoly VSS.$1798.Metal1 0.0566901f
Cred_16283 vin1.P18.GatPoly VSS.$1869.Metal1 0.0144838f
Cred_16284 vin1.P18.GatPoly VSS.$1917.Metal1 0.00333774f
Cred_16285 vin1.P18.GatPoly VSS.$1989.Metal1 2.59884e-05f
Cred_16286 vin1.P18.GatPoly VSS.$2020.Metal1 6.50696e-05f
Cred_16287 vin1.P18.GatPoly VSS.$29.Metal1 2.62021e-07f
Cred_16288 vin1.P18.GatPoly VSS.$3982.Metal2 0.00800795f
Cred_16289 vin1.P18.GatPoly VSS.$4014.Metal2 0.00879088f
Cred_16290 vin1.P18.GatPoly VSS.$4062.Metal2 0.00556066f
Cred_16291 vin1.P18.GatPoly VSS.$4227.Metal2 1.74211e-07f
Cred_16292 vin1.P18.GatPoly VSS.$5159.Metal3 0.00390769f
Cred_16293 vin1.P18.GatPoly VSS.P1.pSD 0.000607908f
Cred_16294 vin1.P18.GatPoly VSS.P43.nSD 0.00173666f
Cred_16295 vin1.P19.GatPoly vout1 0.00823266f
Cred_16296 vin1.P19.GatPoly vout1.$1424.Metal3 0.0415213f
Cred_16297 vin1.P19.GatPoly vout1.P18.nSD 0.0258089f
Cred_16298 vin1.P19.GatPoly vout1.P18.pSD 0.00354281f
Cred_16299 vin1.P19.GatPoly VSS.$1798.Metal1 0.000103919f
Cred_16300 vin1.P19.GatPoly VSS.$1917.Metal1 0.00956147f
Cred_16301 vin1.P19.GatPoly VSS.$1977.Metal1 0.0104793f
Cred_16302 vin1.P19.GatPoly VSS.$1989.Metal1 0.000711861f
Cred_16303 vin1.P19.GatPoly VSS.$2020.Metal1 0.0477301f
Cred_16304 vin1.P19.GatPoly VSS.$29.Metal1 3.25212e-06f
Cred_16305 vin1.P19.GatPoly VSS.$3982.Metal2 0.000786456f
Cred_16306 vin1.P19.GatPoly VSS.$4014.Metal2 0.000585659f
Cred_16307 vin1.P19.GatPoly VSS.$4110.Metal2 0.00496993f
Cred_16308 vin1.P19.GatPoly VSS.$4134.Metal2 0.00693351f
Cred_16309 vin1.P19.GatPoly VSS.$4195.Metal2 0.000492212f
Cred_16310 vin1.P19.GatPoly VSS.$4227.Metal2 0.0129876f
Cred_16311 vin1.P19.GatPoly VSS.$5183.Metal3 0.00278945f
Cred_16312 vin1.P19.GatPoly VSS.$5219.Metal3 0.0035273f
Cred_16313 vin1.P19.GatPoly VSS.P1.pSD 0.0102793f
Cred_16314 vin1.P19.GatPoly VSS.P3.GatPoly 0.0190579f
Cred_16315 vin1.P19.GatPoly VSS.P43.nSD 3.56597e-06f
Cred_16316 vin1.P19.GatPoly VSS.P45.nSD 0.000210815f
Cred_16317 vin1.P19.GatPoly VSS.P47.nSD 0.000210815f
Cred_16318 vin1.P2.GatPoly vout1.$1226.Metal3 0.0393216f
Cred_16319 vin1.P2.GatPoly vout1.P0.nSD 0.000674738f
Cred_16320 vin1.P2.GatPoly vout1.P0.pSD 0.00325793f
Cred_16321 vin1.P2.GatPoly vout1.P2.nSD 0.0223169f
Cred_16322 vin1.P2.GatPoly vout1.P2.pSD 0.00338557f
Cred_16323 vin1.P2.GatPoly VSS.$1989.Metal1 1.52283e-07f
Cred_16324 vin1.P2.GatPoly VSS.$2020.Metal1 3.81286e-07f
Cred_16325 vin1.P2.GatPoly VSS.$2526.Metal2 0.00582372f
Cred_16326 vin1.P2.GatPoly VSS.$2558.Metal2 0.0105643f
Cred_16327 vin1.P2.GatPoly VSS.$2614.Metal2 0.00632534f
Cred_16328 vin1.P2.GatPoly VSS.$2662.Metal2 4.69191e-06f
Cred_16329 vin1.P2.GatPoly VSS.$2721.Metal2 0.000831872f
Cred_16330 vin1.P2.GatPoly VSS.$2753.Metal2 0.000364856f
Cred_16331 vin1.P2.GatPoly VSS.$29.Metal1 0.000103607f
Cred_16332 vin1.P2.GatPoly VSS.$385.Metal1 0.0523928f
Cred_16333 vin1.P2.GatPoly VSS.$4227.Metal2 1.02081e-09f
Cred_16334 vin1.P2.GatPoly VSS.$4511.Metal3 0.004796f
Cred_16335 vin1.P2.GatPoly VSS.$4559.Metal3 0.000293177f
Cred_16336 vin1.P2.GatPoly VSS.$456.Metal1 0.0136645f
Cred_16337 vin1.P2.GatPoly VSS.$504.Metal1 0.0036862f
Cred_16338 vin1.P2.GatPoly VSS.$564.Metal1 9.02649e-05f
Cred_16339 vin1.P2.GatPoly VSS.P1.pSD 0.000948934f
Cred_16340 vin1.P2.GatPoly VSS.P27.nSD 0.00161083f
Cred_16341 vin1.P2.GatPoly VSS.P29.nSD 3.09744e-06f
Cred_16342 vin1.P20.GatPoly vin2.P20.GatPoly 0.00126396f
Cred_16343 vin1.P20.GatPoly vout1.$1226.Metal3 0.157091f
Cred_16344 vin1.P20.GatPoly vout1.P0.nSD 0.00467766f
Cred_16345 vin1.P20.GatPoly vout1.P0.pSD 0.170586f
Cred_16346 vin1.P20.GatPoly vout1.P2.nSD 0.00247482f
Cred_16347 vin1.P20.GatPoly vout1.P2.pSD 0.0135254f
Cred_16348 vin1.P20.GatPoly VSS.$1989.Metal1 9.59742e-10f
Cred_16349 vin1.P20.GatPoly VSS.$2020.Metal1 2.403e-09f
Cred_16350 vin1.P20.GatPoly VSS.$2403.Metal2 4.7835e-06f
Cred_16351 vin1.P20.GatPoly VSS.$2427.Metal2 3.50781e-06f
Cred_16352 vin1.P20.GatPoly VSS.$29.Metal1 8.27085e-06f
Cred_16353 vin1.P20.GatPoly VSS.$4227.Metal2 6.43354e-12f
Cred_16354 vin1.P20.GatPoly VSS.$4415.Metal3 0.000596611f
Cred_16355 vin1.P20.GatPoly VSS.$4451.Metal3 0.000437504f
Cred_16356 vin1.P20.GatPoly VSS.P1.pSD 1.59131e-05f
Cred_16357 vin1.P20.GatPoly VSS.P2.GatPoly 1.27821e-06f
Cred_16358 vin1.P21.GatPoly vin2.P21.GatPoly 0.00126396f
Cred_16359 vin1.P21.GatPoly vout1.$1226.Metal3 0.160661f
Cred_16360 vin1.P21.GatPoly vout1.P0.nSD 0.00458159f
Cred_16361 vin1.P21.GatPoly vout1.P0.pSD 0.152776f
Cred_16362 vin1.P21.GatPoly vout1.P2.nSD 0.00253106f
Cred_16363 vin1.P21.GatPoly vout1.P2.pSD 0.0164452f
Cred_16364 vin1.P22.GatPoly vin2.P22.GatPoly 0.00126396f
Cred_16365 vin1.P22.GatPoly vout1.$1226.Metal3 0.174054f
Cred_16366 vin1.P22.GatPoly vout1.P0.nSD 0.0026994f
Cred_16367 vin1.P22.GatPoly vout1.P0.pSD 0.0174661f
Cred_16368 vin1.P22.GatPoly vout1.P2.nSD 0.00274205f
Cred_16369 vin1.P22.GatPoly vout1.P2.pSD 0.135457f
Cred_16370 vin1.P23.GatPoly vin2.P23.GatPoly 0.00126396f
Cred_16371 vin1.P23.GatPoly vout1.$1226.Metal3 0.177972f
Cred_16372 vin1.P23.GatPoly vout1.P0.nSD 0.00235124f
Cred_16373 vin1.P23.GatPoly vout1.P0.pSD 0.0124941f
Cred_16374 vin1.P23.GatPoly vout1.P2.nSD 0.00255785f
Cred_16375 vin1.P23.GatPoly vout1.P2.pSD 0.13445f
Cred_16376 vin1.P23.GatPoly vout1.P4.pSD 0.00259263f
Cred_16377 vin1.P24.GatPoly vin2.P24.GatPoly 0.00126396f
Cred_16378 vin1.P24.GatPoly vout1.$1226.Metal3 0.216059f
Cred_16379 vin1.P24.GatPoly vout1.P0.nSD 0.000200773f
Cred_16380 vin1.P24.GatPoly vout1.P0.pSD 0.00106687f
Cred_16381 vin1.P24.GatPoly vout1.P2.nSD 0.000218415f
Cred_16382 vin1.P24.GatPoly vout1.P2.pSD 0.00385188f
Cred_16383 vin1.P24.GatPoly vout1.P4.pSD 0.125718f
Cred_16384 vin1.P25.GatPoly vin2.P25.GatPoly 0.00126396f
Cred_16385 vin1.P25.GatPoly vout1.$1226.Metal3 0.201171f
Cred_16386 vin1.P25.GatPoly vout1.$1292.Metal3 0.00742713f
Cred_16387 vin1.P25.GatPoly vout1.P4.pSD 0.120471f
Cred_16388 vin1.P25.GatPoly vout1.P6.nSD 0.000117007f
Cred_16389 vin1.P25.GatPoly vout1.P6.pSD 0.0032321f
Cred_16390 vin1.P26.GatPoly vin2.P26.GatPoly 0.00126396f
Cred_16391 vin1.P26.GatPoly vout1.$1226.Metal3 0.107788f
Cred_16392 vin1.P26.GatPoly vout1.$1292.Metal3 0.0921775f
Cred_16393 vin1.P26.GatPoly vout1.P4.pSD 0.00259263f
Cred_16394 vin1.P26.GatPoly vout1.P6.nSD 0.00145217f
Cred_16395 vin1.P26.GatPoly vout1.P6.pSD 0.128408f
Cred_16396 vin1.P27.GatPoly vin2.P27.GatPoly 0.00126396f
Cred_16397 vin1.P27.GatPoly vout1.$1226.Metal3 0.096316f
Cred_16398 vin1.P27.GatPoly vout1.$1292.Metal3 0.112912f
Cred_16399 vin1.P27.GatPoly vout1.P6.nSD 0.00151737f
Cred_16400 vin1.P27.GatPoly vout1.P6.pSD 0.134153f
Cred_16401 vin1.P27.GatPoly vout1.P8.pSD 0.00266188f
Cred_16402 vin1.P28.GatPoly vin2.P28.GatPoly 0.00126396f
Cred_16403 vin1.P28.GatPoly vout1.$1226.Metal3 0.00742713f
Cred_16404 vin1.P28.GatPoly vout1.$1292.Metal3 0.201171f
Cred_16405 vin1.P28.GatPoly vout1.P6.nSD 0.000117007f
Cred_16406 vin1.P28.GatPoly vout1.P6.pSD 0.0032321f
Cred_16407 vin1.P28.GatPoly vout1.P8.pSD 0.120471f
Cred_16408 vin1.P29.GatPoly vin2.P29.GatPoly 0.00126396f
Cred_16409 vin1.P29.GatPoly vout1.$1292.Metal3 0.20119f
Cred_16410 vin1.P29.GatPoly vout1.$1358.Metal3 0.00715313f
Cred_16411 vin1.P29.GatPoly vout1.P10.nSD 0.000112691f
Cred_16412 vin1.P29.GatPoly vout1.P10.pSD 0.00322922f
Cred_16413 vin1.P29.GatPoly vout1.P8.pSD 0.120733f
Cred_16414 vin1.P3.GatPoly vout1.$1226.Metal3 0.0368429f
Cred_16415 vin1.P3.GatPoly vout1.P0.nSD 0.000489337f
Cred_16416 vin1.P3.GatPoly vout1.P0.pSD 0.00260026f
Cred_16417 vin1.P3.GatPoly vout1.P2.nSD 0.0208402f
Cred_16418 vin1.P3.GatPoly vout1.P2.pSD 0.00290933f
Cred_16419 vin1.P3.GatPoly vout1.P4.nSD 3.18635e-05f
Cred_16420 vin1.P3.GatPoly VSS.$2526.Metal2 0.000510647f
Cred_16421 vin1.P3.GatPoly VSS.$2558.Metal2 0.000685726f
Cred_16422 vin1.P3.GatPoly VSS.$2614.Metal2 6.29324e-06f
Cred_16423 vin1.P3.GatPoly VSS.$2662.Metal2 0.00670696f
Cred_16424 vin1.P3.GatPoly VSS.$2721.Metal2 0.0114439f
Cred_16425 vin1.P3.GatPoly VSS.$2753.Metal2 0.00392052f
Cred_16426 vin1.P3.GatPoly VSS.$385.Metal1 9.06084e-05f
Cred_16427 vin1.P3.GatPoly VSS.$4511.Metal3 0.000393237f
Cred_16428 vin1.P3.GatPoly VSS.$4559.Metal3 0.00490799f
Cred_16429 vin1.P3.GatPoly VSS.$504.Metal1 0.00459092f
Cred_16430 vin1.P3.GatPoly VSS.$544.Metal1 0.01338f
Cred_16431 vin1.P3.GatPoly VSS.$564.Metal1 0.0500973f
Cred_16432 vin1.P3.GatPoly VSS.P1.pSD 1.17745e-05f
Cred_16433 vin1.P3.GatPoly VSS.P27.nSD 3.10923e-06f
Cred_16434 vin1.P3.GatPoly VSS.P29.nSD 0.00154074f
Cred_16435 vin1.P30.GatPoly vin2.P30.GatPoly 0.00126396f
Cred_16436 vin1.P30.GatPoly vout1.$1292.Metal3 0.107309f
Cred_16437 vin1.P30.GatPoly vout1.$1358.Metal3 0.0916983f
Cred_16438 vin1.P30.GatPoly vout1.P10.nSD 0.00144462f
Cred_16439 vin1.P30.GatPoly vout1.P10.pSD 0.129374f
Cred_16440 vin1.P30.GatPoly vout1.P8.pSD 0.00259263f
Cred_16441 vin1.P31.GatPoly vin2.P31.GatPoly 0.00126396f
Cred_16442 vin1.P31.GatPoly vout1.$1292.Metal3 0.0918378f
Cred_16443 vin1.P31.GatPoly vout1.$1358.Metal3 0.106867f
Cred_16444 vin1.P31.GatPoly vout1.P10.nSD 0.00144682f
Cred_16445 vin1.P31.GatPoly vout1.P10.pSD 0.129648f
Cred_16446 vin1.P31.GatPoly vout1.P12.pSD 0.00261888f
Cred_16447 vin1.P32.GatPoly vin2.P32.GatPoly 0.00126396f
Cred_16448 vin1.P32.GatPoly vout1.$1292.Metal3 0.00763443f
Cred_16449 vin1.P32.GatPoly vout1.$1358.Metal3 0.209225f
Cred_16450 vin1.P32.GatPoly vout1.P10.nSD 0.000120273f
Cred_16451 vin1.P32.GatPoly vout1.P10.pSD 0.00334719f
Cred_16452 vin1.P32.GatPoly vout1.P12.pSD 0.127294f
Cred_16453 vin1.P33.GatPoly vin2.P33.GatPoly 0.00126396f
Cred_16454 vin1.P33.GatPoly vout1.$1358.Metal3 0.200112f
Cred_16455 vin1.P33.GatPoly vout1.$1424.Metal3 0.00715313f
Cred_16456 vin1.P33.GatPoly vout1.P12.pSD 0.121811f
Cred_16457 vin1.P33.GatPoly vout1.P14.nSD 0.000112691f
Cred_16458 vin1.P33.GatPoly vout1.P14.pSD 0.00322922f
Cred_16459 vin1.P34.GatPoly vin2.P34.GatPoly 0.00126396f
Cred_16460 vin1.P34.GatPoly vout1.$1358.Metal3 0.106868f
Cred_16461 vin1.P34.GatPoly vout1.$1424.Metal3 0.0918383f
Cred_16462 vin1.P34.GatPoly vout1.P12.pSD 0.00261888f
Cred_16463 vin1.P34.GatPoly vout1.P14.nSD 0.00144683f
Cred_16464 vin1.P34.GatPoly vout1.P14.pSD 0.129647f
Cred_16465 vin1.P35.GatPoly vin2.P35.GatPoly 0.00126396f
Cred_16466 vin1.P35.GatPoly vout1.$1358.Metal3 0.0958538f
Cred_16467 vin1.P35.GatPoly vout1.$1424.Metal3 0.11184f
Cred_16468 vin1.P35.GatPoly vout1.P14.nSD 0.00151009f
Cred_16469 vin1.P35.GatPoly vout1.P14.pSD 0.135381f
Cred_16470 vin1.P35.GatPoly vout1.P16.pSD 0.00269169f
Cred_16471 vin1.P36.GatPoly vin2.P36.GatPoly 0.00126396f
Cred_16472 vin1.P36.GatPoly vout1.$1358.Metal3 0.00715313f
Cred_16473 vin1.P36.GatPoly vout1.$1424.Metal3 0.200603f
Cred_16474 vin1.P36.GatPoly vout1.P14.nSD 0.000112691f
Cred_16475 vin1.P36.GatPoly vout1.P14.pSD 0.00322922f
Cred_16476 vin1.P36.GatPoly vout1.P16.pSD 0.122248f
Cred_16477 vin1.P37.GatPoly vin2.P37.GatPoly 0.00126396f
Cred_16478 vin1.P37.GatPoly vout1 0.0022934f
Cred_16479 vin1.P37.GatPoly vout1.$1424.Metal3 0.204525f
Cred_16480 vin1.P37.GatPoly vout1.P16.pSD 0.121811f
Cred_16481 vin1.P37.GatPoly vout1.P18.nSD 0.000182223f
Cred_16482 vin1.P37.GatPoly vout1.P18.pSD 0.00360581f
Cred_16483 vin1.P38.GatPoly vin2.P38.GatPoly 0.00126396f
Cred_16484 vin1.P38.GatPoly vout1 0.0298642f
Cred_16485 vin1.P38.GatPoly vout1.$1424.Metal3 0.165649f
Cred_16486 vin1.P38.GatPoly vout1.P16.pSD 0.00261888f
Cred_16487 vin1.P38.GatPoly vout1.P18.nSD 0.00237287f
Cred_16488 vin1.P38.GatPoly vout1.P18.pSD 0.13649f
Cred_16489 vin1.P39.GatPoly vin2.P39.GatPoly 0.00126396f
Cred_16490 vin1.P39.GatPoly vout1 0.0348568f
Cred_16491 vin1.P39.GatPoly vout1.$1424.Metal3 0.175799f
Cred_16492 vin1.P39.GatPoly vout1.P18.nSD 0.00276955f
Cred_16493 vin1.P39.GatPoly vout1.P18.pSD 0.155155f
Cred_16494 vin1.P39.GatPoly VSS.$4134.Metal2 0.000431311f
Cred_16495 vin1.P4.GatPoly vout1.$1226.Metal3 0.0471178f
Cred_16496 vin1.P4.GatPoly vout1.P0.nSD 4.53065e-05f
Cred_16497 vin1.P4.GatPoly vout1.P0.pSD 0.000240751f
Cred_16498 vin1.P4.GatPoly vout1.P2.nSD 8.75338e-05f
Cred_16499 vin1.P4.GatPoly vout1.P2.pSD 0.000269368f
Cred_16500 vin1.P4.GatPoly vout1.P4.nSD 0.0222123f
Cred_16501 vin1.P4.GatPoly VSS.$1989.Metal1 2.93716e-07f
Cred_16502 vin1.P4.GatPoly VSS.$2020.Metal1 7.35405e-07f
Cred_16503 vin1.P4.GatPoly VSS.$2721.Metal2 0.00948282f
Cred_16504 vin1.P4.GatPoly VSS.$2753.Metal2 0.00616224f
Cred_16505 vin1.P4.GatPoly VSS.$2777.Metal2 0.00676466f
Cred_16506 vin1.P4.GatPoly VSS.$2825.Metal2 0.00100845f
Cred_16507 vin1.P4.GatPoly VSS.$29.Metal1 5.00449e-05f
Cred_16508 vin1.P4.GatPoly VSS.$2908.Metal2 0.00114923f
Cred_16509 vin1.P4.GatPoly VSS.$2940.Metal2 4.36418e-05f
Cred_16510 vin1.P4.GatPoly VSS.$4227.Metal2 1.96889e-09f
Cred_16511 vin1.P4.GatPoly VSS.$4559.Metal3 0.00154919f
Cred_16512 vin1.P4.GatPoly VSS.$4607.Metal3 0.00341116f
Cred_16513 vin1.P4.GatPoly VSS.$564.Metal1 0.0570885f
Cred_16514 vin1.P4.GatPoly VSS.$663.Metal1 0.0129289f
Cred_16515 vin1.P4.GatPoly VSS.$774.Metal1 9.66851e-05f
Cred_16516 vin1.P4.GatPoly VSS.P1.pSD 0.000978975f
Cred_16517 vin1.P4.GatPoly VSS.P29.nSD 0.00158988f
Cred_16518 vin1.P4.GatPoly VSS.P31.nSD 5.29002e-07f
Cred_16519 vin1.P5.GatPoly vout1.$1226.Metal3 0.0417431f
Cred_16520 vin1.P5.GatPoly vout1.$1292.Metal3 0.00145233f
Cred_16521 vin1.P5.GatPoly vout1.P4.nSD 0.0202828f
Cred_16522 vin1.P5.GatPoly vout1.P6.nSD 5.47436e-05f
Cred_16523 vin1.P5.GatPoly vout1.P6.pSD 0.000125045f
Cred_16524 vin1.P5.GatPoly VSS.$2721.Metal2 0.000831872f
Cred_16525 vin1.P5.GatPoly VSS.$2753.Metal2 0.000364856f
Cred_16526 vin1.P5.GatPoly VSS.$2825.Metal2 4.30156e-05f
Cred_16527 vin1.P5.GatPoly VSS.$2849.Metal2 0.00751382f
Cred_16528 vin1.P5.GatPoly VSS.$2908.Metal2 0.0113716f
Cred_16529 vin1.P5.GatPoly VSS.$2940.Metal2 0.000358966f
Cred_16530 vin1.P5.GatPoly VSS.$4607.Metal3 0.000848036f
Cred_16531 vin1.P5.GatPoly VSS.$4643.Metal3 0.00443521f
Cred_16532 vin1.P5.GatPoly VSS.$564.Metal1 9.02649e-05f
Cred_16533 vin1.P5.GatPoly VSS.$663.Metal1 0.00433478f
Cred_16534 vin1.P5.GatPoly VSS.$731.Metal1 0.0154523f
Cred_16535 vin1.P5.GatPoly VSS.$774.Metal1 0.0521114f
Cred_16536 vin1.P5.GatPoly VSS.P1.pSD 2.14021e-05f
Cred_16537 vin1.P5.GatPoly VSS.P29.nSD 3.09744e-06f
Cred_16538 vin1.P5.GatPoly VSS.P31.nSD 0.000208376f
Cred_16539 vin1.P6.GatPoly vout1.$1226.Metal3 0.0236713f
Cred_16540 vin1.P6.GatPoly vout1.$1292.Metal3 0.0201949f
Cred_16541 vin1.P6.GatPoly vout1.P4.nSD 3.58385e-05f
Cred_16542 vin1.P6.GatPoly vout1.P6.nSD 0.0216827f
Cred_16543 vin1.P6.GatPoly vout1.P6.pSD 0.00173877f
Cred_16544 vin1.P6.GatPoly VSS.$1989.Metal1 2.68027e-07f
Cred_16545 vin1.P6.GatPoly VSS.$2020.Metal1 6.71086e-07f
Cred_16546 vin1.P6.GatPoly VSS.$29.Metal1 9.811e-06f
Cred_16547 vin1.P6.GatPoly VSS.$2908.Metal2 0.00985657f
Cred_16548 vin1.P6.GatPoly VSS.$2940.Metal2 0.00668692f
Cred_16549 vin1.P6.GatPoly VSS.$2988.Metal2 0.00281966f
Cred_16550 vin1.P6.GatPoly VSS.$3060.Metal2 0.000277376f
Cred_16551 vin1.P6.GatPoly VSS.$3095.Metal2 0.00091972f
Cred_16552 vin1.P6.GatPoly VSS.$4227.Metal2 1.79669e-09f
Cred_16553 vin1.P6.GatPoly VSS.$4643.Metal3 0.000775961f
Cred_16554 vin1.P6.GatPoly VSS.$4679.Metal3 0.00440933f
Cred_16555 vin1.P6.GatPoly VSS.$762.Metal1 0.00436754f
Cred_16556 vin1.P6.GatPoly VSS.$774.Metal1 0.0526177f
Cred_16557 vin1.P6.GatPoly VSS.$822.Metal1 0.0148789f
Cred_16558 vin1.P6.GatPoly VSS.$870.Metal1 0.00118965f
Cred_16559 vin1.P6.GatPoly VSS.$922.Metal1 8.99087e-05f
Cred_16560 vin1.P6.GatPoly VSS.P1.pSD 0.000426217f
Cred_16561 vin1.P6.GatPoly VSS.P31.nSD 0.00021155f
Cred_16562 vin1.P6.GatPoly VSS.P33.nSD 3.08522e-06f
Cred_16563 vin1.P7.GatPoly vout1.$1226.Metal3 0.0202598f
Cred_16564 vin1.P7.GatPoly vout1.$1292.Metal3 0.0238867f
Cred_16565 vin1.P7.GatPoly vout1.P6.nSD 0.0215228f
Cred_16566 vin1.P7.GatPoly vout1.P6.pSD 0.00174436f
Cred_16567 vin1.P7.GatPoly vout1.P8.nSD 3.7248e-05f
Cred_16568 vin1.P7.GatPoly VSS.$1989.Metal1 3.53847e-07f
Cred_16569 vin1.P7.GatPoly VSS.$2020.Metal1 8.85961e-07f
Cred_16570 vin1.P7.GatPoly VSS.$29.Metal1 8.21205e-06f
Cred_16571 vin1.P7.GatPoly VSS.$2908.Metal2 0.00114923f
Cred_16572 vin1.P7.GatPoly VSS.$2940.Metal2 4.36418e-05f
Cred_16573 vin1.P7.GatPoly VSS.$2988.Metal2 0.00122955f
Cred_16574 vin1.P7.GatPoly VSS.$3036.Metal2 0.00699176f
Cred_16575 vin1.P7.GatPoly VSS.$3060.Metal2 0.00554893f
Cred_16576 vin1.P7.GatPoly VSS.$3095.Metal2 0.0103462f
Cred_16577 vin1.P7.GatPoly VSS.$4227.Metal2 2.37198e-09f
Cred_16578 vin1.P7.GatPoly VSS.$4703.Metal3 0.00336824f
Cred_16579 vin1.P7.GatPoly VSS.$4751.Metal3 0.00162593f
Cred_16580 vin1.P7.GatPoly VSS.$774.Metal1 9.66851e-05f
Cred_16581 vin1.P7.GatPoly VSS.$870.Metal1 0.0126797f
Cred_16582 vin1.P7.GatPoly VSS.$922.Metal1 0.0564481f
Cred_16583 vin1.P7.GatPoly VSS.P1.pSD 0.000465775f
Cred_16584 vin1.P7.GatPoly VSS.P31.nSD 5.29002e-07f
Cred_16585 vin1.P7.GatPoly VSS.P33.nSD 0.00155756f
Cred_16586 vin1.P8.GatPoly vout1.$1226.Metal3 0.00164772f
Cred_16587 vin1.P8.GatPoly vout1.$1292.Metal3 0.0439192f
Cred_16588 vin1.P8.GatPoly vout1.P6.nSD 6.16726e-05f
Cred_16589 vin1.P8.GatPoly vout1.P6.pSD 0.000141868f
Cred_16590 vin1.P8.GatPoly vout1.P8.nSD 0.0212328f
Cred_16591 vin1.P8.GatPoly VSS 9.06646e-05f
Cred_16592 vin1.P8.GatPoly VSS.$1029.Metal1 0.00413997f
Cred_16593 vin1.P8.GatPoly VSS.$3060.Metal2 0.00308089f
Cred_16594 vin1.P8.GatPoly VSS.$3095.Metal2 0.01257f
Cred_16595 vin1.P8.GatPoly VSS.$3151.Metal2 0.00692018f
Cred_16596 vin1.P8.GatPoly VSS.$3199.Metal2 7.37632e-06f
Cred_16597 vin1.P8.GatPoly VSS.$3250.Metal2 0.000598157f
Cred_16598 vin1.P8.GatPoly VSS.$3282.Metal2 0.000598157f
Cred_16599 vin1.P8.GatPoly VSS.$4751.Metal3 0.00482079f
Cred_16600 vin1.P8.GatPoly VSS.$4799.Metal3 0.000460914f
Cred_16601 vin1.P8.GatPoly VSS.$922.Metal1 0.0493503f
Cred_16602 vin1.P8.GatPoly VSS.$981.Metal1 0.0140247f
Cred_16603 vin1.P8.GatPoly VSS.P1.pSD 9.05855e-06f
Cred_16604 vin1.P8.GatPoly VSS.P33.nSD 0.00155611f
Cred_16605 vin1.P8.GatPoly VSS.P35.nSD 3.11116e-06f
Cred_16606 vin1.P9.GatPoly vout1.$1292.Metal3 0.0441732f
Cred_16607 vin1.P9.GatPoly vout1.$1358.Metal3 0.00170886f
Cred_16608 vin1.P9.GatPoly vout1.P10.nSD 6.38285e-05f
Cred_16609 vin1.P9.GatPoly vout1.P10.pSD 0.000145809f
Cred_16610 vin1.P9.GatPoly vout1.P8.nSD 0.0211729f
Cred_16611 vin1.P9.GatPoly VSS 0.0529426f
Cred_16612 vin1.P9.GatPoly VSS.$1029.Metal1 0.00331295f
Cred_16613 vin1.P9.GatPoly VSS.$1069.Metal1 0.0142989f
Cred_16614 vin1.P9.GatPoly VSS.$1989.Metal1 5.99462e-07f
Cred_16615 vin1.P9.GatPoly VSS.$2020.Metal1 1.50093e-06f
Cred_16616 vin1.P9.GatPoly VSS.$29.Metal1 3.55239e-06f
Cred_16617 vin1.P9.GatPoly VSS.$3060.Metal2 0.000277376f
Cred_16618 vin1.P9.GatPoly VSS.$3095.Metal2 0.00091972f
Cred_16619 vin1.P9.GatPoly VSS.$3199.Metal2 0.00597574f
Cred_16620 vin1.P9.GatPoly VSS.$3250.Metal2 0.00961857f
Cred_16621 vin1.P9.GatPoly VSS.$3282.Metal2 0.00679611f
Cred_16622 vin1.P9.GatPoly VSS.$4227.Metal2 4.01844e-09f
Cred_16623 vin1.P9.GatPoly VSS.$4799.Metal3 0.00390769f
Cred_16624 vin1.P9.GatPoly VSS.$922.Metal1 8.99087e-05f
Cred_16625 vin1.P9.GatPoly VSS.P1.pSD 0.000386181f
Cred_16626 vin1.P9.GatPoly VSS.P33.nSD 3.08522e-06f
Cred_16627 vin1.P9.GatPoly VSS.P35.nSD 0.0016329f
Cred_16628 vin2 VSS 0.0870178f
Cred_16629 vin2 VSS.$1990.Metal1 3.91856e-07f
Cred_16630 vin2 VSS.$4355.Metal3 3.24897e-05f
Cred_16631 vin2 VSS.$4358.Metal3 0.0319254f
Cred_16632 vin2 VSS.$4364.Metal3 2.19882e-06f
Cred_16633 vin2 VSS.$68.Metal1 0.00149719f
Cred_16634 vin2 VSS.P3.pSD 0.00316344f
Cred_16635 vin2.$101.GatPoly vout2.$1292.Metal3 0.00339251f
Cred_16636 vin2.$101.GatPoly vout2.$1358.Metal3 0.00273512f
Cred_16637 vin2.$101.GatPoly vout2.P10.nSD 0.00364314f
Cred_16638 vin2.$101.GatPoly vout2.P10.pSD 0.000233375f
Cred_16639 vin2.$101.GatPoly vout2.P8.nSD 6.16427e-06f
Cred_16640 vin2.$101.GatPoly VSS 0.00190293f
Cred_16641 vin2.$101.GatPoly VSS.$1160.Metal1 1.98943e-06f
Cred_16642 vin2.$101.GatPoly VSS.$1180.Metal1 8.41882e-06f
Cred_16643 vin2.$101.GatPoly VSS.$1990.Metal1 2.59089e-05f
Cred_16644 vin2.$101.GatPoly VSS.$3260.Metal2 0.000400767f
Cred_16645 vin2.$101.GatPoly VSS.$3292.Metal2 0.000400807f
Cred_16646 vin2.$101.GatPoly VSS.$3344.Metal2 4.08818e-08f
Cred_16647 vin2.$101.GatPoly VSS.$4838.Metal3 3.27781e-10f
Cred_16648 vin2.$101.GatPoly VSS.$68.Metal1 1.55494e-05f
Cred_16649 vin2.$101.GatPoly VSS.P3.pSD 0.00365306f
Cred_16650 vin2.$101.GatPoly VSS.P59.nSD 3.02284e-08f
Cred_16651 vin2.$101.GatPoly VSS.P83.nSD 7.11848e-05f
Cred_16652 vin2.$104.GatPoly vout2.$1292.Metal3 0.00513649f
Cred_16653 vin2.$104.GatPoly vout2.$1358.Metal3 0.00513649f
Cred_16654 vin2.$104.GatPoly vout2.P10.nSD 8.09205e-05f
Cred_16655 vin2.$104.GatPoly vout2.P10.pSD 0.00990689f
Cred_16656 vin2.$106.GatPoly vout2.$1292.Metal3 0.0244564f
Cred_16657 vin2.$106.GatPoly vout2.$1358.Metal3 0.0304463f
Cred_16658 vin2.$106.GatPoly vout2.P10.nSD 0.000385287f
Cred_16659 vin2.$106.GatPoly vout2.P10.pSD 0.0348187f
Cred_16660 vin2.$106.GatPoly vout2.P12.pSD 0.000455774f
Cred_16661 vin2.$109.GatPoly vout2.$1292.Metal3 0.00227997f
Cred_16662 vin2.$109.GatPoly vout2.$1358.Metal3 0.00269886f
Cred_16663 vin2.$109.GatPoly vout2.P10.nSD 0.00325776f
Cred_16664 vin2.$109.GatPoly vout2.P10.pSD 0.000194539f
Cred_16665 vin2.$109.GatPoly vout2.P12.nSD 3.92785e-06f
Cred_16666 vin2.$109.GatPoly VSS.$1220.Metal1 5.3362e-07f
Cred_16667 vin2.$109.GatPoly VSS.$1260.Metal1 1.40225e-06f
Cred_16668 vin2.$109.GatPoly VSS.$1266.Metal1 0.0011921f
Cred_16669 vin2.$109.GatPoly VSS.$1990.Metal1 2.71498e-05f
Cred_16670 vin2.$109.GatPoly VSS.$3392.Metal2 2.98926e-09f
Cred_16671 vin2.$109.GatPoly VSS.$3435.Metal2 0.00051197f
Cred_16672 vin2.$109.GatPoly VSS.$68.Metal1 1.15399e-05f
Cred_16673 vin2.$109.GatPoly VSS.P2.pSD 3.2645e-10f
Cred_16674 vin2.$109.GatPoly VSS.P3.pSD 0.00322508f
Cred_16675 vin2.$109.GatPoly VSS.P85.nSD 4.46145e-05f
Cred_16676 vin2.$11.GatPoly vout2.$1226.Metal3 0.000720713f
Cred_16677 vin2.$11.GatPoly vout2.P0.nSD 0.000271067f
Cred_16678 vin2.$11.GatPoly vout2.P0.pSD 9.49465e-05f
Cred_16679 vin2.$11.GatPoly vout2.P2.nSD 1.39824e-05f
Cred_16680 vin2.$11.GatPoly vout2.P2.pSD 6.2053e-05f
Cred_16681 vin2.$11.GatPoly VSS.$1990.Metal1 8.89032e-07f
Cred_16682 vin2.$11.GatPoly VSS.$2481.Metal2 1.82758e-08f
Cred_16683 vin2.$11.GatPoly VSS.$2532.Metal2 0.000233712f
Cred_16684 vin2.$11.GatPoly VSS.$2564.Metal2 0.000313817f
Cred_16685 vin2.$11.GatPoly VSS.$360.Metal1 1.09756e-10f
Cred_16686 vin2.$11.GatPoly VSS.$380.Metal1 6.05005e-06f
Cred_16687 vin2.$11.GatPoly VSS.$386.Metal1 0.00893957f
Cred_16688 vin2.$11.GatPoly VSS.$4478.Metal3 1.46531e-10f
Cred_16689 vin2.$11.GatPoly VSS.$68.Metal1 0.000275324f
Cred_16690 vin2.$11.GatPoly VSS.P3.pSD 0.00262512f
Cred_16691 vin2.$11.GatPoly VSS.P51.nSD 2.02062e-08f
Cred_16692 vin2.$11.GatPoly VSS.P75.nSD 0.000232946f
Cred_16693 vin2.$111.GatPoly vout2.$1292.Metal3 0.00115252f
Cred_16694 vin2.$111.GatPoly vout2.$1358.Metal3 0.00175093f
Cred_16695 vin2.$111.GatPoly vout2.P10.nSD 0.00102547f
Cred_16696 vin2.$111.GatPoly vout2.P10.pSD 9.83392e-05f
Cred_16697 vin2.$111.GatPoly vout2.P12.nSD 5.61121e-06f
Cred_16698 vin2.$111.GatPoly VSS.$1220.Metal1 2.6329e-07f
Cred_16699 vin2.$111.GatPoly VSS.$1260.Metal1 1.29476e-05f
Cred_16700 vin2.$111.GatPoly VSS.$1266.Metal1 0.00746252f
Cred_16701 vin2.$111.GatPoly VSS.$1990.Metal1 2.9206e-05f
Cred_16702 vin2.$111.GatPoly VSS.$3392.Metal2 1.47491e-09f
Cred_16703 vin2.$111.GatPoly VSS.$3435.Metal2 0.00105531f
Cred_16704 vin2.$111.GatPoly VSS.$68.Metal1 8.70948e-06f
Cred_16705 vin2.$111.GatPoly VSS.P2.pSD 1.61072e-10f
Cred_16706 vin2.$111.GatPoly VSS.P3.pSD 0.00290496f
Cred_16707 vin2.$111.GatPoly VSS.P85.nSD 0.000201959f
Cred_16708 vin2.$114.GatPoly vout2.$1292.Metal3 0.000678878f
Cred_16709 vin2.$114.GatPoly vout2.$1358.Metal3 0.0128531f
Cred_16710 vin2.$114.GatPoly vout2.P10.nSD 1.06951e-05f
Cred_16711 vin2.$114.GatPoly vout2.P10.pSD 0.000166405f
Cred_16712 vin2.$114.GatPoly vout2.P12.pSD 0.0077353f
Cred_16713 vin2.$119.GatPoly vout2.$1292.Metal3 0.000253425f
Cred_16714 vin2.$119.GatPoly vout2.$1358.Metal3 0.00238925f
Cred_16715 vin2.$119.GatPoly vout2.P10.nSD 8.98535e-06f
Cred_16716 vin2.$119.GatPoly vout2.P10.pSD 2.16235e-05f
Cred_16717 vin2.$119.GatPoly vout2.P12.nSD 0.000861929f
Cred_16718 vin2.$119.GatPoly VSS.$1266.Metal1 0.00839157f
Cred_16719 vin2.$119.GatPoly VSS.$1339.Metal1 8.41646e-06f
Cred_16720 vin2.$119.GatPoly VSS.$1990.Metal1 4.07451e-05f
Cred_16721 vin2.$119.GatPoly VSS.$3435.Metal2 0.00102568f
Cred_16722 vin2.$119.GatPoly VSS.$3507.Metal2 6.68699e-08f
Cred_16723 vin2.$119.GatPoly VSS.$68.Metal1 8.34319e-06f
Cred_16724 vin2.$119.GatPoly VSS.P3.pSD 0.00335249f
Cred_16725 vin2.$119.GatPoly VSS.P85.nSD 0.000219307f
Cred_16726 vin2.$122.GatPoly vout2.$1292.Metal3 0.000877157f
Cred_16727 vin2.$122.GatPoly vout2.$1358.Metal3 0.0274113f
Cred_16728 vin2.$122.GatPoly vout2.P10.nSD 1.38188e-05f
Cred_16729 vin2.$122.GatPoly vout2.P10.pSD 0.000215008f
Cred_16730 vin2.$122.GatPoly vout2.P12.pSD 0.0188942f
Cred_16731 vin2.$123.GatPoly vout2.$1292.Metal3 0.000106508f
Cred_16732 vin2.$123.GatPoly vout2.$1358.Metal3 0.00905481f
Cred_16733 vin2.$123.GatPoly vout2.$1424.Metal3 2.65924e-05f
Cred_16734 vin2.$123.GatPoly vout2.P10.nSD 3.77632e-06f
Cred_16735 vin2.$123.GatPoly vout2.P10.pSD 9.08784e-06f
Cred_16736 vin2.$123.GatPoly vout2.P12.nSD 0.00591478f
Cred_16737 vin2.$123.GatPoly vout2.P14.nSD 9.42849e-07f
Cred_16738 vin2.$123.GatPoly vout2.P14.pSD 2.269e-06f
Cred_16739 vin2.$123.GatPoly VSS.$1266.Metal1 0.000634609f
Cred_16740 vin2.$123.GatPoly VSS.$1445.Metal1 0.000154764f
Cred_16741 vin2.$123.GatPoly VSS.$1990.Metal1 5.68224e-05f
Cred_16742 vin2.$123.GatPoly VSS.$3435.Metal2 0.000270194f
Cred_16743 vin2.$123.GatPoly VSS.$3603.Metal2 2.45511e-06f
Cred_16744 vin2.$123.GatPoly VSS.$3638.Metal2 6.46511e-05f
Cred_16745 vin2.$123.GatPoly VSS.$68.Metal1 7.44598e-06f
Cred_16746 vin2.$123.GatPoly VSS.P3.pSD 0.00373171f
Cred_16747 vin2.$123.GatPoly VSS.P63.nSD 3.56811e-10f
Cred_16748 vin2.$123.GatPoly VSS.P85.nSD 2.37508e-05f
Cred_16749 vin2.$123.GatPoly VSS.P87.nSD 5.79149e-06f
Cred_16750 vin2.$126.GatPoly vout2.$1358.Metal3 0.0563073f
Cred_16751 vin2.$126.GatPoly vout2.$1424.Metal3 0.00286031f
Cred_16752 vin2.$126.GatPoly vout2.P12.pSD 0.0346375f
Cred_16753 vin2.$126.GatPoly vout2.P14.nSD 4.50615e-05f
Cred_16754 vin2.$126.GatPoly vout2.P14.pSD 0.000701114f
Cred_16755 vin2.$131.GatPoly vout2.$1358.Metal3 0.00469248f
Cred_16756 vin2.$131.GatPoly vout2.$1424.Metal3 0.000411585f
Cred_16757 vin2.$131.GatPoly vout2.P12.nSD 0.00211167f
Cred_16758 vin2.$131.GatPoly vout2.P14.nSD 1.4593e-05f
Cred_16759 vin2.$131.GatPoly vout2.P14.pSD 3.51185e-05f
Cred_16760 vin2.$131.GatPoly VSS.$1407.Metal1 2.21748e-06f
Cred_16761 vin2.$131.GatPoly VSS.$1427.Metal1 8.42002e-06f
Cred_16762 vin2.$131.GatPoly VSS.$1445.Metal1 0.00550767f
Cred_16763 vin2.$131.GatPoly VSS.$1990.Metal1 6.2806e-05f
Cred_16764 vin2.$131.GatPoly VSS.$3555.Metal2 4.65484e-08f
Cred_16765 vin2.$131.GatPoly VSS.$3603.Metal2 4.55804e-05f
Cred_16766 vin2.$131.GatPoly VSS.$3638.Metal2 0.00119906f
Cred_16767 vin2.$131.GatPoly VSS.$4958.Metal3 3.73215e-10f
Cred_16768 vin2.$131.GatPoly VSS.$68.Metal1 5.32811e-06f
Cred_16769 vin2.$131.GatPoly VSS.P3.pSD 0.00330809f
Cred_16770 vin2.$131.GatPoly VSS.P63.nSD 6.61762e-09f
Cred_16771 vin2.$131.GatPoly VSS.P87.nSD 0.000177406f
Cred_16772 vin2.$134.GatPoly vout2.$1358.Metal3 3.10023e-08f
Cred_16773 vin2.$134.GatPoly vout2.$1424.Metal3 1.31326e-08f
Cred_16774 vin2.$134.GatPoly vout2.P12.pSD 1.16045e-09f
Cred_16775 vin2.$134.GatPoly vout2.P14.nSD 2.06892e-10f
Cred_16776 vin2.$134.GatPoly vout2.P14.pSD 2.28099e-09f
Cred_16777 vin2.$135.GatPoly VSS.$1445.Metal1 0.0122579f
Cred_16778 vin2.$135.GatPoly VSS.$1518.Metal1 7.30432e-08f
Cred_16779 vin2.$135.GatPoly VSS.$1990.Metal1 6.90504e-05f
Cred_16780 vin2.$135.GatPoly VSS.$3603.Metal2 2.05674e-05f
Cred_16781 vin2.$135.GatPoly VSS.$3638.Metal2 0.000541607f
Cred_16782 vin2.$135.GatPoly VSS.$68.Metal1 4.06971e-06f
Cred_16783 vin2.$135.GatPoly VSS.P3.pSD 0.00302483f
Cred_16784 vin2.$135.GatPoly VSS.P63.nSD 2.98914e-09f
Cred_16785 vin2.$135.GatPoly VSS.P87.nSD 0.000241435f
Cred_16786 vin2.$136.GatPoly vout2.$1358.Metal3 0.031535f
Cred_16787 vin2.$136.GatPoly vout2.$1424.Metal3 0.0255253f
Cred_16788 vin2.$136.GatPoly vout2.P12.pSD 0.000457058f
Cred_16789 vin2.$136.GatPoly vout2.P14.nSD 0.000402127f
Cred_16790 vin2.$136.GatPoly vout2.P14.pSD 0.0365848f
Cred_16791 vin2.$137.GatPoly vout2.$1358.Metal3 0.00499409f
Cred_16792 vin2.$137.GatPoly vout2.$1424.Metal3 0.00354525f
Cred_16793 vin2.$137.GatPoly vout2.P12.nSD 1.35855e-05f
Cred_16794 vin2.$137.GatPoly vout2.P14.nSD 0.00342747f
Cred_16795 vin2.$137.GatPoly vout2.P14.pSD 0.000302499f
Cred_16796 vin2.$137.GatPoly VSS.$1445.Metal1 0.00489035f
Cred_16797 vin2.$137.GatPoly VSS.$1518.Metal1 9.5518e-08f
Cred_16798 vin2.$137.GatPoly VSS.$1990.Metal1 7.35294e-05f
Cred_16799 vin2.$137.GatPoly VSS.$3603.Metal2 6.6547e-05f
Cred_16800 vin2.$137.GatPoly VSS.$3638.Metal2 0.0017524f
Cred_16801 vin2.$137.GatPoly VSS.$68.Metal1 3.0959e-06f
Cred_16802 vin2.$137.GatPoly VSS.P3.pSD 0.00271121f
Cred_16803 vin2.$137.GatPoly VSS.P63.nSD 9.67155e-09f
Cred_16804 vin2.$137.GatPoly VSS.P87.nSD 0.000183077f
Cred_16805 vin2.$14.GatPoly vout2.$1226.Metal3 0.0508176f
Cred_16806 vin2.$14.GatPoly vout2.P0.nSD 0.000803016f
Cred_16807 vin2.$14.GatPoly vout2.P0.pSD 0.00487722f
Cred_16808 vin2.$14.GatPoly vout2.P2.nSD 0.000800583f
Cred_16809 vin2.$14.GatPoly vout2.P2.pSD 0.0392747f
Cred_16810 vin2.$144.GatPoly vout2.$1358.Metal3 0.00988551f
Cred_16811 vin2.$144.GatPoly vout2.$1424.Metal3 0.0110746f
Cred_16812 vin2.$144.GatPoly vout2.P14.nSD 0.000155737f
Cred_16813 vin2.$144.GatPoly vout2.P14.pSD 0.0161545f
Cred_16814 vin2.$144.GatPoly vout2.P16.pSD 9.04344e-05f
Cred_16815 vin2.$145.GatPoly vout2.$1358.Metal3 0.00354829f
Cred_16816 vin2.$145.GatPoly vout2.$1424.Metal3 0.00372908f
Cred_16817 vin2.$145.GatPoly vout2.P14.nSD 0.00542205f
Cred_16818 vin2.$145.GatPoly vout2.P14.pSD 0.000302758f
Cred_16819 vin2.$145.GatPoly vout2.P16.nSD 1.69521e-06f
Cred_16820 vin2.$145.GatPoly VSS.$1624.Metal1 0.000497646f
Cred_16821 vin2.$145.GatPoly VSS.$1990.Metal1 0.000131046f
Cred_16822 vin2.$145.GatPoly VSS.$3809.Metal2 0.00021693f
Cred_16823 vin2.$145.GatPoly VSS.$68.Metal1 3.88118e-06f
Cred_16824 vin2.$145.GatPoly VSS.P3.pSD 0.00403041f
Cred_16825 vin2.$145.GatPoly VSS.P89.nSD 1.86237e-05f
Cred_16826 vin2.$152.GatPoly vout2.$1358.Metal3 0.00887412f
Cred_16827 vin2.$152.GatPoly vout2.$1424.Metal3 0.0109896f
Cred_16828 vin2.$152.GatPoly vout2.P14.nSD 0.000139803f
Cred_16829 vin2.$152.GatPoly vout2.P14.pSD 0.0126694f
Cred_16830 vin2.$152.GatPoly vout2.P16.pSD 0.00016089f
Cred_16831 vin2.$153.GatPoly vout2.$1358.Metal3 0.000662949f
Cred_16832 vin2.$153.GatPoly vout2.$1424.Metal3 0.000984583f
Cred_16833 vin2.$153.GatPoly vout2.P14.nSD 0.000634338f
Cred_16834 vin2.$153.GatPoly vout2.P14.pSD 5.65662e-05f
Cred_16835 vin2.$153.GatPoly vout2.P16.nSD 3.01592e-06f
Cred_16836 vin2.$153.GatPoly VSS.$1624.Metal1 0.0124478f
Cred_16837 vin2.$153.GatPoly VSS.$1990.Metal1 0.000149461f
Cred_16838 vin2.$153.GatPoly VSS.$3809.Metal2 0.00106095f
Cred_16839 vin2.$153.GatPoly VSS.$68.Metal1 2.57994e-06f
Cred_16840 vin2.$153.GatPoly VSS.P3.pSD 0.00347315f
Cred_16841 vin2.$153.GatPoly VSS.P89.nSD 0.000321196f
Cred_16842 vin2.$156.GatPoly vout2.$1358.Metal3 0.00286031f
Cred_16843 vin2.$156.GatPoly vout2.$1424.Metal3 0.0543541f
Cred_16844 vin2.$156.GatPoly vout2.P14.nSD 4.50615e-05f
Cred_16845 vin2.$156.GatPoly vout2.P14.pSD 0.000701114f
Cred_16846 vin2.$156.GatPoly vout2.P16.pSD 0.032808f
Cred_16847 vin2.$157.GatPoly vout2.$1358.Metal3 0.000689567f
Cred_16848 vin2.$157.GatPoly vout2.$1424.Metal3 0.00807741f
Cred_16849 vin2.$157.GatPoly vout2.P14.nSD 2.4449e-05f
Cred_16850 vin2.$157.GatPoly vout2.P14.pSD 5.88374e-05f
Cred_16851 vin2.$157.GatPoly vout2.P16.nSD 0.00329167f
Cred_16852 vin2.$157.GatPoly VSS.$1624.Metal1 0.00694219f
Cred_16853 vin2.$157.GatPoly VSS.$1990.Metal1 0.000175976f
Cred_16854 vin2.$157.GatPoly VSS.$3809.Metal2 0.00189944f
Cred_16855 vin2.$157.GatPoly VSS.$68.Metal1 1.94641e-06f
Cred_16856 vin2.$157.GatPoly VSS.P3.pSD 0.00324127f
Cred_16857 vin2.$157.GatPoly VSS.P89.nSD 0.000217216f
Cred_16858 vin2.$16.GatPoly vout2.$1226.Metal3 9.75242e-08f
Cred_16859 vin2.$16.GatPoly vout2.P0.nSD 1.4123e-09f
Cred_16860 vin2.$16.GatPoly vout2.P0.pSD 7.50474e-09f
Cred_16861 vin2.$16.GatPoly vout2.P2.nSD 1.5364e-09f
Cred_16862 vin2.$16.GatPoly vout2.P2.pSD 8.39679e-09f
Cred_16863 vin2.$162.GatPoly vout2.$1424.Metal3 0.00960736f
Cred_16864 vin2.$162.GatPoly vout2.P16.pSD 0.00750068f
Cred_16865 vin2.$165.GatPoly vout2 2.45242e-05f
Cred_16866 vin2.$165.GatPoly vout2.$1424.Metal3 0.00808702f
Cred_16867 vin2.$165.GatPoly vout2.P16.nSD 0.00541437f
Cred_16868 vin2.$165.GatPoly vout2.P18.nSD 3.45556e-06f
Cred_16869 vin2.$165.GatPoly vout2.P18.pSD 1.05536e-05f
Cred_16870 vin2.$165.GatPoly VSS.$1799.Metal1 0.000453293f
Cred_16871 vin2.$165.GatPoly VSS.$1990.Metal1 0.000282136f
Cred_16872 vin2.$165.GatPoly VSS.$3988.Metal2 0.000110826f
Cred_16873 vin2.$165.GatPoly VSS.$4020.Metal2 8.25299e-05f
Cred_16874 vin2.$165.GatPoly VSS.$68.Metal1 2.10243e-06f
Cred_16875 vin2.$165.GatPoly VSS.P3.pSD 0.00422098f
Cred_16876 vin2.$165.GatPoly VSS.P67.nSD 7.13592e-09f
Cred_16877 vin2.$165.GatPoly VSS.P91.nSD 1.69563e-05f
Cred_16878 vin2.$166.GatPoly vout2 0.000917059f
Cred_16879 vin2.$166.GatPoly vout2.$1424.Metal3 0.0594151f
Cred_16880 vin2.$166.GatPoly vout2.P16.pSD 0.0353919f
Cred_16881 vin2.$166.GatPoly vout2.P18.nSD 7.28651e-05f
Cred_16882 vin2.$166.GatPoly vout2.P18.pSD 0.000851701f
Cred_16883 vin2.$17.GatPoly vout2.$1226.Metal3 0.00169532f
Cred_16884 vin2.$17.GatPoly vout2.P0.nSD 3.44551e-05f
Cred_16885 vin2.$17.GatPoly vout2.P0.pSD 0.000152976f
Cred_16886 vin2.$17.GatPoly vout2.P2.nSD 0.000738215f
Cred_16887 vin2.$17.GatPoly vout2.P2.pSD 0.000145967f
Cred_16888 vin2.$17.GatPoly VSS.$1990.Metal1 1.1465e-06f
Cred_16889 vin2.$17.GatPoly VSS.$2532.Metal2 0.0004027f
Cred_16890 vin2.$17.GatPoly VSS.$2564.Metal2 0.000540801f
Cred_16891 vin2.$17.GatPoly VSS.$2620.Metal2 3.32646e-08f
Cred_16892 vin2.$17.GatPoly VSS.$386.Metal1 0.00954445f
Cred_16893 vin2.$17.GatPoly VSS.$451.Metal1 3.52716e-11f
Cred_16894 vin2.$17.GatPoly VSS.$4514.Metal3 2.66709e-10f
Cred_16895 vin2.$17.GatPoly VSS.$471.Metal1 1.71316e-06f
Cred_16896 vin2.$17.GatPoly VSS.$68.Metal1 0.000253576f
Cred_16897 vin2.$17.GatPoly VSS.P3.pSD 0.00290175f
Cred_16898 vin2.$17.GatPoly VSS.P51.nSD 3.48193e-08f
Cred_16899 vin2.$17.GatPoly VSS.P75.nSD 0.000255633f
Cred_16900 vin2.$172.GatPoly vout2.$1424.Metal3 1.16374e-07f
Cred_16901 vin2.$173.GatPoly vout2 5.48779e-05f
Cred_16902 vin2.$173.GatPoly vout2.$1424.Metal3 0.0019692f
Cred_16903 vin2.$173.GatPoly vout2.P16.nSD 0.000711506f
Cred_16904 vin2.$173.GatPoly vout2.P18.nSD 7.73254e-06f
Cred_16905 vin2.$173.GatPoly vout2.P18.pSD 2.36159e-05f
Cred_16906 vin2.$173.GatPoly VSS.$1773.Metal1 1.71316e-06f
Cred_16907 vin2.$173.GatPoly VSS.$1793.Metal1 3.52716e-11f
Cred_16908 vin2.$173.GatPoly VSS.$1799.Metal1 0.0099594f
Cred_16909 vin2.$173.GatPoly VSS.$1990.Metal1 0.000253576f
Cred_16910 vin2.$173.GatPoly VSS.$3929.Metal2 3.32646e-08f
Cred_16911 vin2.$173.GatPoly VSS.$3988.Metal2 0.000562129f
Cred_16912 vin2.$173.GatPoly VSS.$4020.Metal2 0.000418582f
Cred_16913 vin2.$173.GatPoly VSS.$5126.Metal3 2.66709e-10f
Cred_16914 vin2.$173.GatPoly VSS.$68.Metal1 1.1465e-06f
Cred_16915 vin2.$173.GatPoly VSS.P3.pSD 0.00290175f
Cred_16916 vin2.$173.GatPoly VSS.P67.nSD 3.61925e-08f
Cred_16917 vin2.$173.GatPoly VSS.P91.nSD 0.000271194f
Cred_16918 vin2.$177.GatPoly vout2 9.62364e-05f
Cred_16919 vin2.$177.GatPoly vout2.$1424.Metal3 0.000765661f
Cred_16920 vin2.$177.GatPoly vout2.P16.nSD 2.62829e-06f
Cred_16921 vin2.$177.GatPoly vout2.P18.nSD 0.000256822f
Cred_16922 vin2.$177.GatPoly vout2.P18.pSD 4.14139e-05f
Cred_16923 vin2.$177.GatPoly VSS.$1799.Metal1 0.00893957f
Cred_16924 vin2.$177.GatPoly VSS.$1864.Metal1 6.05005e-06f
Cred_16925 vin2.$177.GatPoly VSS.$1884.Metal1 1.09756e-10f
Cred_16926 vin2.$177.GatPoly VSS.$1990.Metal1 0.000275324f
Cred_16927 vin2.$177.GatPoly VSS.$3988.Metal2 0.000313817f
Cred_16928 vin2.$177.GatPoly VSS.$4020.Metal2 0.000233712f
Cred_16929 vin2.$177.GatPoly VSS.$4068.Metal2 1.82758e-08f
Cred_16930 vin2.$177.GatPoly VSS.$5162.Metal3 1.46531e-10f
Cred_16931 vin2.$177.GatPoly VSS.$68.Metal1 8.89032e-07f
Cred_16932 vin2.$177.GatPoly VSS.P3.pSD 0.00262512f
Cred_16933 vin2.$177.GatPoly VSS.P67.nSD 2.02062e-08f
Cred_16934 vin2.$177.GatPoly VSS.P91.nSD 0.000232946f
Cred_16935 vin2.$178.GatPoly vout2 0.00802799f
Cred_16936 vin2.$178.GatPoly vout2.$1424.Metal3 0.0455281f
Cred_16937 vin2.$178.GatPoly vout2.P16.pSD 0.000356917f
Cred_16938 vin2.$178.GatPoly vout2.P18.nSD 0.000637866f
Cred_16939 vin2.$178.GatPoly vout2.P18.pSD 0.038301f
Cred_16940 vin2.$178.GatPoly VSS.$4140.Metal2 0.000109957f
Cred_16941 vin2.$181.GatPoly vout2 0.00145572f
Cred_16942 vin2.$181.GatPoly vout2.$1424.Metal3 0.00762217f
Cred_16943 vin2.$181.GatPoly vout2.P16.nSD 2.62829e-06f
Cred_16944 vin2.$181.GatPoly vout2.P18.nSD 0.00567457f
Cred_16945 vin2.$181.GatPoly vout2.P18.pSD 0.000626446f
Cred_16946 vin2.$181.GatPoly VSS.$1799.Metal1 0.00053061f
Cred_16947 vin2.$181.GatPoly VSS.$1952.Metal1 4.55324e-05f
Cred_16948 vin2.$181.GatPoly VSS.$1990.Metal1 0.000694416f
Cred_16949 vin2.$181.GatPoly VSS.$2021.Metal1 0.000217891f
Cred_16950 vin2.$181.GatPoly VSS.$3988.Metal2 2.72725e-05f
Cred_16951 vin2.$181.GatPoly VSS.$4020.Metal2 2.03093e-05f
Cred_16952 vin2.$181.GatPoly VSS.$4116.Metal2 1.85091e-06f
Cred_16953 vin2.$181.GatPoly VSS.$4164.Metal2 5.37076e-06f
Cred_16954 vin2.$181.GatPoly VSS.$68.Metal1 1.31914e-06f
Cred_16955 vin2.$181.GatPoly VSS.P3.pSD 0.00488626f
Cred_16956 vin2.$181.GatPoly VSS.P67.nSD 1.75604e-09f
Cred_16957 vin2.$181.GatPoly VSS.P7.GatPoly 0.000406711f
Cred_16958 vin2.$181.GatPoly VSS.P91.nSD 1.98985e-05f
Cred_16959 vin2.$181.GatPoly VSS.P93.nSD 1.50481e-06f
Cred_16960 vin2.$181.GatPoly VSS.P95.nSD 1.50481e-06f
Cred_16961 vin2.$202.Metal1 vout2.$1226.Metal3 0.0620165f
Cred_16962 vin2.$202.Metal1 vout2.P0.nSD 0.00184666f
Cred_16963 vin2.$202.Metal1 vout2.P0.pSD 0.0676967f
Cred_16964 vin2.$202.Metal1 vout2.P2.nSD 0.000977012f
Cred_16965 vin2.$202.Metal1 vout2.P2.pSD 0.00533959f
Cred_16966 vin2.$202.Metal1 VSS.$1990.Metal1 1.89417e-07f
Cred_16967 vin2.$202.Metal1 VSS.$2409.Metal2 1.07689e-05f
Cred_16968 vin2.$202.Metal1 VSS.$2433.Metal2 7.89696e-06f
Cred_16969 vin2.$202.Metal1 VSS.$4358.Metal3 0.000425406f
Cred_16970 vin2.$202.Metal1 VSS.$4418.Metal3 0.00134312f
Cred_16971 vin2.$202.Metal1 VSS.$4454.Metal3 0.000984932f
Cred_16972 vin2.$202.Metal1 VSS.$68.Metal1 0.000406953f
Cred_16973 vin2.$202.Metal1 VSS.P3.pSD 0.00122929f
Cred_16974 vin2.$202.Metal1 VSS.P6.GatPoly 8.90637e-05f
Cred_16975 vin2.$203.Metal1 vout2.$1226.Metal3 0.0308519f
Cred_16976 vin2.$203.Metal1 vout2.P0.nSD 0.0281682f
Cred_16977 vin2.$203.Metal1 vout2.P0.pSD 0.00487157f
Cred_16978 vin2.$203.Metal1 vout2.P2.nSD 0.000487432f
Cred_16979 vin2.$203.Metal1 vout2.P2.pSD 0.00265633f
Cred_16980 vin2.$203.Metal1 VSS.$158.Metal1 0.000978787f
Cred_16981 vin2.$203.Metal1 VSS.$1990.Metal1 1.62678e-05f
Cred_16982 vin2.$203.Metal1 VSS.$2228.Metal2 0.00207658f
Cred_16983 vin2.$203.Metal1 VSS.$2409.Metal2 0.000119287f
Cred_16984 vin2.$203.Metal1 VSS.$2433.Metal2 0.000137017f
Cred_16985 vin2.$203.Metal1 VSS.$2481.Metal2 2.19277e-05f
Cred_16986 vin2.$203.Metal1 VSS.$2532.Metal2 0.000275531f
Cred_16987 vin2.$203.Metal1 VSS.$2564.Metal2 0.000340553f
Cred_16988 vin2.$203.Metal1 VSS.$292.Metal1 0.00125721f
Cred_16989 vin2.$203.Metal1 VSS.$360.Metal1 0.00134403f
Cred_16990 vin2.$203.Metal1 VSS.$380.Metal1 0.000508459f
Cred_16991 vin2.$203.Metal1 VSS.$386.Metal1 0.00662575f
Cred_16992 vin2.$203.Metal1 VSS.$4358.Metal3 0.000344015f
Cred_16993 vin2.$203.Metal1 VSS.$4478.Metal3 1.75812e-07f
Cred_16994 vin2.$203.Metal1 VSS.$68.Metal1 0.00870838f
Cred_16995 vin2.$203.Metal1 VSS.P3.pSD 0.0593128f
Cred_16996 vin2.$203.Metal1 VSS.P51.nSD 2.19277e-08f
Cred_16997 vin2.$203.Metal1 VSS.P6.GatPoly 0.00157389f
Cred_16998 vin2.$203.Metal1 VSS.P72.nSD 6.46858e-06f
Cred_16999 vin2.$203.Metal1 VSS.P73.nSD 6.46858e-06f
Cred_17000 vin2.$203.Metal1 VSS.P75.nSD 0.000253589f
Cred_17001 vin2.$206.Metal1 vout2.$1226.Metal3 8.52779e-06f
Cred_17002 vin2.$206.Metal1 vout2.P0.nSD 2.53931e-07f
Cred_17003 vin2.$206.Metal1 vout2.P0.pSD 1.34935e-06f
Cred_17004 vin2.$206.Metal1 vout2.P2.nSD 1.34347e-07f
Cred_17005 vin2.$206.Metal1 vout2.P2.pSD 7.34239e-07f
Cred_17006 vin2.$210.Metal1 vout2.$1226.Metal3 8.17381e-06f
Cred_17007 vin2.$210.Metal1 vout2.P0.nSD 1.1837e-07f
Cred_17008 vin2.$210.Metal1 vout2.P0.pSD 6.28996e-07f
Cred_17009 vin2.$210.Metal1 vout2.P2.nSD 1.28771e-07f
Cred_17010 vin2.$210.Metal1 vout2.P2.pSD 7.03761e-07f
Cred_17011 vin2.$211.Metal1 vout2.$1226.Metal3 1.23751e-05f
Cred_17012 vin2.$211.Metal1 vout2.P0.nSD 2.43471e-07f
Cred_17013 vin2.$211.Metal1 vout2.P0.pSD 1.29377e-06f
Cred_17014 vin2.$211.Metal1 vout2.P2.nSD 1.94958e-07f
Cred_17015 vin2.$211.Metal1 vout2.P2.pSD 1.06549e-06f
Cred_17016 vin2.$211.Metal1 VSS.$1990.Metal1 8.27046e-06f
Cred_17017 vin2.$211.Metal1 VSS.$2481.Metal2 1.53249e-06f
Cred_17018 vin2.$211.Metal1 VSS.$2532.Metal2 0.00154718f
Cred_17019 vin2.$211.Metal1 VSS.$2564.Metal2 0.00207838f
Cred_17020 vin2.$211.Metal1 VSS.$2620.Metal2 2.78802e-06f
Cred_17021 vin2.$211.Metal1 VSS.$360.Metal1 9.20339e-09f
Cred_17022 vin2.$211.Metal1 VSS.$380.Metal1 0.000507316f
Cred_17023 vin2.$211.Metal1 VSS.$386.Metal1 0.0418812f
Cred_17024 vin2.$211.Metal1 VSS.$4478.Metal3 1.22871e-08f
Cred_17025 vin2.$211.Metal1 VSS.$451.Metal1 2.95623e-09f
Cred_17026 vin2.$211.Metal1 VSS.$4514.Metal3 2.23537e-08f
Cred_17027 vin2.$211.Metal1 VSS.$471.Metal1 0.000143586f
Cred_17028 vin2.$211.Metal1 VSS.$68.Metal1 0.00215458f
Cred_17029 vin2.$211.Metal1 VSS.P3.pSD 0.022553f
Cred_17030 vin2.$211.Metal1 VSS.P51.nSD 1.33644e-07f
Cred_17031 vin2.$211.Metal1 VSS.P75.nSD 0.00156409f
Cred_17032 vin2.$218.Metal1 vout2.$1226.Metal3 0.00483512f
Cred_17033 vin2.$218.Metal1 vout2.P0.nSD 7.00202e-05f
Cred_17034 vin2.$218.Metal1 vout2.P0.pSD 0.000372076f
Cred_17035 vin2.$218.Metal1 vout2.P2.nSD 7.61729e-05f
Cred_17036 vin2.$218.Metal1 vout2.P2.pSD 0.00423958f
Cred_17037 vin2.$219.Metal1 vout2.$1226.Metal3 0.00095452f
Cred_17038 vin2.$219.Metal1 vout2.P0.nSD 1.90611e-05f
Cred_17039 vin2.$219.Metal1 vout2.P0.pSD 8.53615e-05f
Cred_17040 vin2.$219.Metal1 vout2.P2.nSD 0.000391345f
Cred_17041 vin2.$219.Metal1 vout2.P2.pSD 8.21837e-05f
Cred_17042 vin2.$219.Metal1 VSS.$1990.Metal1 7.28726e-06f
Cred_17043 vin2.$219.Metal1 VSS.$2532.Metal2 0.000371147f
Cred_17044 vin2.$219.Metal1 VSS.$2564.Metal2 0.000518159f
Cred_17045 vin2.$219.Metal1 VSS.$2620.Metal2 1.99279e-05f
Cred_17046 vin2.$219.Metal1 VSS.$386.Metal1 0.00768135f
Cred_17047 vin2.$219.Metal1 VSS.$451.Metal1 2.09529e-08f
Cred_17048 vin2.$219.Metal1 VSS.$4514.Metal3 1.58437e-07f
Cred_17049 vin2.$219.Metal1 VSS.$471.Metal1 0.00224803f
Cred_17050 vin2.$219.Metal1 VSS.$499.Metal1 2.60524e-05f
Cred_17051 vin2.$219.Metal1 VSS.$68.Metal1 0.00142191f
Cred_17052 vin2.$219.Metal1 VSS.P2.pSD 1.59284e-08f
Cred_17053 vin2.$219.Metal1 VSS.P3.pSD 0.0174256f
Cred_17054 vin2.$219.Metal1 VSS.P51.nSD 3.20911e-08f
Cred_17055 vin2.$219.Metal1 VSS.P75.nSD 0.000293209f
Cred_17056 vin2.$223.Metal1 vout2.$1226.Metal3 0.0137326f
Cred_17057 vin2.$223.Metal1 vout2.P0.nSD 0.00020121f
Cred_17058 vin2.$223.Metal1 vout2.P0.pSD 0.00106208f
Cred_17059 vin2.$223.Metal1 vout2.P2.nSD 0.0131392f
Cred_17060 vin2.$223.Metal1 vout2.P2.pSD 0.00118237f
Cred_17061 vin2.$223.Metal1 VSS.$1990.Metal1 8.47542e-06f
Cred_17062 vin2.$223.Metal1 VSS.$2532.Metal2 4.36492e-05f
Cred_17063 vin2.$223.Metal1 VSS.$2564.Metal2 5.86146e-05f
Cred_17064 vin2.$223.Metal1 VSS.$2620.Metal2 3.622e-06f
Cred_17065 vin2.$223.Metal1 VSS.$386.Metal1 0.000239742f
Cred_17066 vin2.$223.Metal1 VSS.$471.Metal1 0.000564734f
Cred_17067 vin2.$223.Metal1 VSS.$499.Metal1 0.000564468f
Cred_17068 vin2.$223.Metal1 VSS.$68.Metal1 0.00124316f
Cred_17069 vin2.$223.Metal1 VSS.P2.pSD 3.45115e-07f
Cred_17070 vin2.$223.Metal1 VSS.P3.pSD 0.0177526f
Cred_17071 vin2.$223.Metal1 VSS.P51.nSD 3.77411e-09f
Cred_17072 vin2.$223.Metal1 VSS.P75.nSD 8.96799e-06f
Cred_17073 vin2.$226.Metal1 vout2.$1226.Metal3 0.0232307f
Cred_17074 vin2.$226.Metal1 vout2.P0.nSD 0.000336417f
Cred_17075 vin2.$226.Metal1 vout2.P0.pSD 0.00178766f
Cred_17076 vin2.$226.Metal1 vout2.P2.nSD 0.000365978f
Cred_17077 vin2.$226.Metal1 vout2.P2.pSD 0.0242275f
Cred_17078 vin2.$229.Metal1 vout2.$1226.Metal3 0.0162775f
Cred_17079 vin2.$229.Metal1 vout2.P0.nSD 0.000235723f
Cred_17080 vin2.$229.Metal1 vout2.P0.pSD 0.00125259f
Cred_17081 vin2.$229.Metal1 vout2.P2.nSD 0.0156674f
Cred_17082 vin2.$229.Metal1 vout2.P2.pSD 0.00140148f
Cred_17083 vin2.$229.Metal1 VSS.$1990.Metal1 9.67646e-06f
Cred_17084 vin2.$229.Metal1 VSS.$2668.Metal2 3.39179e-05f
Cred_17085 vin2.$229.Metal1 VSS.$2711.Metal2 7.66844e-06f
Cred_17086 vin2.$229.Metal1 VSS.$2727.Metal2 9.1726e-06f
Cred_17087 vin2.$229.Metal1 VSS.$4562.Metal3 7.35439e-08f
Cred_17088 vin2.$229.Metal1 VSS.$539.Metal1 2.26786e-08f
Cred_17089 vin2.$229.Metal1 VSS.$559.Metal1 5.07568e-08f
Cred_17090 vin2.$229.Metal1 VSS.$565.Metal1 6.4622e-07f
Cred_17091 vin2.$229.Metal1 VSS.$68.Metal1 0.00111512f
Cred_17092 vin2.$229.Metal1 VSS.P3.pSD 0.0180971f
Cred_17093 vin2.$229.Metal1 VSS.P77.nSD 2.24422e-08f
Cred_17094 vin2.$23.GatPoly vout2.$1226.Metal3 0.00679724f
Cred_17095 vin2.$23.GatPoly vout2.P0.nSD 0.000102861f
Cred_17096 vin2.$23.GatPoly vout2.P0.pSD 0.000533128f
Cred_17097 vin2.$23.GatPoly vout2.P2.nSD 0.00552145f
Cred_17098 vin2.$23.GatPoly vout2.P2.pSD 0.000585239f
Cred_17099 vin2.$23.GatPoly VSS.$1990.Metal1 2.10243e-06f
Cred_17100 vin2.$23.GatPoly VSS.$2532.Metal2 8.25299e-05f
Cred_17101 vin2.$23.GatPoly VSS.$2564.Metal2 0.000110826f
Cred_17102 vin2.$23.GatPoly VSS.$386.Metal1 0.000453293f
Cred_17103 vin2.$23.GatPoly VSS.$68.Metal1 0.000282136f
Cred_17104 vin2.$23.GatPoly VSS.P3.pSD 0.00422098f
Cred_17105 vin2.$23.GatPoly VSS.P51.nSD 7.13592e-09f
Cred_17106 vin2.$23.GatPoly VSS.P75.nSD 1.69563e-05f
Cred_17107 vin2.$232.Metal1 vout2.$1226.Metal3 0.00390011f
Cred_17108 vin2.$232.Metal1 vout2.P0.nSD 5.64797e-05f
Cred_17109 vin2.$232.Metal1 vout2.P0.pSD 0.000300124f
Cred_17110 vin2.$232.Metal1 vout2.P2.nSD 6.14426e-05f
Cred_17111 vin2.$232.Metal1 vout2.P2.pSD 0.00325896f
Cred_17112 vin2.$233.Metal1 vout2.$1226.Metal3 0.00029223f
Cred_17113 vin2.$233.Metal1 vout2.P0.nSD 4.23195e-06f
Cred_17114 vin2.$233.Metal1 vout2.P0.pSD 2.24879e-05f
Cred_17115 vin2.$233.Metal1 vout2.P2.nSD 8.68776e-05f
Cred_17116 vin2.$233.Metal1 vout2.P2.pSD 2.51609e-05f
Cred_17117 vin2.$233.Metal1 VSS.$1990.Metal1 7.36444e-06f
Cred_17118 vin2.$233.Metal1 VSS.$2668.Metal2 4.04704e-05f
Cred_17119 vin2.$233.Metal1 VSS.$2711.Metal2 1.48977e-05f
Cred_17120 vin2.$233.Metal1 VSS.$2727.Metal2 1.78198e-05f
Cred_17121 vin2.$233.Metal1 VSS.$4562.Metal3 1.42875e-07f
Cred_17122 vin2.$233.Metal1 VSS.$539.Metal1 0.0014312f
Cred_17123 vin2.$233.Metal1 VSS.$559.Metal1 9.86064e-08f
Cred_17124 vin2.$233.Metal1 VSS.$565.Metal1 1.25543e-06f
Cred_17125 vin2.$233.Metal1 VSS.$68.Metal1 0.000681194f
Cred_17126 vin2.$233.Metal1 VSS.P3.pSD 0.0124221f
Cred_17127 vin2.$233.Metal1 VSS.P77.nSD 4.3599e-08f
Cred_17128 vin2.$236.Metal1 vout2.$1226.Metal3 3.55807e-05f
Cred_17129 vin2.$236.Metal1 vout2.P0.nSD 5.15264e-07f
Cred_17130 vin2.$236.Metal1 vout2.P0.pSD 2.73803e-06f
Cred_17131 vin2.$236.Metal1 vout2.P2.nSD 5.60541e-07f
Cred_17132 vin2.$236.Metal1 vout2.P2.pSD 3.06348e-06f
Cred_17133 vin2.$237.Metal1 vout2.$1226.Metal3 0.000124248f
Cred_17134 vin2.$237.Metal1 vout2.P0.nSD 1.79931e-06f
Cred_17135 vin2.$237.Metal1 vout2.P0.pSD 9.56121e-06f
Cred_17136 vin2.$237.Metal1 vout2.P2.nSD 1.26286e-05f
Cred_17137 vin2.$237.Metal1 vout2.P2.pSD 1.06977e-05f
Cred_17138 vin2.$237.Metal1 VSS.$1990.Metal1 8.1757e-06f
Cred_17139 vin2.$237.Metal1 VSS.$2668.Metal2 2.79062e-05f
Cred_17140 vin2.$237.Metal1 VSS.$2711.Metal2 0.00102085f
Cred_17141 vin2.$237.Metal1 VSS.$2727.Metal2 1.67928e-05f
Cred_17142 vin2.$237.Metal1 VSS.$4562.Metal3 1.34641e-07f
Cred_17143 vin2.$237.Metal1 VSS.$539.Metal1 4.15188e-08f
Cred_17144 vin2.$237.Metal1 VSS.$559.Metal1 9.29231e-08f
Cred_17145 vin2.$237.Metal1 VSS.$565.Metal1 0.0117446f
Cred_17146 vin2.$237.Metal1 VSS.$68.Metal1 0.000644565f
Cred_17147 vin2.$237.Metal1 VSS.P3.pSD 0.0127873f
Cred_17148 vin2.$237.Metal1 VSS.P77.nSD 0.000424771f
Cred_17149 vin2.$24.GatPoly vout2.$1226.Metal3 0.0493491f
Cred_17150 vin2.$24.GatPoly vout2.P0.nSD 0.000629834f
Cred_17151 vin2.$24.GatPoly vout2.P0.pSD 0.00334683f
Cred_17152 vin2.$24.GatPoly vout2.P2.nSD 0.000685178f
Cred_17153 vin2.$24.GatPoly vout2.P2.pSD 0.0359824f
Cred_17154 vin2.$24.GatPoly vout2.P4.pSD 0.000411545f
Cred_17155 vin2.$241.Metal1 VSS.$1990.Metal1 1.29232e-05f
Cred_17156 vin2.$241.Metal1 VSS.$2711.Metal2 0.00325318f
Cred_17157 vin2.$241.Metal1 VSS.$565.Metal1 0.0376358f
Cred_17158 vin2.$241.Metal1 VSS.$68.Metal1 0.000806279f
Cred_17159 vin2.$241.Metal1 VSS.P3.pSD 0.0180637f
Cred_17160 vin2.$241.Metal1 VSS.P77.nSD 0.00140605f
Cred_17161 vin2.$246.Metal1 vout2.$1226.Metal3 0.010864f
Cred_17162 vin2.$246.Metal1 vout2.P0.nSD 1.32332e-05f
Cred_17163 vin2.$246.Metal1 vout2.P0.pSD 7.0319e-05f
Cred_17164 vin2.$246.Metal1 vout2.P2.nSD 1.4396e-05f
Cred_17165 vin2.$246.Metal1 vout2.P2.pSD 0.000155297f
Cred_17166 vin2.$246.Metal1 vout2.P4.pSD 0.00613201f
Cred_17167 vin2.$247.Metal1 vout2.$1226.Metal3 0.000947268f
Cred_17168 vin2.$247.Metal1 vout2.P0.nSD 2.06442e-06f
Cred_17169 vin2.$247.Metal1 vout2.P0.pSD 1.097e-05f
Cred_17170 vin2.$247.Metal1 vout2.P2.nSD 3.84091e-06f
Cred_17171 vin2.$247.Metal1 vout2.P2.pSD 1.22739e-05f
Cred_17172 vin2.$247.Metal1 vout2.P4.nSD 0.00032997f
Cred_17173 vin2.$247.Metal1 VSS.$1990.Metal1 1.44564e-05f
Cred_17174 vin2.$247.Metal1 VSS.$2711.Metal2 0.00100564f
Cred_17175 vin2.$247.Metal1 VSS.$2783.Metal2 3.84172e-05f
Cred_17176 vin2.$247.Metal1 VSS.$565.Metal1 0.00938489f
Cred_17177 vin2.$247.Metal1 VSS.$638.Metal1 0.00141371f
Cred_17178 vin2.$247.Metal1 VSS.$68.Metal1 0.000708607f
Cred_17179 vin2.$247.Metal1 VSS.P3.pSD 0.0179943f
Cred_17180 vin2.$247.Metal1 VSS.P77.nSD 0.000359848f
Cred_17181 vin2.$25.GatPoly vout2.$1226.Metal3 0.00764f
Cred_17182 vin2.$25.GatPoly vout2.P0.nSD 8.96578e-05f
Cred_17183 vin2.$25.GatPoly vout2.P0.pSD 0.000476427f
Cred_17184 vin2.$25.GatPoly vout2.P2.nSD 0.0033892f
Cred_17185 vin2.$25.GatPoly vout2.P2.pSD 0.000533057f
Cred_17186 vin2.$25.GatPoly vout2.P4.nSD 1.35855e-05f
Cred_17187 vin2.$25.GatPoly VSS.$1990.Metal1 1.94641e-06f
Cred_17188 vin2.$25.GatPoly VSS.$2711.Metal2 0.00189944f
Cred_17189 vin2.$25.GatPoly VSS.$565.Metal1 0.00694219f
Cred_17190 vin2.$25.GatPoly VSS.$68.Metal1 0.000175976f
Cred_17191 vin2.$25.GatPoly VSS.P3.pSD 0.00324127f
Cred_17192 vin2.$25.GatPoly VSS.P77.nSD 0.000217216f
Cred_17193 vin2.$250.Metal1 vout2.$1226.Metal3 0.0205824f
Cred_17194 vin2.$250.Metal1 vout2.P0.nSD 7.43821e-06f
Cred_17195 vin2.$250.Metal1 vout2.P0.pSD 3.95254e-05f
Cred_17196 vin2.$250.Metal1 vout2.P2.nSD 8.09181e-06f
Cred_17197 vin2.$250.Metal1 vout2.P2.pSD 8.72905e-05f
Cred_17198 vin2.$250.Metal1 vout2.P4.pSD 0.0144287f
Cred_17199 vin2.$251.Metal1 vout2.$1226.Metal3 0.0147902f
Cred_17200 vin2.$251.Metal1 vout2.P0.nSD 1.16038e-06f
Cred_17201 vin2.$251.Metal1 vout2.P0.pSD 6.16608e-06f
Cred_17202 vin2.$251.Metal1 vout2.P2.nSD 2.15893e-06f
Cred_17203 vin2.$251.Metal1 vout2.P2.pSD 6.89901e-06f
Cred_17204 vin2.$251.Metal1 vout2.P4.nSD 0.0108783f
Cred_17205 vin2.$251.Metal1 VSS.$1990.Metal1 1.6463e-05f
Cred_17206 vin2.$251.Metal1 VSS.$2711.Metal2 0.000114732f
Cred_17207 vin2.$251.Metal1 VSS.$2783.Metal2 9.08043e-06f
Cred_17208 vin2.$251.Metal1 VSS.$565.Metal1 0.0002632f
Cred_17209 vin2.$251.Metal1 VSS.$658.Metal1 0.00137881f
Cred_17210 vin2.$251.Metal1 VSS.$68.Metal1 0.000613925f
Cred_17211 vin2.$251.Metal1 VSS.P3.pSD 0.0179545f
Cred_17212 vin2.$251.Metal1 VSS.P77.nSD 9.84987e-06f
Cred_17213 vin2.$258.Metal1 vout2.$1226.Metal3 0.0209774f
Cred_17214 vin2.$258.Metal1 vout2.P4.pSD 0.0170573f
Cred_17215 vin2.$259.Metal1 vout2.$1226.Metal3 0.0211429f
Cred_17216 vin2.$259.Metal1 vout2.P4.nSD 0.0169439f
Cred_17217 vin2.$259.Metal1 VSS.$1990.Metal1 1.80559e-05f
Cred_17218 vin2.$259.Metal1 VSS.$2855.Metal2 1.30872e-05f
Cred_17219 vin2.$259.Metal1 VSS.$2914.Metal2 1.71307e-05f
Cred_17220 vin2.$259.Metal1 VSS.$2946.Metal2 5.88414e-07f
Cred_17221 vin2.$259.Metal1 VSS.$4646.Metal3 1.31153e-08f
Cred_17222 vin2.$259.Metal1 VSS.$68.Metal1 0.000534446f
Cred_17223 vin2.$259.Metal1 VSS.$698.Metal1 0.000112647f
Cred_17224 vin2.$259.Metal1 VSS.$726.Metal1 0.000112712f
Cred_17225 vin2.$259.Metal1 VSS.$744.Metal1 1.36076e-06f
Cred_17226 vin2.$259.Metal1 VSS.$757.Metal1 1.73447e-09f
Cred_17227 vin2.$259.Metal1 VSS.P2.pSD 6.88726e-08f
Cred_17228 vin2.$259.Metal1 VSS.P3.pSD 0.0176103f
Cred_17229 vin2.$259.Metal1 VSS.P55.nSD 8.55167e-11f
Cred_17230 vin2.$259.Metal1 VSS.P79.nSD 4.71695e-08f
Cred_17231 vin2.$26.GatPoly vout2.$1226.Metal3 0.00841927f
Cred_17232 vin2.$26.GatPoly vout2.P0.nSD 0.000121924f
Cred_17233 vin2.$26.GatPoly vout2.P0.pSD 0.000647885f
Cred_17234 vin2.$26.GatPoly vout2.P2.nSD 0.000132638f
Cred_17235 vin2.$26.GatPoly vout2.P2.pSD 0.00828964f
Cred_17236 vin2.$262.Metal1 vout2.$1226.Metal3 0.00135071f
Cred_17237 vin2.$262.Metal1 vout2.P4.pSD 0.000374822f
Cred_17238 vin2.$263.Metal1 vout2.$1226.Metal3 0.000395475f
Cred_17239 vin2.$263.Metal1 vout2.P4.nSD 0.00013304f
Cred_17240 vin2.$263.Metal1 VSS.$1990.Metal1 1.44021e-05f
Cred_17241 vin2.$263.Metal1 VSS.$2855.Metal2 5.89938e-05f
Cred_17242 vin2.$263.Metal1 VSS.$2914.Metal2 7.29184e-05f
Cred_17243 vin2.$263.Metal1 VSS.$2946.Metal2 2.50625e-06f
Cred_17244 vin2.$263.Metal1 VSS.$4646.Metal3 5.54877e-08f
Cred_17245 vin2.$263.Metal1 VSS.$68.Metal1 0.000339101f
Cred_17246 vin2.$263.Metal1 VSS.$698.Metal1 0.00104152f
Cred_17247 vin2.$263.Metal1 VSS.$726.Metal1 0.00105951f
Cred_17248 vin2.$263.Metal1 VSS.$744.Metal1 1.08675e-05f
Cred_17249 vin2.$263.Metal1 VSS.$757.Metal1 7.33813e-09f
Cred_17250 vin2.$263.Metal1 VSS.P2.pSD 6.36787e-07f
Cred_17251 vin2.$263.Metal1 VSS.P3.pSD 0.0125784f
Cred_17252 vin2.$263.Metal1 VSS.P55.nSD 3.64243e-10f
Cred_17253 vin2.$263.Metal1 VSS.P79.nSD 3.91229e-07f
Cred_17254 vin2.$264.Metal1 vout2.$1226.Metal3 6.69587e-05f
Cred_17255 vin2.$264.Metal1 vout2.$1292.Metal3 1.67231e-06f
Cred_17256 vin2.$264.Metal1 vout2.P4.pSD 1.95318e-07f
Cred_17257 vin2.$264.Metal1 vout2.P6.nSD 2.63457e-08f
Cred_17258 vin2.$264.Metal1 vout2.P6.pSD 3.39303e-07f
Cred_17259 vin2.$265.Metal1 vout2.$1226.Metal3 0.000176163f
Cred_17260 vin2.$265.Metal1 vout2.P4.nSD 1.87265e-06f
Cred_17261 vin2.$265.Metal1 VSS.$1990.Metal1 2.34029e-05f
Cred_17262 vin2.$265.Metal1 VSS.$2855.Metal2 4.52076e-05f
Cred_17263 vin2.$265.Metal1 VSS.$2914.Metal2 0.00195315f
Cred_17264 vin2.$265.Metal1 VSS.$2946.Metal2 7.35122e-05f
Cred_17265 vin2.$265.Metal1 VSS.$4646.Metal3 1.38935e-07f
Cred_17266 vin2.$265.Metal1 VSS.$68.Metal1 0.000437414f
Cred_17267 vin2.$265.Metal1 VSS.$698.Metal1 1.11867e-08f
Cred_17268 vin2.$265.Metal1 VSS.$726.Metal1 0.00118678f
Cred_17269 vin2.$265.Metal1 VSS.$744.Metal1 0.0204792f
Cred_17270 vin2.$265.Metal1 VSS.$757.Metal1 1.83739e-08f
Cred_17271 vin2.$265.Metal1 VSS.P2.pSD 6.83953e-12f
Cred_17272 vin2.$265.Metal1 VSS.P3.pSD 0.0182416f
Cred_17273 vin2.$265.Metal1 VSS.P55.nSD 1.06838e-08f
Cred_17274 vin2.$265.Metal1 VSS.P79.nSD 0.000787366f
Cred_17275 vin2.$272.Metal1 vout2.$1226.Metal3 4.83458e-05f
Cred_17276 vin2.$272.Metal1 vout2.$1292.Metal3 4.46677e-05f
Cred_17277 vin2.$272.Metal1 vout2.P4.pSD 1.32775e-07f
Cred_17278 vin2.$272.Metal1 vout2.P6.nSD 7.03698e-07f
Cred_17279 vin2.$272.Metal1 vout2.P6.pSD 6.4668e-06f
Cred_17280 vin2.$273.Metal1 vout2.$1226.Metal3 1.13457e-05f
Cred_17281 vin2.$273.Metal1 vout2.$1292.Metal3 1.13457e-05f
Cred_17282 vin2.$273.Metal1 vout2.P6.nSD 2.6058e-07f
Cred_17283 vin2.$273.Metal1 vout2.P6.pSD 9.76862e-07f
Cred_17284 vin2.$273.Metal1 VSS.$1990.Metal1 3.56461e-05f
Cred_17285 vin2.$273.Metal1 VSS.$2914.Metal2 0.00292392f
Cred_17286 vin2.$273.Metal1 VSS.$2946.Metal2 0.000114936f
Cred_17287 vin2.$273.Metal1 VSS.$2994.Metal2 3.90164e-06f
Cred_17288 vin2.$273.Metal1 VSS.$4682.Metal3 3.12825e-08f
Cred_17289 vin2.$273.Metal1 VSS.$68.Metal1 0.000500311f
Cred_17290 vin2.$273.Metal1 VSS.$744.Metal1 0.0342083f
Cred_17291 vin2.$273.Metal1 VSS.$817.Metal1 0.000705757f
Cred_17292 vin2.$273.Metal1 VSS.$837.Metal1 0.000185866f
Cred_17293 vin2.$273.Metal1 VSS.P3.pSD 0.0241202f
Cred_17294 vin2.$273.Metal1 VSS.P55.nSD 1.61371e-08f
Cred_17295 vin2.$273.Metal1 VSS.P79.nSD 0.00130722f
Cred_17296 vin2.$276.Metal1 vout2.$1226.Metal3 7.03749e-05f
Cred_17297 vin2.$276.Metal1 vout2.$1292.Metal3 7.03749e-05f
Cred_17298 vin2.$276.Metal1 vout2.P6.nSD 1.10869e-06f
Cred_17299 vin2.$276.Metal1 vout2.P6.pSD 1.1191e-05f
Cred_17300 vin2.$280.Metal1 vout2.$1226.Metal3 0.00224909f
Cred_17301 vin2.$280.Metal1 vout2.$1292.Metal3 0.00224909f
Cred_17302 vin2.$280.Metal1 vout2.P6.nSD 3.54323e-05f
Cred_17303 vin2.$280.Metal1 vout2.P6.pSD 0.00227072f
Cred_17304 vin2.$281.Metal1 vout2.$1226.Metal3 0.00270877f
Cred_17305 vin2.$281.Metal1 vout2.$1292.Metal3 0.00263404f
Cred_17306 vin2.$281.Metal1 vout2.P4.nSD 7.00732e-07f
Cred_17307 vin2.$281.Metal1 vout2.P6.nSD 0.00337504f
Cred_17308 vin2.$281.Metal1 vout2.P6.pSD 0.000226789f
Cred_17309 vin2.$281.Metal1 VSS.$1990.Metal1 2.99328e-05f
Cred_17310 vin2.$281.Metal1 VSS.$2914.Metal2 0.00012428f
Cred_17311 vin2.$281.Metal1 VSS.$2946.Metal2 2.22308e-05f
Cred_17312 vin2.$281.Metal1 VSS.$2994.Metal2 1.75113e-05f
Cred_17313 vin2.$281.Metal1 VSS.$4682.Metal3 1.40402e-07f
Cred_17314 vin2.$281.Metal1 VSS.$68.Metal1 0.000317862f
Cred_17315 vin2.$281.Metal1 VSS.$744.Metal1 0.000643731f
Cred_17316 vin2.$281.Metal1 VSS.$817.Metal1 0.000705983f
Cred_17317 vin2.$281.Metal1 VSS.$837.Metal1 0.00196867f
Cred_17318 vin2.$281.Metal1 VSS.P3.pSD 0.0176779f
Cred_17319 vin2.$281.Metal1 VSS.P55.nSD 6.85902e-10f
Cred_17320 vin2.$281.Metal1 VSS.P79.nSD 2.41256e-05f
Cred_17321 vin2.$284.Metal1 vout2.$1226.Metal3 0.0116135f
Cred_17322 vin2.$284.Metal1 vout2.$1292.Metal3 0.0116135f
Cred_17323 vin2.$284.Metal1 vout2.P6.nSD 0.00018296f
Cred_17324 vin2.$284.Metal1 vout2.P6.pSD 0.0220364f
Cred_17325 vin2.$285.Metal1 vout2.$1226.Metal3 0.0115648f
Cred_17326 vin2.$285.Metal1 vout2.$1292.Metal3 0.0115353f
Cred_17327 vin2.$285.Metal1 vout2.P4.nSD 2.77091e-07f
Cred_17328 vin2.$285.Metal1 vout2.P6.nSD 0.0198603f
Cred_17329 vin2.$285.Metal1 vout2.P6.pSD 0.000993182f
Cred_17330 vin2.$285.Metal1 VSS.$1990.Metal1 3.65441e-05f
Cred_17331 vin2.$285.Metal1 VSS.$2914.Metal2 3.41933e-05f
Cred_17332 vin2.$285.Metal1 VSS.$2946.Metal2 1.29848e-06f
Cred_17333 vin2.$285.Metal1 VSS.$68.Metal1 0.000292042f
Cred_17334 vin2.$285.Metal1 VSS.$744.Metal1 8.18531e-05f
Cred_17335 vin2.$285.Metal1 VSS.P3.pSD 0.0187601f
Cred_17336 vin2.$285.Metal1 VSS.P55.nSD 1.88713e-10f
Cred_17337 vin2.$285.Metal1 VSS.P79.nSD 3.06305e-06f
Cred_17338 vin2.$290.Metal1 vout2.$1226.Metal3 0.00774494f
Cred_17339 vin2.$290.Metal1 vout2.$1292.Metal3 0.00869489f
Cred_17340 vin2.$290.Metal1 vout2.P6.nSD 0.000122014f
Cred_17341 vin2.$290.Metal1 vout2.P6.pSD 0.0112744f
Cred_17342 vin2.$290.Metal1 vout2.P8.pSD 6.67492e-05f
Cred_17343 vin2.$291.Metal1 vout2.$1226.Metal3 0.00355904f
Cred_17344 vin2.$291.Metal1 vout2.$1292.Metal3 0.00367739f
Cred_17345 vin2.$291.Metal1 vout2.P6.nSD 0.00587158f
Cred_17346 vin2.$291.Metal1 vout2.P6.pSD 0.000306431f
Cred_17347 vin2.$291.Metal1 vout2.P8.nSD 1.10981e-06f
Cred_17348 vin2.$291.Metal1 VSS.$1990.Metal1 5.48823e-05f
Cred_17349 vin2.$291.Metal1 VSS.$3042.Metal2 3.97237e-05f
Cred_17350 vin2.$291.Metal1 VSS.$3085.Metal2 0.000381446f
Cred_17351 vin2.$291.Metal1 VSS.$68.Metal1 0.000327027f
Cred_17352 vin2.$291.Metal1 VSS.$885.Metal1 0.00143116f
Cred_17353 vin2.$291.Metal1 VSS.$905.Metal1 0.000706277f
Cred_17354 vin2.$291.Metal1 VSS.$923.Metal1 0.00298934f
Cred_17355 vin2.$291.Metal1 VSS.P3.pSD 0.0243385f
Cred_17356 vin2.$291.Metal1 VSS.P81.nSD 0.000113232f
Cred_17357 vin2.$294.Metal1 vout2.$1226.Metal3 0.0030992f
Cred_17358 vin2.$294.Metal1 vout2.$1292.Metal3 0.00383442f
Cred_17359 vin2.$294.Metal1 vout2.P6.nSD 4.8825e-05f
Cred_17360 vin2.$294.Metal1 vout2.P6.pSD 0.00428749f
Cred_17361 vin2.$294.Metal1 vout2.P8.pSD 5.16607e-05f
Cred_17362 vin2.$299.Metal1 vout2.$1226.Metal3 2.6058e-05f
Cred_17363 vin2.$299.Metal1 vout2.$1292.Metal3 7.35828e-05f
Cred_17364 vin2.$299.Metal1 vout2.P6.nSD 6.43208e-07f
Cred_17365 vin2.$299.Metal1 vout2.P6.pSD 2.24358e-06f
Cred_17366 vin2.$299.Metal1 vout2.P8.nSD 2.11277e-07f
Cred_17367 vin2.$299.Metal1 VSS.$1990.Metal1 4.7721e-05f
Cred_17368 vin2.$299.Metal1 VSS.$3042.Metal2 5.60458e-06f
Cred_17369 vin2.$299.Metal1 VSS.$3085.Metal2 0.00272224f
Cred_17370 vin2.$299.Metal1 VSS.$68.Metal1 0.000215048f
Cred_17371 vin2.$299.Metal1 VSS.$905.Metal1 0.00070541f
Cred_17372 vin2.$299.Metal1 VSS.$923.Metal1 0.0303602f
Cred_17373 vin2.$299.Metal1 VSS.P3.pSD 0.0184396f
Cred_17374 vin2.$299.Metal1 VSS.P81.nSD 0.00112161f
Cred_17375 vin2.$302.Metal1 vout2.$1292.Metal3 9.34686e-06f
Cred_17376 vin2.$303.Metal1 vout2.$1226.Metal3 3.90959e-05f
Cred_17377 vin2.$303.Metal1 vout2.$1292.Metal3 0.000132079f
Cred_17378 vin2.$303.Metal1 vout2.P6.nSD 1.02929e-06f
Cred_17379 vin2.$303.Metal1 vout2.P6.pSD 3.36614e-06f
Cred_17380 vin2.$303.Metal1 vout2.P8.nSD 4.13368e-07f
Cred_17381 vin2.$303.Metal1 VSS.$1024.Metal1 2.21253e-05f
Cred_17382 vin2.$303.Metal1 VSS.$1990.Metal1 5.43242e-05f
Cred_17383 vin2.$303.Metal1 VSS.$3085.Metal2 0.00254946f
Cred_17384 vin2.$303.Metal1 VSS.$3157.Metal2 1.23942e-07f
Cred_17385 vin2.$303.Metal1 VSS.$68.Metal1 0.000184198f
Cred_17386 vin2.$303.Metal1 VSS.$923.Metal1 0.0269369f
Cred_17387 vin2.$303.Metal1 VSS.$996.Metal1 0.00124475f
Cred_17388 vin2.$303.Metal1 VSS.P2.pSD 1.35355e-08f
Cred_17389 vin2.$303.Metal1 VSS.P3.pSD 0.018226f
Cred_17390 vin2.$303.Metal1 VSS.P81.nSD 0.000994817f
Cred_17391 vin2.$306.Metal1 vout2.$1292.Metal3 0.00115034f
Cred_17392 vin2.$306.Metal1 vout2.P8.pSD 0.000166022f
Cred_17393 vin2.$311.Metal1 vout2.$1292.Metal3 0.0102729f
Cred_17394 vin2.$311.Metal1 vout2.P8.nSD 0.00819768f
Cred_17395 vin2.$311.Metal1 VSS.$1024.Metal1 0.000611238f
Cred_17396 vin2.$311.Metal1 VSS.$1990.Metal1 8.38966e-05f
Cred_17397 vin2.$311.Metal1 VSS.$3157.Metal2 3.57728e-05f
Cred_17398 vin2.$311.Metal1 VSS.$68.Metal1 0.000212409f
Cred_17399 vin2.$311.Metal1 VSS.$996.Metal1 0.00160622f
Cred_17400 vin2.$311.Metal1 VSS.P2.pSD 3.73934e-07f
Cred_17401 vin2.$311.Metal1 VSS.P3.pSD 0.0243075f
Cred_17402 vin2.$312.Metal1 vout2.$1292.Metal3 0.0169113f
Cred_17403 vin2.$312.Metal1 vout2.P8.pSD 0.0137435f
Cred_17404 vin2.$316.Metal1 vout2.$1292.Metal3 0.0161848f
Cred_17405 vin2.$316.Metal1 vout2.P8.pSD 0.0132629f
Cred_17406 vin2.$317.Metal1 vout2.$1292.Metal3 0.0227303f
Cred_17407 vin2.$317.Metal1 vout2.$1358.Metal3 2.16805e-05f
Cred_17408 vin2.$317.Metal1 vout2.P10.nSD 7.68696e-07f
Cred_17409 vin2.$317.Metal1 vout2.P10.pSD 1.84989e-06f
Cred_17410 vin2.$317.Metal1 vout2.P8.nSD 0.0184006f
Cred_17411 vin2.$317.Metal1 VSS 0.00013186f
Cred_17412 vin2.$317.Metal1 VSS.$1990.Metal1 7.28288e-05f
Cred_17413 vin2.$317.Metal1 VSS.$3260.Metal2 2.77703e-05f
Cred_17414 vin2.$317.Metal1 VSS.$3292.Metal2 2.77703e-05f
Cred_17415 vin2.$317.Metal1 VSS.$68.Metal1 0.000138364f
Cred_17416 vin2.$317.Metal1 VSS.P3.pSD 0.0182954f
Cred_17417 vin2.$317.Metal1 VSS.P59.nSD 2.09461e-09f
Cred_17418 vin2.$317.Metal1 VSS.P83.nSD 4.93259e-06f
Cred_17419 vin2.$320.Metal1 vout2.$1292.Metal3 0.00227998f
Cred_17420 vin2.$320.Metal1 vout2.P8.pSD 0.00126704f
Cred_17421 vin2.$321.Metal1 vout2.$1292.Metal3 0.00273835f
Cred_17422 vin2.$321.Metal1 vout2.$1358.Metal3 5.48276e-05f
Cred_17423 vin2.$321.Metal1 vout2.P10.nSD 1.94395e-06f
Cred_17424 vin2.$321.Metal1 vout2.P10.pSD 4.67817e-06f
Cred_17425 vin2.$321.Metal1 vout2.P8.nSD 0.00194825f
Cred_17426 vin2.$321.Metal1 VSS 0.000959551f
Cred_17427 vin2.$321.Metal1 VSS.$1064.Metal1 0.00143118f
Cred_17428 vin2.$321.Metal1 VSS.$1084.Metal1 0.00133876f
Cred_17429 vin2.$321.Metal1 VSS.$1990.Metal1 8.21087e-05f
Cred_17430 vin2.$321.Metal1 VSS.$3205.Metal2 1.46125e-05f
Cred_17431 vin2.$321.Metal1 VSS.$3260.Metal2 0.000112911f
Cred_17432 vin2.$321.Metal1 VSS.$3292.Metal2 9.82985e-05f
Cred_17433 vin2.$321.Metal1 VSS.$4802.Metal3 1.17159e-07f
Cred_17434 vin2.$321.Metal1 VSS.$68.Metal1 0.000120356f
Cred_17435 vin2.$321.Metal1 VSS.P3.pSD 0.0181112f
Cred_17436 vin2.$321.Metal1 VSS.P59.nSD 7.41432e-09f
Cred_17437 vin2.$321.Metal1 VSS.P83.nSD 3.63726e-05f
Cred_17438 vin2.$324.Metal1 vout2.$1292.Metal3 5.64036e-05f
Cred_17439 vin2.$329.Metal1 vout2.$1292.Metal3 2.78522e-05f
Cred_17440 vin2.$329.Metal1 VSS 0.0400139f
Cred_17441 vin2.$329.Metal1 VSS.$1064.Metal1 1.17605e-08f
Cred_17442 vin2.$329.Metal1 VSS.$1084.Metal1 0.00129327f
Cred_17443 vin2.$329.Metal1 VSS.$1990.Metal1 0.00012655f
Cred_17444 vin2.$329.Metal1 VSS.$3205.Metal2 7.68072e-06f
Cred_17445 vin2.$329.Metal1 VSS.$3260.Metal2 0.00178182f
Cred_17446 vin2.$329.Metal1 VSS.$3292.Metal2 0.0017721f
Cred_17447 vin2.$329.Metal1 VSS.$4802.Metal3 6.15823e-08f
Cred_17448 vin2.$329.Metal1 VSS.$68.Metal1 0.000138427f
Cred_17449 vin2.$329.Metal1 VSS.P2.pSD 1.77436e-07f
Cred_17450 vin2.$329.Metal1 VSS.P3.pSD 0.024077f
Cred_17451 vin2.$329.Metal1 VSS.P59.nSD 1.33663e-07f
Cred_17452 vin2.$329.Metal1 VSS.P83.nSD 0.00152675f
Cred_17453 vin2.$334.Metal1 vout2.$1292.Metal3 2.6845e-05f
Cred_17454 vin2.$334.Metal1 vout2.$1358.Metal3 2.6845e-05f
Cred_17455 vin2.$334.Metal1 vout2.P10.nSD 4.22919e-07f
Cred_17456 vin2.$334.Metal1 vout2.P10.pSD 2.29056e-06f
Cred_17457 vin2.$335.Metal1 vout2.$1292.Metal3 0.000712225f
Cred_17458 vin2.$335.Metal1 vout2.$1358.Metal3 0.0006218f
Cred_17459 vin2.$335.Metal1 vout2.P10.nSD 0.000867285f
Cred_17460 vin2.$335.Metal1 vout2.P10.pSD 5.30551e-05f
Cred_17461 vin2.$335.Metal1 vout2.P8.nSD 8.4791e-07f
Cred_17462 vin2.$335.Metal1 VSS 0.0139777f
Cred_17463 vin2.$335.Metal1 VSS.$1160.Metal1 0.00219787f
Cred_17464 vin2.$335.Metal1 VSS.$1180.Metal1 0.000706141f
Cred_17465 vin2.$335.Metal1 VSS.$1990.Metal1 0.000147411f
Cred_17466 vin2.$335.Metal1 VSS.$3260.Metal2 0.000670075f
Cred_17467 vin2.$335.Metal1 VSS.$3292.Metal2 0.000689058f
Cred_17468 vin2.$335.Metal1 VSS.$3344.Metal2 1.89831e-05f
Cred_17469 vin2.$335.Metal1 VSS.$4838.Metal3 1.52203e-07f
Cred_17470 vin2.$335.Metal1 VSS.$68.Metal1 0.000112932f
Cred_17471 vin2.$335.Metal1 VSS.P3.pSD 0.0234844f
Cred_17472 vin2.$335.Metal1 VSS.P59.nSD 5.05415e-08f
Cred_17473 vin2.$335.Metal1 VSS.P83.nSD 0.000539224f
Cred_17474 vin2.$338.Metal1 vout2.$1292.Metal3 0.00106876f
Cred_17475 vin2.$338.Metal1 vout2.$1358.Metal3 0.00106876f
Cred_17476 vin2.$338.Metal1 vout2.P10.nSD 1.68373e-05f
Cred_17477 vin2.$338.Metal1 vout2.P10.pSD 0.00139346f
Cred_17478 vin2.$342.Metal1 vout2.$1292.Metal3 0.00729701f
Cred_17479 vin2.$342.Metal1 vout2.$1358.Metal3 0.00729701f
Cred_17480 vin2.$342.Metal1 vout2.P10.nSD 0.000114958f
Cred_17481 vin2.$342.Metal1 vout2.P10.pSD 0.0137329f
Cred_17482 vin2.$343.Metal1 vout2.$1292.Metal3 0.0117434f
Cred_17483 vin2.$343.Metal1 vout2.$1358.Metal3 0.0117434f
Cred_17484 vin2.$343.Metal1 vout2.P10.nSD 0.0202463f
Cred_17485 vin2.$343.Metal1 vout2.P10.pSD 0.00100201f
Cred_17486 vin2.$343.Metal1 VSS.$1160.Metal1 0.000166735f
Cred_17487 vin2.$343.Metal1 VSS.$1180.Metal1 0.000705584f
Cred_17488 vin2.$343.Metal1 VSS.$1990.Metal1 0.000182647f
Cred_17489 vin2.$343.Metal1 VSS.$3292.Metal2 3.42631e-06f
Cred_17490 vin2.$343.Metal1 VSS.$3344.Metal2 3.42631e-06f
Cred_17491 vin2.$343.Metal1 VSS.$4838.Metal3 2.74714e-08f
Cred_17492 vin2.$343.Metal1 VSS.$68.Metal1 0.000100718f
Cred_17493 vin2.$343.Metal1 VSS.P3.pSD 0.0246956f
Cred_17494 vin2.$346.Metal1 vout2.$1292.Metal3 0.00779934f
Cred_17495 vin2.$346.Metal1 vout2.$1358.Metal3 0.00779934f
Cred_17496 vin2.$346.Metal1 vout2.P10.nSD 0.000122871f
Cred_17497 vin2.$346.Metal1 vout2.P10.pSD 0.0145931f
Cred_17498 vin2.$349.Metal1 vout2.$1292.Metal3 0.00528953f
Cred_17499 vin2.$349.Metal1 vout2.$1358.Metal3 0.00528953f
Cred_17500 vin2.$349.Metal1 vout2.P10.nSD 0.00896468f
Cred_17501 vin2.$349.Metal1 vout2.P10.pSD 0.00045133f
Cred_17502 vin2.$349.Metal1 VSS.$1220.Metal1 0.000611238f
Cred_17503 vin2.$349.Metal1 VSS.$1260.Metal1 0.00160622f
Cred_17504 vin2.$349.Metal1 VSS.$1990.Metal1 0.000215652f
Cred_17505 vin2.$349.Metal1 VSS.$3392.Metal2 3.57728e-05f
Cred_17506 vin2.$349.Metal1 VSS.$68.Metal1 8.54431e-05f
Cred_17507 vin2.$349.Metal1 VSS.P2.pSD 3.73934e-07f
Cred_17508 vin2.$349.Metal1 VSS.P3.pSD 0.0247161f
Cred_17509 vin2.$352.Metal1 vout2.$1292.Metal3 0.00054301f
Cred_17510 vin2.$352.Metal1 vout2.$1358.Metal3 0.00054301f
Cred_17511 vin2.$352.Metal1 vout2.P10.nSD 8.55462e-06f
Cred_17512 vin2.$352.Metal1 vout2.P10.pSD 0.000221788f
Cred_17513 vin2.$356.Metal1 vout2.$1292.Metal3 4.4486e-06f
Cred_17514 vin2.$356.Metal1 vout2.$1358.Metal3 4.4486e-06f
Cred_17515 vin2.$356.Metal1 vout2.P10.nSD 7.00835e-08f
Cred_17516 vin2.$356.Metal1 vout2.P10.pSD 3.79577e-07f
Cred_17517 vin2.$357.Metal1 vout2.$1292.Metal3 4.4255e-05f
Cred_17518 vin2.$357.Metal1 vout2.$1358.Metal3 0.000126429f
Cred_17519 vin2.$357.Metal1 vout2.P10.nSD 1.11056e-06f
Cred_17520 vin2.$357.Metal1 vout2.P10.pSD 3.77606e-06f
Cred_17521 vin2.$357.Metal1 vout2.P12.nSD 4.13368e-07f
Cred_17522 vin2.$357.Metal1 VSS.$1220.Metal1 2.21253e-05f
Cred_17523 vin2.$357.Metal1 VSS.$1260.Metal1 0.00124475f
Cred_17524 vin2.$357.Metal1 VSS.$1266.Metal1 0.0269369f
Cred_17525 vin2.$357.Metal1 VSS.$1990.Metal1 0.000184198f
Cred_17526 vin2.$357.Metal1 VSS.$3392.Metal2 1.23942e-07f
Cred_17527 vin2.$357.Metal1 VSS.$3435.Metal2 0.00254946f
Cred_17528 vin2.$357.Metal1 VSS.$68.Metal1 5.43242e-05f
Cred_17529 vin2.$357.Metal1 VSS.P2.pSD 1.35355e-08f
Cred_17530 vin2.$357.Metal1 VSS.P3.pSD 0.018226f
Cred_17531 vin2.$357.Metal1 VSS.P85.nSD 0.000994817f
Cred_17532 vin2.$36.GatPoly vout2.$1226.Metal3 0.0204022f
Cred_17533 vin2.$36.GatPoly vout2.P0.nSD 2.50207e-05f
Cred_17534 vin2.$36.GatPoly vout2.P0.pSD 0.000132956f
Cred_17535 vin2.$36.GatPoly vout2.P2.nSD 2.72193e-05f
Cred_17536 vin2.$36.GatPoly vout2.P2.pSD 0.000293629f
Cred_17537 vin2.$36.GatPoly vout2.P4.pSD 0.0115941f
Cred_17538 vin2.$361.Metal1 vout2.$1292.Metal3 2.26192e-05f
Cred_17539 vin2.$361.Metal1 vout2.$1358.Metal3 7.73893e-05f
Cred_17540 vin2.$361.Metal1 vout2.P10.nSD 5.67622e-07f
Cred_17541 vin2.$361.Metal1 vout2.P10.pSD 1.92999e-06f
Cred_17542 vin2.$361.Metal1 vout2.P12.nSD 2.32689e-07f
Cred_17543 vin2.$361.Metal1 VSS.$1266.Metal1 0.0303602f
Cred_17544 vin2.$361.Metal1 VSS.$1339.Metal1 0.00070541f
Cred_17545 vin2.$361.Metal1 VSS.$1990.Metal1 0.000215048f
Cred_17546 vin2.$361.Metal1 VSS.$3435.Metal2 0.00272224f
Cred_17547 vin2.$361.Metal1 VSS.$3507.Metal2 5.60458e-06f
Cred_17548 vin2.$361.Metal1 VSS.$68.Metal1 4.7721e-05f
Cred_17549 vin2.$361.Metal1 VSS.P3.pSD 0.0184396f
Cred_17550 vin2.$361.Metal1 VSS.P85.nSD 0.00112161f
Cred_17551 vin2.$364.Metal1 vout2.$1292.Metal3 0.000359051f
Cred_17552 vin2.$364.Metal1 vout2.$1358.Metal3 0.00682448f
Cred_17553 vin2.$364.Metal1 vout2.P10.nSD 5.65651e-06f
Cred_17554 vin2.$364.Metal1 vout2.P10.pSD 8.801e-05f
Cred_17555 vin2.$364.Metal1 vout2.P12.pSD 0.00409171f
Cred_17556 vin2.$368.Metal1 vout2.$1292.Metal3 0.000463919f
Cred_17557 vin2.$368.Metal1 vout2.$1358.Metal3 0.0164812f
Cred_17558 vin2.$368.Metal1 vout2.P10.nSD 7.30861e-06f
Cred_17559 vin2.$368.Metal1 vout2.P10.pSD 0.000113715f
Cred_17560 vin2.$368.Metal1 vout2.P12.pSD 0.0107913f
Cred_17561 vin2.$369.Metal1 vout2.$1292.Metal3 5.63311e-05f
Cred_17562 vin2.$369.Metal1 vout2.$1358.Metal3 0.0075369f
Cred_17563 vin2.$369.Metal1 vout2.P10.nSD 1.99725e-06f
Cred_17564 vin2.$369.Metal1 vout2.P10.pSD 4.80646e-06f
Cred_17565 vin2.$369.Metal1 vout2.P12.nSD 0.00581551f
Cred_17566 vin2.$369.Metal1 VSS.$1266.Metal1 0.00298934f
Cred_17567 vin2.$369.Metal1 VSS.$1339.Metal1 0.000706277f
Cred_17568 vin2.$369.Metal1 VSS.$1359.Metal1 0.00143116f
Cred_17569 vin2.$369.Metal1 VSS.$1990.Metal1 0.000327027f
Cred_17570 vin2.$369.Metal1 VSS.$3435.Metal2 0.000381446f
Cred_17571 vin2.$369.Metal1 VSS.$3507.Metal2 3.97237e-05f
Cred_17572 vin2.$369.Metal1 VSS.$68.Metal1 5.48823e-05f
Cred_17573 vin2.$369.Metal1 VSS.P3.pSD 0.0243385f
Cred_17574 vin2.$369.Metal1 VSS.P85.nSD 0.000113232f
Cred_17575 vin2.$37.GatPoly vout2.$1226.Metal3 0.00166244f
Cred_17576 vin2.$37.GatPoly vout2.P0.nSD 3.90331e-06f
Cred_17577 vin2.$37.GatPoly vout2.P0.pSD 2.07415e-05f
Cred_17578 vin2.$37.GatPoly vout2.P2.nSD 7.26222e-06f
Cred_17579 vin2.$37.GatPoly vout2.P2.pSD 2.3207e-05f
Cred_17580 vin2.$37.GatPoly vout2.P4.nSD 0.000623893f
Cred_17581 vin2.$37.GatPoly VSS.$1990.Metal1 2.57994e-06f
Cred_17582 vin2.$37.GatPoly VSS.$2711.Metal2 0.00106095f
Cred_17583 vin2.$37.GatPoly VSS.$565.Metal1 0.0124478f
Cred_17584 vin2.$37.GatPoly VSS.$68.Metal1 0.000149461f
Cred_17585 vin2.$37.GatPoly VSS.P3.pSD 0.00347315f
Cred_17586 vin2.$37.GatPoly VSS.P77.nSD 0.000321196f
Cred_17587 vin2.$374.Metal1 vout2.$1358.Metal3 0.023578f
Cred_17588 vin2.$374.Metal1 vout2.P12.pSD 0.021265f
Cred_17589 vin2.$375.Metal1 vout2.$1358.Metal3 0.0242595f
Cred_17590 vin2.$375.Metal1 vout2.$1424.Metal3 1.40644e-05f
Cred_17591 vin2.$375.Metal1 vout2.P12.nSD 0.0196785f
Cred_17592 vin2.$375.Metal1 vout2.P14.nSD 4.98662e-07f
Cred_17593 vin2.$375.Metal1 vout2.P14.pSD 1.20005e-06f
Cred_17594 vin2.$375.Metal1 VSS.$1445.Metal1 8.18531e-05f
Cred_17595 vin2.$375.Metal1 VSS.$1990.Metal1 0.000292042f
Cred_17596 vin2.$375.Metal1 VSS.$3603.Metal2 1.29848e-06f
Cred_17597 vin2.$375.Metal1 VSS.$3638.Metal2 3.41933e-05f
Cred_17598 vin2.$375.Metal1 VSS.$68.Metal1 3.65441e-05f
Cred_17599 vin2.$375.Metal1 VSS.P3.pSD 0.0187601f
Cred_17600 vin2.$375.Metal1 VSS.P63.nSD 1.88713e-10f
Cred_17601 vin2.$375.Metal1 VSS.P87.nSD 3.06305e-06f
Cred_17602 vin2.$378.Metal1 vout2.$1358.Metal3 0.00460492f
Cred_17603 vin2.$378.Metal1 vout2.P12.pSD 0.00208398f
Cred_17604 vin2.$379.Metal1 vout2.$1358.Metal3 0.00557193f
Cred_17605 vin2.$379.Metal1 vout2.$1424.Metal3 3.55673e-05f
Cred_17606 vin2.$379.Metal1 vout2.P12.nSD 0.00333354f
Cred_17607 vin2.$379.Metal1 vout2.P14.nSD 1.26106e-06f
Cred_17608 vin2.$379.Metal1 vout2.P14.pSD 3.03479e-06f
Cred_17609 vin2.$379.Metal1 VSS.$1407.Metal1 0.00196867f
Cred_17610 vin2.$379.Metal1 VSS.$1427.Metal1 0.000705983f
Cred_17611 vin2.$379.Metal1 VSS.$1445.Metal1 0.000643731f
Cred_17612 vin2.$379.Metal1 VSS.$1990.Metal1 0.000317862f
Cred_17613 vin2.$379.Metal1 VSS.$3555.Metal2 1.75113e-05f
Cred_17614 vin2.$379.Metal1 VSS.$3603.Metal2 2.22308e-05f
Cred_17615 vin2.$379.Metal1 VSS.$3638.Metal2 0.00012428f
Cred_17616 vin2.$379.Metal1 VSS.$4958.Metal3 1.40402e-07f
Cred_17617 vin2.$379.Metal1 VSS.$68.Metal1 2.99328e-05f
Cred_17618 vin2.$379.Metal1 VSS.P3.pSD 0.0176779f
Cred_17619 vin2.$379.Metal1 VSS.P63.nSD 6.85902e-10f
Cred_17620 vin2.$379.Metal1 VSS.P87.nSD 2.41256e-05f
Cred_17621 vin2.$382.Metal1 vout2.$1358.Metal3 0.000147556f
Cred_17622 vin2.$382.Metal1 vout2.P12.pSD 5.4933e-06f
Cred_17623 vin2.$386.Metal1 vout2.$1358.Metal3 9.54292e-05f
Cred_17624 vin2.$386.Metal1 vout2.$1424.Metal3 1.74057e-06f
Cred_17625 vin2.$386.Metal1 vout2.P12.pSD 2.81725e-06f
Cred_17626 vin2.$386.Metal1 vout2.P14.nSD 2.7421e-08f
Cred_17627 vin2.$386.Metal1 vout2.P14.pSD 3.02317e-07f
Cred_17628 vin2.$387.Metal1 vout2.$1358.Metal3 2.3847e-05f
Cred_17629 vin2.$387.Metal1 vout2.P12.nSD 8.18389e-08f
Cred_17630 vin2.$387.Metal1 VSS.$1407.Metal1 0.000185866f
Cred_17631 vin2.$387.Metal1 VSS.$1427.Metal1 0.000705757f
Cred_17632 vin2.$387.Metal1 VSS.$1445.Metal1 0.0342083f
Cred_17633 vin2.$387.Metal1 VSS.$1990.Metal1 0.000500311f
Cred_17634 vin2.$387.Metal1 VSS.$3555.Metal2 3.90164e-06f
Cred_17635 vin2.$387.Metal1 VSS.$3603.Metal2 0.000114936f
Cred_17636 vin2.$387.Metal1 VSS.$3638.Metal2 0.00292392f
Cred_17637 vin2.$387.Metal1 VSS.$4958.Metal3 3.12825e-08f
Cred_17638 vin2.$387.Metal1 VSS.$68.Metal1 3.56461e-05f
Cred_17639 vin2.$387.Metal1 VSS.P3.pSD 0.0241202f
Cred_17640 vin2.$387.Metal1 VSS.P63.nSD 1.61371e-08f
Cred_17641 vin2.$387.Metal1 VSS.P87.nSD 0.00130722f
Cred_17642 vin2.$392.Metal1 vout2.$1358.Metal3 3.45421e-05f
Cred_17643 vin2.$392.Metal1 vout2.$1424.Metal3 3.10581e-05f
Cred_17644 vin2.$392.Metal1 vout2.P12.pSD 2.26251e-07f
Cred_17645 vin2.$392.Metal1 vout2.P14.nSD 4.89291e-07f
Cred_17646 vin2.$392.Metal1 vout2.P14.pSD 2.87628e-06f
Cred_17647 vin2.$393.Metal1 vout2.$1358.Metal3 8.38441e-05f
Cred_17648 vin2.$393.Metal1 vout2.$1424.Metal3 8.38441e-05f
Cred_17649 vin2.$393.Metal1 vout2.P14.nSD 3.19353e-06f
Cred_17650 vin2.$393.Metal1 vout2.P14.pSD 7.154e-06f
Cred_17651 vin2.$393.Metal1 VSS.$1445.Metal1 0.0204792f
Cred_17652 vin2.$393.Metal1 VSS.$1490.Metal1 1.83739e-08f
Cred_17653 vin2.$393.Metal1 VSS.$1518.Metal1 0.00118678f
Cred_17654 vin2.$393.Metal1 VSS.$1546.Metal1 1.11867e-08f
Cred_17655 vin2.$393.Metal1 VSS.$1990.Metal1 0.000437414f
Cred_17656 vin2.$393.Metal1 VSS.$3603.Metal2 7.35122e-05f
Cred_17657 vin2.$393.Metal1 VSS.$3638.Metal2 0.00195315f
Cred_17658 vin2.$393.Metal1 VSS.$3694.Metal2 4.52076e-05f
Cred_17659 vin2.$393.Metal1 VSS.$4994.Metal3 1.38935e-07f
Cred_17660 vin2.$393.Metal1 VSS.$68.Metal1 2.34029e-05f
Cred_17661 vin2.$393.Metal1 VSS.P2.pSD 6.83953e-12f
Cred_17662 vin2.$393.Metal1 VSS.P3.pSD 0.0182416f
Cred_17663 vin2.$393.Metal1 VSS.P63.nSD 1.06838e-08f
Cred_17664 vin2.$393.Metal1 VSS.P87.nSD 0.000787366f
Cred_17665 vin2.$396.Metal1 vout2.$1358.Metal3 0.00063605f
Cred_17666 vin2.$396.Metal1 vout2.$1424.Metal3 0.00063605f
Cred_17667 vin2.$396.Metal1 vout2.P14.nSD 1.00204e-05f
Cred_17668 vin2.$396.Metal1 vout2.P14.pSD 0.000443449f
Cred_17669 vin2.$397.Metal1 vout2.$1358.Metal3 0.000188225f
Cred_17670 vin2.$397.Metal1 vout2.$1424.Metal3 0.000188225f
Cred_17671 vin2.$397.Metal1 vout2.P14.nSD 0.000136005f
Cred_17672 vin2.$397.Metal1 vout2.P14.pSD 1.60603e-05f
Cred_17673 vin2.$397.Metal1 VSS.$1445.Metal1 1.08675e-05f
Cred_17674 vin2.$397.Metal1 VSS.$1490.Metal1 7.33813e-09f
Cred_17675 vin2.$397.Metal1 VSS.$1518.Metal1 0.00105951f
Cred_17676 vin2.$397.Metal1 VSS.$1546.Metal1 0.00104152f
Cred_17677 vin2.$397.Metal1 VSS.$1990.Metal1 0.000339101f
Cred_17678 vin2.$397.Metal1 VSS.$3603.Metal2 2.50625e-06f
Cred_17679 vin2.$397.Metal1 VSS.$3638.Metal2 7.29184e-05f
Cred_17680 vin2.$397.Metal1 VSS.$3694.Metal2 5.89938e-05f
Cred_17681 vin2.$397.Metal1 VSS.$4994.Metal3 5.54877e-08f
Cred_17682 vin2.$397.Metal1 VSS.$68.Metal1 1.44021e-05f
Cred_17683 vin2.$397.Metal1 VSS.P2.pSD 6.36787e-07f
Cred_17684 vin2.$397.Metal1 VSS.P3.pSD 0.0125784f
Cred_17685 vin2.$397.Metal1 VSS.P63.nSD 3.64243e-10f
Cred_17686 vin2.$397.Metal1 VSS.P87.nSD 3.91229e-07f
Cred_17687 vin2.$400.Metal1 vout2.$1358.Metal3 0.00954509f
Cred_17688 vin2.$400.Metal1 vout2.$1424.Metal3 0.00954509f
Cred_17689 vin2.$400.Metal1 vout2.P14.nSD 0.000150374f
Cred_17690 vin2.$400.Metal1 vout2.P14.pSD 0.0178495f
Cred_17691 vin2.$401.Metal1 vout2.$1358.Metal3 0.0100629f
Cred_17692 vin2.$401.Metal1 vout2.$1424.Metal3 0.0100629f
Cred_17693 vin2.$401.Metal1 vout2.P14.nSD 0.0171024f
Cred_17694 vin2.$401.Metal1 vout2.P14.pSD 0.000858615f
Cred_17695 vin2.$401.Metal1 VSS.$1445.Metal1 1.36076e-06f
Cred_17696 vin2.$401.Metal1 VSS.$1490.Metal1 1.73447e-09f
Cred_17697 vin2.$401.Metal1 VSS.$1518.Metal1 0.000112712f
Cred_17698 vin2.$401.Metal1 VSS.$1546.Metal1 0.000112647f
Cred_17699 vin2.$401.Metal1 VSS.$1990.Metal1 0.000534446f
Cred_17700 vin2.$401.Metal1 VSS.$3603.Metal2 5.88414e-07f
Cred_17701 vin2.$401.Metal1 VSS.$3638.Metal2 1.71307e-05f
Cred_17702 vin2.$401.Metal1 VSS.$3694.Metal2 1.30872e-05f
Cred_17703 vin2.$401.Metal1 VSS.$4994.Metal3 1.31153e-08f
Cred_17704 vin2.$401.Metal1 VSS.$68.Metal1 1.80559e-05f
Cred_17705 vin2.$401.Metal1 VSS.P2.pSD 6.88726e-08f
Cred_17706 vin2.$401.Metal1 VSS.P3.pSD 0.0176103f
Cred_17707 vin2.$401.Metal1 VSS.P63.nSD 8.55167e-11f
Cred_17708 vin2.$401.Metal1 VSS.P87.nSD 4.71695e-08f
Cred_17709 vin2.$408.Metal1 vout2.$1358.Metal3 0.00923975f
Cred_17710 vin2.$408.Metal1 vout2.$1424.Metal3 0.00986865f
Cred_17711 vin2.$408.Metal1 vout2.P14.nSD 0.000145564f
Cred_17712 vin2.$408.Metal1 vout2.P14.pSD 0.0152637f
Cred_17713 vin2.$408.Metal1 vout2.P16.pSD 4.78297e-05f
Cred_17714 vin2.$409.Metal1 vout2.$1358.Metal3 0.00700118f
Cred_17715 vin2.$409.Metal1 vout2.$1424.Metal3 0.00709679f
Cred_17716 vin2.$409.Metal1 vout2.P14.nSD 0.0109886f
Cred_17717 vin2.$409.Metal1 vout2.P14.pSD 0.000597376f
Cred_17718 vin2.$409.Metal1 vout2.P16.nSD 8.9658e-07f
Cred_17719 vin2.$409.Metal1 VSS.$1586.Metal1 0.00137881f
Cred_17720 vin2.$409.Metal1 VSS.$1624.Metal1 0.0002632f
Cred_17721 vin2.$409.Metal1 VSS.$1990.Metal1 0.000613925f
Cred_17722 vin2.$409.Metal1 VSS.$3766.Metal2 9.08043e-06f
Cred_17723 vin2.$409.Metal1 VSS.$3809.Metal2 0.000114732f
Cred_17724 vin2.$409.Metal1 VSS.$68.Metal1 1.6463e-05f
Cred_17725 vin2.$409.Metal1 VSS.P3.pSD 0.0179545f
Cred_17726 vin2.$409.Metal1 VSS.P89.nSD 9.84987e-06f
Cred_17727 vin2.$412.Metal1 vout2.$1358.Metal3 0.00472945f
Cred_17728 vin2.$412.Metal1 vout2.$1424.Metal3 0.00584832f
Cred_17729 vin2.$412.Metal1 vout2.P14.nSD 7.45081e-05f
Cred_17730 vin2.$412.Metal1 vout2.P14.pSD 0.0067038f
Cred_17731 vin2.$412.Metal1 vout2.P16.pSD 8.5093e-05f
Cred_17732 vin2.$413.Metal1 vout2.$1358.Metal3 0.000383f
Cred_17733 vin2.$413.Metal1 vout2.$1424.Metal3 0.000553109f
Cred_17734 vin2.$413.Metal1 vout2.P14.nSD 0.000336004f
Cred_17735 vin2.$413.Metal1 vout2.P14.pSD 3.26795e-05f
Cred_17736 vin2.$413.Metal1 vout2.P16.nSD 1.59509e-06f
Cred_17737 vin2.$413.Metal1 VSS.$1606.Metal1 0.00141371f
Cred_17738 vin2.$413.Metal1 VSS.$1624.Metal1 0.00938489f
Cred_17739 vin2.$413.Metal1 VSS.$1990.Metal1 0.000708607f
Cred_17740 vin2.$413.Metal1 VSS.$3766.Metal2 3.84172e-05f
Cred_17741 vin2.$413.Metal1 VSS.$3809.Metal2 0.00100564f
Cred_17742 vin2.$413.Metal1 VSS.$68.Metal1 1.44564e-05f
Cred_17743 vin2.$413.Metal1 VSS.P3.pSD 0.0179943f
Cred_17744 vin2.$413.Metal1 VSS.P89.nSD 0.000359848f
Cred_17745 vin2.$419.Metal1 VSS.$1624.Metal1 0.0376358f
Cred_17746 vin2.$419.Metal1 VSS.$1990.Metal1 0.000806279f
Cred_17747 vin2.$419.Metal1 VSS.$3809.Metal2 0.00325318f
Cred_17748 vin2.$419.Metal1 VSS.$68.Metal1 1.29232e-05f
Cred_17749 vin2.$419.Metal1 VSS.P3.pSD 0.0180637f
Cred_17750 vin2.$419.Metal1 VSS.P89.nSD 0.00140605f
Cred_17751 vin2.$42.GatPoly vout2.$1226.Metal3 0.0222699f
Cred_17752 vin2.$42.GatPoly vout2.P0.nSD 1.40638e-05f
Cred_17753 vin2.$42.GatPoly vout2.P0.pSD 7.4733e-05f
Cred_17754 vin2.$42.GatPoly vout2.P2.nSD 1.52996e-05f
Cred_17755 vin2.$42.GatPoly vout2.P2.pSD 0.000165045f
Cred_17756 vin2.$42.GatPoly vout2.P4.pSD 0.0152604f
Cred_17757 vin2.$422.Metal1 vout2.$1424.Metal3 4.2458e-05f
Cred_17758 vin2.$423.Metal1 vout2.$1424.Metal3 0.000148264f
Cred_17759 vin2.$423.Metal1 vout2.P16.nSD 1.06712e-05f
Cred_17760 vin2.$423.Metal1 VSS.$1624.Metal1 0.0117446f
Cred_17761 vin2.$423.Metal1 VSS.$1685.Metal1 9.29231e-08f
Cred_17762 vin2.$423.Metal1 VSS.$1705.Metal1 4.15188e-08f
Cred_17763 vin2.$423.Metal1 VSS.$1990.Metal1 0.000644565f
Cred_17764 vin2.$423.Metal1 VSS.$3809.Metal2 0.00102085f
Cred_17765 vin2.$423.Metal1 VSS.$3825.Metal2 1.67928e-05f
Cred_17766 vin2.$423.Metal1 VSS.$3881.Metal2 2.79062e-05f
Cred_17767 vin2.$423.Metal1 VSS.$5078.Metal3 1.34641e-07f
Cred_17768 vin2.$423.Metal1 VSS.$68.Metal1 8.1757e-06f
Cred_17769 vin2.$423.Metal1 VSS.P3.pSD 0.0127873f
Cred_17770 vin2.$423.Metal1 VSS.P89.nSD 0.000424771f
Cred_17771 vin2.$426.Metal1 vout2.$1424.Metal3 0.00449306f
Cred_17772 vin2.$426.Metal1 vout2.P16.pSD 0.00292921f
Cred_17773 vin2.$427.Metal1 vout2.$1424.Metal3 0.000348714f
Cred_17774 vin2.$427.Metal1 vout2.P16.nSD 8.22737e-05f
Cred_17775 vin2.$427.Metal1 VSS.$1624.Metal1 1.25543e-06f
Cred_17776 vin2.$427.Metal1 VSS.$1685.Metal1 9.86064e-08f
Cred_17777 vin2.$427.Metal1 VSS.$1705.Metal1 0.0014312f
Cred_17778 vin2.$427.Metal1 VSS.$1990.Metal1 0.000681194f
Cred_17779 vin2.$427.Metal1 VSS.$3809.Metal2 1.48977e-05f
Cred_17780 vin2.$427.Metal1 VSS.$3825.Metal2 1.78198e-05f
Cred_17781 vin2.$427.Metal1 VSS.$3881.Metal2 4.04704e-05f
Cred_17782 vin2.$427.Metal1 VSS.$5078.Metal3 1.42875e-07f
Cred_17783 vin2.$427.Metal1 VSS.$68.Metal1 7.36444e-06f
Cred_17784 vin2.$427.Metal1 VSS.P3.pSD 0.0124221f
Cred_17785 vin2.$427.Metal1 VSS.P89.nSD 4.3599e-08f
Cred_17786 vin2.$43.GatPoly vout2.$1226.Metal3 0.00760675f
Cred_17787 vin2.$43.GatPoly vout2.P0.nSD 2.194e-06f
Cred_17788 vin2.$43.GatPoly vout2.P0.pSD 1.16586e-05f
Cred_17789 vin2.$43.GatPoly vout2.P2.nSD 4.082e-06f
Cred_17790 vin2.$43.GatPoly vout2.P2.pSD 1.30444e-05f
Cred_17791 vin2.$43.GatPoly vout2.P4.nSD 0.00536615f
Cred_17792 vin2.$43.GatPoly VSS.$1990.Metal1 3.88118e-06f
Cred_17793 vin2.$43.GatPoly VSS.$2711.Metal2 0.00021693f
Cred_17794 vin2.$43.GatPoly VSS.$565.Metal1 0.000497646f
Cred_17795 vin2.$43.GatPoly VSS.$68.Metal1 0.000131046f
Cred_17796 vin2.$43.GatPoly VSS.P3.pSD 0.00403041f
Cred_17797 vin2.$43.GatPoly VSS.P77.nSD 1.86237e-05f
Cred_17798 vin2.$431.Metal1 vout2.$1424.Metal3 0.0194237f
Cred_17799 vin2.$431.Metal1 vout2.P16.nSD 0.015411f
Cred_17800 vin2.$431.Metal1 VSS.$1624.Metal1 6.4622e-07f
Cred_17801 vin2.$431.Metal1 VSS.$1685.Metal1 5.07568e-08f
Cred_17802 vin2.$431.Metal1 VSS.$1705.Metal1 2.26786e-08f
Cred_17803 vin2.$431.Metal1 VSS.$1990.Metal1 0.00111512f
Cred_17804 vin2.$431.Metal1 VSS.$3809.Metal2 7.66844e-06f
Cred_17805 vin2.$431.Metal1 VSS.$3825.Metal2 9.1726e-06f
Cred_17806 vin2.$431.Metal1 VSS.$3881.Metal2 3.39179e-05f
Cred_17807 vin2.$431.Metal1 VSS.$5078.Metal3 7.35439e-08f
Cred_17808 vin2.$431.Metal1 VSS.$68.Metal1 9.67646e-06f
Cred_17809 vin2.$431.Metal1 VSS.P3.pSD 0.0180971f
Cred_17810 vin2.$431.Metal1 VSS.P89.nSD 2.24422e-08f
Cred_17811 vin2.$432.Metal1 vout2.$1424.Metal3 0.0266176f
Cred_17812 vin2.$432.Metal1 vout2.P16.pSD 0.0222725f
Cred_17813 vin2.$439.Metal1 vout2 1.29706e-05f
Cred_17814 vin2.$439.Metal1 vout2.$1424.Metal3 0.0163742f
Cred_17815 vin2.$439.Metal1 vout2.P16.nSD 0.0129229f
Cred_17816 vin2.$439.Metal1 vout2.P18.nSD 1.82761e-06f
Cred_17817 vin2.$439.Metal1 vout2.P18.pSD 5.58169e-06f
Cred_17818 vin2.$439.Metal1 VSS.$1745.Metal1 0.000564468f
Cred_17819 vin2.$439.Metal1 VSS.$1773.Metal1 0.000564734f
Cred_17820 vin2.$439.Metal1 VSS.$1799.Metal1 0.000239742f
Cred_17821 vin2.$439.Metal1 VSS.$1990.Metal1 0.00124316f
Cred_17822 vin2.$439.Metal1 VSS.$3929.Metal2 3.622e-06f
Cred_17823 vin2.$439.Metal1 VSS.$3988.Metal2 5.86146e-05f
Cred_17824 vin2.$439.Metal1 VSS.$4020.Metal2 4.36492e-05f
Cred_17825 vin2.$439.Metal1 VSS.$68.Metal1 8.47542e-06f
Cred_17826 vin2.$439.Metal1 VSS.P2.pSD 3.45115e-07f
Cred_17827 vin2.$439.Metal1 VSS.P3.pSD 0.0177526f
Cred_17828 vin2.$439.Metal1 VSS.P67.nSD 3.77411e-09f
Cred_17829 vin2.$439.Metal1 VSS.P91.nSD 8.96799e-06f
Cred_17830 vin2.$44.GatPoly vout2.$1226.Metal3 0.05686f
Cred_17831 vin2.$44.GatPoly vout2.$1292.Metal3 0.00278657f
Cred_17832 vin2.$44.GatPoly vout2.P4.pSD 0.0337983f
Cred_17833 vin2.$44.GatPoly vout2.P6.nSD 4.38997e-05f
Cred_17834 vin2.$44.GatPoly vout2.P6.pSD 0.000651467f
Cred_17835 vin2.$440.Metal1 vout2.$1424.Metal3 0.00561461f
Cred_17836 vin2.$440.Metal1 vout2.P16.pSD 0.00387364f
Cred_17837 vin2.$441.Metal1 vout2 2.90243e-05f
Cred_17838 vin2.$441.Metal1 vout2.$1424.Metal3 0.00111056f
Cred_17839 vin2.$441.Metal1 vout2.P16.nSD 0.000376308f
Cred_17840 vin2.$441.Metal1 vout2.P18.nSD 4.08965e-06f
Cred_17841 vin2.$441.Metal1 vout2.P18.pSD 1.24902e-05f
Cred_17842 vin2.$441.Metal1 VSS.$1745.Metal1 2.60524e-05f
Cred_17843 vin2.$441.Metal1 VSS.$1773.Metal1 0.00224803f
Cred_17844 vin2.$441.Metal1 VSS.$1793.Metal1 2.09529e-08f
Cred_17845 vin2.$441.Metal1 VSS.$1799.Metal1 0.00768135f
Cred_17846 vin2.$441.Metal1 VSS.$1990.Metal1 0.00142191f
Cred_17847 vin2.$441.Metal1 VSS.$3929.Metal2 1.99279e-05f
Cred_17848 vin2.$441.Metal1 VSS.$3988.Metal2 0.000518159f
Cred_17849 vin2.$441.Metal1 VSS.$4020.Metal2 0.000371147f
Cred_17850 vin2.$441.Metal1 VSS.$5126.Metal3 1.58437e-07f
Cred_17851 vin2.$441.Metal1 VSS.$68.Metal1 7.28726e-06f
Cred_17852 vin2.$441.Metal1 VSS.P2.pSD 1.59284e-08f
Cred_17853 vin2.$441.Metal1 VSS.P3.pSD 0.0174256f
Cred_17854 vin2.$441.Metal1 VSS.P67.nSD 3.20911e-08f
Cred_17855 vin2.$441.Metal1 VSS.P91.nSD 0.000293209f
Cred_17856 vin2.$448.Metal1 vout2.$1424.Metal3 9.75371e-06f
Cred_17857 vin2.$449.Metal1 vout2 8.26931e-07f
Cred_17858 vin2.$449.Metal1 vout2.$1424.Metal3 1.39243e-05f
Cred_17859 vin2.$449.Metal1 vout2.P18.nSD 6.5704e-08f
Cred_17860 vin2.$449.Metal1 vout2.P18.pSD 3.55857e-07f
Cred_17861 vin2.$449.Metal1 VSS.$1773.Metal1 0.000143586f
Cred_17862 vin2.$449.Metal1 VSS.$1793.Metal1 2.95623e-09f
Cred_17863 vin2.$449.Metal1 VSS.$1799.Metal1 0.0418812f
Cred_17864 vin2.$449.Metal1 VSS.$1864.Metal1 0.000507316f
Cred_17865 vin2.$449.Metal1 VSS.$1884.Metal1 9.20339e-09f
Cred_17866 vin2.$449.Metal1 VSS.$1990.Metal1 0.00215458f
Cred_17867 vin2.$449.Metal1 VSS.$3929.Metal2 2.78802e-06f
Cred_17868 vin2.$449.Metal1 VSS.$3988.Metal2 0.00207838f
Cred_17869 vin2.$449.Metal1 VSS.$4020.Metal2 0.00154718f
Cred_17870 vin2.$449.Metal1 VSS.$4068.Metal2 1.53249e-06f
Cred_17871 vin2.$449.Metal1 VSS.$5126.Metal3 2.23537e-08f
Cred_17872 vin2.$449.Metal1 VSS.$5162.Metal3 1.22871e-08f
Cred_17873 vin2.$449.Metal1 VSS.$68.Metal1 8.27046e-06f
Cred_17874 vin2.$449.Metal1 VSS.P3.pSD 0.022553f
Cred_17875 vin2.$449.Metal1 VSS.P67.nSD 1.33644e-07f
Cred_17876 vin2.$449.Metal1 VSS.P91.nSD 0.00156409f
Cred_17877 vin2.$452.Metal1 vout2 1.6785e-06f
Cred_17878 vin2.$452.Metal1 vout2.$1424.Metal3 8.46547e-06f
Cred_17879 vin2.$452.Metal1 vout2.P18.nSD 1.33366e-07f
Cred_17880 vin2.$452.Metal1 vout2.P18.pSD 7.22317e-07f
Cred_17881 vin2.$456.Metal1 vout2 0.011952f
Cred_17882 vin2.$456.Metal1 vout2.$1424.Metal3 0.0602796f
Cred_17883 vin2.$456.Metal1 vout2.P18.nSD 0.000949648f
Cred_17884 vin2.$456.Metal1 vout2.P18.pSD 0.0606796f
Cred_17885 vin2.$456.Metal1 VSS.$4140.Metal2 0.000968708f
Cred_17886 vin2.$457.Metal1 vout2 0.00552629f
Cred_17887 vin2.$457.Metal1 vout2.$1424.Metal3 0.02802f
Cred_17888 vin2.$457.Metal1 vout2.P16.nSD 1.39007e-06f
Cred_17889 vin2.$457.Metal1 vout2.P18.nSD 0.0269006f
Cred_17890 vin2.$457.Metal1 vout2.P18.pSD 0.00237816f
Cred_17891 vin2.$457.Metal1 VSS.$1799.Metal1 0.00662575f
Cred_17892 vin2.$457.Metal1 VSS.$1864.Metal1 0.000508459f
Cred_17893 vin2.$457.Metal1 VSS.$1884.Metal1 0.00134403f
Cred_17894 vin2.$457.Metal1 VSS.$1952.Metal1 0.00125391f
Cred_17895 vin2.$457.Metal1 VSS.$1990.Metal1 0.00841689f
Cred_17896 vin2.$457.Metal1 VSS.$2021.Metal1 0.000861456f
Cred_17897 vin2.$457.Metal1 VSS.$3988.Metal2 0.000340553f
Cred_17898 vin2.$457.Metal1 VSS.$4020.Metal2 0.000275531f
Cred_17899 vin2.$457.Metal1 VSS.$4068.Metal2 2.19277e-05f
Cred_17900 vin2.$457.Metal1 VSS.$4116.Metal2 5.17115e-05f
Cred_17901 vin2.$457.Metal1 VSS.$4164.Metal2 2.12339e-05f
Cred_17902 vin2.$457.Metal1 VSS.$5162.Metal3 1.75812e-07f
Cred_17903 vin2.$457.Metal1 VSS.$68.Metal1 1.644e-05f
Cred_17904 vin2.$457.Metal1 VSS.P3.pSD 0.0594359f
Cred_17905 vin2.$457.Metal1 VSS.P67.nSD 2.19277e-08f
Cred_17906 vin2.$457.Metal1 VSS.P7.GatPoly 0.00160798f
Cred_17907 vin2.$457.Metal1 VSS.P91.nSD 0.000253589f
Cred_17908 vin2.$457.Metal1 VSS.P93.nSD 5.94945e-06f
Cred_17909 vin2.$457.Metal1 VSS.P95.nSD 5.94945e-06f
Cred_17910 vin2.$47.GatPoly vout2.$1226.Metal3 0.00813817f
Cred_17911 vin2.$47.GatPoly vout2.$1292.Metal3 0.000689313f
Cred_17912 vin2.$47.GatPoly vout2.P4.nSD 0.00337161f
Cred_17913 vin2.$47.GatPoly vout2.P6.nSD 2.4445e-05f
Cred_17914 vin2.$47.GatPoly vout2.P6.pSD 5.93495e-05f
Cred_17915 vin2.$47.GatPoly VSS.$1990.Metal1 3.0959e-06f
Cred_17916 vin2.$47.GatPoly VSS.$2914.Metal2 0.0017524f
Cred_17917 vin2.$47.GatPoly VSS.$2946.Metal2 6.6547e-05f
Cred_17918 vin2.$47.GatPoly VSS.$68.Metal1 7.35294e-05f
Cred_17919 vin2.$47.GatPoly VSS.$726.Metal1 9.5518e-08f
Cred_17920 vin2.$47.GatPoly VSS.$744.Metal1 0.00489035f
Cred_17921 vin2.$47.GatPoly VSS.P3.pSD 0.00271121f
Cred_17922 vin2.$47.GatPoly VSS.P55.nSD 9.67155e-09f
Cred_17923 vin2.$47.GatPoly VSS.P79.nSD 0.000183077f
Cred_17924 vin2.$477.Metal2 vout2.$1226.Metal3 0.157491f
Cred_17925 vin2.$477.Metal2 vout2.P0.nSD 0.0111799f
Cred_17926 vin2.$477.Metal2 vout2.P0.pSD 0.0348154f
Cred_17927 vin2.$477.Metal2 vout2.P2.nSD 0.00248113f
Cred_17928 vin2.$477.Metal2 vout2.P2.pSD 0.0135599f
Cred_17929 vin2.$477.Metal2 VSS.$158.Metal1 0.00105762f
Cred_17930 vin2.$477.Metal2 VSS.$1990.Metal1 2.16345e-05f
Cred_17931 vin2.$477.Metal2 VSS.$2228.Metal2 0.0182937f
Cred_17932 vin2.$477.Metal2 VSS.$2409.Metal2 0.00106209f
Cred_17933 vin2.$477.Metal2 VSS.$2433.Metal2 0.00121979f
Cred_17934 vin2.$477.Metal2 VSS.$292.Metal1 4.99247e-05f
Cred_17935 vin2.$477.Metal2 VSS.$4358.Metal3 0.00674605f
Cred_17936 vin2.$477.Metal2 VSS.$4418.Metal3 4.79917e-05f
Cred_17937 vin2.$477.Metal2 VSS.$4454.Metal3 3.51931e-05f
Cred_17938 vin2.$477.Metal2 VSS.$68.Metal1 0.0193176f
Cred_17939 vin2.$477.Metal2 VSS.P3.pSD 0.0943854f
Cred_17940 vin2.$477.Metal2 VSS.P6.GatPoly 0.00153218f
Cred_17941 vin2.$477.Metal2 VSS.P72.nSD 4.71245e-06f
Cred_17942 vin2.$477.Metal2 VSS.P73.nSD 4.71245e-06f
Cred_17943 vin2.$479.Metal2 vout2.$1226.Metal3 0.0868665f
Cred_17944 vin2.$479.Metal2 vout2.P0.nSD 0.00258661f
Cred_17945 vin2.$479.Metal2 vout2.P0.pSD 0.0381694f
Cred_17946 vin2.$479.Metal2 vout2.P2.nSD 0.0013685f
Cred_17947 vin2.$479.Metal2 vout2.P2.pSD 0.00747917f
Cred_17948 vin2.$479.Metal2 VSS.$1990.Metal1 3.05773e-06f
Cred_17949 vin2.$479.Metal2 VSS.$2409.Metal2 9.4431e-07f
Cred_17950 vin2.$479.Metal2 VSS.$2433.Metal2 6.92477e-07f
Cred_17951 vin2.$479.Metal2 VSS.$4358.Metal3 0.00686727f
Cred_17952 vin2.$479.Metal2 VSS.$4418.Metal3 0.000117777f
Cred_17953 vin2.$479.Metal2 VSS.$4454.Metal3 8.63677e-05f
Cred_17954 vin2.$479.Metal2 VSS.$68.Metal1 0.00656938f
Cred_17955 vin2.$479.Metal2 VSS.P3.pSD 0.0198442f
Cred_17956 vin2.$479.Metal2 VSS.P6.GatPoly 0.00143774f
Cred_17957 vin2.$480.Metal2 vout2.$1226.Metal3 0.0907881f
Cred_17958 vin2.$480.Metal2 vout2.P0.nSD 0.0189255f
Cred_17959 vin2.$480.Metal2 vout2.P0.pSD 0.0143653f
Cred_17960 vin2.$480.Metal2 vout2.P2.nSD 0.00143028f
Cred_17961 vin2.$480.Metal2 vout2.P2.pSD 0.00781681f
Cred_17962 vin2.$480.Metal2 VSS.$158.Metal1 0.0019896f
Cred_17963 vin2.$480.Metal2 VSS.$1990.Metal1 8.51513e-06f
Cred_17964 vin2.$480.Metal2 VSS.$2228.Metal2 0.0340986f
Cred_17965 vin2.$480.Metal2 VSS.$2409.Metal2 0.00197894f
Cred_17966 vin2.$480.Metal2 VSS.$2433.Metal2 0.00227307f
Cred_17967 vin2.$480.Metal2 VSS.$2481.Metal2 0.00280513f
Cred_17968 vin2.$480.Metal2 VSS.$2532.Metal2 0.00123426f
Cred_17969 vin2.$480.Metal2 VSS.$2564.Metal2 4.23036e-07f
Cred_17970 vin2.$480.Metal2 VSS.$292.Metal1 0.000119666f
Cred_17971 vin2.$480.Metal2 VSS.$360.Metal1 7.41051e-06f
Cred_17972 vin2.$480.Metal2 VSS.$380.Metal1 3.12966e-06f
Cred_17973 vin2.$480.Metal2 VSS.$386.Metal1 8.23052e-06f
Cred_17974 vin2.$480.Metal2 VSS.$4358.Metal3 0.00570712f
Cred_17975 vin2.$480.Metal2 VSS.$4478.Metal3 9.89351e-06f
Cred_17976 vin2.$480.Metal2 VSS.$68.Metal1 0.0120741f
Cred_17977 vin2.$480.Metal2 VSS.P3.pSD 0.0437946f
Cred_17978 vin2.$480.Metal2 VSS.P51.nSD 2.72387e-11f
Cred_17979 vin2.$480.Metal2 VSS.P6.GatPoly 0.00144983f
Cred_17980 vin2.$480.Metal2 VSS.P72.nSD 8.90993e-06f
Cred_17981 vin2.$480.Metal2 VSS.P73.nSD 8.90993e-06f
Cred_17982 vin2.$480.Metal2 VSS.P75.nSD 3.1529e-07f
Cred_17983 vin2.$483.Metal2 vout2.$1226.Metal3 0.018944f
Cred_17984 vin2.$483.Metal2 vout2.P0.nSD 0.000473205f
Cred_17985 vin2.$483.Metal2 vout2.P0.pSD 0.00280077f
Cred_17986 vin2.$483.Metal2 vout2.P2.nSD 0.000298445f
Cred_17987 vin2.$483.Metal2 vout2.P2.pSD 0.001896f
Cred_17988 vin2.$484.Metal2 vout2.$1226.Metal3 0.0198468f
Cred_17989 vin2.$484.Metal2 vout2.P0.nSD 0.000542768f
Cred_17990 vin2.$484.Metal2 vout2.P0.pSD 0.00259866f
Cred_17991 vin2.$484.Metal2 vout2.P2.nSD 0.00036609f
Cred_17992 vin2.$484.Metal2 vout2.P2.pSD 0.0017088f
Cred_17993 vin2.$484.Metal2 VSS.$1990.Metal1 1.89929e-06f
Cred_17994 vin2.$484.Metal2 VSS.$2481.Metal2 0.00123397f
Cred_17995 vin2.$484.Metal2 VSS.$2532.Metal2 0.0154724f
Cred_17996 vin2.$484.Metal2 VSS.$2564.Metal2 0.0191202f
Cred_17997 vin2.$484.Metal2 VSS.$360.Metal1 7.41063e-06f
Cred_17998 vin2.$484.Metal2 VSS.$380.Metal1 9.77308e-06f
Cred_17999 vin2.$484.Metal2 VSS.$386.Metal1 0.00303595f
Cred_18000 vin2.$484.Metal2 VSS.$4478.Metal3 9.89367e-06f
Cred_18001 vin2.$484.Metal2 VSS.$68.Metal1 0.000566846f
Cred_18002 vin2.$484.Metal2 VSS.P3.pSD 0.00546856f
Cred_18003 vin2.$484.Metal2 VSS.P51.nSD 1.23112e-06f
Cred_18004 vin2.$484.Metal2 VSS.P75.nSD 0.000104727f
Cred_18005 vin2.$486.Metal2 vout2.$1226.Metal3 0.0980207f
Cred_18006 vin2.$486.Metal2 vout2.P0.nSD 0.00241147f
Cred_18007 vin2.$486.Metal2 vout2.P0.pSD 0.0128144f
Cred_18008 vin2.$486.Metal2 vout2.P2.nSD 0.00156497f
Cred_18009 vin2.$486.Metal2 vout2.P2.pSD 0.00854244f
Cred_18010 vin2.$486.Metal2 VSS.$1990.Metal1 1.80668e-05f
Cred_18011 vin2.$486.Metal2 VSS.$2532.Metal2 0.00221267f
Cred_18012 vin2.$486.Metal2 VSS.$2564.Metal2 0.0029713f
Cred_18013 vin2.$486.Metal2 VSS.$386.Metal1 0.000448976f
Cred_18014 vin2.$486.Metal2 VSS.$68.Metal1 0.00466039f
Cred_18015 vin2.$486.Metal2 VSS.P3.pSD 0.0488701f
Cred_18016 vin2.$486.Metal2 VSS.P51.nSD 1.91318e-07f
Cred_18017 vin2.$486.Metal2 VSS.P75.nSD 1.53963e-05f
Cred_18018 vin2.$488.Metal2 vout2.$1226.Metal3 0.0229136f
Cred_18019 vin2.$488.Metal2 vout2.P0.nSD 0.000485607f
Cred_18020 vin2.$488.Metal2 vout2.P0.pSD 0.00296482f
Cred_18021 vin2.$488.Metal2 vout2.P2.nSD 0.000360983f
Cred_18022 vin2.$488.Metal2 vout2.P2.pSD 0.00232861f
Cred_18023 vin2.$489.Metal2 vout2.$1226.Metal3 0.0241259f
Cred_18024 vin2.$489.Metal2 vout2.P0.nSD 0.000579018f
Cred_18025 vin2.$489.Metal2 vout2.P0.pSD 0.0026934f
Cred_18026 vin2.$489.Metal2 vout2.P2.nSD 0.00045182f
Cred_18027 vin2.$489.Metal2 vout2.P2.pSD 0.00207723f
Cred_18028 vin2.$489.Metal2 VSS.$1990.Metal1 3.0301e-06f
Cred_18029 vin2.$489.Metal2 VSS.$2532.Metal2 0.0174818f
Cred_18030 vin2.$489.Metal2 VSS.$2564.Metal2 0.0246652f
Cred_18031 vin2.$489.Metal2 VSS.$2620.Metal2 0.00118965f
Cred_18032 vin2.$489.Metal2 VSS.$386.Metal1 0.00370329f
Cred_18033 vin2.$489.Metal2 VSS.$451.Metal1 1.26142e-06f
Cred_18034 vin2.$489.Metal2 VSS.$4514.Metal3 9.53834e-06f
Cred_18035 vin2.$489.Metal2 VSS.$471.Metal1 1.23083e-05f
Cred_18036 vin2.$489.Metal2 VSS.$68.Metal1 0.000719861f
Cred_18037 vin2.$489.Metal2 VSS.P3.pSD 0.00787323f
Cred_18038 vin2.$489.Metal2 VSS.P51.nSD 1.51156e-06f
Cred_18039 vin2.$489.Metal2 VSS.P75.nSD 0.000127662f
Cred_18040 vin2.$492.Metal2 vout2.$1226.Metal3 0.0495575f
Cred_18041 vin2.$492.Metal2 vout2.P0.nSD 0.00071767f
Cred_18042 vin2.$492.Metal2 vout2.P0.pSD 0.00381358f
Cred_18043 vin2.$492.Metal2 vout2.P2.nSD 0.000780732f
Cred_18044 vin2.$492.Metal2 vout2.P2.pSD 0.014777f
Cred_18045 vin2.$493.Metal2 vout2.$1226.Metal3 0.0303152f
Cred_18046 vin2.$493.Metal2 vout2.P0.nSD 0.000439011f
Cred_18047 vin2.$493.Metal2 vout2.P0.pSD 0.00233283f
Cred_18048 vin2.$493.Metal2 vout2.P2.nSD 0.00472695f
Cred_18049 vin2.$493.Metal2 vout2.P2.pSD 0.00261012f
Cred_18050 vin2.$493.Metal2 VSS.$1990.Metal1 1.96932e-06f
Cred_18051 vin2.$493.Metal2 VSS.$2532.Metal2 6.70053e-07f
Cred_18052 vin2.$493.Metal2 VSS.$2564.Metal2 0.00119052f
Cred_18053 vin2.$493.Metal2 VSS.$2620.Metal2 0.00353881f
Cred_18054 vin2.$493.Metal2 VSS.$386.Metal1 1.75061e-05f
Cred_18055 vin2.$493.Metal2 VSS.$451.Metal1 1.26139e-06f
Cred_18056 vin2.$493.Metal2 VSS.$4514.Metal3 9.5381e-06f
Cred_18057 vin2.$493.Metal2 VSS.$471.Metal1 1.12553e-05f
Cred_18058 vin2.$493.Metal2 VSS.$499.Metal1 4.92789e-07f
Cred_18059 vin2.$493.Metal2 VSS.$68.Metal1 0.000329249f
Cred_18060 vin2.$493.Metal2 VSS.P2.pSD 3.01291e-10f
Cred_18061 vin2.$493.Metal2 VSS.P3.pSD 0.0043762f
Cred_18062 vin2.$493.Metal2 VSS.P51.nSD 5.79358e-11f
Cred_18063 vin2.$493.Metal2 VSS.P75.nSD 6.6924e-07f
Cred_18064 vin2.$495.Metal2 vout2.$1226.Metal3 0.130126f
Cred_18065 vin2.$495.Metal2 vout2.P0.nSD 0.00188443f
Cred_18066 vin2.$495.Metal2 vout2.P0.pSD 0.0100136f
Cred_18067 vin2.$495.Metal2 vout2.P2.nSD 0.00319518f
Cred_18068 vin2.$495.Metal2 vout2.P2.pSD 0.015747f
Cred_18069 vin2.$495.Metal2 VSS.$1990.Metal1 2.54348e-05f
Cred_18070 vin2.$495.Metal2 VSS.$68.Metal1 0.0032525f
Cred_18071 vin2.$495.Metal2 VSS.P3.pSD 0.0497379f
Cred_18072 vin2.$498.Metal2 vout2.$1226.Metal3 0.0769369f
Cred_18073 vin2.$498.Metal2 vout2.P0.nSD 0.00111417f
Cred_18074 vin2.$498.Metal2 vout2.P0.pSD 0.0059205f
Cred_18075 vin2.$498.Metal2 vout2.P2.nSD 0.0141958f
Cred_18076 vin2.$498.Metal2 vout2.P2.pSD 0.00662423f
Cred_18077 vin2.$498.Metal2 VSS.$1990.Metal1 6.14319e-06f
Cred_18078 vin2.$498.Metal2 VSS.$2668.Metal2 0.00282265f
Cred_18079 vin2.$498.Metal2 VSS.$2711.Metal2 0.00063817f
Cred_18080 vin2.$498.Metal2 VSS.$2727.Metal2 0.000763347f
Cred_18081 vin2.$498.Metal2 VSS.$4562.Metal3 6.12034e-06f
Cred_18082 vin2.$498.Metal2 VSS.$539.Metal1 1.88732e-06f
Cred_18083 vin2.$498.Metal2 VSS.$559.Metal1 4.22399e-06f
Cred_18084 vin2.$498.Metal2 VSS.$565.Metal1 5.37786e-05f
Cred_18085 vin2.$498.Metal2 VSS.$68.Metal1 0.000754158f
Cred_18086 vin2.$498.Metal2 VSS.P3.pSD 0.011727f
Cred_18087 vin2.$498.Metal2 VSS.P77.nSD 1.86765e-06f
Cred_18088 vin2.$499.Metal2 vout2.$1226.Metal3 0.0453728f
Cred_18089 vin2.$499.Metal2 vout2.P0.nSD 0.000657069f
Cred_18090 vin2.$499.Metal2 vout2.P0.pSD 0.00349156f
Cred_18091 vin2.$499.Metal2 vout2.P2.nSD 0.000714806f
Cred_18092 vin2.$499.Metal2 vout2.P2.pSD 0.0129722f
Cred_18093 vin2.$503.Metal2 vout2.$1226.Metal3 0.0299793f
Cred_18094 vin2.$503.Metal2 vout2.P0.nSD 0.00024078f
Cred_18095 vin2.$503.Metal2 vout2.P0.pSD 0.00127947f
Cred_18096 vin2.$503.Metal2 vout2.P2.nSD 0.000261938f
Cred_18097 vin2.$503.Metal2 vout2.P2.pSD 0.00181934f
Cred_18098 vin2.$503.Metal2 vout2.P4.pSD 0.000387787f
Cred_18099 vin2.$504.Metal2 vout2.$1226.Metal3 0.0387021f
Cred_18100 vin2.$504.Metal2 vout2.P0.nSD 0.00036249f
Cred_18101 vin2.$504.Metal2 vout2.P0.pSD 0.00192621f
Cred_18102 vin2.$504.Metal2 vout2.P2.nSD 0.00144319f
Cred_18103 vin2.$504.Metal2 vout2.P2.pSD 0.00215517f
Cred_18104 vin2.$504.Metal2 vout2.P4.nSD 6.94739e-05f
Cred_18105 vin2.$504.Metal2 VSS.$1990.Metal1 6.12383e-06f
Cred_18106 vin2.$504.Metal2 VSS.$2668.Metal2 0.00256116f
Cred_18107 vin2.$504.Metal2 VSS.$2711.Metal2 0.0451789f
Cred_18108 vin2.$504.Metal2 VSS.$2727.Metal2 0.0015412f
Cred_18109 vin2.$504.Metal2 VSS.$4562.Metal3 1.2357e-05f
Cred_18110 vin2.$504.Metal2 VSS.$539.Metal1 3.8105e-06f
Cred_18111 vin2.$504.Metal2 VSS.$559.Metal1 8.52825e-06f
Cred_18112 vin2.$504.Metal2 VSS.$565.Metal1 0.00385056f
Cred_18113 vin2.$504.Metal2 VSS.$68.Metal1 0.000452537f
Cred_18114 vin2.$504.Metal2 VSS.P3.pSD 0.00921024f
Cred_18115 vin2.$504.Metal2 VSS.P77.nSD 0.000133911f
Cred_18116 vin2.$506.Metal2 vout2.$1226.Metal3 0.109705f
Cred_18117 vin2.$506.Metal2 vout2.P0.nSD 0.000720669f
Cred_18118 vin2.$506.Metal2 vout2.P0.pSD 0.00382952f
Cred_18119 vin2.$506.Metal2 vout2.P2.nSD 0.000792089f
Cred_18120 vin2.$506.Metal2 vout2.P2.pSD 0.00432936f
Cred_18121 vin2.$506.Metal2 vout2.P4.nSD 8.09507e-06f
Cred_18122 vin2.$506.Metal2 vout2.P4.pSD 4.46531e-05f
Cred_18123 vin2.$506.Metal2 VSS.$1990.Metal1 3.58677e-05f
Cred_18124 vin2.$506.Metal2 VSS.$2711.Metal2 0.00476634f
Cred_18125 vin2.$506.Metal2 VSS.$565.Metal1 0.000401659f
Cred_18126 vin2.$506.Metal2 VSS.$68.Metal1 0.00229387f
Cred_18127 vin2.$506.Metal2 VSS.P3.pSD 0.0505008f
Cred_18128 vin2.$506.Metal2 VSS.P77.nSD 1.3949e-05f
Cred_18129 vin2.$508.Metal2 vout2.$1226.Metal3 0.0174091f
Cred_18130 vin2.$508.Metal2 vout2.P0.nSD 5.31665e-05f
Cred_18131 vin2.$508.Metal2 vout2.P0.pSD 0.000282518f
Cred_18132 vin2.$508.Metal2 vout2.P2.nSD 5.78383e-05f
Cred_18133 vin2.$508.Metal2 vout2.P2.pSD 0.000410889f
Cred_18134 vin2.$508.Metal2 vout2.P4.pSD 9.47899e-05f
Cred_18135 vin2.$509.Metal2 vout2.$1226.Metal3 0.0171927f
Cred_18136 vin2.$509.Metal2 vout2.P0.nSD 5.41085e-05f
Cred_18137 vin2.$509.Metal2 vout2.P0.pSD 0.000287524f
Cred_18138 vin2.$509.Metal2 vout2.P2.nSD 7.60473e-05f
Cred_18139 vin2.$509.Metal2 vout2.P2.pSD 0.0003217f
Cred_18140 vin2.$509.Metal2 vout2.P4.nSD 1.71843e-05f
Cred_18141 vin2.$509.Metal2 VSS.$1990.Metal1 4.73034e-06f
Cred_18142 vin2.$509.Metal2 VSS.$2711.Metal2 0.0277271f
Cred_18143 vin2.$509.Metal2 VSS.$2783.Metal2 0.00298634f
Cred_18144 vin2.$509.Metal2 VSS.$4586.Metal3 3.93375e-06f
Cred_18145 vin2.$509.Metal2 VSS.$565.Metal1 0.00245323f
Cred_18146 vin2.$509.Metal2 VSS.$618.Metal1 3.52655e-06f
Cred_18147 vin2.$509.Metal2 VSS.$638.Metal1 4.04686e-07f
Cred_18148 vin2.$509.Metal2 VSS.$68.Metal1 0.000264532f
Cred_18149 vin2.$509.Metal2 VSS.P3.pSD 0.00622947f
Cred_18150 vin2.$509.Metal2 VSS.P77.nSD 8.58485e-05f
Cred_18151 vin2.$512.Metal2 vout2.$1226.Metal3 0.0496893f
Cred_18152 vin2.$512.Metal2 vout2.P4.pSD 0.00878399f
Cred_18153 vin2.$513.Metal2 vout2.$1226.Metal3 0.0580071f
Cred_18154 vin2.$513.Metal2 vout2.P4.nSD 0.00708599f
Cred_18155 vin2.$513.Metal2 VSS.$1990.Metal1 4.6833e-06f
Cred_18156 vin2.$513.Metal2 VSS.$2783.Metal2 0.00305041f
Cred_18157 vin2.$513.Metal2 VSS.$2831.Metal2 0.000554701f
Cred_18158 vin2.$513.Metal2 VSS.$4610.Metal3 4.44747e-06f
Cred_18159 vin2.$513.Metal2 VSS.$658.Metal1 2.1546e-06f
Cred_18160 vin2.$513.Metal2 VSS.$678.Metal1 2.28519e-06f
Cred_18161 vin2.$513.Metal2 VSS.$68.Metal1 0.000181373f
Cred_18162 vin2.$513.Metal2 VSS.P3.pSD 0.00516648f
Cred_18163 vin2.$515.Metal2 vout2.$1226.Metal3 0.174793f
Cred_18164 vin2.$515.Metal2 vout2.$1292.Metal3 0.00903794f
Cred_18165 vin2.$515.Metal2 vout2.P4.nSD 0.00122542f
Cred_18166 vin2.$515.Metal2 vout2.P4.pSD 0.00137652f
Cred_18167 vin2.$515.Metal2 vout2.P6.nSD 0.000142683f
Cred_18168 vin2.$515.Metal2 vout2.P6.pSD 0.000778162f
Cred_18169 vin2.$515.Metal2 VSS.$1990.Metal1 7.75281e-05f
Cred_18170 vin2.$515.Metal2 VSS.$2914.Metal2 0.00149864f
Cred_18171 vin2.$515.Metal2 VSS.$2946.Metal2 5.69106e-05f
Cred_18172 vin2.$515.Metal2 VSS.$68.Metal1 0.00210015f
Cred_18173 vin2.$515.Metal2 VSS.$744.Metal1 0.000131611f
Cred_18174 vin2.$515.Metal2 VSS.P3.pSD 0.0712918f
Cred_18175 vin2.$515.Metal2 VSS.P55.nSD 8.27105e-09f
Cred_18176 vin2.$515.Metal2 VSS.P79.nSD 4.56217e-06f
Cred_18177 vin2.$517.Metal2 vout2.$1226.Metal3 0.0607039f
Cred_18178 vin2.$517.Metal2 vout2.P4.pSD 0.0130944f
Cred_18179 vin2.$518.Metal2 vout2.$1226.Metal3 0.0773344f
Cred_18180 vin2.$518.Metal2 vout2.P4.nSD 0.0112674f
Cred_18181 vin2.$518.Metal2 VSS.$1990.Metal1 1.02073e-05f
Cred_18182 vin2.$518.Metal2 VSS.$2855.Metal2 0.00339829f
Cred_18183 vin2.$518.Metal2 VSS.$2914.Metal2 0.00470828f
Cred_18184 vin2.$518.Metal2 VSS.$2946.Metal2 0.000161723f
Cred_18185 vin2.$518.Metal2 VSS.$4646.Metal3 3.60467e-06f
Cred_18186 vin2.$518.Metal2 VSS.$68.Metal1 0.000299231f
Cred_18187 vin2.$518.Metal2 VSS.$698.Metal1 1.18318e-06f
Cred_18188 vin2.$518.Metal2 VSS.$726.Metal1 4.30884e-06f
Cred_18189 vin2.$518.Metal2 VSS.$744.Metal1 0.000373998f
Cred_18190 vin2.$518.Metal2 VSS.$757.Metal1 4.76709e-07f
Cred_18191 vin2.$518.Metal2 VSS.P2.pSD 7.23397e-10f
Cred_18192 vin2.$518.Metal2 VSS.P3.pSD 0.00982483f
Cred_18193 vin2.$518.Metal2 VSS.P55.nSD 2.35038e-08f
Cred_18194 vin2.$518.Metal2 VSS.P79.nSD 1.29643e-05f
Cred_18195 vin2.$519.Metal2 vout2.$1226.Metal3 0.0191896f
Cred_18196 vin2.$519.Metal2 vout2.$1292.Metal3 4.91937e-05f
Cred_18197 vin2.$519.Metal2 vout2.P4.pSD 0.000892535f
Cred_18198 vin2.$519.Metal2 vout2.P6.nSD 7.75001e-07f
Cred_18199 vin2.$519.Metal2 vout2.P6.pSD 9.98113e-06f
Cred_18200 vin2.$52.GatPoly vout2.$1226.Metal3 3.63287e-08f
Cred_18201 vin2.$52.GatPoly vout2.$1292.Metal3 8.57734e-09f
Cred_18202 vin2.$52.GatPoly vout2.P4.pSD 1.00179e-09f
Cred_18203 vin2.$52.GatPoly vout2.P6.nSD 1.35128e-10f
Cred_18204 vin2.$52.GatPoly vout2.P6.pSD 1.7403e-09f
Cred_18205 vin2.$524.Metal2 vout2.$1226.Metal3 0.0510252f
Cred_18206 vin2.$524.Metal2 vout2.$1292.Metal3 0.0134562f
Cred_18207 vin2.$524.Metal2 vout2.P4.nSD 0.000190756f
Cred_18208 vin2.$524.Metal2 vout2.P6.nSD 0.000304649f
Cred_18209 vin2.$524.Metal2 vout2.P6.pSD 0.00115857f
Cred_18210 vin2.$524.Metal2 VSS.$1990.Metal1 2.90047e-05f
Cred_18211 vin2.$524.Metal2 VSS.$2855.Metal2 0.00236814f
Cred_18212 vin2.$524.Metal2 VSS.$2914.Metal2 0.0517027f
Cred_18213 vin2.$524.Metal2 VSS.$2946.Metal2 0.00192892f
Cred_18214 vin2.$524.Metal2 VSS.$4646.Metal3 7.27794e-06f
Cred_18215 vin2.$524.Metal2 VSS.$68.Metal1 0.000494826f
Cred_18216 vin2.$524.Metal2 VSS.$698.Metal1 5.85998e-07f
Cred_18217 vin2.$524.Metal2 VSS.$726.Metal1 6.89594e-06f
Cred_18218 vin2.$524.Metal2 VSS.$744.Metal1 0.00469654f
Cred_18219 vin2.$524.Metal2 VSS.$757.Metal1 9.62491e-07f
Cred_18220 vin2.$524.Metal2 VSS.P2.pSD 3.58279e-10f
Cred_18221 vin2.$524.Metal2 VSS.P3.pSD 0.0214754f
Cred_18222 vin2.$524.Metal2 VSS.P55.nSD 2.80338e-07f
Cred_18223 vin2.$524.Metal2 VSS.P79.nSD 0.000163835f
Cred_18224 vin2.$525.Metal2 vout2.$1226.Metal3 0.0502821f
Cred_18225 vin2.$525.Metal2 vout2.$1292.Metal3 0.0180083f
Cred_18226 vin2.$525.Metal2 vout2.P4.nSD 1.43057e-07f
Cred_18227 vin2.$525.Metal2 vout2.P4.pSD 0.000521155f
Cred_18228 vin2.$525.Metal2 vout2.P6.nSD 0.000283847f
Cred_18229 vin2.$525.Metal2 vout2.P6.pSD 0.00230869f
Cred_18230 vin2.$525.Metal2 VSS.$1990.Metal1 1.15238e-05f
Cred_18231 vin2.$525.Metal2 VSS.$2914.Metal2 0.000717863f
Cred_18232 vin2.$525.Metal2 VSS.$2946.Metal2 2.72606e-05f
Cred_18233 vin2.$525.Metal2 VSS.$68.Metal1 0.000183644f
Cred_18234 vin2.$525.Metal2 VSS.$744.Metal1 6.30427e-05f
Cred_18235 vin2.$525.Metal2 VSS.P3.pSD 0.00827242f
Cred_18236 vin2.$525.Metal2 VSS.P55.nSD 3.9619e-09f
Cred_18237 vin2.$525.Metal2 VSS.P79.nSD 2.18532e-06f
Cred_18238 vin2.$529.Metal2 vout2.$1226.Metal3 0.00731763f
Cred_18239 vin2.$529.Metal2 vout2.$1292.Metal3 0.00647235f
Cred_18240 vin2.$529.Metal2 vout2.P4.nSD 1.35309e-06f
Cred_18241 vin2.$529.Metal2 vout2.P6.nSD 0.000127075f
Cred_18242 vin2.$529.Metal2 vout2.P6.pSD 0.000557266f
Cred_18243 vin2.$529.Metal2 VSS.$1990.Metal1 7.29207e-06f
Cred_18244 vin2.$529.Metal2 VSS.$2914.Metal2 0.016284f
Cred_18245 vin2.$529.Metal2 VSS.$2946.Metal2 0.00416061f
Cred_18246 vin2.$529.Metal2 VSS.$2994.Metal2 0.00113256f
Cred_18247 vin2.$529.Metal2 VSS.$4682.Metal3 9.0806e-06f
Cred_18248 vin2.$529.Metal2 VSS.$68.Metal1 8.81949e-05f
Cred_18249 vin2.$529.Metal2 VSS.$744.Metal1 0.00144525f
Cred_18250 vin2.$529.Metal2 VSS.$817.Metal1 1.07668e-05f
Cred_18251 vin2.$529.Metal2 VSS.$837.Metal1 1.13754e-05f
Cred_18252 vin2.$529.Metal2 VSS.P3.pSD 0.00457836f
Cred_18253 vin2.$529.Metal2 VSS.P55.nSD 8.98714e-08f
Cred_18254 vin2.$529.Metal2 VSS.P79.nSD 5.01416e-05f
Cred_18255 vin2.$53.GatPoly VSS.$1990.Metal1 4.06971e-06f
Cred_18256 vin2.$53.GatPoly VSS.$2914.Metal2 0.000541607f
Cred_18257 vin2.$53.GatPoly VSS.$2946.Metal2 2.05674e-05f
Cred_18258 vin2.$53.GatPoly VSS.$68.Metal1 6.90504e-05f
Cred_18259 vin2.$53.GatPoly VSS.$726.Metal1 7.30432e-08f
Cred_18260 vin2.$53.GatPoly VSS.$744.Metal1 0.0122579f
Cred_18261 vin2.$53.GatPoly VSS.P3.pSD 0.00302483f
Cred_18262 vin2.$53.GatPoly VSS.P55.nSD 2.98914e-09f
Cred_18263 vin2.$53.GatPoly VSS.P79.nSD 0.000241435f
Cred_18264 vin2.$532.Metal2 vout2.$1226.Metal3 0.0331409f
Cred_18265 vin2.$532.Metal2 vout2.$1292.Metal3 0.0331409f
Cred_18266 vin2.$532.Metal2 vout2.P6.nSD 0.000522104f
Cred_18267 vin2.$532.Metal2 vout2.P6.pSD 0.0155504f
Cred_18268 vin2.$533.Metal2 vout2.$1226.Metal3 0.0340852f
Cred_18269 vin2.$533.Metal2 vout2.$1292.Metal3 0.0340852f
Cred_18270 vin2.$533.Metal2 vout2.P6.nSD 0.0110647f
Cred_18271 vin2.$533.Metal2 vout2.P6.pSD 0.00293472f
Cred_18272 vin2.$533.Metal2 VSS.$1990.Metal1 1.40151e-05f
Cred_18273 vin2.$533.Metal2 VSS.$2914.Metal2 1.36232e-07f
Cred_18274 vin2.$533.Metal2 VSS.$2946.Metal2 0.00113253f
Cred_18275 vin2.$533.Metal2 VSS.$2994.Metal2 0.00113253f
Cred_18276 vin2.$533.Metal2 VSS.$4682.Metal3 9.08034e-06f
Cred_18277 vin2.$533.Metal2 VSS.$68.Metal1 0.000126823f
Cred_18278 vin2.$533.Metal2 VSS.$744.Metal1 1.57363e-06f
Cred_18279 vin2.$533.Metal2 VSS.$817.Metal1 4.81079e-06f
Cred_18280 vin2.$533.Metal2 VSS.$837.Metal1 9.80683e-06f
Cred_18281 vin2.$533.Metal2 VSS.P3.pSD 0.00759093f
Cred_18282 vin2.$533.Metal2 VSS.P55.nSD 7.51865e-13f
Cred_18283 vin2.$533.Metal2 VSS.P79.nSD 5.90182e-08f
Cred_18284 vin2.$535.Metal2 vout2.$1226.Metal3 0.0985463f
Cred_18285 vin2.$535.Metal2 vout2.$1292.Metal3 0.0795949f
Cred_18286 vin2.$535.Metal2 vout2.P4.nSD 2.98653e-07f
Cred_18287 vin2.$535.Metal2 vout2.P6.nSD 0.00254401f
Cred_18288 vin2.$535.Metal2 vout2.P6.pSD 0.00832374f
Cred_18289 vin2.$535.Metal2 VSS.$1990.Metal1 0.000130086f
Cred_18290 vin2.$535.Metal2 VSS.$2914.Metal2 0.00149864f
Cred_18291 vin2.$535.Metal2 VSS.$2946.Metal2 5.69106e-05f
Cred_18292 vin2.$535.Metal2 VSS.$68.Metal1 0.0012287f
Cred_18293 vin2.$535.Metal2 VSS.$744.Metal1 0.000131611f
Cred_18294 vin2.$535.Metal2 VSS.P3.pSD 0.071407f
Cred_18295 vin2.$535.Metal2 VSS.P55.nSD 8.27105e-09f
Cred_18296 vin2.$535.Metal2 VSS.P79.nSD 4.56217e-06f
Cred_18297 vin2.$537.Metal2 vout2.$1226.Metal3 0.0255876f
Cred_18298 vin2.$537.Metal2 vout2.$1292.Metal3 0.0255876f
Cred_18299 vin2.$537.Metal2 vout2.P6.nSD 0.000403108f
Cred_18300 vin2.$537.Metal2 vout2.P6.pSD 0.0119442f
Cred_18301 vin2.$538.Metal2 vout2.$1226.Metal3 0.0274712f
Cred_18302 vin2.$538.Metal2 vout2.$1292.Metal3 0.0274712f
Cred_18303 vin2.$538.Metal2 vout2.P6.nSD 0.00821486f
Cred_18304 vin2.$538.Metal2 vout2.P6.pSD 0.00236526f
Cred_18305 vin2.$538.Metal2 VSS.$1990.Metal1 1.28004e-05f
Cred_18306 vin2.$538.Metal2 VSS.$3042.Metal2 0.00239142f
Cred_18307 vin2.$538.Metal2 VSS.$3085.Metal2 5.84469e-07f
Cred_18308 vin2.$538.Metal2 VSS.$68.Metal1 9.16324e-05f
Cred_18309 vin2.$538.Metal2 VSS.$905.Metal1 1.73049e-06f
Cred_18310 vin2.$538.Metal2 VSS.$923.Metal1 6.50199e-06f
Cred_18311 vin2.$538.Metal2 VSS.P3.pSD 0.00616587f
Cred_18312 vin2.$538.Metal2 VSS.P81.nSD 2.4666e-07f
Cred_18313 vin2.$541.Metal2 vout2.$1226.Metal3 0.00627618f
Cred_18314 vin2.$541.Metal2 vout2.$1292.Metal3 0.00943108f
Cred_18315 vin2.$541.Metal2 vout2.P6.nSD 9.88754e-05f
Cred_18316 vin2.$541.Metal2 vout2.P6.pSD 0.000719226f
Cred_18317 vin2.$541.Metal2 vout2.P8.pSD 6.00928e-05f
Cred_18318 vin2.$542.Metal2 vout2.$1226.Metal3 0.00916639f
Cred_18319 vin2.$542.Metal2 vout2.$1292.Metal3 0.0189675f
Cred_18320 vin2.$542.Metal2 vout2.P6.nSD 0.000193831f
Cred_18321 vin2.$542.Metal2 vout2.P6.pSD 0.000789222f
Cred_18322 vin2.$542.Metal2 vout2.P8.nSD 4.02867e-05f
Cred_18323 vin2.$542.Metal2 VSS.$1990.Metal1 2.01081e-05f
Cred_18324 vin2.$542.Metal2 VSS.$3042.Metal2 0.00302246f
Cred_18325 vin2.$542.Metal2 VSS.$3085.Metal2 0.0426236f
Cred_18326 vin2.$542.Metal2 VSS.$4730.Metal3 5.05911e-06f
Cred_18327 vin2.$542.Metal2 VSS.$68.Metal1 8.92056e-05f
Cred_18328 vin2.$542.Metal2 VSS.$905.Metal1 1.14797e-05f
Cred_18329 vin2.$542.Metal2 VSS.$923.Metal1 0.00362769f
Cred_18330 vin2.$542.Metal2 VSS.$936.Metal1 2.89664e-06f
Cred_18331 vin2.$542.Metal2 VSS.P3.pSD 0.0076153f
Cred_18332 vin2.$542.Metal2 VSS.P81.nSD 0.000126347f
Cred_18333 vin2.$544.Metal2 vout2.$1226.Metal3 0.0296503f
Cred_18334 vin2.$544.Metal2 vout2.$1292.Metal3 0.0916487f
Cred_18335 vin2.$544.Metal2 vout2.P6.nSD 0.000488088f
Cred_18336 vin2.$544.Metal2 vout2.P6.pSD 0.00258416f
Cred_18337 vin2.$544.Metal2 vout2.P8.nSD 2.09757e-05f
Cred_18338 vin2.$544.Metal2 vout2.P8.pSD 3.1288e-05f
Cred_18339 vin2.$544.Metal2 VSS.$1990.Metal1 0.000148251f
Cred_18340 vin2.$544.Metal2 VSS.$3085.Metal2 0.0131696f
Cred_18341 vin2.$544.Metal2 VSS.$68.Metal1 0.000590062f
Cred_18342 vin2.$544.Metal2 VSS.$923.Metal1 0.0011213f
Cred_18343 vin2.$544.Metal2 VSS.P3.pSD 0.0536049f
Cred_18344 vin2.$544.Metal2 VSS.P81.nSD 3.89907e-05f
Cred_18345 vin2.$546.Metal2 vout2.$1226.Metal3 0.00721531f
Cred_18346 vin2.$546.Metal2 vout2.$1292.Metal3 0.0281306f
Cred_18347 vin2.$546.Metal2 vout2.P6.nSD 0.00011367f
Cred_18348 vin2.$546.Metal2 vout2.P6.pSD 0.00105708f
Cred_18349 vin2.$546.Metal2 vout2.P8.pSD 0.000435848f
Cred_18350 vin2.$549.Metal2 vout2.$1226.Metal3 0.00310844f
Cred_18351 vin2.$549.Metal2 vout2.$1292.Metal3 0.0294593f
Cred_18352 vin2.$549.Metal2 vout2.P6.nSD 8.18366e-05f
Cred_18353 vin2.$549.Metal2 vout2.P6.pSD 0.000267635f
Cred_18354 vin2.$549.Metal2 vout2.P8.nSD 0.00115887f
Cred_18355 vin2.$549.Metal2 VSS.$1024.Metal1 3.79875e-07f
Cred_18356 vin2.$549.Metal2 VSS.$1990.Metal1 2.36248e-05f
Cred_18357 vin2.$549.Metal2 VSS.$3085.Metal2 0.0240728f
Cred_18358 vin2.$549.Metal2 VSS.$3101.Metal2 0.00186341f
Cred_18359 vin2.$549.Metal2 VSS.$3157.Metal2 0.00355795f
Cred_18360 vin2.$549.Metal2 VSS.$4754.Metal3 1.49404e-05f
Cred_18361 vin2.$549.Metal2 VSS.$68.Metal1 7.80933e-05f
Cred_18362 vin2.$549.Metal2 VSS.$923.Metal1 0.00205336f
Cred_18363 vin2.$549.Metal2 VSS.$968.Metal1 2.19689e-07f
Cred_18364 vin2.$549.Metal2 VSS.$996.Metal1 3.60907e-05f
Cred_18365 vin2.$549.Metal2 VSS.P2.pSD 2.32395e-10f
Cred_18366 vin2.$549.Metal2 VSS.P3.pSD 0.00776569f
Cred_18367 vin2.$549.Metal2 VSS.P81.nSD 7.14171e-05f
Cred_18368 vin2.$550.Metal2 vout2.$1292.Metal3 0.0527566f
Cred_18369 vin2.$550.Metal2 vout2.P8.pSD 0.00853468f
Cred_18370 vin2.$553.Metal2 vout2.$1292.Metal3 0.0808159f
Cred_18371 vin2.$553.Metal2 vout2.P8.nSD 0.0119892f
Cred_18372 vin2.$553.Metal2 VSS.$1990.Metal1 3.97131e-05f
Cred_18373 vin2.$553.Metal2 VSS.$3157.Metal2 0.00169455f
Cred_18374 vin2.$553.Metal2 VSS.$68.Metal1 7.87275e-05f
Cred_18375 vin2.$553.Metal2 VSS.P3.pSD 0.0101092f
Cred_18376 vin2.$555.Metal2 vout2.$1292.Metal3 0.155889f
Cred_18377 vin2.$555.Metal2 vout2.P8.nSD 0.00114827f
Cred_18378 vin2.$555.Metal2 vout2.P8.pSD 0.00434025f
Cred_18379 vin2.$555.Metal2 VSS.$1990.Metal1 0.000209592f
Cred_18380 vin2.$555.Metal2 VSS.$68.Metal1 0.000416424f
Cred_18381 vin2.$555.Metal2 VSS.P3.pSD 0.0536361f
Cred_18382 vin2.$557.Metal2 vout2.$1292.Metal3 0.0625715f
Cred_18383 vin2.$557.Metal2 vout2.P8.pSD 0.0114927f
Cred_18384 vin2.$558.Metal2 vout2.$1292.Metal3 0.0406136f
Cred_18385 vin2.$558.Metal2 vout2.P8.nSD 0.00500795f
Cred_18386 vin2.$558.Metal2 VSS 4.24113e-06f
Cred_18387 vin2.$558.Metal2 VSS.$1064.Metal1 1.81271e-06f
Cred_18388 vin2.$558.Metal2 VSS.$1084.Metal1 1.67372e-05f
Cred_18389 vin2.$558.Metal2 VSS.$1990.Metal1 2.21853e-05f
Cred_18390 vin2.$558.Metal2 VSS.$3205.Metal2 0.00311477f
Cred_18391 vin2.$558.Metal2 VSS.$3260.Metal2 0.00118406f
Cred_18392 vin2.$558.Metal2 VSS.$3292.Metal2 1.90149e-07f
Cred_18393 vin2.$558.Metal2 VSS.$4802.Metal3 9.49201e-06f
Cred_18394 vin2.$558.Metal2 VSS.$68.Metal1 3.43897e-05f
Cred_18395 vin2.$558.Metal2 VSS.P3.pSD 0.00501423f
Cred_18396 vin2.$558.Metal2 VSS.P59.nSD 1.43423e-11f
Cred_18397 vin2.$558.Metal2 VSS.P83.nSD 1.61888e-07f
Cred_18398 vin2.$56.GatPoly vout2.$1226.Metal3 0.0315155f
Cred_18399 vin2.$56.GatPoly vout2.$1292.Metal3 0.0256585f
Cred_18400 vin2.$56.GatPoly vout2.P4.pSD 0.000411545f
Cred_18401 vin2.$56.GatPoly vout2.P6.nSD 0.000404226f
Cred_18402 vin2.$56.GatPoly vout2.P6.pSD 0.0362783f
Cred_18403 vin2.$561.Metal2 vout2.$1292.Metal3 0.0233645f
Cred_18404 vin2.$561.Metal2 vout2.$1358.Metal3 0.0048384f
Cred_18405 vin2.$561.Metal2 vout2.P10.nSD 7.62245e-05f
Cred_18406 vin2.$561.Metal2 vout2.P10.pSD 0.000766399f
Cred_18407 vin2.$561.Metal2 vout2.P8.pSD 0.000340744f
Cred_18408 vin2.$562.Metal2 vout2.$1292.Metal3 0.0255226f
Cred_18409 vin2.$562.Metal2 vout2.$1358.Metal3 0.00563563f
Cred_18410 vin2.$562.Metal2 vout2.P10.nSD 0.000159782f
Cred_18411 vin2.$562.Metal2 vout2.P10.pSD 0.000480861f
Cred_18412 vin2.$562.Metal2 vout2.P8.nSD 7.09978e-05f
Cred_18413 vin2.$562.Metal2 VSS 0.00329235f
Cred_18414 vin2.$562.Metal2 VSS.$1064.Metal1 1.81273e-06f
Cred_18415 vin2.$562.Metal2 VSS.$1084.Metal1 1.87802e-05f
Cred_18416 vin2.$562.Metal2 VSS.$1990.Metal1 4.18915e-05f
Cred_18417 vin2.$562.Metal2 VSS.$3205.Metal2 0.00118389f
Cred_18418 vin2.$562.Metal2 VSS.$3260.Metal2 0.020019f
Cred_18419 vin2.$562.Metal2 VSS.$3292.Metal2 0.0188351f
Cred_18420 vin2.$562.Metal2 VSS.$4802.Metal3 9.49214e-06f
Cred_18421 vin2.$562.Metal2 VSS.$68.Metal1 4.6838e-05f
Cred_18422 vin2.$562.Metal2 VSS.P3.pSD 0.00802675f
Cred_18423 vin2.$562.Metal2 VSS.P59.nSD 1.42067e-06f
Cred_18424 vin2.$562.Metal2 VSS.P83.nSD 0.00011298f
Cred_18425 vin2.$564.Metal2 vout2.$1292.Metal3 0.0927722f
Cred_18426 vin2.$564.Metal2 vout2.$1358.Metal3 0.0298818f
Cred_18427 vin2.$564.Metal2 vout2.P10.nSD 0.000494816f
Cred_18428 vin2.$564.Metal2 vout2.P10.pSD 0.00266947f
Cred_18429 vin2.$564.Metal2 vout2.P8.nSD 2.40571e-05f
Cred_18430 vin2.$564.Metal2 vout2.P8.pSD 0.000115459f
Cred_18431 vin2.$564.Metal2 VSS 0.000454548f
Cred_18432 vin2.$564.Metal2 VSS.$1990.Metal1 0.000293302f
Cred_18433 vin2.$564.Metal2 VSS.$3260.Metal2 0.0026226f
Cred_18434 vin2.$564.Metal2 VSS.$3292.Metal2 0.0026226f
Cred_18435 vin2.$564.Metal2 VSS.$68.Metal1 0.0002939f
Cred_18436 vin2.$564.Metal2 VSS.P3.pSD 0.0532676f
Cred_18437 vin2.$564.Metal2 VSS.P59.nSD 1.97814e-07f
Cred_18438 vin2.$564.Metal2 VSS.P83.nSD 1.55832e-05f
Cred_18439 vin2.$566.Metal2 vout2.$1292.Metal3 0.019148f
Cred_18440 vin2.$566.Metal2 vout2.$1358.Metal3 0.00866777f
Cred_18441 vin2.$566.Metal2 vout2.P10.nSD 0.000136553f
Cred_18442 vin2.$566.Metal2 vout2.P10.pSD 0.00109314f
Cred_18443 vin2.$566.Metal2 vout2.P8.pSD 0.000340744f
Cred_18444 vin2.$567.Metal2 vout2.$1292.Metal3 0.0213072f
Cred_18445 vin2.$567.Metal2 vout2.$1358.Metal3 0.00946627f
Cred_18446 vin2.$567.Metal2 vout2.P10.nSD 0.000222271f
Cred_18447 vin2.$567.Metal2 vout2.P10.pSD 0.000807711f
Cred_18448 vin2.$567.Metal2 vout2.P8.nSD 7.09978e-05f
Cred_18449 vin2.$567.Metal2 VSS 0.00326186f
Cred_18450 vin2.$567.Metal2 VSS.$1160.Metal1 1.04645e-05f
Cred_18451 vin2.$567.Metal2 VSS.$1180.Metal1 3.94981e-06f
Cred_18452 vin2.$567.Metal2 VSS.$1990.Metal1 4.72668e-05f
Cred_18453 vin2.$567.Metal2 VSS.$3260.Metal2 0.0174261f
Cred_18454 vin2.$567.Metal2 VSS.$3292.Metal2 0.0186099f
Cred_18455 vin2.$567.Metal2 VSS.$3344.Metal2 0.00118383f
Cred_18456 vin2.$567.Metal2 VSS.$4838.Metal3 9.49168e-06f
Cred_18457 vin2.$567.Metal2 VSS.$68.Metal1 4.22879e-05f
Cred_18458 vin2.$567.Metal2 VSS.P3.pSD 0.0081018f
Cred_18459 vin2.$567.Metal2 VSS.P59.nSD 1.31439e-06f
Cred_18460 vin2.$567.Metal2 VSS.P83.nSD 0.000112877f
Cred_18461 vin2.$570.Metal2 vout2.$1292.Metal3 0.0301756f
Cred_18462 vin2.$570.Metal2 vout2.$1358.Metal3 0.0301756f
Cred_18463 vin2.$570.Metal2 vout2.P10.nSD 0.000475388f
Cred_18464 vin2.$570.Metal2 vout2.P10.pSD 0.0145509f
Cred_18465 vin2.$571.Metal2 vout2.$1292.Metal3 0.0193351f
Cred_18466 vin2.$571.Metal2 vout2.$1358.Metal3 0.0193351f
Cred_18467 vin2.$571.Metal2 vout2.P10.nSD 0.00532148f
Cred_18468 vin2.$571.Metal2 vout2.P10.pSD 0.00164977f
Cred_18469 vin2.$571.Metal2 VSS.$1160.Metal1 1.20657e-05f
Cred_18470 vin2.$571.Metal2 VSS.$1180.Metal1 1.07257e-05f
Cred_18471 vin2.$571.Metal2 VSS.$1990.Metal1 3.46638e-05f
Cred_18472 vin2.$571.Metal2 VSS.$3292.Metal2 0.00118386f
Cred_18473 vin2.$571.Metal2 VSS.$3344.Metal2 0.00311476f
Cred_18474 vin2.$571.Metal2 VSS.$4838.Metal3 9.49194e-06f
Cred_18475 vin2.$571.Metal2 VSS.$68.Metal1 2.23358e-05f
Cred_18476 vin2.$571.Metal2 VSS.P3.pSD 0.00505151f
Cred_18477 vin2.$573.Metal2 vout2.$1292.Metal3 0.0747905f
Cred_18478 vin2.$573.Metal2 vout2.$1358.Metal3 0.0747905f
Cred_18479 vin2.$573.Metal2 vout2.P10.nSD 0.00232652f
Cred_18480 vin2.$573.Metal2 vout2.P10.pSD 0.0107975f
Cred_18481 vin2.$573.Metal2 VSS.$1990.Metal1 0.000416424f
Cred_18482 vin2.$573.Metal2 VSS.$68.Metal1 0.000209592f
Cred_18483 vin2.$573.Metal2 VSS.P3.pSD 0.0536361f
Cred_18484 vin2.$576.Metal2 vout2.$1292.Metal3 0.0384693f
Cred_18485 vin2.$576.Metal2 vout2.$1358.Metal3 0.0384693f
Cred_18486 vin2.$576.Metal2 vout2.P10.nSD 0.0126043f
Cred_18487 vin2.$576.Metal2 vout2.P10.pSD 0.00328239f
Cred_18488 vin2.$576.Metal2 VSS.$1990.Metal1 7.87702e-05f
Cred_18489 vin2.$576.Metal2 VSS.$3392.Metal2 0.00169455f
Cred_18490 vin2.$576.Metal2 VSS.$68.Metal1 3.97335e-05f
Cred_18491 vin2.$576.Metal2 VSS.P3.pSD 0.0101146f
Cred_18492 vin2.$577.Metal2 vout2.$1292.Metal3 0.0244589f
Cred_18493 vin2.$577.Metal2 vout2.$1358.Metal3 0.0244589f
Cred_18494 vin2.$577.Metal2 vout2.P10.nSD 0.000385328f
Cred_18495 vin2.$577.Metal2 vout2.P10.pSD 0.0106749f
Cred_18496 vin2.$580.Metal2 vout2.$1292.Metal3 0.0125416f
Cred_18497 vin2.$580.Metal2 vout2.$1358.Metal3 0.0190751f
Cred_18498 vin2.$580.Metal2 vout2.P10.nSD 0.00135645f
Cred_18499 vin2.$580.Metal2 vout2.P10.pSD 0.00107011f
Cred_18500 vin2.$580.Metal2 vout2.P12.nSD 3.28661e-05f
Cred_18501 vin2.$580.Metal2 VSS.$1220.Metal1 3.79875e-07f
Cred_18502 vin2.$580.Metal2 VSS.$1260.Metal1 3.60907e-05f
Cred_18503 vin2.$580.Metal2 VSS.$1266.Metal1 0.00205336f
Cred_18504 vin2.$580.Metal2 VSS.$1279.Metal1 2.19689e-07f
Cred_18505 vin2.$580.Metal2 VSS.$1990.Metal1 7.80933e-05f
Cred_18506 vin2.$580.Metal2 VSS.$3392.Metal2 0.00355795f
Cred_18507 vin2.$580.Metal2 VSS.$3435.Metal2 0.0240728f
Cred_18508 vin2.$580.Metal2 VSS.$3451.Metal2 0.00186341f
Cred_18509 vin2.$580.Metal2 VSS.$4886.Metal3 1.49404e-05f
Cred_18510 vin2.$580.Metal2 VSS.$68.Metal1 2.36248e-05f
Cred_18511 vin2.$580.Metal2 VSS.P2.pSD 2.32395e-10f
Cred_18512 vin2.$580.Metal2 VSS.P3.pSD 0.00776569f
Cred_18513 vin2.$580.Metal2 VSS.P85.nSD 7.14171e-05f
Cred_18514 vin2.$581.Metal2 vout2.$1292.Metal3 0.00993907f
Cred_18515 vin2.$581.Metal2 vout2.$1358.Metal3 0.0250721f
Cred_18516 vin2.$581.Metal2 vout2.P10.nSD 0.000156581f
Cred_18517 vin2.$581.Metal2 vout2.P10.pSD 0.00131644f
Cred_18518 vin2.$581.Metal2 vout2.P12.pSD 0.000468386f
Cred_18519 vin2.$584.Metal2 vout2.$1292.Metal3 0.0295083f
Cred_18520 vin2.$584.Metal2 vout2.$1358.Metal3 0.0918296f
Cred_18521 vin2.$584.Metal2 vout2.P10.nSD 0.000485851f
Cred_18522 vin2.$584.Metal2 vout2.P10.pSD 0.00254831f
Cred_18523 vin2.$584.Metal2 vout2.P12.nSD 2.09757e-05f
Cred_18524 vin2.$584.Metal2 vout2.P12.pSD 3.05134e-05f
Cred_18525 vin2.$584.Metal2 VSS.$1266.Metal1 0.0011213f
Cred_18526 vin2.$584.Metal2 VSS.$1990.Metal1 0.000589053f
Cred_18527 vin2.$584.Metal2 VSS.$3435.Metal2 0.0131696f
Cred_18528 vin2.$584.Metal2 VSS.$68.Metal1 0.000148505f
Cred_18529 vin2.$584.Metal2 VSS.P3.pSD 0.0536055f
Cred_18530 vin2.$584.Metal2 VSS.P85.nSD 3.89907e-05f
Cred_18531 vin2.$586.Metal2 vout2.$1292.Metal3 0.00150227f
Cred_18532 vin2.$586.Metal2 vout2.$1358.Metal3 0.0150382f
Cred_18533 vin2.$586.Metal2 vout2.P10.nSD 2.36668e-05f
Cred_18534 vin2.$586.Metal2 vout2.P10.pSD 0.000186786f
Cred_18535 vin2.$586.Metal2 vout2.P12.pSD 0.00018411f
Cred_18536 vin2.$587.Metal2 vout2.$1292.Metal3 0.00466478f
Cred_18537 vin2.$587.Metal2 vout2.$1358.Metal3 0.0239312f
Cred_18538 vin2.$587.Metal2 vout2.P10.nSD 0.000113776f
Cred_18539 vin2.$587.Metal2 vout2.P10.pSD 0.000398023f
Cred_18540 vin2.$587.Metal2 vout2.P12.nSD 4.94234e-05f
Cred_18541 vin2.$587.Metal2 VSS.$1266.Metal1 0.00362769f
Cred_18542 vin2.$587.Metal2 VSS.$1311.Metal1 2.89664e-06f
Cred_18543 vin2.$587.Metal2 VSS.$1339.Metal1 1.14797e-05f
Cred_18544 vin2.$587.Metal2 VSS.$1990.Metal1 8.92056e-05f
Cred_18545 vin2.$587.Metal2 VSS.$3435.Metal2 0.0426236f
Cred_18546 vin2.$587.Metal2 VSS.$3507.Metal2 0.00302246f
Cred_18547 vin2.$587.Metal2 VSS.$4910.Metal3 5.05911e-06f
Cred_18548 vin2.$587.Metal2 VSS.$68.Metal1 2.01081e-05f
Cred_18549 vin2.$587.Metal2 VSS.P3.pSD 0.0076153f
Cred_18550 vin2.$587.Metal2 VSS.P85.nSD 0.000126347f
Cred_18551 vin2.$59.GatPoly vout2.$1226.Metal3 0.0029015f
Cred_18552 vin2.$59.GatPoly vout2.$1292.Metal3 0.00203672f
Cred_18553 vin2.$59.GatPoly vout2.P4.nSD 8.10886e-06f
Cred_18554 vin2.$59.GatPoly vout2.P6.nSD 0.00214376f
Cred_18555 vin2.$59.GatPoly vout2.P6.pSD 0.000175361f
Cred_18556 vin2.$59.GatPoly VSS.$1990.Metal1 5.32811e-06f
Cred_18557 vin2.$59.GatPoly VSS.$2914.Metal2 0.00119906f
Cred_18558 vin2.$59.GatPoly VSS.$2946.Metal2 4.55804e-05f
Cred_18559 vin2.$59.GatPoly VSS.$2994.Metal2 4.65484e-08f
Cred_18560 vin2.$59.GatPoly VSS.$4682.Metal3 3.73215e-10f
Cred_18561 vin2.$59.GatPoly VSS.$68.Metal1 6.2806e-05f
Cred_18562 vin2.$59.GatPoly VSS.$744.Metal1 0.00550767f
Cred_18563 vin2.$59.GatPoly VSS.$817.Metal1 8.42002e-06f
Cred_18564 vin2.$59.GatPoly VSS.$837.Metal1 2.21748e-06f
Cred_18565 vin2.$59.GatPoly VSS.P3.pSD 0.00330809f
Cred_18566 vin2.$59.GatPoly VSS.P55.nSD 6.61762e-09f
Cred_18567 vin2.$59.GatPoly VSS.P79.nSD 0.000177406f
Cred_18568 vin2.$590.Metal2 vout2.$1358.Metal3 0.0519778f
Cred_18569 vin2.$590.Metal2 vout2.P12.pSD 0.00988711f
Cred_18570 vin2.$591.Metal2 vout2.$1358.Metal3 0.0577404f
Cred_18571 vin2.$591.Metal2 vout2.P12.nSD 0.00778208f
Cred_18572 vin2.$591.Metal2 VSS.$1266.Metal1 6.50199e-06f
Cred_18573 vin2.$591.Metal2 VSS.$1339.Metal1 1.73049e-06f
Cred_18574 vin2.$591.Metal2 VSS.$1990.Metal1 9.16324e-05f
Cred_18575 vin2.$591.Metal2 VSS.$3435.Metal2 5.84469e-07f
Cred_18576 vin2.$591.Metal2 VSS.$3507.Metal2 0.00239142f
Cred_18577 vin2.$591.Metal2 VSS.$68.Metal1 1.28004e-05f
Cred_18578 vin2.$591.Metal2 VSS.P3.pSD 0.00616587f
Cred_18579 vin2.$591.Metal2 VSS.P85.nSD 2.4666e-07f
Cred_18580 vin2.$593.Metal2 vout2.$1358.Metal3 0.176862f
Cred_18581 vin2.$593.Metal2 vout2.$1424.Metal3 0.00901986f
Cred_18582 vin2.$593.Metal2 vout2.P12.nSD 0.00129007f
Cred_18583 vin2.$593.Metal2 vout2.P12.pSD 0.00144016f
Cred_18584 vin2.$593.Metal2 vout2.P14.nSD 0.000142398f
Cred_18585 vin2.$593.Metal2 vout2.P14.pSD 0.00076962f
Cred_18586 vin2.$593.Metal2 VSS.$1445.Metal1 0.000131611f
Cred_18587 vin2.$593.Metal2 VSS.$1990.Metal1 0.00122868f
Cred_18588 vin2.$593.Metal2 VSS.$3603.Metal2 5.69106e-05f
Cred_18589 vin2.$593.Metal2 VSS.$3638.Metal2 0.00149864f
Cred_18590 vin2.$593.Metal2 VSS.$68.Metal1 0.000130088f
Cred_18591 vin2.$593.Metal2 VSS.P3.pSD 0.071407f
Cred_18592 vin2.$593.Metal2 VSS.P63.nSD 8.27105e-09f
Cred_18593 vin2.$593.Metal2 VSS.P87.nSD 4.56217e-06f
Cred_18594 vin2.$595.Metal2 vout2.$1358.Metal3 0.0705949f
Cred_18595 vin2.$595.Metal2 vout2.P12.pSD 0.0131059f
Cred_18596 vin2.$596.Metal2 vout2.$1358.Metal3 0.0716421f
Cred_18597 vin2.$596.Metal2 vout2.P12.nSD 0.0105277f
Cred_18598 vin2.$596.Metal2 VSS.$1407.Metal1 9.80683e-06f
Cred_18599 vin2.$596.Metal2 VSS.$1427.Metal1 4.81079e-06f
Cred_18600 vin2.$596.Metal2 VSS.$1445.Metal1 1.57363e-06f
Cred_18601 vin2.$596.Metal2 VSS.$1990.Metal1 0.000126823f
Cred_18602 vin2.$596.Metal2 VSS.$3555.Metal2 0.00113253f
Cred_18603 vin2.$596.Metal2 VSS.$3603.Metal2 0.00113253f
Cred_18604 vin2.$596.Metal2 VSS.$3638.Metal2 1.36232e-07f
Cred_18605 vin2.$596.Metal2 VSS.$4958.Metal3 9.08034e-06f
Cred_18606 vin2.$596.Metal2 VSS.$68.Metal1 1.40151e-05f
Cred_18607 vin2.$596.Metal2 VSS.P3.pSD 0.00759093f
Cred_18608 vin2.$596.Metal2 VSS.P63.nSD 7.51865e-13f
Cred_18609 vin2.$596.Metal2 VSS.P87.nSD 5.90182e-08f
Cred_18610 vin2.$600.Metal2 vout2.$1358.Metal3 0.0140062f
Cred_18611 vin2.$600.Metal2 vout2.$1424.Metal3 0.000402309f
Cred_18612 vin2.$600.Metal2 vout2.P12.nSD 2.51091e-05f
Cred_18613 vin2.$600.Metal2 vout2.P14.nSD 7.69108e-06f
Cred_18614 vin2.$600.Metal2 vout2.P14.pSD 3.4327e-05f
Cred_18615 vin2.$600.Metal2 VSS.$1407.Metal1 1.13754e-05f
Cred_18616 vin2.$600.Metal2 VSS.$1427.Metal1 1.07668e-05f
Cred_18617 vin2.$600.Metal2 VSS.$1445.Metal1 0.00144525f
Cred_18618 vin2.$600.Metal2 VSS.$1990.Metal1 8.80901e-05f
Cred_18619 vin2.$600.Metal2 VSS.$3555.Metal2 0.00113256f
Cred_18620 vin2.$600.Metal2 VSS.$3603.Metal2 0.00416061f
Cred_18621 vin2.$600.Metal2 VSS.$3638.Metal2 0.016284f
Cred_18622 vin2.$600.Metal2 VSS.$4958.Metal3 9.0806e-06f
Cred_18623 vin2.$600.Metal2 VSS.$68.Metal1 7.29823e-06f
Cred_18624 vin2.$600.Metal2 VSS.P3.pSD 0.00457845f
Cred_18625 vin2.$600.Metal2 VSS.P63.nSD 8.98714e-08f
Cred_18626 vin2.$600.Metal2 VSS.P87.nSD 5.01416e-05f
Cred_18627 vin2.$601.Metal2 vout2.$1358.Metal3 0.0531514f
Cred_18628 vin2.$601.Metal2 vout2.$1424.Metal3 0.0153467f
Cred_18629 vin2.$601.Metal2 vout2.P12.nSD 1.43057e-07f
Cred_18630 vin2.$601.Metal2 vout2.P12.pSD 0.000804195f
Cred_18631 vin2.$601.Metal2 vout2.P14.nSD 0.000241915f
Cred_18632 vin2.$601.Metal2 vout2.P14.pSD 0.00185992f
Cred_18633 vin2.$601.Metal2 VSS.$1445.Metal1 6.30427e-05f
Cred_18634 vin2.$601.Metal2 VSS.$1990.Metal1 0.000183633f
Cred_18635 vin2.$601.Metal2 VSS.$3603.Metal2 2.72606e-05f
Cred_18636 vin2.$601.Metal2 VSS.$3638.Metal2 0.000717863f
Cred_18637 vin2.$601.Metal2 VSS.$68.Metal1 1.15245e-05f
Cred_18638 vin2.$601.Metal2 VSS.P3.pSD 0.00827243f
Cred_18639 vin2.$601.Metal2 VSS.P63.nSD 3.9619e-09f
Cred_18640 vin2.$601.Metal2 VSS.P87.nSD 2.18532e-06f
Cred_18641 vin2.$605.Metal2 vout2.$1358.Metal3 0.0461637f
Cred_18642 vin2.$605.Metal2 vout2.$1424.Metal3 0.0178808f
Cred_18643 vin2.$605.Metal2 vout2.P12.nSD 9.26598e-05f
Cred_18644 vin2.$605.Metal2 vout2.P14.nSD 0.000472451f
Cred_18645 vin2.$605.Metal2 vout2.P14.pSD 0.00152568f
Cred_18646 vin2.$605.Metal2 VSS.$1445.Metal1 0.00469654f
Cred_18647 vin2.$605.Metal2 VSS.$1490.Metal1 9.62491e-07f
Cred_18648 vin2.$605.Metal2 VSS.$1518.Metal1 6.89594e-06f
Cred_18649 vin2.$605.Metal2 VSS.$1546.Metal1 5.85998e-07f
Cred_18650 vin2.$605.Metal2 VSS.$1990.Metal1 0.000492066f
Cred_18651 vin2.$605.Metal2 VSS.$3603.Metal2 0.00192892f
Cred_18652 vin2.$605.Metal2 VSS.$3638.Metal2 0.0517027f
Cred_18653 vin2.$605.Metal2 VSS.$3694.Metal2 0.00236814f
Cred_18654 vin2.$605.Metal2 VSS.$4994.Metal3 7.27794e-06f
Cred_18655 vin2.$605.Metal2 VSS.$68.Metal1 2.9167e-05f
Cred_18656 vin2.$605.Metal2 VSS.P2.pSD 3.58279e-10f
Cred_18657 vin2.$605.Metal2 VSS.P3.pSD 0.021478f
Cred_18658 vin2.$605.Metal2 VSS.P63.nSD 2.80338e-07f
Cred_18659 vin2.$605.Metal2 VSS.P87.nSD 0.000163835f
Cred_18660 vin2.$608.Metal2 vout2.$1358.Metal3 0.00918213f
Cred_18661 vin2.$608.Metal2 vout2.$1424.Metal3 0.00907964f
Cred_18662 vin2.$608.Metal2 vout2.P12.pSD 6.65553e-06f
Cred_18663 vin2.$608.Metal2 vout2.P14.nSD 0.000143041f
Cred_18664 vin2.$608.Metal2 vout2.P14.pSD 0.00173063f
Cred_18665 vin2.$610.Metal2 vout2.$1358.Metal3 0.0291332f
Cred_18666 vin2.$610.Metal2 vout2.$1424.Metal3 0.0291332f
Cred_18667 vin2.$610.Metal2 vout2.P14.nSD 0.000458966f
Cred_18668 vin2.$610.Metal2 vout2.P14.pSD 0.0159242f
Cred_18669 vin2.$611.Metal2 vout2.$1358.Metal3 0.036807f
Cred_18670 vin2.$611.Metal2 vout2.$1424.Metal3 0.036807f
Cred_18671 vin2.$611.Metal2 vout2.P14.nSD 0.0118473f
Cred_18672 vin2.$611.Metal2 vout2.P14.pSD 0.00314056f
Cred_18673 vin2.$611.Metal2 VSS.$1445.Metal1 0.000373998f
Cred_18674 vin2.$611.Metal2 VSS.$1490.Metal1 4.76709e-07f
Cred_18675 vin2.$611.Metal2 VSS.$1518.Metal1 4.30884e-06f
Cred_18676 vin2.$611.Metal2 VSS.$1546.Metal1 1.18318e-06f
Cred_18677 vin2.$611.Metal2 VSS.$1990.Metal1 0.000299231f
Cred_18678 vin2.$611.Metal2 VSS.$3603.Metal2 0.000161723f
Cred_18679 vin2.$611.Metal2 VSS.$3638.Metal2 0.00470828f
Cred_18680 vin2.$611.Metal2 VSS.$3694.Metal2 0.00339829f
Cred_18681 vin2.$611.Metal2 VSS.$4994.Metal3 3.60467e-06f
Cred_18682 vin2.$611.Metal2 VSS.$68.Metal1 1.02073e-05f
Cred_18683 vin2.$611.Metal2 VSS.P2.pSD 7.23397e-10f
Cred_18684 vin2.$611.Metal2 VSS.P3.pSD 0.00982483f
Cred_18685 vin2.$611.Metal2 VSS.P63.nSD 2.35038e-08f
Cred_18686 vin2.$611.Metal2 VSS.P87.nSD 1.29643e-05f
Cred_18687 vin2.$613.Metal2 vout2.$1358.Metal3 0.0982929f
Cred_18688 vin2.$613.Metal2 vout2.$1424.Metal3 0.0792964f
Cred_18689 vin2.$613.Metal2 vout2.P12.nSD 2.98653e-07f
Cred_18690 vin2.$613.Metal2 vout2.P14.nSD 0.00247466f
Cred_18691 vin2.$613.Metal2 vout2.P14.pSD 0.00812867f
Cred_18692 vin2.$613.Metal2 VSS.$1445.Metal1 0.000131611f
Cred_18693 vin2.$613.Metal2 VSS.$1990.Metal1 0.00210013f
Cred_18694 vin2.$613.Metal2 VSS.$3603.Metal2 5.69106e-05f
Cred_18695 vin2.$613.Metal2 VSS.$3638.Metal2 0.00149864f
Cred_18696 vin2.$613.Metal2 VSS.$68.Metal1 7.75295e-05f
Cred_18697 vin2.$613.Metal2 VSS.P3.pSD 0.0712918f
Cred_18698 vin2.$613.Metal2 VSS.P63.nSD 8.27105e-09f
Cred_18699 vin2.$613.Metal2 VSS.P87.nSD 4.56217e-06f
Cred_18700 vin2.$615.Metal2 vout2.$1358.Metal3 0.0231172f
Cred_18701 vin2.$615.Metal2 vout2.$1424.Metal3 0.0231172f
Cred_18702 vin2.$615.Metal2 vout2.P14.nSD 0.00036419f
Cred_18703 vin2.$615.Metal2 vout2.P14.pSD 0.010938f
Cred_18704 vin2.$616.Metal2 vout2.$1358.Metal3 0.0276082f
Cred_18705 vin2.$616.Metal2 vout2.$1424.Metal3 0.0276082f
Cred_18706 vin2.$616.Metal2 vout2.P14.nSD 0.00752093f
Cred_18707 vin2.$616.Metal2 vout2.P14.pSD 0.00235568f
Cred_18708 vin2.$616.Metal2 VSS.$1566.Metal1 2.28519e-06f
Cred_18709 vin2.$616.Metal2 VSS.$1586.Metal1 2.1546e-06f
Cred_18710 vin2.$616.Metal2 VSS.$1990.Metal1 0.000181373f
Cred_18711 vin2.$616.Metal2 VSS.$3718.Metal2 0.000554701f
Cred_18712 vin2.$616.Metal2 VSS.$3766.Metal2 0.00305041f
Cred_18713 vin2.$616.Metal2 VSS.$5030.Metal3 4.44747e-06f
Cred_18714 vin2.$616.Metal2 VSS.$68.Metal1 4.6833e-06f
Cred_18715 vin2.$616.Metal2 VSS.P3.pSD 0.00516648f
Cred_18716 vin2.$619.Metal2 vout2.$1358.Metal3 0.00660463f
Cred_18717 vin2.$619.Metal2 vout2.$1424.Metal3 0.0109848f
Cred_18718 vin2.$619.Metal2 vout2.P14.nSD 0.00010405f
Cred_18719 vin2.$619.Metal2 vout2.P14.pSD 0.000659154f
Cred_18720 vin2.$619.Metal2 vout2.P16.pSD 9.56129e-05f
Cred_18721 vin2.$620.Metal2 vout2.$1358.Metal3 0.00640448f
Cred_18722 vin2.$620.Metal2 vout2.$1424.Metal3 0.010863f
Cred_18723 vin2.$620.Metal2 vout2.P14.nSD 0.000118081f
Cred_18724 vin2.$620.Metal2 vout2.P14.pSD 0.000546463f
Cred_18725 vin2.$620.Metal2 vout2.P16.nSD 1.71843e-05f
Cred_18726 vin2.$620.Metal2 VSS.$1606.Metal1 4.04686e-07f
Cred_18727 vin2.$620.Metal2 VSS.$1624.Metal1 0.00245323f
Cred_18728 vin2.$620.Metal2 VSS.$1629.Metal1 3.52655e-06f
Cred_18729 vin2.$620.Metal2 VSS.$1990.Metal1 0.000264532f
Cred_18730 vin2.$620.Metal2 VSS.$3766.Metal2 0.00298634f
Cred_18731 vin2.$620.Metal2 VSS.$3809.Metal2 0.0277271f
Cred_18732 vin2.$620.Metal2 VSS.$5054.Metal3 3.93375e-06f
Cred_18733 vin2.$620.Metal2 VSS.$68.Metal1 4.73034e-06f
Cred_18734 vin2.$620.Metal2 VSS.P3.pSD 0.00622947f
Cred_18735 vin2.$620.Metal2 VSS.P89.nSD 8.58485e-05f
Cred_18736 vin2.$622.Metal2 vout2.$1358.Metal3 0.028528f
Cred_18737 vin2.$622.Metal2 vout2.$1424.Metal3 0.0879111f
Cred_18738 vin2.$622.Metal2 vout2.P14.nSD 0.000457527f
Cred_18739 vin2.$622.Metal2 vout2.P14.pSD 0.0024792f
Cred_18740 vin2.$622.Metal2 vout2.P16.nSD 8.09507e-06f
Cred_18741 vin2.$622.Metal2 vout2.P16.pSD 4.50408e-05f
Cred_18742 vin2.$622.Metal2 VSS.$1624.Metal1 0.000401659f
Cred_18743 vin2.$622.Metal2 VSS.$1990.Metal1 0.00229387f
Cred_18744 vin2.$622.Metal2 VSS.$3809.Metal2 0.00476634f
Cred_18745 vin2.$622.Metal2 VSS.$68.Metal1 3.58677e-05f
Cred_18746 vin2.$622.Metal2 VSS.P3.pSD 0.0505008f
Cred_18747 vin2.$622.Metal2 VSS.P89.nSD 1.3949e-05f
Cred_18748 vin2.$624.Metal2 vout2.$1358.Metal3 0.00634131f
Cred_18749 vin2.$624.Metal2 vout2.$1424.Metal3 0.0261527f
Cred_18750 vin2.$624.Metal2 vout2.P14.nSD 9.99013e-05f
Cred_18751 vin2.$624.Metal2 vout2.P14.pSD 0.000957923f
Cred_18752 vin2.$624.Metal2 vout2.P16.pSD 0.000416851f
Cred_18753 vin2.$625.Metal2 vout2.$1358.Metal3 0.00650663f
Cred_18754 vin2.$625.Metal2 vout2.$1424.Metal3 0.036376f
Cred_18755 vin2.$625.Metal2 vout2.P14.nSD 0.00017198f
Cred_18756 vin2.$625.Metal2 vout2.P14.pSD 0.000555179f
Cred_18757 vin2.$625.Metal2 vout2.P16.nSD 0.00104885f
Cred_18758 vin2.$625.Metal2 VSS.$1624.Metal1 0.00385056f
Cred_18759 vin2.$625.Metal2 VSS.$1685.Metal1 8.52825e-06f
Cred_18760 vin2.$625.Metal2 VSS.$1705.Metal1 3.8105e-06f
Cred_18761 vin2.$625.Metal2 VSS.$1990.Metal1 0.000452537f
Cred_18762 vin2.$625.Metal2 VSS.$3809.Metal2 0.0451789f
Cred_18763 vin2.$625.Metal2 VSS.$3825.Metal2 0.0015412f
Cred_18764 vin2.$625.Metal2 VSS.$3881.Metal2 0.00256116f
Cred_18765 vin2.$625.Metal2 VSS.$5078.Metal3 1.2357e-05f
Cred_18766 vin2.$625.Metal2 VSS.$68.Metal1 6.12383e-06f
Cred_18767 vin2.$625.Metal2 VSS.P3.pSD 0.00921024f
Cred_18768 vin2.$625.Metal2 VSS.P89.nSD 0.000133911f
Cred_18769 vin2.$628.Metal2 vout2.$1424.Metal3 0.0538987f
Cred_18770 vin2.$628.Metal2 vout2.P16.pSD 0.00930781f
Cred_18771 vin2.$631.Metal2 vout2.$1424.Metal3 0.0918079f
Cred_18772 vin2.$631.Metal2 vout2.P16.nSD 0.0129837f
Cred_18773 vin2.$631.Metal2 VSS.$1624.Metal1 5.37786e-05f
Cred_18774 vin2.$631.Metal2 VSS.$1685.Metal1 4.22399e-06f
Cred_18775 vin2.$631.Metal2 VSS.$1705.Metal1 1.88732e-06f
Cred_18776 vin2.$631.Metal2 VSS.$1990.Metal1 0.000754158f
Cred_18777 vin2.$631.Metal2 VSS.$3809.Metal2 0.00063817f
Cred_18778 vin2.$631.Metal2 VSS.$3825.Metal2 0.000763347f
Cred_18779 vin2.$631.Metal2 VSS.$3881.Metal2 0.00282265f
Cred_18780 vin2.$631.Metal2 VSS.$5078.Metal3 6.12034e-06f
Cred_18781 vin2.$631.Metal2 VSS.$68.Metal1 6.14319e-06f
Cred_18782 vin2.$631.Metal2 VSS.P3.pSD 0.011727f
Cred_18783 vin2.$631.Metal2 VSS.P89.nSD 1.86765e-06f
Cred_18784 vin2.$633.Metal2 vout2.$1424.Metal3 0.156738f
Cred_18785 vin2.$633.Metal2 vout2.P16.nSD 0.00114517f
Cred_18786 vin2.$633.Metal2 vout2.P16.pSD 0.0046241f
Cred_18787 vin2.$633.Metal2 VSS.$1990.Metal1 0.0032525f
Cred_18788 vin2.$633.Metal2 VSS.$68.Metal1 2.54348e-05f
Cred_18789 vin2.$633.Metal2 VSS.P3.pSD 0.0497379f
Cred_18790 vin2.$635.Metal2 vout2.$1424.Metal3 0.0588585f
Cred_18791 vin2.$635.Metal2 vout2.P16.pSD 0.010786f
Cred_18792 vin2.$636.Metal2 vout2.$1424.Metal3 0.0361747f
Cred_18793 vin2.$636.Metal2 vout2.P16.nSD 0.00424937f
Cred_18794 vin2.$636.Metal2 VSS.$1745.Metal1 4.92789e-07f
Cred_18795 vin2.$636.Metal2 VSS.$1773.Metal1 1.12553e-05f
Cred_18796 vin2.$636.Metal2 VSS.$1793.Metal1 1.26139e-06f
Cred_18797 vin2.$636.Metal2 VSS.$1799.Metal1 1.75061e-05f
Cred_18798 vin2.$636.Metal2 VSS.$1990.Metal1 0.000329249f
Cred_18799 vin2.$636.Metal2 VSS.$3929.Metal2 0.00353881f
Cred_18800 vin2.$636.Metal2 VSS.$3988.Metal2 0.00119052f
Cred_18801 vin2.$636.Metal2 VSS.$4020.Metal2 6.70053e-07f
Cred_18802 vin2.$636.Metal2 VSS.$5126.Metal3 9.5381e-06f
Cred_18803 vin2.$636.Metal2 VSS.$68.Metal1 1.96932e-06f
Cred_18804 vin2.$636.Metal2 VSS.P2.pSD 3.01291e-10f
Cred_18805 vin2.$636.Metal2 VSS.P3.pSD 0.0043762f
Cred_18806 vin2.$636.Metal2 VSS.P67.nSD 5.79358e-11f
Cred_18807 vin2.$636.Metal2 VSS.P91.nSD 6.6924e-07f
Cred_18808 vin2.$639.Metal2 vout2 0.00144545f
Cred_18809 vin2.$639.Metal2 vout2.$1424.Metal3 0.0258238f
Cred_18810 vin2.$639.Metal2 vout2.P16.pSD 0.000359875f
Cred_18811 vin2.$639.Metal2 vout2.P18.nSD 0.000114848f
Cred_18812 vin2.$639.Metal2 vout2.P18.pSD 0.000882401f
Cred_18813 vin2.$64.GatPoly vout2.$1226.Metal3 0.012872f
Cred_18814 vin2.$64.GatPoly vout2.$1292.Metal3 0.0146682f
Cred_18815 vin2.$64.GatPoly vout2.P6.nSD 0.000202787f
Cred_18816 vin2.$64.GatPoly vout2.P6.pSD 0.0198092f
Cred_18817 vin2.$64.GatPoly vout2.P8.pSD 0.000126207f
Cred_18818 vin2.$640.Metal2 vout2 0.00147839f
Cred_18819 vin2.$640.Metal2 vout2.$1424.Metal3 0.0275791f
Cred_18820 vin2.$640.Metal2 vout2.P16.nSD 7.17394e-05f
Cred_18821 vin2.$640.Metal2 vout2.P18.nSD 0.00016196f
Cred_18822 vin2.$640.Metal2 vout2.P18.pSD 0.000636201f
Cred_18823 vin2.$640.Metal2 VSS.$1773.Metal1 1.23083e-05f
Cred_18824 vin2.$640.Metal2 VSS.$1793.Metal1 1.26142e-06f
Cred_18825 vin2.$640.Metal2 VSS.$1799.Metal1 0.00370329f
Cred_18826 vin2.$640.Metal2 VSS.$1990.Metal1 0.000719861f
Cred_18827 vin2.$640.Metal2 VSS.$3929.Metal2 0.00118965f
Cred_18828 vin2.$640.Metal2 VSS.$3988.Metal2 0.0246652f
Cred_18829 vin2.$640.Metal2 VSS.$4020.Metal2 0.0174818f
Cred_18830 vin2.$640.Metal2 VSS.$5126.Metal3 9.53834e-06f
Cred_18831 vin2.$640.Metal2 VSS.$68.Metal1 3.0301e-06f
Cred_18832 vin2.$640.Metal2 VSS.P3.pSD 0.00787323f
Cred_18833 vin2.$640.Metal2 VSS.P67.nSD 1.51156e-06f
Cred_18834 vin2.$640.Metal2 VSS.P91.nSD 0.000127662f
Cred_18835 vin2.$642.Metal2 vout2 0.0213644f
Cred_18836 vin2.$642.Metal2 vout2.$1424.Metal3 0.169796f
Cred_18837 vin2.$642.Metal2 vout2.P16.nSD 2.07511e-05f
Cred_18838 vin2.$642.Metal2 vout2.P16.pSD 0.000104096f
Cred_18839 vin2.$642.Metal2 vout2.P18.nSD 0.00209452f
Cred_18840 vin2.$642.Metal2 vout2.P18.pSD 0.00968706f
Cred_18841 vin2.$642.Metal2 VSS.$1799.Metal1 0.000448976f
Cred_18842 vin2.$642.Metal2 VSS.$1990.Metal1 0.00822701f
Cred_18843 vin2.$642.Metal2 VSS.$3988.Metal2 0.0029713f
Cred_18844 vin2.$642.Metal2 VSS.$4020.Metal2 0.00221267f
Cred_18845 vin2.$642.Metal2 VSS.$68.Metal1 2.40756e-05f
Cred_18846 vin2.$642.Metal2 VSS.P3.pSD 0.0716776f
Cred_18847 vin2.$642.Metal2 VSS.P67.nSD 1.91318e-07f
Cred_18848 vin2.$642.Metal2 VSS.P91.nSD 1.53963e-05f
Cred_18849 vin2.$644.Metal2 vout2 0.00236295f
Cred_18850 vin2.$644.Metal2 vout2.$1424.Metal3 0.0200647f
Cred_18851 vin2.$644.Metal2 vout2.P16.pSD 0.000267992f
Cred_18852 vin2.$644.Metal2 vout2.P18.nSD 0.000187749f
Cred_18853 vin2.$644.Metal2 vout2.P18.pSD 0.00121076f
Cred_18854 vin2.$645.Metal2 vout2 0.0023875f
Cred_18855 vin2.$645.Metal2 vout2.$1424.Metal3 0.0213719f
Cred_18856 vin2.$645.Metal2 vout2.P16.nSD 5.34229e-05f
Cred_18857 vin2.$645.Metal2 vout2.P18.nSD 0.000222834f
Cred_18858 vin2.$645.Metal2 vout2.P18.pSD 0.00102742f
Cred_18859 vin2.$645.Metal2 VSS.$1799.Metal1 0.00303595f
Cred_18860 vin2.$645.Metal2 VSS.$1864.Metal1 9.77308e-06f
Cred_18861 vin2.$645.Metal2 VSS.$1884.Metal1 7.41063e-06f
Cred_18862 vin2.$645.Metal2 VSS.$1990.Metal1 0.000566846f
Cred_18863 vin2.$645.Metal2 VSS.$3988.Metal2 0.0191202f
Cred_18864 vin2.$645.Metal2 VSS.$4020.Metal2 0.0154724f
Cred_18865 vin2.$645.Metal2 VSS.$4068.Metal2 0.00123397f
Cred_18866 vin2.$645.Metal2 VSS.$5162.Metal3 9.89367e-06f
Cred_18867 vin2.$645.Metal2 VSS.$68.Metal1 1.89929e-06f
Cred_18868 vin2.$645.Metal2 VSS.P3.pSD 0.00546856f
Cred_18869 vin2.$645.Metal2 VSS.P67.nSD 1.23112e-06f
Cred_18870 vin2.$645.Metal2 VSS.P91.nSD 0.000104727f
Cred_18871 vin2.$648.Metal2 vout2 0.00759115f
Cred_18872 vin2.$648.Metal2 vout2.$1424.Metal3 0.0382858f
Cred_18873 vin2.$648.Metal2 vout2.P18.nSD 0.000628695f
Cred_18874 vin2.$648.Metal2 vout2.P18.pSD 0.0119231f
Cred_18875 vin2.$648.Metal2 VSS.$1990.Metal1 0.000237127f
Cred_18876 vin2.$648.Metal2 VSS.$4140.Metal2 2.05108e-05f
Cred_18877 vin2.$648.Metal2 VSS.$68.Metal1 3.99498e-07f
Cred_18878 vin2.$648.Metal2 VSS.P3.pSD 0.00151636f
Cred_18879 vin2.$649.Metal2 vout2 0.00787611f
Cred_18880 vin2.$649.Metal2 vout2.$1424.Metal3 0.039723f
Cred_18881 vin2.$649.Metal2 vout2.P18.nSD 0.00696391f
Cred_18882 vin2.$649.Metal2 vout2.P18.pSD 0.0034127f
Cred_18883 vin2.$649.Metal2 VSS.$1799.Metal1 8.23052e-06f
Cred_18884 vin2.$649.Metal2 VSS.$1864.Metal1 3.12966e-06f
Cred_18885 vin2.$649.Metal2 VSS.$1884.Metal1 7.41051e-06f
Cred_18886 vin2.$649.Metal2 VSS.$1952.Metal1 2.6659e-05f
Cred_18887 vin2.$649.Metal2 VSS.$1990.Metal1 0.00105295f
Cred_18888 vin2.$649.Metal2 VSS.$2021.Metal1 1.83151e-05f
Cred_18889 vin2.$649.Metal2 VSS.$3988.Metal2 4.23036e-07f
Cred_18890 vin2.$649.Metal2 VSS.$4020.Metal2 0.00123426f
Cred_18891 vin2.$649.Metal2 VSS.$4068.Metal2 0.00280513f
Cred_18892 vin2.$649.Metal2 VSS.$4116.Metal2 1.09942e-06f
Cred_18893 vin2.$649.Metal2 VSS.$4164.Metal2 4.51447e-07f
Cred_18894 vin2.$649.Metal2 VSS.$5162.Metal3 9.89351e-06f
Cred_18895 vin2.$649.Metal2 VSS.$68.Metal1 1.96385e-06f
Cred_18896 vin2.$649.Metal2 VSS.P3.pSD 0.00717092f
Cred_18897 vin2.$649.Metal2 VSS.P67.nSD 2.72387e-11f
Cred_18898 vin2.$649.Metal2 VSS.P7.GatPoly 3.41867e-05f
Cred_18899 vin2.$649.Metal2 VSS.P91.nSD 3.1529e-07f
Cred_18900 vin2.$649.Metal2 VSS.P93.nSD 1.26489e-07f
Cred_18901 vin2.$649.Metal2 VSS.P95.nSD 1.26489e-07f
Cred_18902 vin2.$65.GatPoly vout2.$1226.Metal3 0.00430056f
Cred_18903 vin2.$65.GatPoly vout2.$1292.Metal3 0.00446847f
Cred_18904 vin2.$65.GatPoly vout2.P4.nSD 5.23911e-07f
Cred_18905 vin2.$65.GatPoly vout2.P6.nSD 0.00598165f
Cred_18906 vin2.$65.GatPoly vout2.P6.pSD 0.000365466f
Cred_18907 vin2.$65.GatPoly vout2.P8.nSD 2.09838e-06f
Cred_18908 vin2.$65.GatPoly VSS.$1990.Metal1 7.44598e-06f
Cred_18909 vin2.$65.GatPoly VSS.$2914.Metal2 6.46511e-05f
Cred_18910 vin2.$65.GatPoly VSS.$2946.Metal2 2.45511e-06f
Cred_18911 vin2.$65.GatPoly VSS.$3085.Metal2 0.000270194f
Cred_18912 vin2.$65.GatPoly VSS.$68.Metal1 5.68224e-05f
Cred_18913 vin2.$65.GatPoly VSS.$744.Metal1 0.000154764f
Cred_18914 vin2.$65.GatPoly VSS.$923.Metal1 0.000634609f
Cred_18915 vin2.$65.GatPoly VSS.P3.pSD 0.00373171f
Cred_18916 vin2.$65.GatPoly VSS.P55.nSD 3.56811e-10f
Cred_18917 vin2.$65.GatPoly VSS.P79.nSD 5.79149e-06f
Cred_18918 vin2.$65.GatPoly VSS.P81.nSD 2.37508e-05f
Cred_18919 vin2.$653.Metal2 vout2 0.0188727f
Cred_18920 vin2.$653.Metal2 vout2.$1424.Metal3 0.0951841f
Cred_18921 vin2.$653.Metal2 vout2.P18.nSD 0.00159718f
Cred_18922 vin2.$653.Metal2 vout2.P18.pSD 0.029659f
Cred_18923 vin2.$653.Metal2 VSS.$1990.Metal1 0.000906663f
Cred_18924 vin2.$653.Metal2 VSS.$4140.Metal2 0.000101763f
Cred_18925 vin2.$653.Metal2 VSS.$68.Metal1 1.52749e-06f
Cred_18926 vin2.$653.Metal2 VSS.P3.pSD 0.00579784f
Cred_18927 vin2.$654.Metal2 vout2 0.0189692f
Cred_18928 vin2.$654.Metal2 vout2.$1424.Metal3 0.0956705f
Cred_18929 vin2.$654.Metal2 vout2.P18.nSD 0.0163347f
Cred_18930 vin2.$654.Metal2 vout2.P18.pSD 0.00825231f
Cred_18931 vin2.$654.Metal2 VSS.$1952.Metal1 0.000146429f
Cred_18932 vin2.$654.Metal2 VSS.$1990.Metal1 0.00325836f
Cred_18933 vin2.$654.Metal2 VSS.$2021.Metal1 9.47858e-05f
Cred_18934 vin2.$654.Metal2 VSS.$4116.Metal2 0.00327421f
Cred_18935 vin2.$654.Metal2 VSS.$4164.Metal2 2.33636e-06f
Cred_18936 vin2.$654.Metal2 VSS.$68.Metal1 4.86936e-06f
Cred_18937 vin2.$654.Metal2 VSS.P3.pSD 0.0195316f
Cred_18938 vin2.$654.Metal2 VSS.P7.GatPoly 0.000176926f
Cred_18939 vin2.$654.Metal2 VSS.P93.nSD 6.54617e-07f
Cred_18940 vin2.$654.Metal2 VSS.P95.nSD 6.54617e-07f
Cred_18941 vin2.$7.GatPoly vout2.$1226.Metal3 0.0076483f
Cred_18942 vin2.$7.GatPoly vout2.P0.nSD 0.00586264f
Cred_18943 vin2.$7.GatPoly vout2.P0.pSD 0.00119109f
Cred_18944 vin2.$7.GatPoly vout2.P2.nSD 0.00012312f
Cred_18945 vin2.$7.GatPoly vout2.P2.pSD 0.000658515f
Cred_18946 vin2.$7.GatPoly VSS.$158.Metal1 0.000221962f
Cred_18947 vin2.$7.GatPoly VSS.$1990.Metal1 1.31269e-06f
Cred_18948 vin2.$7.GatPoly VSS.$2228.Metal2 7.67149e-05f
Cred_18949 vin2.$7.GatPoly VSS.$2409.Metal2 4.14065e-06f
Cred_18950 vin2.$7.GatPoly VSS.$2433.Metal2 4.75607e-06f
Cred_18951 vin2.$7.GatPoly VSS.$2532.Metal2 2.03093e-05f
Cred_18952 vin2.$7.GatPoly VSS.$2564.Metal2 2.72725e-05f
Cred_18953 vin2.$7.GatPoly VSS.$292.Metal1 4.56443e-05f
Cred_18954 vin2.$7.GatPoly VSS.$386.Metal1 0.00053061f
Cred_18955 vin2.$7.GatPoly VSS.$4358.Metal3 1.19413e-05f
Cred_18956 vin2.$7.GatPoly VSS.$68.Metal1 0.000704208f
Cred_18957 vin2.$7.GatPoly VSS.P3.pSD 0.00487998f
Cred_18958 vin2.$7.GatPoly VSS.P51.nSD 1.75604e-09f
Cred_18959 vin2.$7.GatPoly VSS.P6.GatPoly 0.000379998f
Cred_18960 vin2.$7.GatPoly VSS.P72.nSD 1.52282e-06f
Cred_18961 vin2.$7.GatPoly VSS.P73.nSD 1.52282e-06f
Cred_18962 vin2.$7.GatPoly VSS.P75.nSD 1.98985e-05f
Cred_18963 vin2.$71.GatPoly vout2.$1226.Metal3 0.00101616f
Cred_18964 vin2.$71.GatPoly vout2.$1292.Metal3 0.00154863f
Cred_18965 vin2.$71.GatPoly vout2.P6.nSD 0.000877937f
Cred_18966 vin2.$71.GatPoly vout2.P6.pSD 8.74912e-05f
Cred_18967 vin2.$71.GatPoly vout2.P8.nSD 4.99287e-06f
Cred_18968 vin2.$71.GatPoly VSS.$1990.Metal1 8.34319e-06f
Cred_18969 vin2.$71.GatPoly VSS.$3042.Metal2 6.68699e-08f
Cred_18970 vin2.$71.GatPoly VSS.$3085.Metal2 0.00102568f
Cred_18971 vin2.$71.GatPoly VSS.$68.Metal1 4.07451e-05f
Cred_18972 vin2.$71.GatPoly VSS.$905.Metal1 8.41646e-06f
Cred_18973 vin2.$71.GatPoly VSS.$923.Metal1 0.00839157f
Cred_18974 vin2.$71.GatPoly VSS.P3.pSD 0.00335249f
Cred_18975 vin2.$71.GatPoly VSS.P81.nSD 0.000219307f
Cred_18976 vin2.$72.GatPoly vout2.$1226.Metal3 0.00583736f
Cred_18977 vin2.$72.GatPoly vout2.$1292.Metal3 0.00722747f
Cred_18978 vin2.$72.GatPoly vout2.P6.nSD 9.19621e-05f
Cred_18979 vin2.$72.GatPoly vout2.P6.pSD 0.00810359f
Cred_18980 vin2.$72.GatPoly vout2.P8.pSD 9.76778e-05f
Cred_18981 vin2.$76.GatPoly vout2.$1226.Metal3 0.00277707f
Cred_18982 vin2.$76.GatPoly vout2.$1292.Metal3 0.0545756f
Cred_18983 vin2.$76.GatPoly vout2.P6.nSD 4.37501e-05f
Cred_18984 vin2.$76.GatPoly vout2.P6.pSD 0.00064954f
Cred_18985 vin2.$76.GatPoly vout2.P8.pSD 0.0321726f
Cred_18986 vin2.$79.GatPoly vout2.$1226.Metal3 0.000284706f
Cred_18987 vin2.$79.GatPoly vout2.$1292.Metal3 0.00270625f
Cred_18988 vin2.$79.GatPoly vout2.P6.nSD 1.00965e-05f
Cred_18989 vin2.$79.GatPoly vout2.P6.pSD 2.4513e-05f
Cred_18990 vin2.$79.GatPoly vout2.P8.nSD 0.00100732f
Cred_18991 vin2.$79.GatPoly VSS.$1024.Metal1 2.6329e-07f
Cred_18992 vin2.$79.GatPoly VSS.$1990.Metal1 8.70948e-06f
Cred_18993 vin2.$79.GatPoly VSS.$3085.Metal2 0.00105531f
Cred_18994 vin2.$79.GatPoly VSS.$3157.Metal2 1.47491e-09f
Cred_18995 vin2.$79.GatPoly VSS.$68.Metal1 2.9206e-05f
Cred_18996 vin2.$79.GatPoly VSS.$923.Metal1 0.00746252f
Cred_18997 vin2.$79.GatPoly VSS.$996.Metal1 1.29476e-05f
Cred_18998 vin2.$79.GatPoly VSS.P2.pSD 1.61072e-10f
Cred_18999 vin2.$79.GatPoly VSS.P3.pSD 0.00290496f
Cred_19000 vin2.$79.GatPoly VSS.P81.nSD 0.000201959f
Cred_19001 vin2.$8.GatPoly vout2.$1226.Metal3 0.0447792f
Cred_19002 vin2.$8.GatPoly vout2.P0.nSD 0.00125947f
Cred_19003 vin2.$8.GatPoly vout2.P0.pSD 0.0416323f
Cred_19004 vin2.$8.GatPoly vout2.P2.nSD 0.000705455f
Cred_19005 vin2.$8.GatPoly vout2.P2.pSD 0.00425854f
Cred_19006 vin2.$8.GatPoly VSS.$1990.Metal1 3.45158e-09f
Cred_19007 vin2.$8.GatPoly VSS.$2409.Metal2 1.21987e-06f
Cred_19008 vin2.$8.GatPoly VSS.$2433.Metal2 8.94547e-07f
Cred_19009 vin2.$8.GatPoly VSS.$4358.Metal3 7.75182e-06f
Cred_19010 vin2.$8.GatPoly VSS.$4418.Metal3 0.000152145f
Cred_19011 vin2.$8.GatPoly VSS.$4454.Metal3 0.00011157f
Cred_19012 vin2.$8.GatPoly VSS.$68.Metal1 7.41556e-06f
Cred_19013 vin2.$8.GatPoly VSS.P3.pSD 2.24003e-05f
Cred_19014 vin2.$8.GatPoly VSS.P6.GatPoly 1.62293e-06f
Cred_19015 vin2.$81.GatPoly vout2.$1226.Metal3 0.000199294f
Cred_19016 vin2.$81.GatPoly vout2.$1292.Metal3 0.00189437f
Cred_19017 vin2.$81.GatPoly vout2.P6.nSD 7.06754e-06f
Cred_19018 vin2.$81.GatPoly vout2.P6.pSD 1.71591e-05f
Cred_19019 vin2.$81.GatPoly vout2.P8.nSD 0.000705121f
Cred_19020 vin2.$81.GatPoly VSS.$1024.Metal1 5.3362e-07f
Cred_19021 vin2.$81.GatPoly VSS.$1990.Metal1 5.84669e-06f
Cred_19022 vin2.$81.GatPoly VSS.$3085.Metal2 0.00051197f
Cred_19023 vin2.$81.GatPoly VSS.$3157.Metal2 2.98926e-09f
Cred_19024 vin2.$81.GatPoly VSS.$68.Metal1 1.52101e-05f
Cred_19025 vin2.$81.GatPoly VSS.$923.Metal1 0.0011921f
Cred_19026 vin2.$81.GatPoly VSS.$996.Metal1 1.40225e-06f
Cred_19027 vin2.$81.GatPoly VSS.P2.pSD 3.2645e-10f
Cred_19028 vin2.$81.GatPoly VSS.P3.pSD 0.00172124f
Cred_19029 vin2.$81.GatPoly VSS.P81.nSD 4.46145e-05f
Cred_19030 vin2.$82.GatPoly vout2.$1292.Metal3 0.0109782f
Cred_19031 vin2.$82.GatPoly vout2.P8.pSD 0.0092696f
Cred_19032 vin2.$83.GatPoly vout2.$1292.Metal3 0.00728129f
Cred_19033 vin2.$83.GatPoly vout2.$1358.Metal3 4.09926e-05f
Cred_19034 vin2.$83.GatPoly vout2.P10.nSD 1.45342e-06f
Cred_19035 vin2.$83.GatPoly vout2.P10.pSD 3.49769e-06f
Cred_19036 vin2.$83.GatPoly vout2.P8.nSD 0.00574639f
Cred_19037 vin2.$83.GatPoly VSS 0.000249314f
Cred_19038 vin2.$83.GatPoly VSS.$1990.Metal1 1.38781e-05f
Cred_19039 vin2.$83.GatPoly VSS.$3260.Metal2 5.25068e-05f
Cred_19040 vin2.$83.GatPoly VSS.$3292.Metal2 5.25068e-05f
Cred_19041 vin2.$83.GatPoly VSS.$68.Metal1 2.83194e-05f
Cred_19042 vin2.$83.GatPoly VSS.P3.pSD 0.00361328f
Cred_19043 vin2.$83.GatPoly VSS.P59.nSD 3.96041e-09f
Cred_19044 vin2.$83.GatPoly VSS.P83.nSD 9.32633e-06f
Cred_19045 vin2.$86.GatPoly vout2.$1292.Metal3 0.0565322f
Cred_19046 vin2.$86.GatPoly vout2.$1358.Metal3 0.00285379f
Cred_19047 vin2.$86.GatPoly vout2.P10.nSD 4.49588e-05f
Cred_19048 vin2.$86.GatPoly vout2.P10.pSD 0.000699669f
Cred_19049 vin2.$86.GatPoly vout2.P8.pSD 0.0335743f
Cred_19050 vin2.$91.GatPoly vout2.$1292.Metal3 0.00338463f
Cred_19051 vin2.$91.GatPoly vout2.$1358.Metal3 0.000300258f
Cred_19052 vin2.$91.GatPoly vout2.P10.nSD 1.06458e-05f
Cred_19053 vin2.$91.GatPoly vout2.P10.pSD 2.56195e-05f
Cred_19054 vin2.$91.GatPoly vout2.P8.nSD 0.00147864f
Cred_19055 vin2.$91.GatPoly VSS 0.00492823f
Cred_19056 vin2.$91.GatPoly VSS.$1064.Metal1 1.39888e-10f
Cred_19057 vin2.$91.GatPoly VSS.$1084.Metal1 0.00056091f
Cred_19058 vin2.$91.GatPoly VSS.$1990.Metal1 1.56901e-05f
Cred_19059 vin2.$91.GatPoly VSS.$3205.Metal2 9.13599e-08f
Cred_19060 vin2.$91.GatPoly VSS.$3260.Metal2 0.000486203f
Cred_19061 vin2.$91.GatPoly VSS.$3292.Metal2 0.000482253f
Cred_19062 vin2.$91.GatPoly VSS.$4802.Metal3 7.32503e-10f
Cred_19063 vin2.$91.GatPoly VSS.$68.Metal1 2.08596e-05f
Cred_19064 vin2.$91.GatPoly VSS.P2.pSD 3.35488e-07f
Cred_19065 vin2.$91.GatPoly VSS.P3.pSD 0.00329186f
Cred_19066 vin2.$91.GatPoly VSS.P59.nSD 3.63747e-08f
Cred_19067 vin2.$91.GatPoly VSS.P83.nSD 0.000151821f
Cred_19068 vin2.$95.GatPoly vout2.$1292.Metal3 0.000500257f
Cred_19069 vin2.$95.GatPoly vout2.$1358.Metal3 0.000329284f
Cred_19070 vin2.$95.GatPoly vout2.P10.nSD 0.000288881f
Cred_19071 vin2.$95.GatPoly vout2.P10.pSD 2.80962e-05f
Cred_19072 vin2.$95.GatPoly vout2.P8.nSD 1.60319e-06f
Cred_19073 vin2.$95.GatPoly VSS 0.0115635f
Cred_19074 vin2.$95.GatPoly VSS.$1084.Metal1 0.00054898f
Cred_19075 vin2.$95.GatPoly VSS.$1160.Metal1 0.00138831f
Cred_19076 vin2.$95.GatPoly VSS.$1990.Metal1 1.95211e-05f
Cred_19077 vin2.$95.GatPoly VSS.$3260.Metal2 0.000458167f
Cred_19078 vin2.$95.GatPoly VSS.$3292.Metal2 0.000464066f
Cred_19079 vin2.$95.GatPoly VSS.$68.Metal1 1.78712e-05f
Cred_19080 vin2.$95.GatPoly VSS.P2.pSD 1.1839e-06f
Cred_19081 vin2.$95.GatPoly VSS.P3.pSD 0.0033997f
Cred_19082 vin2.$95.GatPoly VSS.P59.nSD 3.42669e-08f
Cred_19083 vin2.$95.GatPoly VSS.P83.nSD 0.000317921f
Cred_19084 vin2.$96.GatPoly vout2.$1292.Metal3 0.0312837f
Cred_19085 vin2.$96.GatPoly vout2.$1358.Metal3 0.0254406f
Cred_19086 vin2.$96.GatPoly vout2.P10.nSD 0.000400792f
Cred_19087 vin2.$96.GatPoly vout2.P10.pSD 0.0365361f
Cred_19088 vin2.$96.GatPoly vout2.P8.pSD 0.000410777f
Cred_19089 vin2.P0.GatPoly vin3.P0.GatPoly 0.0011729f
Cred_19090 vin2.P0.GatPoly vout2.$1226.Metal3 0.0351926f
Cred_19091 vin2.P0.GatPoly vout2.P0.nSD 0.0265079f
Cred_19092 vin2.P0.GatPoly vout2.P0.pSD 0.0055685f
Cred_19093 vin2.P0.GatPoly vout2.P2.nSD 0.000554427f
Cred_19094 vin2.P0.GatPoly vout2.P2.pSD 0.00303007f
Cred_19095 vin2.P0.GatPoly VSS.$158.Metal1 0.046122f
Cred_19096 vin2.P0.GatPoly VSS.$1990.Metal1 2.39485e-06f
Cred_19097 vin2.P0.GatPoly VSS.$2228.Metal2 0.0132543f
Cred_19098 vin2.P0.GatPoly VSS.$2409.Metal2 0.00526351f
Cred_19099 vin2.P0.GatPoly VSS.$2433.Metal2 0.00416049f
Cred_19100 vin2.P0.GatPoly VSS.$2532.Metal2 0.000585659f
Cred_19101 vin2.P0.GatPoly VSS.$2564.Metal2 0.000786456f
Cred_19102 vin2.P0.GatPoly VSS.$292.Metal1 0.0110655f
Cred_19103 vin2.P0.GatPoly VSS.$312.Metal1 0.00565657f
Cred_19104 vin2.P0.GatPoly VSS.$386.Metal1 0.000103919f
Cred_19105 vin2.P0.GatPoly VSS.$4358.Metal3 1.00893e-05f
Cred_19106 vin2.P0.GatPoly VSS.$4418.Metal3 0.00347266f
Cred_19107 vin2.P0.GatPoly VSS.$4454.Metal3 0.00276441f
Cred_19108 vin2.P0.GatPoly VSS.$68.Metal1 0.0061425f
Cred_19109 vin2.P0.GatPoly VSS.P2.pSD 1.68643e-06f
Cred_19110 vin2.P0.GatPoly VSS.P3.pSD 0.0107995f
Cred_19111 vin2.P0.GatPoly VSS.P51.nSD 5.06388e-08f
Cred_19112 vin2.P0.GatPoly VSS.P6.GatPoly 0.0188624f
Cred_19113 vin2.P0.GatPoly VSS.P72.nSD 0.000218584f
Cred_19114 vin2.P0.GatPoly VSS.P73.nSD 0.000218584f
Cred_19115 vin2.P0.GatPoly VSS.P75.nSD 3.51533e-06f
Cred_19116 vin2.P1.GatPoly vin3.P1.GatPoly 0.0011729f
Cred_19117 vin2.P1.GatPoly vout2.$1226.Metal3 0.0367128f
Cred_19118 vin2.P1.GatPoly vout2.P0.nSD 0.0231313f
Cred_19119 vin2.P1.GatPoly vout2.P0.pSD 0.00555071f
Cred_19120 vin2.P1.GatPoly vout2.P2.nSD 0.000617178f
Cred_19121 vin2.P1.GatPoly vout2.P2.pSD 0.00316095f
Cred_19122 vin2.P1.GatPoly VSS.$1990.Metal1 1.91358e-07f
Cred_19123 vin2.P1.GatPoly VSS.$2481.Metal2 0.00555605f
Cred_19124 vin2.P1.GatPoly VSS.$2532.Metal2 0.0100554f
Cred_19125 vin2.P1.GatPoly VSS.$2564.Metal2 0.00805698f
Cred_19126 vin2.P1.GatPoly VSS.$332.Metal1 0.00288352f
Cred_19127 vin2.P1.GatPoly VSS.$360.Metal1 0.0119698f
Cred_19128 vin2.P1.GatPoly VSS.$380.Metal1 0.00398334f
Cred_19129 vin2.P1.GatPoly VSS.$386.Metal1 0.0578336f
Cred_19130 vin2.P1.GatPoly VSS.$4478.Metal3 0.00390771f
Cred_19131 vin2.P1.GatPoly VSS.$68.Metal1 7.16041e-05f
Cred_19132 vin2.P1.GatPoly VSS.P2.pSD 1.76215e-06f
Cred_19133 vin2.P1.GatPoly VSS.P3.pSD 0.000617818f
Cred_19134 vin2.P1.GatPoly VSS.P51.nSD 5.18777e-07f
Cred_19135 vin2.P1.GatPoly VSS.P75.nSD 0.00177164f
Cred_19136 vin2.P10.GatPoly vin3.P10.GatPoly 0.0011729f
Cred_19137 vin2.P10.GatPoly vout2.$1292.Metal3 0.023736f
Cred_19138 vin2.P10.GatPoly vout2.$1358.Metal3 0.0201678f
Cred_19139 vin2.P10.GatPoly vout2.P10.nSD 0.0214537f
Cred_19140 vin2.P10.GatPoly vout2.P10.pSD 0.00172082f
Cred_19141 vin2.P10.GatPoly vout2.P8.nSD 3.66983e-05f
Cred_19142 vin2.P10.GatPoly VSS 0.0533796f
Cred_19143 vin2.P10.GatPoly VSS.$1160.Metal1 0.00991321f
Cred_19144 vin2.P10.GatPoly VSS.$1180.Metal1 0.00847338f
Cred_19145 vin2.P10.GatPoly VSS.$1200.Metal1 0.00137957f
Cred_19146 vin2.P10.GatPoly VSS.$1266.Metal1 8.80351e-05f
Cred_19147 vin2.P10.GatPoly VSS.$1990.Metal1 2.15699e-06f
Cred_19148 vin2.P10.GatPoly VSS.$3260.Metal2 0.00682065f
Cred_19149 vin2.P10.GatPoly VSS.$3292.Metal2 0.00964318f
Cred_19150 vin2.P10.GatPoly VSS.$3344.Metal2 0.00595581f
Cred_19151 vin2.P10.GatPoly VSS.$3435.Metal2 0.00119903f
Cred_19152 vin2.P10.GatPoly VSS.$4838.Metal3 0.0039077f
Cred_19153 vin2.P10.GatPoly VSS.$68.Metal1 1.63916e-06f
Cred_19154 vin2.P10.GatPoly VSS.P2.pSD 9.41436e-07f
Cred_19155 vin2.P10.GatPoly VSS.P3.pSD 0.000343889f
Cred_19156 vin2.P10.GatPoly VSS.P59.nSD 5.14458e-07f
Cred_19157 vin2.P10.GatPoly VSS.P83.nSD 0.00166168f
Cred_19158 vin2.P10.GatPoly VSS.P85.nSD 3.02093e-06f
Cred_19159 vin2.P11.GatPoly vin3.P11.GatPoly 0.0011729f
Cred_19160 vin2.P11.GatPoly vout2.$1292.Metal3 0.0201189f
Cred_19161 vin2.P11.GatPoly vout2.$1358.Metal3 0.0235822f
Cred_19162 vin2.P11.GatPoly vout2.P10.nSD 0.0215498f
Cred_19163 vin2.P11.GatPoly vout2.P10.pSD 0.00171665f
Cred_19164 vin2.P11.GatPoly vout2.P12.nSD 3.57144e-05f
Cred_19165 vin2.P11.GatPoly VSS 9.06646e-05f
Cred_19166 vin2.P11.GatPoly VSS.$1220.Metal1 0.00528126f
Cred_19167 vin2.P11.GatPoly VSS.$1260.Metal1 0.0124547f
Cred_19168 vin2.P11.GatPoly VSS.$1266.Metal1 0.0511685f
Cred_19169 vin2.P11.GatPoly VSS.$1279.Metal1 4.6155e-05f
Cred_19170 vin2.P11.GatPoly VSS.$3260.Metal2 0.000598157f
Cred_19171 vin2.P11.GatPoly VSS.$3292.Metal2 0.000598157f
Cred_19172 vin2.P11.GatPoly VSS.$3392.Metal2 0.00702415f
Cred_19173 vin2.P11.GatPoly VSS.$3435.Metal2 0.0133121f
Cred_19174 vin2.P11.GatPoly VSS.$3451.Metal2 0.00246723f
Cred_19175 vin2.P11.GatPoly VSS.$4862.Metal3 0.00093661f
Cred_19176 vin2.P11.GatPoly VSS.$4886.Metal3 0.00436081f
Cred_19177 vin2.P11.GatPoly VSS.P2.pSD 2.79537e-06f
Cred_19178 vin2.P11.GatPoly VSS.P3.pSD 2.79537e-06f
Cred_19179 vin2.P11.GatPoly VSS.P59.nSD 4.51169e-08f
Cred_19180 vin2.P11.GatPoly VSS.P83.nSD 3.06604e-06f
Cred_19181 vin2.P11.GatPoly VSS.P85.nSD 0.00155293f
Cred_19182 vin2.P12.GatPoly vin3.P12.GatPoly 0.0011729f
Cred_19183 vin2.P12.GatPoly vout2.$1292.Metal3 0.00172617f
Cred_19184 vin2.P12.GatPoly vout2.$1358.Metal3 0.0443094f
Cred_19185 vin2.P12.GatPoly vout2.P10.nSD 6.44422e-05f
Cred_19186 vin2.P12.GatPoly vout2.P10.pSD 0.000147285f
Cred_19187 vin2.P12.GatPoly vout2.P12.nSD 0.0212036f
Cred_19188 vin2.P12.GatPoly VSS.$1266.Metal1 0.0529027f
Cred_19189 vin2.P12.GatPoly VSS.$1311.Metal1 0.00100572f
Cred_19190 vin2.P12.GatPoly VSS.$1339.Metal1 0.00769148f
Cred_19191 vin2.P12.GatPoly VSS.$1359.Metal1 0.00913213f
Cred_19192 vin2.P12.GatPoly VSS.$1379.Metal1 0.00235249f
Cred_19193 vin2.P12.GatPoly VSS.$1445.Metal1 8.84065e-05f
Cred_19194 vin2.P12.GatPoly VSS.$1990.Metal1 5.95569e-06f
Cred_19195 vin2.P12.GatPoly VSS.$3435.Metal2 0.0149481f
Cred_19196 vin2.P12.GatPoly VSS.$3507.Metal2 0.00792992f
Cred_19197 vin2.P12.GatPoly VSS.$3555.Metal2 0.00123086f
Cred_19198 vin2.P12.GatPoly VSS.$3603.Metal2 4.3853e-05f
Cred_19199 vin2.P12.GatPoly VSS.$3638.Metal2 0.0011548f
Cred_19200 vin2.P12.GatPoly VSS.$4910.Metal3 0.00331224f
Cred_19201 vin2.P12.GatPoly VSS.$4934.Metal3 0.00174233f
Cred_19202 vin2.P12.GatPoly VSS.$68.Metal1 9.75091e-07f
Cred_19203 vin2.P12.GatPoly VSS.P3.pSD 0.000438819f
Cred_19204 vin2.P12.GatPoly VSS.P63.nSD 6.37334e-09f
Cred_19205 vin2.P12.GatPoly VSS.P85.nSD 0.00162147f
Cred_19206 vin2.P12.GatPoly VSS.P87.nSD 3.0273e-06f
Cred_19207 vin2.P13.GatPoly vin3.P13.GatPoly 0.0011729f
Cred_19208 vin2.P13.GatPoly vout2.$1358.Metal3 0.0441012f
Cred_19209 vin2.P13.GatPoly vout2.$1424.Metal3 0.00165462f
Cred_19210 vin2.P13.GatPoly vout2.P12.nSD 0.0213646f
Cred_19211 vin2.P13.GatPoly vout2.P14.nSD 6.19055e-05f
Cred_19212 vin2.P13.GatPoly vout2.P14.pSD 0.000141181f
Cred_19213 vin2.P13.GatPoly VSS.$1266.Metal1 8.80351e-05f
Cred_19214 vin2.P13.GatPoly VSS.$1379.Metal1 0.000779039f
Cred_19215 vin2.P13.GatPoly VSS.$1407.Metal1 0.00867663f
Cred_19216 vin2.P13.GatPoly VSS.$1427.Metal1 0.0085415f
Cred_19217 vin2.P13.GatPoly VSS.$1445.Metal1 0.0515393f
Cred_19218 vin2.P13.GatPoly VSS.$1990.Metal1 7.30198e-06f
Cred_19219 vin2.P13.GatPoly VSS.$3435.Metal2 0.00119903f
Cred_19220 vin2.P13.GatPoly VSS.$3555.Metal2 0.00281776f
Cred_19221 vin2.P13.GatPoly VSS.$3603.Metal2 0.00677111f
Cred_19222 vin2.P13.GatPoly VSS.$3638.Metal2 0.0128324f
Cred_19223 vin2.P13.GatPoly VSS.$4958.Metal3 0.00440935f
Cred_19224 vin2.P13.GatPoly VSS.$4994.Metal3 0.000775961f
Cred_19225 vin2.P13.GatPoly VSS.$68.Metal1 7.6038e-07f
Cred_19226 vin2.P13.GatPoly VSS.P2.pSD 7.31944e-07f
Cred_19227 vin2.P13.GatPoly VSS.P3.pSD 0.000428302f
Cred_19228 vin2.P13.GatPoly VSS.P63.nSD 7.07877e-08f
Cred_19229 vin2.P13.GatPoly VSS.P85.nSD 3.02093e-06f
Cred_19230 vin2.P13.GatPoly VSS.P87.nSD 0.00155239f
Cred_19231 vin2.P14.GatPoly vin3.P14.GatPoly 0.0011729f
Cred_19232 vin2.P14.GatPoly vout2.$1358.Metal3 0.0222288f
Cred_19233 vin2.P14.GatPoly vout2.$1424.Metal3 0.0191762f
Cred_19234 vin2.P14.GatPoly vout2.P12.nSD 3.18635e-05f
Cred_19235 vin2.P14.GatPoly vout2.P14.nSD 0.0205849f
Cred_19236 vin2.P14.GatPoly vout2.P14.pSD 0.00163622f
Cred_19237 vin2.P14.GatPoly VSS.$1445.Metal1 0.0513476f
Cred_19238 vin2.P14.GatPoly VSS.$1490.Metal1 0.000343182f
Cred_19239 vin2.P14.GatPoly VSS.$1518.Metal1 0.0108588f
Cred_19240 vin2.P14.GatPoly VSS.$1546.Metal1 0.00696281f
Cred_19241 vin2.P14.GatPoly VSS.$1566.Metal1 0.000380545f
Cred_19242 vin2.P14.GatPoly VSS.$1624.Metal1 8.80351e-05f
Cred_19243 vin2.P14.GatPoly VSS.$3603.Metal2 0.000473185f
Cred_19244 vin2.P14.GatPoly VSS.$3638.Metal2 0.0143804f
Cred_19245 vin2.P14.GatPoly VSS.$3694.Metal2 0.00748984f
Cred_19246 vin2.P14.GatPoly VSS.$3718.Metal2 8.69857e-06f
Cred_19247 vin2.P14.GatPoly VSS.$3809.Metal2 0.00119903f
Cred_19248 vin2.P14.GatPoly VSS.$4994.Metal3 0.00443521f
Cred_19249 vin2.P14.GatPoly VSS.$5030.Metal3 0.000848036f
Cred_19250 vin2.P14.GatPoly VSS.P2.pSD 2.68972e-06f
Cred_19251 vin2.P14.GatPoly VSS.P3.pSD 2.68972e-06f
Cred_19252 vin2.P14.GatPoly VSS.P63.nSD 6.87699e-08f
Cred_19253 vin2.P14.GatPoly VSS.P87.nSD 0.00156238f
Cred_19254 vin2.P14.GatPoly VSS.P89.nSD 3.02093e-06f
Cred_19255 vin2.P15.GatPoly vin3.P15.GatPoly 0.0011729f
Cred_19256 vin2.P15.GatPoly vout2.$1358.Metal3 0.0209365f
Cred_19257 vin2.P15.GatPoly vout2.$1424.Metal3 0.0246698f
Cred_19258 vin2.P15.GatPoly vout2.P14.nSD 0.0225422f
Cred_19259 vin2.P15.GatPoly vout2.P14.pSD 0.00178641f
Cred_19260 vin2.P15.GatPoly vout2.P16.nSD 3.82463e-05f
Cred_19261 vin2.P15.GatPoly VSS.$1445.Metal1 8.84065e-05f
Cred_19262 vin2.P15.GatPoly VSS.$1566.Metal1 0.00153789f
Cred_19263 vin2.P15.GatPoly VSS.$1586.Metal1 0.00744981f
Cred_19264 vin2.P15.GatPoly VSS.$1606.Metal1 0.00868565f
Cred_19265 vin2.P15.GatPoly VSS.$1624.Metal1 0.051926f
Cred_19266 vin2.P15.GatPoly VSS.$1629.Metal1 0.00225715f
Cred_19267 vin2.P15.GatPoly VSS.$1990.Metal1 3.62944e-05f
Cred_19268 vin2.P15.GatPoly VSS.$3603.Metal2 4.3853e-05f
Cred_19269 vin2.P15.GatPoly VSS.$3638.Metal2 0.0011548f
Cred_19270 vin2.P15.GatPoly VSS.$3718.Metal2 0.00101102f
Cred_19271 vin2.P15.GatPoly VSS.$3766.Metal2 0.00748422f
Cred_19272 vin2.P15.GatPoly VSS.$3809.Metal2 0.0147845f
Cred_19273 vin2.P15.GatPoly VSS.$5030.Metal3 0.00186198f
Cred_19274 vin2.P15.GatPoly VSS.$5054.Metal3 0.00315449f
Cred_19275 vin2.P15.GatPoly VSS.$68.Metal1 8.10235e-07f
Cred_19276 vin2.P15.GatPoly VSS.P3.pSD 0.000966227f
Cred_19277 vin2.P15.GatPoly VSS.P63.nSD 6.37334e-09f
Cred_19278 vin2.P15.GatPoly VSS.P87.nSD 3.0273e-06f
Cred_19279 vin2.P15.GatPoly VSS.P89.nSD 0.00158901f
Cred_19280 vin2.P16.GatPoly vin3.P16.GatPoly 0.0011729f
Cred_19281 vin2.P16.GatPoly vout2.$1358.Metal3 0.00145287f
Cred_19282 vin2.P16.GatPoly vout2.$1424.Metal3 0.0417745f
Cred_19283 vin2.P16.GatPoly vout2.P14.nSD 5.47521e-05f
Cred_19284 vin2.P16.GatPoly vout2.P14.pSD 0.000123966f
Cred_19285 vin2.P16.GatPoly vout2.P16.nSD 0.0203078f
Cred_19286 vin2.P16.GatPoly VSS.$1624.Metal1 0.0507781f
Cred_19287 vin2.P16.GatPoly VSS.$1685.Metal1 0.00592918f
Cred_19288 vin2.P16.GatPoly VSS.$1705.Metal1 0.00893219f
Cred_19289 vin2.P16.GatPoly VSS.$1725.Metal1 0.00380395f
Cred_19290 vin2.P16.GatPoly VSS.$1799.Metal1 9.06084e-05f
Cred_19291 vin2.P16.GatPoly VSS.$3809.Metal2 0.0128681f
Cred_19292 vin2.P16.GatPoly VSS.$3825.Metal2 0.0026751f
Cred_19293 vin2.P16.GatPoly VSS.$3881.Metal2 0.00685255f
Cred_19294 vin2.P16.GatPoly VSS.$3988.Metal2 0.000685726f
Cred_19295 vin2.P16.GatPoly VSS.$4020.Metal2 0.000510647f
Cred_19296 vin2.P16.GatPoly VSS.$5078.Metal3 0.00451617f
Cred_19297 vin2.P16.GatPoly VSS.$5102.Metal3 0.000799087f
Cred_19298 vin2.P16.GatPoly VSS.P67.nSD 4.41529e-08f
Cred_19299 vin2.P16.GatPoly VSS.P89.nSD 0.00153329f
Cred_19300 vin2.P16.GatPoly VSS.P91.nSD 3.06508e-06f
Cred_19301 vin2.P17.GatPoly vin3.P17.GatPoly 0.0011729f
Cred_19302 vin2.P17.GatPoly vout2 0.0005655f
Cred_19303 vin2.P17.GatPoly vout2.$1424.Metal3 0.0463676f
Cred_19304 vin2.P17.GatPoly vout2.P16.nSD 0.0216974f
Cred_19305 vin2.P17.GatPoly vout2.P18.nSD 8.29213e-05f
Cred_19306 vin2.P17.GatPoly vout2.P18.pSD 0.000243355f
Cred_19307 vin2.P17.GatPoly VSS.$1624.Metal1 8.80351e-05f
Cred_19308 vin2.P17.GatPoly VSS.$1745.Metal1 0.00397253f
Cred_19309 vin2.P17.GatPoly VSS.$1773.Metal1 0.0122493f
Cred_19310 vin2.P17.GatPoly VSS.$1793.Metal1 0.00207842f
Cred_19311 vin2.P17.GatPoly VSS.$1799.Metal1 0.0530635f
Cred_19312 vin2.P17.GatPoly VSS.$1990.Metal1 7.51395e-05f
Cred_19313 vin2.P17.GatPoly VSS.$3809.Metal2 0.00119903f
Cred_19314 vin2.P17.GatPoly VSS.$3929.Metal2 0.00639424f
Cred_19315 vin2.P17.GatPoly VSS.$3988.Metal2 0.0106298f
Cred_19316 vin2.P17.GatPoly VSS.$4020.Metal2 0.00582239f
Cred_19317 vin2.P17.GatPoly VSS.$5102.Metal3 0.000595757f
Cred_19318 vin2.P17.GatPoly VSS.$5126.Metal3 0.00450346f
Cred_19319 vin2.P17.GatPoly VSS.$68.Metal1 4.21603e-07f
Cred_19320 vin2.P17.GatPoly VSS.P2.pSD 2.26408e-06f
Cred_19321 vin2.P17.GatPoly VSS.P3.pSD 0.000969661f
Cred_19322 vin2.P17.GatPoly VSS.P67.nSD 5.03431e-07f
Cred_19323 vin2.P17.GatPoly VSS.P89.nSD 3.02093e-06f
Cred_19324 vin2.P17.GatPoly VSS.P91.nSD 0.00160903f
Cred_19325 vin2.P18.GatPoly vin3.P18.GatPoly 0.0011729f
Cred_19326 vin2.P18.GatPoly vout2 0.00663761f
Cred_19327 vin2.P18.GatPoly vout2.$1424.Metal3 0.0372692f
Cred_19328 vin2.P18.GatPoly vout2.P16.nSD 3.88024e-05f
Cred_19329 vin2.P18.GatPoly vout2.P18.nSD 0.0223709f
Cred_19330 vin2.P18.GatPoly vout2.P18.pSD 0.0028564f
Cred_19331 vin2.P18.GatPoly VSS.$1799.Metal1 0.0563753f
Cred_19332 vin2.P18.GatPoly VSS.$1864.Metal1 0.00398334f
Cred_19333 vin2.P18.GatPoly VSS.$1884.Metal1 0.0119698f
Cred_19334 vin2.P18.GatPoly VSS.$1912.Metal1 0.00288352f
Cred_19335 vin2.P18.GatPoly VSS.$1990.Metal1 7.16041e-05f
Cred_19336 vin2.P18.GatPoly VSS.$3988.Metal2 0.0079941f
Cred_19337 vin2.P18.GatPoly VSS.$4020.Metal2 0.0100086f
Cred_19338 vin2.P18.GatPoly VSS.$4068.Metal2 0.00555605f
Cred_19339 vin2.P18.GatPoly VSS.$5162.Metal3 0.00390771f
Cred_19340 vin2.P18.GatPoly VSS.$68.Metal1 1.91358e-07f
Cred_19341 vin2.P18.GatPoly VSS.P2.pSD 1.76215e-06f
Cred_19342 vin2.P18.GatPoly VSS.P3.pSD 0.000617818f
Cred_19343 vin2.P18.GatPoly VSS.P67.nSD 5.14728e-07f
Cred_19344 vin2.P18.GatPoly VSS.P91.nSD 0.00172612f
Cred_19345 vin2.P19.GatPoly vin3.P19.GatPoly 0.00665644f
Cred_19346 vin2.P19.GatPoly vout2 0.00823235f
Cred_19347 vin2.P19.GatPoly vout2.$1424.Metal3 0.0415197f
Cred_19348 vin2.P19.GatPoly vout2.P18.nSD 0.0258089f
Cred_19349 vin2.P19.GatPoly vout2.P18.pSD 0.00354267f
Cred_19350 vin2.P19.GatPoly VSS.$1799.Metal1 0.000103919f
Cred_19351 vin2.P19.GatPoly VSS.$1932.Metal1 0.00590746f
Cred_19352 vin2.P19.GatPoly VSS.$1952.Metal1 0.0114087f
Cred_19353 vin2.P19.GatPoly VSS.$1990.Metal1 0.00613453f
Cred_19354 vin2.P19.GatPoly VSS.$2021.Metal1 0.0461689f
Cred_19355 vin2.P19.GatPoly VSS.$3988.Metal2 0.000786456f
Cred_19356 vin2.P19.GatPoly VSS.$4020.Metal2 0.000585659f
Cred_19357 vin2.P19.GatPoly VSS.$4116.Metal2 0.0049051f
Cred_19358 vin2.P19.GatPoly VSS.$4140.Metal2 0.00633399f
Cred_19359 vin2.P19.GatPoly VSS.$4164.Metal2 0.014075f
Cred_19360 vin2.P19.GatPoly VSS.$5186.Metal3 0.00278945f
Cred_19361 vin2.P19.GatPoly VSS.$5222.Metal3 0.00352294f
Cred_19362 vin2.P19.GatPoly VSS.$68.Metal1 2.40066e-06f
Cred_19363 vin2.P19.GatPoly VSS.P2.pSD 1.68643e-06f
Cred_19364 vin2.P19.GatPoly VSS.P3.pSD 0.0108064f
Cred_19365 vin2.P19.GatPoly VSS.P67.nSD 5.06388e-08f
Cred_19366 vin2.P19.GatPoly VSS.P7.GatPoly 0.0190579f
Cred_19367 vin2.P19.GatPoly VSS.P91.nSD 3.51533e-06f
Cred_19368 vin2.P19.GatPoly VSS.P93.nSD 0.00021879f
Cred_19369 vin2.P19.GatPoly VSS.P95.nSD 0.00021879f
Cred_19370 vin2.P2.GatPoly vin3.P2.GatPoly 0.0011729f
Cred_19371 vin2.P2.GatPoly vout2.$1226.Metal3 0.0393216f
Cred_19372 vin2.P2.GatPoly vout2.P0.nSD 0.000674738f
Cred_19373 vin2.P2.GatPoly vout2.P0.pSD 0.00325793f
Cred_19374 vin2.P2.GatPoly vout2.P2.nSD 0.0223169f
Cred_19375 vin2.P2.GatPoly vout2.P2.pSD 0.00338557f
Cred_19376 vin2.P2.GatPoly VSS.$1990.Metal1 4.21603e-07f
Cred_19377 vin2.P2.GatPoly VSS.$2532.Metal2 0.00581989f
Cred_19378 vin2.P2.GatPoly VSS.$2564.Metal2 0.0106264f
Cred_19379 vin2.P2.GatPoly VSS.$2620.Metal2 0.00639424f
Cred_19380 vin2.P2.GatPoly VSS.$2711.Metal2 0.00119903f
Cred_19381 vin2.P2.GatPoly VSS.$386.Metal1 0.0529856f
Cred_19382 vin2.P2.GatPoly VSS.$451.Metal1 0.00207842f
Cred_19383 vin2.P2.GatPoly VSS.$4514.Metal3 0.00450346f
Cred_19384 vin2.P2.GatPoly VSS.$4538.Metal3 0.000595757f
Cred_19385 vin2.P2.GatPoly VSS.$471.Metal1 0.0122493f
Cred_19386 vin2.P2.GatPoly VSS.$499.Metal1 0.00397253f
Cred_19387 vin2.P2.GatPoly VSS.$565.Metal1 8.80351e-05f
Cred_19388 vin2.P2.GatPoly VSS.$68.Metal1 7.51395e-05f
Cred_19389 vin2.P2.GatPoly VSS.P2.pSD 2.26408e-06f
Cred_19390 vin2.P2.GatPoly VSS.P3.pSD 0.000969661f
Cred_19391 vin2.P2.GatPoly VSS.P51.nSD 5.03214e-07f
Cred_19392 vin2.P2.GatPoly VSS.P75.nSD 0.0016066f
Cred_19393 vin2.P2.GatPoly VSS.P77.nSD 3.02093e-06f
Cred_19394 vin2.P20.GatPoly vout2.$1226.Metal3 0.157091f
Cred_19395 vin2.P20.GatPoly vout2.P0.nSD 0.00467767f
Cred_19396 vin2.P20.GatPoly vout2.P0.pSD 0.170586f
Cred_19397 vin2.P20.GatPoly vout2.P2.nSD 0.00247482f
Cred_19398 vin2.P20.GatPoly vout2.P2.pSD 0.0135255f
Cred_19399 vin2.P20.GatPoly VSS.$1990.Metal1 2.71844e-09f
Cred_19400 vin2.P20.GatPoly VSS.$2409.Metal2 4.7835e-06f
Cred_19401 vin2.P20.GatPoly VSS.$2433.Metal2 3.50781e-06f
Cred_19402 vin2.P20.GatPoly VSS.$4358.Metal3 6.10528e-06f
Cred_19403 vin2.P20.GatPoly VSS.$4418.Metal3 0.000596611f
Cred_19404 vin2.P20.GatPoly VSS.$4454.Metal3 0.000437504f
Cred_19405 vin2.P20.GatPoly VSS.$68.Metal1 5.84044e-06f
Cred_19406 vin2.P20.GatPoly VSS.P3.pSD 1.76423e-05f
Cred_19407 vin2.P20.GatPoly VSS.P6.GatPoly 1.27821e-06f
Cred_19408 vin2.P21.GatPoly vout2.$1226.Metal3 0.160661f
Cred_19409 vin2.P21.GatPoly vout2.P0.nSD 0.00458159f
Cred_19410 vin2.P21.GatPoly vout2.P0.pSD 0.152776f
Cred_19411 vin2.P21.GatPoly vout2.P2.nSD 0.00253106f
Cred_19412 vin2.P21.GatPoly vout2.P2.pSD 0.0164452f
Cred_19413 vin2.P22.GatPoly vout2.$1226.Metal3 0.174054f
Cred_19414 vin2.P22.GatPoly vout2.P0.nSD 0.0026994f
Cred_19415 vin2.P22.GatPoly vout2.P0.pSD 0.0174661f
Cred_19416 vin2.P22.GatPoly vout2.P2.nSD 0.00274205f
Cred_19417 vin2.P22.GatPoly vout2.P2.pSD 0.135457f
Cred_19418 vin2.P23.GatPoly vout2.$1226.Metal3 0.177972f
Cred_19419 vin2.P23.GatPoly vout2.P0.nSD 0.00235124f
Cred_19420 vin2.P23.GatPoly vout2.P0.pSD 0.0124941f
Cred_19421 vin2.P23.GatPoly vout2.P2.nSD 0.00255785f
Cred_19422 vin2.P23.GatPoly vout2.P2.pSD 0.13445f
Cred_19423 vin2.P23.GatPoly vout2.P4.pSD 0.00259263f
Cred_19424 vin2.P24.GatPoly vout2.$1226.Metal3 0.216059f
Cred_19425 vin2.P24.GatPoly vout2.P0.nSD 0.000200773f
Cred_19426 vin2.P24.GatPoly vout2.P0.pSD 0.00106687f
Cred_19427 vin2.P24.GatPoly vout2.P2.nSD 0.000218415f
Cred_19428 vin2.P24.GatPoly vout2.P2.pSD 0.00385188f
Cred_19429 vin2.P24.GatPoly vout2.P4.pSD 0.125718f
Cred_19430 vin2.P25.GatPoly vout2.$1226.Metal3 0.201171f
Cred_19431 vin2.P25.GatPoly vout2.$1292.Metal3 0.00742713f
Cred_19432 vin2.P25.GatPoly vout2.P4.pSD 0.120471f
Cred_19433 vin2.P25.GatPoly vout2.P6.nSD 0.000117007f
Cred_19434 vin2.P25.GatPoly vout2.P6.pSD 0.0032321f
Cred_19435 vin2.P26.GatPoly vout2.$1226.Metal3 0.107788f
Cred_19436 vin2.P26.GatPoly vout2.$1292.Metal3 0.0921775f
Cred_19437 vin2.P26.GatPoly vout2.P4.pSD 0.00259263f
Cred_19438 vin2.P26.GatPoly vout2.P6.nSD 0.00145217f
Cred_19439 vin2.P26.GatPoly vout2.P6.pSD 0.128408f
Cred_19440 vin2.P27.GatPoly vout2.$1226.Metal3 0.096316f
Cred_19441 vin2.P27.GatPoly vout2.$1292.Metal3 0.112912f
Cred_19442 vin2.P27.GatPoly vout2.P6.nSD 0.00151737f
Cred_19443 vin2.P27.GatPoly vout2.P6.pSD 0.134153f
Cred_19444 vin2.P27.GatPoly vout2.P8.pSD 0.00266188f
Cred_19445 vin2.P28.GatPoly vout2.$1226.Metal3 0.00742713f
Cred_19446 vin2.P28.GatPoly vout2.$1292.Metal3 0.201171f
Cred_19447 vin2.P28.GatPoly vout2.P6.nSD 0.000117007f
Cred_19448 vin2.P28.GatPoly vout2.P6.pSD 0.0032321f
Cred_19449 vin2.P28.GatPoly vout2.P8.pSD 0.120471f
Cred_19450 vin2.P29.GatPoly vout2.$1292.Metal3 0.20119f
Cred_19451 vin2.P29.GatPoly vout2.$1358.Metal3 0.00715313f
Cred_19452 vin2.P29.GatPoly vout2.P10.nSD 0.000112691f
Cred_19453 vin2.P29.GatPoly vout2.P10.pSD 0.00322922f
Cred_19454 vin2.P29.GatPoly vout2.P8.pSD 0.120733f
Cred_19455 vin2.P3.GatPoly vin3.P3.GatPoly 0.0011729f
Cred_19456 vin2.P3.GatPoly vout2.$1226.Metal3 0.0368429f
Cred_19457 vin2.P3.GatPoly vout2.P0.nSD 0.000489337f
Cred_19458 vin2.P3.GatPoly vout2.P0.pSD 0.00260026f
Cred_19459 vin2.P3.GatPoly vout2.P2.nSD 0.0208402f
Cred_19460 vin2.P3.GatPoly vout2.P2.pSD 0.00290933f
Cred_19461 vin2.P3.GatPoly vout2.P4.nSD 3.18635e-05f
Cred_19462 vin2.P3.GatPoly VSS.$2532.Metal2 0.000510647f
Cred_19463 vin2.P3.GatPoly VSS.$2564.Metal2 0.000685726f
Cred_19464 vin2.P3.GatPoly VSS.$2668.Metal2 0.00685255f
Cred_19465 vin2.P3.GatPoly VSS.$2711.Metal2 0.0128681f
Cred_19466 vin2.P3.GatPoly VSS.$2727.Metal2 0.0026751f
Cred_19467 vin2.P3.GatPoly VSS.$386.Metal1 9.06084e-05f
Cred_19468 vin2.P3.GatPoly VSS.$4538.Metal3 0.000799087f
Cred_19469 vin2.P3.GatPoly VSS.$4562.Metal3 0.00451617f
Cred_19470 vin2.P3.GatPoly VSS.$519.Metal1 0.00380395f
Cred_19471 vin2.P3.GatPoly VSS.$539.Metal1 0.00893219f
Cred_19472 vin2.P3.GatPoly VSS.$559.Metal1 0.00592918f
Cred_19473 vin2.P3.GatPoly VSS.$565.Metal1 0.0507781f
Cred_19474 vin2.P3.GatPoly VSS.P51.nSD 4.41529e-08f
Cred_19475 vin2.P3.GatPoly VSS.P75.nSD 3.06508e-06f
Cred_19476 vin2.P3.GatPoly VSS.P77.nSD 0.00153329f
Cred_19477 vin2.P30.GatPoly vout2.$1292.Metal3 0.107309f
Cred_19478 vin2.P30.GatPoly vout2.$1358.Metal3 0.0916983f
Cred_19479 vin2.P30.GatPoly vout2.P10.nSD 0.00144462f
Cred_19480 vin2.P30.GatPoly vout2.P10.pSD 0.129374f
Cred_19481 vin2.P30.GatPoly vout2.P8.pSD 0.00259263f
Cred_19482 vin2.P31.GatPoly vout2.$1292.Metal3 0.0918383f
Cred_19483 vin2.P31.GatPoly vout2.$1358.Metal3 0.106868f
Cred_19484 vin2.P31.GatPoly vout2.P10.nSD 0.00144683f
Cred_19485 vin2.P31.GatPoly vout2.P10.pSD 0.129647f
Cred_19486 vin2.P31.GatPoly vout2.P12.pSD 0.00261888f
Cred_19487 vin2.P32.GatPoly vout2.$1292.Metal3 0.00763443f
Cred_19488 vin2.P32.GatPoly vout2.$1358.Metal3 0.209225f
Cred_19489 vin2.P32.GatPoly vout2.P10.nSD 0.000120273f
Cred_19490 vin2.P32.GatPoly vout2.P10.pSD 0.00334719f
Cred_19491 vin2.P32.GatPoly vout2.P12.pSD 0.127294f
Cred_19492 vin2.P33.GatPoly vout2.$1358.Metal3 0.200113f
Cred_19493 vin2.P33.GatPoly vout2.$1424.Metal3 0.00715313f
Cred_19494 vin2.P33.GatPoly vout2.P12.pSD 0.12181f
Cred_19495 vin2.P33.GatPoly vout2.P14.nSD 0.000112691f
Cred_19496 vin2.P33.GatPoly vout2.P14.pSD 0.00322922f
Cred_19497 vin2.P34.GatPoly vout2.$1358.Metal3 0.106868f
Cred_19498 vin2.P34.GatPoly vout2.$1424.Metal3 0.0918383f
Cred_19499 vin2.P34.GatPoly vout2.P12.pSD 0.00261888f
Cred_19500 vin2.P34.GatPoly vout2.P14.nSD 0.00144683f
Cred_19501 vin2.P34.GatPoly vout2.P14.pSD 0.129647f
Cred_19502 vin2.P35.GatPoly vout2.$1358.Metal3 0.0958543f
Cred_19503 vin2.P35.GatPoly vout2.$1424.Metal3 0.111841f
Cred_19504 vin2.P35.GatPoly vout2.P14.nSD 0.00151009f
Cred_19505 vin2.P35.GatPoly vout2.P14.pSD 0.13538f
Cred_19506 vin2.P35.GatPoly vout2.P16.pSD 0.00269169f
Cred_19507 vin2.P36.GatPoly vout2.$1358.Metal3 0.00715313f
Cred_19508 vin2.P36.GatPoly vout2.$1424.Metal3 0.200603f
Cred_19509 vin2.P36.GatPoly vout2.P14.nSD 0.000112691f
Cred_19510 vin2.P36.GatPoly vout2.P14.pSD 0.00322922f
Cred_19511 vin2.P36.GatPoly vout2.P16.pSD 0.122248f
Cred_19512 vin2.P37.GatPoly vout2 0.0022934f
Cred_19513 vin2.P37.GatPoly vout2.$1424.Metal3 0.204526f
Cred_19514 vin2.P37.GatPoly vout2.P16.pSD 0.12181f
Cred_19515 vin2.P37.GatPoly vout2.P18.nSD 0.000182223f
Cred_19516 vin2.P37.GatPoly vout2.P18.pSD 0.00360581f
Cred_19517 vin2.P38.GatPoly vout2 0.0298642f
Cred_19518 vin2.P38.GatPoly vout2.$1424.Metal3 0.165649f
Cred_19519 vin2.P38.GatPoly vout2.P16.pSD 0.00261888f
Cred_19520 vin2.P38.GatPoly vout2.P18.nSD 0.00237287f
Cred_19521 vin2.P38.GatPoly vout2.P18.pSD 0.13649f
Cred_19522 vin2.P39.GatPoly vout2 0.0348568f
Cred_19523 vin2.P39.GatPoly vout2.$1424.Metal3 0.175799f
Cred_19524 vin2.P39.GatPoly vout2.P18.nSD 0.00276955f
Cred_19525 vin2.P39.GatPoly vout2.P18.pSD 0.155155f
Cred_19526 vin2.P39.GatPoly VSS.$4140.Metal2 0.000431311f
Cred_19527 vin2.P4.GatPoly vin3.P4.GatPoly 0.0011729f
Cred_19528 vin2.P4.GatPoly vout2.$1226.Metal3 0.0471178f
Cred_19529 vin2.P4.GatPoly vout2.P0.nSD 4.53065e-05f
Cred_19530 vin2.P4.GatPoly vout2.P0.pSD 0.000240751f
Cred_19531 vin2.P4.GatPoly vout2.P2.nSD 8.75338e-05f
Cred_19532 vin2.P4.GatPoly vout2.P2.pSD 0.000269368f
Cred_19533 vin2.P4.GatPoly vout2.P4.nSD 0.0222123f
Cred_19534 vin2.P4.GatPoly VSS.$1990.Metal1 8.10235e-07f
Cred_19535 vin2.P4.GatPoly VSS.$2711.Metal2 0.0147845f
Cred_19536 vin2.P4.GatPoly VSS.$2783.Metal2 0.00748422f
Cred_19537 vin2.P4.GatPoly VSS.$2831.Metal2 0.00101102f
Cred_19538 vin2.P4.GatPoly VSS.$2914.Metal2 0.0011548f
Cred_19539 vin2.P4.GatPoly VSS.$2946.Metal2 4.3853e-05f
Cred_19540 vin2.P4.GatPoly VSS.$4586.Metal3 0.00315449f
Cred_19541 vin2.P4.GatPoly VSS.$4610.Metal3 0.00186198f
Cred_19542 vin2.P4.GatPoly VSS.$565.Metal1 0.051926f
Cred_19543 vin2.P4.GatPoly VSS.$618.Metal1 0.00225715f
Cred_19544 vin2.P4.GatPoly VSS.$638.Metal1 0.00868565f
Cred_19545 vin2.P4.GatPoly VSS.$658.Metal1 0.00744981f
Cred_19546 vin2.P4.GatPoly VSS.$678.Metal1 0.00153789f
Cred_19547 vin2.P4.GatPoly VSS.$68.Metal1 3.62944e-05f
Cred_19548 vin2.P4.GatPoly VSS.$744.Metal1 8.84065e-05f
Cred_19549 vin2.P4.GatPoly VSS.P3.pSD 0.000966227f
Cred_19550 vin2.P4.GatPoly VSS.P55.nSD 6.37334e-09f
Cred_19551 vin2.P4.GatPoly VSS.P77.nSD 0.00158901f
Cred_19552 vin2.P4.GatPoly VSS.P79.nSD 3.0273e-06f
Cred_19553 vin2.P5.GatPoly vin3.P5.GatPoly 0.0011729f
Cred_19554 vin2.P5.GatPoly vout2.$1226.Metal3 0.0417431f
Cred_19555 vin2.P5.GatPoly vout2.$1292.Metal3 0.00145233f
Cred_19556 vin2.P5.GatPoly vout2.P4.nSD 0.0202828f
Cred_19557 vin2.P5.GatPoly vout2.P6.nSD 5.47436e-05f
Cred_19558 vin2.P5.GatPoly vout2.P6.pSD 0.000125045f
Cred_19559 vin2.P5.GatPoly VSS.$2711.Metal2 0.00119903f
Cred_19560 vin2.P5.GatPoly VSS.$2831.Metal2 8.69857e-06f
Cred_19561 vin2.P5.GatPoly VSS.$2855.Metal2 0.00748984f
Cred_19562 vin2.P5.GatPoly VSS.$2914.Metal2 0.0143303f
Cred_19563 vin2.P5.GatPoly VSS.$2946.Metal2 0.000471281f
Cred_19564 vin2.P5.GatPoly VSS.$4610.Metal3 0.000848036f
Cred_19565 vin2.P5.GatPoly VSS.$4646.Metal3 0.00443521f
Cred_19566 vin2.P5.GatPoly VSS.$565.Metal1 8.80351e-05f
Cred_19567 vin2.P5.GatPoly VSS.$678.Metal1 0.000380545f
Cred_19568 vin2.P5.GatPoly VSS.$698.Metal1 0.00696281f
Cred_19569 vin2.P5.GatPoly VSS.$726.Metal1 0.0108588f
Cred_19570 vin2.P5.GatPoly VSS.$744.Metal1 0.0506574f
Cred_19571 vin2.P5.GatPoly VSS.$757.Metal1 0.000343182f
Cred_19572 vin2.P5.GatPoly VSS.P2.pSD 2.68972e-06f
Cred_19573 vin2.P5.GatPoly VSS.P3.pSD 2.68972e-06f
Cred_19574 vin2.P5.GatPoly VSS.P55.nSD 6.84932e-08f
Cred_19575 vin2.P5.GatPoly VSS.P77.nSD 3.02093e-06f
Cred_19576 vin2.P5.GatPoly VSS.P79.nSD 0.00154084f
Cred_19577 vin2.P6.GatPoly vin3.P6.GatPoly 0.0011729f
Cred_19578 vin2.P6.GatPoly vout2.$1226.Metal3 0.0236713f
Cred_19579 vin2.P6.GatPoly vout2.$1292.Metal3 0.0201949f
Cred_19580 vin2.P6.GatPoly vout2.P4.nSD 3.58385e-05f
Cred_19581 vin2.P6.GatPoly vout2.P6.nSD 0.0216827f
Cred_19582 vin2.P6.GatPoly vout2.P6.pSD 0.00173877f
Cred_19583 vin2.P6.GatPoly VSS.$1990.Metal1 7.6038e-07f
Cred_19584 vin2.P6.GatPoly VSS.$2914.Metal2 0.0128825f
Cred_19585 vin2.P6.GatPoly VSS.$2946.Metal2 0.00677301f
Cred_19586 vin2.P6.GatPoly VSS.$2994.Metal2 0.00281776f
Cred_19587 vin2.P6.GatPoly VSS.$3085.Metal2 0.00119903f
Cred_19588 vin2.P6.GatPoly VSS.$4646.Metal3 0.000775961f
Cred_19589 vin2.P6.GatPoly VSS.$4682.Metal3 0.00440935f
Cred_19590 vin2.P6.GatPoly VSS.$68.Metal1 7.30198e-06f
Cred_19591 vin2.P6.GatPoly VSS.$744.Metal1 0.0522293f
Cred_19592 vin2.P6.GatPoly VSS.$817.Metal1 0.0085415f
Cred_19593 vin2.P6.GatPoly VSS.$837.Metal1 0.00867663f
Cred_19594 vin2.P6.GatPoly VSS.$865.Metal1 0.000779039f
Cred_19595 vin2.P6.GatPoly VSS.$923.Metal1 8.80351e-05f
Cred_19596 vin2.P6.GatPoly VSS.P2.pSD 7.31944e-07f
Cred_19597 vin2.P6.GatPoly VSS.P3.pSD 0.000428302f
Cred_19598 vin2.P6.GatPoly VSS.P55.nSD 7.10643e-08f
Cred_19599 vin2.P6.GatPoly VSS.P79.nSD 0.00157393f
Cred_19600 vin2.P6.GatPoly VSS.P81.nSD 3.02093e-06f
Cred_19601 vin2.P7.GatPoly vin3.P7.GatPoly 0.0011729f
Cred_19602 vin2.P7.GatPoly vout2.$1226.Metal3 0.0202598f
Cred_19603 vin2.P7.GatPoly vout2.$1292.Metal3 0.0238867f
Cred_19604 vin2.P7.GatPoly vout2.P6.nSD 0.0215228f
Cred_19605 vin2.P7.GatPoly vout2.P6.pSD 0.00174436f
Cred_19606 vin2.P7.GatPoly vout2.P8.nSD 3.7248e-05f
Cred_19607 vin2.P7.GatPoly VSS.$1990.Metal1 9.75091e-07f
Cred_19608 vin2.P7.GatPoly VSS.$2914.Metal2 0.0011548f
Cred_19609 vin2.P7.GatPoly VSS.$2946.Metal2 4.3853e-05f
Cred_19610 vin2.P7.GatPoly VSS.$2994.Metal2 0.00123086f
Cred_19611 vin2.P7.GatPoly VSS.$3042.Metal2 0.00792992f
Cred_19612 vin2.P7.GatPoly VSS.$3085.Metal2 0.014792f
Cred_19613 vin2.P7.GatPoly VSS.$4706.Metal3 0.00174233f
Cred_19614 vin2.P7.GatPoly VSS.$4730.Metal3 0.00331224f
Cred_19615 vin2.P7.GatPoly VSS.$68.Metal1 5.95569e-06f
Cred_19616 vin2.P7.GatPoly VSS.$744.Metal1 8.84065e-05f
Cred_19617 vin2.P7.GatPoly VSS.$865.Metal1 0.00235249f
Cred_19618 vin2.P7.GatPoly VSS.$885.Metal1 0.00913213f
Cred_19619 vin2.P7.GatPoly VSS.$905.Metal1 0.00769148f
Cred_19620 vin2.P7.GatPoly VSS.$923.Metal1 0.0508325f
Cred_19621 vin2.P7.GatPoly VSS.$936.Metal1 0.00100572f
Cred_19622 vin2.P7.GatPoly VSS.P3.pSD 0.000438819f
Cred_19623 vin2.P7.GatPoly VSS.P55.nSD 6.37334e-09f
Cred_19624 vin2.P7.GatPoly VSS.P79.nSD 3.0273e-06f
Cred_19625 vin2.P7.GatPoly VSS.P81.nSD 0.00155684f
Cred_19626 vin2.P8.GatPoly vin3.P8.GatPoly 0.0011729f
Cred_19627 vin2.P8.GatPoly vout2.$1226.Metal3 0.00164772f
Cred_19628 vin2.P8.GatPoly vout2.$1292.Metal3 0.0439192f
Cred_19629 vin2.P8.GatPoly vout2.P6.nSD 6.16726e-05f
Cred_19630 vin2.P8.GatPoly vout2.P6.pSD 0.000141868f
Cred_19631 vin2.P8.GatPoly vout2.P8.nSD 0.0212328f
Cred_19632 vin2.P8.GatPoly VSS 9.06646e-05f
Cred_19633 vin2.P8.GatPoly VSS.$1024.Metal1 0.00528126f
Cred_19634 vin2.P8.GatPoly VSS.$3085.Metal2 0.0133121f
Cred_19635 vin2.P8.GatPoly VSS.$3101.Metal2 0.00246723f
Cred_19636 vin2.P8.GatPoly VSS.$3157.Metal2 0.00702415f
Cred_19637 vin2.P8.GatPoly VSS.$3260.Metal2 0.000598157f
Cred_19638 vin2.P8.GatPoly VSS.$3292.Metal2 0.000598157f
Cred_19639 vin2.P8.GatPoly VSS.$4754.Metal3 0.00436081f
Cred_19640 vin2.P8.GatPoly VSS.$4778.Metal3 0.00093661f
Cred_19641 vin2.P8.GatPoly VSS.$923.Metal1 0.0511685f
Cred_19642 vin2.P8.GatPoly VSS.$968.Metal1 4.6155e-05f
Cred_19643 vin2.P8.GatPoly VSS.$996.Metal1 0.0124547f
Cred_19644 vin2.P8.GatPoly VSS.P2.pSD 2.79537e-06f
Cred_19645 vin2.P8.GatPoly VSS.P3.pSD 2.79537e-06f
Cred_19646 vin2.P8.GatPoly VSS.P59.nSD 4.51169e-08f
Cred_19647 vin2.P8.GatPoly VSS.P81.nSD 0.00155293f
Cred_19648 vin2.P8.GatPoly VSS.P83.nSD 3.06604e-06f
Cred_19649 vin2.P9.GatPoly vin3.P9.GatPoly 0.0011729f
Cred_19650 vin2.P9.GatPoly vout2.$1292.Metal3 0.0447268f
Cred_19651 vin2.P9.GatPoly vout2.$1358.Metal3 0.0017178f
Cred_19652 vin2.P9.GatPoly vout2.P10.nSD 6.41454e-05f
Cred_19653 vin2.P9.GatPoly vout2.P10.pSD 0.000146571f
Cred_19654 vin2.P9.GatPoly vout2.P8.nSD 0.0215851f
Cred_19655 vin2.P9.GatPoly VSS 0.0525372f
Cred_19656 vin2.P9.GatPoly VSS.$1044.Metal1 0.00137957f
Cred_19657 vin2.P9.GatPoly VSS.$1064.Metal1 0.00847338f
Cred_19658 vin2.P9.GatPoly VSS.$1084.Metal1 0.00991321f
Cred_19659 vin2.P9.GatPoly VSS.$1990.Metal1 2.75749e-06f
Cred_19660 vin2.P9.GatPoly VSS.$3085.Metal2 0.00119903f
Cred_19661 vin2.P9.GatPoly VSS.$3205.Metal2 0.00595581f
Cred_19662 vin2.P9.GatPoly VSS.$3260.Metal2 0.00963009f
Cred_19663 vin2.P9.GatPoly VSS.$3292.Metal2 0.00680756f
Cred_19664 vin2.P9.GatPoly VSS.$4802.Metal3 0.0039077f
Cred_19665 vin2.P9.GatPoly VSS.$68.Metal1 4.5444e-06f
Cred_19666 vin2.P9.GatPoly VSS.$923.Metal1 8.80351e-05f
Cred_19667 vin2.P9.GatPoly VSS.P2.pSD 9.41436e-07f
Cred_19668 vin2.P9.GatPoly VSS.P3.pSD 0.000646408f
Cred_19669 vin2.P9.GatPoly VSS.P59.nSD 5.13471e-07f
Cred_19670 vin2.P9.GatPoly VSS.P81.nSD 3.02093e-06f
Cred_19671 vin2.P9.GatPoly VSS.P83.nSD 0.00163442f
Cred_19672 vin3 VSS 0.0870178f
Cred_19673 vin3 VSS.$1990.Metal1 3.91856e-07f
Cred_19674 vin3 VSS.$4355.Metal3 2.19882e-06f
Cred_19675 vin3 VSS.$4358.Metal3 0.0319254f
Cred_19676 vin3 VSS.$4364.Metal3 3.24897e-05f
Cred_19677 vin3 VSS.$68.Metal1 0.00149719f
Cred_19678 vin3 VSS.P2.pSD 0.00316344f
Cred_19679 vin3.$10.GatPoly vout3.$1226.Metal3 0.000720713f
Cred_19680 vin3.$10.GatPoly vout3.P0.nSD 0.000271067f
Cred_19681 vin3.$10.GatPoly vout3.P0.pSD 9.49465e-05f
Cred_19682 vin3.$10.GatPoly vout3.P2.nSD 1.39824e-05f
Cred_19683 vin3.$10.GatPoly vout3.P2.pSD 6.2053e-05f
Cred_19684 vin3.$10.GatPoly VSS.$1990.Metal1 8.89032e-07f
Cred_19685 vin3.$10.GatPoly VSS.$2481.Metal2 1.82758e-08f
Cred_19686 vin3.$10.GatPoly VSS.$2532.Metal2 0.000233712f
Cred_19687 vin3.$10.GatPoly VSS.$2564.Metal2 0.000313817f
Cred_19688 vin3.$10.GatPoly VSS.$360.Metal1 1.09756e-10f
Cred_19689 vin3.$10.GatPoly VSS.$380.Metal1 6.05005e-06f
Cred_19690 vin3.$10.GatPoly VSS.$386.Metal1 0.00893957f
Cred_19691 vin3.$10.GatPoly VSS.$4478.Metal3 1.46531e-10f
Cred_19692 vin3.$10.GatPoly VSS.$68.Metal1 0.000275324f
Cred_19693 vin3.$10.GatPoly VSS.P2.pSD 0.00262512f
Cred_19694 vin3.$10.GatPoly VSS.P51.nSD 0.000232946f
Cred_19695 vin3.$10.GatPoly VSS.P75.nSD 2.02062e-08f
Cred_19696 vin3.$100.GatPoly vout3.$1292.Metal3 0.00339251f
Cred_19697 vin3.$100.GatPoly vout3.$1358.Metal3 0.00273512f
Cred_19698 vin3.$100.GatPoly vout3.P10.nSD 0.00364314f
Cred_19699 vin3.$100.GatPoly vout3.P10.pSD 0.000233375f
Cred_19700 vin3.$100.GatPoly vout3.P8.nSD 6.16427e-06f
Cred_19701 vin3.$100.GatPoly VSS 0.00190293f
Cred_19702 vin3.$100.GatPoly VSS.$1160.Metal1 1.98943e-06f
Cred_19703 vin3.$100.GatPoly VSS.$1180.Metal1 8.41882e-06f
Cred_19704 vin3.$100.GatPoly VSS.$1990.Metal1 2.59089e-05f
Cred_19705 vin3.$100.GatPoly VSS.$3260.Metal2 0.000400767f
Cred_19706 vin3.$100.GatPoly VSS.$3292.Metal2 0.000400807f
Cred_19707 vin3.$100.GatPoly VSS.$3344.Metal2 4.08818e-08f
Cred_19708 vin3.$100.GatPoly VSS.$4838.Metal3 3.27781e-10f
Cred_19709 vin3.$100.GatPoly VSS.$68.Metal1 1.55494e-05f
Cred_19710 vin3.$100.GatPoly VSS.P2.pSD 0.00365306f
Cred_19711 vin3.$100.GatPoly VSS.P59.nSD 7.11848e-05f
Cred_19712 vin3.$100.GatPoly VSS.P83.nSD 3.02284e-08f
Cred_19713 vin3.$105.GatPoly vout3.$1292.Metal3 0.00513649f
Cred_19714 vin3.$105.GatPoly vout3.$1358.Metal3 0.00513649f
Cred_19715 vin3.$105.GatPoly vout3.P10.nSD 8.09205e-05f
Cred_19716 vin3.$105.GatPoly vout3.P10.pSD 0.00990689f
Cred_19717 vin3.$107.GatPoly vout3.$1292.Metal3 0.0244564f
Cred_19718 vin3.$107.GatPoly vout3.$1358.Metal3 0.0304463f
Cred_19719 vin3.$107.GatPoly vout3.P10.nSD 0.000385287f
Cred_19720 vin3.$107.GatPoly vout3.P10.pSD 0.0348187f
Cred_19721 vin3.$107.GatPoly vout3.P12.pSD 0.000455774f
Cred_19722 vin3.$108.GatPoly vout3.$1292.Metal3 0.00227997f
Cred_19723 vin3.$108.GatPoly vout3.$1358.Metal3 0.00269886f
Cred_19724 vin3.$108.GatPoly vout3.P10.nSD 0.00325776f
Cred_19725 vin3.$108.GatPoly vout3.P10.pSD 0.000194539f
Cred_19726 vin3.$108.GatPoly vout3.P12.nSD 3.92785e-06f
Cred_19727 vin3.$108.GatPoly VSS.$1220.Metal1 5.3362e-07f
Cred_19728 vin3.$108.GatPoly VSS.$1260.Metal1 1.40225e-06f
Cred_19729 vin3.$108.GatPoly VSS.$1266.Metal1 0.0011921f
Cred_19730 vin3.$108.GatPoly VSS.$1990.Metal1 2.71498e-05f
Cred_19731 vin3.$108.GatPoly VSS.$3392.Metal2 2.98926e-09f
Cred_19732 vin3.$108.GatPoly VSS.$3435.Metal2 0.00051197f
Cred_19733 vin3.$108.GatPoly VSS.$68.Metal1 1.15399e-05f
Cred_19734 vin3.$108.GatPoly VSS.P2.pSD 0.00322508f
Cred_19735 vin3.$108.GatPoly VSS.P3.pSD 3.2645e-10f
Cred_19736 vin3.$108.GatPoly VSS.P61.nSD 4.46145e-05f
Cred_19737 vin3.$110.GatPoly vout3.$1292.Metal3 0.00115252f
Cred_19738 vin3.$110.GatPoly vout3.$1358.Metal3 0.00175093f
Cred_19739 vin3.$110.GatPoly vout3.P10.nSD 0.00102547f
Cred_19740 vin3.$110.GatPoly vout3.P10.pSD 9.83392e-05f
Cred_19741 vin3.$110.GatPoly vout3.P12.nSD 5.61121e-06f
Cred_19742 vin3.$110.GatPoly VSS.$1220.Metal1 2.6329e-07f
Cred_19743 vin3.$110.GatPoly VSS.$1260.Metal1 1.29476e-05f
Cred_19744 vin3.$110.GatPoly VSS.$1266.Metal1 0.00746252f
Cred_19745 vin3.$110.GatPoly VSS.$1990.Metal1 2.9206e-05f
Cred_19746 vin3.$110.GatPoly VSS.$3392.Metal2 1.47491e-09f
Cred_19747 vin3.$110.GatPoly VSS.$3435.Metal2 0.00105531f
Cred_19748 vin3.$110.GatPoly VSS.$68.Metal1 8.70948e-06f
Cred_19749 vin3.$110.GatPoly VSS.P2.pSD 0.00290496f
Cred_19750 vin3.$110.GatPoly VSS.P3.pSD 1.61072e-10f
Cred_19751 vin3.$110.GatPoly VSS.P61.nSD 0.000201959f
Cred_19752 vin3.$115.GatPoly vout3.$1292.Metal3 0.000678878f
Cred_19753 vin3.$115.GatPoly vout3.$1358.Metal3 0.0128531f
Cred_19754 vin3.$115.GatPoly vout3.P10.nSD 1.06951e-05f
Cred_19755 vin3.$115.GatPoly vout3.P10.pSD 0.000166405f
Cred_19756 vin3.$115.GatPoly vout3.P12.pSD 0.0077353f
Cred_19757 vin3.$118.GatPoly vout3.$1292.Metal3 0.000253425f
Cred_19758 vin3.$118.GatPoly vout3.$1358.Metal3 0.00238925f
Cred_19759 vin3.$118.GatPoly vout3.P10.nSD 8.98535e-06f
Cred_19760 vin3.$118.GatPoly vout3.P10.pSD 2.16235e-05f
Cred_19761 vin3.$118.GatPoly vout3.P12.nSD 0.000861929f
Cred_19762 vin3.$118.GatPoly VSS.$1266.Metal1 0.00839157f
Cred_19763 vin3.$118.GatPoly VSS.$1339.Metal1 8.41646e-06f
Cred_19764 vin3.$118.GatPoly VSS.$1990.Metal1 4.07451e-05f
Cred_19765 vin3.$118.GatPoly VSS.$3435.Metal2 0.00102568f
Cred_19766 vin3.$118.GatPoly VSS.$3507.Metal2 6.68699e-08f
Cred_19767 vin3.$118.GatPoly VSS.$68.Metal1 8.34319e-06f
Cred_19768 vin3.$118.GatPoly VSS.P2.pSD 0.00335249f
Cred_19769 vin3.$118.GatPoly VSS.P61.nSD 0.000219307f
Cred_19770 vin3.$122.GatPoly vout3.$1292.Metal3 0.000106508f
Cred_19771 vin3.$122.GatPoly vout3.$1358.Metal3 0.00905481f
Cred_19772 vin3.$122.GatPoly vout3.$1424.Metal3 2.65924e-05f
Cred_19773 vin3.$122.GatPoly vout3.P10.nSD 3.77632e-06f
Cred_19774 vin3.$122.GatPoly vout3.P10.pSD 9.08784e-06f
Cred_19775 vin3.$122.GatPoly vout3.P12.nSD 0.00591478f
Cred_19776 vin3.$122.GatPoly vout3.P14.nSD 9.42849e-07f
Cred_19777 vin3.$122.GatPoly vout3.P14.pSD 2.269e-06f
Cred_19778 vin3.$122.GatPoly VSS.$1266.Metal1 0.000634609f
Cred_19779 vin3.$122.GatPoly VSS.$1445.Metal1 0.000154764f
Cred_19780 vin3.$122.GatPoly VSS.$1990.Metal1 5.68224e-05f
Cred_19781 vin3.$122.GatPoly VSS.$3435.Metal2 0.000270194f
Cred_19782 vin3.$122.GatPoly VSS.$3603.Metal2 2.45511e-06f
Cred_19783 vin3.$122.GatPoly VSS.$3638.Metal2 6.46511e-05f
Cred_19784 vin3.$122.GatPoly VSS.$68.Metal1 7.44598e-06f
Cred_19785 vin3.$122.GatPoly VSS.P2.pSD 0.00373171f
Cred_19786 vin3.$122.GatPoly VSS.P61.nSD 2.37508e-05f
Cred_19787 vin3.$122.GatPoly VSS.P63.nSD 5.79149e-06f
Cred_19788 vin3.$122.GatPoly VSS.P87.nSD 3.56811e-10f
Cred_19789 vin3.$123.GatPoly vout3.$1292.Metal3 0.000877157f
Cred_19790 vin3.$123.GatPoly vout3.$1358.Metal3 0.0274113f
Cred_19791 vin3.$123.GatPoly vout3.P10.nSD 1.38188e-05f
Cred_19792 vin3.$123.GatPoly vout3.P10.pSD 0.000215008f
Cred_19793 vin3.$123.GatPoly vout3.P12.pSD 0.0188942f
Cred_19794 vin3.$127.GatPoly vout3.$1358.Metal3 0.0563073f
Cred_19795 vin3.$127.GatPoly vout3.$1424.Metal3 0.00286031f
Cred_19796 vin3.$127.GatPoly vout3.P12.pSD 0.0346375f
Cred_19797 vin3.$127.GatPoly vout3.P14.nSD 4.50615e-05f
Cred_19798 vin3.$127.GatPoly vout3.P14.pSD 0.000701114f
Cred_19799 vin3.$130.GatPoly vout3.$1358.Metal3 0.00469248f
Cred_19800 vin3.$130.GatPoly vout3.$1424.Metal3 0.000411585f
Cred_19801 vin3.$130.GatPoly vout3.P12.nSD 0.00211167f
Cred_19802 vin3.$130.GatPoly vout3.P14.nSD 1.4593e-05f
Cred_19803 vin3.$130.GatPoly vout3.P14.pSD 3.51185e-05f
Cred_19804 vin3.$130.GatPoly VSS.$1407.Metal1 2.21748e-06f
Cred_19805 vin3.$130.GatPoly VSS.$1427.Metal1 8.42002e-06f
Cred_19806 vin3.$130.GatPoly VSS.$1445.Metal1 0.00550767f
Cred_19807 vin3.$130.GatPoly VSS.$1990.Metal1 6.2806e-05f
Cred_19808 vin3.$130.GatPoly VSS.$3555.Metal2 4.65484e-08f
Cred_19809 vin3.$130.GatPoly VSS.$3603.Metal2 4.55804e-05f
Cred_19810 vin3.$130.GatPoly VSS.$3638.Metal2 0.00119906f
Cred_19811 vin3.$130.GatPoly VSS.$4958.Metal3 3.73215e-10f
Cred_19812 vin3.$130.GatPoly VSS.$68.Metal1 5.32811e-06f
Cred_19813 vin3.$130.GatPoly VSS.P2.pSD 0.00330809f
Cred_19814 vin3.$130.GatPoly VSS.P63.nSD 0.000177406f
Cred_19815 vin3.$130.GatPoly VSS.P87.nSD 6.61762e-09f
Cred_19816 vin3.$134.GatPoly VSS.$1445.Metal1 0.0122579f
Cred_19817 vin3.$134.GatPoly VSS.$1518.Metal1 7.30432e-08f
Cred_19818 vin3.$134.GatPoly VSS.$1990.Metal1 6.90504e-05f
Cred_19819 vin3.$134.GatPoly VSS.$3603.Metal2 2.05674e-05f
Cred_19820 vin3.$134.GatPoly VSS.$3638.Metal2 0.000541607f
Cred_19821 vin3.$134.GatPoly VSS.$68.Metal1 4.06971e-06f
Cred_19822 vin3.$134.GatPoly VSS.P2.pSD 0.00302483f
Cred_19823 vin3.$134.GatPoly VSS.P63.nSD 0.000241435f
Cred_19824 vin3.$134.GatPoly VSS.P87.nSD 2.98914e-09f
Cred_19825 vin3.$135.GatPoly vout3.$1358.Metal3 3.10023e-08f
Cred_19826 vin3.$135.GatPoly vout3.$1424.Metal3 1.31326e-08f
Cred_19827 vin3.$135.GatPoly vout3.P12.pSD 1.16045e-09f
Cred_19828 vin3.$135.GatPoly vout3.P14.nSD 2.06892e-10f
Cred_19829 vin3.$135.GatPoly vout3.P14.pSD 2.28099e-09f
Cred_19830 vin3.$136.GatPoly vout3.$1358.Metal3 0.00499409f
Cred_19831 vin3.$136.GatPoly vout3.$1424.Metal3 0.00354525f
Cred_19832 vin3.$136.GatPoly vout3.P12.nSD 1.35855e-05f
Cred_19833 vin3.$136.GatPoly vout3.P14.nSD 0.00342747f
Cred_19834 vin3.$136.GatPoly vout3.P14.pSD 0.000302499f
Cred_19835 vin3.$136.GatPoly VSS.$1445.Metal1 0.00489035f
Cred_19836 vin3.$136.GatPoly VSS.$1518.Metal1 9.5518e-08f
Cred_19837 vin3.$136.GatPoly VSS.$1990.Metal1 7.35294e-05f
Cred_19838 vin3.$136.GatPoly VSS.$3603.Metal2 6.6547e-05f
Cred_19839 vin3.$136.GatPoly VSS.$3638.Metal2 0.0017524f
Cred_19840 vin3.$136.GatPoly VSS.$68.Metal1 3.0959e-06f
Cred_19841 vin3.$136.GatPoly VSS.P2.pSD 0.00271121f
Cred_19842 vin3.$136.GatPoly VSS.P63.nSD 0.000183077f
Cred_19843 vin3.$136.GatPoly VSS.P87.nSD 9.67155e-09f
Cred_19844 vin3.$137.GatPoly vout3.$1358.Metal3 0.031535f
Cred_19845 vin3.$137.GatPoly vout3.$1424.Metal3 0.0255253f
Cred_19846 vin3.$137.GatPoly vout3.P12.pSD 0.000457058f
Cred_19847 vin3.$137.GatPoly vout3.P14.nSD 0.000402127f
Cred_19848 vin3.$137.GatPoly vout3.P14.pSD 0.0365848f
Cred_19849 vin3.$144.GatPoly vout3.$1358.Metal3 0.00354829f
Cred_19850 vin3.$144.GatPoly vout3.$1424.Metal3 0.00372908f
Cred_19851 vin3.$144.GatPoly vout3.P14.nSD 0.00542205f
Cred_19852 vin3.$144.GatPoly vout3.P14.pSD 0.000302758f
Cred_19853 vin3.$144.GatPoly vout3.P16.nSD 1.69521e-06f
Cred_19854 vin3.$144.GatPoly VSS.$1624.Metal1 0.000497646f
Cred_19855 vin3.$144.GatPoly VSS.$1990.Metal1 0.000131046f
Cred_19856 vin3.$144.GatPoly VSS.$3809.Metal2 0.00021693f
Cred_19857 vin3.$144.GatPoly VSS.$68.Metal1 3.88118e-06f
Cred_19858 vin3.$144.GatPoly VSS.P2.pSD 0.00403041f
Cred_19859 vin3.$144.GatPoly VSS.P65.nSD 1.86237e-05f
Cred_19860 vin3.$145.GatPoly vout3.$1358.Metal3 0.00988551f
Cred_19861 vin3.$145.GatPoly vout3.$1424.Metal3 0.0110746f
Cred_19862 vin3.$145.GatPoly vout3.P14.nSD 0.000155737f
Cred_19863 vin3.$145.GatPoly vout3.P14.pSD 0.0161545f
Cred_19864 vin3.$145.GatPoly vout3.P16.pSD 9.04344e-05f
Cred_19865 vin3.$15.GatPoly vout3.$1226.Metal3 0.0508176f
Cred_19866 vin3.$15.GatPoly vout3.P0.nSD 0.000803016f
Cred_19867 vin3.$15.GatPoly vout3.P0.pSD 0.00487722f
Cred_19868 vin3.$15.GatPoly vout3.P2.nSD 0.000800583f
Cred_19869 vin3.$15.GatPoly vout3.P2.pSD 0.0392747f
Cred_19870 vin3.$152.GatPoly vout3.$1358.Metal3 0.000662949f
Cred_19871 vin3.$152.GatPoly vout3.$1424.Metal3 0.000984583f
Cred_19872 vin3.$152.GatPoly vout3.P14.nSD 0.000634338f
Cred_19873 vin3.$152.GatPoly vout3.P14.pSD 5.65662e-05f
Cred_19874 vin3.$152.GatPoly vout3.P16.nSD 3.01592e-06f
Cred_19875 vin3.$152.GatPoly VSS.$1624.Metal1 0.0124478f
Cred_19876 vin3.$152.GatPoly VSS.$1990.Metal1 0.000149461f
Cred_19877 vin3.$152.GatPoly VSS.$3809.Metal2 0.00106095f
Cred_19878 vin3.$152.GatPoly VSS.$68.Metal1 2.57994e-06f
Cred_19879 vin3.$152.GatPoly VSS.P2.pSD 0.00347315f
Cred_19880 vin3.$152.GatPoly VSS.P65.nSD 0.000321196f
Cred_19881 vin3.$153.GatPoly vout3.$1358.Metal3 0.00887412f
Cred_19882 vin3.$153.GatPoly vout3.$1424.Metal3 0.0109896f
Cred_19883 vin3.$153.GatPoly vout3.P14.nSD 0.000139803f
Cred_19884 vin3.$153.GatPoly vout3.P14.pSD 0.0126694f
Cred_19885 vin3.$153.GatPoly vout3.P16.pSD 0.00016089f
Cred_19886 vin3.$156.GatPoly vout3.$1358.Metal3 0.000689567f
Cred_19887 vin3.$156.GatPoly vout3.$1424.Metal3 0.00807741f
Cred_19888 vin3.$156.GatPoly vout3.P14.nSD 2.4449e-05f
Cred_19889 vin3.$156.GatPoly vout3.P14.pSD 5.88374e-05f
Cred_19890 vin3.$156.GatPoly vout3.P16.nSD 0.00329167f
Cred_19891 vin3.$156.GatPoly VSS.$1624.Metal1 0.00694219f
Cred_19892 vin3.$156.GatPoly VSS.$1990.Metal1 0.000175976f
Cred_19893 vin3.$156.GatPoly VSS.$3809.Metal2 0.00189944f
Cred_19894 vin3.$156.GatPoly VSS.$68.Metal1 1.94641e-06f
Cred_19895 vin3.$156.GatPoly VSS.P2.pSD 0.00324127f
Cred_19896 vin3.$156.GatPoly VSS.P65.nSD 0.000217216f
Cred_19897 vin3.$157.GatPoly vout3.$1358.Metal3 0.00286031f
Cred_19898 vin3.$157.GatPoly vout3.$1424.Metal3 0.0543541f
Cred_19899 vin3.$157.GatPoly vout3.P14.nSD 4.50615e-05f
Cred_19900 vin3.$157.GatPoly vout3.P14.pSD 0.000701114f
Cred_19901 vin3.$157.GatPoly vout3.P16.pSD 0.032808f
Cred_19902 vin3.$16.GatPoly vout3.$1226.Metal3 0.00169532f
Cred_19903 vin3.$16.GatPoly vout3.P0.nSD 3.44551e-05f
Cred_19904 vin3.$16.GatPoly vout3.P0.pSD 0.000152976f
Cred_19905 vin3.$16.GatPoly vout3.P2.nSD 0.000738215f
Cred_19906 vin3.$16.GatPoly vout3.P2.pSD 0.000145967f
Cred_19907 vin3.$16.GatPoly VSS.$1990.Metal1 1.1465e-06f
Cred_19908 vin3.$16.GatPoly VSS.$2532.Metal2 0.0004027f
Cred_19909 vin3.$16.GatPoly VSS.$2564.Metal2 0.000540801f
Cred_19910 vin3.$16.GatPoly VSS.$2620.Metal2 3.32646e-08f
Cred_19911 vin3.$16.GatPoly VSS.$386.Metal1 0.00954445f
Cred_19912 vin3.$16.GatPoly VSS.$451.Metal1 3.52716e-11f
Cred_19913 vin3.$16.GatPoly VSS.$4514.Metal3 2.66709e-10f
Cred_19914 vin3.$16.GatPoly VSS.$471.Metal1 1.71316e-06f
Cred_19915 vin3.$16.GatPoly VSS.$68.Metal1 0.000253576f
Cred_19916 vin3.$16.GatPoly VSS.P2.pSD 0.00290175f
Cred_19917 vin3.$16.GatPoly VSS.P51.nSD 0.000255633f
Cred_19918 vin3.$16.GatPoly VSS.P75.nSD 3.48193e-08f
Cred_19919 vin3.$163.GatPoly vout3.$1424.Metal3 0.00960736f
Cred_19920 vin3.$163.GatPoly vout3.P16.pSD 0.00750068f
Cred_19921 vin3.$164.GatPoly vout3 2.45242e-05f
Cred_19922 vin3.$164.GatPoly vout3.$1424.Metal3 0.00808702f
Cred_19923 vin3.$164.GatPoly vout3.P16.nSD 0.00541437f
Cred_19924 vin3.$164.GatPoly vout3.P18.nSD 3.45556e-06f
Cred_19925 vin3.$164.GatPoly vout3.P18.pSD 1.05536e-05f
Cred_19926 vin3.$164.GatPoly VSS.$1799.Metal1 0.000453293f
Cred_19927 vin3.$164.GatPoly VSS.$1990.Metal1 0.000282136f
Cred_19928 vin3.$164.GatPoly VSS.$3988.Metal2 0.000110826f
Cred_19929 vin3.$164.GatPoly VSS.$4020.Metal2 8.25299e-05f
Cred_19930 vin3.$164.GatPoly VSS.$68.Metal1 2.10243e-06f
Cred_19931 vin3.$164.GatPoly VSS.P2.pSD 0.00422098f
Cred_19932 vin3.$164.GatPoly VSS.P67.nSD 1.69563e-05f
Cred_19933 vin3.$164.GatPoly VSS.P91.nSD 7.13592e-09f
Cred_19934 vin3.$167.GatPoly vout3 0.000917059f
Cred_19935 vin3.$167.GatPoly vout3.$1424.Metal3 0.0594151f
Cred_19936 vin3.$167.GatPoly vout3.P16.pSD 0.0353919f
Cred_19937 vin3.$167.GatPoly vout3.P18.nSD 7.28651e-05f
Cred_19938 vin3.$167.GatPoly vout3.P18.pSD 0.000851701f
Cred_19939 vin3.$17.GatPoly vout3.$1226.Metal3 9.75242e-08f
Cred_19940 vin3.$17.GatPoly vout3.P0.nSD 1.4123e-09f
Cred_19941 vin3.$17.GatPoly vout3.P0.pSD 7.50474e-09f
Cred_19942 vin3.$17.GatPoly vout3.P2.nSD 1.5364e-09f
Cred_19943 vin3.$17.GatPoly vout3.P2.pSD 8.39679e-09f
Cred_19944 vin3.$172.GatPoly vout3 5.48779e-05f
Cred_19945 vin3.$172.GatPoly vout3.$1424.Metal3 0.0019692f
Cred_19946 vin3.$172.GatPoly vout3.P16.nSD 0.000711506f
Cred_19947 vin3.$172.GatPoly vout3.P18.nSD 7.73254e-06f
Cred_19948 vin3.$172.GatPoly vout3.P18.pSD 2.36159e-05f
Cred_19949 vin3.$172.GatPoly VSS.$1773.Metal1 1.71316e-06f
Cred_19950 vin3.$172.GatPoly VSS.$1793.Metal1 3.52716e-11f
Cred_19951 vin3.$172.GatPoly VSS.$1799.Metal1 0.0099594f
Cred_19952 vin3.$172.GatPoly VSS.$1990.Metal1 0.000253576f
Cred_19953 vin3.$172.GatPoly VSS.$3929.Metal2 3.32646e-08f
Cred_19954 vin3.$172.GatPoly VSS.$3988.Metal2 0.000562129f
Cred_19955 vin3.$172.GatPoly VSS.$4020.Metal2 0.000418582f
Cred_19956 vin3.$172.GatPoly VSS.$5126.Metal3 2.66709e-10f
Cred_19957 vin3.$172.GatPoly VSS.$68.Metal1 1.1465e-06f
Cred_19958 vin3.$172.GatPoly VSS.P2.pSD 0.00290175f
Cred_19959 vin3.$172.GatPoly VSS.P67.nSD 0.000271194f
Cred_19960 vin3.$172.GatPoly VSS.P91.nSD 3.61925e-08f
Cred_19961 vin3.$173.GatPoly vout3.$1424.Metal3 1.16374e-07f
Cred_19962 vin3.$176.GatPoly vout3 9.62364e-05f
Cred_19963 vin3.$176.GatPoly vout3.$1424.Metal3 0.000765661f
Cred_19964 vin3.$176.GatPoly vout3.P16.nSD 2.62829e-06f
Cred_19965 vin3.$176.GatPoly vout3.P18.nSD 0.000256822f
Cred_19966 vin3.$176.GatPoly vout3.P18.pSD 4.14139e-05f
Cred_19967 vin3.$176.GatPoly VSS.$1799.Metal1 0.00893957f
Cred_19968 vin3.$176.GatPoly VSS.$1864.Metal1 6.05005e-06f
Cred_19969 vin3.$176.GatPoly VSS.$1884.Metal1 1.09756e-10f
Cred_19970 vin3.$176.GatPoly VSS.$1990.Metal1 0.000275324f
Cred_19971 vin3.$176.GatPoly VSS.$3988.Metal2 0.000313817f
Cred_19972 vin3.$176.GatPoly VSS.$4020.Metal2 0.000233712f
Cred_19973 vin3.$176.GatPoly VSS.$4068.Metal2 1.82758e-08f
Cred_19974 vin3.$176.GatPoly VSS.$5162.Metal3 1.46531e-10f
Cred_19975 vin3.$176.GatPoly VSS.$68.Metal1 8.89032e-07f
Cred_19976 vin3.$176.GatPoly VSS.P2.pSD 0.00262512f
Cred_19977 vin3.$176.GatPoly VSS.P67.nSD 0.000232946f
Cred_19978 vin3.$176.GatPoly VSS.P91.nSD 2.02062e-08f
Cred_19979 vin3.$179.GatPoly vout3 0.00802799f
Cred_19980 vin3.$179.GatPoly vout3.$1424.Metal3 0.0455281f
Cred_19981 vin3.$179.GatPoly vout3.P16.pSD 0.000356917f
Cred_19982 vin3.$179.GatPoly vout3.P18.nSD 0.000637866f
Cred_19983 vin3.$179.GatPoly vout3.P18.pSD 0.038301f
Cred_19984 vin3.$179.GatPoly VSS.$4140.Metal2 0.000109957f
Cred_19985 vin3.$180.GatPoly vout3 0.00145572f
Cred_19986 vin3.$180.GatPoly vout3.$1424.Metal3 0.00762217f
Cred_19987 vin3.$180.GatPoly vout3.P16.nSD 2.62829e-06f
Cred_19988 vin3.$180.GatPoly vout3.P18.nSD 0.00567457f
Cred_19989 vin3.$180.GatPoly vout3.P18.pSD 0.000626446f
Cred_19990 vin3.$180.GatPoly VSS.$1799.Metal1 0.00053061f
Cred_19991 vin3.$180.GatPoly VSS.$1952.Metal1 4.55324e-05f
Cred_19992 vin3.$180.GatPoly VSS.$1990.Metal1 0.000694416f
Cred_19993 vin3.$180.GatPoly VSS.$2022.Metal1 0.000217891f
Cred_19994 vin3.$180.GatPoly VSS.$3988.Metal2 2.72725e-05f
Cred_19995 vin3.$180.GatPoly VSS.$4020.Metal2 2.03093e-05f
Cred_19996 vin3.$180.GatPoly VSS.$4116.Metal2 1.85091e-06f
Cred_19997 vin3.$180.GatPoly VSS.$4174.Metal2 5.37076e-06f
Cred_19998 vin3.$180.GatPoly VSS.$68.Metal1 1.31914e-06f
Cred_19999 vin3.$180.GatPoly VSS.P2.pSD 0.00488626f
Cred_20000 vin3.$180.GatPoly VSS.P5.GatPoly 0.000406711f
Cred_20001 vin3.$180.GatPoly VSS.P67.nSD 1.98985e-05f
Cred_20002 vin3.$180.GatPoly VSS.P69.nSD 1.50481e-06f
Cred_20003 vin3.$180.GatPoly VSS.P71.nSD 1.50481e-06f
Cred_20004 vin3.$180.GatPoly VSS.P91.nSD 1.75604e-09f
Cred_20005 vin3.$202.Metal1 vout3.$1226.Metal3 0.030871f
Cred_20006 vin3.$202.Metal1 vout3.P0.nSD 0.0281763f
Cred_20007 vin3.$202.Metal1 vout3.P0.pSD 0.0048746f
Cred_20008 vin3.$202.Metal1 vout3.P2.nSD 0.000487734f
Cred_20009 vin3.$202.Metal1 vout3.P2.pSD 0.00265798f
Cred_20010 vin3.$202.Metal1 VSS.$159.Metal1 0.000983898f
Cred_20011 vin3.$202.Metal1 VSS.$1990.Metal1 1.62678e-05f
Cred_20012 vin3.$202.Metal1 VSS.$2238.Metal2 0.002166f
Cred_20013 vin3.$202.Metal1 VSS.$2409.Metal2 0.000119287f
Cred_20014 vin3.$202.Metal1 VSS.$2433.Metal2 0.000137017f
Cred_20015 vin3.$202.Metal1 VSS.$2481.Metal2 2.19277e-05f
Cred_20016 vin3.$202.Metal1 VSS.$2532.Metal2 0.000275531f
Cred_20017 vin3.$202.Metal1 VSS.$2564.Metal2 0.000340553f
Cred_20018 vin3.$202.Metal1 VSS.$292.Metal1 0.00125721f
Cred_20019 vin3.$202.Metal1 VSS.$360.Metal1 0.00134403f
Cred_20020 vin3.$202.Metal1 VSS.$380.Metal1 0.000508459f
Cred_20021 vin3.$202.Metal1 VSS.$386.Metal1 0.00662575f
Cred_20022 vin3.$202.Metal1 VSS.$4358.Metal3 0.000615753f
Cred_20023 vin3.$202.Metal1 VSS.$4478.Metal3 1.75812e-07f
Cred_20024 vin3.$202.Metal1 VSS.$68.Metal1 0.00870838f
Cred_20025 vin3.$202.Metal1 VSS.P2.pSD 0.0593128f
Cred_20026 vin3.$202.Metal1 VSS.P4.GatPoly 0.00157389f
Cred_20027 vin3.$202.Metal1 VSS.P48.nSD 6.49096e-06f
Cred_20028 vin3.$202.Metal1 VSS.P49.nSD 6.49096e-06f
Cred_20029 vin3.$202.Metal1 VSS.P51.nSD 0.000253589f
Cred_20030 vin3.$202.Metal1 VSS.P75.nSD 2.19277e-08f
Cred_20031 vin3.$203.Metal1 vout3.$1226.Metal3 0.0619989f
Cred_20032 vin3.$203.Metal1 vout3.P0.nSD 0.00184613f
Cred_20033 vin3.$203.Metal1 vout3.P0.pSD 0.0676836f
Cred_20034 vin3.$203.Metal1 vout3.P2.nSD 0.000976734f
Cred_20035 vin3.$203.Metal1 vout3.P2.pSD 0.00533807f
Cred_20036 vin3.$203.Metal1 VSS.$1990.Metal1 1.95535e-07f
Cred_20037 vin3.$203.Metal1 VSS.$2409.Metal2 1.07689e-05f
Cred_20038 vin3.$203.Metal1 VSS.$2433.Metal2 7.89696e-06f
Cred_20039 vin3.$203.Metal1 VSS.$4418.Metal3 0.00134312f
Cred_20040 vin3.$203.Metal1 VSS.$4454.Metal3 0.000984932f
Cred_20041 vin3.$203.Metal1 VSS.$68.Metal1 0.000417954f
Cred_20042 vin3.$203.Metal1 VSS.P2.pSD 0.00126719f
Cred_20043 vin3.$203.Metal1 VSS.P4.GatPoly 8.90637e-05f
Cred_20044 vin3.$207.Metal1 vout3.$1226.Metal3 8.52779e-06f
Cred_20045 vin3.$207.Metal1 vout3.P0.nSD 2.53931e-07f
Cred_20046 vin3.$207.Metal1 vout3.P0.pSD 1.34935e-06f
Cred_20047 vin3.$207.Metal1 vout3.P2.nSD 1.34347e-07f
Cred_20048 vin3.$207.Metal1 vout3.P2.pSD 7.34239e-07f
Cred_20049 vin3.$210.Metal1 vout3.$1226.Metal3 1.23751e-05f
Cred_20050 vin3.$210.Metal1 vout3.P0.nSD 2.43471e-07f
Cred_20051 vin3.$210.Metal1 vout3.P0.pSD 1.29377e-06f
Cred_20052 vin3.$210.Metal1 vout3.P2.nSD 1.94958e-07f
Cred_20053 vin3.$210.Metal1 vout3.P2.pSD 1.06549e-06f
Cred_20054 vin3.$210.Metal1 VSS.$1990.Metal1 8.27046e-06f
Cred_20055 vin3.$210.Metal1 VSS.$2481.Metal2 1.53249e-06f
Cred_20056 vin3.$210.Metal1 VSS.$2532.Metal2 0.00154718f
Cred_20057 vin3.$210.Metal1 VSS.$2564.Metal2 0.00207838f
Cred_20058 vin3.$210.Metal1 VSS.$2620.Metal2 2.78802e-06f
Cred_20059 vin3.$210.Metal1 VSS.$360.Metal1 9.20339e-09f
Cred_20060 vin3.$210.Metal1 VSS.$380.Metal1 0.000507316f
Cred_20061 vin3.$210.Metal1 VSS.$386.Metal1 0.0418812f
Cred_20062 vin3.$210.Metal1 VSS.$4478.Metal3 1.22871e-08f
Cred_20063 vin3.$210.Metal1 VSS.$451.Metal1 2.95623e-09f
Cred_20064 vin3.$210.Metal1 VSS.$4514.Metal3 2.23537e-08f
Cred_20065 vin3.$210.Metal1 VSS.$471.Metal1 0.000143586f
Cred_20066 vin3.$210.Metal1 VSS.$68.Metal1 0.00215458f
Cred_20067 vin3.$210.Metal1 VSS.P2.pSD 0.022553f
Cred_20068 vin3.$210.Metal1 VSS.P51.nSD 0.00156409f
Cred_20069 vin3.$210.Metal1 VSS.P75.nSD 1.33644e-07f
Cred_20070 vin3.$211.Metal1 vout3.$1226.Metal3 8.17381e-06f
Cred_20071 vin3.$211.Metal1 vout3.P0.nSD 1.1837e-07f
Cred_20072 vin3.$211.Metal1 vout3.P0.pSD 6.28996e-07f
Cred_20073 vin3.$211.Metal1 vout3.P2.nSD 1.28771e-07f
Cred_20074 vin3.$211.Metal1 vout3.P2.pSD 7.03761e-07f
Cred_20075 vin3.$218.Metal1 vout3.$1226.Metal3 0.00095452f
Cred_20076 vin3.$218.Metal1 vout3.P0.nSD 1.90611e-05f
Cred_20077 vin3.$218.Metal1 vout3.P0.pSD 8.53615e-05f
Cred_20078 vin3.$218.Metal1 vout3.P2.nSD 0.000391345f
Cred_20079 vin3.$218.Metal1 vout3.P2.pSD 8.21837e-05f
Cred_20080 vin3.$218.Metal1 VSS.$1990.Metal1 7.28726e-06f
Cred_20081 vin3.$218.Metal1 VSS.$2532.Metal2 0.000371147f
Cred_20082 vin3.$218.Metal1 VSS.$2564.Metal2 0.000518159f
Cred_20083 vin3.$218.Metal1 VSS.$2620.Metal2 1.99279e-05f
Cred_20084 vin3.$218.Metal1 VSS.$386.Metal1 0.00768135f
Cred_20085 vin3.$218.Metal1 VSS.$451.Metal1 2.09529e-08f
Cred_20086 vin3.$218.Metal1 VSS.$4514.Metal3 1.58437e-07f
Cred_20087 vin3.$218.Metal1 VSS.$471.Metal1 0.00224803f
Cred_20088 vin3.$218.Metal1 VSS.$499.Metal1 2.60524e-05f
Cred_20089 vin3.$218.Metal1 VSS.$68.Metal1 0.00142191f
Cred_20090 vin3.$218.Metal1 VSS.P2.pSD 0.0174256f
Cred_20091 vin3.$218.Metal1 VSS.P3.pSD 1.59284e-08f
Cred_20092 vin3.$218.Metal1 VSS.P51.nSD 0.000293209f
Cred_20093 vin3.$218.Metal1 VSS.P75.nSD 3.20911e-08f
Cred_20094 vin3.$219.Metal1 vout3.$1226.Metal3 0.00483512f
Cred_20095 vin3.$219.Metal1 vout3.P0.nSD 7.00202e-05f
Cred_20096 vin3.$219.Metal1 vout3.P0.pSD 0.000372076f
Cred_20097 vin3.$219.Metal1 vout3.P2.nSD 7.61729e-05f
Cred_20098 vin3.$219.Metal1 vout3.P2.pSD 0.00423958f
Cred_20099 vin3.$22.GatPoly vout3.$1226.Metal3 0.00679724f
Cred_20100 vin3.$22.GatPoly vout3.P0.nSD 0.000102861f
Cred_20101 vin3.$22.GatPoly vout3.P0.pSD 0.000533128f
Cred_20102 vin3.$22.GatPoly vout3.P2.nSD 0.00552145f
Cred_20103 vin3.$22.GatPoly vout3.P2.pSD 0.000585239f
Cred_20104 vin3.$22.GatPoly VSS.$1990.Metal1 2.10243e-06f
Cred_20105 vin3.$22.GatPoly VSS.$2532.Metal2 8.25299e-05f
Cred_20106 vin3.$22.GatPoly VSS.$2564.Metal2 0.000110826f
Cred_20107 vin3.$22.GatPoly VSS.$386.Metal1 0.000453293f
Cred_20108 vin3.$22.GatPoly VSS.$68.Metal1 0.000282136f
Cred_20109 vin3.$22.GatPoly VSS.P2.pSD 0.00422098f
Cred_20110 vin3.$22.GatPoly VSS.P51.nSD 1.69563e-05f
Cred_20111 vin3.$22.GatPoly VSS.P75.nSD 7.13592e-09f
Cred_20112 vin3.$222.Metal1 vout3.$1226.Metal3 0.0137326f
Cred_20113 vin3.$222.Metal1 vout3.P0.nSD 0.00020121f
Cred_20114 vin3.$222.Metal1 vout3.P0.pSD 0.00106208f
Cred_20115 vin3.$222.Metal1 vout3.P2.nSD 0.0131392f
Cred_20116 vin3.$222.Metal1 vout3.P2.pSD 0.00118237f
Cred_20117 vin3.$222.Metal1 VSS.$1990.Metal1 8.47542e-06f
Cred_20118 vin3.$222.Metal1 VSS.$2532.Metal2 4.36492e-05f
Cred_20119 vin3.$222.Metal1 VSS.$2564.Metal2 5.86146e-05f
Cred_20120 vin3.$222.Metal1 VSS.$2620.Metal2 3.622e-06f
Cred_20121 vin3.$222.Metal1 VSS.$386.Metal1 0.000239742f
Cred_20122 vin3.$222.Metal1 VSS.$471.Metal1 0.000564734f
Cred_20123 vin3.$222.Metal1 VSS.$499.Metal1 0.000564468f
Cred_20124 vin3.$222.Metal1 VSS.$68.Metal1 0.00124316f
Cred_20125 vin3.$222.Metal1 VSS.P2.pSD 0.0177526f
Cred_20126 vin3.$222.Metal1 VSS.P3.pSD 3.45115e-07f
Cred_20127 vin3.$222.Metal1 VSS.P51.nSD 8.96799e-06f
Cred_20128 vin3.$222.Metal1 VSS.P75.nSD 3.77411e-09f
Cred_20129 vin3.$227.Metal1 vout3.$1226.Metal3 0.0232307f
Cred_20130 vin3.$227.Metal1 vout3.P0.nSD 0.000336417f
Cred_20131 vin3.$227.Metal1 vout3.P0.pSD 0.00178766f
Cred_20132 vin3.$227.Metal1 vout3.P2.nSD 0.000365978f
Cred_20133 vin3.$227.Metal1 vout3.P2.pSD 0.0242275f
Cred_20134 vin3.$228.Metal1 vout3.$1226.Metal3 0.0162775f
Cred_20135 vin3.$228.Metal1 vout3.P0.nSD 0.000235723f
Cred_20136 vin3.$228.Metal1 vout3.P0.pSD 0.00125259f
Cred_20137 vin3.$228.Metal1 vout3.P2.nSD 0.0156674f
Cred_20138 vin3.$228.Metal1 vout3.P2.pSD 0.00140148f
Cred_20139 vin3.$228.Metal1 VSS.$1990.Metal1 9.67646e-06f
Cred_20140 vin3.$228.Metal1 VSS.$2668.Metal2 3.39179e-05f
Cred_20141 vin3.$228.Metal1 VSS.$2711.Metal2 7.66844e-06f
Cred_20142 vin3.$228.Metal1 VSS.$2727.Metal2 9.1726e-06f
Cred_20143 vin3.$228.Metal1 VSS.$4562.Metal3 7.35439e-08f
Cred_20144 vin3.$228.Metal1 VSS.$539.Metal1 2.26786e-08f
Cred_20145 vin3.$228.Metal1 VSS.$559.Metal1 5.07568e-08f
Cred_20146 vin3.$228.Metal1 VSS.$565.Metal1 6.4622e-07f
Cred_20147 vin3.$228.Metal1 VSS.$68.Metal1 0.00111512f
Cred_20148 vin3.$228.Metal1 VSS.P2.pSD 0.0180971f
Cred_20149 vin3.$228.Metal1 VSS.P53.nSD 2.24422e-08f
Cred_20150 vin3.$232.Metal1 vout3.$1226.Metal3 0.00029223f
Cred_20151 vin3.$232.Metal1 vout3.P0.nSD 4.23195e-06f
Cred_20152 vin3.$232.Metal1 vout3.P0.pSD 2.24879e-05f
Cred_20153 vin3.$232.Metal1 vout3.P2.nSD 8.68776e-05f
Cred_20154 vin3.$232.Metal1 vout3.P2.pSD 2.51609e-05f
Cred_20155 vin3.$232.Metal1 VSS.$1990.Metal1 7.36444e-06f
Cred_20156 vin3.$232.Metal1 VSS.$2668.Metal2 4.04704e-05f
Cred_20157 vin3.$232.Metal1 VSS.$2711.Metal2 1.48977e-05f
Cred_20158 vin3.$232.Metal1 VSS.$2727.Metal2 1.78198e-05f
Cred_20159 vin3.$232.Metal1 VSS.$4562.Metal3 1.42875e-07f
Cred_20160 vin3.$232.Metal1 VSS.$539.Metal1 0.0014312f
Cred_20161 vin3.$232.Metal1 VSS.$559.Metal1 9.86064e-08f
Cred_20162 vin3.$232.Metal1 VSS.$565.Metal1 1.25543e-06f
Cred_20163 vin3.$232.Metal1 VSS.$68.Metal1 0.000681194f
Cred_20164 vin3.$232.Metal1 VSS.P2.pSD 0.0124221f
Cred_20165 vin3.$232.Metal1 VSS.P53.nSD 4.3599e-08f
Cred_20166 vin3.$233.Metal1 vout3.$1226.Metal3 0.00390011f
Cred_20167 vin3.$233.Metal1 vout3.P0.nSD 5.64797e-05f
Cred_20168 vin3.$233.Metal1 vout3.P0.pSD 0.000300124f
Cred_20169 vin3.$233.Metal1 vout3.P2.nSD 6.14426e-05f
Cred_20170 vin3.$233.Metal1 vout3.P2.pSD 0.00325896f
Cred_20171 vin3.$236.Metal1 vout3.$1226.Metal3 0.000124248f
Cred_20172 vin3.$236.Metal1 vout3.P0.nSD 1.79931e-06f
Cred_20173 vin3.$236.Metal1 vout3.P0.pSD 9.56121e-06f
Cred_20174 vin3.$236.Metal1 vout3.P2.nSD 1.26286e-05f
Cred_20175 vin3.$236.Metal1 vout3.P2.pSD 1.06977e-05f
Cred_20176 vin3.$236.Metal1 VSS.$1990.Metal1 8.1757e-06f
Cred_20177 vin3.$236.Metal1 VSS.$2668.Metal2 2.79062e-05f
Cred_20178 vin3.$236.Metal1 VSS.$2711.Metal2 0.00102085f
Cred_20179 vin3.$236.Metal1 VSS.$2727.Metal2 1.67928e-05f
Cred_20180 vin3.$236.Metal1 VSS.$4562.Metal3 1.34641e-07f
Cred_20181 vin3.$236.Metal1 VSS.$539.Metal1 4.15188e-08f
Cred_20182 vin3.$236.Metal1 VSS.$559.Metal1 9.29231e-08f
Cred_20183 vin3.$236.Metal1 VSS.$565.Metal1 0.0117446f
Cred_20184 vin3.$236.Metal1 VSS.$68.Metal1 0.000644565f
Cred_20185 vin3.$236.Metal1 VSS.P2.pSD 0.0127873f
Cred_20186 vin3.$236.Metal1 VSS.P53.nSD 0.000424771f
Cred_20187 vin3.$237.Metal1 vout3.$1226.Metal3 3.55807e-05f
Cred_20188 vin3.$237.Metal1 vout3.P0.nSD 5.15264e-07f
Cred_20189 vin3.$237.Metal1 vout3.P0.pSD 2.73803e-06f
Cred_20190 vin3.$237.Metal1 vout3.P2.nSD 5.60541e-07f
Cred_20191 vin3.$237.Metal1 vout3.P2.pSD 3.06348e-06f
Cred_20192 vin3.$24.GatPoly vout3.$1226.Metal3 0.00764f
Cred_20193 vin3.$24.GatPoly vout3.P0.nSD 8.96578e-05f
Cred_20194 vin3.$24.GatPoly vout3.P0.pSD 0.000476427f
Cred_20195 vin3.$24.GatPoly vout3.P2.nSD 0.0033892f
Cred_20196 vin3.$24.GatPoly vout3.P2.pSD 0.000533057f
Cred_20197 vin3.$24.GatPoly vout3.P4.nSD 1.35855e-05f
Cred_20198 vin3.$24.GatPoly VSS.$1990.Metal1 1.94641e-06f
Cred_20199 vin3.$24.GatPoly VSS.$2711.Metal2 0.00189944f
Cred_20200 vin3.$24.GatPoly VSS.$565.Metal1 0.00694219f
Cred_20201 vin3.$24.GatPoly VSS.$68.Metal1 0.000175976f
Cred_20202 vin3.$24.GatPoly VSS.P2.pSD 0.00324127f
Cred_20203 vin3.$24.GatPoly VSS.P53.nSD 0.000217216f
Cred_20204 vin3.$240.Metal1 VSS.$1990.Metal1 1.29232e-05f
Cred_20205 vin3.$240.Metal1 VSS.$2711.Metal2 0.00325318f
Cred_20206 vin3.$240.Metal1 VSS.$565.Metal1 0.0376358f
Cred_20207 vin3.$240.Metal1 VSS.$68.Metal1 0.000806279f
Cred_20208 vin3.$240.Metal1 VSS.P2.pSD 0.0180637f
Cred_20209 vin3.$240.Metal1 VSS.P53.nSD 0.00140605f
Cred_20210 vin3.$246.Metal1 vout3.$1226.Metal3 0.000947268f
Cred_20211 vin3.$246.Metal1 vout3.P0.nSD 2.06442e-06f
Cred_20212 vin3.$246.Metal1 vout3.P0.pSD 1.097e-05f
Cred_20213 vin3.$246.Metal1 vout3.P2.nSD 3.84091e-06f
Cred_20214 vin3.$246.Metal1 vout3.P2.pSD 1.22739e-05f
Cred_20215 vin3.$246.Metal1 vout3.P4.nSD 0.00032997f
Cred_20216 vin3.$246.Metal1 VSS.$1990.Metal1 1.44564e-05f
Cred_20217 vin3.$246.Metal1 VSS.$2711.Metal2 0.00100564f
Cred_20218 vin3.$246.Metal1 VSS.$2783.Metal2 3.84172e-05f
Cred_20219 vin3.$246.Metal1 VSS.$565.Metal1 0.00938489f
Cred_20220 vin3.$246.Metal1 VSS.$638.Metal1 0.00141371f
Cred_20221 vin3.$246.Metal1 VSS.$68.Metal1 0.000708607f
Cred_20222 vin3.$246.Metal1 VSS.P2.pSD 0.0179943f
Cred_20223 vin3.$246.Metal1 VSS.P53.nSD 0.000359848f
Cred_20224 vin3.$247.Metal1 vout3.$1226.Metal3 0.010864f
Cred_20225 vin3.$247.Metal1 vout3.P0.nSD 1.32332e-05f
Cred_20226 vin3.$247.Metal1 vout3.P0.pSD 7.0319e-05f
Cred_20227 vin3.$247.Metal1 vout3.P2.nSD 1.4396e-05f
Cred_20228 vin3.$247.Metal1 vout3.P2.pSD 0.000155297f
Cred_20229 vin3.$247.Metal1 vout3.P4.pSD 0.00613201f
Cred_20230 vin3.$25.GatPoly vout3.$1226.Metal3 0.0493491f
Cred_20231 vin3.$25.GatPoly vout3.P0.nSD 0.000629834f
Cred_20232 vin3.$25.GatPoly vout3.P0.pSD 0.00334683f
Cred_20233 vin3.$25.GatPoly vout3.P2.nSD 0.000685178f
Cred_20234 vin3.$25.GatPoly vout3.P2.pSD 0.0359824f
Cred_20235 vin3.$25.GatPoly vout3.P4.pSD 0.000411545f
Cred_20236 vin3.$250.Metal1 vout3.$1226.Metal3 0.0147902f
Cred_20237 vin3.$250.Metal1 vout3.P0.nSD 1.16038e-06f
Cred_20238 vin3.$250.Metal1 vout3.P0.pSD 6.16608e-06f
Cred_20239 vin3.$250.Metal1 vout3.P2.nSD 2.15893e-06f
Cred_20240 vin3.$250.Metal1 vout3.P2.pSD 6.89901e-06f
Cred_20241 vin3.$250.Metal1 vout3.P4.nSD 0.0108783f
Cred_20242 vin3.$250.Metal1 VSS.$1990.Metal1 1.6463e-05f
Cred_20243 vin3.$250.Metal1 VSS.$2711.Metal2 0.000114732f
Cred_20244 vin3.$250.Metal1 VSS.$2783.Metal2 9.08043e-06f
Cred_20245 vin3.$250.Metal1 VSS.$565.Metal1 0.0002632f
Cred_20246 vin3.$250.Metal1 VSS.$658.Metal1 0.00137881f
Cred_20247 vin3.$250.Metal1 VSS.$68.Metal1 0.000613925f
Cred_20248 vin3.$250.Metal1 VSS.P2.pSD 0.0179545f
Cred_20249 vin3.$250.Metal1 VSS.P53.nSD 9.84987e-06f
Cred_20250 vin3.$251.Metal1 vout3.$1226.Metal3 0.0205824f
Cred_20251 vin3.$251.Metal1 vout3.P0.nSD 7.43821e-06f
Cred_20252 vin3.$251.Metal1 vout3.P0.pSD 3.95254e-05f
Cred_20253 vin3.$251.Metal1 vout3.P2.nSD 8.09181e-06f
Cred_20254 vin3.$251.Metal1 vout3.P2.pSD 8.72905e-05f
Cred_20255 vin3.$251.Metal1 vout3.P4.pSD 0.0144287f
Cred_20256 vin3.$258.Metal1 vout3.$1226.Metal3 0.0211429f
Cred_20257 vin3.$258.Metal1 vout3.P4.nSD 0.0169439f
Cred_20258 vin3.$258.Metal1 VSS.$1990.Metal1 1.80559e-05f
Cred_20259 vin3.$258.Metal1 VSS.$2855.Metal2 1.30872e-05f
Cred_20260 vin3.$258.Metal1 VSS.$2914.Metal2 1.71307e-05f
Cred_20261 vin3.$258.Metal1 VSS.$2946.Metal2 5.88414e-07f
Cred_20262 vin3.$258.Metal1 VSS.$4646.Metal3 1.31153e-08f
Cred_20263 vin3.$258.Metal1 VSS.$68.Metal1 0.000534446f
Cred_20264 vin3.$258.Metal1 VSS.$698.Metal1 0.000112647f
Cred_20265 vin3.$258.Metal1 VSS.$726.Metal1 0.000112712f
Cred_20266 vin3.$258.Metal1 VSS.$744.Metal1 1.36076e-06f
Cred_20267 vin3.$258.Metal1 VSS.$757.Metal1 1.73447e-09f
Cred_20268 vin3.$258.Metal1 VSS.P2.pSD 0.0176103f
Cred_20269 vin3.$258.Metal1 VSS.P3.pSD 6.88726e-08f
Cred_20270 vin3.$258.Metal1 VSS.P55.nSD 4.71695e-08f
Cred_20271 vin3.$258.Metal1 VSS.P79.nSD 8.55167e-11f
Cred_20272 vin3.$259.Metal1 vout3.$1226.Metal3 0.0209774f
Cred_20273 vin3.$259.Metal1 vout3.P4.pSD 0.0170573f
Cred_20274 vin3.$262.Metal1 vout3.$1226.Metal3 0.000395475f
Cred_20275 vin3.$262.Metal1 vout3.P4.nSD 0.00013304f
Cred_20276 vin3.$262.Metal1 VSS.$1990.Metal1 1.44021e-05f
Cred_20277 vin3.$262.Metal1 VSS.$2855.Metal2 5.89938e-05f
Cred_20278 vin3.$262.Metal1 VSS.$2914.Metal2 7.29184e-05f
Cred_20279 vin3.$262.Metal1 VSS.$2946.Metal2 2.50625e-06f
Cred_20280 vin3.$262.Metal1 VSS.$4646.Metal3 5.54877e-08f
Cred_20281 vin3.$262.Metal1 VSS.$68.Metal1 0.000339101f
Cred_20282 vin3.$262.Metal1 VSS.$698.Metal1 0.00104152f
Cred_20283 vin3.$262.Metal1 VSS.$726.Metal1 0.00105951f
Cred_20284 vin3.$262.Metal1 VSS.$744.Metal1 1.08675e-05f
Cred_20285 vin3.$262.Metal1 VSS.$757.Metal1 7.33813e-09f
Cred_20286 vin3.$262.Metal1 VSS.P2.pSD 0.0125784f
Cred_20287 vin3.$262.Metal1 VSS.P3.pSD 6.36787e-07f
Cred_20288 vin3.$262.Metal1 VSS.P55.nSD 3.91229e-07f
Cred_20289 vin3.$262.Metal1 VSS.P79.nSD 3.64243e-10f
Cred_20290 vin3.$263.Metal1 vout3.$1226.Metal3 0.00135071f
Cred_20291 vin3.$263.Metal1 vout3.P4.pSD 0.000374822f
Cred_20292 vin3.$264.Metal1 vout3.$1226.Metal3 0.000176163f
Cred_20293 vin3.$264.Metal1 vout3.P4.nSD 1.87265e-06f
Cred_20294 vin3.$264.Metal1 VSS.$1990.Metal1 2.34029e-05f
Cred_20295 vin3.$264.Metal1 VSS.$2855.Metal2 4.52076e-05f
Cred_20296 vin3.$264.Metal1 VSS.$2914.Metal2 0.00195315f
Cred_20297 vin3.$264.Metal1 VSS.$2946.Metal2 7.35122e-05f
Cred_20298 vin3.$264.Metal1 VSS.$4646.Metal3 1.38935e-07f
Cred_20299 vin3.$264.Metal1 VSS.$68.Metal1 0.000437414f
Cred_20300 vin3.$264.Metal1 VSS.$698.Metal1 1.11867e-08f
Cred_20301 vin3.$264.Metal1 VSS.$726.Metal1 0.00118678f
Cred_20302 vin3.$264.Metal1 VSS.$744.Metal1 0.0204792f
Cred_20303 vin3.$264.Metal1 VSS.$757.Metal1 1.83739e-08f
Cred_20304 vin3.$264.Metal1 VSS.P2.pSD 0.0182416f
Cred_20305 vin3.$264.Metal1 VSS.P3.pSD 6.83953e-12f
Cred_20306 vin3.$264.Metal1 VSS.P55.nSD 0.000787366f
Cred_20307 vin3.$264.Metal1 VSS.P79.nSD 1.06838e-08f
Cred_20308 vin3.$265.Metal1 vout3.$1226.Metal3 6.69587e-05f
Cred_20309 vin3.$265.Metal1 vout3.$1292.Metal3 1.67231e-06f
Cred_20310 vin3.$265.Metal1 vout3.P4.pSD 1.95318e-07f
Cred_20311 vin3.$265.Metal1 vout3.P6.nSD 2.63457e-08f
Cred_20312 vin3.$265.Metal1 vout3.P6.pSD 3.39303e-07f
Cred_20313 vin3.$27.GatPoly vout3.$1226.Metal3 0.00841927f
Cred_20314 vin3.$27.GatPoly vout3.P0.nSD 0.000121924f
Cred_20315 vin3.$27.GatPoly vout3.P0.pSD 0.000647885f
Cred_20316 vin3.$27.GatPoly vout3.P2.nSD 0.000132638f
Cred_20317 vin3.$27.GatPoly vout3.P2.pSD 0.00828964f
Cred_20318 vin3.$272.Metal1 vout3.$1226.Metal3 1.13457e-05f
Cred_20319 vin3.$272.Metal1 vout3.$1292.Metal3 1.13457e-05f
Cred_20320 vin3.$272.Metal1 vout3.P6.nSD 2.6058e-07f
Cred_20321 vin3.$272.Metal1 vout3.P6.pSD 9.76862e-07f
Cred_20322 vin3.$272.Metal1 VSS.$1990.Metal1 3.56461e-05f
Cred_20323 vin3.$272.Metal1 VSS.$2914.Metal2 0.00292392f
Cred_20324 vin3.$272.Metal1 VSS.$2946.Metal2 0.000114936f
Cred_20325 vin3.$272.Metal1 VSS.$2994.Metal2 3.90164e-06f
Cred_20326 vin3.$272.Metal1 VSS.$4682.Metal3 3.12825e-08f
Cred_20327 vin3.$272.Metal1 VSS.$68.Metal1 0.000500311f
Cred_20328 vin3.$272.Metal1 VSS.$744.Metal1 0.0342083f
Cred_20329 vin3.$272.Metal1 VSS.$817.Metal1 0.000705757f
Cred_20330 vin3.$272.Metal1 VSS.$837.Metal1 0.000185866f
Cred_20331 vin3.$272.Metal1 VSS.P2.pSD 0.0241202f
Cred_20332 vin3.$272.Metal1 VSS.P55.nSD 0.00130722f
Cred_20333 vin3.$272.Metal1 VSS.P79.nSD 1.61371e-08f
Cred_20334 vin3.$273.Metal1 vout3.$1226.Metal3 4.83458e-05f
Cred_20335 vin3.$273.Metal1 vout3.$1292.Metal3 4.46677e-05f
Cred_20336 vin3.$273.Metal1 vout3.P4.pSD 1.32775e-07f
Cred_20337 vin3.$273.Metal1 vout3.P6.nSD 7.03698e-07f
Cred_20338 vin3.$273.Metal1 vout3.P6.pSD 6.4668e-06f
Cred_20339 vin3.$277.Metal1 vout3.$1226.Metal3 7.03749e-05f
Cred_20340 vin3.$277.Metal1 vout3.$1292.Metal3 7.03749e-05f
Cred_20341 vin3.$277.Metal1 vout3.P6.nSD 1.10869e-06f
Cred_20342 vin3.$277.Metal1 vout3.P6.pSD 1.1191e-05f
Cred_20343 vin3.$280.Metal1 vout3.$1226.Metal3 0.00270877f
Cred_20344 vin3.$280.Metal1 vout3.$1292.Metal3 0.00263404f
Cred_20345 vin3.$280.Metal1 vout3.P4.nSD 7.00732e-07f
Cred_20346 vin3.$280.Metal1 vout3.P6.nSD 0.00337504f
Cred_20347 vin3.$280.Metal1 vout3.P6.pSD 0.000226789f
Cred_20348 vin3.$280.Metal1 VSS.$1990.Metal1 2.99328e-05f
Cred_20349 vin3.$280.Metal1 VSS.$2914.Metal2 0.00012428f
Cred_20350 vin3.$280.Metal1 VSS.$2946.Metal2 2.22308e-05f
Cred_20351 vin3.$280.Metal1 VSS.$2994.Metal2 1.75113e-05f
Cred_20352 vin3.$280.Metal1 VSS.$4682.Metal3 1.40402e-07f
Cred_20353 vin3.$280.Metal1 VSS.$68.Metal1 0.000317862f
Cred_20354 vin3.$280.Metal1 VSS.$744.Metal1 0.000643731f
Cred_20355 vin3.$280.Metal1 VSS.$817.Metal1 0.000705983f
Cred_20356 vin3.$280.Metal1 VSS.$837.Metal1 0.00196867f
Cred_20357 vin3.$280.Metal1 VSS.P2.pSD 0.0176779f
Cred_20358 vin3.$280.Metal1 VSS.P55.nSD 2.41256e-05f
Cred_20359 vin3.$280.Metal1 VSS.P79.nSD 6.85902e-10f
Cred_20360 vin3.$281.Metal1 vout3.$1226.Metal3 0.00224909f
Cred_20361 vin3.$281.Metal1 vout3.$1292.Metal3 0.00224909f
Cred_20362 vin3.$281.Metal1 vout3.P6.nSD 3.54323e-05f
Cred_20363 vin3.$281.Metal1 vout3.P6.pSD 0.00227072f
Cred_20364 vin3.$284.Metal1 vout3.$1226.Metal3 0.0115648f
Cred_20365 vin3.$284.Metal1 vout3.$1292.Metal3 0.0115353f
Cred_20366 vin3.$284.Metal1 vout3.P4.nSD 2.77091e-07f
Cred_20367 vin3.$284.Metal1 vout3.P6.nSD 0.0198603f
Cred_20368 vin3.$284.Metal1 vout3.P6.pSD 0.000993182f
Cred_20369 vin3.$284.Metal1 VSS.$1990.Metal1 3.65441e-05f
Cred_20370 vin3.$284.Metal1 VSS.$2914.Metal2 3.41933e-05f
Cred_20371 vin3.$284.Metal1 VSS.$2946.Metal2 1.29848e-06f
Cred_20372 vin3.$284.Metal1 VSS.$68.Metal1 0.000292042f
Cred_20373 vin3.$284.Metal1 VSS.$744.Metal1 8.18531e-05f
Cred_20374 vin3.$284.Metal1 VSS.P2.pSD 0.0187601f
Cred_20375 vin3.$284.Metal1 VSS.P55.nSD 3.06305e-06f
Cred_20376 vin3.$284.Metal1 VSS.P79.nSD 1.88713e-10f
Cred_20377 vin3.$285.Metal1 vout3.$1226.Metal3 0.0116135f
Cred_20378 vin3.$285.Metal1 vout3.$1292.Metal3 0.0116135f
Cred_20379 vin3.$285.Metal1 vout3.P6.nSD 0.00018296f
Cred_20380 vin3.$285.Metal1 vout3.P6.pSD 0.0220364f
Cred_20381 vin3.$290.Metal1 vout3.$1226.Metal3 0.00355904f
Cred_20382 vin3.$290.Metal1 vout3.$1292.Metal3 0.00367739f
Cred_20383 vin3.$290.Metal1 vout3.P6.nSD 0.00587158f
Cred_20384 vin3.$290.Metal1 vout3.P6.pSD 0.000306431f
Cred_20385 vin3.$290.Metal1 vout3.P8.nSD 1.10981e-06f
Cred_20386 vin3.$290.Metal1 VSS.$1990.Metal1 5.48823e-05f
Cred_20387 vin3.$290.Metal1 VSS.$3042.Metal2 3.97237e-05f
Cred_20388 vin3.$290.Metal1 VSS.$3085.Metal2 0.000381446f
Cred_20389 vin3.$290.Metal1 VSS.$68.Metal1 0.000327027f
Cred_20390 vin3.$290.Metal1 VSS.$885.Metal1 0.00143116f
Cred_20391 vin3.$290.Metal1 VSS.$905.Metal1 0.000706277f
Cred_20392 vin3.$290.Metal1 VSS.$923.Metal1 0.00298934f
Cred_20393 vin3.$290.Metal1 VSS.P2.pSD 0.0243385f
Cred_20394 vin3.$290.Metal1 VSS.P57.nSD 0.000113232f
Cred_20395 vin3.$291.Metal1 vout3.$1226.Metal3 0.00774494f
Cred_20396 vin3.$291.Metal1 vout3.$1292.Metal3 0.00869489f
Cred_20397 vin3.$291.Metal1 vout3.P6.nSD 0.000122014f
Cred_20398 vin3.$291.Metal1 vout3.P6.pSD 0.0112744f
Cred_20399 vin3.$291.Metal1 vout3.P8.pSD 6.67492e-05f
Cred_20400 vin3.$295.Metal1 vout3.$1226.Metal3 0.0030992f
Cred_20401 vin3.$295.Metal1 vout3.$1292.Metal3 0.00383442f
Cred_20402 vin3.$295.Metal1 vout3.P6.nSD 4.8825e-05f
Cred_20403 vin3.$295.Metal1 vout3.P6.pSD 0.00428749f
Cred_20404 vin3.$295.Metal1 vout3.P8.pSD 5.16607e-05f
Cred_20405 vin3.$298.Metal1 vout3.$1226.Metal3 2.6058e-05f
Cred_20406 vin3.$298.Metal1 vout3.$1292.Metal3 7.35828e-05f
Cred_20407 vin3.$298.Metal1 vout3.P6.nSD 6.43208e-07f
Cred_20408 vin3.$298.Metal1 vout3.P6.pSD 2.24358e-06f
Cred_20409 vin3.$298.Metal1 vout3.P8.nSD 2.11277e-07f
Cred_20410 vin3.$298.Metal1 VSS.$1990.Metal1 4.7721e-05f
Cred_20411 vin3.$298.Metal1 VSS.$3042.Metal2 5.60458e-06f
Cred_20412 vin3.$298.Metal1 VSS.$3085.Metal2 0.00272224f
Cred_20413 vin3.$298.Metal1 VSS.$68.Metal1 0.000215048f
Cred_20414 vin3.$298.Metal1 VSS.$905.Metal1 0.00070541f
Cred_20415 vin3.$298.Metal1 VSS.$923.Metal1 0.0303602f
Cred_20416 vin3.$298.Metal1 VSS.P2.pSD 0.0184396f
Cred_20417 vin3.$298.Metal1 VSS.P57.nSD 0.00112161f
Cred_20418 vin3.$302.Metal1 vout3.$1226.Metal3 3.90959e-05f
Cred_20419 vin3.$302.Metal1 vout3.$1292.Metal3 0.000132079f
Cred_20420 vin3.$302.Metal1 vout3.P6.nSD 1.02929e-06f
Cred_20421 vin3.$302.Metal1 vout3.P6.pSD 3.36614e-06f
Cred_20422 vin3.$302.Metal1 vout3.P8.nSD 4.13368e-07f
Cred_20423 vin3.$302.Metal1 VSS.$1024.Metal1 2.21253e-05f
Cred_20424 vin3.$302.Metal1 VSS.$1990.Metal1 5.43242e-05f
Cred_20425 vin3.$302.Metal1 VSS.$3085.Metal2 0.00254946f
Cred_20426 vin3.$302.Metal1 VSS.$3157.Metal2 1.23942e-07f
Cred_20427 vin3.$302.Metal1 VSS.$68.Metal1 0.000184198f
Cred_20428 vin3.$302.Metal1 VSS.$923.Metal1 0.0269369f
Cred_20429 vin3.$302.Metal1 VSS.$996.Metal1 0.00124475f
Cred_20430 vin3.$302.Metal1 VSS.P2.pSD 0.018226f
Cred_20431 vin3.$302.Metal1 VSS.P3.pSD 1.35355e-08f
Cred_20432 vin3.$302.Metal1 VSS.P57.nSD 0.000994817f
Cred_20433 vin3.$303.Metal1 vout3.$1292.Metal3 9.34686e-06f
Cred_20434 vin3.$307.Metal1 vout3.$1292.Metal3 0.00115034f
Cred_20435 vin3.$307.Metal1 vout3.P8.pSD 0.000166022f
Cred_20436 vin3.$310.Metal1 vout3.$1292.Metal3 0.0102729f
Cred_20437 vin3.$310.Metal1 vout3.P8.nSD 0.00819768f
Cred_20438 vin3.$310.Metal1 VSS.$1024.Metal1 0.000611238f
Cred_20439 vin3.$310.Metal1 VSS.$1990.Metal1 8.38966e-05f
Cred_20440 vin3.$310.Metal1 VSS.$3157.Metal2 3.57728e-05f
Cred_20441 vin3.$310.Metal1 VSS.$68.Metal1 0.000212409f
Cred_20442 vin3.$310.Metal1 VSS.$996.Metal1 0.00160622f
Cred_20443 vin3.$310.Metal1 VSS.P2.pSD 0.0243075f
Cred_20444 vin3.$310.Metal1 VSS.P3.pSD 3.73934e-07f
Cred_20445 vin3.$313.Metal1 vout3.$1292.Metal3 0.0169072f
Cred_20446 vin3.$313.Metal1 vout3.P8.pSD 0.0137418f
Cred_20447 vin3.$316.Metal1 vout3.$1292.Metal3 0.0227303f
Cred_20448 vin3.$316.Metal1 vout3.$1358.Metal3 2.16805e-05f
Cred_20449 vin3.$316.Metal1 vout3.P10.nSD 7.68696e-07f
Cred_20450 vin3.$316.Metal1 vout3.P10.pSD 1.84989e-06f
Cred_20451 vin3.$316.Metal1 vout3.P8.nSD 0.0184006f
Cred_20452 vin3.$316.Metal1 VSS 0.00013186f
Cred_20453 vin3.$316.Metal1 VSS.$1990.Metal1 7.28288e-05f
Cred_20454 vin3.$316.Metal1 VSS.$3260.Metal2 2.77703e-05f
Cred_20455 vin3.$316.Metal1 VSS.$3292.Metal2 2.77703e-05f
Cred_20456 vin3.$316.Metal1 VSS.$68.Metal1 0.000138364f
Cred_20457 vin3.$316.Metal1 VSS.P2.pSD 0.0182954f
Cred_20458 vin3.$316.Metal1 VSS.P59.nSD 4.93259e-06f
Cred_20459 vin3.$316.Metal1 VSS.P83.nSD 2.09461e-09f
Cred_20460 vin3.$317.Metal1 vout3.$1292.Metal3 0.0161833f
Cred_20461 vin3.$317.Metal1 vout3.P8.pSD 0.0132623f
Cred_20462 vin3.$320.Metal1 vout3.$1292.Metal3 0.00273835f
Cred_20463 vin3.$320.Metal1 vout3.$1358.Metal3 5.48276e-05f
Cred_20464 vin3.$320.Metal1 vout3.P10.nSD 1.94395e-06f
Cred_20465 vin3.$320.Metal1 vout3.P10.pSD 4.67817e-06f
Cred_20466 vin3.$320.Metal1 vout3.P8.nSD 0.00194825f
Cred_20467 vin3.$320.Metal1 VSS 0.000959551f
Cred_20468 vin3.$320.Metal1 VSS.$1064.Metal1 0.00143118f
Cred_20469 vin3.$320.Metal1 VSS.$1084.Metal1 0.00133876f
Cred_20470 vin3.$320.Metal1 VSS.$1990.Metal1 8.21087e-05f
Cred_20471 vin3.$320.Metal1 VSS.$3205.Metal2 1.46125e-05f
Cred_20472 vin3.$320.Metal1 VSS.$3260.Metal2 0.000112911f
Cred_20473 vin3.$320.Metal1 VSS.$3292.Metal2 9.82985e-05f
Cred_20474 vin3.$320.Metal1 VSS.$4802.Metal3 1.17159e-07f
Cred_20475 vin3.$320.Metal1 VSS.$68.Metal1 0.000120356f
Cred_20476 vin3.$320.Metal1 VSS.P2.pSD 0.0181112f
Cred_20477 vin3.$320.Metal1 VSS.P59.nSD 3.63726e-05f
Cred_20478 vin3.$320.Metal1 VSS.P83.nSD 7.41432e-09f
Cred_20479 vin3.$321.Metal1 vout3.$1292.Metal3 0.00227998f
Cred_20480 vin3.$321.Metal1 vout3.P8.pSD 0.00126704f
Cred_20481 vin3.$325.Metal1 vout3.$1292.Metal3 5.64036e-05f
Cred_20482 vin3.$328.Metal1 vout3.$1292.Metal3 2.78522e-05f
Cred_20483 vin3.$328.Metal1 VSS 0.0400139f
Cred_20484 vin3.$328.Metal1 VSS.$1064.Metal1 1.17605e-08f
Cred_20485 vin3.$328.Metal1 VSS.$1084.Metal1 0.00129327f
Cred_20486 vin3.$328.Metal1 VSS.$1990.Metal1 0.00012655f
Cred_20487 vin3.$328.Metal1 VSS.$3205.Metal2 7.68072e-06f
Cred_20488 vin3.$328.Metal1 VSS.$3260.Metal2 0.00178182f
Cred_20489 vin3.$328.Metal1 VSS.$3292.Metal2 0.0017721f
Cred_20490 vin3.$328.Metal1 VSS.$4802.Metal3 6.15823e-08f
Cred_20491 vin3.$328.Metal1 VSS.$68.Metal1 0.000138427f
Cred_20492 vin3.$328.Metal1 VSS.P2.pSD 0.024077f
Cred_20493 vin3.$328.Metal1 VSS.P3.pSD 1.77436e-07f
Cred_20494 vin3.$328.Metal1 VSS.P59.nSD 0.00152675f
Cred_20495 vin3.$328.Metal1 VSS.P83.nSD 1.33663e-07f
Cred_20496 vin3.$334.Metal1 vout3.$1292.Metal3 0.000712225f
Cred_20497 vin3.$334.Metal1 vout3.$1358.Metal3 0.0006218f
Cred_20498 vin3.$334.Metal1 vout3.P10.nSD 0.000867285f
Cred_20499 vin3.$334.Metal1 vout3.P10.pSD 5.30551e-05f
Cred_20500 vin3.$334.Metal1 vout3.P8.nSD 8.4791e-07f
Cred_20501 vin3.$334.Metal1 VSS 0.0139777f
Cred_20502 vin3.$334.Metal1 VSS.$1160.Metal1 0.00219787f
Cred_20503 vin3.$334.Metal1 VSS.$1180.Metal1 0.000706141f
Cred_20504 vin3.$334.Metal1 VSS.$1990.Metal1 0.000147411f
Cred_20505 vin3.$334.Metal1 VSS.$3260.Metal2 0.000670075f
Cred_20506 vin3.$334.Metal1 VSS.$3292.Metal2 0.000689058f
Cred_20507 vin3.$334.Metal1 VSS.$3344.Metal2 1.89831e-05f
Cred_20508 vin3.$334.Metal1 VSS.$4838.Metal3 1.52203e-07f
Cred_20509 vin3.$334.Metal1 VSS.$68.Metal1 0.000112932f
Cred_20510 vin3.$334.Metal1 VSS.P2.pSD 0.0234844f
Cred_20511 vin3.$334.Metal1 VSS.P59.nSD 0.000539224f
Cred_20512 vin3.$334.Metal1 VSS.P83.nSD 5.05415e-08f
Cred_20513 vin3.$335.Metal1 vout3.$1292.Metal3 2.6845e-05f
Cred_20514 vin3.$335.Metal1 vout3.$1358.Metal3 2.6845e-05f
Cred_20515 vin3.$335.Metal1 vout3.P10.nSD 4.22919e-07f
Cred_20516 vin3.$335.Metal1 vout3.P10.pSD 2.29056e-06f
Cred_20517 vin3.$339.Metal1 vout3.$1292.Metal3 0.00106876f
Cred_20518 vin3.$339.Metal1 vout3.$1358.Metal3 0.00106876f
Cred_20519 vin3.$339.Metal1 vout3.P10.nSD 1.68373e-05f
Cred_20520 vin3.$339.Metal1 vout3.P10.pSD 0.00139346f
Cred_20521 vin3.$342.Metal1 vout3.$1292.Metal3 0.0117434f
Cred_20522 vin3.$342.Metal1 vout3.$1358.Metal3 0.0117434f
Cred_20523 vin3.$342.Metal1 vout3.P10.nSD 0.0202463f
Cred_20524 vin3.$342.Metal1 vout3.P10.pSD 0.00100201f
Cred_20525 vin3.$342.Metal1 VSS.$1160.Metal1 0.000166735f
Cred_20526 vin3.$342.Metal1 VSS.$1180.Metal1 0.000705584f
Cred_20527 vin3.$342.Metal1 VSS.$1990.Metal1 0.000182647f
Cred_20528 vin3.$342.Metal1 VSS.$3292.Metal2 3.42631e-06f
Cred_20529 vin3.$342.Metal1 VSS.$3344.Metal2 3.42631e-06f
Cred_20530 vin3.$342.Metal1 VSS.$4838.Metal3 2.74714e-08f
Cred_20531 vin3.$342.Metal1 VSS.$68.Metal1 0.000100718f
Cred_20532 vin3.$342.Metal1 VSS.P2.pSD 0.0246956f
Cred_20533 vin3.$343.Metal1 vout3.$1292.Metal3 0.00729627f
Cred_20534 vin3.$343.Metal1 vout3.$1358.Metal3 0.00729627f
Cred_20535 vin3.$343.Metal1 vout3.P10.nSD 0.000114946f
Cred_20536 vin3.$343.Metal1 vout3.P10.pSD 0.0137322f
Cred_20537 vin3.$347.Metal1 vout3.$1292.Metal3 0.00779742f
Cred_20538 vin3.$347.Metal1 vout3.$1358.Metal3 0.00779742f
Cred_20539 vin3.$347.Metal1 vout3.P10.nSD 0.000122841f
Cred_20540 vin3.$347.Metal1 vout3.P10.pSD 0.0145913f
Cred_20541 vin3.$348.Metal1 vout3.$1292.Metal3 0.00528953f
Cred_20542 vin3.$348.Metal1 vout3.$1358.Metal3 0.00528953f
Cred_20543 vin3.$348.Metal1 vout3.P10.nSD 0.00896468f
Cred_20544 vin3.$348.Metal1 vout3.P10.pSD 0.00045133f
Cred_20545 vin3.$348.Metal1 VSS.$1220.Metal1 0.000611238f
Cred_20546 vin3.$348.Metal1 VSS.$1260.Metal1 0.00160622f
Cred_20547 vin3.$348.Metal1 VSS.$1990.Metal1 0.000215652f
Cred_20548 vin3.$348.Metal1 VSS.$3392.Metal2 3.57728e-05f
Cred_20549 vin3.$348.Metal1 VSS.$68.Metal1 8.54431e-05f
Cred_20550 vin3.$348.Metal1 VSS.P2.pSD 0.0247161f
Cred_20551 vin3.$348.Metal1 VSS.P3.pSD 3.73934e-07f
Cred_20552 vin3.$353.Metal1 vout3.$1292.Metal3 0.00054301f
Cred_20553 vin3.$353.Metal1 vout3.$1358.Metal3 0.00054301f
Cred_20554 vin3.$353.Metal1 vout3.P10.nSD 8.55462e-06f
Cred_20555 vin3.$353.Metal1 vout3.P10.pSD 0.000221788f
Cred_20556 vin3.$356.Metal1 vout3.$1292.Metal3 4.4255e-05f
Cred_20557 vin3.$356.Metal1 vout3.$1358.Metal3 0.000126429f
Cred_20558 vin3.$356.Metal1 vout3.P10.nSD 1.11056e-06f
Cred_20559 vin3.$356.Metal1 vout3.P10.pSD 3.77606e-06f
Cred_20560 vin3.$356.Metal1 vout3.P12.nSD 4.13368e-07f
Cred_20561 vin3.$356.Metal1 VSS.$1220.Metal1 2.21253e-05f
Cred_20562 vin3.$356.Metal1 VSS.$1260.Metal1 0.00124475f
Cred_20563 vin3.$356.Metal1 VSS.$1266.Metal1 0.0269369f
Cred_20564 vin3.$356.Metal1 VSS.$1990.Metal1 0.000184198f
Cred_20565 vin3.$356.Metal1 VSS.$3392.Metal2 1.23942e-07f
Cred_20566 vin3.$356.Metal1 VSS.$3435.Metal2 0.00254946f
Cred_20567 vin3.$356.Metal1 VSS.$68.Metal1 5.43242e-05f
Cred_20568 vin3.$356.Metal1 VSS.P2.pSD 0.018226f
Cred_20569 vin3.$356.Metal1 VSS.P3.pSD 1.35355e-08f
Cred_20570 vin3.$356.Metal1 VSS.P61.nSD 0.000994817f
Cred_20571 vin3.$357.Metal1 vout3.$1292.Metal3 4.4486e-06f
Cred_20572 vin3.$357.Metal1 vout3.$1358.Metal3 4.4486e-06f
Cred_20573 vin3.$357.Metal1 vout3.P10.nSD 7.00835e-08f
Cred_20574 vin3.$357.Metal1 vout3.P10.pSD 3.79577e-07f
Cred_20575 vin3.$36.GatPoly vout3.$1226.Metal3 0.00166244f
Cred_20576 vin3.$36.GatPoly vout3.P0.nSD 3.90331e-06f
Cred_20577 vin3.$36.GatPoly vout3.P0.pSD 2.07415e-05f
Cred_20578 vin3.$36.GatPoly vout3.P2.nSD 7.26222e-06f
Cred_20579 vin3.$36.GatPoly vout3.P2.pSD 2.3207e-05f
Cred_20580 vin3.$36.GatPoly vout3.P4.nSD 0.000623893f
Cred_20581 vin3.$36.GatPoly VSS.$1990.Metal1 2.57994e-06f
Cred_20582 vin3.$36.GatPoly VSS.$2711.Metal2 0.00106095f
Cred_20583 vin3.$36.GatPoly VSS.$565.Metal1 0.0124478f
Cred_20584 vin3.$36.GatPoly VSS.$68.Metal1 0.000149461f
Cred_20585 vin3.$36.GatPoly VSS.P2.pSD 0.00347315f
Cred_20586 vin3.$36.GatPoly VSS.P53.nSD 0.000321196f
Cred_20587 vin3.$360.Metal1 vout3.$1292.Metal3 2.26192e-05f
Cred_20588 vin3.$360.Metal1 vout3.$1358.Metal3 7.73893e-05f
Cred_20589 vin3.$360.Metal1 vout3.P10.nSD 5.67622e-07f
Cred_20590 vin3.$360.Metal1 vout3.P10.pSD 1.92999e-06f
Cred_20591 vin3.$360.Metal1 vout3.P12.nSD 2.32689e-07f
Cred_20592 vin3.$360.Metal1 VSS.$1266.Metal1 0.0303602f
Cred_20593 vin3.$360.Metal1 VSS.$1339.Metal1 0.00070541f
Cred_20594 vin3.$360.Metal1 VSS.$1990.Metal1 0.000215048f
Cred_20595 vin3.$360.Metal1 VSS.$3435.Metal2 0.00272224f
Cred_20596 vin3.$360.Metal1 VSS.$3507.Metal2 5.60458e-06f
Cred_20597 vin3.$360.Metal1 VSS.$68.Metal1 4.7721e-05f
Cred_20598 vin3.$360.Metal1 VSS.P2.pSD 0.0184396f
Cred_20599 vin3.$360.Metal1 VSS.P61.nSD 0.00112161f
Cred_20600 vin3.$365.Metal1 vout3.$1292.Metal3 0.000359051f
Cred_20601 vin3.$365.Metal1 vout3.$1358.Metal3 0.00682448f
Cred_20602 vin3.$365.Metal1 vout3.P10.nSD 5.65651e-06f
Cred_20603 vin3.$365.Metal1 vout3.P10.pSD 8.801e-05f
Cred_20604 vin3.$365.Metal1 vout3.P12.pSD 0.00409171f
Cred_20605 vin3.$368.Metal1 vout3.$1292.Metal3 5.63311e-05f
Cred_20606 vin3.$368.Metal1 vout3.$1358.Metal3 0.0075369f
Cred_20607 vin3.$368.Metal1 vout3.P10.nSD 1.99725e-06f
Cred_20608 vin3.$368.Metal1 vout3.P10.pSD 4.80646e-06f
Cred_20609 vin3.$368.Metal1 vout3.P12.nSD 0.00581551f
Cred_20610 vin3.$368.Metal1 VSS.$1266.Metal1 0.00298934f
Cred_20611 vin3.$368.Metal1 VSS.$1339.Metal1 0.000706277f
Cred_20612 vin3.$368.Metal1 VSS.$1359.Metal1 0.00143116f
Cred_20613 vin3.$368.Metal1 VSS.$1990.Metal1 0.000327027f
Cred_20614 vin3.$368.Metal1 VSS.$3435.Metal2 0.000381446f
Cred_20615 vin3.$368.Metal1 VSS.$3507.Metal2 3.97237e-05f
Cred_20616 vin3.$368.Metal1 VSS.$68.Metal1 5.48823e-05f
Cred_20617 vin3.$368.Metal1 VSS.P2.pSD 0.0243385f
Cred_20618 vin3.$368.Metal1 VSS.P61.nSD 0.000113232f
Cred_20619 vin3.$369.Metal1 vout3.$1292.Metal3 0.000463919f
Cred_20620 vin3.$369.Metal1 vout3.$1358.Metal3 0.0164812f
Cred_20621 vin3.$369.Metal1 vout3.P10.nSD 7.30861e-06f
Cred_20622 vin3.$369.Metal1 vout3.P10.pSD 0.000113715f
Cred_20623 vin3.$369.Metal1 vout3.P12.pSD 0.0107913f
Cred_20624 vin3.$37.GatPoly vout3.$1226.Metal3 0.0204022f
Cred_20625 vin3.$37.GatPoly vout3.P0.nSD 2.50207e-05f
Cred_20626 vin3.$37.GatPoly vout3.P0.pSD 0.000132956f
Cred_20627 vin3.$37.GatPoly vout3.P2.nSD 2.72193e-05f
Cred_20628 vin3.$37.GatPoly vout3.P2.pSD 0.000293629f
Cred_20629 vin3.$37.GatPoly vout3.P4.pSD 0.0115941f
Cred_20630 vin3.$374.Metal1 vout3.$1358.Metal3 0.0242595f
Cred_20631 vin3.$374.Metal1 vout3.$1424.Metal3 1.40644e-05f
Cred_20632 vin3.$374.Metal1 vout3.P12.nSD 0.0196785f
Cred_20633 vin3.$374.Metal1 vout3.P14.nSD 4.98662e-07f
Cred_20634 vin3.$374.Metal1 vout3.P14.pSD 1.20005e-06f
Cred_20635 vin3.$374.Metal1 VSS.$1445.Metal1 8.18531e-05f
Cred_20636 vin3.$374.Metal1 VSS.$1990.Metal1 0.000292042f
Cred_20637 vin3.$374.Metal1 VSS.$3603.Metal2 1.29848e-06f
Cred_20638 vin3.$374.Metal1 VSS.$3638.Metal2 3.41933e-05f
Cred_20639 vin3.$374.Metal1 VSS.$68.Metal1 3.65441e-05f
Cred_20640 vin3.$374.Metal1 VSS.P2.pSD 0.0187601f
Cred_20641 vin3.$374.Metal1 VSS.P63.nSD 3.06305e-06f
Cred_20642 vin3.$374.Metal1 VSS.P87.nSD 1.88713e-10f
Cred_20643 vin3.$375.Metal1 vout3.$1358.Metal3 0.023578f
Cred_20644 vin3.$375.Metal1 vout3.P12.pSD 0.021265f
Cred_20645 vin3.$378.Metal1 vout3.$1358.Metal3 0.00557193f
Cred_20646 vin3.$378.Metal1 vout3.$1424.Metal3 3.55673e-05f
Cred_20647 vin3.$378.Metal1 vout3.P12.nSD 0.00333354f
Cred_20648 vin3.$378.Metal1 vout3.P14.nSD 1.26106e-06f
Cred_20649 vin3.$378.Metal1 vout3.P14.pSD 3.03479e-06f
Cred_20650 vin3.$378.Metal1 VSS.$1407.Metal1 0.00196867f
Cred_20651 vin3.$378.Metal1 VSS.$1427.Metal1 0.000705983f
Cred_20652 vin3.$378.Metal1 VSS.$1445.Metal1 0.000643731f
Cred_20653 vin3.$378.Metal1 VSS.$1990.Metal1 0.000317862f
Cred_20654 vin3.$378.Metal1 VSS.$3555.Metal2 1.75113e-05f
Cred_20655 vin3.$378.Metal1 VSS.$3603.Metal2 2.22308e-05f
Cred_20656 vin3.$378.Metal1 VSS.$3638.Metal2 0.00012428f
Cred_20657 vin3.$378.Metal1 VSS.$4958.Metal3 1.40402e-07f
Cred_20658 vin3.$378.Metal1 VSS.$68.Metal1 2.99328e-05f
Cred_20659 vin3.$378.Metal1 VSS.P2.pSD 0.0176779f
Cred_20660 vin3.$378.Metal1 VSS.P63.nSD 2.41256e-05f
Cred_20661 vin3.$378.Metal1 VSS.P87.nSD 6.85902e-10f
Cred_20662 vin3.$379.Metal1 vout3.$1358.Metal3 0.00460492f
Cred_20663 vin3.$379.Metal1 vout3.P12.pSD 0.00208398f
Cred_20664 vin3.$383.Metal1 vout3.$1358.Metal3 0.000147556f
Cred_20665 vin3.$383.Metal1 vout3.P12.pSD 5.4933e-06f
Cred_20666 vin3.$386.Metal1 vout3.$1358.Metal3 2.3847e-05f
Cred_20667 vin3.$386.Metal1 vout3.P12.nSD 8.18389e-08f
Cred_20668 vin3.$386.Metal1 VSS.$1407.Metal1 0.000185866f
Cred_20669 vin3.$386.Metal1 VSS.$1427.Metal1 0.000705757f
Cred_20670 vin3.$386.Metal1 VSS.$1445.Metal1 0.0342083f
Cred_20671 vin3.$386.Metal1 VSS.$1990.Metal1 0.000500311f
Cred_20672 vin3.$386.Metal1 VSS.$3555.Metal2 3.90164e-06f
Cred_20673 vin3.$386.Metal1 VSS.$3603.Metal2 0.000114936f
Cred_20674 vin3.$386.Metal1 VSS.$3638.Metal2 0.00292392f
Cred_20675 vin3.$386.Metal1 VSS.$4958.Metal3 3.12825e-08f
Cred_20676 vin3.$386.Metal1 VSS.$68.Metal1 3.56461e-05f
Cred_20677 vin3.$386.Metal1 VSS.P2.pSD 0.0241202f
Cred_20678 vin3.$386.Metal1 VSS.P63.nSD 0.00130722f
Cred_20679 vin3.$386.Metal1 VSS.P87.nSD 1.61371e-08f
Cred_20680 vin3.$387.Metal1 vout3.$1358.Metal3 9.54292e-05f
Cred_20681 vin3.$387.Metal1 vout3.$1424.Metal3 1.74057e-06f
Cred_20682 vin3.$387.Metal1 vout3.P12.pSD 2.81725e-06f
Cred_20683 vin3.$387.Metal1 vout3.P14.nSD 2.7421e-08f
Cred_20684 vin3.$387.Metal1 vout3.P14.pSD 3.02317e-07f
Cred_20685 vin3.$392.Metal1 vout3.$1358.Metal3 8.38441e-05f
Cred_20686 vin3.$392.Metal1 vout3.$1424.Metal3 8.38441e-05f
Cred_20687 vin3.$392.Metal1 vout3.P14.nSD 3.19353e-06f
Cred_20688 vin3.$392.Metal1 vout3.P14.pSD 7.154e-06f
Cred_20689 vin3.$392.Metal1 VSS.$1445.Metal1 0.0204792f
Cred_20690 vin3.$392.Metal1 VSS.$1490.Metal1 1.83739e-08f
Cred_20691 vin3.$392.Metal1 VSS.$1518.Metal1 0.00118678f
Cred_20692 vin3.$392.Metal1 VSS.$1546.Metal1 1.11867e-08f
Cred_20693 vin3.$392.Metal1 VSS.$1990.Metal1 0.000437414f
Cred_20694 vin3.$392.Metal1 VSS.$3603.Metal2 7.35122e-05f
Cred_20695 vin3.$392.Metal1 VSS.$3638.Metal2 0.00195315f
Cred_20696 vin3.$392.Metal1 VSS.$3694.Metal2 4.52076e-05f
Cred_20697 vin3.$392.Metal1 VSS.$4994.Metal3 1.38935e-07f
Cred_20698 vin3.$392.Metal1 VSS.$68.Metal1 2.34029e-05f
Cred_20699 vin3.$392.Metal1 VSS.P2.pSD 0.0182416f
Cred_20700 vin3.$392.Metal1 VSS.P3.pSD 6.83953e-12f
Cred_20701 vin3.$392.Metal1 VSS.P63.nSD 0.000787366f
Cred_20702 vin3.$392.Metal1 VSS.P87.nSD 1.06838e-08f
Cred_20703 vin3.$393.Metal1 vout3.$1358.Metal3 3.45421e-05f
Cred_20704 vin3.$393.Metal1 vout3.$1424.Metal3 3.10581e-05f
Cred_20705 vin3.$393.Metal1 vout3.P12.pSD 2.26251e-07f
Cred_20706 vin3.$393.Metal1 vout3.P14.nSD 4.89291e-07f
Cred_20707 vin3.$393.Metal1 vout3.P14.pSD 2.87628e-06f
Cred_20708 vin3.$396.Metal1 vout3.$1358.Metal3 0.000188225f
Cred_20709 vin3.$396.Metal1 vout3.$1424.Metal3 0.000188225f
Cred_20710 vin3.$396.Metal1 vout3.P14.nSD 0.000136005f
Cred_20711 vin3.$396.Metal1 vout3.P14.pSD 1.60603e-05f
Cred_20712 vin3.$396.Metal1 VSS.$1445.Metal1 1.08675e-05f
Cred_20713 vin3.$396.Metal1 VSS.$1490.Metal1 7.33813e-09f
Cred_20714 vin3.$396.Metal1 VSS.$1518.Metal1 0.00105951f
Cred_20715 vin3.$396.Metal1 VSS.$1546.Metal1 0.00104152f
Cred_20716 vin3.$396.Metal1 VSS.$1990.Metal1 0.000339101f
Cred_20717 vin3.$396.Metal1 VSS.$3603.Metal2 2.50625e-06f
Cred_20718 vin3.$396.Metal1 VSS.$3638.Metal2 7.29184e-05f
Cred_20719 vin3.$396.Metal1 VSS.$3694.Metal2 5.89938e-05f
Cred_20720 vin3.$396.Metal1 VSS.$4994.Metal3 5.54877e-08f
Cred_20721 vin3.$396.Metal1 VSS.$68.Metal1 1.44021e-05f
Cred_20722 vin3.$396.Metal1 VSS.P2.pSD 0.0125784f
Cred_20723 vin3.$396.Metal1 VSS.P3.pSD 6.36787e-07f
Cred_20724 vin3.$396.Metal1 VSS.P63.nSD 3.91229e-07f
Cred_20725 vin3.$396.Metal1 VSS.P87.nSD 3.64243e-10f
Cred_20726 vin3.$397.Metal1 vout3.$1358.Metal3 0.00063605f
Cred_20727 vin3.$397.Metal1 vout3.$1424.Metal3 0.00063605f
Cred_20728 vin3.$397.Metal1 vout3.P14.nSD 1.00204e-05f
Cred_20729 vin3.$397.Metal1 vout3.P14.pSD 0.000443449f
Cred_20730 vin3.$400.Metal1 vout3.$1358.Metal3 0.0100629f
Cred_20731 vin3.$400.Metal1 vout3.$1424.Metal3 0.0100629f
Cred_20732 vin3.$400.Metal1 vout3.P14.nSD 0.0171024f
Cred_20733 vin3.$400.Metal1 vout3.P14.pSD 0.000858615f
Cred_20734 vin3.$400.Metal1 VSS.$1445.Metal1 1.36076e-06f
Cred_20735 vin3.$400.Metal1 VSS.$1490.Metal1 1.73447e-09f
Cred_20736 vin3.$400.Metal1 VSS.$1518.Metal1 0.000112712f
Cred_20737 vin3.$400.Metal1 VSS.$1546.Metal1 0.000112647f
Cred_20738 vin3.$400.Metal1 VSS.$1990.Metal1 0.000534446f
Cred_20739 vin3.$400.Metal1 VSS.$3603.Metal2 5.88414e-07f
Cred_20740 vin3.$400.Metal1 VSS.$3638.Metal2 1.71307e-05f
Cred_20741 vin3.$400.Metal1 VSS.$3694.Metal2 1.30872e-05f
Cred_20742 vin3.$400.Metal1 VSS.$4994.Metal3 1.31153e-08f
Cred_20743 vin3.$400.Metal1 VSS.$68.Metal1 1.80559e-05f
Cred_20744 vin3.$400.Metal1 VSS.P2.pSD 0.0176103f
Cred_20745 vin3.$400.Metal1 VSS.P3.pSD 6.88726e-08f
Cred_20746 vin3.$400.Metal1 VSS.P63.nSD 4.71695e-08f
Cred_20747 vin3.$400.Metal1 VSS.P87.nSD 8.55167e-11f
Cred_20748 vin3.$401.Metal1 vout3.$1358.Metal3 0.00954509f
Cred_20749 vin3.$401.Metal1 vout3.$1424.Metal3 0.00954509f
Cred_20750 vin3.$401.Metal1 vout3.P14.nSD 0.000150374f
Cred_20751 vin3.$401.Metal1 vout3.P14.pSD 0.0178495f
Cred_20752 vin3.$408.Metal1 vout3.$1358.Metal3 0.00700118f
Cred_20753 vin3.$408.Metal1 vout3.$1424.Metal3 0.00709679f
Cred_20754 vin3.$408.Metal1 vout3.P14.nSD 0.0109886f
Cred_20755 vin3.$408.Metal1 vout3.P14.pSD 0.000597376f
Cred_20756 vin3.$408.Metal1 vout3.P16.nSD 8.9658e-07f
Cred_20757 vin3.$408.Metal1 VSS.$1586.Metal1 0.00137881f
Cred_20758 vin3.$408.Metal1 VSS.$1624.Metal1 0.0002632f
Cred_20759 vin3.$408.Metal1 VSS.$1990.Metal1 0.000613925f
Cred_20760 vin3.$408.Metal1 VSS.$3766.Metal2 9.08043e-06f
Cred_20761 vin3.$408.Metal1 VSS.$3809.Metal2 0.000114732f
Cred_20762 vin3.$408.Metal1 VSS.$68.Metal1 1.6463e-05f
Cred_20763 vin3.$408.Metal1 VSS.P2.pSD 0.0179545f
Cred_20764 vin3.$408.Metal1 VSS.P65.nSD 9.84987e-06f
Cred_20765 vin3.$409.Metal1 vout3.$1358.Metal3 0.00923975f
Cred_20766 vin3.$409.Metal1 vout3.$1424.Metal3 0.00986865f
Cred_20767 vin3.$409.Metal1 vout3.P14.nSD 0.000145564f
Cred_20768 vin3.$409.Metal1 vout3.P14.pSD 0.0152637f
Cred_20769 vin3.$409.Metal1 vout3.P16.pSD 4.78297e-05f
Cred_20770 vin3.$412.Metal1 vout3.$1358.Metal3 0.000383f
Cred_20771 vin3.$412.Metal1 vout3.$1424.Metal3 0.000553109f
Cred_20772 vin3.$412.Metal1 vout3.P14.nSD 0.000336004f
Cred_20773 vin3.$412.Metal1 vout3.P14.pSD 3.26795e-05f
Cred_20774 vin3.$412.Metal1 vout3.P16.nSD 1.59509e-06f
Cred_20775 vin3.$412.Metal1 VSS.$1606.Metal1 0.00141371f
Cred_20776 vin3.$412.Metal1 VSS.$1624.Metal1 0.00938489f
Cred_20777 vin3.$412.Metal1 VSS.$1990.Metal1 0.000708607f
Cred_20778 vin3.$412.Metal1 VSS.$3766.Metal2 3.84172e-05f
Cred_20779 vin3.$412.Metal1 VSS.$3809.Metal2 0.00100564f
Cred_20780 vin3.$412.Metal1 VSS.$68.Metal1 1.44564e-05f
Cred_20781 vin3.$412.Metal1 VSS.P2.pSD 0.0179943f
Cred_20782 vin3.$412.Metal1 VSS.P65.nSD 0.000359848f
Cred_20783 vin3.$413.Metal1 vout3.$1358.Metal3 0.00472945f
Cred_20784 vin3.$413.Metal1 vout3.$1424.Metal3 0.00584832f
Cred_20785 vin3.$413.Metal1 vout3.P14.nSD 7.45081e-05f
Cred_20786 vin3.$413.Metal1 vout3.P14.pSD 0.0067038f
Cred_20787 vin3.$413.Metal1 vout3.P16.pSD 8.5093e-05f
Cred_20788 vin3.$418.Metal1 VSS.$1624.Metal1 0.0376358f
Cred_20789 vin3.$418.Metal1 VSS.$1990.Metal1 0.000806279f
Cred_20790 vin3.$418.Metal1 VSS.$3809.Metal2 0.00325318f
Cred_20791 vin3.$418.Metal1 VSS.$68.Metal1 1.29232e-05f
Cred_20792 vin3.$418.Metal1 VSS.P2.pSD 0.0180637f
Cred_20793 vin3.$418.Metal1 VSS.P65.nSD 0.00140605f
Cred_20794 vin3.$42.GatPoly vout3.$1226.Metal3 0.00760675f
Cred_20795 vin3.$42.GatPoly vout3.P0.nSD 2.194e-06f
Cred_20796 vin3.$42.GatPoly vout3.P0.pSD 1.16586e-05f
Cred_20797 vin3.$42.GatPoly vout3.P2.nSD 4.082e-06f
Cred_20798 vin3.$42.GatPoly vout3.P2.pSD 1.30444e-05f
Cred_20799 vin3.$42.GatPoly vout3.P4.nSD 0.00536615f
Cred_20800 vin3.$42.GatPoly VSS.$1990.Metal1 3.88118e-06f
Cred_20801 vin3.$42.GatPoly VSS.$2711.Metal2 0.00021693f
Cred_20802 vin3.$42.GatPoly VSS.$565.Metal1 0.000497646f
Cred_20803 vin3.$42.GatPoly VSS.$68.Metal1 0.000131046f
Cred_20804 vin3.$42.GatPoly VSS.P2.pSD 0.00403041f
Cred_20805 vin3.$42.GatPoly VSS.P53.nSD 1.86237e-05f
Cred_20806 vin3.$422.Metal1 vout3.$1424.Metal3 0.000148264f
Cred_20807 vin3.$422.Metal1 vout3.P16.nSD 1.06712e-05f
Cred_20808 vin3.$422.Metal1 VSS.$1624.Metal1 0.0117446f
Cred_20809 vin3.$422.Metal1 VSS.$1685.Metal1 9.29231e-08f
Cred_20810 vin3.$422.Metal1 VSS.$1705.Metal1 4.15188e-08f
Cred_20811 vin3.$422.Metal1 VSS.$1990.Metal1 0.000644565f
Cred_20812 vin3.$422.Metal1 VSS.$3809.Metal2 0.00102085f
Cred_20813 vin3.$422.Metal1 VSS.$3825.Metal2 1.67928e-05f
Cred_20814 vin3.$422.Metal1 VSS.$3881.Metal2 2.79062e-05f
Cred_20815 vin3.$422.Metal1 VSS.$5078.Metal3 1.34641e-07f
Cred_20816 vin3.$422.Metal1 VSS.$68.Metal1 8.1757e-06f
Cred_20817 vin3.$422.Metal1 VSS.P2.pSD 0.0127873f
Cred_20818 vin3.$422.Metal1 VSS.P65.nSD 0.000424771f
Cred_20819 vin3.$423.Metal1 vout3.$1424.Metal3 4.2458e-05f
Cred_20820 vin3.$426.Metal1 vout3.$1424.Metal3 0.000348714f
Cred_20821 vin3.$426.Metal1 vout3.P16.nSD 8.22737e-05f
Cred_20822 vin3.$426.Metal1 VSS.$1624.Metal1 1.25543e-06f
Cred_20823 vin3.$426.Metal1 VSS.$1685.Metal1 9.86064e-08f
Cred_20824 vin3.$426.Metal1 VSS.$1705.Metal1 0.0014312f
Cred_20825 vin3.$426.Metal1 VSS.$1990.Metal1 0.000681194f
Cred_20826 vin3.$426.Metal1 VSS.$3809.Metal2 1.48977e-05f
Cred_20827 vin3.$426.Metal1 VSS.$3825.Metal2 1.78198e-05f
Cred_20828 vin3.$426.Metal1 VSS.$3881.Metal2 4.04704e-05f
Cred_20829 vin3.$426.Metal1 VSS.$5078.Metal3 1.42875e-07f
Cred_20830 vin3.$426.Metal1 VSS.$68.Metal1 7.36444e-06f
Cred_20831 vin3.$426.Metal1 VSS.P2.pSD 0.0124221f
Cred_20832 vin3.$426.Metal1 VSS.P65.nSD 4.3599e-08f
Cred_20833 vin3.$427.Metal1 vout3.$1424.Metal3 0.00449306f
Cred_20834 vin3.$427.Metal1 vout3.P16.pSD 0.00292921f
Cred_20835 vin3.$43.GatPoly vout3.$1226.Metal3 0.0222699f
Cred_20836 vin3.$43.GatPoly vout3.P0.nSD 1.40638e-05f
Cred_20837 vin3.$43.GatPoly vout3.P0.pSD 7.4733e-05f
Cred_20838 vin3.$43.GatPoly vout3.P2.nSD 1.52996e-05f
Cred_20839 vin3.$43.GatPoly vout3.P2.pSD 0.000165045f
Cred_20840 vin3.$43.GatPoly vout3.P4.pSD 0.0152604f
Cred_20841 vin3.$430.Metal1 vout3.$1424.Metal3 0.0194237f
Cred_20842 vin3.$430.Metal1 vout3.P16.nSD 0.015411f
Cred_20843 vin3.$430.Metal1 VSS.$1624.Metal1 6.4622e-07f
Cred_20844 vin3.$430.Metal1 VSS.$1685.Metal1 5.07568e-08f
Cred_20845 vin3.$430.Metal1 VSS.$1705.Metal1 2.26786e-08f
Cred_20846 vin3.$430.Metal1 VSS.$1990.Metal1 0.00111512f
Cred_20847 vin3.$430.Metal1 VSS.$3809.Metal2 7.66844e-06f
Cred_20848 vin3.$430.Metal1 VSS.$3825.Metal2 9.1726e-06f
Cred_20849 vin3.$430.Metal1 VSS.$3881.Metal2 3.39179e-05f
Cred_20850 vin3.$430.Metal1 VSS.$5078.Metal3 7.35439e-08f
Cred_20851 vin3.$430.Metal1 VSS.$68.Metal1 9.67646e-06f
Cred_20852 vin3.$430.Metal1 VSS.P2.pSD 0.0180971f
Cred_20853 vin3.$430.Metal1 VSS.P65.nSD 2.24422e-08f
Cred_20854 vin3.$433.Metal1 vout3.$1424.Metal3 0.0266176f
Cred_20855 vin3.$433.Metal1 vout3.P16.pSD 0.0222725f
Cred_20856 vin3.$437.Metal1 vout3 1.29706e-05f
Cred_20857 vin3.$437.Metal1 vout3.$1424.Metal3 0.0163742f
Cred_20858 vin3.$437.Metal1 vout3.P16.nSD 0.0129229f
Cred_20859 vin3.$437.Metal1 vout3.P18.nSD 1.82761e-06f
Cred_20860 vin3.$437.Metal1 vout3.P18.pSD 5.58169e-06f
Cred_20861 vin3.$437.Metal1 VSS.$1745.Metal1 0.000564468f
Cred_20862 vin3.$437.Metal1 VSS.$1773.Metal1 0.000564734f
Cred_20863 vin3.$437.Metal1 VSS.$1799.Metal1 0.000239742f
Cred_20864 vin3.$437.Metal1 VSS.$1990.Metal1 0.00124316f
Cred_20865 vin3.$437.Metal1 VSS.$3929.Metal2 3.622e-06f
Cred_20866 vin3.$437.Metal1 VSS.$3988.Metal2 5.86146e-05f
Cred_20867 vin3.$437.Metal1 VSS.$4020.Metal2 4.36492e-05f
Cred_20868 vin3.$437.Metal1 VSS.$68.Metal1 8.47542e-06f
Cred_20869 vin3.$437.Metal1 VSS.P2.pSD 0.0177526f
Cred_20870 vin3.$437.Metal1 VSS.P3.pSD 3.45115e-07f
Cred_20871 vin3.$437.Metal1 VSS.P67.nSD 8.96799e-06f
Cred_20872 vin3.$437.Metal1 VSS.P91.nSD 3.77411e-09f
Cred_20873 vin3.$44.GatPoly vout3.$1226.Metal3 0.00813817f
Cred_20874 vin3.$44.GatPoly vout3.$1292.Metal3 0.000689313f
Cred_20875 vin3.$44.GatPoly vout3.P4.nSD 0.00337161f
Cred_20876 vin3.$44.GatPoly vout3.P6.nSD 2.4445e-05f
Cred_20877 vin3.$44.GatPoly vout3.P6.pSD 5.93495e-05f
Cred_20878 vin3.$44.GatPoly VSS.$1990.Metal1 3.0959e-06f
Cred_20879 vin3.$44.GatPoly VSS.$2914.Metal2 0.0017524f
Cred_20880 vin3.$44.GatPoly VSS.$2946.Metal2 6.6547e-05f
Cred_20881 vin3.$44.GatPoly VSS.$68.Metal1 7.35294e-05f
Cred_20882 vin3.$44.GatPoly VSS.$726.Metal1 9.5518e-08f
Cred_20883 vin3.$44.GatPoly VSS.$744.Metal1 0.00489035f
Cred_20884 vin3.$44.GatPoly VSS.P2.pSD 0.00271121f
Cred_20885 vin3.$44.GatPoly VSS.P55.nSD 0.000183077f
Cred_20886 vin3.$44.GatPoly VSS.P79.nSD 9.67155e-09f
Cred_20887 vin3.$440.Metal1 vout3 2.90243e-05f
Cred_20888 vin3.$440.Metal1 vout3.$1424.Metal3 0.00111056f
Cred_20889 vin3.$440.Metal1 vout3.P16.nSD 0.000376308f
Cred_20890 vin3.$440.Metal1 vout3.P18.nSD 4.08965e-06f
Cred_20891 vin3.$440.Metal1 vout3.P18.pSD 1.24902e-05f
Cred_20892 vin3.$440.Metal1 VSS.$1745.Metal1 2.60524e-05f
Cred_20893 vin3.$440.Metal1 VSS.$1773.Metal1 0.00224803f
Cred_20894 vin3.$440.Metal1 VSS.$1793.Metal1 2.09529e-08f
Cred_20895 vin3.$440.Metal1 VSS.$1799.Metal1 0.00768135f
Cred_20896 vin3.$440.Metal1 VSS.$1990.Metal1 0.00142191f
Cred_20897 vin3.$440.Metal1 VSS.$3929.Metal2 1.99279e-05f
Cred_20898 vin3.$440.Metal1 VSS.$3988.Metal2 0.000518159f
Cred_20899 vin3.$440.Metal1 VSS.$4020.Metal2 0.000371147f
Cred_20900 vin3.$440.Metal1 VSS.$5126.Metal3 1.58437e-07f
Cred_20901 vin3.$440.Metal1 VSS.$68.Metal1 7.28726e-06f
Cred_20902 vin3.$440.Metal1 VSS.P2.pSD 0.0174256f
Cred_20903 vin3.$440.Metal1 VSS.P3.pSD 1.59284e-08f
Cred_20904 vin3.$440.Metal1 VSS.P67.nSD 0.000293209f
Cred_20905 vin3.$440.Metal1 VSS.P91.nSD 3.20911e-08f
Cred_20906 vin3.$441.Metal1 vout3.$1424.Metal3 0.00561461f
Cred_20907 vin3.$441.Metal1 vout3.P16.pSD 0.00387364f
Cred_20908 vin3.$448.Metal1 vout3 8.26931e-07f
Cred_20909 vin3.$448.Metal1 vout3.$1424.Metal3 1.39243e-05f
Cred_20910 vin3.$448.Metal1 vout3.P18.nSD 6.5704e-08f
Cred_20911 vin3.$448.Metal1 vout3.P18.pSD 3.55857e-07f
Cred_20912 vin3.$448.Metal1 VSS.$1773.Metal1 0.000143586f
Cred_20913 vin3.$448.Metal1 VSS.$1793.Metal1 2.95623e-09f
Cred_20914 vin3.$448.Metal1 VSS.$1799.Metal1 0.0418812f
Cred_20915 vin3.$448.Metal1 VSS.$1864.Metal1 0.000507316f
Cred_20916 vin3.$448.Metal1 VSS.$1884.Metal1 9.20339e-09f
Cred_20917 vin3.$448.Metal1 VSS.$1990.Metal1 0.00215458f
Cred_20918 vin3.$448.Metal1 VSS.$3929.Metal2 2.78802e-06f
Cred_20919 vin3.$448.Metal1 VSS.$3988.Metal2 0.00207838f
Cred_20920 vin3.$448.Metal1 VSS.$4020.Metal2 0.00154718f
Cred_20921 vin3.$448.Metal1 VSS.$4068.Metal2 1.53249e-06f
Cred_20922 vin3.$448.Metal1 VSS.$5126.Metal3 2.23537e-08f
Cred_20923 vin3.$448.Metal1 VSS.$5162.Metal3 1.22871e-08f
Cred_20924 vin3.$448.Metal1 VSS.$68.Metal1 8.27046e-06f
Cred_20925 vin3.$448.Metal1 VSS.P2.pSD 0.022553f
Cred_20926 vin3.$448.Metal1 VSS.P67.nSD 0.00156409f
Cred_20927 vin3.$448.Metal1 VSS.P91.nSD 1.33644e-07f
Cred_20928 vin3.$449.Metal1 vout3.$1424.Metal3 9.75371e-06f
Cred_20929 vin3.$453.Metal1 vout3 1.6785e-06f
Cred_20930 vin3.$453.Metal1 vout3.$1424.Metal3 8.46547e-06f
Cred_20931 vin3.$453.Metal1 vout3.P18.nSD 1.33366e-07f
Cred_20932 vin3.$453.Metal1 vout3.P18.pSD 7.22317e-07f
Cred_20933 vin3.$456.Metal1 vout3 0.00552629f
Cred_20934 vin3.$456.Metal1 vout3.$1424.Metal3 0.02802f
Cred_20935 vin3.$456.Metal1 vout3.P16.nSD 1.39007e-06f
Cred_20936 vin3.$456.Metal1 vout3.P18.nSD 0.0269006f
Cred_20937 vin3.$456.Metal1 vout3.P18.pSD 0.00237816f
Cred_20938 vin3.$456.Metal1 VSS.$1799.Metal1 0.00662575f
Cred_20939 vin3.$456.Metal1 VSS.$1864.Metal1 0.000508459f
Cred_20940 vin3.$456.Metal1 VSS.$1884.Metal1 0.00134403f
Cred_20941 vin3.$456.Metal1 VSS.$1952.Metal1 0.00125391f
Cred_20942 vin3.$456.Metal1 VSS.$1990.Metal1 0.00841689f
Cred_20943 vin3.$456.Metal1 VSS.$2022.Metal1 0.000861456f
Cred_20944 vin3.$456.Metal1 VSS.$3988.Metal2 0.000340553f
Cred_20945 vin3.$456.Metal1 VSS.$4020.Metal2 0.000275531f
Cred_20946 vin3.$456.Metal1 VSS.$4068.Metal2 2.19277e-05f
Cred_20947 vin3.$456.Metal1 VSS.$4116.Metal2 5.17115e-05f
Cred_20948 vin3.$456.Metal1 VSS.$4174.Metal2 2.12339e-05f
Cred_20949 vin3.$456.Metal1 VSS.$5162.Metal3 1.75812e-07f
Cred_20950 vin3.$456.Metal1 VSS.$68.Metal1 1.644e-05f
Cred_20951 vin3.$456.Metal1 VSS.P2.pSD 0.0594359f
Cred_20952 vin3.$456.Metal1 VSS.P5.GatPoly 0.00160798f
Cred_20953 vin3.$456.Metal1 VSS.P67.nSD 0.000253589f
Cred_20954 vin3.$456.Metal1 VSS.P69.nSD 5.94945e-06f
Cred_20955 vin3.$456.Metal1 VSS.P71.nSD 5.94945e-06f
Cred_20956 vin3.$456.Metal1 VSS.P91.nSD 2.19277e-08f
Cred_20957 vin3.$457.Metal1 vout3 0.011952f
Cred_20958 vin3.$457.Metal1 vout3.$1424.Metal3 0.0602796f
Cred_20959 vin3.$457.Metal1 vout3.P18.nSD 0.000949648f
Cred_20960 vin3.$457.Metal1 vout3.P18.pSD 0.0606796f
Cred_20961 vin3.$457.Metal1 VSS.$4140.Metal2 0.000968708f
Cred_20962 vin3.$47.GatPoly vout3.$1226.Metal3 0.05686f
Cred_20963 vin3.$47.GatPoly vout3.$1292.Metal3 0.00278657f
Cred_20964 vin3.$47.GatPoly vout3.P4.pSD 0.0337983f
Cred_20965 vin3.$47.GatPoly vout3.P6.nSD 4.38997e-05f
Cred_20966 vin3.$47.GatPoly vout3.P6.pSD 0.000651467f
Cred_20967 vin3.$477.Metal2 vout3.$1226.Metal3 0.157521f
Cred_20968 vin3.$477.Metal2 vout3.P0.nSD 0.0112951f
Cred_20969 vin3.$477.Metal2 vout3.P0.pSD 0.0346678f
Cred_20970 vin3.$477.Metal2 vout3.P2.nSD 0.00248159f
Cred_20971 vin3.$477.Metal2 vout3.P2.pSD 0.0135625f
Cred_20972 vin3.$477.Metal2 VSS.$159.Metal1 0.00110311f
Cred_20973 vin3.$477.Metal2 VSS.$1990.Metal1 2.16875e-05f
Cred_20974 vin3.$477.Metal2 VSS.$2238.Metal2 0.0190896f
Cred_20975 vin3.$477.Metal2 VSS.$2409.Metal2 0.00106209f
Cred_20976 vin3.$477.Metal2 VSS.$2433.Metal2 0.00121979f
Cred_20977 vin3.$477.Metal2 VSS.$292.Metal1 4.99247e-05f
Cred_20978 vin3.$477.Metal2 VSS.$4358.Metal3 0.00548045f
Cred_20979 vin3.$477.Metal2 VSS.$4418.Metal3 4.79917e-05f
Cred_20980 vin3.$477.Metal2 VSS.$4454.Metal3 3.51931e-05f
Cred_20981 vin3.$477.Metal2 VSS.$68.Metal1 0.0194129f
Cred_20982 vin3.$477.Metal2 VSS.P2.pSD 0.0947136f
Cred_20983 vin3.$477.Metal2 VSS.P4.GatPoly 0.00153218f
Cred_20984 vin3.$477.Metal2 VSS.P48.nSD 4.91163e-06f
Cred_20985 vin3.$477.Metal2 VSS.P49.nSD 4.91163e-06f
Cred_20986 vin3.$479.Metal2 vout3.$1226.Metal3 0.0913285f
Cred_20987 vin3.$479.Metal2 vout3.P0.nSD 0.0191546f
Cred_20988 vin3.$479.Metal2 vout3.P0.pSD 0.0144508f
Cred_20989 vin3.$479.Metal2 vout3.P2.nSD 0.0014388f
Cred_20990 vin3.$479.Metal2 vout3.P2.pSD 0.00786335f
Cred_20991 vin3.$479.Metal2 VSS.$159.Metal1 0.00207439f
Cred_20992 vin3.$479.Metal2 VSS.$1990.Metal1 8.51513e-06f
Cred_20993 vin3.$479.Metal2 VSS.$2238.Metal2 0.0355821f
Cred_20994 vin3.$479.Metal2 VSS.$2409.Metal2 0.00197894f
Cred_20995 vin3.$479.Metal2 VSS.$2433.Metal2 0.00227307f
Cred_20996 vin3.$479.Metal2 VSS.$2481.Metal2 0.00280513f
Cred_20997 vin3.$479.Metal2 VSS.$2532.Metal2 0.00123426f
Cred_20998 vin3.$479.Metal2 VSS.$2564.Metal2 4.23036e-07f
Cred_20999 vin3.$479.Metal2 VSS.$292.Metal1 0.000119666f
Cred_21000 vin3.$479.Metal2 VSS.$360.Metal1 7.41051e-06f
Cred_21001 vin3.$479.Metal2 VSS.$380.Metal1 3.12966e-06f
Cred_21002 vin3.$479.Metal2 VSS.$386.Metal1 8.23052e-06f
Cred_21003 vin3.$479.Metal2 VSS.$4358.Metal3 0.0102152f
Cred_21004 vin3.$479.Metal2 VSS.$4478.Metal3 9.89351e-06f
Cred_21005 vin3.$479.Metal2 VSS.$68.Metal1 0.0120741f
Cred_21006 vin3.$479.Metal2 VSS.P2.pSD 0.0437946f
Cred_21007 vin3.$479.Metal2 VSS.P4.GatPoly 0.00144983f
Cred_21008 vin3.$479.Metal2 VSS.P48.nSD 9.28119e-06f
Cred_21009 vin3.$479.Metal2 VSS.P49.nSD 9.28119e-06f
Cred_21010 vin3.$479.Metal2 VSS.P51.nSD 3.1529e-07f
Cred_21011 vin3.$479.Metal2 VSS.P75.nSD 2.72387e-11f
Cred_21012 vin3.$480.Metal2 vout3.$1226.Metal3 0.0863808f
Cred_21013 vin3.$480.Metal2 vout3.P0.nSD 0.00257215f
Cred_21014 vin3.$480.Metal2 vout3.P0.pSD 0.0378089f
Cred_21015 vin3.$480.Metal2 vout3.P2.nSD 0.00136085f
Cred_21016 vin3.$480.Metal2 vout3.P2.pSD 0.00743735f
Cred_21017 vin3.$480.Metal2 VSS.$1990.Metal1 3.15648e-06f
Cred_21018 vin3.$480.Metal2 VSS.$2409.Metal2 9.4431e-07f
Cred_21019 vin3.$480.Metal2 VSS.$2433.Metal2 6.92477e-07f
Cred_21020 vin3.$480.Metal2 VSS.$4418.Metal3 0.000117777f
Cred_21021 vin3.$480.Metal2 VSS.$4454.Metal3 8.63677e-05f
Cred_21022 vin3.$480.Metal2 VSS.$68.Metal1 0.00674696f
Cred_21023 vin3.$480.Metal2 VSS.P2.pSD 0.020456f
Cred_21024 vin3.$480.Metal2 VSS.P4.GatPoly 0.00143774f
Cred_21025 vin3.$483.Metal2 vout3.$1226.Metal3 0.0198468f
Cred_21026 vin3.$483.Metal2 vout3.P0.nSD 0.000542768f
Cred_21027 vin3.$483.Metal2 vout3.P0.pSD 0.00259866f
Cred_21028 vin3.$483.Metal2 vout3.P2.nSD 0.00036609f
Cred_21029 vin3.$483.Metal2 vout3.P2.pSD 0.0017088f
Cred_21030 vin3.$483.Metal2 VSS.$1990.Metal1 1.89929e-06f
Cred_21031 vin3.$483.Metal2 VSS.$2481.Metal2 0.00123397f
Cred_21032 vin3.$483.Metal2 VSS.$2532.Metal2 0.0154724f
Cred_21033 vin3.$483.Metal2 VSS.$2564.Metal2 0.0191202f
Cred_21034 vin3.$483.Metal2 VSS.$360.Metal1 7.41063e-06f
Cred_21035 vin3.$483.Metal2 VSS.$380.Metal1 9.77308e-06f
Cred_21036 vin3.$483.Metal2 VSS.$386.Metal1 0.00303595f
Cred_21037 vin3.$483.Metal2 VSS.$4478.Metal3 9.89367e-06f
Cred_21038 vin3.$483.Metal2 VSS.$68.Metal1 0.000566846f
Cred_21039 vin3.$483.Metal2 VSS.P2.pSD 0.00546856f
Cred_21040 vin3.$483.Metal2 VSS.P51.nSD 0.000104727f
Cred_21041 vin3.$483.Metal2 VSS.P75.nSD 1.23112e-06f
Cred_21042 vin3.$484.Metal2 vout3.$1226.Metal3 0.018944f
Cred_21043 vin3.$484.Metal2 vout3.P0.nSD 0.000473205f
Cred_21044 vin3.$484.Metal2 vout3.P0.pSD 0.00280077f
Cred_21045 vin3.$484.Metal2 vout3.P2.nSD 0.000298445f
Cred_21046 vin3.$484.Metal2 vout3.P2.pSD 0.001896f
Cred_21047 vin3.$486.Metal2 vout3.$1226.Metal3 0.0980207f
Cred_21048 vin3.$486.Metal2 vout3.P0.nSD 0.00241147f
Cred_21049 vin3.$486.Metal2 vout3.P0.pSD 0.0128144f
Cred_21050 vin3.$486.Metal2 vout3.P2.nSD 0.00156497f
Cred_21051 vin3.$486.Metal2 vout3.P2.pSD 0.00854244f
Cred_21052 vin3.$486.Metal2 VSS.$1990.Metal1 1.80668e-05f
Cred_21053 vin3.$486.Metal2 VSS.$2532.Metal2 0.00221267f
Cred_21054 vin3.$486.Metal2 VSS.$2564.Metal2 0.0029713f
Cred_21055 vin3.$486.Metal2 VSS.$386.Metal1 0.000448976f
Cred_21056 vin3.$486.Metal2 VSS.$68.Metal1 0.00466039f
Cred_21057 vin3.$486.Metal2 VSS.P2.pSD 0.0488701f
Cred_21058 vin3.$486.Metal2 VSS.P51.nSD 1.53963e-05f
Cred_21059 vin3.$486.Metal2 VSS.P75.nSD 1.91318e-07f
Cred_21060 vin3.$488.Metal2 vout3.$1226.Metal3 0.0241259f
Cred_21061 vin3.$488.Metal2 vout3.P0.nSD 0.000579018f
Cred_21062 vin3.$488.Metal2 vout3.P0.pSD 0.0026934f
Cred_21063 vin3.$488.Metal2 vout3.P2.nSD 0.00045182f
Cred_21064 vin3.$488.Metal2 vout3.P2.pSD 0.00207723f
Cred_21065 vin3.$488.Metal2 VSS.$1990.Metal1 3.0301e-06f
Cred_21066 vin3.$488.Metal2 VSS.$2532.Metal2 0.0174818f
Cred_21067 vin3.$488.Metal2 VSS.$2564.Metal2 0.0246652f
Cred_21068 vin3.$488.Metal2 VSS.$2620.Metal2 0.00118965f
Cred_21069 vin3.$488.Metal2 VSS.$386.Metal1 0.00370329f
Cred_21070 vin3.$488.Metal2 VSS.$451.Metal1 1.26142e-06f
Cred_21071 vin3.$488.Metal2 VSS.$4514.Metal3 9.53834e-06f
Cred_21072 vin3.$488.Metal2 VSS.$471.Metal1 1.23083e-05f
Cred_21073 vin3.$488.Metal2 VSS.$68.Metal1 0.000719861f
Cred_21074 vin3.$488.Metal2 VSS.P2.pSD 0.00787323f
Cred_21075 vin3.$488.Metal2 VSS.P51.nSD 0.000127662f
Cred_21076 vin3.$488.Metal2 VSS.P75.nSD 1.51156e-06f
Cred_21077 vin3.$489.Metal2 vout3.$1226.Metal3 0.0229136f
Cred_21078 vin3.$489.Metal2 vout3.P0.nSD 0.000485607f
Cred_21079 vin3.$489.Metal2 vout3.P0.pSD 0.00296482f
Cred_21080 vin3.$489.Metal2 vout3.P2.nSD 0.000360983f
Cred_21081 vin3.$489.Metal2 vout3.P2.pSD 0.00232861f
Cred_21082 vin3.$492.Metal2 vout3.$1226.Metal3 0.0303152f
Cred_21083 vin3.$492.Metal2 vout3.P0.nSD 0.000439011f
Cred_21084 vin3.$492.Metal2 vout3.P0.pSD 0.00233283f
Cred_21085 vin3.$492.Metal2 vout3.P2.nSD 0.00472695f
Cred_21086 vin3.$492.Metal2 vout3.P2.pSD 0.00261012f
Cred_21087 vin3.$492.Metal2 VSS.$1990.Metal1 1.96932e-06f
Cred_21088 vin3.$492.Metal2 VSS.$2532.Metal2 6.70053e-07f
Cred_21089 vin3.$492.Metal2 VSS.$2564.Metal2 0.00119052f
Cred_21090 vin3.$492.Metal2 VSS.$2620.Metal2 0.00353881f
Cred_21091 vin3.$492.Metal2 VSS.$386.Metal1 1.75061e-05f
Cred_21092 vin3.$492.Metal2 VSS.$451.Metal1 1.26139e-06f
Cred_21093 vin3.$492.Metal2 VSS.$4514.Metal3 9.5381e-06f
Cred_21094 vin3.$492.Metal2 VSS.$471.Metal1 1.12553e-05f
Cred_21095 vin3.$492.Metal2 VSS.$499.Metal1 4.92789e-07f
Cred_21096 vin3.$492.Metal2 VSS.$68.Metal1 0.000329249f
Cred_21097 vin3.$492.Metal2 VSS.P2.pSD 0.0043762f
Cred_21098 vin3.$492.Metal2 VSS.P3.pSD 3.01291e-10f
Cred_21099 vin3.$492.Metal2 VSS.P51.nSD 6.6924e-07f
Cred_21100 vin3.$492.Metal2 VSS.P75.nSD 5.79358e-11f
Cred_21101 vin3.$493.Metal2 vout3.$1226.Metal3 0.0495575f
Cred_21102 vin3.$493.Metal2 vout3.P0.nSD 0.00071767f
Cred_21103 vin3.$493.Metal2 vout3.P0.pSD 0.00381358f
Cred_21104 vin3.$493.Metal2 vout3.P2.nSD 0.000780732f
Cred_21105 vin3.$493.Metal2 vout3.P2.pSD 0.014777f
Cred_21106 vin3.$495.Metal2 vout3.$1226.Metal3 0.130126f
Cred_21107 vin3.$495.Metal2 vout3.P0.nSD 0.00188443f
Cred_21108 vin3.$495.Metal2 vout3.P0.pSD 0.0100136f
Cred_21109 vin3.$495.Metal2 vout3.P2.nSD 0.00319518f
Cred_21110 vin3.$495.Metal2 vout3.P2.pSD 0.015747f
Cred_21111 vin3.$495.Metal2 VSS.$1990.Metal1 2.54348e-05f
Cred_21112 vin3.$495.Metal2 VSS.$68.Metal1 0.0032525f
Cred_21113 vin3.$495.Metal2 VSS.P2.pSD 0.0497379f
Cred_21114 vin3.$497.Metal2 vout3.$1226.Metal3 0.0769369f
Cred_21115 vin3.$497.Metal2 vout3.P0.nSD 0.00111417f
Cred_21116 vin3.$497.Metal2 vout3.P0.pSD 0.0059205f
Cred_21117 vin3.$497.Metal2 vout3.P2.nSD 0.0141958f
Cred_21118 vin3.$497.Metal2 vout3.P2.pSD 0.00662423f
Cred_21119 vin3.$497.Metal2 VSS.$1990.Metal1 6.14319e-06f
Cred_21120 vin3.$497.Metal2 VSS.$2668.Metal2 0.00282265f
Cred_21121 vin3.$497.Metal2 VSS.$2711.Metal2 0.00063817f
Cred_21122 vin3.$497.Metal2 VSS.$2727.Metal2 0.000763347f
Cred_21123 vin3.$497.Metal2 VSS.$4562.Metal3 6.12034e-06f
Cred_21124 vin3.$497.Metal2 VSS.$539.Metal1 1.88732e-06f
Cred_21125 vin3.$497.Metal2 VSS.$559.Metal1 4.22399e-06f
Cred_21126 vin3.$497.Metal2 VSS.$565.Metal1 5.37786e-05f
Cred_21127 vin3.$497.Metal2 VSS.$68.Metal1 0.000754158f
Cred_21128 vin3.$497.Metal2 VSS.P2.pSD 0.011727f
Cred_21129 vin3.$497.Metal2 VSS.P53.nSD 1.86765e-06f
Cred_21130 vin3.$500.Metal2 vout3.$1226.Metal3 0.0453728f
Cred_21131 vin3.$500.Metal2 vout3.P0.nSD 0.000657069f
Cred_21132 vin3.$500.Metal2 vout3.P0.pSD 0.00349156f
Cred_21133 vin3.$500.Metal2 vout3.P2.nSD 0.000714806f
Cred_21134 vin3.$500.Metal2 vout3.P2.pSD 0.0129722f
Cred_21135 vin3.$503.Metal2 vout3.$1226.Metal3 0.0387021f
Cred_21136 vin3.$503.Metal2 vout3.P0.nSD 0.00036249f
Cred_21137 vin3.$503.Metal2 vout3.P0.pSD 0.00192621f
Cred_21138 vin3.$503.Metal2 vout3.P2.nSD 0.00144319f
Cred_21139 vin3.$503.Metal2 vout3.P2.pSD 0.00215517f
Cred_21140 vin3.$503.Metal2 vout3.P4.nSD 6.94739e-05f
Cred_21141 vin3.$503.Metal2 VSS.$1990.Metal1 6.12383e-06f
Cred_21142 vin3.$503.Metal2 VSS.$2668.Metal2 0.00256116f
Cred_21143 vin3.$503.Metal2 VSS.$2711.Metal2 0.0451789f
Cred_21144 vin3.$503.Metal2 VSS.$2727.Metal2 0.0015412f
Cred_21145 vin3.$503.Metal2 VSS.$4562.Metal3 1.2357e-05f
Cred_21146 vin3.$503.Metal2 VSS.$539.Metal1 3.8105e-06f
Cred_21147 vin3.$503.Metal2 VSS.$559.Metal1 8.52825e-06f
Cred_21148 vin3.$503.Metal2 VSS.$565.Metal1 0.00385056f
Cred_21149 vin3.$503.Metal2 VSS.$68.Metal1 0.000452537f
Cred_21150 vin3.$503.Metal2 VSS.P2.pSD 0.00921024f
Cred_21151 vin3.$503.Metal2 VSS.P53.nSD 0.000133911f
Cred_21152 vin3.$504.Metal2 vout3.$1226.Metal3 0.0299793f
Cred_21153 vin3.$504.Metal2 vout3.P0.nSD 0.00024078f
Cred_21154 vin3.$504.Metal2 vout3.P0.pSD 0.00127947f
Cred_21155 vin3.$504.Metal2 vout3.P2.nSD 0.000261938f
Cred_21156 vin3.$504.Metal2 vout3.P2.pSD 0.00181934f
Cred_21157 vin3.$504.Metal2 vout3.P4.pSD 0.000387787f
Cred_21158 vin3.$506.Metal2 vout3.$1226.Metal3 0.109705f
Cred_21159 vin3.$506.Metal2 vout3.P0.nSD 0.000720669f
Cred_21160 vin3.$506.Metal2 vout3.P0.pSD 0.00382952f
Cred_21161 vin3.$506.Metal2 vout3.P2.nSD 0.000792089f
Cred_21162 vin3.$506.Metal2 vout3.P2.pSD 0.00432936f
Cred_21163 vin3.$506.Metal2 vout3.P4.nSD 8.09507e-06f
Cred_21164 vin3.$506.Metal2 vout3.P4.pSD 4.46531e-05f
Cred_21165 vin3.$506.Metal2 VSS.$1990.Metal1 3.58677e-05f
Cred_21166 vin3.$506.Metal2 VSS.$2711.Metal2 0.00476634f
Cred_21167 vin3.$506.Metal2 VSS.$565.Metal1 0.000401659f
Cred_21168 vin3.$506.Metal2 VSS.$68.Metal1 0.00229387f
Cred_21169 vin3.$506.Metal2 VSS.P2.pSD 0.0505008f
Cred_21170 vin3.$506.Metal2 VSS.P53.nSD 1.3949e-05f
Cred_21171 vin3.$508.Metal2 vout3.$1226.Metal3 0.0171927f
Cred_21172 vin3.$508.Metal2 vout3.P0.nSD 5.41085e-05f
Cred_21173 vin3.$508.Metal2 vout3.P0.pSD 0.000287524f
Cred_21174 vin3.$508.Metal2 vout3.P2.nSD 7.60473e-05f
Cred_21175 vin3.$508.Metal2 vout3.P2.pSD 0.0003217f
Cred_21176 vin3.$508.Metal2 vout3.P4.nSD 1.71843e-05f
Cred_21177 vin3.$508.Metal2 VSS.$1990.Metal1 4.73034e-06f
Cred_21178 vin3.$508.Metal2 VSS.$2711.Metal2 0.0277271f
Cred_21179 vin3.$508.Metal2 VSS.$2783.Metal2 0.00298634f
Cred_21180 vin3.$508.Metal2 VSS.$4586.Metal3 3.93375e-06f
Cred_21181 vin3.$508.Metal2 VSS.$565.Metal1 0.00245323f
Cred_21182 vin3.$508.Metal2 VSS.$618.Metal1 3.52655e-06f
Cred_21183 vin3.$508.Metal2 VSS.$638.Metal1 4.04686e-07f
Cred_21184 vin3.$508.Metal2 VSS.$68.Metal1 0.000264532f
Cred_21185 vin3.$508.Metal2 VSS.P2.pSD 0.00622947f
Cred_21186 vin3.$508.Metal2 VSS.P53.nSD 8.58485e-05f
Cred_21187 vin3.$509.Metal2 vout3.$1226.Metal3 0.0174091f
Cred_21188 vin3.$509.Metal2 vout3.P0.nSD 5.31665e-05f
Cred_21189 vin3.$509.Metal2 vout3.P0.pSD 0.000282518f
Cred_21190 vin3.$509.Metal2 vout3.P2.nSD 5.78383e-05f
Cred_21191 vin3.$509.Metal2 vout3.P2.pSD 0.000410889f
Cred_21192 vin3.$509.Metal2 vout3.P4.pSD 9.47899e-05f
Cred_21193 vin3.$512.Metal2 vout3.$1226.Metal3 0.0580071f
Cred_21194 vin3.$512.Metal2 vout3.P4.nSD 0.00708599f
Cred_21195 vin3.$512.Metal2 VSS.$1990.Metal1 4.6833e-06f
Cred_21196 vin3.$512.Metal2 VSS.$2783.Metal2 0.00305041f
Cred_21197 vin3.$512.Metal2 VSS.$2831.Metal2 0.000554701f
Cred_21198 vin3.$512.Metal2 VSS.$4610.Metal3 4.44747e-06f
Cred_21199 vin3.$512.Metal2 VSS.$658.Metal1 2.1546e-06f
Cred_21200 vin3.$512.Metal2 VSS.$678.Metal1 2.28519e-06f
Cred_21201 vin3.$512.Metal2 VSS.$68.Metal1 0.000181373f
Cred_21202 vin3.$512.Metal2 VSS.P2.pSD 0.00516648f
Cred_21203 vin3.$513.Metal2 vout3.$1226.Metal3 0.0496893f
Cred_21204 vin3.$513.Metal2 vout3.P4.pSD 0.00878399f
Cred_21205 vin3.$515.Metal2 vout3.$1226.Metal3 0.174793f
Cred_21206 vin3.$515.Metal2 vout3.$1292.Metal3 0.00903794f
Cred_21207 vin3.$515.Metal2 vout3.P4.nSD 0.00122542f
Cred_21208 vin3.$515.Metal2 vout3.P4.pSD 0.00137652f
Cred_21209 vin3.$515.Metal2 vout3.P6.nSD 0.000142683f
Cred_21210 vin3.$515.Metal2 vout3.P6.pSD 0.000778162f
Cred_21211 vin3.$515.Metal2 VSS.$1990.Metal1 7.75281e-05f
Cred_21212 vin3.$515.Metal2 VSS.$2914.Metal2 0.00149864f
Cred_21213 vin3.$515.Metal2 VSS.$2946.Metal2 5.69106e-05f
Cred_21214 vin3.$515.Metal2 VSS.$68.Metal1 0.00210015f
Cred_21215 vin3.$515.Metal2 VSS.$744.Metal1 0.000131611f
Cred_21216 vin3.$515.Metal2 VSS.P2.pSD 0.0712918f
Cred_21217 vin3.$515.Metal2 VSS.P55.nSD 4.56217e-06f
Cred_21218 vin3.$515.Metal2 VSS.P79.nSD 8.27105e-09f
Cred_21219 vin3.$517.Metal2 vout3.$1226.Metal3 0.0773344f
Cred_21220 vin3.$517.Metal2 vout3.P4.nSD 0.0112674f
Cred_21221 vin3.$517.Metal2 VSS.$1990.Metal1 1.02073e-05f
Cred_21222 vin3.$517.Metal2 VSS.$2855.Metal2 0.00339829f
Cred_21223 vin3.$517.Metal2 VSS.$2914.Metal2 0.00470828f
Cred_21224 vin3.$517.Metal2 VSS.$2946.Metal2 0.000161723f
Cred_21225 vin3.$517.Metal2 VSS.$4646.Metal3 3.60467e-06f
Cred_21226 vin3.$517.Metal2 VSS.$68.Metal1 0.000299231f
Cred_21227 vin3.$517.Metal2 VSS.$698.Metal1 1.18318e-06f
Cred_21228 vin3.$517.Metal2 VSS.$726.Metal1 4.30884e-06f
Cred_21229 vin3.$517.Metal2 VSS.$744.Metal1 0.000373998f
Cred_21230 vin3.$517.Metal2 VSS.$757.Metal1 4.76709e-07f
Cred_21231 vin3.$517.Metal2 VSS.P2.pSD 0.00982483f
Cred_21232 vin3.$517.Metal2 VSS.P3.pSD 7.23397e-10f
Cred_21233 vin3.$517.Metal2 VSS.P55.nSD 1.29643e-05f
Cred_21234 vin3.$517.Metal2 VSS.P79.nSD 2.35038e-08f
Cred_21235 vin3.$518.Metal2 vout3.$1226.Metal3 0.0607039f
Cred_21236 vin3.$518.Metal2 vout3.P4.pSD 0.0130944f
Cred_21237 vin3.$52.GatPoly VSS.$1990.Metal1 4.06971e-06f
Cred_21238 vin3.$52.GatPoly VSS.$2914.Metal2 0.000541607f
Cred_21239 vin3.$52.GatPoly VSS.$2946.Metal2 2.05674e-05f
Cred_21240 vin3.$52.GatPoly VSS.$68.Metal1 6.90504e-05f
Cred_21241 vin3.$52.GatPoly VSS.$726.Metal1 7.30432e-08f
Cred_21242 vin3.$52.GatPoly VSS.$744.Metal1 0.0122579f
Cred_21243 vin3.$52.GatPoly VSS.P2.pSD 0.00302483f
Cred_21244 vin3.$52.GatPoly VSS.P55.nSD 0.000241435f
Cred_21245 vin3.$52.GatPoly VSS.P79.nSD 2.98914e-09f
Cred_21246 vin3.$520.Metal2 vout3.$1226.Metal3 0.0191896f
Cred_21247 vin3.$520.Metal2 vout3.$1292.Metal3 4.91937e-05f
Cred_21248 vin3.$520.Metal2 vout3.P4.pSD 0.000892535f
Cred_21249 vin3.$520.Metal2 vout3.P6.nSD 7.75001e-07f
Cred_21250 vin3.$520.Metal2 vout3.P6.pSD 9.98113e-06f
Cred_21251 vin3.$523.Metal2 vout3.$1226.Metal3 0.0510252f
Cred_21252 vin3.$523.Metal2 vout3.$1292.Metal3 0.0134562f
Cred_21253 vin3.$523.Metal2 vout3.P4.nSD 0.000190756f
Cred_21254 vin3.$523.Metal2 vout3.P6.nSD 0.000304649f
Cred_21255 vin3.$523.Metal2 vout3.P6.pSD 0.00115857f
Cred_21256 vin3.$523.Metal2 VSS.$1990.Metal1 2.90047e-05f
Cred_21257 vin3.$523.Metal2 VSS.$2855.Metal2 0.00236814f
Cred_21258 vin3.$523.Metal2 VSS.$2914.Metal2 0.0517027f
Cred_21259 vin3.$523.Metal2 VSS.$2946.Metal2 0.00192892f
Cred_21260 vin3.$523.Metal2 VSS.$4646.Metal3 7.27794e-06f
Cred_21261 vin3.$523.Metal2 VSS.$68.Metal1 0.000494826f
Cred_21262 vin3.$523.Metal2 VSS.$698.Metal1 5.85998e-07f
Cred_21263 vin3.$523.Metal2 VSS.$726.Metal1 6.89594e-06f
Cred_21264 vin3.$523.Metal2 VSS.$744.Metal1 0.00469654f
Cred_21265 vin3.$523.Metal2 VSS.$757.Metal1 9.62491e-07f
Cred_21266 vin3.$523.Metal2 VSS.P2.pSD 0.0214754f
Cred_21267 vin3.$523.Metal2 VSS.P3.pSD 3.58279e-10f
Cred_21268 vin3.$523.Metal2 VSS.P55.nSD 0.000163835f
Cred_21269 vin3.$523.Metal2 VSS.P79.nSD 2.80338e-07f
Cred_21270 vin3.$527.Metal2 vout3.$1226.Metal3 0.0502821f
Cred_21271 vin3.$527.Metal2 vout3.$1292.Metal3 0.0180083f
Cred_21272 vin3.$527.Metal2 vout3.P4.nSD 1.43057e-07f
Cred_21273 vin3.$527.Metal2 vout3.P4.pSD 0.000521155f
Cred_21274 vin3.$527.Metal2 vout3.P6.nSD 0.000283847f
Cred_21275 vin3.$527.Metal2 vout3.P6.pSD 0.00230869f
Cred_21276 vin3.$527.Metal2 VSS.$1990.Metal1 1.15238e-05f
Cred_21277 vin3.$527.Metal2 VSS.$2914.Metal2 0.000717863f
Cred_21278 vin3.$527.Metal2 VSS.$2946.Metal2 2.72606e-05f
Cred_21279 vin3.$527.Metal2 VSS.$68.Metal1 0.000183644f
Cred_21280 vin3.$527.Metal2 VSS.$744.Metal1 6.30427e-05f
Cred_21281 vin3.$527.Metal2 VSS.P2.pSD 0.00827242f
Cred_21282 vin3.$527.Metal2 VSS.P55.nSD 2.18532e-06f
Cred_21283 vin3.$527.Metal2 VSS.P79.nSD 3.9619e-09f
Cred_21284 vin3.$528.Metal2 vout3.$1226.Metal3 0.00731763f
Cred_21285 vin3.$528.Metal2 vout3.$1292.Metal3 0.00647235f
Cred_21286 vin3.$528.Metal2 vout3.P4.nSD 1.35309e-06f
Cred_21287 vin3.$528.Metal2 vout3.P6.nSD 0.000127075f
Cred_21288 vin3.$528.Metal2 vout3.P6.pSD 0.000557266f
Cred_21289 vin3.$528.Metal2 VSS.$1990.Metal1 7.29207e-06f
Cred_21290 vin3.$528.Metal2 VSS.$2914.Metal2 0.016284f
Cred_21291 vin3.$528.Metal2 VSS.$2946.Metal2 0.00416061f
Cred_21292 vin3.$528.Metal2 VSS.$2994.Metal2 0.00113256f
Cred_21293 vin3.$528.Metal2 VSS.$4682.Metal3 9.0806e-06f
Cred_21294 vin3.$528.Metal2 VSS.$68.Metal1 8.81949e-05f
Cred_21295 vin3.$528.Metal2 VSS.$744.Metal1 0.00144525f
Cred_21296 vin3.$528.Metal2 VSS.$817.Metal1 1.07668e-05f
Cred_21297 vin3.$528.Metal2 VSS.$837.Metal1 1.13754e-05f
Cred_21298 vin3.$528.Metal2 VSS.P2.pSD 0.00457836f
Cred_21299 vin3.$528.Metal2 VSS.P55.nSD 5.01416e-05f
Cred_21300 vin3.$528.Metal2 VSS.P79.nSD 8.98714e-08f
Cred_21301 vin3.$53.GatPoly vout3.$1226.Metal3 3.63287e-08f
Cred_21302 vin3.$53.GatPoly vout3.$1292.Metal3 8.57734e-09f
Cred_21303 vin3.$53.GatPoly vout3.P4.pSD 1.00179e-09f
Cred_21304 vin3.$53.GatPoly vout3.P6.nSD 1.35128e-10f
Cred_21305 vin3.$53.GatPoly vout3.P6.pSD 1.7403e-09f
Cred_21306 vin3.$532.Metal2 vout3.$1226.Metal3 0.0340852f
Cred_21307 vin3.$532.Metal2 vout3.$1292.Metal3 0.0340852f
Cred_21308 vin3.$532.Metal2 vout3.P6.nSD 0.0110647f
Cred_21309 vin3.$532.Metal2 vout3.P6.pSD 0.00293472f
Cred_21310 vin3.$532.Metal2 VSS.$1990.Metal1 1.40151e-05f
Cred_21311 vin3.$532.Metal2 VSS.$2914.Metal2 1.36232e-07f
Cred_21312 vin3.$532.Metal2 VSS.$2946.Metal2 0.00113253f
Cred_21313 vin3.$532.Metal2 VSS.$2994.Metal2 0.00113253f
Cred_21314 vin3.$532.Metal2 VSS.$4682.Metal3 9.08034e-06f
Cred_21315 vin3.$532.Metal2 VSS.$68.Metal1 0.000126823f
Cred_21316 vin3.$532.Metal2 VSS.$744.Metal1 1.57363e-06f
Cred_21317 vin3.$532.Metal2 VSS.$817.Metal1 4.81079e-06f
Cred_21318 vin3.$532.Metal2 VSS.$837.Metal1 9.80683e-06f
Cred_21319 vin3.$532.Metal2 VSS.P2.pSD 0.00759093f
Cred_21320 vin3.$532.Metal2 VSS.P55.nSD 5.90182e-08f
Cred_21321 vin3.$532.Metal2 VSS.P79.nSD 7.51865e-13f
Cred_21322 vin3.$533.Metal2 vout3.$1226.Metal3 0.0331409f
Cred_21323 vin3.$533.Metal2 vout3.$1292.Metal3 0.0331409f
Cred_21324 vin3.$533.Metal2 vout3.P6.nSD 0.000522104f
Cred_21325 vin3.$533.Metal2 vout3.P6.pSD 0.0155504f
Cred_21326 vin3.$535.Metal2 vout3.$1226.Metal3 0.0985463f
Cred_21327 vin3.$535.Metal2 vout3.$1292.Metal3 0.0795949f
Cred_21328 vin3.$535.Metal2 vout3.P4.nSD 2.98653e-07f
Cred_21329 vin3.$535.Metal2 vout3.P6.nSD 0.00254401f
Cred_21330 vin3.$535.Metal2 vout3.P6.pSD 0.00832374f
Cred_21331 vin3.$535.Metal2 VSS.$1990.Metal1 0.000130086f
Cred_21332 vin3.$535.Metal2 VSS.$2914.Metal2 0.00149864f
Cred_21333 vin3.$535.Metal2 VSS.$2946.Metal2 5.69106e-05f
Cred_21334 vin3.$535.Metal2 VSS.$68.Metal1 0.0012287f
Cred_21335 vin3.$535.Metal2 VSS.$744.Metal1 0.000131611f
Cred_21336 vin3.$535.Metal2 VSS.P2.pSD 0.071407f
Cred_21337 vin3.$535.Metal2 VSS.P55.nSD 4.56217e-06f
Cred_21338 vin3.$535.Metal2 VSS.P79.nSD 8.27105e-09f
Cred_21339 vin3.$537.Metal2 vout3.$1226.Metal3 0.0274712f
Cred_21340 vin3.$537.Metal2 vout3.$1292.Metal3 0.0274712f
Cred_21341 vin3.$537.Metal2 vout3.P6.nSD 0.00821486f
Cred_21342 vin3.$537.Metal2 vout3.P6.pSD 0.00236526f
Cred_21343 vin3.$537.Metal2 VSS.$1990.Metal1 1.28004e-05f
Cred_21344 vin3.$537.Metal2 VSS.$3042.Metal2 0.00239142f
Cred_21345 vin3.$537.Metal2 VSS.$3085.Metal2 5.84469e-07f
Cred_21346 vin3.$537.Metal2 VSS.$68.Metal1 9.16324e-05f
Cred_21347 vin3.$537.Metal2 VSS.$905.Metal1 1.73049e-06f
Cred_21348 vin3.$537.Metal2 VSS.$923.Metal1 6.50199e-06f
Cred_21349 vin3.$537.Metal2 VSS.P2.pSD 0.00616587f
Cred_21350 vin3.$537.Metal2 VSS.P57.nSD 2.4666e-07f
Cred_21351 vin3.$538.Metal2 vout3.$1226.Metal3 0.0255876f
Cred_21352 vin3.$538.Metal2 vout3.$1292.Metal3 0.0255876f
Cred_21353 vin3.$538.Metal2 vout3.P6.nSD 0.000403108f
Cred_21354 vin3.$538.Metal2 vout3.P6.pSD 0.0119442f
Cred_21355 vin3.$541.Metal2 vout3.$1226.Metal3 0.00916639f
Cred_21356 vin3.$541.Metal2 vout3.$1292.Metal3 0.0189675f
Cred_21357 vin3.$541.Metal2 vout3.P6.nSD 0.000193831f
Cred_21358 vin3.$541.Metal2 vout3.P6.pSD 0.000789222f
Cred_21359 vin3.$541.Metal2 vout3.P8.nSD 4.02867e-05f
Cred_21360 vin3.$541.Metal2 VSS.$1990.Metal1 2.01081e-05f
Cred_21361 vin3.$541.Metal2 VSS.$3042.Metal2 0.00302246f
Cred_21362 vin3.$541.Metal2 VSS.$3085.Metal2 0.0426236f
Cred_21363 vin3.$541.Metal2 VSS.$4730.Metal3 5.05911e-06f
Cred_21364 vin3.$541.Metal2 VSS.$68.Metal1 8.92056e-05f
Cred_21365 vin3.$541.Metal2 VSS.$905.Metal1 1.14797e-05f
Cred_21366 vin3.$541.Metal2 VSS.$923.Metal1 0.00362769f
Cred_21367 vin3.$541.Metal2 VSS.$936.Metal1 2.89664e-06f
Cred_21368 vin3.$541.Metal2 VSS.P2.pSD 0.0076153f
Cred_21369 vin3.$541.Metal2 VSS.P57.nSD 0.000126347f
Cred_21370 vin3.$542.Metal2 vout3.$1226.Metal3 0.00627618f
Cred_21371 vin3.$542.Metal2 vout3.$1292.Metal3 0.00943108f
Cred_21372 vin3.$542.Metal2 vout3.P6.nSD 9.88754e-05f
Cred_21373 vin3.$542.Metal2 vout3.P6.pSD 0.000719226f
Cred_21374 vin3.$542.Metal2 vout3.P8.pSD 6.00928e-05f
Cred_21375 vin3.$544.Metal2 vout3.$1226.Metal3 0.0296503f
Cred_21376 vin3.$544.Metal2 vout3.$1292.Metal3 0.0916487f
Cred_21377 vin3.$544.Metal2 vout3.P6.nSD 0.000488088f
Cred_21378 vin3.$544.Metal2 vout3.P6.pSD 0.00258416f
Cred_21379 vin3.$544.Metal2 vout3.P8.nSD 2.09757e-05f
Cred_21380 vin3.$544.Metal2 vout3.P8.pSD 3.1288e-05f
Cred_21381 vin3.$544.Metal2 VSS.$1990.Metal1 0.000148251f
Cred_21382 vin3.$544.Metal2 VSS.$3085.Metal2 0.0131696f
Cred_21383 vin3.$544.Metal2 VSS.$68.Metal1 0.000590062f
Cred_21384 vin3.$544.Metal2 VSS.$923.Metal1 0.0011213f
Cred_21385 vin3.$544.Metal2 VSS.P2.pSD 0.0536049f
Cred_21386 vin3.$544.Metal2 VSS.P57.nSD 3.89907e-05f
Cred_21387 vin3.$547.Metal2 vout3.$1226.Metal3 0.00721531f
Cred_21388 vin3.$547.Metal2 vout3.$1292.Metal3 0.0281306f
Cred_21389 vin3.$547.Metal2 vout3.P6.nSD 0.00011367f
Cred_21390 vin3.$547.Metal2 vout3.P6.pSD 0.00105708f
Cred_21391 vin3.$547.Metal2 vout3.P8.pSD 0.000435848f
Cred_21392 vin3.$548.Metal2 vout3.$1226.Metal3 0.00310844f
Cred_21393 vin3.$548.Metal2 vout3.$1292.Metal3 0.0294593f
Cred_21394 vin3.$548.Metal2 vout3.P6.nSD 8.18366e-05f
Cred_21395 vin3.$548.Metal2 vout3.P6.pSD 0.000267635f
Cred_21396 vin3.$548.Metal2 vout3.P8.nSD 0.00115887f
Cred_21397 vin3.$548.Metal2 VSS.$1024.Metal1 3.79875e-07f
Cred_21398 vin3.$548.Metal2 VSS.$1990.Metal1 2.36248e-05f
Cred_21399 vin3.$548.Metal2 VSS.$3085.Metal2 0.0240728f
Cred_21400 vin3.$548.Metal2 VSS.$3101.Metal2 0.00186341f
Cred_21401 vin3.$548.Metal2 VSS.$3157.Metal2 0.00355795f
Cred_21402 vin3.$548.Metal2 VSS.$4754.Metal3 1.49404e-05f
Cred_21403 vin3.$548.Metal2 VSS.$68.Metal1 7.80933e-05f
Cred_21404 vin3.$548.Metal2 VSS.$923.Metal1 0.00205336f
Cred_21405 vin3.$548.Metal2 VSS.$968.Metal1 2.19689e-07f
Cred_21406 vin3.$548.Metal2 VSS.$996.Metal1 3.60907e-05f
Cred_21407 vin3.$548.Metal2 VSS.P2.pSD 0.00776569f
Cred_21408 vin3.$548.Metal2 VSS.P3.pSD 2.32395e-10f
Cred_21409 vin3.$548.Metal2 VSS.P57.nSD 7.14171e-05f
Cred_21410 vin3.$551.Metal2 vout3.$1292.Metal3 0.0524597f
Cred_21411 vin3.$551.Metal2 vout3.P8.pSD 0.00841488f
Cred_21412 vin3.$552.Metal2 vout3.$1292.Metal3 0.0816158f
Cred_21413 vin3.$552.Metal2 vout3.P8.nSD 0.0122269f
Cred_21414 vin3.$552.Metal2 VSS.$1990.Metal1 3.97131e-05f
Cred_21415 vin3.$552.Metal2 VSS.$3157.Metal2 0.00169455f
Cred_21416 vin3.$552.Metal2 VSS.$68.Metal1 7.87275e-05f
Cred_21417 vin3.$552.Metal2 VSS.P2.pSD 0.0101092f
Cred_21418 vin3.$555.Metal2 vout3.$1292.Metal3 0.155728f
Cred_21419 vin3.$555.Metal2 vout3.P8.nSD 0.00114827f
Cred_21420 vin3.$555.Metal2 vout3.P8.pSD 0.00427509f
Cred_21421 vin3.$555.Metal2 VSS.$1990.Metal1 0.000209592f
Cred_21422 vin3.$555.Metal2 VSS.$68.Metal1 0.000416424f
Cred_21423 vin3.$555.Metal2 VSS.P2.pSD 0.0536361f
Cred_21424 vin3.$557.Metal2 vout3.$1292.Metal3 0.0406136f
Cred_21425 vin3.$557.Metal2 vout3.P8.nSD 0.00500795f
Cred_21426 vin3.$557.Metal2 VSS 4.24113e-06f
Cred_21427 vin3.$557.Metal2 VSS.$1064.Metal1 1.81271e-06f
Cred_21428 vin3.$557.Metal2 VSS.$1084.Metal1 1.67372e-05f
Cred_21429 vin3.$557.Metal2 VSS.$1990.Metal1 2.21853e-05f
Cred_21430 vin3.$557.Metal2 VSS.$3205.Metal2 0.00311477f
Cred_21431 vin3.$557.Metal2 VSS.$3260.Metal2 0.00118406f
Cred_21432 vin3.$557.Metal2 VSS.$3292.Metal2 1.90149e-07f
Cred_21433 vin3.$557.Metal2 VSS.$4802.Metal3 9.49201e-06f
Cred_21434 vin3.$557.Metal2 VSS.$68.Metal1 3.43897e-05f
Cred_21435 vin3.$557.Metal2 VSS.P2.pSD 0.00501423f
Cred_21436 vin3.$557.Metal2 VSS.P59.nSD 1.61888e-07f
Cred_21437 vin3.$557.Metal2 VSS.P83.nSD 1.43423e-11f
Cred_21438 vin3.$558.Metal2 vout3.$1292.Metal3 0.0622962f
Cred_21439 vin3.$558.Metal2 vout3.P8.pSD 0.0113817f
Cred_21440 vin3.$561.Metal2 vout3.$1292.Metal3 0.0255226f
Cred_21441 vin3.$561.Metal2 vout3.$1358.Metal3 0.00563563f
Cred_21442 vin3.$561.Metal2 vout3.P10.nSD 0.000159782f
Cred_21443 vin3.$561.Metal2 vout3.P10.pSD 0.000480861f
Cred_21444 vin3.$561.Metal2 vout3.P8.nSD 7.09978e-05f
Cred_21445 vin3.$561.Metal2 VSS 0.00329235f
Cred_21446 vin3.$561.Metal2 VSS.$1064.Metal1 1.81273e-06f
Cred_21447 vin3.$561.Metal2 VSS.$1084.Metal1 1.87802e-05f
Cred_21448 vin3.$561.Metal2 VSS.$1990.Metal1 4.18915e-05f
Cred_21449 vin3.$561.Metal2 VSS.$3205.Metal2 0.00118389f
Cred_21450 vin3.$561.Metal2 VSS.$3260.Metal2 0.020019f
Cred_21451 vin3.$561.Metal2 VSS.$3292.Metal2 0.0188351f
Cred_21452 vin3.$561.Metal2 VSS.$4802.Metal3 9.49214e-06f
Cred_21453 vin3.$561.Metal2 VSS.$68.Metal1 4.6838e-05f
Cred_21454 vin3.$561.Metal2 VSS.P2.pSD 0.00802675f
Cred_21455 vin3.$561.Metal2 VSS.P59.nSD 0.00011298f
Cred_21456 vin3.$561.Metal2 VSS.P83.nSD 1.42067e-06f
Cred_21457 vin3.$562.Metal2 vout3.$1292.Metal3 0.0233645f
Cred_21458 vin3.$562.Metal2 vout3.$1358.Metal3 0.0048384f
Cred_21459 vin3.$562.Metal2 vout3.P10.nSD 7.62245e-05f
Cred_21460 vin3.$562.Metal2 vout3.P10.pSD 0.000766399f
Cred_21461 vin3.$562.Metal2 vout3.P8.pSD 0.000340744f
Cred_21462 vin3.$564.Metal2 vout3.$1292.Metal3 0.0927722f
Cred_21463 vin3.$564.Metal2 vout3.$1358.Metal3 0.0298818f
Cred_21464 vin3.$564.Metal2 vout3.P10.nSD 0.000494816f
Cred_21465 vin3.$564.Metal2 vout3.P10.pSD 0.00266947f
Cred_21466 vin3.$564.Metal2 vout3.P8.nSD 2.40571e-05f
Cred_21467 vin3.$564.Metal2 vout3.P8.pSD 0.000115459f
Cred_21468 vin3.$564.Metal2 VSS 0.000454548f
Cred_21469 vin3.$564.Metal2 VSS.$1990.Metal1 0.000293302f
Cred_21470 vin3.$564.Metal2 VSS.$3260.Metal2 0.0026226f
Cred_21471 vin3.$564.Metal2 VSS.$3292.Metal2 0.0026226f
Cred_21472 vin3.$564.Metal2 VSS.$68.Metal1 0.0002939f
Cred_21473 vin3.$564.Metal2 VSS.P2.pSD 0.0532676f
Cred_21474 vin3.$564.Metal2 VSS.P59.nSD 1.55832e-05f
Cred_21475 vin3.$564.Metal2 VSS.P83.nSD 1.97814e-07f
Cred_21476 vin3.$566.Metal2 vout3.$1292.Metal3 0.0213072f
Cred_21477 vin3.$566.Metal2 vout3.$1358.Metal3 0.00946627f
Cred_21478 vin3.$566.Metal2 vout3.P10.nSD 0.000222271f
Cred_21479 vin3.$566.Metal2 vout3.P10.pSD 0.000807711f
Cred_21480 vin3.$566.Metal2 vout3.P8.nSD 7.09978e-05f
Cred_21481 vin3.$566.Metal2 VSS 0.00326186f
Cred_21482 vin3.$566.Metal2 VSS.$1160.Metal1 1.04645e-05f
Cred_21483 vin3.$566.Metal2 VSS.$1180.Metal1 3.94981e-06f
Cred_21484 vin3.$566.Metal2 VSS.$1990.Metal1 4.72668e-05f
Cred_21485 vin3.$566.Metal2 VSS.$3260.Metal2 0.0174261f
Cred_21486 vin3.$566.Metal2 VSS.$3292.Metal2 0.0186099f
Cred_21487 vin3.$566.Metal2 VSS.$3344.Metal2 0.00118383f
Cred_21488 vin3.$566.Metal2 VSS.$4838.Metal3 9.49168e-06f
Cred_21489 vin3.$566.Metal2 VSS.$68.Metal1 4.22879e-05f
Cred_21490 vin3.$566.Metal2 VSS.P2.pSD 0.0081018f
Cred_21491 vin3.$566.Metal2 VSS.P59.nSD 0.000112877f
Cred_21492 vin3.$566.Metal2 VSS.P83.nSD 1.31439e-06f
Cred_21493 vin3.$567.Metal2 vout3.$1292.Metal3 0.019148f
Cred_21494 vin3.$567.Metal2 vout3.$1358.Metal3 0.00866777f
Cred_21495 vin3.$567.Metal2 vout3.P10.nSD 0.000136553f
Cred_21496 vin3.$567.Metal2 vout3.P10.pSD 0.00109314f
Cred_21497 vin3.$567.Metal2 vout3.P8.pSD 0.000340744f
Cred_21498 vin3.$57.GatPoly vout3.$1226.Metal3 0.0315155f
Cred_21499 vin3.$57.GatPoly vout3.$1292.Metal3 0.0256585f
Cred_21500 vin3.$57.GatPoly vout3.P4.pSD 0.000411545f
Cred_21501 vin3.$57.GatPoly vout3.P6.nSD 0.000404226f
Cred_21502 vin3.$57.GatPoly vout3.P6.pSD 0.0362783f
Cred_21503 vin3.$570.Metal2 vout3.$1292.Metal3 0.0193351f
Cred_21504 vin3.$570.Metal2 vout3.$1358.Metal3 0.0193351f
Cred_21505 vin3.$570.Metal2 vout3.P10.nSD 0.00532148f
Cred_21506 vin3.$570.Metal2 vout3.P10.pSD 0.00164977f
Cred_21507 vin3.$570.Metal2 VSS.$1160.Metal1 1.20657e-05f
Cred_21508 vin3.$570.Metal2 VSS.$1180.Metal1 1.07257e-05f
Cred_21509 vin3.$570.Metal2 VSS.$1990.Metal1 3.46638e-05f
Cred_21510 vin3.$570.Metal2 VSS.$3292.Metal2 0.00118386f
Cred_21511 vin3.$570.Metal2 VSS.$3344.Metal2 0.00311476f
Cred_21512 vin3.$570.Metal2 VSS.$4838.Metal3 9.49194e-06f
Cred_21513 vin3.$570.Metal2 VSS.$68.Metal1 2.23358e-05f
Cred_21514 vin3.$570.Metal2 VSS.P2.pSD 0.00505151f
Cred_21515 vin3.$571.Metal2 vout3.$1292.Metal3 0.0300458f
Cred_21516 vin3.$571.Metal2 vout3.$1358.Metal3 0.0300458f
Cred_21517 vin3.$571.Metal2 vout3.P10.nSD 0.000473344f
Cred_21518 vin3.$571.Metal2 vout3.P10.pSD 0.0144261f
Cred_21519 vin3.$573.Metal2 vout3.$1292.Metal3 0.0747144f
Cred_21520 vin3.$573.Metal2 vout3.$1358.Metal3 0.0747144f
Cred_21521 vin3.$573.Metal2 vout3.P10.nSD 0.00232532f
Cred_21522 vin3.$573.Metal2 vout3.P10.pSD 0.0107242f
Cred_21523 vin3.$573.Metal2 VSS.$1990.Metal1 0.000416424f
Cred_21524 vin3.$573.Metal2 VSS.$68.Metal1 0.000209592f
Cred_21525 vin3.$573.Metal2 VSS.P2.pSD 0.0536361f
Cred_21526 vin3.$575.Metal2 vout3.$1292.Metal3 0.03885f
Cred_21527 vin3.$575.Metal2 vout3.$1358.Metal3 0.03885f
Cred_21528 vin3.$575.Metal2 vout3.P10.nSD 0.012848f
Cred_21529 vin3.$575.Metal2 vout3.P10.pSD 0.00331488f
Cred_21530 vin3.$575.Metal2 VSS.$1990.Metal1 7.87702e-05f
Cred_21531 vin3.$575.Metal2 VSS.$3392.Metal2 0.00169455f
Cred_21532 vin3.$575.Metal2 VSS.$68.Metal1 3.97335e-05f
Cred_21533 vin3.$575.Metal2 VSS.P2.pSD 0.0101146f
Cred_21534 vin3.$578.Metal2 vout3.$1292.Metal3 0.024319f
Cred_21535 vin3.$578.Metal2 vout3.$1358.Metal3 0.024319f
Cred_21536 vin3.$578.Metal2 vout3.P10.nSD 0.000383123f
Cred_21537 vin3.$578.Metal2 vout3.P10.pSD 0.0105403f
Cred_21538 vin3.$579.Metal2 vout3.$1292.Metal3 0.0125416f
Cred_21539 vin3.$579.Metal2 vout3.$1358.Metal3 0.0190751f
Cred_21540 vin3.$579.Metal2 vout3.P10.nSD 0.00135645f
Cred_21541 vin3.$579.Metal2 vout3.P10.pSD 0.00107011f
Cred_21542 vin3.$579.Metal2 vout3.P12.nSD 3.28661e-05f
Cred_21543 vin3.$579.Metal2 VSS.$1220.Metal1 3.79875e-07f
Cred_21544 vin3.$579.Metal2 VSS.$1260.Metal1 3.60907e-05f
Cred_21545 vin3.$579.Metal2 VSS.$1266.Metal1 0.00205336f
Cred_21546 vin3.$579.Metal2 VSS.$1279.Metal1 2.19689e-07f
Cred_21547 vin3.$579.Metal2 VSS.$1990.Metal1 7.80933e-05f
Cred_21548 vin3.$579.Metal2 VSS.$3392.Metal2 0.00355795f
Cred_21549 vin3.$579.Metal2 VSS.$3435.Metal2 0.0240728f
Cred_21550 vin3.$579.Metal2 VSS.$3451.Metal2 0.00186341f
Cred_21551 vin3.$579.Metal2 VSS.$4886.Metal3 1.49404e-05f
Cred_21552 vin3.$579.Metal2 VSS.$68.Metal1 2.36248e-05f
Cred_21553 vin3.$579.Metal2 VSS.P2.pSD 0.00776569f
Cred_21554 vin3.$579.Metal2 VSS.P3.pSD 2.32395e-10f
Cred_21555 vin3.$579.Metal2 VSS.P61.nSD 7.14171e-05f
Cred_21556 vin3.$58.GatPoly vout3.$1226.Metal3 0.0029015f
Cred_21557 vin3.$58.GatPoly vout3.$1292.Metal3 0.00203672f
Cred_21558 vin3.$58.GatPoly vout3.P4.nSD 8.10886e-06f
Cred_21559 vin3.$58.GatPoly vout3.P6.nSD 0.00214376f
Cred_21560 vin3.$58.GatPoly vout3.P6.pSD 0.000175361f
Cred_21561 vin3.$58.GatPoly VSS.$1990.Metal1 5.32811e-06f
Cred_21562 vin3.$58.GatPoly VSS.$2914.Metal2 0.00119906f
Cred_21563 vin3.$58.GatPoly VSS.$2946.Metal2 4.55804e-05f
Cred_21564 vin3.$58.GatPoly VSS.$2994.Metal2 4.65484e-08f
Cred_21565 vin3.$58.GatPoly VSS.$4682.Metal3 3.73215e-10f
Cred_21566 vin3.$58.GatPoly VSS.$68.Metal1 6.2806e-05f
Cred_21567 vin3.$58.GatPoly VSS.$744.Metal1 0.00550767f
Cred_21568 vin3.$58.GatPoly VSS.$817.Metal1 8.42002e-06f
Cred_21569 vin3.$58.GatPoly VSS.$837.Metal1 2.21748e-06f
Cred_21570 vin3.$58.GatPoly VSS.P2.pSD 0.00330809f
Cred_21571 vin3.$58.GatPoly VSS.P55.nSD 0.000177406f
Cred_21572 vin3.$58.GatPoly VSS.P79.nSD 6.61762e-09f
Cred_21573 vin3.$582.Metal2 vout3.$1292.Metal3 0.00993907f
Cred_21574 vin3.$582.Metal2 vout3.$1358.Metal3 0.0250721f
Cred_21575 vin3.$582.Metal2 vout3.P10.nSD 0.000156581f
Cred_21576 vin3.$582.Metal2 vout3.P10.pSD 0.00131644f
Cred_21577 vin3.$582.Metal2 vout3.P12.pSD 0.000468386f
Cred_21578 vin3.$584.Metal2 vout3.$1292.Metal3 0.0295083f
Cred_21579 vin3.$584.Metal2 vout3.$1358.Metal3 0.0918296f
Cred_21580 vin3.$584.Metal2 vout3.P10.nSD 0.000485851f
Cred_21581 vin3.$584.Metal2 vout3.P10.pSD 0.00254831f
Cred_21582 vin3.$584.Metal2 vout3.P12.nSD 2.09757e-05f
Cred_21583 vin3.$584.Metal2 vout3.P12.pSD 3.05134e-05f
Cred_21584 vin3.$584.Metal2 VSS.$1266.Metal1 0.0011213f
Cred_21585 vin3.$584.Metal2 VSS.$1990.Metal1 0.000589053f
Cred_21586 vin3.$584.Metal2 VSS.$3435.Metal2 0.0131696f
Cred_21587 vin3.$584.Metal2 VSS.$68.Metal1 0.000148505f
Cred_21588 vin3.$584.Metal2 VSS.P2.pSD 0.0536055f
Cred_21589 vin3.$584.Metal2 VSS.P61.nSD 3.89907e-05f
Cred_21590 vin3.$586.Metal2 vout3.$1292.Metal3 0.00466478f
Cred_21591 vin3.$586.Metal2 vout3.$1358.Metal3 0.0239312f
Cred_21592 vin3.$586.Metal2 vout3.P10.nSD 0.000113776f
Cred_21593 vin3.$586.Metal2 vout3.P10.pSD 0.000398023f
Cred_21594 vin3.$586.Metal2 vout3.P12.nSD 4.94234e-05f
Cred_21595 vin3.$586.Metal2 VSS.$1266.Metal1 0.00362769f
Cred_21596 vin3.$586.Metal2 VSS.$1311.Metal1 2.89664e-06f
Cred_21597 vin3.$586.Metal2 VSS.$1339.Metal1 1.14797e-05f
Cred_21598 vin3.$586.Metal2 VSS.$1990.Metal1 8.92056e-05f
Cred_21599 vin3.$586.Metal2 VSS.$3435.Metal2 0.0426236f
Cred_21600 vin3.$586.Metal2 VSS.$3507.Metal2 0.00302246f
Cred_21601 vin3.$586.Metal2 VSS.$4910.Metal3 5.05911e-06f
Cred_21602 vin3.$586.Metal2 VSS.$68.Metal1 2.01081e-05f
Cred_21603 vin3.$586.Metal2 VSS.P2.pSD 0.0076153f
Cred_21604 vin3.$586.Metal2 VSS.P61.nSD 0.000126347f
Cred_21605 vin3.$587.Metal2 vout3.$1292.Metal3 0.00150227f
Cred_21606 vin3.$587.Metal2 vout3.$1358.Metal3 0.0150382f
Cred_21607 vin3.$587.Metal2 vout3.P10.nSD 2.36668e-05f
Cred_21608 vin3.$587.Metal2 vout3.P10.pSD 0.000186786f
Cred_21609 vin3.$587.Metal2 vout3.P12.pSD 0.00018411f
Cred_21610 vin3.$590.Metal2 vout3.$1358.Metal3 0.0577404f
Cred_21611 vin3.$590.Metal2 vout3.P12.nSD 0.00778208f
Cred_21612 vin3.$590.Metal2 VSS.$1266.Metal1 6.50199e-06f
Cred_21613 vin3.$590.Metal2 VSS.$1339.Metal1 1.73049e-06f
Cred_21614 vin3.$590.Metal2 VSS.$1990.Metal1 9.16324e-05f
Cred_21615 vin3.$590.Metal2 VSS.$3435.Metal2 5.84469e-07f
Cred_21616 vin3.$590.Metal2 VSS.$3507.Metal2 0.00239142f
Cred_21617 vin3.$590.Metal2 VSS.$68.Metal1 1.28004e-05f
Cred_21618 vin3.$590.Metal2 VSS.P2.pSD 0.00616587f
Cred_21619 vin3.$590.Metal2 VSS.P61.nSD 2.4666e-07f
Cred_21620 vin3.$591.Metal2 vout3.$1358.Metal3 0.0519778f
Cred_21621 vin3.$591.Metal2 vout3.P12.pSD 0.00988711f
Cred_21622 vin3.$593.Metal2 vout3.$1358.Metal3 0.176862f
Cred_21623 vin3.$593.Metal2 vout3.$1424.Metal3 0.00901986f
Cred_21624 vin3.$593.Metal2 vout3.P12.nSD 0.00129007f
Cred_21625 vin3.$593.Metal2 vout3.P12.pSD 0.00144016f
Cred_21626 vin3.$593.Metal2 vout3.P14.nSD 0.000142398f
Cred_21627 vin3.$593.Metal2 vout3.P14.pSD 0.00076962f
Cred_21628 vin3.$593.Metal2 VSS.$1445.Metal1 0.000131611f
Cred_21629 vin3.$593.Metal2 VSS.$1990.Metal1 0.00122868f
Cred_21630 vin3.$593.Metal2 VSS.$3603.Metal2 5.69106e-05f
Cred_21631 vin3.$593.Metal2 VSS.$3638.Metal2 0.00149864f
Cred_21632 vin3.$593.Metal2 VSS.$68.Metal1 0.000130088f
Cred_21633 vin3.$593.Metal2 VSS.P2.pSD 0.071407f
Cred_21634 vin3.$593.Metal2 VSS.P63.nSD 4.56217e-06f
Cred_21635 vin3.$593.Metal2 VSS.P87.nSD 8.27105e-09f
Cred_21636 vin3.$595.Metal2 vout3.$1358.Metal3 0.0716421f
Cred_21637 vin3.$595.Metal2 vout3.P12.nSD 0.0105277f
Cred_21638 vin3.$595.Metal2 VSS.$1407.Metal1 9.80683e-06f
Cred_21639 vin3.$595.Metal2 VSS.$1427.Metal1 4.81079e-06f
Cred_21640 vin3.$595.Metal2 VSS.$1445.Metal1 1.57363e-06f
Cred_21641 vin3.$595.Metal2 VSS.$1990.Metal1 0.000126823f
Cred_21642 vin3.$595.Metal2 VSS.$3555.Metal2 0.00113253f
Cred_21643 vin3.$595.Metal2 VSS.$3603.Metal2 0.00113253f
Cred_21644 vin3.$595.Metal2 VSS.$3638.Metal2 1.36232e-07f
Cred_21645 vin3.$595.Metal2 VSS.$4958.Metal3 9.08034e-06f
Cred_21646 vin3.$595.Metal2 VSS.$68.Metal1 1.40151e-05f
Cred_21647 vin3.$595.Metal2 VSS.P2.pSD 0.00759093f
Cred_21648 vin3.$595.Metal2 VSS.P63.nSD 5.90182e-08f
Cred_21649 vin3.$595.Metal2 VSS.P87.nSD 7.51865e-13f
Cred_21650 vin3.$596.Metal2 vout3.$1358.Metal3 0.0705949f
Cred_21651 vin3.$596.Metal2 vout3.P12.pSD 0.0131059f
Cred_21652 vin3.$599.Metal2 vout3.$1358.Metal3 0.0140062f
Cred_21653 vin3.$599.Metal2 vout3.$1424.Metal3 0.000402309f
Cred_21654 vin3.$599.Metal2 vout3.P12.nSD 2.51091e-05f
Cred_21655 vin3.$599.Metal2 vout3.P14.nSD 7.69108e-06f
Cred_21656 vin3.$599.Metal2 vout3.P14.pSD 3.4327e-05f
Cred_21657 vin3.$599.Metal2 VSS.$1407.Metal1 1.13754e-05f
Cred_21658 vin3.$599.Metal2 VSS.$1427.Metal1 1.07668e-05f
Cred_21659 vin3.$599.Metal2 VSS.$1445.Metal1 0.00144525f
Cred_21660 vin3.$599.Metal2 VSS.$1990.Metal1 8.80901e-05f
Cred_21661 vin3.$599.Metal2 VSS.$3555.Metal2 0.00113256f
Cred_21662 vin3.$599.Metal2 VSS.$3603.Metal2 0.00416061f
Cred_21663 vin3.$599.Metal2 VSS.$3638.Metal2 0.016284f
Cred_21664 vin3.$599.Metal2 VSS.$4958.Metal3 9.0806e-06f
Cred_21665 vin3.$599.Metal2 VSS.$68.Metal1 7.29823e-06f
Cred_21666 vin3.$599.Metal2 VSS.P2.pSD 0.00457845f
Cred_21667 vin3.$599.Metal2 VSS.P63.nSD 5.01416e-05f
Cred_21668 vin3.$599.Metal2 VSS.P87.nSD 8.98714e-08f
Cred_21669 vin3.$6.GatPoly vout3.$1226.Metal3 0.00764895f
Cred_21670 vin3.$6.GatPoly vout3.P0.nSD 0.00586292f
Cred_21671 vin3.$6.GatPoly vout3.P0.pSD 0.0011912f
Cred_21672 vin3.$6.GatPoly vout3.P2.nSD 0.00012313f
Cred_21673 vin3.$6.GatPoly vout3.P2.pSD 0.000658571f
Cred_21674 vin3.$6.GatPoly VSS.$159.Metal1 0.000222139f
Cred_21675 vin3.$6.GatPoly VSS.$1990.Metal1 1.31269e-06f
Cred_21676 vin3.$6.GatPoly VSS.$2238.Metal2 7.98189e-05f
Cred_21677 vin3.$6.GatPoly VSS.$2409.Metal2 4.14065e-06f
Cred_21678 vin3.$6.GatPoly VSS.$2433.Metal2 4.75607e-06f
Cred_21679 vin3.$6.GatPoly VSS.$2532.Metal2 2.03093e-05f
Cred_21680 vin3.$6.GatPoly VSS.$2564.Metal2 2.72725e-05f
Cred_21681 vin3.$6.GatPoly VSS.$292.Metal1 4.56443e-05f
Cred_21682 vin3.$6.GatPoly VSS.$386.Metal1 0.00053061f
Cred_21683 vin3.$6.GatPoly VSS.$4358.Metal3 2.13738e-05f
Cred_21684 vin3.$6.GatPoly VSS.$68.Metal1 0.000704208f
Cred_21685 vin3.$6.GatPoly VSS.P2.pSD 0.00487998f
Cred_21686 vin3.$6.GatPoly VSS.P4.GatPoly 0.000379998f
Cred_21687 vin3.$6.GatPoly VSS.P48.nSD 1.5236e-06f
Cred_21688 vin3.$6.GatPoly VSS.P49.nSD 1.5236e-06f
Cred_21689 vin3.$6.GatPoly VSS.P51.nSD 1.98985e-05f
Cred_21690 vin3.$6.GatPoly VSS.P75.nSD 1.75604e-09f
Cred_21691 vin3.$603.Metal2 vout3.$1358.Metal3 0.0531514f
Cred_21692 vin3.$603.Metal2 vout3.$1424.Metal3 0.0153467f
Cred_21693 vin3.$603.Metal2 vout3.P12.nSD 1.43057e-07f
Cred_21694 vin3.$603.Metal2 vout3.P12.pSD 0.000804195f
Cred_21695 vin3.$603.Metal2 vout3.P14.nSD 0.000241915f
Cred_21696 vin3.$603.Metal2 vout3.P14.pSD 0.00185992f
Cred_21697 vin3.$603.Metal2 VSS.$1445.Metal1 6.30427e-05f
Cred_21698 vin3.$603.Metal2 VSS.$1990.Metal1 0.000183633f
Cred_21699 vin3.$603.Metal2 VSS.$3603.Metal2 2.72606e-05f
Cred_21700 vin3.$603.Metal2 VSS.$3638.Metal2 0.000717863f
Cred_21701 vin3.$603.Metal2 VSS.$68.Metal1 1.15245e-05f
Cred_21702 vin3.$603.Metal2 VSS.P2.pSD 0.00827243f
Cred_21703 vin3.$603.Metal2 VSS.P63.nSD 2.18532e-06f
Cred_21704 vin3.$603.Metal2 VSS.P87.nSD 3.9619e-09f
Cred_21705 vin3.$604.Metal2 vout3.$1358.Metal3 0.0461637f
Cred_21706 vin3.$604.Metal2 vout3.$1424.Metal3 0.0178808f
Cred_21707 vin3.$604.Metal2 vout3.P12.nSD 9.26598e-05f
Cred_21708 vin3.$604.Metal2 vout3.P14.nSD 0.000472451f
Cred_21709 vin3.$604.Metal2 vout3.P14.pSD 0.00152568f
Cred_21710 vin3.$604.Metal2 VSS.$1445.Metal1 0.00469654f
Cred_21711 vin3.$604.Metal2 VSS.$1490.Metal1 9.62491e-07f
Cred_21712 vin3.$604.Metal2 VSS.$1518.Metal1 6.89594e-06f
Cred_21713 vin3.$604.Metal2 VSS.$1546.Metal1 5.85998e-07f
Cred_21714 vin3.$604.Metal2 VSS.$1990.Metal1 0.000492066f
Cred_21715 vin3.$604.Metal2 VSS.$3603.Metal2 0.00192892f
Cred_21716 vin3.$604.Metal2 VSS.$3638.Metal2 0.0517027f
Cred_21717 vin3.$604.Metal2 VSS.$3694.Metal2 0.00236814f
Cred_21718 vin3.$604.Metal2 VSS.$4994.Metal3 7.27794e-06f
Cred_21719 vin3.$604.Metal2 VSS.$68.Metal1 2.9167e-05f
Cred_21720 vin3.$604.Metal2 VSS.P2.pSD 0.021478f
Cred_21721 vin3.$604.Metal2 VSS.P3.pSD 3.58279e-10f
Cred_21722 vin3.$604.Metal2 VSS.P63.nSD 0.000163835f
Cred_21723 vin3.$604.Metal2 VSS.P87.nSD 2.80338e-07f
Cred_21724 vin3.$609.Metal2 vout3.$1358.Metal3 0.00918213f
Cred_21725 vin3.$609.Metal2 vout3.$1424.Metal3 0.00907964f
Cred_21726 vin3.$609.Metal2 vout3.P12.pSD 6.65553e-06f
Cred_21727 vin3.$609.Metal2 vout3.P14.nSD 0.000143041f
Cred_21728 vin3.$609.Metal2 vout3.P14.pSD 0.00173063f
Cred_21729 vin3.$610.Metal2 vout3.$1358.Metal3 0.036807f
Cred_21730 vin3.$610.Metal2 vout3.$1424.Metal3 0.036807f
Cred_21731 vin3.$610.Metal2 vout3.P14.nSD 0.0118473f
Cred_21732 vin3.$610.Metal2 vout3.P14.pSD 0.00314056f
Cred_21733 vin3.$610.Metal2 VSS.$1445.Metal1 0.000373998f
Cred_21734 vin3.$610.Metal2 VSS.$1490.Metal1 4.76709e-07f
Cred_21735 vin3.$610.Metal2 VSS.$1518.Metal1 4.30884e-06f
Cred_21736 vin3.$610.Metal2 VSS.$1546.Metal1 1.18318e-06f
Cred_21737 vin3.$610.Metal2 VSS.$1990.Metal1 0.000299231f
Cred_21738 vin3.$610.Metal2 VSS.$3603.Metal2 0.000161723f
Cred_21739 vin3.$610.Metal2 VSS.$3638.Metal2 0.00470828f
Cred_21740 vin3.$610.Metal2 VSS.$3694.Metal2 0.00339829f
Cred_21741 vin3.$610.Metal2 VSS.$4994.Metal3 3.60467e-06f
Cred_21742 vin3.$610.Metal2 VSS.$68.Metal1 1.02073e-05f
Cred_21743 vin3.$610.Metal2 VSS.P2.pSD 0.00982483f
Cred_21744 vin3.$610.Metal2 VSS.P3.pSD 7.23397e-10f
Cred_21745 vin3.$610.Metal2 VSS.P63.nSD 1.29643e-05f
Cred_21746 vin3.$610.Metal2 VSS.P87.nSD 2.35038e-08f
Cred_21747 vin3.$611.Metal2 vout3.$1358.Metal3 0.0291332f
Cred_21748 vin3.$611.Metal2 vout3.$1424.Metal3 0.0291332f
Cred_21749 vin3.$611.Metal2 vout3.P14.nSD 0.000458966f
Cred_21750 vin3.$611.Metal2 vout3.P14.pSD 0.0159242f
Cred_21751 vin3.$613.Metal2 vout3.$1358.Metal3 0.0982929f
Cred_21752 vin3.$613.Metal2 vout3.$1424.Metal3 0.0792964f
Cred_21753 vin3.$613.Metal2 vout3.P12.nSD 2.98653e-07f
Cred_21754 vin3.$613.Metal2 vout3.P14.nSD 0.00247466f
Cred_21755 vin3.$613.Metal2 vout3.P14.pSD 0.00812867f
Cred_21756 vin3.$613.Metal2 VSS.$1445.Metal1 0.000131611f
Cred_21757 vin3.$613.Metal2 VSS.$1990.Metal1 0.00210013f
Cred_21758 vin3.$613.Metal2 VSS.$3603.Metal2 5.69106e-05f
Cred_21759 vin3.$613.Metal2 VSS.$3638.Metal2 0.00149864f
Cred_21760 vin3.$613.Metal2 VSS.$68.Metal1 7.75295e-05f
Cred_21761 vin3.$613.Metal2 VSS.P2.pSD 0.0712918f
Cred_21762 vin3.$613.Metal2 VSS.P63.nSD 4.56217e-06f
Cred_21763 vin3.$613.Metal2 VSS.P87.nSD 8.27105e-09f
Cred_21764 vin3.$615.Metal2 vout3.$1358.Metal3 0.0276082f
Cred_21765 vin3.$615.Metal2 vout3.$1424.Metal3 0.0276082f
Cred_21766 vin3.$615.Metal2 vout3.P14.nSD 0.00752093f
Cred_21767 vin3.$615.Metal2 vout3.P14.pSD 0.00235568f
Cred_21768 vin3.$615.Metal2 VSS.$1566.Metal1 2.28519e-06f
Cred_21769 vin3.$615.Metal2 VSS.$1586.Metal1 2.1546e-06f
Cred_21770 vin3.$615.Metal2 VSS.$1990.Metal1 0.000181373f
Cred_21771 vin3.$615.Metal2 VSS.$3718.Metal2 0.000554701f
Cred_21772 vin3.$615.Metal2 VSS.$3766.Metal2 0.00305041f
Cred_21773 vin3.$615.Metal2 VSS.$5030.Metal3 4.44747e-06f
Cred_21774 vin3.$615.Metal2 VSS.$68.Metal1 4.6833e-06f
Cred_21775 vin3.$615.Metal2 VSS.P2.pSD 0.00516648f
Cred_21776 vin3.$616.Metal2 vout3.$1358.Metal3 0.0231172f
Cred_21777 vin3.$616.Metal2 vout3.$1424.Metal3 0.0231172f
Cred_21778 vin3.$616.Metal2 vout3.P14.nSD 0.00036419f
Cred_21779 vin3.$616.Metal2 vout3.P14.pSD 0.010938f
Cred_21780 vin3.$619.Metal2 vout3.$1358.Metal3 0.00640448f
Cred_21781 vin3.$619.Metal2 vout3.$1424.Metal3 0.010863f
Cred_21782 vin3.$619.Metal2 vout3.P14.nSD 0.000118081f
Cred_21783 vin3.$619.Metal2 vout3.P14.pSD 0.000546463f
Cred_21784 vin3.$619.Metal2 vout3.P16.nSD 1.71843e-05f
Cred_21785 vin3.$619.Metal2 VSS.$1606.Metal1 4.04686e-07f
Cred_21786 vin3.$619.Metal2 VSS.$1624.Metal1 0.00245323f
Cred_21787 vin3.$619.Metal2 VSS.$1629.Metal1 3.52655e-06f
Cred_21788 vin3.$619.Metal2 VSS.$1990.Metal1 0.000264532f
Cred_21789 vin3.$619.Metal2 VSS.$3766.Metal2 0.00298634f
Cred_21790 vin3.$619.Metal2 VSS.$3809.Metal2 0.0277271f
Cred_21791 vin3.$619.Metal2 VSS.$5054.Metal3 3.93375e-06f
Cred_21792 vin3.$619.Metal2 VSS.$68.Metal1 4.73034e-06f
Cred_21793 vin3.$619.Metal2 VSS.P2.pSD 0.00622947f
Cred_21794 vin3.$619.Metal2 VSS.P65.nSD 8.58485e-05f
Cred_21795 vin3.$620.Metal2 vout3.$1358.Metal3 0.00660463f
Cred_21796 vin3.$620.Metal2 vout3.$1424.Metal3 0.0109848f
Cred_21797 vin3.$620.Metal2 vout3.P14.nSD 0.00010405f
Cred_21798 vin3.$620.Metal2 vout3.P14.pSD 0.000659154f
Cred_21799 vin3.$620.Metal2 vout3.P16.pSD 9.56129e-05f
Cred_21800 vin3.$622.Metal2 vout3.$1358.Metal3 0.028528f
Cred_21801 vin3.$622.Metal2 vout3.$1424.Metal3 0.0879111f
Cred_21802 vin3.$622.Metal2 vout3.P14.nSD 0.000457527f
Cred_21803 vin3.$622.Metal2 vout3.P14.pSD 0.0024792f
Cred_21804 vin3.$622.Metal2 vout3.P16.nSD 8.09507e-06f
Cred_21805 vin3.$622.Metal2 vout3.P16.pSD 4.50408e-05f
Cred_21806 vin3.$622.Metal2 VSS.$1624.Metal1 0.000401659f
Cred_21807 vin3.$622.Metal2 VSS.$1990.Metal1 0.00229387f
Cred_21808 vin3.$622.Metal2 VSS.$3809.Metal2 0.00476634f
Cred_21809 vin3.$622.Metal2 VSS.$68.Metal1 3.58677e-05f
Cred_21810 vin3.$622.Metal2 VSS.P2.pSD 0.0505008f
Cred_21811 vin3.$622.Metal2 VSS.P65.nSD 1.3949e-05f
Cred_21812 vin3.$624.Metal2 vout3.$1358.Metal3 0.00650663f
Cred_21813 vin3.$624.Metal2 vout3.$1424.Metal3 0.036376f
Cred_21814 vin3.$624.Metal2 vout3.P14.nSD 0.00017198f
Cred_21815 vin3.$624.Metal2 vout3.P14.pSD 0.000555179f
Cred_21816 vin3.$624.Metal2 vout3.P16.nSD 0.00104885f
Cred_21817 vin3.$624.Metal2 VSS.$1624.Metal1 0.00385056f
Cred_21818 vin3.$624.Metal2 VSS.$1685.Metal1 8.52825e-06f
Cred_21819 vin3.$624.Metal2 VSS.$1705.Metal1 3.8105e-06f
Cred_21820 vin3.$624.Metal2 VSS.$1990.Metal1 0.000452537f
Cred_21821 vin3.$624.Metal2 VSS.$3809.Metal2 0.0451789f
Cred_21822 vin3.$624.Metal2 VSS.$3825.Metal2 0.0015412f
Cred_21823 vin3.$624.Metal2 VSS.$3881.Metal2 0.00256116f
Cred_21824 vin3.$624.Metal2 VSS.$5078.Metal3 1.2357e-05f
Cred_21825 vin3.$624.Metal2 VSS.$68.Metal1 6.12383e-06f
Cred_21826 vin3.$624.Metal2 VSS.P2.pSD 0.00921024f
Cred_21827 vin3.$624.Metal2 VSS.P65.nSD 0.000133911f
Cred_21828 vin3.$625.Metal2 vout3.$1358.Metal3 0.00634131f
Cred_21829 vin3.$625.Metal2 vout3.$1424.Metal3 0.0261527f
Cred_21830 vin3.$625.Metal2 vout3.P14.nSD 9.99013e-05f
Cred_21831 vin3.$625.Metal2 vout3.P14.pSD 0.000957923f
Cred_21832 vin3.$625.Metal2 vout3.P16.pSD 0.000416851f
Cred_21833 vin3.$629.Metal2 vout3.$1424.Metal3 0.0538987f
Cred_21834 vin3.$629.Metal2 vout3.P16.pSD 0.00930781f
Cred_21835 vin3.$630.Metal2 vout3.$1424.Metal3 0.0918079f
Cred_21836 vin3.$630.Metal2 vout3.P16.nSD 0.0129837f
Cred_21837 vin3.$630.Metal2 VSS.$1624.Metal1 5.37786e-05f
Cred_21838 vin3.$630.Metal2 VSS.$1685.Metal1 4.22399e-06f
Cred_21839 vin3.$630.Metal2 VSS.$1705.Metal1 1.88732e-06f
Cred_21840 vin3.$630.Metal2 VSS.$1990.Metal1 0.000754158f
Cred_21841 vin3.$630.Metal2 VSS.$3809.Metal2 0.00063817f
Cred_21842 vin3.$630.Metal2 VSS.$3825.Metal2 0.000763347f
Cred_21843 vin3.$630.Metal2 VSS.$3881.Metal2 0.00282265f
Cred_21844 vin3.$630.Metal2 VSS.$5078.Metal3 6.12034e-06f
Cred_21845 vin3.$630.Metal2 VSS.$68.Metal1 6.14319e-06f
Cred_21846 vin3.$630.Metal2 VSS.P2.pSD 0.011727f
Cred_21847 vin3.$630.Metal2 VSS.P65.nSD 1.86765e-06f
Cred_21848 vin3.$633.Metal2 vout3.$1424.Metal3 0.156738f
Cred_21849 vin3.$633.Metal2 vout3.P16.nSD 0.00114517f
Cred_21850 vin3.$633.Metal2 vout3.P16.pSD 0.0046241f
Cred_21851 vin3.$633.Metal2 VSS.$1990.Metal1 0.0032525f
Cred_21852 vin3.$633.Metal2 VSS.$68.Metal1 2.54348e-05f
Cred_21853 vin3.$633.Metal2 VSS.P2.pSD 0.0497379f
Cred_21854 vin3.$635.Metal2 vout3.$1424.Metal3 0.0361747f
Cred_21855 vin3.$635.Metal2 vout3.P16.nSD 0.00424937f
Cred_21856 vin3.$635.Metal2 VSS.$1745.Metal1 4.92789e-07f
Cred_21857 vin3.$635.Metal2 VSS.$1773.Metal1 1.12553e-05f
Cred_21858 vin3.$635.Metal2 VSS.$1793.Metal1 1.26139e-06f
Cred_21859 vin3.$635.Metal2 VSS.$1799.Metal1 1.75061e-05f
Cred_21860 vin3.$635.Metal2 VSS.$1990.Metal1 0.000329249f
Cred_21861 vin3.$635.Metal2 VSS.$3929.Metal2 0.00353881f
Cred_21862 vin3.$635.Metal2 VSS.$3988.Metal2 0.00119052f
Cred_21863 vin3.$635.Metal2 VSS.$4020.Metal2 6.70053e-07f
Cred_21864 vin3.$635.Metal2 VSS.$5126.Metal3 9.5381e-06f
Cred_21865 vin3.$635.Metal2 VSS.$68.Metal1 1.96932e-06f
Cred_21866 vin3.$635.Metal2 VSS.P2.pSD 0.0043762f
Cred_21867 vin3.$635.Metal2 VSS.P3.pSD 3.01291e-10f
Cred_21868 vin3.$635.Metal2 VSS.P67.nSD 6.6924e-07f
Cred_21869 vin3.$635.Metal2 VSS.P91.nSD 5.79358e-11f
Cred_21870 vin3.$636.Metal2 vout3.$1424.Metal3 0.0588585f
Cred_21871 vin3.$636.Metal2 vout3.P16.pSD 0.010786f
Cred_21872 vin3.$639.Metal2 vout3 0.00147839f
Cred_21873 vin3.$639.Metal2 vout3.$1424.Metal3 0.0275791f
Cred_21874 vin3.$639.Metal2 vout3.P16.nSD 7.17394e-05f
Cred_21875 vin3.$639.Metal2 vout3.P18.nSD 0.00016196f
Cred_21876 vin3.$639.Metal2 vout3.P18.pSD 0.000636201f
Cred_21877 vin3.$639.Metal2 VSS.$1773.Metal1 1.23083e-05f
Cred_21878 vin3.$639.Metal2 VSS.$1793.Metal1 1.26142e-06f
Cred_21879 vin3.$639.Metal2 VSS.$1799.Metal1 0.00370329f
Cred_21880 vin3.$639.Metal2 VSS.$1990.Metal1 0.000719861f
Cred_21881 vin3.$639.Metal2 VSS.$3929.Metal2 0.00118965f
Cred_21882 vin3.$639.Metal2 VSS.$3988.Metal2 0.0246652f
Cred_21883 vin3.$639.Metal2 VSS.$4020.Metal2 0.0174818f
Cred_21884 vin3.$639.Metal2 VSS.$5126.Metal3 9.53834e-06f
Cred_21885 vin3.$639.Metal2 VSS.$68.Metal1 3.0301e-06f
Cred_21886 vin3.$639.Metal2 VSS.P2.pSD 0.00787323f
Cred_21887 vin3.$639.Metal2 VSS.P67.nSD 0.000127662f
Cred_21888 vin3.$639.Metal2 VSS.P91.nSD 1.51156e-06f
Cred_21889 vin3.$64.GatPoly vout3.$1226.Metal3 0.00430056f
Cred_21890 vin3.$64.GatPoly vout3.$1292.Metal3 0.00446847f
Cred_21891 vin3.$64.GatPoly vout3.P4.nSD 5.23911e-07f
Cred_21892 vin3.$64.GatPoly vout3.P6.nSD 0.00598165f
Cred_21893 vin3.$64.GatPoly vout3.P6.pSD 0.000365466f
Cred_21894 vin3.$64.GatPoly vout3.P8.nSD 2.09838e-06f
Cred_21895 vin3.$64.GatPoly VSS.$1990.Metal1 7.44598e-06f
Cred_21896 vin3.$64.GatPoly VSS.$2914.Metal2 6.46511e-05f
Cred_21897 vin3.$64.GatPoly VSS.$2946.Metal2 2.45511e-06f
Cred_21898 vin3.$64.GatPoly VSS.$3085.Metal2 0.000270194f
Cred_21899 vin3.$64.GatPoly VSS.$68.Metal1 5.68224e-05f
Cred_21900 vin3.$64.GatPoly VSS.$744.Metal1 0.000154764f
Cred_21901 vin3.$64.GatPoly VSS.$923.Metal1 0.000634609f
Cred_21902 vin3.$64.GatPoly VSS.P2.pSD 0.00373171f
Cred_21903 vin3.$64.GatPoly VSS.P55.nSD 5.79149e-06f
Cred_21904 vin3.$64.GatPoly VSS.P57.nSD 2.37508e-05f
Cred_21905 vin3.$64.GatPoly VSS.P79.nSD 3.56811e-10f
Cred_21906 vin3.$640.Metal2 vout3 0.00144545f
Cred_21907 vin3.$640.Metal2 vout3.$1424.Metal3 0.0258238f
Cred_21908 vin3.$640.Metal2 vout3.P16.pSD 0.000359875f
Cred_21909 vin3.$640.Metal2 vout3.P18.nSD 0.000114848f
Cred_21910 vin3.$640.Metal2 vout3.P18.pSD 0.000882401f
Cred_21911 vin3.$642.Metal2 vout3 0.0213667f
Cred_21912 vin3.$642.Metal2 vout3.$1424.Metal3 0.169808f
Cred_21913 vin3.$642.Metal2 vout3.P16.nSD 2.07511e-05f
Cred_21914 vin3.$642.Metal2 vout3.P16.pSD 0.000104096f
Cred_21915 vin3.$642.Metal2 vout3.P18.nSD 0.00209609f
Cred_21916 vin3.$642.Metal2 vout3.P18.pSD 0.00968299f
Cred_21917 vin3.$642.Metal2 VSS.$1799.Metal1 0.000448976f
Cred_21918 vin3.$642.Metal2 VSS.$1990.Metal1 0.00824013f
Cred_21919 vin3.$642.Metal2 VSS.$3988.Metal2 0.0029713f
Cred_21920 vin3.$642.Metal2 VSS.$4020.Metal2 0.00221267f
Cred_21921 vin3.$642.Metal2 VSS.$68.Metal1 2.40937e-05f
Cred_21922 vin3.$642.Metal2 VSS.P2.pSD 0.0717515f
Cred_21923 vin3.$642.Metal2 VSS.P67.nSD 1.53963e-05f
Cred_21924 vin3.$642.Metal2 VSS.P91.nSD 1.91318e-07f
Cred_21925 vin3.$644.Metal2 vout3 0.0023875f
Cred_21926 vin3.$644.Metal2 vout3.$1424.Metal3 0.0213719f
Cred_21927 vin3.$644.Metal2 vout3.P16.nSD 5.34229e-05f
Cred_21928 vin3.$644.Metal2 vout3.P18.nSD 0.000222834f
Cred_21929 vin3.$644.Metal2 vout3.P18.pSD 0.00102742f
Cred_21930 vin3.$644.Metal2 VSS.$1799.Metal1 0.00303595f
Cred_21931 vin3.$644.Metal2 VSS.$1864.Metal1 9.77308e-06f
Cred_21932 vin3.$644.Metal2 VSS.$1884.Metal1 7.41063e-06f
Cred_21933 vin3.$644.Metal2 VSS.$1990.Metal1 0.000566846f
Cred_21934 vin3.$644.Metal2 VSS.$3988.Metal2 0.0191202f
Cred_21935 vin3.$644.Metal2 VSS.$4020.Metal2 0.0154724f
Cred_21936 vin3.$644.Metal2 VSS.$4068.Metal2 0.00123397f
Cred_21937 vin3.$644.Metal2 VSS.$5162.Metal3 9.89367e-06f
Cred_21938 vin3.$644.Metal2 VSS.$68.Metal1 1.89929e-06f
Cred_21939 vin3.$644.Metal2 VSS.P2.pSD 0.00546856f
Cred_21940 vin3.$644.Metal2 VSS.P67.nSD 0.000104727f
Cred_21941 vin3.$644.Metal2 VSS.P91.nSD 1.23112e-06f
Cred_21942 vin3.$645.Metal2 vout3 0.00236295f
Cred_21943 vin3.$645.Metal2 vout3.$1424.Metal3 0.0200647f
Cred_21944 vin3.$645.Metal2 vout3.P16.pSD 0.000267992f
Cred_21945 vin3.$645.Metal2 vout3.P18.nSD 0.000187749f
Cred_21946 vin3.$645.Metal2 vout3.P18.pSD 0.00121076f
Cred_21947 vin3.$648.Metal2 vout3 0.00799174f
Cred_21948 vin3.$648.Metal2 vout3.$1424.Metal3 0.0403062f
Cred_21949 vin3.$648.Metal2 vout3.P18.nSD 0.00697683f
Cred_21950 vin3.$648.Metal2 vout3.P18.pSD 0.00346657f
Cred_21951 vin3.$648.Metal2 VSS.$1799.Metal1 8.23052e-06f
Cred_21952 vin3.$648.Metal2 VSS.$1864.Metal1 3.12966e-06f
Cred_21953 vin3.$648.Metal2 VSS.$1884.Metal1 7.41051e-06f
Cred_21954 vin3.$648.Metal2 VSS.$1952.Metal1 2.6659e-05f
Cred_21955 vin3.$648.Metal2 VSS.$1990.Metal1 0.00108749f
Cred_21956 vin3.$648.Metal2 VSS.$2022.Metal1 1.83151e-05f
Cred_21957 vin3.$648.Metal2 VSS.$3988.Metal2 4.23036e-07f
Cred_21958 vin3.$648.Metal2 VSS.$4020.Metal2 0.00123426f
Cred_21959 vin3.$648.Metal2 VSS.$4068.Metal2 0.00280513f
Cred_21960 vin3.$648.Metal2 VSS.$4116.Metal2 1.09942e-06f
Cred_21961 vin3.$648.Metal2 VSS.$4174.Metal2 4.51447e-07f
Cred_21962 vin3.$648.Metal2 VSS.$5162.Metal3 9.89351e-06f
Cred_21963 vin3.$648.Metal2 VSS.$68.Metal1 2.02308e-06f
Cred_21964 vin3.$648.Metal2 VSS.P2.pSD 0.00739439f
Cred_21965 vin3.$648.Metal2 VSS.P5.GatPoly 3.41867e-05f
Cred_21966 vin3.$648.Metal2 VSS.P67.nSD 3.1529e-07f
Cred_21967 vin3.$648.Metal2 VSS.P69.nSD 1.26489e-07f
Cred_21968 vin3.$648.Metal2 VSS.P71.nSD 1.26489e-07f
Cred_21969 vin3.$648.Metal2 VSS.P91.nSD 2.72387e-11f
Cred_21970 vin3.$649.Metal2 vout3 0.00747504f
Cred_21971 vin3.$649.Metal2 vout3.$1424.Metal3 0.0377002f
Cred_21972 vin3.$649.Metal2 vout3.P18.nSD 0.000615456f
Cred_21973 vin3.$649.Metal2 vout3.P18.pSD 0.0118701f
Cred_21974 vin3.$649.Metal2 VSS.$1990.Metal1 0.000199873f
Cred_21975 vin3.$649.Metal2 VSS.$4140.Metal2 2.05108e-05f
Cred_21976 vin3.$649.Metal2 VSS.$68.Metal1 3.36511e-07f
Cred_21977 vin3.$649.Metal2 VSS.P2.pSD 0.00127757f
Cred_21978 vin3.$65.GatPoly vout3.$1226.Metal3 0.012872f
Cred_21979 vin3.$65.GatPoly vout3.$1292.Metal3 0.0146682f
Cred_21980 vin3.$65.GatPoly vout3.P6.nSD 0.000202787f
Cred_21981 vin3.$65.GatPoly vout3.P6.pSD 0.0198092f
Cred_21982 vin3.$65.GatPoly vout3.P8.pSD 0.000126207f
Cred_21983 vin3.$653.Metal2 vout3 0.0195798f
Cred_21984 vin3.$653.Metal2 vout3.$1424.Metal3 0.0987504f
Cred_21985 vin3.$653.Metal2 vout3.P18.nSD 0.0167257f
Cred_21986 vin3.$653.Metal2 vout3.P18.pSD 0.00853083f
Cred_21987 vin3.$653.Metal2 VSS.$1952.Metal1 0.000146429f
Cred_21988 vin3.$653.Metal2 VSS.$1990.Metal1 0.0033904f
Cred_21989 vin3.$653.Metal2 VSS.$2022.Metal1 9.47858e-05f
Cred_21990 vin3.$653.Metal2 VSS.$4116.Metal2 0.00327421f
Cred_21991 vin3.$653.Metal2 VSS.$4174.Metal2 2.33636e-06f
Cred_21992 vin3.$653.Metal2 VSS.$68.Metal1 5.09583e-06f
Cred_21993 vin3.$653.Metal2 VSS.P2.pSD 0.020386f
Cred_21994 vin3.$653.Metal2 VSS.P5.GatPoly 0.000176926f
Cred_21995 vin3.$653.Metal2 VSS.P69.nSD 6.54617e-07f
Cred_21996 vin3.$653.Metal2 VSS.P71.nSD 6.54617e-07f
Cred_21997 vin3.$654.Metal2 vout3 0.0182745f
Cred_21998 vin3.$654.Metal2 vout3.$1424.Metal3 0.0921671f
Cred_21999 vin3.$654.Metal2 vout3.P18.nSD 0.00153431f
Cred_22000 vin3.$654.Metal2 vout3.P18.pSD 0.0289679f
Cred_22001 vin3.$654.Metal2 VSS.$1990.Metal1 0.000764219f
Cred_22002 vin3.$654.Metal2 VSS.$4140.Metal2 0.000101763f
Cred_22003 vin3.$654.Metal2 VSS.$68.Metal1 1.28666e-06f
Cred_22004 vin3.$654.Metal2 VSS.P2.pSD 0.00488482f
Cred_22005 vin3.$70.GatPoly vout3.$1226.Metal3 0.00101616f
Cred_22006 vin3.$70.GatPoly vout3.$1292.Metal3 0.00154863f
Cred_22007 vin3.$70.GatPoly vout3.P6.nSD 0.000877937f
Cred_22008 vin3.$70.GatPoly vout3.P6.pSD 8.74912e-05f
Cred_22009 vin3.$70.GatPoly vout3.P8.nSD 4.99287e-06f
Cred_22010 vin3.$70.GatPoly VSS.$1990.Metal1 8.34319e-06f
Cred_22011 vin3.$70.GatPoly VSS.$3042.Metal2 6.68699e-08f
Cred_22012 vin3.$70.GatPoly VSS.$3085.Metal2 0.00102568f
Cred_22013 vin3.$70.GatPoly VSS.$68.Metal1 4.07451e-05f
Cred_22014 vin3.$70.GatPoly VSS.$905.Metal1 8.41646e-06f
Cred_22015 vin3.$70.GatPoly VSS.$923.Metal1 0.00839157f
Cred_22016 vin3.$70.GatPoly VSS.P2.pSD 0.00335249f
Cred_22017 vin3.$70.GatPoly VSS.P57.nSD 0.000219307f
Cred_22018 vin3.$73.GatPoly vout3.$1226.Metal3 0.00583736f
Cred_22019 vin3.$73.GatPoly vout3.$1292.Metal3 0.00722747f
Cred_22020 vin3.$73.GatPoly vout3.P6.nSD 9.19621e-05f
Cred_22021 vin3.$73.GatPoly vout3.P6.pSD 0.00810359f
Cred_22022 vin3.$73.GatPoly vout3.P8.pSD 9.76778e-05f
Cred_22023 vin3.$77.GatPoly vout3.$1226.Metal3 0.00277707f
Cred_22024 vin3.$77.GatPoly vout3.$1292.Metal3 0.0545756f
Cred_22025 vin3.$77.GatPoly vout3.P6.nSD 4.37501e-05f
Cred_22026 vin3.$77.GatPoly vout3.P6.pSD 0.00064954f
Cred_22027 vin3.$77.GatPoly vout3.P8.pSD 0.0321726f
Cred_22028 vin3.$78.GatPoly vout3.$1226.Metal3 0.000284706f
Cred_22029 vin3.$78.GatPoly vout3.$1292.Metal3 0.00270625f
Cred_22030 vin3.$78.GatPoly vout3.P6.nSD 1.00965e-05f
Cred_22031 vin3.$78.GatPoly vout3.P6.pSD 2.4513e-05f
Cred_22032 vin3.$78.GatPoly vout3.P8.nSD 0.00100732f
Cred_22033 vin3.$78.GatPoly VSS.$1024.Metal1 2.6329e-07f
Cred_22034 vin3.$78.GatPoly VSS.$1990.Metal1 8.70948e-06f
Cred_22035 vin3.$78.GatPoly VSS.$3085.Metal2 0.00105531f
Cred_22036 vin3.$78.GatPoly VSS.$3157.Metal2 1.47491e-09f
Cred_22037 vin3.$78.GatPoly VSS.$68.Metal1 2.9206e-05f
Cred_22038 vin3.$78.GatPoly VSS.$923.Metal1 0.00746252f
Cred_22039 vin3.$78.GatPoly VSS.$996.Metal1 1.29476e-05f
Cred_22040 vin3.$78.GatPoly VSS.P2.pSD 0.00290496f
Cred_22041 vin3.$78.GatPoly VSS.P3.pSD 1.61072e-10f
Cred_22042 vin3.$78.GatPoly VSS.P57.nSD 0.000201959f
Cred_22043 vin3.$80.GatPoly vout3.$1226.Metal3 0.000199294f
Cred_22044 vin3.$80.GatPoly vout3.$1292.Metal3 0.00189437f
Cred_22045 vin3.$80.GatPoly vout3.P6.nSD 7.06754e-06f
Cred_22046 vin3.$80.GatPoly vout3.P6.pSD 1.71591e-05f
Cred_22047 vin3.$80.GatPoly vout3.P8.nSD 0.000705121f
Cred_22048 vin3.$80.GatPoly VSS.$1024.Metal1 5.3362e-07f
Cred_22049 vin3.$80.GatPoly VSS.$1990.Metal1 5.84669e-06f
Cred_22050 vin3.$80.GatPoly VSS.$3085.Metal2 0.00051197f
Cred_22051 vin3.$80.GatPoly VSS.$3157.Metal2 2.98926e-09f
Cred_22052 vin3.$80.GatPoly VSS.$68.Metal1 1.52101e-05f
Cred_22053 vin3.$80.GatPoly VSS.$923.Metal1 0.0011921f
Cred_22054 vin3.$80.GatPoly VSS.$996.Metal1 1.40225e-06f
Cred_22055 vin3.$80.GatPoly VSS.P2.pSD 0.00172124f
Cred_22056 vin3.$80.GatPoly VSS.P3.pSD 3.2645e-10f
Cred_22057 vin3.$80.GatPoly VSS.P57.nSD 4.46145e-05f
Cred_22058 vin3.$82.GatPoly vout3.$1292.Metal3 0.00728129f
Cred_22059 vin3.$82.GatPoly vout3.$1358.Metal3 4.09926e-05f
Cred_22060 vin3.$82.GatPoly vout3.P10.nSD 1.45342e-06f
Cred_22061 vin3.$82.GatPoly vout3.P10.pSD 3.49769e-06f
Cred_22062 vin3.$82.GatPoly vout3.P8.nSD 0.00574639f
Cred_22063 vin3.$82.GatPoly VSS 0.000249314f
Cred_22064 vin3.$82.GatPoly VSS.$1990.Metal1 1.38781e-05f
Cred_22065 vin3.$82.GatPoly VSS.$3260.Metal2 5.25068e-05f
Cred_22066 vin3.$82.GatPoly VSS.$3292.Metal2 5.25068e-05f
Cred_22067 vin3.$82.GatPoly VSS.$68.Metal1 2.83194e-05f
Cred_22068 vin3.$82.GatPoly VSS.P2.pSD 0.00361328f
Cred_22069 vin3.$82.GatPoly VSS.P59.nSD 9.32633e-06f
Cred_22070 vin3.$82.GatPoly VSS.P83.nSD 3.96041e-09f
Cred_22071 vin3.$83.GatPoly vout3.$1292.Metal3 0.0109782f
Cred_22072 vin3.$83.GatPoly vout3.P8.pSD 0.0092696f
Cred_22073 vin3.$87.GatPoly vout3.$1292.Metal3 0.0565322f
Cred_22074 vin3.$87.GatPoly vout3.$1358.Metal3 0.00285379f
Cred_22075 vin3.$87.GatPoly vout3.P10.nSD 4.49588e-05f
Cred_22076 vin3.$87.GatPoly vout3.P10.pSD 0.000699669f
Cred_22077 vin3.$87.GatPoly vout3.P8.pSD 0.0335743f
Cred_22078 vin3.$9.GatPoly vout3.$1226.Metal3 0.0447789f
Cred_22079 vin3.$9.GatPoly vout3.P0.nSD 0.00125946f
Cred_22080 vin3.$9.GatPoly vout3.P0.pSD 0.041632f
Cred_22081 vin3.$9.GatPoly vout3.P2.nSD 0.00070545f
Cred_22082 vin3.$9.GatPoly vout3.P2.pSD 0.00425851f
Cred_22083 vin3.$9.GatPoly VSS.$1990.Metal1 3.56306e-09f
Cred_22084 vin3.$9.GatPoly VSS.$2409.Metal2 1.21987e-06f
Cred_22085 vin3.$9.GatPoly VSS.$2433.Metal2 8.94547e-07f
Cred_22086 vin3.$9.GatPoly VSS.$4418.Metal3 0.000152145f
Cred_22087 vin3.$9.GatPoly VSS.$4454.Metal3 0.00011157f
Cred_22088 vin3.$9.GatPoly VSS.$68.Metal1 7.61602e-06f
Cred_22089 vin3.$9.GatPoly VSS.P2.pSD 2.30909e-05f
Cred_22090 vin3.$9.GatPoly VSS.P4.GatPoly 1.62293e-06f
Cred_22091 vin3.$90.GatPoly vout3.$1292.Metal3 0.00338463f
Cred_22092 vin3.$90.GatPoly vout3.$1358.Metal3 0.000300258f
Cred_22093 vin3.$90.GatPoly vout3.P10.nSD 1.06458e-05f
Cred_22094 vin3.$90.GatPoly vout3.P10.pSD 2.56195e-05f
Cred_22095 vin3.$90.GatPoly vout3.P8.nSD 0.00147864f
Cred_22096 vin3.$90.GatPoly VSS 0.00492823f
Cred_22097 vin3.$90.GatPoly VSS.$1064.Metal1 1.39888e-10f
Cred_22098 vin3.$90.GatPoly VSS.$1084.Metal1 0.00056091f
Cred_22099 vin3.$90.GatPoly VSS.$1990.Metal1 1.56901e-05f
Cred_22100 vin3.$90.GatPoly VSS.$3205.Metal2 9.13599e-08f
Cred_22101 vin3.$90.GatPoly VSS.$3260.Metal2 0.000486203f
Cred_22102 vin3.$90.GatPoly VSS.$3292.Metal2 0.000482253f
Cred_22103 vin3.$90.GatPoly VSS.$4802.Metal3 7.32503e-10f
Cred_22104 vin3.$90.GatPoly VSS.$68.Metal1 2.08596e-05f
Cred_22105 vin3.$90.GatPoly VSS.P2.pSD 0.00329186f
Cred_22106 vin3.$90.GatPoly VSS.P3.pSD 3.35488e-07f
Cred_22107 vin3.$90.GatPoly VSS.P59.nSD 0.000151821f
Cred_22108 vin3.$90.GatPoly VSS.P83.nSD 3.63747e-08f
Cred_22109 vin3.$94.GatPoly vout3.$1292.Metal3 0.000500257f
Cred_22110 vin3.$94.GatPoly vout3.$1358.Metal3 0.000329284f
Cred_22111 vin3.$94.GatPoly vout3.P10.nSD 0.000288881f
Cred_22112 vin3.$94.GatPoly vout3.P10.pSD 2.80962e-05f
Cred_22113 vin3.$94.GatPoly vout3.P8.nSD 1.60319e-06f
Cred_22114 vin3.$94.GatPoly VSS 0.0115635f
Cred_22115 vin3.$94.GatPoly VSS.$1084.Metal1 0.00054898f
Cred_22116 vin3.$94.GatPoly VSS.$1160.Metal1 0.00138831f
Cred_22117 vin3.$94.GatPoly VSS.$1990.Metal1 1.95211e-05f
Cred_22118 vin3.$94.GatPoly VSS.$3260.Metal2 0.000458167f
Cred_22119 vin3.$94.GatPoly VSS.$3292.Metal2 0.000464066f
Cred_22120 vin3.$94.GatPoly VSS.$68.Metal1 1.78712e-05f
Cred_22121 vin3.$94.GatPoly VSS.P2.pSD 0.0033997f
Cred_22122 vin3.$94.GatPoly VSS.P3.pSD 1.1839e-06f
Cred_22123 vin3.$94.GatPoly VSS.P59.nSD 0.000317921f
Cred_22124 vin3.$94.GatPoly VSS.P83.nSD 3.42669e-08f
Cred_22125 vin3.$97.GatPoly vout3.$1292.Metal3 0.0312837f
Cred_22126 vin3.$97.GatPoly vout3.$1358.Metal3 0.0254406f
Cred_22127 vin3.$97.GatPoly vout3.P10.nSD 0.000400792f
Cred_22128 vin3.$97.GatPoly vout3.P10.pSD 0.0365361f
Cred_22129 vin3.$97.GatPoly vout3.P8.pSD 0.000410777f
Cred_22130 vin3.P0.GatPoly vout3.$1226.Metal3 0.0351932f
Cred_22131 vin3.P0.GatPoly vout3.P0.nSD 0.0265081f
Cred_22132 vin3.P0.GatPoly vout3.P0.pSD 0.00556858f
Cred_22133 vin3.P0.GatPoly vout3.P2.nSD 0.000554435f
Cred_22134 vin3.P0.GatPoly vout3.P2.pSD 0.00303011f
Cred_22135 vin3.P0.GatPoly VSS.$159.Metal1 0.0461221f
Cred_22136 vin3.P0.GatPoly VSS.$1990.Metal1 2.39485e-06f
Cred_22137 vin3.P0.GatPoly VSS.$2238.Metal2 0.0132569f
Cred_22138 vin3.P0.GatPoly VSS.$2409.Metal2 0.00526351f
Cred_22139 vin3.P0.GatPoly VSS.$2433.Metal2 0.00416049f
Cred_22140 vin3.P0.GatPoly VSS.$2532.Metal2 0.000585659f
Cred_22141 vin3.P0.GatPoly VSS.$2564.Metal2 0.000786456f
Cred_22142 vin3.P0.GatPoly VSS.$292.Metal1 0.0110655f
Cred_22143 vin3.P0.GatPoly VSS.$312.Metal1 0.00565657f
Cred_22144 vin3.P0.GatPoly VSS.$386.Metal1 0.000103919f
Cred_22145 vin3.P0.GatPoly VSS.$4358.Metal3 1.80589e-05f
Cred_22146 vin3.P0.GatPoly VSS.$4418.Metal3 0.00347266f
Cred_22147 vin3.P0.GatPoly VSS.$4454.Metal3 0.00276441f
Cred_22148 vin3.P0.GatPoly VSS.$68.Metal1 0.0061425f
Cred_22149 vin3.P0.GatPoly VSS.P2.pSD 0.0107995f
Cred_22150 vin3.P0.GatPoly VSS.P3.pSD 1.68643e-06f
Cred_22151 vin3.P0.GatPoly VSS.P4.GatPoly 0.0188624f
Cred_22152 vin3.P0.GatPoly VSS.P48.nSD 0.000218585f
Cred_22153 vin3.P0.GatPoly VSS.P49.nSD 0.000218585f
Cred_22154 vin3.P0.GatPoly VSS.P51.nSD 3.51533e-06f
Cred_22155 vin3.P0.GatPoly VSS.P75.nSD 5.06388e-08f
Cred_22156 vin3.P1.GatPoly vout3.$1226.Metal3 0.0367128f
Cred_22157 vin3.P1.GatPoly vout3.P0.nSD 0.0231313f
Cred_22158 vin3.P1.GatPoly vout3.P0.pSD 0.00555071f
Cred_22159 vin3.P1.GatPoly vout3.P2.nSD 0.000617178f
Cred_22160 vin3.P1.GatPoly vout3.P2.pSD 0.00316095f
Cred_22161 vin3.P1.GatPoly VSS.$1990.Metal1 1.91358e-07f
Cred_22162 vin3.P1.GatPoly VSS.$2481.Metal2 0.00555605f
Cred_22163 vin3.P1.GatPoly VSS.$2532.Metal2 0.0100554f
Cred_22164 vin3.P1.GatPoly VSS.$2564.Metal2 0.00805698f
Cred_22165 vin3.P1.GatPoly VSS.$332.Metal1 0.00288352f
Cred_22166 vin3.P1.GatPoly VSS.$360.Metal1 0.0119698f
Cred_22167 vin3.P1.GatPoly VSS.$380.Metal1 0.00398334f
Cred_22168 vin3.P1.GatPoly VSS.$386.Metal1 0.0578336f
Cred_22169 vin3.P1.GatPoly VSS.$4478.Metal3 0.00390771f
Cred_22170 vin3.P1.GatPoly VSS.$68.Metal1 7.16041e-05f
Cred_22171 vin3.P1.GatPoly VSS.P2.pSD 0.000617818f
Cred_22172 vin3.P1.GatPoly VSS.P3.pSD 1.76215e-06f
Cred_22173 vin3.P1.GatPoly VSS.P51.nSD 0.00177164f
Cred_22174 vin3.P1.GatPoly VSS.P75.nSD 5.18777e-07f
Cred_22175 vin3.P10.GatPoly vout3.$1292.Metal3 0.023736f
Cred_22176 vin3.P10.GatPoly vout3.$1358.Metal3 0.0201678f
Cred_22177 vin3.P10.GatPoly vout3.P10.nSD 0.0214537f
Cred_22178 vin3.P10.GatPoly vout3.P10.pSD 0.00172082f
Cred_22179 vin3.P10.GatPoly vout3.P8.nSD 3.66983e-05f
Cred_22180 vin3.P10.GatPoly VSS 0.0540698f
Cred_22181 vin3.P10.GatPoly VSS.$1160.Metal1 0.00991321f
Cred_22182 vin3.P10.GatPoly VSS.$1180.Metal1 0.00847338f
Cred_22183 vin3.P10.GatPoly VSS.$1200.Metal1 0.00137957f
Cred_22184 vin3.P10.GatPoly VSS.$1266.Metal1 8.80351e-05f
Cred_22185 vin3.P10.GatPoly VSS.$1990.Metal1 2.15699e-06f
Cred_22186 vin3.P10.GatPoly VSS.$3260.Metal2 0.00684661f
Cred_22187 vin3.P10.GatPoly VSS.$3292.Metal2 0.00966915f
Cred_22188 vin3.P10.GatPoly VSS.$3344.Metal2 0.00595581f
Cred_22189 vin3.P10.GatPoly VSS.$3435.Metal2 0.00119903f
Cred_22190 vin3.P10.GatPoly VSS.$4838.Metal3 0.0039077f
Cred_22191 vin3.P10.GatPoly VSS.$68.Metal1 1.63916e-06f
Cred_22192 vin3.P10.GatPoly VSS.P2.pSD 0.000343889f
Cred_22193 vin3.P10.GatPoly VSS.P3.pSD 9.41436e-07f
Cred_22194 vin3.P10.GatPoly VSS.P59.nSD 0.00168323f
Cred_22195 vin3.P10.GatPoly VSS.P61.nSD 3.02093e-06f
Cred_22196 vin3.P10.GatPoly VSS.P83.nSD 5.16416e-07f
Cred_22197 vin3.P11.GatPoly vout3.$1292.Metal3 0.0201189f
Cred_22198 vin3.P11.GatPoly vout3.$1358.Metal3 0.0235822f
Cred_22199 vin3.P11.GatPoly vout3.P10.nSD 0.0215498f
Cred_22200 vin3.P11.GatPoly vout3.P10.pSD 0.00171665f
Cred_22201 vin3.P11.GatPoly vout3.P12.nSD 3.57144e-05f
Cred_22202 vin3.P11.GatPoly VSS 9.06646e-05f
Cred_22203 vin3.P11.GatPoly VSS.$1220.Metal1 0.00528126f
Cred_22204 vin3.P11.GatPoly VSS.$1260.Metal1 0.0124547f
Cred_22205 vin3.P11.GatPoly VSS.$1266.Metal1 0.0518586f
Cred_22206 vin3.P11.GatPoly VSS.$1279.Metal1 4.6155e-05f
Cred_22207 vin3.P11.GatPoly VSS.$3260.Metal2 0.000598157f
Cred_22208 vin3.P11.GatPoly VSS.$3292.Metal2 0.000598157f
Cred_22209 vin3.P11.GatPoly VSS.$3392.Metal2 0.00702415f
Cred_22210 vin3.P11.GatPoly VSS.$3435.Metal2 0.0133641f
Cred_22211 vin3.P11.GatPoly VSS.$3451.Metal2 0.00246723f
Cred_22212 vin3.P11.GatPoly VSS.$4862.Metal3 0.00093661f
Cred_22213 vin3.P11.GatPoly VSS.$4886.Metal3 0.00436081f
Cred_22214 vin3.P11.GatPoly VSS.P2.pSD 2.79537e-06f
Cred_22215 vin3.P11.GatPoly VSS.P3.pSD 2.79537e-06f
Cred_22216 vin3.P11.GatPoly VSS.P59.nSD 3.06604e-06f
Cred_22217 vin3.P11.GatPoly VSS.P61.nSD 0.00157447f
Cred_22218 vin3.P11.GatPoly VSS.P83.nSD 4.51169e-08f
Cred_22219 vin3.P12.GatPoly vout3.$1292.Metal3 0.00172617f
Cred_22220 vin3.P12.GatPoly vout3.$1358.Metal3 0.0443094f
Cred_22221 vin3.P12.GatPoly vout3.P10.nSD 6.44422e-05f
Cred_22222 vin3.P12.GatPoly vout3.P10.pSD 0.000147285f
Cred_22223 vin3.P12.GatPoly vout3.P12.nSD 0.0212036f
Cred_22224 vin3.P12.GatPoly VSS.$1266.Metal1 0.0515226f
Cred_22225 vin3.P12.GatPoly VSS.$1311.Metal1 0.00100572f
Cred_22226 vin3.P12.GatPoly VSS.$1339.Metal1 0.00769148f
Cred_22227 vin3.P12.GatPoly VSS.$1359.Metal1 0.00913213f
Cred_22228 vin3.P12.GatPoly VSS.$1379.Metal1 0.00235249f
Cred_22229 vin3.P12.GatPoly VSS.$1445.Metal1 8.84065e-05f
Cred_22230 vin3.P12.GatPoly VSS.$1990.Metal1 5.95569e-06f
Cred_22231 vin3.P12.GatPoly VSS.$3435.Metal2 0.014844f
Cred_22232 vin3.P12.GatPoly VSS.$3507.Metal2 0.00792992f
Cred_22233 vin3.P12.GatPoly VSS.$3555.Metal2 0.00123086f
Cred_22234 vin3.P12.GatPoly VSS.$3603.Metal2 4.3853e-05f
Cred_22235 vin3.P12.GatPoly VSS.$3638.Metal2 0.0011548f
Cred_22236 vin3.P12.GatPoly VSS.$4910.Metal3 0.00331224f
Cred_22237 vin3.P12.GatPoly VSS.$4934.Metal3 0.00174233f
Cred_22238 vin3.P12.GatPoly VSS.$68.Metal1 9.75091e-07f
Cred_22239 vin3.P12.GatPoly VSS.P2.pSD 0.000438819f
Cred_22240 vin3.P12.GatPoly VSS.P61.nSD 0.00157838f
Cred_22241 vin3.P12.GatPoly VSS.P63.nSD 3.0273e-06f
Cred_22242 vin3.P12.GatPoly VSS.P87.nSD 6.37334e-09f
Cred_22243 vin3.P13.GatPoly vout3.$1358.Metal3 0.0441012f
Cred_22244 vin3.P13.GatPoly vout3.$1424.Metal3 0.00165462f
Cred_22245 vin3.P13.GatPoly vout3.P12.nSD 0.0213646f
Cred_22246 vin3.P13.GatPoly vout3.P14.nSD 6.19055e-05f
Cred_22247 vin3.P13.GatPoly vout3.P14.pSD 0.000141181f
Cred_22248 vin3.P13.GatPoly VSS.$1266.Metal1 8.80351e-05f
Cred_22249 vin3.P13.GatPoly VSS.$1379.Metal1 0.000779039f
Cred_22250 vin3.P13.GatPoly VSS.$1407.Metal1 0.00867663f
Cred_22251 vin3.P13.GatPoly VSS.$1427.Metal1 0.0085415f
Cred_22252 vin3.P13.GatPoly VSS.$1445.Metal1 0.0522293f
Cred_22253 vin3.P13.GatPoly VSS.$1990.Metal1 7.30198e-06f
Cred_22254 vin3.P13.GatPoly VSS.$3435.Metal2 0.00119903f
Cred_22255 vin3.P13.GatPoly VSS.$3555.Metal2 0.00281776f
Cred_22256 vin3.P13.GatPoly VSS.$3603.Metal2 0.00677301f
Cred_22257 vin3.P13.GatPoly VSS.$3638.Metal2 0.0128825f
Cred_22258 vin3.P13.GatPoly VSS.$4958.Metal3 0.00440935f
Cred_22259 vin3.P13.GatPoly VSS.$4994.Metal3 0.000775961f
Cred_22260 vin3.P13.GatPoly VSS.$68.Metal1 7.6038e-07f
Cred_22261 vin3.P13.GatPoly VSS.P2.pSD 0.000428302f
Cred_22262 vin3.P13.GatPoly VSS.P3.pSD 7.31944e-07f
Cred_22263 vin3.P13.GatPoly VSS.P61.nSD 3.02093e-06f
Cred_22264 vin3.P13.GatPoly VSS.P63.nSD 0.00157393f
Cred_22265 vin3.P13.GatPoly VSS.P87.nSD 7.10643e-08f
Cred_22266 vin3.P14.GatPoly vout3.$1358.Metal3 0.0222288f
Cred_22267 vin3.P14.GatPoly vout3.$1424.Metal3 0.0191762f
Cred_22268 vin3.P14.GatPoly vout3.P12.nSD 3.18635e-05f
Cred_22269 vin3.P14.GatPoly vout3.P14.nSD 0.0205849f
Cred_22270 vin3.P14.GatPoly vout3.P14.pSD 0.00163622f
Cred_22271 vin3.P14.GatPoly VSS.$1445.Metal1 0.0506574f
Cred_22272 vin3.P14.GatPoly VSS.$1490.Metal1 0.000343182f
Cred_22273 vin3.P14.GatPoly VSS.$1518.Metal1 0.0108588f
Cred_22274 vin3.P14.GatPoly VSS.$1546.Metal1 0.00696281f
Cred_22275 vin3.P14.GatPoly VSS.$1566.Metal1 0.000380545f
Cred_22276 vin3.P14.GatPoly VSS.$1624.Metal1 8.80351e-05f
Cred_22277 vin3.P14.GatPoly VSS.$3603.Metal2 0.000471281f
Cred_22278 vin3.P14.GatPoly VSS.$3638.Metal2 0.0143303f
Cred_22279 vin3.P14.GatPoly VSS.$3694.Metal2 0.00748984f
Cred_22280 vin3.P14.GatPoly VSS.$3718.Metal2 8.69857e-06f
Cred_22281 vin3.P14.GatPoly VSS.$3809.Metal2 0.00119903f
Cred_22282 vin3.P14.GatPoly VSS.$4994.Metal3 0.00443521f
Cred_22283 vin3.P14.GatPoly VSS.$5030.Metal3 0.000848036f
Cred_22284 vin3.P14.GatPoly VSS.P2.pSD 2.68972e-06f
Cred_22285 vin3.P14.GatPoly VSS.P3.pSD 2.68972e-06f
Cred_22286 vin3.P14.GatPoly VSS.P63.nSD 0.00154084f
Cred_22287 vin3.P14.GatPoly VSS.P65.nSD 3.02093e-06f
Cred_22288 vin3.P14.GatPoly VSS.P87.nSD 6.84932e-08f
Cred_22289 vin3.P15.GatPoly vout3.$1358.Metal3 0.0209365f
Cred_22290 vin3.P15.GatPoly vout3.$1424.Metal3 0.0246698f
Cred_22291 vin3.P15.GatPoly vout3.P14.nSD 0.0225422f
Cred_22292 vin3.P15.GatPoly vout3.P14.pSD 0.00178641f
Cred_22293 vin3.P15.GatPoly vout3.P16.nSD 3.82463e-05f
Cred_22294 vin3.P15.GatPoly VSS.$1445.Metal1 8.84065e-05f
Cred_22295 vin3.P15.GatPoly VSS.$1566.Metal1 0.00153789f
Cred_22296 vin3.P15.GatPoly VSS.$1586.Metal1 0.00744981f
Cred_22297 vin3.P15.GatPoly VSS.$1606.Metal1 0.00868565f
Cred_22298 vin3.P15.GatPoly VSS.$1624.Metal1 0.051926f
Cred_22299 vin3.P15.GatPoly VSS.$1629.Metal1 0.00225715f
Cred_22300 vin3.P15.GatPoly VSS.$1990.Metal1 3.62944e-05f
Cred_22301 vin3.P15.GatPoly VSS.$3603.Metal2 4.3853e-05f
Cred_22302 vin3.P15.GatPoly VSS.$3638.Metal2 0.0011548f
Cred_22303 vin3.P15.GatPoly VSS.$3718.Metal2 0.00101102f
Cred_22304 vin3.P15.GatPoly VSS.$3766.Metal2 0.00748422f
Cred_22305 vin3.P15.GatPoly VSS.$3809.Metal2 0.0147845f
Cred_22306 vin3.P15.GatPoly VSS.$5030.Metal3 0.00186198f
Cred_22307 vin3.P15.GatPoly VSS.$5054.Metal3 0.00315449f
Cred_22308 vin3.P15.GatPoly VSS.$68.Metal1 8.10235e-07f
Cred_22309 vin3.P15.GatPoly VSS.P2.pSD 0.000966227f
Cred_22310 vin3.P15.GatPoly VSS.P63.nSD 3.0273e-06f
Cred_22311 vin3.P15.GatPoly VSS.P65.nSD 0.00158901f
Cred_22312 vin3.P15.GatPoly VSS.P87.nSD 6.37334e-09f
Cred_22313 vin3.P16.GatPoly vout3.$1358.Metal3 0.00145287f
Cred_22314 vin3.P16.GatPoly vout3.$1424.Metal3 0.0417745f
Cred_22315 vin3.P16.GatPoly vout3.P14.nSD 5.47521e-05f
Cred_22316 vin3.P16.GatPoly vout3.P14.pSD 0.000123966f
Cred_22317 vin3.P16.GatPoly vout3.P16.nSD 0.0203078f
Cred_22318 vin3.P16.GatPoly VSS.$1624.Metal1 0.0507781f
Cred_22319 vin3.P16.GatPoly VSS.$1685.Metal1 0.00592918f
Cred_22320 vin3.P16.GatPoly VSS.$1705.Metal1 0.00893219f
Cred_22321 vin3.P16.GatPoly VSS.$1725.Metal1 0.00380395f
Cred_22322 vin3.P16.GatPoly VSS.$1799.Metal1 9.06084e-05f
Cred_22323 vin3.P16.GatPoly VSS.$3809.Metal2 0.0128681f
Cred_22324 vin3.P16.GatPoly VSS.$3825.Metal2 0.0026751f
Cred_22325 vin3.P16.GatPoly VSS.$3881.Metal2 0.00685255f
Cred_22326 vin3.P16.GatPoly VSS.$3988.Metal2 0.000685726f
Cred_22327 vin3.P16.GatPoly VSS.$4020.Metal2 0.000510647f
Cred_22328 vin3.P16.GatPoly VSS.$5078.Metal3 0.00451617f
Cred_22329 vin3.P16.GatPoly VSS.$5102.Metal3 0.000799087f
Cred_22330 vin3.P16.GatPoly VSS.P65.nSD 0.00153329f
Cred_22331 vin3.P16.GatPoly VSS.P67.nSD 3.06508e-06f
Cred_22332 vin3.P16.GatPoly VSS.P91.nSD 4.41529e-08f
Cred_22333 vin3.P17.GatPoly vout3 0.0005655f
Cred_22334 vin3.P17.GatPoly vout3.$1424.Metal3 0.0463676f
Cred_22335 vin3.P17.GatPoly vout3.P16.nSD 0.0216974f
Cred_22336 vin3.P17.GatPoly vout3.P18.nSD 8.29213e-05f
Cred_22337 vin3.P17.GatPoly vout3.P18.pSD 0.000243355f
Cred_22338 vin3.P17.GatPoly VSS.$1624.Metal1 8.80351e-05f
Cred_22339 vin3.P17.GatPoly VSS.$1745.Metal1 0.00397253f
Cred_22340 vin3.P17.GatPoly VSS.$1773.Metal1 0.0122493f
Cred_22341 vin3.P17.GatPoly VSS.$1793.Metal1 0.00207842f
Cred_22342 vin3.P17.GatPoly VSS.$1799.Metal1 0.0530635f
Cred_22343 vin3.P17.GatPoly VSS.$1990.Metal1 7.51395e-05f
Cred_22344 vin3.P17.GatPoly VSS.$3809.Metal2 0.00119903f
Cred_22345 vin3.P17.GatPoly VSS.$3929.Metal2 0.00639424f
Cred_22346 vin3.P17.GatPoly VSS.$3988.Metal2 0.0106298f
Cred_22347 vin3.P17.GatPoly VSS.$4020.Metal2 0.00582239f
Cred_22348 vin3.P17.GatPoly VSS.$5102.Metal3 0.000595757f
Cred_22349 vin3.P17.GatPoly VSS.$5126.Metal3 0.00450346f
Cred_22350 vin3.P17.GatPoly VSS.$68.Metal1 4.21603e-07f
Cred_22351 vin3.P17.GatPoly VSS.P2.pSD 0.000969661f
Cred_22352 vin3.P17.GatPoly VSS.P3.pSD 2.26408e-06f
Cred_22353 vin3.P17.GatPoly VSS.P65.nSD 3.02093e-06f
Cred_22354 vin3.P17.GatPoly VSS.P67.nSD 0.00160903f
Cred_22355 vin3.P17.GatPoly VSS.P91.nSD 5.03431e-07f
Cred_22356 vin3.P18.GatPoly vout3 0.00663761f
Cred_22357 vin3.P18.GatPoly vout3.$1424.Metal3 0.0372692f
Cred_22358 vin3.P18.GatPoly vout3.P16.nSD 3.88024e-05f
Cred_22359 vin3.P18.GatPoly vout3.P18.nSD 0.0223709f
Cred_22360 vin3.P18.GatPoly vout3.P18.pSD 0.0028564f
Cred_22361 vin3.P18.GatPoly VSS.$1799.Metal1 0.0563753f
Cred_22362 vin3.P18.GatPoly VSS.$1864.Metal1 0.00398334f
Cred_22363 vin3.P18.GatPoly VSS.$1884.Metal1 0.0119698f
Cred_22364 vin3.P18.GatPoly VSS.$1912.Metal1 0.00288352f
Cred_22365 vin3.P18.GatPoly VSS.$1990.Metal1 7.16041e-05f
Cred_22366 vin3.P18.GatPoly VSS.$3988.Metal2 0.0079941f
Cred_22367 vin3.P18.GatPoly VSS.$4020.Metal2 0.0100086f
Cred_22368 vin3.P18.GatPoly VSS.$4068.Metal2 0.00555605f
Cred_22369 vin3.P18.GatPoly VSS.$5162.Metal3 0.00390771f
Cred_22370 vin3.P18.GatPoly VSS.$68.Metal1 1.91358e-07f
Cred_22371 vin3.P18.GatPoly VSS.P2.pSD 0.000617818f
Cred_22372 vin3.P18.GatPoly VSS.P3.pSD 1.76215e-06f
Cred_22373 vin3.P18.GatPoly VSS.P67.nSD 0.00172612f
Cred_22374 vin3.P18.GatPoly VSS.P91.nSD 5.14728e-07f
Cred_22375 vin3.P19.GatPoly vout3 0.00823235f
Cred_22376 vin3.P19.GatPoly vout3.$1424.Metal3 0.0415197f
Cred_22377 vin3.P19.GatPoly vout3.P18.nSD 0.0258089f
Cred_22378 vin3.P19.GatPoly vout3.P18.pSD 0.00354267f
Cred_22379 vin3.P19.GatPoly VSS.$1799.Metal1 0.000103919f
Cred_22380 vin3.P19.GatPoly VSS.$1932.Metal1 0.00590746f
Cred_22381 vin3.P19.GatPoly VSS.$1952.Metal1 0.0114087f
Cred_22382 vin3.P19.GatPoly VSS.$1990.Metal1 0.00613453f
Cred_22383 vin3.P19.GatPoly VSS.$2022.Metal1 0.0461689f
Cred_22384 vin3.P19.GatPoly VSS.$3988.Metal2 0.000786456f
Cred_22385 vin3.P19.GatPoly VSS.$4020.Metal2 0.000585659f
Cred_22386 vin3.P19.GatPoly VSS.$4116.Metal2 0.0049051f
Cred_22387 vin3.P19.GatPoly VSS.$4140.Metal2 0.00633399f
Cred_22388 vin3.P19.GatPoly VSS.$4174.Metal2 0.014075f
Cred_22389 vin3.P19.GatPoly VSS.$5186.Metal3 0.00278945f
Cred_22390 vin3.P19.GatPoly VSS.$5222.Metal3 0.00352294f
Cred_22391 vin3.P19.GatPoly VSS.$68.Metal1 2.40066e-06f
Cred_22392 vin3.P19.GatPoly VSS.P2.pSD 0.0108064f
Cred_22393 vin3.P19.GatPoly VSS.P3.pSD 1.68643e-06f
Cred_22394 vin3.P19.GatPoly VSS.P5.GatPoly 0.0190579f
Cred_22395 vin3.P19.GatPoly VSS.P67.nSD 3.51533e-06f
Cred_22396 vin3.P19.GatPoly VSS.P69.nSD 0.00021879f
Cred_22397 vin3.P19.GatPoly VSS.P71.nSD 0.00021879f
Cred_22398 vin3.P19.GatPoly VSS.P91.nSD 5.06388e-08f
Cred_22399 vin3.P2.GatPoly vout3.$1226.Metal3 0.0393216f
Cred_22400 vin3.P2.GatPoly vout3.P0.nSD 0.000674738f
Cred_22401 vin3.P2.GatPoly vout3.P0.pSD 0.00325793f
Cred_22402 vin3.P2.GatPoly vout3.P2.nSD 0.0223169f
Cred_22403 vin3.P2.GatPoly vout3.P2.pSD 0.00338557f
Cred_22404 vin3.P2.GatPoly VSS.$1990.Metal1 4.21603e-07f
Cred_22405 vin3.P2.GatPoly VSS.$2532.Metal2 0.00581989f
Cred_22406 vin3.P2.GatPoly VSS.$2564.Metal2 0.0106264f
Cred_22407 vin3.P2.GatPoly VSS.$2620.Metal2 0.00639424f
Cred_22408 vin3.P2.GatPoly VSS.$2711.Metal2 0.00119903f
Cred_22409 vin3.P2.GatPoly VSS.$386.Metal1 0.0529856f
Cred_22410 vin3.P2.GatPoly VSS.$451.Metal1 0.00207842f
Cred_22411 vin3.P2.GatPoly VSS.$4514.Metal3 0.00450346f
Cred_22412 vin3.P2.GatPoly VSS.$4538.Metal3 0.000595757f
Cred_22413 vin3.P2.GatPoly VSS.$471.Metal1 0.0122493f
Cred_22414 vin3.P2.GatPoly VSS.$499.Metal1 0.00397253f
Cred_22415 vin3.P2.GatPoly VSS.$565.Metal1 8.80351e-05f
Cred_22416 vin3.P2.GatPoly VSS.$68.Metal1 7.51395e-05f
Cred_22417 vin3.P2.GatPoly VSS.P2.pSD 0.000969661f
Cred_22418 vin3.P2.GatPoly VSS.P3.pSD 2.26408e-06f
Cred_22419 vin3.P2.GatPoly VSS.P51.nSD 0.0016066f
Cred_22420 vin3.P2.GatPoly VSS.P53.nSD 3.02093e-06f
Cred_22421 vin3.P2.GatPoly VSS.P75.nSD 5.03214e-07f
Cred_22422 vin3.P20.GatPoly vin4.P20.GatPoly 0.00126396f
Cred_22423 vin3.P20.GatPoly vout3.$1226.Metal3 0.157091f
Cred_22424 vin3.P20.GatPoly vout3.P0.nSD 0.00467766f
Cred_22425 vin3.P20.GatPoly vout3.P0.pSD 0.170586f
Cred_22426 vin3.P20.GatPoly vout3.P2.nSD 0.00247482f
Cred_22427 vin3.P20.GatPoly vout3.P2.pSD 0.0135254f
Cred_22428 vin3.P20.GatPoly VSS.$1990.Metal1 2.80624e-09f
Cred_22429 vin3.P20.GatPoly VSS.$2409.Metal2 4.7835e-06f
Cred_22430 vin3.P20.GatPoly VSS.$2433.Metal2 3.50781e-06f
Cred_22431 vin3.P20.GatPoly VSS.$4418.Metal3 0.000596611f
Cred_22432 vin3.P20.GatPoly VSS.$4454.Metal3 0.000437504f
Cred_22433 vin3.P20.GatPoly VSS.$68.Metal1 5.99832e-06f
Cred_22434 vin3.P20.GatPoly VSS.P2.pSD 1.81862e-05f
Cred_22435 vin3.P20.GatPoly VSS.P4.GatPoly 1.27821e-06f
Cred_22436 vin3.P21.GatPoly vin4.P21.GatPoly 0.00126396f
Cred_22437 vin3.P21.GatPoly vout3.$1226.Metal3 0.160661f
Cred_22438 vin3.P21.GatPoly vout3.P0.nSD 0.00458159f
Cred_22439 vin3.P21.GatPoly vout3.P0.pSD 0.152776f
Cred_22440 vin3.P21.GatPoly vout3.P2.nSD 0.00253106f
Cred_22441 vin3.P21.GatPoly vout3.P2.pSD 0.0164452f
Cred_22442 vin3.P22.GatPoly vin4.P22.GatPoly 0.00126396f
Cred_22443 vin3.P22.GatPoly vout3.$1226.Metal3 0.174054f
Cred_22444 vin3.P22.GatPoly vout3.P0.nSD 0.0026994f
Cred_22445 vin3.P22.GatPoly vout3.P0.pSD 0.0174661f
Cred_22446 vin3.P22.GatPoly vout3.P2.nSD 0.00274205f
Cred_22447 vin3.P22.GatPoly vout3.P2.pSD 0.135457f
Cred_22448 vin3.P23.GatPoly vin4.P23.GatPoly 0.00126396f
Cred_22449 vin3.P23.GatPoly vout3.$1226.Metal3 0.177972f
Cred_22450 vin3.P23.GatPoly vout3.P0.nSD 0.00235124f
Cred_22451 vin3.P23.GatPoly vout3.P0.pSD 0.0124941f
Cred_22452 vin3.P23.GatPoly vout3.P2.nSD 0.00255785f
Cred_22453 vin3.P23.GatPoly vout3.P2.pSD 0.13445f
Cred_22454 vin3.P23.GatPoly vout3.P4.pSD 0.00259263f
Cred_22455 vin3.P24.GatPoly vin4.P24.GatPoly 0.00126396f
Cred_22456 vin3.P24.GatPoly vout3.$1226.Metal3 0.216059f
Cred_22457 vin3.P24.GatPoly vout3.P0.nSD 0.000200773f
Cred_22458 vin3.P24.GatPoly vout3.P0.pSD 0.00106687f
Cred_22459 vin3.P24.GatPoly vout3.P2.nSD 0.000218415f
Cred_22460 vin3.P24.GatPoly vout3.P2.pSD 0.00385188f
Cred_22461 vin3.P24.GatPoly vout3.P4.pSD 0.125718f
Cred_22462 vin3.P25.GatPoly vin4.P25.GatPoly 0.00126396f
Cred_22463 vin3.P25.GatPoly vout3.$1226.Metal3 0.201171f
Cred_22464 vin3.P25.GatPoly vout3.$1292.Metal3 0.00742713f
Cred_22465 vin3.P25.GatPoly vout3.P4.pSD 0.120471f
Cred_22466 vin3.P25.GatPoly vout3.P6.nSD 0.000117007f
Cred_22467 vin3.P25.GatPoly vout3.P6.pSD 0.0032321f
Cred_22468 vin3.P26.GatPoly vin4.P26.GatPoly 0.00126396f
Cred_22469 vin3.P26.GatPoly vout3.$1226.Metal3 0.107788f
Cred_22470 vin3.P26.GatPoly vout3.$1292.Metal3 0.0921775f
Cred_22471 vin3.P26.GatPoly vout3.P4.pSD 0.00259263f
Cred_22472 vin3.P26.GatPoly vout3.P6.nSD 0.00145217f
Cred_22473 vin3.P26.GatPoly vout3.P6.pSD 0.128408f
Cred_22474 vin3.P27.GatPoly vin4.P27.GatPoly 0.00126396f
Cred_22475 vin3.P27.GatPoly vout3.$1226.Metal3 0.096316f
Cred_22476 vin3.P27.GatPoly vout3.$1292.Metal3 0.112912f
Cred_22477 vin3.P27.GatPoly vout3.P6.nSD 0.00151737f
Cred_22478 vin3.P27.GatPoly vout3.P6.pSD 0.134153f
Cred_22479 vin3.P27.GatPoly vout3.P8.pSD 0.00266188f
Cred_22480 vin3.P28.GatPoly vin4.P28.GatPoly 0.00126396f
Cred_22481 vin3.P28.GatPoly vout3.$1226.Metal3 0.00742713f
Cred_22482 vin3.P28.GatPoly vout3.$1292.Metal3 0.201171f
Cred_22483 vin3.P28.GatPoly vout3.P6.nSD 0.000117007f
Cred_22484 vin3.P28.GatPoly vout3.P6.pSD 0.0032321f
Cred_22485 vin3.P28.GatPoly vout3.P8.pSD 0.120471f
Cred_22486 vin3.P29.GatPoly vin4.P29.GatPoly 0.00126396f
Cred_22487 vin3.P29.GatPoly vout3.$1292.Metal3 0.20119f
Cred_22488 vin3.P29.GatPoly vout3.$1358.Metal3 0.00715313f
Cred_22489 vin3.P29.GatPoly vout3.P10.nSD 0.000112691f
Cred_22490 vin3.P29.GatPoly vout3.P10.pSD 0.00322922f
Cred_22491 vin3.P29.GatPoly vout3.P8.pSD 0.120733f
Cred_22492 vin3.P3.GatPoly vout3.$1226.Metal3 0.0368429f
Cred_22493 vin3.P3.GatPoly vout3.P0.nSD 0.000489337f
Cred_22494 vin3.P3.GatPoly vout3.P0.pSD 0.00260026f
Cred_22495 vin3.P3.GatPoly vout3.P2.nSD 0.0208402f
Cred_22496 vin3.P3.GatPoly vout3.P2.pSD 0.00290933f
Cred_22497 vin3.P3.GatPoly vout3.P4.nSD 3.18635e-05f
Cred_22498 vin3.P3.GatPoly VSS.$2532.Metal2 0.000510647f
Cred_22499 vin3.P3.GatPoly VSS.$2564.Metal2 0.000685726f
Cred_22500 vin3.P3.GatPoly VSS.$2668.Metal2 0.00685255f
Cred_22501 vin3.P3.GatPoly VSS.$2711.Metal2 0.0128681f
Cred_22502 vin3.P3.GatPoly VSS.$2727.Metal2 0.0026751f
Cred_22503 vin3.P3.GatPoly VSS.$386.Metal1 9.06084e-05f
Cred_22504 vin3.P3.GatPoly VSS.$4538.Metal3 0.000799087f
Cred_22505 vin3.P3.GatPoly VSS.$4562.Metal3 0.00451617f
Cred_22506 vin3.P3.GatPoly VSS.$519.Metal1 0.00380395f
Cred_22507 vin3.P3.GatPoly VSS.$539.Metal1 0.00893219f
Cred_22508 vin3.P3.GatPoly VSS.$559.Metal1 0.00592918f
Cred_22509 vin3.P3.GatPoly VSS.$565.Metal1 0.0507781f
Cred_22510 vin3.P3.GatPoly VSS.P51.nSD 3.06508e-06f
Cred_22511 vin3.P3.GatPoly VSS.P53.nSD 0.00153329f
Cred_22512 vin3.P3.GatPoly VSS.P75.nSD 4.41529e-08f
Cred_22513 vin3.P30.GatPoly vin4.P30.GatPoly 0.00126396f
Cred_22514 vin3.P30.GatPoly vout3.$1292.Metal3 0.107309f
Cred_22515 vin3.P30.GatPoly vout3.$1358.Metal3 0.0916983f
Cred_22516 vin3.P30.GatPoly vout3.P10.nSD 0.00144462f
Cred_22517 vin3.P30.GatPoly vout3.P10.pSD 0.129374f
Cred_22518 vin3.P30.GatPoly vout3.P8.pSD 0.00259263f
Cred_22519 vin3.P31.GatPoly vin4.P31.GatPoly 0.00126396f
Cred_22520 vin3.P31.GatPoly vout3.$1292.Metal3 0.0918378f
Cred_22521 vin3.P31.GatPoly vout3.$1358.Metal3 0.106867f
Cred_22522 vin3.P31.GatPoly vout3.P10.nSD 0.00144682f
Cred_22523 vin3.P31.GatPoly vout3.P10.pSD 0.129648f
Cred_22524 vin3.P31.GatPoly vout3.P12.pSD 0.00261888f
Cred_22525 vin3.P32.GatPoly vin4.P32.GatPoly 0.00126396f
Cred_22526 vin3.P32.GatPoly vout3.$1292.Metal3 0.00763443f
Cred_22527 vin3.P32.GatPoly vout3.$1358.Metal3 0.209225f
Cred_22528 vin3.P32.GatPoly vout3.P10.nSD 0.000120273f
Cred_22529 vin3.P32.GatPoly vout3.P10.pSD 0.00334719f
Cred_22530 vin3.P32.GatPoly vout3.P12.pSD 0.127295f
Cred_22531 vin3.P33.GatPoly vin4.P33.GatPoly 0.00126396f
Cred_22532 vin3.P33.GatPoly vout3.$1358.Metal3 0.200112f
Cred_22533 vin3.P33.GatPoly vout3.$1424.Metal3 0.00715313f
Cred_22534 vin3.P33.GatPoly vout3.P12.pSD 0.121811f
Cred_22535 vin3.P33.GatPoly vout3.P14.nSD 0.000112691f
Cred_22536 vin3.P33.GatPoly vout3.P14.pSD 0.00322922f
Cred_22537 vin3.P34.GatPoly vin4.P34.GatPoly 0.00126396f
Cred_22538 vin3.P34.GatPoly vout3.$1358.Metal3 0.106867f
Cred_22539 vin3.P34.GatPoly vout3.$1424.Metal3 0.091838f
Cred_22540 vin3.P34.GatPoly vout3.P12.pSD 0.00261888f
Cred_22541 vin3.P34.GatPoly vout3.P14.nSD 0.00144682f
Cred_22542 vin3.P34.GatPoly vout3.P14.pSD 0.129647f
Cred_22543 vin3.P35.GatPoly vin4.P35.GatPoly 0.00126396f
Cred_22544 vin3.P35.GatPoly vout3.$1358.Metal3 0.0958538f
Cred_22545 vin3.P35.GatPoly vout3.$1424.Metal3 0.11184f
Cred_22546 vin3.P35.GatPoly vout3.P14.nSD 0.00151009f
Cred_22547 vin3.P35.GatPoly vout3.P14.pSD 0.135381f
Cred_22548 vin3.P35.GatPoly vout3.P16.pSD 0.00269169f
Cred_22549 vin3.P36.GatPoly vin4.P36.GatPoly 0.00126396f
Cred_22550 vin3.P36.GatPoly vout3.$1358.Metal3 0.00715313f
Cred_22551 vin3.P36.GatPoly vout3.$1424.Metal3 0.200603f
Cred_22552 vin3.P36.GatPoly vout3.P14.nSD 0.000112691f
Cred_22553 vin3.P36.GatPoly vout3.P14.pSD 0.00322922f
Cred_22554 vin3.P36.GatPoly vout3.P16.pSD 0.122248f
Cred_22555 vin3.P37.GatPoly vin4.P37.GatPoly 0.00126396f
Cred_22556 vin3.P37.GatPoly vout3 0.0022934f
Cred_22557 vin3.P37.GatPoly vout3.$1424.Metal3 0.204525f
Cred_22558 vin3.P37.GatPoly vout3.P16.pSD 0.121811f
Cred_22559 vin3.P37.GatPoly vout3.P18.nSD 0.000182223f
Cred_22560 vin3.P37.GatPoly vout3.P18.pSD 0.00360581f
Cred_22561 vin3.P38.GatPoly vin4.P38.GatPoly 0.00126396f
Cred_22562 vin3.P38.GatPoly vout3 0.0298642f
Cred_22563 vin3.P38.GatPoly vout3.$1424.Metal3 0.165649f
Cred_22564 vin3.P38.GatPoly vout3.P16.pSD 0.00261888f
Cred_22565 vin3.P38.GatPoly vout3.P18.nSD 0.00237287f
Cred_22566 vin3.P38.GatPoly vout3.P18.pSD 0.13649f
Cred_22567 vin3.P39.GatPoly vin4.P39.GatPoly 0.00126396f
Cred_22568 vin3.P39.GatPoly vout3 0.0348568f
Cred_22569 vin3.P39.GatPoly vout3.$1424.Metal3 0.175799f
Cred_22570 vin3.P39.GatPoly vout3.P18.nSD 0.00276955f
Cred_22571 vin3.P39.GatPoly vout3.P18.pSD 0.155155f
Cred_22572 vin3.P39.GatPoly VSS.$4140.Metal2 0.000431311f
Cred_22573 vin3.P4.GatPoly vout3.$1226.Metal3 0.0471178f
Cred_22574 vin3.P4.GatPoly vout3.P0.nSD 4.53065e-05f
Cred_22575 vin3.P4.GatPoly vout3.P0.pSD 0.000240751f
Cred_22576 vin3.P4.GatPoly vout3.P2.nSD 8.75338e-05f
Cred_22577 vin3.P4.GatPoly vout3.P2.pSD 0.000269368f
Cred_22578 vin3.P4.GatPoly vout3.P4.nSD 0.0222123f
Cred_22579 vin3.P4.GatPoly VSS.$1990.Metal1 8.10235e-07f
Cred_22580 vin3.P4.GatPoly VSS.$2711.Metal2 0.0147845f
Cred_22581 vin3.P4.GatPoly VSS.$2783.Metal2 0.00748422f
Cred_22582 vin3.P4.GatPoly VSS.$2831.Metal2 0.00101102f
Cred_22583 vin3.P4.GatPoly VSS.$2914.Metal2 0.0011548f
Cred_22584 vin3.P4.GatPoly VSS.$2946.Metal2 4.3853e-05f
Cred_22585 vin3.P4.GatPoly VSS.$4586.Metal3 0.00315449f
Cred_22586 vin3.P4.GatPoly VSS.$4610.Metal3 0.00186198f
Cred_22587 vin3.P4.GatPoly VSS.$565.Metal1 0.051926f
Cred_22588 vin3.P4.GatPoly VSS.$618.Metal1 0.00225715f
Cred_22589 vin3.P4.GatPoly VSS.$638.Metal1 0.00868565f
Cred_22590 vin3.P4.GatPoly VSS.$658.Metal1 0.00744981f
Cred_22591 vin3.P4.GatPoly VSS.$678.Metal1 0.00153789f
Cred_22592 vin3.P4.GatPoly VSS.$68.Metal1 3.62944e-05f
Cred_22593 vin3.P4.GatPoly VSS.$744.Metal1 8.84065e-05f
Cred_22594 vin3.P4.GatPoly VSS.P2.pSD 0.000966227f
Cred_22595 vin3.P4.GatPoly VSS.P53.nSD 0.00158901f
Cred_22596 vin3.P4.GatPoly VSS.P55.nSD 3.0273e-06f
Cred_22597 vin3.P4.GatPoly VSS.P79.nSD 6.37334e-09f
Cred_22598 vin3.P5.GatPoly vout3.$1226.Metal3 0.0417431f
Cred_22599 vin3.P5.GatPoly vout3.$1292.Metal3 0.00145233f
Cred_22600 vin3.P5.GatPoly vout3.P4.nSD 0.0202828f
Cred_22601 vin3.P5.GatPoly vout3.P6.nSD 5.47436e-05f
Cred_22602 vin3.P5.GatPoly vout3.P6.pSD 0.000125045f
Cred_22603 vin3.P5.GatPoly VSS.$2711.Metal2 0.00119903f
Cred_22604 vin3.P5.GatPoly VSS.$2831.Metal2 8.69857e-06f
Cred_22605 vin3.P5.GatPoly VSS.$2855.Metal2 0.00748984f
Cred_22606 vin3.P5.GatPoly VSS.$2914.Metal2 0.0143303f
Cred_22607 vin3.P5.GatPoly VSS.$2946.Metal2 0.000471281f
Cred_22608 vin3.P5.GatPoly VSS.$4610.Metal3 0.000848036f
Cred_22609 vin3.P5.GatPoly VSS.$4646.Metal3 0.00443521f
Cred_22610 vin3.P5.GatPoly VSS.$565.Metal1 8.80351e-05f
Cred_22611 vin3.P5.GatPoly VSS.$678.Metal1 0.000380545f
Cred_22612 vin3.P5.GatPoly VSS.$698.Metal1 0.00696281f
Cred_22613 vin3.P5.GatPoly VSS.$726.Metal1 0.0108588f
Cred_22614 vin3.P5.GatPoly VSS.$744.Metal1 0.0506574f
Cred_22615 vin3.P5.GatPoly VSS.$757.Metal1 0.000343182f
Cred_22616 vin3.P5.GatPoly VSS.P2.pSD 2.68972e-06f
Cred_22617 vin3.P5.GatPoly VSS.P3.pSD 2.68972e-06f
Cred_22618 vin3.P5.GatPoly VSS.P53.nSD 3.02093e-06f
Cred_22619 vin3.P5.GatPoly VSS.P55.nSD 0.00154084f
Cred_22620 vin3.P5.GatPoly VSS.P79.nSD 6.84932e-08f
Cred_22621 vin3.P6.GatPoly vout3.$1226.Metal3 0.0236713f
Cred_22622 vin3.P6.GatPoly vout3.$1292.Metal3 0.0201949f
Cred_22623 vin3.P6.GatPoly vout3.P4.nSD 3.58385e-05f
Cred_22624 vin3.P6.GatPoly vout3.P6.nSD 0.0216827f
Cred_22625 vin3.P6.GatPoly vout3.P6.pSD 0.00173877f
Cred_22626 vin3.P6.GatPoly VSS.$1990.Metal1 7.6038e-07f
Cred_22627 vin3.P6.GatPoly VSS.$2914.Metal2 0.0128825f
Cred_22628 vin3.P6.GatPoly VSS.$2946.Metal2 0.00677301f
Cred_22629 vin3.P6.GatPoly VSS.$2994.Metal2 0.00281776f
Cred_22630 vin3.P6.GatPoly VSS.$3085.Metal2 0.00119903f
Cred_22631 vin3.P6.GatPoly VSS.$4646.Metal3 0.000775961f
Cred_22632 vin3.P6.GatPoly VSS.$4682.Metal3 0.00440935f
Cred_22633 vin3.P6.GatPoly VSS.$68.Metal1 7.30198e-06f
Cred_22634 vin3.P6.GatPoly VSS.$744.Metal1 0.0522293f
Cred_22635 vin3.P6.GatPoly VSS.$817.Metal1 0.0085415f
Cred_22636 vin3.P6.GatPoly VSS.$837.Metal1 0.00867663f
Cred_22637 vin3.P6.GatPoly VSS.$865.Metal1 0.000779039f
Cred_22638 vin3.P6.GatPoly VSS.$923.Metal1 8.80351e-05f
Cred_22639 vin3.P6.GatPoly VSS.P2.pSD 0.000428302f
Cred_22640 vin3.P6.GatPoly VSS.P3.pSD 7.31944e-07f
Cred_22641 vin3.P6.GatPoly VSS.P55.nSD 0.00157393f
Cred_22642 vin3.P6.GatPoly VSS.P57.nSD 3.02093e-06f
Cred_22643 vin3.P6.GatPoly VSS.P79.nSD 7.10643e-08f
Cred_22644 vin3.P7.GatPoly vout3.$1226.Metal3 0.0202598f
Cred_22645 vin3.P7.GatPoly vout3.$1292.Metal3 0.0238867f
Cred_22646 vin3.P7.GatPoly vout3.P6.nSD 0.0215228f
Cred_22647 vin3.P7.GatPoly vout3.P6.pSD 0.00174436f
Cred_22648 vin3.P7.GatPoly vout3.P8.nSD 3.7248e-05f
Cred_22649 vin3.P7.GatPoly VSS.$1990.Metal1 9.75091e-07f
Cred_22650 vin3.P7.GatPoly VSS.$2914.Metal2 0.0011548f
Cred_22651 vin3.P7.GatPoly VSS.$2946.Metal2 4.3853e-05f
Cred_22652 vin3.P7.GatPoly VSS.$2994.Metal2 0.00123086f
Cred_22653 vin3.P7.GatPoly VSS.$3042.Metal2 0.00792992f
Cred_22654 vin3.P7.GatPoly VSS.$3085.Metal2 0.014792f
Cred_22655 vin3.P7.GatPoly VSS.$4706.Metal3 0.00174233f
Cred_22656 vin3.P7.GatPoly VSS.$4730.Metal3 0.00331224f
Cred_22657 vin3.P7.GatPoly VSS.$68.Metal1 5.95569e-06f
Cred_22658 vin3.P7.GatPoly VSS.$744.Metal1 8.84065e-05f
Cred_22659 vin3.P7.GatPoly VSS.$865.Metal1 0.00235249f
Cred_22660 vin3.P7.GatPoly VSS.$885.Metal1 0.00913213f
Cred_22661 vin3.P7.GatPoly VSS.$905.Metal1 0.00769148f
Cred_22662 vin3.P7.GatPoly VSS.$923.Metal1 0.0508325f
Cred_22663 vin3.P7.GatPoly VSS.$936.Metal1 0.00100572f
Cred_22664 vin3.P7.GatPoly VSS.P2.pSD 0.000438819f
Cred_22665 vin3.P7.GatPoly VSS.P55.nSD 3.0273e-06f
Cred_22666 vin3.P7.GatPoly VSS.P57.nSD 0.00155684f
Cred_22667 vin3.P7.GatPoly VSS.P79.nSD 6.37334e-09f
Cred_22668 vin3.P8.GatPoly vout3.$1226.Metal3 0.00164772f
Cred_22669 vin3.P8.GatPoly vout3.$1292.Metal3 0.0439192f
Cred_22670 vin3.P8.GatPoly vout3.P6.nSD 6.16726e-05f
Cred_22671 vin3.P8.GatPoly vout3.P6.pSD 0.000141868f
Cred_22672 vin3.P8.GatPoly vout3.P8.nSD 0.0212328f
Cred_22673 vin3.P8.GatPoly VSS 9.06646e-05f
Cred_22674 vin3.P8.GatPoly VSS.$1024.Metal1 0.00528126f
Cred_22675 vin3.P8.GatPoly VSS.$3085.Metal2 0.0133121f
Cred_22676 vin3.P8.GatPoly VSS.$3101.Metal2 0.00246723f
Cred_22677 vin3.P8.GatPoly VSS.$3157.Metal2 0.00702415f
Cred_22678 vin3.P8.GatPoly VSS.$3260.Metal2 0.000598157f
Cred_22679 vin3.P8.GatPoly VSS.$3292.Metal2 0.000598157f
Cred_22680 vin3.P8.GatPoly VSS.$4754.Metal3 0.00436081f
Cred_22681 vin3.P8.GatPoly VSS.$4778.Metal3 0.00093661f
Cred_22682 vin3.P8.GatPoly VSS.$923.Metal1 0.0511685f
Cred_22683 vin3.P8.GatPoly VSS.$968.Metal1 4.6155e-05f
Cred_22684 vin3.P8.GatPoly VSS.$996.Metal1 0.0124547f
Cred_22685 vin3.P8.GatPoly VSS.P2.pSD 2.79537e-06f
Cred_22686 vin3.P8.GatPoly VSS.P3.pSD 2.79537e-06f
Cred_22687 vin3.P8.GatPoly VSS.P57.nSD 0.00155293f
Cred_22688 vin3.P8.GatPoly VSS.P59.nSD 3.06604e-06f
Cred_22689 vin3.P8.GatPoly VSS.P83.nSD 4.51169e-08f
Cred_22690 vin3.P9.GatPoly vout3.$1292.Metal3 0.0447268f
Cred_22691 vin3.P9.GatPoly vout3.$1358.Metal3 0.0017178f
Cred_22692 vin3.P9.GatPoly vout3.P10.nSD 6.41454e-05f
Cred_22693 vin3.P9.GatPoly vout3.P10.pSD 0.000146571f
Cred_22694 vin3.P9.GatPoly vout3.P8.nSD 0.0215851f
Cred_22695 vin3.P9.GatPoly VSS 0.0525372f
Cred_22696 vin3.P9.GatPoly VSS.$1044.Metal1 0.00137957f
Cred_22697 vin3.P9.GatPoly VSS.$1064.Metal1 0.00847338f
Cred_22698 vin3.P9.GatPoly VSS.$1084.Metal1 0.00991321f
Cred_22699 vin3.P9.GatPoly VSS.$1990.Metal1 2.75749e-06f
Cred_22700 vin3.P9.GatPoly VSS.$3085.Metal2 0.00119903f
Cred_22701 vin3.P9.GatPoly VSS.$3205.Metal2 0.00595581f
Cred_22702 vin3.P9.GatPoly VSS.$3260.Metal2 0.00963009f
Cred_22703 vin3.P9.GatPoly VSS.$3292.Metal2 0.00680756f
Cred_22704 vin3.P9.GatPoly VSS.$4802.Metal3 0.0039077f
Cred_22705 vin3.P9.GatPoly VSS.$68.Metal1 4.5444e-06f
Cred_22706 vin3.P9.GatPoly VSS.$923.Metal1 8.80351e-05f
Cred_22707 vin3.P9.GatPoly VSS.P2.pSD 0.000646408f
Cred_22708 vin3.P9.GatPoly VSS.P3.pSD 9.41436e-07f
Cred_22709 vin3.P9.GatPoly VSS.P57.nSD 3.02093e-06f
Cred_22710 vin3.P9.GatPoly VSS.P59.nSD 0.00163442f
Cred_22711 vin3.P9.GatPoly VSS.P83.nSD 5.13471e-07f
Cred_22712 vin4 VSS 0.090216f
Cred_22713 vin4 VSS.$1991.Metal1 1.27553e-07f
Cred_22714 vin4 VSS.$2023.Metal1 3.19367e-07f
Cred_22715 vin4 VSS.$4241.Metal2 8.5504e-10f
Cred_22716 vin4 VSS.$4355.Metal3 1.64493e-08f
Cred_22717 vin4 VSS.$4358.Metal3 3.69932e-05f
Cred_22718 vin4 VSS.$4364.Metal3 0.0274051f
Cred_22719 vin4 VSS.$66.Metal1 0.00206442f
Cred_22720 vin4 VSS.P0.pSD 0.00259616f
Cred_22721 vin4.$103.GatPoly vout4.$1292.Metal3 0.00434755f
Cred_22722 vin4.$103.GatPoly vout4.$1358.Metal3 0.00410225f
Cred_22723 vin4.$103.GatPoly vout4.P10.nSD 0.00585196f
Cred_22724 vin4.$103.GatPoly vout4.P10.pSD 0.000350025f
Cred_22725 vin4.$103.GatPoly vout4.P8.nSD 2.30011e-06f
Cred_22726 vin4.$103.GatPoly VSS 0.000710053f
Cred_22727 vin4.$103.GatPoly VSS.$1991.Metal1 1.00251e-05f
Cred_22728 vin4.$103.GatPoly VSS.$2023.Metal1 2.51007e-05f
Cred_22729 vin4.$103.GatPoly VSS.$3276.Metal2 0.000149541f
Cred_22730 vin4.$103.GatPoly VSS.$3308.Metal2 0.000149541f
Cred_22731 vin4.$103.GatPoly VSS.$4241.Metal2 6.7202e-08f
Cred_22732 vin4.$103.GatPoly VSS.$66.Metal1 2.07184e-05f
Cred_22733 vin4.$103.GatPoly VSS.P0.pSD 0.00369707f
Cred_22734 vin4.$103.GatPoly VSS.P11.nSD 2.65729e-05f
Cred_22735 vin4.$104.GatPoly vout4.$1292.Metal3 0.00513649f
Cred_22736 vin4.$104.GatPoly vout4.$1358.Metal3 0.00513649f
Cred_22737 vin4.$104.GatPoly vout4.P10.nSD 8.09205e-05f
Cred_22738 vin4.$104.GatPoly vout4.P10.pSD 0.00990689f
Cred_22739 vin4.$106.GatPoly vout4.$1292.Metal3 0.0244564f
Cred_22740 vin4.$106.GatPoly vout4.$1358.Metal3 0.0304463f
Cred_22741 vin4.$106.GatPoly vout4.P10.nSD 0.000385287f
Cred_22742 vin4.$106.GatPoly vout4.P10.pSD 0.0348187f
Cred_22743 vin4.$106.GatPoly vout4.P12.pSD 0.000455774f
Cred_22744 vin4.$109.GatPoly vout4.$1292.Metal3 0.00168266f
Cred_22745 vin4.$109.GatPoly vout4.$1358.Metal3 0.00210155f
Cred_22746 vin4.$109.GatPoly vout4.P10.nSD 0.002228f
Cred_22747 vin4.$109.GatPoly vout4.P10.pSD 0.000143573f
Cred_22748 vin4.$109.GatPoly vout4.P12.nSD 3.92785e-06f
Cred_22749 vin4.$109.GatPoly VSS.$1214.Metal1 4.53682e-07f
Cred_22750 vin4.$109.GatPoly VSS.$1254.Metal1 1.48102e-06f
Cred_22751 vin4.$109.GatPoly VSS.$1267.Metal1 0.0011929f
Cred_22752 vin4.$109.GatPoly VSS.$1991.Metal1 8.02145e-06f
Cred_22753 vin4.$109.GatPoly VSS.$2023.Metal1 2.00841e-05f
Cred_22754 vin4.$109.GatPoly VSS.$3404.Metal2 3.79032e-09f
Cred_22755 vin4.$109.GatPoly VSS.$3463.Metal2 0.000392707f
Cred_22756 vin4.$109.GatPoly VSS.$3495.Metal2 0.000118436f
Cred_22757 vin4.$109.GatPoly VSS.$4241.Metal2 5.3771e-08f
Cred_22758 vin4.$109.GatPoly VSS.$66.Metal1 1.23946e-05f
Cred_22759 vin4.$109.GatPoly VSS.P0.pSD 0.00256124f
Cred_22760 vin4.$109.GatPoly VSS.P13.nSD 4.4642e-05f
Cred_22761 vin4.$11.GatPoly vout4.$1226.Metal3 0.000720713f
Cred_22762 vin4.$11.GatPoly vout4.P0.nSD 0.000271067f
Cred_22763 vin4.$11.GatPoly vout4.P0.pSD 9.49465e-05f
Cred_22764 vin4.$11.GatPoly vout4.P2.nSD 1.39824e-05f
Cred_22765 vin4.$11.GatPoly vout4.P2.pSD 6.2053e-05f
Cred_22766 vin4.$11.GatPoly VSS.$1991.Metal1 3.19973e-07f
Cred_22767 vin4.$11.GatPoly VSS.$2023.Metal1 8.01147e-07f
Cred_22768 vin4.$11.GatPoly VSS.$2493.Metal2 1.82757e-08f
Cred_22769 vin4.$11.GatPoly VSS.$2544.Metal2 0.000233724f
Cred_22770 vin4.$11.GatPoly VSS.$2576.Metal2 0.000313817f
Cred_22771 vin4.$11.GatPoly VSS.$374.Metal1 3.65208e-06f
Cred_22772 vin4.$11.GatPoly VSS.$387.Metal1 0.00875726f
Cred_22773 vin4.$11.GatPoly VSS.$4241.Metal2 2.1449e-09f
Cred_22774 vin4.$11.GatPoly VSS.$4484.Metal3 1.46531e-10f
Cred_22775 vin4.$11.GatPoly VSS.$66.Metal1 0.000379633f
Cred_22776 vin4.$11.GatPoly VSS.P0.pSD 0.00252058f
Cred_22777 vin4.$11.GatPoly VSS.P3.nSD 0.000232966f
Cred_22778 vin4.$111.GatPoly vout4.$1292.Metal3 0.00115252f
Cred_22779 vin4.$111.GatPoly vout4.$1358.Metal3 0.00175093f
Cred_22780 vin4.$111.GatPoly vout4.P10.nSD 0.00102547f
Cred_22781 vin4.$111.GatPoly vout4.P10.pSD 9.83392e-05f
Cred_22782 vin4.$111.GatPoly vout4.P12.nSD 5.61121e-06f
Cred_22783 vin4.$111.GatPoly VSS.$1214.Metal1 2.98183e-07f
Cred_22784 vin4.$111.GatPoly VSS.$1254.Metal1 1.29111e-05f
Cred_22785 vin4.$111.GatPoly VSS.$1267.Metal1 0.00732535f
Cred_22786 vin4.$111.GatPoly VSS.$1991.Metal1 1.06001e-05f
Cred_22787 vin4.$111.GatPoly VSS.$2023.Metal1 2.65406e-05f
Cred_22788 vin4.$111.GatPoly VSS.$3404.Metal2 2.49119e-09f
Cred_22789 vin4.$111.GatPoly VSS.$3463.Metal2 0.000809477f
Cred_22790 vin4.$111.GatPoly VSS.$3495.Metal2 0.000244128f
Cred_22791 vin4.$111.GatPoly VSS.$4241.Metal2 7.10568e-08f
Cred_22792 vin4.$111.GatPoly VSS.$66.Metal1 1.20084e-05f
Cred_22793 vin4.$111.GatPoly VSS.P0.pSD 0.00289365f
Cred_22794 vin4.$111.GatPoly VSS.P13.nSD 0.000202016f
Cred_22795 vin4.$114.GatPoly vout4.$1292.Metal3 0.000678878f
Cred_22796 vin4.$114.GatPoly vout4.$1358.Metal3 0.0128531f
Cred_22797 vin4.$114.GatPoly vout4.P10.nSD 1.06951e-05f
Cred_22798 vin4.$114.GatPoly vout4.P10.pSD 0.000166405f
Cred_22799 vin4.$114.GatPoly vout4.P12.pSD 0.0077353f
Cred_22800 vin4.$119.GatPoly vout4.$1292.Metal3 0.000253425f
Cred_22801 vin4.$119.GatPoly vout4.$1358.Metal3 0.00238925f
Cred_22802 vin4.$119.GatPoly vout4.P10.nSD 8.98535e-06f
Cred_22803 vin4.$119.GatPoly vout4.P10.pSD 2.16235e-05f
Cred_22804 vin4.$119.GatPoly vout4.P12.nSD 0.000861929f
Cred_22805 vin4.$119.GatPoly VSS.$1267.Metal1 0.00823109f
Cred_22806 vin4.$119.GatPoly VSS.$1373.Metal1 3.74658e-06f
Cred_22807 vin4.$119.GatPoly VSS.$1991.Metal1 1.47882e-05f
Cred_22808 vin4.$119.GatPoly VSS.$2023.Metal1 3.70266e-05f
Cred_22809 vin4.$119.GatPoly VSS.$3463.Metal2 0.000786752f
Cred_22810 vin4.$119.GatPoly VSS.$3495.Metal2 0.000237304f
Cred_22811 vin4.$119.GatPoly VSS.$3519.Metal2 9.81705e-08f
Cred_22812 vin4.$119.GatPoly VSS.$4241.Metal2 9.9131e-08f
Cred_22813 vin4.$119.GatPoly VSS.$66.Metal1 1.15031e-05f
Cred_22814 vin4.$119.GatPoly VSS.P0.pSD 0.00333817f
Cred_22815 vin4.$119.GatPoly VSS.P13.nSD 0.000219362f
Cred_22816 vin4.$122.GatPoly vout4.$1292.Metal3 0.000877157f
Cred_22817 vin4.$122.GatPoly vout4.$1358.Metal3 0.0274113f
Cred_22818 vin4.$122.GatPoly vout4.P10.nSD 1.38188e-05f
Cred_22819 vin4.$122.GatPoly vout4.P10.pSD 0.000215008f
Cred_22820 vin4.$122.GatPoly vout4.P12.pSD 0.0188942f
Cred_22821 vin4.$123.GatPoly vout4.$1292.Metal3 0.000106508f
Cred_22822 vin4.$123.GatPoly vout4.$1358.Metal3 0.0090962f
Cred_22823 vin4.$123.GatPoly vout4.$1424.Metal3 2.65924e-05f
Cred_22824 vin4.$123.GatPoly vout4.P10.nSD 3.77632e-06f
Cred_22825 vin4.$123.GatPoly vout4.P10.pSD 9.08784e-06f
Cred_22826 vin4.$123.GatPoly vout4.P12.nSD 0.00591517f
Cred_22827 vin4.$123.GatPoly vout4.P14.nSD 9.42849e-07f
Cred_22828 vin4.$123.GatPoly vout4.P14.pSD 2.269e-06f
Cred_22829 vin4.$123.GatPoly VSS.$1267.Metal1 0.000635031f
Cred_22830 vin4.$123.GatPoly VSS.$1483.Metal1 0.000169257f
Cred_22831 vin4.$123.GatPoly VSS.$1991.Metal1 2.0133e-05f
Cred_22832 vin4.$123.GatPoly VSS.$2023.Metal1 5.04089e-05f
Cred_22833 vin4.$123.GatPoly VSS.$3463.Metal2 0.000207253f
Cred_22834 vin4.$123.GatPoly VSS.$3495.Metal2 6.25048e-05f
Cred_22835 vin4.$123.GatPoly VSS.$3615.Metal2 2.08531e-06f
Cred_22836 vin4.$123.GatPoly VSS.$3650.Metal2 5.4913e-05f
Cred_22837 vin4.$123.GatPoly VSS.$4241.Metal2 1.34959e-07f
Cred_22838 vin4.$123.GatPoly VSS.$66.Metal1 1.00489e-05f
Cred_22839 vin4.$123.GatPoly VSS.P0.pSD 0.00363f
Cred_22840 vin4.$123.GatPoly VSS.P13.nSD 2.37653e-05f
Cred_22841 vin4.$123.GatPoly VSS.P15.nSD 1.40717e-06f
Cred_22842 vin4.$126.GatPoly vout4.$1358.Metal3 0.0563073f
Cred_22843 vin4.$126.GatPoly vout4.$1424.Metal3 0.00286031f
Cred_22844 vin4.$126.GatPoly vout4.P12.pSD 0.0346375f
Cred_22845 vin4.$126.GatPoly vout4.P14.nSD 4.50615e-05f
Cred_22846 vin4.$126.GatPoly vout4.P14.pSD 0.000701114f
Cred_22847 vin4.$131.GatPoly vout4.$1358.Metal3 0.00469248f
Cred_22848 vin4.$131.GatPoly vout4.$1424.Metal3 0.000411585f
Cred_22849 vin4.$131.GatPoly vout4.P12.nSD 0.00211167f
Cred_22850 vin4.$131.GatPoly vout4.P14.nSD 1.4593e-05f
Cred_22851 vin4.$131.GatPoly vout4.P14.pSD 3.51185e-05f
Cred_22852 vin4.$131.GatPoly VSS.$1373.Metal1 2.28603e-07f
Cred_22853 vin4.$131.GatPoly VSS.$1421.Metal1 2.16492e-05f
Cred_22854 vin4.$131.GatPoly VSS.$1483.Metal1 0.00513046f
Cred_22855 vin4.$131.GatPoly VSS.$1484.Metal1 0.000751257f
Cred_22856 vin4.$131.GatPoly VSS.$1991.Metal1 2.26569e-05f
Cred_22857 vin4.$131.GatPoly VSS.$2023.Metal1 5.67283e-05f
Cred_22858 vin4.$131.GatPoly VSS.$3567.Metal2 4.84579e-08f
Cred_22859 vin4.$131.GatPoly VSS.$3615.Metal2 3.45181e-05f
Cred_22860 vin4.$131.GatPoly VSS.$3650.Metal2 0.000904124f
Cred_22861 vin4.$131.GatPoly VSS.$4241.Metal2 1.51878e-07f
Cred_22862 vin4.$131.GatPoly VSS.$4964.Metal3 3.73213e-10f
Cred_22863 vin4.$131.GatPoly VSS.$66.Metal1 7.28406e-06f
Cred_22864 vin4.$131.GatPoly VSS.P0.pSD 0.00326543f
Cred_22865 vin4.$131.GatPoly VSS.P15.nSD 4.46155e-05f
Cred_22866 vin4.$134.GatPoly vout4.$1358.Metal3 3.10023e-08f
Cred_22867 vin4.$134.GatPoly vout4.$1424.Metal3 1.31326e-08f
Cred_22868 vin4.$134.GatPoly vout4.P12.pSD 1.16045e-09f
Cred_22869 vin4.$134.GatPoly vout4.P14.nSD 2.06892e-10f
Cred_22870 vin4.$134.GatPoly vout4.P14.pSD 2.28099e-09f
Cred_22871 vin4.$135.GatPoly VSS.$1421.Metal1 0.000101628f
Cred_22872 vin4.$135.GatPoly VSS.$1483.Metal1 0.00687275f
Cred_22873 vin4.$135.GatPoly VSS.$1484.Metal1 0.00548286f
Cred_22874 vin4.$135.GatPoly VSS.$1512.Metal1 7.03154e-08f
Cred_22875 vin4.$135.GatPoly VSS.$1580.Metal1 2.63576e-09f
Cred_22876 vin4.$135.GatPoly VSS.$1991.Metal1 2.50615e-05f
Cred_22877 vin4.$135.GatPoly VSS.$2023.Metal1 6.27489e-05f
Cred_22878 vin4.$135.GatPoly VSS.$3615.Metal2 6.46772e-06f
Cred_22879 vin4.$135.GatPoly VSS.$3650.Metal2 0.000147958f
Cred_22880 vin4.$135.GatPoly VSS.$3706.Metal2 4.42625e-11f
Cred_22881 vin4.$135.GatPoly VSS.$3730.Metal2 2.20213e-11f
Cred_22882 vin4.$135.GatPoly VSS.$4241.Metal2 1.67997e-07f
Cred_22883 vin4.$135.GatPoly VSS.$66.Metal1 5.60979e-06f
Cred_22884 vin4.$135.GatPoly VSS.P0.pSD 0.00300467f
Cred_22885 vin4.$135.GatPoly VSS.P15.nSD 6.41932e-05f
Cred_22886 vin4.$136.GatPoly vout4.$1358.Metal3 0.031535f
Cred_22887 vin4.$136.GatPoly vout4.$1424.Metal3 0.0255253f
Cred_22888 vin4.$136.GatPoly vout4.P12.pSD 0.000457058f
Cred_22889 vin4.$136.GatPoly vout4.P14.nSD 0.000402127f
Cred_22890 vin4.$136.GatPoly vout4.P14.pSD 0.0365848f
Cred_22891 vin4.$137.GatPoly vout4.$1358.Metal3 0.00499834f
Cred_22892 vin4.$137.GatPoly vout4.$1424.Metal3 0.00354951f
Cred_22893 vin4.$137.GatPoly vout4.P12.nSD 1.35855e-05f
Cred_22894 vin4.$137.GatPoly vout4.P14.nSD 0.00342762f
Cred_22895 vin4.$137.GatPoly vout4.P14.pSD 0.000302862f
Cred_22896 vin4.$137.GatPoly VSS.$1483.Metal1 0.0053483f
Cred_22897 vin4.$137.GatPoly VSS.$1512.Metal1 9.19509e-08f
Cred_22898 vin4.$137.GatPoly VSS.$1580.Metal1 3.44676e-09f
Cred_22899 vin4.$137.GatPoly VSS.$1991.Metal1 2.64529e-05f
Cred_22900 vin4.$137.GatPoly VSS.$2023.Metal1 6.62327e-05f
Cred_22901 vin4.$137.GatPoly VSS.$3615.Metal2 5.48618e-05f
Cred_22902 vin4.$137.GatPoly VSS.$3650.Metal2 0.00144469f
Cred_22903 vin4.$137.GatPoly VSS.$3706.Metal2 5.78817e-11f
Cred_22904 vin4.$137.GatPoly VSS.$3730.Metal2 2.87971e-11f
Cred_22905 vin4.$137.GatPoly VSS.$4241.Metal2 1.77324e-07f
Cred_22906 vin4.$137.GatPoly VSS.$66.Metal1 4.23571e-06f
Cred_22907 vin4.$137.GatPoly VSS.P0.pSD 0.00266835f
Cred_22908 vin4.$137.GatPoly VSS.P15.nSD 4.45362e-05f
Cred_22909 vin4.$14.GatPoly vout4.$1226.Metal3 0.0508176f
Cred_22910 vin4.$14.GatPoly vout4.P0.nSD 0.000803016f
Cred_22911 vin4.$14.GatPoly vout4.P0.pSD 0.00487722f
Cred_22912 vin4.$14.GatPoly vout4.P2.nSD 0.000800583f
Cred_22913 vin4.$14.GatPoly vout4.P2.pSD 0.0392747f
Cred_22914 vin4.$144.GatPoly vout4.$1358.Metal3 0.00988551f
Cred_22915 vin4.$144.GatPoly vout4.$1424.Metal3 0.0110746f
Cred_22916 vin4.$144.GatPoly vout4.P14.nSD 0.000155737f
Cred_22917 vin4.$144.GatPoly vout4.P14.pSD 0.0161545f
Cred_22918 vin4.$144.GatPoly vout4.P16.pSD 9.04344e-05f
Cred_22919 vin4.$145.GatPoly vout4.$1358.Metal3 0.00355408f
Cred_22920 vin4.$145.GatPoly vout4.$1424.Metal3 0.00373487f
Cred_22921 vin4.$145.GatPoly vout4.P14.nSD 0.00542225f
Cred_22922 vin4.$145.GatPoly vout4.P14.pSD 0.000303252f
Cred_22923 vin4.$145.GatPoly vout4.P16.nSD 1.69521e-06f
Cred_22924 vin4.$145.GatPoly VSS.$1625.Metal1 0.00049805f
Cred_22925 vin4.$145.GatPoly VSS.$1991.Metal1 4.56998e-05f
Cred_22926 vin4.$145.GatPoly VSS.$2023.Metal1 0.000114423f
Cred_22927 vin4.$145.GatPoly VSS.$3802.Metal2 6.60099e-05f
Cred_22928 vin4.$145.GatPoly VSS.$3837.Metal2 0.000150503f
Cred_22929 vin4.$145.GatPoly VSS.$4241.Metal2 3.06344e-07f
Cred_22930 vin4.$145.GatPoly VSS.$66.Metal1 5.13245e-06f
Cred_22931 vin4.$145.GatPoly VSS.P0.pSD 0.00383389f
Cred_22932 vin4.$145.GatPoly VSS.P17.nSD 1.86375e-05f
Cred_22933 vin4.$152.GatPoly vout4.$1358.Metal3 0.00887412f
Cred_22934 vin4.$152.GatPoly vout4.$1424.Metal3 0.0109896f
Cred_22935 vin4.$152.GatPoly vout4.P14.nSD 0.000139803f
Cred_22936 vin4.$152.GatPoly vout4.P14.pSD 0.0126694f
Cred_22937 vin4.$152.GatPoly vout4.P16.pSD 0.00016089f
Cred_22938 vin4.$153.GatPoly vout4.$1358.Metal3 0.000662949f
Cred_22939 vin4.$153.GatPoly vout4.$1424.Metal3 0.000984583f
Cred_22940 vin4.$153.GatPoly vout4.P14.nSD 0.000634338f
Cred_22941 vin4.$153.GatPoly vout4.P14.pSD 5.65662e-05f
Cred_22942 vin4.$153.GatPoly vout4.P16.nSD 3.01592e-06f
Cred_22943 vin4.$153.GatPoly VSS.$1625.Metal1 0.0121868f
Cred_22944 vin4.$153.GatPoly VSS.$1991.Metal1 5.42463e-05f
Cred_22945 vin4.$153.GatPoly VSS.$2023.Metal1 0.000135822f
Cred_22946 vin4.$153.GatPoly VSS.$3802.Metal2 0.000322837f
Cred_22947 vin4.$153.GatPoly VSS.$3837.Metal2 0.000736069f
Cred_22948 vin4.$153.GatPoly VSS.$4241.Metal2 3.63635e-07f
Cred_22949 vin4.$153.GatPoly VSS.$66.Metal1 3.55355e-06f
Cred_22950 vin4.$153.GatPoly VSS.P0.pSD 0.00343121f
Cred_22951 vin4.$153.GatPoly VSS.P17.nSD 0.000321264f
Cred_22952 vin4.$156.GatPoly vout4.$1358.Metal3 0.00286031f
Cred_22953 vin4.$156.GatPoly vout4.$1424.Metal3 0.0543541f
Cred_22954 vin4.$156.GatPoly vout4.P14.nSD 4.50615e-05f
Cred_22955 vin4.$156.GatPoly vout4.P14.pSD 0.000701114f
Cred_22956 vin4.$156.GatPoly vout4.P16.pSD 0.032808f
Cred_22957 vin4.$157.GatPoly vout4.$1358.Metal3 0.000689567f
Cred_22958 vin4.$157.GatPoly vout4.$1424.Metal3 0.00808297f
Cred_22959 vin4.$157.GatPoly vout4.P14.nSD 2.4449e-05f
Cred_22960 vin4.$157.GatPoly vout4.P14.pSD 5.88374e-05f
Cred_22961 vin4.$157.GatPoly vout4.P16.nSD 0.00329172f
Cred_22962 vin4.$157.GatPoly VSS.$1625.Metal1 0.0068704f
Cred_22963 vin4.$157.GatPoly VSS.$1991.Metal1 6.35814e-05f
Cred_22964 vin4.$157.GatPoly VSS.$2023.Metal1 0.000159195f
Cred_22965 vin4.$157.GatPoly VSS.$3802.Metal2 0.000577984f
Cred_22966 vin4.$157.GatPoly VSS.$3837.Metal2 0.0013178f
Cred_22967 vin4.$157.GatPoly VSS.$4241.Metal2 4.26212e-07f
Cred_22968 vin4.$157.GatPoly VSS.$66.Metal1 2.66958e-06f
Cred_22969 vin4.$157.GatPoly VSS.P0.pSD 0.00317942f
Cred_22970 vin4.$157.GatPoly VSS.P17.nSD 0.000217338f
Cred_22971 vin4.$16.GatPoly vout4.$1226.Metal3 9.75242e-08f
Cred_22972 vin4.$16.GatPoly vout4.P0.nSD 1.4123e-09f
Cred_22973 vin4.$16.GatPoly vout4.P0.pSD 7.50474e-09f
Cred_22974 vin4.$16.GatPoly vout4.P2.nSD 1.5364e-09f
Cred_22975 vin4.$16.GatPoly vout4.P2.pSD 8.39679e-09f
Cred_22976 vin4.$162.GatPoly vout4.$1424.Metal3 0.00960736f
Cred_22977 vin4.$162.GatPoly vout4.P16.pSD 0.00750068f
Cred_22978 vin4.$165.GatPoly vout4 2.45242e-05f
Cred_22979 vin4.$165.GatPoly vout4.$1424.Metal3 0.00809357f
Cred_22980 vin4.$165.GatPoly vout4.P16.nSD 0.00541443f
Cred_22981 vin4.$165.GatPoly vout4.P18.nSD 3.45556e-06f
Cred_22982 vin4.$165.GatPoly vout4.P18.pSD 1.05536e-05f
Cred_22983 vin4.$165.GatPoly VSS.$1800.Metal1 0.000453293f
Cred_22984 vin4.$165.GatPoly VSS.$1991.Metal1 9.62957e-05f
Cred_22985 vin4.$165.GatPoly VSS.$2023.Metal1 0.000241105f
Cred_22986 vin4.$165.GatPoly VSS.$4000.Metal2 0.000110826f
Cred_22987 vin4.$165.GatPoly VSS.$4032.Metal2 8.25299e-05f
Cred_22988 vin4.$165.GatPoly VSS.$4241.Metal2 6.45509e-07f
Cred_22989 vin4.$165.GatPoly VSS.$66.Metal1 2.71637e-06f
Cred_22990 vin4.$165.GatPoly VSS.P0.pSD 0.00389309f
Cred_22991 vin4.$165.GatPoly VSS.P19.nSD 1.69634e-05f
Cred_22992 vin4.$166.GatPoly vout4 0.000917059f
Cred_22993 vin4.$166.GatPoly vout4.$1424.Metal3 0.0594151f
Cred_22994 vin4.$166.GatPoly vout4.P16.pSD 0.0353919f
Cred_22995 vin4.$166.GatPoly vout4.P18.nSD 7.28651e-05f
Cred_22996 vin4.$166.GatPoly vout4.P18.pSD 0.000851701f
Cred_22997 vin4.$17.GatPoly vout4.$1226.Metal3 0.00169532f
Cred_22998 vin4.$17.GatPoly vout4.P0.nSD 3.44551e-05f
Cred_22999 vin4.$17.GatPoly vout4.P0.pSD 0.000152976f
Cred_23000 vin4.$17.GatPoly vout4.P2.nSD 0.000738215f
Cred_23001 vin4.$17.GatPoly vout4.P2.pSD 0.000145967f
Cred_23002 vin4.$17.GatPoly VSS.$1991.Metal1 4.13632e-07f
Cred_23003 vin4.$17.GatPoly VSS.$2023.Metal1 1.03565e-06f
Cred_23004 vin4.$17.GatPoly VSS.$2544.Metal2 0.0004027f
Cred_23005 vin4.$17.GatPoly VSS.$2576.Metal2 0.000540801f
Cred_23006 vin4.$17.GatPoly VSS.$2632.Metal2 3.40456e-08f
Cred_23007 vin4.$17.GatPoly VSS.$387.Metal1 0.00935976f
Cred_23008 vin4.$17.GatPoly VSS.$4241.Metal2 2.77274e-09f
Cred_23009 vin4.$17.GatPoly VSS.$4520.Metal3 2.66708e-10f
Cred_23010 vin4.$17.GatPoly VSS.$465.Metal1 1.61848e-06f
Cred_23011 vin4.$17.GatPoly VSS.$513.Metal1 9.35005e-08f
Cred_23012 vin4.$17.GatPoly VSS.$66.Metal1 0.000349646f
Cred_23013 vin4.$17.GatPoly VSS.P0.pSD 0.00280538f
Cred_23014 vin4.$17.GatPoly VSS.P3.nSD 0.000255668f
Cred_23015 vin4.$172.GatPoly vout4.$1424.Metal3 1.16374e-07f
Cred_23016 vin4.$173.GatPoly vout4 5.48779e-05f
Cred_23017 vin4.$173.GatPoly vout4.$1424.Metal3 0.0019692f
Cred_23018 vin4.$173.GatPoly vout4.P16.nSD 0.000711506f
Cred_23019 vin4.$173.GatPoly vout4.P18.nSD 7.73254e-06f
Cred_23020 vin4.$173.GatPoly vout4.P18.pSD 2.36159e-05f
Cred_23021 vin4.$173.GatPoly VSS.$1739.Metal1 9.35005e-08f
Cred_23022 vin4.$173.GatPoly VSS.$1787.Metal1 1.61848e-06f
Cred_23023 vin4.$173.GatPoly VSS.$1800.Metal1 0.00977471f
Cred_23024 vin4.$173.GatPoly VSS.$1991.Metal1 9.20342e-05f
Cred_23025 vin4.$173.GatPoly VSS.$2023.Metal1 0.000230435f
Cred_23026 vin4.$173.GatPoly VSS.$3941.Metal2 3.40456e-08f
Cred_23027 vin4.$173.GatPoly VSS.$4000.Metal2 0.000562129f
Cred_23028 vin4.$173.GatPoly VSS.$4032.Metal2 0.000418582f
Cred_23029 vin4.$173.GatPoly VSS.$4241.Metal2 6.16942e-07f
Cred_23030 vin4.$173.GatPoly VSS.$5132.Metal3 2.66708e-10f
Cred_23031 vin4.$173.GatPoly VSS.$66.Metal1 1.57436e-06f
Cred_23032 vin4.$173.GatPoly VSS.P0.pSD 0.00283182f
Cred_23033 vin4.$173.GatPoly VSS.P19.nSD 0.00027123f
Cred_23034 vin4.$177.GatPoly vout4 9.62364e-05f
Cred_23035 vin4.$177.GatPoly vout4.$1424.Metal3 0.000765661f
Cred_23036 vin4.$177.GatPoly vout4.P16.nSD 2.62829e-06f
Cred_23037 vin4.$177.GatPoly vout4.P18.nSD 0.000256822f
Cred_23038 vin4.$177.GatPoly vout4.P18.pSD 4.14139e-05f
Cred_23039 vin4.$177.GatPoly VSS.$1800.Metal1 0.00875726f
Cred_23040 vin4.$177.GatPoly VSS.$1878.Metal1 3.65208e-06f
Cred_23041 vin4.$177.GatPoly VSS.$1991.Metal1 9.99276e-05f
Cred_23042 vin4.$177.GatPoly VSS.$2023.Metal1 0.000250198f
Cred_23043 vin4.$177.GatPoly VSS.$4000.Metal2 0.000313817f
Cred_23044 vin4.$177.GatPoly VSS.$4032.Metal2 0.000233724f
Cred_23045 vin4.$177.GatPoly VSS.$4080.Metal2 1.82757e-08f
Cred_23046 vin4.$177.GatPoly VSS.$4241.Metal2 6.69855e-07f
Cred_23047 vin4.$177.GatPoly VSS.$5168.Metal3 1.46531e-10f
Cred_23048 vin4.$177.GatPoly VSS.$66.Metal1 1.2188e-06f
Cred_23049 vin4.$177.GatPoly VSS.P0.pSD 0.00254932f
Cred_23050 vin4.$177.GatPoly VSS.P19.nSD 0.000232966f
Cred_23051 vin4.$178.GatPoly vout4 0.00802799f
Cred_23052 vin4.$178.GatPoly vout4.$1424.Metal3 0.0455281f
Cred_23053 vin4.$178.GatPoly vout4.P16.pSD 0.000356917f
Cred_23054 vin4.$178.GatPoly vout4.P18.nSD 0.000637866f
Cred_23055 vin4.$178.GatPoly vout4.P18.pSD 0.038301f
Cred_23056 vin4.$178.GatPoly VSS.$4152.Metal2 0.000109957f
Cred_23057 vin4.$181.GatPoly vout4 0.00145658f
Cred_23058 vin4.$181.GatPoly vout4.$1424.Metal3 0.00762653f
Cred_23059 vin4.$181.GatPoly vout4.P16.nSD 2.62829e-06f
Cred_23060 vin4.$181.GatPoly vout4.P18.nSD 0.00567469f
Cred_23061 vin4.$181.GatPoly vout4.P18.pSD 0.000626818f
Cred_23062 vin4.$181.GatPoly VSS.$1800.Metal1 0.00053061f
Cred_23063 vin4.$181.GatPoly VSS.$1926.Metal1 2.21677e-05f
Cred_23064 vin4.$181.GatPoly VSS.$1986.Metal1 2.28935e-05f
Cred_23065 vin4.$181.GatPoly VSS.$1991.Metal1 0.000246669f
Cred_23066 vin4.$181.GatPoly VSS.$2023.Metal1 0.000835746f
Cred_23067 vin4.$181.GatPoly VSS.$4000.Metal2 2.72725e-05f
Cred_23068 vin4.$181.GatPoly VSS.$4032.Metal2 2.03093e-05f
Cred_23069 vin4.$181.GatPoly VSS.$4128.Metal2 2.03611e-06f
Cred_23070 vin4.$181.GatPoly VSS.$4152.Metal2 1.9141e-07f
Cred_23071 vin4.$181.GatPoly VSS.$4241.Metal2 6.8619e-06f
Cred_23072 vin4.$181.GatPoly VSS.$66.Metal1 1.76328e-06f
Cred_23073 vin4.$181.GatPoly VSS.P0.pSD 0.00459525f
Cred_23074 vin4.$181.GatPoly VSS.P1.GatPoly 0.000406711f
Cred_23075 vin4.$181.GatPoly VSS.P19.nSD 1.99003e-05f
Cred_23076 vin4.$181.GatPoly VSS.P21.nSD 1.46261e-06f
Cred_23077 vin4.$181.GatPoly VSS.P23.nSD 1.46261e-06f
Cred_23078 vin4.$202.Metal1 vout4.$1226.Metal3 0.0619989f
Cred_23079 vin4.$202.Metal1 vout4.P0.nSD 0.00184613f
Cred_23080 vin4.$202.Metal1 vout4.P0.pSD 0.0676836f
Cred_23081 vin4.$202.Metal1 vout4.P2.nSD 0.000976734f
Cred_23082 vin4.$202.Metal1 vout4.P2.pSD 0.00533807f
Cred_23083 vin4.$202.Metal1 VSS.$1991.Metal1 6.47607e-08f
Cred_23084 vin4.$202.Metal1 VSS.$2023.Metal1 1.62148e-07f
Cred_23085 vin4.$202.Metal1 VSS.$2421.Metal2 1.07689e-05f
Cred_23086 vin4.$202.Metal1 VSS.$2445.Metal2 7.89696e-06f
Cred_23087 vin4.$202.Metal1 VSS.$4241.Metal2 4.34117e-10f
Cred_23088 vin4.$202.Metal1 VSS.$4364.Metal3 0.000425406f
Cred_23089 vin4.$202.Metal1 VSS.$4424.Metal3 0.00134312f
Cred_23090 vin4.$202.Metal1 VSS.$4460.Metal3 0.000984932f
Cred_23091 vin4.$202.Metal1 VSS.$66.Metal1 0.000561131f
Cred_23092 vin4.$202.Metal1 VSS.P0.GatPoly 8.90637e-05f
Cred_23093 vin4.$202.Metal1 VSS.P0.pSD 0.00107507f
Cred_23094 vin4.$203.Metal1 vout4.$1226.Metal3 0.0308776f
Cred_23095 vin4.$203.Metal1 vout4.P0.nSD 0.0281766f
Cred_23096 vin4.$203.Metal1 vout4.P0.pSD 0.00487564f
Cred_23097 vin4.$203.Metal1 vout4.P2.nSD 0.000487838f
Cred_23098 vin4.$203.Metal1 vout4.P2.pSD 0.00265855f
Cred_23099 vin4.$203.Metal1 VSS.$160.Metal1 0.0009827f
Cred_23100 vin4.$203.Metal1 VSS.$1991.Metal1 5.81131e-06f
Cred_23101 vin4.$203.Metal1 VSS.$2023.Metal1 1.45504e-05f
Cred_23102 vin4.$203.Metal1 VSS.$2240.Metal2 0.00203318f
Cred_23103 vin4.$203.Metal1 VSS.$2360.Metal2 1.87708e-05f
Cred_23104 vin4.$203.Metal1 VSS.$2421.Metal2 0.000145294f
Cred_23105 vin4.$203.Metal1 VSS.$2445.Metal2 0.00014213f
Cred_23106 vin4.$203.Metal1 VSS.$2493.Metal2 2.30851e-05f
Cred_23107 vin4.$203.Metal1 VSS.$2544.Metal2 0.00027649f
Cred_23108 vin4.$203.Metal1 VSS.$2576.Metal2 0.000340553f
Cred_23109 vin4.$203.Metal1 VSS.$266.Metal1 0.000632286f
Cred_23110 vin4.$203.Metal1 VSS.$326.Metal1 0.00075064f
Cred_23111 vin4.$203.Metal1 VSS.$374.Metal1 0.00151066f
Cred_23112 vin4.$203.Metal1 VSS.$387.Metal1 0.006826f
Cred_23113 vin4.$203.Metal1 VSS.$4241.Metal2 3.89556e-08f
Cred_23114 vin4.$203.Metal1 VSS.$4364.Metal3 0.000225147f
Cred_23115 vin4.$203.Metal1 VSS.$4424.Metal3 1.66269e-07f
Cred_23116 vin4.$203.Metal1 VSS.$4484.Metal3 1.75811e-07f
Cred_23117 vin4.$203.Metal1 VSS.$66.Metal1 0.0119916f
Cred_23118 vin4.$203.Metal1 VSS.P0.GatPoly 0.00157389f
Cred_23119 vin4.$203.Metal1 VSS.P0.nSD 6.29583e-06f
Cred_23120 vin4.$203.Metal1 VSS.P0.pSD 0.0559358f
Cred_23121 vin4.$203.Metal1 VSS.P1.nSD 6.29583e-06f
Cred_23122 vin4.$203.Metal1 VSS.P3.nSD 0.000253611f
Cred_23123 vin4.$206.Metal1 vout4.$1226.Metal3 8.52779e-06f
Cred_23124 vin4.$206.Metal1 vout4.P0.nSD 2.53931e-07f
Cred_23125 vin4.$206.Metal1 vout4.P0.pSD 1.34935e-06f
Cred_23126 vin4.$206.Metal1 vout4.P2.nSD 1.34347e-07f
Cred_23127 vin4.$206.Metal1 vout4.P2.pSD 7.34239e-07f
Cred_23128 vin4.$210.Metal1 vout4.$1226.Metal3 8.17381e-06f
Cred_23129 vin4.$210.Metal1 vout4.P0.nSD 1.1837e-07f
Cred_23130 vin4.$210.Metal1 vout4.P0.pSD 6.28996e-07f
Cred_23131 vin4.$210.Metal1 vout4.P2.nSD 1.28771e-07f
Cred_23132 vin4.$210.Metal1 vout4.P2.pSD 7.03761e-07f
Cred_23133 vin4.$211.Metal1 vout4.$1226.Metal3 1.23751e-05f
Cred_23134 vin4.$211.Metal1 vout4.P0.nSD 2.43471e-07f
Cred_23135 vin4.$211.Metal1 vout4.P0.pSD 1.29377e-06f
Cred_23136 vin4.$211.Metal1 vout4.P2.nSD 1.94958e-07f
Cred_23137 vin4.$211.Metal1 vout4.P2.pSD 1.06549e-06f
Cred_23138 vin4.$211.Metal1 VSS.$1991.Metal1 2.98062e-06f
Cred_23139 vin4.$211.Metal1 VSS.$2023.Metal1 7.46286e-06f
Cred_23140 vin4.$211.Metal1 VSS.$2493.Metal2 1.53248e-06f
Cred_23141 vin4.$211.Metal1 VSS.$2544.Metal2 0.00154814f
Cred_23142 vin4.$211.Metal1 VSS.$2576.Metal2 0.00207838f
Cred_23143 vin4.$211.Metal1 VSS.$2632.Metal2 2.85347e-06f
Cred_23144 vin4.$211.Metal1 VSS.$374.Metal1 0.000306238f
Cred_23145 vin4.$211.Metal1 VSS.$387.Metal1 0.0419833f
Cred_23146 vin4.$211.Metal1 VSS.$4241.Metal2 1.99803e-08f
Cred_23147 vin4.$211.Metal1 VSS.$4484.Metal3 1.22871e-08f
Cred_23148 vin4.$211.Metal1 VSS.$4520.Metal3 2.23536e-08f
Cred_23149 vin4.$211.Metal1 VSS.$465.Metal1 0.00013565f
Cred_23150 vin4.$211.Metal1 VSS.$513.Metal1 7.83657e-06f
Cred_23151 vin4.$211.Metal1 VSS.$66.Metal1 0.00297087f
Cred_23152 vin4.$211.Metal1 VSS.P0.pSD 0.0217349f
Cred_23153 vin4.$211.Metal1 VSS.P3.nSD 0.00156422f
Cred_23154 vin4.$218.Metal1 vout4.$1226.Metal3 0.00483512f
Cred_23155 vin4.$218.Metal1 vout4.P0.nSD 7.00202e-05f
Cred_23156 vin4.$218.Metal1 vout4.P0.pSD 0.000372076f
Cred_23157 vin4.$218.Metal1 vout4.P2.nSD 7.61729e-05f
Cred_23158 vin4.$218.Metal1 vout4.P2.pSD 0.00423958f
Cred_23159 vin4.$219.Metal1 vout4.$1226.Metal3 0.00095452f
Cred_23160 vin4.$219.Metal1 vout4.P0.nSD 1.90611e-05f
Cred_23161 vin4.$219.Metal1 vout4.P0.pSD 8.53615e-05f
Cred_23162 vin4.$219.Metal1 vout4.P2.nSD 0.000391345f
Cred_23163 vin4.$219.Metal1 vout4.P2.pSD 8.21837e-05f
Cred_23164 vin4.$219.Metal1 VSS.$1991.Metal1 2.63095e-06f
Cred_23165 vin4.$219.Metal1 VSS.$2023.Metal1 6.58736e-06f
Cred_23166 vin4.$219.Metal1 VSS.$2544.Metal2 0.000371147f
Cred_23167 vin4.$219.Metal1 VSS.$2576.Metal2 0.000518159f
Cred_23168 vin4.$219.Metal1 VSS.$2632.Metal2 2.09779e-05f
Cred_23169 vin4.$219.Metal1 VSS.$387.Metal1 0.00768135f
Cred_23170 vin4.$219.Metal1 VSS.$4241.Metal2 1.76363e-08f
Cred_23171 vin4.$219.Metal1 VSS.$4520.Metal3 1.58436e-07f
Cred_23172 vin4.$219.Metal1 VSS.$465.Metal1 0.00212675f
Cred_23173 vin4.$219.Metal1 VSS.$513.Metal1 0.000145714f
Cred_23174 vin4.$219.Metal1 VSS.$66.Metal1 0.00196061f
Cred_23175 vin4.$219.Metal1 VSS.P0.pSD 0.0168856f
Cred_23176 vin4.$219.Metal1 VSS.P3.nSD 0.000293242f
Cred_23177 vin4.$223.Metal1 vout4.$1226.Metal3 0.0137326f
Cred_23178 vin4.$223.Metal1 vout4.P0.nSD 0.00020121f
Cred_23179 vin4.$223.Metal1 vout4.P0.pSD 0.00106208f
Cred_23180 vin4.$223.Metal1 vout4.P2.nSD 0.0131392f
Cred_23181 vin4.$223.Metal1 vout4.P2.pSD 0.00118237f
Cred_23182 vin4.$223.Metal1 VSS.$1991.Metal1 3.06394e-06f
Cred_23183 vin4.$223.Metal1 VSS.$2023.Metal1 7.67148e-06f
Cred_23184 vin4.$223.Metal1 VSS.$2544.Metal2 4.36492e-05f
Cred_23185 vin4.$223.Metal1 VSS.$2576.Metal2 5.86146e-05f
Cred_23186 vin4.$223.Metal1 VSS.$2632.Metal2 4.42291e-06f
Cred_23187 vin4.$223.Metal1 VSS.$387.Metal1 0.000239742f
Cred_23188 vin4.$223.Metal1 VSS.$4241.Metal2 2.05388e-08f
Cred_23189 vin4.$223.Metal1 VSS.$465.Metal1 0.000598552f
Cred_23190 vin4.$223.Metal1 VSS.$513.Metal1 0.000529433f
Cred_23191 vin4.$223.Metal1 VSS.$66.Metal1 0.00171414f
Cred_23192 vin4.$223.Metal1 VSS.P0.pSD 0.0172801f
Cred_23193 vin4.$223.Metal1 VSS.P3.nSD 8.97176e-06f
Cred_23194 vin4.$226.Metal1 vout4.$1226.Metal3 0.0232307f
Cred_23195 vin4.$226.Metal1 vout4.P0.nSD 0.000336417f
Cred_23196 vin4.$226.Metal1 vout4.P0.pSD 0.00178766f
Cred_23197 vin4.$226.Metal1 vout4.P2.nSD 0.000365978f
Cred_23198 vin4.$226.Metal1 vout4.P2.pSD 0.0242275f
Cred_23199 vin4.$229.Metal1 vout4.$1226.Metal3 0.0162804f
Cred_23200 vin4.$229.Metal1 vout4.P0.nSD 0.000235765f
Cred_23201 vin4.$229.Metal1 vout4.P0.pSD 0.00125282f
Cred_23202 vin4.$229.Metal1 vout4.P2.nSD 0.0156675f
Cred_23203 vin4.$229.Metal1 vout4.P2.pSD 0.00140173f
Cred_23204 vin4.$229.Metal1 VSS.$1991.Metal1 3.4995e-06f
Cred_23205 vin4.$229.Metal1 VSS.$2023.Metal1 8.76205e-06f
Cred_23206 vin4.$229.Metal1 VSS.$2680.Metal2 3.39178e-05f
Cred_23207 vin4.$229.Metal1 VSS.$2739.Metal2 1.44928e-05f
Cred_23208 vin4.$229.Metal1 VSS.$2771.Metal2 2.33344e-06f
Cred_23209 vin4.$229.Metal1 VSS.$4241.Metal2 2.34586e-08f
Cred_23210 vin4.$229.Metal1 VSS.$4568.Metal3 7.35435e-08f
Cred_23211 vin4.$229.Metal1 VSS.$553.Metal1 7.35435e-08f
Cred_23212 vin4.$229.Metal1 VSS.$566.Metal1 6.60482e-07f
Cred_23213 vin4.$229.Metal1 VSS.$66.Metal1 0.00153691f
Cred_23214 vin4.$229.Metal1 VSS.P0.pSD 0.017664f
Cred_23215 vin4.$229.Metal1 VSS.P5.nSD 2.29316e-08f
Cred_23216 vin4.$23.GatPoly vout4.$1226.Metal3 0.00680273f
Cred_23217 vin4.$23.GatPoly vout4.P0.nSD 0.00010294f
Cred_23218 vin4.$23.GatPoly vout4.P0.pSD 0.00053355f
Cred_23219 vin4.$23.GatPoly vout4.P2.nSD 0.0055216f
Cred_23220 vin4.$23.GatPoly vout4.P2.pSD 0.000585712f
Cred_23221 vin4.$23.GatPoly VSS.$1991.Metal1 7.14196e-07f
Cred_23222 vin4.$23.GatPoly VSS.$2023.Metal1 1.7882e-06f
Cred_23223 vin4.$23.GatPoly VSS.$2544.Metal2 8.25299e-05f
Cred_23224 vin4.$23.GatPoly VSS.$2576.Metal2 0.000110826f
Cred_23225 vin4.$23.GatPoly VSS.$387.Metal1 0.000453293f
Cred_23226 vin4.$23.GatPoly VSS.$4241.Metal2 4.78754e-09f
Cred_23227 vin4.$23.GatPoly VSS.$66.Metal1 0.000365835f
Cred_23228 vin4.$23.GatPoly VSS.P0.pSD 0.00386551f
Cred_23229 vin4.$23.GatPoly VSS.P3.nSD 1.69634e-05f
Cred_23230 vin4.$232.Metal1 vout4.$1226.Metal3 0.00390011f
Cred_23231 vin4.$232.Metal1 vout4.P0.nSD 5.64797e-05f
Cred_23232 vin4.$232.Metal1 vout4.P0.pSD 0.000300124f
Cred_23233 vin4.$232.Metal1 vout4.P2.nSD 6.14426e-05f
Cred_23234 vin4.$232.Metal1 vout4.P2.pSD 0.00325896f
Cred_23235 vin4.$233.Metal1 vout4.$1226.Metal3 0.00029252f
Cred_23236 vin4.$233.Metal1 vout4.P0.nSD 4.23614e-06f
Cred_23237 vin4.$233.Metal1 vout4.P0.pSD 2.25102e-05f
Cred_23238 vin4.$233.Metal1 vout4.P2.nSD 8.68854e-05f
Cred_23239 vin4.$233.Metal1 vout4.P2.pSD 2.51858e-05f
Cred_23240 vin4.$233.Metal1 VSS.$1991.Metal1 2.66606e-06f
Cred_23241 vin4.$233.Metal1 VSS.$2023.Metal1 6.67527e-06f
Cred_23242 vin4.$233.Metal1 VSS.$2680.Metal2 4.38787e-05f
Cred_23243 vin4.$233.Metal1 VSS.$2739.Metal2 2.81555e-05f
Cred_23244 vin4.$233.Metal1 VSS.$2771.Metal2 4.53323e-06f
Cred_23245 vin4.$233.Metal1 VSS.$4241.Metal2 1.78716e-08f
Cred_23246 vin4.$233.Metal1 VSS.$4568.Metal3 1.42875e-07f
Cred_23247 vin4.$233.Metal1 VSS.$513.Metal1 0.000407947f
Cred_23248 vin4.$233.Metal1 VSS.$553.Metal1 0.00101873f
Cred_23249 vin4.$233.Metal1 VSS.$566.Metal1 1.28313e-06f
Cred_23250 vin4.$233.Metal1 VSS.$66.Metal1 0.000939203f
Cred_23251 vin4.$233.Metal1 VSS.P0.pSD 0.0121624f
Cred_23252 vin4.$233.Metal1 VSS.P5.nSD 4.45497e-08f
Cred_23253 vin4.$236.Metal1 vout4.$1226.Metal3 3.55807e-05f
Cred_23254 vin4.$236.Metal1 vout4.P0.nSD 5.15264e-07f
Cred_23255 vin4.$236.Metal1 vout4.P0.pSD 2.73803e-06f
Cred_23256 vin4.$236.Metal1 vout4.P2.nSD 5.60541e-07f
Cred_23257 vin4.$236.Metal1 vout4.P2.pSD 3.06348e-06f
Cred_23258 vin4.$237.Metal1 vout4.$1226.Metal3 0.000124248f
Cred_23259 vin4.$237.Metal1 vout4.P0.nSD 1.79931e-06f
Cred_23260 vin4.$237.Metal1 vout4.P0.pSD 9.56121e-06f
Cred_23261 vin4.$237.Metal1 vout4.P2.nSD 1.26286e-05f
Cred_23262 vin4.$237.Metal1 vout4.P2.pSD 1.06977e-05f
Cred_23263 vin4.$237.Metal1 VSS.$1991.Metal1 2.96102e-06f
Cred_23264 vin4.$237.Metal1 VSS.$2023.Metal1 7.41379e-06f
Cred_23265 vin4.$237.Metal1 VSS.$2680.Metal2 2.79061e-05f
Cred_23266 vin4.$237.Metal1 VSS.$2739.Metal2 0.000725046f
Cred_23267 vin4.$237.Metal1 VSS.$2771.Metal2 0.000310638f
Cred_23268 vin4.$237.Metal1 VSS.$4241.Metal2 1.98489e-08f
Cred_23269 vin4.$237.Metal1 VSS.$4568.Metal3 1.3464e-07f
Cred_23270 vin4.$237.Metal1 VSS.$553.Metal1 1.3464e-07f
Cred_23271 vin4.$237.Metal1 VSS.$566.Metal1 0.0117113f
Cred_23272 vin4.$237.Metal1 VSS.$66.Metal1 0.000888765f
Cred_23273 vin4.$237.Metal1 VSS.P0.pSD 0.0125409f
Cred_23274 vin4.$237.Metal1 VSS.P5.nSD 0.000424836f
Cred_23275 vin4.$24.GatPoly vout4.$1226.Metal3 0.0493491f
Cred_23276 vin4.$24.GatPoly vout4.P0.nSD 0.000629834f
Cred_23277 vin4.$24.GatPoly vout4.P0.pSD 0.00334683f
Cred_23278 vin4.$24.GatPoly vout4.P2.nSD 0.000685178f
Cred_23279 vin4.$24.GatPoly vout4.P2.pSD 0.0359824f
Cred_23280 vin4.$24.GatPoly vout4.P4.pSD 0.000411545f
Cred_23281 vin4.$241.Metal1 VSS.$1991.Metal1 4.68251e-06f
Cred_23282 vin4.$241.Metal1 VSS.$2023.Metal1 1.17241e-05f
Cred_23283 vin4.$241.Metal1 VSS.$2739.Metal2 0.00225701f
Cred_23284 vin4.$241.Metal1 VSS.$2771.Metal2 0.000989916f
Cred_23285 vin4.$241.Metal1 VSS.$4241.Metal2 3.13888e-08f
Cred_23286 vin4.$241.Metal1 VSS.$566.Metal1 0.0375483f
Cred_23287 vin4.$241.Metal1 VSS.$66.Metal1 0.00111175f
Cred_23288 vin4.$241.Metal1 VSS.P0.pSD 0.0177548f
Cred_23289 vin4.$241.Metal1 VSS.P5.nSD 0.00140626f
Cred_23290 vin4.$246.Metal1 vout4.$1226.Metal3 0.010864f
Cred_23291 vin4.$246.Metal1 vout4.P0.nSD 1.32332e-05f
Cred_23292 vin4.$246.Metal1 vout4.P0.pSD 7.0319e-05f
Cred_23293 vin4.$246.Metal1 vout4.P2.nSD 1.4396e-05f
Cred_23294 vin4.$246.Metal1 vout4.P2.pSD 0.000155297f
Cred_23295 vin4.$246.Metal1 vout4.P4.pSD 0.00613201f
Cred_23296 vin4.$247.Metal1 vout4.$1226.Metal3 0.000947268f
Cred_23297 vin4.$247.Metal1 vout4.P0.nSD 2.06442e-06f
Cred_23298 vin4.$247.Metal1 vout4.P0.pSD 1.097e-05f
Cred_23299 vin4.$247.Metal1 vout4.P2.nSD 3.84091e-06f
Cred_23300 vin4.$247.Metal1 vout4.P2.pSD 1.22739e-05f
Cred_23301 vin4.$247.Metal1 vout4.P4.nSD 0.00032997f
Cred_23302 vin4.$247.Metal1 VSS.$1991.Metal1 5.23995e-06f
Cred_23303 vin4.$247.Metal1 VSS.$2023.Metal1 1.31198e-05f
Cred_23304 vin4.$247.Metal1 VSS.$2739.Metal2 0.000697698f
Cred_23305 vin4.$247.Metal1 VSS.$2771.Metal2 0.000309797f
Cred_23306 vin4.$247.Metal1 VSS.$2795.Metal2 4.46721e-05f
Cred_23307 vin4.$247.Metal1 VSS.$4241.Metal2 3.51255e-08f
Cred_23308 vin4.$247.Metal1 VSS.$566.Metal1 0.0100393f
Cred_23309 vin4.$247.Metal1 VSS.$66.Metal1 0.00097707f
Cred_23310 vin4.$247.Metal1 VSS.$672.Metal1 0.00074865f
Cred_23311 vin4.$247.Metal1 VSS.P0.pSD 0.0177243f
Cred_23312 vin4.$247.Metal1 VSS.P5.nSD 0.000359912f
Cred_23313 vin4.$25.GatPoly vout4.$1226.Metal3 0.00764466f
Cred_23314 vin4.$25.GatPoly vout4.P0.nSD 8.97252e-05f
Cred_23315 vin4.$25.GatPoly vout4.P0.pSD 0.000476785f
Cred_23316 vin4.$25.GatPoly vout4.P2.nSD 0.00338933f
Cred_23317 vin4.$25.GatPoly vout4.P2.pSD 0.000533457f
Cred_23318 vin4.$25.GatPoly vout4.P4.nSD 1.35855e-05f
Cred_23319 vin4.$25.GatPoly VSS.$1991.Metal1 7.02156e-07f
Cred_23320 vin4.$25.GatPoly VSS.$2023.Metal1 1.75806e-06f
Cred_23321 vin4.$25.GatPoly VSS.$2739.Metal2 0.0013178f
Cred_23322 vin4.$25.GatPoly VSS.$2771.Metal2 0.000577984f
Cred_23323 vin4.$25.GatPoly VSS.$4241.Metal2 4.70684e-09f
Cred_23324 vin4.$25.GatPoly VSS.$566.Metal1 0.0068704f
Cred_23325 vin4.$25.GatPoly VSS.$66.Metal1 0.000241551f
Cred_23326 vin4.$25.GatPoly VSS.P0.pSD 0.00316128f
Cred_23327 vin4.$25.GatPoly VSS.P5.nSD 0.000217338f
Cred_23328 vin4.$250.Metal1 vout4.$1226.Metal3 0.0205824f
Cred_23329 vin4.$250.Metal1 vout4.P0.nSD 7.43821e-06f
Cred_23330 vin4.$250.Metal1 vout4.P0.pSD 3.95254e-05f
Cred_23331 vin4.$250.Metal1 vout4.P2.nSD 8.09181e-06f
Cred_23332 vin4.$250.Metal1 vout4.P2.pSD 8.72905e-05f
Cred_23333 vin4.$250.Metal1 vout4.P4.pSD 0.0144287f
Cred_23334 vin4.$251.Metal1 vout4.$1226.Metal3 0.0147902f
Cred_23335 vin4.$251.Metal1 vout4.P0.nSD 1.16038e-06f
Cred_23336 vin4.$251.Metal1 vout4.P0.pSD 6.16608e-06f
Cred_23337 vin4.$251.Metal1 vout4.P2.nSD 2.15893e-06f
Cred_23338 vin4.$251.Metal1 vout4.P2.pSD 6.89901e-06f
Cred_23339 vin4.$251.Metal1 vout4.P4.nSD 0.0108783f
Cred_23340 vin4.$251.Metal1 VSS.$1991.Metal1 5.96914e-06f
Cred_23341 vin4.$251.Metal1 VSS.$2023.Metal1 1.49455e-05f
Cred_23342 vin4.$251.Metal1 VSS.$2739.Metal2 7.95992e-05f
Cred_23343 vin4.$251.Metal1 VSS.$2771.Metal2 3.6165e-05f
Cred_23344 vin4.$251.Metal1 VSS.$2795.Metal2 1.2149e-05f
Cred_23345 vin4.$251.Metal1 VSS.$4241.Metal2 4.00135e-08f
Cred_23346 vin4.$251.Metal1 VSS.$566.Metal1 0.000479229f
Cred_23347 vin4.$251.Metal1 VSS.$66.Metal1 0.000846518f
Cred_23348 vin4.$251.Metal1 VSS.$672.Metal1 0.00115729f
Cred_23349 vin4.$251.Metal1 VSS.P0.pSD 0.0177188f
Cred_23350 vin4.$251.Metal1 VSS.P5.nSD 9.85719e-06f
Cred_23351 vin4.$258.Metal1 vout4.$1226.Metal3 0.0209774f
Cred_23352 vin4.$258.Metal1 vout4.P4.pSD 0.0170573f
Cred_23353 vin4.$259.Metal1 vout4.$1226.Metal3 0.0211493f
Cred_23354 vin4.$259.Metal1 vout4.P4.nSD 0.0169439f
Cred_23355 vin4.$259.Metal1 VSS.$1991.Metal1 6.54217e-06f
Cred_23356 vin4.$259.Metal1 VSS.$2023.Metal1 1.63803e-05f
Cred_23357 vin4.$259.Metal1 VSS.$2843.Metal2 5.83555e-07f
Cred_23358 vin4.$259.Metal1 VSS.$2867.Metal2 1.35373e-05f
Cred_23359 vin4.$259.Metal1 VSS.$2926.Metal2 1.70451e-05f
Cred_23360 vin4.$259.Metal1 VSS.$2958.Metal2 5.85163e-07f
Cred_23361 vin4.$259.Metal1 VSS.$4241.Metal2 4.38548e-08f
Cred_23362 vin4.$259.Metal1 VSS.$4652.Metal3 1.31152e-08f
Cred_23363 vin4.$259.Metal1 VSS.$66.Metal1 0.000736286f
Cred_23364 vin4.$259.Metal1 VSS.$672.Metal1 6.98466e-05f
Cred_23365 vin4.$259.Metal1 VSS.$740.Metal1 0.000154212f
Cred_23366 vin4.$259.Metal1 VSS.$785.Metal1 1.48819e-06f
Cred_23367 vin4.$259.Metal1 VSS.P0.pSD 0.0173878f
Cred_23368 vin4.$259.Metal1 VSS.P7.nSD 8.70293e-09f
Cred_23369 vin4.$26.GatPoly vout4.$1226.Metal3 0.00841927f
Cred_23370 vin4.$26.GatPoly vout4.P0.nSD 0.000121924f
Cred_23371 vin4.$26.GatPoly vout4.P0.pSD 0.000647885f
Cred_23372 vin4.$26.GatPoly vout4.P2.nSD 0.000132638f
Cred_23373 vin4.$26.GatPoly vout4.P2.pSD 0.00828964f
Cred_23374 vin4.$262.Metal1 vout4.$1226.Metal3 0.00135071f
Cred_23375 vin4.$262.Metal1 vout4.P4.pSD 0.000374822f
Cred_23376 vin4.$263.Metal1 vout4.$1226.Metal3 0.000396588f
Cred_23377 vin4.$263.Metal1 vout4.P4.nSD 0.000133051f
Cred_23378 vin4.$263.Metal1 VSS.$1991.Metal1 5.22282e-06f
Cred_23379 vin4.$263.Metal1 VSS.$2023.Metal1 1.30769e-05f
Cred_23380 vin4.$263.Metal1 VSS.$2843.Metal2 5.40074e-06f
Cred_23381 vin4.$263.Metal1 VSS.$2867.Metal2 6.31661e-05f
Cred_23382 vin4.$263.Metal1 VSS.$2926.Metal2 7.22346e-05f
Cred_23383 vin4.$263.Metal1 VSS.$2958.Metal2 2.48028e-06f
Cred_23384 vin4.$263.Metal1 VSS.$4241.Metal2 3.50107e-08f
Cred_23385 vin4.$263.Metal1 VSS.$4652.Metal3 5.54875e-08f
Cred_23386 vin4.$263.Metal1 VSS.$66.Metal1 0.000467462f
Cred_23387 vin4.$263.Metal1 VSS.$672.Metal1 0.000646423f
Cred_23388 vin4.$263.Metal1 VSS.$740.Metal1 0.00144256f
Cred_23389 vin4.$263.Metal1 VSS.$785.Metal1 1.18852e-05f
Cred_23390 vin4.$263.Metal1 VSS.P0.pSD 0.0124465f
Cred_23391 vin4.$263.Metal1 VSS.P7.nSD 8.37022e-08f
Cred_23392 vin4.$264.Metal1 vout4.$1226.Metal3 6.69587e-05f
Cred_23393 vin4.$264.Metal1 vout4.$1292.Metal3 1.67231e-06f
Cred_23394 vin4.$264.Metal1 vout4.P4.pSD 1.95318e-07f
Cred_23395 vin4.$264.Metal1 vout4.P6.nSD 2.63457e-08f
Cred_23396 vin4.$264.Metal1 vout4.P6.pSD 3.39303e-07f
Cred_23397 vin4.$265.Metal1 vout4.$1226.Metal3 0.000176163f
Cred_23398 vin4.$265.Metal1 vout4.P4.nSD 1.87265e-06f
Cred_23399 vin4.$265.Metal1 VSS.$1991.Metal1 8.48969e-06f
Cred_23400 vin4.$265.Metal1 VSS.$2023.Metal1 2.12565e-05f
Cred_23401 vin4.$265.Metal1 VSS.$2843.Metal2 3.57813e-07f
Cred_23402 vin4.$265.Metal1 VSS.$2867.Metal2 4.59267e-05f
Cred_23403 vin4.$265.Metal1 VSS.$2926.Metal2 0.000664556f
Cred_23404 vin4.$265.Metal1 VSS.$2958.Metal2 2.45783e-05f
Cred_23405 vin4.$265.Metal1 VSS.$4241.Metal2 5.69098e-08f
Cred_23406 vin4.$265.Metal1 VSS.$4652.Metal3 1.38935e-07f
Cred_23407 vin4.$265.Metal1 VSS.$66.Metal1 0.000603133f
Cred_23408 vin4.$265.Metal1 VSS.$672.Metal1 4.28272e-05f
Cred_23409 vin4.$265.Metal1 VSS.$740.Metal1 0.00114249f
Cred_23410 vin4.$265.Metal1 VSS.$785.Metal1 0.022397f
Cred_23411 vin4.$265.Metal1 VSS.P0.pSD 0.0180699f
Cred_23412 vin4.$265.Metal1 VSS.P7.nSD 0.000207174f
Cred_23413 vin4.$272.Metal1 vout4.$1226.Metal3 4.83458e-05f
Cred_23414 vin4.$272.Metal1 vout4.$1292.Metal3 4.46677e-05f
Cred_23415 vin4.$272.Metal1 vout4.P4.pSD 1.32775e-07f
Cred_23416 vin4.$272.Metal1 vout4.P6.nSD 7.03698e-07f
Cred_23417 vin4.$272.Metal1 vout4.P6.pSD 6.4668e-06f
Cred_23418 vin4.$273.Metal1 vout4.$1226.Metal3 1.13457e-05f
Cred_23419 vin4.$273.Metal1 vout4.$1292.Metal3 1.13457e-05f
Cred_23420 vin4.$273.Metal1 vout4.P6.nSD 2.6058e-07f
Cred_23421 vin4.$273.Metal1 vout4.P6.pSD 9.76862e-07f
Cred_23422 vin4.$273.Metal1 VSS.$1991.Metal1 1.29327e-05f
Cred_23423 vin4.$273.Metal1 VSS.$2023.Metal1 3.23808e-05f
Cred_23424 vin4.$273.Metal1 VSS.$2926.Metal2 0.000798763f
Cred_23425 vin4.$273.Metal1 VSS.$2958.Metal2 3.61193e-05f
Cred_23426 vin4.$273.Metal1 VSS.$3006.Metal2 4.06169e-06f
Cred_23427 vin4.$273.Metal1 VSS.$4241.Metal2 8.66929e-08f
Cred_23428 vin4.$273.Metal1 VSS.$4688.Metal3 3.12823e-08f
Cred_23429 vin4.$273.Metal1 VSS.$66.Metal1 0.000689859f
Cred_23430 vin4.$273.Metal1 VSS.$771.Metal1 0.000613059f
Cred_23431 vin4.$273.Metal1 VSS.$785.Metal1 0.0369406f
Cred_23432 vin4.$273.Metal1 VSS.$831.Metal1 0.0006588f
Cred_23433 vin4.$273.Metal1 VSS.$879.Metal1 1.91613e-05f
Cred_23434 vin4.$273.Metal1 VSS.P0.pSD 0.0239216f
Cred_23435 vin4.$273.Metal1 VSS.P7.nSD 0.000350366f
Cred_23436 vin4.$276.Metal1 vout4.$1226.Metal3 7.03749e-05f
Cred_23437 vin4.$276.Metal1 vout4.$1292.Metal3 7.03749e-05f
Cred_23438 vin4.$276.Metal1 vout4.P6.nSD 1.10869e-06f
Cred_23439 vin4.$276.Metal1 vout4.P6.pSD 1.1191e-05f
Cred_23440 vin4.$280.Metal1 vout4.$1226.Metal3 0.00224909f
Cred_23441 vin4.$280.Metal1 vout4.$1292.Metal3 0.00224909f
Cred_23442 vin4.$280.Metal1 vout4.P6.nSD 3.54323e-05f
Cred_23443 vin4.$280.Metal1 vout4.P6.pSD 0.00227072f
Cred_23444 vin4.$281.Metal1 vout4.$1226.Metal3 0.00270877f
Cred_23445 vin4.$281.Metal1 vout4.$1292.Metal3 0.00263404f
Cred_23446 vin4.$281.Metal1 vout4.P4.nSD 7.00732e-07f
Cred_23447 vin4.$281.Metal1 vout4.P6.nSD 0.00337504f
Cred_23448 vin4.$281.Metal1 vout4.P6.pSD 0.000226789f
Cred_23449 vin4.$281.Metal1 VSS.$1991.Metal1 1.08494e-05f
Cred_23450 vin4.$281.Metal1 VSS.$2023.Metal1 2.71647e-05f
Cred_23451 vin4.$281.Metal1 VSS.$2926.Metal2 8.3775e-05f
Cred_23452 vin4.$281.Metal1 VSS.$2958.Metal2 2.25167e-05f
Cred_23453 vin4.$281.Metal1 VSS.$3006.Metal2 1.92068e-05f
Cred_23454 vin4.$281.Metal1 VSS.$4241.Metal2 7.27279e-08f
Cred_23455 vin4.$281.Metal1 VSS.$4688.Metal3 1.40401e-07f
Cred_23456 vin4.$281.Metal1 VSS.$66.Metal1 0.000437913f
Cred_23457 vin4.$281.Metal1 VSS.$771.Metal1 0.000217158f
Cred_23458 vin4.$281.Metal1 VSS.$785.Metal1 0.000705229f
Cred_23459 vin4.$281.Metal1 VSS.$831.Metal1 0.0022483f
Cred_23460 vin4.$281.Metal1 VSS.$879.Metal1 0.000202968f
Cred_23461 vin4.$281.Metal1 VSS.P0.pSD 0.017534f
Cred_23462 vin4.$281.Metal1 VSS.P7.nSD 5.88858e-06f
Cred_23463 vin4.$284.Metal1 vout4.$1226.Metal3 0.0116135f
Cred_23464 vin4.$284.Metal1 vout4.$1292.Metal3 0.0116135f
Cred_23465 vin4.$284.Metal1 vout4.P6.nSD 0.00018296f
Cred_23466 vin4.$284.Metal1 vout4.P6.pSD 0.0220364f
Cred_23467 vin4.$285.Metal1 vout4.$1226.Metal3 0.0115648f
Cred_23468 vin4.$285.Metal1 vout4.$1292.Metal3 0.0115353f
Cred_23469 vin4.$285.Metal1 vout4.P4.nSD 2.77091e-07f
Cred_23470 vin4.$285.Metal1 vout4.P6.nSD 0.0198603f
Cred_23471 vin4.$285.Metal1 vout4.P6.pSD 0.000993182f
Cred_23472 vin4.$285.Metal1 VSS.$1991.Metal1 1.32305e-05f
Cred_23473 vin4.$285.Metal1 VSS.$2023.Metal1 3.31265e-05f
Cred_23474 vin4.$285.Metal1 VSS.$2926.Metal2 2.90429e-05f
Cred_23475 vin4.$285.Metal1 VSS.$2958.Metal2 1.10289e-06f
Cred_23476 vin4.$285.Metal1 VSS.$4241.Metal2 8.86893e-08f
Cred_23477 vin4.$285.Metal1 VSS.$66.Metal1 0.000401699f
Cred_23478 vin4.$285.Metal1 VSS.$785.Metal1 8.95181e-05f
Cred_23479 vin4.$285.Metal1 VSS.P0.pSD 0.0185954f
Cred_23480 vin4.$285.Metal1 VSS.P7.nSD 7.44237e-07f
Cred_23481 vin4.$290.Metal1 vout4.$1226.Metal3 0.00774494f
Cred_23482 vin4.$290.Metal1 vout4.$1292.Metal3 0.00869489f
Cred_23483 vin4.$290.Metal1 vout4.P6.nSD 0.000122014f
Cred_23484 vin4.$290.Metal1 vout4.P6.pSD 0.0112744f
Cred_23485 vin4.$290.Metal1 vout4.P8.pSD 6.67492e-05f
Cred_23486 vin4.$291.Metal1 vout4.$1226.Metal3 0.00355904f
Cred_23487 vin4.$291.Metal1 vout4.$1292.Metal3 0.00367739f
Cred_23488 vin4.$291.Metal1 vout4.P6.nSD 0.00587158f
Cred_23489 vin4.$291.Metal1 vout4.P6.pSD 0.000306431f
Cred_23490 vin4.$291.Metal1 vout4.P8.nSD 1.10981e-06f
Cred_23491 vin4.$291.Metal1 VSS.$1991.Metal1 1.99161e-05f
Cred_23492 vin4.$291.Metal1 VSS.$2023.Metal1 4.98658e-05f
Cred_23493 vin4.$291.Metal1 VSS.$3054.Metal2 4.76175e-05f
Cred_23494 vin4.$291.Metal1 VSS.$3078.Metal2 9.29939e-05f
Cred_23495 vin4.$291.Metal1 VSS.$3113.Metal2 0.000292588f
Cred_23496 vin4.$291.Metal1 VSS.$4241.Metal2 1.33505e-07f
Cred_23497 vin4.$291.Metal1 VSS.$66.Metal1 0.000450924f
Cred_23498 vin4.$291.Metal1 VSS.$879.Metal1 0.00138105f
Cred_23499 vin4.$291.Metal1 VSS.$924.Metal1 0.00373045f
Cred_23500 vin4.$291.Metal1 VSS.P0.pSD 0.0242028f
Cred_23501 vin4.$291.Metal1 VSS.P10.nSD 0.000113253f
Cred_23502 vin4.$294.Metal1 vout4.$1226.Metal3 0.0030992f
Cred_23503 vin4.$294.Metal1 vout4.$1292.Metal3 0.00383442f
Cred_23504 vin4.$294.Metal1 vout4.P6.nSD 4.8825e-05f
Cred_23505 vin4.$294.Metal1 vout4.P6.pSD 0.00428749f
Cred_23506 vin4.$294.Metal1 vout4.P8.pSD 5.16607e-05f
Cred_23507 vin4.$299.Metal1 vout4.$1226.Metal3 2.6058e-05f
Cred_23508 vin4.$299.Metal1 vout4.$1292.Metal3 7.35828e-05f
Cred_23509 vin4.$299.Metal1 vout4.P6.nSD 6.43208e-07f
Cred_23510 vin4.$299.Metal1 vout4.P6.pSD 2.24358e-06f
Cred_23511 vin4.$299.Metal1 vout4.P8.nSD 2.11277e-07f
Cred_23512 vin4.$299.Metal1 VSS.$1991.Metal1 1.7318e-05f
Cred_23513 vin4.$299.Metal1 VSS.$2023.Metal1 4.33608e-05f
Cred_23514 vin4.$299.Metal1 VSS.$3054.Metal2 8.22798e-06f
Cred_23515 vin4.$299.Metal1 VSS.$3078.Metal2 0.000632215f
Cred_23516 vin4.$299.Metal1 VSS.$3113.Metal2 0.0020881f
Cred_23517 vin4.$299.Metal1 VSS.$4241.Metal2 1.1609e-07f
Cred_23518 vin4.$299.Metal1 VSS.$66.Metal1 0.00029652f
Cred_23519 vin4.$299.Metal1 VSS.$879.Metal1 0.000314013f
Cred_23520 vin4.$299.Metal1 VSS.$924.Metal1 0.0306613f
Cred_23521 vin4.$299.Metal1 VSS.P0.pSD 0.0183463f
Cred_23522 vin4.$299.Metal1 VSS.P10.nSD 0.00112176f
Cred_23523 vin4.$302.Metal1 vout4.$1292.Metal3 9.34686e-06f
Cred_23524 vin4.$303.Metal1 vout4.$1226.Metal3 3.90959e-05f
Cred_23525 vin4.$303.Metal1 vout4.$1292.Metal3 0.000132079f
Cred_23526 vin4.$303.Metal1 vout4.P6.nSD 1.02929e-06f
Cred_23527 vin4.$303.Metal1 vout4.P6.pSD 3.36614e-06f
Cred_23528 vin4.$303.Metal1 vout4.P8.nSD 4.13368e-07f
Cred_23529 vin4.$303.Metal1 VSS.$1038.Metal1 2.6008e-05f
Cred_23530 vin4.$303.Metal1 VSS.$1991.Metal1 1.97149e-05f
Cred_23531 vin4.$303.Metal1 VSS.$2023.Metal1 4.93622e-05f
Cred_23532 vin4.$303.Metal1 VSS.$3078.Metal2 0.000589775f
Cred_23533 vin4.$303.Metal1 VSS.$3113.Metal2 0.00195557f
Cred_23534 vin4.$303.Metal1 VSS.$3169.Metal2 2.17285e-07f
Cred_23535 vin4.$303.Metal1 VSS.$4241.Metal2 1.32157e-07f
Cred_23536 vin4.$303.Metal1 VSS.$66.Metal1 0.000253982f
Cred_23537 vin4.$303.Metal1 VSS.$924.Metal1 0.0268674f
Cred_23538 vin4.$303.Metal1 VSS.$990.Metal1 0.00124072f
Cred_23539 vin4.$303.Metal1 VSS.P0.pSD 0.0181414f
Cred_23540 vin4.$303.Metal1 VSS.P10.nSD 0.000994954f
Cred_23541 vin4.$306.Metal1 vout4.$1292.Metal3 0.00115034f
Cred_23542 vin4.$306.Metal1 vout4.P8.pSD 0.000166022f
Cred_23543 vin4.$311.Metal1 vout4.$1292.Metal3 0.00222534f
Cred_23544 vin4.$311.Metal1 vout4.P8.nSD 0.00164979f
Cred_23545 vin4.$311.Metal1 VSS.$1038.Metal1 0.000519672f
Cred_23546 vin4.$311.Metal1 VSS.$1991.Metal1 2.22635e-05f
Cred_23547 vin4.$311.Metal1 VSS.$2023.Metal1 5.57432e-05f
Cred_23548 vin4.$311.Metal1 VSS.$3169.Metal2 3.66904e-05f
Cred_23549 vin4.$311.Metal1 VSS.$4241.Metal2 1.49241e-07f
Cred_23550 vin4.$311.Metal1 VSS.$66.Metal1 0.000226896f
Cred_23551 vin4.$311.Metal1 VSS.$990.Metal1 0.00169644f
Cred_23552 vin4.$311.Metal1 VSS.P0.pSD 0.0182363f
Cred_23553 vin4.$312.Metal1 vout4.$1292.Metal3 0.0169072f
Cred_23554 vin4.$312.Metal1 vout4.P8.pSD 0.0137418f
Cred_23555 vin4.$313.Metal1 vout4.$1292.Metal3 0.0235303f
Cred_23556 vin4.$313.Metal1 vout4.P8.nSD 0.0191443f
Cred_23557 vin4.$313.Metal1 VSS.$1991.Metal1 2.53728e-05f
Cred_23558 vin4.$313.Metal1 VSS.$2023.Metal1 6.35285e-05f
Cred_23559 vin4.$313.Metal1 VSS.$4241.Metal2 1.70084e-07f
Cred_23560 vin4.$313.Metal1 VSS.$66.Metal1 0.000194338f
Cred_23561 vin4.$313.Metal1 VSS.P0.pSD 0.0180212f
Cred_23562 vin4.$316.Metal1 vout4.$1292.Metal3 0.0161833f
Cred_23563 vin4.$316.Metal1 vout4.P8.pSD 0.0132623f
Cred_23564 vin4.$320.Metal1 vout4.$1292.Metal3 0.00227998f
Cred_23565 vin4.$320.Metal1 vout4.P8.pSD 0.00126704f
Cred_23566 vin4.$321.Metal1 vout4.$1292.Metal3 0.0091509f
Cred_23567 vin4.$321.Metal1 vout4.$1358.Metal3 4.72442e-05f
Cred_23568 vin4.$321.Metal1 vout4.P10.nSD 1.67507e-06f
Cred_23569 vin4.$321.Metal1 vout4.P10.pSD 4.03112e-06f
Cred_23570 vin4.$321.Metal1 vout4.P8.nSD 0.00719773f
Cred_23571 vin4.$321.Metal1 VSS 0.00105442f
Cred_23572 vin4.$321.Metal1 VSS.$1038.Metal1 0.00047739f
Cred_23573 vin4.$321.Metal1 VSS.$1078.Metal1 0.00214531f
Cred_23574 vin4.$321.Metal1 VSS.$1991.Metal1 3.8286e-05f
Cred_23575 vin4.$321.Metal1 VSS.$2023.Metal1 9.58605e-05f
Cred_23576 vin4.$321.Metal1 VSS.$3217.Metal2 1.86009e-05f
Cred_23577 vin4.$321.Metal1 VSS.$3276.Metal2 0.000103786f
Cred_23578 vin4.$321.Metal1 VSS.$3308.Metal2 8.85851e-05f
Cred_23579 vin4.$321.Metal1 VSS.$4241.Metal2 2.56647e-07f
Cred_23580 vin4.$321.Metal1 VSS.$4808.Metal3 1.17159e-07f
Cred_23581 vin4.$321.Metal1 VSS.$66.Metal1 0.000224436f
Cred_23582 vin4.$321.Metal1 VSS.P0.pSD 0.023765f
Cred_23583 vin4.$321.Metal1 VSS.P11.nSD 3.4654e-05f
Cred_23584 vin4.$324.Metal1 vout4.$1292.Metal3 5.64036e-05f
Cred_23585 vin4.$329.Metal1 vout4.$1292.Metal3 2.78522e-05f
Cred_23586 vin4.$329.Metal1 VSS 0.0402521f
Cred_23587 vin4.$329.Metal1 VSS.$1078.Metal1 0.00100323f
Cred_23588 vin4.$329.Metal1 VSS.$1991.Metal1 4.59296e-05f
Cred_23589 vin4.$329.Metal1 VSS.$2023.Metal1 0.000114998f
Cred_23590 vin4.$329.Metal1 VSS.$3217.Metal2 7.68068e-06f
Cred_23591 vin4.$329.Metal1 VSS.$3276.Metal2 0.00178235f
Cred_23592 vin4.$329.Metal1 VSS.$3308.Metal2 0.00177337f
Cred_23593 vin4.$329.Metal1 VSS.$4241.Metal2 3.07884e-07f
Cred_23594 vin4.$329.Metal1 VSS.$4808.Metal3 6.1582e-08f
Cred_23595 vin4.$329.Metal1 VSS.$66.Metal1 0.000190869f
Cred_23596 vin4.$329.Metal1 VSS.P0.pSD 0.0239902f
Cred_23597 vin4.$329.Metal1 VSS.P11.nSD 0.00152799f
Cred_23598 vin4.$334.Metal1 vout4.$1292.Metal3 2.6845e-05f
Cred_23599 vin4.$334.Metal1 vout4.$1358.Metal3 2.6845e-05f
Cred_23600 vin4.$334.Metal1 vout4.P10.nSD 4.22919e-07f
Cred_23601 vin4.$334.Metal1 vout4.P10.pSD 2.29056e-06f
Cred_23602 vin4.$335.Metal1 vout4.$1292.Metal3 0.000387573f
Cred_23603 vin4.$335.Metal1 vout4.$1358.Metal3 0.000264287f
Cred_23604 vin4.$335.Metal1 vout4.P10.nSD 0.000208731f
Cred_23605 vin4.$335.Metal1 vout4.P10.pSD 2.25503e-05f
Cred_23606 vin4.$335.Metal1 vout4.P8.nSD 1.15604e-06f
Cred_23607 vin4.$335.Metal1 VSS 0.0142867f
Cred_23608 vin4.$335.Metal1 VSS.$1174.Metal1 0.00181565f
Cred_23609 vin4.$335.Metal1 VSS.$1991.Metal1 3.91217e-05f
Cred_23610 vin4.$335.Metal1 VSS.$2023.Metal1 9.7953e-05f
Cred_23611 vin4.$335.Metal1 VSS.$3276.Metal2 0.000690108f
Cred_23612 vin4.$335.Metal1 VSS.$3308.Metal2 0.000706555f
Cred_23613 vin4.$335.Metal1 VSS.$3356.Metal2 1.55542e-05f
Cred_23614 vin4.$335.Metal1 VSS.$4241.Metal2 2.62249e-07f
Cred_23615 vin4.$335.Metal1 VSS.$4844.Metal3 1.2471e-07f
Cred_23616 vin4.$335.Metal1 VSS.$66.Metal1 0.000120232f
Cred_23617 vin4.$335.Metal1 VSS.P0.pSD 0.0176008f
Cred_23618 vin4.$335.Metal1 VSS.P11.nSD 0.000542835f
Cred_23619 vin4.$338.Metal1 vout4.$1292.Metal3 0.00106876f
Cred_23620 vin4.$338.Metal1 vout4.$1358.Metal3 0.00106876f
Cred_23621 vin4.$338.Metal1 vout4.P10.nSD 1.68373e-05f
Cred_23622 vin4.$338.Metal1 vout4.P10.pSD 0.00139346f
Cred_23623 vin4.$339.Metal1 vout4.$1292.Metal3 0.00450804f
Cred_23624 vin4.$339.Metal1 vout4.$1358.Metal3 0.00437831f
Cred_23625 vin4.$339.Metal1 vout4.P10.nSD 0.00731727f
Cred_23626 vin4.$339.Metal1 vout4.P10.pSD 0.000373579f
Cred_23627 vin4.$339.Metal1 vout4.P8.nSD 1.2165e-06f
Cred_23628 vin4.$339.Metal1 VSS 0.000411154f
Cred_23629 vin4.$339.Metal1 VSS.$1174.Metal1 0.00125084f
Cred_23630 vin4.$339.Metal1 VSS.$1214.Metal1 0.00047739f
Cred_23631 vin4.$339.Metal1 VSS.$1991.Metal1 4.67235e-05f
Cred_23632 vin4.$339.Metal1 VSS.$2023.Metal1 0.000116986f
Cred_23633 vin4.$339.Metal1 VSS.$3276.Metal2 7.90903e-05f
Cred_23634 vin4.$339.Metal1 VSS.$3308.Metal2 8.61888e-05f
Cred_23635 vin4.$339.Metal1 VSS.$3356.Metal2 1.09383e-05f
Cred_23636 vin4.$339.Metal1 VSS.$4241.Metal2 3.13207e-07f
Cred_23637 vin4.$339.Metal1 VSS.$4844.Metal3 5.57214e-08f
Cred_23638 vin4.$339.Metal1 VSS.$66.Metal1 0.000109428f
Cred_23639 vin4.$339.Metal1 VSS.P0.pSD 0.0183523f
Cred_23640 vin4.$339.Metal1 VSS.P11.nSD 1.40541e-05f
Cred_23641 vin4.$342.Metal1 vout4.$1292.Metal3 0.00729701f
Cred_23642 vin4.$342.Metal1 vout4.$1358.Metal3 0.00729701f
Cred_23643 vin4.$342.Metal1 vout4.P10.nSD 0.000114958f
Cred_23644 vin4.$342.Metal1 vout4.P10.pSD 0.0137329f
Cred_23645 vin4.$346.Metal1 vout4.$1292.Metal3 0.00779934f
Cred_23646 vin4.$346.Metal1 vout4.$1358.Metal3 0.00779934f
Cred_23647 vin4.$346.Metal1 vout4.P10.nSD 0.000122871f
Cred_23648 vin4.$346.Metal1 vout4.P10.pSD 0.0145931f
Cred_23649 vin4.$347.Metal1 vout4.$1292.Metal3 0.0111991f
Cred_23650 vin4.$347.Metal1 vout4.$1358.Metal3 0.0111991f
Cred_23651 vin4.$347.Metal1 vout4.P10.nSD 0.0193208f
Cred_23652 vin4.$347.Metal1 vout4.P10.pSD 0.000955568f
Cred_23653 vin4.$347.Metal1 VSS.$1991.Metal1 5.11536e-05f
Cred_23654 vin4.$347.Metal1 VSS.$2023.Metal1 0.000128078f
Cred_23655 vin4.$347.Metal1 VSS.$4241.Metal2 3.42903e-07f
Cred_23656 vin4.$347.Metal1 VSS.$66.Metal1 9.63952e-05f
Cred_23657 vin4.$347.Metal1 VSS.P0.pSD 0.0180287f
Cred_23658 vin4.$349.Metal1 vout4.$1292.Metal3 0.00105914f
Cred_23659 vin4.$349.Metal1 vout4.$1358.Metal3 0.00105914f
Cred_23660 vin4.$349.Metal1 vout4.P10.nSD 0.00166647f
Cred_23661 vin4.$349.Metal1 vout4.P10.pSD 9.03714e-05f
Cred_23662 vin4.$349.Metal1 VSS.$1214.Metal1 0.000519672f
Cred_23663 vin4.$349.Metal1 VSS.$1254.Metal1 0.00169644f
Cred_23664 vin4.$349.Metal1 VSS.$1991.Metal1 5.97238e-05f
Cred_23665 vin4.$349.Metal1 VSS.$2023.Metal1 0.000149536f
Cred_23666 vin4.$349.Metal1 VSS.$3404.Metal2 3.66904e-05f
Cred_23667 vin4.$349.Metal1 VSS.$4241.Metal2 4.00352e-07f
Cred_23668 vin4.$349.Metal1 VSS.$66.Metal1 8.45828e-05f
Cred_23669 vin4.$349.Metal1 VSS.P0.pSD 0.0182471f
Cred_23670 vin4.$352.Metal1 vout4.$1292.Metal3 0.00054301f
Cred_23671 vin4.$352.Metal1 vout4.$1358.Metal3 0.00054301f
Cred_23672 vin4.$352.Metal1 vout4.P10.nSD 8.55462e-06f
Cred_23673 vin4.$352.Metal1 vout4.P10.pSD 0.000221788f
Cred_23674 vin4.$356.Metal1 vout4.$1292.Metal3 4.4486e-06f
Cred_23675 vin4.$356.Metal1 vout4.$1358.Metal3 4.4486e-06f
Cred_23676 vin4.$356.Metal1 vout4.P10.nSD 7.00835e-08f
Cred_23677 vin4.$356.Metal1 vout4.P10.pSD 3.79577e-07f
Cred_23678 vin4.$357.Metal1 vout4.$1292.Metal3 4.4255e-05f
Cred_23679 vin4.$357.Metal1 vout4.$1358.Metal3 0.000126429f
Cred_23680 vin4.$357.Metal1 vout4.P10.nSD 1.11056e-06f
Cred_23681 vin4.$357.Metal1 vout4.P10.pSD 3.77606e-06f
Cred_23682 vin4.$357.Metal1 vout4.P12.nSD 4.13368e-07f
Cred_23683 vin4.$357.Metal1 VSS.$1214.Metal1 2.6008e-05f
Cred_23684 vin4.$357.Metal1 VSS.$1254.Metal1 0.00124072f
Cred_23685 vin4.$357.Metal1 VSS.$1267.Metal1 0.0268674f
Cred_23686 vin4.$357.Metal1 VSS.$1991.Metal1 6.68532e-05f
Cred_23687 vin4.$357.Metal1 VSS.$2023.Metal1 0.000167387f
Cred_23688 vin4.$357.Metal1 VSS.$3404.Metal2 2.17285e-07f
Cred_23689 vin4.$357.Metal1 VSS.$3463.Metal2 0.00195557f
Cred_23690 vin4.$357.Metal1 VSS.$3495.Metal2 0.000589775f
Cred_23691 vin4.$357.Metal1 VSS.$4241.Metal2 4.48144e-07f
Cred_23692 vin4.$357.Metal1 VSS.$66.Metal1 7.49008e-05f
Cred_23693 vin4.$357.Metal1 VSS.P0.pSD 0.018155f
Cred_23694 vin4.$357.Metal1 VSS.P13.nSD 0.000994954f
Cred_23695 vin4.$36.GatPoly vout4.$1226.Metal3 0.0204022f
Cred_23696 vin4.$36.GatPoly vout4.P0.nSD 2.50207e-05f
Cred_23697 vin4.$36.GatPoly vout4.P0.pSD 0.000132956f
Cred_23698 vin4.$36.GatPoly vout4.P2.nSD 2.72193e-05f
Cred_23699 vin4.$36.GatPoly vout4.P2.pSD 0.000293629f
Cred_23700 vin4.$36.GatPoly vout4.P4.pSD 0.0115941f
Cred_23701 vin4.$361.Metal1 vout4.$1292.Metal3 2.26192e-05f
Cred_23702 vin4.$361.Metal1 vout4.$1358.Metal3 7.73893e-05f
Cred_23703 vin4.$361.Metal1 vout4.P10.nSD 5.67622e-07f
Cred_23704 vin4.$361.Metal1 vout4.P10.pSD 1.92999e-06f
Cred_23705 vin4.$361.Metal1 vout4.P12.nSD 2.32689e-07f
Cred_23706 vin4.$361.Metal1 VSS.$1267.Metal1 0.0306613f
Cred_23707 vin4.$361.Metal1 VSS.$1373.Metal1 0.000314013f
Cred_23708 vin4.$361.Metal1 VSS.$1991.Metal1 7.80502e-05f
Cred_23709 vin4.$361.Metal1 VSS.$2023.Metal1 0.000195422f
Cred_23710 vin4.$361.Metal1 VSS.$3463.Metal2 0.0020881f
Cred_23711 vin4.$361.Metal1 VSS.$3495.Metal2 0.000632215f
Cred_23712 vin4.$361.Metal1 VSS.$3519.Metal2 8.22798e-06f
Cred_23713 vin4.$361.Metal1 VSS.$4241.Metal2 5.23202e-07f
Cred_23714 vin4.$361.Metal1 VSS.$66.Metal1 6.57951e-05f
Cred_23715 vin4.$361.Metal1 VSS.P0.pSD 0.0183639f
Cred_23716 vin4.$361.Metal1 VSS.P13.nSD 0.00112176f
Cred_23717 vin4.$364.Metal1 vout4.$1292.Metal3 0.000359051f
Cred_23718 vin4.$364.Metal1 vout4.$1358.Metal3 0.00682448f
Cred_23719 vin4.$364.Metal1 vout4.P10.nSD 5.65651e-06f
Cred_23720 vin4.$364.Metal1 vout4.P10.pSD 8.801e-05f
Cred_23721 vin4.$364.Metal1 vout4.P12.pSD 0.00409171f
Cred_23722 vin4.$368.Metal1 vout4.$1292.Metal3 0.000463919f
Cred_23723 vin4.$368.Metal1 vout4.$1358.Metal3 0.0164812f
Cred_23724 vin4.$368.Metal1 vout4.P10.nSD 7.30861e-06f
Cred_23725 vin4.$368.Metal1 vout4.P10.pSD 0.000113715f
Cred_23726 vin4.$368.Metal1 vout4.P12.pSD 0.0107913f
Cred_23727 vin4.$369.Metal1 vout4.$1292.Metal3 5.63311e-05f
Cred_23728 vin4.$369.Metal1 vout4.$1358.Metal3 0.0075369f
Cred_23729 vin4.$369.Metal1 vout4.P10.nSD 1.99725e-06f
Cred_23730 vin4.$369.Metal1 vout4.P10.pSD 4.80646e-06f
Cred_23731 vin4.$369.Metal1 vout4.P12.nSD 0.00581551f
Cred_23732 vin4.$369.Metal1 VSS.$1267.Metal1 0.00373045f
Cred_23733 vin4.$369.Metal1 VSS.$1373.Metal1 0.00138105f
Cred_23734 vin4.$369.Metal1 VSS.$1991.Metal1 0.000118693f
Cred_23735 vin4.$369.Metal1 VSS.$2023.Metal1 0.000297182f
Cred_23736 vin4.$369.Metal1 VSS.$3463.Metal2 0.000292588f
Cred_23737 vin4.$369.Metal1 VSS.$3495.Metal2 9.29939e-05f
Cred_23738 vin4.$369.Metal1 VSS.$3519.Metal2 4.76175e-05f
Cred_23739 vin4.$369.Metal1 VSS.$4241.Metal2 7.95644e-07f
Cred_23740 vin4.$369.Metal1 VSS.$66.Metal1 7.56667e-05f
Cred_23741 vin4.$369.Metal1 VSS.P0.pSD 0.0242313f
Cred_23742 vin4.$369.Metal1 VSS.P13.nSD 0.000113253f
Cred_23743 vin4.$37.GatPoly vout4.$1226.Metal3 0.00166244f
Cred_23744 vin4.$37.GatPoly vout4.P0.nSD 3.90331e-06f
Cred_23745 vin4.$37.GatPoly vout4.P0.pSD 2.07415e-05f
Cred_23746 vin4.$37.GatPoly vout4.P2.nSD 7.26222e-06f
Cred_23747 vin4.$37.GatPoly vout4.P2.pSD 2.3207e-05f
Cred_23748 vin4.$37.GatPoly vout4.P4.nSD 0.000623893f
Cred_23749 vin4.$37.GatPoly VSS.$1991.Metal1 9.34914e-07f
Cred_23750 vin4.$37.GatPoly VSS.$2023.Metal1 2.34084e-06f
Cred_23751 vin4.$37.GatPoly VSS.$2739.Metal2 0.000736069f
Cred_23752 vin4.$37.GatPoly VSS.$2771.Metal2 0.000322837f
Cred_23753 vin4.$37.GatPoly VSS.$4241.Metal2 6.26711e-09f
Cred_23754 vin4.$37.GatPoly VSS.$566.Metal1 0.0121868f
Cred_23755 vin4.$37.GatPoly VSS.$66.Metal1 0.000206086f
Cred_23756 vin4.$37.GatPoly VSS.P0.pSD 0.00341582f
Cred_23757 vin4.$37.GatPoly VSS.P5.nSD 0.000321264f
Cred_23758 vin4.$374.Metal1 vout4.$1358.Metal3 0.023578f
Cred_23759 vin4.$374.Metal1 vout4.P12.pSD 0.021265f
Cred_23760 vin4.$375.Metal1 vout4.$1358.Metal3 0.0242595f
Cred_23761 vin4.$375.Metal1 vout4.$1424.Metal3 1.40644e-05f
Cred_23762 vin4.$375.Metal1 vout4.P12.nSD 0.0196785f
Cred_23763 vin4.$375.Metal1 vout4.P14.nSD 4.98662e-07f
Cred_23764 vin4.$375.Metal1 vout4.P14.pSD 1.20005e-06f
Cred_23765 vin4.$375.Metal1 VSS.$1483.Metal1 8.95181e-05f
Cred_23766 vin4.$375.Metal1 VSS.$1991.Metal1 0.000105736f
Cred_23767 vin4.$375.Metal1 VSS.$2023.Metal1 0.000264741f
Cred_23768 vin4.$375.Metal1 VSS.$3615.Metal2 1.10289e-06f
Cred_23769 vin4.$375.Metal1 VSS.$3650.Metal2 2.90429e-05f
Cred_23770 vin4.$375.Metal1 VSS.$4241.Metal2 7.08788e-07f
Cred_23771 vin4.$375.Metal1 VSS.$66.Metal1 5.02671e-05f
Cred_23772 vin4.$375.Metal1 VSS.P0.pSD 0.0186221f
Cred_23773 vin4.$375.Metal1 VSS.P15.nSD 7.44237e-07f
Cred_23774 vin4.$378.Metal1 vout4.$1358.Metal3 0.00460492f
Cred_23775 vin4.$378.Metal1 vout4.P12.pSD 0.00208398f
Cred_23776 vin4.$379.Metal1 vout4.$1358.Metal3 0.00557193f
Cred_23777 vin4.$379.Metal1 vout4.$1424.Metal3 3.55673e-05f
Cred_23778 vin4.$379.Metal1 vout4.P12.nSD 0.00333354f
Cred_23779 vin4.$379.Metal1 vout4.P14.nSD 1.26106e-06f
Cred_23780 vin4.$379.Metal1 vout4.P14.pSD 3.03479e-06f
Cred_23781 vin4.$379.Metal1 VSS.$1373.Metal1 0.000202968f
Cred_23782 vin4.$379.Metal1 VSS.$1421.Metal1 0.0022483f
Cred_23783 vin4.$379.Metal1 VSS.$1483.Metal1 0.000705229f
Cred_23784 vin4.$379.Metal1 VSS.$1484.Metal1 0.000217158f
Cred_23785 vin4.$379.Metal1 VSS.$1991.Metal1 0.000115268f
Cred_23786 vin4.$379.Metal1 VSS.$2023.Metal1 0.000288608f
Cred_23787 vin4.$379.Metal1 VSS.$3567.Metal2 1.92068e-05f
Cred_23788 vin4.$379.Metal1 VSS.$3615.Metal2 2.25167e-05f
Cred_23789 vin4.$379.Metal1 VSS.$3650.Metal2 8.3775e-05f
Cred_23790 vin4.$379.Metal1 VSS.$4241.Metal2 7.72687e-07f
Cred_23791 vin4.$379.Metal1 VSS.$4964.Metal3 1.40401e-07f
Cred_23792 vin4.$379.Metal1 VSS.$66.Metal1 4.12215e-05f
Cred_23793 vin4.$379.Metal1 VSS.P0.pSD 0.0175642f
Cred_23794 vin4.$379.Metal1 VSS.P15.nSD 5.88858e-06f
Cred_23795 vin4.$382.Metal1 vout4.$1358.Metal3 0.000147556f
Cred_23796 vin4.$382.Metal1 vout4.P12.pSD 5.4933e-06f
Cred_23797 vin4.$386.Metal1 vout4.$1358.Metal3 9.54292e-05f
Cred_23798 vin4.$386.Metal1 vout4.$1424.Metal3 1.74057e-06f
Cred_23799 vin4.$386.Metal1 vout4.P12.pSD 2.81725e-06f
Cred_23800 vin4.$386.Metal1 vout4.P14.nSD 2.7421e-08f
Cred_23801 vin4.$386.Metal1 vout4.P14.pSD 3.02317e-07f
Cred_23802 vin4.$387.Metal1 vout4.$1358.Metal3 2.3847e-05f
Cred_23803 vin4.$387.Metal1 vout4.P12.nSD 8.18389e-08f
Cred_23804 vin4.$387.Metal1 VSS.$1373.Metal1 1.91613e-05f
Cred_23805 vin4.$387.Metal1 VSS.$1421.Metal1 0.0006588f
Cred_23806 vin4.$387.Metal1 VSS.$1483.Metal1 0.0369406f
Cred_23807 vin4.$387.Metal1 VSS.$1484.Metal1 0.000613059f
Cred_23808 vin4.$387.Metal1 VSS.$1991.Metal1 0.000181585f
Cred_23809 vin4.$387.Metal1 VSS.$2023.Metal1 0.000454653f
Cred_23810 vin4.$387.Metal1 VSS.$3567.Metal2 4.06169e-06f
Cred_23811 vin4.$387.Metal1 VSS.$3615.Metal2 3.61193e-05f
Cred_23812 vin4.$387.Metal1 VSS.$3650.Metal2 0.000798763f
Cred_23813 vin4.$387.Metal1 VSS.$4241.Metal2 1.21724e-06f
Cred_23814 vin4.$387.Metal1 VSS.$4964.Metal3 3.12823e-08f
Cred_23815 vin4.$387.Metal1 VSS.$66.Metal1 4.91381e-05f
Cred_23816 vin4.$387.Metal1 VSS.P0.pSD 0.0239703f
Cred_23817 vin4.$387.Metal1 VSS.P15.nSD 0.000350366f
Cred_23818 vin4.$392.Metal1 vout4.$1358.Metal3 3.45421e-05f
Cred_23819 vin4.$392.Metal1 vout4.$1424.Metal3 3.10581e-05f
Cred_23820 vin4.$392.Metal1 vout4.P12.pSD 2.26251e-07f
Cred_23821 vin4.$392.Metal1 vout4.P14.nSD 4.89291e-07f
Cred_23822 vin4.$392.Metal1 vout4.P14.pSD 2.87628e-06f
Cred_23823 vin4.$393.Metal1 vout4.$1358.Metal3 8.38441e-05f
Cred_23824 vin4.$393.Metal1 vout4.$1424.Metal3 8.38441e-05f
Cred_23825 vin4.$393.Metal1 vout4.P14.nSD 3.19353e-06f
Cred_23826 vin4.$393.Metal1 vout4.P14.pSD 7.154e-06f
Cred_23827 vin4.$393.Metal1 VSS.$1483.Metal1 0.022397f
Cred_23828 vin4.$393.Metal1 VSS.$1512.Metal1 0.00114249f
Cred_23829 vin4.$393.Metal1 VSS.$1580.Metal1 4.28272e-05f
Cred_23830 vin4.$393.Metal1 VSS.$1991.Metal1 0.000158757f
Cred_23831 vin4.$393.Metal1 VSS.$2023.Metal1 0.000397496f
Cred_23832 vin4.$393.Metal1 VSS.$3615.Metal2 2.45783e-05f
Cred_23833 vin4.$393.Metal1 VSS.$3650.Metal2 0.000664556f
Cred_23834 vin4.$393.Metal1 VSS.$3706.Metal2 4.59267e-05f
Cred_23835 vin4.$393.Metal1 VSS.$3730.Metal2 3.57813e-07f
Cred_23836 vin4.$393.Metal1 VSS.$4241.Metal2 1.06421e-06f
Cred_23837 vin4.$393.Metal1 VSS.$5000.Metal3 1.38935e-07f
Cred_23838 vin4.$393.Metal1 VSS.$66.Metal1 3.22581e-05f
Cred_23839 vin4.$393.Metal1 VSS.P0.pSD 0.0181132f
Cred_23840 vin4.$393.Metal1 VSS.P15.nSD 0.000207174f
Cred_23841 vin4.$396.Metal1 vout4.$1358.Metal3 0.00063605f
Cred_23842 vin4.$396.Metal1 vout4.$1424.Metal3 0.00063605f
Cred_23843 vin4.$396.Metal1 vout4.P14.nSD 1.00204e-05f
Cred_23844 vin4.$396.Metal1 vout4.P14.pSD 0.000443449f
Cred_23845 vin4.$397.Metal1 vout4.$1358.Metal3 0.000188754f
Cred_23846 vin4.$397.Metal1 vout4.$1424.Metal3 0.000188754f
Cred_23847 vin4.$397.Metal1 vout4.P14.nSD 0.000136024f
Cred_23848 vin4.$397.Metal1 vout4.P14.pSD 1.61055e-05f
Cred_23849 vin4.$397.Metal1 VSS.$1483.Metal1 1.18852e-05f
Cred_23850 vin4.$397.Metal1 VSS.$1512.Metal1 0.00144256f
Cred_23851 vin4.$397.Metal1 VSS.$1580.Metal1 0.000646423f
Cred_23852 vin4.$397.Metal1 VSS.$1991.Metal1 0.000123046f
Cred_23853 vin4.$397.Metal1 VSS.$2023.Metal1 0.000308082f
Cred_23854 vin4.$397.Metal1 VSS.$3615.Metal2 2.48028e-06f
Cred_23855 vin4.$397.Metal1 VSS.$3650.Metal2 7.22346e-05f
Cred_23856 vin4.$397.Metal1 VSS.$3706.Metal2 6.31661e-05f
Cred_23857 vin4.$397.Metal1 VSS.$3730.Metal2 5.40074e-06f
Cred_23858 vin4.$397.Metal1 VSS.$4241.Metal2 8.24826e-07f
Cred_23859 vin4.$397.Metal1 VSS.$5000.Metal3 5.54875e-08f
Cred_23860 vin4.$397.Metal1 VSS.$66.Metal1 1.98459e-05f
Cred_23861 vin4.$397.Metal1 VSS.P0.pSD 0.0124805f
Cred_23862 vin4.$397.Metal1 VSS.P15.nSD 8.37022e-08f
Cred_23863 vin4.$400.Metal1 vout4.$1358.Metal3 0.00954509f
Cred_23864 vin4.$400.Metal1 vout4.$1424.Metal3 0.00954509f
Cred_23865 vin4.$400.Metal1 vout4.P14.nSD 0.000150374f
Cred_23866 vin4.$400.Metal1 vout4.P14.pSD 0.0178495f
Cred_23867 vin4.$401.Metal1 vout4.$1358.Metal3 0.0100659f
Cred_23868 vin4.$401.Metal1 vout4.$1424.Metal3 0.0100659f
Cred_23869 vin4.$401.Metal1 vout4.P14.nSD 0.0171025f
Cred_23870 vin4.$401.Metal1 vout4.P14.pSD 0.000858876f
Cred_23871 vin4.$401.Metal1 VSS.$1483.Metal1 1.48819e-06f
Cred_23872 vin4.$401.Metal1 VSS.$1512.Metal1 0.000154212f
Cred_23873 vin4.$401.Metal1 VSS.$1580.Metal1 6.98466e-05f
Cred_23874 vin4.$401.Metal1 VSS.$1991.Metal1 0.000193806f
Cred_23875 vin4.$401.Metal1 VSS.$2023.Metal1 0.000485252f
Cred_23876 vin4.$401.Metal1 VSS.$3615.Metal2 5.85163e-07f
Cred_23877 vin4.$401.Metal1 VSS.$3650.Metal2 1.70451e-05f
Cred_23878 vin4.$401.Metal1 VSS.$3706.Metal2 1.35373e-05f
Cred_23879 vin4.$401.Metal1 VSS.$3730.Metal2 5.83555e-07f
Cred_23880 vin4.$401.Metal1 VSS.$4241.Metal2 1.29916e-06f
Cred_23881 vin4.$401.Metal1 VSS.$5000.Metal3 1.31152e-08f
Cred_23882 vin4.$401.Metal1 VSS.$66.Metal1 2.48605e-05f
Cred_23883 vin4.$401.Metal1 VSS.P0.pSD 0.0174418f
Cred_23884 vin4.$401.Metal1 VSS.P15.nSD 8.70293e-09f
Cred_23885 vin4.$408.Metal1 vout4.$1358.Metal3 0.00923975f
Cred_23886 vin4.$408.Metal1 vout4.$1424.Metal3 0.00986865f
Cred_23887 vin4.$408.Metal1 vout4.P14.nSD 0.000145564f
Cred_23888 vin4.$408.Metal1 vout4.P14.pSD 0.0152637f
Cred_23889 vin4.$408.Metal1 vout4.P16.pSD 4.78297e-05f
Cred_23890 vin4.$409.Metal1 vout4.$1358.Metal3 0.00700118f
Cred_23891 vin4.$409.Metal1 vout4.$1424.Metal3 0.00709679f
Cred_23892 vin4.$409.Metal1 vout4.P14.nSD 0.0109886f
Cred_23893 vin4.$409.Metal1 vout4.P14.pSD 0.000597376f
Cred_23894 vin4.$409.Metal1 vout4.P16.nSD 8.9658e-07f
Cred_23895 vin4.$409.Metal1 VSS.$1580.Metal1 0.00115729f
Cred_23896 vin4.$409.Metal1 VSS.$1625.Metal1 0.000479229f
Cred_23897 vin4.$409.Metal1 VSS.$1991.Metal1 0.000222821f
Cred_23898 vin4.$409.Metal1 VSS.$2023.Metal1 0.0005579f
Cred_23899 vin4.$409.Metal1 VSS.$3778.Metal2 1.2149e-05f
Cred_23900 vin4.$409.Metal1 VSS.$3802.Metal2 3.6165e-05f
Cred_23901 vin4.$409.Metal1 VSS.$3837.Metal2 7.95992e-05f
Cred_23902 vin4.$409.Metal1 VSS.$4241.Metal2 1.49366e-06f
Cred_23903 vin4.$409.Metal1 VSS.$66.Metal1 2.26844e-05f
Cred_23904 vin4.$409.Metal1 VSS.P0.pSD 0.0177814f
Cred_23905 vin4.$409.Metal1 VSS.P17.nSD 9.85719e-06f
Cred_23906 vin4.$412.Metal1 vout4.$1358.Metal3 0.00472945f
Cred_23907 vin4.$412.Metal1 vout4.$1424.Metal3 0.00584832f
Cred_23908 vin4.$412.Metal1 vout4.P14.nSD 7.45081e-05f
Cred_23909 vin4.$412.Metal1 vout4.P14.pSD 0.0067038f
Cred_23910 vin4.$412.Metal1 vout4.P16.pSD 8.5093e-05f
Cred_23911 vin4.$413.Metal1 vout4.$1358.Metal3 0.000383f
Cred_23912 vin4.$413.Metal1 vout4.$1424.Metal3 0.000553109f
Cred_23913 vin4.$413.Metal1 vout4.P14.nSD 0.000336004f
Cred_23914 vin4.$413.Metal1 vout4.P14.pSD 3.26795e-05f
Cred_23915 vin4.$413.Metal1 vout4.P16.nSD 1.59509e-06f
Cred_23916 vin4.$413.Metal1 VSS.$1580.Metal1 0.00074865f
Cred_23917 vin4.$413.Metal1 VSS.$1625.Metal1 0.0100393f
Cred_23918 vin4.$413.Metal1 VSS.$1991.Metal1 0.000257186f
Cred_23919 vin4.$413.Metal1 VSS.$2023.Metal1 0.000643941f
Cred_23920 vin4.$413.Metal1 VSS.$3778.Metal2 4.46721e-05f
Cred_23921 vin4.$413.Metal1 VSS.$3802.Metal2 0.000309797f
Cred_23922 vin4.$413.Metal1 VSS.$3837.Metal2 0.000697698f
Cred_23923 vin4.$413.Metal1 VSS.$4241.Metal2 1.72402e-06f
Cred_23924 vin4.$413.Metal1 VSS.$66.Metal1 1.99152e-05f
Cred_23925 vin4.$413.Metal1 VSS.P0.pSD 0.017797f
Cred_23926 vin4.$413.Metal1 VSS.P17.nSD 0.000359912f
Cred_23927 vin4.$419.Metal1 VSS.$1625.Metal1 0.0375483f
Cred_23928 vin4.$419.Metal1 VSS.$1991.Metal1 0.000292635f
Cred_23929 vin4.$419.Metal1 VSS.$2023.Metal1 0.0007327f
Cred_23930 vin4.$419.Metal1 VSS.$3802.Metal2 0.000989916f
Cred_23931 vin4.$419.Metal1 VSS.$3837.Metal2 0.00225701f
Cred_23932 vin4.$419.Metal1 VSS.$4241.Metal2 1.96165e-06f
Cred_23933 vin4.$419.Metal1 VSS.$66.Metal1 1.77986e-05f
Cred_23934 vin4.$419.Metal1 VSS.P0.pSD 0.0178378f
Cred_23935 vin4.$419.Metal1 VSS.P17.nSD 0.00140626f
Cred_23936 vin4.$42.GatPoly vout4.$1226.Metal3 0.0222699f
Cred_23937 vin4.$42.GatPoly vout4.P0.nSD 1.40638e-05f
Cred_23938 vin4.$42.GatPoly vout4.P0.pSD 7.4733e-05f
Cred_23939 vin4.$42.GatPoly vout4.P2.nSD 1.52996e-05f
Cred_23940 vin4.$42.GatPoly vout4.P2.pSD 0.000165045f
Cred_23941 vin4.$42.GatPoly vout4.P4.pSD 0.0152604f
Cred_23942 vin4.$422.Metal1 vout4.$1424.Metal3 4.2458e-05f
Cred_23943 vin4.$423.Metal1 vout4.$1424.Metal3 0.000148264f
Cred_23944 vin4.$423.Metal1 vout4.P16.nSD 1.06712e-05f
Cred_23945 vin4.$423.Metal1 VSS.$1625.Metal1 0.0117113f
Cred_23946 vin4.$423.Metal1 VSS.$1699.Metal1 1.3464e-07f
Cred_23947 vin4.$423.Metal1 VSS.$1991.Metal1 0.000233942f
Cred_23948 vin4.$423.Metal1 VSS.$2023.Metal1 0.000585743f
Cred_23949 vin4.$423.Metal1 VSS.$3802.Metal2 0.000310638f
Cred_23950 vin4.$423.Metal1 VSS.$3837.Metal2 0.000725046f
Cred_23951 vin4.$423.Metal1 VSS.$3893.Metal2 2.79061e-05f
Cred_23952 vin4.$423.Metal1 VSS.$4241.Metal2 1.56821e-06f
Cred_23953 vin4.$423.Metal1 VSS.$5084.Metal3 1.3464e-07f
Cred_23954 vin4.$423.Metal1 VSS.$66.Metal1 1.12566e-05f
Cred_23955 vin4.$423.Metal1 VSS.P0.pSD 0.0126075f
Cred_23956 vin4.$423.Metal1 VSS.P17.nSD 0.000424836f
Cred_23957 vin4.$426.Metal1 vout4.$1424.Metal3 0.00449306f
Cred_23958 vin4.$426.Metal1 vout4.P16.pSD 0.00292921f
Cred_23959 vin4.$427.Metal1 vout4.$1424.Metal3 0.00034906f
Cred_23960 vin4.$427.Metal1 vout4.P16.nSD 8.2277e-05f
Cred_23961 vin4.$427.Metal1 VSS.$1625.Metal1 1.28313e-06f
Cred_23962 vin4.$427.Metal1 VSS.$1699.Metal1 0.00101873f
Cred_23963 vin4.$427.Metal1 VSS.$1739.Metal1 0.000407947f
Cred_23964 vin4.$427.Metal1 VSS.$1991.Metal1 0.000247218f
Cred_23965 vin4.$427.Metal1 VSS.$2023.Metal1 0.000618984f
Cred_23966 vin4.$427.Metal1 VSS.$3802.Metal2 4.53323e-06f
Cred_23967 vin4.$427.Metal1 VSS.$3837.Metal2 2.81555e-05f
Cred_23968 vin4.$427.Metal1 VSS.$3893.Metal2 4.38787e-05f
Cred_23969 vin4.$427.Metal1 VSS.$4241.Metal2 1.6572e-06f
Cred_23970 vin4.$427.Metal1 VSS.$5084.Metal3 1.42875e-07f
Cred_23971 vin4.$427.Metal1 VSS.$66.Metal1 1.01365e-05f
Cred_23972 vin4.$427.Metal1 VSS.P0.pSD 0.012233f
Cred_23973 vin4.$427.Metal1 VSS.P17.nSD 4.45497e-08f
Cred_23974 vin4.$43.GatPoly vout4.$1226.Metal3 0.00761891f
Cred_23975 vin4.$43.GatPoly vout4.P0.nSD 2.194e-06f
Cred_23976 vin4.$43.GatPoly vout4.P0.pSD 1.16586e-05f
Cred_23977 vin4.$43.GatPoly vout4.P2.nSD 4.082e-06f
Cred_23978 vin4.$43.GatPoly vout4.P2.pSD 1.30444e-05f
Cred_23979 vin4.$43.GatPoly vout4.P4.nSD 0.00536626f
Cred_23980 vin4.$43.GatPoly VSS.$1991.Metal1 1.35059e-06f
Cred_23981 vin4.$43.GatPoly VSS.$2023.Metal1 3.38159e-06f
Cred_23982 vin4.$43.GatPoly VSS.$2739.Metal2 0.000150503f
Cred_23983 vin4.$43.GatPoly VSS.$2771.Metal2 6.60099e-05f
Cred_23984 vin4.$43.GatPoly VSS.$4241.Metal2 9.05352e-09f
Cred_23985 vin4.$43.GatPoly VSS.$566.Metal1 0.00049805f
Cred_23986 vin4.$43.GatPoly VSS.$66.Metal1 0.000173618f
Cred_23987 vin4.$43.GatPoly VSS.P0.pSD 0.00382109f
Cred_23988 vin4.$43.GatPoly VSS.P5.nSD 1.86375e-05f
Cred_23989 vin4.$431.Metal1 vout4.$1424.Metal3 0.0194272f
Cred_23990 vin4.$431.Metal1 vout4.P16.nSD 0.015411f
Cred_23991 vin4.$431.Metal1 VSS.$1625.Metal1 6.60482e-07f
Cred_23992 vin4.$431.Metal1 VSS.$1699.Metal1 7.35435e-08f
Cred_23993 vin4.$431.Metal1 VSS.$1991.Metal1 0.000404548f
Cred_23994 vin4.$431.Metal1 VSS.$2023.Metal1 0.00101291f
Cred_23995 vin4.$431.Metal1 VSS.$3802.Metal2 2.33344e-06f
Cred_23996 vin4.$431.Metal1 VSS.$3837.Metal2 1.44928e-05f
Cred_23997 vin4.$431.Metal1 VSS.$3893.Metal2 3.39178e-05f
Cred_23998 vin4.$431.Metal1 VSS.$4241.Metal2 2.71185e-06f
Cred_23999 vin4.$431.Metal1 VSS.$5084.Metal3 7.35435e-08f
Cred_24000 vin4.$431.Metal1 VSS.$66.Metal1 1.33078e-05f
Cred_24001 vin4.$431.Metal1 VSS.P0.pSD 0.0177797f
Cred_24002 vin4.$431.Metal1 VSS.P17.nSD 2.29316e-08f
Cred_24003 vin4.$432.Metal1 vout4.$1424.Metal3 0.0266176f
Cred_24004 vin4.$432.Metal1 vout4.P16.pSD 0.0222725f
Cred_24005 vin4.$439.Metal1 vout4 1.29706e-05f
Cred_24006 vin4.$439.Metal1 vout4.$1424.Metal3 0.0163742f
Cred_24007 vin4.$439.Metal1 vout4.P16.nSD 0.0129229f
Cred_24008 vin4.$439.Metal1 vout4.P18.nSD 1.82761e-06f
Cred_24009 vin4.$439.Metal1 vout4.P18.pSD 5.58169e-06f
Cred_24010 vin4.$439.Metal1 VSS.$1739.Metal1 0.000529433f
Cred_24011 vin4.$439.Metal1 VSS.$1787.Metal1 0.000598552f
Cred_24012 vin4.$439.Metal1 VSS.$1800.Metal1 0.000239742f
Cred_24013 vin4.$439.Metal1 VSS.$1991.Metal1 0.000451199f
Cred_24014 vin4.$439.Metal1 VSS.$2023.Metal1 0.00112971f
Cred_24015 vin4.$439.Metal1 VSS.$3941.Metal2 4.42291e-06f
Cred_24016 vin4.$439.Metal1 VSS.$4000.Metal2 5.86146e-05f
Cred_24017 vin4.$439.Metal1 VSS.$4032.Metal2 4.36492e-05f
Cred_24018 vin4.$439.Metal1 VSS.$4241.Metal2 3.02457e-06f
Cred_24019 vin4.$439.Metal1 VSS.$66.Metal1 1.16546e-05f
Cred_24020 vin4.$439.Metal1 VSS.P0.pSD 0.0174094f
Cred_24021 vin4.$439.Metal1 VSS.P19.nSD 8.97176e-06f
Cred_24022 vin4.$44.GatPoly vout4.$1226.Metal3 0.05686f
Cred_24023 vin4.$44.GatPoly vout4.$1292.Metal3 0.00278657f
Cred_24024 vin4.$44.GatPoly vout4.P4.pSD 0.0337983f
Cred_24025 vin4.$44.GatPoly vout4.P6.nSD 4.38997e-05f
Cred_24026 vin4.$44.GatPoly vout4.P6.pSD 0.000651467f
Cred_24027 vin4.$440.Metal1 vout4.$1424.Metal3 0.00561461f
Cred_24028 vin4.$440.Metal1 vout4.P16.pSD 0.00387364f
Cred_24029 vin4.$441.Metal1 vout4 2.90243e-05f
Cred_24030 vin4.$441.Metal1 vout4.$1424.Metal3 0.00111056f
Cred_24031 vin4.$441.Metal1 vout4.P16.nSD 0.000376308f
Cred_24032 vin4.$441.Metal1 vout4.P18.nSD 4.08965e-06f
Cred_24033 vin4.$441.Metal1 vout4.P18.pSD 1.24902e-05f
Cred_24034 vin4.$441.Metal1 VSS.$1739.Metal1 0.000145714f
Cred_24035 vin4.$441.Metal1 VSS.$1787.Metal1 0.00212675f
Cred_24036 vin4.$441.Metal1 VSS.$1800.Metal1 0.00768135f
Cred_24037 vin4.$441.Metal1 VSS.$1991.Metal1 0.000516075f
Cred_24038 vin4.$441.Metal1 VSS.$2023.Metal1 0.00129215f
Cred_24039 vin4.$441.Metal1 VSS.$3941.Metal2 2.09779e-05f
Cred_24040 vin4.$441.Metal1 VSS.$4000.Metal2 0.000518159f
Cred_24041 vin4.$441.Metal1 VSS.$4032.Metal2 0.000371147f
Cred_24042 vin4.$441.Metal1 VSS.$4241.Metal2 3.45946e-06f
Cred_24043 vin4.$441.Metal1 VSS.$5132.Metal3 1.58436e-07f
Cred_24044 vin4.$441.Metal1 VSS.$66.Metal1 1.00117e-05f
Cred_24045 vin4.$441.Metal1 VSS.P0.pSD 0.0170337f
Cred_24046 vin4.$441.Metal1 VSS.P19.nSD 0.000293242f
Cred_24047 vin4.$448.Metal1 vout4.$1424.Metal3 9.75371e-06f
Cred_24048 vin4.$449.Metal1 vout4 8.26931e-07f
Cred_24049 vin4.$449.Metal1 vout4.$1424.Metal3 1.39243e-05f
Cred_24050 vin4.$449.Metal1 vout4.P18.nSD 6.5704e-08f
Cred_24051 vin4.$449.Metal1 vout4.P18.pSD 3.55857e-07f
Cred_24052 vin4.$449.Metal1 VSS.$1739.Metal1 7.83657e-06f
Cred_24053 vin4.$449.Metal1 VSS.$1787.Metal1 0.00013565f
Cred_24054 vin4.$449.Metal1 VSS.$1800.Metal1 0.0419833f
Cred_24055 vin4.$449.Metal1 VSS.$1878.Metal1 0.000306238f
Cred_24056 vin4.$449.Metal1 VSS.$1991.Metal1 0.000781996f
Cred_24057 vin4.$449.Metal1 VSS.$2023.Metal1 0.00195796f
Cred_24058 vin4.$449.Metal1 VSS.$3941.Metal2 2.85347e-06f
Cred_24059 vin4.$449.Metal1 VSS.$4000.Metal2 0.00207838f
Cred_24060 vin4.$449.Metal1 VSS.$4032.Metal2 0.00154814f
Cred_24061 vin4.$449.Metal1 VSS.$4080.Metal2 1.53248e-06f
Cred_24062 vin4.$449.Metal1 VSS.$4241.Metal2 5.24203e-06f
Cred_24063 vin4.$449.Metal1 VSS.$5132.Metal3 2.23536e-08f
Cred_24064 vin4.$449.Metal1 VSS.$5168.Metal3 1.22871e-08f
Cred_24065 vin4.$449.Metal1 VSS.$66.Metal1 1.13486e-05f
Cred_24066 vin4.$449.Metal1 VSS.P0.pSD 0.0219597f
Cred_24067 vin4.$449.Metal1 VSS.P19.nSD 0.00156422f
Cred_24068 vin4.$452.Metal1 vout4 1.6785e-06f
Cred_24069 vin4.$452.Metal1 vout4.$1424.Metal3 8.46547e-06f
Cred_24070 vin4.$452.Metal1 vout4.P18.nSD 1.33366e-07f
Cred_24071 vin4.$452.Metal1 vout4.P18.pSD 7.22317e-07f
Cred_24072 vin4.$456.Metal1 vout4 0.011952f
Cred_24073 vin4.$456.Metal1 vout4.$1424.Metal3 0.0602796f
Cred_24074 vin4.$456.Metal1 vout4.P18.nSD 0.000949648f
Cred_24075 vin4.$456.Metal1 vout4.P18.pSD 0.0606796f
Cred_24076 vin4.$456.Metal1 VSS.$4152.Metal2 0.000968708f
Cred_24077 vin4.$457.Metal1 vout4 0.00552697f
Cred_24078 vin4.$457.Metal1 vout4.$1424.Metal3 0.0280234f
Cred_24079 vin4.$457.Metal1 vout4.P16.nSD 1.39007e-06f
Cred_24080 vin4.$457.Metal1 vout4.P18.nSD 0.0269007f
Cred_24081 vin4.$457.Metal1 vout4.P18.pSD 0.00237845f
Cred_24082 vin4.$457.Metal1 VSS.$1800.Metal1 0.006826f
Cred_24083 vin4.$457.Metal1 VSS.$1878.Metal1 0.00151066f
Cred_24084 vin4.$457.Metal1 VSS.$1926.Metal1 0.000749035f
Cred_24085 vin4.$457.Metal1 VSS.$1986.Metal1 0.000630463f
Cred_24086 vin4.$457.Metal1 VSS.$1991.Metal1 0.00305066f
Cred_24087 vin4.$457.Metal1 VSS.$2023.Metal1 0.00850068f
Cred_24088 vin4.$457.Metal1 VSS.$4000.Metal2 0.000340553f
Cred_24089 vin4.$457.Metal1 VSS.$4032.Metal2 0.00027649f
Cred_24090 vin4.$457.Metal1 VSS.$4080.Metal2 2.30851e-05f
Cred_24091 vin4.$457.Metal1 VSS.$4128.Metal2 5.68117e-05f
Cred_24092 vin4.$457.Metal1 VSS.$4152.Metal2 5.27123e-06f
Cred_24093 vin4.$457.Metal1 VSS.$4241.Metal2 4.10417e-05f
Cred_24094 vin4.$457.Metal1 VSS.$5168.Metal3 1.75811e-07f
Cred_24095 vin4.$457.Metal1 VSS.$66.Metal1 2.24234e-05f
Cred_24096 vin4.$457.Metal1 VSS.P0.pSD 0.0570481f
Cred_24097 vin4.$457.Metal1 VSS.P1.GatPoly 0.00160798f
Cred_24098 vin4.$457.Metal1 VSS.P19.nSD 0.000253611f
Cred_24099 vin4.$457.Metal1 VSS.P21.nSD 5.78261e-06f
Cred_24100 vin4.$457.Metal1 VSS.P23.nSD 5.78261e-06f
Cred_24101 vin4.$47.GatPoly vout4.$1226.Metal3 0.00814711f
Cred_24102 vin4.$47.GatPoly vout4.$1292.Metal3 0.000689313f
Cred_24103 vin4.$47.GatPoly vout4.P4.nSD 0.0033717f
Cred_24104 vin4.$47.GatPoly vout4.P6.nSD 2.4445e-05f
Cred_24105 vin4.$47.GatPoly vout4.P6.pSD 5.93495e-05f
Cred_24106 vin4.$47.GatPoly VSS.$1991.Metal1 1.11471e-06f
Cred_24107 vin4.$47.GatPoly VSS.$2023.Metal1 2.791e-06f
Cred_24108 vin4.$47.GatPoly VSS.$2843.Metal2 2.87971e-11f
Cred_24109 vin4.$47.GatPoly VSS.$2867.Metal2 5.78817e-11f
Cred_24110 vin4.$47.GatPoly VSS.$2926.Metal2 0.00144469f
Cred_24111 vin4.$47.GatPoly VSS.$2958.Metal2 5.48618e-05f
Cred_24112 vin4.$47.GatPoly VSS.$4241.Metal2 7.47233e-09f
Cred_24113 vin4.$47.GatPoly VSS.$66.Metal1 0.000100497f
Cred_24114 vin4.$47.GatPoly VSS.$672.Metal1 3.44676e-09f
Cred_24115 vin4.$47.GatPoly VSS.$740.Metal1 9.19509e-08f
Cred_24116 vin4.$47.GatPoly VSS.$785.Metal1 0.0053483f
Cred_24117 vin4.$47.GatPoly VSS.P0.pSD 0.00266104f
Cred_24118 vin4.$47.GatPoly VSS.P7.nSD 4.45362e-05f
Cred_24119 vin4.$477.Metal2 vout4.$1226.Metal3 0.157549f
Cred_24120 vin4.$477.Metal2 vout4.P0.nSD 0.0112965f
Cred_24121 vin4.$477.Metal2 vout4.P0.pSD 0.0346722f
Cred_24122 vin4.$477.Metal2 vout4.P2.nSD 0.00248204f
Cred_24123 vin4.$477.Metal2 vout4.P2.pSD 0.0135649f
Cred_24124 vin4.$477.Metal2 VSS.$160.Metal1 0.00108378f
Cred_24125 vin4.$477.Metal2 VSS.$1991.Metal1 7.66263e-06f
Cred_24126 vin4.$477.Metal2 VSS.$2023.Metal1 1.91857e-05f
Cred_24127 vin4.$477.Metal2 VSS.$2240.Metal2 0.0179132f
Cred_24128 vin4.$477.Metal2 VSS.$2360.Metal2 0.000167068f
Cred_24129 vin4.$477.Metal2 VSS.$2421.Metal2 0.00124673f
Cred_24130 vin4.$477.Metal2 VSS.$2445.Metal2 0.00121999f
Cred_24131 vin4.$477.Metal2 VSS.$266.Metal1 2.65819e-05f
Cred_24132 vin4.$477.Metal2 VSS.$326.Metal1 2.43061e-05f
Cred_24133 vin4.$477.Metal2 VSS.$4241.Metal2 5.13657e-08f
Cred_24134 vin4.$477.Metal2 VSS.$4364.Metal3 0.00568807f
Cred_24135 vin4.$477.Metal2 VSS.$4424.Metal3 4.94716e-05f
Cred_24136 vin4.$477.Metal2 VSS.$4460.Metal3 3.51931e-05f
Cred_24137 vin4.$477.Metal2 VSS.$66.Metal1 0.0266358f
Cred_24138 vin4.$477.Metal2 VSS.P0.GatPoly 0.00153218f
Cred_24139 vin4.$477.Metal2 VSS.P0.nSD 4.65729e-06f
Cred_24140 vin4.$477.Metal2 VSS.P0.pSD 0.0870592f
Cred_24141 vin4.$477.Metal2 VSS.P1.nSD 4.65729e-06f
Cred_24142 vin4.$479.Metal2 vout4.$1226.Metal3 0.0863808f
Cred_24143 vin4.$479.Metal2 vout4.P0.nSD 0.00257215f
Cred_24144 vin4.$479.Metal2 vout4.P0.pSD 0.0378089f
Cred_24145 vin4.$479.Metal2 vout4.P2.nSD 0.00136085f
Cred_24146 vin4.$479.Metal2 vout4.P2.pSD 0.00743735f
Cred_24147 vin4.$479.Metal2 VSS.$1991.Metal1 1.04542e-06f
Cred_24148 vin4.$479.Metal2 VSS.$2023.Metal1 2.61753e-06f
Cred_24149 vin4.$479.Metal2 VSS.$2421.Metal2 9.4431e-07f
Cred_24150 vin4.$479.Metal2 VSS.$2445.Metal2 6.92477e-07f
Cred_24151 vin4.$479.Metal2 VSS.$4241.Metal2 7.00789e-09f
Cred_24152 vin4.$479.Metal2 VSS.$4364.Metal3 0.00686727f
Cred_24153 vin4.$479.Metal2 VSS.$4424.Metal3 0.000117777f
Cred_24154 vin4.$479.Metal2 VSS.$4460.Metal3 8.63677e-05f
Cred_24155 vin4.$479.Metal2 VSS.$66.Metal1 0.00905826f
Cred_24156 vin4.$479.Metal2 VSS.P0.GatPoly 0.00143774f
Cred_24157 vin4.$479.Metal2 VSS.P0.pSD 0.0173547f
Cred_24158 vin4.$480.Metal2 vout4.$1226.Metal3 0.0913809f
Cred_24159 vin4.$480.Metal2 vout4.P0.nSD 0.0191572f
Cred_24160 vin4.$480.Metal2 vout4.P0.pSD 0.0144591f
Cred_24161 vin4.$480.Metal2 vout4.P2.nSD 0.00143962f
Cred_24162 vin4.$480.Metal2 vout4.P2.pSD 0.00786786f
Cred_24163 vin4.$480.Metal2 VSS.$160.Metal1 0.00203839f
Cred_24164 vin4.$480.Metal2 VSS.$1991.Metal1 2.97162e-06f
Cred_24165 vin4.$480.Metal2 VSS.$2023.Metal1 7.44035e-06f
Cred_24166 vin4.$480.Metal2 VSS.$2240.Metal2 0.0333893f
Cred_24167 vin4.$480.Metal2 VSS.$2360.Metal2 0.000311402f
Cred_24168 vin4.$480.Metal2 VSS.$2421.Metal2 0.00232322f
Cred_24169 vin4.$480.Metal2 VSS.$2445.Metal2 0.00227355f
Cred_24170 vin4.$480.Metal2 VSS.$2493.Metal2 0.00280512f
Cred_24171 vin4.$480.Metal2 VSS.$2544.Metal2 0.00123426f
Cred_24172 vin4.$480.Metal2 VSS.$2576.Metal2 4.23036e-07f
Cred_24173 vin4.$480.Metal2 VSS.$266.Metal1 6.2926e-05f
Cred_24174 vin4.$480.Metal2 VSS.$326.Metal1 5.82599e-05f
Cred_24175 vin4.$480.Metal2 VSS.$374.Metal1 1.02915e-05f
Cred_24176 vin4.$480.Metal2 VSS.$387.Metal1 8.49027e-06f
Cred_24177 vin4.$480.Metal2 VSS.$4241.Metal2 1.992e-08f
Cred_24178 vin4.$480.Metal2 VSS.$4364.Metal3 0.00373512f
Cred_24179 vin4.$480.Metal2 VSS.$4424.Metal3 2.75835e-06f
Cred_24180 vin4.$480.Metal2 VSS.$4484.Metal3 9.89346e-06f
Cred_24181 vin4.$480.Metal2 VSS.$66.Metal1 0.0166472f
Cred_24182 vin4.$480.Metal2 VSS.P0.GatPoly 0.00144983f
Cred_24183 vin4.$480.Metal2 VSS.P0.nSD 8.80358e-06f
Cred_24184 vin4.$480.Metal2 VSS.P0.pSD 0.0392125f
Cred_24185 vin4.$480.Metal2 VSS.P1.nSD 8.80358e-06f
Cred_24186 vin4.$480.Metal2 VSS.P3.nSD 3.15318e-07f
Cred_24187 vin4.$483.Metal2 vout4.$1226.Metal3 0.018944f
Cred_24188 vin4.$483.Metal2 vout4.P0.nSD 0.000473205f
Cred_24189 vin4.$483.Metal2 vout4.P0.pSD 0.00280077f
Cred_24190 vin4.$483.Metal2 vout4.P2.nSD 0.000298445f
Cred_24191 vin4.$483.Metal2 vout4.P2.pSD 0.001896f
Cred_24192 vin4.$484.Metal2 vout4.$1226.Metal3 0.019879f
Cred_24193 vin4.$484.Metal2 vout4.P0.nSD 0.000543235f
Cred_24194 vin4.$484.Metal2 vout4.P0.pSD 0.00260114f
Cred_24195 vin4.$484.Metal2 vout4.P2.nSD 0.000366959f
Cred_24196 vin4.$484.Metal2 vout4.P2.pSD 0.00171158f
Cred_24197 vin4.$484.Metal2 VSS.$1991.Metal1 6.83783e-07f
Cred_24198 vin4.$484.Metal2 VSS.$2023.Metal1 1.71206e-06f
Cred_24199 vin4.$484.Metal2 VSS.$2493.Metal2 0.00123396f
Cred_24200 vin4.$484.Metal2 VSS.$2544.Metal2 0.0154724f
Cred_24201 vin4.$484.Metal2 VSS.$2576.Metal2 0.0191202f
Cred_24202 vin4.$484.Metal2 VSS.$374.Metal1 1.43018e-05f
Cred_24203 vin4.$484.Metal2 VSS.$387.Metal1 0.00303883f
Cred_24204 vin4.$484.Metal2 VSS.$4241.Metal2 4.58368e-09f
Cred_24205 vin4.$484.Metal2 VSS.$4484.Metal3 9.89362e-06f
Cred_24206 vin4.$484.Metal2 VSS.$66.Metal1 0.000781602f
Cred_24207 vin4.$484.Metal2 VSS.P0.pSD 0.00525331f
Cred_24208 vin4.$484.Metal2 VSS.P3.nSD 0.000105958f
Cred_24209 vin4.$486.Metal2 vout4.$1226.Metal3 0.0980332f
Cred_24210 vin4.$486.Metal2 vout4.P0.nSD 0.00241165f
Cred_24211 vin4.$486.Metal2 vout4.P0.pSD 0.0128154f
Cred_24212 vin4.$486.Metal2 vout4.P2.nSD 0.00156531f
Cred_24213 vin4.$486.Metal2 vout4.P2.pSD 0.00854352f
Cred_24214 vin4.$486.Metal2 VSS.$1991.Metal1 6.51159e-06f
Cred_24215 vin4.$486.Metal2 VSS.$2023.Metal1 1.63037e-05f
Cred_24216 vin4.$486.Metal2 VSS.$2544.Metal2 0.00221267f
Cred_24217 vin4.$486.Metal2 VSS.$2576.Metal2 0.0029713f
Cred_24218 vin4.$486.Metal2 VSS.$387.Metal1 0.000448976f
Cred_24219 vin4.$486.Metal2 VSS.$4241.Metal2 4.36498e-08f
Cred_24220 vin4.$486.Metal2 VSS.$66.Metal1 0.00642603f
Cred_24221 vin4.$486.Metal2 VSS.P0.pSD 0.0470997f
Cred_24222 vin4.$486.Metal2 VSS.P3.nSD 1.55876e-05f
Cred_24223 vin4.$488.Metal2 vout4.$1226.Metal3 0.0229136f
Cred_24224 vin4.$488.Metal2 vout4.P0.nSD 0.000485607f
Cred_24225 vin4.$488.Metal2 vout4.P0.pSD 0.00296482f
Cred_24226 vin4.$488.Metal2 vout4.P2.nSD 0.000360983f
Cred_24227 vin4.$488.Metal2 vout4.P2.pSD 0.00232861f
Cred_24228 vin4.$489.Metal2 vout4.$1226.Metal3 0.0241692f
Cred_24229 vin4.$489.Metal2 vout4.P0.nSD 0.000579645f
Cred_24230 vin4.$489.Metal2 vout4.P0.pSD 0.00269673f
Cred_24231 vin4.$489.Metal2 vout4.P2.nSD 0.000452987f
Cred_24232 vin4.$489.Metal2 vout4.P2.pSD 0.00208096f
Cred_24233 vin4.$489.Metal2 VSS.$1991.Metal1 1.09271e-06f
Cred_24234 vin4.$489.Metal2 VSS.$2023.Metal1 2.73592e-06f
Cred_24235 vin4.$489.Metal2 VSS.$2544.Metal2 0.0174818f
Cred_24236 vin4.$489.Metal2 VSS.$2576.Metal2 0.0246652f
Cred_24237 vin4.$489.Metal2 VSS.$2632.Metal2 0.00118965f
Cred_24238 vin4.$489.Metal2 VSS.$387.Metal1 0.00370329f
Cred_24239 vin4.$489.Metal2 VSS.$4241.Metal2 7.32486e-09f
Cred_24240 vin4.$489.Metal2 VSS.$4520.Metal3 9.53831e-06f
Cred_24241 vin4.$489.Metal2 VSS.$465.Metal1 1.33539e-05f
Cred_24242 vin4.$489.Metal2 VSS.$513.Metal1 2.20468e-07f
Cred_24243 vin4.$489.Metal2 VSS.$66.Metal1 0.000992589f
Cred_24244 vin4.$489.Metal2 VSS.P0.pSD 0.00759969f
Cred_24245 vin4.$489.Metal2 VSS.P3.nSD 0.000129173f
Cred_24246 vin4.$492.Metal2 vout4.$1226.Metal3 0.0495575f
Cred_24247 vin4.$492.Metal2 vout4.P0.nSD 0.00071767f
Cred_24248 vin4.$492.Metal2 vout4.P0.pSD 0.00381358f
Cred_24249 vin4.$492.Metal2 vout4.P2.nSD 0.000780732f
Cred_24250 vin4.$492.Metal2 vout4.P2.pSD 0.014777f
Cred_24251 vin4.$493.Metal2 vout4.$1226.Metal3 0.0303152f
Cred_24252 vin4.$493.Metal2 vout4.P0.nSD 0.000439011f
Cred_24253 vin4.$493.Metal2 vout4.P0.pSD 0.00233283f
Cred_24254 vin4.$493.Metal2 vout4.P2.nSD 0.00472695f
Cred_24255 vin4.$493.Metal2 vout4.P2.pSD 0.00261012f
Cred_24256 vin4.$493.Metal2 VSS.$1991.Metal1 7.11529e-07f
Cred_24257 vin4.$493.Metal2 VSS.$2023.Metal1 1.78153e-06f
Cred_24258 vin4.$493.Metal2 VSS.$2544.Metal2 6.70053e-07f
Cred_24259 vin4.$493.Metal2 VSS.$2576.Metal2 0.00119052f
Cred_24260 vin4.$493.Metal2 VSS.$2632.Metal2 0.00353881f
Cred_24261 vin4.$493.Metal2 VSS.$387.Metal1 1.75061e-05f
Cred_24262 vin4.$493.Metal2 VSS.$4241.Metal2 4.76967e-09f
Cred_24263 vin4.$493.Metal2 VSS.$4520.Metal3 9.53807e-06f
Cred_24264 vin4.$493.Metal2 VSS.$465.Metal1 1.24159e-05f
Cred_24265 vin4.$493.Metal2 VSS.$513.Metal1 5.98294e-07f
Cred_24266 vin4.$493.Metal2 VSS.$66.Metal1 0.000453989f
Cred_24267 vin4.$493.Metal2 VSS.P0.pSD 0.00425093f
Cred_24268 vin4.$493.Metal2 VSS.P3.nSD 6.69298e-07f
Cred_24269 vin4.$495.Metal2 vout4.$1226.Metal3 0.130126f
Cred_24270 vin4.$495.Metal2 vout4.P0.nSD 0.00188443f
Cred_24271 vin4.$495.Metal2 vout4.P0.pSD 0.0100136f
Cred_24272 vin4.$495.Metal2 vout4.P2.nSD 0.00319518f
Cred_24273 vin4.$495.Metal2 vout4.P2.pSD 0.015747f
Cred_24274 vin4.$495.Metal2 VSS.$1991.Metal1 9.19956e-06f
Cred_24275 vin4.$495.Metal2 VSS.$2023.Metal1 2.30338e-05f
Cred_24276 vin4.$495.Metal2 VSS.$4241.Metal2 6.16684e-08f
Cred_24277 vin4.$495.Metal2 VSS.$66.Metal1 0.00448474f
Cred_24278 vin4.$495.Metal2 VSS.P0.pSD 0.0484988f
Cred_24279 vin4.$498.Metal2 vout4.$1226.Metal3 0.0769369f
Cred_24280 vin4.$498.Metal2 vout4.P0.nSD 0.00111417f
Cred_24281 vin4.$498.Metal2 vout4.P0.pSD 0.0059205f
Cred_24282 vin4.$498.Metal2 vout4.P2.nSD 0.0141958f
Cred_24283 vin4.$498.Metal2 vout4.P2.pSD 0.00662423f
Cred_24284 vin4.$498.Metal2 VSS.$1991.Metal1 2.22225e-06f
Cred_24285 vin4.$498.Metal2 VSS.$2023.Metal1 5.56408e-06f
Cred_24286 vin4.$498.Metal2 VSS.$2680.Metal2 0.00282265f
Cred_24287 vin4.$498.Metal2 VSS.$2739.Metal2 0.00120609f
Cred_24288 vin4.$498.Metal2 VSS.$2771.Metal2 0.00019419f
Cred_24289 vin4.$498.Metal2 VSS.$4241.Metal2 1.48967e-08f
Cred_24290 vin4.$498.Metal2 VSS.$4568.Metal3 6.12031e-06f
Cred_24291 vin4.$498.Metal2 VSS.$553.Metal1 6.12031e-06f
Cred_24292 vin4.$498.Metal2 VSS.$566.Metal1 5.49654e-05f
Cred_24293 vin4.$498.Metal2 VSS.$66.Metal1 0.00103988f
Cred_24294 vin4.$498.Metal2 VSS.P0.pSD 0.0114396f
Cred_24295 vin4.$498.Metal2 VSS.P5.nSD 1.90837e-06f
Cred_24296 vin4.$499.Metal2 vout4.$1226.Metal3 0.0453728f
Cred_24297 vin4.$499.Metal2 vout4.P0.nSD 0.000657069f
Cred_24298 vin4.$499.Metal2 vout4.P0.pSD 0.00349156f
Cred_24299 vin4.$499.Metal2 vout4.P2.nSD 0.000714806f
Cred_24300 vin4.$499.Metal2 vout4.P2.pSD 0.0129722f
Cred_24301 vin4.$503.Metal2 vout4.$1226.Metal3 0.0299793f
Cred_24302 vin4.$503.Metal2 vout4.P0.nSD 0.00024078f
Cred_24303 vin4.$503.Metal2 vout4.P0.pSD 0.00127947f
Cred_24304 vin4.$503.Metal2 vout4.P2.nSD 0.000261938f
Cred_24305 vin4.$503.Metal2 vout4.P2.pSD 0.00181934f
Cred_24306 vin4.$503.Metal2 vout4.P4.pSD 0.000387787f
Cred_24307 vin4.$504.Metal2 vout4.$1226.Metal3 0.0387021f
Cred_24308 vin4.$504.Metal2 vout4.P0.nSD 0.00036249f
Cred_24309 vin4.$504.Metal2 vout4.P0.pSD 0.00192621f
Cred_24310 vin4.$504.Metal2 vout4.P2.nSD 0.00144319f
Cred_24311 vin4.$504.Metal2 vout4.P2.pSD 0.00215517f
Cred_24312 vin4.$504.Metal2 vout4.P4.nSD 6.94739e-05f
Cred_24313 vin4.$504.Metal2 VSS.$1991.Metal1 2.21818e-06f
Cred_24314 vin4.$504.Metal2 VSS.$2023.Metal1 5.55388e-06f
Cred_24315 vin4.$504.Metal2 VSS.$2680.Metal2 0.00256115f
Cred_24316 vin4.$504.Metal2 VSS.$2739.Metal2 0.0328856f
Cred_24317 vin4.$504.Metal2 VSS.$2771.Metal2 0.0137476f
Cred_24318 vin4.$504.Metal2 VSS.$4241.Metal2 1.48694e-08f
Cred_24319 vin4.$504.Metal2 VSS.$4568.Metal3 1.23569e-05f
Cred_24320 vin4.$504.Metal2 VSS.$553.Metal1 1.23569e-05f
Cred_24321 vin4.$504.Metal2 VSS.$566.Metal1 0.00393458f
Cred_24322 vin4.$504.Metal2 VSS.$66.Metal1 0.000623986f
Cred_24323 vin4.$504.Metal2 VSS.P0.pSD 0.00903713f
Cred_24324 vin4.$504.Metal2 VSS.P5.nSD 0.000136794f
Cred_24325 vin4.$506.Metal2 vout4.$1226.Metal3 0.109705f
Cred_24326 vin4.$506.Metal2 vout4.P0.nSD 0.000720669f
Cred_24327 vin4.$506.Metal2 vout4.P0.pSD 0.00382952f
Cred_24328 vin4.$506.Metal2 vout4.P2.nSD 0.000792089f
Cred_24329 vin4.$506.Metal2 vout4.P2.pSD 0.00432936f
Cred_24330 vin4.$506.Metal2 vout4.P4.nSD 8.09507e-06f
Cred_24331 vin4.$506.Metal2 vout4.P4.pSD 4.46531e-05f
Cred_24332 vin4.$506.Metal2 VSS.$1991.Metal1 1.29956e-05f
Cred_24333 vin4.$506.Metal2 VSS.$2023.Metal1 3.25383e-05f
Cred_24334 vin4.$506.Metal2 VSS.$2739.Metal2 0.00330681f
Cred_24335 vin4.$506.Metal2 VSS.$2771.Metal2 0.00145036f
Cred_24336 vin4.$506.Metal2 VSS.$4241.Metal2 8.71145e-08f
Cred_24337 vin4.$506.Metal2 VSS.$566.Metal1 0.000410524f
Cred_24338 vin4.$506.Metal2 VSS.$66.Metal1 0.00316293f
Cred_24339 vin4.$506.Metal2 VSS.P0.pSD 0.049622f
Cred_24340 vin4.$506.Metal2 VSS.P5.nSD 1.42532e-05f
Cred_24341 vin4.$508.Metal2 vout4.$1226.Metal3 0.0174091f
Cred_24342 vin4.$508.Metal2 vout4.P0.nSD 5.31665e-05f
Cred_24343 vin4.$508.Metal2 vout4.P0.pSD 0.000282518f
Cred_24344 vin4.$508.Metal2 vout4.P2.nSD 5.78383e-05f
Cred_24345 vin4.$508.Metal2 vout4.P2.pSD 0.000410889f
Cred_24346 vin4.$508.Metal2 vout4.P4.pSD 9.47899e-05f
Cred_24347 vin4.$509.Metal2 vout4.$1226.Metal3 0.0171927f
Cred_24348 vin4.$509.Metal2 vout4.P0.nSD 5.41085e-05f
Cred_24349 vin4.$509.Metal2 vout4.P0.pSD 0.000287524f
Cred_24350 vin4.$509.Metal2 vout4.P2.nSD 7.60473e-05f
Cred_24351 vin4.$509.Metal2 vout4.P2.pSD 0.0003217f
Cred_24352 vin4.$509.Metal2 vout4.P4.nSD 1.71843e-05f
Cred_24353 vin4.$509.Metal2 VSS.$1991.Metal1 1.71427e-06f
Cred_24354 vin4.$509.Metal2 VSS.$2023.Metal1 4.29217e-06f
Cred_24355 vin4.$509.Metal2 VSS.$2739.Metal2 0.0187469f
Cred_24356 vin4.$509.Metal2 VSS.$2771.Metal2 0.00942665f
Cred_24357 vin4.$509.Metal2 VSS.$2795.Metal2 0.00249571f
Cred_24358 vin4.$509.Metal2 VSS.$4241.Metal2 1.14914e-08f
Cred_24359 vin4.$509.Metal2 VSS.$566.Metal1 0.00250348f
Cred_24360 vin4.$509.Metal2 VSS.$66.Metal1 0.000364753f
Cred_24361 vin4.$509.Metal2 VSS.P0.pSD 0.00612796f
Cred_24362 vin4.$509.Metal2 VSS.P5.nSD 8.75729e-05f
Cred_24363 vin4.$512.Metal2 vout4.$1226.Metal3 0.0496893f
Cred_24364 vin4.$512.Metal2 vout4.P4.pSD 0.00878399f
Cred_24365 vin4.$513.Metal2 vout4.$1226.Metal3 0.0580995f
Cred_24366 vin4.$513.Metal2 vout4.P4.nSD 0.00708686f
Cred_24367 vin4.$513.Metal2 VSS.$1991.Metal1 1.69801e-06f
Cred_24368 vin4.$513.Metal2 VSS.$2023.Metal1 4.25146e-06f
Cred_24369 vin4.$513.Metal2 VSS.$2795.Metal2 0.00305041f
Cred_24370 vin4.$513.Metal2 VSS.$2843.Metal2 0.000554698f
Cred_24371 vin4.$513.Metal2 VSS.$4241.Metal2 1.13824e-08f
Cred_24372 vin4.$513.Metal2 VSS.$4616.Metal3 4.44744e-06f
Cred_24373 vin4.$513.Metal2 VSS.$66.Metal1 0.000250088f
Cred_24374 vin4.$513.Metal2 VSS.$672.Metal1 4.44744e-06f
Cred_24375 vin4.$513.Metal2 VSS.P0.pSD 0.00509649f
Cred_24376 vin4.$515.Metal2 vout4.$1226.Metal3 0.174793f
Cred_24377 vin4.$515.Metal2 vout4.$1292.Metal3 0.00903794f
Cred_24378 vin4.$515.Metal2 vout4.P4.nSD 0.00122542f
Cred_24379 vin4.$515.Metal2 vout4.P4.pSD 0.00137652f
Cred_24380 vin4.$515.Metal2 vout4.P6.nSD 0.000142683f
Cred_24381 vin4.$515.Metal2 vout4.P6.pSD 0.000778162f
Cred_24382 vin4.$515.Metal2 VSS.$1991.Metal1 2.81179e-05f
Cred_24383 vin4.$515.Metal2 VSS.$2023.Metal1 7.04016e-05f
Cred_24384 vin4.$515.Metal2 VSS.$2926.Metal2 0.00149036f
Cred_24385 vin4.$515.Metal2 VSS.$2958.Metal2 5.65961e-05f
Cred_24386 vin4.$515.Metal2 VSS.$4241.Metal2 1.88486e-07f
Cred_24387 vin4.$515.Metal2 VSS.$66.Metal1 0.00289581f
Cred_24388 vin4.$515.Metal2 VSS.$785.Metal1 0.000143935f
Cred_24389 vin4.$515.Metal2 VSS.P0.pSD 0.0704749f
Cred_24390 vin4.$515.Metal2 VSS.P7.nSD 8.41734e-07f
Cred_24391 vin4.$517.Metal2 vout4.$1226.Metal3 0.0607039f
Cred_24392 vin4.$517.Metal2 vout4.P4.pSD 0.0130944f
Cred_24393 vin4.$518.Metal2 vout4.$1226.Metal3 0.0773344f
Cred_24394 vin4.$518.Metal2 vout4.P4.nSD 0.0112674f
Cred_24395 vin4.$518.Metal2 VSS.$1991.Metal1 3.70178e-06f
Cred_24396 vin4.$518.Metal2 VSS.$2023.Metal1 9.2685e-06f
Cred_24397 vin4.$518.Metal2 VSS.$2843.Metal2 6.12933e-09f
Cred_24398 vin4.$518.Metal2 VSS.$2867.Metal2 0.00339829f
Cred_24399 vin4.$518.Metal2 VSS.$2926.Metal2 0.00468475f
Cred_24400 vin4.$518.Metal2 VSS.$2958.Metal2 0.000160829f
Cred_24401 vin4.$518.Metal2 VSS.$4241.Metal2 2.48145e-08f
Cred_24402 vin4.$518.Metal2 VSS.$4652.Metal3 3.60466e-06f
Cred_24403 vin4.$518.Metal2 VSS.$66.Metal1 0.000412597f
Cred_24404 vin4.$518.Metal2 VSS.$672.Metal1 7.33628e-07f
Cred_24405 vin4.$518.Metal2 VSS.$740.Metal1 5.22427e-06f
Cred_24406 vin4.$518.Metal2 VSS.$785.Metal1 0.000409021f
Cred_24407 vin4.$518.Metal2 VSS.P0.pSD 0.00970868f
Cred_24408 vin4.$518.Metal2 VSS.P7.nSD 2.39196e-06f
Cred_24409 vin4.$519.Metal2 vout4.$1226.Metal3 0.0191896f
Cred_24410 vin4.$519.Metal2 vout4.$1292.Metal3 4.91937e-05f
Cred_24411 vin4.$519.Metal2 vout4.P4.pSD 0.000892535f
Cred_24412 vin4.$519.Metal2 vout4.P6.nSD 7.75001e-07f
Cred_24413 vin4.$519.Metal2 vout4.P6.pSD 9.98113e-06f
Cred_24414 vin4.$52.GatPoly vout4.$1226.Metal3 3.63287e-08f
Cred_24415 vin4.$52.GatPoly vout4.$1292.Metal3 8.57734e-09f
Cred_24416 vin4.$52.GatPoly vout4.P4.pSD 1.00179e-09f
Cred_24417 vin4.$52.GatPoly vout4.P6.nSD 1.35128e-10f
Cred_24418 vin4.$52.GatPoly vout4.P6.pSD 1.7403e-09f
Cred_24419 vin4.$524.Metal2 vout4.$1226.Metal3 0.0510252f
Cred_24420 vin4.$524.Metal2 vout4.$1292.Metal3 0.0134562f
Cred_24421 vin4.$524.Metal2 vout4.P4.nSD 0.000190756f
Cred_24422 vin4.$524.Metal2 vout4.P6.nSD 0.000304649f
Cred_24423 vin4.$524.Metal2 vout4.P6.pSD 0.00115857f
Cred_24424 vin4.$524.Metal2 VSS.$1991.Metal1 1.05223e-05f
Cred_24425 vin4.$524.Metal2 VSS.$2023.Metal1 2.63457e-05f
Cred_24426 vin4.$524.Metal2 VSS.$2843.Metal2 3.03569e-09f
Cred_24427 vin4.$524.Metal2 VSS.$2867.Metal2 0.00236814f
Cred_24428 vin4.$524.Metal2 VSS.$2926.Metal2 0.0514072f
Cred_24429 vin4.$524.Metal2 VSS.$2958.Metal2 0.0019177f
Cred_24430 vin4.$524.Metal2 VSS.$4241.Metal2 7.05351e-08f
Cred_24431 vin4.$524.Metal2 VSS.$4652.Metal3 7.27792e-06f
Cred_24432 vin4.$524.Metal2 VSS.$66.Metal1 0.000682296f
Cred_24433 vin4.$524.Metal2 VSS.$672.Metal1 3.63346e-07f
Cred_24434 vin4.$524.Metal2 VSS.$740.Metal1 8.08006e-06f
Cred_24435 vin4.$524.Metal2 VSS.$785.Metal1 0.00513633f
Cred_24436 vin4.$524.Metal2 VSS.P0.pSD 0.02128f
Cred_24437 vin4.$524.Metal2 VSS.P7.nSD 3.10561e-05f
Cred_24438 vin4.$525.Metal2 vout4.$1226.Metal3 0.0502821f
Cred_24439 vin4.$525.Metal2 vout4.$1292.Metal3 0.0180083f
Cred_24440 vin4.$525.Metal2 vout4.P4.nSD 1.43057e-07f
Cred_24441 vin4.$525.Metal2 vout4.P4.pSD 0.000521155f
Cred_24442 vin4.$525.Metal2 vout4.P6.nSD 0.000283847f
Cred_24443 vin4.$525.Metal2 vout4.P6.pSD 0.00230869f
Cred_24444 vin4.$525.Metal2 VSS.$1991.Metal1 4.18072e-06f
Cred_24445 vin4.$525.Metal2 VSS.$2023.Metal1 1.04677e-05f
Cred_24446 vin4.$525.Metal2 VSS.$2926.Metal2 0.000713896f
Cred_24447 vin4.$525.Metal2 VSS.$2958.Metal2 2.711e-05f
Cred_24448 vin4.$525.Metal2 VSS.$4241.Metal2 2.80251e-08f
Cred_24449 vin4.$525.Metal2 VSS.$66.Metal1 0.000253219f
Cred_24450 vin4.$525.Metal2 VSS.$785.Metal1 6.89462e-05f
Cred_24451 vin4.$525.Metal2 VSS.P0.pSD 0.00819969f
Cred_24452 vin4.$525.Metal2 VSS.P7.nSD 4.03198e-07f
Cred_24453 vin4.$529.Metal2 vout4.$1226.Metal3 0.00731763f
Cred_24454 vin4.$529.Metal2 vout4.$1292.Metal3 0.00647235f
Cred_24455 vin4.$529.Metal2 vout4.P4.nSD 1.35309e-06f
Cred_24456 vin4.$529.Metal2 vout4.P6.nSD 0.000127075f
Cred_24457 vin4.$529.Metal2 vout4.P6.pSD 0.000557266f
Cred_24458 vin4.$529.Metal2 VSS.$1991.Metal1 2.64576e-06f
Cred_24459 vin4.$529.Metal2 VSS.$2023.Metal1 6.62445e-06f
Cred_24460 vin4.$529.Metal2 VSS.$2926.Metal2 0.016193f
Cred_24461 vin4.$529.Metal2 VSS.$2958.Metal2 0.00415717f
Cred_24462 vin4.$529.Metal2 VSS.$3006.Metal2 0.00113256f
Cred_24463 vin4.$529.Metal2 VSS.$4241.Metal2 1.77356e-08f
Cred_24464 vin4.$529.Metal2 VSS.$4688.Metal3 9.08056e-06f
Cred_24465 vin4.$529.Metal2 VSS.$66.Metal1 0.000121608f
Cred_24466 vin4.$529.Metal2 VSS.$771.Metal1 2.61458e-06f
Cred_24467 vin4.$529.Metal2 VSS.$785.Metal1 0.0015806f
Cred_24468 vin4.$529.Metal2 VSS.$831.Metal1 1.90177e-05f
Cred_24469 vin4.$529.Metal2 VSS.$879.Metal1 4.71576e-07f
Cred_24470 vin4.$529.Metal2 VSS.P0.pSD 0.00454296f
Cred_24471 vin4.$529.Metal2 VSS.P7.nSD 9.28578e-06f
Cred_24472 vin4.$53.GatPoly VSS.$1991.Metal1 1.4764e-06f
Cred_24473 vin4.$53.GatPoly VSS.$2023.Metal1 3.69662e-06f
Cred_24474 vin4.$53.GatPoly VSS.$2843.Metal2 2.20213e-11f
Cred_24475 vin4.$53.GatPoly VSS.$2867.Metal2 4.42625e-11f
Cred_24476 vin4.$53.GatPoly VSS.$2926.Metal2 0.000147958f
Cred_24477 vin4.$53.GatPoly VSS.$2958.Metal2 6.46772e-06f
Cred_24478 vin4.$53.GatPoly VSS.$4241.Metal2 9.89694e-09f
Cred_24479 vin4.$53.GatPoly VSS.$66.Metal1 9.52108e-05f
Cred_24480 vin4.$53.GatPoly VSS.$672.Metal1 2.63576e-09f
Cred_24481 vin4.$53.GatPoly VSS.$740.Metal1 7.03154e-08f
Cred_24482 vin4.$53.GatPoly VSS.$771.Metal1 0.00548286f
Cred_24483 vin4.$53.GatPoly VSS.$785.Metal1 0.00687275f
Cred_24484 vin4.$53.GatPoly VSS.$831.Metal1 0.000101628f
Cred_24485 vin4.$53.GatPoly VSS.P0.pSD 0.00299787f
Cred_24486 vin4.$53.GatPoly VSS.P7.nSD 6.41932e-05f
Cred_24487 vin4.$532.Metal2 vout4.$1226.Metal3 0.0331409f
Cred_24488 vin4.$532.Metal2 vout4.$1292.Metal3 0.0331409f
Cred_24489 vin4.$532.Metal2 vout4.P6.nSD 0.000522104f
Cred_24490 vin4.$532.Metal2 vout4.P6.pSD 0.0155504f
Cred_24491 vin4.$533.Metal2 vout4.$1226.Metal3 0.0341047f
Cred_24492 vin4.$533.Metal2 vout4.$1292.Metal3 0.0341047f
Cred_24493 vin4.$533.Metal2 vout4.P6.nSD 0.0110654f
Cred_24494 vin4.$533.Metal2 vout4.P6.pSD 0.0029364f
Cred_24495 vin4.$533.Metal2 VSS.$1991.Metal1 5.08548e-06f
Cred_24496 vin4.$533.Metal2 VSS.$2023.Metal1 1.2733e-05f
Cred_24497 vin4.$533.Metal2 VSS.$2926.Metal2 3.72161e-08f
Cred_24498 vin4.$533.Metal2 VSS.$2958.Metal2 0.00113253f
Cred_24499 vin4.$533.Metal2 VSS.$3006.Metal2 0.00113252f
Cred_24500 vin4.$533.Metal2 VSS.$4241.Metal2 3.40901e-08f
Cred_24501 vin4.$533.Metal2 VSS.$4688.Metal3 9.08029e-06f
Cred_24502 vin4.$533.Metal2 VSS.$66.Metal1 0.000174871f
Cred_24503 vin4.$533.Metal2 VSS.$771.Metal1 7.82459e-07f
Cred_24504 vin4.$533.Metal2 VSS.$785.Metal1 1.72537e-06f
Cred_24505 vin4.$533.Metal2 VSS.$831.Metal1 1.35199e-05f
Cred_24506 vin4.$533.Metal2 VSS.$879.Metal1 3.09872e-07f
Cred_24507 vin4.$533.Metal2 VSS.P0.pSD 0.00753904f
Cred_24508 vin4.$533.Metal2 VSS.P7.nSD 1.44361e-08f
Cred_24509 vin4.$535.Metal2 vout4.$1226.Metal3 0.0985516f
Cred_24510 vin4.$535.Metal2 vout4.$1292.Metal3 0.0796002f
Cred_24511 vin4.$535.Metal2 vout4.P4.nSD 2.98653e-07f
Cred_24512 vin4.$535.Metal2 vout4.P6.nSD 0.0025442f
Cred_24513 vin4.$535.Metal2 vout4.P6.pSD 0.00832419f
Cred_24514 vin4.$535.Metal2 VSS.$1991.Metal1 4.72023e-05f
Cred_24515 vin4.$535.Metal2 VSS.$2023.Metal1 0.000118185f
Cred_24516 vin4.$535.Metal2 VSS.$2926.Metal2 0.00149036f
Cred_24517 vin4.$535.Metal2 VSS.$2958.Metal2 5.65961e-05f
Cred_24518 vin4.$535.Metal2 VSS.$4241.Metal2 3.16416e-07f
Cred_24519 vin4.$535.Metal2 VSS.$66.Metal1 0.0016942f
Cred_24520 vin4.$535.Metal2 VSS.$785.Metal1 0.000143935f
Cred_24521 vin4.$535.Metal2 VSS.P0.pSD 0.0709058f
Cred_24522 vin4.$535.Metal2 VSS.P7.nSD 8.41734e-07f
Cred_24523 vin4.$537.Metal2 vout4.$1226.Metal3 0.0255876f
Cred_24524 vin4.$537.Metal2 vout4.$1292.Metal3 0.0255876f
Cred_24525 vin4.$537.Metal2 vout4.P6.nSD 0.000403108f
Cred_24526 vin4.$537.Metal2 vout4.P6.pSD 0.0119442f
Cred_24527 vin4.$538.Metal2 vout4.$1226.Metal3 0.0274843f
Cred_24528 vin4.$538.Metal2 vout4.$1292.Metal3 0.0274843f
Cred_24529 vin4.$538.Metal2 vout4.P6.nSD 0.00821533f
Cred_24530 vin4.$538.Metal2 vout4.P6.pSD 0.00236638f
Cred_24531 vin4.$538.Metal2 VSS.$1991.Metal1 4.64494e-06f
Cred_24532 vin4.$538.Metal2 VSS.$2023.Metal1 1.163e-05f
Cred_24533 vin4.$538.Metal2 VSS.$3054.Metal2 0.00239142f
Cred_24534 vin4.$538.Metal2 VSS.$3078.Metal2 1.41269e-07f
Cred_24535 vin4.$538.Metal2 VSS.$3113.Metal2 4.48317e-07f
Cred_24536 vin4.$538.Metal2 VSS.$4241.Metal2 3.11369e-08f
Cred_24537 vin4.$538.Metal2 VSS.$66.Metal1 0.000126348f
Cred_24538 vin4.$538.Metal2 VSS.$879.Metal1 7.70326e-07f
Cred_24539 vin4.$538.Metal2 VSS.$924.Metal1 7.44747e-06f
Cred_24540 vin4.$538.Metal2 VSS.P0.pSD 0.00612765f
Cred_24541 vin4.$538.Metal2 VSS.P10.nSD 2.46691e-07f
Cred_24542 vin4.$541.Metal2 vout4.$1226.Metal3 0.00627618f
Cred_24543 vin4.$541.Metal2 vout4.$1292.Metal3 0.00943108f
Cred_24544 vin4.$541.Metal2 vout4.P6.nSD 9.88754e-05f
Cred_24545 vin4.$541.Metal2 vout4.P6.pSD 0.000719226f
Cred_24546 vin4.$541.Metal2 vout4.P8.pSD 6.00928e-05f
Cred_24547 vin4.$542.Metal2 vout4.$1226.Metal3 0.00916639f
Cred_24548 vin4.$542.Metal2 vout4.$1292.Metal3 0.0189675f
Cred_24549 vin4.$542.Metal2 vout4.P6.nSD 0.000193831f
Cred_24550 vin4.$542.Metal2 vout4.P6.pSD 0.000789222f
Cred_24551 vin4.$542.Metal2 vout4.P8.nSD 4.02867e-05f
Cred_24552 vin4.$542.Metal2 VSS.$1991.Metal1 7.29726e-06f
Cred_24553 vin4.$542.Metal2 VSS.$2023.Metal1 1.82709e-05f
Cred_24554 vin4.$542.Metal2 VSS.$3054.Metal2 0.00239151f
Cred_24555 vin4.$542.Metal2 VSS.$3078.Metal2 0.0111327f
Cred_24556 vin4.$542.Metal2 VSS.$3113.Metal2 0.0320645f
Cred_24557 vin4.$542.Metal2 VSS.$4241.Metal2 4.89165e-08f
Cred_24558 vin4.$542.Metal2 VSS.$66.Metal1 0.000123002f
Cred_24559 vin4.$542.Metal2 VSS.$879.Metal1 4.15136e-06f
Cred_24560 vin4.$542.Metal2 VSS.$924.Metal1 0.0036981f
Cred_24561 vin4.$542.Metal2 VSS.P0.pSD 0.00757602f
Cred_24562 vin4.$542.Metal2 VSS.P10.nSD 0.000128589f
Cred_24563 vin4.$544.Metal2 vout4.$1226.Metal3 0.0296503f
Cred_24564 vin4.$544.Metal2 vout4.$1292.Metal3 0.0916487f
Cred_24565 vin4.$544.Metal2 vout4.P6.nSD 0.000488088f
Cred_24566 vin4.$544.Metal2 vout4.P6.pSD 0.00258416f
Cred_24567 vin4.$544.Metal2 vout4.P8.nSD 2.09757e-05f
Cred_24568 vin4.$544.Metal2 vout4.P8.pSD 3.1288e-05f
Cred_24569 vin4.$544.Metal2 VSS.$1991.Metal1 5.38933e-05f
Cred_24570 vin4.$544.Metal2 VSS.$2023.Metal1 0.000134938f
Cred_24571 vin4.$544.Metal2 VSS.$3078.Metal2 0.00304655f
Cred_24572 vin4.$544.Metal2 VSS.$3113.Metal2 0.0101017f
Cred_24573 vin4.$544.Metal2 VSS.$4241.Metal2 3.61269e-07f
Cred_24574 vin4.$544.Metal2 VSS.$66.Metal1 0.000812219f
Cred_24575 vin4.$544.Metal2 VSS.$924.Metal1 0.00114188f
Cred_24576 vin4.$544.Metal2 VSS.P0.pSD 0.0533417f
Cred_24577 vin4.$544.Metal2 VSS.P10.nSD 3.96969e-05f
Cred_24578 vin4.$546.Metal2 vout4.$1226.Metal3 0.00721531f
Cred_24579 vin4.$546.Metal2 vout4.$1292.Metal3 0.0281306f
Cred_24580 vin4.$546.Metal2 vout4.P6.nSD 0.00011367f
Cred_24581 vin4.$546.Metal2 vout4.P6.pSD 0.00105708f
Cred_24582 vin4.$546.Metal2 vout4.P8.pSD 0.000435848f
Cred_24583 vin4.$549.Metal2 vout4.$1226.Metal3 0.00310844f
Cred_24584 vin4.$549.Metal2 vout4.$1292.Metal3 0.0294593f
Cred_24585 vin4.$549.Metal2 vout4.P6.nSD 8.18366e-05f
Cred_24586 vin4.$549.Metal2 vout4.P6.pSD 0.000267635f
Cred_24587 vin4.$549.Metal2 vout4.P8.nSD 0.00115887f
Cred_24588 vin4.$549.Metal2 VSS.$1038.Metal1 4.46539e-07f
Cred_24589 vin4.$549.Metal2 VSS.$1991.Metal1 8.57375e-06f
Cred_24590 vin4.$549.Metal2 VSS.$2023.Metal1 2.14669e-05f
Cred_24591 vin4.$549.Metal2 VSS.$3078.Metal2 0.00559985f
Cred_24592 vin4.$549.Metal2 VSS.$3113.Metal2 0.020359f
Cred_24593 vin4.$549.Metal2 VSS.$3169.Metal2 0.0034856f
Cred_24594 vin4.$549.Metal2 VSS.$4241.Metal2 5.74733e-08f
Cred_24595 vin4.$549.Metal2 VSS.$4760.Metal3 1.43603e-05f
Cred_24596 vin4.$549.Metal2 VSS.$66.Metal1 0.000107679f
Cred_24597 vin4.$549.Metal2 VSS.$924.Metal1 0.0021025f
Cred_24598 vin4.$549.Metal2 VSS.$990.Metal1 3.56627e-05f
Cred_24599 vin4.$549.Metal2 VSS.P0.pSD 0.00772963f
Cred_24600 vin4.$549.Metal2 VSS.P10.nSD 7.31077e-05f
Cred_24601 vin4.$550.Metal2 vout4.$1292.Metal3 0.0524597f
Cred_24602 vin4.$550.Metal2 vout4.P8.pSD 0.00841488f
Cred_24603 vin4.$553.Metal2 vout4.$1292.Metal3 0.081548f
Cred_24604 vin4.$553.Metal2 vout4.P8.nSD 0.0121718f
Cred_24605 vin4.$553.Metal2 VSS.$1991.Metal1 1.43541e-05f
Cred_24606 vin4.$553.Metal2 VSS.$2023.Metal1 3.59398e-05f
Cred_24607 vin4.$553.Metal2 VSS.$3169.Metal2 0.00169455f
Cred_24608 vin4.$553.Metal2 VSS.$4241.Metal2 9.62213e-08f
Cred_24609 vin4.$553.Metal2 VSS.$66.Metal1 0.000108021f
Cred_24610 vin4.$553.Metal2 VSS.P0.pSD 0.0100229f
Cred_24611 vin4.$555.Metal2 vout4.$1292.Metal3 0.155728f
Cred_24612 vin4.$555.Metal2 vout4.P8.nSD 0.00114827f
Cred_24613 vin4.$555.Metal2 vout4.P8.pSD 0.00427509f
Cred_24614 vin4.$555.Metal2 VSS.$1991.Metal1 7.60665e-05f
Cred_24615 vin4.$555.Metal2 VSS.$2023.Metal1 0.000190455f
Cred_24616 vin4.$555.Metal2 VSS.$4241.Metal2 5.09904e-07f
Cred_24617 vin4.$555.Metal2 VSS.$66.Metal1 0.000574185f
Cred_24618 vin4.$555.Metal2 VSS.P0.pSD 0.0534209f
Cred_24619 vin4.$557.Metal2 vout4.$1292.Metal3 0.0622962f
Cred_24620 vin4.$557.Metal2 vout4.P8.pSD 0.0113817f
Cred_24621 vin4.$558.Metal2 vout4.$1292.Metal3 0.0406837f
Cred_24622 vin4.$558.Metal2 vout4.P8.nSD 0.00506498f
Cred_24623 vin4.$558.Metal2 VSS 5.19621e-06f
Cred_24624 vin4.$558.Metal2 VSS.$1078.Metal1 1.75984e-05f
Cred_24625 vin4.$558.Metal2 VSS.$1991.Metal1 8.14161e-06f
Cred_24626 vin4.$558.Metal2 VSS.$2023.Metal1 2.0385e-05f
Cred_24627 vin4.$558.Metal2 VSS.$3217.Metal2 0.00311477f
Cred_24628 vin4.$558.Metal2 VSS.$3276.Metal2 0.00118406f
Cred_24629 vin4.$558.Metal2 VSS.$3308.Metal2 1.90149e-07f
Cred_24630 vin4.$558.Metal2 VSS.$4241.Metal2 5.45765e-08f
Cred_24631 vin4.$558.Metal2 VSS.$4808.Metal3 9.49197e-06f
Cred_24632 vin4.$558.Metal2 VSS.$66.Metal1 4.80372e-05f
Cred_24633 vin4.$558.Metal2 VSS.P0.pSD 0.0050557f
Cred_24634 vin4.$558.Metal2 VSS.P11.nSD 1.61903e-07f
Cred_24635 vin4.$56.GatPoly vout4.$1226.Metal3 0.0315155f
Cred_24636 vin4.$56.GatPoly vout4.$1292.Metal3 0.0256585f
Cred_24637 vin4.$56.GatPoly vout4.P4.pSD 0.000411545f
Cred_24638 vin4.$56.GatPoly vout4.P6.nSD 0.000404226f
Cred_24639 vin4.$56.GatPoly vout4.P6.pSD 0.0362783f
Cred_24640 vin4.$561.Metal2 vout4.$1292.Metal3 0.0233645f
Cred_24641 vin4.$561.Metal2 vout4.$1358.Metal3 0.0048384f
Cred_24642 vin4.$561.Metal2 vout4.P10.nSD 7.62245e-05f
Cred_24643 vin4.$561.Metal2 vout4.P10.pSD 0.000766399f
Cred_24644 vin4.$561.Metal2 vout4.P8.pSD 0.000340744f
Cred_24645 vin4.$562.Metal2 vout4.$1292.Metal3 0.0249549f
Cred_24646 vin4.$562.Metal2 vout4.$1358.Metal3 0.00545257f
Cred_24647 vin4.$562.Metal2 vout4.P10.nSD 0.000153291f
Cred_24648 vin4.$562.Metal2 vout4.P10.pSD 0.000465241f
Cred_24649 vin4.$562.Metal2 vout4.P8.nSD 6.73912e-05f
Cred_24650 vin4.$562.Metal2 VSS 0.00329353f
Cred_24651 vin4.$562.Metal2 VSS.$1078.Metal1 1.94247e-05f
Cred_24652 vin4.$562.Metal2 VSS.$1991.Metal1 1.52039e-05f
Cred_24653 vin4.$562.Metal2 VSS.$2023.Metal1 3.80674e-05f
Cred_24654 vin4.$562.Metal2 VSS.$3217.Metal2 0.00118388f
Cred_24655 vin4.$562.Metal2 VSS.$3276.Metal2 0.020019f
Cred_24656 vin4.$562.Metal2 VSS.$3308.Metal2 0.0188351f
Cred_24657 vin4.$562.Metal2 VSS.$4241.Metal2 1.01918e-07f
Cred_24658 vin4.$562.Metal2 VSS.$4808.Metal3 9.4921e-06f
Cred_24659 vin4.$562.Metal2 VSS.$66.Metal1 6.4582e-05f
Cred_24660 vin4.$562.Metal2 VSS.P0.pSD 0.00799752f
Cred_24661 vin4.$562.Metal2 VSS.P11.nSD 0.000114401f
Cred_24662 vin4.$564.Metal2 vout4.$1292.Metal3 0.0925799f
Cred_24663 vin4.$564.Metal2 vout4.$1358.Metal3 0.0298197f
Cred_24664 vin4.$564.Metal2 vout4.P10.nSD 0.000492617f
Cred_24665 vin4.$564.Metal2 vout4.P10.pSD 0.00266417f
Cred_24666 vin4.$564.Metal2 vout4.P8.nSD 2.2835e-05f
Cred_24667 vin4.$564.Metal2 vout4.P8.pSD 0.000115459f
Cred_24668 vin4.$564.Metal2 VSS 0.000454548f
Cred_24669 vin4.$564.Metal2 VSS.$1991.Metal1 0.00010645f
Cred_24670 vin4.$564.Metal2 VSS.$2023.Metal1 0.000266529f
Cred_24671 vin4.$564.Metal2 VSS.$3276.Metal2 0.0026226f
Cred_24672 vin4.$564.Metal2 VSS.$3308.Metal2 0.0026226f
Cred_24673 vin4.$564.Metal2 VSS.$4241.Metal2 7.13576e-07f
Cred_24674 vin4.$564.Metal2 VSS.$66.Metal1 0.00040524f
Cred_24675 vin4.$564.Metal2 VSS.P0.pSD 0.0530758f
Cred_24676 vin4.$564.Metal2 VSS.P11.nSD 1.5781e-05f
Cred_24677 vin4.$566.Metal2 vout4.$1292.Metal3 0.019148f
Cred_24678 vin4.$566.Metal2 vout4.$1358.Metal3 0.00866777f
Cred_24679 vin4.$566.Metal2 vout4.P10.nSD 0.000136553f
Cred_24680 vin4.$566.Metal2 vout4.P10.pSD 0.00109314f
Cred_24681 vin4.$566.Metal2 vout4.P8.pSD 0.000340744f
Cred_24682 vin4.$567.Metal2 vout4.$1292.Metal3 0.0207382f
Cred_24683 vin4.$567.Metal2 vout4.$1358.Metal3 0.00928194f
Cred_24684 vin4.$567.Metal2 vout4.P10.nSD 0.00021362f
Cred_24685 vin4.$567.Metal2 vout4.P10.pSD 0.000791983f
Cred_24686 vin4.$567.Metal2 vout4.P8.nSD 6.73912e-05f
Cred_24687 vin4.$567.Metal2 VSS 0.0032621f
Cred_24688 vin4.$567.Metal2 VSS.$1174.Metal1 1.15393e-05f
Cred_24689 vin4.$567.Metal2 VSS.$1991.Metal1 1.71105e-05f
Cred_24690 vin4.$567.Metal2 VSS.$2023.Metal1 4.28413e-05f
Cred_24691 vin4.$567.Metal2 VSS.$3276.Metal2 0.0174261f
Cred_24692 vin4.$567.Metal2 VSS.$3308.Metal2 0.0186099f
Cred_24693 vin4.$567.Metal2 VSS.$3356.Metal2 0.00118381f
Cred_24694 vin4.$567.Metal2 VSS.$4241.Metal2 1.14699e-07f
Cred_24695 vin4.$567.Metal2 VSS.$4844.Metal3 9.49156e-06f
Cred_24696 vin4.$567.Metal2 VSS.$66.Metal1 5.81986e-05f
Cred_24697 vin4.$567.Metal2 VSS.P0.pSD 0.00805495f
Cred_24698 vin4.$567.Metal2 VSS.P11.nSD 0.000114191f
Cred_24699 vin4.$570.Metal2 vout4.$1292.Metal3 0.0301756f
Cred_24700 vin4.$570.Metal2 vout4.$1358.Metal3 0.0301756f
Cred_24701 vin4.$570.Metal2 vout4.P10.nSD 0.000475388f
Cred_24702 vin4.$570.Metal2 vout4.P10.pSD 0.0145509f
Cred_24703 vin4.$571.Metal2 vout4.$1292.Metal3 0.0193631f
Cred_24704 vin4.$571.Metal2 vout4.$1358.Metal3 0.0193631f
Cred_24705 vin4.$571.Metal2 vout4.P10.nSD 0.00537002f
Cred_24706 vin4.$571.Metal2 vout4.P10.pSD 0.00165216f
Cred_24707 vin4.$571.Metal2 VSS 2.41257e-07f
Cred_24708 vin4.$571.Metal2 VSS.$1174.Metal1 1.15393e-05f
Cred_24709 vin4.$571.Metal2 VSS.$1991.Metal1 1.2559e-05f
Cred_24710 vin4.$571.Metal2 VSS.$2023.Metal1 3.14451e-05f
Cred_24711 vin4.$571.Metal2 VSS.$3308.Metal2 0.00118381f
Cred_24712 vin4.$571.Metal2 VSS.$3356.Metal2 0.00311471f
Cred_24713 vin4.$571.Metal2 VSS.$4241.Metal2 8.41879e-08f
Cred_24714 vin4.$571.Metal2 VSS.$4844.Metal3 9.49156e-06f
Cred_24715 vin4.$571.Metal2 VSS.$66.Metal1 3.06823e-05f
Cred_24716 vin4.$571.Metal2 VSS.P0.pSD 0.00501956f
Cred_24717 vin4.$573.Metal2 vout4.$1292.Metal3 0.0747905f
Cred_24718 vin4.$573.Metal2 vout4.$1358.Metal3 0.0747905f
Cred_24719 vin4.$573.Metal2 vout4.P10.nSD 0.00232652f
Cred_24720 vin4.$573.Metal2 vout4.P10.pSD 0.0107975f
Cred_24721 vin4.$573.Metal2 VSS.$1991.Metal1 0.000151137f
Cred_24722 vin4.$573.Metal2 VSS.$2023.Metal1 0.000378417f
Cred_24723 vin4.$573.Metal2 VSS.$4241.Metal2 1.01313e-06f
Cred_24724 vin4.$573.Metal2 VSS.$66.Metal1 0.000288988f
Cred_24725 vin4.$573.Metal2 VSS.P0.pSD 0.0534425f
Cred_24726 vin4.$576.Metal2 vout4.$1292.Metal3 0.0384317f
Cred_24727 vin4.$576.Metal2 vout4.$1358.Metal3 0.0384317f
Cred_24728 vin4.$576.Metal2 vout4.P10.nSD 0.0125395f
Cred_24729 vin4.$576.Metal2 vout4.P10.pSD 0.00327919f
Cred_24730 vin4.$576.Metal2 VSS.$1991.Metal1 2.84334e-05f
Cred_24731 vin4.$576.Metal2 VSS.$2023.Metal1 7.11915e-05f
Cred_24732 vin4.$576.Metal2 VSS.$3404.Metal2 0.00169455f
Cred_24733 vin4.$576.Metal2 VSS.$4241.Metal2 1.90601e-07f
Cred_24734 vin4.$576.Metal2 VSS.$66.Metal1 5.45333e-05f
Cred_24735 vin4.$576.Metal2 VSS.P0.pSD 0.0100269f
Cred_24736 vin4.$577.Metal2 vout4.$1292.Metal3 0.0244589f
Cred_24737 vin4.$577.Metal2 vout4.$1358.Metal3 0.0244589f
Cred_24738 vin4.$577.Metal2 vout4.P10.nSD 0.000385328f
Cred_24739 vin4.$577.Metal2 vout4.P10.pSD 0.0106749f
Cred_24740 vin4.$580.Metal2 vout4.$1292.Metal3 0.0125416f
Cred_24741 vin4.$580.Metal2 vout4.$1358.Metal3 0.0190751f
Cred_24742 vin4.$580.Metal2 vout4.P10.nSD 0.00135645f
Cred_24743 vin4.$580.Metal2 vout4.P10.pSD 0.00107011f
Cred_24744 vin4.$580.Metal2 vout4.P12.nSD 3.28661e-05f
Cred_24745 vin4.$580.Metal2 VSS.$1214.Metal1 4.46539e-07f
Cred_24746 vin4.$580.Metal2 VSS.$1254.Metal1 3.56627e-05f
Cred_24747 vin4.$580.Metal2 VSS.$1267.Metal1 0.0021025f
Cred_24748 vin4.$580.Metal2 VSS.$1991.Metal1 2.83434e-05f
Cred_24749 vin4.$580.Metal2 VSS.$2023.Metal1 7.09661e-05f
Cred_24750 vin4.$580.Metal2 VSS.$3404.Metal2 0.0034856f
Cred_24751 vin4.$580.Metal2 VSS.$3463.Metal2 0.020359f
Cred_24752 vin4.$580.Metal2 VSS.$3495.Metal2 0.00559985f
Cred_24753 vin4.$580.Metal2 VSS.$4241.Metal2 1.89997e-07f
Cred_24754 vin4.$580.Metal2 VSS.$4892.Metal3 1.43603e-05f
Cred_24755 vin4.$580.Metal2 VSS.$66.Metal1 3.25733e-05f
Cred_24756 vin4.$580.Metal2 VSS.P0.pSD 0.00773534f
Cred_24757 vin4.$580.Metal2 VSS.P13.nSD 7.31077e-05f
Cred_24758 vin4.$581.Metal2 vout4.$1292.Metal3 0.00993907f
Cred_24759 vin4.$581.Metal2 vout4.$1358.Metal3 0.0250721f
Cred_24760 vin4.$581.Metal2 vout4.P10.nSD 0.000156581f
Cred_24761 vin4.$581.Metal2 vout4.P10.pSD 0.00131644f
Cred_24762 vin4.$581.Metal2 vout4.P12.pSD 0.000468386f
Cred_24763 vin4.$584.Metal2 vout4.$1292.Metal3 0.0295083f
Cred_24764 vin4.$584.Metal2 vout4.$1358.Metal3 0.0918296f
Cred_24765 vin4.$584.Metal2 vout4.P10.nSD 0.000485851f
Cred_24766 vin4.$584.Metal2 vout4.P10.pSD 0.00254831f
Cred_24767 vin4.$584.Metal2 vout4.P12.nSD 2.09757e-05f
Cred_24768 vin4.$584.Metal2 vout4.P12.pSD 3.05134e-05f
Cred_24769 vin4.$584.Metal2 VSS.$1267.Metal1 0.00114188f
Cred_24770 vin4.$584.Metal2 VSS.$1991.Metal1 0.000214159f
Cred_24771 vin4.$584.Metal2 VSS.$2023.Metal1 0.000536211f
Cred_24772 vin4.$584.Metal2 VSS.$3463.Metal2 0.0101017f
Cred_24773 vin4.$584.Metal2 VSS.$3495.Metal2 0.00304655f
Cred_24774 vin4.$584.Metal2 VSS.$4241.Metal2 1.43559e-06f
Cred_24775 vin4.$584.Metal2 VSS.$66.Metal1 0.000204402f
Cred_24776 vin4.$584.Metal2 VSS.P0.pSD 0.053387f
Cred_24777 vin4.$584.Metal2 VSS.P13.nSD 3.96969e-05f
Cred_24778 vin4.$586.Metal2 vout4.$1292.Metal3 0.00150227f
Cred_24779 vin4.$586.Metal2 vout4.$1358.Metal3 0.0150382f
Cred_24780 vin4.$586.Metal2 vout4.P10.nSD 2.36668e-05f
Cred_24781 vin4.$586.Metal2 vout4.P10.pSD 0.000186786f
Cred_24782 vin4.$586.Metal2 vout4.P12.pSD 0.00018411f
Cred_24783 vin4.$587.Metal2 vout4.$1292.Metal3 0.00466478f
Cred_24784 vin4.$587.Metal2 vout4.$1358.Metal3 0.0239312f
Cred_24785 vin4.$587.Metal2 vout4.P10.nSD 0.000113776f
Cred_24786 vin4.$587.Metal2 vout4.P10.pSD 0.000398023f
Cred_24787 vin4.$587.Metal2 vout4.P12.nSD 4.94234e-05f
Cred_24788 vin4.$587.Metal2 VSS.$1267.Metal1 0.0036981f
Cred_24789 vin4.$587.Metal2 VSS.$1373.Metal1 4.15136e-06f
Cred_24790 vin4.$587.Metal2 VSS.$1991.Metal1 3.23766e-05f
Cred_24791 vin4.$587.Metal2 VSS.$2023.Metal1 8.10644e-05f
Cred_24792 vin4.$587.Metal2 VSS.$3463.Metal2 0.0320645f
Cred_24793 vin4.$587.Metal2 VSS.$3495.Metal2 0.0111327f
Cred_24794 vin4.$587.Metal2 VSS.$3519.Metal2 0.00239151f
Cred_24795 vin4.$587.Metal2 VSS.$4241.Metal2 2.17033e-07f
Cred_24796 vin4.$587.Metal2 VSS.$66.Metal1 2.7724e-05f
Cred_24797 vin4.$587.Metal2 VSS.P0.pSD 0.00758325f
Cred_24798 vin4.$587.Metal2 VSS.P13.nSD 0.000128589f
Cred_24799 vin4.$59.GatPoly vout4.$1226.Metal3 0.0029015f
Cred_24800 vin4.$59.GatPoly vout4.$1292.Metal3 0.00203672f
Cred_24801 vin4.$59.GatPoly vout4.P4.nSD 8.10886e-06f
Cred_24802 vin4.$59.GatPoly vout4.P6.nSD 0.00214376f
Cred_24803 vin4.$59.GatPoly vout4.P6.pSD 0.000175361f
Cred_24804 vin4.$59.GatPoly VSS.$1991.Metal1 1.91713e-06f
Cred_24805 vin4.$59.GatPoly VSS.$2023.Metal1 4.8001e-06f
Cred_24806 vin4.$59.GatPoly VSS.$2926.Metal2 0.000904124f
Cred_24807 vin4.$59.GatPoly VSS.$2958.Metal2 3.45181e-05f
Cred_24808 vin4.$59.GatPoly VSS.$3006.Metal2 4.84579e-08f
Cred_24809 vin4.$59.GatPoly VSS.$4241.Metal2 1.28513e-08f
Cred_24810 vin4.$59.GatPoly VSS.$4688.Metal3 3.73213e-10f
Cred_24811 vin4.$59.GatPoly VSS.$66.Metal1 8.60755e-05f
Cred_24812 vin4.$59.GatPoly VSS.$771.Metal1 0.000751257f
Cred_24813 vin4.$59.GatPoly VSS.$785.Metal1 0.00513046f
Cred_24814 vin4.$59.GatPoly VSS.$831.Metal1 2.16492e-05f
Cred_24815 vin4.$59.GatPoly VSS.$879.Metal1 2.28603e-07f
Cred_24816 vin4.$59.GatPoly VSS.P0.pSD 0.00325944f
Cred_24817 vin4.$59.GatPoly VSS.P7.nSD 4.46155e-05f
Cred_24818 vin4.$590.Metal2 vout4.$1358.Metal3 0.0519778f
Cred_24819 vin4.$590.Metal2 vout4.P12.pSD 0.00988711f
Cred_24820 vin4.$591.Metal2 vout4.$1358.Metal3 0.0577679f
Cred_24821 vin4.$591.Metal2 vout4.P12.nSD 0.00778234f
Cred_24822 vin4.$591.Metal2 VSS.$1267.Metal1 7.44747e-06f
Cred_24823 vin4.$591.Metal2 VSS.$1373.Metal1 7.70326e-07f
Cred_24824 vin4.$591.Metal2 VSS.$1991.Metal1 3.32575e-05f
Cred_24825 vin4.$591.Metal2 VSS.$2023.Metal1 8.327e-05f
Cred_24826 vin4.$591.Metal2 VSS.$3463.Metal2 4.48317e-07f
Cred_24827 vin4.$591.Metal2 VSS.$3495.Metal2 1.41269e-07f
Cred_24828 vin4.$591.Metal2 VSS.$3519.Metal2 0.00239142f
Cred_24829 vin4.$591.Metal2 VSS.$4241.Metal2 2.22938e-07f
Cred_24830 vin4.$591.Metal2 VSS.$66.Metal1 1.76476e-05f
Cred_24831 vin4.$591.Metal2 VSS.P0.pSD 0.00613591f
Cred_24832 vin4.$591.Metal2 VSS.P13.nSD 2.46691e-07f
Cred_24833 vin4.$593.Metal2 vout4.$1358.Metal3 0.176873f
Cred_24834 vin4.$593.Metal2 vout4.$1424.Metal3 0.00901986f
Cred_24835 vin4.$593.Metal2 vout4.P12.nSD 0.00129017f
Cred_24836 vin4.$593.Metal2 vout4.P12.pSD 0.00144016f
Cred_24837 vin4.$593.Metal2 vout4.P14.nSD 0.000142398f
Cred_24838 vin4.$593.Metal2 vout4.P14.pSD 0.00076962f
Cred_24839 vin4.$593.Metal2 VSS.$1483.Metal1 0.000143935f
Cred_24840 vin4.$593.Metal2 VSS.$1991.Metal1 0.000445942f
Cred_24841 vin4.$593.Metal2 VSS.$2023.Metal1 0.00111655f
Cred_24842 vin4.$593.Metal2 VSS.$3615.Metal2 5.65961e-05f
Cred_24843 vin4.$593.Metal2 VSS.$3650.Metal2 0.00149036f
Cred_24844 vin4.$593.Metal2 VSS.$4241.Metal2 2.98933e-06f
Cred_24845 vin4.$593.Metal2 VSS.$66.Metal1 0.000179342f
Cred_24846 vin4.$593.Metal2 VSS.P0.pSD 0.0710209f
Cred_24847 vin4.$593.Metal2 VSS.P15.nSD 8.41734e-07f
Cred_24848 vin4.$595.Metal2 vout4.$1358.Metal3 0.0705949f
Cred_24849 vin4.$595.Metal2 vout4.P12.pSD 0.0131059f
Cred_24850 vin4.$596.Metal2 vout4.$1358.Metal3 0.071683f
Cred_24851 vin4.$596.Metal2 vout4.P12.nSD 0.0105281f
Cred_24852 vin4.$596.Metal2 VSS.$1373.Metal1 3.09872e-07f
Cred_24853 vin4.$596.Metal2 VSS.$1421.Metal1 1.35199e-05f
Cred_24854 vin4.$596.Metal2 VSS.$1483.Metal1 1.72537e-06f
Cred_24855 vin4.$596.Metal2 VSS.$1484.Metal1 7.82459e-07f
Cred_24856 vin4.$596.Metal2 VSS.$1991.Metal1 4.60297e-05f
Cred_24857 vin4.$596.Metal2 VSS.$2023.Metal1 0.000115249f
Cred_24858 vin4.$596.Metal2 VSS.$3567.Metal2 0.00113252f
Cred_24859 vin4.$596.Metal2 VSS.$3615.Metal2 0.00113253f
Cred_24860 vin4.$596.Metal2 VSS.$3650.Metal2 3.72161e-08f
Cred_24861 vin4.$596.Metal2 VSS.$4241.Metal2 3.08555e-07f
Cred_24862 vin4.$596.Metal2 VSS.$4964.Metal3 9.08029e-06f
Cred_24863 vin4.$596.Metal2 VSS.$66.Metal1 1.93217e-05f
Cred_24864 vin4.$596.Metal2 VSS.P0.pSD 0.00755086f
Cred_24865 vin4.$596.Metal2 VSS.P15.nSD 1.44361e-08f
Cred_24866 vin4.$600.Metal2 vout4.$1358.Metal3 0.0140062f
Cred_24867 vin4.$600.Metal2 vout4.$1424.Metal3 0.000402309f
Cred_24868 vin4.$600.Metal2 vout4.P12.nSD 2.51091e-05f
Cred_24869 vin4.$600.Metal2 vout4.P14.nSD 7.69108e-06f
Cred_24870 vin4.$600.Metal2 vout4.P14.pSD 3.4327e-05f
Cred_24871 vin4.$600.Metal2 VSS.$1373.Metal1 4.71576e-07f
Cred_24872 vin4.$600.Metal2 VSS.$1421.Metal1 1.90177e-05f
Cred_24873 vin4.$600.Metal2 VSS.$1483.Metal1 0.0015806f
Cred_24874 vin4.$600.Metal2 VSS.$1484.Metal1 2.61458e-06f
Cred_24875 vin4.$600.Metal2 VSS.$1991.Metal1 3.19718e-05f
Cred_24876 vin4.$600.Metal2 VSS.$2023.Metal1 8.0051e-05f
Cred_24877 vin4.$600.Metal2 VSS.$3567.Metal2 0.00113256f
Cred_24878 vin4.$600.Metal2 VSS.$3615.Metal2 0.00415717f
Cred_24879 vin4.$600.Metal2 VSS.$3650.Metal2 0.016193f
Cred_24880 vin4.$600.Metal2 VSS.$4241.Metal2 2.1432e-07f
Cred_24881 vin4.$600.Metal2 VSS.$4964.Metal3 9.08056e-06f
Cred_24882 vin4.$600.Metal2 VSS.$66.Metal1 1.0061e-05f
Cred_24883 vin4.$600.Metal2 VSS.P0.pSD 0.00455155f
Cred_24884 vin4.$600.Metal2 VSS.P15.nSD 9.28578e-06f
Cred_24885 vin4.$601.Metal2 vout4.$1358.Metal3 0.0531514f
Cred_24886 vin4.$601.Metal2 vout4.$1424.Metal3 0.0153467f
Cred_24887 vin4.$601.Metal2 vout4.P12.nSD 1.43057e-07f
Cred_24888 vin4.$601.Metal2 vout4.P12.pSD 0.000804195f
Cred_24889 vin4.$601.Metal2 vout4.P14.nSD 0.000241915f
Cred_24890 vin4.$601.Metal2 vout4.P14.pSD 0.00185992f
Cred_24891 vin4.$601.Metal2 VSS.$1483.Metal1 6.89462e-05f
Cred_24892 vin4.$601.Metal2 VSS.$1991.Metal1 6.66486e-05f
Cred_24893 vin4.$601.Metal2 VSS.$2023.Metal1 0.000166875f
Cred_24894 vin4.$601.Metal2 VSS.$3615.Metal2 2.711e-05f
Cred_24895 vin4.$601.Metal2 VSS.$3650.Metal2 0.000713896f
Cred_24896 vin4.$601.Metal2 VSS.$4241.Metal2 4.46772e-07f
Cred_24897 vin4.$601.Metal2 VSS.$66.Metal1 1.5886e-05f
Cred_24898 vin4.$601.Metal2 VSS.P0.pSD 0.00821773f
Cred_24899 vin4.$601.Metal2 VSS.P15.nSD 4.03198e-07f
Cred_24900 vin4.$605.Metal2 vout4.$1358.Metal3 0.0461637f
Cred_24901 vin4.$605.Metal2 vout4.$1424.Metal3 0.0178808f
Cred_24902 vin4.$605.Metal2 vout4.P12.nSD 9.26598e-05f
Cred_24903 vin4.$605.Metal2 vout4.P14.nSD 0.000472451f
Cred_24904 vin4.$605.Metal2 vout4.P14.pSD 0.00152568f
Cred_24905 vin4.$605.Metal2 VSS.$1483.Metal1 0.00513633f
Cred_24906 vin4.$605.Metal2 VSS.$1512.Metal1 8.08006e-06f
Cred_24907 vin4.$605.Metal2 VSS.$1580.Metal1 3.63346e-07f
Cred_24908 vin4.$605.Metal2 VSS.$1991.Metal1 0.000178593f
Cred_24909 vin4.$605.Metal2 VSS.$2023.Metal1 0.00044716f
Cred_24910 vin4.$605.Metal2 VSS.$3615.Metal2 0.0019177f
Cred_24911 vin4.$605.Metal2 VSS.$3650.Metal2 0.0514072f
Cred_24912 vin4.$605.Metal2 VSS.$3706.Metal2 0.00236814f
Cred_24913 vin4.$605.Metal2 VSS.$3730.Metal2 3.03569e-09f
Cred_24914 vin4.$605.Metal2 VSS.$4241.Metal2 1.19718e-06f
Cred_24915 vin4.$605.Metal2 VSS.$5000.Metal3 7.27792e-06f
Cred_24916 vin4.$605.Metal2 VSS.$66.Metal1 4.02046e-05f
Cred_24917 vin4.$605.Metal2 VSS.P0.pSD 0.0213321f
Cred_24918 vin4.$605.Metal2 VSS.P15.nSD 3.10561e-05f
Cred_24919 vin4.$608.Metal2 vout4.$1358.Metal3 0.00918213f
Cred_24920 vin4.$608.Metal2 vout4.$1424.Metal3 0.00907964f
Cred_24921 vin4.$608.Metal2 vout4.P12.pSD 6.65553e-06f
Cred_24922 vin4.$608.Metal2 vout4.P14.nSD 0.000143041f
Cred_24923 vin4.$608.Metal2 vout4.P14.pSD 0.00173063f
Cred_24924 vin4.$610.Metal2 vout4.$1358.Metal3 0.0291332f
Cred_24925 vin4.$610.Metal2 vout4.$1424.Metal3 0.0291332f
Cred_24926 vin4.$610.Metal2 vout4.P14.nSD 0.000458966f
Cred_24927 vin4.$610.Metal2 vout4.P14.pSD 0.0159242f
Cred_24928 vin4.$611.Metal2 vout4.$1358.Metal3 0.036807f
Cred_24929 vin4.$611.Metal2 vout4.$1424.Metal3 0.036807f
Cred_24930 vin4.$611.Metal2 vout4.P14.nSD 0.0118473f
Cred_24931 vin4.$611.Metal2 vout4.P14.pSD 0.00314056f
Cred_24932 vin4.$611.Metal2 VSS.$1483.Metal1 0.000409021f
Cred_24933 vin4.$611.Metal2 VSS.$1512.Metal1 5.22427e-06f
Cred_24934 vin4.$611.Metal2 VSS.$1580.Metal1 7.33628e-07f
Cred_24935 vin4.$611.Metal2 VSS.$1991.Metal1 0.000108604f
Cred_24936 vin4.$611.Metal2 VSS.$2023.Metal1 0.000271923f
Cred_24937 vin4.$611.Metal2 VSS.$3615.Metal2 0.000160829f
Cred_24938 vin4.$611.Metal2 VSS.$3650.Metal2 0.00468475f
Cred_24939 vin4.$611.Metal2 VSS.$3706.Metal2 0.00339829f
Cred_24940 vin4.$611.Metal2 VSS.$3730.Metal2 6.12933e-09f
Cred_24941 vin4.$611.Metal2 VSS.$4241.Metal2 7.28019e-07f
Cred_24942 vin4.$611.Metal2 VSS.$5000.Metal3 3.60466e-06f
Cred_24943 vin4.$611.Metal2 VSS.$66.Metal1 1.40668e-05f
Cred_24944 vin4.$611.Metal2 VSS.P0.pSD 0.00973895f
Cred_24945 vin4.$611.Metal2 VSS.P15.nSD 2.39196e-06f
Cred_24946 vin4.$613.Metal2 vout4.$1358.Metal3 0.0982929f
Cred_24947 vin4.$613.Metal2 vout4.$1424.Metal3 0.0792964f
Cred_24948 vin4.$613.Metal2 vout4.P12.nSD 2.98653e-07f
Cred_24949 vin4.$613.Metal2 vout4.P14.nSD 0.00247466f
Cred_24950 vin4.$613.Metal2 vout4.P14.pSD 0.00812867f
Cred_24951 vin4.$613.Metal2 VSS.$1483.Metal1 0.000143935f
Cred_24952 vin4.$613.Metal2 VSS.$1991.Metal1 0.00076223f
Cred_24953 vin4.$613.Metal2 VSS.$2023.Metal1 0.00190847f
Cred_24954 vin4.$613.Metal2 VSS.$3615.Metal2 5.65961e-05f
Cred_24955 vin4.$613.Metal2 VSS.$3650.Metal2 0.00149036f
Cred_24956 vin4.$613.Metal2 VSS.$4241.Metal2 5.10954e-06f
Cred_24957 vin4.$613.Metal2 VSS.$66.Metal1 0.000106849f
Cred_24958 vin4.$613.Metal2 VSS.P0.pSD 0.0706868f
Cred_24959 vin4.$613.Metal2 VSS.P15.nSD 8.41734e-07f
Cred_24960 vin4.$615.Metal2 vout4.$1358.Metal3 0.0231172f
Cred_24961 vin4.$615.Metal2 vout4.$1424.Metal3 0.0231172f
Cred_24962 vin4.$615.Metal2 vout4.P14.nSD 0.00036419f
Cred_24963 vin4.$615.Metal2 vout4.P14.pSD 0.010938f
Cred_24964 vin4.$616.Metal2 vout4.$1358.Metal3 0.0276522f
Cred_24965 vin4.$616.Metal2 vout4.$1424.Metal3 0.0276522f
Cred_24966 vin4.$616.Metal2 vout4.P14.nSD 0.00752249f
Cred_24967 vin4.$616.Metal2 vout4.P14.pSD 0.00235943f
Cred_24968 vin4.$616.Metal2 VSS.$1580.Metal1 4.44744e-06f
Cred_24969 vin4.$616.Metal2 VSS.$1991.Metal1 6.58285e-05f
Cred_24970 vin4.$616.Metal2 VSS.$2023.Metal1 0.000164821f
Cred_24971 vin4.$616.Metal2 VSS.$3730.Metal2 0.000554698f
Cred_24972 vin4.$616.Metal2 VSS.$3778.Metal2 0.00305041f
Cred_24973 vin4.$616.Metal2 VSS.$4241.Metal2 4.41275e-07f
Cred_24974 vin4.$616.Metal2 VSS.$5036.Metal3 4.44744e-06f
Cred_24975 vin4.$616.Metal2 VSS.$66.Metal1 6.45297e-06f
Cred_24976 vin4.$616.Metal2 VSS.P0.pSD 0.00511499f
Cred_24977 vin4.$619.Metal2 vout4.$1358.Metal3 0.00660463f
Cred_24978 vin4.$619.Metal2 vout4.$1424.Metal3 0.0109848f
Cred_24979 vin4.$619.Metal2 vout4.P14.nSD 0.00010405f
Cred_24980 vin4.$619.Metal2 vout4.P14.pSD 0.000659154f
Cred_24981 vin4.$619.Metal2 vout4.P16.pSD 9.56129e-05f
Cred_24982 vin4.$620.Metal2 vout4.$1358.Metal3 0.00640448f
Cred_24983 vin4.$620.Metal2 vout4.$1424.Metal3 0.010863f
Cred_24984 vin4.$620.Metal2 vout4.P14.nSD 0.000118081f
Cred_24985 vin4.$620.Metal2 vout4.P14.pSD 0.000546463f
Cred_24986 vin4.$620.Metal2 vout4.P16.nSD 1.71843e-05f
Cred_24987 vin4.$620.Metal2 VSS.$1625.Metal1 0.00250348f
Cred_24988 vin4.$620.Metal2 VSS.$1991.Metal1 9.60107e-05f
Cred_24989 vin4.$620.Metal2 VSS.$2023.Metal1 0.000240391f
Cred_24990 vin4.$620.Metal2 VSS.$3778.Metal2 0.00249571f
Cred_24991 vin4.$620.Metal2 VSS.$3802.Metal2 0.00942665f
Cred_24992 vin4.$620.Metal2 VSS.$3837.Metal2 0.0187469f
Cred_24993 vin4.$620.Metal2 VSS.$4241.Metal2 6.43598e-07f
Cred_24994 vin4.$620.Metal2 VSS.$66.Metal1 6.51571e-06f
Cred_24995 vin4.$620.Metal2 VSS.P0.pSD 0.00615517f
Cred_24996 vin4.$620.Metal2 VSS.P17.nSD 8.75729e-05f
Cred_24997 vin4.$622.Metal2 vout4.$1358.Metal3 0.028528f
Cred_24998 vin4.$622.Metal2 vout4.$1424.Metal3 0.0879111f
Cred_24999 vin4.$622.Metal2 vout4.P14.nSD 0.000457527f
Cred_25000 vin4.$622.Metal2 vout4.P14.pSD 0.0024792f
Cred_25001 vin4.$622.Metal2 vout4.P16.nSD 8.09507e-06f
Cred_25002 vin4.$622.Metal2 vout4.P16.pSD 4.50408e-05f
Cred_25003 vin4.$622.Metal2 VSS.$1625.Metal1 0.000410524f
Cred_25004 vin4.$622.Metal2 VSS.$1991.Metal1 0.00083255f
Cred_25005 vin4.$622.Metal2 VSS.$2023.Metal1 0.00208454f
Cred_25006 vin4.$622.Metal2 VSS.$3802.Metal2 0.00145036f
Cred_25007 vin4.$622.Metal2 VSS.$3837.Metal2 0.00330681f
Cred_25008 vin4.$622.Metal2 VSS.$4241.Metal2 5.58092e-06f
Cred_25009 vin4.$622.Metal2 VSS.$66.Metal1 4.93978e-05f
Cred_25010 vin4.$622.Metal2 VSS.P0.pSD 0.0498584f
Cred_25011 vin4.$622.Metal2 VSS.P17.nSD 1.42532e-05f
Cred_25012 vin4.$624.Metal2 vout4.$1358.Metal3 0.00634131f
Cred_25013 vin4.$624.Metal2 vout4.$1424.Metal3 0.0261527f
Cred_25014 vin4.$624.Metal2 vout4.P14.nSD 9.99013e-05f
Cred_25015 vin4.$624.Metal2 vout4.P14.pSD 0.000957923f
Cred_25016 vin4.$624.Metal2 vout4.P16.pSD 0.000416851f
Cred_25017 vin4.$625.Metal2 vout4.$1358.Metal3 0.00650663f
Cred_25018 vin4.$625.Metal2 vout4.$1424.Metal3 0.036376f
Cred_25019 vin4.$625.Metal2 vout4.P14.nSD 0.00017198f
Cred_25020 vin4.$625.Metal2 vout4.P14.pSD 0.000555179f
Cred_25021 vin4.$625.Metal2 vout4.P16.nSD 0.00104885f
Cred_25022 vin4.$625.Metal2 VSS.$1625.Metal1 0.00393458f
Cred_25023 vin4.$625.Metal2 VSS.$1699.Metal1 1.23569e-05f
Cred_25024 vin4.$625.Metal2 VSS.$1991.Metal1 0.000164246f
Cred_25025 vin4.$625.Metal2 VSS.$2023.Metal1 0.00041124f
Cred_25026 vin4.$625.Metal2 VSS.$3802.Metal2 0.0137476f
Cred_25027 vin4.$625.Metal2 VSS.$3837.Metal2 0.0328856f
Cred_25028 vin4.$625.Metal2 VSS.$3893.Metal2 0.00256115f
Cred_25029 vin4.$625.Metal2 VSS.$4241.Metal2 1.10101e-06f
Cred_25030 vin4.$625.Metal2 VSS.$5084.Metal3 1.23569e-05f
Cred_25031 vin4.$625.Metal2 VSS.$66.Metal1 8.43231e-06f
Cred_25032 vin4.$625.Metal2 VSS.P0.pSD 0.00908388f
Cred_25033 vin4.$625.Metal2 VSS.P17.nSD 0.000136794f
Cred_25034 vin4.$628.Metal2 vout4.$1424.Metal3 0.0538987f
Cred_25035 vin4.$628.Metal2 vout4.P16.pSD 0.00930781f
Cred_25036 vin4.$631.Metal2 vout4.$1424.Metal3 0.0918079f
Cred_25037 vin4.$631.Metal2 vout4.P16.nSD 0.0129837f
Cred_25038 vin4.$631.Metal2 VSS.$1625.Metal1 5.49654e-05f
Cred_25039 vin4.$631.Metal2 VSS.$1699.Metal1 6.12031e-06f
Cred_25040 vin4.$631.Metal2 VSS.$1991.Metal1 0.000273718f
Cred_25041 vin4.$631.Metal2 VSS.$2023.Metal1 0.000685335f
Cred_25042 vin4.$631.Metal2 VSS.$3802.Metal2 0.00019419f
Cred_25043 vin4.$631.Metal2 VSS.$3837.Metal2 0.00120609f
Cred_25044 vin4.$631.Metal2 VSS.$3893.Metal2 0.00282265f
Cred_25045 vin4.$631.Metal2 VSS.$4241.Metal2 1.83484e-06f
Cred_25046 vin4.$631.Metal2 VSS.$5084.Metal3 6.12031e-06f
Cred_25047 vin4.$631.Metal2 VSS.$66.Metal1 8.45128e-06f
Cred_25048 vin4.$631.Metal2 VSS.P0.pSD 0.011518f
Cred_25049 vin4.$631.Metal2 VSS.P17.nSD 1.90837e-06f
Cred_25050 vin4.$633.Metal2 vout4.$1424.Metal3 0.156738f
Cred_25051 vin4.$633.Metal2 vout4.P16.nSD 0.00114517f
Cred_25052 vin4.$633.Metal2 vout4.P16.pSD 0.0046241f
Cred_25053 vin4.$633.Metal2 VSS.$1991.Metal1 0.00118048f
Cred_25054 vin4.$633.Metal2 VSS.$2023.Metal1 0.00295568f
Cred_25055 vin4.$633.Metal2 VSS.$4241.Metal2 7.91323e-06f
Cred_25056 vin4.$633.Metal2 VSS.$66.Metal1 3.49876e-05f
Cred_25057 vin4.$633.Metal2 VSS.P0.pSD 0.0488368f
Cred_25058 vin4.$635.Metal2 vout4.$1424.Metal3 0.0588585f
Cred_25059 vin4.$635.Metal2 vout4.P16.pSD 0.010786f
Cred_25060 vin4.$636.Metal2 vout4.$1424.Metal3 0.0361747f
Cred_25061 vin4.$636.Metal2 vout4.P16.nSD 0.00424937f
Cred_25062 vin4.$636.Metal2 VSS.$1739.Metal1 5.98294e-07f
Cred_25063 vin4.$636.Metal2 VSS.$1787.Metal1 1.24159e-05f
Cred_25064 vin4.$636.Metal2 VSS.$1800.Metal1 1.75061e-05f
Cred_25065 vin4.$636.Metal2 VSS.$1991.Metal1 0.0001195f
Cred_25066 vin4.$636.Metal2 VSS.$2023.Metal1 0.000299203f
Cred_25067 vin4.$636.Metal2 VSS.$3941.Metal2 0.00353881f
Cred_25068 vin4.$636.Metal2 VSS.$4000.Metal2 0.00119052f
Cred_25069 vin4.$636.Metal2 VSS.$4032.Metal2 6.70053e-07f
Cred_25070 vin4.$636.Metal2 VSS.$4241.Metal2 8.01054e-07f
Cred_25071 vin4.$636.Metal2 VSS.$5132.Metal3 9.53807e-06f
Cred_25072 vin4.$636.Metal2 VSS.$66.Metal1 2.70698e-06f
Cred_25073 vin4.$636.Metal2 VSS.P0.pSD 0.00428521f
Cred_25074 vin4.$636.Metal2 VSS.P19.nSD 6.69298e-07f
Cred_25075 vin4.$639.Metal2 vout4 0.00144545f
Cred_25076 vin4.$639.Metal2 vout4.$1424.Metal3 0.0258238f
Cred_25077 vin4.$639.Metal2 vout4.P16.pSD 0.000359875f
Cred_25078 vin4.$639.Metal2 vout4.P18.nSD 0.000114848f
Cred_25079 vin4.$639.Metal2 vout4.P18.pSD 0.000882401f
Cred_25080 vin4.$64.GatPoly vout4.$1226.Metal3 0.012872f
Cred_25081 vin4.$64.GatPoly vout4.$1292.Metal3 0.0146682f
Cred_25082 vin4.$64.GatPoly vout4.P6.nSD 0.000202787f
Cred_25083 vin4.$64.GatPoly vout4.P6.pSD 0.0198092f
Cred_25084 vin4.$64.GatPoly vout4.P8.pSD 0.000126207f
Cred_25085 vin4.$640.Metal2 vout4 0.00147839f
Cred_25086 vin4.$640.Metal2 vout4.$1424.Metal3 0.0276307f
Cred_25087 vin4.$640.Metal2 vout4.P16.nSD 7.2224e-05f
Cred_25088 vin4.$640.Metal2 vout4.P18.nSD 0.00016196f
Cred_25089 vin4.$640.Metal2 vout4.P18.pSD 0.000636201f
Cred_25090 vin4.$640.Metal2 VSS.$1739.Metal1 2.20468e-07f
Cred_25091 vin4.$640.Metal2 VSS.$1787.Metal1 1.33539e-05f
Cred_25092 vin4.$640.Metal2 VSS.$1800.Metal1 0.00370329f
Cred_25093 vin4.$640.Metal2 VSS.$1991.Metal1 0.00026127f
Cred_25094 vin4.$640.Metal2 VSS.$2023.Metal1 0.000654168f
Cred_25095 vin4.$640.Metal2 VSS.$3941.Metal2 0.00118965f
Cred_25096 vin4.$640.Metal2 VSS.$4000.Metal2 0.0246652f
Cred_25097 vin4.$640.Metal2 VSS.$4032.Metal2 0.0174818f
Cred_25098 vin4.$640.Metal2 VSS.$4241.Metal2 1.7514e-06f
Cred_25099 vin4.$640.Metal2 VSS.$5132.Metal3 9.53831e-06f
Cred_25100 vin4.$640.Metal2 VSS.$66.Metal1 4.15964e-06f
Cred_25101 vin4.$640.Metal2 VSS.P0.pSD 0.00767477f
Cred_25102 vin4.$640.Metal2 VSS.P19.nSD 0.000129173f
Cred_25103 vin4.$642.Metal2 vout4 0.0213651f
Cred_25104 vin4.$642.Metal2 vout4.$1424.Metal3 0.169814f
Cred_25105 vin4.$642.Metal2 vout4.P16.nSD 2.08912e-05f
Cred_25106 vin4.$642.Metal2 vout4.P16.pSD 0.000104096f
Cred_25107 vin4.$642.Metal2 vout4.P18.nSD 0.0020946f
Cred_25108 vin4.$642.Metal2 vout4.P18.pSD 0.00968733f
Cred_25109 vin4.$642.Metal2 VSS.$1800.Metal1 0.000448976f
Cred_25110 vin4.$642.Metal2 VSS.$1991.Metal1 0.00298596f
Cred_25111 vin4.$642.Metal2 VSS.$2023.Metal1 0.00747623f
Cred_25112 vin4.$642.Metal2 VSS.$4000.Metal2 0.0029713f
Cred_25113 vin4.$642.Metal2 VSS.$4032.Metal2 0.00221267f
Cred_25114 vin4.$642.Metal2 VSS.$4241.Metal2 2.00161e-05f
Cred_25115 vin4.$642.Metal2 VSS.$66.Metal1 3.29861e-05f
Cred_25116 vin4.$642.Metal2 VSS.P0.pSD 0.0694135f
Cred_25117 vin4.$642.Metal2 VSS.P19.nSD 1.55876e-05f
Cred_25118 vin4.$644.Metal2 vout4 0.00236295f
Cred_25119 vin4.$644.Metal2 vout4.$1424.Metal3 0.0200647f
Cred_25120 vin4.$644.Metal2 vout4.P16.pSD 0.000267992f
Cred_25121 vin4.$644.Metal2 vout4.P18.nSD 0.000187749f
Cred_25122 vin4.$644.Metal2 vout4.P18.pSD 0.00121076f
Cred_25123 vin4.$645.Metal2 vout4 0.0023875f
Cred_25124 vin4.$645.Metal2 vout4.$1424.Metal3 0.0214104f
Cred_25125 vin4.$645.Metal2 vout4.P16.nSD 5.37838e-05f
Cred_25126 vin4.$645.Metal2 vout4.P18.nSD 0.000222834f
Cred_25127 vin4.$645.Metal2 vout4.P18.pSD 0.00102742f
Cred_25128 vin4.$645.Metal2 VSS.$1800.Metal1 0.00303883f
Cred_25129 vin4.$645.Metal2 VSS.$1878.Metal1 1.43018e-05f
Cred_25130 vin4.$645.Metal2 VSS.$1991.Metal1 0.000205734f
Cred_25131 vin4.$645.Metal2 VSS.$2023.Metal1 0.000515117f
Cred_25132 vin4.$645.Metal2 VSS.$4000.Metal2 0.0191202f
Cred_25133 vin4.$645.Metal2 VSS.$4032.Metal2 0.0154724f
Cred_25134 vin4.$645.Metal2 VSS.$4080.Metal2 0.00123396f
Cred_25135 vin4.$645.Metal2 VSS.$4241.Metal2 1.37912e-06f
Cred_25136 vin4.$645.Metal2 VSS.$5168.Metal3 9.89362e-06f
Cred_25137 vin4.$645.Metal2 VSS.$66.Metal1 2.60432e-06f
Cred_25138 vin4.$645.Metal2 VSS.P0.pSD 0.00531248f
Cred_25139 vin4.$645.Metal2 VSS.P19.nSD 0.000105958f
Cred_25140 vin4.$648.Metal2 vout4 0.00759119f
Cred_25141 vin4.$648.Metal2 vout4.$1424.Metal3 0.038286f
Cred_25142 vin4.$648.Metal2 vout4.P18.nSD 0.000628701f
Cred_25143 vin4.$648.Metal2 vout4.P18.pSD 0.0119231f
Cred_25144 vin4.$648.Metal2 VSS.$1991.Metal1 8.60643e-05f
Cred_25145 vin4.$648.Metal2 VSS.$2023.Metal1 0.000215488f
Cred_25146 vin4.$648.Metal2 VSS.$4152.Metal2 2.05108e-05f
Cred_25147 vin4.$648.Metal2 VSS.$4241.Metal2 5.76924e-07f
Cred_25148 vin4.$648.Metal2 VSS.$66.Metal1 5.44775e-07f
Cred_25149 vin4.$648.Metal2 VSS.P0.pSD 0.00145121f
Cred_25150 vin4.$649.Metal2 vout4 0.00787937f
Cred_25151 vin4.$649.Metal2 vout4.$1424.Metal3 0.0397395f
Cred_25152 vin4.$649.Metal2 vout4.P18.nSD 0.00696437f
Cred_25153 vin4.$649.Metal2 vout4.P18.pSD 0.0034141f
Cred_25154 vin4.$649.Metal2 VSS.$1800.Metal1 8.49027e-06f
Cred_25155 vin4.$649.Metal2 VSS.$1878.Metal1 1.02915e-05f
Cred_25156 vin4.$649.Metal2 VSS.$1926.Metal1 1.29791e-05f
Cred_25157 vin4.$649.Metal2 VSS.$1986.Metal1 1.34041e-05f
Cred_25158 vin4.$649.Metal2 VSS.$1991.Metal1 0.000382075f
Cred_25159 vin4.$649.Metal2 VSS.$2023.Metal1 0.000974975f
Cred_25160 vin4.$649.Metal2 VSS.$4000.Metal2 4.23036e-07f
Cred_25161 vin4.$649.Metal2 VSS.$4032.Metal2 0.00123426f
Cred_25162 vin4.$649.Metal2 VSS.$4080.Metal2 0.00280512f
Cred_25163 vin4.$649.Metal2 VSS.$4128.Metal2 1.20785e-06f
Cred_25164 vin4.$649.Metal2 VSS.$4152.Metal2 1.1207e-07f
Cred_25165 vin4.$649.Metal2 VSS.$4241.Metal2 2.999e-06f
Cred_25166 vin4.$649.Metal2 VSS.$5168.Metal3 9.89346e-06f
Cred_25167 vin4.$649.Metal2 VSS.$66.Metal1 2.68026e-06f
Cred_25168 vin4.$649.Metal2 VSS.P0.pSD 0.00687997f
Cred_25169 vin4.$649.Metal2 VSS.P1.GatPoly 3.41867e-05f
Cred_25170 vin4.$649.Metal2 VSS.P19.nSD 3.15318e-07f
Cred_25171 vin4.$649.Metal2 VSS.P21.nSD 1.22942e-07f
Cred_25172 vin4.$649.Metal2 VSS.P23.nSD 1.22942e-07f
Cred_25173 vin4.$65.GatPoly vout4.$1226.Metal3 0.00432025f
Cred_25174 vin4.$65.GatPoly vout4.$1292.Metal3 0.00448816f
Cred_25175 vin4.$65.GatPoly vout4.P4.nSD 5.23911e-07f
Cred_25176 vin4.$65.GatPoly vout4.P6.nSD 0.00598235f
Cred_25177 vin4.$65.GatPoly vout4.P6.pSD 0.000367161f
Cred_25178 vin4.$65.GatPoly vout4.P8.nSD 2.09838e-06f
Cred_25179 vin4.$65.GatPoly VSS.$1991.Metal1 2.64491e-06f
Cred_25180 vin4.$65.GatPoly VSS.$2023.Metal1 6.62232e-06f
Cred_25181 vin4.$65.GatPoly VSS.$2926.Metal2 5.4913e-05f
Cred_25182 vin4.$65.GatPoly VSS.$2958.Metal2 2.08531e-06f
Cred_25183 vin4.$65.GatPoly VSS.$3078.Metal2 6.25048e-05f
Cred_25184 vin4.$65.GatPoly VSS.$3113.Metal2 0.000207253f
Cred_25185 vin4.$65.GatPoly VSS.$4241.Metal2 1.77299e-08f
Cred_25186 vin4.$65.GatPoly VSS.$66.Metal1 7.64869e-05f
Cred_25187 vin4.$65.GatPoly VSS.$785.Metal1 0.000169257f
Cred_25188 vin4.$65.GatPoly VSS.$924.Metal1 0.000635031f
Cred_25189 vin4.$65.GatPoly VSS.P0.pSD 0.00362495f
Cred_25190 vin4.$65.GatPoly VSS.P10.nSD 2.37653e-05f
Cred_25191 vin4.$65.GatPoly VSS.P7.nSD 1.40717e-06f
Cred_25192 vin4.$653.Metal2 vout4 0.0188729f
Cred_25193 vin4.$653.Metal2 vout4.$1424.Metal3 0.0951849f
Cred_25194 vin4.$653.Metal2 vout4.P18.nSD 0.00159721f
Cred_25195 vin4.$653.Metal2 vout4.P18.pSD 0.029659f
Cred_25196 vin4.$653.Metal2 VSS.$1991.Metal1 0.000329069f
Cred_25197 vin4.$653.Metal2 VSS.$2023.Metal1 0.000823923f
Cred_25198 vin4.$653.Metal2 VSS.$4152.Metal2 0.000101763f
Cred_25199 vin4.$653.Metal2 VSS.$4241.Metal2 2.20588e-06f
Cred_25200 vin4.$653.Metal2 VSS.$66.Metal1 2.08296e-06f
Cred_25201 vin4.$653.Metal2 VSS.P0.pSD 0.00554875f
Cred_25202 vin4.$654.Metal2 vout4 0.0189817f
Cred_25203 vin4.$654.Metal2 vout4.$1424.Metal3 0.0957336f
Cred_25204 vin4.$654.Metal2 vout4.P18.nSD 0.0163365f
Cred_25205 vin4.$654.Metal2 vout4.P18.pSD 0.00825769f
Cred_25206 vin4.$654.Metal2 VSS.$1926.Metal1 7.12898e-05f
Cred_25207 vin4.$654.Metal2 VSS.$1986.Metal1 7.36241e-05f
Cred_25208 vin4.$654.Metal2 VSS.$1991.Metal1 0.00118223f
Cred_25209 vin4.$654.Metal2 VSS.$2023.Metal1 0.00305495f
Cred_25210 vin4.$654.Metal2 VSS.$4128.Metal2 0.00327481f
Cred_25211 vin4.$654.Metal2 VSS.$4152.Metal2 6.15563e-07f
Cred_25212 vin4.$654.Metal2 VSS.$4241.Metal2 1.01907e-05f
Cred_25213 vin4.$654.Metal2 VSS.$66.Metal1 6.62802e-06f
Cred_25214 vin4.$654.Metal2 VSS.P0.pSD 0.0186299f
Cred_25215 vin4.$654.Metal2 VSS.P1.GatPoly 0.000176926f
Cred_25216 vin4.$654.Metal2 VSS.P21.nSD 6.36259e-07f
Cred_25217 vin4.$654.Metal2 VSS.P23.nSD 6.36259e-07f
Cred_25218 vin4.$7.GatPoly vout4.$1226.Metal3 0.00765342f
Cred_25219 vin4.$7.GatPoly vout4.P0.nSD 0.00586314f
Cred_25220 vin4.$7.GatPoly vout4.P0.pSD 0.0011919f
Cred_25221 vin4.$7.GatPoly vout4.P2.nSD 0.000123201f
Cred_25222 vin4.$7.GatPoly vout4.P2.pSD 0.000658956f
Cred_25223 vin4.$7.GatPoly VSS.$160.Metal1 0.000222311f
Cred_25224 vin4.$7.GatPoly VSS.$1991.Metal1 4.59618e-07f
Cred_25225 vin4.$7.GatPoly VSS.$2023.Metal1 1.15079e-06f
Cred_25226 vin4.$7.GatPoly VSS.$2240.Metal2 7.50686e-05f
Cred_25227 vin4.$7.GatPoly VSS.$2360.Metal2 6.51564e-07f
Cred_25228 vin4.$7.GatPoly VSS.$2421.Metal2 5.05183e-06f
Cred_25229 vin4.$7.GatPoly VSS.$2445.Metal2 4.94172e-06f
Cred_25230 vin4.$7.GatPoly VSS.$2544.Metal2 2.03093e-05f
Cred_25231 vin4.$7.GatPoly VSS.$2576.Metal2 2.72725e-05f
Cred_25232 vin4.$7.GatPoly VSS.$266.Metal1 2.29556e-05f
Cred_25233 vin4.$7.GatPoly VSS.$326.Metal1 2.22222e-05f
Cred_25234 vin4.$7.GatPoly VSS.$387.Metal1 0.00053061f
Cred_25235 vin4.$7.GatPoly VSS.$4241.Metal2 3.08101e-09f
Cred_25236 vin4.$7.GatPoly VSS.$4364.Metal3 7.8152e-06f
Cred_25237 vin4.$7.GatPoly VSS.$4424.Metal3 5.77146e-09f
Cred_25238 vin4.$7.GatPoly VSS.$66.Metal1 0.000950616f
Cred_25239 vin4.$7.GatPoly VSS.P0.GatPoly 0.000379998f
Cred_25240 vin4.$7.GatPoly VSS.P0.nSD 1.48042e-06f
Cred_25241 vin4.$7.GatPoly VSS.P0.pSD 0.00451422f
Cred_25242 vin4.$7.GatPoly VSS.P1.nSD 1.48042e-06f
Cred_25243 vin4.$7.GatPoly VSS.P3.nSD 1.99003e-05f
Cred_25244 vin4.$71.GatPoly vout4.$1226.Metal3 0.00101616f
Cred_25245 vin4.$71.GatPoly vout4.$1292.Metal3 0.00154863f
Cred_25246 vin4.$71.GatPoly vout4.P6.nSD 0.000877937f
Cred_25247 vin4.$71.GatPoly vout4.P6.pSD 8.74912e-05f
Cred_25248 vin4.$71.GatPoly vout4.P8.nSD 4.99287e-06f
Cred_25249 vin4.$71.GatPoly VSS.$1991.Metal1 3.02773e-06f
Cred_25250 vin4.$71.GatPoly VSS.$2023.Metal1 7.58081e-06f
Cred_25251 vin4.$71.GatPoly VSS.$3054.Metal2 9.81705e-08f
Cred_25252 vin4.$71.GatPoly VSS.$3078.Metal2 0.000237304f
Cred_25253 vin4.$71.GatPoly VSS.$3113.Metal2 0.000786752f
Cred_25254 vin4.$71.GatPoly VSS.$4241.Metal2 2.02961e-08f
Cred_25255 vin4.$71.GatPoly VSS.$66.Metal1 5.61816e-05f
Cred_25256 vin4.$71.GatPoly VSS.$879.Metal1 3.74658e-06f
Cred_25257 vin4.$71.GatPoly VSS.$924.Metal1 0.00823109f
Cred_25258 vin4.$71.GatPoly VSS.P0.pSD 0.00333478f
Cred_25259 vin4.$71.GatPoly VSS.P10.nSD 0.000219362f
Cred_25260 vin4.$72.GatPoly vout4.$1226.Metal3 0.00583736f
Cred_25261 vin4.$72.GatPoly vout4.$1292.Metal3 0.00722747f
Cred_25262 vin4.$72.GatPoly vout4.P6.nSD 9.19621e-05f
Cred_25263 vin4.$72.GatPoly vout4.P6.pSD 0.00810359f
Cred_25264 vin4.$72.GatPoly vout4.P8.pSD 9.76778e-05f
Cred_25265 vin4.$76.GatPoly vout4.$1226.Metal3 0.00277707f
Cred_25266 vin4.$76.GatPoly vout4.$1292.Metal3 0.0545756f
Cred_25267 vin4.$76.GatPoly vout4.P6.nSD 4.37501e-05f
Cred_25268 vin4.$76.GatPoly vout4.P6.pSD 0.00064954f
Cred_25269 vin4.$76.GatPoly vout4.P8.pSD 0.0321726f
Cred_25270 vin4.$79.GatPoly vout4.$1226.Metal3 0.000284706f
Cred_25271 vin4.$79.GatPoly vout4.$1292.Metal3 0.00270625f
Cred_25272 vin4.$79.GatPoly vout4.P6.nSD 1.00965e-05f
Cred_25273 vin4.$79.GatPoly vout4.P6.pSD 2.4513e-05f
Cred_25274 vin4.$79.GatPoly vout4.P8.nSD 0.00100732f
Cred_25275 vin4.$79.GatPoly VSS.$1038.Metal1 2.98183e-07f
Cred_25276 vin4.$79.GatPoly VSS.$1991.Metal1 3.16078e-06f
Cred_25277 vin4.$79.GatPoly VSS.$2023.Metal1 7.91396e-06f
Cred_25278 vin4.$79.GatPoly VSS.$3078.Metal2 0.000244128f
Cred_25279 vin4.$79.GatPoly VSS.$3113.Metal2 0.000809477f
Cred_25280 vin4.$79.GatPoly VSS.$3169.Metal2 2.49119e-09f
Cred_25281 vin4.$79.GatPoly VSS.$4241.Metal2 2.1188e-08f
Cred_25282 vin4.$79.GatPoly VSS.$66.Metal1 4.02709e-05f
Cred_25283 vin4.$79.GatPoly VSS.$924.Metal1 0.00732535f
Cred_25284 vin4.$79.GatPoly VSS.$990.Metal1 1.29111e-05f
Cred_25285 vin4.$79.GatPoly VSS.P0.pSD 0.00289151f
Cred_25286 vin4.$79.GatPoly VSS.P10.nSD 0.000202016f
Cred_25287 vin4.$8.GatPoly vout4.$1226.Metal3 0.0447789f
Cred_25288 vin4.$8.GatPoly vout4.P0.nSD 0.00125946f
Cred_25289 vin4.$8.GatPoly vout4.P0.pSD 0.041632f
Cred_25290 vin4.$8.GatPoly vout4.P2.nSD 0.00070545f
Cred_25291 vin4.$8.GatPoly vout4.P2.pSD 0.00425851f
Cred_25292 vin4.$8.GatPoly VSS.$1991.Metal1 1.18008e-09f
Cred_25293 vin4.$8.GatPoly VSS.$2023.Metal1 2.95468e-09f
Cred_25294 vin4.$8.GatPoly VSS.$2421.Metal2 1.21987e-06f
Cred_25295 vin4.$8.GatPoly VSS.$2445.Metal2 8.94547e-07f
Cred_25296 vin4.$8.GatPoly VSS.$4241.Metal2 7.91055e-12f
Cred_25297 vin4.$8.GatPoly VSS.$4364.Metal3 7.75182e-06f
Cred_25298 vin4.$8.GatPoly VSS.$4424.Metal3 0.000152145f
Cred_25299 vin4.$8.GatPoly VSS.$4460.Metal3 0.00011157f
Cred_25300 vin4.$8.GatPoly VSS.$66.Metal1 1.0225e-05f
Cred_25301 vin4.$8.GatPoly VSS.P0.GatPoly 1.62293e-06f
Cred_25302 vin4.$8.GatPoly VSS.P0.pSD 1.95901e-05f
Cred_25303 vin4.$81.GatPoly vout4.$1226.Metal3 0.000199294f
Cred_25304 vin4.$81.GatPoly vout4.$1292.Metal3 0.00373469f
Cred_25305 vin4.$81.GatPoly vout4.P6.nSD 7.06754e-06f
Cred_25306 vin4.$81.GatPoly vout4.P6.pSD 1.71591e-05f
Cred_25307 vin4.$81.GatPoly vout4.P8.nSD 0.00220149f
Cred_25308 vin4.$81.GatPoly VSS.$1038.Metal1 4.53682e-07f
Cred_25309 vin4.$81.GatPoly VSS.$1991.Metal1 3.26246e-06f
Cred_25310 vin4.$81.GatPoly VSS.$2023.Metal1 8.16854e-06f
Cred_25311 vin4.$81.GatPoly VSS.$3078.Metal2 0.000118436f
Cred_25312 vin4.$81.GatPoly VSS.$3113.Metal2 0.000392707f
Cred_25313 vin4.$81.GatPoly VSS.$3169.Metal2 3.79032e-09f
Cred_25314 vin4.$81.GatPoly VSS.$4241.Metal2 2.18696e-08f
Cred_25315 vin4.$81.GatPoly VSS.$66.Metal1 3.04743e-05f
Cred_25316 vin4.$81.GatPoly VSS.$924.Metal1 0.0011929f
Cred_25317 vin4.$81.GatPoly VSS.$990.Metal1 1.48102e-06f
Cred_25318 vin4.$81.GatPoly VSS.P0.pSD 0.00255986f
Cred_25319 vin4.$81.GatPoly VSS.P10.nSD 4.4642e-05f
Cred_25320 vin4.$82.GatPoly vout4.$1292.Metal3 0.0109782f
Cred_25321 vin4.$82.GatPoly vout4.P8.pSD 0.0092696f
Cred_25322 vin4.$85.GatPoly vout4.$1292.Metal3 0.00847535f
Cred_25323 vin4.$85.GatPoly vout4.$1358.Metal3 8.93274e-05f
Cred_25324 vin4.$85.GatPoly vout4.P10.nSD 3.16716e-06f
Cred_25325 vin4.$85.GatPoly vout4.P10.pSD 7.62187e-06f
Cred_25326 vin4.$85.GatPoly vout4.P8.nSD 0.00569174f
Cred_25327 vin4.$85.GatPoly VSS 0.000543284f
Cred_25328 vin4.$85.GatPoly VSS.$1991.Metal1 5.10621e-06f
Cred_25329 vin4.$85.GatPoly VSS.$2023.Metal1 1.27849e-05f
Cred_25330 vin4.$85.GatPoly VSS.$3276.Metal2 0.000114418f
Cred_25331 vin4.$85.GatPoly VSS.$3308.Metal2 0.000114418f
Cred_25332 vin4.$85.GatPoly VSS.$4241.Metal2 3.4229e-08f
Cred_25333 vin4.$85.GatPoly VSS.$66.Metal1 3.62908e-05f
Cred_25334 vin4.$85.GatPoly VSS.P0.pSD 0.00349303f
Cred_25335 vin4.$85.GatPoly VSS.P11.nSD 2.03318e-05f
Cred_25336 vin4.$86.GatPoly vout4.$1292.Metal3 0.0565322f
Cred_25337 vin4.$86.GatPoly vout4.$1358.Metal3 0.00285379f
Cred_25338 vin4.$86.GatPoly vout4.P10.nSD 4.49588e-05f
Cred_25339 vin4.$86.GatPoly vout4.P10.pSD 0.000699669f
Cred_25340 vin4.$86.GatPoly vout4.P8.pSD 0.0335743f
Cred_25341 vin4.$91.GatPoly vout4.$1292.Metal3 0.00275715f
Cred_25342 vin4.$91.GatPoly vout4.$1358.Metal3 0.000290126f
Cred_25343 vin4.$91.GatPoly vout4.P10.nSD 1.02866e-05f
Cred_25344 vin4.$91.GatPoly vout4.P10.pSD 2.47551e-05f
Cred_25345 vin4.$91.GatPoly vout4.P8.nSD 0.00101147f
Cred_25346 vin4.$91.GatPoly VSS 0.00511851f
Cred_25347 vin4.$91.GatPoly VSS.$1078.Metal1 0.000212333f
Cred_25348 vin4.$91.GatPoly VSS.$1991.Metal1 5.23962e-06f
Cred_25349 vin4.$91.GatPoly VSS.$2023.Metal1 1.3119e-05f
Cred_25350 vin4.$91.GatPoly VSS.$3217.Metal2 9.13595e-08f
Cred_25351 vin4.$91.GatPoly VSS.$3276.Metal2 0.000473398f
Cred_25352 vin4.$91.GatPoly VSS.$3308.Metal2 0.000471677f
Cred_25353 vin4.$91.GatPoly VSS.$4241.Metal2 3.51233e-08f
Cred_25354 vin4.$91.GatPoly VSS.$4808.Metal3 7.325e-10f
Cred_25355 vin4.$91.GatPoly VSS.$66.Metal1 2.56866e-05f
Cred_25356 vin4.$91.GatPoly VSS.P0.pSD 0.00297592f
Cred_25357 vin4.$91.GatPoly VSS.P11.nSD 0.00015164f
Cred_25358 vin4.$95.GatPoly vout4.$1292.Metal3 0.000682049f
Cred_25359 vin4.$95.GatPoly vout4.$1358.Metal3 0.000448945f
Cred_25360 vin4.$95.GatPoly vout4.P10.nSD 0.00039386f
Cred_25361 vin4.$95.GatPoly vout4.P10.pSD 3.83063e-05f
Cred_25362 vin4.$95.GatPoly vout4.P8.nSD 2.18579e-06f
Cred_25363 vin4.$95.GatPoly VSS 0.0126278f
Cred_25364 vin4.$95.GatPoly VSS.$1078.Metal1 0.000201669f
Cred_25365 vin4.$95.GatPoly VSS.$1174.Metal1 0.000509998f
Cred_25366 vin4.$95.GatPoly VSS.$1991.Metal1 7.58449e-06f
Cred_25367 vin4.$95.GatPoly VSS.$2023.Metal1 1.899e-05f
Cred_25368 vin4.$95.GatPoly VSS.$3276.Metal2 0.000502281f
Cred_25369 vin4.$95.GatPoly VSS.$3308.Metal2 0.000504765f
Cred_25370 vin4.$95.GatPoly VSS.$4241.Metal2 5.08419e-08f
Cred_25371 vin4.$95.GatPoly VSS.$66.Metal1 2.59008e-05f
Cred_25372 vin4.$95.GatPoly VSS.P0.pSD 0.00359133f
Cred_25373 vin4.$95.GatPoly VSS.P11.nSD 0.000332057f
Cred_25374 vin4.$96.GatPoly vout4.$1292.Metal3 0.0312837f
Cred_25375 vin4.$96.GatPoly vout4.$1358.Metal3 0.0254406f
Cred_25376 vin4.$96.GatPoly vout4.P10.nSD 0.000400792f
Cred_25377 vin4.$96.GatPoly vout4.P10.pSD 0.0365361f
Cred_25378 vin4.$96.GatPoly vout4.P8.pSD 0.000410777f
Cred_25379 vin4.P0.GatPoly vout4.$1226.Metal3 0.0351948f
Cred_25380 vin4.P0.GatPoly vout4.P0.nSD 0.0265082f
Cred_25381 vin4.P0.GatPoly vout4.P0.pSD 0.00556885f
Cred_25382 vin4.P0.GatPoly vout4.P2.nSD 0.000554462f
Cred_25383 vin4.P0.GatPoly vout4.P2.pSD 0.00303026f
Cred_25384 vin4.P0.GatPoly VSS.$160.Metal1 0.0458996f
Cred_25385 vin4.P0.GatPoly VSS.$1991.Metal1 8.47855e-07f
Cred_25386 vin4.P0.GatPoly VSS.$2023.Metal1 2.12286e-06f
Cred_25387 vin4.P0.GatPoly VSS.$2240.Metal2 0.0121622f
Cred_25388 vin4.P0.GatPoly VSS.$2360.Metal2 0.000492762f
Cred_25389 vin4.P0.GatPoly VSS.$2421.Metal2 0.00586171f
Cred_25390 vin4.P0.GatPoly VSS.$2445.Metal2 0.00422297f
Cred_25391 vin4.P0.GatPoly VSS.$2544.Metal2 0.000585659f
Cred_25392 vin4.P0.GatPoly VSS.$2576.Metal2 0.000786456f
Cred_25393 vin4.P0.GatPoly VSS.$266.Metal1 0.0102494f
Cred_25394 vin4.P0.GatPoly VSS.$326.Metal1 0.00920261f
Cred_25395 vin4.P0.GatPoly VSS.$387.Metal1 0.000103919f
Cred_25396 vin4.P0.GatPoly VSS.$4241.Metal2 5.68351e-09f
Cred_25397 vin4.P0.GatPoly VSS.$4364.Metal3 6.60313e-06f
Cred_25398 vin4.P0.GatPoly VSS.$4424.Metal3 0.00347702f
Cred_25399 vin4.P0.GatPoly VSS.$4460.Metal3 0.00276441f
Cred_25400 vin4.P0.GatPoly VSS.$66.Metal1 0.00271541f
Cred_25401 vin4.P0.GatPoly VSS.P0.GatPoly 0.0188624f
Cred_25402 vin4.P0.GatPoly VSS.P0.nSD 0.000210612f
Cred_25403 vin4.P0.GatPoly VSS.P0.pSD 0.0100631f
Cred_25404 vin4.P0.GatPoly VSS.P1.nSD 0.000210612f
Cred_25405 vin4.P0.GatPoly VSS.P3.nSD 3.56597e-06f
Cred_25406 vin4.P1.GatPoly vout4.$1226.Metal3 0.0367128f
Cred_25407 vin4.P1.GatPoly vout4.P0.nSD 0.0231313f
Cred_25408 vin4.P1.GatPoly vout4.P0.pSD 0.00555071f
Cred_25409 vin4.P1.GatPoly vout4.P2.nSD 0.000617178f
Cred_25410 vin4.P1.GatPoly vout4.P2.pSD 0.00316095f
Cred_25411 vin4.P1.GatPoly VSS.$1991.Metal1 6.87509e-08f
Cred_25412 vin4.P1.GatPoly VSS.$2023.Metal1 1.72138e-07f
Cred_25413 vin4.P1.GatPoly VSS.$2493.Metal2 0.00556066f
Cred_25414 vin4.P1.GatPoly VSS.$2544.Metal2 0.0088377f
Cred_25415 vin4.P1.GatPoly VSS.$2576.Metal2 0.00807083f
Cred_25416 vin4.P1.GatPoly VSS.$326.Metal1 0.00333774f
Cred_25417 vin4.P1.GatPoly VSS.$374.Metal1 0.0144838f
Cred_25418 vin4.P1.GatPoly VSS.$387.Metal1 0.0581484f
Cred_25419 vin4.P1.GatPoly VSS.$4241.Metal2 4.60865e-10f
Cred_25420 vin4.P1.GatPoly VSS.$4484.Metal3 0.00390769f
Cred_25421 vin4.P1.GatPoly VSS.$66.Metal1 9.87321e-05f
Cred_25422 vin4.P1.GatPoly VSS.P0.pSD 0.000600429f
Cred_25423 vin4.P1.GatPoly VSS.P3.nSD 0.00178219f
Cred_25424 vin4.P10.GatPoly vout4.$1292.Metal3 0.0242843f
Cred_25425 vin4.P10.GatPoly vout4.$1358.Metal3 0.0205287f
Cred_25426 vin4.P10.GatPoly vout4.P10.nSD 0.0217703f
Cred_25427 vin4.P10.GatPoly vout4.P10.pSD 0.00175161f
Cred_25428 vin4.P10.GatPoly vout4.P8.nSD 3.84552e-05f
Cred_25429 vin4.P10.GatPoly VSS 0.0550719f
Cred_25430 vin4.P10.GatPoly VSS.$1174.Metal1 0.0142989f
Cred_25431 vin4.P10.GatPoly VSS.$1214.Metal1 0.00331295f
Cred_25432 vin4.P10.GatPoly VSS.$1267.Metal1 8.99087e-05f
Cred_25433 vin4.P10.GatPoly VSS.$1991.Metal1 2.28943e-06f
Cred_25434 vin4.P10.GatPoly VSS.$2023.Metal1 5.73227e-06f
Cred_25435 vin4.P10.GatPoly VSS.$3276.Metal2 0.00696084f
Cred_25436 vin4.P10.GatPoly VSS.$3308.Metal2 0.0097833f
Cred_25437 vin4.P10.GatPoly VSS.$3356.Metal2 0.00597574f
Cred_25438 vin4.P10.GatPoly VSS.$3463.Metal2 0.00091972f
Cred_25439 vin4.P10.GatPoly VSS.$3495.Metal2 0.000277376f
Cred_25440 vin4.P10.GatPoly VSS.$4241.Metal2 1.5347e-08f
Cred_25441 vin4.P10.GatPoly VSS.$4844.Metal3 0.00390769f
Cred_25442 vin4.P10.GatPoly VSS.$66.Metal1 6.05797e-06f
Cred_25443 vin4.P10.GatPoly VSS.P0.pSD 0.000967334f
Cred_25444 vin4.P10.GatPoly VSS.P11.nSD 0.00170404f
Cred_25445 vin4.P10.GatPoly VSS.P13.nSD 3.08522e-06f
Cred_25446 vin4.P11.GatPoly vout4.$1292.Metal3 0.0201189f
Cred_25447 vin4.P11.GatPoly vout4.$1358.Metal3 0.0235822f
Cred_25448 vin4.P11.GatPoly vout4.P10.nSD 0.0215498f
Cred_25449 vin4.P11.GatPoly vout4.P10.pSD 0.00171665f
Cred_25450 vin4.P11.GatPoly vout4.P12.nSD 3.57144e-05f
Cred_25451 vin4.P11.GatPoly VSS 9.06646e-05f
Cred_25452 vin4.P11.GatPoly VSS.$1214.Metal1 0.00413997f
Cred_25453 vin4.P11.GatPoly VSS.$1254.Metal1 0.0140247f
Cred_25454 vin4.P11.GatPoly VSS.$1267.Metal1 0.0500404f
Cred_25455 vin4.P11.GatPoly VSS.$3276.Metal2 0.000598157f
Cred_25456 vin4.P11.GatPoly VSS.$3308.Metal2 0.000598157f
Cred_25457 vin4.P11.GatPoly VSS.$3356.Metal2 7.37632e-06f
Cred_25458 vin4.P11.GatPoly VSS.$3404.Metal2 0.00692018f
Cred_25459 vin4.P11.GatPoly VSS.$3463.Metal2 0.0126099f
Cred_25460 vin4.P11.GatPoly VSS.$3495.Metal2 0.00309293f
Cred_25461 vin4.P11.GatPoly VSS.$4844.Metal3 0.000460914f
Cred_25462 vin4.P11.GatPoly VSS.$4892.Metal3 0.00482079f
Cred_25463 vin4.P11.GatPoly VSS.P0.pSD 9.05855e-06f
Cred_25464 vin4.P11.GatPoly VSS.P11.nSD 3.11116e-06f
Cred_25465 vin4.P11.GatPoly VSS.P13.nSD 0.00157765f
Cred_25466 vin4.P12.GatPoly vout4.$1292.Metal3 0.00172617f
Cred_25467 vin4.P12.GatPoly vout4.$1358.Metal3 0.0443094f
Cred_25468 vin4.P12.GatPoly vout4.P10.nSD 6.44422e-05f
Cred_25469 vin4.P12.GatPoly vout4.P10.pSD 0.000147285f
Cred_25470 vin4.P12.GatPoly vout4.P12.nSD 0.0212036f
Cred_25471 vin4.P12.GatPoly VSS.$1267.Metal1 0.0571382f
Cred_25472 vin4.P12.GatPoly VSS.$1373.Metal1 0.0126797f
Cred_25473 vin4.P12.GatPoly VSS.$1483.Metal1 9.66851e-05f
Cred_25474 vin4.P12.GatPoly VSS.$1991.Metal1 2.16158e-06f
Cred_25475 vin4.P12.GatPoly VSS.$2023.Metal1 5.41216e-06f
Cred_25476 vin4.P12.GatPoly VSS.$3463.Metal2 0.0103861f
Cred_25477 vin4.P12.GatPoly VSS.$3495.Metal2 0.00556097f
Cred_25478 vin4.P12.GatPoly VSS.$3519.Metal2 0.00699176f
Cred_25479 vin4.P12.GatPoly VSS.$3567.Metal2 0.00122955f
Cred_25480 vin4.P12.GatPoly VSS.$3615.Metal2 4.36418e-05f
Cred_25481 vin4.P12.GatPoly VSS.$3650.Metal2 0.00114923f
Cred_25482 vin4.P12.GatPoly VSS.$4241.Metal2 1.449e-08f
Cred_25483 vin4.P12.GatPoly VSS.$4892.Metal3 0.00162593f
Cred_25484 vin4.P12.GatPoly VSS.$4940.Metal3 0.00336824f
Cred_25485 vin4.P12.GatPoly VSS.$66.Metal1 1.34436e-06f
Cred_25486 vin4.P12.GatPoly VSS.P0.pSD 0.000466296f
Cred_25487 vin4.P12.GatPoly VSS.P13.nSD 0.0015791f
Cred_25488 vin4.P12.GatPoly VSS.P15.nSD 5.29002e-07f
Cred_25489 vin4.P13.GatPoly vout4.$1358.Metal3 0.0441012f
Cred_25490 vin4.P13.GatPoly vout4.$1424.Metal3 0.00165462f
Cred_25491 vin4.P13.GatPoly vout4.P12.nSD 0.0213646f
Cred_25492 vin4.P13.GatPoly vout4.P14.nSD 6.19055e-05f
Cred_25493 vin4.P13.GatPoly vout4.P14.pSD 0.000141181f
Cred_25494 vin4.P13.GatPoly VSS.$1267.Metal1 8.99087e-05f
Cred_25495 vin4.P13.GatPoly VSS.$1373.Metal1 0.00118965f
Cred_25496 vin4.P13.GatPoly VSS.$1421.Metal1 0.0148789f
Cred_25497 vin4.P13.GatPoly VSS.$1483.Metal1 0.0526177f
Cred_25498 vin4.P13.GatPoly VSS.$1484.Metal1 0.00436754f
Cred_25499 vin4.P13.GatPoly VSS.$1991.Metal1 2.58246e-06f
Cred_25500 vin4.P13.GatPoly VSS.$2023.Metal1 6.46596e-06f
Cred_25501 vin4.P13.GatPoly VSS.$3463.Metal2 0.00091972f
Cred_25502 vin4.P13.GatPoly VSS.$3495.Metal2 0.000277376f
Cred_25503 vin4.P13.GatPoly VSS.$3567.Metal2 0.00281966f
Cred_25504 vin4.P13.GatPoly VSS.$3615.Metal2 0.00668692f
Cred_25505 vin4.P13.GatPoly VSS.$3650.Metal2 0.00985657f
Cred_25506 vin4.P13.GatPoly VSS.$4241.Metal2 1.73113e-08f
Cred_25507 vin4.P13.GatPoly VSS.$4964.Metal3 0.00440933f
Cred_25508 vin4.P13.GatPoly VSS.$5000.Metal3 0.000775961f
Cred_25509 vin4.P13.GatPoly VSS.$66.Metal1 1.01834e-06f
Cred_25510 vin4.P13.GatPoly VSS.P0.pSD 0.000426885f
Cred_25511 vin4.P13.GatPoly VSS.P13.nSD 3.08522e-06f
Cred_25512 vin4.P13.GatPoly VSS.P15.nSD 0.00021155f
Cred_25513 vin4.P14.GatPoly vout4.$1358.Metal3 0.0222288f
Cred_25514 vin4.P14.GatPoly vout4.$1424.Metal3 0.0191762f
Cred_25515 vin4.P14.GatPoly vout4.P12.nSD 3.18635e-05f
Cred_25516 vin4.P14.GatPoly vout4.P14.nSD 0.0205849f
Cred_25517 vin4.P14.GatPoly vout4.P14.pSD 0.00163622f
Cred_25518 vin4.P14.GatPoly VSS.$1483.Metal1 0.0521114f
Cred_25519 vin4.P14.GatPoly VSS.$1512.Metal1 0.0154523f
Cred_25520 vin4.P14.GatPoly VSS.$1580.Metal1 0.00433478f
Cred_25521 vin4.P14.GatPoly VSS.$1625.Metal1 9.02649e-05f
Cred_25522 vin4.P14.GatPoly VSS.$3615.Metal2 0.000358966f
Cred_25523 vin4.P14.GatPoly VSS.$3650.Metal2 0.0113716f
Cred_25524 vin4.P14.GatPoly VSS.$3706.Metal2 0.00751382f
Cred_25525 vin4.P14.GatPoly VSS.$3730.Metal2 4.30156e-05f
Cred_25526 vin4.P14.GatPoly VSS.$3802.Metal2 0.000364856f
Cred_25527 vin4.P14.GatPoly VSS.$3837.Metal2 0.000831872f
Cred_25528 vin4.P14.GatPoly VSS.$5000.Metal3 0.00443521f
Cred_25529 vin4.P14.GatPoly VSS.$5036.Metal3 0.000848036f
Cred_25530 vin4.P14.GatPoly VSS.P0.pSD 2.14021e-05f
Cred_25531 vin4.P14.GatPoly VSS.P15.nSD 0.000208376f
Cred_25532 vin4.P14.GatPoly VSS.P17.nSD 3.09744e-06f
Cred_25533 vin4.P15.GatPoly vout4.$1358.Metal3 0.0209365f
Cred_25534 vin4.P15.GatPoly vout4.$1424.Metal3 0.0246698f
Cred_25535 vin4.P15.GatPoly vout4.P14.nSD 0.0225422f
Cred_25536 vin4.P15.GatPoly vout4.P14.pSD 0.00178641f
Cred_25537 vin4.P15.GatPoly vout4.P16.nSD 3.82463e-05f
Cred_25538 vin4.P15.GatPoly VSS.$1483.Metal1 9.66851e-05f
Cred_25539 vin4.P15.GatPoly VSS.$1580.Metal1 0.0129289f
Cred_25540 vin4.P15.GatPoly VSS.$1625.Metal1 0.0570885f
Cred_25541 vin4.P15.GatPoly VSS.$1991.Metal1 1.31729e-05f
Cred_25542 vin4.P15.GatPoly VSS.$2023.Metal1 3.29822e-05f
Cred_25543 vin4.P15.GatPoly VSS.$3615.Metal2 4.36418e-05f
Cred_25544 vin4.P15.GatPoly VSS.$3650.Metal2 0.00114923f
Cred_25545 vin4.P15.GatPoly VSS.$3730.Metal2 0.00100845f
Cred_25546 vin4.P15.GatPoly VSS.$3778.Metal2 0.00676466f
Cred_25547 vin4.P15.GatPoly VSS.$3802.Metal2 0.00616224f
Cred_25548 vin4.P15.GatPoly VSS.$3837.Metal2 0.00948282f
Cred_25549 vin4.P15.GatPoly VSS.$4241.Metal2 8.83032e-08f
Cred_25550 vin4.P15.GatPoly VSS.$5036.Metal3 0.00341116f
Cred_25551 vin4.P15.GatPoly VSS.$5084.Metal3 0.00154919f
Cred_25552 vin4.P15.GatPoly VSS.$66.Metal1 1.11627e-06f
Cred_25553 vin4.P15.GatPoly VSS.P0.pSD 0.000982691f
Cred_25554 vin4.P15.GatPoly VSS.P15.nSD 5.29002e-07f
Cred_25555 vin4.P15.GatPoly VSS.P17.nSD 0.00158988f
Cred_25556 vin4.P16.GatPoly vout4.$1358.Metal3 0.00145287f
Cred_25557 vin4.P16.GatPoly vout4.$1424.Metal3 0.0417745f
Cred_25558 vin4.P16.GatPoly vout4.P14.nSD 5.47521e-05f
Cred_25559 vin4.P16.GatPoly vout4.P14.pSD 0.000123966f
Cred_25560 vin4.P16.GatPoly vout4.P16.nSD 0.0203078f
Cred_25561 vin4.P16.GatPoly VSS.$1625.Metal1 0.0494072f
Cred_25562 vin4.P16.GatPoly VSS.$1699.Metal1 0.01338f
Cred_25563 vin4.P16.GatPoly VSS.$1739.Metal1 0.00459092f
Cred_25564 vin4.P16.GatPoly VSS.$1800.Metal1 9.06084e-05f
Cred_25565 vin4.P16.GatPoly VSS.$3802.Metal2 0.00390469f
Cred_25566 vin4.P16.GatPoly VSS.$3837.Metal2 0.0114078f
Cred_25567 vin4.P16.GatPoly VSS.$3893.Metal2 0.00670696f
Cred_25568 vin4.P16.GatPoly VSS.$3941.Metal2 6.29324e-06f
Cred_25569 vin4.P16.GatPoly VSS.$4000.Metal2 0.000685726f
Cred_25570 vin4.P16.GatPoly VSS.$4032.Metal2 0.000510647f
Cred_25571 vin4.P16.GatPoly VSS.$5084.Metal3 0.00490799f
Cred_25572 vin4.P16.GatPoly VSS.$5132.Metal3 0.000393237f
Cred_25573 vin4.P16.GatPoly VSS.P0.pSD 1.17745e-05f
Cred_25574 vin4.P16.GatPoly VSS.P17.nSD 0.00151919f
Cred_25575 vin4.P16.GatPoly VSS.P19.nSD 3.10923e-06f
Cred_25576 vin4.P17.GatPoly vout4 0.0005655f
Cred_25577 vin4.P17.GatPoly vout4.$1424.Metal3 0.0463676f
Cred_25578 vin4.P17.GatPoly vout4.P16.nSD 0.0216974f
Cred_25579 vin4.P17.GatPoly vout4.P18.nSD 8.29213e-05f
Cred_25580 vin4.P17.GatPoly vout4.P18.pSD 0.000243355f
Cred_25581 vin4.P17.GatPoly VSS.$1625.Metal1 9.02649e-05f
Cred_25582 vin4.P17.GatPoly VSS.$1739.Metal1 0.0036862f
Cred_25583 vin4.P17.GatPoly VSS.$1787.Metal1 0.0136645f
Cred_25584 vin4.P17.GatPoly VSS.$1800.Metal1 0.0517025f
Cred_25585 vin4.P17.GatPoly VSS.$1991.Metal1 2.72715e-05f
Cred_25586 vin4.P17.GatPoly VSS.$2023.Metal1 6.82824e-05f
Cred_25587 vin4.P17.GatPoly VSS.$3802.Metal2 0.000364856f
Cred_25588 vin4.P17.GatPoly VSS.$3837.Metal2 0.000831872f
Cred_25589 vin4.P17.GatPoly VSS.$3893.Metal2 4.69191e-06f
Cred_25590 vin4.P17.GatPoly VSS.$3941.Metal2 0.00632534f
Cred_25591 vin4.P17.GatPoly VSS.$4000.Metal2 0.0105346f
Cred_25592 vin4.P17.GatPoly VSS.$4032.Metal2 0.00580156f
Cred_25593 vin4.P17.GatPoly VSS.$4241.Metal2 1.82812e-07f
Cred_25594 vin4.P17.GatPoly VSS.$5084.Metal3 0.000293177f
Cred_25595 vin4.P17.GatPoly VSS.$5132.Metal3 0.004796f
Cred_25596 vin4.P17.GatPoly VSS.$66.Metal1 5.79407e-07f
Cred_25597 vin4.P17.GatPoly VSS.P0.pSD 0.00095676f
Cred_25598 vin4.P17.GatPoly VSS.P17.nSD 3.09744e-06f
Cred_25599 vin4.P17.GatPoly VSS.P19.nSD 0.00158928f
Cred_25600 vin4.P18.GatPoly vout4 0.00663761f
Cred_25601 vin4.P18.GatPoly vout4.$1424.Metal3 0.0372692f
Cred_25602 vin4.P18.GatPoly vout4.P16.nSD 3.88024e-05f
Cred_25603 vin4.P18.GatPoly vout4.P18.nSD 0.0223709f
Cred_25604 vin4.P18.GatPoly vout4.P18.pSD 0.0028564f
Cred_25605 vin4.P18.GatPoly VSS.$1800.Metal1 0.0581484f
Cred_25606 vin4.P18.GatPoly VSS.$1878.Metal1 0.0144838f
Cred_25607 vin4.P18.GatPoly VSS.$1926.Metal1 0.00333774f
Cred_25608 vin4.P18.GatPoly VSS.$1991.Metal1 2.59884e-05f
Cred_25609 vin4.P18.GatPoly VSS.$2023.Metal1 6.50696e-05f
Cred_25610 vin4.P18.GatPoly VSS.$4000.Metal2 0.00807083f
Cred_25611 vin4.P18.GatPoly VSS.$4032.Metal2 0.0088377f
Cred_25612 vin4.P18.GatPoly VSS.$4080.Metal2 0.00556066f
Cred_25613 vin4.P18.GatPoly VSS.$4241.Metal2 1.74211e-07f
Cred_25614 vin4.P18.GatPoly VSS.$5168.Metal3 0.00390769f
Cred_25615 vin4.P18.GatPoly VSS.$66.Metal1 2.62021e-07f
Cred_25616 vin4.P18.GatPoly VSS.P0.pSD 0.000607908f
Cred_25617 vin4.P18.GatPoly VSS.P19.nSD 0.00178219f
Cred_25618 vin4.P19.GatPoly vout4 0.00823266f
Cred_25619 vin4.P19.GatPoly vout4.$1424.Metal3 0.0415213f
Cred_25620 vin4.P19.GatPoly vout4.P18.nSD 0.0258089f
Cred_25621 vin4.P19.GatPoly vout4.P18.pSD 0.00354281f
Cred_25622 vin4.P19.GatPoly VSS.$1800.Metal1 0.000103919f
Cred_25623 vin4.P19.GatPoly VSS.$1926.Metal1 0.00956147f
Cred_25624 vin4.P19.GatPoly VSS.$1986.Metal1 0.0104793f
Cred_25625 vin4.P19.GatPoly VSS.$1991.Metal1 0.000711861f
Cred_25626 vin4.P19.GatPoly VSS.$2023.Metal1 0.0477301f
Cred_25627 vin4.P19.GatPoly VSS.$4000.Metal2 0.000786456f
Cred_25628 vin4.P19.GatPoly VSS.$4032.Metal2 0.000585659f
Cred_25629 vin4.P19.GatPoly VSS.$4128.Metal2 0.00496993f
Cred_25630 vin4.P19.GatPoly VSS.$4152.Metal2 0.00693351f
Cred_25631 vin4.P19.GatPoly VSS.$4213.Metal2 0.000492212f
Cred_25632 vin4.P19.GatPoly VSS.$4241.Metal2 0.0129876f
Cred_25633 vin4.P19.GatPoly VSS.$5192.Metal3 0.00278945f
Cred_25634 vin4.P19.GatPoly VSS.$5228.Metal3 0.0035273f
Cred_25635 vin4.P19.GatPoly VSS.$66.Metal1 3.25212e-06f
Cred_25636 vin4.P19.GatPoly VSS.P0.pSD 0.0102793f
Cred_25637 vin4.P19.GatPoly VSS.P1.GatPoly 0.0190579f
Cred_25638 vin4.P19.GatPoly VSS.P19.nSD 3.56597e-06f
Cred_25639 vin4.P19.GatPoly VSS.P21.nSD 0.000210815f
Cred_25640 vin4.P19.GatPoly VSS.P23.nSD 0.000210815f
Cred_25641 vin4.P2.GatPoly vout4.$1226.Metal3 0.0393216f
Cred_25642 vin4.P2.GatPoly vout4.P0.nSD 0.000674738f
Cred_25643 vin4.P2.GatPoly vout4.P0.pSD 0.00325793f
Cred_25644 vin4.P2.GatPoly vout4.P2.nSD 0.0223169f
Cred_25645 vin4.P2.GatPoly vout4.P2.pSD 0.00338557f
Cred_25646 vin4.P2.GatPoly VSS.$1991.Metal1 1.52283e-07f
Cred_25647 vin4.P2.GatPoly VSS.$2023.Metal1 3.81286e-07f
Cred_25648 vin4.P2.GatPoly VSS.$2544.Metal2 0.00582372f
Cred_25649 vin4.P2.GatPoly VSS.$2576.Metal2 0.0105643f
Cred_25650 vin4.P2.GatPoly VSS.$2632.Metal2 0.00632534f
Cred_25651 vin4.P2.GatPoly VSS.$2680.Metal2 4.69191e-06f
Cred_25652 vin4.P2.GatPoly VSS.$2739.Metal2 0.000831872f
Cred_25653 vin4.P2.GatPoly VSS.$2771.Metal2 0.000364856f
Cred_25654 vin4.P2.GatPoly VSS.$387.Metal1 0.0523928f
Cred_25655 vin4.P2.GatPoly VSS.$4241.Metal2 1.02081e-09f
Cred_25656 vin4.P2.GatPoly VSS.$4520.Metal3 0.004796f
Cred_25657 vin4.P2.GatPoly VSS.$4568.Metal3 0.000293177f
Cred_25658 vin4.P2.GatPoly VSS.$465.Metal1 0.0136645f
Cred_25659 vin4.P2.GatPoly VSS.$513.Metal1 0.0036862f
Cred_25660 vin4.P2.GatPoly VSS.$566.Metal1 9.02649e-05f
Cred_25661 vin4.P2.GatPoly VSS.$66.Metal1 0.000103607f
Cred_25662 vin4.P2.GatPoly VSS.P0.pSD 0.000948934f
Cred_25663 vin4.P2.GatPoly VSS.P3.nSD 0.00161083f
Cred_25664 vin4.P2.GatPoly VSS.P5.nSD 3.09744e-06f
Cred_25665 vin4.P20.GatPoly vout4.$1226.Metal3 0.157091f
Cred_25666 vin4.P20.GatPoly vout4.P0.nSD 0.00467766f
Cred_25667 vin4.P20.GatPoly vout4.P0.pSD 0.170586f
Cred_25668 vin4.P20.GatPoly vout4.P2.nSD 0.00247482f
Cred_25669 vin4.P20.GatPoly vout4.P2.pSD 0.0135254f
Cred_25670 vin4.P20.GatPoly VSS.$1991.Metal1 9.29423e-10f
Cred_25671 vin4.P20.GatPoly VSS.$2023.Metal1 2.32709e-09f
Cred_25672 vin4.P20.GatPoly VSS.$2421.Metal2 4.7835e-06f
Cred_25673 vin4.P20.GatPoly VSS.$2445.Metal2 3.50781e-06f
Cred_25674 vin4.P20.GatPoly VSS.$4241.Metal2 6.23029e-12f
Cred_25675 vin4.P20.GatPoly VSS.$4364.Metal3 6.10528e-06f
Cred_25676 vin4.P20.GatPoly VSS.$4424.Metal3 0.000596611f
Cred_25677 vin4.P20.GatPoly VSS.$4460.Metal3 0.000437504f
Cred_25678 vin4.P20.GatPoly VSS.$66.Metal1 8.05316e-06f
Cred_25679 vin4.P20.GatPoly VSS.P0.GatPoly 1.27821e-06f
Cred_25680 vin4.P20.GatPoly VSS.P0.pSD 1.5429e-05f
Cred_25681 vin4.P21.GatPoly vout4.$1226.Metal3 0.160661f
Cred_25682 vin4.P21.GatPoly vout4.P0.nSD 0.00458159f
Cred_25683 vin4.P21.GatPoly vout4.P0.pSD 0.152776f
Cred_25684 vin4.P21.GatPoly vout4.P2.nSD 0.00253106f
Cred_25685 vin4.P21.GatPoly vout4.P2.pSD 0.0164452f
Cred_25686 vin4.P22.GatPoly vout4.$1226.Metal3 0.174054f
Cred_25687 vin4.P22.GatPoly vout4.P0.nSD 0.0026994f
Cred_25688 vin4.P22.GatPoly vout4.P0.pSD 0.0174661f
Cred_25689 vin4.P22.GatPoly vout4.P2.nSD 0.00274205f
Cred_25690 vin4.P22.GatPoly vout4.P2.pSD 0.135457f
Cred_25691 vin4.P23.GatPoly vout4.$1226.Metal3 0.177972f
Cred_25692 vin4.P23.GatPoly vout4.P0.nSD 0.00235124f
Cred_25693 vin4.P23.GatPoly vout4.P0.pSD 0.0124941f
Cred_25694 vin4.P23.GatPoly vout4.P2.nSD 0.00255785f
Cred_25695 vin4.P23.GatPoly vout4.P2.pSD 0.13445f
Cred_25696 vin4.P23.GatPoly vout4.P4.pSD 0.00259263f
Cred_25697 vin4.P24.GatPoly vout4.$1226.Metal3 0.216059f
Cred_25698 vin4.P24.GatPoly vout4.P0.nSD 0.000200773f
Cred_25699 vin4.P24.GatPoly vout4.P0.pSD 0.00106687f
Cred_25700 vin4.P24.GatPoly vout4.P2.nSD 0.000218415f
Cred_25701 vin4.P24.GatPoly vout4.P2.pSD 0.00385188f
Cred_25702 vin4.P24.GatPoly vout4.P4.pSD 0.125718f
Cred_25703 vin4.P25.GatPoly vout4.$1226.Metal3 0.201171f
Cred_25704 vin4.P25.GatPoly vout4.$1292.Metal3 0.00742713f
Cred_25705 vin4.P25.GatPoly vout4.P4.pSD 0.120471f
Cred_25706 vin4.P25.GatPoly vout4.P6.nSD 0.000117007f
Cred_25707 vin4.P25.GatPoly vout4.P6.pSD 0.0032321f
Cred_25708 vin4.P26.GatPoly vout4.$1226.Metal3 0.107788f
Cred_25709 vin4.P26.GatPoly vout4.$1292.Metal3 0.0921775f
Cred_25710 vin4.P26.GatPoly vout4.P4.pSD 0.00259263f
Cred_25711 vin4.P26.GatPoly vout4.P6.nSD 0.00145217f
Cred_25712 vin4.P26.GatPoly vout4.P6.pSD 0.128408f
Cred_25713 vin4.P27.GatPoly vout4.$1226.Metal3 0.096316f
Cred_25714 vin4.P27.GatPoly vout4.$1292.Metal3 0.112912f
Cred_25715 vin4.P27.GatPoly vout4.P6.nSD 0.00151737f
Cred_25716 vin4.P27.GatPoly vout4.P6.pSD 0.134153f
Cred_25717 vin4.P27.GatPoly vout4.P8.pSD 0.00266188f
Cred_25718 vin4.P28.GatPoly vout4.$1226.Metal3 0.00742713f
Cred_25719 vin4.P28.GatPoly vout4.$1292.Metal3 0.201171f
Cred_25720 vin4.P28.GatPoly vout4.P6.nSD 0.000117007f
Cred_25721 vin4.P28.GatPoly vout4.P6.pSD 0.0032321f
Cred_25722 vin4.P28.GatPoly vout4.P8.pSD 0.120471f
Cred_25723 vin4.P29.GatPoly vout4.$1292.Metal3 0.20119f
Cred_25724 vin4.P29.GatPoly vout4.$1358.Metal3 0.00715313f
Cred_25725 vin4.P29.GatPoly vout4.P10.nSD 0.000112691f
Cred_25726 vin4.P29.GatPoly vout4.P10.pSD 0.00322922f
Cred_25727 vin4.P29.GatPoly vout4.P8.pSD 0.120733f
Cred_25728 vin4.P3.GatPoly vout4.$1226.Metal3 0.0368429f
Cred_25729 vin4.P3.GatPoly vout4.P0.nSD 0.000489337f
Cred_25730 vin4.P3.GatPoly vout4.P0.pSD 0.00260026f
Cred_25731 vin4.P3.GatPoly vout4.P2.nSD 0.0208402f
Cred_25732 vin4.P3.GatPoly vout4.P2.pSD 0.00290933f
Cred_25733 vin4.P3.GatPoly vout4.P4.nSD 3.18635e-05f
Cred_25734 vin4.P3.GatPoly VSS.$2544.Metal2 0.000510647f
Cred_25735 vin4.P3.GatPoly VSS.$2576.Metal2 0.000685726f
Cred_25736 vin4.P3.GatPoly VSS.$2632.Metal2 6.29324e-06f
Cred_25737 vin4.P3.GatPoly VSS.$2680.Metal2 0.00670696f
Cred_25738 vin4.P3.GatPoly VSS.$2739.Metal2 0.0114078f
Cred_25739 vin4.P3.GatPoly VSS.$2771.Metal2 0.00390469f
Cred_25740 vin4.P3.GatPoly VSS.$387.Metal1 9.06084e-05f
Cred_25741 vin4.P3.GatPoly VSS.$4520.Metal3 0.000393237f
Cred_25742 vin4.P3.GatPoly VSS.$4568.Metal3 0.00490799f
Cred_25743 vin4.P3.GatPoly VSS.$513.Metal1 0.00459092f
Cred_25744 vin4.P3.GatPoly VSS.$553.Metal1 0.01338f
Cred_25745 vin4.P3.GatPoly VSS.$566.Metal1 0.0494072f
Cred_25746 vin4.P3.GatPoly VSS.P0.pSD 1.17745e-05f
Cred_25747 vin4.P3.GatPoly VSS.P3.nSD 3.10923e-06f
Cred_25748 vin4.P3.GatPoly VSS.P5.nSD 0.00151919f
Cred_25749 vin4.P30.GatPoly vout4.$1292.Metal3 0.107309f
Cred_25750 vin4.P30.GatPoly vout4.$1358.Metal3 0.0916983f
Cred_25751 vin4.P30.GatPoly vout4.P10.nSD 0.00144462f
Cred_25752 vin4.P30.GatPoly vout4.P10.pSD 0.129374f
Cred_25753 vin4.P30.GatPoly vout4.P8.pSD 0.00259263f
Cred_25754 vin4.P31.GatPoly vout4.$1292.Metal3 0.0918383f
Cred_25755 vin4.P31.GatPoly vout4.$1358.Metal3 0.106868f
Cred_25756 vin4.P31.GatPoly vout4.P10.nSD 0.00144683f
Cred_25757 vin4.P31.GatPoly vout4.P10.pSD 0.129647f
Cred_25758 vin4.P31.GatPoly vout4.P12.pSD 0.00261888f
Cred_25759 vin4.P32.GatPoly vout4.$1292.Metal3 0.00763443f
Cred_25760 vin4.P32.GatPoly vout4.$1358.Metal3 0.209225f
Cred_25761 vin4.P32.GatPoly vout4.P10.nSD 0.000120273f
Cred_25762 vin4.P32.GatPoly vout4.P10.pSD 0.00334719f
Cred_25763 vin4.P32.GatPoly vout4.P12.pSD 0.127294f
Cred_25764 vin4.P33.GatPoly vout4.$1358.Metal3 0.200113f
Cred_25765 vin4.P33.GatPoly vout4.$1424.Metal3 0.00715313f
Cred_25766 vin4.P33.GatPoly vout4.P12.pSD 0.12181f
Cred_25767 vin4.P33.GatPoly vout4.P14.nSD 0.000112691f
Cred_25768 vin4.P33.GatPoly vout4.P14.pSD 0.00322922f
Cred_25769 vin4.P34.GatPoly vout4.$1358.Metal3 0.106868f
Cred_25770 vin4.P34.GatPoly vout4.$1424.Metal3 0.0918383f
Cred_25771 vin4.P34.GatPoly vout4.P12.pSD 0.00261888f
Cred_25772 vin4.P34.GatPoly vout4.P14.nSD 0.00144683f
Cred_25773 vin4.P34.GatPoly vout4.P14.pSD 0.129647f
Cred_25774 vin4.P35.GatPoly vout4.$1358.Metal3 0.0958543f
Cred_25775 vin4.P35.GatPoly vout4.$1424.Metal3 0.111841f
Cred_25776 vin4.P35.GatPoly vout4.P14.nSD 0.00151009f
Cred_25777 vin4.P35.GatPoly vout4.P14.pSD 0.13538f
Cred_25778 vin4.P35.GatPoly vout4.P16.pSD 0.00269169f
Cred_25779 vin4.P36.GatPoly vout4.$1358.Metal3 0.00715313f
Cred_25780 vin4.P36.GatPoly vout4.$1424.Metal3 0.200603f
Cred_25781 vin4.P36.GatPoly vout4.P14.nSD 0.000112691f
Cred_25782 vin4.P36.GatPoly vout4.P14.pSD 0.00322922f
Cred_25783 vin4.P36.GatPoly vout4.P16.pSD 0.122248f
Cred_25784 vin4.P37.GatPoly vout4 0.0022934f
Cred_25785 vin4.P37.GatPoly vout4.$1424.Metal3 0.204526f
Cred_25786 vin4.P37.GatPoly vout4.P16.pSD 0.12181f
Cred_25787 vin4.P37.GatPoly vout4.P18.nSD 0.000182223f
Cred_25788 vin4.P37.GatPoly vout4.P18.pSD 0.00360581f
Cred_25789 vin4.P38.GatPoly vout4 0.0298642f
Cred_25790 vin4.P38.GatPoly vout4.$1424.Metal3 0.165649f
Cred_25791 vin4.P38.GatPoly vout4.P16.pSD 0.00261888f
Cred_25792 vin4.P38.GatPoly vout4.P18.nSD 0.00237287f
Cred_25793 vin4.P38.GatPoly vout4.P18.pSD 0.13649f
Cred_25794 vin4.P39.GatPoly vout4 0.0348568f
Cred_25795 vin4.P39.GatPoly vout4.$1424.Metal3 0.175799f
Cred_25796 vin4.P39.GatPoly vout4.P18.nSD 0.00276955f
Cred_25797 vin4.P39.GatPoly vout4.P18.pSD 0.155155f
Cred_25798 vin4.P39.GatPoly VSS.$4152.Metal2 0.000431311f
Cred_25799 vin4.P4.GatPoly vout4.$1226.Metal3 0.0471178f
Cred_25800 vin4.P4.GatPoly vout4.P0.nSD 4.53065e-05f
Cred_25801 vin4.P4.GatPoly vout4.P0.pSD 0.000240751f
Cred_25802 vin4.P4.GatPoly vout4.P2.nSD 8.75338e-05f
Cred_25803 vin4.P4.GatPoly vout4.P2.pSD 0.000269368f
Cred_25804 vin4.P4.GatPoly vout4.P4.nSD 0.0222123f
Cred_25805 vin4.P4.GatPoly VSS.$1991.Metal1 2.93716e-07f
Cred_25806 vin4.P4.GatPoly VSS.$2023.Metal1 7.35405e-07f
Cred_25807 vin4.P4.GatPoly VSS.$2739.Metal2 0.00951892f
Cred_25808 vin4.P4.GatPoly VSS.$2771.Metal2 0.00617807f
Cred_25809 vin4.P4.GatPoly VSS.$2795.Metal2 0.00676466f
Cred_25810 vin4.P4.GatPoly VSS.$2843.Metal2 0.00100845f
Cred_25811 vin4.P4.GatPoly VSS.$2926.Metal2 0.00114923f
Cred_25812 vin4.P4.GatPoly VSS.$2958.Metal2 4.36418e-05f
Cred_25813 vin4.P4.GatPoly VSS.$4241.Metal2 1.96889e-09f
Cred_25814 vin4.P4.GatPoly VSS.$4568.Metal3 0.00154919f
Cred_25815 vin4.P4.GatPoly VSS.$4616.Metal3 0.00341116f
Cred_25816 vin4.P4.GatPoly VSS.$566.Metal1 0.0577786f
Cred_25817 vin4.P4.GatPoly VSS.$66.Metal1 5.00449e-05f
Cred_25818 vin4.P4.GatPoly VSS.$672.Metal1 0.0129289f
Cred_25819 vin4.P4.GatPoly VSS.$785.Metal1 9.66851e-05f
Cred_25820 vin4.P4.GatPoly VSS.P0.pSD 0.000978975f
Cred_25821 vin4.P4.GatPoly VSS.P5.nSD 0.00161143f
Cred_25822 vin4.P4.GatPoly VSS.P7.nSD 5.29002e-07f
Cred_25823 vin4.P5.GatPoly vout4.$1226.Metal3 0.0417431f
Cred_25824 vin4.P5.GatPoly vout4.$1292.Metal3 0.00145233f
Cred_25825 vin4.P5.GatPoly vout4.P4.nSD 0.0202828f
Cred_25826 vin4.P5.GatPoly vout4.P6.nSD 5.47436e-05f
Cred_25827 vin4.P5.GatPoly vout4.P6.pSD 0.000125045f
Cred_25828 vin4.P5.GatPoly VSS.$2739.Metal2 0.000831872f
Cred_25829 vin4.P5.GatPoly VSS.$2771.Metal2 0.000364856f
Cred_25830 vin4.P5.GatPoly VSS.$2843.Metal2 4.30156e-05f
Cred_25831 vin4.P5.GatPoly VSS.$2867.Metal2 0.00751382f
Cred_25832 vin4.P5.GatPoly VSS.$2926.Metal2 0.0113649f
Cred_25833 vin4.P5.GatPoly VSS.$2958.Metal2 0.000358712f
Cred_25834 vin4.P5.GatPoly VSS.$4616.Metal3 0.000848036f
Cred_25835 vin4.P5.GatPoly VSS.$4652.Metal3 0.00443521f
Cred_25836 vin4.P5.GatPoly VSS.$566.Metal1 9.02649e-05f
Cred_25837 vin4.P5.GatPoly VSS.$672.Metal1 0.00433478f
Cred_25838 vin4.P5.GatPoly VSS.$740.Metal1 0.0154523f
Cred_25839 vin4.P5.GatPoly VSS.$785.Metal1 0.0513567f
Cred_25840 vin4.P5.GatPoly VSS.P0.pSD 2.14021e-05f
Cred_25841 vin4.P5.GatPoly VSS.P5.nSD 3.09744e-06f
Cred_25842 vin4.P5.GatPoly VSS.P7.nSD 0.000206383f
Cred_25843 vin4.P6.GatPoly vout4.$1226.Metal3 0.0236713f
Cred_25844 vin4.P6.GatPoly vout4.$1292.Metal3 0.0201949f
Cred_25845 vin4.P6.GatPoly vout4.P4.nSD 3.58385e-05f
Cred_25846 vin4.P6.GatPoly vout4.P6.nSD 0.0216827f
Cred_25847 vin4.P6.GatPoly vout4.P6.pSD 0.00173877f
Cred_25848 vin4.P6.GatPoly VSS.$1991.Metal1 2.68027e-07f
Cred_25849 vin4.P6.GatPoly VSS.$2023.Metal1 6.71086e-07f
Cred_25850 vin4.P6.GatPoly VSS.$2926.Metal2 0.00984987f
Cred_25851 vin4.P6.GatPoly VSS.$2958.Metal2 0.00668667f
Cred_25852 vin4.P6.GatPoly VSS.$3006.Metal2 0.00281966f
Cred_25853 vin4.P6.GatPoly VSS.$3078.Metal2 0.000277376f
Cred_25854 vin4.P6.GatPoly VSS.$3113.Metal2 0.00091972f
Cred_25855 vin4.P6.GatPoly VSS.$4241.Metal2 1.79669e-09f
Cred_25856 vin4.P6.GatPoly VSS.$4652.Metal3 0.000775961f
Cred_25857 vin4.P6.GatPoly VSS.$4688.Metal3 0.00440933f
Cred_25858 vin4.P6.GatPoly VSS.$66.Metal1 9.811e-06f
Cred_25859 vin4.P6.GatPoly VSS.$771.Metal1 0.00436754f
Cred_25860 vin4.P6.GatPoly VSS.$785.Metal1 0.0518631f
Cred_25861 vin4.P6.GatPoly VSS.$831.Metal1 0.0148789f
Cred_25862 vin4.P6.GatPoly VSS.$879.Metal1 0.00118965f
Cred_25863 vin4.P6.GatPoly VSS.$924.Metal1 8.99087e-05f
Cred_25864 vin4.P6.GatPoly VSS.P0.pSD 0.000426217f
Cred_25865 vin4.P6.GatPoly VSS.P10.nSD 3.08522e-06f
Cred_25866 vin4.P6.GatPoly VSS.P7.nSD 0.000209557f
Cred_25867 vin4.P7.GatPoly vout4.$1226.Metal3 0.0202598f
Cred_25868 vin4.P7.GatPoly vout4.$1292.Metal3 0.0238867f
Cred_25869 vin4.P7.GatPoly vout4.P6.nSD 0.0215228f
Cred_25870 vin4.P7.GatPoly vout4.P6.pSD 0.00174436f
Cred_25871 vin4.P7.GatPoly vout4.P8.nSD 3.7248e-05f
Cred_25872 vin4.P7.GatPoly VSS.$1991.Metal1 3.53847e-07f
Cred_25873 vin4.P7.GatPoly VSS.$2023.Metal1 8.85961e-07f
Cred_25874 vin4.P7.GatPoly VSS.$2926.Metal2 0.00114923f
Cred_25875 vin4.P7.GatPoly VSS.$2958.Metal2 4.36418e-05f
Cred_25876 vin4.P7.GatPoly VSS.$3006.Metal2 0.00122955f
Cred_25877 vin4.P7.GatPoly VSS.$3054.Metal2 0.00699176f
Cred_25878 vin4.P7.GatPoly VSS.$3078.Metal2 0.00558505f
Cred_25879 vin4.P7.GatPoly VSS.$3113.Metal2 0.0104659f
Cred_25880 vin4.P7.GatPoly VSS.$4241.Metal2 2.37198e-09f
Cred_25881 vin4.P7.GatPoly VSS.$4712.Metal3 0.00336824f
Cred_25882 vin4.P7.GatPoly VSS.$4760.Metal3 0.00162593f
Cred_25883 vin4.P7.GatPoly VSS.$66.Metal1 8.21205e-06f
Cred_25884 vin4.P7.GatPoly VSS.$785.Metal1 9.66851e-05f
Cred_25885 vin4.P7.GatPoly VSS.$879.Metal1 0.0126797f
Cred_25886 vin4.P7.GatPoly VSS.$924.Metal1 0.0585185f
Cred_25887 vin4.P7.GatPoly VSS.P0.pSD 0.000465775f
Cred_25888 vin4.P7.GatPoly VSS.P10.nSD 0.0016222f
Cred_25889 vin4.P7.GatPoly VSS.P7.nSD 5.29002e-07f
Cred_25890 vin4.P8.GatPoly vout4.$1226.Metal3 0.00164772f
Cred_25891 vin4.P8.GatPoly vout4.$1292.Metal3 0.0439192f
Cred_25892 vin4.P8.GatPoly vout4.P6.nSD 6.16726e-05f
Cred_25893 vin4.P8.GatPoly vout4.P6.pSD 0.000141868f
Cred_25894 vin4.P8.GatPoly vout4.P8.nSD 0.0212328f
Cred_25895 vin4.P8.GatPoly VSS 9.06646e-05f
Cred_25896 vin4.P8.GatPoly VSS.$1038.Metal1 0.00413997f
Cred_25897 vin4.P8.GatPoly VSS.$3078.Metal2 0.00308089f
Cred_25898 vin4.P8.GatPoly VSS.$3113.Metal2 0.01257f
Cred_25899 vin4.P8.GatPoly VSS.$3169.Metal2 0.00692018f
Cred_25900 vin4.P8.GatPoly VSS.$3217.Metal2 7.37632e-06f
Cred_25901 vin4.P8.GatPoly VSS.$3276.Metal2 0.000598157f
Cred_25902 vin4.P8.GatPoly VSS.$3308.Metal2 0.000598157f
Cred_25903 vin4.P8.GatPoly VSS.$4760.Metal3 0.00482079f
Cred_25904 vin4.P8.GatPoly VSS.$4808.Metal3 0.000460914f
Cred_25905 vin4.P8.GatPoly VSS.$924.Metal1 0.0493503f
Cred_25906 vin4.P8.GatPoly VSS.$990.Metal1 0.0140247f
Cred_25907 vin4.P8.GatPoly VSS.P0.pSD 9.05855e-06f
Cred_25908 vin4.P8.GatPoly VSS.P10.nSD 0.00155611f
Cred_25909 vin4.P8.GatPoly VSS.P11.nSD 3.11116e-06f
Cred_25910 vin4.P9.GatPoly vout4.$1292.Metal3 0.0441732f
Cred_25911 vin4.P9.GatPoly vout4.$1358.Metal3 0.00170886f
Cred_25912 vin4.P9.GatPoly vout4.P10.nSD 6.38285e-05f
Cred_25913 vin4.P9.GatPoly vout4.P10.pSD 0.000145809f
Cred_25914 vin4.P9.GatPoly vout4.P8.nSD 0.0211729f
Cred_25915 vin4.P9.GatPoly VSS 0.0522523f
Cred_25916 vin4.P9.GatPoly VSS.$1038.Metal1 0.00331295f
Cred_25917 vin4.P9.GatPoly VSS.$1078.Metal1 0.0142989f
Cred_25918 vin4.P9.GatPoly VSS.$1991.Metal1 5.99462e-07f
Cred_25919 vin4.P9.GatPoly VSS.$2023.Metal1 1.50093e-06f
Cred_25920 vin4.P9.GatPoly VSS.$3078.Metal2 0.000277376f
Cred_25921 vin4.P9.GatPoly VSS.$3113.Metal2 0.00091972f
Cred_25922 vin4.P9.GatPoly VSS.$3217.Metal2 0.00597574f
Cred_25923 vin4.P9.GatPoly VSS.$3276.Metal2 0.00959261f
Cred_25924 vin4.P9.GatPoly VSS.$3308.Metal2 0.00677015f
Cred_25925 vin4.P9.GatPoly VSS.$4241.Metal2 4.01844e-09f
Cred_25926 vin4.P9.GatPoly VSS.$4808.Metal3 0.00390769f
Cred_25927 vin4.P9.GatPoly VSS.$66.Metal1 3.55239e-06f
Cred_25928 vin4.P9.GatPoly VSS.$924.Metal1 8.99087e-05f
Cred_25929 vin4.P9.GatPoly VSS.P0.pSD 0.000386181f
Cred_25930 vin4.P9.GatPoly VSS.P10.nSD 3.08522e-06f
Cred_25931 vin4.P9.GatPoly VSS.P11.nSD 0.00161135f
Cred_25932 vout1 VSS 0.135208f
Cred_25933 vout1 VSS.$1798.Metal1 0.00240463f
Cred_25934 vout1 VSS.$1869.Metal1 0.00028066f
Cred_25935 vout1 VSS.$1917.Metal1 0.00119602f
Cred_25936 vout1 VSS.$1977.Metal1 4.97681e-05f
Cred_25937 vout1 VSS.$1989.Metal1 0.00152863f
Cred_25938 vout1 VSS.$2020.Metal1 0.00609691f
Cred_25939 vout1 VSS.$29.Metal1 2.52183e-06f
Cred_25940 vout1 VSS.$3982.Metal2 0.00404105f
Cred_25941 vout1 VSS.$4014.Metal2 0.00301064f
Cred_25942 vout1 VSS.$4062.Metal2 0.000908986f
Cred_25943 vout1 VSS.$4110.Metal2 0.000554405f
Cred_25944 vout1 VSS.$4134.Metal2 4.4453e-06f
Cred_25945 vout1 VSS.$4195.Metal2 1.27156e-06f
Cred_25946 vout1 VSS.$4227.Metal2 0.0172824f
Cred_25947 vout1 VSS.$4251.Metal2 3.74901e-06f
Cred_25948 vout1 VSS.$5123.Metal3 0.000132446f
Cred_25949 vout1 VSS.$5159.Metal3 0.00113744f
Cred_25950 vout1 VSS.$5183.Metal3 0.00209884f
Cred_25951 vout1 VSS.$5219.Metal3 0.00106272f
Cred_25952 vout1 VSS.$5243.Metal3 0.000951156f
Cred_25953 vout1 VSS.$5279.Metal3 0.055872f
Cred_25954 vout1 VSS.$5282.Metal3 5.54424e-05f
Cred_25955 vout1 VSS.$5288.Metal3 2.46529e-08f
Cred_25956 vout1 VSS.P1.pSD 0.0104989f
Cred_25957 vout1 VSS.P3.GatPoly 0.000629903f
Cred_25958 vout1 VSS.P43.nSD 8.26499e-05f
Cred_25959 vout1 VSS.P45.nSD 1.10302e-05f
Cred_25960 vout1 VSS.P47.nSD 1.10302e-05f
Cred_25961 vout1.$1226.Metal3 VSS.$157.Metal1 0.00875304f
Cred_25962 vout1.$1226.Metal3 VSS.$1989.Metal1 8.27613e-06f
Cred_25963 vout1.$1226.Metal3 VSS.$2020.Metal1 2.07218e-05f
Cred_25964 vout1.$1226.Metal3 VSS.$2226.Metal2 0.0341062f
Cred_25965 vout1.$1226.Metal3 VSS.$2403.Metal2 9.06117e-06f
Cred_25966 vout1.$1226.Metal3 VSS.$2427.Metal2 0.00278813f
Cred_25967 vout1.$1226.Metal3 VSS.$2475.Metal2 0.00458873f
Cred_25968 vout1.$1226.Metal3 VSS.$2526.Metal2 0.0334789f
Cred_25969 vout1.$1226.Metal3 VSS.$2558.Metal2 0.0449507f
Cred_25970 vout1.$1226.Metal3 VSS.$257.Metal1 0.000251239f
Cred_25971 vout1.$1226.Metal3 VSS.$2614.Metal2 0.00437245f
Cred_25972 vout1.$1226.Metal3 VSS.$2662.Metal2 0.00379928f
Cred_25973 vout1.$1226.Metal3 VSS.$2721.Metal2 0.0651013f
Cred_25974 vout1.$1226.Metal3 VSS.$2753.Metal2 0.0285802f
Cred_25975 vout1.$1226.Metal3 VSS.$2777.Metal2 0.00192648f
Cred_25976 vout1.$1226.Metal3 VSS.$2825.Metal2 0.00757602f
Cred_25977 vout1.$1226.Metal3 VSS.$2849.Metal2 6.23475e-05f
Cred_25978 vout1.$1226.Metal3 VSS.$29.Metal1 0.00273333f
Cred_25979 vout1.$1226.Metal3 VSS.$2908.Metal2 0.0657654f
Cred_25980 vout1.$1226.Metal3 VSS.$2940.Metal2 0.00250881f
Cred_25981 vout1.$1226.Metal3 VSS.$2988.Metal2 0.00355674f
Cred_25982 vout1.$1226.Metal3 VSS.$3036.Metal2 0.00101031f
Cred_25983 vout1.$1226.Metal3 VSS.$3060.Metal2 0.00490519f
Cred_25984 vout1.$1226.Metal3 VSS.$3095.Metal2 0.0162244f
Cred_25985 vout1.$1226.Metal3 VSS.$317.Metal1 0.00603775f
Cred_25986 vout1.$1226.Metal3 VSS.$365.Metal1 0.00141682f
Cred_25987 vout1.$1226.Metal3 VSS.$385.Metal1 0.0257244f
Cred_25988 vout1.$1226.Metal3 VSS.$4227.Metal2 5.54782e-08f
Cred_25989 vout1.$1226.Metal3 VSS.$4415.Metal3 0.000868144f
Cred_25990 vout1.$1226.Metal3 VSS.$4451.Metal3 0.00927183f
Cred_25991 vout1.$1226.Metal3 VSS.$4475.Metal3 0.00622321f
Cred_25992 vout1.$1226.Metal3 VSS.$4511.Metal3 0.0107065f
Cred_25993 vout1.$1226.Metal3 VSS.$4559.Metal3 0.0119988f
Cred_25994 vout1.$1226.Metal3 VSS.$456.Metal1 0.000930393f
Cred_25995 vout1.$1226.Metal3 VSS.$4607.Metal3 0.0160831f
Cred_25996 vout1.$1226.Metal3 VSS.$4643.Metal3 0.00935134f
Cred_25997 vout1.$1226.Metal3 VSS.$4679.Metal3 0.00492856f
Cred_25998 vout1.$1226.Metal3 VSS.$4703.Metal3 0.00619596f
Cred_25999 vout1.$1226.Metal3 VSS.$4751.Metal3 0.000885582f
Cred_26000 vout1.$1226.Metal3 VSS.$504.Metal1 0.00711959f
Cred_26001 vout1.$1226.Metal3 VSS.$544.Metal1 0.00108062f
Cred_26002 vout1.$1226.Metal3 VSS.$564.Metal1 0.0294106f
Cred_26003 vout1.$1226.Metal3 VSS.$663.Metal1 0.00800819f
Cred_26004 vout1.$1226.Metal3 VSS.$731.Metal1 0.0026768f
Cred_26005 vout1.$1226.Metal3 VSS.$774.Metal1 0.0253105f
Cred_26006 vout1.$1226.Metal3 VSS.$822.Metal1 0.00142814f
Cred_26007 vout1.$1226.Metal3 VSS.$870.Metal1 0.00374972f
Cred_26008 vout1.$1226.Metal3 VSS.$922.Metal1 0.00747146f
Cred_26009 vout1.$1226.Metal3 VSS.P1.pSD 0.0262555f
Cred_26010 vout1.$1226.Metal3 VSS.P2.GatPoly 0.000934859f
Cred_26011 vout1.$1226.Metal3 VSS.P24.nSD 4.48919e-05f
Cred_26012 vout1.$1226.Metal3 VSS.P25.nSD 4.48919e-05f
Cred_26013 vout1.$1226.Metal3 VSS.P27.nSD 0.000884248f
Cred_26014 vout1.$1226.Metal3 VSS.P29.nSD 0.00100682f
Cred_26015 vout1.$1226.Metal3 VSS.P31.nSD 0.000139443f
Cred_26016 vout1.$1226.Metal3 VSS.P33.nSD 0.0002568f
Cred_26017 vout1.$1292.Metal3 VSS 0.0234977f
Cred_26018 vout1.$1292.Metal3 VSS.$1029.Metal1 0.00864164f
Cred_26019 vout1.$1292.Metal3 VSS.$1069.Metal1 0.00137119f
Cred_26020 vout1.$1292.Metal3 VSS.$1165.Metal1 0.000652614f
Cred_26021 vout1.$1292.Metal3 VSS.$1205.Metal1 0.00411295f
Cred_26022 vout1.$1292.Metal3 VSS.$1245.Metal1 0.000419648f
Cred_26023 vout1.$1292.Metal3 VSS.$1265.Metal1 0.00747422f
Cred_26024 vout1.$1292.Metal3 VSS.$1989.Metal1 2.75682e-05f
Cred_26025 vout1.$1292.Metal3 VSS.$2020.Metal1 6.90253e-05f
Cred_26026 vout1.$1292.Metal3 VSS.$29.Metal1 0.000208832f
Cred_26027 vout1.$1292.Metal3 VSS.$2908.Metal2 0.0239438f
Cred_26028 vout1.$1292.Metal3 VSS.$2940.Metal2 0.000917199f
Cred_26029 vout1.$1292.Metal3 VSS.$2988.Metal2 0.00355674f
Cred_26030 vout1.$1292.Metal3 VSS.$3036.Metal2 0.0010141f
Cred_26031 vout1.$1292.Metal3 VSS.$3060.Metal2 0.0169873f
Cred_26032 vout1.$1292.Metal3 VSS.$3095.Metal2 0.0562725f
Cred_26033 vout1.$1292.Metal3 VSS.$3151.Metal2 0.00412732f
Cred_26034 vout1.$1292.Metal3 VSS.$3199.Metal2 0.00563603f
Cred_26035 vout1.$1292.Metal3 VSS.$3250.Metal2 0.0345933f
Cred_26036 vout1.$1292.Metal3 VSS.$3282.Metal2 0.0345896f
Cred_26037 vout1.$1292.Metal3 VSS.$3338.Metal2 0.00268245f
Cred_26038 vout1.$1292.Metal3 VSS.$3386.Metal2 0.00196438f
Cred_26039 vout1.$1292.Metal3 VSS.$3445.Metal2 0.0162287f
Cred_26040 vout1.$1292.Metal3 VSS.$3477.Metal2 0.00489635f
Cred_26041 vout1.$1292.Metal3 VSS.$3501.Metal2 1.80083e-06f
Cred_26042 vout1.$1292.Metal3 VSS.$4227.Metal2 1.84801e-07f
Cred_26043 vout1.$1292.Metal3 VSS.$4643.Metal3 0.000797211f
Cred_26044 vout1.$1292.Metal3 VSS.$4679.Metal3 0.00446283f
Cred_26045 vout1.$1292.Metal3 VSS.$4703.Metal3 0.00666787f
Cred_26046 vout1.$1292.Metal3 VSS.$4751.Metal3 0.0133508f
Cred_26047 vout1.$1292.Metal3 VSS.$4799.Metal3 0.0135383f
Cred_26048 vout1.$1292.Metal3 VSS.$4835.Metal3 0.00711484f
Cred_26049 vout1.$1292.Metal3 VSS.$4883.Metal3 0.00593279f
Cred_26050 vout1.$1292.Metal3 VSS.$4931.Metal3 0.000224605f
Cred_26051 vout1.$1292.Metal3 VSS.$774.Metal1 0.00819691f
Cred_26052 vout1.$1292.Metal3 VSS.$822.Metal1 0.00142814f
Cred_26053 vout1.$1292.Metal3 VSS.$870.Metal1 0.00374972f
Cred_26054 vout1.$1292.Metal3 VSS.$922.Metal1 0.0229545f
Cred_26055 vout1.$1292.Metal3 VSS.$981.Metal1 0.000881713f
Cred_26056 vout1.$1292.Metal3 VSS.P1.pSD 0.0171991f
Cred_26057 vout1.$1292.Metal3 VSS.P31.nSD 4.4933e-05f
Cred_26058 vout1.$1292.Metal3 VSS.P33.nSD 0.000789078f
Cred_26059 vout1.$1292.Metal3 VSS.P35.nSD 0.000806486f
Cred_26060 vout1.$1292.Metal3 VSS.P37.nSD 0.000256895f
Cred_26061 vout1.$1358.Metal3 VSS 0.00750761f
Cred_26062 vout1.$1358.Metal3 VSS.$1165.Metal1 0.000652614f
Cred_26063 vout1.$1358.Metal3 VSS.$1205.Metal1 0.00411295f
Cred_26064 vout1.$1358.Metal3 VSS.$1245.Metal1 0.000419648f
Cred_26065 vout1.$1358.Metal3 VSS.$1265.Metal1 0.0232945f
Cred_26066 vout1.$1358.Metal3 VSS.$1364.Metal1 0.00788136f
Cred_26067 vout1.$1358.Metal3 VSS.$1412.Metal1 0.00300175f
Cred_26068 vout1.$1358.Metal3 VSS.$1466.Metal1 0.0252153f
Cred_26069 vout1.$1358.Metal3 VSS.$1503.Metal1 0.00127401f
Cred_26070 vout1.$1358.Metal3 VSS.$1571.Metal1 0.00381146f
Cred_26071 vout1.$1358.Metal3 VSS.$1623.Metal1 0.00753015f
Cred_26072 vout1.$1358.Metal3 VSS.$1989.Metal1 0.000116877f
Cred_26073 vout1.$1358.Metal3 VSS.$2020.Metal1 0.000292636f
Cred_26074 vout1.$1358.Metal3 VSS.$29.Metal1 5.29641e-05f
Cred_26075 vout1.$1358.Metal3 VSS.$3250.Metal2 0.0124009f
Cred_26076 vout1.$1358.Metal3 VSS.$3282.Metal2 0.0124042f
Cred_26077 vout1.$1358.Metal3 VSS.$3338.Metal2 0.00268245f
Cred_26078 vout1.$1358.Metal3 VSS.$3386.Metal2 0.00196438f
Cred_26079 vout1.$1358.Metal3 VSS.$3445.Metal2 0.0571041f
Cred_26080 vout1.$1358.Metal3 VSS.$3477.Metal2 0.0172493f
Cred_26081 vout1.$1358.Metal3 VSS.$3501.Metal2 0.00212533f
Cred_26082 vout1.$1358.Metal3 VSS.$3549.Metal2 0.00747574f
Cred_26083 vout1.$1358.Metal3 VSS.$3597.Metal2 0.00249183f
Cred_26084 vout1.$1358.Metal3 VSS.$3632.Metal2 0.0651354f
Cred_26085 vout1.$1358.Metal3 VSS.$3688.Metal2 2.9674e-05f
Cred_26086 vout1.$1358.Metal3 VSS.$3712.Metal2 0.00360577f
Cred_26087 vout1.$1358.Metal3 VSS.$3760.Metal2 0.00091524f
Cred_26088 vout1.$1358.Metal3 VSS.$3784.Metal2 0.00645074f
Cred_26089 vout1.$1358.Metal3 VSS.$3819.Metal2 0.014681f
Cred_26090 vout1.$1358.Metal3 VSS.$4227.Metal2 7.83473e-07f
Cred_26091 vout1.$1358.Metal3 VSS.$4799.Metal3 0.000413099f
Cred_26092 vout1.$1358.Metal3 VSS.$4835.Metal3 0.00624688f
Cred_26093 vout1.$1358.Metal3 VSS.$4883.Metal3 0.00779416f
Cred_26094 vout1.$1358.Metal3 VSS.$4931.Metal3 0.0132476f
Cred_26095 vout1.$1358.Metal3 VSS.$4955.Metal3 0.00960187f
Cred_26096 vout1.$1358.Metal3 VSS.$4991.Metal3 0.00574692f
Cred_26097 vout1.$1358.Metal3 VSS.$5027.Metal3 0.00744765f
Cred_26098 vout1.$1358.Metal3 VSS.$5075.Metal3 0.000908368f
Cred_26099 vout1.$1358.Metal3 VSS.P1.pSD 0.0175755f
Cred_26100 vout1.$1358.Metal3 VSS.P35.nSD 0.000257708f
Cred_26101 vout1.$1358.Metal3 VSS.P37.nSD 0.000799944f
Cred_26102 vout1.$1358.Metal3 VSS.P39.nSD 0.000139048f
Cred_26103 vout1.$1358.Metal3 VSS.P41.nSD 0.00025711f
Cred_26104 vout1.$1424.Metal3 VSS.$1466.Metal1 0.00810174f
Cred_26105 vout1.$1424.Metal3 VSS.$1503.Metal1 0.00127401f
Cred_26106 vout1.$1424.Metal3 VSS.$1571.Metal1 0.00381146f
Cred_26107 vout1.$1424.Metal3 VSS.$1623.Metal1 0.0231089f
Cred_26108 vout1.$1424.Metal3 VSS.$1690.Metal1 0.00128949f
Cred_26109 vout1.$1424.Metal3 VSS.$1730.Metal1 0.00849572f
Cred_26110 vout1.$1424.Metal3 VSS.$1778.Metal1 0.00111023f
Cred_26111 vout1.$1424.Metal3 VSS.$1798.Metal1 0.0276485f
Cred_26112 vout1.$1424.Metal3 VSS.$1869.Metal1 0.0014155f
Cred_26113 vout1.$1424.Metal3 VSS.$1917.Metal1 0.00603211f
Cred_26114 vout1.$1424.Metal3 VSS.$1977.Metal1 0.000251004f
Cred_26115 vout1.$1424.Metal3 VSS.$1989.Metal1 0.00381242f
Cred_26116 vout1.$1424.Metal3 VSS.$2020.Metal1 0.0209919f
Cred_26117 vout1.$1424.Metal3 VSS.$29.Metal1 2.14302e-05f
Cred_26118 vout1.$1424.Metal3 VSS.$3597.Metal2 0.000886752f
Cred_26119 vout1.$1424.Metal3 VSS.$3632.Metal2 0.0233079f
Cred_26120 vout1.$1424.Metal3 VSS.$3688.Metal2 2.9674e-05f
Cred_26121 vout1.$1424.Metal3 VSS.$3712.Metal2 0.00360577f
Cred_26122 vout1.$1424.Metal3 VSS.$3760.Metal2 0.000919402f
Cred_26123 vout1.$1424.Metal3 VSS.$3784.Metal2 0.0226613f
Cred_26124 vout1.$1424.Metal3 VSS.$3819.Metal2 0.0516346f
Cred_26125 vout1.$1424.Metal3 VSS.$3875.Metal2 0.00453363f
Cred_26126 vout1.$1424.Metal3 VSS.$3923.Metal2 0.00521759f
Cred_26127 vout1.$1424.Metal3 VSS.$3982.Metal2 0.0457973f
Cred_26128 vout1.$1424.Metal3 VSS.$4014.Metal2 0.034108f
Cred_26129 vout1.$1424.Metal3 VSS.$4062.Metal2 0.00458445f
Cred_26130 vout1.$1424.Metal3 VSS.$4110.Metal2 0.00279613f
Cred_26131 vout1.$1424.Metal3 VSS.$4134.Metal2 2.24198e-05f
Cred_26132 vout1.$1424.Metal3 VSS.$4195.Metal2 6.41308e-06f
Cred_26133 vout1.$1424.Metal3 VSS.$4227.Metal2 0.0871371f
Cred_26134 vout1.$1424.Metal3 VSS.$4251.Metal2 1.8908e-05f
Cred_26135 vout1.$1424.Metal3 VSS.$4955.Metal3 0.000221663f
Cred_26136 vout1.$1424.Metal3 VSS.$4991.Metal3 0.0040713f
Cred_26137 vout1.$1424.Metal3 VSS.$5027.Metal3 0.00796675f
Cred_26138 vout1.$1424.Metal3 VSS.$5075.Metal3 0.012949f
Cred_26139 vout1.$1424.Metal3 VSS.$5123.Metal3 0.0131551f
Cred_26140 vout1.$1424.Metal3 VSS.$5159.Metal3 0.00654111f
Cred_26141 vout1.$1424.Metal3 VSS.$5183.Metal3 0.0105855f
Cred_26142 vout1.$1424.Metal3 VSS.$5219.Metal3 0.0053598f
Cred_26143 vout1.$1424.Metal3 VSS.$5243.Metal3 0.00479713f
Cred_26144 vout1.$1424.Metal3 VSS.$5279.Metal3 0.026816f
Cred_26145 vout1.$1424.Metal3 VSS.P1.pSD 0.0457499f
Cred_26146 vout1.$1424.Metal3 VSS.P3.GatPoly 0.0031769f
Cred_26147 vout1.$1424.Metal3 VSS.P39.nSD 4.45375e-05f
Cred_26148 vout1.$1424.Metal3 VSS.P41.nSD 0.000792675f
Cred_26149 vout1.$1424.Metal3 VSS.P43.nSD 0.000949648f
Cred_26150 vout1.$1424.Metal3 VSS.P45.nSD 5.56306e-05f
Cred_26151 vout1.$1424.Metal3 VSS.P47.nSD 5.56306e-05f
Cred_26152 vout1.P0.nSD VSS.$157.Metal1 0.00782429f
Cred_26153 vout1.P0.nSD VSS.$1989.Metal1 3.51431e-08f
Cred_26154 vout1.P0.nSD VSS.$2020.Metal1 8.79912e-08f
Cred_26155 vout1.P0.nSD VSS.$2226.Metal2 0.00669665f
Cred_26156 vout1.P0.nSD VSS.$2403.Metal2 2.66139e-06f
Cred_26157 vout1.P0.nSD VSS.$2427.Metal2 0.00117928f
Cred_26158 vout1.P0.nSD VSS.$2475.Metal2 0.00194136f
Cred_26159 vout1.P0.nSD VSS.$2526.Metal2 0.00439121f
Cred_26160 vout1.P0.nSD VSS.$2558.Metal2 0.00589656f
Cred_26161 vout1.P0.nSD VSS.$257.Metal1 0.000274567f
Cred_26162 vout1.P0.nSD VSS.$2614.Metal2 6.33199e-05f
Cred_26163 vout1.P0.nSD VSS.$2662.Metal2 5.50195e-05f
Cred_26164 vout1.P0.nSD VSS.$2721.Metal2 0.000420836f
Cred_26165 vout1.P0.nSD VSS.$2753.Metal2 0.000184612f
Cred_26166 vout1.P0.nSD VSS.$2777.Metal2 5.05102e-08f
Cred_26167 vout1.P0.nSD VSS.$29.Metal1 5.70572e-05f
Cred_26168 vout1.P0.nSD VSS.$317.Metal1 0.00476631f
Cred_26169 vout1.P0.nSD VSS.$365.Metal1 0.0010383f
Cred_26170 vout1.P0.nSD VSS.$385.Metal1 0.0118033f
Cred_26171 vout1.P0.nSD VSS.$4227.Metal2 2.35578e-10f
Cred_26172 vout1.P0.nSD VSS.$4415.Metal3 4.56197e-05f
Cred_26173 vout1.P0.nSD VSS.$4451.Metal3 0.000493588f
Cred_26174 vout1.P0.nSD VSS.$4475.Metal3 0.000239325f
Cred_26175 vout1.P0.nSD VSS.$4511.Metal3 0.000179453f
Cred_26176 vout1.P0.nSD VSS.$4559.Metal3 0.000146123f
Cred_26177 vout1.P0.nSD VSS.$456.Metal1 1.34735e-05f
Cred_26178 vout1.P0.nSD VSS.$4607.Metal3 6.29978e-06f
Cred_26179 vout1.P0.nSD VSS.$504.Metal1 0.000103103f
Cred_26180 vout1.P0.nSD VSS.$544.Metal1 1.56491e-05f
Cred_26181 vout1.P0.nSD VSS.$564.Metal1 0.00018561f
Cred_26182 vout1.P0.nSD VSS.P1.pSD 0.000280167f
Cred_26183 vout1.P0.nSD VSS.P2.GatPoly 4.696e-05f
Cred_26184 vout1.P0.nSD VSS.P24.nSD 4.18236e-05f
Cred_26185 vout1.P0.nSD VSS.P25.nSD 4.18236e-05f
Cred_26186 vout1.P0.nSD VSS.P27.nSD 0.000405379f
Cred_26187 vout1.P0.nSD VSS.P29.nSD 6.37964e-06f
Cred_26188 vout1.P0.pSD VSS.$157.Metal1 0.00138499f
Cred_26189 vout1.P0.pSD VSS.$1989.Metal1 1.86745e-07f
Cred_26190 vout1.P0.pSD VSS.$2020.Metal1 4.67571e-07f
Cred_26191 vout1.P0.pSD VSS.$2226.Metal2 0.0053966f
Cred_26192 vout1.P0.pSD VSS.$2403.Metal2 1.43374e-06f
Cred_26193 vout1.P0.pSD VSS.$2427.Metal2 0.000441164f
Cred_26194 vout1.P0.pSD VSS.$2475.Metal2 0.000726072f
Cred_26195 vout1.P0.pSD VSS.$2526.Metal2 0.00398795f
Cred_26196 vout1.P0.pSD VSS.$2558.Metal2 0.00535418f
Cred_26197 vout1.P0.pSD VSS.$257.Metal1 3.97533e-05f
Cred_26198 vout1.P0.pSD VSS.$2614.Metal2 0.000336472f
Cred_26199 vout1.P0.pSD VSS.$2662.Metal2 0.000292364f
Cred_26200 vout1.P0.pSD VSS.$2721.Metal2 0.00223626f
Cred_26201 vout1.P0.pSD VSS.$2753.Metal2 0.000980996f
Cred_26202 vout1.P0.pSD VSS.$2777.Metal2 2.68403e-07f
Cred_26203 vout1.P0.pSD VSS.$29.Metal1 0.000303192f
Cred_26204 vout1.P0.pSD VSS.$317.Metal1 0.000955347f
Cred_26205 vout1.P0.pSD VSS.$365.Metal1 0.000224183f
Cred_26206 vout1.P0.pSD VSS.$385.Metal1 0.00304994f
Cred_26207 vout1.P0.pSD VSS.$4227.Metal2 1.25182e-09f
Cred_26208 vout1.P0.pSD VSS.$4415.Metal3 0.000137366f
Cred_26209 vout1.P0.pSD VSS.$4451.Metal3 0.00146707f
Cred_26210 vout1.P0.pSD VSS.$4475.Metal3 0.000984693f
Cred_26211 vout1.P0.pSD VSS.$4511.Metal3 0.000953582f
Cred_26212 vout1.P0.pSD VSS.$4559.Metal3 0.000776474f
Cred_26213 vout1.P0.pSD VSS.$456.Metal1 7.15962e-05f
Cred_26214 vout1.P0.pSD VSS.$4607.Metal3 3.3476e-05f
Cred_26215 vout1.P0.pSD VSS.$504.Metal1 0.000547871f
Cred_26216 vout1.P0.pSD VSS.$544.Metal1 8.31566e-05f
Cred_26217 vout1.P0.pSD VSS.$564.Metal1 0.000986299f
Cred_26218 vout1.P0.pSD VSS.P1.pSD 0.00146586f
Cred_26219 vout1.P0.pSD VSS.P2.GatPoly 0.000147922f
Cred_26220 vout1.P0.pSD VSS.P24.nSD 7.1032e-06f
Cred_26221 vout1.P0.pSD VSS.P25.nSD 7.1032e-06f
Cred_26222 vout1.P0.pSD VSS.P27.nSD 0.000104832f
Cred_26223 vout1.P0.pSD VSS.P29.nSD 3.39003e-05f
Cred_26224 vout1.P10.nSD VSS 0.0101413f
Cred_26225 vout1.P10.nSD VSS.$1165.Metal1 0.000756689f
Cred_26226 vout1.P10.nSD VSS.$1205.Metal1 0.00474861f
Cred_26227 vout1.P10.nSD VSS.$1245.Metal1 0.000483714f
Cred_26228 vout1.P10.nSD VSS.$1265.Metal1 0.0106057f
Cred_26229 vout1.P10.nSD VSS.$1989.Metal1 1.89326e-07f
Cred_26230 vout1.P10.nSD VSS.$2020.Metal1 4.74035e-07f
Cred_26231 vout1.P10.nSD VSS.$29.Metal1 3.57327e-07f
Cred_26232 vout1.P10.nSD VSS.$3250.Metal2 0.00404459f
Cred_26233 vout1.P10.nSD VSS.$3282.Metal2 0.00404464f
Cred_26234 vout1.P10.nSD VSS.$3338.Metal2 0.00168631f
Cred_26235 vout1.P10.nSD VSS.$3386.Metal2 0.00122639f
Cred_26236 vout1.P10.nSD VSS.$3445.Metal2 0.0061508f
Cred_26237 vout1.P10.nSD VSS.$3477.Metal2 0.00185504f
Cred_26238 vout1.P10.nSD VSS.$3501.Metal2 2.83704e-08f
Cred_26239 vout1.P10.nSD VSS.$4227.Metal2 1.26913e-09f
Cred_26240 vout1.P10.nSD VSS.$4799.Metal3 6.50798e-06f
Cred_26241 vout1.P10.nSD VSS.$4835.Metal3 0.000196229f
Cred_26242 vout1.P10.nSD VSS.$4883.Metal3 0.000181332f
Cred_26243 vout1.P10.nSD VSS.$4931.Metal3 3.53844e-06f
Cred_26244 vout1.P10.nSD VSS.P1.pSD 7.0402e-05f
Cred_26245 vout1.P10.nSD VSS.P35.nSD 0.000347636f
Cred_26246 vout1.P10.nSD VSS.P37.nSD 0.000364238f
Cred_26247 vout1.P10.pSD VSS 0.000640587f
Cred_26248 vout1.P10.pSD VSS.$1165.Metal1 5.56843e-05f
Cred_26249 vout1.P10.pSD VSS.$1205.Metal1 0.000350938f
Cred_26250 vout1.P10.pSD VSS.$1245.Metal1 3.58065e-05f
Cred_26251 vout1.P10.pSD VSS.$1265.Metal1 0.000637738f
Cred_26252 vout1.P10.pSD VSS.$1989.Metal1 1.0254e-06f
Cred_26253 vout1.P10.pSD VSS.$2020.Metal1 2.56741e-06f
Cred_26254 vout1.P10.pSD VSS.$29.Metal1 1.93531e-06f
Cred_26255 vout1.P10.pSD VSS.$3250.Metal2 0.00105811f
Cred_26256 vout1.P10.pSD VSS.$3282.Metal2 0.00105839f
Cred_26257 vout1.P10.pSD VSS.$3338.Metal2 0.00022888f
Cred_26258 vout1.P10.pSD VSS.$3386.Metal2 0.000167611f
Cred_26259 vout1.P10.pSD VSS.$3445.Metal2 0.00138472f
Cred_26260 vout1.P10.pSD VSS.$3477.Metal2 0.000417781f
Cred_26261 vout1.P10.pSD VSS.$3501.Metal2 1.53656e-07f
Cred_26262 vout1.P10.pSD VSS.$4227.Metal2 6.8737e-09f
Cred_26263 vout1.P10.pSD VSS.$4799.Metal3 3.52477e-05f
Cred_26264 vout1.P10.pSD VSS.$4835.Metal3 0.000533016f
Cred_26265 vout1.P10.pSD VSS.$4883.Metal3 0.000506216f
Cred_26266 vout1.P10.pSD VSS.$4931.Metal3 1.91644e-05f
Cred_26267 vout1.P10.pSD VSS.P1.pSD 0.000358699f
Cred_26268 vout1.P10.pSD VSS.P35.nSD 2.1989e-05f
Cred_26269 vout1.P10.pSD VSS.P37.nSD 2.19196e-05f
Cred_26270 vout1.P12.nSD VSS.$1265.Metal1 0.0100188f
Cred_26271 vout1.P12.nSD VSS.$1364.Metal1 0.00426979f
Cred_26272 vout1.P12.nSD VSS.$1412.Metal1 0.00163283f
Cred_26273 vout1.P12.nSD VSS.$1466.Metal1 0.0114595f
Cred_26274 vout1.P12.nSD VSS.$3445.Metal2 0.005925f
Cred_26275 vout1.P12.nSD VSS.$3477.Metal2 0.0017869f
Cred_26276 vout1.P12.nSD VSS.$3501.Metal2 0.000623845f
Cred_26277 vout1.P12.nSD VSS.$3549.Metal2 0.00222004f
Cred_26278 vout1.P12.nSD VSS.$3597.Metal2 0.000256048f
Cred_26279 vout1.P12.nSD VSS.$3632.Metal2 0.00674259f
Cred_26280 vout1.P12.nSD VSS.$4931.Metal3 0.000116547f
Cred_26281 vout1.P12.nSD VSS.$4955.Metal3 6.06927e-05f
Cred_26282 vout1.P12.nSD VSS.P1.pSD 3.83807e-06f
Cred_26283 vout1.P12.nSD VSS.P37.nSD 0.000343431f
Cred_26284 vout1.P12.nSD VSS.P39.nSD 6.29961e-05f
Cred_26285 vout1.P14.nSD VSS.$1466.Metal1 0.0110044f
Cred_26286 vout1.P14.nSD VSS.$1503.Metal1 0.00143608f
Cred_26287 vout1.P14.nSD VSS.$1571.Metal1 0.00447194f
Cred_26288 vout1.P14.nSD VSS.$1623.Metal1 0.0106935f
Cred_26289 vout1.P14.nSD VSS.$1989.Metal1 8.65575e-07f
Cred_26290 vout1.P14.nSD VSS.$2020.Metal1 2.16723e-06f
Cred_26291 vout1.P14.nSD VSS.$29.Metal1 9.87944e-08f
Cred_26292 vout1.P14.nSD VSS.$3597.Metal2 0.000275155f
Cred_26293 vout1.P14.nSD VSS.$3632.Metal2 0.00724505f
Cred_26294 vout1.P14.nSD VSS.$3688.Metal2 1.26477e-05f
Cred_26295 vout1.P14.nSD VSS.$3712.Metal2 0.00230297f
Cred_26296 vout1.P14.nSD VSS.$3760.Metal2 0.000579095f
Cred_26297 vout1.P14.nSD VSS.$3784.Metal2 0.00244074f
Cred_26298 vout1.P14.nSD VSS.$3819.Metal2 0.00556334f
Cred_26299 vout1.P14.nSD VSS.$4227.Metal2 5.8023e-09f
Cred_26300 vout1.P14.nSD VSS.$4955.Metal3 3.49209e-06f
Cred_26301 vout1.P14.nSD VSS.$4991.Metal3 0.000107941f
Cred_26302 vout1.P14.nSD VSS.$5027.Metal3 0.000255207f
Cred_26303 vout1.P14.nSD VSS.$5075.Metal3 1.43105e-05f
Cred_26304 vout1.P14.nSD VSS.P1.pSD 8.12896e-05f
Cred_26305 vout1.P14.nSD VSS.P39.nSD 6.00629e-05f
Cred_26306 vout1.P14.nSD VSS.P41.nSD 0.00036432f
Cred_26307 vout1.P14.pSD VSS.$1466.Metal1 0.000691282f
Cred_26308 vout1.P14.pSD VSS.$1503.Metal1 0.000108705f
Cred_26309 vout1.P14.pSD VSS.$1571.Metal1 0.000325213f
Cred_26310 vout1.P14.pSD VSS.$1623.Metal1 0.000642511f
Cred_26311 vout1.P14.pSD VSS.$1989.Metal1 4.68802e-06f
Cred_26312 vout1.P14.pSD VSS.$2020.Metal1 1.17378e-05f
Cred_26313 vout1.P14.pSD VSS.$29.Metal1 5.35077e-07f
Cred_26314 vout1.P14.pSD VSS.$3597.Metal2 7.56622e-05f
Cred_26315 vout1.P14.pSD VSS.$3632.Metal2 0.00198875f
Cred_26316 vout1.P14.pSD VSS.$3688.Metal2 2.53194e-06f
Cred_26317 vout1.P14.pSD VSS.$3712.Metal2 0.000307663f
Cred_26318 vout1.P14.pSD VSS.$3760.Metal2 7.8093e-05f
Cred_26319 vout1.P14.pSD VSS.$3784.Metal2 0.00055041f
Cred_26320 vout1.P14.pSD VSS.$3819.Metal2 0.00125265f
Cred_26321 vout1.P14.pSD VSS.$4227.Metal2 3.14257e-08f
Cred_26322 vout1.P14.pSD VSS.$4955.Metal3 1.89134e-05f
Cred_26323 vout1.P14.pSD VSS.$4991.Metal3 0.000347384f
Cred_26324 vout1.P14.pSD VSS.$5027.Metal3 0.000635471f
Cred_26325 vout1.P14.pSD VSS.$5075.Metal3 7.75066e-05f
Cred_26326 vout1.P14.pSD VSS.P1.pSD 0.000392703f
Cred_26327 vout1.P14.pSD VSS.P39.nSD 3.80016e-06f
Cred_26328 vout1.P14.pSD VSS.P41.nSD 2.1938e-05f
Cred_26329 vout1.P16.nSD VSS.$1623.Metal1 0.00981692f
Cred_26330 vout1.P16.nSD VSS.$1690.Metal1 0.000656678f
Cred_26331 vout1.P16.nSD VSS.$1730.Metal1 0.00466558f
Cred_26332 vout1.P16.nSD VSS.$1778.Metal1 0.000731436f
Cred_26333 vout1.P16.nSD VSS.$1798.Metal1 0.0103228f
Cred_26334 vout1.P16.nSD VSS.$3784.Metal2 0.00236728f
Cred_26335 vout1.P16.nSD VSS.$3819.Metal2 0.00539739f
Cred_26336 vout1.P16.nSD VSS.$3875.Metal2 0.00131867f
Cred_26337 vout1.P16.nSD VSS.$3923.Metal2 0.00152183f
Cred_26338 vout1.P16.nSD VSS.$3982.Metal2 0.00438658f
Cred_26339 vout1.P16.nSD VSS.$4014.Metal2 0.0032666f
Cred_26340 vout1.P16.nSD VSS.$5075.Metal3 9.05797e-05f
Cred_26341 vout1.P16.nSD VSS.$5123.Metal3 9.5102e-05f
Cred_26342 vout1.P16.nSD VSS.P1.pSD 4.10999e-06f
Cred_26343 vout1.P16.nSD VSS.P41.nSD 0.000337153f
Cred_26344 vout1.P16.nSD VSS.P43.nSD 0.000353982f
Cred_26345 vout1.P18.nSD VSS.$1798.Metal1 0.0106321f
Cred_26346 vout1.P18.nSD VSS.$1869.Metal1 0.00100668f
Cred_26347 vout1.P18.nSD VSS.$1917.Metal1 0.00463155f
Cred_26348 vout1.P18.nSD VSS.$1977.Metal1 0.000268959f
Cred_26349 vout1.P18.nSD VSS.$1989.Metal1 6.40083e-05f
Cred_26350 vout1.P18.nSD VSS.$2020.Metal1 0.00784467f
Cred_26351 vout1.P18.nSD VSS.$29.Metal1 1.48566e-07f
Cred_26352 vout1.P18.nSD VSS.$3982.Metal2 0.00502884f
Cred_26353 vout1.P18.nSD VSS.$4014.Metal2 0.00374499f
Cred_26354 vout1.P18.nSD VSS.$4062.Metal2 0.00183893f
Cred_26355 vout1.P18.nSD VSS.$4110.Metal2 0.00111721f
Cred_26356 vout1.P18.nSD VSS.$4134.Metal2 2.66973e-06f
Cred_26357 vout1.P18.nSD VSS.$4195.Metal2 1.79168e-07f
Cred_26358 vout1.P18.nSD VSS.$4227.Metal2 0.00706373f
Cred_26359 vout1.P18.nSD VSS.$4251.Metal2 5.28251e-07f
Cred_26360 vout1.P18.nSD VSS.$5123.Metal3 1.05235e-05f
Cred_26361 vout1.P18.nSD VSS.$5159.Metal3 0.000124745f
Cred_26362 vout1.P18.nSD VSS.$5183.Metal3 0.000307469f
Cred_26363 vout1.P18.nSD VSS.$5219.Metal3 0.000106762f
Cred_26364 vout1.P18.nSD VSS.$5243.Metal3 0.000134022f
Cred_26365 vout1.P18.nSD VSS.$5279.Metal3 0.000749183f
Cred_26366 vout1.P18.nSD VSS.P1.pSD 0.000552281f
Cred_26367 vout1.P18.nSD VSS.P3.GatPoly 7.51285e-05f
Cred_26368 vout1.P18.nSD VSS.P43.nSD 0.00036515f
Cred_26369 vout1.P18.nSD VSS.P45.nSD 4.10396e-05f
Cred_26370 vout1.P18.nSD VSS.P47.nSD 4.10396e-05f
Cred_26371 vout1.P18.pSD VSS.$1798.Metal1 0.0010348f
Cred_26372 vout1.P18.pSD VSS.$1869.Metal1 0.000120778f
Cred_26373 vout1.P18.pSD VSS.$1917.Metal1 0.00051469f
Cred_26374 vout1.P18.pSD VSS.$1977.Metal1 2.1417e-05f
Cred_26375 vout1.P18.pSD VSS.$1989.Metal1 0.000302452f
Cred_26376 vout1.P18.pSD VSS.$2020.Metal1 0.00173394f
Cred_26377 vout1.P18.pSD VSS.$29.Metal1 7.71985e-07f
Cred_26378 vout1.P18.pSD VSS.$3982.Metal2 0.00173901f
Cred_26379 vout1.P18.pSD VSS.$4014.Metal2 0.00129558f
Cred_26380 vout1.P18.pSD VSS.$4062.Metal2 0.000391169f
Cred_26381 vout1.P18.pSD VSS.$4110.Metal2 0.00023858f
Cred_26382 vout1.P18.pSD VSS.$4134.Metal2 1.91297e-06f
Cred_26383 vout1.P18.pSD VSS.$4195.Metal2 5.47197e-07f
Cred_26384 vout1.P18.pSD VSS.$4227.Metal2 0.00743483f
Cred_26385 vout1.P18.pSD VSS.$4251.Metal2 1.61333e-06f
Cred_26386 vout1.P18.pSD VSS.$5123.Metal3 5.69961e-05f
Cred_26387 vout1.P18.pSD VSS.$5159.Metal3 0.000489482f
Cred_26388 vout1.P18.pSD VSS.$5183.Metal3 0.000903207f
Cred_26389 vout1.P18.pSD VSS.$5219.Metal3 0.000457325f
Cred_26390 vout1.P18.pSD VSS.$5243.Metal3 0.000409316f
Cred_26391 vout1.P18.pSD VSS.$5279.Metal3 0.00228807f
Cred_26392 vout1.P18.pSD VSS.P1.pSD 0.00277939f
Cred_26393 vout1.P18.pSD VSS.P3.GatPoly 0.000271069f
Cred_26394 vout1.P18.pSD VSS.P43.nSD 3.55672e-05f
Cred_26395 vout1.P18.pSD VSS.P45.nSD 4.74669e-06f
Cred_26396 vout1.P18.pSD VSS.P47.nSD 4.74669e-06f
Cred_26397 vout1.P2.nSD VSS.$157.Metal1 0.000137896f
Cred_26398 vout1.P2.nSD VSS.$1989.Metal1 2.83901e-08f
Cred_26399 vout1.P2.nSD VSS.$2020.Metal1 7.10831e-08f
Cred_26400 vout1.P2.nSD VSS.$2226.Metal2 0.000537311f
Cred_26401 vout1.P2.nSD VSS.$2403.Metal2 1.4275e-07f
Cred_26402 vout1.P2.nSD VSS.$2427.Metal2 4.39244e-05f
Cred_26403 vout1.P2.nSD VSS.$2475.Metal2 7.22912e-05f
Cred_26404 vout1.P2.nSD VSS.$2526.Metal2 0.00384063f
Cred_26405 vout1.P2.nSD VSS.$2558.Metal2 0.00515731f
Cred_26406 vout1.P2.nSD VSS.$257.Metal1 3.95803e-06f
Cred_26407 vout1.P2.nSD VSS.$2614.Metal2 0.00159072f
Cred_26408 vout1.P2.nSD VSS.$2662.Metal2 0.00137853f
Cred_26409 vout1.P2.nSD VSS.$2721.Metal2 0.00575062f
Cred_26410 vout1.P2.nSD VSS.$2753.Metal2 0.00252224f
Cred_26411 vout1.P2.nSD VSS.$2777.Metal2 5.49486e-08f
Cred_26412 vout1.P2.nSD VSS.$29.Metal1 3.47304e-05f
Cred_26413 vout1.P2.nSD VSS.$317.Metal1 9.5119e-05f
Cred_26414 vout1.P2.nSD VSS.$365.Metal1 2.23207e-05f
Cred_26415 vout1.P2.nSD VSS.$385.Metal1 0.0102244f
Cred_26416 vout1.P2.nSD VSS.$4227.Metal2 1.9031e-10f
Cred_26417 vout1.P2.nSD VSS.$4415.Metal3 1.36768e-05f
Cred_26418 vout1.P2.nSD VSS.$4451.Metal3 0.000146069f
Cred_26419 vout1.P2.nSD VSS.$4475.Metal3 9.80408e-05f
Cred_26420 vout1.P2.nSD VSS.$4511.Metal3 0.000263772f
Cred_26421 vout1.P2.nSD VSS.$4559.Metal3 0.000249543f
Cred_26422 vout1.P2.nSD VSS.$456.Metal1 0.000746093f
Cred_26423 vout1.P2.nSD VSS.$4607.Metal3 6.85334e-06f
Cred_26424 vout1.P2.nSD VSS.$504.Metal1 0.00477774f
Cred_26425 vout1.P2.nSD VSS.$544.Metal1 0.000673702f
Cred_26426 vout1.P2.nSD VSS.$564.Metal1 0.0100071f
Cred_26427 vout1.P2.nSD VSS.P1.pSD 0.000200273f
Cred_26428 vout1.P2.nSD VSS.P2.GatPoly 1.47278e-05f
Cred_26429 vout1.P2.nSD VSS.P24.nSD 7.07229e-07f
Cred_26430 vout1.P2.nSD VSS.P25.nSD 7.07229e-07f
Cred_26431 vout1.P2.nSD VSS.P27.nSD 0.00035116f
Cred_26432 vout1.P2.nSD VSS.P29.nSD 0.000343691f
Cred_26433 vout1.P2.pSD VSS.$157.Metal1 0.000753632f
Cred_26434 vout1.P2.pSD VSS.$1989.Metal1 1.55158e-07f
Cred_26435 vout1.P2.pSD VSS.$2020.Metal1 3.88485e-07f
Cred_26436 vout1.P2.pSD VSS.$2226.Metal2 0.00293653f
Cred_26437 vout1.P2.pSD VSS.$2403.Metal2 7.80163e-07f
Cred_26438 vout1.P2.pSD VSS.$2427.Metal2 0.000240057f
Cred_26439 vout1.P2.pSD VSS.$2475.Metal2 0.000395088f
Cred_26440 vout1.P2.pSD VSS.$2526.Metal2 0.00288252f
Cred_26441 vout1.P2.pSD VSS.$2558.Metal2 0.00387023f
Cred_26442 vout1.P2.pSD VSS.$257.Metal1 2.16316e-05f
Cred_26443 vout1.P2.pSD VSS.$2614.Metal2 0.000376466f
Cred_26444 vout1.P2.pSD VSS.$2662.Metal2 0.000327116f
Cred_26445 vout1.P2.pSD VSS.$2721.Metal2 0.00250207f
Cred_26446 vout1.P2.pSD VSS.$2753.Metal2 0.0010976f
Cred_26447 vout1.P2.pSD VSS.$2777.Metal2 3.00306e-07f
Cred_26448 vout1.P2.pSD VSS.$29.Metal1 0.00018981f
Cred_26449 vout1.P2.pSD VSS.$317.Metal1 0.000519847f
Cred_26450 vout1.P2.pSD VSS.$365.Metal1 0.000121988f
Cred_26451 vout1.P2.pSD VSS.$385.Metal1 0.00221486f
Cred_26452 vout1.P2.pSD VSS.$4227.Metal2 1.04009e-09f
Cred_26453 vout1.P2.pSD VSS.$4415.Metal3 7.47468e-05f
Cred_26454 vout1.P2.pSD VSS.$4451.Metal3 0.000798301f
Cred_26455 vout1.P2.pSD VSS.$4475.Metal3 0.000535816f
Cred_26456 vout1.P2.pSD VSS.$4511.Metal3 0.000921822f
Cred_26457 vout1.P2.pSD VSS.$4559.Metal3 0.000868769f
Cred_26458 vout1.P2.pSD VSS.$456.Metal1 8.01064e-05f
Cred_26459 vout1.P2.pSD VSS.$4607.Metal3 3.74551e-05f
Cred_26460 vout1.P2.pSD VSS.$504.Metal1 0.000612994f
Cred_26461 vout1.P2.pSD VSS.$544.Metal1 9.3041e-05f
Cred_26462 vout1.P2.pSD VSS.$564.Metal1 0.00110353f
Cred_26463 vout1.P2.pSD VSS.P1.pSD 0.00107208f
Cred_26464 vout1.P2.pSD VSS.P2.GatPoly 8.0491e-05f
Cred_26465 vout1.P2.pSD VSS.P24.nSD 3.86517e-06f
Cred_26466 vout1.P2.pSD VSS.P25.nSD 3.86517e-06f
Cred_26467 vout1.P2.pSD VSS.P27.nSD 7.61333e-05f
Cred_26468 vout1.P2.pSD VSS.P29.nSD 3.79299e-05f
Cred_26469 vout1.P4.nSD VSS.$2721.Metal2 0.00544458f
Cred_26470 vout1.P4.nSD VSS.$2753.Metal2 0.00238847f
Cred_26471 vout1.P4.nSD VSS.$2777.Metal2 0.000564676f
Cred_26472 vout1.P4.nSD VSS.$2825.Metal2 0.00224617f
Cred_26473 vout1.P4.nSD VSS.$2849.Metal2 1.21802e-05f
Cred_26474 vout1.P4.nSD VSS.$2908.Metal2 0.00674259f
Cred_26475 vout1.P4.nSD VSS.$2940.Metal2 0.000256048f
Cred_26476 vout1.P4.nSD VSS.$4607.Metal3 0.000137876f
Cred_26477 vout1.P4.nSD VSS.$4643.Metal3 4.38017e-05f
Cred_26478 vout1.P4.nSD VSS.$564.Metal1 0.0107272f
Cred_26479 vout1.P4.nSD VSS.$663.Metal1 0.0044119f
Cred_26480 vout1.P4.nSD VSS.$731.Metal1 0.00141601f
Cred_26481 vout1.P4.nSD VSS.$774.Metal1 0.0114595f
Cred_26482 vout1.P4.nSD VSS.P1.pSD 8.78263e-06f
Cred_26483 vout1.P4.nSD VSS.P29.nSD 0.000365061f
Cred_26484 vout1.P4.nSD VSS.P31.nSD 6.29961e-05f
Cred_26485 vout1.P6.nSD VSS.$1989.Metal1 4.73697e-08f
Cred_26486 vout1.P6.nSD VSS.$2020.Metal1 1.18604e-07f
Cred_26487 vout1.P6.nSD VSS.$29.Metal1 1.42139e-06f
Cred_26488 vout1.P6.nSD VSS.$2908.Metal2 0.00718682f
Cred_26489 vout1.P6.nSD VSS.$2940.Metal2 0.000273042f
Cred_26490 vout1.P6.nSD VSS.$2988.Metal2 0.00227607f
Cred_26491 vout1.P6.nSD VSS.$3036.Metal2 0.000639761f
Cred_26492 vout1.P6.nSD VSS.$3060.Metal2 0.00185517f
Cred_26493 vout1.P6.nSD VSS.$3095.Metal2 0.00615073f
Cred_26494 vout1.P6.nSD VSS.$4227.Metal2 3.17538e-10f
Cred_26495 vout1.P6.nSD VSS.$4643.Metal3 1.25593e-05f
Cred_26496 vout1.P6.nSD VSS.$4679.Metal3 0.000131f
Cred_26497 vout1.P6.nSD VSS.$4703.Metal3 0.000214159f
Cred_26498 vout1.P6.nSD VSS.$4751.Metal3 1.39515e-05f
Cred_26499 vout1.P6.nSD VSS.$774.Metal1 0.0110755f
Cred_26500 vout1.P6.nSD VSS.$822.Metal1 0.00165533f
Cred_26501 vout1.P6.nSD VSS.$870.Metal1 0.00432886f
Cred_26502 vout1.P6.nSD VSS.$922.Metal1 0.0106057f
Cred_26503 vout1.P6.nSD VSS.P1.pSD 6.94716e-05f
Cred_26504 vout1.P6.nSD VSS.P31.nSD 6.02365e-05f
Cred_26505 vout1.P6.nSD VSS.P33.nSD 0.000364237f
Cred_26506 vout1.P6.pSD VSS.$1989.Metal1 2.58886e-07f
Cred_26507 vout1.P6.pSD VSS.$2020.Metal1 6.48199e-07f
Cred_26508 vout1.P6.pSD VSS.$29.Metal1 7.7682e-06f
Cred_26509 vout1.P6.pSD VSS.$2908.Metal2 0.00206155f
Cred_26510 vout1.P6.pSD VSS.$2940.Metal2 7.89704e-05f
Cred_26511 vout1.P6.pSD VSS.$2988.Metal2 0.000306234f
Cred_26512 vout1.P6.pSD VSS.$3036.Metal2 8.69874e-05f
Cred_26513 vout1.P6.pSD VSS.$3060.Metal2 0.000422334f
Cred_26514 vout1.P6.pSD VSS.$3095.Metal2 0.00139691f
Cred_26515 vout1.P6.pSD VSS.$4227.Metal2 1.73542e-09f
Cred_26516 vout1.P6.pSD VSS.$4643.Metal3 6.86395e-05f
Cred_26517 vout1.P6.pSD VSS.$4679.Metal3 0.000384247f
Cred_26518 vout1.P6.pSD VSS.$4703.Metal3 0.000533469f
Cred_26519 vout1.P6.pSD VSS.$4751.Metal3 7.62482e-05f
Cred_26520 vout1.P6.pSD VSS.$774.Metal1 0.00070575f
Cred_26521 vout1.P6.pSD VSS.$822.Metal1 0.000122962f
Cred_26522 vout1.P6.pSD VSS.$870.Metal1 0.000322849f
Cred_26523 vout1.P6.pSD VSS.$922.Metal1 0.00064329f
Cred_26524 vout1.P6.pSD VSS.P1.pSD 0.000358702f
Cred_26525 vout1.P6.pSD VSS.P31.nSD 3.86871e-06f
Cred_26526 vout1.P6.pSD VSS.P33.nSD 2.21104e-05f
Cred_26527 vout1.P8.nSD VSS 0.0107023f
Cred_26528 vout1.P8.nSD VSS.$1029.Metal1 0.00468381f
Cred_26529 vout1.P8.nSD VSS.$1069.Metal1 0.000746408f
Cred_26530 vout1.P8.nSD VSS.$3060.Metal2 0.0017813f
Cred_26531 vout1.P8.nSD VSS.$3095.Metal2 0.00590641f
Cred_26532 vout1.P8.nSD VSS.$3151.Metal2 0.00119544f
Cred_26533 vout1.P8.nSD VSS.$3199.Metal2 0.00164405f
Cred_26534 vout1.P8.nSD VSS.$3250.Metal2 0.00384189f
Cred_26535 vout1.P8.nSD VSS.$3282.Metal2 0.00384189f
Cred_26536 vout1.P8.nSD VSS.$4751.Metal3 8.78663e-05f
Cred_26537 vout1.P8.nSD VSS.$4799.Metal3 9.78154e-05f
Cred_26538 vout1.P8.nSD VSS.$922.Metal1 0.00980864f
Cred_26539 vout1.P8.nSD VSS.$981.Metal1 0.000477103f
Cred_26540 vout1.P8.nSD VSS.P1.pSD 4.17331e-06f
Cred_26541 vout1.P8.nSD VSS.P33.nSD 0.000336869f
Cred_26542 vout1.P8.nSD VSS.P35.nSD 0.000366899f
Cred_26543 vout2 VSS 0.137478f
Cred_26544 vout2 VSS.$1799.Metal1 0.00240463f
Cred_26545 vout2 VSS.$1884.Metal1 0.000233319f
Cred_26546 vout2 VSS.$1912.Metal1 0.00107758f
Cred_26547 vout2 VSS.$1932.Metal1 0.000218361f
Cred_26548 vout2 VSS.$1990.Metal1 0.00421169f
Cred_26549 vout2 VSS.$2021.Metal1 0.00224316f
Cred_26550 vout2 VSS.$3988.Metal2 0.00404105f
Cred_26551 vout2 VSS.$4020.Metal2 0.00301064f
Cred_26552 vout2 VSS.$4068.Metal2 0.000908188f
Cred_26553 vout2 VSS.$4116.Metal2 0.000553571f
Cred_26554 vout2 VSS.$4140.Metal2 4.02919e-06f
Cred_26555 vout2 VSS.$4164.Metal2 0.0172954f
Cred_26556 vout2 VSS.$5126.Metal3 0.000132446f
Cred_26557 vout2 VSS.$5162.Metal3 0.00113744f
Cred_26558 vout2 VSS.$5186.Metal3 0.00209884f
Cred_26559 vout2 VSS.$5222.Metal3 0.000904126f
Cred_26560 vout2 VSS.$5234.Metal3 0.000318457f
Cred_26561 vout2 VSS.$5246.Metal3 0.000397863f
Cred_26562 vout2 VSS.$5258.Metal3 0.000397863f
Cred_26563 vout2 VSS.$5270.Metal3 0.000397863f
Cred_26564 vout2 VSS.$5279.Metal3 5.37283e-05f
Cred_26565 vout2 VSS.$5282.Metal3 0.052127f
Cred_26566 vout2 VSS.$5288.Metal3 1.07557e-06f
Cred_26567 vout2 VSS.$68.Metal1 1.9072e-06f
Cred_26568 vout2 VSS.P2.pSD 1.42626e-07f
Cred_26569 vout2 VSS.P3.pSD 0.0116531f
Cred_26570 vout2 VSS.P67.nSD 2.60129e-07f
Cred_26571 vout2 VSS.P7.GatPoly 0.000629903f
Cred_26572 vout2 VSS.P91.nSD 8.23898e-05f
Cred_26573 vout2 VSS.P93.nSD 1.12935e-05f
Cred_26574 vout2 VSS.P95.nSD 1.12935e-05f
Cred_26575 vout2.$1226.Metal3 VSS.$158.Metal1 0.00869667f
Cred_26576 vout2.$1226.Metal3 VSS.$1990.Metal1 2.28562e-05f
Cred_26577 vout2.$1226.Metal3 VSS.$2228.Metal2 0.03416f
Cred_26578 vout2.$1226.Metal3 VSS.$2409.Metal2 6.96059e-06f
Cred_26579 vout2.$1226.Metal3 VSS.$2433.Metal2 0.00278392f
Cred_26580 vout2.$1226.Metal3 VSS.$2481.Metal2 0.0045847f
Cred_26581 vout2.$1226.Metal3 VSS.$2532.Metal2 0.0334809f
Cred_26582 vout2.$1226.Metal3 VSS.$2564.Metal2 0.0449534f
Cred_26583 vout2.$1226.Metal3 VSS.$2620.Metal2 0.00429162f
Cred_26584 vout2.$1226.Metal3 VSS.$2668.Metal2 0.00371453f
Cred_26585 vout2.$1226.Metal3 VSS.$2711.Metal2 0.0937864f
Cred_26586 vout2.$1226.Metal3 VSS.$2727.Metal2 7.08788e-06f
Cred_26587 vout2.$1226.Metal3 VSS.$2783.Metal2 0.00190622f
Cred_26588 vout2.$1226.Metal3 VSS.$2831.Metal2 0.00754049f
Cred_26589 vout2.$1226.Metal3 VSS.$2855.Metal2 3.99861e-05f
Cred_26590 vout2.$1226.Metal3 VSS.$2914.Metal2 0.0672216f
Cred_26591 vout2.$1226.Metal3 VSS.$2946.Metal2 0.00256411f
Cred_26592 vout2.$1226.Metal3 VSS.$2994.Metal2 0.00355346f
Cred_26593 vout2.$1226.Metal3 VSS.$3042.Metal2 0.00100321f
Cred_26594 vout2.$1226.Metal3 VSS.$3085.Metal2 0.0211424f
Cred_26595 vout2.$1226.Metal3 VSS.$312.Metal1 0.00110233f
Cred_26596 vout2.$1226.Metal3 VSS.$332.Metal1 0.00543982f
Cred_26597 vout2.$1226.Metal3 VSS.$360.Metal1 0.00117784f
Cred_26598 vout2.$1226.Metal3 VSS.$386.Metal1 0.0257815f
Cred_26599 vout2.$1226.Metal3 VSS.$4418.Metal3 0.000868144f
Cred_26600 vout2.$1226.Metal3 VSS.$4454.Metal3 0.00927183f
Cred_26601 vout2.$1226.Metal3 VSS.$4478.Metal3 0.00622321f
Cred_26602 vout2.$1226.Metal3 VSS.$4514.Metal3 0.00597424f
Cred_26603 vout2.$1226.Metal3 VSS.$4538.Metal3 0.00961622f
Cred_26604 vout2.$1226.Metal3 VSS.$4562.Metal3 0.00492304f
Cred_26605 vout2.$1226.Metal3 VSS.$4586.Metal3 0.00476246f
Cred_26606 vout2.$1226.Metal3 VSS.$4610.Metal3 0.0137395f
Cred_26607 vout2.$1226.Metal3 VSS.$4646.Metal3 0.00935134f
Cred_26608 vout2.$1226.Metal3 VSS.$4682.Metal3 0.00492856f
Cred_26609 vout2.$1226.Metal3 VSS.$4706.Metal3 0.00531038f
Cred_26610 vout2.$1226.Metal3 VSS.$471.Metal1 0.000358247f
Cred_26611 vout2.$1226.Metal3 VSS.$4730.Metal3 0.00179962f
Cred_26612 vout2.$1226.Metal3 VSS.$499.Metal1 0.00515037f
Cred_26613 vout2.$1226.Metal3 VSS.$519.Metal1 0.00364151f
Cred_26614 vout2.$1226.Metal3 VSS.$565.Metal1 0.0289951f
Cred_26615 vout2.$1226.Metal3 VSS.$658.Metal1 0.000673831f
Cred_26616 vout2.$1226.Metal3 VSS.$678.Metal1 0.00533005f
Cred_26617 vout2.$1226.Metal3 VSS.$68.Metal1 0.00198231f
Cred_26618 vout2.$1226.Metal3 VSS.$698.Metal1 0.00486162f
Cred_26619 vout2.$1226.Metal3 VSS.$744.Metal1 0.0231433f
Cred_26620 vout2.$1226.Metal3 VSS.$837.Metal1 0.00130646f
Cred_26621 vout2.$1226.Metal3 VSS.$865.Metal1 0.00387514f
Cred_26622 vout2.$1226.Metal3 VSS.$885.Metal1 1.29425e-06f
Cred_26623 vout2.$1226.Metal3 VSS.$923.Metal1 0.00743843f
Cred_26624 vout2.$1226.Metal3 VSS.P2.pSD 1.73756e-06f
Cred_26625 vout2.$1226.Metal3 VSS.P3.pSD 0.0269835f
Cred_26626 vout2.$1226.Metal3 VSS.P51.nSD 2.89366e-06f
Cred_26627 vout2.$1226.Metal3 VSS.P55.nSD 3.70921e-07f
Cred_26628 vout2.$1226.Metal3 VSS.P6.GatPoly 0.000934859f
Cred_26629 vout2.$1226.Metal3 VSS.P72.nSD 4.61504e-05f
Cred_26630 vout2.$1226.Metal3 VSS.P73.nSD 4.61504e-05f
Cred_26631 vout2.$1226.Metal3 VSS.P75.nSD 0.000883316f
Cred_26632 vout2.$1226.Metal3 VSS.P77.nSD 0.000996143f
Cred_26633 vout2.$1226.Metal3 VSS.P79.nSD 0.000794752f
Cred_26634 vout2.$1226.Metal3 VSS.P81.nSD 0.000255666f
Cred_26635 vout2.$1292.Metal3 VSS 0.0234977f
Cred_26636 vout2.$1292.Metal3 VSS.$1024.Metal1 0.00539748f
Cred_26637 vout2.$1292.Metal3 VSS.$1044.Metal1 0.00552315f
Cred_26638 vout2.$1292.Metal3 VSS.$1200.Metal1 0.00262872f
Cred_26639 vout2.$1292.Metal3 VSS.$1220.Metal1 0.00256891f
Cred_26640 vout2.$1292.Metal3 VSS.$1266.Metal1 0.00744117f
Cred_26641 vout2.$1292.Metal3 VSS.$1990.Metal1 7.59611e-05f
Cred_26642 vout2.$1292.Metal3 VSS.$2914.Metal2 0.0244154f
Cred_26643 vout2.$1292.Metal3 VSS.$2946.Metal2 0.000935108f
Cred_26644 vout2.$1292.Metal3 VSS.$2994.Metal2 0.00355346f
Cred_26645 vout2.$1292.Metal3 VSS.$3042.Metal2 0.00100321f
Cred_26646 vout2.$1292.Metal3 VSS.$3085.Metal2 0.0733379f
Cred_26647 vout2.$1292.Metal3 VSS.$3101.Metal2 7.68897e-06f
Cred_26648 vout2.$1292.Metal3 VSS.$3157.Metal2 0.00402533f
Cred_26649 vout2.$1292.Metal3 VSS.$3205.Metal2 0.00552995f
Cred_26650 vout2.$1292.Metal3 VSS.$3260.Metal2 0.0345933f
Cred_26651 vout2.$1292.Metal3 VSS.$3292.Metal2 0.0345896f
Cred_26652 vout2.$1292.Metal3 VSS.$3344.Metal2 0.00263196f
Cred_26653 vout2.$1292.Metal3 VSS.$3392.Metal2 0.00191584f
Cred_26654 vout2.$1292.Metal3 VSS.$3435.Metal2 0.0211502f
Cred_26655 vout2.$1292.Metal3 VSS.$3451.Metal2 3.65954e-06f
Cred_26656 vout2.$1292.Metal3 VSS.$4646.Metal3 0.000797211f
Cred_26657 vout2.$1292.Metal3 VSS.$4682.Metal3 0.00446283f
Cred_26658 vout2.$1292.Metal3 VSS.$4706.Metal3 0.00531038f
Cred_26659 vout2.$1292.Metal3 VSS.$4730.Metal3 0.00275861f
Cred_26660 vout2.$1292.Metal3 VSS.$4754.Metal3 0.00607902f
Cred_26661 vout2.$1292.Metal3 VSS.$4778.Metal3 0.0120183f
Cred_26662 vout2.$1292.Metal3 VSS.$4802.Metal3 0.00762396f
Cred_26663 vout2.$1292.Metal3 VSS.$4838.Metal3 0.00429993f
Cred_26664 vout2.$1292.Metal3 VSS.$4862.Metal3 0.00572008f
Cred_26665 vout2.$1292.Metal3 VSS.$4886.Metal3 0.00289329f
Cred_26666 vout2.$1292.Metal3 VSS.$4910.Metal3 0.000456428f
Cred_26667 vout2.$1292.Metal3 VSS.$68.Metal1 0.000151454f
Cred_26668 vout2.$1292.Metal3 VSS.$744.Metal1 0.00749505f
Cred_26669 vout2.$1292.Metal3 VSS.$837.Metal1 0.00130646f
Cred_26670 vout2.$1292.Metal3 VSS.$865.Metal1 0.00387514f
Cred_26671 vout2.$1292.Metal3 VSS.$885.Metal1 1.29425e-06f
Cred_26672 vout2.$1292.Metal3 VSS.$923.Metal1 0.0228399f
Cred_26673 vout2.$1292.Metal3 VSS.P2.pSD 7.98628e-07f
Cred_26674 vout2.$1292.Metal3 VSS.P3.pSD 0.0172634f
Cred_26675 vout2.$1292.Metal3 VSS.P55.nSD 1.34714e-07f
Cred_26676 vout2.$1292.Metal3 VSS.P59.nSD 2.60795e-06f
Cred_26677 vout2.$1292.Metal3 VSS.P79.nSD 0.000257143f
Cred_26678 vout2.$1292.Metal3 VSS.P81.nSD 0.000785145f
Cred_26679 vout2.$1292.Metal3 VSS.P83.nSD 0.000803878f
Cred_26680 vout2.$1292.Metal3 VSS.P85.nSD 0.000255761f
Cred_26681 vout2.$1358.Metal3 VSS 0.00750761f
Cred_26682 vout2.$1358.Metal3 VSS.$1200.Metal1 0.00262872f
Cred_26683 vout2.$1358.Metal3 VSS.$1220.Metal1 0.00256891f
Cred_26684 vout2.$1358.Metal3 VSS.$1266.Metal1 0.0231782f
Cred_26685 vout2.$1358.Metal3 VSS.$1359.Metal1 2.72033e-06f
Cred_26686 vout2.$1358.Metal3 VSS.$1379.Metal1 0.00814498f
Cred_26687 vout2.$1358.Metal3 VSS.$1407.Metal1 0.002746f
Cred_26688 vout2.$1358.Metal3 VSS.$1445.Metal1 0.0230563f
Cred_26689 vout2.$1358.Metal3 VSS.$1546.Metal1 0.00231387f
Cred_26690 vout2.$1358.Metal3 VSS.$1566.Metal1 0.00253681f
Cred_26691 vout2.$1358.Metal3 VSS.$1586.Metal1 0.000320707f
Cred_26692 vout2.$1358.Metal3 VSS.$1624.Metal1 0.00744117f
Cred_26693 vout2.$1358.Metal3 VSS.$1990.Metal1 0.000322024f
Cred_26694 vout2.$1358.Metal3 VSS.$3260.Metal2 0.0124009f
Cred_26695 vout2.$1358.Metal3 VSS.$3292.Metal2 0.0124042f
Cred_26696 vout2.$1358.Metal3 VSS.$3344.Metal2 0.00263196f
Cred_26697 vout2.$1358.Metal3 VSS.$3392.Metal2 0.00191584f
Cred_26698 vout2.$1358.Metal3 VSS.$3435.Metal2 0.0744197f
Cred_26699 vout2.$1358.Metal3 VSS.$3451.Metal2 3.65954e-06f
Cred_26700 vout2.$1358.Metal3 VSS.$3507.Metal2 0.00210861f
Cred_26701 vout2.$1358.Metal3 VSS.$3555.Metal2 0.00746885f
Cred_26702 vout2.$1358.Metal3 VSS.$3603.Metal2 0.00254692f
Cred_26703 vout2.$1358.Metal3 VSS.$3638.Metal2 0.0665862f
Cred_26704 vout2.$1358.Metal3 VSS.$3694.Metal2 1.90312e-05f
Cred_26705 vout2.$1358.Metal3 VSS.$3718.Metal2 0.00358886f
Cred_26706 vout2.$1358.Metal3 VSS.$3766.Metal2 0.000907258f
Cred_26707 vout2.$1358.Metal3 VSS.$3809.Metal2 0.0211502f
Cred_26708 vout2.$1358.Metal3 VSS.$4802.Metal3 0.000413099f
Cred_26709 vout2.$1358.Metal3 VSS.$4838.Metal3 0.00343198f
Cred_26710 vout2.$1358.Metal3 VSS.$4862.Metal3 0.00572008f
Cred_26711 vout2.$1358.Metal3 VSS.$4886.Metal3 0.00289329f
Cred_26712 vout2.$1358.Metal3 VSS.$4910.Metal3 0.00423897f
Cred_26713 vout2.$1358.Metal3 VSS.$4934.Metal3 0.0111616f
Cred_26714 vout2.$1358.Metal3 VSS.$4958.Metal3 0.00960187f
Cred_26715 vout2.$1358.Metal3 VSS.$4994.Metal3 0.00574692f
Cred_26716 vout2.$1358.Metal3 VSS.$5030.Metal3 0.00653928f
Cred_26717 vout2.$1358.Metal3 VSS.$5054.Metal3 0.00184593f
Cred_26718 vout2.$1358.Metal3 VSS.$68.Metal1 3.84174e-05f
Cred_26719 vout2.$1358.Metal3 VSS.P2.pSD 1.6786e-06f
Cred_26720 vout2.$1358.Metal3 VSS.P3.pSD 0.0176616f
Cred_26721 vout2.$1358.Metal3 VSS.P59.nSD 9.35106e-07f
Cred_26722 vout2.$1358.Metal3 VSS.P63.nSD 3.67396e-07f
Cred_26723 vout2.$1358.Metal3 VSS.P83.nSD 0.000256773f
Cred_26724 vout2.$1358.Metal3 VSS.P85.nSD 0.000795954f
Cred_26725 vout2.$1358.Metal3 VSS.P87.nSD 0.000791895f
Cred_26726 vout2.$1358.Metal3 VSS.P89.nSD 0.000255761f
Cred_26727 vout2.$1424.Metal3 VSS.$1445.Metal1 0.00740803f
Cred_26728 vout2.$1424.Metal3 VSS.$1546.Metal1 0.00231387f
Cred_26729 vout2.$1424.Metal3 VSS.$1566.Metal1 0.00253681f
Cred_26730 vout2.$1424.Metal3 VSS.$1586.Metal1 0.000320707f
Cred_26731 vout2.$1424.Metal3 VSS.$1624.Metal1 0.0229209f
Cred_26732 vout2.$1424.Metal3 VSS.$1725.Metal1 0.00434536f
Cred_26733 vout2.$1424.Metal3 VSS.$1745.Metal1 0.00614587f
Cred_26734 vout2.$1424.Metal3 VSS.$1773.Metal1 0.000427491f
Cred_26735 vout2.$1424.Metal3 VSS.$1799.Metal1 0.0276485f
Cred_26736 vout2.$1424.Metal3 VSS.$1884.Metal1 0.00117674f
Cred_26737 vout2.$1424.Metal3 VSS.$1912.Metal1 0.00543474f
Cred_26738 vout2.$1424.Metal3 VSS.$1932.Metal1 0.0011013f
Cred_26739 vout2.$1424.Metal3 VSS.$1990.Metal1 0.010504f
Cred_26740 vout2.$1424.Metal3 VSS.$2021.Metal1 0.0113133f
Cred_26741 vout2.$1424.Metal3 VSS.$3603.Metal2 0.000904453f
Cred_26742 vout2.$1424.Metal3 VSS.$3638.Metal2 0.023774f
Cred_26743 vout2.$1424.Metal3 VSS.$3694.Metal2 1.90312e-05f
Cred_26744 vout2.$1424.Metal3 VSS.$3718.Metal2 0.00358886f
Cred_26745 vout2.$1424.Metal3 VSS.$3766.Metal2 0.000907258f
Cred_26746 vout2.$1424.Metal3 VSS.$3809.Metal2 0.0743958f
Cred_26747 vout2.$1424.Metal3 VSS.$3825.Metal2 8.45788e-06f
Cred_26748 vout2.$1424.Metal3 VSS.$3881.Metal2 0.0044325f
Cred_26749 vout2.$1424.Metal3 VSS.$3929.Metal2 0.00512114f
Cred_26750 vout2.$1424.Metal3 VSS.$3988.Metal2 0.0457973f
Cred_26751 vout2.$1424.Metal3 VSS.$4020.Metal2 0.034108f
Cred_26752 vout2.$1424.Metal3 VSS.$4068.Metal2 0.00458042f
Cred_26753 vout2.$1424.Metal3 VSS.$4116.Metal2 0.00279192f
Cred_26754 vout2.$1424.Metal3 VSS.$4140.Metal2 2.03212e-05f
Cred_26755 vout2.$1424.Metal3 VSS.$4164.Metal2 0.0872292f
Cred_26756 vout2.$1424.Metal3 VSS.$4958.Metal3 0.000221663f
Cred_26757 vout2.$1424.Metal3 VSS.$4994.Metal3 0.0040713f
Cred_26758 vout2.$1424.Metal3 VSS.$5030.Metal3 0.00653928f
Cred_26759 vout2.$1424.Metal3 VSS.$5054.Metal3 0.00290082f
Cred_26760 vout2.$1424.Metal3 VSS.$5078.Metal3 0.0058746f
Cred_26761 vout2.$1424.Metal3 VSS.$5102.Metal3 0.0114749f
Cred_26762 vout2.$1424.Metal3 VSS.$5126.Metal3 0.00750822f
Cred_26763 vout2.$1424.Metal3 VSS.$5162.Metal3 0.00654111f
Cred_26764 vout2.$1424.Metal3 VSS.$5186.Metal3 0.0105855f
Cred_26765 vout2.$1424.Metal3 VSS.$5222.Metal3 0.00455994f
Cred_26766 vout2.$1424.Metal3 VSS.$5234.Metal3 0.00160613f
Cred_26767 vout2.$1424.Metal3 VSS.$5246.Metal3 0.00200661f
Cred_26768 vout2.$1424.Metal3 VSS.$5258.Metal3 0.00200661f
Cred_26769 vout2.$1424.Metal3 VSS.$5270.Metal3 0.00200661f
Cred_26770 vout2.$1424.Metal3 VSS.$5282.Metal3 0.0248253f
Cred_26771 vout2.$1424.Metal3 VSS.$68.Metal1 1.57372e-05f
Cred_26772 vout2.$1424.Metal3 VSS.P2.pSD 9.80574e-07f
Cred_26773 vout2.$1424.Metal3 VSS.P3.pSD 0.0486156f
Cred_26774 vout2.$1424.Metal3 VSS.P63.nSD 1.3119e-07f
Cred_26775 vout2.$1424.Metal3 VSS.P67.nSD 2.94764e-06f
Cred_26776 vout2.$1424.Metal3 VSS.P7.GatPoly 0.0031769f
Cred_26777 vout2.$1424.Metal3 VSS.P87.nSD 0.000254285f
Cred_26778 vout2.$1424.Metal3 VSS.P89.nSD 0.000787928f
Cred_26779 vout2.$1424.Metal3 VSS.P91.nSD 0.0009467f
Cred_26780 vout2.$1424.Metal3 VSS.P93.nSD 5.69585e-05f
Cred_26781 vout2.$1424.Metal3 VSS.P95.nSD 5.69585e-05f
Cred_26782 vout2.P0.nSD VSS.$158.Metal1 0.00780722f
Cred_26783 vout2.P0.nSD VSS.$1990.Metal1 9.79445e-08f
Cred_26784 vout2.P0.nSD VSS.$2228.Metal2 0.0067111f
Cred_26785 vout2.P0.nSD VSS.$2409.Metal2 3.65768e-07f
Cred_26786 vout2.P0.nSD VSS.$2433.Metal2 0.00117467f
Cred_26787 vout2.P0.nSD VSS.$2481.Metal2 0.00193838f
Cred_26788 vout2.P0.nSD VSS.$2532.Metal2 0.00436661f
Cred_26789 vout2.P0.nSD VSS.$2564.Metal2 0.00586353f
Cred_26790 vout2.P0.nSD VSS.$2620.Metal2 6.21494e-05f
Cred_26791 vout2.P0.nSD VSS.$2668.Metal2 5.37922e-05f
Cred_26792 vout2.P0.nSD VSS.$2711.Metal2 0.000607206f
Cred_26793 vout2.P0.nSD VSS.$2727.Metal2 1.02644e-07f
Cred_26794 vout2.P0.nSD VSS.$312.Metal1 0.00120282f
Cred_26795 vout2.P0.nSD VSS.$332.Metal1 0.00403006f
Cred_26796 vout2.P0.nSD VSS.$360.Metal1 0.00085959f
Cred_26797 vout2.P0.nSD VSS.$386.Metal1 0.0111038f
Cred_26798 vout2.P0.nSD VSS.$4418.Metal3 4.56197e-05f
Cred_26799 vout2.P0.nSD VSS.$4454.Metal3 0.000493588f
Cred_26800 vout2.P0.nSD VSS.$4478.Metal3 0.000239325f
Cred_26801 vout2.P0.nSD VSS.$4514.Metal3 0.000110923f
Cred_26802 vout2.P0.nSD VSS.$4538.Metal3 0.000139258f
Cred_26803 vout2.P0.nSD VSS.$4562.Metal3 7.12933e-05f
Cred_26804 vout2.P0.nSD VSS.$4586.Metal3 1.2802e-05f
Cred_26805 vout2.P0.nSD VSS.$471.Metal1 5.18797e-06f
Cred_26806 vout2.P0.nSD VSS.$499.Metal1 7.45854e-05f
Cred_26807 vout2.P0.nSD VSS.$519.Metal1 5.27347e-05f
Cred_26808 vout2.P0.nSD VSS.$565.Metal1 0.000194724f
Cred_26809 vout2.P0.nSD VSS.$68.Metal1 4.13799e-05f
Cred_26810 vout2.P0.nSD VSS.P2.pSD 5.28629e-07f
Cred_26811 vout2.P0.nSD VSS.P3.pSD 0.000291843f
Cred_26812 vout2.P0.nSD VSS.P51.nSD 3.7752e-07f
Cred_26813 vout2.P0.nSD VSS.P6.GatPoly 4.696e-05f
Cred_26814 vout2.P0.nSD VSS.P72.nSD 4.31259e-05f
Cred_26815 vout2.P0.nSD VSS.P73.nSD 4.31259e-05f
Cred_26816 vout2.P0.nSD VSS.P75.nSD 0.000380984f
Cred_26817 vout2.P0.nSD VSS.P77.nSD 6.69258e-06f
Cred_26818 vout2.P0.pSD VSS.$158.Metal1 0.00137607f
Cred_26819 vout2.P0.pSD VSS.$1990.Metal1 5.20461e-07f
Cred_26820 vout2.P0.pSD VSS.$2228.Metal2 0.00540512f
Cred_26821 vout2.P0.pSD VSS.$2409.Metal2 1.10137e-06f
Cred_26822 vout2.P0.pSD VSS.$2433.Metal2 0.000440497f
Cred_26823 vout2.P0.pSD VSS.$2481.Metal2 0.000725434f
Cred_26824 vout2.P0.pSD VSS.$2532.Metal2 0.00398624f
Cred_26825 vout2.P0.pSD VSS.$2564.Metal2 0.00535189f
Cred_26826 vout2.P0.pSD VSS.$2620.Metal2 0.000330252f
Cred_26827 vout2.P0.pSD VSS.$2668.Metal2 0.000285843f
Cred_26828 vout2.P0.pSD VSS.$2711.Metal2 0.00322659f
Cred_26829 vout2.P0.pSD VSS.$2727.Metal2 5.45431e-07f
Cred_26830 vout2.P0.pSD VSS.$312.Metal1 0.00017442f
Cred_26831 vout2.P0.pSD VSS.$332.Metal1 0.000860738f
Cred_26832 vout2.P0.pSD VSS.$360.Metal1 0.000186369f
Cred_26833 vout2.P0.pSD VSS.$386.Metal1 0.00300149f
Cred_26834 vout2.P0.pSD VSS.$4418.Metal3 0.000137366f
Cred_26835 vout2.P0.pSD VSS.$4454.Metal3 0.00146707f
Cred_26836 vout2.P0.pSD VSS.$4478.Metal3 0.000984693f
Cred_26837 vout2.P0.pSD VSS.$4514.Metal3 0.000589425f
Cred_26838 vout2.P0.pSD VSS.$4538.Metal3 0.000739994f
Cred_26839 vout2.P0.pSD VSS.$4562.Metal3 0.000378841f
Cred_26840 vout2.P0.pSD VSS.$4586.Metal3 6.80277e-05f
Cred_26841 vout2.P0.pSD VSS.$471.Metal1 2.7568e-05f
Cred_26842 vout2.P0.pSD VSS.$499.Metal1 0.000396335f
Cred_26843 vout2.P0.pSD VSS.$519.Metal1 0.000280223f
Cred_26844 vout2.P0.pSD VSS.$565.Metal1 0.00103473f
Cred_26845 vout2.P0.pSD VSS.$68.Metal1 0.000219886f
Cred_26846 vout2.P0.pSD VSS.P2.pSD 1.30772e-07f
Cred_26847 vout2.P0.pSD VSS.P3.pSD 0.00154813f
Cred_26848 vout2.P0.pSD VSS.P51.nSD 3.4447e-07f
Cred_26849 vout2.P0.pSD VSS.P6.GatPoly 0.000147922f
Cred_26850 vout2.P0.pSD VSS.P72.nSD 7.30234e-06f
Cred_26851 vout2.P0.pSD VSS.P73.nSD 7.30234e-06f
Cred_26852 vout2.P0.pSD VSS.P75.nSD 0.000102824f
Cred_26853 vout2.P0.pSD VSS.P77.nSD 3.55632e-05f
Cred_26854 vout2.P10.nSD VSS 0.0101413f
Cred_26855 vout2.P10.nSD VSS.$1200.Metal1 0.00304576f
Cred_26856 vout2.P10.nSD VSS.$1220.Metal1 0.00295783f
Cred_26857 vout2.P10.nSD VSS.$1266.Metal1 0.0105932f
Cred_26858 vout2.P10.nSD VSS.$1990.Metal1 5.21645e-07f
Cred_26859 vout2.P10.nSD VSS.$3260.Metal2 0.00404459f
Cred_26860 vout2.P10.nSD VSS.$3292.Metal2 0.00404464f
Cred_26861 vout2.P10.nSD VSS.$3344.Metal2 0.00167822f
Cred_26862 vout2.P10.nSD VSS.$3392.Metal2 0.00122058f
Cred_26863 vout2.P10.nSD VSS.$3435.Metal2 0.00801866f
Cred_26864 vout2.P10.nSD VSS.$3451.Metal2 5.76525e-08f
Cred_26865 vout2.P10.nSD VSS.$4802.Metal3 6.50798e-06f
Cred_26866 vout2.P10.nSD VSS.$4838.Metal3 8.57235e-05f
Cred_26867 vout2.P10.nSD VSS.$4862.Metal3 0.000224555f
Cred_26868 vout2.P10.nSD VSS.$4886.Metal3 6.72879e-05f
Cred_26869 vout2.P10.nSD VSS.$4910.Metal3 7.19059e-06f
Cred_26870 vout2.P10.nSD VSS.$68.Metal1 2.59156e-07f
Cred_26871 vout2.P10.nSD VSS.P3.pSD 6.64122e-05f
Cred_26872 vout2.P10.nSD VSS.P59.nSD 3.05065e-07f
Cred_26873 vout2.P10.nSD VSS.P83.nSD 0.000347331f
Cred_26874 vout2.P10.nSD VSS.P85.nSD 0.000363808f
Cred_26875 vout2.P10.pSD VSS 0.000640587f
Cred_26876 vout2.P10.pSD VSS.$1200.Metal1 0.000224296f
Cred_26877 vout2.P10.pSD VSS.$1220.Metal1 0.000219193f
Cred_26878 vout2.P10.pSD VSS.$1266.Metal1 0.000634918f
Cred_26879 vout2.P10.pSD VSS.$1990.Metal1 2.82527e-06f
Cred_26880 vout2.P10.pSD VSS.$3260.Metal2 0.00105811f
Cred_26881 vout2.P10.pSD VSS.$3292.Metal2 0.00105839f
Cred_26882 vout2.P10.pSD VSS.$3344.Metal2 0.000224572f
Cred_26883 vout2.P10.pSD VSS.$3392.Metal2 0.000163469f
Cred_26884 vout2.P10.pSD VSS.$3435.Metal2 0.00180464f
Cred_26885 vout2.P10.pSD VSS.$3451.Metal2 3.1225e-07f
Cred_26886 vout2.P10.pSD VSS.$4802.Metal3 3.52477e-05f
Cred_26887 vout2.P10.pSD VSS.$4838.Metal3 0.000292834f
Cred_26888 vout2.P10.pSD VSS.$4862.Metal3 0.000488067f
Cred_26889 vout2.P10.pSD VSS.$4886.Metal3 0.00024687f
Cred_26890 vout2.P10.pSD VSS.$4910.Metal3 3.89447e-05f
Cred_26891 vout2.P10.pSD VSS.$68.Metal1 1.40361e-06f
Cred_26892 vout2.P10.pSD VSS.P3.pSD 0.000359693f
Cred_26893 vout2.P10.pSD VSS.P59.nSD 7.9788e-08f
Cred_26894 vout2.P10.pSD VSS.P83.nSD 2.19092e-05f
Cred_26895 vout2.P10.pSD VSS.P85.nSD 2.18228e-05f
Cred_26896 vout2.P12.nSD VSS.$1266.Metal1 0.0100067f
Cred_26897 vout2.P12.nSD VSS.$1359.Metal1 8.08366e-07f
Cred_26898 vout2.P12.nSD VSS.$1379.Metal1 0.00441278f
Cred_26899 vout2.P12.nSD VSS.$1407.Metal1 0.00149478f
Cred_26900 vout2.P12.nSD VSS.$1445.Metal1 0.0104783f
Cred_26901 vout2.P12.nSD VSS.$3435.Metal2 0.00772439f
Cred_26902 vout2.P12.nSD VSS.$3507.Metal2 0.000623847f
Cred_26903 vout2.P12.nSD VSS.$3555.Metal2 0.0022163f
Cred_26904 vout2.P12.nSD VSS.$3603.Metal2 0.000281085f
Cred_26905 vout2.P12.nSD VSS.$3638.Metal2 0.00740191f
Cred_26906 vout2.P12.nSD VSS.$4934.Metal3 0.000116547f
Cred_26907 vout2.P12.nSD VSS.$4958.Metal3 6.06927e-05f
Cred_26908 vout2.P12.nSD VSS.P2.pSD 9.13744e-07f
Cred_26909 vout2.P12.nSD VSS.P3.pSD 9.13744e-07f
Cred_26910 vout2.P12.nSD VSS.P63.nSD 4.08512e-08f
Cred_26911 vout2.P12.nSD VSS.P85.nSD 0.000343017f
Cred_26912 vout2.P12.nSD VSS.P87.nSD 0.00035982f
Cred_26913 vout2.P14.nSD VSS.$1445.Metal1 0.0100621f
Cred_26914 vout2.P14.nSD VSS.$1546.Metal1 0.00259801f
Cred_26915 vout2.P14.nSD VSS.$1566.Metal1 0.00288903f
Cred_26916 vout2.P14.nSD VSS.$1586.Metal1 0.000548125f
Cred_26917 vout2.P14.nSD VSS.$1624.Metal1 0.0105932f
Cred_26918 vout2.P14.nSD VSS.$1990.Metal1 2.38486e-06f
Cred_26919 vout2.P14.nSD VSS.$3603.Metal2 0.000299197f
Cred_26920 vout2.P14.nSD VSS.$3638.Metal2 0.00787818f
Cred_26921 vout2.P14.nSD VSS.$3694.Metal2 6.51011e-07f
Cred_26922 vout2.P14.nSD VSS.$3718.Metal2 0.00228389f
Cred_26923 vout2.P14.nSD VSS.$3766.Metal2 0.000577769f
Cred_26924 vout2.P14.nSD VSS.$3809.Metal2 0.00801866f
Cred_26925 vout2.P14.nSD VSS.$4958.Metal3 3.49209e-06f
Cred_26926 vout2.P14.nSD VSS.$4994.Metal3 0.000107941f
Cred_26927 vout2.P14.nSD VSS.$5030.Metal3 0.000240897f
Cred_26928 vout2.P14.nSD VSS.$5054.Metal3 2.90808e-05f
Cred_26929 vout2.P14.nSD VSS.$68.Metal1 7.16936e-08f
Cred_26930 vout2.P14.nSD VSS.P3.pSD 7.30662e-05f
Cred_26931 vout2.P14.nSD VSS.P63.nSD 4.34795e-08f
Cred_26932 vout2.P14.nSD VSS.P87.nSD 0.000345093f
Cred_26933 vout2.P14.nSD VSS.P89.nSD 0.000363808f
Cred_26934 vout2.P14.pSD VSS.$1445.Metal1 0.000632091f
Cred_26935 vout2.P14.pSD VSS.$1546.Metal1 0.000197431f
Cred_26936 vout2.P14.pSD VSS.$1566.Metal1 0.000216454f
Cred_26937 vout2.P14.pSD VSS.$1586.Metal1 2.73644e-05f
Cred_26938 vout2.P14.pSD VSS.$1624.Metal1 0.000634918f
Cred_26939 vout2.P14.pSD VSS.$1990.Metal1 1.29166e-05f
Cred_26940 vout2.P14.pSD VSS.$3603.Metal2 7.71726e-05f
Cred_26941 vout2.P14.pSD VSS.$3638.Metal2 0.00202852f
Cred_26942 vout2.P14.pSD VSS.$3694.Metal2 1.62384e-06f
Cred_26943 vout2.P14.pSD VSS.$3718.Metal2 0.00030622f
Cred_26944 vout2.P14.pSD VSS.$3766.Metal2 7.74118e-05f
Cred_26945 vout2.P14.pSD VSS.$3809.Metal2 0.00180464f
Cred_26946 vout2.P14.pSD VSS.$4958.Metal3 1.89134e-05f
Cred_26947 vout2.P14.pSD VSS.$4994.Metal3 0.000347384f
Cred_26948 vout2.P14.pSD VSS.$5030.Metal3 0.000557965f
Cred_26949 vout2.P14.pSD VSS.$5054.Metal3 0.000157504f
Cred_26950 vout2.P14.pSD VSS.$68.Metal1 3.88298e-07f
Cred_26951 vout2.P14.pSD VSS.P3.pSD 0.000395732f
Cred_26952 vout2.P14.pSD VSS.P63.nSD 1.11938e-08f
Cred_26953 vout2.P14.pSD VSS.P87.nSD 2.16969e-05f
Cred_26954 vout2.P14.pSD VSS.P89.nSD 2.18228e-05f
Cred_26955 vout2.P16.nSD VSS.$1624.Metal1 0.00980245f
Cred_26956 vout2.P16.nSD VSS.$1725.Metal1 0.00221157f
Cred_26957 vout2.P16.nSD VSS.$1745.Metal1 0.00350787f
Cred_26958 vout2.P16.nSD VSS.$1773.Metal1 0.00034694f
Cred_26959 vout2.P16.nSD VSS.$1799.Metal1 0.0103228f
Cred_26960 vout2.P16.nSD VSS.$3809.Metal2 0.00777963f
Cred_26961 vout2.P16.nSD VSS.$3881.Metal2 0.00131213f
Cred_26962 vout2.P16.nSD VSS.$3929.Metal2 0.00151725f
Cred_26963 vout2.P16.nSD VSS.$3988.Metal2 0.00438658f
Cred_26964 vout2.P16.nSD VSS.$4020.Metal2 0.0032666f
Cred_26965 vout2.P16.nSD VSS.$5078.Metal3 2.44203e-05f
Cred_26966 vout2.P16.nSD VSS.$5102.Metal3 0.000134441f
Cred_26967 vout2.P16.nSD VSS.$5126.Metal3 2.89426e-05f
Cred_26968 vout2.P16.nSD VSS.P2.pSD 2.12019e-07f
Cred_26969 vout2.P16.nSD VSS.P3.pSD 2.12019e-07f
Cred_26970 vout2.P16.nSD VSS.P67.nSD 2.82445e-07f
Cred_26971 vout2.P16.nSD VSS.P89.nSD 0.000336657f
Cred_26972 vout2.P16.nSD VSS.P91.nSD 0.000353699f
Cred_26973 vout2.P18.nSD VSS.$1799.Metal1 0.0106321f
Cred_26974 vout2.P18.nSD VSS.$1884.Metal1 0.0008333f
Cred_26975 vout2.P18.nSD VSS.$1912.Metal1 0.00390865f
Cred_26976 vout2.P18.nSD VSS.$1932.Metal1 0.00117822f
Cred_26977 vout2.P18.nSD VSS.$1990.Metal1 0.000176354f
Cred_26978 vout2.P18.nSD VSS.$2021.Metal1 0.00766697f
Cred_26979 vout2.P18.nSD VSS.$3988.Metal2 0.00502884f
Cred_26980 vout2.P18.nSD VSS.$4020.Metal2 0.00374499f
Cred_26981 vout2.P18.nSD VSS.$4068.Metal2 0.00183604f
Cred_26982 vout2.P18.nSD VSS.$4116.Metal2 0.0011127f
Cred_26983 vout2.P18.nSD VSS.$4140.Metal2 4.20991e-07f
Cred_26984 vout2.P18.nSD VSS.$4164.Metal2 0.00707783f
Cred_26985 vout2.P18.nSD VSS.$5126.Metal3 1.05235e-05f
Cred_26986 vout2.P18.nSD VSS.$5162.Metal3 0.000124745f
Cred_26987 vout2.P18.nSD VSS.$5186.Metal3 0.000307469f
Cred_26988 vout2.P18.nSD VSS.$5222.Metal3 8.4416e-05f
Cred_26989 vout2.P18.nSD VSS.$5234.Metal3 4.48719e-05f
Cred_26990 vout2.P18.nSD VSS.$5246.Metal3 5.60606e-05f
Cred_26991 vout2.P18.nSD VSS.$5258.Metal3 5.60606e-05f
Cred_26992 vout2.P18.nSD VSS.$5270.Metal3 5.60606e-05f
Cred_26993 vout2.P18.nSD VSS.$5282.Metal3 0.000693567f
Cred_26994 vout2.P18.nSD VSS.$68.Metal1 1.11023e-07f
Cred_26995 vout2.P18.nSD VSS.P2.pSD 5.09388e-07f
Cred_26996 vout2.P18.nSD VSS.P3.pSD 0.000596822f
Cred_26997 vout2.P18.nSD VSS.P67.nSD 3.23794e-07f
Cred_26998 vout2.P18.nSD VSS.P7.GatPoly 7.51285e-05f
Cred_26999 vout2.P18.nSD VSS.P91.nSD 0.000364826f
Cred_27000 vout2.P18.nSD VSS.P93.nSD 4.23149e-05f
Cred_27001 vout2.P18.nSD VSS.P95.nSD 4.23149e-05f
Cred_27002 vout2.P18.pSD VSS.$1799.Metal1 0.0010348f
Cred_27003 vout2.P18.pSD VSS.$1884.Metal1 0.000100406f
Cred_27004 vout2.P18.pSD VSS.$1912.Metal1 0.00046372f
Cred_27005 vout2.P18.pSD VSS.$1932.Metal1 9.39683e-05f
Cred_27006 vout2.P18.pSD VSS.$1990.Metal1 0.000833315f
Cred_27007 vout2.P18.pSD VSS.$2021.Metal1 0.000965309f
Cred_27008 vout2.P18.pSD VSS.$3988.Metal2 0.00173901f
Cred_27009 vout2.P18.pSD VSS.$4020.Metal2 0.00129558f
Cred_27010 vout2.P18.pSD VSS.$4068.Metal2 0.000390825f
Cred_27011 vout2.P18.pSD VSS.$4116.Metal2 0.000238221f
Cred_27012 vout2.P18.pSD VSS.$4140.Metal2 1.7339e-06f
Cred_27013 vout2.P18.pSD VSS.$4164.Metal2 0.00744284f
Cred_27014 vout2.P18.pSD VSS.$5126.Metal3 5.69961e-05f
Cred_27015 vout2.P18.pSD VSS.$5162.Metal3 0.000489482f
Cred_27016 vout2.P18.pSD VSS.$5186.Metal3 0.000903207f
Cred_27017 vout2.P18.pSD VSS.$5222.Metal3 0.000389077f
Cred_27018 vout2.P18.pSD VSS.$5234.Metal3 0.000137043f
Cred_27019 vout2.P18.pSD VSS.$5246.Metal3 0.000171214f
Cred_27020 vout2.P18.pSD VSS.$5258.Metal3 0.000171214f
Cred_27021 vout2.P18.pSD VSS.$5270.Metal3 0.000171214f
Cred_27022 vout2.P18.pSD VSS.$5282.Metal3 0.00211822f
Cred_27023 vout2.P18.pSD VSS.$68.Metal1 5.7536e-07f
Cred_27024 vout2.P18.pSD VSS.P2.pSD 6.13769e-08f
Cred_27025 vout2.P18.pSD VSS.P3.pSD 0.00300763f
Cred_27026 vout2.P18.pSD VSS.P67.nSD 1.11943e-07f
Cred_27027 vout2.P18.pSD VSS.P7.GatPoly 0.000271069f
Cred_27028 vout2.P18.pSD VSS.P91.nSD 3.54552e-05f
Cred_27029 vout2.P18.pSD VSS.P93.nSD 4.85999e-06f
Cred_27030 vout2.P18.pSD VSS.P95.nSD 4.85999e-06f
Cred_27031 vout2.P2.nSD VSS.$158.Metal1 0.000137008f
Cred_27032 vout2.P2.nSD VSS.$1990.Metal1 7.89013e-08f
Cred_27033 vout2.P2.nSD VSS.$2228.Metal2 0.000538159f
Cred_27034 vout2.P2.nSD VSS.$2409.Metal2 1.09658e-07f
Cred_27035 vout2.P2.nSD VSS.$2433.Metal2 4.3858e-05f
Cred_27036 vout2.P2.nSD VSS.$2481.Metal2 7.22277e-05f
Cred_27037 vout2.P2.nSD VSS.$2532.Metal2 0.00386475f
Cred_27038 vout2.P2.nSD VSS.$2564.Metal2 0.0051897f
Cred_27039 vout2.P2.nSD VSS.$2620.Metal2 0.00158486f
Cred_27040 vout2.P2.nSD VSS.$2668.Metal2 0.00137065f
Cred_27041 vout2.P2.nSD VSS.$2711.Metal2 0.00834602f
Cred_27042 vout2.P2.nSD VSS.$2727.Metal2 1.11663e-07f
Cred_27043 vout2.P2.nSD VSS.$312.Metal1 1.73661e-05f
Cred_27044 vout2.P2.nSD VSS.$332.Metal1 8.56992e-05f
Cred_27045 vout2.P2.nSD VSS.$360.Metal1 1.85558e-05f
Cred_27046 vout2.P2.nSD VSS.$386.Metal1 0.0109103f
Cred_27047 vout2.P2.nSD VSS.$4418.Metal3 1.36768e-05f
Cred_27048 vout2.P2.nSD VSS.$4454.Metal3 0.000146069f
Cred_27049 vout2.P2.nSD VSS.$4478.Metal3 9.80408e-05f
Cred_27050 vout2.P2.nSD VSS.$4514.Metal3 0.000123061f
Cred_27051 vout2.P2.nSD VSS.$4538.Metal3 0.000285935f
Cred_27052 vout2.P2.nSD VSS.$4562.Metal3 0.000101978f
Cred_27053 vout2.P2.nSD VSS.$4586.Metal3 1.39269e-05f
Cred_27054 vout2.P2.nSD VSS.$471.Metal1 0.000352583f
Cred_27055 vout2.P2.nSD VSS.$499.Metal1 0.00358901f
Cred_27056 vout2.P2.nSD VSS.$519.Metal1 0.00226894f
Cred_27057 vout2.P2.nSD VSS.$565.Metal1 0.0106878f
Cred_27058 vout2.P2.nSD VSS.$68.Metal1 2.51878e-05f
Cred_27059 vout2.P2.nSD VSS.P2.pSD 2.26811e-07f
Cred_27060 vout2.P2.nSD VSS.P3.pSD 0.000205774f
Cred_27061 vout2.P2.nSD VSS.P51.nSD 3.34144e-07f
Cred_27062 vout2.P2.nSD VSS.P6.GatPoly 1.47278e-05f
Cred_27063 vout2.P2.nSD VSS.P72.nSD 7.27057e-07f
Cred_27064 vout2.P2.nSD VSS.P73.nSD 7.27057e-07f
Cred_27065 vout2.P2.nSD VSS.P75.nSD 0.000374376f
Cred_27066 vout2.P2.nSD VSS.P77.nSD 0.00036706f
Cred_27067 vout2.P2.pSD VSS.$158.Metal1 0.00074878f
Cred_27068 vout2.P2.pSD VSS.$1990.Metal1 4.31214e-07f
Cred_27069 vout2.P2.pSD VSS.$2228.Metal2 0.00294116f
Cred_27070 vout2.P2.pSD VSS.$2409.Metal2 5.99303e-07f
Cred_27071 vout2.P2.pSD VSS.$2433.Metal2 0.000239694f
Cred_27072 vout2.P2.pSD VSS.$2481.Metal2 0.000394741f
Cred_27073 vout2.P2.pSD VSS.$2532.Metal2 0.00288269f
Cred_27074 vout2.P2.pSD VSS.$2564.Metal2 0.00387047f
Cred_27075 vout2.P2.pSD VSS.$2620.Metal2 0.000369507f
Cred_27076 vout2.P2.pSD VSS.$2668.Metal2 0.000319819f
Cred_27077 vout2.P2.pSD VSS.$2711.Metal2 0.00361012f
Cred_27078 vout2.P2.pSD VSS.$2727.Metal2 6.10263e-07f
Cred_27079 vout2.P2.pSD VSS.$312.Metal1 9.49098e-05f
Cred_27080 vout2.P2.pSD VSS.$332.Metal1 0.000468366f
Cred_27081 vout2.P2.pSD VSS.$360.Metal1 0.000101412f
Cred_27082 vout2.P2.pSD VSS.$386.Metal1 0.00221978f
Cred_27083 vout2.P2.pSD VSS.$4418.Metal3 7.47468e-05f
Cred_27084 vout2.P2.pSD VSS.$4454.Metal3 0.000798301f
Cred_27085 vout2.P2.pSD VSS.$4478.Metal3 0.000535816f
Cred_27086 vout2.P2.pSD VSS.$4514.Metal3 0.00051438f
Cred_27087 vout2.P2.pSD VSS.$4538.Metal3 0.000827952f
Cred_27088 vout2.P2.pSD VSS.$4562.Metal3 0.000423871f
Cred_27089 vout2.P2.pSD VSS.$4586.Metal3 7.61138e-05f
Cred_27090 vout2.P2.pSD VSS.$471.Metal1 3.08449e-05f
Cred_27091 vout2.P2.pSD VSS.$499.Metal1 0.000443445f
Cred_27092 vout2.P2.pSD VSS.$519.Metal1 0.000313532f
Cred_27093 vout2.P2.pSD VSS.$565.Metal1 0.00115772f
Cred_27094 vout2.P2.pSD VSS.$68.Metal1 0.000137657f
Cred_27095 vout2.P2.pSD VSS.P2.pSD 8.08415e-08f
Cred_27096 vout2.P2.pSD VSS.P3.pSD 0.00112344f
Cred_27097 vout2.P2.pSD VSS.P51.nSD 2.49143e-07f
Cred_27098 vout2.P2.pSD VSS.P6.GatPoly 8.0491e-05f
Cred_27099 vout2.P2.pSD VSS.P72.nSD 3.97353e-06f
Cred_27100 vout2.P2.pSD VSS.P73.nSD 3.97353e-06f
Cred_27101 vout2.P2.pSD VSS.P75.nSD 7.60531e-05f
Cred_27102 vout2.P2.pSD VSS.P77.nSD 3.97905e-05f
Cred_27103 vout2.P4.nSD VSS.$2711.Metal2 0.00779109f
Cred_27104 vout2.P4.nSD VSS.$2783.Metal2 0.000563476f
Cred_27105 vout2.P4.nSD VSS.$2831.Metal2 0.00222735f
Cred_27106 vout2.P4.nSD VSS.$2855.Metal2 3.51192e-07f
Cred_27107 vout2.P4.nSD VSS.$2914.Metal2 0.00740191f
Cred_27108 vout2.P4.nSD VSS.$2946.Metal2 0.000281085f
Cred_27109 vout2.P4.nSD VSS.$4610.Metal3 0.000137876f
Cred_27110 vout2.P4.nSD VSS.$4646.Metal3 4.38017e-05f
Cred_27111 vout2.P4.nSD VSS.$565.Metal1 0.00994302f
Cred_27112 vout2.P4.nSD VSS.$658.Metal1 0.000543073f
Cred_27113 vout2.P4.nSD VSS.$678.Metal1 0.00284907f
Cred_27114 vout2.P4.nSD VSS.$698.Metal1 0.00256155f
Cred_27115 vout2.P4.nSD VSS.$744.Metal1 0.0104783f
Cred_27116 vout2.P4.nSD VSS.P55.nSD 4.08512e-08f
Cred_27117 vout2.P4.nSD VSS.P77.nSD 0.000341045f
Cred_27118 vout2.P4.nSD VSS.P79.nSD 0.00035982f
Cred_27119 vout2.P6.nSD VSS.$1990.Metal1 1.30542e-07f
Cred_27120 vout2.P6.nSD VSS.$2914.Metal2 0.00782404f
Cred_27121 vout2.P6.nSD VSS.$2946.Metal2 0.000297241f
Cred_27122 vout2.P6.nSD VSS.$2994.Metal2 0.00227228f
Cred_27123 vout2.P6.nSD VSS.$3042.Metal2 0.000639652f
Cred_27124 vout2.P6.nSD VSS.$3085.Metal2 0.00801853f
Cred_27125 vout2.P6.nSD VSS.$4646.Metal3 1.25593e-05f
Cred_27126 vout2.P6.nSD VSS.$4682.Metal3 0.000131f
Cred_27127 vout2.P6.nSD VSS.$4706.Metal3 0.000200207f
Cred_27128 vout2.P6.nSD VSS.$4730.Metal3 2.83514e-05f
Cred_27129 vout2.P6.nSD VSS.$68.Metal1 1.03084e-06f
Cred_27130 vout2.P6.nSD VSS.$744.Metal1 0.0101272f
Cred_27131 vout2.P6.nSD VSS.$837.Metal1 0.00151536f
Cred_27132 vout2.P6.nSD VSS.$865.Metal1 0.00447383f
Cred_27133 vout2.P6.nSD VSS.$885.Metal1 8.28756e-07f
Cred_27134 vout2.P6.nSD VSS.$923.Metal1 0.0105931f
Cred_27135 vout2.P6.nSD VSS.P2.pSD 9.26325e-07f
Cred_27136 vout2.P6.nSD VSS.P3.pSD 6.69332e-05f
Cred_27137 vout2.P6.nSD VSS.P55.nSD 4.31805e-08f
Cred_27138 vout2.P6.nSD VSS.P79.nSD 0.000347109f
Cred_27139 vout2.P6.nSD VSS.P81.nSD 0.000363807f
Cred_27140 vout2.P6.pSD VSS.$1990.Metal1 7.13444e-07f
Cred_27141 vout2.P6.pSD VSS.$2914.Metal2 0.00210216f
Cred_27142 vout2.P6.pSD VSS.$2946.Metal2 8.05124e-05f
Cred_27143 vout2.P6.pSD VSS.$2994.Metal2 0.000305951f
Cred_27144 vout2.P6.pSD VSS.$3042.Metal2 8.63764e-05f
Cred_27145 vout2.P6.pSD VSS.$3085.Metal2 0.00182035f
Cred_27146 vout2.P6.pSD VSS.$4646.Metal3 6.86395e-05f
Cred_27147 vout2.P6.pSD VSS.$4682.Metal3 0.000384247f
Cred_27148 vout2.P6.pSD VSS.$4706.Metal3 0.000457221f
Cred_27149 vout2.P6.pSD VSS.$4730.Metal3 0.000154947f
Cred_27150 vout2.P6.pSD VSS.$68.Metal1 5.63379e-06f
Cred_27151 vout2.P6.pSD VSS.$744.Metal1 0.00064532f
Cred_27152 vout2.P6.pSD VSS.$837.Metal1 0.000112486f
Cred_27153 vout2.P6.pSD VSS.$865.Metal1 0.000333648f
Cred_27154 vout2.P6.pSD VSS.$885.Metal1 1.11435e-07f
Cred_27155 vout2.P6.pSD VSS.$923.Metal1 0.000640445f
Cred_27156 vout2.P6.pSD VSS.P2.pSD 6.87615e-08f
Cred_27157 vout2.P6.pSD VSS.P3.pSD 0.000360811f
Cred_27158 vout2.P6.pSD VSS.P55.nSD 1.15988e-08f
Cred_27159 vout2.P6.pSD VSS.P79.nSD 2.21399e-05f
Cred_27160 vout2.P6.pSD VSS.P81.nSD 2.20128e-05f
Cred_27161 vout2.P8.nSD VSS 0.0107023f
Cred_27162 vout2.P8.nSD VSS.$1024.Metal1 0.00291736f
Cred_27163 vout2.P8.nSD VSS.$1044.Metal1 0.00300434f
Cred_27164 vout2.P8.nSD VSS.$3085.Metal2 0.00770015f
Cred_27165 vout2.P8.nSD VSS.$3157.Metal2 0.0011904f
Cred_27166 vout2.P8.nSD VSS.$3205.Metal2 0.00163676f
Cred_27167 vout2.P8.nSD VSS.$3260.Metal2 0.00384189f
Cred_27168 vout2.P8.nSD VSS.$3292.Metal2 0.00384189f
Cred_27169 vout2.P8.nSD VSS.$4754.Metal3 2.17069e-05f
Cred_27170 vout2.P8.nSD VSS.$4778.Metal3 0.000134441f
Cred_27171 vout2.P8.nSD VSS.$4802.Metal3 3.16559e-05f
Cred_27172 vout2.P8.nSD VSS.$923.Metal1 0.00979661f
Cred_27173 vout2.P8.nSD VSS.P59.nSD 2.89781e-07f
Cred_27174 vout2.P8.nSD VSS.P81.nSD 0.000336456f
Cred_27175 vout2.P8.nSD VSS.P83.nSD 0.000366609f
Cred_27176 vout3 VSS 0.137478f
Cred_27177 vout3 VSS.$1799.Metal1 0.00240463f
Cred_27178 vout3 VSS.$1884.Metal1 0.000233319f
Cred_27179 vout3 VSS.$1912.Metal1 0.00107758f
Cred_27180 vout3 VSS.$1932.Metal1 0.000218361f
Cred_27181 vout3 VSS.$1990.Metal1 0.00421169f
Cred_27182 vout3 VSS.$2022.Metal1 0.00224316f
Cred_27183 vout3 VSS.$3988.Metal2 0.00404105f
Cred_27184 vout3 VSS.$4020.Metal2 0.00301064f
Cred_27185 vout3 VSS.$4068.Metal2 0.000908188f
Cred_27186 vout3 VSS.$4116.Metal2 0.000553571f
Cred_27187 vout3 VSS.$4140.Metal2 4.02919e-06f
Cred_27188 vout3 VSS.$4174.Metal2 0.0172954f
Cred_27189 vout3 VSS.$5126.Metal3 0.000132446f
Cred_27190 vout3 VSS.$5162.Metal3 0.00113744f
Cred_27191 vout3 VSS.$5186.Metal3 0.00209884f
Cred_27192 vout3 VSS.$5222.Metal3 0.000904126f
Cred_27193 vout3 VSS.$5234.Metal3 0.000318457f
Cred_27194 vout3 VSS.$5246.Metal3 0.000397863f
Cred_27195 vout3 VSS.$5258.Metal3 0.000397863f
Cred_27196 vout3 VSS.$5270.Metal3 0.000397863f
Cred_27197 vout3 VSS.$5279.Metal3 1.07557e-06f
Cred_27198 vout3 VSS.$5282.Metal3 0.052127f
Cred_27199 vout3 VSS.$5288.Metal3 5.37283e-05f
Cred_27200 vout3 VSS.$68.Metal1 1.9072e-06f
Cred_27201 vout3 VSS.P2.pSD 0.0116531f
Cred_27202 vout3 VSS.P3.pSD 1.42626e-07f
Cred_27203 vout3 VSS.P5.GatPoly 0.000629903f
Cred_27204 vout3 VSS.P67.nSD 8.23898e-05f
Cred_27205 vout3 VSS.P69.nSD 1.12935e-05f
Cred_27206 vout3 VSS.P71.nSD 1.12935e-05f
Cred_27207 vout3 VSS.P91.nSD 2.60129e-07f
Cred_27208 vout3.$1226.Metal3 VSS.$159.Metal1 0.00869667f
Cred_27209 vout3.$1226.Metal3 VSS.$1990.Metal1 2.28562e-05f
Cred_27210 vout3.$1226.Metal3 VSS.$2238.Metal2 0.03416f
Cred_27211 vout3.$1226.Metal3 VSS.$2409.Metal2 6.96059e-06f
Cred_27212 vout3.$1226.Metal3 VSS.$2433.Metal2 0.00278392f
Cred_27213 vout3.$1226.Metal3 VSS.$2481.Metal2 0.0045847f
Cred_27214 vout3.$1226.Metal3 VSS.$2532.Metal2 0.0334789f
Cred_27215 vout3.$1226.Metal3 VSS.$2564.Metal2 0.0449507f
Cred_27216 vout3.$1226.Metal3 VSS.$2620.Metal2 0.00429162f
Cred_27217 vout3.$1226.Metal3 VSS.$2668.Metal2 0.00371453f
Cred_27218 vout3.$1226.Metal3 VSS.$2711.Metal2 0.0937977f
Cred_27219 vout3.$1226.Metal3 VSS.$2727.Metal2 7.08788e-06f
Cred_27220 vout3.$1226.Metal3 VSS.$2783.Metal2 0.00190622f
Cred_27221 vout3.$1226.Metal3 VSS.$2831.Metal2 0.00754049f
Cred_27222 vout3.$1226.Metal3 VSS.$2855.Metal2 3.99861e-05f
Cred_27223 vout3.$1226.Metal3 VSS.$2914.Metal2 0.0672216f
Cred_27224 vout3.$1226.Metal3 VSS.$2946.Metal2 0.00256411f
Cred_27225 vout3.$1226.Metal3 VSS.$2994.Metal2 0.00355346f
Cred_27226 vout3.$1226.Metal3 VSS.$3042.Metal2 0.00100321f
Cred_27227 vout3.$1226.Metal3 VSS.$3085.Metal2 0.0211424f
Cred_27228 vout3.$1226.Metal3 VSS.$312.Metal1 0.00110233f
Cred_27229 vout3.$1226.Metal3 VSS.$332.Metal1 0.00543982f
Cred_27230 vout3.$1226.Metal3 VSS.$360.Metal1 0.00117784f
Cred_27231 vout3.$1226.Metal3 VSS.$386.Metal1 0.0257244f
Cred_27232 vout3.$1226.Metal3 VSS.$4418.Metal3 0.000868144f
Cred_27233 vout3.$1226.Metal3 VSS.$4454.Metal3 0.00927183f
Cred_27234 vout3.$1226.Metal3 VSS.$4478.Metal3 0.00622321f
Cred_27235 vout3.$1226.Metal3 VSS.$4514.Metal3 0.00597424f
Cred_27236 vout3.$1226.Metal3 VSS.$4538.Metal3 0.00961622f
Cred_27237 vout3.$1226.Metal3 VSS.$4562.Metal3 0.00492304f
Cred_27238 vout3.$1226.Metal3 VSS.$4586.Metal3 0.00476246f
Cred_27239 vout3.$1226.Metal3 VSS.$4610.Metal3 0.0137395f
Cred_27240 vout3.$1226.Metal3 VSS.$4646.Metal3 0.00935134f
Cred_27241 vout3.$1226.Metal3 VSS.$4682.Metal3 0.00492856f
Cred_27242 vout3.$1226.Metal3 VSS.$4706.Metal3 0.00531038f
Cred_27243 vout3.$1226.Metal3 VSS.$471.Metal1 0.000358247f
Cred_27244 vout3.$1226.Metal3 VSS.$4730.Metal3 0.00179962f
Cred_27245 vout3.$1226.Metal3 VSS.$499.Metal1 0.00515037f
Cred_27246 vout3.$1226.Metal3 VSS.$519.Metal1 0.00364151f
Cred_27247 vout3.$1226.Metal3 VSS.$565.Metal1 0.0291318f
Cred_27248 vout3.$1226.Metal3 VSS.$658.Metal1 0.000673831f
Cred_27249 vout3.$1226.Metal3 VSS.$678.Metal1 0.00533005f
Cred_27250 vout3.$1226.Metal3 VSS.$68.Metal1 0.00198231f
Cred_27251 vout3.$1226.Metal3 VSS.$698.Metal1 0.00486162f
Cred_27252 vout3.$1226.Metal3 VSS.$744.Metal1 0.0231433f
Cred_27253 vout3.$1226.Metal3 VSS.$837.Metal1 0.00130646f
Cred_27254 vout3.$1226.Metal3 VSS.$865.Metal1 0.00387514f
Cred_27255 vout3.$1226.Metal3 VSS.$885.Metal1 1.29425e-06f
Cred_27256 vout3.$1226.Metal3 VSS.$923.Metal1 0.00743843f
Cred_27257 vout3.$1226.Metal3 VSS.P2.pSD 0.0269835f
Cred_27258 vout3.$1226.Metal3 VSS.P3.pSD 1.73756e-06f
Cred_27259 vout3.$1226.Metal3 VSS.P4.GatPoly 0.000934859f
Cred_27260 vout3.$1226.Metal3 VSS.P48.nSD 4.61504e-05f
Cred_27261 vout3.$1226.Metal3 VSS.P49.nSD 4.61504e-05f
Cred_27262 vout3.$1226.Metal3 VSS.P51.nSD 0.000881354f
Cred_27263 vout3.$1226.Metal3 VSS.P53.nSD 0.00100084f
Cred_27264 vout3.$1226.Metal3 VSS.P55.nSD 0.000794752f
Cred_27265 vout3.$1226.Metal3 VSS.P57.nSD 0.000255666f
Cred_27266 vout3.$1226.Metal3 VSS.P75.nSD 2.89348e-06f
Cred_27267 vout3.$1226.Metal3 VSS.P79.nSD 3.70921e-07f
Cred_27268 vout3.$1292.Metal3 VSS 0.0234977f
Cred_27269 vout3.$1292.Metal3 VSS.$1024.Metal1 0.00539748f
Cred_27270 vout3.$1292.Metal3 VSS.$1044.Metal1 0.00552315f
Cred_27271 vout3.$1292.Metal3 VSS.$1200.Metal1 0.00262872f
Cred_27272 vout3.$1292.Metal3 VSS.$1220.Metal1 0.00256891f
Cred_27273 vout3.$1292.Metal3 VSS.$1266.Metal1 0.00744117f
Cred_27274 vout3.$1292.Metal3 VSS.$1990.Metal1 7.59611e-05f
Cred_27275 vout3.$1292.Metal3 VSS.$2914.Metal2 0.0244154f
Cred_27276 vout3.$1292.Metal3 VSS.$2946.Metal2 0.000935108f
Cred_27277 vout3.$1292.Metal3 VSS.$2994.Metal2 0.00355346f
Cred_27278 vout3.$1292.Metal3 VSS.$3042.Metal2 0.00100321f
Cred_27279 vout3.$1292.Metal3 VSS.$3085.Metal2 0.0733379f
Cred_27280 vout3.$1292.Metal3 VSS.$3101.Metal2 7.68897e-06f
Cred_27281 vout3.$1292.Metal3 VSS.$3157.Metal2 0.00402533f
Cred_27282 vout3.$1292.Metal3 VSS.$3205.Metal2 0.00552995f
Cred_27283 vout3.$1292.Metal3 VSS.$3260.Metal2 0.0345933f
Cred_27284 vout3.$1292.Metal3 VSS.$3292.Metal2 0.0345896f
Cred_27285 vout3.$1292.Metal3 VSS.$3344.Metal2 0.00263196f
Cred_27286 vout3.$1292.Metal3 VSS.$3392.Metal2 0.00191584f
Cred_27287 vout3.$1292.Metal3 VSS.$3435.Metal2 0.0211502f
Cred_27288 vout3.$1292.Metal3 VSS.$3451.Metal2 3.65954e-06f
Cred_27289 vout3.$1292.Metal3 VSS.$4646.Metal3 0.000797211f
Cred_27290 vout3.$1292.Metal3 VSS.$4682.Metal3 0.00446283f
Cred_27291 vout3.$1292.Metal3 VSS.$4706.Metal3 0.00531038f
Cred_27292 vout3.$1292.Metal3 VSS.$4730.Metal3 0.00275861f
Cred_27293 vout3.$1292.Metal3 VSS.$4754.Metal3 0.00607902f
Cred_27294 vout3.$1292.Metal3 VSS.$4778.Metal3 0.0120183f
Cred_27295 vout3.$1292.Metal3 VSS.$4802.Metal3 0.00762396f
Cred_27296 vout3.$1292.Metal3 VSS.$4838.Metal3 0.00429993f
Cred_27297 vout3.$1292.Metal3 VSS.$4862.Metal3 0.00572008f
Cred_27298 vout3.$1292.Metal3 VSS.$4886.Metal3 0.00289329f
Cred_27299 vout3.$1292.Metal3 VSS.$4910.Metal3 0.000456428f
Cred_27300 vout3.$1292.Metal3 VSS.$68.Metal1 0.000151454f
Cred_27301 vout3.$1292.Metal3 VSS.$744.Metal1 0.00749505f
Cred_27302 vout3.$1292.Metal3 VSS.$837.Metal1 0.00130646f
Cred_27303 vout3.$1292.Metal3 VSS.$865.Metal1 0.00387514f
Cred_27304 vout3.$1292.Metal3 VSS.$885.Metal1 1.29425e-06f
Cred_27305 vout3.$1292.Metal3 VSS.$923.Metal1 0.0228399f
Cred_27306 vout3.$1292.Metal3 VSS.P2.pSD 0.0172634f
Cred_27307 vout3.$1292.Metal3 VSS.P3.pSD 7.98628e-07f
Cred_27308 vout3.$1292.Metal3 VSS.P55.nSD 0.000257143f
Cred_27309 vout3.$1292.Metal3 VSS.P57.nSD 0.000785145f
Cred_27310 vout3.$1292.Metal3 VSS.P59.nSD 0.000803878f
Cred_27311 vout3.$1292.Metal3 VSS.P61.nSD 0.000255761f
Cred_27312 vout3.$1292.Metal3 VSS.P79.nSD 1.34714e-07f
Cred_27313 vout3.$1292.Metal3 VSS.P83.nSD 2.60795e-06f
Cred_27314 vout3.$1358.Metal3 VSS 0.00750761f
Cred_27315 vout3.$1358.Metal3 VSS.$1200.Metal1 0.00262872f
Cred_27316 vout3.$1358.Metal3 VSS.$1220.Metal1 0.00256891f
Cred_27317 vout3.$1358.Metal3 VSS.$1266.Metal1 0.0231782f
Cred_27318 vout3.$1358.Metal3 VSS.$1359.Metal1 2.72033e-06f
Cred_27319 vout3.$1358.Metal3 VSS.$1379.Metal1 0.00814498f
Cred_27320 vout3.$1358.Metal3 VSS.$1407.Metal1 0.002746f
Cred_27321 vout3.$1358.Metal3 VSS.$1445.Metal1 0.0230563f
Cred_27322 vout3.$1358.Metal3 VSS.$1546.Metal1 0.00231387f
Cred_27323 vout3.$1358.Metal3 VSS.$1566.Metal1 0.00253681f
Cred_27324 vout3.$1358.Metal3 VSS.$1586.Metal1 0.000320707f
Cred_27325 vout3.$1358.Metal3 VSS.$1624.Metal1 0.00744117f
Cred_27326 vout3.$1358.Metal3 VSS.$1990.Metal1 0.000322024f
Cred_27327 vout3.$1358.Metal3 VSS.$3260.Metal2 0.0124009f
Cred_27328 vout3.$1358.Metal3 VSS.$3292.Metal2 0.0124042f
Cred_27329 vout3.$1358.Metal3 VSS.$3344.Metal2 0.00263196f
Cred_27330 vout3.$1358.Metal3 VSS.$3392.Metal2 0.00191584f
Cred_27331 vout3.$1358.Metal3 VSS.$3435.Metal2 0.0744197f
Cred_27332 vout3.$1358.Metal3 VSS.$3451.Metal2 3.65954e-06f
Cred_27333 vout3.$1358.Metal3 VSS.$3507.Metal2 0.00210861f
Cred_27334 vout3.$1358.Metal3 VSS.$3555.Metal2 0.00746885f
Cred_27335 vout3.$1358.Metal3 VSS.$3603.Metal2 0.00254692f
Cred_27336 vout3.$1358.Metal3 VSS.$3638.Metal2 0.0665862f
Cred_27337 vout3.$1358.Metal3 VSS.$3694.Metal2 1.90312e-05f
Cred_27338 vout3.$1358.Metal3 VSS.$3718.Metal2 0.00358886f
Cred_27339 vout3.$1358.Metal3 VSS.$3766.Metal2 0.000907258f
Cred_27340 vout3.$1358.Metal3 VSS.$3809.Metal2 0.0211502f
Cred_27341 vout3.$1358.Metal3 VSS.$4802.Metal3 0.000413099f
Cred_27342 vout3.$1358.Metal3 VSS.$4838.Metal3 0.00343198f
Cred_27343 vout3.$1358.Metal3 VSS.$4862.Metal3 0.00572008f
Cred_27344 vout3.$1358.Metal3 VSS.$4886.Metal3 0.00289329f
Cred_27345 vout3.$1358.Metal3 VSS.$4910.Metal3 0.00423897f
Cred_27346 vout3.$1358.Metal3 VSS.$4934.Metal3 0.0111616f
Cred_27347 vout3.$1358.Metal3 VSS.$4958.Metal3 0.00960187f
Cred_27348 vout3.$1358.Metal3 VSS.$4994.Metal3 0.00574692f
Cred_27349 vout3.$1358.Metal3 VSS.$5030.Metal3 0.00653928f
Cred_27350 vout3.$1358.Metal3 VSS.$5054.Metal3 0.00184593f
Cred_27351 vout3.$1358.Metal3 VSS.$68.Metal1 3.84174e-05f
Cred_27352 vout3.$1358.Metal3 VSS.P2.pSD 0.0176616f
Cred_27353 vout3.$1358.Metal3 VSS.P3.pSD 1.6786e-06f
Cred_27354 vout3.$1358.Metal3 VSS.P59.nSD 0.000256773f
Cred_27355 vout3.$1358.Metal3 VSS.P61.nSD 0.000795954f
Cred_27356 vout3.$1358.Metal3 VSS.P63.nSD 0.000791895f
Cred_27357 vout3.$1358.Metal3 VSS.P65.nSD 0.000255761f
Cred_27358 vout3.$1358.Metal3 VSS.P83.nSD 9.35106e-07f
Cred_27359 vout3.$1358.Metal3 VSS.P87.nSD 3.67396e-07f
Cred_27360 vout3.$1424.Metal3 VSS.$1445.Metal1 0.00740803f
Cred_27361 vout3.$1424.Metal3 VSS.$1546.Metal1 0.00231387f
Cred_27362 vout3.$1424.Metal3 VSS.$1566.Metal1 0.00253681f
Cred_27363 vout3.$1424.Metal3 VSS.$1586.Metal1 0.000320707f
Cred_27364 vout3.$1424.Metal3 VSS.$1624.Metal1 0.0229209f
Cred_27365 vout3.$1424.Metal3 VSS.$1725.Metal1 0.00434536f
Cred_27366 vout3.$1424.Metal3 VSS.$1745.Metal1 0.00614587f
Cred_27367 vout3.$1424.Metal3 VSS.$1773.Metal1 0.000427491f
Cred_27368 vout3.$1424.Metal3 VSS.$1799.Metal1 0.0276485f
Cred_27369 vout3.$1424.Metal3 VSS.$1884.Metal1 0.00117674f
Cred_27370 vout3.$1424.Metal3 VSS.$1912.Metal1 0.00543474f
Cred_27371 vout3.$1424.Metal3 VSS.$1932.Metal1 0.0011013f
Cred_27372 vout3.$1424.Metal3 VSS.$1990.Metal1 0.010504f
Cred_27373 vout3.$1424.Metal3 VSS.$2022.Metal1 0.0113133f
Cred_27374 vout3.$1424.Metal3 VSS.$3603.Metal2 0.000904453f
Cred_27375 vout3.$1424.Metal3 VSS.$3638.Metal2 0.023774f
Cred_27376 vout3.$1424.Metal3 VSS.$3694.Metal2 1.90312e-05f
Cred_27377 vout3.$1424.Metal3 VSS.$3718.Metal2 0.00358886f
Cred_27378 vout3.$1424.Metal3 VSS.$3766.Metal2 0.000907258f
Cred_27379 vout3.$1424.Metal3 VSS.$3809.Metal2 0.0743958f
Cred_27380 vout3.$1424.Metal3 VSS.$3825.Metal2 8.45788e-06f
Cred_27381 vout3.$1424.Metal3 VSS.$3881.Metal2 0.0044325f
Cred_27382 vout3.$1424.Metal3 VSS.$3929.Metal2 0.00512114f
Cred_27383 vout3.$1424.Metal3 VSS.$3988.Metal2 0.0457973f
Cred_27384 vout3.$1424.Metal3 VSS.$4020.Metal2 0.034108f
Cred_27385 vout3.$1424.Metal3 VSS.$4068.Metal2 0.00458042f
Cred_27386 vout3.$1424.Metal3 VSS.$4116.Metal2 0.00279192f
Cred_27387 vout3.$1424.Metal3 VSS.$4140.Metal2 2.03212e-05f
Cred_27388 vout3.$1424.Metal3 VSS.$4174.Metal2 0.0872292f
Cred_27389 vout3.$1424.Metal3 VSS.$4958.Metal3 0.000221663f
Cred_27390 vout3.$1424.Metal3 VSS.$4994.Metal3 0.0040713f
Cred_27391 vout3.$1424.Metal3 VSS.$5030.Metal3 0.00653928f
Cred_27392 vout3.$1424.Metal3 VSS.$5054.Metal3 0.00290082f
Cred_27393 vout3.$1424.Metal3 VSS.$5078.Metal3 0.0058746f
Cred_27394 vout3.$1424.Metal3 VSS.$5102.Metal3 0.0114749f
Cred_27395 vout3.$1424.Metal3 VSS.$5126.Metal3 0.00750822f
Cred_27396 vout3.$1424.Metal3 VSS.$5162.Metal3 0.00654111f
Cred_27397 vout3.$1424.Metal3 VSS.$5186.Metal3 0.0105855f
Cred_27398 vout3.$1424.Metal3 VSS.$5222.Metal3 0.00455994f
Cred_27399 vout3.$1424.Metal3 VSS.$5234.Metal3 0.00160613f
Cred_27400 vout3.$1424.Metal3 VSS.$5246.Metal3 0.00200661f
Cred_27401 vout3.$1424.Metal3 VSS.$5258.Metal3 0.00200661f
Cred_27402 vout3.$1424.Metal3 VSS.$5270.Metal3 0.00200661f
Cred_27403 vout3.$1424.Metal3 VSS.$5282.Metal3 0.0248253f
Cred_27404 vout3.$1424.Metal3 VSS.$68.Metal1 1.57372e-05f
Cred_27405 vout3.$1424.Metal3 VSS.P2.pSD 0.0486156f
Cred_27406 vout3.$1424.Metal3 VSS.P3.pSD 9.80574e-07f
Cred_27407 vout3.$1424.Metal3 VSS.P5.GatPoly 0.0031769f
Cred_27408 vout3.$1424.Metal3 VSS.P63.nSD 0.000254285f
Cred_27409 vout3.$1424.Metal3 VSS.P65.nSD 0.000787928f
Cred_27410 vout3.$1424.Metal3 VSS.P67.nSD 0.0009467f
Cred_27411 vout3.$1424.Metal3 VSS.P69.nSD 5.69585e-05f
Cred_27412 vout3.$1424.Metal3 VSS.P71.nSD 5.69585e-05f
Cred_27413 vout3.$1424.Metal3 VSS.P87.nSD 1.3119e-07f
Cred_27414 vout3.$1424.Metal3 VSS.P91.nSD 2.94764e-06f
Cred_27415 vout3.P0.nSD VSS.$159.Metal1 0.00780722f
Cred_27416 vout3.P0.nSD VSS.$1990.Metal1 9.79445e-08f
Cred_27417 vout3.P0.nSD VSS.$2238.Metal2 0.0067111f
Cred_27418 vout3.P0.nSD VSS.$2409.Metal2 3.65768e-07f
Cred_27419 vout3.P0.nSD VSS.$2433.Metal2 0.00117467f
Cred_27420 vout3.P0.nSD VSS.$2481.Metal2 0.00193838f
Cred_27421 vout3.P0.nSD VSS.$2532.Metal2 0.00439121f
Cred_27422 vout3.P0.nSD VSS.$2564.Metal2 0.00589656f
Cred_27423 vout3.P0.nSD VSS.$2620.Metal2 6.21494e-05f
Cred_27424 vout3.P0.nSD VSS.$2668.Metal2 5.37922e-05f
Cred_27425 vout3.P0.nSD VSS.$2711.Metal2 0.00060636f
Cred_27426 vout3.P0.nSD VSS.$2727.Metal2 1.02644e-07f
Cred_27427 vout3.P0.nSD VSS.$312.Metal1 0.00120282f
Cred_27428 vout3.P0.nSD VSS.$332.Metal1 0.00403006f
Cred_27429 vout3.P0.nSD VSS.$360.Metal1 0.00085959f
Cred_27430 vout3.P0.nSD VSS.$386.Metal1 0.0118033f
Cred_27431 vout3.P0.nSD VSS.$4418.Metal3 4.56197e-05f
Cred_27432 vout3.P0.nSD VSS.$4454.Metal3 0.000493588f
Cred_27433 vout3.P0.nSD VSS.$4478.Metal3 0.000239325f
Cred_27434 vout3.P0.nSD VSS.$4514.Metal3 0.000110923f
Cred_27435 vout3.P0.nSD VSS.$4538.Metal3 0.000139258f
Cred_27436 vout3.P0.nSD VSS.$4562.Metal3 7.12933e-05f
Cred_27437 vout3.P0.nSD VSS.$4586.Metal3 1.2802e-05f
Cred_27438 vout3.P0.nSD VSS.$471.Metal1 5.18797e-06f
Cred_27439 vout3.P0.nSD VSS.$499.Metal1 7.45854e-05f
Cred_27440 vout3.P0.nSD VSS.$519.Metal1 5.27347e-05f
Cred_27441 vout3.P0.nSD VSS.$565.Metal1 0.000184482f
Cred_27442 vout3.P0.nSD VSS.$68.Metal1 4.13799e-05f
Cred_27443 vout3.P0.nSD VSS.P2.pSD 0.000291843f
Cred_27444 vout3.P0.nSD VSS.P3.pSD 5.28629e-07f
Cred_27445 vout3.P0.nSD VSS.P4.GatPoly 4.696e-05f
Cred_27446 vout3.P0.nSD VSS.P48.nSD 4.31259e-05f
Cred_27447 vout3.P0.nSD VSS.P49.nSD 4.31259e-05f
Cred_27448 vout3.P0.nSD VSS.P51.nSD 0.000405f
Cred_27449 vout3.P0.nSD VSS.P53.nSD 6.34094e-06f
Cred_27450 vout3.P0.nSD VSS.P75.nSD 3.79647e-07f
Cred_27451 vout3.P0.pSD VSS.$159.Metal1 0.00137607f
Cred_27452 vout3.P0.pSD VSS.$1990.Metal1 5.20461e-07f
Cred_27453 vout3.P0.pSD VSS.$2238.Metal2 0.00540512f
Cred_27454 vout3.P0.pSD VSS.$2409.Metal2 1.10137e-06f
Cred_27455 vout3.P0.pSD VSS.$2433.Metal2 0.000440497f
Cred_27456 vout3.P0.pSD VSS.$2481.Metal2 0.000725434f
Cred_27457 vout3.P0.pSD VSS.$2532.Metal2 0.00398795f
Cred_27458 vout3.P0.pSD VSS.$2564.Metal2 0.00535418f
Cred_27459 vout3.P0.pSD VSS.$2620.Metal2 0.000330252f
Cred_27460 vout3.P0.pSD VSS.$2668.Metal2 0.000285843f
Cred_27461 vout3.P0.pSD VSS.$2711.Metal2 0.0032221f
Cred_27462 vout3.P0.pSD VSS.$2727.Metal2 5.45431e-07f
Cred_27463 vout3.P0.pSD VSS.$312.Metal1 0.00017442f
Cred_27464 vout3.P0.pSD VSS.$332.Metal1 0.000860738f
Cred_27465 vout3.P0.pSD VSS.$360.Metal1 0.000186369f
Cred_27466 vout3.P0.pSD VSS.$386.Metal1 0.00304994f
Cred_27467 vout3.P0.pSD VSS.$4418.Metal3 0.000137366f
Cred_27468 vout3.P0.pSD VSS.$4454.Metal3 0.00146707f
Cred_27469 vout3.P0.pSD VSS.$4478.Metal3 0.000984693f
Cred_27470 vout3.P0.pSD VSS.$4514.Metal3 0.000589425f
Cred_27471 vout3.P0.pSD VSS.$4538.Metal3 0.000739994f
Cred_27472 vout3.P0.pSD VSS.$4562.Metal3 0.000378841f
Cred_27473 vout3.P0.pSD VSS.$4586.Metal3 6.80277e-05f
Cred_27474 vout3.P0.pSD VSS.$471.Metal1 2.7568e-05f
Cred_27475 vout3.P0.pSD VSS.$499.Metal1 0.000396335f
Cred_27476 vout3.P0.pSD VSS.$519.Metal1 0.000280223f
Cred_27477 vout3.P0.pSD VSS.$565.Metal1 0.000980307f
Cred_27478 vout3.P0.pSD VSS.$68.Metal1 0.000219886f
Cred_27479 vout3.P0.pSD VSS.P2.pSD 0.00154813f
Cred_27480 vout3.P0.pSD VSS.P3.pSD 1.30772e-07f
Cred_27481 vout3.P0.pSD VSS.P4.GatPoly 0.000147922f
Cred_27482 vout3.P0.pSD VSS.P48.nSD 7.30234e-06f
Cred_27483 vout3.P0.pSD VSS.P49.nSD 7.30234e-06f
Cred_27484 vout3.P0.pSD VSS.P51.nSD 0.000104487f
Cred_27485 vout3.P0.pSD VSS.P53.nSD 3.36947e-05f
Cred_27486 vout3.P0.pSD VSS.P75.nSD 3.44617e-07f
Cred_27487 vout3.P10.nSD VSS 0.0101413f
Cred_27488 vout3.P10.nSD VSS.$1200.Metal1 0.00304576f
Cred_27489 vout3.P10.nSD VSS.$1220.Metal1 0.00295783f
Cred_27490 vout3.P10.nSD VSS.$1266.Metal1 0.0105932f
Cred_27491 vout3.P10.nSD VSS.$1990.Metal1 5.21645e-07f
Cred_27492 vout3.P10.nSD VSS.$3260.Metal2 0.00404459f
Cred_27493 vout3.P10.nSD VSS.$3292.Metal2 0.00404464f
Cred_27494 vout3.P10.nSD VSS.$3344.Metal2 0.00167822f
Cred_27495 vout3.P10.nSD VSS.$3392.Metal2 0.00122058f
Cred_27496 vout3.P10.nSD VSS.$3435.Metal2 0.00801866f
Cred_27497 vout3.P10.nSD VSS.$3451.Metal2 5.76525e-08f
Cred_27498 vout3.P10.nSD VSS.$4802.Metal3 6.50798e-06f
Cred_27499 vout3.P10.nSD VSS.$4838.Metal3 8.57235e-05f
Cred_27500 vout3.P10.nSD VSS.$4862.Metal3 0.000224555f
Cred_27501 vout3.P10.nSD VSS.$4886.Metal3 6.72879e-05f
Cred_27502 vout3.P10.nSD VSS.$4910.Metal3 7.19059e-06f
Cred_27503 vout3.P10.nSD VSS.$68.Metal1 2.59156e-07f
Cred_27504 vout3.P10.nSD VSS.P2.pSD 6.64122e-05f
Cred_27505 vout3.P10.nSD VSS.P59.nSD 0.000347331f
Cred_27506 vout3.P10.nSD VSS.P61.nSD 0.000363808f
Cred_27507 vout3.P10.nSD VSS.P83.nSD 3.05065e-07f
Cred_27508 vout3.P10.pSD VSS 0.000640587f
Cred_27509 vout3.P10.pSD VSS.$1200.Metal1 0.000224296f
Cred_27510 vout3.P10.pSD VSS.$1220.Metal1 0.000219193f
Cred_27511 vout3.P10.pSD VSS.$1266.Metal1 0.000634918f
Cred_27512 vout3.P10.pSD VSS.$1990.Metal1 2.82527e-06f
Cred_27513 vout3.P10.pSD VSS.$3260.Metal2 0.00105811f
Cred_27514 vout3.P10.pSD VSS.$3292.Metal2 0.00105839f
Cred_27515 vout3.P10.pSD VSS.$3344.Metal2 0.000224572f
Cred_27516 vout3.P10.pSD VSS.$3392.Metal2 0.000163469f
Cred_27517 vout3.P10.pSD VSS.$3435.Metal2 0.00180464f
Cred_27518 vout3.P10.pSD VSS.$3451.Metal2 3.1225e-07f
Cred_27519 vout3.P10.pSD VSS.$4802.Metal3 3.52477e-05f
Cred_27520 vout3.P10.pSD VSS.$4838.Metal3 0.000292834f
Cred_27521 vout3.P10.pSD VSS.$4862.Metal3 0.000488067f
Cred_27522 vout3.P10.pSD VSS.$4886.Metal3 0.00024687f
Cred_27523 vout3.P10.pSD VSS.$4910.Metal3 3.89447e-05f
Cred_27524 vout3.P10.pSD VSS.$68.Metal1 1.40361e-06f
Cred_27525 vout3.P10.pSD VSS.P2.pSD 0.000359693f
Cred_27526 vout3.P10.pSD VSS.P59.nSD 2.19092e-05f
Cred_27527 vout3.P10.pSD VSS.P61.nSD 2.18228e-05f
Cred_27528 vout3.P10.pSD VSS.P83.nSD 7.9788e-08f
Cred_27529 vout3.P12.nSD VSS.$1266.Metal1 0.0100067f
Cred_27530 vout3.P12.nSD VSS.$1359.Metal1 8.08366e-07f
Cred_27531 vout3.P12.nSD VSS.$1379.Metal1 0.00441278f
Cred_27532 vout3.P12.nSD VSS.$1407.Metal1 0.00149478f
Cred_27533 vout3.P12.nSD VSS.$1445.Metal1 0.0104783f
Cred_27534 vout3.P12.nSD VSS.$3435.Metal2 0.00772439f
Cred_27535 vout3.P12.nSD VSS.$3507.Metal2 0.000623847f
Cred_27536 vout3.P12.nSD VSS.$3555.Metal2 0.0022163f
Cred_27537 vout3.P12.nSD VSS.$3603.Metal2 0.000281085f
Cred_27538 vout3.P12.nSD VSS.$3638.Metal2 0.00740191f
Cred_27539 vout3.P12.nSD VSS.$4934.Metal3 0.000116547f
Cred_27540 vout3.P12.nSD VSS.$4958.Metal3 6.06927e-05f
Cred_27541 vout3.P12.nSD VSS.P2.pSD 9.13744e-07f
Cred_27542 vout3.P12.nSD VSS.P3.pSD 9.13744e-07f
Cred_27543 vout3.P12.nSD VSS.P61.nSD 0.000343017f
Cred_27544 vout3.P12.nSD VSS.P63.nSD 0.00035982f
Cred_27545 vout3.P12.nSD VSS.P87.nSD 4.08512e-08f
Cred_27546 vout3.P14.nSD VSS.$1445.Metal1 0.0100621f
Cred_27547 vout3.P14.nSD VSS.$1546.Metal1 0.00259801f
Cred_27548 vout3.P14.nSD VSS.$1566.Metal1 0.00288903f
Cred_27549 vout3.P14.nSD VSS.$1586.Metal1 0.000548125f
Cred_27550 vout3.P14.nSD VSS.$1624.Metal1 0.0105932f
Cred_27551 vout3.P14.nSD VSS.$1990.Metal1 2.38486e-06f
Cred_27552 vout3.P14.nSD VSS.$3603.Metal2 0.000299197f
Cred_27553 vout3.P14.nSD VSS.$3638.Metal2 0.00787818f
Cred_27554 vout3.P14.nSD VSS.$3694.Metal2 6.51011e-07f
Cred_27555 vout3.P14.nSD VSS.$3718.Metal2 0.00228389f
Cred_27556 vout3.P14.nSD VSS.$3766.Metal2 0.000577769f
Cred_27557 vout3.P14.nSD VSS.$3809.Metal2 0.00801866f
Cred_27558 vout3.P14.nSD VSS.$4958.Metal3 3.49209e-06f
Cred_27559 vout3.P14.nSD VSS.$4994.Metal3 0.000107941f
Cred_27560 vout3.P14.nSD VSS.$5030.Metal3 0.000240897f
Cred_27561 vout3.P14.nSD VSS.$5054.Metal3 2.90808e-05f
Cred_27562 vout3.P14.nSD VSS.$68.Metal1 7.16936e-08f
Cred_27563 vout3.P14.nSD VSS.P2.pSD 7.30662e-05f
Cred_27564 vout3.P14.nSD VSS.P63.nSD 0.000345093f
Cred_27565 vout3.P14.nSD VSS.P65.nSD 0.000363808f
Cred_27566 vout3.P14.nSD VSS.P87.nSD 4.34795e-08f
Cred_27567 vout3.P14.pSD VSS.$1445.Metal1 0.000632091f
Cred_27568 vout3.P14.pSD VSS.$1546.Metal1 0.000197431f
Cred_27569 vout3.P14.pSD VSS.$1566.Metal1 0.000216454f
Cred_27570 vout3.P14.pSD VSS.$1586.Metal1 2.73644e-05f
Cred_27571 vout3.P14.pSD VSS.$1624.Metal1 0.000634918f
Cred_27572 vout3.P14.pSD VSS.$1990.Metal1 1.29166e-05f
Cred_27573 vout3.P14.pSD VSS.$3603.Metal2 7.71726e-05f
Cred_27574 vout3.P14.pSD VSS.$3638.Metal2 0.00202852f
Cred_27575 vout3.P14.pSD VSS.$3694.Metal2 1.62384e-06f
Cred_27576 vout3.P14.pSD VSS.$3718.Metal2 0.00030622f
Cred_27577 vout3.P14.pSD VSS.$3766.Metal2 7.74118e-05f
Cred_27578 vout3.P14.pSD VSS.$3809.Metal2 0.00180464f
Cred_27579 vout3.P14.pSD VSS.$4958.Metal3 1.89134e-05f
Cred_27580 vout3.P14.pSD VSS.$4994.Metal3 0.000347384f
Cred_27581 vout3.P14.pSD VSS.$5030.Metal3 0.000557965f
Cred_27582 vout3.P14.pSD VSS.$5054.Metal3 0.000157504f
Cred_27583 vout3.P14.pSD VSS.$68.Metal1 3.88298e-07f
Cred_27584 vout3.P14.pSD VSS.P2.pSD 0.000395732f
Cred_27585 vout3.P14.pSD VSS.P63.nSD 2.16969e-05f
Cred_27586 vout3.P14.pSD VSS.P65.nSD 2.18228e-05f
Cred_27587 vout3.P14.pSD VSS.P87.nSD 1.11938e-08f
Cred_27588 vout3.P16.nSD VSS.$1624.Metal1 0.00980245f
Cred_27589 vout3.P16.nSD VSS.$1725.Metal1 0.00221157f
Cred_27590 vout3.P16.nSD VSS.$1745.Metal1 0.00350787f
Cred_27591 vout3.P16.nSD VSS.$1773.Metal1 0.00034694f
Cred_27592 vout3.P16.nSD VSS.$1799.Metal1 0.0103228f
Cred_27593 vout3.P16.nSD VSS.$3809.Metal2 0.00777963f
Cred_27594 vout3.P16.nSD VSS.$3881.Metal2 0.00131213f
Cred_27595 vout3.P16.nSD VSS.$3929.Metal2 0.00151725f
Cred_27596 vout3.P16.nSD VSS.$3988.Metal2 0.00438658f
Cred_27597 vout3.P16.nSD VSS.$4020.Metal2 0.0032666f
Cred_27598 vout3.P16.nSD VSS.$5078.Metal3 2.44203e-05f
Cred_27599 vout3.P16.nSD VSS.$5102.Metal3 0.000134441f
Cred_27600 vout3.P16.nSD VSS.$5126.Metal3 2.89426e-05f
Cred_27601 vout3.P16.nSD VSS.P2.pSD 2.12019e-07f
Cred_27602 vout3.P16.nSD VSS.P3.pSD 2.12019e-07f
Cred_27603 vout3.P16.nSD VSS.P65.nSD 0.000336657f
Cred_27604 vout3.P16.nSD VSS.P67.nSD 0.000353699f
Cred_27605 vout3.P16.nSD VSS.P91.nSD 2.82445e-07f
Cred_27606 vout3.P18.nSD VSS.$1799.Metal1 0.0106321f
Cred_27607 vout3.P18.nSD VSS.$1884.Metal1 0.0008333f
Cred_27608 vout3.P18.nSD VSS.$1912.Metal1 0.00390865f
Cred_27609 vout3.P18.nSD VSS.$1932.Metal1 0.00117822f
Cred_27610 vout3.P18.nSD VSS.$1990.Metal1 0.000176354f
Cred_27611 vout3.P18.nSD VSS.$2022.Metal1 0.00766697f
Cred_27612 vout3.P18.nSD VSS.$3988.Metal2 0.00502884f
Cred_27613 vout3.P18.nSD VSS.$4020.Metal2 0.00374499f
Cred_27614 vout3.P18.nSD VSS.$4068.Metal2 0.00183604f
Cred_27615 vout3.P18.nSD VSS.$4116.Metal2 0.0011127f
Cred_27616 vout3.P18.nSD VSS.$4140.Metal2 4.20991e-07f
Cred_27617 vout3.P18.nSD VSS.$4174.Metal2 0.00707783f
Cred_27618 vout3.P18.nSD VSS.$5126.Metal3 1.05235e-05f
Cred_27619 vout3.P18.nSD VSS.$5162.Metal3 0.000124745f
Cred_27620 vout3.P18.nSD VSS.$5186.Metal3 0.000307469f
Cred_27621 vout3.P18.nSD VSS.$5222.Metal3 8.4416e-05f
Cred_27622 vout3.P18.nSD VSS.$5234.Metal3 4.48719e-05f
Cred_27623 vout3.P18.nSD VSS.$5246.Metal3 5.60606e-05f
Cred_27624 vout3.P18.nSD VSS.$5258.Metal3 5.60606e-05f
Cred_27625 vout3.P18.nSD VSS.$5270.Metal3 5.60606e-05f
Cred_27626 vout3.P18.nSD VSS.$5282.Metal3 0.000693567f
Cred_27627 vout3.P18.nSD VSS.$68.Metal1 1.11023e-07f
Cred_27628 vout3.P18.nSD VSS.P2.pSD 0.000596822f
Cred_27629 vout3.P18.nSD VSS.P3.pSD 5.09388e-07f
Cred_27630 vout3.P18.nSD VSS.P5.GatPoly 7.51285e-05f
Cred_27631 vout3.P18.nSD VSS.P67.nSD 0.000364826f
Cred_27632 vout3.P18.nSD VSS.P69.nSD 4.23149e-05f
Cred_27633 vout3.P18.nSD VSS.P71.nSD 4.23149e-05f
Cred_27634 vout3.P18.nSD VSS.P91.nSD 3.23794e-07f
Cred_27635 vout3.P18.pSD VSS.$1799.Metal1 0.0010348f
Cred_27636 vout3.P18.pSD VSS.$1884.Metal1 0.000100406f
Cred_27637 vout3.P18.pSD VSS.$1912.Metal1 0.00046372f
Cred_27638 vout3.P18.pSD VSS.$1932.Metal1 9.39683e-05f
Cred_27639 vout3.P18.pSD VSS.$1990.Metal1 0.000833315f
Cred_27640 vout3.P18.pSD VSS.$2022.Metal1 0.000965309f
Cred_27641 vout3.P18.pSD VSS.$3988.Metal2 0.00173901f
Cred_27642 vout3.P18.pSD VSS.$4020.Metal2 0.00129558f
Cred_27643 vout3.P18.pSD VSS.$4068.Metal2 0.000390825f
Cred_27644 vout3.P18.pSD VSS.$4116.Metal2 0.000238221f
Cred_27645 vout3.P18.pSD VSS.$4140.Metal2 1.7339e-06f
Cred_27646 vout3.P18.pSD VSS.$4174.Metal2 0.00744284f
Cred_27647 vout3.P18.pSD VSS.$5126.Metal3 5.69961e-05f
Cred_27648 vout3.P18.pSD VSS.$5162.Metal3 0.000489482f
Cred_27649 vout3.P18.pSD VSS.$5186.Metal3 0.000903207f
Cred_27650 vout3.P18.pSD VSS.$5222.Metal3 0.000389077f
Cred_27651 vout3.P18.pSD VSS.$5234.Metal3 0.000137043f
Cred_27652 vout3.P18.pSD VSS.$5246.Metal3 0.000171214f
Cred_27653 vout3.P18.pSD VSS.$5258.Metal3 0.000171214f
Cred_27654 vout3.P18.pSD VSS.$5270.Metal3 0.000171214f
Cred_27655 vout3.P18.pSD VSS.$5282.Metal3 0.00211822f
Cred_27656 vout3.P18.pSD VSS.$68.Metal1 5.7536e-07f
Cred_27657 vout3.P18.pSD VSS.P2.pSD 0.00300763f
Cred_27658 vout3.P18.pSD VSS.P3.pSD 6.13769e-08f
Cred_27659 vout3.P18.pSD VSS.P5.GatPoly 0.000271069f
Cred_27660 vout3.P18.pSD VSS.P67.nSD 3.54552e-05f
Cred_27661 vout3.P18.pSD VSS.P69.nSD 4.85999e-06f
Cred_27662 vout3.P18.pSD VSS.P71.nSD 4.85999e-06f
Cred_27663 vout3.P18.pSD VSS.P91.nSD 1.11943e-07f
Cred_27664 vout3.P2.nSD VSS.$159.Metal1 0.000137008f
Cred_27665 vout3.P2.nSD VSS.$1990.Metal1 7.89013e-08f
Cred_27666 vout3.P2.nSD VSS.$2238.Metal2 0.000538159f
Cred_27667 vout3.P2.nSD VSS.$2409.Metal2 1.09658e-07f
Cred_27668 vout3.P2.nSD VSS.$2433.Metal2 4.3858e-05f
Cred_27669 vout3.P2.nSD VSS.$2481.Metal2 7.22277e-05f
Cred_27670 vout3.P2.nSD VSS.$2532.Metal2 0.00384063f
Cred_27671 vout3.P2.nSD VSS.$2564.Metal2 0.00515731f
Cred_27672 vout3.P2.nSD VSS.$2620.Metal2 0.00158486f
Cred_27673 vout3.P2.nSD VSS.$2668.Metal2 0.00137065f
Cred_27674 vout3.P2.nSD VSS.$2711.Metal2 0.00828853f
Cred_27675 vout3.P2.nSD VSS.$2727.Metal2 1.11663e-07f
Cred_27676 vout3.P2.nSD VSS.$312.Metal1 1.73661e-05f
Cred_27677 vout3.P2.nSD VSS.$332.Metal1 8.56992e-05f
Cred_27678 vout3.P2.nSD VSS.$360.Metal1 1.85558e-05f
Cred_27679 vout3.P2.nSD VSS.$386.Metal1 0.0102244f
Cred_27680 vout3.P2.nSD VSS.$4418.Metal3 1.36768e-05f
Cred_27681 vout3.P2.nSD VSS.$4454.Metal3 0.000146069f
Cred_27682 vout3.P2.nSD VSS.$4478.Metal3 9.80408e-05f
Cred_27683 vout3.P2.nSD VSS.$4514.Metal3 0.000123061f
Cred_27684 vout3.P2.nSD VSS.$4538.Metal3 0.000285935f
Cred_27685 vout3.P2.nSD VSS.$4562.Metal3 0.000101978f
Cred_27686 vout3.P2.nSD VSS.$4586.Metal3 1.39269e-05f
Cred_27687 vout3.P2.nSD VSS.$471.Metal1 0.000352583f
Cred_27688 vout3.P2.nSD VSS.$499.Metal1 0.00358901f
Cred_27689 vout3.P2.nSD VSS.$519.Metal1 0.00226894f
Cred_27690 vout3.P2.nSD VSS.$565.Metal1 0.00999173f
Cred_27691 vout3.P2.nSD VSS.$68.Metal1 2.51878e-05f
Cred_27692 vout3.P2.nSD VSS.P2.pSD 0.000205774f
Cred_27693 vout3.P2.nSD VSS.P3.pSD 2.26811e-07f
Cred_27694 vout3.P2.nSD VSS.P4.GatPoly 1.47278e-05f
Cred_27695 vout3.P2.nSD VSS.P48.nSD 7.27057e-07f
Cred_27696 vout3.P2.nSD VSS.P49.nSD 7.27057e-07f
Cred_27697 vout3.P2.nSD VSS.P51.nSD 0.000350828f
Cred_27698 vout3.P2.nSD VSS.P53.nSD 0.000343162f
Cred_27699 vout3.P2.nSD VSS.P75.nSD 3.32059e-07f
Cred_27700 vout3.P2.pSD VSS.$159.Metal1 0.00074878f
Cred_27701 vout3.P2.pSD VSS.$1990.Metal1 4.31214e-07f
Cred_27702 vout3.P2.pSD VSS.$2238.Metal2 0.00294116f
Cred_27703 vout3.P2.pSD VSS.$2409.Metal2 5.99303e-07f
Cred_27704 vout3.P2.pSD VSS.$2433.Metal2 0.000239694f
Cred_27705 vout3.P2.pSD VSS.$2481.Metal2 0.000394741f
Cred_27706 vout3.P2.pSD VSS.$2532.Metal2 0.00288252f
Cred_27707 vout3.P2.pSD VSS.$2564.Metal2 0.00387023f
Cred_27708 vout3.P2.pSD VSS.$2620.Metal2 0.000369507f
Cred_27709 vout3.P2.pSD VSS.$2668.Metal2 0.000319819f
Cred_27710 vout3.P2.pSD VSS.$2711.Metal2 0.00360509f
Cred_27711 vout3.P2.pSD VSS.$2727.Metal2 6.10263e-07f
Cred_27712 vout3.P2.pSD VSS.$312.Metal1 9.49098e-05f
Cred_27713 vout3.P2.pSD VSS.$332.Metal1 0.000468366f
Cred_27714 vout3.P2.pSD VSS.$360.Metal1 0.000101412f
Cred_27715 vout3.P2.pSD VSS.$386.Metal1 0.00221486f
Cred_27716 vout3.P2.pSD VSS.$4418.Metal3 7.47468e-05f
Cred_27717 vout3.P2.pSD VSS.$4454.Metal3 0.000798301f
Cred_27718 vout3.P2.pSD VSS.$4478.Metal3 0.000535816f
Cred_27719 vout3.P2.pSD VSS.$4514.Metal3 0.00051438f
Cred_27720 vout3.P2.pSD VSS.$4538.Metal3 0.000827952f
Cred_27721 vout3.P2.pSD VSS.$4562.Metal3 0.000423871f
Cred_27722 vout3.P2.pSD VSS.$4586.Metal3 7.61138e-05f
Cred_27723 vout3.P2.pSD VSS.$471.Metal1 3.08449e-05f
Cred_27724 vout3.P2.pSD VSS.$499.Metal1 0.000443445f
Cred_27725 vout3.P2.pSD VSS.$519.Metal1 0.000313532f
Cred_27726 vout3.P2.pSD VSS.$565.Metal1 0.00109683f
Cred_27727 vout3.P2.pSD VSS.$68.Metal1 0.000137657f
Cred_27728 vout3.P2.pSD VSS.P2.pSD 0.00112344f
Cred_27729 vout3.P2.pSD VSS.P3.pSD 8.08415e-08f
Cred_27730 vout3.P2.pSD VSS.P4.GatPoly 8.0491e-05f
Cred_27731 vout3.P2.pSD VSS.P48.nSD 3.97353e-06f
Cred_27732 vout3.P2.pSD VSS.P49.nSD 3.97353e-06f
Cred_27733 vout3.P2.pSD VSS.P51.nSD 7.58842e-05f
Cred_27734 vout3.P2.pSD VSS.P53.nSD 3.76998e-05f
Cred_27735 vout3.P2.pSD VSS.P75.nSD 2.49128e-07f
Cred_27736 vout3.P4.nSD VSS.$2711.Metal2 0.00784765f
Cred_27737 vout3.P4.nSD VSS.$2783.Metal2 0.000563476f
Cred_27738 vout3.P4.nSD VSS.$2831.Metal2 0.00222735f
Cred_27739 vout3.P4.nSD VSS.$2855.Metal2 3.51192e-07f
Cred_27740 vout3.P4.nSD VSS.$2914.Metal2 0.00740191f
Cred_27741 vout3.P4.nSD VSS.$2946.Metal2 0.000281085f
Cred_27742 vout3.P4.nSD VSS.$4610.Metal3 0.000137876f
Cred_27743 vout3.P4.nSD VSS.$4646.Metal3 4.38017e-05f
Cred_27744 vout3.P4.nSD VSS.$565.Metal1 0.0106279f
Cred_27745 vout3.P4.nSD VSS.$658.Metal1 0.000543073f
Cred_27746 vout3.P4.nSD VSS.$678.Metal1 0.00284907f
Cred_27747 vout3.P4.nSD VSS.$698.Metal1 0.00256155f
Cred_27748 vout3.P4.nSD VSS.$744.Metal1 0.0104783f
Cred_27749 vout3.P4.nSD VSS.P53.nSD 0.000364561f
Cred_27750 vout3.P4.nSD VSS.P55.nSD 0.00035982f
Cred_27751 vout3.P4.nSD VSS.P79.nSD 4.08512e-08f
Cred_27752 vout3.P6.nSD VSS.$1990.Metal1 1.30542e-07f
Cred_27753 vout3.P6.nSD VSS.$2914.Metal2 0.00782404f
Cred_27754 vout3.P6.nSD VSS.$2946.Metal2 0.000297241f
Cred_27755 vout3.P6.nSD VSS.$2994.Metal2 0.00227228f
Cred_27756 vout3.P6.nSD VSS.$3042.Metal2 0.000639652f
Cred_27757 vout3.P6.nSD VSS.$3085.Metal2 0.00801853f
Cred_27758 vout3.P6.nSD VSS.$4646.Metal3 1.25593e-05f
Cred_27759 vout3.P6.nSD VSS.$4682.Metal3 0.000131f
Cred_27760 vout3.P6.nSD VSS.$4706.Metal3 0.000200207f
Cred_27761 vout3.P6.nSD VSS.$4730.Metal3 2.83514e-05f
Cred_27762 vout3.P6.nSD VSS.$68.Metal1 1.03084e-06f
Cred_27763 vout3.P6.nSD VSS.$744.Metal1 0.0101272f
Cred_27764 vout3.P6.nSD VSS.$837.Metal1 0.00151536f
Cred_27765 vout3.P6.nSD VSS.$865.Metal1 0.00447383f
Cred_27766 vout3.P6.nSD VSS.$885.Metal1 8.28756e-07f
Cred_27767 vout3.P6.nSD VSS.$923.Metal1 0.0105931f
Cred_27768 vout3.P6.nSD VSS.P2.pSD 6.69332e-05f
Cred_27769 vout3.P6.nSD VSS.P3.pSD 9.26325e-07f
Cred_27770 vout3.P6.nSD VSS.P55.nSD 0.000347109f
Cred_27771 vout3.P6.nSD VSS.P57.nSD 0.000363807f
Cred_27772 vout3.P6.nSD VSS.P79.nSD 4.31805e-08f
Cred_27773 vout3.P6.pSD VSS.$1990.Metal1 7.13444e-07f
Cred_27774 vout3.P6.pSD VSS.$2914.Metal2 0.00210216f
Cred_27775 vout3.P6.pSD VSS.$2946.Metal2 8.05124e-05f
Cred_27776 vout3.P6.pSD VSS.$2994.Metal2 0.000305951f
Cred_27777 vout3.P6.pSD VSS.$3042.Metal2 8.63764e-05f
Cred_27778 vout3.P6.pSD VSS.$3085.Metal2 0.00182035f
Cred_27779 vout3.P6.pSD VSS.$4646.Metal3 6.86395e-05f
Cred_27780 vout3.P6.pSD VSS.$4682.Metal3 0.000384247f
Cred_27781 vout3.P6.pSD VSS.$4706.Metal3 0.000457221f
Cred_27782 vout3.P6.pSD VSS.$4730.Metal3 0.000154947f
Cred_27783 vout3.P6.pSD VSS.$68.Metal1 5.63379e-06f
Cred_27784 vout3.P6.pSD VSS.$744.Metal1 0.00064532f
Cred_27785 vout3.P6.pSD VSS.$837.Metal1 0.000112486f
Cred_27786 vout3.P6.pSD VSS.$865.Metal1 0.000333648f
Cred_27787 vout3.P6.pSD VSS.$885.Metal1 1.11435e-07f
Cred_27788 vout3.P6.pSD VSS.$923.Metal1 0.000640445f
Cred_27789 vout3.P6.pSD VSS.P2.pSD 0.000360811f
Cred_27790 vout3.P6.pSD VSS.P3.pSD 6.87615e-08f
Cred_27791 vout3.P6.pSD VSS.P55.nSD 2.21399e-05f
Cred_27792 vout3.P6.pSD VSS.P57.nSD 2.20128e-05f
Cred_27793 vout3.P6.pSD VSS.P79.nSD 1.15988e-08f
Cred_27794 vout3.P8.nSD VSS 0.0107023f
Cred_27795 vout3.P8.nSD VSS.$1024.Metal1 0.00291736f
Cred_27796 vout3.P8.nSD VSS.$1044.Metal1 0.00300434f
Cred_27797 vout3.P8.nSD VSS.$3085.Metal2 0.00770015f
Cred_27798 vout3.P8.nSD VSS.$3157.Metal2 0.0011904f
Cred_27799 vout3.P8.nSD VSS.$3205.Metal2 0.00163676f
Cred_27800 vout3.P8.nSD VSS.$3260.Metal2 0.00384189f
Cred_27801 vout3.P8.nSD VSS.$3292.Metal2 0.00384189f
Cred_27802 vout3.P8.nSD VSS.$4754.Metal3 2.17069e-05f
Cred_27803 vout3.P8.nSD VSS.$4778.Metal3 0.000134441f
Cred_27804 vout3.P8.nSD VSS.$4802.Metal3 3.16559e-05f
Cred_27805 vout3.P8.nSD VSS.$923.Metal1 0.00979661f
Cred_27806 vout3.P8.nSD VSS.P57.nSD 0.000336456f
Cred_27807 vout3.P8.nSD VSS.P59.nSD 0.000366609f
Cred_27808 vout3.P8.nSD VSS.P83.nSD 2.89781e-07f
Cred_27809 vout4 VSS 0.135208f
Cred_27810 vout4 VSS.$1800.Metal1 0.00240463f
Cred_27811 vout4 VSS.$1878.Metal1 0.00028066f
Cred_27812 vout4 VSS.$1926.Metal1 0.00119602f
Cred_27813 vout4 VSS.$1986.Metal1 4.97681e-05f
Cred_27814 vout4 VSS.$1991.Metal1 0.00152863f
Cred_27815 vout4 VSS.$2023.Metal1 0.00609691f
Cred_27816 vout4 VSS.$4000.Metal2 0.00404105f
Cred_27817 vout4 VSS.$4032.Metal2 0.00301064f
Cred_27818 vout4 VSS.$4080.Metal2 0.000908986f
Cred_27819 vout4 VSS.$4128.Metal2 0.000554405f
Cred_27820 vout4 VSS.$4152.Metal2 4.4453e-06f
Cred_27821 vout4 VSS.$4213.Metal2 1.27156e-06f
Cred_27822 vout4 VSS.$4241.Metal2 0.0172824f
Cred_27823 vout4 VSS.$4271.Metal2 3.74901e-06f
Cred_27824 vout4 VSS.$5132.Metal3 0.000132446f
Cred_27825 vout4 VSS.$5168.Metal3 0.00113744f
Cred_27826 vout4 VSS.$5192.Metal3 0.00209884f
Cred_27827 vout4 VSS.$5228.Metal3 0.00106272f
Cred_27828 vout4 VSS.$5252.Metal3 0.000951156f
Cred_27829 vout4 VSS.$5279.Metal3 2.46529e-08f
Cred_27830 vout4 VSS.$5282.Metal3 5.54424e-05f
Cred_27831 vout4 VSS.$5288.Metal3 0.055872f
Cred_27832 vout4 VSS.$66.Metal1 2.52183e-06f
Cred_27833 vout4 VSS.P0.pSD 0.0104989f
Cred_27834 vout4 VSS.P1.GatPoly 0.000629903f
Cred_27835 vout4 VSS.P19.nSD 8.26499e-05f
Cred_27836 vout4 VSS.P21.nSD 1.10302e-05f
Cred_27837 vout4 VSS.P23.nSD 1.10302e-05f
Cred_27838 vout4.$1226.Metal3 VSS.$160.Metal1 0.00875304f
Cred_27839 vout4.$1226.Metal3 VSS.$1991.Metal1 8.27613e-06f
Cred_27840 vout4.$1226.Metal3 VSS.$2023.Metal1 2.07218e-05f
Cred_27841 vout4.$1226.Metal3 VSS.$2240.Metal2 0.0341062f
Cred_27842 vout4.$1226.Metal3 VSS.$2421.Metal2 9.06117e-06f
Cred_27843 vout4.$1226.Metal3 VSS.$2445.Metal2 0.00278813f
Cred_27844 vout4.$1226.Metal3 VSS.$2493.Metal2 0.00458873f
Cred_27845 vout4.$1226.Metal3 VSS.$2544.Metal2 0.0334809f
Cred_27846 vout4.$1226.Metal3 VSS.$2576.Metal2 0.0449534f
Cred_27847 vout4.$1226.Metal3 VSS.$2632.Metal2 0.00437245f
Cred_27848 vout4.$1226.Metal3 VSS.$266.Metal1 0.000251239f
Cred_27849 vout4.$1226.Metal3 VSS.$2680.Metal2 0.00379928f
Cred_27850 vout4.$1226.Metal3 VSS.$2739.Metal2 0.0650935f
Cred_27851 vout4.$1226.Metal3 VSS.$2771.Metal2 0.0285768f
Cred_27852 vout4.$1226.Metal3 VSS.$2795.Metal2 0.00192648f
Cred_27853 vout4.$1226.Metal3 VSS.$2843.Metal2 0.00757602f
Cred_27854 vout4.$1226.Metal3 VSS.$2867.Metal2 6.23475e-05f
Cred_27855 vout4.$1226.Metal3 VSS.$2926.Metal2 0.0657654f
Cred_27856 vout4.$1226.Metal3 VSS.$2958.Metal2 0.00250881f
Cred_27857 vout4.$1226.Metal3 VSS.$3006.Metal2 0.00355674f
Cred_27858 vout4.$1226.Metal3 VSS.$3054.Metal2 0.00101031f
Cred_27859 vout4.$1226.Metal3 VSS.$3078.Metal2 0.00490519f
Cred_27860 vout4.$1226.Metal3 VSS.$3113.Metal2 0.0162244f
Cred_27861 vout4.$1226.Metal3 VSS.$326.Metal1 0.00603775f
Cred_27862 vout4.$1226.Metal3 VSS.$374.Metal1 0.00141682f
Cred_27863 vout4.$1226.Metal3 VSS.$387.Metal1 0.0257815f
Cred_27864 vout4.$1226.Metal3 VSS.$4241.Metal2 5.54782e-08f
Cred_27865 vout4.$1226.Metal3 VSS.$4424.Metal3 0.000868144f
Cred_27866 vout4.$1226.Metal3 VSS.$4460.Metal3 0.00927183f
Cred_27867 vout4.$1226.Metal3 VSS.$4484.Metal3 0.00622321f
Cred_27868 vout4.$1226.Metal3 VSS.$4520.Metal3 0.0107065f
Cred_27869 vout4.$1226.Metal3 VSS.$4568.Metal3 0.0119988f
Cred_27870 vout4.$1226.Metal3 VSS.$4616.Metal3 0.0160831f
Cred_27871 vout4.$1226.Metal3 VSS.$465.Metal1 0.000930393f
Cred_27872 vout4.$1226.Metal3 VSS.$4652.Metal3 0.00935134f
Cred_27873 vout4.$1226.Metal3 VSS.$4688.Metal3 0.00492856f
Cred_27874 vout4.$1226.Metal3 VSS.$4712.Metal3 0.00619596f
Cred_27875 vout4.$1226.Metal3 VSS.$4760.Metal3 0.000885582f
Cred_27876 vout4.$1226.Metal3 VSS.$513.Metal1 0.00711959f
Cred_27877 vout4.$1226.Metal3 VSS.$553.Metal1 0.00108062f
Cred_27878 vout4.$1226.Metal3 VSS.$566.Metal1 0.0292739f
Cred_27879 vout4.$1226.Metal3 VSS.$66.Metal1 0.00273333f
Cred_27880 vout4.$1226.Metal3 VSS.$672.Metal1 0.00800819f
Cred_27881 vout4.$1226.Metal3 VSS.$740.Metal1 0.0026768f
Cred_27882 vout4.$1226.Metal3 VSS.$785.Metal1 0.0253105f
Cred_27883 vout4.$1226.Metal3 VSS.$831.Metal1 0.00142814f
Cred_27884 vout4.$1226.Metal3 VSS.$879.Metal1 0.00374972f
Cred_27885 vout4.$1226.Metal3 VSS.$924.Metal1 0.00747146f
Cred_27886 vout4.$1226.Metal3 VSS.P0.GatPoly 0.000934859f
Cred_27887 vout4.$1226.Metal3 VSS.P0.nSD 4.48919e-05f
Cred_27888 vout4.$1226.Metal3 VSS.P0.pSD 0.0262555f
Cred_27889 vout4.$1226.Metal3 VSS.P1.nSD 4.48919e-05f
Cred_27890 vout4.$1226.Metal3 VSS.P10.nSD 0.0002568f
Cred_27891 vout4.$1226.Metal3 VSS.P3.nSD 0.000886209f
Cred_27892 vout4.$1226.Metal3 VSS.P5.nSD 0.00100213f
Cred_27893 vout4.$1226.Metal3 VSS.P7.nSD 0.000139443f
Cred_27894 vout4.$1292.Metal3 VSS 0.0234977f
Cred_27895 vout4.$1292.Metal3 VSS.$1038.Metal1 0.00864164f
Cred_27896 vout4.$1292.Metal3 VSS.$1078.Metal1 0.00137119f
Cred_27897 vout4.$1292.Metal3 VSS.$1174.Metal1 0.000652614f
Cred_27898 vout4.$1292.Metal3 VSS.$1214.Metal1 0.00411295f
Cred_27899 vout4.$1292.Metal3 VSS.$1254.Metal1 0.000419648f
Cred_27900 vout4.$1292.Metal3 VSS.$1267.Metal1 0.00747422f
Cred_27901 vout4.$1292.Metal3 VSS.$1991.Metal1 2.75682e-05f
Cred_27902 vout4.$1292.Metal3 VSS.$2023.Metal1 6.90253e-05f
Cred_27903 vout4.$1292.Metal3 VSS.$2926.Metal2 0.0239438f
Cred_27904 vout4.$1292.Metal3 VSS.$2958.Metal2 0.000917199f
Cred_27905 vout4.$1292.Metal3 VSS.$3006.Metal2 0.00355674f
Cred_27906 vout4.$1292.Metal3 VSS.$3054.Metal2 0.0010141f
Cred_27907 vout4.$1292.Metal3 VSS.$3078.Metal2 0.0169873f
Cred_27908 vout4.$1292.Metal3 VSS.$3113.Metal2 0.0562725f
Cred_27909 vout4.$1292.Metal3 VSS.$3169.Metal2 0.00412732f
Cred_27910 vout4.$1292.Metal3 VSS.$3217.Metal2 0.00563603f
Cred_27911 vout4.$1292.Metal3 VSS.$3276.Metal2 0.0345933f
Cred_27912 vout4.$1292.Metal3 VSS.$3308.Metal2 0.0345896f
Cred_27913 vout4.$1292.Metal3 VSS.$3356.Metal2 0.00268245f
Cred_27914 vout4.$1292.Metal3 VSS.$3404.Metal2 0.00196438f
Cred_27915 vout4.$1292.Metal3 VSS.$3463.Metal2 0.0162287f
Cred_27916 vout4.$1292.Metal3 VSS.$3495.Metal2 0.00489635f
Cred_27917 vout4.$1292.Metal3 VSS.$3519.Metal2 1.80083e-06f
Cred_27918 vout4.$1292.Metal3 VSS.$4241.Metal2 1.84801e-07f
Cred_27919 vout4.$1292.Metal3 VSS.$4652.Metal3 0.000797211f
Cred_27920 vout4.$1292.Metal3 VSS.$4688.Metal3 0.00446283f
Cred_27921 vout4.$1292.Metal3 VSS.$4712.Metal3 0.00666787f
Cred_27922 vout4.$1292.Metal3 VSS.$4760.Metal3 0.0133508f
Cred_27923 vout4.$1292.Metal3 VSS.$4808.Metal3 0.0135383f
Cred_27924 vout4.$1292.Metal3 VSS.$4844.Metal3 0.00711484f
Cred_27925 vout4.$1292.Metal3 VSS.$4892.Metal3 0.00593279f
Cred_27926 vout4.$1292.Metal3 VSS.$4940.Metal3 0.000224605f
Cred_27927 vout4.$1292.Metal3 VSS.$66.Metal1 0.000208832f
Cred_27928 vout4.$1292.Metal3 VSS.$785.Metal1 0.00819691f
Cred_27929 vout4.$1292.Metal3 VSS.$831.Metal1 0.00142814f
Cred_27930 vout4.$1292.Metal3 VSS.$879.Metal1 0.00374972f
Cred_27931 vout4.$1292.Metal3 VSS.$924.Metal1 0.0229545f
Cred_27932 vout4.$1292.Metal3 VSS.$990.Metal1 0.000881713f
Cred_27933 vout4.$1292.Metal3 VSS.P0.pSD 0.0171991f
Cred_27934 vout4.$1292.Metal3 VSS.P10.nSD 0.000789078f
Cred_27935 vout4.$1292.Metal3 VSS.P11.nSD 0.000806486f
Cred_27936 vout4.$1292.Metal3 VSS.P13.nSD 0.000256895f
Cred_27937 vout4.$1292.Metal3 VSS.P7.nSD 4.4933e-05f
Cred_27938 vout4.$1358.Metal3 VSS 0.00750761f
Cred_27939 vout4.$1358.Metal3 VSS.$1174.Metal1 0.000652614f
Cred_27940 vout4.$1358.Metal3 VSS.$1214.Metal1 0.00411295f
Cred_27941 vout4.$1358.Metal3 VSS.$1254.Metal1 0.000419648f
Cred_27942 vout4.$1358.Metal3 VSS.$1267.Metal1 0.0232945f
Cred_27943 vout4.$1358.Metal3 VSS.$1373.Metal1 0.00788136f
Cred_27944 vout4.$1358.Metal3 VSS.$1421.Metal1 0.00300175f
Cred_27945 vout4.$1358.Metal3 VSS.$1483.Metal1 0.0252153f
Cred_27946 vout4.$1358.Metal3 VSS.$1512.Metal1 0.00127401f
Cred_27947 vout4.$1358.Metal3 VSS.$1580.Metal1 0.00381146f
Cred_27948 vout4.$1358.Metal3 VSS.$1625.Metal1 0.00753015f
Cred_27949 vout4.$1358.Metal3 VSS.$1991.Metal1 0.000116877f
Cred_27950 vout4.$1358.Metal3 VSS.$2023.Metal1 0.000292636f
Cred_27951 vout4.$1358.Metal3 VSS.$3276.Metal2 0.0124009f
Cred_27952 vout4.$1358.Metal3 VSS.$3308.Metal2 0.0124042f
Cred_27953 vout4.$1358.Metal3 VSS.$3356.Metal2 0.00268245f
Cred_27954 vout4.$1358.Metal3 VSS.$3404.Metal2 0.00196438f
Cred_27955 vout4.$1358.Metal3 VSS.$3463.Metal2 0.0571041f
Cred_27956 vout4.$1358.Metal3 VSS.$3495.Metal2 0.0172493f
Cred_27957 vout4.$1358.Metal3 VSS.$3519.Metal2 0.00212533f
Cred_27958 vout4.$1358.Metal3 VSS.$3567.Metal2 0.00747574f
Cred_27959 vout4.$1358.Metal3 VSS.$3615.Metal2 0.00249183f
Cred_27960 vout4.$1358.Metal3 VSS.$3650.Metal2 0.0651354f
Cred_27961 vout4.$1358.Metal3 VSS.$3706.Metal2 2.9674e-05f
Cred_27962 vout4.$1358.Metal3 VSS.$3730.Metal2 0.00360577f
Cred_27963 vout4.$1358.Metal3 VSS.$3778.Metal2 0.00091524f
Cred_27964 vout4.$1358.Metal3 VSS.$3802.Metal2 0.00645074f
Cred_27965 vout4.$1358.Metal3 VSS.$3837.Metal2 0.014681f
Cred_27966 vout4.$1358.Metal3 VSS.$4241.Metal2 7.83473e-07f
Cred_27967 vout4.$1358.Metal3 VSS.$4808.Metal3 0.000413099f
Cred_27968 vout4.$1358.Metal3 VSS.$4844.Metal3 0.00624688f
Cred_27969 vout4.$1358.Metal3 VSS.$4892.Metal3 0.00779416f
Cred_27970 vout4.$1358.Metal3 VSS.$4940.Metal3 0.0132476f
Cred_27971 vout4.$1358.Metal3 VSS.$4964.Metal3 0.00960187f
Cred_27972 vout4.$1358.Metal3 VSS.$5000.Metal3 0.00574692f
Cred_27973 vout4.$1358.Metal3 VSS.$5036.Metal3 0.00744765f
Cred_27974 vout4.$1358.Metal3 VSS.$5084.Metal3 0.000908368f
Cred_27975 vout4.$1358.Metal3 VSS.$66.Metal1 5.29641e-05f
Cred_27976 vout4.$1358.Metal3 VSS.P0.pSD 0.0175755f
Cred_27977 vout4.$1358.Metal3 VSS.P11.nSD 0.000257708f
Cred_27978 vout4.$1358.Metal3 VSS.P13.nSD 0.000799944f
Cred_27979 vout4.$1358.Metal3 VSS.P15.nSD 0.000139048f
Cred_27980 vout4.$1358.Metal3 VSS.P17.nSD 0.00025711f
Cred_27981 vout4.$1424.Metal3 VSS.$1483.Metal1 0.00810174f
Cred_27982 vout4.$1424.Metal3 VSS.$1512.Metal1 0.00127401f
Cred_27983 vout4.$1424.Metal3 VSS.$1580.Metal1 0.00381146f
Cred_27984 vout4.$1424.Metal3 VSS.$1625.Metal1 0.0231089f
Cred_27985 vout4.$1424.Metal3 VSS.$1699.Metal1 0.00128949f
Cred_27986 vout4.$1424.Metal3 VSS.$1739.Metal1 0.00849572f
Cred_27987 vout4.$1424.Metal3 VSS.$1787.Metal1 0.00111023f
Cred_27988 vout4.$1424.Metal3 VSS.$1800.Metal1 0.0276485f
Cred_27989 vout4.$1424.Metal3 VSS.$1878.Metal1 0.0014155f
Cred_27990 vout4.$1424.Metal3 VSS.$1926.Metal1 0.00603211f
Cred_27991 vout4.$1424.Metal3 VSS.$1986.Metal1 0.000251004f
Cred_27992 vout4.$1424.Metal3 VSS.$1991.Metal1 0.00381242f
Cred_27993 vout4.$1424.Metal3 VSS.$2023.Metal1 0.0209919f
Cred_27994 vout4.$1424.Metal3 VSS.$3615.Metal2 0.000886752f
Cred_27995 vout4.$1424.Metal3 VSS.$3650.Metal2 0.0233079f
Cred_27996 vout4.$1424.Metal3 VSS.$3706.Metal2 2.9674e-05f
Cred_27997 vout4.$1424.Metal3 VSS.$3730.Metal2 0.00360577f
Cred_27998 vout4.$1424.Metal3 VSS.$3778.Metal2 0.000919402f
Cred_27999 vout4.$1424.Metal3 VSS.$3802.Metal2 0.0226613f
Cred_28000 vout4.$1424.Metal3 VSS.$3837.Metal2 0.0516346f
Cred_28001 vout4.$1424.Metal3 VSS.$3893.Metal2 0.00453363f
Cred_28002 vout4.$1424.Metal3 VSS.$3941.Metal2 0.00521759f
Cred_28003 vout4.$1424.Metal3 VSS.$4000.Metal2 0.0457973f
Cred_28004 vout4.$1424.Metal3 VSS.$4032.Metal2 0.034108f
Cred_28005 vout4.$1424.Metal3 VSS.$4080.Metal2 0.00458445f
Cred_28006 vout4.$1424.Metal3 VSS.$4128.Metal2 0.00279613f
Cred_28007 vout4.$1424.Metal3 VSS.$4152.Metal2 2.24198e-05f
Cred_28008 vout4.$1424.Metal3 VSS.$4213.Metal2 6.41308e-06f
Cred_28009 vout4.$1424.Metal3 VSS.$4241.Metal2 0.0871371f
Cred_28010 vout4.$1424.Metal3 VSS.$4271.Metal2 1.8908e-05f
Cred_28011 vout4.$1424.Metal3 VSS.$4964.Metal3 0.000221663f
Cred_28012 vout4.$1424.Metal3 VSS.$5000.Metal3 0.0040713f
Cred_28013 vout4.$1424.Metal3 VSS.$5036.Metal3 0.00796675f
Cred_28014 vout4.$1424.Metal3 VSS.$5084.Metal3 0.012949f
Cred_28015 vout4.$1424.Metal3 VSS.$5132.Metal3 0.0131551f
Cred_28016 vout4.$1424.Metal3 VSS.$5168.Metal3 0.00654111f
Cred_28017 vout4.$1424.Metal3 VSS.$5192.Metal3 0.0105855f
Cred_28018 vout4.$1424.Metal3 VSS.$5228.Metal3 0.0053598f
Cred_28019 vout4.$1424.Metal3 VSS.$5252.Metal3 0.00479713f
Cred_28020 vout4.$1424.Metal3 VSS.$5288.Metal3 0.026816f
Cred_28021 vout4.$1424.Metal3 VSS.$66.Metal1 2.14302e-05f
Cred_28022 vout4.$1424.Metal3 VSS.P0.pSD 0.0457499f
Cred_28023 vout4.$1424.Metal3 VSS.P1.GatPoly 0.0031769f
Cred_28024 vout4.$1424.Metal3 VSS.P15.nSD 4.45375e-05f
Cred_28025 vout4.$1424.Metal3 VSS.P17.nSD 0.000792675f
Cred_28026 vout4.$1424.Metal3 VSS.P19.nSD 0.000949648f
Cred_28027 vout4.$1424.Metal3 VSS.P21.nSD 5.56306e-05f
Cred_28028 vout4.$1424.Metal3 VSS.P23.nSD 5.56306e-05f
Cred_28029 vout4.P0.nSD VSS.$160.Metal1 0.00782429f
Cred_28030 vout4.P0.nSD VSS.$1991.Metal1 3.51431e-08f
Cred_28031 vout4.P0.nSD VSS.$2023.Metal1 8.79912e-08f
Cred_28032 vout4.P0.nSD VSS.$2240.Metal2 0.00669665f
Cred_28033 vout4.P0.nSD VSS.$2421.Metal2 2.66139e-06f
Cred_28034 vout4.P0.nSD VSS.$2445.Metal2 0.00117928f
Cred_28035 vout4.P0.nSD VSS.$2493.Metal2 0.00194136f
Cred_28036 vout4.P0.nSD VSS.$2544.Metal2 0.00436661f
Cred_28037 vout4.P0.nSD VSS.$2576.Metal2 0.00586353f
Cred_28038 vout4.P0.nSD VSS.$2632.Metal2 6.33199e-05f
Cred_28039 vout4.P0.nSD VSS.$266.Metal1 0.000274567f
Cred_28040 vout4.P0.nSD VSS.$2680.Metal2 5.50195e-05f
Cred_28041 vout4.P0.nSD VSS.$2739.Metal2 0.000421423f
Cred_28042 vout4.P0.nSD VSS.$2771.Metal2 0.000184869f
Cred_28043 vout4.P0.nSD VSS.$2795.Metal2 5.05102e-08f
Cred_28044 vout4.P0.nSD VSS.$326.Metal1 0.00476631f
Cred_28045 vout4.P0.nSD VSS.$374.Metal1 0.0010383f
Cred_28046 vout4.P0.nSD VSS.$387.Metal1 0.0111038f
Cred_28047 vout4.P0.nSD VSS.$4241.Metal2 2.35578e-10f
Cred_28048 vout4.P0.nSD VSS.$4424.Metal3 4.56197e-05f
Cred_28049 vout4.P0.nSD VSS.$4460.Metal3 0.000493588f
Cred_28050 vout4.P0.nSD VSS.$4484.Metal3 0.000239325f
Cred_28051 vout4.P0.nSD VSS.$4520.Metal3 0.000179453f
Cred_28052 vout4.P0.nSD VSS.$4568.Metal3 0.000146123f
Cred_28053 vout4.P0.nSD VSS.$4616.Metal3 6.29978e-06f
Cred_28054 vout4.P0.nSD VSS.$465.Metal1 1.34735e-05f
Cred_28055 vout4.P0.nSD VSS.$513.Metal1 0.000103103f
Cred_28056 vout4.P0.nSD VSS.$553.Metal1 1.56491e-05f
Cred_28057 vout4.P0.nSD VSS.$566.Metal1 0.000195853f
Cred_28058 vout4.P0.nSD VSS.$66.Metal1 5.70572e-05f
Cred_28059 vout4.P0.nSD VSS.P0.GatPoly 4.696e-05f
Cred_28060 vout4.P0.nSD VSS.P0.nSD 4.18236e-05f
Cred_28061 vout4.P0.nSD VSS.P0.pSD 0.000280167f
Cred_28062 vout4.P0.nSD VSS.P1.nSD 4.18236e-05f
Cred_28063 vout4.P0.nSD VSS.P3.nSD 0.000381362f
Cred_28064 vout4.P0.nSD VSS.P5.nSD 6.73133e-06f
Cred_28065 vout4.P0.pSD VSS.$160.Metal1 0.00138499f
Cred_28066 vout4.P0.pSD VSS.$1991.Metal1 1.86745e-07f
Cred_28067 vout4.P0.pSD VSS.$2023.Metal1 4.67571e-07f
Cred_28068 vout4.P0.pSD VSS.$2240.Metal2 0.0053966f
Cred_28069 vout4.P0.pSD VSS.$2421.Metal2 1.43374e-06f
Cred_28070 vout4.P0.pSD VSS.$2445.Metal2 0.000441164f
Cred_28071 vout4.P0.pSD VSS.$2493.Metal2 0.000726072f
Cred_28072 vout4.P0.pSD VSS.$2544.Metal2 0.00398624f
Cred_28073 vout4.P0.pSD VSS.$2576.Metal2 0.00535189f
Cred_28074 vout4.P0.pSD VSS.$2632.Metal2 0.000336472f
Cred_28075 vout4.P0.pSD VSS.$266.Metal1 3.97533e-05f
Cred_28076 vout4.P0.pSD VSS.$2680.Metal2 0.000292364f
Cred_28077 vout4.P0.pSD VSS.$2739.Metal2 0.00223937f
Cred_28078 vout4.P0.pSD VSS.$2771.Metal2 0.000982363f
Cred_28079 vout4.P0.pSD VSS.$2795.Metal2 2.68403e-07f
Cred_28080 vout4.P0.pSD VSS.$326.Metal1 0.000955347f
Cred_28081 vout4.P0.pSD VSS.$374.Metal1 0.000224183f
Cred_28082 vout4.P0.pSD VSS.$387.Metal1 0.00300149f
Cred_28083 vout4.P0.pSD VSS.$4241.Metal2 1.25182e-09f
Cred_28084 vout4.P0.pSD VSS.$4424.Metal3 0.000137366f
Cred_28085 vout4.P0.pSD VSS.$4460.Metal3 0.00146707f
Cred_28086 vout4.P0.pSD VSS.$4484.Metal3 0.000984693f
Cred_28087 vout4.P0.pSD VSS.$4520.Metal3 0.000953582f
Cred_28088 vout4.P0.pSD VSS.$4568.Metal3 0.000776474f
Cred_28089 vout4.P0.pSD VSS.$4616.Metal3 3.3476e-05f
Cred_28090 vout4.P0.pSD VSS.$465.Metal1 7.15962e-05f
Cred_28091 vout4.P0.pSD VSS.$513.Metal1 0.000547871f
Cred_28092 vout4.P0.pSD VSS.$553.Metal1 8.31566e-05f
Cred_28093 vout4.P0.pSD VSS.$566.Metal1 0.00104073f
Cred_28094 vout4.P0.pSD VSS.$66.Metal1 0.000303192f
Cred_28095 vout4.P0.pSD VSS.P0.GatPoly 0.000147922f
Cred_28096 vout4.P0.pSD VSS.P0.nSD 7.1032e-06f
Cred_28097 vout4.P0.pSD VSS.P0.pSD 0.00146586f
Cred_28098 vout4.P0.pSD VSS.P1.nSD 7.1032e-06f
Cred_28099 vout4.P0.pSD VSS.P3.nSD 0.000103168f
Cred_28100 vout4.P0.pSD VSS.P5.nSD 3.57692e-05f
Cred_28101 vout4.P10.nSD VSS 0.0101413f
Cred_28102 vout4.P10.nSD VSS.$1174.Metal1 0.000756689f
Cred_28103 vout4.P10.nSD VSS.$1214.Metal1 0.00474861f
Cred_28104 vout4.P10.nSD VSS.$1254.Metal1 0.000483714f
Cred_28105 vout4.P10.nSD VSS.$1267.Metal1 0.0106057f
Cred_28106 vout4.P10.nSD VSS.$1991.Metal1 1.89326e-07f
Cred_28107 vout4.P10.nSD VSS.$2023.Metal1 4.74035e-07f
Cred_28108 vout4.P10.nSD VSS.$3276.Metal2 0.00404459f
Cred_28109 vout4.P10.nSD VSS.$3308.Metal2 0.00404464f
Cred_28110 vout4.P10.nSD VSS.$3356.Metal2 0.00168631f
Cred_28111 vout4.P10.nSD VSS.$3404.Metal2 0.00122639f
Cred_28112 vout4.P10.nSD VSS.$3463.Metal2 0.0061508f
Cred_28113 vout4.P10.nSD VSS.$3495.Metal2 0.00185504f
Cred_28114 vout4.P10.nSD VSS.$3519.Metal2 2.83704e-08f
Cred_28115 vout4.P10.nSD VSS.$4241.Metal2 1.26913e-09f
Cred_28116 vout4.P10.nSD VSS.$4808.Metal3 6.50798e-06f
Cred_28117 vout4.P10.nSD VSS.$4844.Metal3 0.000196229f
Cred_28118 vout4.P10.nSD VSS.$4892.Metal3 0.000181332f
Cred_28119 vout4.P10.nSD VSS.$4940.Metal3 3.53844e-06f
Cred_28120 vout4.P10.nSD VSS.$66.Metal1 3.57327e-07f
Cred_28121 vout4.P10.nSD VSS.P0.pSD 7.0402e-05f
Cred_28122 vout4.P10.nSD VSS.P11.nSD 0.000347636f
Cred_28123 vout4.P10.nSD VSS.P13.nSD 0.000364238f
Cred_28124 vout4.P10.pSD VSS 0.000640587f
Cred_28125 vout4.P10.pSD VSS.$1174.Metal1 5.56843e-05f
Cred_28126 vout4.P10.pSD VSS.$1214.Metal1 0.000350938f
Cred_28127 vout4.P10.pSD VSS.$1254.Metal1 3.58065e-05f
Cred_28128 vout4.P10.pSD VSS.$1267.Metal1 0.000637738f
Cred_28129 vout4.P10.pSD VSS.$1991.Metal1 1.0254e-06f
Cred_28130 vout4.P10.pSD VSS.$2023.Metal1 2.56741e-06f
Cred_28131 vout4.P10.pSD VSS.$3276.Metal2 0.00105811f
Cred_28132 vout4.P10.pSD VSS.$3308.Metal2 0.00105839f
Cred_28133 vout4.P10.pSD VSS.$3356.Metal2 0.00022888f
Cred_28134 vout4.P10.pSD VSS.$3404.Metal2 0.000167611f
Cred_28135 vout4.P10.pSD VSS.$3463.Metal2 0.00138472f
Cred_28136 vout4.P10.pSD VSS.$3495.Metal2 0.000417781f
Cred_28137 vout4.P10.pSD VSS.$3519.Metal2 1.53656e-07f
Cred_28138 vout4.P10.pSD VSS.$4241.Metal2 6.8737e-09f
Cred_28139 vout4.P10.pSD VSS.$4808.Metal3 3.52477e-05f
Cred_28140 vout4.P10.pSD VSS.$4844.Metal3 0.000533016f
Cred_28141 vout4.P10.pSD VSS.$4892.Metal3 0.000506216f
Cred_28142 vout4.P10.pSD VSS.$4940.Metal3 1.91644e-05f
Cred_28143 vout4.P10.pSD VSS.$66.Metal1 1.93531e-06f
Cred_28144 vout4.P10.pSD VSS.P0.pSD 0.000358699f
Cred_28145 vout4.P10.pSD VSS.P11.nSD 2.1989e-05f
Cred_28146 vout4.P10.pSD VSS.P13.nSD 2.19196e-05f
Cred_28147 vout4.P12.nSD VSS.$1267.Metal1 0.0100188f
Cred_28148 vout4.P12.nSD VSS.$1373.Metal1 0.00426979f
Cred_28149 vout4.P12.nSD VSS.$1421.Metal1 0.00163283f
Cred_28150 vout4.P12.nSD VSS.$1483.Metal1 0.0114595f
Cred_28151 vout4.P12.nSD VSS.$3463.Metal2 0.005925f
Cred_28152 vout4.P12.nSD VSS.$3495.Metal2 0.0017869f
Cred_28153 vout4.P12.nSD VSS.$3519.Metal2 0.000623845f
Cred_28154 vout4.P12.nSD VSS.$3567.Metal2 0.00222004f
Cred_28155 vout4.P12.nSD VSS.$3615.Metal2 0.000256048f
Cred_28156 vout4.P12.nSD VSS.$3650.Metal2 0.00674259f
Cred_28157 vout4.P12.nSD VSS.$4940.Metal3 0.000116547f
Cred_28158 vout4.P12.nSD VSS.$4964.Metal3 6.06927e-05f
Cred_28159 vout4.P12.nSD VSS.P0.pSD 3.83807e-06f
Cred_28160 vout4.P12.nSD VSS.P13.nSD 0.000343431f
Cred_28161 vout4.P12.nSD VSS.P15.nSD 6.29961e-05f
Cred_28162 vout4.P14.nSD VSS.$1483.Metal1 0.0110044f
Cred_28163 vout4.P14.nSD VSS.$1512.Metal1 0.00143608f
Cred_28164 vout4.P14.nSD VSS.$1580.Metal1 0.00447194f
Cred_28165 vout4.P14.nSD VSS.$1625.Metal1 0.0106935f
Cred_28166 vout4.P14.nSD VSS.$1991.Metal1 8.65575e-07f
Cred_28167 vout4.P14.nSD VSS.$2023.Metal1 2.16723e-06f
Cred_28168 vout4.P14.nSD VSS.$3615.Metal2 0.000275155f
Cred_28169 vout4.P14.nSD VSS.$3650.Metal2 0.00724505f
Cred_28170 vout4.P14.nSD VSS.$3706.Metal2 1.26477e-05f
Cred_28171 vout4.P14.nSD VSS.$3730.Metal2 0.00230297f
Cred_28172 vout4.P14.nSD VSS.$3778.Metal2 0.000579095f
Cred_28173 vout4.P14.nSD VSS.$3802.Metal2 0.00244074f
Cred_28174 vout4.P14.nSD VSS.$3837.Metal2 0.00556334f
Cred_28175 vout4.P14.nSD VSS.$4241.Metal2 5.8023e-09f
Cred_28176 vout4.P14.nSD VSS.$4964.Metal3 3.49209e-06f
Cred_28177 vout4.P14.nSD VSS.$5000.Metal3 0.000107941f
Cred_28178 vout4.P14.nSD VSS.$5036.Metal3 0.000255207f
Cred_28179 vout4.P14.nSD VSS.$5084.Metal3 1.43105e-05f
Cred_28180 vout4.P14.nSD VSS.$66.Metal1 9.87944e-08f
Cred_28181 vout4.P14.nSD VSS.P0.pSD 8.12896e-05f
Cred_28182 vout4.P14.nSD VSS.P15.nSD 6.00629e-05f
Cred_28183 vout4.P14.nSD VSS.P17.nSD 0.00036432f
Cred_28184 vout4.P14.pSD VSS.$1483.Metal1 0.000691282f
Cred_28185 vout4.P14.pSD VSS.$1512.Metal1 0.000108705f
Cred_28186 vout4.P14.pSD VSS.$1580.Metal1 0.000325213f
Cred_28187 vout4.P14.pSD VSS.$1625.Metal1 0.000642511f
Cred_28188 vout4.P14.pSD VSS.$1991.Metal1 4.68802e-06f
Cred_28189 vout4.P14.pSD VSS.$2023.Metal1 1.17378e-05f
Cred_28190 vout4.P14.pSD VSS.$3615.Metal2 7.56622e-05f
Cred_28191 vout4.P14.pSD VSS.$3650.Metal2 0.00198875f
Cred_28192 vout4.P14.pSD VSS.$3706.Metal2 2.53194e-06f
Cred_28193 vout4.P14.pSD VSS.$3730.Metal2 0.000307663f
Cred_28194 vout4.P14.pSD VSS.$3778.Metal2 7.8093e-05f
Cred_28195 vout4.P14.pSD VSS.$3802.Metal2 0.00055041f
Cred_28196 vout4.P14.pSD VSS.$3837.Metal2 0.00125265f
Cred_28197 vout4.P14.pSD VSS.$4241.Metal2 3.14257e-08f
Cred_28198 vout4.P14.pSD VSS.$4964.Metal3 1.89134e-05f
Cred_28199 vout4.P14.pSD VSS.$5000.Metal3 0.000347384f
Cred_28200 vout4.P14.pSD VSS.$5036.Metal3 0.000635471f
Cred_28201 vout4.P14.pSD VSS.$5084.Metal3 7.75066e-05f
Cred_28202 vout4.P14.pSD VSS.$66.Metal1 5.35077e-07f
Cred_28203 vout4.P14.pSD VSS.P0.pSD 0.000392703f
Cred_28204 vout4.P14.pSD VSS.P15.nSD 3.80016e-06f
Cred_28205 vout4.P14.pSD VSS.P17.nSD 2.1938e-05f
Cred_28206 vout4.P16.nSD VSS.$1625.Metal1 0.00981692f
Cred_28207 vout4.P16.nSD VSS.$1699.Metal1 0.000656678f
Cred_28208 vout4.P16.nSD VSS.$1739.Metal1 0.00466558f
Cred_28209 vout4.P16.nSD VSS.$1787.Metal1 0.000731436f
Cred_28210 vout4.P16.nSD VSS.$1800.Metal1 0.0103228f
Cred_28211 vout4.P16.nSD VSS.$3802.Metal2 0.00236728f
Cred_28212 vout4.P16.nSD VSS.$3837.Metal2 0.00539739f
Cred_28213 vout4.P16.nSD VSS.$3893.Metal2 0.00131867f
Cred_28214 vout4.P16.nSD VSS.$3941.Metal2 0.00152183f
Cred_28215 vout4.P16.nSD VSS.$4000.Metal2 0.00438658f
Cred_28216 vout4.P16.nSD VSS.$4032.Metal2 0.0032666f
Cred_28217 vout4.P16.nSD VSS.$5084.Metal3 9.05797e-05f
Cred_28218 vout4.P16.nSD VSS.$5132.Metal3 9.5102e-05f
Cred_28219 vout4.P16.nSD VSS.P0.pSD 4.10999e-06f
Cred_28220 vout4.P16.nSD VSS.P17.nSD 0.000337153f
Cred_28221 vout4.P16.nSD VSS.P19.nSD 0.000353982f
Cred_28222 vout4.P18.nSD VSS.$1800.Metal1 0.0106321f
Cred_28223 vout4.P18.nSD VSS.$1878.Metal1 0.00100668f
Cred_28224 vout4.P18.nSD VSS.$1926.Metal1 0.00463155f
Cred_28225 vout4.P18.nSD VSS.$1986.Metal1 0.000268959f
Cred_28226 vout4.P18.nSD VSS.$1991.Metal1 6.40083e-05f
Cred_28227 vout4.P18.nSD VSS.$2023.Metal1 0.00784467f
Cred_28228 vout4.P18.nSD VSS.$4000.Metal2 0.00502884f
Cred_28229 vout4.P18.nSD VSS.$4032.Metal2 0.00374499f
Cred_28230 vout4.P18.nSD VSS.$4080.Metal2 0.00183893f
Cred_28231 vout4.P18.nSD VSS.$4128.Metal2 0.00111721f
Cred_28232 vout4.P18.nSD VSS.$4152.Metal2 2.66973e-06f
Cred_28233 vout4.P18.nSD VSS.$4213.Metal2 1.79168e-07f
Cred_28234 vout4.P18.nSD VSS.$4241.Metal2 0.00706373f
Cred_28235 vout4.P18.nSD VSS.$4271.Metal2 5.28251e-07f
Cred_28236 vout4.P18.nSD VSS.$5132.Metal3 1.05235e-05f
Cred_28237 vout4.P18.nSD VSS.$5168.Metal3 0.000124745f
Cred_28238 vout4.P18.nSD VSS.$5192.Metal3 0.000307469f
Cred_28239 vout4.P18.nSD VSS.$5228.Metal3 0.000106762f
Cred_28240 vout4.P18.nSD VSS.$5252.Metal3 0.000134022f
Cred_28241 vout4.P18.nSD VSS.$5288.Metal3 0.000749183f
Cred_28242 vout4.P18.nSD VSS.$66.Metal1 1.48566e-07f
Cred_28243 vout4.P18.nSD VSS.P0.pSD 0.000552281f
Cred_28244 vout4.P18.nSD VSS.P1.GatPoly 7.51285e-05f
Cred_28245 vout4.P18.nSD VSS.P19.nSD 0.00036515f
Cred_28246 vout4.P18.nSD VSS.P21.nSD 4.10396e-05f
Cred_28247 vout4.P18.nSD VSS.P23.nSD 4.10396e-05f
Cred_28248 vout4.P18.pSD VSS.$1800.Metal1 0.0010348f
Cred_28249 vout4.P18.pSD VSS.$1878.Metal1 0.000120778f
Cred_28250 vout4.P18.pSD VSS.$1926.Metal1 0.00051469f
Cred_28251 vout4.P18.pSD VSS.$1986.Metal1 2.1417e-05f
Cred_28252 vout4.P18.pSD VSS.$1991.Metal1 0.000302452f
Cred_28253 vout4.P18.pSD VSS.$2023.Metal1 0.00173394f
Cred_28254 vout4.P18.pSD VSS.$4000.Metal2 0.00173901f
Cred_28255 vout4.P18.pSD VSS.$4032.Metal2 0.00129558f
Cred_28256 vout4.P18.pSD VSS.$4080.Metal2 0.000391169f
Cred_28257 vout4.P18.pSD VSS.$4128.Metal2 0.00023858f
Cred_28258 vout4.P18.pSD VSS.$4152.Metal2 1.91297e-06f
Cred_28259 vout4.P18.pSD VSS.$4213.Metal2 5.47197e-07f
Cred_28260 vout4.P18.pSD VSS.$4241.Metal2 0.00743483f
Cred_28261 vout4.P18.pSD VSS.$4271.Metal2 1.61333e-06f
Cred_28262 vout4.P18.pSD VSS.$5132.Metal3 5.69961e-05f
Cred_28263 vout4.P18.pSD VSS.$5168.Metal3 0.000489482f
Cred_28264 vout4.P18.pSD VSS.$5192.Metal3 0.000903207f
Cred_28265 vout4.P18.pSD VSS.$5228.Metal3 0.000457325f
Cred_28266 vout4.P18.pSD VSS.$5252.Metal3 0.000409316f
Cred_28267 vout4.P18.pSD VSS.$5288.Metal3 0.00228807f
Cred_28268 vout4.P18.pSD VSS.$66.Metal1 7.71985e-07f
Cred_28269 vout4.P18.pSD VSS.P0.pSD 0.00277939f
Cred_28270 vout4.P18.pSD VSS.P1.GatPoly 0.000271069f
Cred_28271 vout4.P18.pSD VSS.P19.nSD 3.55672e-05f
Cred_28272 vout4.P18.pSD VSS.P21.nSD 4.74669e-06f
Cred_28273 vout4.P18.pSD VSS.P23.nSD 4.74669e-06f
Cred_28274 vout4.P2.nSD VSS.$160.Metal1 0.000137896f
Cred_28275 vout4.P2.nSD VSS.$1991.Metal1 2.83901e-08f
Cred_28276 vout4.P2.nSD VSS.$2023.Metal1 7.10831e-08f
Cred_28277 vout4.P2.nSD VSS.$2240.Metal2 0.000537311f
Cred_28278 vout4.P2.nSD VSS.$2421.Metal2 1.4275e-07f
Cred_28279 vout4.P2.nSD VSS.$2445.Metal2 4.39244e-05f
Cred_28280 vout4.P2.nSD VSS.$2493.Metal2 7.22912e-05f
Cred_28281 vout4.P2.nSD VSS.$2544.Metal2 0.00386475f
Cred_28282 vout4.P2.nSD VSS.$2576.Metal2 0.0051897f
Cred_28283 vout4.P2.nSD VSS.$2632.Metal2 0.00159072f
Cred_28284 vout4.P2.nSD VSS.$266.Metal1 3.95803e-06f
Cred_28285 vout4.P2.nSD VSS.$2680.Metal2 0.00137853f
Cred_28286 vout4.P2.nSD VSS.$2739.Metal2 0.00579051f
Cred_28287 vout4.P2.nSD VSS.$2771.Metal2 0.00253973f
Cred_28288 vout4.P2.nSD VSS.$2795.Metal2 5.49486e-08f
Cred_28289 vout4.P2.nSD VSS.$326.Metal1 9.5119e-05f
Cred_28290 vout4.P2.nSD VSS.$374.Metal1 2.23207e-05f
Cred_28291 vout4.P2.nSD VSS.$387.Metal1 0.0109103f
Cred_28292 vout4.P2.nSD VSS.$4241.Metal2 1.9031e-10f
Cred_28293 vout4.P2.nSD VSS.$4424.Metal3 1.36768e-05f
Cred_28294 vout4.P2.nSD VSS.$4460.Metal3 0.000146069f
Cred_28295 vout4.P2.nSD VSS.$4484.Metal3 9.80408e-05f
Cred_28296 vout4.P2.nSD VSS.$4520.Metal3 0.000263772f
Cred_28297 vout4.P2.nSD VSS.$4568.Metal3 0.000249543f
Cred_28298 vout4.P2.nSD VSS.$4616.Metal3 6.85334e-06f
Cred_28299 vout4.P2.nSD VSS.$465.Metal1 0.000746093f
Cred_28300 vout4.P2.nSD VSS.$513.Metal1 0.00477774f
Cred_28301 vout4.P2.nSD VSS.$553.Metal1 0.000673702f
Cred_28302 vout4.P2.nSD VSS.$566.Metal1 0.0107033f
Cred_28303 vout4.P2.nSD VSS.$66.Metal1 3.47304e-05f
Cred_28304 vout4.P2.nSD VSS.P0.GatPoly 1.47278e-05f
Cred_28305 vout4.P2.nSD VSS.P0.nSD 7.07229e-07f
Cred_28306 vout4.P2.nSD VSS.P0.pSD 0.000200273f
Cred_28307 vout4.P2.nSD VSS.P1.nSD 7.07229e-07f
Cred_28308 vout4.P2.nSD VSS.P3.nSD 0.000374711f
Cred_28309 vout4.P2.nSD VSS.P5.nSD 0.000367592f
Cred_28310 vout4.P2.pSD VSS.$160.Metal1 0.000753632f
Cred_28311 vout4.P2.pSD VSS.$1991.Metal1 1.55158e-07f
Cred_28312 vout4.P2.pSD VSS.$2023.Metal1 3.88485e-07f
Cred_28313 vout4.P2.pSD VSS.$2240.Metal2 0.00293653f
Cred_28314 vout4.P2.pSD VSS.$2421.Metal2 7.80163e-07f
Cred_28315 vout4.P2.pSD VSS.$2445.Metal2 0.000240057f
Cred_28316 vout4.P2.pSD VSS.$2493.Metal2 0.000395088f
Cred_28317 vout4.P2.pSD VSS.$2544.Metal2 0.00288269f
Cred_28318 vout4.P2.pSD VSS.$2576.Metal2 0.00387047f
Cred_28319 vout4.P2.pSD VSS.$2632.Metal2 0.000376466f
Cred_28320 vout4.P2.pSD VSS.$266.Metal1 2.16316e-05f
Cred_28321 vout4.P2.pSD VSS.$2680.Metal2 0.000327116f
Cred_28322 vout4.P2.pSD VSS.$2739.Metal2 0.00250556f
Cred_28323 vout4.P2.pSD VSS.$2771.Metal2 0.00109913f
Cred_28324 vout4.P2.pSD VSS.$2795.Metal2 3.00306e-07f
Cred_28325 vout4.P2.pSD VSS.$326.Metal1 0.000519847f
Cred_28326 vout4.P2.pSD VSS.$374.Metal1 0.000121988f
Cred_28327 vout4.P2.pSD VSS.$387.Metal1 0.00221978f
Cred_28328 vout4.P2.pSD VSS.$4241.Metal2 1.04009e-09f
Cred_28329 vout4.P2.pSD VSS.$4424.Metal3 7.47468e-05f
Cred_28330 vout4.P2.pSD VSS.$4460.Metal3 0.000798301f
Cred_28331 vout4.P2.pSD VSS.$4484.Metal3 0.000535816f
Cred_28332 vout4.P2.pSD VSS.$4520.Metal3 0.000921822f
Cred_28333 vout4.P2.pSD VSS.$4568.Metal3 0.000868769f
Cred_28334 vout4.P2.pSD VSS.$4616.Metal3 3.74551e-05f
Cred_28335 vout4.P2.pSD VSS.$465.Metal1 8.01064e-05f
Cred_28336 vout4.P2.pSD VSS.$513.Metal1 0.000612994f
Cred_28337 vout4.P2.pSD VSS.$553.Metal1 9.3041e-05f
Cred_28338 vout4.P2.pSD VSS.$566.Metal1 0.00116444f
Cred_28339 vout4.P2.pSD VSS.$66.Metal1 0.00018981f
Cred_28340 vout4.P2.pSD VSS.P0.GatPoly 8.0491e-05f
Cred_28341 vout4.P2.pSD VSS.P0.nSD 3.86517e-06f
Cred_28342 vout4.P2.pSD VSS.P0.pSD 0.00107208f
Cred_28343 vout4.P2.pSD VSS.P1.nSD 3.86517e-06f
Cred_28344 vout4.P2.pSD VSS.P3.nSD 7.63022e-05f
Cred_28345 vout4.P2.pSD VSS.P5.nSD 4.00208e-05f
Cred_28346 vout4.P4.nSD VSS.$2739.Metal2 0.00540534f
Cred_28347 vout4.P4.nSD VSS.$2771.Metal2 0.00237126f
Cred_28348 vout4.P4.nSD VSS.$2795.Metal2 0.000564676f
Cred_28349 vout4.P4.nSD VSS.$2843.Metal2 0.00224617f
Cred_28350 vout4.P4.nSD VSS.$2867.Metal2 1.21802e-05f
Cred_28351 vout4.P4.nSD VSS.$2926.Metal2 0.00674259f
Cred_28352 vout4.P4.nSD VSS.$2958.Metal2 0.000256048f
Cred_28353 vout4.P4.nSD VSS.$4616.Metal3 0.000137876f
Cred_28354 vout4.P4.nSD VSS.$4652.Metal3 4.38017e-05f
Cred_28355 vout4.P4.nSD VSS.$566.Metal1 0.0100422f
Cred_28356 vout4.P4.nSD VSS.$672.Metal1 0.0044119f
Cred_28357 vout4.P4.nSD VSS.$740.Metal1 0.00141601f
Cred_28358 vout4.P4.nSD VSS.$785.Metal1 0.0114595f
Cred_28359 vout4.P4.nSD VSS.P0.pSD 8.78263e-06f
Cred_28360 vout4.P4.nSD VSS.P5.nSD 0.000341543f
Cred_28361 vout4.P4.nSD VSS.P7.nSD 6.29961e-05f
Cred_28362 vout4.P6.nSD VSS.$1991.Metal1 4.73697e-08f
Cred_28363 vout4.P6.nSD VSS.$2023.Metal1 1.18604e-07f
Cred_28364 vout4.P6.nSD VSS.$2926.Metal2 0.00718682f
Cred_28365 vout4.P6.nSD VSS.$2958.Metal2 0.000273042f
Cred_28366 vout4.P6.nSD VSS.$3006.Metal2 0.00227607f
Cred_28367 vout4.P6.nSD VSS.$3054.Metal2 0.000639761f
Cred_28368 vout4.P6.nSD VSS.$3078.Metal2 0.00185517f
Cred_28369 vout4.P6.nSD VSS.$3113.Metal2 0.00615073f
Cred_28370 vout4.P6.nSD VSS.$4241.Metal2 3.17538e-10f
Cred_28371 vout4.P6.nSD VSS.$4652.Metal3 1.25593e-05f
Cred_28372 vout4.P6.nSD VSS.$4688.Metal3 0.000131f
Cred_28373 vout4.P6.nSD VSS.$4712.Metal3 0.000214159f
Cred_28374 vout4.P6.nSD VSS.$4760.Metal3 1.39515e-05f
Cred_28375 vout4.P6.nSD VSS.$66.Metal1 1.42139e-06f
Cred_28376 vout4.P6.nSD VSS.$785.Metal1 0.0110755f
Cred_28377 vout4.P6.nSD VSS.$831.Metal1 0.00165533f
Cred_28378 vout4.P6.nSD VSS.$879.Metal1 0.00432886f
Cred_28379 vout4.P6.nSD VSS.$924.Metal1 0.0106057f
Cred_28380 vout4.P6.nSD VSS.P0.pSD 6.94716e-05f
Cred_28381 vout4.P6.nSD VSS.P10.nSD 0.000364237f
Cred_28382 vout4.P6.nSD VSS.P7.nSD 6.02365e-05f
Cred_28383 vout4.P6.pSD VSS.$1991.Metal1 2.58886e-07f
Cred_28384 vout4.P6.pSD VSS.$2023.Metal1 6.48199e-07f
Cred_28385 vout4.P6.pSD VSS.$2926.Metal2 0.00206155f
Cred_28386 vout4.P6.pSD VSS.$2958.Metal2 7.89704e-05f
Cred_28387 vout4.P6.pSD VSS.$3006.Metal2 0.000306234f
Cred_28388 vout4.P6.pSD VSS.$3054.Metal2 8.69874e-05f
Cred_28389 vout4.P6.pSD VSS.$3078.Metal2 0.000422334f
Cred_28390 vout4.P6.pSD VSS.$3113.Metal2 0.00139691f
Cred_28391 vout4.P6.pSD VSS.$4241.Metal2 1.73542e-09f
Cred_28392 vout4.P6.pSD VSS.$4652.Metal3 6.86395e-05f
Cred_28393 vout4.P6.pSD VSS.$4688.Metal3 0.000384247f
Cred_28394 vout4.P6.pSD VSS.$4712.Metal3 0.000533469f
Cred_28395 vout4.P6.pSD VSS.$4760.Metal3 7.62482e-05f
Cred_28396 vout4.P6.pSD VSS.$66.Metal1 7.7682e-06f
Cred_28397 vout4.P6.pSD VSS.$785.Metal1 0.00070575f
Cred_28398 vout4.P6.pSD VSS.$831.Metal1 0.000122962f
Cred_28399 vout4.P6.pSD VSS.$879.Metal1 0.000322849f
Cred_28400 vout4.P6.pSD VSS.$924.Metal1 0.00064329f
Cred_28401 vout4.P6.pSD VSS.P0.pSD 0.000358702f
Cred_28402 vout4.P6.pSD VSS.P10.nSD 2.21104e-05f
Cred_28403 vout4.P6.pSD VSS.P7.nSD 3.86871e-06f
Cred_28404 vout4.P8.nSD VSS 0.0107023f
Cred_28405 vout4.P8.nSD VSS.$1038.Metal1 0.00468381f
Cred_28406 vout4.P8.nSD VSS.$1078.Metal1 0.000746408f
Cred_28407 vout4.P8.nSD VSS.$3078.Metal2 0.0017813f
Cred_28408 vout4.P8.nSD VSS.$3113.Metal2 0.00590641f
Cred_28409 vout4.P8.nSD VSS.$3169.Metal2 0.00119544f
Cred_28410 vout4.P8.nSD VSS.$3217.Metal2 0.00164405f
Cred_28411 vout4.P8.nSD VSS.$3276.Metal2 0.00384189f
Cred_28412 vout4.P8.nSD VSS.$3308.Metal2 0.00384189f
Cred_28413 vout4.P8.nSD VSS.$4760.Metal3 8.78663e-05f
Cred_28414 vout4.P8.nSD VSS.$4808.Metal3 9.78154e-05f
Cred_28415 vout4.P8.nSD VSS.$924.Metal1 0.00980864f
Cred_28416 vout4.P8.nSD VSS.$990.Metal1 0.000477103f
Cred_28417 vout4.P8.nSD VSS.P0.pSD 4.17331e-06f
Cred_28418 vout4.P8.nSD VSS.P10.nSD 0.000336869f
Cred_28419 vout4.P8.nSD VSS.P11.nSD 0.000366899f
Rred_1 VDD VDD.$1995.Metal1 0.0168574201471
Rred_2 VDD VDD.$1999.Metal1 0.0168574201471
Rred_3 VDD VDD.$2223.Metal1 0.0168574201471
Rred_4 VDD VDD.$2227.Metal1 0.0168574201471
Rred_5 VDD VDD.$5766.Metal2 0.865447900904
Rred_6 VDD VDD.$5806.Metal2 0.865447900904
Rred_7 VDD VDD.$5846.Metal2 0.865447900904
Rred_8 VDD VDD.$5886.Metal2 0.865447900904
Rred_9 VDD VDD.$7478.Metal3 3.64452712725
Rred_10 VDD VDD.$7484.Metal3 3.64452712725
Rred_11 VDD VDD.$8402.Metal3 3.64452712725
Rred_12 VDD VDD.$8408.Metal3 3.64452712725
Rred_13 VDD VDD.P0.nSD 13.7924346658
Rred_14 VDD VDD.P1.nSD 13.7924346658
Rred_15 VDD VDD.P11.pSD 1.98799712027
Rred_16 VDD VDD.P2.nSD 13.7924346658
Rred_17 VDD VDD.P3.nSD 13.7924346658
Rred_18 VDD VDD.P35.pSD 1.98799712027
Rred_19 VDD VDD.P59.pSD 1.98799712027
Rred_20 VDD VDD.P83.pSD 1.98799712027
Rred_21 VDD.$1001.Metal1 VDD.$1021.Metal1 0.010404186219
Rred_22 VDD.$1001.Metal1 VDD.$4892.Metal2 2.35325729591
Rred_23 VDD.$1001.Metal1 VDD.$4998.Metal2 9.80659138163
Rred_24 VDD.$1001.Metal1 VDD.$7688.Metal3 1223.10590957
Rred_25 VDD.$1001.Metal1 VDD.$981.Metal1 0.0104068614969
Rred_26 VDD.$1001.Metal1 VDD.P0.nSD 17
Rred_27 VDD.$1001.Metal1 VDD.P2.nSD 17
Rred_28 VDD.$1017.Metal1 VDD.$1024.Metal1 0.0131659822165
Rred_29 VDD.$1017.Metal1 VDD.$4880.Metal2 4.38166848966
Rred_30 VDD.$1017.Metal1 VDD.$4986.Metal2 2.37168738593
Rred_31 VDD.$1017.Metal1 VDD.$7682.Metal3 546.494129806
Rred_32 VDD.$1017.Metal1 VDD.$997.Metal1 0.010404186219
Rred_33 VDD.$1017.Metal1 VDD.P1.nSD 14.0627009151
Rred_34 VDD.$1017.Metal1 VDD.P3.nSD 14.0627009151
Rred_35 VDD.$1021.Metal1 VDD.$1025.Metal1 0.0131659822165
Rred_36 VDD.$1021.Metal1 VDD.$4892.Metal2 4.38166848966
Rred_37 VDD.$1021.Metal1 VDD.$4998.Metal2 2.37168738593
Rred_38 VDD.$1021.Metal1 VDD.$7688.Metal3 546.494129806
Rred_39 VDD.$1021.Metal1 VDD.P0.nSD 14.0627009151
Rred_40 VDD.$1021.Metal1 VDD.P2.nSD 14.0627009151
Rred_41 VDD.$1024.Metal1 VDD.$1247.Metal1 0.0180912247213
Rred_42 VDD.$1024.Metal1 VDD.$4986.Metal2 0.666825662375
Rred_43 VDD.$1024.Metal1 VDD.$5066.Metal2 1.25914383683
Rred_44 VDD.$1024.Metal1 VDD.P1.nSD 12.4615829176
Rred_45 VDD.$1024.Metal1 VDD.P29.pSD 1.98874159732
Rred_46 VDD.$1024.Metal1 VDD.P3.nSD 12.4615829176
Rred_47 VDD.$1024.Metal1 VDD.P77.pSD 1.98874159732
Rred_48 VDD.$1025.Metal1 VDD.$1251.Metal1 0.0180912247213
Rred_49 VDD.$1025.Metal1 VDD.$4998.Metal2 0.666825662375
Rred_50 VDD.$1025.Metal1 VDD.$5078.Metal2 1.25914383683
Rred_51 VDD.$1025.Metal1 VDD.P0.nSD 12.4615829176
Rred_52 VDD.$1025.Metal1 VDD.P2.nSD 12.4615829176
Rred_53 VDD.$1025.Metal1 VDD.P5.pSD 1.98874159732
Rred_54 VDD.$1025.Metal1 VDD.P53.pSD 1.98874159732
Rred_55 VDD.$116.Metal1 VDD.$129.Metal1 0.0448372520171
Rred_56 VDD.$116.Metal1 VDD.$132.Metal1 0.0410784942806
Rred_57 VDD.$116.Metal1 VDD.$4106.Metal1 128125.241191
Rred_58 VDD.$116.Metal1 VDD.$4204.Metal2 4.05152947356
Rred_59 VDD.$116.Metal1 VDD.$4206.Metal2 3.37605024229
Rred_60 VDD.$116.Metal1 VDD.P1.nSD 2.01513428871
Rred_61 VDD.$116.Metal1 VDD.P3.nSD 2.01164563
Rred_62 VDD.$117.Metal1 VDD.$158.Metal1 0.0731271020638
Rred_63 VDD.$117.Metal1 VDD.$360.Metal1 0.100296948733
Rred_64 VDD.$117.Metal1 VDD.$388.Metal1 0.126052112616
Rred_65 VDD.$117.Metal1 VDD.$4235.Metal2 6.72557017604
Rred_66 VDD.$117.Metal1 VDD.$4236.Metal2 3.29647063762
Rred_67 VDD.$117.Metal1 VDD.$4237.Metal2 5.40731551599
Rred_68 VDD.$117.Metal1 VDD.$509.Metal1 0.0339819469444
Rred_69 VDD.$117.Metal1 VDD.P24.pSD 6.69668074804
Rred_70 VDD.$117.Metal1 VDD.P25.pSD 8.02466480886
Rred_71 VDD.$118.Metal1 VDD.$135.Metal1 0.0448372520171
Rred_72 VDD.$118.Metal1 VDD.$138.Metal1 0.0410784942806
Rred_73 VDD.$118.Metal1 VDD.$4107.Metal1 128125.241191
Rred_74 VDD.$118.Metal1 VDD.$4216.Metal2 4.05152947356
Rred_75 VDD.$118.Metal1 VDD.$4218.Metal2 3.37605024229
Rred_76 VDD.$118.Metal1 VDD.P0.nSD 2.01164563
Rred_77 VDD.$118.Metal1 VDD.P2.nSD 2.01513428871
Rred_78 VDD.$119.Metal1 VDD.$186.Metal1 0.0731271020638
Rred_79 VDD.$119.Metal1 VDD.$362.Metal1 0.100296948733
Rred_80 VDD.$119.Metal1 VDD.$390.Metal1 0.126052112616
Rred_81 VDD.$119.Metal1 VDD.$4263.Metal2 6.72557017604
Rred_82 VDD.$119.Metal1 VDD.$4264.Metal2 3.29647063762
Rred_83 VDD.$119.Metal1 VDD.$4265.Metal2 5.40731551599
Rred_84 VDD.$119.Metal1 VDD.$543.Metal1 0.0339819469444
Rred_85 VDD.$119.Metal1 VDD.P48.pSD 6.69668074804
Rred_86 VDD.$119.Metal1 VDD.P49.pSD 8.02466480886
Rred_87 VDD.$1247.Metal1 VDD.$1267.Metal1 0.010404186219
Rred_88 VDD.$1247.Metal1 VDD.$5066.Metal2 1.82095135804
Rred_89 VDD.$1247.Metal1 VDD.$5114.Metal2 4.38166848966
Rred_90 VDD.$1247.Metal1 VDD.$7718.Metal3 546.494129806
Rred_91 VDD.$1247.Metal1 VDD.P1.nSD 11.9529522847
Rred_92 VDD.$1247.Metal1 VDD.P3.nSD 11.9529522847
Rred_93 VDD.$1251.Metal1 VDD.$1271.Metal1 0.010404186219
Rred_94 VDD.$1251.Metal1 VDD.$5078.Metal2 1.82095135804
Rred_95 VDD.$1251.Metal1 VDD.$5126.Metal2 4.38166848966
Rred_96 VDD.$1251.Metal1 VDD.$7724.Metal3 546.494129806
Rred_97 VDD.$1251.Metal1 VDD.P0.nSD 11.9529522847
Rred_98 VDD.$1251.Metal1 VDD.P2.nSD 11.9529522847
Rred_99 VDD.$1267.Metal1 VDD.$1287.Metal1 0.0104068614969
Rred_100 VDD.$1267.Metal1 VDD.$5066.Metal2 9.80659138163
Rred_101 VDD.$1267.Metal1 VDD.$5114.Metal2 2.35325729591
Rred_102 VDD.$1267.Metal1 VDD.$7718.Metal3 1223.10590957
Rred_103 VDD.$1267.Metal1 VDD.P1.nSD 17
Rred_104 VDD.$1267.Metal1 VDD.P3.nSD 17
Rred_105 VDD.$1271.Metal1 VDD.$1291.Metal1 0.0104068614969
Rred_106 VDD.$1271.Metal1 VDD.$5078.Metal2 9.80659138163
Rred_107 VDD.$1271.Metal1 VDD.$5126.Metal2 2.35325729591
Rred_108 VDD.$1271.Metal1 VDD.$7724.Metal3 1223.10590957
Rred_109 VDD.$1271.Metal1 VDD.P0.nSD 17
Rred_110 VDD.$1271.Metal1 VDD.P2.nSD 17
Rred_111 VDD.$1287.Metal1 VDD.$1307.Metal1 0.0104033182853
Rred_112 VDD.$1287.Metal1 VDD.$5114.Metal2 2.29983953107
Rred_113 VDD.$1287.Metal1 VDD.$5162.Metal2 10.8379599635
Rred_114 VDD.$1287.Metal1 VDD.$7742.Metal3 1351.74112626
Rred_115 VDD.$1287.Metal1 VDD.P1.nSD 17
Rred_116 VDD.$1287.Metal1 VDD.P3.nSD 17
Rred_117 VDD.$129.Metal1 VDD.$360.Metal1 0.100035059304
Rred_118 VDD.$129.Metal1 VDD.$4200.Metal2 3.09875776573
Rred_119 VDD.$129.Metal1 VDD.$4202.Metal2 2.25
Rred_120 VDD.$129.Metal1 VDD.$4204.Metal2 5.11611120874
Rred_121 VDD.$129.Metal1 VDD.P1.nSD 8.74636663511
Rred_122 VDD.$1291.Metal1 VDD.$1311.Metal1 0.0104033182853
Rred_123 VDD.$1291.Metal1 VDD.$5126.Metal2 2.29983953107
Rred_124 VDD.$1291.Metal1 VDD.$5174.Metal2 10.8379599635
Rred_125 VDD.$1291.Metal1 VDD.$7748.Metal3 1351.74112626
Rred_126 VDD.$1291.Metal1 VDD.P0.nSD 17
Rred_127 VDD.$1291.Metal1 VDD.P2.nSD 17
Rred_128 VDD.$1307.Metal1 VDD.$1335.Metal1 0.0208620449569
Rred_129 VDD.$1307.Metal1 VDD.$5114.Metal2 4.20247427156
Rred_130 VDD.$1307.Metal1 VDD.$5162.Metal2 1.68241800287
Rred_131 VDD.$1307.Metal1 VDD.$7742.Metal3 524.144518347
Rred_132 VDD.$1307.Metal1 VDD.P1.nSD 11.3486133252
Rred_133 VDD.$1307.Metal1 VDD.P3.nSD 11.3486133252
Rred_134 VDD.$1311.Metal1 VDD.$1339.Metal1 0.0208620449569
Rred_135 VDD.$1311.Metal1 VDD.$5126.Metal2 4.20247427156
Rred_136 VDD.$1311.Metal1 VDD.$5174.Metal2 1.68241800287
Rred_137 VDD.$1311.Metal1 VDD.$7748.Metal3 524.144518347
Rred_138 VDD.$1311.Metal1 VDD.P0.nSD 11.3486133252
Rred_139 VDD.$1311.Metal1 VDD.P2.nSD 11.3486133252
Rred_140 VDD.$132.Metal1 VDD.$361.Metal1 0.0708027078622
Rred_141 VDD.$132.Metal1 VDD.$4206.Metal2 3.90268759255
Rred_142 VDD.$132.Metal1 VDD.$4208.Metal2 1.8
Rred_143 VDD.$132.Metal1 VDD.$4210.Metal2 2.59752517975
Rred_144 VDD.$132.Metal1 VDD.P3.nSD 6.90197015494
Rred_145 VDD.$1335.Metal1 VDD.$1413.Metal1 0.0103971187595
Rred_146 VDD.$1335.Metal1 VDD.$5162.Metal2 1.6827530387
Rred_147 VDD.$1335.Metal1 VDD.$5268.Metal2 3.48811062896
Rred_148 VDD.$1335.Metal1 VDD.$7766.Metal3 435.047057381
Rred_149 VDD.$1335.Metal1 VDD.P1.nSD 11.3468336065
Rred_150 VDD.$1335.Metal1 VDD.P3.nSD 11.3468336065
Rred_151 VDD.$1339.Metal1 VDD.$1417.Metal1 0.0103971187595
Rred_152 VDD.$1339.Metal1 VDD.$5174.Metal2 1.6827530387
Rred_153 VDD.$1339.Metal1 VDD.$5280.Metal2 3.48811062896
Rred_154 VDD.$1339.Metal1 VDD.$7772.Metal3 435.047057381
Rred_155 VDD.$1339.Metal1 VDD.P0.nSD 11.3468336065
Rred_156 VDD.$1339.Metal1 VDD.P2.nSD 11.3468336065
Rred_157 VDD.$135.Metal1 VDD.$362.Metal1 0.100035059304
Rred_158 VDD.$135.Metal1 VDD.$4212.Metal2 3.09875776573
Rred_159 VDD.$135.Metal1 VDD.$4214.Metal2 2.25
Rred_160 VDD.$135.Metal1 VDD.$4216.Metal2 5.11611120874
Rred_161 VDD.$135.Metal1 VDD.P2.nSD 8.74636663511
Rred_162 VDD.$1354.Metal1 VDD.$1413.Metal1 0.00397329591049
Rred_163 VDD.$1354.Metal1 VDD.$1557.Metal1 0.00641666666667
Rred_164 VDD.$1354.Metal1 VDD.$5210.Metal2 0.672846329255
Rred_165 VDD.$1354.Metal1 VDD.$5268.Metal2 1.69611050725
Rred_166 VDD.$1354.Metal1 VDD.P31.pSD 1.99292147919
Rred_167 VDD.$1354.Metal1 VDD.P79.pSD 1.99292147919
Rred_168 VDD.$1355.Metal1 VDD.$1417.Metal1 0.00397329591049
Rred_169 VDD.$1355.Metal1 VDD.$1561.Metal1 0.00641666666667
Rred_170 VDD.$1355.Metal1 VDD.$5211.Metal2 0.672846329255
Rred_171 VDD.$1355.Metal1 VDD.$5280.Metal2 1.69611050725
Rred_172 VDD.$1355.Metal1 VDD.P55.pSD 1.99292147919
Rred_173 VDD.$1355.Metal1 VDD.P7.pSD 1.99292147919
Rred_174 VDD.$138.Metal1 VDD.$363.Metal1 0.0708027078622
Rred_175 VDD.$138.Metal1 VDD.$4218.Metal2 3.90268759255
Rred_176 VDD.$138.Metal1 VDD.$4220.Metal2 1.8
Rred_177 VDD.$138.Metal1 VDD.$4222.Metal2 2.59752517975
Rred_178 VDD.$138.Metal1 VDD.P0.nSD 6.90197015494
Rred_179 VDD.$1413.Metal1 VDD.$5162.Metal2 22.8665030121
Rred_180 VDD.$1413.Metal1 VDD.$5268.Metal2 8.28951071668
Rred_181 VDD.$1413.Metal1 VDD.$7766.Metal3 2851.97515394
Rred_182 VDD.$1413.Metal1 VDD.P1.nSD 17
Rred_183 VDD.$1413.Metal1 VDD.P3.nSD 17
Rred_184 VDD.$1417.Metal1 VDD.$5174.Metal2 22.8665030121
Rred_185 VDD.$1417.Metal1 VDD.$5280.Metal2 8.28951071668
Rred_186 VDD.$1417.Metal1 VDD.$7772.Metal3 2851.97515394
Rred_187 VDD.$1417.Metal1 VDD.P0.nSD 17
Rred_188 VDD.$1417.Metal1 VDD.P2.nSD 17
Rred_189 VDD.$1557.Metal1 VDD.$1577.Metal1 0.0104066673416
Rred_190 VDD.$1557.Metal1 VDD.$5210.Metal2 6.52224174504
Rred_191 VDD.$1557.Metal1 VDD.$5372.Metal2 6.76992181131
Rred_192 VDD.$1557.Metal1 VDD.$7790.Metal3 844.363862273
Rred_193 VDD.$1557.Metal1 VDD.P1.nSD 17
Rred_194 VDD.$1557.Metal1 VDD.P3.nSD 17
Rred_195 VDD.$1561.Metal1 VDD.$1581.Metal1 0.0104066673416
Rred_196 VDD.$1561.Metal1 VDD.$5211.Metal2 6.52224174504
Rred_197 VDD.$1561.Metal1 VDD.$5384.Metal2 6.76992181131
Rred_198 VDD.$1561.Metal1 VDD.$7796.Metal3 844.363862273
Rred_199 VDD.$1561.Metal1 VDD.P0.nSD 17
Rred_200 VDD.$1561.Metal1 VDD.P2.nSD 17
Rred_201 VDD.$157.Metal1 VDD.$158.Metal1 0.0469277028211
Rred_202 VDD.$157.Metal1 VDD.$225.Metal1 22093.6689375
Rred_203 VDD.$157.Metal1 VDD.$226.Metal1 8287.38032743
Rred_204 VDD.$157.Metal1 VDD.$4231.Metal2 6.09977235433
Rred_205 VDD.$157.Metal1 VDD.$4233.Metal2 6.02735332455
Rred_206 VDD.$157.Metal1 VDD.P24.pSD 18.4563405638
Rred_207 VDD.$1577.Metal1 VDD.$1597.Metal1 0.0104023800154
Rred_208 VDD.$1577.Metal1 VDD.$5210.Metal2 5.46458092152
Rred_209 VDD.$1577.Metal1 VDD.$5372.Metal2 2.91756000322
Rred_210 VDD.$1577.Metal1 VDD.$7790.Metal3 707.439992715
Rred_211 VDD.$1577.Metal1 VDD.P1.nSD 17
Rred_212 VDD.$1577.Metal1 VDD.P3.nSD 17
Rred_213 VDD.$158.Metal1 VDD.$4233.Metal2 18.040917646
Rred_214 VDD.$158.Metal1 VDD.$4235.Metal2 6.82187411869
Rred_215 VDD.$158.Metal1 VDD.$508.Metal1 6119.89076118
Rred_216 VDD.$158.Metal1 VDD.$509.Metal1 217774.594191
Rred_217 VDD.$158.Metal1 VDD.P24.pSD 10.5956712708
Rred_218 VDD.$1581.Metal1 VDD.$1601.Metal1 0.0104023800154
Rred_219 VDD.$1581.Metal1 VDD.$5211.Metal2 5.46458092152
Rred_220 VDD.$1581.Metal1 VDD.$5384.Metal2 2.91756000322
Rred_221 VDD.$1581.Metal1 VDD.$7796.Metal3 707.439992715
Rred_222 VDD.$1581.Metal1 VDD.P0.nSD 17
Rred_223 VDD.$1581.Metal1 VDD.P2.nSD 17
Rred_224 VDD.$1597.Metal1 VDD.$1617.Metal1 0.0103919111578
Rred_225 VDD.$1597.Metal1 VDD.$5372.Metal2 1.94576678886
Rred_226 VDD.$1597.Metal1 VDD.$5420.Metal2 68.5651496211
Rred_227 VDD.$1597.Metal1 VDD.$7814.Metal3 8551.64005804
Rred_228 VDD.$1597.Metal1 VDD.P1.nSD 17
Rred_229 VDD.$1597.Metal1 VDD.P3.nSD 17
Rred_230 VDD.$1601.Metal1 VDD.$1621.Metal1 0.0103919111578
Rred_231 VDD.$1601.Metal1 VDD.$5384.Metal2 1.94576678886
Rred_232 VDD.$1601.Metal1 VDD.$5432.Metal2 68.5651496211
Rred_233 VDD.$1601.Metal1 VDD.$7820.Metal3 8551.64005804
Rred_234 VDD.$1601.Metal1 VDD.P0.nSD 17
Rred_235 VDD.$1601.Metal1 VDD.P2.nSD 17
Rred_236 VDD.$1617.Metal1 VDD.$1645.Metal1 0.0208605570636
Rred_237 VDD.$1617.Metal1 VDD.$5372.Metal2 3.16454536712
Rred_238 VDD.$1617.Metal1 VDD.$5420.Metal2 1.68264009502
Rred_239 VDD.$1617.Metal1 VDD.$7814.Metal3 394.691079601
Rred_240 VDD.$1617.Metal1 VDD.P1.nSD 11.3448022212
Rred_241 VDD.$1617.Metal1 VDD.P3.nSD 11.3448022212
Rred_242 VDD.$1621.Metal1 VDD.$1649.Metal1 0.0208605570636
Rred_243 VDD.$1621.Metal1 VDD.$5384.Metal2 3.16454536712
Rred_244 VDD.$1621.Metal1 VDD.$5432.Metal2 1.68264009502
Rred_245 VDD.$1621.Metal1 VDD.$7820.Metal3 394.691079601
Rred_246 VDD.$1621.Metal1 VDD.P0.nSD 11.3448022212
Rred_247 VDD.$1621.Metal1 VDD.P2.nSD 11.3448022212
Rred_248 VDD.$1645.Metal1 VDD.$1665.Metal1 0.0104055501146
Rred_249 VDD.$1645.Metal1 VDD.$5420.Metal2 1.68192524462
Rred_250 VDD.$1645.Metal1 VDD.$5468.Metal2 4.78989338831
Rred_251 VDD.$1645.Metal1 VDD.$7838.Metal3 597.409097765
Rred_252 VDD.$1645.Metal1 VDD.P1.nSD 11.3483442433
Rred_253 VDD.$1645.Metal1 VDD.P3.nSD 11.3483442433
Rred_254 VDD.$1649.Metal1 VDD.$1669.Metal1 0.0104055501146
Rred_255 VDD.$1649.Metal1 VDD.$5432.Metal2 1.68192524462
Rred_256 VDD.$1649.Metal1 VDD.$5480.Metal2 4.78989338831
Rred_257 VDD.$1649.Metal1 VDD.$7844.Metal3 597.409097765
Rred_258 VDD.$1649.Metal1 VDD.P0.nSD 11.3483442433
Rred_259 VDD.$1649.Metal1 VDD.P2.nSD 11.3483442433
Rred_260 VDD.$1665.Metal1 VDD.$1684.Metal1 0.0156279254927
Rred_261 VDD.$1665.Metal1 VDD.$5420.Metal2 8.2386166279
Rred_262 VDD.$1665.Metal1 VDD.$5468.Metal2 1.87939934463
Rred_263 VDD.$1665.Metal1 VDD.$7838.Metal3 1027.54364816
Rred_264 VDD.$1665.Metal1 VDD.P1.nSD 12.7591015902
Rred_265 VDD.$1665.Metal1 VDD.P3.nSD 12.7591015902
Rred_266 VDD.$1669.Metal1 VDD.$1685.Metal1 0.0156279254927
Rred_267 VDD.$1669.Metal1 VDD.$5432.Metal2 8.2386166279
Rred_268 VDD.$1669.Metal1 VDD.$5480.Metal2 1.87939934463
Rred_269 VDD.$1669.Metal1 VDD.$7844.Metal3 1027.54364816
Rred_270 VDD.$1669.Metal1 VDD.P0.nSD 12.7591015902
Rred_271 VDD.$1669.Metal1 VDD.P2.nSD 12.7591015902
Rred_272 VDD.$1684.Metal1 VDD.$1831.Metal1 0.00519887924383
Rred_273 VDD.$1684.Metal1 VDD.$5468.Metal2 1.67492510577
Rred_274 VDD.$1684.Metal1 VDD.$5550.Metal2 0.698938274809
Rred_275 VDD.$1684.Metal1 VDD.P1.nSD 25.5297207234
Rred_276 VDD.$1684.Metal1 VDD.P3.nSD 25.5297207234
Rred_277 VDD.$1684.Metal1 VDD.P33.pSD 1.98940628725
Rred_278 VDD.$1684.Metal1 VDD.P81.pSD 1.98940628725
Rred_279 VDD.$1685.Metal1 VDD.$1835.Metal1 0.00519887924383
Rred_280 VDD.$1685.Metal1 VDD.$5480.Metal2 1.67492510577
Rred_281 VDD.$1685.Metal1 VDD.$5562.Metal2 0.698938274809
Rred_282 VDD.$1685.Metal1 VDD.P0.nSD 25.5297207234
Rred_283 VDD.$1685.Metal1 VDD.P10.pSD 1.98940628725
Rred_284 VDD.$1685.Metal1 VDD.P2.nSD 25.5297207234
Rred_285 VDD.$1685.Metal1 VDD.P57.pSD 1.98940628725
Rred_286 VDD.$1831.Metal1 VDD.$1915.Metal1 0.0208624136971
Rred_287 VDD.$1831.Metal1 VDD.$5550.Metal2 2.68650219298
Rred_288 VDD.$1831.Metal1 VDD.$5630.Metal2 2.9685122125
Rred_289 VDD.$1831.Metal1 VDD.P1.nSD 11.348680007
Rred_290 VDD.$1831.Metal1 VDD.P3.nSD 11.348680007
Rred_291 VDD.$1835.Metal1 VDD.$1919.Metal1 0.0208624136971
Rred_292 VDD.$1835.Metal1 VDD.$5562.Metal2 2.68650219298
Rred_293 VDD.$1835.Metal1 VDD.$5642.Metal2 2.9685122125
Rred_294 VDD.$1835.Metal1 VDD.P0.nSD 11.348680007
Rred_295 VDD.$1835.Metal1 VDD.P2.nSD 11.348680007
Rred_296 VDD.$185.Metal1 VDD.$186.Metal1 0.0469277028211
Rred_297 VDD.$185.Metal1 VDD.$259.Metal1 22093.6689375
Rred_298 VDD.$185.Metal1 VDD.$260.Metal1 8287.38032743
Rred_299 VDD.$185.Metal1 VDD.$4259.Metal2 6.09977235433
Rred_300 VDD.$185.Metal1 VDD.$4261.Metal2 6.02735332455
Rred_301 VDD.$185.Metal1 VDD.P48.pSD 18.4563405638
Rred_302 VDD.$186.Metal1 VDD.$4261.Metal2 18.040917646
Rred_303 VDD.$186.Metal1 VDD.$4263.Metal2 6.82187411869
Rred_304 VDD.$186.Metal1 VDD.$542.Metal1 6119.89076118
Rred_305 VDD.$186.Metal1 VDD.$543.Metal1 217774.594191
Rred_306 VDD.$186.Metal1 VDD.P48.pSD 10.5956712708
Rred_307 VDD.$1915.Metal1 VDD.$1935.Metal1 0.0103999705414
Rred_308 VDD.$1915.Metal1 VDD.$5630.Metal2 1.68271596698
Rred_309 VDD.$1915.Metal1 VDD.$5678.Metal2 3.74281772218
Rred_310 VDD.$1915.Metal1 VDD.$7886.Metal3 466.81484894
Rred_311 VDD.$1915.Metal1 VDD.P1.nSD 11.3483014192
Rred_312 VDD.$1915.Metal1 VDD.P3.nSD 11.3483014192
Rred_313 VDD.$1919.Metal1 VDD.$1939.Metal1 0.0103999705414
Rred_314 VDD.$1919.Metal1 VDD.$5642.Metal2 1.68271596698
Rred_315 VDD.$1919.Metal1 VDD.$5690.Metal2 3.74281772218
Rred_316 VDD.$1919.Metal1 VDD.$7892.Metal3 466.81484894
Rred_317 VDD.$1919.Metal1 VDD.P0.nSD 11.3483014192
Rred_318 VDD.$1919.Metal1 VDD.P2.nSD 11.3483014192
Rred_319 VDD.$1935.Metal1 VDD.$1955.Metal1 0.0104061145833
Rred_320 VDD.$1935.Metal1 VDD.$5630.Metal2 15.8349980554
Rred_321 VDD.$1935.Metal1 VDD.$5678.Metal2 2.15309979481
Rred_322 VDD.$1935.Metal1 VDD.$7886.Metal3 1974.98589936
Rred_323 VDD.$1935.Metal1 VDD.P1.nSD 17
Rred_324 VDD.$1935.Metal1 VDD.P3.nSD 17
Rred_325 VDD.$1939.Metal1 VDD.$1959.Metal1 0.0104061145833
Rred_326 VDD.$1939.Metal1 VDD.$5642.Metal2 15.8349980554
Rred_327 VDD.$1939.Metal1 VDD.$5690.Metal2 2.15309979481
Rred_328 VDD.$1939.Metal1 VDD.$7892.Metal3 1974.98589936
Rred_329 VDD.$1939.Metal1 VDD.P0.nSD 17
Rred_330 VDD.$1939.Metal1 VDD.P2.nSD 17
Rred_331 VDD.$1955.Metal1 VDD.$1975.Metal1 0.0104061145833
Rred_332 VDD.$1955.Metal1 VDD.$5678.Metal2 3.78404166667
Rred_333 VDD.$1955.Metal1 VDD.$5702.Metal2 3.78404166667
Rred_334 VDD.$1955.Metal1 VDD.P1.nSD 17
Rred_335 VDD.$1955.Metal1 VDD.P3.nSD 17
Rred_336 VDD.$1959.Metal1 VDD.$1979.Metal1 0.0104061145833
Rred_337 VDD.$1959.Metal1 VDD.$5690.Metal2 3.78404166667
Rred_338 VDD.$1959.Metal1 VDD.$5714.Metal2 3.78404166667
Rred_339 VDD.$1959.Metal1 VDD.P0.nSD 17
Rred_340 VDD.$1959.Metal1 VDD.P2.nSD 17
Rred_341 VDD.$1975.Metal1 VDD.$1995.Metal1 0.0103999705414
Rred_342 VDD.$1975.Metal1 VDD.$5702.Metal2 2.15309979481
Rred_343 VDD.$1975.Metal1 VDD.$5766.Metal2 15.8349980554
Rred_344 VDD.$1975.Metal1 VDD.$7922.Metal3 1974.98589936
Rred_345 VDD.$1975.Metal1 VDD.P1.nSD 17
Rred_346 VDD.$1975.Metal1 VDD.P3.nSD 17
Rred_347 VDD.$1979.Metal1 VDD.$1999.Metal1 0.0103999705414
Rred_348 VDD.$1979.Metal1 VDD.$5714.Metal2 2.15309979481
Rred_349 VDD.$1979.Metal1 VDD.$5806.Metal2 15.8349980554
Rred_350 VDD.$1979.Metal1 VDD.$7928.Metal3 1974.98589936
Rred_351 VDD.$1979.Metal1 VDD.P0.nSD 17
Rred_352 VDD.$1979.Metal1 VDD.P2.nSD 17
Rred_353 VDD.$1995.Metal1 VDD.$5702.Metal2 3.74281772218
Rred_354 VDD.$1995.Metal1 VDD.$5766.Metal2 1.94212947093
Rred_355 VDD.$1995.Metal1 VDD.$7922.Metal3 466.81484894
Rred_356 VDD.$1995.Metal1 VDD.P1.nSD 12.312761802
Rred_357 VDD.$1995.Metal1 VDD.P3.nSD 12.312761802
Rred_358 VDD.$1999.Metal1 VDD.$5714.Metal2 3.74281772218
Rred_359 VDD.$1999.Metal1 VDD.$5806.Metal2 1.94212947093
Rred_360 VDD.$1999.Metal1 VDD.$7928.Metal3 466.81484894
Rred_361 VDD.$1999.Metal1 VDD.P0.nSD 12.312761802
Rred_362 VDD.$1999.Metal1 VDD.P2.nSD 12.312761802
Rred_363 VDD.$2223.Metal1 VDD.$2243.Metal1 0.0103999705414
Rred_364 VDD.$2223.Metal1 VDD.$5846.Metal2 1.94212947093
Rred_365 VDD.$2223.Metal1 VDD.$5936.Metal2 3.74281772218
Rred_366 VDD.$2223.Metal1 VDD.$7958.Metal3 466.81484894
Rred_367 VDD.$2223.Metal1 VDD.P1.nSD 12.312761802
Rred_368 VDD.$2223.Metal1 VDD.P3.nSD 12.312761802
Rred_369 VDD.$2227.Metal1 VDD.$2247.Metal1 0.0103999705414
Rred_370 VDD.$2227.Metal1 VDD.$5886.Metal2 1.94212947093
Rred_371 VDD.$2227.Metal1 VDD.$5948.Metal2 3.74281772218
Rred_372 VDD.$2227.Metal1 VDD.$7964.Metal3 466.81484894
Rred_373 VDD.$2227.Metal1 VDD.P0.nSD 12.312761802
Rred_374 VDD.$2227.Metal1 VDD.P2.nSD 12.312761802
Rred_375 VDD.$2243.Metal1 VDD.$2263.Metal1 0.0104061145833
Rred_376 VDD.$2243.Metal1 VDD.$5846.Metal2 15.8349980554
Rred_377 VDD.$2243.Metal1 VDD.$5936.Metal2 2.15309979481
Rred_378 VDD.$2243.Metal1 VDD.$7958.Metal3 1974.98589936
Rred_379 VDD.$2243.Metal1 VDD.P1.nSD 17
Rred_380 VDD.$2243.Metal1 VDD.P3.nSD 17
Rred_381 VDD.$2247.Metal1 VDD.$2267.Metal1 0.0104061145833
Rred_382 VDD.$2247.Metal1 VDD.$5886.Metal2 15.8349980554
Rred_383 VDD.$2247.Metal1 VDD.$5948.Metal2 2.15309979481
Rred_384 VDD.$2247.Metal1 VDD.$7964.Metal3 1974.98589936
Rred_385 VDD.$2247.Metal1 VDD.P0.nSD 17
Rred_386 VDD.$2247.Metal1 VDD.P2.nSD 17
Rred_387 VDD.$225.Metal1 VDD.$226.Metal1 0.025365926806
Rred_388 VDD.$225.Metal1 VDD.$4231.Metal2 0.512003366412
Rred_389 VDD.$225.Metal1 VDD.$4233.Metal2 33.10521796
Rred_390 VDD.$225.Metal1 VDD.P24.pSD 2.07027273886
Rred_391 VDD.$225.Metal1 VDD.P25.pSD 2.07027273886
Rred_392 VDD.$226.Metal1 VDD.$4231.Metal2 12.4177281212
Rred_393 VDD.$226.Metal1 VDD.$4233.Metal2 4.81908408106
Rred_394 VDD.$226.Metal1 VDD.$508.Metal1 0.0556661596173
Rred_395 VDD.$226.Metal1 VDD.P24.pSD 17
Rred_396 VDD.$226.Metal1 VDD.P25.pSD 11.2148909248
Rred_397 VDD.$2263.Metal1 VDD.$2283.Metal1 0.0104060460767
Rred_398 VDD.$2263.Metal1 VDD.$5936.Metal2 2.52939521146
Rred_399 VDD.$2263.Metal1 VDD.$5984.Metal2 7.62871232124
Rred_400 VDD.$2263.Metal1 VDD.$7982.Metal3 951.474652036
Rred_401 VDD.$2263.Metal1 VDD.P1.nSD 17
Rred_402 VDD.$2263.Metal1 VDD.P3.nSD 17
Rred_403 VDD.$2267.Metal1 VDD.$2287.Metal1 0.0104060460767
Rred_404 VDD.$2267.Metal1 VDD.$5948.Metal2 2.52939521146
Rred_405 VDD.$2267.Metal1 VDD.$5996.Metal2 7.62871232124
Rred_406 VDD.$2267.Metal1 VDD.$7988.Metal3 951.474652036
Rred_407 VDD.$2267.Metal1 VDD.P0.nSD 17
Rred_408 VDD.$2267.Metal1 VDD.P2.nSD 17
Rred_409 VDD.$2283.Metal1 VDD.$2323.Metal1 0.0208598118236
Rred_410 VDD.$2283.Metal1 VDD.$5936.Metal2 5.02378616276
Rred_411 VDD.$2283.Metal1 VDD.$5984.Metal2 1.68172377179
Rred_412 VDD.$2283.Metal1 VDD.$7982.Metal3 626.580868414
Rred_413 VDD.$2283.Metal1 VDD.P1.nSD 11.3482094588
Rred_414 VDD.$2283.Metal1 VDD.P3.nSD 11.3482094588
Rred_415 VDD.$2287.Metal1 VDD.$2327.Metal1 0.0208598118236
Rred_416 VDD.$2287.Metal1 VDD.$5948.Metal2 5.02378616276
Rred_417 VDD.$2287.Metal1 VDD.$5996.Metal2 1.68172377179
Rred_418 VDD.$2287.Metal1 VDD.$7988.Metal3 626.580868414
Rred_419 VDD.$2287.Metal1 VDD.P0.nSD 11.3482094588
Rred_420 VDD.$2287.Metal1 VDD.P2.nSD 11.3482094588
Rred_421 VDD.$2323.Metal1 VDD.$2389.Metal1 0.0103899273095
Rred_422 VDD.$2323.Metal1 VDD.$5984.Metal2 1.68255549341
Rred_423 VDD.$2323.Metal1 VDD.$6090.Metal2 3.06949523821
Rred_424 VDD.$2323.Metal1 VDD.$8006.Metal3 382.836157757
Rred_425 VDD.$2323.Metal1 VDD.P1.nSD 11.3441704394
Rred_426 VDD.$2323.Metal1 VDD.P3.nSD 11.3441704394
Rred_427 VDD.$2327.Metal1 VDD.$2393.Metal1 0.0103899273095
Rred_428 VDD.$2327.Metal1 VDD.$5996.Metal2 1.68255549341
Rred_429 VDD.$2327.Metal1 VDD.$6102.Metal2 3.06949523821
Rred_430 VDD.$2327.Metal1 VDD.$8012.Metal3 382.836157757
Rred_431 VDD.$2327.Metal1 VDD.P0.nSD 11.3441704394
Rred_432 VDD.$2327.Metal1 VDD.P2.nSD 11.3441704394
Rred_433 VDD.$2330.Metal1 VDD.$2389.Metal1 0.00519887924383
Rred_434 VDD.$2330.Metal1 VDD.$2477.Metal1 0.00519444444444
Rred_435 VDD.$2330.Metal1 VDD.$6032.Metal2 0.672846329255
Rred_436 VDD.$2330.Metal1 VDD.$6090.Metal2 3.40290277778
Rred_437 VDD.$2330.Metal1 VDD.P37.pSD 1.99292147919
Rred_438 VDD.$2330.Metal1 VDD.P85.pSD 1.99292147919
Rred_439 VDD.$2331.Metal1 VDD.$2393.Metal1 0.00519887924383
Rred_440 VDD.$2331.Metal1 VDD.$2481.Metal1 0.00519444444444
Rred_441 VDD.$2331.Metal1 VDD.$6033.Metal2 0.672846329255
Rred_442 VDD.$2331.Metal1 VDD.$6102.Metal2 3.40290277778
Rred_443 VDD.$2331.Metal1 VDD.P13.pSD 1.99292147919
Rred_444 VDD.$2331.Metal1 VDD.P61.pSD 1.99292147919
Rred_445 VDD.$2389.Metal1 VDD.$5984.Metal2 205.656180959
Rred_446 VDD.$2389.Metal1 VDD.$6090.Metal2 2.6518607363
Rred_447 VDD.$2389.Metal1 VDD.$8006.Metal3 25650.0225697
Rred_448 VDD.$2389.Metal1 VDD.P1.nSD 17
Rred_449 VDD.$2389.Metal1 VDD.P3.nSD 17
Rred_450 VDD.$2393.Metal1 VDD.$5996.Metal2 205.656180959
Rred_451 VDD.$2393.Metal1 VDD.$6102.Metal2 2.6518607363
Rred_452 VDD.$2393.Metal1 VDD.$8012.Metal3 25650.0225697
Rred_453 VDD.$2393.Metal1 VDD.P0.nSD 17
Rred_454 VDD.$2393.Metal1 VDD.P2.nSD 17
Rred_455 VDD.$2477.Metal1 VDD.$2553.Metal1 0.0104064271562
Rred_456 VDD.$2477.Metal1 VDD.$6032.Metal2 4.66484882808
Rred_457 VDD.$2477.Metal1 VDD.$6194.Metal2 6.07170799846
Rred_458 VDD.$2477.Metal1 VDD.$8030.Metal3 757.280653908
Rred_459 VDD.$2477.Metal1 VDD.P1.nSD 17
Rred_460 VDD.$2477.Metal1 VDD.P3.nSD 17
Rred_461 VDD.$2481.Metal1 VDD.$2557.Metal1 0.0104064271562
Rred_462 VDD.$2481.Metal1 VDD.$6033.Metal2 4.66484882808
Rred_463 VDD.$2481.Metal1 VDD.$6206.Metal2 6.07170799846
Rred_464 VDD.$2481.Metal1 VDD.$8036.Metal3 757.280653908
Rred_465 VDD.$2481.Metal1 VDD.P0.nSD 17
Rred_466 VDD.$2481.Metal1 VDD.P2.nSD 17
Rred_467 VDD.$2553.Metal1 VDD.$2573.Metal1 0.0104056166409
Rred_468 VDD.$2553.Metal1 VDD.$6032.Metal2 6.27341738947
Rred_469 VDD.$2553.Metal1 VDD.$6194.Metal2 2.72351925575
Rred_470 VDD.$2553.Metal1 VDD.$8030.Metal3 1018.41191388
Rred_471 VDD.$2553.Metal1 VDD.P1.nSD 17
Rred_472 VDD.$2553.Metal1 VDD.P3.nSD 17
Rred_473 VDD.$2557.Metal1 VDD.$2577.Metal1 0.0104056166409
Rred_474 VDD.$2557.Metal1 VDD.$6033.Metal2 6.27341738947
Rred_475 VDD.$2557.Metal1 VDD.$6206.Metal2 2.72351925575
Rred_476 VDD.$2557.Metal1 VDD.$8036.Metal3 1018.41191388
Rred_477 VDD.$2557.Metal1 VDD.P0.nSD 17
Rred_478 VDD.$2557.Metal1 VDD.P2.nSD 17
Rred_479 VDD.$2573.Metal1 VDD.$2593.Metal1 0.0103986066457
Rred_480 VDD.$2573.Metal1 VDD.$6194.Metal2 2.10822082493
Rred_481 VDD.$2573.Metal1 VDD.$6242.Metal2 18.7116343669
Rred_482 VDD.$2573.Metal1 VDD.$8054.Metal3 2333.76814442
Rred_483 VDD.$2573.Metal1 VDD.P1.nSD 17
Rred_484 VDD.$2573.Metal1 VDD.P3.nSD 17
Rred_485 VDD.$2577.Metal1 VDD.$2597.Metal1 0.0103986066457
Rred_486 VDD.$2577.Metal1 VDD.$6206.Metal2 2.10822082493
Rred_487 VDD.$2577.Metal1 VDD.$6254.Metal2 18.7116343669
Rred_488 VDD.$2577.Metal1 VDD.$8060.Metal3 2333.76814442
Rred_489 VDD.$2577.Metal1 VDD.P0.nSD 17
Rred_490 VDD.$2577.Metal1 VDD.P2.nSD 17
Rred_491 VDD.$259.Metal1 VDD.$260.Metal1 0.025365926806
Rred_492 VDD.$259.Metal1 VDD.$4259.Metal2 0.512003366412
Rred_493 VDD.$259.Metal1 VDD.$4261.Metal2 33.10521796
Rred_494 VDD.$259.Metal1 VDD.P48.pSD 2.07027273886
Rred_495 VDD.$259.Metal1 VDD.P49.pSD 2.07027273886
Rred_496 VDD.$2593.Metal1 VDD.$2621.Metal1 0.0208622916459
Rred_497 VDD.$2593.Metal1 VDD.$6194.Metal2 3.61101715853
Rred_498 VDD.$2593.Metal1 VDD.$6242.Metal2 1.6827454053
Rred_499 VDD.$2593.Metal1 VDD.$8054.Metal3 450.376308574
Rred_500 VDD.$2593.Metal1 VDD.P1.nSD 11.3475561438
Rred_501 VDD.$2593.Metal1 VDD.P3.nSD 11.3475561438
Rred_502 VDD.$2597.Metal1 VDD.$2625.Metal1 0.0208622916459
Rred_503 VDD.$2597.Metal1 VDD.$6206.Metal2 3.61101715853
Rred_504 VDD.$2597.Metal1 VDD.$6254.Metal2 1.6827454053
Rred_505 VDD.$2597.Metal1 VDD.$8060.Metal3 450.376308574
Rred_506 VDD.$2597.Metal1 VDD.P0.nSD 11.3475561438
Rred_507 VDD.$2597.Metal1 VDD.P2.nSD 11.3475561438
Rred_508 VDD.$260.Metal1 VDD.$4259.Metal2 12.4177281212
Rred_509 VDD.$260.Metal1 VDD.$4261.Metal2 4.81908408106
Rred_510 VDD.$260.Metal1 VDD.$542.Metal1 0.0556661596173
Rred_511 VDD.$260.Metal1 VDD.P48.pSD 17
Rred_512 VDD.$260.Metal1 VDD.P49.pSD 11.2148909248
Rred_513 VDD.$2621.Metal1 VDD.$2641.Metal1 0.0104023263612
Rred_514 VDD.$2621.Metal1 VDD.$6242.Metal2 1.68254336609
Rred_515 VDD.$2621.Metal1 VDD.$6290.Metal2 4.0372863795
Rred_516 VDD.$2621.Metal1 VDD.$8078.Metal3 503.541815624
Rred_517 VDD.$2621.Metal1 VDD.P1.nSD 11.3486579358
Rred_518 VDD.$2621.Metal1 VDD.P3.nSD 11.3486579358
Rred_519 VDD.$2625.Metal1 VDD.$2645.Metal1 0.0104023263612
Rred_520 VDD.$2625.Metal1 VDD.$6254.Metal2 1.68254336609
Rred_521 VDD.$2625.Metal1 VDD.$6302.Metal2 4.0372863795
Rred_522 VDD.$2625.Metal1 VDD.$8084.Metal3 503.541815624
Rred_523 VDD.$2625.Metal1 VDD.P0.nSD 11.3486579358
Rred_524 VDD.$2625.Metal1 VDD.P2.nSD 11.3486579358
Rred_525 VDD.$2641.Metal1 VDD.$2660.Metal1 0.016851519775
Rred_526 VDD.$2641.Metal1 VDD.$6242.Metal2 12.1118591385
Rred_527 VDD.$2641.Metal1 VDD.$6290.Metal2 1.78503067067
Rred_528 VDD.$2641.Metal1 VDD.$8078.Metal3 1510.62544687
Rred_529 VDD.$2641.Metal1 VDD.P1.nSD 12.3119108098
Rred_530 VDD.$2641.Metal1 VDD.P3.nSD 12.3119108098
Rred_531 VDD.$2645.Metal1 VDD.$2661.Metal1 0.016851519775
Rred_532 VDD.$2645.Metal1 VDD.$6254.Metal2 12.1118591385
Rred_533 VDD.$2645.Metal1 VDD.$6302.Metal2 1.78503067067
Rred_534 VDD.$2645.Metal1 VDD.$8084.Metal3 1510.62544687
Rred_535 VDD.$2645.Metal1 VDD.P0.nSD 12.3119108098
Rred_536 VDD.$2645.Metal1 VDD.P2.nSD 12.3119108098
Rred_537 VDD.$2660.Metal1 VDD.$2807.Metal1 0.00397329591049
Rred_538 VDD.$2660.Metal1 VDD.$6290.Metal2 4.13747604883
Rred_539 VDD.$2660.Metal1 VDD.$6372.Metal2 0.495002229587
Rred_540 VDD.$2660.Metal1 VDD.P1.nSD 27.5279211787
Rred_541 VDD.$2660.Metal1 VDD.P3.nSD 27.5279211787
Rred_542 VDD.$2660.Metal1 VDD.P39.pSD 1.99222205734
Rred_543 VDD.$2660.Metal1 VDD.P87.pSD 1.99222205734
Rred_544 VDD.$2661.Metal1 VDD.$2811.Metal1 0.00397329591049
Rred_545 VDD.$2661.Metal1 VDD.$6302.Metal2 4.13747604883
Rred_546 VDD.$2661.Metal1 VDD.$6384.Metal2 0.495002229587
Rred_547 VDD.$2661.Metal1 VDD.P0.nSD 27.5279211787
Rred_548 VDD.$2661.Metal1 VDD.P15.pSD 1.99222205734
Rred_549 VDD.$2661.Metal1 VDD.P2.nSD 27.5279211787
Rred_550 VDD.$2661.Metal1 VDD.P63.pSD 1.99222205734
Rred_551 VDD.$2807.Metal1 VDD.$2883.Metal1 0.0103971187595
Rred_552 VDD.$2807.Metal1 VDD.$6372.Metal2 8.28951071668
Rred_553 VDD.$2807.Metal1 VDD.$6476.Metal2 22.8665030121
Rred_554 VDD.$2807.Metal1 VDD.$8114.Metal3 2851.97515394
Rred_555 VDD.$2807.Metal1 VDD.P1.nSD 17
Rred_556 VDD.$2807.Metal1 VDD.P3.nSD 17
Rred_557 VDD.$2811.Metal1 VDD.$2887.Metal1 0.0103971187595
Rred_558 VDD.$2811.Metal1 VDD.$6384.Metal2 8.28951071668
Rred_559 VDD.$2811.Metal1 VDD.$6488.Metal2 22.8665030121
Rred_560 VDD.$2811.Metal1 VDD.$8120.Metal3 2851.97515394
Rred_561 VDD.$2811.Metal1 VDD.P0.nSD 17
Rred_562 VDD.$2811.Metal1 VDD.P2.nSD 17
Rred_563 VDD.$2883.Metal1 VDD.$2911.Metal1 0.0208620449569
Rred_564 VDD.$2883.Metal1 VDD.$6372.Metal2 3.48811062896
Rred_565 VDD.$2883.Metal1 VDD.$6476.Metal2 1.6827530387
Rred_566 VDD.$2883.Metal1 VDD.$8114.Metal3 435.047057381
Rred_567 VDD.$2883.Metal1 VDD.P1.nSD 11.3468336065
Rred_568 VDD.$2883.Metal1 VDD.P3.nSD 11.3468336065
Rred_569 VDD.$2887.Metal1 VDD.$2915.Metal1 0.0208620449569
Rred_570 VDD.$2887.Metal1 VDD.$6384.Metal2 3.48811062896
Rred_571 VDD.$2887.Metal1 VDD.$6488.Metal2 1.6827530387
Rred_572 VDD.$2887.Metal1 VDD.$8120.Metal3 435.047057381
Rred_573 VDD.$2887.Metal1 VDD.P0.nSD 11.3468336065
Rred_574 VDD.$2887.Metal1 VDD.P2.nSD 11.3468336065
Rred_575 VDD.$2911.Metal1 VDD.$2931.Metal1 0.0104033182853
Rred_576 VDD.$2911.Metal1 VDD.$6476.Metal2 1.68241800287
Rred_577 VDD.$2911.Metal1 VDD.$6524.Metal2 4.20247427156
Rred_578 VDD.$2911.Metal1 VDD.$8138.Metal3 524.144518347
Rred_579 VDD.$2911.Metal1 VDD.P1.nSD 11.3486133252
Rred_580 VDD.$2911.Metal1 VDD.P3.nSD 11.3486133252
Rred_581 VDD.$2915.Metal1 VDD.$2935.Metal1 0.0104033182853
Rred_582 VDD.$2915.Metal1 VDD.$6488.Metal2 1.68241800287
Rred_583 VDD.$2915.Metal1 VDD.$6536.Metal2 4.20247427156
Rred_584 VDD.$2915.Metal1 VDD.$8144.Metal3 524.144518347
Rred_585 VDD.$2915.Metal1 VDD.P0.nSD 11.3486133252
Rred_586 VDD.$2915.Metal1 VDD.P2.nSD 11.3486133252
Rred_587 VDD.$2931.Metal1 VDD.$2951.Metal1 0.0104068614969
Rred_588 VDD.$2931.Metal1 VDD.$6476.Metal2 10.8379599635
Rred_589 VDD.$2931.Metal1 VDD.$6524.Metal2 2.29983953107
Rred_590 VDD.$2931.Metal1 VDD.$8138.Metal3 1351.74112626
Rred_591 VDD.$2931.Metal1 VDD.P1.nSD 17
Rred_592 VDD.$2931.Metal1 VDD.P3.nSD 17
Rred_593 VDD.$2935.Metal1 VDD.$2955.Metal1 0.0104068614969
Rred_594 VDD.$2935.Metal1 VDD.$6488.Metal2 10.8379599635
Rred_595 VDD.$2935.Metal1 VDD.$6536.Metal2 2.29983953107
Rred_596 VDD.$2935.Metal1 VDD.$8144.Metal3 1351.74112626
Rred_597 VDD.$2935.Metal1 VDD.P0.nSD 17
Rred_598 VDD.$2935.Metal1 VDD.P2.nSD 17
Rred_599 VDD.$2951.Metal1 VDD.$2971.Metal1 0.010404186219
Rred_600 VDD.$2951.Metal1 VDD.$6524.Metal2 2.35325729591
Rred_601 VDD.$2951.Metal1 VDD.$6572.Metal2 9.80659138163
Rred_602 VDD.$2951.Metal1 VDD.$8162.Metal3 1223.10590957
Rred_603 VDD.$2951.Metal1 VDD.P1.nSD 17
Rred_604 VDD.$2951.Metal1 VDD.P3.nSD 17
Rred_605 VDD.$2955.Metal1 VDD.$2975.Metal1 0.010404186219
Rred_606 VDD.$2955.Metal1 VDD.$6536.Metal2 2.35325729591
Rred_607 VDD.$2955.Metal1 VDD.$6584.Metal2 9.80659138163
Rred_608 VDD.$2955.Metal1 VDD.$8168.Metal3 1223.10590957
Rred_609 VDD.$2955.Metal1 VDD.P0.nSD 17
Rred_610 VDD.$2955.Metal1 VDD.P2.nSD 17
Rred_611 VDD.$2971.Metal1 VDD.$2998.Metal1 0.0180912247213
Rred_612 VDD.$2971.Metal1 VDD.$6524.Metal2 4.38166848966
Rred_613 VDD.$2971.Metal1 VDD.$6572.Metal2 1.82095135804
Rred_614 VDD.$2971.Metal1 VDD.$8162.Metal3 546.494129806
Rred_615 VDD.$2971.Metal1 VDD.P1.nSD 11.9529522847
Rred_616 VDD.$2971.Metal1 VDD.P3.nSD 11.9529522847
Rred_617 VDD.$2975.Metal1 VDD.$2999.Metal1 0.0180912247213
Rred_618 VDD.$2975.Metal1 VDD.$6536.Metal2 4.38166848966
Rred_619 VDD.$2975.Metal1 VDD.$6584.Metal2 1.82095135804
Rred_620 VDD.$2975.Metal1 VDD.$8168.Metal3 546.494129806
Rred_621 VDD.$2975.Metal1 VDD.P0.nSD 11.9529522847
Rred_622 VDD.$2975.Metal1 VDD.P2.nSD 11.9529522847
Rred_623 VDD.$2998.Metal1 VDD.$3201.Metal1 0.0131659822165
Rred_624 VDD.$2998.Metal1 VDD.$6572.Metal2 1.25914383683
Rred_625 VDD.$2998.Metal1 VDD.$6654.Metal2 0.666825662375
Rred_626 VDD.$2998.Metal1 VDD.P1.nSD 12.4615829176
Rred_627 VDD.$2998.Metal1 VDD.P3.nSD 12.4615829176
Rred_628 VDD.$2998.Metal1 VDD.P41.pSD 1.98874159732
Rred_629 VDD.$2998.Metal1 VDD.P89.pSD 1.98874159732
Rred_630 VDD.$2999.Metal1 VDD.$3205.Metal1 0.0131659822165
Rred_631 VDD.$2999.Metal1 VDD.$6584.Metal2 1.25914383683
Rred_632 VDD.$2999.Metal1 VDD.$6666.Metal2 0.666825662375
Rred_633 VDD.$2999.Metal1 VDD.P0.nSD 12.4615829176
Rred_634 VDD.$2999.Metal1 VDD.P17.pSD 1.98874159732
Rred_635 VDD.$2999.Metal1 VDD.P2.nSD 12.4615829176
Rred_636 VDD.$2999.Metal1 VDD.P65.pSD 1.98874159732
Rred_637 VDD.$3201.Metal1 VDD.$3221.Metal1 0.010404186219
Rred_638 VDD.$3201.Metal1 VDD.$6654.Metal2 2.37168738593
Rred_639 VDD.$3201.Metal1 VDD.$6758.Metal2 4.38166848966
Rred_640 VDD.$3201.Metal1 VDD.$8198.Metal3 546.494129806
Rred_641 VDD.$3201.Metal1 VDD.P1.nSD 14.0627009151
Rred_642 VDD.$3201.Metal1 VDD.P3.nSD 14.0627009151
Rred_643 VDD.$3205.Metal1 VDD.$3225.Metal1 0.010404186219
Rred_644 VDD.$3205.Metal1 VDD.$6666.Metal2 2.37168738593
Rred_645 VDD.$3205.Metal1 VDD.$6770.Metal2 4.38166848966
Rred_646 VDD.$3205.Metal1 VDD.$8204.Metal3 546.494129806
Rred_647 VDD.$3205.Metal1 VDD.P0.nSD 14.0627009151
Rred_648 VDD.$3205.Metal1 VDD.P2.nSD 14.0627009151
Rred_649 VDD.$3221.Metal1 VDD.$3241.Metal1 0.0104068614969
Rred_650 VDD.$3221.Metal1 VDD.$6654.Metal2 9.80659138163
Rred_651 VDD.$3221.Metal1 VDD.$6758.Metal2 2.35325729591
Rred_652 VDD.$3221.Metal1 VDD.$8198.Metal3 1223.10590957
Rred_653 VDD.$3221.Metal1 VDD.P1.nSD 17
Rred_654 VDD.$3221.Metal1 VDD.P3.nSD 17
Rred_655 VDD.$3225.Metal1 VDD.$3245.Metal1 0.0104068614969
Rred_656 VDD.$3225.Metal1 VDD.$6666.Metal2 9.80659138163
Rred_657 VDD.$3225.Metal1 VDD.$6770.Metal2 2.35325729591
Rred_658 VDD.$3225.Metal1 VDD.$8204.Metal3 1223.10590957
Rred_659 VDD.$3225.Metal1 VDD.P0.nSD 17
Rred_660 VDD.$3225.Metal1 VDD.P2.nSD 17
Rred_661 VDD.$3241.Metal1 VDD.$3261.Metal1 0.0104033182853
Rred_662 VDD.$3241.Metal1 VDD.$6758.Metal2 2.29983953107
Rred_663 VDD.$3241.Metal1 VDD.$6806.Metal2 10.8379599635
Rred_664 VDD.$3241.Metal1 VDD.$8222.Metal3 1351.74112626
Rred_665 VDD.$3241.Metal1 VDD.P1.nSD 17
Rred_666 VDD.$3241.Metal1 VDD.P3.nSD 17
Rred_667 VDD.$3245.Metal1 VDD.$3265.Metal1 0.0104033182853
Rred_668 VDD.$3245.Metal1 VDD.$6770.Metal2 2.29983953107
Rred_669 VDD.$3245.Metal1 VDD.$6818.Metal2 10.8379599635
Rred_670 VDD.$3245.Metal1 VDD.$8228.Metal3 1351.74112626
Rred_671 VDD.$3245.Metal1 VDD.P0.nSD 17
Rred_672 VDD.$3245.Metal1 VDD.P2.nSD 17
Rred_673 VDD.$3261.Metal1 VDD.$3289.Metal1 0.0208620449569
Rred_674 VDD.$3261.Metal1 VDD.$6758.Metal2 4.20247427156
Rred_675 VDD.$3261.Metal1 VDD.$6806.Metal2 1.68241800287
Rred_676 VDD.$3261.Metal1 VDD.$8222.Metal3 524.144518347
Rred_677 VDD.$3261.Metal1 VDD.P1.nSD 11.3486133252
Rred_678 VDD.$3261.Metal1 VDD.P3.nSD 11.3486133252
Rred_679 VDD.$3265.Metal1 VDD.$3293.Metal1 0.0208620449569
Rred_680 VDD.$3265.Metal1 VDD.$6770.Metal2 4.20247427156
Rred_681 VDD.$3265.Metal1 VDD.$6818.Metal2 1.68241800287
Rred_682 VDD.$3265.Metal1 VDD.$8228.Metal3 524.144518347
Rred_683 VDD.$3265.Metal1 VDD.P0.nSD 11.3486133252
Rred_684 VDD.$3265.Metal1 VDD.P2.nSD 11.3486133252
Rred_685 VDD.$3289.Metal1 VDD.$3309.Metal1 0.0103971187595
Rred_686 VDD.$3289.Metal1 VDD.$6806.Metal2 1.6827530387
Rred_687 VDD.$3289.Metal1 VDD.$6912.Metal2 3.48811062896
Rred_688 VDD.$3289.Metal1 VDD.$8246.Metal3 435.047057381
Rred_689 VDD.$3289.Metal1 VDD.P1.nSD 11.3468336065
Rred_690 VDD.$3289.Metal1 VDD.P3.nSD 11.3468336065
Rred_691 VDD.$3293.Metal1 VDD.$3313.Metal1 0.0103971187595
Rred_692 VDD.$3293.Metal1 VDD.$6818.Metal2 1.6827530387
Rred_693 VDD.$3293.Metal1 VDD.$6924.Metal2 3.48811062896
Rred_694 VDD.$3293.Metal1 VDD.$8252.Metal3 435.047057381
Rred_695 VDD.$3293.Metal1 VDD.P0.nSD 11.3468336065
Rred_696 VDD.$3293.Metal1 VDD.P2.nSD 11.3468336065
Rred_697 VDD.$3309.Metal1 VDD.$3316.Metal1 0.00887363747428
Rred_698 VDD.$3309.Metal1 VDD.$6806.Metal2 22.8665030121
Rred_699 VDD.$3309.Metal1 VDD.$6912.Metal2 2.24485514274
Rred_700 VDD.$3309.Metal1 VDD.$8246.Metal3 2851.97515394
Rred_701 VDD.$3309.Metal1 VDD.P1.nSD 17
Rred_702 VDD.$3309.Metal1 VDD.P3.nSD 17
Rred_703 VDD.$3313.Metal1 VDD.$3317.Metal1 0.00887363747428
Rred_704 VDD.$3313.Metal1 VDD.$6818.Metal2 22.8665030121
Rred_705 VDD.$3313.Metal1 VDD.$6924.Metal2 2.24485514274
Rred_706 VDD.$3313.Metal1 VDD.$8252.Metal3 2851.97515394
Rred_707 VDD.$3313.Metal1 VDD.P0.nSD 17
Rred_708 VDD.$3313.Metal1 VDD.P2.nSD 17
Rred_709 VDD.$3316.Metal1 VDD.$3531.Metal1 0.0119412090979
Rred_710 VDD.$3316.Metal1 VDD.$6912.Metal2 0.900286807852
Rred_711 VDD.$3316.Metal1 VDD.$6992.Metal2 1.11734273443
Rred_712 VDD.$3316.Metal1 VDD.P1.nSD 19.5066478997
Rred_713 VDD.$3316.Metal1 VDD.P3.nSD 19.5066478997
Rred_714 VDD.$3316.Metal1 VDD.P43.pSD 1.98810169492
Rred_715 VDD.$3316.Metal1 VDD.P91.pSD 1.98810169492
Rred_716 VDD.$3317.Metal1 VDD.$3535.Metal1 0.0119412090979
Rred_717 VDD.$3317.Metal1 VDD.$6924.Metal2 0.900286807852
Rred_718 VDD.$3317.Metal1 VDD.$7004.Metal2 1.11734273443
Rred_719 VDD.$3317.Metal1 VDD.P0.nSD 19.5066478997
Rred_720 VDD.$3317.Metal1 VDD.P19.pSD 1.98810169492
Rred_721 VDD.$3317.Metal1 VDD.P2.nSD 19.5066478997
Rred_722 VDD.$3317.Metal1 VDD.P67.pSD 1.98810169492
Rred_723 VDD.$3531.Metal1 VDD.$3551.Metal1 0.0104023263612
Rred_724 VDD.$3531.Metal1 VDD.$6992.Metal2 2.06823431305
Rred_725 VDD.$3531.Metal1 VDD.$7040.Metal2 12.1118591385
Rred_726 VDD.$3531.Metal1 VDD.$8282.Metal3 1510.62544687
Rred_727 VDD.$3531.Metal1 VDD.P1.nSD 15.0717018687
Rred_728 VDD.$3531.Metal1 VDD.P3.nSD 15.0717018687
Rred_729 VDD.$3535.Metal1 VDD.$3555.Metal1 0.0104023263612
Rred_730 VDD.$3535.Metal1 VDD.$7004.Metal2 2.06823431305
Rred_731 VDD.$3535.Metal1 VDD.$7052.Metal2 12.1118591385
Rred_732 VDD.$3535.Metal1 VDD.$8288.Metal3 1510.62544687
Rred_733 VDD.$3535.Metal1 VDD.P0.nSD 15.0717018687
Rred_734 VDD.$3535.Metal1 VDD.P2.nSD 15.0717018687
Rred_735 VDD.$3551.Metal1 VDD.$3579.Metal1 0.0208622916459
Rred_736 VDD.$3551.Metal1 VDD.$6992.Metal2 4.0372863795
Rred_737 VDD.$3551.Metal1 VDD.$7040.Metal2 1.68254336609
Rred_738 VDD.$3551.Metal1 VDD.$8282.Metal3 503.541815624
Rred_739 VDD.$3551.Metal1 VDD.P1.nSD 11.3486579358
Rred_740 VDD.$3551.Metal1 VDD.P3.nSD 11.3486579358
Rred_741 VDD.$3555.Metal1 VDD.$3583.Metal1 0.0208622916459
Rred_742 VDD.$3555.Metal1 VDD.$7004.Metal2 4.0372863795
Rred_743 VDD.$3555.Metal1 VDD.$7052.Metal2 1.68254336609
Rred_744 VDD.$3555.Metal1 VDD.$8288.Metal3 503.541815624
Rred_745 VDD.$3555.Metal1 VDD.P0.nSD 11.3486579358
Rred_746 VDD.$3555.Metal1 VDD.P2.nSD 11.3486579358
Rred_747 VDD.$3579.Metal1 VDD.$3599.Metal1 0.0103986066457
Rred_748 VDD.$3579.Metal1 VDD.$7040.Metal2 1.6827454053
Rred_749 VDD.$3579.Metal1 VDD.$7088.Metal2 3.61101715853
Rred_750 VDD.$3579.Metal1 VDD.$8306.Metal3 450.376308574
Rred_751 VDD.$3579.Metal1 VDD.P1.nSD 11.3475561438
Rred_752 VDD.$3579.Metal1 VDD.P3.nSD 11.3475561438
Rred_753 VDD.$3583.Metal1 VDD.$3603.Metal1 0.0103986066457
Rred_754 VDD.$3583.Metal1 VDD.$7052.Metal2 1.6827454053
Rred_755 VDD.$3583.Metal1 VDD.$7100.Metal2 3.61101715853
Rred_756 VDD.$3583.Metal1 VDD.$8312.Metal3 450.376308574
Rred_757 VDD.$3583.Metal1 VDD.P0.nSD 11.3475561438
Rred_758 VDD.$3583.Metal1 VDD.P2.nSD 11.3475561438
Rred_759 VDD.$3599.Metal1 VDD.$3619.Metal1 0.0104056166409
Rred_760 VDD.$3599.Metal1 VDD.$7040.Metal2 18.7116343669
Rred_761 VDD.$3599.Metal1 VDD.$7088.Metal2 2.10822082493
Rred_762 VDD.$3599.Metal1 VDD.$8306.Metal3 2333.76814442
Rred_763 VDD.$3599.Metal1 VDD.P1.nSD 17
Rred_764 VDD.$3599.Metal1 VDD.P3.nSD 17
Rred_765 VDD.$360.Metal1 VDD.$388.Metal1 27.0826084457
Rred_766 VDD.$360.Metal1 VDD.$4200.Metal2 6.23864140322
Rred_767 VDD.$360.Metal1 VDD.$4236.Metal2 48.5734673451
Rred_768 VDD.$360.Metal1 VDD.$4237.Metal2 5.94259858122
Rred_769 VDD.$360.Metal1 VDD.P1.nSD 5.66788854941
Rred_770 VDD.$360.Metal1 VDD.P2.GatPoly 84.93
Rred_771 VDD.$360.Metal1 VDD.P24.pSD 18.5372418383
Rred_772 VDD.$3603.Metal1 VDD.$3623.Metal1 0.0104056166409
Rred_773 VDD.$3603.Metal1 VDD.$7052.Metal2 18.7116343669
Rred_774 VDD.$3603.Metal1 VDD.$7100.Metal2 2.10822082493
Rred_775 VDD.$3603.Metal1 VDD.$8312.Metal3 2333.76814442
Rred_776 VDD.$3603.Metal1 VDD.P0.nSD 17
Rred_777 VDD.$3603.Metal1 VDD.P2.nSD 17
Rred_778 VDD.$361.Metal1 VDD.$4210.Metal2 0.395718840323
Rred_779 VDD.$361.Metal1 VDD.P3.nSD 3.8095353518
Rred_780 VDD.$361.Metal1 VDD.P6.GatPoly 28.31
Rred_781 VDD.$361.Metal1 VDD.P72.pSD 1.49943454635
Rred_782 VDD.$361.Metal1 VDD.P73.pSD 1.49943454635
Rred_783 VDD.$3619.Metal1 VDD.$3639.Metal1 0.0104064880401
Rred_784 VDD.$3619.Metal1 VDD.$7088.Metal2 4.08656944445
Rred_785 VDD.$3619.Metal1 VDD.$7112.Metal2 3.52319971264
Rred_786 VDD.$3619.Metal1 VDD.P1.nSD 17
Rred_787 VDD.$3619.Metal1 VDD.P3.nSD 17
Rred_788 VDD.$362.Metal1 VDD.$390.Metal1 27.0826084457
Rred_789 VDD.$362.Metal1 VDD.$4212.Metal2 6.23864140322
Rred_790 VDD.$362.Metal1 VDD.$4264.Metal2 48.5734673451
Rred_791 VDD.$362.Metal1 VDD.$4265.Metal2 5.94259858122
Rred_792 VDD.$362.Metal1 VDD.P2.nSD 5.66788854941
Rred_793 VDD.$362.Metal1 VDD.P4.GatPoly 84.93
Rred_794 VDD.$362.Metal1 VDD.P48.pSD 18.5372418383
Rred_795 VDD.$3623.Metal1 VDD.$3643.Metal1 0.0104064880401
Rred_796 VDD.$3623.Metal1 VDD.$7100.Metal2 4.08656944445
Rred_797 VDD.$3623.Metal1 VDD.$7124.Metal2 3.52319971264
Rred_798 VDD.$3623.Metal1 VDD.P0.nSD 17
Rred_799 VDD.$3623.Metal1 VDD.P2.nSD 17
Rred_800 VDD.$363.Metal1 VDD.$4222.Metal2 0.395718840323
Rred_801 VDD.$363.Metal1 VDD.P0.GatPoly 28.31
Rred_802 VDD.$363.Metal1 VDD.P0.nSD 3.8095353518
Rred_803 VDD.$363.Metal1 VDD.P0.pSD 1.49943454635
Rred_804 VDD.$363.Metal1 VDD.P1.pSD 1.49943454635
Rred_805 VDD.$3639.Metal1 VDD.$3646.Metal1 0.270142334821
Rred_806 VDD.$3639.Metal1 VDD.$3649.Metal1 0.111093962345
Rred_807 VDD.$3639.Metal1 VDD.$7112.Metal2 2.61981517094
Rred_808 VDD.$3639.Metal1 VDD.$7138.Metal2 16.8589658868
Rred_809 VDD.$3639.Metal1 VDD.$7140.Metal2 7.68234372912
Rred_810 VDD.$3639.Metal1 VDD.P1.nSD 17
Rred_811 VDD.$3639.Metal1 VDD.P3.nSD 17
Rred_812 VDD.$3643.Metal1 VDD.$3652.Metal1 0.270142334821
Rred_813 VDD.$3643.Metal1 VDD.$3655.Metal1 0.111093962345
Rred_814 VDD.$3643.Metal1 VDD.$7124.Metal2 2.61981517094
Rred_815 VDD.$3643.Metal1 VDD.$7150.Metal2 16.8589658868
Rred_816 VDD.$3643.Metal1 VDD.$7152.Metal2 7.68234372912
Rred_817 VDD.$3643.Metal1 VDD.P0.nSD 17
Rred_818 VDD.$3643.Metal1 VDD.P2.nSD 17
Rred_819 VDD.$3646.Metal1 VDD.$3649.Metal1 3.97833994763
Rred_820 VDD.$3646.Metal1 VDD.$3794.Metal1 0.143800059603
Rred_821 VDD.$3646.Metal1 VDD.$7136.Metal2 4.5
Rred_822 VDD.$3646.Metal1 VDD.$7138.Metal2 6.44642508898
Rred_823 VDD.$3646.Metal1 VDD.$7140.Metal2 12.6322301467
Rred_824 VDD.$3646.Metal1 VDD.P1.nSD 17.6853719602
Rred_825 VDD.$3649.Metal1 VDD.$7138.Metal2 248.2791063
Rred_826 VDD.$3649.Metal1 VDD.$7140.Metal2 113.136561765
Rred_827 VDD.$3649.Metal1 VDD.$7142.Metal2 9
Rred_828 VDD.$3649.Metal1 VDD.$7144.Metal2 9.31471882173
Rred_829 VDD.$3649.Metal1 VDD.$7146.Metal2 9.562523059
Rred_830 VDD.$3652.Metal1 VDD.$3655.Metal1 3.97833994763
Rred_831 VDD.$3652.Metal1 VDD.$3796.Metal1 0.143800059603
Rred_832 VDD.$3652.Metal1 VDD.$7148.Metal2 4.5
Rred_833 VDD.$3652.Metal1 VDD.$7150.Metal2 6.44642508898
Rred_834 VDD.$3652.Metal1 VDD.$7152.Metal2 12.6322301467
Rred_835 VDD.$3652.Metal1 VDD.P2.nSD 17.6853719602
Rred_836 VDD.$3655.Metal1 VDD.$7150.Metal2 248.2791063
Rred_837 VDD.$3655.Metal1 VDD.$7152.Metal2 113.136561765
Rred_838 VDD.$3655.Metal1 VDD.$7154.Metal2 9
Rred_839 VDD.$3655.Metal1 VDD.$7156.Metal2 9.31471882173
Rred_840 VDD.$3655.Metal1 VDD.$7158.Metal2 9.562523059
Rred_841 VDD.$3658.Metal1 VDD.$3731.Metal1 0.0339819469444
Rred_842 VDD.$3658.Metal1 VDD.$3794.Metal1 0.126052112616
Rred_843 VDD.$3658.Metal1 VDD.$3851.Metal1 0.100296948733
Rred_844 VDD.$3658.Metal1 VDD.$4032.Metal1 0.0731271020638
Rred_845 VDD.$3658.Metal1 VDD.$7173.Metal2 6.72557017604
Rred_846 VDD.$3658.Metal1 VDD.$7174.Metal2 3.29647063762
Rred_847 VDD.$3658.Metal1 VDD.$7175.Metal2 5.40731551599
Rred_848 VDD.$3658.Metal1 VDD.P45.pSD 8.02466480886
Rred_849 VDD.$3658.Metal1 VDD.P47.pSD 6.69668074804
Rred_850 VDD.$3660.Metal1 VDD.$3765.Metal1 0.0339819469444
Rred_851 VDD.$3660.Metal1 VDD.$3796.Metal1 0.126052112616
Rred_852 VDD.$3660.Metal1 VDD.$3857.Metal1 0.100296948733
Rred_853 VDD.$3660.Metal1 VDD.$4060.Metal1 0.0731271020638
Rred_854 VDD.$3660.Metal1 VDD.$7201.Metal2 6.72557017604
Rred_855 VDD.$3660.Metal1 VDD.$7202.Metal2 3.29647063762
Rred_856 VDD.$3660.Metal1 VDD.$7203.Metal2 5.40731551599
Rred_857 VDD.$3660.Metal1 VDD.P69.pSD 8.02466480886
Rred_858 VDD.$3660.Metal1 VDD.P71.pSD 6.69668074804
Rred_859 VDD.$3727.Metal1 VDD.$3728.Metal1 0.025365926806
Rred_860 VDD.$3727.Metal1 VDD.$4031.Metal1 22093.6689375
Rred_861 VDD.$3727.Metal1 VDD.$7169.Metal2 0.512003366412
Rred_862 VDD.$3727.Metal1 VDD.$7171.Metal2 33.10521796
Rred_863 VDD.$3727.Metal1 VDD.P45.pSD 2.07027273886
Rred_864 VDD.$3727.Metal1 VDD.P47.pSD 2.07027273886
Rred_865 VDD.$3728.Metal1 VDD.$3730.Metal1 0.0556661596173
Rred_866 VDD.$3728.Metal1 VDD.$4031.Metal1 8287.38032743
Rred_867 VDD.$3728.Metal1 VDD.$7169.Metal2 12.4177281212
Rred_868 VDD.$3728.Metal1 VDD.$7171.Metal2 4.81908408106
Rred_869 VDD.$3728.Metal1 VDD.P45.pSD 11.2148909248
Rred_870 VDD.$3728.Metal1 VDD.P47.pSD 17
Rred_871 VDD.$3730.Metal1 VDD.$3731.Metal1 0.0300959525217
Rred_872 VDD.$3730.Metal1 VDD.$4032.Metal1 6119.89076118
Rred_873 VDD.$3730.Metal1 VDD.$7171.Metal2 4.94495942488
Rred_874 VDD.$3730.Metal1 VDD.$7173.Metal2 9.27560002785
Rred_875 VDD.$3730.Metal1 VDD.P45.pSD 11.4815584753
Rred_876 VDD.$3731.Metal1 VDD.$4032.Metal1 217774.594191
Rred_877 VDD.$3731.Metal1 VDD.$7171.Metal2 330.06962228
Rred_878 VDD.$3731.Metal1 VDD.$7173.Metal2 10.4840395758
Rred_879 VDD.$3731.Metal1 VDD.P45.pSD 16.1120834306
Rred_880 VDD.$3736.Metal1 VDD.$3737.Metal1 0.0166730887752
Rred_881 VDD.$3736.Metal1 VDD.$3795.Metal1 0.0395331374099
Rred_882 VDD.$3736.Metal1 VDD.$7176.Metal2 3.1313155371
Rred_883 VDD.$3736.Metal1 VDD.$7178.Metal2 17.8124010356
Rred_884 VDD.$3736.Metal1 VDD.P93.pSD 10.831148609
Rred_885 VDD.$3736.Metal1 VDD.P95.pSD 10.831148609
Rred_886 VDD.$3737.Metal1 VDD.$3738.Metal1 0.0166662778099
Rred_887 VDD.$3737.Metal1 VDD.$7176.Metal2 9.09569414583
Rred_888 VDD.$3737.Metal1 VDD.$7178.Metal2 5.85054099171
Rred_889 VDD.$3737.Metal1 VDD.P93.pSD 17
Rred_890 VDD.$3737.Metal1 VDD.P95.pSD 17
Rred_891 VDD.$3738.Metal1 VDD.$3739.Metal1 0.0166549767343
Rred_892 VDD.$3738.Metal1 VDD.$7178.Metal2 3.61326430825
Rred_893 VDD.$3738.Metal1 VDD.$7180.Metal2 213.516616265
Rred_894 VDD.$3738.Metal1 VDD.P93.pSD 17
Rred_895 VDD.$3738.Metal1 VDD.P95.pSD 17
Rred_896 VDD.$3739.Metal1 VDD.$3741.Metal1 0.0336649638842
Rred_897 VDD.$3739.Metal1 VDD.$7178.Metal2 6.18888742798
Rred_898 VDD.$3739.Metal1 VDD.$7180.Metal2 3.24796024221
Rred_899 VDD.$3739.Metal1 VDD.P93.pSD 11.3717940732
Rred_900 VDD.$3739.Metal1 VDD.P95.pSD 11.3717940732
Rred_901 VDD.$3741.Metal1 VDD.$3742.Metal1 0.0166704549822
Rred_902 VDD.$3741.Metal1 VDD.$3743.Metal1 6450.595614
Rred_903 VDD.$3741.Metal1 VDD.$7180.Metal2 2.87532708662
Rred_904 VDD.$3741.Metal1 VDD.$7183.Metal2 12.3764049952
Rred_905 VDD.$3741.Metal1 VDD.P93.pSD 11.321112267
Rred_906 VDD.$3741.Metal1 VDD.P95.pSD 11.321112267
Rred_907 VDD.$3742.Metal1 VDD.$3743.Metal1 0.0166749221639
Rred_908 VDD.$3742.Metal1 VDD.$7180.Metal2 8.13873024254
Rred_909 VDD.$3742.Metal1 VDD.$7183.Metal2 6.36165854995
Rred_910 VDD.$3742.Metal1 VDD.P93.pSD 17
Rred_911 VDD.$3742.Metal1 VDD.P95.pSD 17
Rred_912 VDD.$3743.Metal1 VDD.$3744.Metal1 0.0169102994016
Rred_913 VDD.$3743.Metal1 VDD.$7180.Metal2 21.4581456389
Rred_914 VDD.$3743.Metal1 VDD.$7183.Metal2 4.22409521522
Rred_915 VDD.$3743.Metal1 VDD.P93.pSD 17
Rred_916 VDD.$3743.Metal1 VDD.P95.pSD 17
Rred_917 VDD.$3744.Metal1 VDD.$3745.Metal1 0.0166710938849
Rred_918 VDD.$3744.Metal1 VDD.$3746.Metal1 8109.57123758
Rred_919 VDD.$3744.Metal1 VDD.$7183.Metal2 3.97069454499
Rred_920 VDD.$3744.Metal1 VDD.$7186.Metal2 32.1798539624
Rred_921 VDD.$3744.Metal1 VDD.P93.pSD 17
Rred_922 VDD.$3744.Metal1 VDD.P95.pSD 17
Rred_923 VDD.$3745.Metal1 VDD.$3746.Metal1 0.016662565638
Rred_924 VDD.$3745.Metal1 VDD.$7183.Metal2 5.78585336292
Rred_925 VDD.$3745.Metal1 VDD.$7186.Metal2 9.32073315893
Rred_926 VDD.$3745.Metal1 VDD.P93.pSD 17
Rred_927 VDD.$3745.Metal1 VDD.P95.pSD 17
Rred_928 VDD.$3746.Metal1 VDD.$7183.Metal2 10.3753231177
Rred_929 VDD.$3746.Metal1 VDD.$7186.Metal2 0.700984783014
Rred_930 VDD.$3746.Metal1 VDD.P93.pSD 2.98959667091
Rred_931 VDD.$3746.Metal1 VDD.P95.pSD 2.98959667091
Rred_932 VDD.$3761.Metal1 VDD.$3762.Metal1 0.025365926806
Rred_933 VDD.$3761.Metal1 VDD.$4059.Metal1 22093.6689375
Rred_934 VDD.$3761.Metal1 VDD.$7197.Metal2 0.512003366412
Rred_935 VDD.$3761.Metal1 VDD.$7199.Metal2 33.10521796
Rred_936 VDD.$3761.Metal1 VDD.P69.pSD 2.07027273886
Rred_937 VDD.$3761.Metal1 VDD.P71.pSD 2.07027273886
Rred_938 VDD.$3762.Metal1 VDD.$3764.Metal1 0.0556661596173
Rred_939 VDD.$3762.Metal1 VDD.$4059.Metal1 8287.38032743
Rred_940 VDD.$3762.Metal1 VDD.$7197.Metal2 12.4177281212
Rred_941 VDD.$3762.Metal1 VDD.$7199.Metal2 4.81908408106
Rred_942 VDD.$3762.Metal1 VDD.P69.pSD 11.2148909248
Rred_943 VDD.$3762.Metal1 VDD.P71.pSD 17
Rred_944 VDD.$3764.Metal1 VDD.$3765.Metal1 0.0300959525217
Rred_945 VDD.$3764.Metal1 VDD.$4060.Metal1 6119.89076118
Rred_946 VDD.$3764.Metal1 VDD.$7199.Metal2 4.94495942488
Rred_947 VDD.$3764.Metal1 VDD.$7201.Metal2 9.27560002785
Rred_948 VDD.$3764.Metal1 VDD.P69.pSD 11.4815584753
Rred_949 VDD.$3765.Metal1 VDD.$4060.Metal1 217774.594191
Rred_950 VDD.$3765.Metal1 VDD.$7199.Metal2 330.06962228
Rred_951 VDD.$3765.Metal1 VDD.$7201.Metal2 10.4840395758
Rred_952 VDD.$3765.Metal1 VDD.P69.pSD 16.1120834306
Rred_953 VDD.$3770.Metal1 VDD.$3771.Metal1 0.0166730887752
Rred_954 VDD.$3770.Metal1 VDD.$3797.Metal1 0.0395331374099
Rred_955 VDD.$3770.Metal1 VDD.$7204.Metal2 3.1313155371
Rred_956 VDD.$3770.Metal1 VDD.$7206.Metal2 17.8124010356
Rred_957 VDD.$3770.Metal1 VDD.P21.pSD 10.831148609
Rred_958 VDD.$3770.Metal1 VDD.P23.pSD 10.831148609
Rred_959 VDD.$3771.Metal1 VDD.$3772.Metal1 0.0166662778099
Rred_960 VDD.$3771.Metal1 VDD.$7204.Metal2 9.09569414583
Rred_961 VDD.$3771.Metal1 VDD.$7206.Metal2 5.85054099171
Rred_962 VDD.$3771.Metal1 VDD.P21.pSD 17
Rred_963 VDD.$3771.Metal1 VDD.P23.pSD 17
Rred_964 VDD.$3772.Metal1 VDD.$3773.Metal1 0.0166549767343
Rred_965 VDD.$3772.Metal1 VDD.$7206.Metal2 3.61326430825
Rred_966 VDD.$3772.Metal1 VDD.$7208.Metal2 213.516616265
Rred_967 VDD.$3772.Metal1 VDD.P21.pSD 17
Rred_968 VDD.$3772.Metal1 VDD.P23.pSD 17
Rred_969 VDD.$3773.Metal1 VDD.$3775.Metal1 0.0336649638842
Rred_970 VDD.$3773.Metal1 VDD.$7206.Metal2 6.18888742798
Rred_971 VDD.$3773.Metal1 VDD.$7208.Metal2 3.24796024221
Rred_972 VDD.$3773.Metal1 VDD.P21.pSD 11.3717940732
Rred_973 VDD.$3773.Metal1 VDD.P23.pSD 11.3717940732
Rred_974 VDD.$3775.Metal1 VDD.$3776.Metal1 0.0166704549822
Rred_975 VDD.$3775.Metal1 VDD.$3777.Metal1 6450.595614
Rred_976 VDD.$3775.Metal1 VDD.$7208.Metal2 2.87532708662
Rred_977 VDD.$3775.Metal1 VDD.$7211.Metal2 12.3764049952
Rred_978 VDD.$3775.Metal1 VDD.P21.pSD 11.321112267
Rred_979 VDD.$3775.Metal1 VDD.P23.pSD 11.321112267
Rred_980 VDD.$3776.Metal1 VDD.$3777.Metal1 0.0166749221639
Rred_981 VDD.$3776.Metal1 VDD.$7208.Metal2 8.13873024254
Rred_982 VDD.$3776.Metal1 VDD.$7211.Metal2 6.36165854995
Rred_983 VDD.$3776.Metal1 VDD.P21.pSD 17
Rred_984 VDD.$3776.Metal1 VDD.P23.pSD 17
Rred_985 VDD.$3777.Metal1 VDD.$3778.Metal1 0.0169102994016
Rred_986 VDD.$3777.Metal1 VDD.$7208.Metal2 21.4581456389
Rred_987 VDD.$3777.Metal1 VDD.$7211.Metal2 4.22409521522
Rred_988 VDD.$3777.Metal1 VDD.P21.pSD 17
Rred_989 VDD.$3777.Metal1 VDD.P23.pSD 17
Rred_990 VDD.$3778.Metal1 VDD.$3779.Metal1 0.0166710938849
Rred_991 VDD.$3778.Metal1 VDD.$3780.Metal1 8109.57123758
Rred_992 VDD.$3778.Metal1 VDD.$7211.Metal2 3.97069454499
Rred_993 VDD.$3778.Metal1 VDD.$7214.Metal2 32.1798539624
Rred_994 VDD.$3778.Metal1 VDD.P21.pSD 17
Rred_995 VDD.$3778.Metal1 VDD.P23.pSD 17
Rred_996 VDD.$3779.Metal1 VDD.$3780.Metal1 0.016662565638
Rred_997 VDD.$3779.Metal1 VDD.$7211.Metal2 5.78585336292
Rred_998 VDD.$3779.Metal1 VDD.$7214.Metal2 9.32073315893
Rred_999 VDD.$3779.Metal1 VDD.P21.pSD 17
Rred_1000 VDD.$3779.Metal1 VDD.P23.pSD 17
Rred_1001 VDD.$3780.Metal1 VDD.$7211.Metal2 10.3753231177
Rred_1002 VDD.$3780.Metal1 VDD.$7214.Metal2 0.700984783014
Rred_1003 VDD.$3780.Metal1 VDD.P21.pSD 2.98959667091
Rred_1004 VDD.$3780.Metal1 VDD.P23.pSD 2.98959667091
Rred_1005 VDD.$3794.Metal1 VDD.$3851.Metal1 27.0826084457
Rred_1006 VDD.$3794.Metal1 VDD.$7136.Metal2 11.4531592308
Rred_1007 VDD.$3794.Metal1 VDD.$7174.Metal2 119.747372691
Rred_1008 VDD.$3794.Metal1 VDD.$7175.Metal2 5.60535939113
Rred_1009 VDD.$3794.Metal1 VDD.P1.nSD 16.498837807
Rred_1010 VDD.$3794.Metal1 VDD.P3.GatPoly 42.465
Rred_1011 VDD.$3794.Metal1 VDD.P45.pSD 20.8443766667
Rred_1012 VDD.$3795.Metal1 VDD.$3802.Metal1 0.0708027078622
Rred_1013 VDD.$3795.Metal1 VDD.$7146.Metal2 3.38553729989
Rred_1014 VDD.$3795.Metal1 VDD.$7176.Metal2 3.70234043319
Rred_1015 VDD.$3795.Metal1 VDD.P3.nSD 3.8095353518
Rred_1016 VDD.$3795.Metal1 VDD.P7.GatPoly 28.31
Rred_1017 VDD.$3795.Metal1 VDD.P93.pSD 39.7418064881
Rred_1018 VDD.$3795.Metal1 VDD.P95.pSD 39.7418064881
Rred_1019 VDD.$3796.Metal1 VDD.$3857.Metal1 27.0826084457
Rred_1020 VDD.$3796.Metal1 VDD.$7148.Metal2 11.4531592308
Rred_1021 VDD.$3796.Metal1 VDD.$7202.Metal2 119.747372691
Rred_1022 VDD.$3796.Metal1 VDD.$7203.Metal2 5.60535939113
Rred_1023 VDD.$3796.Metal1 VDD.P2.nSD 16.498837807
Rred_1024 VDD.$3796.Metal1 VDD.P5.GatPoly 42.465
Rred_1025 VDD.$3796.Metal1 VDD.P69.pSD 20.8443766667
Rred_1026 VDD.$3797.Metal1 VDD.$3808.Metal1 0.0708027078622
Rred_1027 VDD.$3797.Metal1 VDD.$7158.Metal2 3.38553729989
Rred_1028 VDD.$3797.Metal1 VDD.$7204.Metal2 3.70234043319
Rred_1029 VDD.$3797.Metal1 VDD.P0.nSD 3.8095353518
Rred_1030 VDD.$3797.Metal1 VDD.P1.GatPoly 28.31
Rred_1031 VDD.$3797.Metal1 VDD.P21.pSD 39.7418064881
Rred_1032 VDD.$3797.Metal1 VDD.P23.pSD 39.7418064881
Rred_1033 VDD.$3802.Metal1 VDD.$4106.Metal1 0.0410784942806
Rred_1034 VDD.$3802.Metal1 VDD.$7142.Metal2 3.90268759255
Rred_1035 VDD.$3802.Metal1 VDD.$7144.Metal2 1.8
Rred_1036 VDD.$3802.Metal1 VDD.$7146.Metal2 2.59752517975
Rred_1037 VDD.$3802.Metal1 VDD.P3.nSD 6.90197015494
Rred_1038 VDD.$3808.Metal1 VDD.$4107.Metal1 0.0410784942806
Rred_1039 VDD.$3808.Metal1 VDD.$7154.Metal2 3.90268759255
Rred_1040 VDD.$3808.Metal1 VDD.$7156.Metal2 1.8
Rred_1041 VDD.$3808.Metal1 VDD.$7158.Metal2 2.59752517975
Rred_1042 VDD.$3808.Metal1 VDD.P0.nSD 6.90197015494
Rred_1043 VDD.$3839.Metal1 VDD.$3851.Metal1 0.100035059304
Rred_1044 VDD.$3839.Metal1 VDD.$4106.Metal1 0.0448372520171
Rred_1045 VDD.$3839.Metal1 VDD.$7136.Metal2 3.09875776573
Rred_1046 VDD.$3839.Metal1 VDD.$7138.Metal2 2.25
Rred_1047 VDD.$3839.Metal1 VDD.$7140.Metal2 5.11611120874
Rred_1048 VDD.$3839.Metal1 VDD.P1.nSD 8.74636663511
Rred_1049 VDD.$3845.Metal1 VDD.$3857.Metal1 0.100035059304
Rred_1050 VDD.$3845.Metal1 VDD.$4107.Metal1 0.0448372520171
Rred_1051 VDD.$3845.Metal1 VDD.$7148.Metal2 3.09875776573
Rred_1052 VDD.$3845.Metal1 VDD.$7150.Metal2 2.25
Rred_1053 VDD.$3845.Metal1 VDD.$7152.Metal2 5.11611120874
Rred_1054 VDD.$3845.Metal1 VDD.P2.nSD 8.74636663511
Rred_1055 VDD.$3851.Metal1 VDD.$7136.Metal2 6.23864140322
Rred_1056 VDD.$3851.Metal1 VDD.$7174.Metal2 48.5734673451
Rred_1057 VDD.$3851.Metal1 VDD.$7175.Metal2 5.94259858122
Rred_1058 VDD.$3851.Metal1 VDD.P1.nSD 5.66788854941
Rred_1059 VDD.$3851.Metal1 VDD.P3.GatPoly 84.93
Rred_1060 VDD.$3851.Metal1 VDD.P47.pSD 18.5372418383
Rred_1061 VDD.$3857.Metal1 VDD.$7148.Metal2 6.23864140322
Rred_1062 VDD.$3857.Metal1 VDD.$7202.Metal2 48.5734673451
Rred_1063 VDD.$3857.Metal1 VDD.$7203.Metal2 5.94259858122
Rred_1064 VDD.$3857.Metal1 VDD.P2.nSD 5.66788854941
Rred_1065 VDD.$3857.Metal1 VDD.P5.GatPoly 84.93
Rred_1066 VDD.$3857.Metal1 VDD.P71.pSD 18.5372418383
Rred_1067 VDD.$388.Metal1 VDD.$404.Metal1 0.143800059603
Rred_1068 VDD.$388.Metal1 VDD.$4200.Metal2 11.4531592308
Rred_1069 VDD.$388.Metal1 VDD.$4236.Metal2 119.747372691
Rred_1070 VDD.$388.Metal1 VDD.$4237.Metal2 5.60535939113
Rred_1071 VDD.$388.Metal1 VDD.P1.nSD 16.498837807
Rred_1072 VDD.$388.Metal1 VDD.P2.GatPoly 42.465
Rred_1073 VDD.$388.Metal1 VDD.P25.pSD 20.8443766667
Rred_1074 VDD.$390.Metal1 VDD.$410.Metal1 0.143800059603
Rred_1075 VDD.$390.Metal1 VDD.$4212.Metal2 11.4531592308
Rred_1076 VDD.$390.Metal1 VDD.$4264.Metal2 119.747372691
Rred_1077 VDD.$390.Metal1 VDD.$4265.Metal2 5.60535939113
Rred_1078 VDD.$390.Metal1 VDD.P2.nSD 16.498837807
Rred_1079 VDD.$390.Metal1 VDD.P4.GatPoly 42.465
Rred_1080 VDD.$390.Metal1 VDD.P49.pSD 20.8443766667
Rred_1081 VDD.$4031.Metal1 VDD.$4032.Metal1 0.0469277028211
Rred_1082 VDD.$4031.Metal1 VDD.$7169.Metal2 6.09977235433
Rred_1083 VDD.$4031.Metal1 VDD.$7171.Metal2 6.02735332455
Rred_1084 VDD.$4031.Metal1 VDD.P47.pSD 18.4563405638
Rred_1085 VDD.$4032.Metal1 VDD.$7171.Metal2 18.040917646
Rred_1086 VDD.$4032.Metal1 VDD.$7173.Metal2 6.82187411869
Rred_1087 VDD.$4032.Metal1 VDD.P47.pSD 10.5956712708
Rred_1088 VDD.$404.Metal1 VDD.$4200.Metal2 4.5
Rred_1089 VDD.$404.Metal1 VDD.$4202.Metal2 6.44642508898
Rred_1090 VDD.$404.Metal1 VDD.$4204.Metal2 12.6322301467
Rred_1091 VDD.$404.Metal1 VDD.$567.Metal1 3.97833994763
Rred_1092 VDD.$404.Metal1 VDD.$579.Metal1 0.270142334821
Rred_1093 VDD.$404.Metal1 VDD.P1.nSD 17.6853719602
Rred_1094 VDD.$4059.Metal1 VDD.$4060.Metal1 0.0469277028211
Rred_1095 VDD.$4059.Metal1 VDD.$7197.Metal2 6.09977235433
Rred_1096 VDD.$4059.Metal1 VDD.$7199.Metal2 6.02735332455
Rred_1097 VDD.$4059.Metal1 VDD.P71.pSD 18.4563405638
Rred_1098 VDD.$4060.Metal1 VDD.$7199.Metal2 18.040917646
Rred_1099 VDD.$4060.Metal1 VDD.$7201.Metal2 6.82187411869
Rred_1100 VDD.$4060.Metal1 VDD.P71.pSD 10.5956712708
Rred_1101 VDD.$410.Metal1 VDD.$4212.Metal2 4.5
Rred_1102 VDD.$410.Metal1 VDD.$4214.Metal2 6.44642508898
Rred_1103 VDD.$410.Metal1 VDD.$4216.Metal2 12.6322301467
Rred_1104 VDD.$410.Metal1 VDD.$573.Metal1 3.97833994763
Rred_1105 VDD.$410.Metal1 VDD.$583.Metal1 0.270142334821
Rred_1106 VDD.$410.Metal1 VDD.P2.nSD 17.6853719602
Rred_1107 VDD.$4106.Metal1 VDD.$7140.Metal2 4.05152947356
Rred_1108 VDD.$4106.Metal1 VDD.$7142.Metal2 3.37605024229
Rred_1109 VDD.$4106.Metal1 VDD.P1.nSD 2.01513428871
Rred_1110 VDD.$4106.Metal1 VDD.P3.nSD 2.01164563
Rred_1111 VDD.$4107.Metal1 VDD.$7152.Metal2 4.05152947356
Rred_1112 VDD.$4107.Metal1 VDD.$7154.Metal2 3.37605024229
Rred_1113 VDD.$4107.Metal1 VDD.P0.nSD 2.01164563
Rred_1114 VDD.$4107.Metal1 VDD.P2.nSD 2.01513428871
Rred_1115 VDD.$4200.Metal2 VDD.$4202.Metal2 0.013640831758
Rred_1116 VDD.$4200.Metal2 VDD.$4237.Metal2 0.0563107648129
Rred_1117 VDD.$4200.Metal2 VDD.$7478.Metal3 9
Rred_1118 VDD.$4200.Metal2 VDD.$7490.Metal3 9
Rred_1119 VDD.$4200.Metal2 VDD.$7502.Metal3 9
Rred_1120 VDD.$4200.Metal2 VDD.$7514.Metal3 9
Rred_1121 VDD.$4200.Metal2 VDD.$7526.Metal3 9
Rred_1122 VDD.$4200.Metal2 VDD.$7538.Metal3 9
Rred_1123 VDD.$4200.Metal2 VDD.P1.nSD 749.627801058
Rred_1124 VDD.$4202.Metal2 VDD.$4204.Metal2 0.0136405957342
Rred_1125 VDD.$4202.Metal2 VDD.$567.Metal1 248.2791063
Rred_1126 VDD.$4202.Metal2 VDD.$579.Metal1 16.8589658868
Rred_1127 VDD.$4202.Metal2 VDD.$7478.Metal3 9
Rred_1128 VDD.$4202.Metal2 VDD.$7490.Metal3 9
Rred_1129 VDD.$4202.Metal2 VDD.$7502.Metal3 9
Rred_1130 VDD.$4202.Metal2 VDD.$7514.Metal3 9
Rred_1131 VDD.$4202.Metal2 VDD.$7526.Metal3 9
Rred_1132 VDD.$4202.Metal2 VDD.$7538.Metal3 9
Rred_1133 VDD.$4204.Metal2 VDD.$4206.Metal2 0.0344136795057
Rred_1134 VDD.$4204.Metal2 VDD.$4526.Metal2 0.0330185759294
Rred_1135 VDD.$4204.Metal2 VDD.$567.Metal1 113.136561765
Rred_1136 VDD.$4204.Metal2 VDD.$579.Metal1 7.68234372912
Rred_1137 VDD.$4204.Metal2 VDD.$7478.Metal3 9
Rred_1138 VDD.$4204.Metal2 VDD.$7490.Metal3 9
Rred_1139 VDD.$4204.Metal2 VDD.$7502.Metal3 9
Rred_1140 VDD.$4204.Metal2 VDD.$7514.Metal3 9
Rred_1141 VDD.$4204.Metal2 VDD.$7526.Metal3 9
Rred_1142 VDD.$4204.Metal2 VDD.$7538.Metal3 9
Rred_1143 VDD.$4206.Metal2 VDD.$4208.Metal2 0.013640831758
Rred_1144 VDD.$4206.Metal2 VDD.$4526.Metal2 0.0330185759294
Rred_1145 VDD.$4206.Metal2 VDD.$567.Metal1 9
Rred_1146 VDD.$4206.Metal2 VDD.$7478.Metal3 9
Rred_1147 VDD.$4206.Metal2 VDD.$7490.Metal3 9
Rred_1148 VDD.$4206.Metal2 VDD.$7502.Metal3 9
Rred_1149 VDD.$4206.Metal2 VDD.$7514.Metal3 9
Rred_1150 VDD.$4206.Metal2 VDD.$7526.Metal3 9
Rred_1151 VDD.$4206.Metal2 VDD.$7538.Metal3 9
Rred_1152 VDD.$4208.Metal2 VDD.$4210.Metal2 0.0136404870809
Rred_1153 VDD.$4208.Metal2 VDD.$567.Metal1 9.31471882173
Rred_1154 VDD.$4208.Metal2 VDD.$7478.Metal3 9
Rred_1155 VDD.$4208.Metal2 VDD.$7490.Metal3 9
Rred_1156 VDD.$4208.Metal2 VDD.$7502.Metal3 9
Rred_1157 VDD.$4208.Metal2 VDD.$7514.Metal3 9
Rred_1158 VDD.$4208.Metal2 VDD.$7526.Metal3 9
Rred_1159 VDD.$4208.Metal2 VDD.$7538.Metal3 9
Rred_1160 VDD.$4210.Metal2 VDD.$567.Metal1 9.562523059
Rred_1161 VDD.$4210.Metal2 VDD.$7478.Metal3 9
Rred_1162 VDD.$4210.Metal2 VDD.$7490.Metal3 9
Rred_1163 VDD.$4210.Metal2 VDD.$7502.Metal3 9
Rred_1164 VDD.$4210.Metal2 VDD.$7514.Metal3 9
Rred_1165 VDD.$4210.Metal2 VDD.$7526.Metal3 9
Rred_1166 VDD.$4210.Metal2 VDD.$7538.Metal3 9
Rred_1167 VDD.$4210.Metal2 VDD.P3.nSD 592.933403088
Rred_1168 VDD.$4210.Metal2 VDD.P72.pSD 5.03277812319
Rred_1169 VDD.$4210.Metal2 VDD.P73.pSD 5.03277812319
Rred_1170 VDD.$4212.Metal2 VDD.$4214.Metal2 0.013640831758
Rred_1171 VDD.$4212.Metal2 VDD.$4265.Metal2 0.0563107648129
Rred_1172 VDD.$4212.Metal2 VDD.$7484.Metal3 9
Rred_1173 VDD.$4212.Metal2 VDD.$7496.Metal3 9
Rred_1174 VDD.$4212.Metal2 VDD.$7508.Metal3 9
Rred_1175 VDD.$4212.Metal2 VDD.$7520.Metal3 9
Rred_1176 VDD.$4212.Metal2 VDD.$7532.Metal3 9
Rred_1177 VDD.$4212.Metal2 VDD.$7544.Metal3 9
Rred_1178 VDD.$4212.Metal2 VDD.P2.nSD 749.627801058
Rred_1179 VDD.$4214.Metal2 VDD.$4216.Metal2 0.0136405957342
Rred_1180 VDD.$4214.Metal2 VDD.$573.Metal1 248.2791063
Rred_1181 VDD.$4214.Metal2 VDD.$583.Metal1 16.8589658868
Rred_1182 VDD.$4214.Metal2 VDD.$7484.Metal3 9
Rred_1183 VDD.$4214.Metal2 VDD.$7496.Metal3 9
Rred_1184 VDD.$4214.Metal2 VDD.$7508.Metal3 9
Rred_1185 VDD.$4214.Metal2 VDD.$7520.Metal3 9
Rred_1186 VDD.$4214.Metal2 VDD.$7532.Metal3 9
Rred_1187 VDD.$4214.Metal2 VDD.$7544.Metal3 9
Rred_1188 VDD.$4216.Metal2 VDD.$4218.Metal2 0.0344136795057
Rred_1189 VDD.$4216.Metal2 VDD.$4538.Metal2 0.0330185759294
Rred_1190 VDD.$4216.Metal2 VDD.$573.Metal1 113.136561765
Rred_1191 VDD.$4216.Metal2 VDD.$583.Metal1 7.68234372912
Rred_1192 VDD.$4216.Metal2 VDD.$7484.Metal3 9
Rred_1193 VDD.$4216.Metal2 VDD.$7496.Metal3 9
Rred_1194 VDD.$4216.Metal2 VDD.$7508.Metal3 9
Rred_1195 VDD.$4216.Metal2 VDD.$7520.Metal3 9
Rred_1196 VDD.$4216.Metal2 VDD.$7532.Metal3 9
Rred_1197 VDD.$4216.Metal2 VDD.$7544.Metal3 9
Rred_1198 VDD.$4218.Metal2 VDD.$4220.Metal2 0.013640831758
Rred_1199 VDD.$4218.Metal2 VDD.$4538.Metal2 0.0330185759294
Rred_1200 VDD.$4218.Metal2 VDD.$573.Metal1 9
Rred_1201 VDD.$4218.Metal2 VDD.$7484.Metal3 9
Rred_1202 VDD.$4218.Metal2 VDD.$7496.Metal3 9
Rred_1203 VDD.$4218.Metal2 VDD.$7508.Metal3 9
Rred_1204 VDD.$4218.Metal2 VDD.$7520.Metal3 9
Rred_1205 VDD.$4218.Metal2 VDD.$7532.Metal3 9
Rred_1206 VDD.$4218.Metal2 VDD.$7544.Metal3 9
Rred_1207 VDD.$4220.Metal2 VDD.$4222.Metal2 0.0136404870809
Rred_1208 VDD.$4220.Metal2 VDD.$573.Metal1 9.31471882173
Rred_1209 VDD.$4220.Metal2 VDD.$7484.Metal3 9
Rred_1210 VDD.$4220.Metal2 VDD.$7496.Metal3 9
Rred_1211 VDD.$4220.Metal2 VDD.$7508.Metal3 9
Rred_1212 VDD.$4220.Metal2 VDD.$7520.Metal3 9
Rred_1213 VDD.$4220.Metal2 VDD.$7532.Metal3 9
Rred_1214 VDD.$4220.Metal2 VDD.$7544.Metal3 9
Rred_1215 VDD.$4222.Metal2 VDD.$573.Metal1 9.562523059
Rred_1216 VDD.$4222.Metal2 VDD.$7484.Metal3 9
Rred_1217 VDD.$4222.Metal2 VDD.$7496.Metal3 9
Rred_1218 VDD.$4222.Metal2 VDD.$7508.Metal3 9
Rred_1219 VDD.$4222.Metal2 VDD.$7520.Metal3 9
Rred_1220 VDD.$4222.Metal2 VDD.$7532.Metal3 9
Rred_1221 VDD.$4222.Metal2 VDD.$7544.Metal3 9
Rred_1222 VDD.$4222.Metal2 VDD.P0.nSD 592.933403088
Rred_1223 VDD.$4222.Metal2 VDD.P0.pSD 5.03277812319
Rred_1224 VDD.$4222.Metal2 VDD.P1.pSD 5.03277812319
Rred_1225 VDD.$4231.Metal2 VDD.$4233.Metal2 0.0273432884735
Rred_1226 VDD.$4231.Metal2 VDD.P24.pSD 14.0821006029
Rred_1227 VDD.$4231.Metal2 VDD.P25.pSD 14.0821006029
Rred_1228 VDD.$4233.Metal2 VDD.$4235.Metal2 0.0273436802632
Rred_1229 VDD.$4233.Metal2 VDD.$508.Metal1 4.94495942488
Rred_1230 VDD.$4233.Metal2 VDD.$509.Metal1 330.06962228
Rred_1231 VDD.$4233.Metal2 VDD.P25.pSD 6270.37861931
Rred_1232 VDD.$4235.Metal2 VDD.$4236.Metal2 0.013640831758
Rred_1233 VDD.$4235.Metal2 VDD.$508.Metal1 9.27560002785
Rred_1234 VDD.$4235.Metal2 VDD.$509.Metal1 10.4840395758
Rred_1235 VDD.$4235.Metal2 VDD.P24.pSD 4792.78393733
Rred_1236 VDD.$4235.Metal2 VDD.P25.pSD 485522.422041
Rred_1237 VDD.$4236.Metal2 VDD.$4237.Metal2 0.0136407731205
Rred_1238 VDD.$4236.Metal2 VDD.P24.pSD 7699.82070935
Rred_1239 VDD.$4236.Metal2 VDD.P25.pSD 13759.4674119
Rred_1240 VDD.$4237.Metal2 VDD.P24.pSD 2268.78616064
Rred_1241 VDD.$4237.Metal2 VDD.P25.pSD 3701.09101018
Rred_1242 VDD.$4259.Metal2 VDD.$4261.Metal2 0.0273432884735
Rred_1243 VDD.$4259.Metal2 VDD.P48.pSD 14.0821006029
Rred_1244 VDD.$4259.Metal2 VDD.P49.pSD 14.0821006029
Rred_1245 VDD.$4261.Metal2 VDD.$4263.Metal2 0.0273436802632
Rred_1246 VDD.$4261.Metal2 VDD.$542.Metal1 4.94495942488
Rred_1247 VDD.$4261.Metal2 VDD.$543.Metal1 330.06962228
Rred_1248 VDD.$4261.Metal2 VDD.P49.pSD 6270.37861931
Rred_1249 VDD.$4263.Metal2 VDD.$4264.Metal2 0.013640831758
Rred_1250 VDD.$4263.Metal2 VDD.$542.Metal1 9.27560002785
Rred_1251 VDD.$4263.Metal2 VDD.$543.Metal1 10.4840395758
Rred_1252 VDD.$4263.Metal2 VDD.P48.pSD 4792.78393733
Rred_1253 VDD.$4263.Metal2 VDD.P49.pSD 485522.422041
Rred_1254 VDD.$4264.Metal2 VDD.$4265.Metal2 0.0136407731205
Rred_1255 VDD.$4264.Metal2 VDD.P48.pSD 7699.82070935
Rred_1256 VDD.$4264.Metal2 VDD.P49.pSD 13759.4674119
Rred_1257 VDD.$4265.Metal2 VDD.P48.pSD 2268.78616064
Rred_1258 VDD.$4265.Metal2 VDD.P49.pSD 3701.09101018
Rred_1259 VDD.$4526.Metal2 VDD.$4574.Metal2 0.0242460326016
Rred_1260 VDD.$4526.Metal2 VDD.$579.Metal1 2.61981517094
Rred_1261 VDD.$4526.Metal2 VDD.$599.Metal1 2.46784092657
Rred_1262 VDD.$4526.Metal2 VDD.$619.Metal1 4.78989338831
Rred_1263 VDD.$4526.Metal2 VDD.$7538.Metal3 3.01202666667
Rred_1264 VDD.$4526.Metal2 VDD.$7562.Metal3 1.50900919513
Rred_1265 VDD.$4538.Metal2 VDD.$4586.Metal2 0.0242460326016
Rred_1266 VDD.$4538.Metal2 VDD.$583.Metal1 2.61981517094
Rred_1267 VDD.$4538.Metal2 VDD.$603.Metal1 2.46784092657
Rred_1268 VDD.$4538.Metal2 VDD.$623.Metal1 4.78989338831
Rred_1269 VDD.$4538.Metal2 VDD.$7544.Metal3 3.01202666667
Rred_1270 VDD.$4538.Metal2 VDD.$7568.Metal3 1.50900919513
Rred_1271 VDD.$4574.Metal2 VDD.$4622.Metal2 0.0242461594591
Rred_1272 VDD.$4574.Metal2 VDD.$599.Metal1 8.2386166279
Rred_1273 VDD.$4574.Metal2 VDD.$619.Metal1 1.68192524462
Rred_1274 VDD.$4574.Metal2 VDD.$647.Metal1 1.68264009502
Rred_1275 VDD.$4574.Metal2 VDD.$667.Metal1 68.5651496211
Rred_1276 VDD.$4574.Metal2 VDD.$7562.Metal3 1.50900919513
Rred_1277 VDD.$4574.Metal2 VDD.$7586.Metal3 1.50901313491
Rred_1278 VDD.$4574.Metal2 VDD.P1.nSD 5879.79163862
Rred_1279 VDD.$4574.Metal2 VDD.P3.nSD 5879.79163862
Rred_1280 VDD.$4586.Metal2 VDD.$4634.Metal2 0.0242461594591
Rred_1281 VDD.$4586.Metal2 VDD.$603.Metal1 8.2386166279
Rred_1282 VDD.$4586.Metal2 VDD.$623.Metal1 1.68192524462
Rred_1283 VDD.$4586.Metal2 VDD.$657.Metal1 1.68264009502
Rred_1284 VDD.$4586.Metal2 VDD.$671.Metal1 68.5651496211
Rred_1285 VDD.$4586.Metal2 VDD.$7568.Metal3 1.50900919513
Rred_1286 VDD.$4586.Metal2 VDD.$7592.Metal3 1.50901313491
Rred_1287 VDD.$4586.Metal2 VDD.P0.nSD 5879.79163862
Rred_1288 VDD.$4586.Metal2 VDD.P2.nSD 5879.79163862
Rred_1289 VDD.$4622.Metal2 VDD.$4646.Metal2 0.0120266666667
Rred_1290 VDD.$4622.Metal2 VDD.$647.Metal1 3.16454536712
Rred_1291 VDD.$4622.Metal2 VDD.$667.Metal1 1.94576678886
Rred_1292 VDD.$4622.Metal2 VDD.$687.Metal1 6.00779166667
Rred_1293 VDD.$4622.Metal2 VDD.$7586.Metal3 1.50901313491
Rred_1294 VDD.$4622.Metal2 VDD.$7610.Metal3 3.01202666667
Rred_1295 VDD.$4634.Metal2 VDD.$4658.Metal2 0.0120266666667
Rred_1296 VDD.$4634.Metal2 VDD.$657.Metal1 3.16454536712
Rred_1297 VDD.$4634.Metal2 VDD.$671.Metal1 1.94576678886
Rred_1298 VDD.$4634.Metal2 VDD.$691.Metal1 6.00779166667
Rred_1299 VDD.$4634.Metal2 VDD.$7592.Metal3 1.50901313491
Rred_1300 VDD.$4634.Metal2 VDD.$7616.Metal3 3.01202666667
Rred_1301 VDD.$4646.Metal2 VDD.$4728.Metal2 0.0120990638258
Rred_1302 VDD.$4646.Metal2 VDD.$687.Metal1 2.4941356433
Rred_1303 VDD.$4646.Metal2 VDD.$706.Metal1 1.11734273443
Rred_1304 VDD.$4646.Metal2 VDD.$7610.Metal3 1.5
Rred_1305 VDD.$4646.Metal2 VDD.P1.nSD 42082.9728891
Rred_1306 VDD.$4646.Metal2 VDD.P27.pSD 8.42198716889
Rred_1307 VDD.$4646.Metal2 VDD.P3.nSD 42082.9728891
Rred_1308 VDD.$4646.Metal2 VDD.P75.pSD 8.42198716889
Rred_1309 VDD.$4658.Metal2 VDD.$4740.Metal2 0.0120990638258
Rred_1310 VDD.$4658.Metal2 VDD.$691.Metal1 2.4941356433
Rred_1311 VDD.$4658.Metal2 VDD.$707.Metal1 1.11734273443
Rred_1312 VDD.$4658.Metal2 VDD.$7616.Metal3 1.5
Rred_1313 VDD.$4658.Metal2 VDD.P0.nSD 42082.9728891
Rred_1314 VDD.$4658.Metal2 VDD.P2.nSD 42082.9728891
Rred_1315 VDD.$4658.Metal2 VDD.P3.pSD 8.42198716889
Rred_1316 VDD.$4658.Metal2 VDD.P51.pSD 8.42198716889
Rred_1317 VDD.$4728.Metal2 VDD.$4808.Metal2 0.0120264116929
Rred_1318 VDD.$4728.Metal2 VDD.$706.Metal1 0.900286807852
Rred_1319 VDD.$4728.Metal2 VDD.$7610.Metal3 2.26502132807
Rred_1320 VDD.$4728.Metal2 VDD.$7646.Metal3 4.54820309381
Rred_1321 VDD.$4728.Metal2 VDD.$909.Metal1 2.4892281746
Rred_1322 VDD.$4728.Metal2 VDD.P27.pSD 6.27169257257
Rred_1323 VDD.$4728.Metal2 VDD.P75.pSD 6.27169257257
Rred_1324 VDD.$4740.Metal2 VDD.$4820.Metal2 0.0120264116929
Rred_1325 VDD.$4740.Metal2 VDD.$707.Metal1 0.900286807852
Rred_1326 VDD.$4740.Metal2 VDD.$7616.Metal3 2.26502132807
Rred_1327 VDD.$4740.Metal2 VDD.$7652.Metal3 4.54820309381
Rred_1328 VDD.$4740.Metal2 VDD.$913.Metal1 2.4892281746
Rred_1329 VDD.$4740.Metal2 VDD.P3.pSD 6.27169257257
Rred_1330 VDD.$4740.Metal2 VDD.P51.pSD 6.27169257257
Rred_1331 VDD.$4808.Metal2 VDD.$4856.Metal2 0.0242461421407
Rred_1332 VDD.$4808.Metal2 VDD.$7610.Metal3 4.54820309381
Rred_1333 VDD.$4808.Metal2 VDD.$7646.Metal3 1.29503556563
Rred_1334 VDD.$4808.Metal2 VDD.$909.Metal1 2.65960492999
Rred_1335 VDD.$4808.Metal2 VDD.$937.Metal1 1.68270088521
Rred_1336 VDD.$4808.Metal2 VDD.$957.Metal1 41.1464525044
Rred_1337 VDD.$4808.Metal2 VDD.P1.nSD 5680.64566217
Rred_1338 VDD.$4808.Metal2 VDD.P3.nSD 5680.64566217
Rred_1339 VDD.$4820.Metal2 VDD.$4868.Metal2 0.0242461421407
Rred_1340 VDD.$4820.Metal2 VDD.$7616.Metal3 4.54820309381
Rred_1341 VDD.$4820.Metal2 VDD.$7652.Metal3 1.29503556563
Rred_1342 VDD.$4820.Metal2 VDD.$913.Metal1 2.65960492999
Rred_1343 VDD.$4820.Metal2 VDD.$941.Metal1 1.68270088521
Rred_1344 VDD.$4820.Metal2 VDD.$961.Metal1 41.1464525044
Rred_1345 VDD.$4820.Metal2 VDD.P0.nSD 5680.64566217
Rred_1346 VDD.$4820.Metal2 VDD.P2.nSD 5680.64566217
Rred_1347 VDD.$4856.Metal2 VDD.$4880.Metal2 0.0120264116929
Rred_1348 VDD.$4856.Metal2 VDD.$7646.Metal3 1.29503556563
Rred_1349 VDD.$4856.Metal2 VDD.$7682.Metal3 4.54820309381
Rred_1350 VDD.$4856.Metal2 VDD.$937.Metal1 3.26559146861
Rred_1351 VDD.$4856.Metal2 VDD.$957.Metal1 1.98402216085
Rred_1352 VDD.$4856.Metal2 VDD.$977.Metal1 5.37590716374
Rred_1353 VDD.$4868.Metal2 VDD.$4892.Metal2 0.0120264116929
Rred_1354 VDD.$4868.Metal2 VDD.$7652.Metal3 1.29503556563
Rred_1355 VDD.$4868.Metal2 VDD.$7688.Metal3 4.54820309381
Rred_1356 VDD.$4868.Metal2 VDD.$941.Metal1 3.26559146861
Rred_1357 VDD.$4868.Metal2 VDD.$961.Metal1 1.98402216085
Rred_1358 VDD.$4868.Metal2 VDD.$981.Metal1 5.37590716374
Rred_1359 VDD.$4880.Metal2 VDD.$4986.Metal2 0.0242460452723
Rred_1360 VDD.$4880.Metal2 VDD.$7646.Metal3 4.54820309381
Rred_1361 VDD.$4880.Metal2 VDD.$7682.Metal3 1.29503334991
Rred_1362 VDD.$4880.Metal2 VDD.$977.Metal1 2.91932738095
Rred_1363 VDD.$4880.Metal2 VDD.$997.Metal1 2.35325729591
Rred_1364 VDD.$4892.Metal2 VDD.$4998.Metal2 0.0242460452723
Rred_1365 VDD.$4892.Metal2 VDD.$7652.Metal3 4.54820309381
Rred_1366 VDD.$4892.Metal2 VDD.$7688.Metal3 1.29503334991
Rred_1367 VDD.$4892.Metal2 VDD.$981.Metal1 2.91932738095
Rred_1368 VDD.$4986.Metal2 VDD.$5066.Metal2 0.0120891238911
Rred_1369 VDD.$4986.Metal2 VDD.$7682.Metal3 1.29503334991
Rred_1370 VDD.$4986.Metal2 VDD.$7718.Metal3 4.54820309381
Rred_1371 VDD.$4986.Metal2 VDD.$997.Metal1 9.80659138163
Rred_1372 VDD.$4986.Metal2 VDD.P1.nSD 13099.9828476
Rred_1373 VDD.$4986.Metal2 VDD.P29.pSD 5.16725721254
Rred_1374 VDD.$4986.Metal2 VDD.P3.nSD 13099.9828476
Rred_1375 VDD.$4986.Metal2 VDD.P77.pSD 5.16725721254
Rred_1376 VDD.$4998.Metal2 VDD.$5078.Metal2 0.0120891238911
Rred_1377 VDD.$4998.Metal2 VDD.$7688.Metal3 1.29503334991
Rred_1378 VDD.$4998.Metal2 VDD.$7724.Metal3 4.54820309381
Rred_1379 VDD.$4998.Metal2 VDD.P0.nSD 13099.9828476
Rred_1380 VDD.$4998.Metal2 VDD.P2.nSD 13099.9828476
Rred_1381 VDD.$4998.Metal2 VDD.P5.pSD 5.16725721254
Rred_1382 VDD.$4998.Metal2 VDD.P53.pSD 5.16725721254
Rred_1383 VDD.$5066.Metal2 VDD.$5114.Metal2 0.0242460452723
Rred_1384 VDD.$5066.Metal2 VDD.$7682.Metal3 4.54820309381
Rred_1385 VDD.$5066.Metal2 VDD.$7718.Metal3 1.29503334991
Rred_1386 VDD.$5066.Metal2 VDD.P1.nSD 6480.19286914
Rred_1387 VDD.$5066.Metal2 VDD.P29.pSD 11.7813464446
Rred_1388 VDD.$5066.Metal2 VDD.P3.nSD 6480.19286914
Rred_1389 VDD.$5066.Metal2 VDD.P77.pSD 11.7813464446
Rred_1390 VDD.$5078.Metal2 VDD.$5126.Metal2 0.0242460452723
Rred_1391 VDD.$5078.Metal2 VDD.$7688.Metal3 4.54820309381
Rred_1392 VDD.$5078.Metal2 VDD.$7724.Metal3 1.29503334991
Rred_1393 VDD.$5078.Metal2 VDD.P0.nSD 6480.19286914
Rred_1394 VDD.$5078.Metal2 VDD.P2.nSD 6480.19286914
Rred_1395 VDD.$5078.Metal2 VDD.P5.pSD 11.7813464446
Rred_1396 VDD.$5078.Metal2 VDD.P53.pSD 11.7813464446
Rred_1397 VDD.$508.Metal1 VDD.$509.Metal1 0.0300959525217
Rred_1398 VDD.$508.Metal1 VDD.P25.pSD 11.4815584753
Rred_1399 VDD.$509.Metal1 VDD.P25.pSD 16.1120834306
Rred_1400 VDD.$5114.Metal2 VDD.$5162.Metal2 0.0242460533372
Rred_1401 VDD.$5114.Metal2 VDD.$7718.Metal3 1.50900958864
Rred_1402 VDD.$5114.Metal2 VDD.$7742.Metal3 1.50900983911
Rred_1403 VDD.$5126.Metal2 VDD.$5174.Metal2 0.0242460533372
Rred_1404 VDD.$5126.Metal2 VDD.$7724.Metal3 1.50900958864
Rred_1405 VDD.$5126.Metal2 VDD.$7748.Metal3 1.50900983911
Rred_1406 VDD.$5162.Metal2 VDD.$5268.Metal2 0.0242461109832
Rred_1407 VDD.$5162.Metal2 VDD.$7742.Metal3 1.50900983911
Rred_1408 VDD.$5162.Metal2 VDD.$7766.Metal3 1.5090116294
Rred_1409 VDD.$5162.Metal2 VDD.P1.nSD 5320.19092171
Rred_1410 VDD.$5162.Metal2 VDD.P3.nSD 5320.19092171
Rred_1411 VDD.$5174.Metal2 VDD.$5280.Metal2 0.0242461109832
Rred_1412 VDD.$5174.Metal2 VDD.$7748.Metal3 1.50900983911
Rred_1413 VDD.$5174.Metal2 VDD.$7772.Metal3 1.5090116294
Rred_1414 VDD.$5174.Metal2 VDD.P0.nSD 5320.19092171
Rred_1415 VDD.$5174.Metal2 VDD.P2.nSD 5320.19092171
Rred_1416 VDD.$5210.Metal2 VDD.$5268.Metal2 0.00044
Rred_1417 VDD.$5210.Metal2 VDD.$5372.Metal2 0.023798972643
Rred_1418 VDD.$5210.Metal2 VDD.$7790.Metal3 2.96827541279
Rred_1419 VDD.$5210.Metal2 VDD.P31.pSD 3.57324071428
Rred_1420 VDD.$5210.Metal2 VDD.P79.pSD 3.57324071428
Rred_1421 VDD.$5211.Metal2 VDD.$5280.Metal2 0.00044
Rred_1422 VDD.$5211.Metal2 VDD.$5384.Metal2 0.023798972643
Rred_1423 VDD.$5211.Metal2 VDD.$7796.Metal3 2.96827541279
Rred_1424 VDD.$5211.Metal2 VDD.P55.pSD 3.57324071428
Rred_1425 VDD.$5211.Metal2 VDD.P7.pSD 3.57324071428
Rred_1426 VDD.$5268.Metal2 VDD.$7766.Metal3 1.5090116294
Rred_1427 VDD.$5268.Metal2 VDD.$7790.Metal3 3.01202666667
Rred_1428 VDD.$5280.Metal2 VDD.$7772.Metal3 1.5090116294
Rred_1429 VDD.$5280.Metal2 VDD.$7796.Metal3 3.01202666667
Rred_1430 VDD.$5372.Metal2 VDD.$5420.Metal2 0.0242461594591
Rred_1431 VDD.$5372.Metal2 VDD.$7790.Metal3 1.52306018408
Rred_1432 VDD.$5372.Metal2 VDD.$7814.Metal3 1.50901313491
Rred_1433 VDD.$5384.Metal2 VDD.$5432.Metal2 0.0242461594591
Rred_1434 VDD.$5384.Metal2 VDD.$7796.Metal3 1.52306018408
Rred_1435 VDD.$5384.Metal2 VDD.$7820.Metal3 1.50901313491
Rred_1436 VDD.$542.Metal1 VDD.$543.Metal1 0.0300959525217
Rred_1437 VDD.$542.Metal1 VDD.P49.pSD 11.4815584753
Rred_1438 VDD.$5420.Metal2 VDD.$5468.Metal2 0.0242460326016
Rred_1439 VDD.$5420.Metal2 VDD.$7814.Metal3 1.50901313491
Rred_1440 VDD.$5420.Metal2 VDD.$7838.Metal3 1.50900919513
Rred_1441 VDD.$5420.Metal2 VDD.P1.nSD 5879.79163862
Rred_1442 VDD.$5420.Metal2 VDD.P3.nSD 5879.79163862
Rred_1443 VDD.$543.Metal1 VDD.P49.pSD 16.1120834306
Rred_1444 VDD.$5432.Metal2 VDD.$5480.Metal2 0.0242460326016
Rred_1445 VDD.$5432.Metal2 VDD.$7820.Metal3 1.50901313491
Rred_1446 VDD.$5432.Metal2 VDD.$7844.Metal3 1.50900919513
Rred_1447 VDD.$5432.Metal2 VDD.P0.nSD 5879.79163862
Rred_1448 VDD.$5432.Metal2 VDD.P2.nSD 5879.79163862
Rred_1449 VDD.$5468.Metal2 VDD.$5550.Metal2 0.0120789633719
Rred_1450 VDD.$5468.Metal2 VDD.$5630.Metal2 763.40928525
Rred_1451 VDD.$5468.Metal2 VDD.$7838.Metal3 1.2105620173
Rred_1452 VDD.$5468.Metal2 VDD.$7886.Metal3 6.12084600264
Rred_1453 VDD.$5468.Metal2 VDD.P1.nSD 12875.9004695
Rred_1454 VDD.$5468.Metal2 VDD.P3.nSD 12875.9004695
Rred_1455 VDD.$5468.Metal2 VDD.P33.pSD 15.4889049214
Rred_1456 VDD.$5468.Metal2 VDD.P81.pSD 15.4889049214
Rred_1457 VDD.$5480.Metal2 VDD.$5562.Metal2 0.0120789633719
Rred_1458 VDD.$5480.Metal2 VDD.$5642.Metal2 763.40928525
Rred_1459 VDD.$5480.Metal2 VDD.$7844.Metal3 1.2105620173
Rred_1460 VDD.$5480.Metal2 VDD.$7892.Metal3 6.12084600264
Rred_1461 VDD.$5480.Metal2 VDD.P0.nSD 12875.9004695
Rred_1462 VDD.$5480.Metal2 VDD.P10.pSD 15.4889049214
Rred_1463 VDD.$5480.Metal2 VDD.P2.nSD 12875.9004695
Rred_1464 VDD.$5480.Metal2 VDD.P57.pSD 15.4889049214
Rred_1465 VDD.$5550.Metal2 VDD.$5630.Metal2 0.012026286226
Rred_1466 VDD.$5550.Metal2 VDD.$7838.Metal3 3.04820309381
Rred_1467 VDD.$5550.Metal2 VDD.$7886.Metal3 3.04820309381
Rred_1468 VDD.$5550.Metal2 VDD.P33.pSD 4.67125703981
Rred_1469 VDD.$5550.Metal2 VDD.P81.pSD 4.67125703981
Rred_1470 VDD.$5562.Metal2 VDD.$5642.Metal2 0.012026286226
Rred_1471 VDD.$5562.Metal2 VDD.$7844.Metal3 3.04820309381
Rred_1472 VDD.$5562.Metal2 VDD.$7892.Metal3 3.04820309381
Rred_1473 VDD.$5562.Metal2 VDD.P10.pSD 4.67125703981
Rred_1474 VDD.$5562.Metal2 VDD.P57.pSD 4.67125703981
Rred_1475 VDD.$5630.Metal2 VDD.$5678.Metal2 0.0242460844575
Rred_1476 VDD.$5630.Metal2 VDD.$7838.Metal3 6.12084600264
Rred_1477 VDD.$5630.Metal2 VDD.$7886.Metal3 1.21056305374
Rred_1478 VDD.$5630.Metal2 VDD.P1.nSD 5002.65600433
Rred_1479 VDD.$5630.Metal2 VDD.P3.nSD 5002.65600433
Rred_1480 VDD.$5642.Metal2 VDD.$5690.Metal2 0.0242460844575
Rred_1481 VDD.$5642.Metal2 VDD.$7844.Metal3 6.12084600264
Rred_1482 VDD.$5642.Metal2 VDD.$7892.Metal3 1.21056305374
Rred_1483 VDD.$5642.Metal2 VDD.P0.nSD 5002.65600433
Rred_1484 VDD.$5642.Metal2 VDD.P2.nSD 5002.65600433
Rred_1485 VDD.$567.Metal1 VDD.$579.Metal1 0.111093962345
Rred_1486 VDD.$5678.Metal2 VDD.$5702.Metal2 0.0120264116929
Rred_1487 VDD.$5678.Metal2 VDD.$7886.Metal3 1.29503424621
Rred_1488 VDD.$5678.Metal2 VDD.$7922.Metal3 4.54820309381
Rred_1489 VDD.$5690.Metal2 VDD.$5714.Metal2 0.0120264116929
Rred_1490 VDD.$5690.Metal2 VDD.$7892.Metal3 1.29503424621
Rred_1491 VDD.$5690.Metal2 VDD.$7928.Metal3 4.54820309381
Rred_1492 VDD.$5702.Metal2 VDD.$5766.Metal2 0.0242460844575
Rred_1493 VDD.$5702.Metal2 VDD.$7886.Metal3 4.54820309381
Rred_1494 VDD.$5702.Metal2 VDD.$7922.Metal3 1.29503424621
Rred_1495 VDD.$5714.Metal2 VDD.$5806.Metal2 0.0242460844575
Rred_1496 VDD.$5714.Metal2 VDD.$7892.Metal3 4.54820309381
Rred_1497 VDD.$5714.Metal2 VDD.$7928.Metal3 1.29503424621
Rred_1498 VDD.$573.Metal1 VDD.$583.Metal1 0.111093962345
Rred_1499 VDD.$5766.Metal2 VDD.$5846.Metal2 0.012100390081
Rred_1500 VDD.$5766.Metal2 VDD.$7922.Metal3 1.29503424621
Rred_1501 VDD.$5766.Metal2 VDD.$7958.Metal3 4.54820309381
Rred_1502 VDD.$5766.Metal2 VDD.P1.nSD 6605.68932994
Rred_1503 VDD.$5766.Metal2 VDD.P3.nSD 6605.68932994
Rred_1504 VDD.$5766.Metal2 VDD.P35.pSD 7.19044270877
Rred_1505 VDD.$5766.Metal2 VDD.P83.pSD 7.19044270877
Rred_1506 VDD.$579.Metal1 VDD.$599.Metal1 0.0104064880401
Rred_1507 VDD.$579.Metal1 VDD.P1.nSD 17
Rred_1508 VDD.$579.Metal1 VDD.P3.nSD 17
Rred_1509 VDD.$5806.Metal2 VDD.$5886.Metal2 0.012100390081
Rred_1510 VDD.$5806.Metal2 VDD.$7928.Metal3 1.29503424621
Rred_1511 VDD.$5806.Metal2 VDD.$7964.Metal3 4.54820309381
Rred_1512 VDD.$5806.Metal2 VDD.P0.nSD 6605.68932994
Rred_1513 VDD.$5806.Metal2 VDD.P11.pSD 7.19044270877
Rred_1514 VDD.$5806.Metal2 VDD.P2.nSD 6605.68932994
Rred_1515 VDD.$5806.Metal2 VDD.P59.pSD 7.19044270877
Rred_1516 VDD.$583.Metal1 VDD.$603.Metal1 0.0104064880401
Rred_1517 VDD.$583.Metal1 VDD.P0.nSD 17
Rred_1518 VDD.$583.Metal1 VDD.P2.nSD 17
Rred_1519 VDD.$5846.Metal2 VDD.$5936.Metal2 0.0242460844575
Rred_1520 VDD.$5846.Metal2 VDD.$7922.Metal3 4.54820309381
Rred_1521 VDD.$5846.Metal2 VDD.$7958.Metal3 1.29503424621
Rred_1522 VDD.$5846.Metal2 VDD.P1.nSD 6605.68932994
Rred_1523 VDD.$5846.Metal2 VDD.P3.nSD 6605.68932994
Rred_1524 VDD.$5846.Metal2 VDD.P35.pSD 7.19044270877
Rred_1525 VDD.$5846.Metal2 VDD.P83.pSD 7.19044270877
Rred_1526 VDD.$5886.Metal2 VDD.$5948.Metal2 0.0242460844575
Rred_1527 VDD.$5886.Metal2 VDD.$7928.Metal3 4.54820309381
Rred_1528 VDD.$5886.Metal2 VDD.$7964.Metal3 1.29503424621
Rred_1529 VDD.$5886.Metal2 VDD.P0.nSD 6605.68932994
Rred_1530 VDD.$5886.Metal2 VDD.P11.pSD 7.19044270877
Rred_1531 VDD.$5886.Metal2 VDD.P2.nSD 6605.68932994
Rred_1532 VDD.$5886.Metal2 VDD.P59.pSD 7.19044270877
Rred_1533 VDD.$5936.Metal2 VDD.$5984.Metal2 0.0242460279948
Rred_1534 VDD.$5936.Metal2 VDD.$7958.Metal3 1.5090108056
Rred_1535 VDD.$5936.Metal2 VDD.$7982.Metal3 1.50900905206
Rred_1536 VDD.$5948.Metal2 VDD.$5996.Metal2 0.0242460279948
Rred_1537 VDD.$5948.Metal2 VDD.$7964.Metal3 1.5090108056
Rred_1538 VDD.$5948.Metal2 VDD.$7988.Metal3 1.50900905206
Rred_1539 VDD.$5984.Metal2 VDD.$6090.Metal2 0.024246177939
Rred_1540 VDD.$5984.Metal2 VDD.$7982.Metal3 1.50900905206
Rred_1541 VDD.$5984.Metal2 VDD.$8006.Metal3 1.50901370883
Rred_1542 VDD.$5984.Metal2 VDD.P1.nSD 6093.38455073
Rred_1543 VDD.$5984.Metal2 VDD.P3.nSD 6093.38455073
Rred_1544 VDD.$599.Metal1 VDD.$619.Metal1 0.0104055501146
Rred_1545 VDD.$599.Metal1 VDD.$7562.Metal3 1027.54364816
Rred_1546 VDD.$599.Metal1 VDD.P1.nSD 17
Rred_1547 VDD.$599.Metal1 VDD.P3.nSD 17
Rred_1548 VDD.$5996.Metal2 VDD.$6102.Metal2 0.024246177939
Rred_1549 VDD.$5996.Metal2 VDD.$7988.Metal3 1.50900905206
Rred_1550 VDD.$5996.Metal2 VDD.$8012.Metal3 1.50901370883
Rred_1551 VDD.$5996.Metal2 VDD.P0.nSD 6093.38455073
Rred_1552 VDD.$5996.Metal2 VDD.P2.nSD 6093.38455073
Rred_1553 VDD.$603.Metal1 VDD.$623.Metal1 0.0104055501146
Rred_1554 VDD.$603.Metal1 VDD.$7568.Metal3 1027.54364816
Rred_1555 VDD.$603.Metal1 VDD.P0.nSD 17
Rred_1556 VDD.$603.Metal1 VDD.P2.nSD 17
Rred_1557 VDD.$6032.Metal2 VDD.$6090.Metal2 0.00278666666667
Rred_1558 VDD.$6032.Metal2 VDD.$6194.Metal2 0.0214147099109
Rred_1559 VDD.$6032.Metal2 VDD.$8030.Metal3 2.67090339797
Rred_1560 VDD.$6032.Metal2 VDD.P37.pSD 3.57324071428
Rred_1561 VDD.$6032.Metal2 VDD.P85.pSD 3.57324071428
Rred_1562 VDD.$6033.Metal2 VDD.$6102.Metal2 0.00278666666667
Rred_1563 VDD.$6033.Metal2 VDD.$6206.Metal2 0.0214147099109
Rred_1564 VDD.$6033.Metal2 VDD.$8036.Metal3 2.67090339797
Rred_1565 VDD.$6033.Metal2 VDD.P13.pSD 3.57324071428
Rred_1566 VDD.$6033.Metal2 VDD.P61.pSD 3.57324071428
Rred_1567 VDD.$6090.Metal2 VDD.$8006.Metal3 1.50901370883
Rred_1568 VDD.$6090.Metal2 VDD.$8030.Metal3 3.01202666667
Rred_1569 VDD.$6102.Metal2 VDD.$8012.Metal3 1.50901370883
Rred_1570 VDD.$6102.Metal2 VDD.$8036.Metal3 3.01202666667
Rred_1571 VDD.$619.Metal1 VDD.$647.Metal1 0.0208605570636
Rred_1572 VDD.$619.Metal1 VDD.$7562.Metal3 597.409097765
Rred_1573 VDD.$619.Metal1 VDD.P1.nSD 11.3483442433
Rred_1574 VDD.$619.Metal1 VDD.P3.nSD 11.3483442433
Rred_1575 VDD.$6194.Metal2 VDD.$6242.Metal2 0.0242460971418
Rred_1576 VDD.$6194.Metal2 VDD.$8030.Metal3 1.6138009324
Rred_1577 VDD.$6194.Metal2 VDD.$8054.Metal3 1.50901119954
Rred_1578 VDD.$6206.Metal2 VDD.$6254.Metal2 0.0242460971418
Rred_1579 VDD.$6206.Metal2 VDD.$8036.Metal3 1.6138009324
Rred_1580 VDD.$6206.Metal2 VDD.$8060.Metal3 1.50901119954
Rred_1581 VDD.$623.Metal1 VDD.$657.Metal1 0.0208605570636
Rred_1582 VDD.$623.Metal1 VDD.$7568.Metal3 597.409097765
Rred_1583 VDD.$623.Metal1 VDD.P0.nSD 11.3483442433
Rred_1584 VDD.$623.Metal1 VDD.P2.nSD 11.3483442433
Rred_1585 VDD.$6242.Metal2 VDD.$6290.Metal2 0.0242460625559
Rred_1586 VDD.$6242.Metal2 VDD.$8054.Metal3 1.50901119954
Rred_1587 VDD.$6242.Metal2 VDD.$8078.Metal3 1.50901012541
Rred_1588 VDD.$6242.Metal2 VDD.P1.nSD 5156.55371387
Rred_1589 VDD.$6242.Metal2 VDD.P3.nSD 5156.55371387
Rred_1590 VDD.$6254.Metal2 VDD.$6302.Metal2 0.0242460625559
Rred_1591 VDD.$6254.Metal2 VDD.$8060.Metal3 1.50901119954
Rred_1592 VDD.$6254.Metal2 VDD.$8084.Metal3 1.50901012541
Rred_1593 VDD.$6254.Metal2 VDD.P0.nSD 5156.55371387
Rred_1594 VDD.$6254.Metal2 VDD.P2.nSD 5156.55371387
Rred_1595 VDD.$6290.Metal2 VDD.$6372.Metal2 0.0120368417226
Rred_1596 VDD.$6290.Metal2 VDD.$8078.Metal3 1.29503374524
Rred_1597 VDD.$6290.Metal2 VDD.$8114.Metal3 4.54820309381
Rred_1598 VDD.$6290.Metal2 VDD.P1.nSD 14139.9506297
Rred_1599 VDD.$6290.Metal2 VDD.P3.nSD 14139.9506297
Rred_1600 VDD.$6290.Metal2 VDD.P39.pSD 97.7532854053
Rred_1601 VDD.$6290.Metal2 VDD.P87.pSD 97.7532854053
Rred_1602 VDD.$6302.Metal2 VDD.$6384.Metal2 0.0120368417226
Rred_1603 VDD.$6302.Metal2 VDD.$8084.Metal3 1.29503374524
Rred_1604 VDD.$6302.Metal2 VDD.$8120.Metal3 4.54820309381
Rred_1605 VDD.$6302.Metal2 VDD.P0.nSD 14139.9506297
Rred_1606 VDD.$6302.Metal2 VDD.P15.pSD 97.7532854053
Rred_1607 VDD.$6302.Metal2 VDD.P2.nSD 14139.9506297
Rred_1608 VDD.$6302.Metal2 VDD.P63.pSD 97.7532854053
Rred_1609 VDD.$6372.Metal2 VDD.$6476.Metal2 0.0242461109832
Rred_1610 VDD.$6372.Metal2 VDD.$8078.Metal3 4.54820309381
Rred_1611 VDD.$6372.Metal2 VDD.$8114.Metal3 1.29503485295
Rred_1612 VDD.$6372.Metal2 VDD.P39.pSD 3.71215007867
Rred_1613 VDD.$6372.Metal2 VDD.P87.pSD 3.71215007867
Rred_1614 VDD.$6384.Metal2 VDD.$6488.Metal2 0.0242461109832
Rred_1615 VDD.$6384.Metal2 VDD.$8084.Metal3 4.54820309381
Rred_1616 VDD.$6384.Metal2 VDD.$8120.Metal3 1.29503485295
Rred_1617 VDD.$6384.Metal2 VDD.P15.pSD 3.71215007867
Rred_1618 VDD.$6384.Metal2 VDD.P63.pSD 3.71215007867
Rred_1619 VDD.$647.Metal1 VDD.$667.Metal1 0.0103919111578
Rred_1620 VDD.$647.Metal1 VDD.$7586.Metal3 394.691079601
Rred_1621 VDD.$647.Metal1 VDD.P1.nSD 11.3448022212
Rred_1622 VDD.$647.Metal1 VDD.P3.nSD 11.3448022212
Rred_1623 VDD.$6476.Metal2 VDD.$6524.Metal2 0.0242460533372
Rred_1624 VDD.$6476.Metal2 VDD.$8114.Metal3 1.5090116294
Rred_1625 VDD.$6476.Metal2 VDD.$8138.Metal3 1.50900983911
Rred_1626 VDD.$6476.Metal2 VDD.P1.nSD 5320.19092171
Rred_1627 VDD.$6476.Metal2 VDD.P3.nSD 5320.19092171
Rred_1628 VDD.$6488.Metal2 VDD.$6536.Metal2 0.0242460533372
Rred_1629 VDD.$6488.Metal2 VDD.$8120.Metal3 1.5090116294
Rred_1630 VDD.$6488.Metal2 VDD.$8144.Metal3 1.50900983911
Rred_1631 VDD.$6488.Metal2 VDD.P0.nSD 5320.19092171
Rred_1632 VDD.$6488.Metal2 VDD.P2.nSD 5320.19092171
Rred_1633 VDD.$6524.Metal2 VDD.$6572.Metal2 0.0242460452723
Rred_1634 VDD.$6524.Metal2 VDD.$8138.Metal3 1.50900983911
Rred_1635 VDD.$6524.Metal2 VDD.$8162.Metal3 1.50900958864
Rred_1636 VDD.$6536.Metal2 VDD.$6584.Metal2 0.0242460452723
Rred_1637 VDD.$6536.Metal2 VDD.$8144.Metal3 1.50900983911
Rred_1638 VDD.$6536.Metal2 VDD.$8168.Metal3 1.50900958864
Rred_1639 VDD.$657.Metal1 VDD.$671.Metal1 0.0103919111578
Rred_1640 VDD.$657.Metal1 VDD.$7592.Metal3 394.691079601
Rred_1641 VDD.$657.Metal1 VDD.P0.nSD 11.3448022212
Rred_1642 VDD.$657.Metal1 VDD.P2.nSD 11.3448022212
Rred_1643 VDD.$6572.Metal2 VDD.$6654.Metal2 0.0120891238911
Rred_1644 VDD.$6572.Metal2 VDD.$8162.Metal3 1.29503334991
Rred_1645 VDD.$6572.Metal2 VDD.$8198.Metal3 4.54820309381
Rred_1646 VDD.$6572.Metal2 VDD.P1.nSD 6480.19286914
Rred_1647 VDD.$6572.Metal2 VDD.P3.nSD 6480.19286914
Rred_1648 VDD.$6572.Metal2 VDD.P41.pSD 11.7813464446
Rred_1649 VDD.$6572.Metal2 VDD.P89.pSD 11.7813464446
Rred_1650 VDD.$6584.Metal2 VDD.$6666.Metal2 0.0120891238911
Rred_1651 VDD.$6584.Metal2 VDD.$8168.Metal3 1.29503334991
Rred_1652 VDD.$6584.Metal2 VDD.$8204.Metal3 4.54820309381
Rred_1653 VDD.$6584.Metal2 VDD.P0.nSD 6480.19286914
Rred_1654 VDD.$6584.Metal2 VDD.P17.pSD 11.7813464446
Rred_1655 VDD.$6584.Metal2 VDD.P2.nSD 6480.19286914
Rred_1656 VDD.$6584.Metal2 VDD.P65.pSD 11.7813464446
Rred_1657 VDD.$6654.Metal2 VDD.$6758.Metal2 0.0242460452723
Rred_1658 VDD.$6654.Metal2 VDD.$8162.Metal3 4.54820309381
Rred_1659 VDD.$6654.Metal2 VDD.$8198.Metal3 1.29503334991
Rred_1660 VDD.$6654.Metal2 VDD.P1.nSD 13099.9828476
Rred_1661 VDD.$6654.Metal2 VDD.P3.nSD 13099.9828476
Rred_1662 VDD.$6654.Metal2 VDD.P41.pSD 5.16725721254
Rred_1663 VDD.$6654.Metal2 VDD.P89.pSD 5.16725721254
Rred_1664 VDD.$6666.Metal2 VDD.$6770.Metal2 0.0242460452723
Rred_1665 VDD.$6666.Metal2 VDD.$8168.Metal3 4.54820309381
Rred_1666 VDD.$6666.Metal2 VDD.$8204.Metal3 1.29503334991
Rred_1667 VDD.$6666.Metal2 VDD.P0.nSD 13099.9828476
Rred_1668 VDD.$6666.Metal2 VDD.P17.pSD 5.16725721254
Rred_1669 VDD.$6666.Metal2 VDD.P2.nSD 13099.9828476
Rred_1670 VDD.$6666.Metal2 VDD.P65.pSD 5.16725721254
Rred_1671 VDD.$667.Metal1 VDD.$687.Metal1 0.0104023800154
Rred_1672 VDD.$667.Metal1 VDD.$7586.Metal3 8551.64005804
Rred_1673 VDD.$667.Metal1 VDD.P1.nSD 17
Rred_1674 VDD.$667.Metal1 VDD.P3.nSD 17
Rred_1675 VDD.$671.Metal1 VDD.$691.Metal1 0.0104023800154
Rred_1676 VDD.$671.Metal1 VDD.$7592.Metal3 8551.64005804
Rred_1677 VDD.$671.Metal1 VDD.P0.nSD 17
Rred_1678 VDD.$671.Metal1 VDD.P2.nSD 17
Rred_1679 VDD.$6758.Metal2 VDD.$6806.Metal2 0.0242460533372
Rred_1680 VDD.$6758.Metal2 VDD.$8198.Metal3 1.50900958864
Rred_1681 VDD.$6758.Metal2 VDD.$8222.Metal3 1.50900983911
Rred_1682 VDD.$6770.Metal2 VDD.$6818.Metal2 0.0242460533372
Rred_1683 VDD.$6770.Metal2 VDD.$8204.Metal3 1.50900958864
Rred_1684 VDD.$6770.Metal2 VDD.$8228.Metal3 1.50900983911
Rred_1685 VDD.$6806.Metal2 VDD.$6912.Metal2 0.0242461109832
Rred_1686 VDD.$6806.Metal2 VDD.$8222.Metal3 1.50900983911
Rred_1687 VDD.$6806.Metal2 VDD.$8246.Metal3 1.5090116294
Rred_1688 VDD.$6806.Metal2 VDD.P1.nSD 5320.19092171
Rred_1689 VDD.$6806.Metal2 VDD.P3.nSD 5320.19092171
Rred_1690 VDD.$6818.Metal2 VDD.$6924.Metal2 0.0242461109832
Rred_1691 VDD.$6818.Metal2 VDD.$8228.Metal3 1.50900983911
Rred_1692 VDD.$6818.Metal2 VDD.$8252.Metal3 1.5090116294
Rred_1693 VDD.$6818.Metal2 VDD.P0.nSD 5320.19092171
Rred_1694 VDD.$6818.Metal2 VDD.P2.nSD 5320.19092171
Rred_1695 VDD.$687.Metal1 VDD.$706.Metal1 0.0119412090979
Rred_1696 VDD.$687.Metal1 VDD.P1.nSD 15.0717018687
Rred_1697 VDD.$687.Metal1 VDD.P3.nSD 15.0717018687
Rred_1698 VDD.$691.Metal1 VDD.$707.Metal1 0.0119412090979
Rred_1699 VDD.$691.Metal1 VDD.P0.nSD 15.0717018687
Rred_1700 VDD.$691.Metal1 VDD.P2.nSD 15.0717018687
Rred_1701 VDD.$6912.Metal2 VDD.$6992.Metal2 0.012098805773
Rred_1702 VDD.$6912.Metal2 VDD.$8246.Metal3 1.29503485295
Rred_1703 VDD.$6912.Metal2 VDD.$8282.Metal3 4.54820309381
Rred_1704 VDD.$6912.Metal2 VDD.P43.pSD 6.27169257257
Rred_1705 VDD.$6912.Metal2 VDD.P91.pSD 6.27169257257
Rred_1706 VDD.$6924.Metal2 VDD.$7004.Metal2 0.012098805773
Rred_1707 VDD.$6924.Metal2 VDD.$8252.Metal3 1.29503485295
Rred_1708 VDD.$6924.Metal2 VDD.$8288.Metal3 4.54820309381
Rred_1709 VDD.$6924.Metal2 VDD.P19.pSD 6.27169257257
Rred_1710 VDD.$6924.Metal2 VDD.P67.pSD 6.27169257257
Rred_1711 VDD.$6992.Metal2 VDD.$7040.Metal2 0.0242460625559
Rred_1712 VDD.$6992.Metal2 VDD.$8246.Metal3 4.54820309381
Rred_1713 VDD.$6992.Metal2 VDD.$8282.Metal3 1.29503374524
Rred_1714 VDD.$6992.Metal2 VDD.P1.nSD 42082.9728891
Rred_1715 VDD.$6992.Metal2 VDD.P3.nSD 42082.9728891
Rred_1716 VDD.$6992.Metal2 VDD.P43.pSD 8.42198716889
Rred_1717 VDD.$6992.Metal2 VDD.P91.pSD 8.42198716889
Rred_1718 VDD.$7004.Metal2 VDD.$7052.Metal2 0.0242460625559
Rred_1719 VDD.$7004.Metal2 VDD.$8252.Metal3 4.54820309381
Rred_1720 VDD.$7004.Metal2 VDD.$8288.Metal3 1.29503374524
Rred_1721 VDD.$7004.Metal2 VDD.P0.nSD 42082.9728891
Rred_1722 VDD.$7004.Metal2 VDD.P19.pSD 8.42198716889
Rred_1723 VDD.$7004.Metal2 VDD.P2.nSD 42082.9728891
Rred_1724 VDD.$7004.Metal2 VDD.P67.pSD 8.42198716889
Rred_1725 VDD.$7040.Metal2 VDD.$7088.Metal2 0.0242460971418
Rred_1726 VDD.$7040.Metal2 VDD.$8282.Metal3 1.50901012541
Rred_1727 VDD.$7040.Metal2 VDD.$8306.Metal3 1.50901119954
Rred_1728 VDD.$7040.Metal2 VDD.P1.nSD 5156.55371387
Rred_1729 VDD.$7040.Metal2 VDD.P3.nSD 5156.55371387
Rred_1730 VDD.$7052.Metal2 VDD.$7100.Metal2 0.0242460971418
Rred_1731 VDD.$7052.Metal2 VDD.$8288.Metal3 1.50901012541
Rred_1732 VDD.$7052.Metal2 VDD.$8312.Metal3 1.50901119954
Rred_1733 VDD.$7052.Metal2 VDD.P0.nSD 5156.55371387
Rred_1734 VDD.$7052.Metal2 VDD.P2.nSD 5156.55371387
Rred_1735 VDD.$706.Metal1 VDD.$909.Metal1 0.00887363747428
Rred_1736 VDD.$706.Metal1 VDD.P1.nSD 19.5066478997
Rred_1737 VDD.$706.Metal1 VDD.P27.pSD 1.98810169492
Rred_1738 VDD.$706.Metal1 VDD.P3.nSD 19.5066478997
Rred_1739 VDD.$706.Metal1 VDD.P75.pSD 1.98810169492
Rred_1740 VDD.$707.Metal1 VDD.$913.Metal1 0.00887363747428
Rred_1741 VDD.$707.Metal1 VDD.P0.nSD 19.5066478997
Rred_1742 VDD.$707.Metal1 VDD.P2.nSD 19.5066478997
Rred_1743 VDD.$707.Metal1 VDD.P3.pSD 1.98810169492
Rred_1744 VDD.$707.Metal1 VDD.P51.pSD 1.98810169492
Rred_1745 VDD.$7088.Metal2 VDD.$7112.Metal2 0.0120264116929
Rred_1746 VDD.$7088.Metal2 VDD.$8306.Metal3 1.29503453635
Rred_1747 VDD.$7088.Metal2 VDD.$8342.Metal3 4.54820309381
Rred_1748 VDD.$7100.Metal2 VDD.$7124.Metal2 0.0120264116929
Rred_1749 VDD.$7100.Metal2 VDD.$8312.Metal3 1.29503453635
Rred_1750 VDD.$7100.Metal2 VDD.$8348.Metal3 4.54820309381
Rred_1751 VDD.$7112.Metal2 VDD.$7140.Metal2 0.0330185759294
Rred_1752 VDD.$7112.Metal2 VDD.$7142.Metal2 0.0330185759294
Rred_1753 VDD.$7112.Metal2 VDD.$8306.Metal3 4.54820309381
Rred_1754 VDD.$7112.Metal2 VDD.$8342.Metal3 2.26502132807
Rred_1755 VDD.$7124.Metal2 VDD.$7152.Metal2 0.0330185759294
Rred_1756 VDD.$7124.Metal2 VDD.$7154.Metal2 0.0330185759294
Rred_1757 VDD.$7124.Metal2 VDD.$8312.Metal3 4.54820309381
Rred_1758 VDD.$7124.Metal2 VDD.$8348.Metal3 2.26502132807
Rred_1759 VDD.$7136.Metal2 VDD.$7138.Metal2 0.013640831758
Rred_1760 VDD.$7136.Metal2 VDD.$7175.Metal2 0.0563107648129
Rred_1761 VDD.$7136.Metal2 VDD.$8342.Metal3 9
Rred_1762 VDD.$7136.Metal2 VDD.$8354.Metal3 9
Rred_1763 VDD.$7136.Metal2 VDD.$8366.Metal3 9
Rred_1764 VDD.$7136.Metal2 VDD.$8378.Metal3 9
Rred_1765 VDD.$7136.Metal2 VDD.$8390.Metal3 9
Rred_1766 VDD.$7136.Metal2 VDD.$8402.Metal3 9
Rred_1767 VDD.$7136.Metal2 VDD.P1.nSD 749.627801058
Rred_1768 VDD.$7138.Metal2 VDD.$7140.Metal2 0.0136405957342
Rred_1769 VDD.$7138.Metal2 VDD.$8342.Metal3 9
Rred_1770 VDD.$7138.Metal2 VDD.$8354.Metal3 9
Rred_1771 VDD.$7138.Metal2 VDD.$8366.Metal3 9
Rred_1772 VDD.$7138.Metal2 VDD.$8378.Metal3 9
Rred_1773 VDD.$7138.Metal2 VDD.$8390.Metal3 9
Rred_1774 VDD.$7138.Metal2 VDD.$8402.Metal3 9
Rred_1775 VDD.$7140.Metal2 VDD.$7142.Metal2 0.0344136795057
Rred_1776 VDD.$7140.Metal2 VDD.$8342.Metal3 9
Rred_1777 VDD.$7140.Metal2 VDD.$8354.Metal3 9
Rred_1778 VDD.$7140.Metal2 VDD.$8366.Metal3 9
Rred_1779 VDD.$7140.Metal2 VDD.$8378.Metal3 9
Rred_1780 VDD.$7140.Metal2 VDD.$8390.Metal3 9
Rred_1781 VDD.$7140.Metal2 VDD.$8402.Metal3 9
Rred_1782 VDD.$7142.Metal2 VDD.$7144.Metal2 0.013640831758
Rred_1783 VDD.$7142.Metal2 VDD.$8342.Metal3 9
Rred_1784 VDD.$7142.Metal2 VDD.$8354.Metal3 9
Rred_1785 VDD.$7142.Metal2 VDD.$8366.Metal3 9
Rred_1786 VDD.$7142.Metal2 VDD.$8378.Metal3 9
Rred_1787 VDD.$7142.Metal2 VDD.$8390.Metal3 9
Rred_1788 VDD.$7142.Metal2 VDD.$8402.Metal3 9
Rred_1789 VDD.$7144.Metal2 VDD.$7146.Metal2 0.0136404870809
Rred_1790 VDD.$7144.Metal2 VDD.$8342.Metal3 9
Rred_1791 VDD.$7144.Metal2 VDD.$8354.Metal3 9
Rred_1792 VDD.$7144.Metal2 VDD.$8366.Metal3 9
Rred_1793 VDD.$7144.Metal2 VDD.$8378.Metal3 9
Rred_1794 VDD.$7144.Metal2 VDD.$8390.Metal3 9
Rred_1795 VDD.$7144.Metal2 VDD.$8402.Metal3 9
Rred_1796 VDD.$7146.Metal2 VDD.$7176.Metal2 0.0563107648129
Rred_1797 VDD.$7146.Metal2 VDD.$8342.Metal3 9
Rred_1798 VDD.$7146.Metal2 VDD.$8354.Metal3 9
Rred_1799 VDD.$7146.Metal2 VDD.$8366.Metal3 9
Rred_1800 VDD.$7146.Metal2 VDD.$8378.Metal3 9
Rred_1801 VDD.$7146.Metal2 VDD.$8390.Metal3 9
Rred_1802 VDD.$7146.Metal2 VDD.$8402.Metal3 9
Rred_1803 VDD.$7146.Metal2 VDD.P3.nSD 592.933403088
Rred_1804 VDD.$7148.Metal2 VDD.$7150.Metal2 0.013640831758
Rred_1805 VDD.$7148.Metal2 VDD.$7203.Metal2 0.0563107648129
Rred_1806 VDD.$7148.Metal2 VDD.$8348.Metal3 9
Rred_1807 VDD.$7148.Metal2 VDD.$8360.Metal3 9
Rred_1808 VDD.$7148.Metal2 VDD.$8372.Metal3 9
Rred_1809 VDD.$7148.Metal2 VDD.$8384.Metal3 9
Rred_1810 VDD.$7148.Metal2 VDD.$8396.Metal3 9
Rred_1811 VDD.$7148.Metal2 VDD.$8408.Metal3 9
Rred_1812 VDD.$7148.Metal2 VDD.P2.nSD 749.627801058
Rred_1813 VDD.$7150.Metal2 VDD.$7152.Metal2 0.0136405957342
Rred_1814 VDD.$7150.Metal2 VDD.$8348.Metal3 9
Rred_1815 VDD.$7150.Metal2 VDD.$8360.Metal3 9
Rred_1816 VDD.$7150.Metal2 VDD.$8372.Metal3 9
Rred_1817 VDD.$7150.Metal2 VDD.$8384.Metal3 9
Rred_1818 VDD.$7150.Metal2 VDD.$8396.Metal3 9
Rred_1819 VDD.$7150.Metal2 VDD.$8408.Metal3 9
Rred_1820 VDD.$7152.Metal2 VDD.$7154.Metal2 0.0344136795057
Rred_1821 VDD.$7152.Metal2 VDD.$8348.Metal3 9
Rred_1822 VDD.$7152.Metal2 VDD.$8360.Metal3 9
Rred_1823 VDD.$7152.Metal2 VDD.$8372.Metal3 9
Rred_1824 VDD.$7152.Metal2 VDD.$8384.Metal3 9
Rred_1825 VDD.$7152.Metal2 VDD.$8396.Metal3 9
Rred_1826 VDD.$7152.Metal2 VDD.$8408.Metal3 9
Rred_1827 VDD.$7154.Metal2 VDD.$7156.Metal2 0.013640831758
Rred_1828 VDD.$7154.Metal2 VDD.$8348.Metal3 9
Rred_1829 VDD.$7154.Metal2 VDD.$8360.Metal3 9
Rred_1830 VDD.$7154.Metal2 VDD.$8372.Metal3 9
Rred_1831 VDD.$7154.Metal2 VDD.$8384.Metal3 9
Rred_1832 VDD.$7154.Metal2 VDD.$8396.Metal3 9
Rred_1833 VDD.$7154.Metal2 VDD.$8408.Metal3 9
Rred_1834 VDD.$7156.Metal2 VDD.$7158.Metal2 0.0136404870809
Rred_1835 VDD.$7156.Metal2 VDD.$8348.Metal3 9
Rred_1836 VDD.$7156.Metal2 VDD.$8360.Metal3 9
Rred_1837 VDD.$7156.Metal2 VDD.$8372.Metal3 9
Rred_1838 VDD.$7156.Metal2 VDD.$8384.Metal3 9
Rred_1839 VDD.$7156.Metal2 VDD.$8396.Metal3 9
Rred_1840 VDD.$7156.Metal2 VDD.$8408.Metal3 9
Rred_1841 VDD.$7158.Metal2 VDD.$7204.Metal2 0.0563107648129
Rred_1842 VDD.$7158.Metal2 VDD.$8348.Metal3 9
Rred_1843 VDD.$7158.Metal2 VDD.$8360.Metal3 9
Rred_1844 VDD.$7158.Metal2 VDD.$8372.Metal3 9
Rred_1845 VDD.$7158.Metal2 VDD.$8384.Metal3 9
Rred_1846 VDD.$7158.Metal2 VDD.$8396.Metal3 9
Rred_1847 VDD.$7158.Metal2 VDD.$8408.Metal3 9
Rred_1848 VDD.$7158.Metal2 VDD.P0.nSD 592.933403088
Rred_1849 VDD.$7169.Metal2 VDD.$7171.Metal2 0.0273432884735
Rred_1850 VDD.$7169.Metal2 VDD.P45.pSD 14.0821006029
Rred_1851 VDD.$7169.Metal2 VDD.P47.pSD 14.0821006029
Rred_1852 VDD.$7171.Metal2 VDD.$7173.Metal2 0.0273436802632
Rred_1853 VDD.$7171.Metal2 VDD.P45.pSD 6270.37861931
Rred_1854 VDD.$7173.Metal2 VDD.$7174.Metal2 0.013640831758
Rred_1855 VDD.$7173.Metal2 VDD.P45.pSD 485522.422041
Rred_1856 VDD.$7173.Metal2 VDD.P47.pSD 4792.78393733
Rred_1857 VDD.$7174.Metal2 VDD.$7175.Metal2 0.0136407731205
Rred_1858 VDD.$7174.Metal2 VDD.P45.pSD 13759.4674119
Rred_1859 VDD.$7174.Metal2 VDD.P47.pSD 7699.82070935
Rred_1860 VDD.$7175.Metal2 VDD.P45.pSD 3701.09101018
Rred_1861 VDD.$7175.Metal2 VDD.P47.pSD 2268.78616064
Rred_1862 VDD.$7176.Metal2 VDD.$7178.Metal2 0.0273436106697
Rred_1863 VDD.$7176.Metal2 VDD.P93.pSD 10908.1850238
Rred_1864 VDD.$7176.Metal2 VDD.P95.pSD 10908.1850238
Rred_1865 VDD.$7178.Metal2 VDD.$7180.Metal2 0.0273436781895
Rred_1866 VDD.$7180.Metal2 VDD.$7183.Metal2 0.0411705704037
Rred_1867 VDD.$7180.Metal2 VDD.P93.pSD 6880.74713891
Rred_1868 VDD.$7180.Metal2 VDD.P95.pSD 6880.74713891
Rred_1869 VDD.$7183.Metal2 VDD.$7186.Metal2 0.041170657851
Rred_1870 VDD.$7186.Metal2 VDD.P93.pSD 79.9230955855
Rred_1871 VDD.$7186.Metal2 VDD.P95.pSD 79.9230955855
Rred_1872 VDD.$7197.Metal2 VDD.$7199.Metal2 0.0273432884735
Rred_1873 VDD.$7197.Metal2 VDD.P69.pSD 14.0821006029
Rred_1874 VDD.$7197.Metal2 VDD.P71.pSD 14.0821006029
Rred_1875 VDD.$7199.Metal2 VDD.$7201.Metal2 0.0273436802632
Rred_1876 VDD.$7199.Metal2 VDD.P69.pSD 6270.37861931
Rred_1877 VDD.$7201.Metal2 VDD.$7202.Metal2 0.013640831758
Rred_1878 VDD.$7201.Metal2 VDD.P69.pSD 485522.422041
Rred_1879 VDD.$7201.Metal2 VDD.P71.pSD 4792.78393733
Rred_1880 VDD.$7202.Metal2 VDD.$7203.Metal2 0.0136407731205
Rred_1881 VDD.$7202.Metal2 VDD.P69.pSD 13759.4674119
Rred_1882 VDD.$7202.Metal2 VDD.P71.pSD 7699.82070935
Rred_1883 VDD.$7203.Metal2 VDD.P69.pSD 3701.09101018
Rred_1884 VDD.$7203.Metal2 VDD.P71.pSD 2268.78616064
Rred_1885 VDD.$7204.Metal2 VDD.$7206.Metal2 0.0273436106697
Rred_1886 VDD.$7204.Metal2 VDD.P21.pSD 10908.1850238
Rred_1887 VDD.$7204.Metal2 VDD.P23.pSD 10908.1850238
Rred_1888 VDD.$7206.Metal2 VDD.$7208.Metal2 0.0273436781895
Rred_1889 VDD.$7208.Metal2 VDD.$7211.Metal2 0.0411705704037
Rred_1890 VDD.$7208.Metal2 VDD.P21.pSD 6880.74713891
Rred_1891 VDD.$7208.Metal2 VDD.P23.pSD 6880.74713891
Rred_1892 VDD.$7211.Metal2 VDD.$7214.Metal2 0.041170657851
Rred_1893 VDD.$7214.Metal2 VDD.P21.pSD 79.9230955855
Rred_1894 VDD.$7214.Metal2 VDD.P23.pSD 79.9230955855
Rred_1895 VDD.$7478.Metal3 VDD.$7490.Metal3 0.0120266666667
Rred_1896 VDD.$7484.Metal3 VDD.$7496.Metal3 0.0120266666667
Rred_1897 VDD.$7490.Metal3 VDD.$7502.Metal3 0.0120266666667
Rred_1898 VDD.$7496.Metal3 VDD.$7508.Metal3 0.0120266666667
Rred_1899 VDD.$7502.Metal3 VDD.$7514.Metal3 0.0120266666667
Rred_1900 VDD.$7508.Metal3 VDD.$7520.Metal3 0.0120266666667
Rred_1901 VDD.$7514.Metal3 VDD.$7526.Metal3 0.0120266666667
Rred_1902 VDD.$7520.Metal3 VDD.$7532.Metal3 0.0120266666667
Rred_1903 VDD.$7526.Metal3 VDD.$7538.Metal3 0.0120266666667
Rred_1904 VDD.$7532.Metal3 VDD.$7544.Metal3 0.0120266666667
Rred_1905 VDD.$7538.Metal3 VDD.$7562.Metal3 0.0241497604741
Rred_1906 VDD.$7544.Metal3 VDD.$7568.Metal3 0.0241497604741
Rred_1907 VDD.$7562.Metal3 VDD.$7586.Metal3 0.0241497604741
Rred_1908 VDD.$7568.Metal3 VDD.$7592.Metal3 0.0241497604741
Rred_1909 VDD.$7586.Metal3 VDD.$7610.Metal3 0.0241497604741
Rred_1910 VDD.$7592.Metal3 VDD.$7616.Metal3 0.0241497604741
Rred_1911 VDD.$7610.Metal3 VDD.$7646.Metal3 0.0364664816945
Rred_1912 VDD.$7616.Metal3 VDD.$7652.Metal3 0.0364664816945
Rred_1913 VDD.$7646.Metal3 VDD.$7682.Metal3 0.0364664816945
Rred_1914 VDD.$7646.Metal3 VDD.$937.Metal1 407.293836161
Rred_1915 VDD.$7646.Metal3 VDD.$957.Metal1 5131.90233563
Rred_1916 VDD.$7652.Metal3 VDD.$7688.Metal3 0.0364664816945
Rred_1917 VDD.$7652.Metal3 VDD.$941.Metal1 407.293836161
Rred_1918 VDD.$7652.Metal3 VDD.$961.Metal1 5131.90233563
Rred_1919 VDD.$7682.Metal3 VDD.$7718.Metal3 0.0364664816945
Rred_1920 VDD.$7682.Metal3 VDD.$997.Metal1 1223.10590957
Rred_1921 VDD.$7688.Metal3 VDD.$7724.Metal3 0.0364664816945
Rred_1922 VDD.$7718.Metal3 VDD.$7742.Metal3 0.0241497604741
Rred_1923 VDD.$7724.Metal3 VDD.$7748.Metal3 0.0241497604741
Rred_1924 VDD.$7742.Metal3 VDD.$7766.Metal3 0.0241497604741
Rred_1925 VDD.$7748.Metal3 VDD.$7772.Metal3 0.0241497604741
Rred_1926 VDD.$7766.Metal3 VDD.$7790.Metal3 0.0241497604741
Rred_1927 VDD.$7772.Metal3 VDD.$7796.Metal3 0.0241497604741
Rred_1928 VDD.$7790.Metal3 VDD.$7814.Metal3 0.0241497604741
Rred_1929 VDD.$7796.Metal3 VDD.$7820.Metal3 0.0241497604741
Rred_1930 VDD.$7814.Metal3 VDD.$7838.Metal3 0.0241497604741
Rred_1931 VDD.$7820.Metal3 VDD.$7844.Metal3 0.0241497604741
Rred_1932 VDD.$7838.Metal3 VDD.$7886.Metal3 0.0490755830613
Rred_1933 VDD.$7844.Metal3 VDD.$7892.Metal3 0.0490755830613
Rred_1934 VDD.$7886.Metal3 VDD.$7922.Metal3 0.0364664816945
Rred_1935 VDD.$7892.Metal3 VDD.$7928.Metal3 0.0364664816945
Rred_1936 VDD.$7922.Metal3 VDD.$7958.Metal3 0.0364664816945
Rred_1937 VDD.$7928.Metal3 VDD.$7964.Metal3 0.0364664816945
Rred_1938 VDD.$7958.Metal3 VDD.$7982.Metal3 0.0241497604741
Rred_1939 VDD.$7964.Metal3 VDD.$7988.Metal3 0.0241497604741
Rred_1940 VDD.$7982.Metal3 VDD.$8006.Metal3 0.0241497604741
Rred_1941 VDD.$7988.Metal3 VDD.$8012.Metal3 0.0241497604741
Rred_1942 VDD.$8006.Metal3 VDD.$8030.Metal3 0.0241497604741
Rred_1943 VDD.$8012.Metal3 VDD.$8036.Metal3 0.0241497604741
Rred_1944 VDD.$8030.Metal3 VDD.$8054.Metal3 0.0241497604741
Rred_1945 VDD.$8036.Metal3 VDD.$8060.Metal3 0.0241497604741
Rred_1946 VDD.$8054.Metal3 VDD.$8078.Metal3 0.0241497604741
Rred_1947 VDD.$8060.Metal3 VDD.$8084.Metal3 0.0241497604741
Rred_1948 VDD.$8078.Metal3 VDD.$8114.Metal3 0.0364664816945
Rred_1949 VDD.$8084.Metal3 VDD.$8120.Metal3 0.0364664816945
Rred_1950 VDD.$8114.Metal3 VDD.$8138.Metal3 0.0241497604741
Rred_1951 VDD.$8120.Metal3 VDD.$8144.Metal3 0.0241497604741
Rred_1952 VDD.$8138.Metal3 VDD.$8162.Metal3 0.0241497604741
Rred_1953 VDD.$8144.Metal3 VDD.$8168.Metal3 0.0241497604741
Rred_1954 VDD.$8162.Metal3 VDD.$8198.Metal3 0.0364664816945
Rred_1955 VDD.$8168.Metal3 VDD.$8204.Metal3 0.0364664816945
Rred_1956 VDD.$8198.Metal3 VDD.$8222.Metal3 0.0241497604741
Rred_1957 VDD.$8204.Metal3 VDD.$8228.Metal3 0.0241497604741
Rred_1958 VDD.$8222.Metal3 VDD.$8246.Metal3 0.0241497604741
Rred_1959 VDD.$8228.Metal3 VDD.$8252.Metal3 0.0241497604741
Rred_1960 VDD.$8246.Metal3 VDD.$8282.Metal3 0.0364664816945
Rred_1961 VDD.$8252.Metal3 VDD.$8288.Metal3 0.0364664816945
Rred_1962 VDD.$8282.Metal3 VDD.$8306.Metal3 0.0241497604741
Rred_1963 VDD.$8288.Metal3 VDD.$8312.Metal3 0.0241497604741
Rred_1964 VDD.$8306.Metal3 VDD.$8342.Metal3 0.0364664816945
Rred_1965 VDD.$8312.Metal3 VDD.$8348.Metal3 0.0364664816945
Rred_1966 VDD.$8342.Metal3 VDD.$8354.Metal3 0.0120266666667
Rred_1967 VDD.$8348.Metal3 VDD.$8360.Metal3 0.0120266666667
Rred_1968 VDD.$8354.Metal3 VDD.$8366.Metal3 0.0120266666667
Rred_1969 VDD.$8360.Metal3 VDD.$8372.Metal3 0.0120266666667
Rred_1970 VDD.$8366.Metal3 VDD.$8378.Metal3 0.0120266666667
Rred_1971 VDD.$8372.Metal3 VDD.$8384.Metal3 0.0120266666667
Rred_1972 VDD.$8378.Metal3 VDD.$8390.Metal3 0.0120266666667
Rred_1973 VDD.$8384.Metal3 VDD.$8396.Metal3 0.0120266666667
Rred_1974 VDD.$8390.Metal3 VDD.$8402.Metal3 0.0120266666667
Rred_1975 VDD.$8396.Metal3 VDD.$8408.Metal3 0.0120266666667
Rred_1976 VDD.$909.Metal1 VDD.$937.Metal1 0.0208611776658
Rred_1977 VDD.$909.Metal1 VDD.P1.nSD 11.3484564808
Rred_1978 VDD.$909.Metal1 VDD.P3.nSD 11.3484564808
Rred_1979 VDD.$913.Metal1 VDD.$941.Metal1 0.0208611776658
Rred_1980 VDD.$913.Metal1 VDD.P0.nSD 11.3484564808
Rred_1981 VDD.$913.Metal1 VDD.P2.nSD 11.3484564808
Rred_1982 VDD.$937.Metal1 VDD.$957.Metal1 0.0103937710155
Rred_1983 VDD.$937.Metal1 VDD.P1.nSD 11.3454566644
Rred_1984 VDD.$937.Metal1 VDD.P3.nSD 11.3454566644
Rred_1985 VDD.$941.Metal1 VDD.$961.Metal1 0.0103937710155
Rred_1986 VDD.$941.Metal1 VDD.P0.nSD 11.3454566644
Rred_1987 VDD.$941.Metal1 VDD.P2.nSD 11.3454566644
Rred_1988 VDD.$957.Metal1 VDD.$977.Metal1 0.0104033759002
Rred_1989 VDD.$957.Metal1 VDD.P1.nSD 17
Rred_1990 VDD.$957.Metal1 VDD.P3.nSD 17
Rred_1991 VDD.$961.Metal1 VDD.$981.Metal1 0.0104033759002
Rred_1992 VDD.$961.Metal1 VDD.P0.nSD 17
Rred_1993 VDD.$961.Metal1 VDD.P2.nSD 17
Rred_1994 VDD.$977.Metal1 VDD.$997.Metal1 0.0104068614969
Rred_1995 VDD.$977.Metal1 VDD.P1.nSD 17
Rred_1996 VDD.$977.Metal1 VDD.P3.nSD 17
Rred_1997 VDD.$981.Metal1 VDD.P0.nSD 17
Rred_1998 VDD.$981.Metal1 VDD.P2.nSD 17
Rred_1999 VDD.$997.Metal1 VDD.P1.nSD 17
Rred_2000 VDD.$997.Metal1 VDD.P3.nSD 17
Rred_2001 VDD.P0.nSD VDD.P2.nSD 3486.88935296
Rred_2002 VDD.P0.pSD VDD.P1.pSD 14.8826674875
Rred_2003 VDD.P1.nSD VDD.P3.nSD 3486.88935296
Rred_2004 VDD.P10.pSD VDD.P57.pSD 5989.78200054
Rred_2005 VDD.P11.pSD VDD.P59.pSD 4272.70221297
Rred_2006 VDD.P15.pSD VDD.P63.pSD 30146.3768151
Rred_2007 VDD.P17.pSD VDD.P65.pSD 5035.59650536
Rred_2008 VDD.P19.pSD VDD.P67.pSD 4365.63647684
Rred_2009 VDD.P21.pSD VDD.P23.pSD 330.013358454
Rred_2010 VDD.P24.pSD VDD.P25.pSD 58.4880547969
Rred_2011 VDD.P27.pSD VDD.P75.pSD 4365.63647684
Rred_2012 VDD.P29.pSD VDD.P77.pSD 5035.59650536
Rred_2013 VDD.P3.pSD VDD.P51.pSD 4365.63647684
Rred_2014 VDD.P33.pSD VDD.P81.pSD 5989.78200054
Rred_2015 VDD.P35.pSD VDD.P83.pSD 4272.70221297
Rred_2016 VDD.P39.pSD VDD.P87.pSD 30146.3768151
Rred_2017 VDD.P41.pSD VDD.P89.pSD 5035.59650536
Rred_2018 VDD.P43.pSD VDD.P91.pSD 4365.63647684
Rred_2019 VDD.P45.pSD VDD.P47.pSD 58.4880547969
Rred_2020 VDD.P48.pSD VDD.P49.pSD 58.4880547969
Rred_2021 VDD.P5.pSD VDD.P53.pSD 5035.59650536
Rred_2022 VDD.P69.pSD VDD.P71.pSD 58.4880547969
Rred_2023 VDD.P72.pSD VDD.P73.pSD 14.8826674875
Rred_2024 VDD.P93.pSD VDD.P95.pSD 330.013358454
Rred_2025 vin1 vin1.$477.Metal2 1.24696
Rred_2026 vin1.$10.GatPoly vin1.$16.GatPoly 20.0625185185
Rred_2027 vin1.$10.GatPoly vin1.$202.Metal1 20.489591646
Rred_2028 vin1.$10.GatPoly vin1.$210.Metal1 16.8901542286
Rred_2029 vin1.$10.GatPoly vin1.$479.Metal2 23421.3890021
Rred_2030 vin1.$10.GatPoly vin1.$483.Metal2 2115.07400678
Rred_2031 vin1.$10.GatPoly vin1.$6.GatPoly 33.2847407407
Rred_2032 vin1.$10.GatPoly vin1.P1.GatPoly 19.9708444444
Rred_2033 vin1.$102.GatPoly vin1.$108.GatPoly 20.0625185185
Rred_2034 vin1.$102.GatPoly vin1.$334.Metal1 158.710238626
Rred_2035 vin1.$102.GatPoly vin1.$338.Metal1 17.3193062589
Rred_2036 vin1.$102.GatPoly vin1.$346.Metal1 16.8757273465
Rred_2037 vin1.$102.GatPoly vin1.$570.Metal2 2987.58348254
Rred_2038 vin1.$102.GatPoly vin1.$575.Metal2 5498.19357361
Rred_2039 vin1.$102.GatPoly vin1.$94.GatPoly 83.9400817622
Rred_2040 vin1.$102.GatPoly vin1.P10.GatPoly 27.8344874504
Rred_2041 vin1.$105.GatPoly vin1.$107.GatPoly 15.0537042157
Rred_2042 vin1.$105.GatPoly vin1.$339.Metal1 123.604185185
Rred_2043 vin1.$105.GatPoly vin1.$343.Metal1 33.8281181896
Rred_2044 vin1.$105.GatPoly vin1.$347.Metal1 13.0141464528
Rred_2045 vin1.$105.GatPoly vin1.$353.Metal1 98.1690707437
Rred_2046 vin1.$105.GatPoly vin1.$578.Metal2 5361.89490005
Rred_2047 vin1.$105.GatPoly vin1.$97.GatPoly 30.7637083127
Rred_2048 vin1.$107.GatPoly vin1.$115.GatPoly 29.4260595885
Rred_2049 vin1.$107.GatPoly vin1.$347.Metal1 57.8243567653
Rred_2050 vin1.$107.GatPoly vin1.$353.Metal1 15.9311738026
Rred_2051 vin1.$107.GatPoly vin1.$357.Metal1 55.6375076253
Rred_2052 vin1.$107.GatPoly vin1.$578.Metal2 3154.05582356
Rred_2053 vin1.$107.GatPoly vin1.P31.GatPoly 22.26
Rred_2054 vin1.$108.GatPoly vin1.$110.GatPoly 11.1325184116
Rred_2055 vin1.$108.GatPoly vin1.$346.Metal1 37.9333333333
Rred_2056 vin1.$108.GatPoly vin1.$348.Metal1 15.5718406742
Rred_2057 vin1.$108.GatPoly vin1.$356.Metal1 430.191522254
Rred_2058 vin1.$108.GatPoly vin1.$579.Metal2 25055.8390465
Rred_2059 vin1.$108.GatPoly vin1.P11.GatPoly 16.2266666667
Rred_2060 vin1.$110.GatPoly vin1.$118.GatPoly 42.8025468312
Rred_2061 vin1.$110.GatPoly vin1.$348.Metal1 31.5600123225
Rred_2062 vin1.$110.GatPoly vin1.$356.Metal1 15.334097558
Rred_2063 vin1.$110.GatPoly vin1.$360.Metal1 80.9291851852
Rred_2064 vin1.$110.GatPoly vin1.$579.Metal2 1714.75888267
Rred_2065 vin1.$110.GatPoly vin1.P11.GatPoly 11.3586666667
Rred_2066 vin1.$115.GatPoly vin1.$123.GatPoly 51.4620406015
Rred_2067 vin1.$115.GatPoly vin1.$353.Metal1 135.119661376
Rred_2068 vin1.$115.GatPoly vin1.$357.Metal1 16.0835537092
Rred_2069 vin1.$115.GatPoly vin1.$365.Metal1 15.9974348707
Rred_2070 vin1.$115.GatPoly vin1.$369.Metal1 97.3021776078
Rred_2071 vin1.$115.GatPoly vin1.$582.Metal2 4543.078818
Rred_2072 vin1.$115.GatPoly vin1.$587.Metal2 3372.27982918
Rred_2073 vin1.$115.GatPoly vin1.P32.GatPoly 93.7877994151
Rred_2074 vin1.$118.GatPoly vin1.$122.GatPoly 33.2347189542
Rred_2075 vin1.$118.GatPoly vin1.$356.Metal1 80.9291851852
Rred_2076 vin1.$118.GatPoly vin1.$360.Metal1 15.5987328054
Rred_2077 vin1.$118.GatPoly vin1.$368.Metal1 20.4860406756
Rred_2078 vin1.$118.GatPoly vin1.$586.Metal2 2301.94136839
Rred_2079 vin1.$118.GatPoly vin1.$590.Metal2 12405.3841055
Rred_2080 vin1.$118.GatPoly vin1.P12.GatPoly 12.9518899643
Rred_2081 vin1.$122.GatPoly vin1.$130.GatPoly 60.50563664
Rred_2082 vin1.$122.GatPoly vin1.$368.Metal1 18.2531011901
Rred_2083 vin1.$122.GatPoly vin1.$374.Metal1 15.6601627124
Rred_2084 vin1.$122.GatPoly vin1.$378.Metal1 84.9923100066
Rred_2085 vin1.$122.GatPoly vin1.$590.Metal2 1611.09899248
Rred_2086 vin1.$122.GatPoly vin1.P12.GatPoly 30.8176484848
Rred_2087 vin1.$122.GatPoly vin1.P13.GatPoly 123.431498746
Rred_2088 vin1.$123.GatPoly vin1.$127.GatPoly 36.1143032099
Rred_2089 vin1.$123.GatPoly vin1.$365.Metal1 97.3021776078
Rred_2090 vin1.$123.GatPoly vin1.$369.Metal1 16.2930131079
Rred_2091 vin1.$123.GatPoly vin1.$375.Metal1 15.7999014456
Rred_2092 vin1.$123.GatPoly vin1.$379.Metal1 96.7347407407
Rred_2093 vin1.$123.GatPoly vin1.$591.Metal2 1611.09899248
Rred_2094 vin1.$123.GatPoly vin1.P32.GatPoly 72.5872454666
Rred_2095 vin1.$127.GatPoly vin1.$135.GatPoly 26.7507621399
Rred_2096 vin1.$127.GatPoly vin1.$375.Metal1 68.2833464052
Rred_2097 vin1.$127.GatPoly vin1.$379.Metal1 27.001323271
Rred_2098 vin1.$127.GatPoly vin1.$383.Metal1 20.0005513629
Rred_2099 vin1.$127.GatPoly vin1.$387.Metal1 50.5791721133
Rred_2100 vin1.$127.GatPoly vin1.P33.GatPoly 22.26
Rred_2101 vin1.$130.GatPoly vin1.$134.GatPoly 20.0625185185
Rred_2102 vin1.$130.GatPoly vin1.$374.Metal1 114.401413815
Rred_2103 vin1.$130.GatPoly vin1.$378.Metal1 18.1851091752
Rred_2104 vin1.$130.GatPoly vin1.$386.Metal1 16.8812213797
Rred_2105 vin1.$130.GatPoly vin1.$595.Metal2 8439.59448869
Rred_2106 vin1.$130.GatPoly vin1.$599.Metal2 2525.70222612
Rred_2107 vin1.$130.GatPoly vin1.P13.GatPoly 7.97486881396
Rred_2108 vin1.$134.GatPoly vin1.$136.GatPoly 17.2080405764
Rred_2109 vin1.$134.GatPoly vin1.$386.Metal1 16.9633899809
Rred_2110 vin1.$134.GatPoly vin1.$392.Metal1 17.7474958524
Rred_2111 vin1.$134.GatPoly vin1.$396.Metal1 2936.27252746
Rred_2112 vin1.$134.GatPoly vin1.$604.Metal2 1989.57191416
Rred_2113 vin1.$135.GatPoly vin1.$137.GatPoly 17.2080405764
Rred_2114 vin1.$135.GatPoly vin1.$383.Metal1 171.969185185
Rred_2115 vin1.$135.GatPoly vin1.$387.Metal1 16.3265000824
Rred_2116 vin1.$135.GatPoly vin1.$393.Metal1 17.7474001705
Rred_2117 vin1.$135.GatPoly vin1.$397.Metal1 2936.27252746
Rred_2118 vin1.$135.GatPoly vin1.$603.Metal2 2027.68731673
Rred_2119 vin1.$135.GatPoly vin1.$609.Metal2 111904.93744
Rred_2120 vin1.$136.GatPoly vin1.$144.GatPoly 25.4131134156
Rred_2121 vin1.$136.GatPoly vin1.$392.Metal1 33.0203657934
Rred_2122 vin1.$136.GatPoly vin1.$396.Metal1 18.8410085241
Rred_2123 vin1.$136.GatPoly vin1.$400.Metal1 48.0500043573
Rred_2124 vin1.$136.GatPoly vin1.P14.GatPoly 4.76
Rred_2125 vin1.$137.GatPoly vin1.$145.GatPoly 25.4131134156
Rred_2126 vin1.$137.GatPoly vin1.$393.Metal1 33.0203657934
Rred_2127 vin1.$137.GatPoly vin1.$397.Metal1 18.8410085241
Rred_2128 vin1.$137.GatPoly vin1.$401.Metal1 48.0500043573
Rred_2129 vin1.$137.GatPoly vin1.P34.GatPoly 22.26
Rred_2130 vin1.$144.GatPoly vin1.$152.GatPoly 80.7317467344
Rred_2131 vin1.$144.GatPoly vin1.$396.Metal1 204.212518518
Rred_2132 vin1.$144.GatPoly vin1.$400.Metal1 16.3459334659
Rred_2133 vin1.$144.GatPoly vin1.$408.Metal1 16.4300806005
Rred_2134 vin1.$144.GatPoly vin1.$412.Metal1 152.644058952
Rred_2135 vin1.$144.GatPoly vin1.$610.Metal2 3870.9558658
Rred_2136 vin1.$144.GatPoly vin1.$615.Metal2 3870.9558658
Rred_2137 vin1.$144.GatPoly vin1.P15.GatPoly 38.1468722988
Rred_2138 vin1.$145.GatPoly vin1.$153.GatPoly 50.9131933514
Rred_2139 vin1.$145.GatPoly vin1.$397.Metal1 204.212518518
Rred_2140 vin1.$145.GatPoly vin1.$401.Metal1 16.3459334659
Rred_2141 vin1.$145.GatPoly vin1.$409.Metal1 15.8678203345
Rred_2142 vin1.$145.GatPoly vin1.$413.Metal1 96.2644412107
Rred_2143 vin1.$145.GatPoly vin1.$611.Metal2 3870.9558658
Rred_2144 vin1.$145.GatPoly vin1.$616.Metal2 3870.9558658
Rred_2145 vin1.$145.GatPoly vin1.P35.GatPoly 112.502748125
Rred_2146 vin1.$15.GatPoly vin1.$17.GatPoly 8.64681481481
Rred_2147 vin1.$15.GatPoly vin1.$219.Metal1 12.6296021429
Rred_2148 vin1.$15.GatPoly vin1.$227.Metal1 37.7619085138
Rred_2149 vin1.$15.GatPoly vin1.$27.GatPoly 41.3580961617
Rred_2150 vin1.$15.GatPoly vin1.$493.Metal2 2934.89262124
Rred_2151 vin1.$15.GatPoly vin1.P22.GatPoly 22.26
Rred_2152 vin1.$152.GatPoly vin1.$156.GatPoly 40.1272493827
Rred_2153 vin1.$152.GatPoly vin1.$408.Metal1 152.644058952
Rred_2154 vin1.$152.GatPoly vin1.$412.Metal1 18.6069469566
Rred_2155 vin1.$152.GatPoly vin1.$418.Metal1 15.6802121879
Rred_2156 vin1.$152.GatPoly vin1.$422.Metal1 85.9869629629
Rred_2157 vin1.$152.GatPoly vin1.$619.Metal2 1563.02782058
Rred_2158 vin1.$152.GatPoly vin1.P15.GatPoly 21.4418885263
Rred_2159 vin1.$153.GatPoly vin1.$157.GatPoly 40.1272493827
Rred_2160 vin1.$153.GatPoly vin1.$409.Metal1 96.2644412107
Rred_2161 vin1.$153.GatPoly vin1.$413.Metal1 16.5099701104
Rred_2162 vin1.$153.GatPoly vin1.$419.Metal1 15.6802121879
Rred_2163 vin1.$153.GatPoly vin1.$423.Metal1 85.9869629629
Rred_2164 vin1.$153.GatPoly vin1.$620.Metal2 1563.02782058
Rred_2165 vin1.$153.GatPoly vin1.P35.GatPoly 63.2364133369
Rred_2166 vin1.$156.GatPoly vin1.$164.GatPoly 22.7378159671
Rred_2167 vin1.$156.GatPoly vin1.$418.Metal1 75.8708496732
Rred_2168 vin1.$156.GatPoly vin1.$422.Metal1 30.0016540887
Rred_2169 vin1.$156.GatPoly vin1.$426.Metal1 17.0002205452
Rred_2170 vin1.$156.GatPoly vin1.$430.Metal1 42.9916688453
Rred_2171 vin1.$156.GatPoly vin1.P16.GatPoly 4.76
Rred_2172 vin1.$157.GatPoly vin1.$163.GatPoly 9.36029629629
Rred_2173 vin1.$157.GatPoly vin1.$419.Metal1 75.8708496732
Rred_2174 vin1.$157.GatPoly vin1.$423.Metal1 30.0016540887
Rred_2175 vin1.$157.GatPoly vin1.$427.Metal1 17.6980392157
Rred_2176 vin1.$157.GatPoly vin1.P36.GatPoly 22.26
Rred_2177 vin1.$16.GatPoly vin1.$210.Metal1 16.8857192322
Rred_2178 vin1.$16.GatPoly vin1.$218.Metal1 19.3496497775
Rred_2179 vin1.$16.GatPoly vin1.$22.GatPoly 77.9511897103
Rred_2180 vin1.$16.GatPoly vin1.$222.Metal1 147.386703234
Rred_2181 vin1.$16.GatPoly vin1.$488.Metal2 2301.94136839
Rred_2182 vin1.$16.GatPoly vin1.$492.Metal2 12405.3841055
Rred_2183 vin1.$16.GatPoly vin1.P2.GatPoly 19.176544151
Rred_2184 vin1.$163.GatPoly vin1.$167.GatPoly 41.3580961617
Rred_2185 vin1.$163.GatPoly vin1.$427.Metal1 27.2939474766
Rred_2186 vin1.$163.GatPoly vin1.$433.Metal1 14.2581745852
Rred_2187 vin1.$163.GatPoly vin1.$441.Metal1 115.651204718
Rred_2188 vin1.$163.GatPoly vin1.$629.Metal2 2664.67413314
Rred_2189 vin1.$163.GatPoly vin1.$636.Metal2 6114.14760608
Rred_2190 vin1.$164.GatPoly vin1.$172.GatPoly 77.9511897103
Rred_2191 vin1.$164.GatPoly vin1.$426.Metal1 365.429185185
Rred_2192 vin1.$164.GatPoly vin1.$430.Metal1 16.5931436324
Rred_2193 vin1.$164.GatPoly vin1.$437.Metal1 16.2158441731
Rred_2194 vin1.$164.GatPoly vin1.$440.Metal1 147.386703234
Rred_2195 vin1.$164.GatPoly vin1.$630.Metal2 1836.80456241
Rred_2196 vin1.$164.GatPoly vin1.P17.GatPoly 42.9114848609
Rred_2197 vin1.$167.GatPoly vin1.$173.GatPoly 8.64681481481
Rred_2198 vin1.$167.GatPoly vin1.$433.Metal1 37.7619085138
Rred_2199 vin1.$167.GatPoly vin1.$441.Metal1 12.6296021429
Rred_2200 vin1.$167.GatPoly vin1.$636.Metal2 2934.89262124
Rred_2201 vin1.$167.GatPoly vin1.P37.GatPoly 22.26
Rred_2202 vin1.$17.GatPoly vin1.$207.Metal1 80.9291851852
Rred_2203 vin1.$17.GatPoly vin1.$211.Metal1 15.5987328054
Rred_2204 vin1.$17.GatPoly vin1.$219.Metal1 27.3987871831
Rred_2205 vin1.$17.GatPoly vin1.$489.Metal2 2301.94136839
Rred_2206 vin1.$17.GatPoly vin1.$493.Metal2 12405.3841055
Rred_2207 vin1.$17.GatPoly vin1.$9.GatPoly 42.8025468312
Rred_2208 vin1.$172.GatPoly vin1.$176.GatPoly 20.0625185185
Rred_2209 vin1.$172.GatPoly vin1.$437.Metal1 147.386703234
Rred_2210 vin1.$172.GatPoly vin1.$440.Metal1 19.3496497775
Rred_2211 vin1.$172.GatPoly vin1.$448.Metal1 16.8857192322
Rred_2212 vin1.$172.GatPoly vin1.$635.Metal2 12405.3841055
Rred_2213 vin1.$172.GatPoly vin1.$639.Metal2 2301.94136839
Rred_2214 vin1.$172.GatPoly vin1.P17.GatPoly 19.176544151
Rred_2215 vin1.$173.GatPoly vin1.$179.GatPoly 42.8025468312
Rred_2216 vin1.$173.GatPoly vin1.$441.Metal1 27.3987871831
Rred_2217 vin1.$173.GatPoly vin1.$449.Metal1 15.5987328054
Rred_2218 vin1.$173.GatPoly vin1.$453.Metal1 80.9291851852
Rred_2219 vin1.$173.GatPoly vin1.$636.Metal2 12405.3841055
Rred_2220 vin1.$173.GatPoly vin1.$640.Metal2 2301.94136839
Rred_2221 vin1.$176.GatPoly vin1.$180.GatPoly 33.2847407407
Rred_2222 vin1.$176.GatPoly vin1.$448.Metal1 16.8901542286
Rred_2223 vin1.$176.GatPoly vin1.$456.Metal1 20.489591646
Rred_2224 vin1.$176.GatPoly vin1.$644.Metal2 2115.07400678
Rred_2225 vin1.$176.GatPoly vin1.$648.Metal2 23421.3890021
Rred_2226 vin1.$176.GatPoly vin1.P18.GatPoly 19.9708444444
Rred_2227 vin1.$179.GatPoly vin1.$449.Metal1 80.9291851852
Rred_2228 vin1.$179.GatPoly vin1.$453.Metal1 32.0018746339
Rred_2229 vin1.$179.GatPoly vin1.$457.Metal1 8.16033769425
Rred_2230 vin1.$179.GatPoly vin1.$649.Metal2 877.519802179
Rred_2231 vin1.$179.GatPoly vin1.$654.Metal2 295.150090209
Rred_2232 vin1.$179.GatPoly vin1.P38.GatPoly 22.26
Rred_2233 vin1.$179.GatPoly vin1.P39.GatPoly 365.628758224
Rred_2234 vin1.$180.GatPoly vin1.$456.Metal1 8.0987663346
Rred_2235 vin1.$180.GatPoly vin1.$648.Metal2 456.549538848
Rred_2236 vin1.$180.GatPoly vin1.$653.Metal2 158.542646647
Rred_2237 vin1.$180.GatPoly vin1.P18.GatPoly 19.9708444444
Rred_2238 vin1.$180.GatPoly vin1.P19.GatPoly 86.7094752085
Rred_2239 vin1.$202.Metal1 vin1.$210.Metal1 0.362310386809
Rred_2240 vin1.$202.Metal1 vin1.$477.Metal2 15.7883328011
Rred_2241 vin1.$202.Metal1 vin1.$479.Metal2 3.68923170446
Rred_2242 vin1.$202.Metal1 vin1.$483.Metal2 11.4454036843
Rred_2243 vin1.$202.Metal1 vin1.$6.GatPoly 8.08946310818
Rred_2244 vin1.$202.Metal1 vin1.P0.GatPoly 21.8775056486
Rred_2245 vin1.$202.Metal1 vin1.P1.GatPoly 37.76
Rred_2246 vin1.$203.Metal1 vin1.$207.Metal1 0.178496116933
Rred_2247 vin1.$203.Metal1 vin1.$477.Metal2 15.3809322347
Rred_2248 vin1.$203.Metal1 vin1.$480.Metal2 3.67675955388
Rred_2249 vin1.$203.Metal1 vin1.$484.Metal2 20.9909233253
Rred_2250 vin1.$203.Metal1 vin1.$9.GatPoly 8.15512705888
Rred_2251 vin1.$203.Metal1 vin1.P20.GatPoly 41.4017255522
Rred_2252 vin1.$207.Metal1 vin1.$211.Metal1 0.178675191093
Rred_2253 vin1.$207.Metal1 vin1.$480.Metal2 137.607164021
Rred_2254 vin1.$207.Metal1 vin1.$484.Metal2 12.426647102
Rred_2255 vin1.$207.Metal1 vin1.$9.GatPoly 32.0018746339
Rred_2256 vin1.$210.Metal1 vin1.$218.Metal1 0.362653569415
Rred_2257 vin1.$210.Metal1 vin1.$479.Metal2 279.314226443
Rred_2258 vin1.$210.Metal1 vin1.$483.Metal2 12.9766510302
Rred_2259 vin1.$210.Metal1 vin1.$488.Metal2 11.5186194376
Rred_2260 vin1.$210.Metal1 vin1.$492.Metal2 148.012303013
Rred_2261 vin1.$211.Metal1 vin1.$219.Metal1 0.362653569415
Rred_2262 vin1.$211.Metal1 vin1.$484.Metal2 26.726552795
Rred_2263 vin1.$211.Metal1 vin1.$489.Metal2 11.5186194376
Rred_2264 vin1.$211.Metal1 vin1.$493.Metal2 148.012303013
Rred_2265 vin1.$211.Metal1 vin1.$9.GatPoly 80.9291851852
Rred_2266 vin1.$218.Metal1 vin1.$22.GatPoly 147.386703234
Rred_2267 vin1.$218.Metal1 vin1.$222.Metal1 0.178129923539
Rred_2268 vin1.$218.Metal1 vin1.$488.Metal2 12.8905653645
Rred_2269 vin1.$218.Metal1 vin1.$492.Metal2 18.9451496641
Rred_2270 vin1.$218.Metal1 vin1.P2.GatPoly 36.2581717142
Rred_2271 vin1.$219.Metal1 vin1.$227.Metal1 0.39094415179
Rred_2272 vin1.$219.Metal1 vin1.$27.GatPoly 115.651204718
Rred_2273 vin1.$219.Metal1 vin1.$489.Metal2 12.8905653645
Rred_2274 vin1.$219.Metal1 vin1.$493.Metal2 9.17818171348
Rred_2275 vin1.$22.GatPoly vin1.$222.Metal1 16.2158441731
Rred_2276 vin1.$22.GatPoly vin1.$228.Metal1 16.5931436324
Rred_2277 vin1.$22.GatPoly vin1.$232.Metal1 365.429185185
Rred_2278 vin1.$22.GatPoly vin1.$24.GatPoly 22.7378159671
Rred_2279 vin1.$22.GatPoly vin1.$497.Metal2 1836.80456241
Rred_2280 vin1.$22.GatPoly vin1.P2.GatPoly 42.9114848609
Rred_2281 vin1.$222.Metal1 vin1.$228.Metal1 0.36174266925
Rred_2282 vin1.$222.Metal1 vin1.$492.Metal2 9.42324175824
Rred_2283 vin1.$222.Metal1 vin1.$497.Metal2 21.8084097251
Rred_2284 vin1.$222.Metal1 vin1.P2.GatPoly 81.1351604514
Rred_2285 vin1.$227.Metal1 vin1.$233.Metal1 0.331848942782
Rred_2286 vin1.$227.Metal1 vin1.$27.GatPoly 14.2581745852
Rred_2287 vin1.$227.Metal1 vin1.$493.Metal2 11.1591689028
Rred_2288 vin1.$227.Metal1 vin1.$495.Metal2 38.1149573586
Rred_2289 vin1.$227.Metal1 vin1.$500.Metal2 12.4168010073
Rred_2290 vin1.$228.Metal1 vin1.$232.Metal1 0.178852088262
Rred_2291 vin1.$228.Metal1 vin1.$236.Metal1 4036.92165822
Rred_2292 vin1.$228.Metal1 vin1.$24.GatPoly 42.9916688453
Rred_2293 vin1.$228.Metal1 vin1.$497.Metal2 9.12759240183
Rred_2294 vin1.$228.Metal1 vin1.$503.Metal2 43.9859302507
Rred_2295 vin1.$232.Metal1 vin1.$236.Metal1 0.17894182666
Rred_2296 vin1.$232.Metal1 vin1.$24.GatPoly 17.0002205452
Rred_2297 vin1.$232.Metal1 vin1.$497.Metal2 23.8007022261
Rred_2298 vin1.$232.Metal1 vin1.$503.Metal2 22.6413748687
Rred_2299 vin1.$233.Metal1 vin1.$237.Metal1 0.178949087371
Rred_2300 vin1.$233.Metal1 vin1.$25.GatPoly 17.6980392157
Rred_2301 vin1.$233.Metal1 vin1.$27.GatPoly 27.2939474766
Rred_2302 vin1.$233.Metal1 vin1.$500.Metal2 10.4731205828
Rred_2303 vin1.$233.Metal1 vin1.$504.Metal2 42.814045977
Rred_2304 vin1.$236.Metal1 vin1.$24.GatPoly 30.0016540887
Rred_2305 vin1.$236.Metal1 vin1.$240.Metal1 0.178504947966
Rred_2306 vin1.$236.Metal1 vin1.$36.GatPoly 85.9869629629
Rred_2307 vin1.$236.Metal1 vin1.$497.Metal2 48.5088769371
Rred_2308 vin1.$236.Metal1 vin1.$503.Metal2 15.140503946
Rred_2309 vin1.$237.Metal1 vin1.$241.Metal1 0.178504947966
Rred_2310 vin1.$237.Metal1 vin1.$25.GatPoly 30.0016540887
Rred_2311 vin1.$237.Metal1 vin1.$37.GatPoly 85.9869629629
Rred_2312 vin1.$237.Metal1 vin1.$500.Metal2 31.8360854701
Rred_2313 vin1.$237.Metal1 vin1.$504.Metal2 17.9090803107
Rred_2314 vin1.$24.GatPoly vin1.$240.Metal1 75.8708496732
Rred_2315 vin1.$24.GatPoly vin1.$36.GatPoly 40.1272493827
Rred_2316 vin1.$24.GatPoly vin1.P3.GatPoly 4.76
Rred_2317 vin1.$240.Metal1 vin1.$246.Metal1 0.36182906056
Rred_2318 vin1.$240.Metal1 vin1.$36.GatPoly 15.6802121879
Rred_2319 vin1.$240.Metal1 vin1.$503.Metal2 11.5864555256
Rred_2320 vin1.$240.Metal1 vin1.$508.Metal2 18.0168451015
Rred_2321 vin1.$241.Metal1 vin1.$247.Metal1 0.36182906056
Rred_2322 vin1.$241.Metal1 vin1.$25.GatPoly 75.8708496732
Rred_2323 vin1.$241.Metal1 vin1.$37.GatPoly 15.6802121879
Rred_2324 vin1.$241.Metal1 vin1.$504.Metal2 11.5864555256
Rred_2325 vin1.$241.Metal1 vin1.$509.Metal2 18.0168451015
Rred_2326 vin1.$246.Metal1 vin1.$250.Metal1 0.17852453123
Rred_2327 vin1.$246.Metal1 vin1.$36.GatPoly 18.6069469566
Rred_2328 vin1.$246.Metal1 vin1.$42.GatPoly 152.644058952
Rred_2329 vin1.$246.Metal1 vin1.$508.Metal2 10.1769943283
Rred_2330 vin1.$246.Metal1 vin1.$512.Metal2 22.5350597402
Rred_2331 vin1.$246.Metal1 vin1.P4.GatPoly 40.541385869
Rred_2332 vin1.$247.Metal1 vin1.$251.Metal1 0.178459879632
Rred_2333 vin1.$247.Metal1 vin1.$37.GatPoly 16.5099701104
Rred_2334 vin1.$247.Metal1 vin1.$43.GatPoly 96.2644412107
Rred_2335 vin1.$247.Metal1 vin1.$509.Metal2 10.1769943283
Rred_2336 vin1.$247.Metal1 vin1.$513.Metal2 22.5350597402
Rred_2337 vin1.$247.Metal1 vin1.P24.GatPoly 119.564647066
Rred_2338 vin1.$25.GatPoly vin1.$27.GatPoly 9.36029629629
Rred_2339 vin1.$25.GatPoly vin1.$37.GatPoly 40.1272493827
Rred_2340 vin1.$25.GatPoly vin1.P23.GatPoly 22.26
Rred_2341 vin1.$250.Metal1 vin1.$258.Metal1 0.362824398622
Rred_2342 vin1.$250.Metal1 vin1.$36.GatPoly 152.644058952
Rred_2343 vin1.$250.Metal1 vin1.$42.GatPoly 16.4300806005
Rred_2344 vin1.$250.Metal1 vin1.$508.Metal2 95.3406373629
Rred_2345 vin1.$250.Metal1 vin1.$512.Metal2 10.1192256903
Rred_2346 vin1.$250.Metal1 vin1.$517.Metal2 46.1776507338
Rred_2347 vin1.$250.Metal1 vin1.P4.GatPoly 72.1264392205
Rred_2348 vin1.$251.Metal1 vin1.$259.Metal1 0.362824398622
Rred_2349 vin1.$251.Metal1 vin1.$37.GatPoly 96.2644412107
Rred_2350 vin1.$251.Metal1 vin1.$43.GatPoly 15.8678203345
Rred_2351 vin1.$251.Metal1 vin1.$509.Metal2 95.3406373629
Rred_2352 vin1.$251.Metal1 vin1.$513.Metal2 10.1192256903
Rred_2353 vin1.$251.Metal1 vin1.$518.Metal2 46.1776507338
Rred_2354 vin1.$251.Metal1 vin1.P24.GatPoly 212.715280069
Rred_2355 vin1.$258.Metal1 vin1.$262.Metal1 0.178550748274
Rred_2356 vin1.$258.Metal1 vin1.$264.Metal1 7610.30667437
Rred_2357 vin1.$258.Metal1 vin1.$42.GatPoly 16.3459334659
Rred_2358 vin1.$258.Metal1 vin1.$44.GatPoly 48.0500043573
Rred_2359 vin1.$258.Metal1 vin1.$512.Metal2 46.1776507338
Rred_2360 vin1.$258.Metal1 vin1.$517.Metal2 9.7817715397
Rred_2361 vin1.$258.Metal1 vin1.$523.Metal2 145.280351752
Rred_2362 vin1.$259.Metal1 vin1.$263.Metal1 0.178557568839
Rred_2363 vin1.$259.Metal1 vin1.$43.GatPoly 16.3459334659
Rred_2364 vin1.$259.Metal1 vin1.$47.GatPoly 48.0500043573
Rred_2365 vin1.$259.Metal1 vin1.$513.Metal2 46.1776507338
Rred_2366 vin1.$259.Metal1 vin1.$518.Metal2 11.3207867366
Rred_2367 vin1.$259.Metal1 vin1.$520.Metal2 47.2209706961
Rred_2368 vin1.$262.Metal1 vin1.$264.Metal1 0.180721425263
Rred_2369 vin1.$262.Metal1 vin1.$42.GatPoly 204.212518518
Rred_2370 vin1.$262.Metal1 vin1.$44.GatPoly 18.8410085241
Rred_2371 vin1.$262.Metal1 vin1.$517.Metal2 17.0071631934
Rred_2372 vin1.$262.Metal1 vin1.$52.GatPoly 2936.27252746
Rred_2373 vin1.$262.Metal1 vin1.$523.Metal2 34.3389922323
Rred_2374 vin1.$263.Metal1 vin1.$265.Metal1 0.180739583769
Rred_2375 vin1.$263.Metal1 vin1.$43.GatPoly 204.212518518
Rred_2376 vin1.$263.Metal1 vin1.$47.GatPoly 18.8410085241
Rred_2377 vin1.$263.Metal1 vin1.$520.Metal2 11.1613203463
Rred_2378 vin1.$263.Metal1 vin1.$53.GatPoly 2936.27252746
Rred_2379 vin1.$264.Metal1 vin1.$272.Metal1 0.358974281487
Rred_2380 vin1.$264.Metal1 vin1.$44.GatPoly 33.0203657934
Rred_2381 vin1.$264.Metal1 vin1.$517.Metal2 27.6894597146
Rred_2382 vin1.$264.Metal1 vin1.$52.GatPoly 17.7474958524
Rred_2383 vin1.$264.Metal1 vin1.$523.Metal2 8.62947986197
Rred_2384 vin1.$265.Metal1 vin1.$273.Metal1 0.358969093271
Rred_2385 vin1.$265.Metal1 vin1.$47.GatPoly 33.0203657934
Rred_2386 vin1.$265.Metal1 vin1.$520.Metal2 17.6141428574
Rred_2387 vin1.$265.Metal1 vin1.$527.Metal2 10.4000814367
Rred_2388 vin1.$265.Metal1 vin1.$53.GatPoly 17.7474001705
Rred_2389 vin1.$27.GatPoly vin1.$493.Metal2 6114.14760608
Rred_2390 vin1.$27.GatPoly vin1.$500.Metal2 2664.67413314
Rred_2391 vin1.$272.Metal1 vin1.$280.Metal1 0.362797942164
Rred_2392 vin1.$272.Metal1 vin1.$52.GatPoly 16.9633899809
Rred_2393 vin1.$272.Metal1 vin1.$523.Metal2 15.0113662187
Rred_2394 vin1.$272.Metal1 vin1.$528.Metal2 10.3514401745
Rred_2395 vin1.$272.Metal1 vin1.$532.Metal2 100.688434264
Rred_2396 vin1.$272.Metal1 vin1.$58.GatPoly 16.8812213797
Rred_2397 vin1.$273.Metal1 vin1.$277.Metal1 0.178843777497
Rred_2398 vin1.$273.Metal1 vin1.$281.Metal1 4137.53229591
Rred_2399 vin1.$273.Metal1 vin1.$520.Metal2 844.325347394
Rred_2400 vin1.$273.Metal1 vin1.$527.Metal2 9.30100123455
Rred_2401 vin1.$273.Metal1 vin1.$53.GatPoly 16.3265000824
Rred_2402 vin1.$273.Metal1 vin1.$533.Metal2 49.717844922
Rred_2403 vin1.$273.Metal1 vin1.$57.GatPoly 50.5791721133
Rred_2404 vin1.$277.Metal1 vin1.$281.Metal1 0.178898601437
Rred_2405 vin1.$277.Metal1 vin1.$527.Metal2 22.3566696457
Rred_2406 vin1.$277.Metal1 vin1.$53.GatPoly 171.969185185
Rred_2407 vin1.$277.Metal1 vin1.$533.Metal2 24.1058961615
Rred_2408 vin1.$277.Metal1 vin1.$57.GatPoly 20.0005513629
Rred_2409 vin1.$280.Metal1 vin1.$284.Metal1 0.178374896227
Rred_2410 vin1.$280.Metal1 vin1.$528.Metal2 14.7413390447
Rred_2411 vin1.$280.Metal1 vin1.$532.Metal2 15.9997708552
Rred_2412 vin1.$280.Metal1 vin1.$58.GatPoly 18.1851091752
Rred_2413 vin1.$280.Metal1 vin1.$64.GatPoly 84.9923100066
Rred_2414 vin1.$280.Metal1 vin1.P6.GatPoly 92.2851475241
Rred_2415 vin1.$281.Metal1 vin1.$285.Metal1 0.178398933563
Rred_2416 vin1.$281.Metal1 vin1.$527.Metal2 43.4328267333
Rred_2417 vin1.$281.Metal1 vin1.$533.Metal2 15.7349129944
Rred_2418 vin1.$281.Metal1 vin1.$57.GatPoly 27.001323271
Rred_2419 vin1.$281.Metal1 vin1.$65.GatPoly 96.7347407407
Rred_2420 vin1.$284.Metal1 vin1.$290.Metal1 0.361824121591
Rred_2421 vin1.$284.Metal1 vin1.$532.Metal2 10.7656516291
Rred_2422 vin1.$284.Metal1 vin1.$537.Metal2 19.1286039107
Rred_2423 vin1.$284.Metal1 vin1.$58.GatPoly 114.401413815
Rred_2424 vin1.$284.Metal1 vin1.$64.GatPoly 15.6601627124
Rred_2425 vin1.$284.Metal1 vin1.P6.GatPoly 233.378884183
Rred_2426 vin1.$285.Metal1 vin1.$291.Metal1 0.361824121591
Rred_2427 vin1.$285.Metal1 vin1.$533.Metal2 10.7656516291
Rred_2428 vin1.$285.Metal1 vin1.$538.Metal2 19.1286039107
Rred_2429 vin1.$285.Metal1 vin1.$57.GatPoly 68.2833464052
Rred_2430 vin1.$285.Metal1 vin1.$65.GatPoly 15.7999014456
Rred_2431 vin1.$290.Metal1 vin1.$298.Metal1 0.362653569415
Rred_2432 vin1.$290.Metal1 vin1.$537.Metal2 9.52216809103
Rred_2433 vin1.$290.Metal1 vin1.$541.Metal2 12.8905653645
Rred_2434 vin1.$290.Metal1 vin1.$64.GatPoly 18.2531011901
Rred_2435 vin1.$290.Metal1 vin1.$70.GatPoly 20.4860406756
Rred_2436 vin1.$290.Metal1 vin1.P7.GatPoly 58.2686631016
Rred_2437 vin1.$291.Metal1 vin1.$295.Metal1 0.17857627571
Rred_2438 vin1.$291.Metal1 vin1.$538.Metal2 10.1777438502
Rred_2439 vin1.$291.Metal1 vin1.$542.Metal2 24.3181269841
Rred_2440 vin1.$291.Metal1 vin1.$65.GatPoly 16.2930131079
Rred_2441 vin1.$291.Metal1 vin1.$73.GatPoly 97.3021776078
Rred_2442 vin1.$291.Metal1 vin1.P27.GatPoly 137.244791849
Rred_2443 vin1.$295.Metal1 vin1.$303.Metal1 0.362799427562
Rred_2444 vin1.$295.Metal1 vin1.$538.Metal2 72.9543809522
Rred_2445 vin1.$295.Metal1 vin1.$542.Metal2 10.1293546422
Rred_2446 vin1.$295.Metal1 vin1.$547.Metal2 54.2048156595
Rred_2447 vin1.$295.Metal1 vin1.$65.GatPoly 97.3021776078
Rred_2448 vin1.$295.Metal1 vin1.$73.GatPoly 15.9974348707
Rred_2449 vin1.$295.Metal1 vin1.P27.GatPoly 177.329872844
Rred_2450 vin1.$298.Metal1 vin1.$302.Metal1 0.178668868145
Rred_2451 vin1.$298.Metal1 vin1.$537.Metal2 148.012303013
Rred_2452 vin1.$298.Metal1 vin1.$541.Metal2 9.91391002973
Rred_2453 vin1.$298.Metal1 vin1.$544.Metal2 136.676492583
Rred_2454 vin1.$298.Metal1 vin1.$548.Metal2 63.5012825511
Rred_2455 vin1.$298.Metal1 vin1.$70.GatPoly 15.5987328054
Rred_2456 vin1.$298.Metal1 vin1.$78.GatPoly 80.9291851852
Rred_2457 vin1.$302.Metal1 vin1.$310.Metal1 0.375564027363
Rred_2458 vin1.$302.Metal1 vin1.$541.Metal2 36.3717608362
Rred_2459 vin1.$302.Metal1 vin1.$544.Metal2 69.856873987
Rred_2460 vin1.$302.Metal1 vin1.$548.Metal2 10.5831998195
Rred_2461 vin1.$302.Metal1 vin1.$70.GatPoly 80.9291851852
Rred_2462 vin1.$302.Metal1 vin1.$78.GatPoly 15.334097558
Rred_2463 vin1.$302.Metal1 vin1.$80.GatPoly 430.191522254
Rred_2464 vin1.$303.Metal1 vin1.$307.Metal1 0.178371493384
Rred_2465 vin1.$303.Metal1 vin1.$542.Metal2 40.2164761345
Rred_2466 vin1.$303.Metal1 vin1.$547.Metal2 10.1082003498
Rred_2467 vin1.$303.Metal1 vin1.$551.Metal2 137.607164021
Rred_2468 vin1.$303.Metal1 vin1.$73.GatPoly 16.0835537092
Rred_2469 vin1.$303.Metal1 vin1.$77.GatPoly 55.6375076253
Rred_2470 vin1.$307.Metal1 vin1.$313.Metal1 0.36146618849
Rred_2471 vin1.$307.Metal1 vin1.$547.Metal2 20.9909233253
Rred_2472 vin1.$307.Metal1 vin1.$551.Metal2 10.1668380754
Rred_2473 vin1.$307.Metal1 vin1.$73.GatPoly 135.119661376
Rred_2474 vin1.$307.Metal1 vin1.$77.GatPoly 15.9311738026
Rred_2475 vin1.$307.Metal1 vin1.$83.GatPoly 98.1690707437
Rred_2476 vin1.$310.Metal1 vin1.$312.Metal1 0.165
Rred_2477 vin1.$310.Metal1 vin1.$548.Metal2 9.92591643291
Rred_2478 vin1.$310.Metal1 vin1.$552.Metal2 18.1718095238
Rred_2479 vin1.$310.Metal1 vin1.$78.GatPoly 31.5600123225
Rred_2480 vin1.$310.Metal1 vin1.$80.GatPoly 15.5718406742
Rred_2481 vin1.$312.Metal1 vin1.$320.Metal1 0.362724514501
Rred_2482 vin1.$312.Metal1 vin1.$552.Metal2 10.5257138212
Rred_2483 vin1.$312.Metal1 vin1.$557.Metal2 35.6129523328
Rred_2484 vin1.$312.Metal1 vin1.$80.GatPoly 37.9333333333
Rred_2485 vin1.$312.Metal1 vin1.$84.GatPoly 16.8757273465
Rred_2486 vin1.$313.Metal1 vin1.$317.Metal1 0.178799366164
Rred_2487 vin1.$313.Metal1 vin1.$551.Metal2 11.008714331
Rred_2488 vin1.$313.Metal1 vin1.$555.Metal2 57.4004804448
Rred_2489 vin1.$313.Metal1 vin1.$558.Metal2 33.6812736494
Rred_2490 vin1.$313.Metal1 vin1.$77.GatPoly 57.8243567653
Rred_2491 vin1.$313.Metal1 vin1.$83.GatPoly 13.0141464528
Rred_2492 vin1.$317.Metal1 vin1.$321.Metal1 0.178838571508
Rred_2493 vin1.$317.Metal1 vin1.$551.Metal2 80.5238780093
Rred_2494 vin1.$317.Metal1 vin1.$555.Metal2 148.032817989
Rred_2495 vin1.$317.Metal1 vin1.$558.Metal2 14.6154515868
Rred_2496 vin1.$317.Metal1 vin1.$83.GatPoly 33.8281181896
Rred_2497 vin1.$317.Metal1 vin1.$87.GatPoly 58.1666753812
Rred_2498 vin1.$320.Metal1 vin1.$328.Metal1 0.362169844265
Rred_2499 vin1.$320.Metal1 vin1.$552.Metal2 65.6028069289
Rred_2500 vin1.$320.Metal1 vin1.$557.Metal2 8.52565576862
Rred_2501 vin1.$320.Metal1 vin1.$561.Metal2 24.2669420704
Rred_2502 vin1.$320.Metal1 vin1.$84.GatPoly 17.7993670334
Rred_2503 vin1.$320.Metal1 vin1.$90.GatPoly 20.2758380631
Rred_2504 vin1.$320.Metal1 vin1.P9.GatPoly 68.7832679738
Rred_2505 vin1.$321.Metal1 vin1.$325.Metal1 0.178840374465
Rred_2506 vin1.$321.Metal1 vin1.$558.Metal2 14.1682801538
Rred_2507 vin1.$321.Metal1 vin1.$562.Metal2 59.0882403627
Rred_2508 vin1.$321.Metal1 vin1.$83.GatPoly 123.604185185
Rred_2509 vin1.$321.Metal1 vin1.$87.GatPoly 23.0008821806
Rred_2510 vin1.$325.Metal1 vin1.$331.Metal1 0.361795734713
Rred_2511 vin1.$325.Metal1 vin1.$558.Metal2 26.4011286728
Rred_2512 vin1.$325.Metal1 vin1.$562.Metal2 10.1761275149
Rred_2513 vin1.$325.Metal1 vin1.$87.GatPoly 27.1411764706
Rred_2514 vin1.$325.Metal1 vin1.$93.GatPoly 19.1121432091
Rred_2515 vin1.$328.Metal1 vin1.$334.Metal1 0.361795734713
Rred_2516 vin1.$328.Metal1 vin1.$557.Metal2 53.4649554857
Rred_2517 vin1.$328.Metal1 vin1.$561.Metal2 8.0753915984
Rred_2518 vin1.$328.Metal1 vin1.$566.Metal2 20.3813394518
Rred_2519 vin1.$328.Metal1 vin1.$90.GatPoly 16.8684682797
Rred_2520 vin1.$328.Metal1 vin1.$94.GatPoly 16.8807966702
Rred_2521 vin1.$331.Metal1 vin1.$335.Metal1 0.178273944544
Rred_2522 vin1.$331.Metal1 vin1.$562.Metal2 20.3813394518
Rred_2523 vin1.$331.Metal1 vin1.$567.Metal2 10.0511202186
Rred_2524 vin1.$331.Metal1 vin1.$93.GatPoly 15.9520155185
Rred_2525 vin1.$331.Metal1 vin1.$97.GatPoly 60.6958431373
Rred_2526 vin1.$334.Metal1 vin1.$338.Metal1 0.178733854286
Rred_2527 vin1.$334.Metal1 vin1.$566.Metal2 10.1761275149
Rred_2528 vin1.$334.Metal1 vin1.$570.Metal2 26.4011286728
Rred_2529 vin1.$334.Metal1 vin1.$94.GatPoly 17.1496072721
Rred_2530 vin1.$334.Metal1 vin1.P10.GatPoly 55.3808723806
Rred_2531 vin1.$335.Metal1 vin1.$339.Metal1 0.178840374465
Rred_2532 vin1.$335.Metal1 vin1.$567.Metal2 20.2863564567
Rred_2533 vin1.$335.Metal1 vin1.$571.Metal2 26.4011286728
Rred_2534 vin1.$335.Metal1 vin1.$93.GatPoly 114.647703704
Rred_2535 vin1.$335.Metal1 vin1.$97.GatPoly 24.0009924532
Rred_2536 vin1.$338.Metal1 vin1.$346.Metal1 0.362724514501
Rred_2537 vin1.$338.Metal1 vin1.$566.Metal2 59.0882403627
Rred_2538 vin1.$338.Metal1 vin1.$570.Metal2 10.1385860384
Rred_2539 vin1.$338.Metal1 vin1.$575.Metal2 65.6028069289
Rred_2540 vin1.$338.Metal1 vin1.$94.GatPoly 158.710238626
Rred_2541 vin1.$338.Metal1 vin1.P10.GatPoly 52.6282325743
Rred_2542 vin1.$339.Metal1 vin1.$343.Metal1 0.178838571508
Rred_2543 vin1.$339.Metal1 vin1.$567.Metal2 59.0882403627
Rred_2544 vin1.$339.Metal1 vin1.$571.Metal2 14.1682801538
Rred_2545 vin1.$339.Metal1 vin1.$97.GatPoly 23.0008821806
Rred_2546 vin1.$343.Metal1 vin1.$347.Metal1 0.178799366164
Rred_2547 vin1.$343.Metal1 vin1.$571.Metal2 14.6154515868
Rred_2548 vin1.$343.Metal1 vin1.$573.Metal2 148.032817989
Rred_2549 vin1.$343.Metal1 vin1.$578.Metal2 80.5238780093
Rred_2550 vin1.$343.Metal1 vin1.$97.GatPoly 58.1666753812
Rred_2551 vin1.$346.Metal1 vin1.$348.Metal1 0.165
Rred_2552 vin1.$346.Metal1 vin1.$570.Metal2 35.6129523328
Rred_2553 vin1.$346.Metal1 vin1.$575.Metal2 10.5257138212
Rred_2554 vin1.$347.Metal1 vin1.$353.Metal1 0.36146618849
Rred_2555 vin1.$347.Metal1 vin1.$571.Metal2 33.6812736494
Rred_2556 vin1.$347.Metal1 vin1.$573.Metal2 57.4004804448
Rred_2557 vin1.$347.Metal1 vin1.$578.Metal2 11.008714331
Rred_2558 vin1.$348.Metal1 vin1.$356.Metal1 0.375564027363
Rred_2559 vin1.$348.Metal1 vin1.$575.Metal2 18.1718095238
Rred_2560 vin1.$348.Metal1 vin1.$579.Metal2 9.92591643291
Rred_2561 vin1.$353.Metal1 vin1.$357.Metal1 0.178371493384
Rred_2562 vin1.$353.Metal1 vin1.$578.Metal2 10.1668380754
Rred_2563 vin1.$353.Metal1 vin1.$582.Metal2 20.9909233253
Rred_2564 vin1.$356.Metal1 vin1.$360.Metal1 0.178668868145
Rred_2565 vin1.$356.Metal1 vin1.$579.Metal2 10.5831998195
Rred_2566 vin1.$356.Metal1 vin1.$584.Metal2 69.856873987
Rred_2567 vin1.$356.Metal1 vin1.$586.Metal2 36.3717608362
Rred_2568 vin1.$357.Metal1 vin1.$365.Metal1 0.362799427562
Rred_2569 vin1.$357.Metal1 vin1.$578.Metal2 137.607164021
Rred_2570 vin1.$357.Metal1 vin1.$582.Metal2 10.1082003498
Rred_2571 vin1.$357.Metal1 vin1.$587.Metal2 40.2164761345
Rred_2572 vin1.$36.GatPoly vin1.$42.GatPoly 80.7317467344
Rred_2573 vin1.$36.GatPoly vin1.$508.Metal2 1563.02782058
Rred_2574 vin1.$36.GatPoly vin1.P4.GatPoly 21.4418885263
Rred_2575 vin1.$360.Metal1 vin1.$368.Metal1 0.362653569415
Rred_2576 vin1.$360.Metal1 vin1.$579.Metal2 63.5012825511
Rred_2577 vin1.$360.Metal1 vin1.$584.Metal2 136.676492583
Rred_2578 vin1.$360.Metal1 vin1.$586.Metal2 9.91391002973
Rred_2579 vin1.$360.Metal1 vin1.$590.Metal2 148.012303013
Rred_2580 vin1.$365.Metal1 vin1.$369.Metal1 0.17857627571
Rred_2581 vin1.$365.Metal1 vin1.$582.Metal2 54.2048156595
Rred_2582 vin1.$365.Metal1 vin1.$587.Metal2 10.1293546422
Rred_2583 vin1.$365.Metal1 vin1.$591.Metal2 72.9543809522
Rred_2584 vin1.$365.Metal1 vin1.P32.GatPoly 177.329872844
Rred_2585 vin1.$368.Metal1 vin1.$374.Metal1 0.361824121591
Rred_2586 vin1.$368.Metal1 vin1.$586.Metal2 12.8905653645
Rred_2587 vin1.$368.Metal1 vin1.$590.Metal2 9.52216809103
Rred_2588 vin1.$368.Metal1 vin1.P12.GatPoly 58.2686631016
Rred_2589 vin1.$369.Metal1 vin1.$375.Metal1 0.361824121591
Rred_2590 vin1.$369.Metal1 vin1.$587.Metal2 24.3181269841
Rred_2591 vin1.$369.Metal1 vin1.$591.Metal2 10.1777438502
Rred_2592 vin1.$369.Metal1 vin1.P32.GatPoly 137.244791849
Rred_2593 vin1.$37.GatPoly vin1.$43.GatPoly 50.9131933514
Rred_2594 vin1.$37.GatPoly vin1.$509.Metal2 1563.02782058
Rred_2595 vin1.$37.GatPoly vin1.P24.GatPoly 63.2364133369
Rred_2596 vin1.$374.Metal1 vin1.$378.Metal1 0.178374896227
Rred_2597 vin1.$374.Metal1 vin1.$590.Metal2 19.1286039107
Rred_2598 vin1.$374.Metal1 vin1.$595.Metal2 10.7656516291
Rred_2599 vin1.$374.Metal1 vin1.P13.GatPoly 233.378884183
Rred_2600 vin1.$375.Metal1 vin1.$379.Metal1 0.178398933563
Rred_2601 vin1.$375.Metal1 vin1.$591.Metal2 19.1286039107
Rred_2602 vin1.$375.Metal1 vin1.$596.Metal2 10.7656516291
Rred_2603 vin1.$378.Metal1 vin1.$386.Metal1 0.362797942164
Rred_2604 vin1.$378.Metal1 vin1.$595.Metal2 15.9997708552
Rred_2605 vin1.$378.Metal1 vin1.$599.Metal2 14.7413390447
Rred_2606 vin1.$378.Metal1 vin1.P13.GatPoly 92.2851475241
Rred_2607 vin1.$379.Metal1 vin1.$383.Metal1 0.178898601437
Rred_2608 vin1.$379.Metal1 vin1.$387.Metal1 4137.53229591
Rred_2609 vin1.$379.Metal1 vin1.$596.Metal2 15.7349129944
Rred_2610 vin1.$379.Metal1 vin1.$603.Metal2 43.4328267333
Rred_2611 vin1.$383.Metal1 vin1.$387.Metal1 0.178843777497
Rred_2612 vin1.$383.Metal1 vin1.$596.Metal2 24.1058961615
Rred_2613 vin1.$383.Metal1 vin1.$603.Metal2 22.3566696457
Rred_2614 vin1.$386.Metal1 vin1.$392.Metal1 0.358974281487
Rred_2615 vin1.$386.Metal1 vin1.$595.Metal2 100.688434264
Rred_2616 vin1.$386.Metal1 vin1.$599.Metal2 10.3514401745
Rred_2617 vin1.$386.Metal1 vin1.$604.Metal2 15.0113662187
Rred_2618 vin1.$387.Metal1 vin1.$393.Metal1 0.358969093271
Rred_2619 vin1.$387.Metal1 vin1.$596.Metal2 49.717844922
Rred_2620 vin1.$387.Metal1 vin1.$603.Metal2 9.30100123455
Rred_2621 vin1.$387.Metal1 vin1.$609.Metal2 844.325347394
Rred_2622 vin1.$392.Metal1 vin1.$396.Metal1 0.180721425263
Rred_2623 vin1.$392.Metal1 vin1.$400.Metal1 7610.30667437
Rred_2624 vin1.$392.Metal1 vin1.$604.Metal2 8.62947986197
Rred_2625 vin1.$392.Metal1 vin1.$610.Metal2 27.6894597146
Rred_2626 vin1.$393.Metal1 vin1.$397.Metal1 0.180739583769
Rred_2627 vin1.$393.Metal1 vin1.$603.Metal2 10.4000814367
Rred_2628 vin1.$393.Metal1 vin1.$609.Metal2 17.6141428574
Rred_2629 vin1.$396.Metal1 vin1.$400.Metal1 0.178550748274
Rred_2630 vin1.$396.Metal1 vin1.$604.Metal2 34.3389922323
Rred_2631 vin1.$396.Metal1 vin1.$610.Metal2 17.0071631934
Rred_2632 vin1.$397.Metal1 vin1.$401.Metal1 0.178557568839
Rred_2633 vin1.$397.Metal1 vin1.$609.Metal2 11.1613203463
Rred_2634 vin1.$400.Metal1 vin1.$408.Metal1 0.362824398622
Rred_2635 vin1.$400.Metal1 vin1.$604.Metal2 145.280351752
Rred_2636 vin1.$400.Metal1 vin1.$610.Metal2 9.7817715397
Rred_2637 vin1.$400.Metal1 vin1.$615.Metal2 46.1776507338
Rred_2638 vin1.$401.Metal1 vin1.$409.Metal1 0.362824398622
Rred_2639 vin1.$401.Metal1 vin1.$609.Metal2 47.2209706961
Rred_2640 vin1.$401.Metal1 vin1.$611.Metal2 11.3207867366
Rred_2641 vin1.$401.Metal1 vin1.$616.Metal2 46.1776507338
Rred_2642 vin1.$408.Metal1 vin1.$412.Metal1 0.17852453123
Rred_2643 vin1.$408.Metal1 vin1.$610.Metal2 46.1776507338
Rred_2644 vin1.$408.Metal1 vin1.$615.Metal2 10.1192256903
Rred_2645 vin1.$408.Metal1 vin1.$619.Metal2 95.3406373629
Rred_2646 vin1.$408.Metal1 vin1.P15.GatPoly 72.1264392205
Rred_2647 vin1.$409.Metal1 vin1.$413.Metal1 0.178459879632
Rred_2648 vin1.$409.Metal1 vin1.$611.Metal2 46.1776507338
Rred_2649 vin1.$409.Metal1 vin1.$616.Metal2 10.1192256903
Rred_2650 vin1.$409.Metal1 vin1.$620.Metal2 95.3406373629
Rred_2651 vin1.$409.Metal1 vin1.P35.GatPoly 212.715280069
Rred_2652 vin1.$412.Metal1 vin1.$418.Metal1 0.36182906056
Rred_2653 vin1.$412.Metal1 vin1.$615.Metal2 22.5350597402
Rred_2654 vin1.$412.Metal1 vin1.$619.Metal2 10.1769943283
Rred_2655 vin1.$412.Metal1 vin1.P15.GatPoly 40.541385869
Rred_2656 vin1.$413.Metal1 vin1.$419.Metal1 0.36182906056
Rred_2657 vin1.$413.Metal1 vin1.$616.Metal2 22.5350597402
Rred_2658 vin1.$413.Metal1 vin1.$620.Metal2 10.1769943283
Rred_2659 vin1.$413.Metal1 vin1.P35.GatPoly 119.564647066
Rred_2660 vin1.$418.Metal1 vin1.$422.Metal1 0.178504947966
Rred_2661 vin1.$418.Metal1 vin1.$619.Metal2 18.0168451015
Rred_2662 vin1.$418.Metal1 vin1.$624.Metal2 11.5864555256
Rred_2663 vin1.$419.Metal1 vin1.$423.Metal1 0.178504947966
Rred_2664 vin1.$419.Metal1 vin1.$620.Metal2 18.0168451015
Rred_2665 vin1.$419.Metal1 vin1.$625.Metal2 11.5864555256
Rred_2666 vin1.$42.GatPoly vin1.$44.GatPoly 25.4131134156
Rred_2667 vin1.$42.GatPoly vin1.$512.Metal2 3870.9558658
Rred_2668 vin1.$42.GatPoly vin1.$517.Metal2 3870.9558658
Rred_2669 vin1.$42.GatPoly vin1.P4.GatPoly 38.1468722988
Rred_2670 vin1.$422.Metal1 vin1.$426.Metal1 0.17894182666
Rred_2671 vin1.$422.Metal1 vin1.$430.Metal1 4036.92165822
Rred_2672 vin1.$422.Metal1 vin1.$624.Metal2 15.140503946
Rred_2673 vin1.$422.Metal1 vin1.$630.Metal2 48.5088769371
Rred_2674 vin1.$423.Metal1 vin1.$427.Metal1 0.178949087371
Rred_2675 vin1.$423.Metal1 vin1.$625.Metal2 17.9090803107
Rred_2676 vin1.$423.Metal1 vin1.$629.Metal2 31.8360854701
Rred_2677 vin1.$426.Metal1 vin1.$430.Metal1 0.178852088262
Rred_2678 vin1.$426.Metal1 vin1.$624.Metal2 22.6413748687
Rred_2679 vin1.$426.Metal1 vin1.$630.Metal2 23.8007022261
Rred_2680 vin1.$427.Metal1 vin1.$433.Metal1 0.331848942782
Rred_2681 vin1.$427.Metal1 vin1.$625.Metal2 42.814045977
Rred_2682 vin1.$427.Metal1 vin1.$629.Metal2 10.4731205828
Rred_2683 vin1.$43.GatPoly vin1.$47.GatPoly 25.4131134156
Rred_2684 vin1.$43.GatPoly vin1.$513.Metal2 3870.9558658
Rred_2685 vin1.$43.GatPoly vin1.$518.Metal2 3870.9558658
Rred_2686 vin1.$43.GatPoly vin1.P24.GatPoly 112.502748125
Rred_2687 vin1.$430.Metal1 vin1.$437.Metal1 0.36174266925
Rred_2688 vin1.$430.Metal1 vin1.$624.Metal2 43.9859302507
Rred_2689 vin1.$430.Metal1 vin1.$630.Metal2 9.12759240183
Rred_2690 vin1.$433.Metal1 vin1.$441.Metal1 0.39094415179
Rred_2691 vin1.$433.Metal1 vin1.$629.Metal2 12.4168010073
Rred_2692 vin1.$433.Metal1 vin1.$633.Metal2 38.1149573586
Rred_2693 vin1.$433.Metal1 vin1.$636.Metal2 11.1591689028
Rred_2694 vin1.$437.Metal1 vin1.$440.Metal1 0.178129923539
Rred_2695 vin1.$437.Metal1 vin1.$630.Metal2 21.8084097251
Rred_2696 vin1.$437.Metal1 vin1.$635.Metal2 9.42324175824
Rred_2697 vin1.$437.Metal1 vin1.P17.GatPoly 81.1351604514
Rred_2698 vin1.$44.GatPoly vin1.$52.GatPoly 17.2080405764
Rred_2699 vin1.$44.GatPoly vin1.P5.GatPoly 4.76
Rred_2700 vin1.$440.Metal1 vin1.$448.Metal1 0.362653569415
Rred_2701 vin1.$440.Metal1 vin1.$635.Metal2 18.9451496641
Rred_2702 vin1.$440.Metal1 vin1.$639.Metal2 12.8905653645
Rred_2703 vin1.$440.Metal1 vin1.P17.GatPoly 36.2581717142
Rred_2704 vin1.$441.Metal1 vin1.$449.Metal1 0.362653569415
Rred_2705 vin1.$441.Metal1 vin1.$636.Metal2 9.17818171348
Rred_2706 vin1.$441.Metal1 vin1.$640.Metal2 12.8905653645
Rred_2707 vin1.$448.Metal1 vin1.$456.Metal1 0.362310386809
Rred_2708 vin1.$448.Metal1 vin1.$635.Metal2 148.012303013
Rred_2709 vin1.$448.Metal1 vin1.$639.Metal2 11.5186194376
Rred_2710 vin1.$448.Metal1 vin1.$644.Metal2 12.9766510302
Rred_2711 vin1.$448.Metal1 vin1.$648.Metal2 279.314226443
Rred_2712 vin1.$449.Metal1 vin1.$453.Metal1 0.178675191093
Rred_2713 vin1.$449.Metal1 vin1.$636.Metal2 148.012303013
Rred_2714 vin1.$449.Metal1 vin1.$640.Metal2 11.5186194376
Rred_2715 vin1.$449.Metal1 vin1.$645.Metal2 26.726552795
Rred_2716 vin1.$453.Metal1 vin1.$457.Metal1 0.178496116933
Rred_2717 vin1.$453.Metal1 vin1.$645.Metal2 12.426647102
Rred_2718 vin1.$453.Metal1 vin1.$649.Metal2 137.607164021
Rred_2719 vin1.$456.Metal1 vin1.$644.Metal2 11.4454036843
Rred_2720 vin1.$456.Metal1 vin1.$648.Metal2 6.53320320366
Rred_2721 vin1.$456.Metal1 vin1.$653.Metal2 5.38299903212
Rred_2722 vin1.$456.Metal1 vin1.P18.GatPoly 37.76
Rred_2723 vin1.$456.Metal1 vin1.P19.GatPoly 21.9316993903
Rred_2724 vin1.$457.Metal1 vin1.$645.Metal2 20.9909233253
Rred_2725 vin1.$457.Metal1 vin1.$649.Metal2 6.62883717454
Rred_2726 vin1.$457.Metal1 vin1.$654.Metal2 5.24434565257
Rred_2727 vin1.$457.Metal1 vin1.P39.GatPoly 41.5022353547
Rred_2728 vin1.$47.GatPoly vin1.$53.GatPoly 17.2080405764
Rred_2729 vin1.$47.GatPoly vin1.P25.GatPoly 22.26
Rred_2730 vin1.$477.Metal2 vin1.$479.Metal2 0.396394780345
Rred_2731 vin1.$477.Metal2 vin1.$480.Metal2 0.396375994988
Rred_2732 vin1.$477.Metal2 vin1.$486.Metal2 0.12144
Rred_2733 vin1.$477.Metal2 vin1.$6.GatPoly 465.005483652
Rred_2734 vin1.$477.Metal2 vin1.$9.GatPoly 865.63392982
Rred_2735 vin1.$477.Metal2 vin1.P0.GatPoly 584.620514403
Rred_2736 vin1.$477.Metal2 vin1.P20.GatPoly 1158.69091838
Rred_2737 vin1.$479.Metal2 vin1.$483.Metal2 0.346885244507
Rred_2738 vin1.$479.Metal2 vin1.$6.GatPoly 161.378216951
Rred_2739 vin1.$479.Metal2 vin1.P0.GatPoly 240.616715671
Rred_2740 vin1.$480.Metal2 vin1.$484.Metal2 0.346891446111
Rred_2741 vin1.$480.Metal2 vin1.$9.GatPoly 303.791569168
Rred_2742 vin1.$480.Metal2 vin1.P20.GatPoly 472.14281189
Rred_2743 vin1.$483.Metal2 vin1.$486.Metal2 0.692446258504
Rred_2744 vin1.$483.Metal2 vin1.$488.Metal2 0.200294372294
Rred_2745 vin1.$484.Metal2 vin1.$486.Metal2 0.692446258504
Rred_2746 vin1.$484.Metal2 vin1.$489.Metal2 0.200294372294
Rred_2747 vin1.$486.Metal2 vin1.$488.Metal2 0.515651469098
Rred_2748 vin1.$486.Metal2 vin1.$489.Metal2 0.515651469098
Rred_2749 vin1.$486.Metal2 vin1.$495.Metal2 0.12144
Rred_2750 vin1.$488.Metal2 vin1.$492.Metal2 0.346876010592
Rred_2751 vin1.$489.Metal2 vin1.$493.Metal2 0.346876010592
Rred_2752 vin1.$492.Metal2 vin1.$495.Metal2 4.31912380951
Rred_2753 vin1.$492.Metal2 vin1.$497.Metal2 0.178476190476
Rred_2754 vin1.$493.Metal2 vin1.$495.Metal2 0.643273146381
Rred_2755 vin1.$493.Metal2 vin1.$500.Metal2 0.463026148652
Rred_2756 vin1.$495.Metal2 vin1.$497.Metal2 0.280462585034
Rred_2757 vin1.$495.Metal2 vin1.$500.Metal2 0.727612519313
Rred_2758 vin1.$495.Metal2 vin1.$506.Metal2 0.12144
Rred_2759 vin1.$497.Metal2 vin1.$503.Metal2 0.528548299458
Rred_2760 vin1.$500.Metal2 vin1.$504.Metal2 0.346883084067
Rred_2761 vin1.$503.Metal2 vin1.$506.Metal2 0.417099415205
Rred_2762 vin1.$503.Metal2 vin1.$508.Metal2 0.196484848485
Rred_2763 vin1.$504.Metal2 vin1.$506.Metal2 0.417099415205
Rred_2764 vin1.$504.Metal2 vin1.$509.Metal2 0.196484848485
Rred_2765 vin1.$506.Metal2 vin1.$508.Metal2 0.950986666669
Rred_2766 vin1.$506.Metal2 vin1.$509.Metal2 0.950986666669
Rred_2767 vin1.$506.Metal2 vin1.$515.Metal2 0.12144
Rred_2768 vin1.$508.Metal2 vin1.$512.Metal2 0.3468888772
Rred_2769 vin1.$509.Metal2 vin1.$513.Metal2 0.3468888772
Rred_2770 vin1.$512.Metal2 vin1.$515.Metal2 0.885199294533
Rred_2771 vin1.$512.Metal2 vin1.$517.Metal2 0.19751717122
Rred_2772 vin1.$513.Metal2 vin1.$515.Metal2 0.885199294533
Rred_2773 vin1.$513.Metal2 vin1.$518.Metal2 0.19751717122
Rred_2774 vin1.$515.Metal2 vin1.$517.Metal2 0.434552380953
Rred_2775 vin1.$515.Metal2 vin1.$518.Metal2 0.434552380953
Rred_2776 vin1.$515.Metal2 vin1.$523.Metal2 0.793988220725
Rred_2777 vin1.$515.Metal2 vin1.$527.Metal2 0.747094537052
Rred_2778 vin1.$515.Metal2 vin1.$528.Metal2 20.9083564791
Rred_2779 vin1.$515.Metal2 vin1.$535.Metal2 0.357864457583
Rred_2780 vin1.$517.Metal2 vin1.$523.Metal2 0.528590320902
Rred_2781 vin1.$518.Metal2 vin1.$520.Metal2 0.17180952381
Rred_2782 vin1.$52.GatPoly vin1.$523.Metal2 1989.57191416
Rred_2783 vin1.$52.GatPoly vin1.$58.GatPoly 20.0625185185
Rred_2784 vin1.$520.Metal2 vin1.$527.Metal2 0.353544628822
Rred_2785 vin1.$520.Metal2 vin1.$53.GatPoly 111904.93744
Rred_2786 vin1.$523.Metal2 vin1.$527.Metal2 1.65756685141
Rred_2787 vin1.$523.Metal2 vin1.$528.Metal2 0.17524885292
Rred_2788 vin1.$523.Metal2 vin1.$535.Metal2 0.793988220725
Rred_2789 vin1.$527.Metal2 vin1.$528.Metal2 43.6492604206
Rred_2790 vin1.$527.Metal2 vin1.$53.GatPoly 2027.68731673
Rred_2791 vin1.$527.Metal2 vin1.$533.Metal2 0.521902039577
Rred_2792 vin1.$527.Metal2 vin1.$535.Metal2 0.747094537052
Rred_2793 vin1.$528.Metal2 vin1.$532.Metal2 0.346869470833
Rred_2794 vin1.$528.Metal2 vin1.$535.Metal2 20.9083564791
Rred_2795 vin1.$528.Metal2 vin1.$58.GatPoly 2525.70222612
Rred_2796 vin1.$53.GatPoly vin1.$57.GatPoly 26.7507621399
Rred_2797 vin1.$532.Metal2 vin1.$535.Metal2 0.493407191448
Rred_2798 vin1.$532.Metal2 vin1.$537.Metal2 0.19980952381
Rred_2799 vin1.$532.Metal2 vin1.$58.GatPoly 8439.59448869
Rred_2800 vin1.$533.Metal2 vin1.$535.Metal2 0.493407191448
Rred_2801 vin1.$533.Metal2 vin1.$538.Metal2 0.19980952381
Rred_2802 vin1.$535.Metal2 vin1.$537.Metal2 0.732634920637
Rred_2803 vin1.$535.Metal2 vin1.$538.Metal2 0.732634920637
Rred_2804 vin1.$535.Metal2 vin1.$544.Metal2 0.12144
Rred_2805 vin1.$537.Metal2 vin1.$541.Metal2 0.346876010592
Rred_2806 vin1.$537.Metal2 vin1.$64.GatPoly 1611.09899248
Rred_2807 vin1.$537.Metal2 vin1.$70.GatPoly 12405.3841055
Rred_2808 vin1.$538.Metal2 vin1.$542.Metal2 0.346886758096
Rred_2809 vin1.$538.Metal2 vin1.$65.GatPoly 1611.09899248
Rred_2810 vin1.$541.Metal2 vin1.$544.Metal2 0.546093875877
Rred_2811 vin1.$541.Metal2 vin1.$548.Metal2 0.457460174986
Rred_2812 vin1.$541.Metal2 vin1.$70.GatPoly 2301.94136839
Rred_2813 vin1.$542.Metal2 vin1.$544.Metal2 1.22615538847
Rred_2814 vin1.$542.Metal2 vin1.$547.Metal2 0.192530627203
Rred_2815 vin1.$542.Metal2 vin1.$73.GatPoly 3372.27982918
Rred_2816 vin1.$544.Metal2 vin1.$547.Metal2 0.369792894936
Rred_2817 vin1.$544.Metal2 vin1.$548.Metal2 0.878613986878
Rred_2818 vin1.$544.Metal2 vin1.$555.Metal2 0.12144
Rred_2819 vin1.$547.Metal2 vin1.$551.Metal2 0.346891446111
Rred_2820 vin1.$547.Metal2 vin1.$73.GatPoly 4543.078818
Rred_2821 vin1.$548.Metal2 vin1.$552.Metal2 0.346898882339
Rred_2822 vin1.$548.Metal2 vin1.$78.GatPoly 1714.75888267
Rred_2823 vin1.$548.Metal2 vin1.$80.GatPoly 25055.8390465
Rred_2824 vin1.$551.Metal2 vin1.$555.Metal2 0.786467062936
Rred_2825 vin1.$551.Metal2 vin1.$558.Metal2 0.461480673293
Rred_2826 vin1.$551.Metal2 vin1.$77.GatPoly 3154.05582356
Rred_2827 vin1.$551.Metal2 vin1.$83.GatPoly 5361.89490005
Rred_2828 vin1.$552.Metal2 vin1.$555.Metal2 0.315849765258
Rred_2829 vin1.$552.Metal2 vin1.$557.Metal2 0.185328000708
Rred_2830 vin1.$552.Metal2 vin1.$84.GatPoly 5498.19357361
Rred_2831 vin1.$555.Metal2 vin1.$557.Metal2 2.03866666667
Rred_2832 vin1.$555.Metal2 vin1.$558.Metal2 0.599073779942
Rred_2833 vin1.$555.Metal2 vin1.$564.Metal2 0.12144
Rred_2834 vin1.$557.Metal2 vin1.$561.Metal2 0.346865293749
Rred_2835 vin1.$557.Metal2 vin1.$84.GatPoly 2987.58348254
Rred_2836 vin1.$557.Metal2 vin1.$90.GatPoly 4494.85080275
Rred_2837 vin1.$558.Metal2 vin1.$562.Metal2 0.346885087058
Rred_2838 vin1.$561.Metal2 vin1.$564.Metal2 0.592952380953
Rred_2839 vin1.$561.Metal2 vin1.$566.Metal2 0.200917748918
Rred_2840 vin1.$561.Metal2 vin1.$90.GatPoly 3453.79724991
Rred_2841 vin1.$562.Metal2 vin1.$564.Metal2 0.592952380953
Rred_2842 vin1.$562.Metal2 vin1.$567.Metal2 0.200917748918
Rred_2843 vin1.$562.Metal2 vin1.$93.GatPoly 1716.610141
Rred_2844 vin1.$564.Metal2 vin1.$566.Metal2 0.592952380953
Rred_2845 vin1.$564.Metal2 vin1.$567.Metal2 0.592952380953
Rred_2846 vin1.$564.Metal2 vin1.$573.Metal2 0.12144
Rred_2847 vin1.$566.Metal2 vin1.$570.Metal2 0.346885087058
Rred_2848 vin1.$566.Metal2 vin1.$94.GatPoly 1716.610141
Rred_2849 vin1.$567.Metal2 vin1.$571.Metal2 0.346885087058
Rred_2850 vin1.$57.GatPoly vin1.$65.GatPoly 36.1143032099
Rred_2851 vin1.$57.GatPoly vin1.P26.GatPoly 22.26
Rred_2852 vin1.$570.Metal2 vin1.$573.Metal2 2.03866666667
Rred_2853 vin1.$570.Metal2 vin1.$575.Metal2 0.185328000708
Rred_2854 vin1.$571.Metal2 vin1.$573.Metal2 0.599073779942
Rred_2855 vin1.$571.Metal2 vin1.$578.Metal2 0.461480673293
Rred_2856 vin1.$573.Metal2 vin1.$575.Metal2 0.315849765258
Rred_2857 vin1.$573.Metal2 vin1.$578.Metal2 0.786467062936
Rred_2858 vin1.$573.Metal2 vin1.$584.Metal2 0.12144
Rred_2859 vin1.$575.Metal2 vin1.$579.Metal2 0.346898882339
Rred_2860 vin1.$578.Metal2 vin1.$582.Metal2 0.346891446111
Rred_2861 vin1.$579.Metal2 vin1.$584.Metal2 0.878613986878
Rred_2862 vin1.$579.Metal2 vin1.$586.Metal2 0.457460174986
Rred_2863 vin1.$58.GatPoly vin1.$64.GatPoly 60.50563664
Rred_2864 vin1.$58.GatPoly vin1.P6.GatPoly 7.97486881396
Rred_2865 vin1.$582.Metal2 vin1.$584.Metal2 0.369792894936
Rred_2866 vin1.$582.Metal2 vin1.$587.Metal2 0.192530627203
Rred_2867 vin1.$584.Metal2 vin1.$586.Metal2 0.546093875877
Rred_2868 vin1.$584.Metal2 vin1.$587.Metal2 1.22615538847
Rred_2869 vin1.$584.Metal2 vin1.$593.Metal2 0.12144
Rred_2870 vin1.$586.Metal2 vin1.$590.Metal2 0.346876010592
Rred_2871 vin1.$587.Metal2 vin1.$591.Metal2 0.346886758096
Rred_2872 vin1.$590.Metal2 vin1.$593.Metal2 0.732634920637
Rred_2873 vin1.$590.Metal2 vin1.$595.Metal2 0.19980952381
Rred_2874 vin1.$591.Metal2 vin1.$593.Metal2 0.732634920637
Rred_2875 vin1.$591.Metal2 vin1.$596.Metal2 0.19980952381
Rred_2876 vin1.$593.Metal2 vin1.$595.Metal2 0.493407191448
Rred_2877 vin1.$593.Metal2 vin1.$596.Metal2 0.493407191448
Rred_2878 vin1.$593.Metal2 vin1.$599.Metal2 20.9083564791
Rred_2879 vin1.$593.Metal2 vin1.$603.Metal2 0.747094537052
Rred_2880 vin1.$593.Metal2 vin1.$604.Metal2 0.793988220725
Rred_2881 vin1.$593.Metal2 vin1.$613.Metal2 0.357864457583
Rred_2882 vin1.$595.Metal2 vin1.$599.Metal2 0.346869470833
Rred_2883 vin1.$596.Metal2 vin1.$603.Metal2 0.521902039577
Rred_2884 vin1.$599.Metal2 vin1.$603.Metal2 43.6492604206
Rred_2885 vin1.$599.Metal2 vin1.$604.Metal2 0.17524885292
Rred_2886 vin1.$599.Metal2 vin1.$613.Metal2 20.9083564791
Rred_2887 vin1.$6.GatPoly vin1.P0.GatPoly 86.6806517579
Rred_2888 vin1.$6.GatPoly vin1.P1.GatPoly 19.9708444444
Rred_2889 vin1.$603.Metal2 vin1.$604.Metal2 1.65756685141
Rred_2890 vin1.$603.Metal2 vin1.$609.Metal2 0.353544628822
Rred_2891 vin1.$603.Metal2 vin1.$613.Metal2 0.747094537052
Rred_2892 vin1.$604.Metal2 vin1.$610.Metal2 0.528590320902
Rred_2893 vin1.$604.Metal2 vin1.$613.Metal2 0.793988220725
Rred_2894 vin1.$609.Metal2 vin1.$611.Metal2 0.17180952381
Rred_2895 vin1.$610.Metal2 vin1.$613.Metal2 0.434552380953
Rred_2896 vin1.$610.Metal2 vin1.$615.Metal2 0.19751717122
Rred_2897 vin1.$611.Metal2 vin1.$613.Metal2 0.434552380953
Rred_2898 vin1.$611.Metal2 vin1.$616.Metal2 0.19751717122
Rred_2899 vin1.$613.Metal2 vin1.$615.Metal2 0.885199294533
Rred_2900 vin1.$613.Metal2 vin1.$616.Metal2 0.885199294533
Rred_2901 vin1.$613.Metal2 vin1.$622.Metal2 0.12144
Rred_2902 vin1.$615.Metal2 vin1.$619.Metal2 0.3468888772
Rred_2903 vin1.$616.Metal2 vin1.$620.Metal2 0.3468888772
Rred_2904 vin1.$619.Metal2 vin1.$622.Metal2 0.950986666669
Rred_2905 vin1.$619.Metal2 vin1.$624.Metal2 0.196484848485
Rred_2906 vin1.$620.Metal2 vin1.$622.Metal2 0.950986666669
Rred_2907 vin1.$620.Metal2 vin1.$625.Metal2 0.196484848485
Rred_2908 vin1.$622.Metal2 vin1.$624.Metal2 0.417099415205
Rred_2909 vin1.$622.Metal2 vin1.$625.Metal2 0.417099415205
Rred_2910 vin1.$622.Metal2 vin1.$633.Metal2 0.12144
Rred_2911 vin1.$624.Metal2 vin1.$630.Metal2 0.528548299458
Rred_2912 vin1.$625.Metal2 vin1.$629.Metal2 0.346883084067
Rred_2913 vin1.$629.Metal2 vin1.$633.Metal2 0.727612519313
Rred_2914 vin1.$629.Metal2 vin1.$636.Metal2 0.463026148652
Rred_2915 vin1.$630.Metal2 vin1.$633.Metal2 0.280462585034
Rred_2916 vin1.$630.Metal2 vin1.$635.Metal2 0.178476190476
Rred_2917 vin1.$633.Metal2 vin1.$635.Metal2 4.31912380951
Rred_2918 vin1.$633.Metal2 vin1.$636.Metal2 0.643273146381
Rred_2919 vin1.$633.Metal2 vin1.$642.Metal2 0.12144
Rred_2920 vin1.$635.Metal2 vin1.$639.Metal2 0.346876010592
Rred_2921 vin1.$636.Metal2 vin1.$640.Metal2 0.346876010592
Rred_2922 vin1.$639.Metal2 vin1.$642.Metal2 0.515651469098
Rred_2923 vin1.$639.Metal2 vin1.$644.Metal2 0.200294372294
Rred_2924 vin1.$64.GatPoly vin1.$70.GatPoly 33.2347189542
Rred_2925 vin1.$64.GatPoly vin1.P6.GatPoly 123.431498746
Rred_2926 vin1.$64.GatPoly vin1.P7.GatPoly 30.8176484848
Rred_2927 vin1.$640.Metal2 vin1.$642.Metal2 0.515651469098
Rred_2928 vin1.$640.Metal2 vin1.$645.Metal2 0.200294372294
Rred_2929 vin1.$642.Metal2 vin1.$644.Metal2 0.692446258504
Rred_2930 vin1.$642.Metal2 vin1.$645.Metal2 0.692446258504
Rred_2931 vin1.$642.Metal2 vin1.$648.Metal2 2.98963708333
Rred_2932 vin1.$642.Metal2 vin1.$649.Metal2 3.5599249307
Rred_2933 vin1.$642.Metal2 vin1.$653.Metal2 0.781905083333
Rred_2934 vin1.$642.Metal2 vin1.$654.Metal2 0.931057289569
Rred_2935 vin1.$644.Metal2 vin1.$648.Metal2 0.346885244507
Rred_2936 vin1.$645.Metal2 vin1.$649.Metal2 0.346891446111
Rred_2937 vin1.$648.Metal2 vin1.$649.Metal2 53.5446887191
Rred_2938 vin1.$648.Metal2 vin1.$653.Metal2 0.182222484268
Rred_2939 vin1.$648.Metal2 vin1.$654.Metal2 14.0039955112
Rred_2940 vin1.$648.Metal2 vin1.P19.GatPoly 1031.5624039
Rred_2941 vin1.$649.Metal2 vin1.$653.Metal2 14.0039955112
Rred_2942 vin1.$649.Metal2 vin1.$654.Metal2 0.180819600935
Rred_2943 vin1.$649.Metal2 vin1.P39.GatPoly 1960.12022876
Rred_2944 vin1.$65.GatPoly vin1.$73.GatPoly 51.4620406015
Rred_2945 vin1.$65.GatPoly vin1.P27.GatPoly 72.5872454666
Rred_2946 vin1.$653.Metal2 vin1.$654.Metal2 3.66258344139
Rred_2947 vin1.$653.Metal2 vin1.P19.GatPoly 199.325141092
Rred_2948 vin1.$654.Metal2 vin1.P39.GatPoly 395.072001344
Rred_2949 vin1.$70.GatPoly vin1.$78.GatPoly 42.8025468312
Rred_2950 vin1.$70.GatPoly vin1.P7.GatPoly 12.9518899643
Rred_2951 vin1.$73.GatPoly vin1.$77.GatPoly 29.4260595885
Rred_2952 vin1.$73.GatPoly vin1.P27.GatPoly 93.7877994151
Rred_2953 vin1.$77.GatPoly vin1.$83.GatPoly 15.0537042157
Rred_2954 vin1.$77.GatPoly vin1.P28.GatPoly 22.26
Rred_2955 vin1.$78.GatPoly vin1.$80.GatPoly 11.1325184116
Rred_2956 vin1.$78.GatPoly vin1.P8.GatPoly 11.3586666667
Rred_2957 vin1.$80.GatPoly vin1.$84.GatPoly 20.0625185185
Rred_2958 vin1.$80.GatPoly vin1.P8.GatPoly 16.2266666667
Rred_2959 vin1.$83.GatPoly vin1.$87.GatPoly 30.7637083127
Rred_2960 vin1.$84.GatPoly vin1.$90.GatPoly 32.0988583878
Rred_2961 vin1.$84.GatPoly vin1.P9.GatPoly 36.3787061728
Rred_2962 vin1.$87.GatPoly vin1.$93.GatPoly 14.3546666667
Rred_2963 vin1.$87.GatPoly vin1.P29.GatPoly 22.26
Rred_2964 vin1.$9.GatPoly vin1.P20.GatPoly 365.489864519
Rred_2965 vin1.$9.GatPoly vin1.P21.GatPoly 22.26
Rred_2966 vin1.$90.GatPoly vin1.$94.GatPoly 20.0625185185
Rred_2967 vin1.$90.GatPoly vin1.P9.GatPoly 11.2006811616
Rred_2968 vin1.$93.GatPoly vin1.$97.GatPoly 32.101357037
Rred_2969 vin1.$94.GatPoly vin1.P10.GatPoly 29.2903280591
Rred_2970 vin1.$97.GatPoly vin1.P30.GatPoly 22.26
Rred_2971 vin2 vin2.$477.Metal2 1.24696
Rred_2972 vin2.$101.GatPoly vin2.$109.GatPoly 42.7425970977
Rred_2973 vin2.$101.GatPoly vin2.$335.Metal1 20.0890603495
Rred_2974 vin2.$101.GatPoly vin2.$343.Metal1 14.2883104861
Rred_2975 vin2.$101.GatPoly vin2.$349.Metal1 157.344579311
Rred_2976 vin2.$101.GatPoly vin2.$567.Metal2 10044.7987195
Rred_2977 vin2.$101.GatPoly vin2.$571.Metal2 2408.55915615
Rred_2978 vin2.$101.GatPoly vin2.$576.Metal2 11957.7663662
Rred_2979 vin2.$101.GatPoly vin2.$95.GatPoly 31.32108061
Rred_2980 vin2.$101.GatPoly vin2.P10.GatPoly 10.3860540384
Rred_2981 vin2.$104.GatPoly vin2.$106.GatPoly 15.0537042157
Rred_2982 vin2.$104.GatPoly vin2.$338.Metal1 123.604185185
Rred_2983 vin2.$104.GatPoly vin2.$342.Metal1 33.8281181896
Rred_2984 vin2.$104.GatPoly vin2.$346.Metal1 13.0141464528
Rred_2985 vin2.$104.GatPoly vin2.$352.Metal1 98.1690707437
Rred_2986 vin2.$104.GatPoly vin2.$577.Metal2 5361.89490005
Rred_2987 vin2.$104.GatPoly vin2.$96.GatPoly 30.7637083127
Rred_2988 vin2.$106.GatPoly vin2.$114.GatPoly 29.4260595885
Rred_2989 vin2.$106.GatPoly vin2.$346.Metal1 57.8243567653
Rred_2990 vin2.$106.GatPoly vin2.$352.Metal1 15.9311738026
Rred_2991 vin2.$106.GatPoly vin2.$356.Metal1 55.6375076253
Rred_2992 vin2.$106.GatPoly vin2.$577.Metal2 3154.05582356
Rred_2993 vin2.$106.GatPoly vin2.P31.GatPoly 22.26
Rred_2994 vin2.$109.GatPoly vin2.$111.GatPoly 11.1325184116
Rred_2995 vin2.$109.GatPoly vin2.$343.Metal1 36.757635223
Rred_2996 vin2.$109.GatPoly vin2.$349.Metal1 12.4547299484
Rred_2997 vin2.$109.GatPoly vin2.$357.Metal1 430.191522254
Rred_2998 vin2.$109.GatPoly vin2.$576.Metal2 4728.46648928
Rred_2999 vin2.$109.GatPoly vin2.$580.Metal2 25055.8390465
Rred_3000 vin2.$109.GatPoly vin2.P11.GatPoly 16.2266666667
Rred_3001 vin2.$11.GatPoly vin2.$17.GatPoly 20.0625185185
Rred_3002 vin2.$11.GatPoly vin2.$203.Metal1 20.489591646
Rred_3003 vin2.$11.GatPoly vin2.$211.Metal1 16.8901542286
Rred_3004 vin2.$11.GatPoly vin2.$480.Metal2 23421.3890021
Rred_3005 vin2.$11.GatPoly vin2.$484.Metal2 2115.07400678
Rred_3006 vin2.$11.GatPoly vin2.$7.GatPoly 33.2847407407
Rred_3007 vin2.$11.GatPoly vin2.P1.GatPoly 19.9708444444
Rred_3008 vin2.$111.GatPoly vin2.$119.GatPoly 42.8025468312
Rred_3009 vin2.$111.GatPoly vin2.$349.Metal1 31.5600123225
Rred_3010 vin2.$111.GatPoly vin2.$357.Metal1 15.334097558
Rred_3011 vin2.$111.GatPoly vin2.$361.Metal1 80.9291851852
Rred_3012 vin2.$111.GatPoly vin2.$580.Metal2 1714.75888267
Rred_3013 vin2.$111.GatPoly vin2.P11.GatPoly 11.3586666667
Rred_3014 vin2.$114.GatPoly vin2.$122.GatPoly 51.4620406015
Rred_3015 vin2.$114.GatPoly vin2.$352.Metal1 135.119661376
Rred_3016 vin2.$114.GatPoly vin2.$356.Metal1 16.0835537092
Rred_3017 vin2.$114.GatPoly vin2.$364.Metal1 15.9974348707
Rred_3018 vin2.$114.GatPoly vin2.$368.Metal1 97.3021776078
Rred_3019 vin2.$114.GatPoly vin2.$581.Metal2 4543.078818
Rred_3020 vin2.$114.GatPoly vin2.$586.Metal2 3372.27982918
Rred_3021 vin2.$114.GatPoly vin2.P32.GatPoly 93.7877994151
Rred_3022 vin2.$119.GatPoly vin2.$123.GatPoly 33.2347189542
Rred_3023 vin2.$119.GatPoly vin2.$357.Metal1 80.9291851852
Rred_3024 vin2.$119.GatPoly vin2.$361.Metal1 15.5987328054
Rred_3025 vin2.$119.GatPoly vin2.$369.Metal1 20.4860406756
Rred_3026 vin2.$119.GatPoly vin2.$587.Metal2 2301.94136839
Rred_3027 vin2.$119.GatPoly vin2.$591.Metal2 12405.3841055
Rred_3028 vin2.$119.GatPoly vin2.P12.GatPoly 12.9518899643
Rred_3029 vin2.$122.GatPoly vin2.$126.GatPoly 36.1143032099
Rred_3030 vin2.$122.GatPoly vin2.$364.Metal1 97.3021776078
Rred_3031 vin2.$122.GatPoly vin2.$368.Metal1 16.2930131079
Rred_3032 vin2.$122.GatPoly vin2.$374.Metal1 15.7999014456
Rred_3033 vin2.$122.GatPoly vin2.$378.Metal1 96.7347407407
Rred_3034 vin2.$122.GatPoly vin2.$590.Metal2 1611.09899248
Rred_3035 vin2.$122.GatPoly vin2.P32.GatPoly 72.5872454666
Rred_3036 vin2.$123.GatPoly vin2.$131.GatPoly 60.50563664
Rred_3037 vin2.$123.GatPoly vin2.$369.Metal1 18.2531011901
Rred_3038 vin2.$123.GatPoly vin2.$375.Metal1 15.6601627124
Rred_3039 vin2.$123.GatPoly vin2.$379.Metal1 84.9923100066
Rred_3040 vin2.$123.GatPoly vin2.$591.Metal2 1611.09899248
Rred_3041 vin2.$123.GatPoly vin2.P12.GatPoly 30.8176484848
Rred_3042 vin2.$123.GatPoly vin2.P13.GatPoly 123.431498746
Rred_3043 vin2.$126.GatPoly vin2.$134.GatPoly 26.7507621399
Rred_3044 vin2.$126.GatPoly vin2.$374.Metal1 68.2833464052
Rred_3045 vin2.$126.GatPoly vin2.$378.Metal1 27.001323271
Rred_3046 vin2.$126.GatPoly vin2.$382.Metal1 20.0005513629
Rred_3047 vin2.$126.GatPoly vin2.$386.Metal1 50.5791721133
Rred_3048 vin2.$126.GatPoly vin2.P33.GatPoly 22.26
Rred_3049 vin2.$131.GatPoly vin2.$135.GatPoly 20.0625185185
Rred_3050 vin2.$131.GatPoly vin2.$375.Metal1 114.401413815
Rred_3051 vin2.$131.GatPoly vin2.$379.Metal1 18.1851091752
Rred_3052 vin2.$131.GatPoly vin2.$387.Metal1 16.8812213797
Rred_3053 vin2.$131.GatPoly vin2.$596.Metal2 8439.59448869
Rred_3054 vin2.$131.GatPoly vin2.$600.Metal2 2525.70222612
Rred_3055 vin2.$131.GatPoly vin2.P13.GatPoly 7.97486881396
Rred_3056 vin2.$134.GatPoly vin2.$136.GatPoly 17.2080405764
Rred_3057 vin2.$134.GatPoly vin2.$382.Metal1 171.969185185
Rred_3058 vin2.$134.GatPoly vin2.$386.Metal1 16.3265000824
Rred_3059 vin2.$134.GatPoly vin2.$392.Metal1 17.7474001705
Rred_3060 vin2.$134.GatPoly vin2.$396.Metal1 2936.27252746
Rred_3061 vin2.$134.GatPoly vin2.$601.Metal2 2027.68731673
Rred_3062 vin2.$134.GatPoly vin2.$608.Metal2 111904.93744
Rred_3063 vin2.$135.GatPoly vin2.$137.GatPoly 17.2080405764
Rred_3064 vin2.$135.GatPoly vin2.$387.Metal1 16.9633899809
Rred_3065 vin2.$135.GatPoly vin2.$393.Metal1 17.7474958524
Rred_3066 vin2.$135.GatPoly vin2.$397.Metal1 2936.27252746
Rred_3067 vin2.$135.GatPoly vin2.$605.Metal2 1989.57191416
Rred_3068 vin2.$136.GatPoly vin2.$144.GatPoly 25.4131134156
Rred_3069 vin2.$136.GatPoly vin2.$392.Metal1 33.0203657934
Rred_3070 vin2.$136.GatPoly vin2.$396.Metal1 18.8410085241
Rred_3071 vin2.$136.GatPoly vin2.$400.Metal1 48.0500043573
Rred_3072 vin2.$136.GatPoly vin2.P34.GatPoly 22.26
Rred_3073 vin2.$137.GatPoly vin2.$145.GatPoly 25.4131134156
Rred_3074 vin2.$137.GatPoly vin2.$393.Metal1 33.0203657934
Rred_3075 vin2.$137.GatPoly vin2.$397.Metal1 18.8410085241
Rred_3076 vin2.$137.GatPoly vin2.$401.Metal1 48.0500043573
Rred_3077 vin2.$137.GatPoly vin2.P14.GatPoly 4.76
Rred_3078 vin2.$14.GatPoly vin2.$16.GatPoly 8.64681481481
Rred_3079 vin2.$14.GatPoly vin2.$218.Metal1 12.6296021429
Rred_3080 vin2.$14.GatPoly vin2.$226.Metal1 37.7619085138
Rred_3081 vin2.$14.GatPoly vin2.$26.GatPoly 41.3580961617
Rred_3082 vin2.$14.GatPoly vin2.$492.Metal2 2934.89262124
Rred_3083 vin2.$14.GatPoly vin2.P22.GatPoly 22.26
Rred_3084 vin2.$144.GatPoly vin2.$152.GatPoly 50.9131933514
Rred_3085 vin2.$144.GatPoly vin2.$396.Metal1 204.212518518
Rred_3086 vin2.$144.GatPoly vin2.$400.Metal1 16.3459334659
Rred_3087 vin2.$144.GatPoly vin2.$408.Metal1 15.8678203345
Rred_3088 vin2.$144.GatPoly vin2.$412.Metal1 96.2644412107
Rred_3089 vin2.$144.GatPoly vin2.$610.Metal2 3870.9558658
Rred_3090 vin2.$144.GatPoly vin2.$615.Metal2 3870.9558658
Rred_3091 vin2.$144.GatPoly vin2.P35.GatPoly 112.502748125
Rred_3092 vin2.$145.GatPoly vin2.$153.GatPoly 80.7317467344
Rred_3093 vin2.$145.GatPoly vin2.$397.Metal1 204.212518518
Rred_3094 vin2.$145.GatPoly vin2.$401.Metal1 16.3459334659
Rred_3095 vin2.$145.GatPoly vin2.$409.Metal1 16.4300806005
Rred_3096 vin2.$145.GatPoly vin2.$413.Metal1 152.644058952
Rred_3097 vin2.$145.GatPoly vin2.$611.Metal2 3870.9558658
Rred_3098 vin2.$145.GatPoly vin2.$616.Metal2 3870.9558658
Rred_3099 vin2.$145.GatPoly vin2.P15.GatPoly 38.1468722988
Rred_3100 vin2.$152.GatPoly vin2.$156.GatPoly 40.1272493827
Rred_3101 vin2.$152.GatPoly vin2.$408.Metal1 96.2644412107
Rred_3102 vin2.$152.GatPoly vin2.$412.Metal1 16.5099701104
Rred_3103 vin2.$152.GatPoly vin2.$418.Metal1 15.6802121879
Rred_3104 vin2.$152.GatPoly vin2.$422.Metal1 85.9869629629
Rred_3105 vin2.$152.GatPoly vin2.$619.Metal2 1563.02782058
Rred_3106 vin2.$152.GatPoly vin2.P35.GatPoly 63.2364133369
Rred_3107 vin2.$153.GatPoly vin2.$157.GatPoly 40.1272493827
Rred_3108 vin2.$153.GatPoly vin2.$409.Metal1 152.644058952
Rred_3109 vin2.$153.GatPoly vin2.$413.Metal1 18.6069469566
Rred_3110 vin2.$153.GatPoly vin2.$419.Metal1 15.6802121879
Rred_3111 vin2.$153.GatPoly vin2.$423.Metal1 85.9869629629
Rred_3112 vin2.$153.GatPoly vin2.$620.Metal2 1563.02782058
Rred_3113 vin2.$153.GatPoly vin2.P15.GatPoly 21.4418885263
Rred_3114 vin2.$156.GatPoly vin2.$162.GatPoly 9.36029629629
Rred_3115 vin2.$156.GatPoly vin2.$418.Metal1 75.8708496732
Rred_3116 vin2.$156.GatPoly vin2.$422.Metal1 30.0016540887
Rred_3117 vin2.$156.GatPoly vin2.$426.Metal1 17.6980392157
Rred_3118 vin2.$156.GatPoly vin2.P36.GatPoly 22.26
Rred_3119 vin2.$157.GatPoly vin2.$165.GatPoly 22.7378159671
Rred_3120 vin2.$157.GatPoly vin2.$419.Metal1 75.8708496732
Rred_3121 vin2.$157.GatPoly vin2.$423.Metal1 30.0016540887
Rred_3122 vin2.$157.GatPoly vin2.$427.Metal1 17.0002205452
Rred_3123 vin2.$157.GatPoly vin2.$431.Metal1 42.9916688453
Rred_3124 vin2.$157.GatPoly vin2.P16.GatPoly 4.76
Rred_3125 vin2.$16.GatPoly vin2.$206.Metal1 80.9291851852
Rred_3126 vin2.$16.GatPoly vin2.$210.Metal1 15.5987328054
Rred_3127 vin2.$16.GatPoly vin2.$218.Metal1 27.3987871831
Rred_3128 vin2.$16.GatPoly vin2.$488.Metal2 2301.94136839
Rred_3129 vin2.$16.GatPoly vin2.$492.Metal2 12405.3841055
Rred_3130 vin2.$16.GatPoly vin2.$8.GatPoly 42.8025468312
Rred_3131 vin2.$162.GatPoly vin2.$166.GatPoly 41.3580961617
Rred_3132 vin2.$162.GatPoly vin2.$426.Metal1 27.2939474766
Rred_3133 vin2.$162.GatPoly vin2.$432.Metal1 14.2581745852
Rred_3134 vin2.$162.GatPoly vin2.$440.Metal1 115.651204718
Rred_3135 vin2.$162.GatPoly vin2.$628.Metal2 2664.67413314
Rred_3136 vin2.$162.GatPoly vin2.$635.Metal2 6114.14760608
Rred_3137 vin2.$165.GatPoly vin2.$173.GatPoly 77.9511897103
Rred_3138 vin2.$165.GatPoly vin2.$427.Metal1 365.429185185
Rred_3139 vin2.$165.GatPoly vin2.$431.Metal1 16.5931436324
Rred_3140 vin2.$165.GatPoly vin2.$439.Metal1 16.2158441731
Rred_3141 vin2.$165.GatPoly vin2.$441.Metal1 147.386703234
Rred_3142 vin2.$165.GatPoly vin2.$631.Metal2 1836.80456241
Rred_3143 vin2.$165.GatPoly vin2.P17.GatPoly 42.9114848609
Rred_3144 vin2.$166.GatPoly vin2.$172.GatPoly 8.64681481481
Rred_3145 vin2.$166.GatPoly vin2.$432.Metal1 37.7619085138
Rred_3146 vin2.$166.GatPoly vin2.$440.Metal1 12.6296021429
Rred_3147 vin2.$166.GatPoly vin2.$635.Metal2 2934.89262124
Rred_3148 vin2.$166.GatPoly vin2.P37.GatPoly 22.26
Rred_3149 vin2.$17.GatPoly vin2.$211.Metal1 16.8857192322
Rred_3150 vin2.$17.GatPoly vin2.$219.Metal1 19.3496497775
Rred_3151 vin2.$17.GatPoly vin2.$223.Metal1 147.386703234
Rred_3152 vin2.$17.GatPoly vin2.$23.GatPoly 77.9511897103
Rred_3153 vin2.$17.GatPoly vin2.$489.Metal2 2301.94136839
Rred_3154 vin2.$17.GatPoly vin2.$493.Metal2 12405.3841055
Rred_3155 vin2.$17.GatPoly vin2.P2.GatPoly 19.176544151
Rred_3156 vin2.$172.GatPoly vin2.$178.GatPoly 42.8025468312
Rred_3157 vin2.$172.GatPoly vin2.$440.Metal1 27.3987871831
Rred_3158 vin2.$172.GatPoly vin2.$448.Metal1 15.5987328054
Rred_3159 vin2.$172.GatPoly vin2.$452.Metal1 80.9291851852
Rred_3160 vin2.$172.GatPoly vin2.$635.Metal2 12405.3841055
Rred_3161 vin2.$172.GatPoly vin2.$639.Metal2 2301.94136839
Rred_3162 vin2.$173.GatPoly vin2.$177.GatPoly 20.0625185185
Rred_3163 vin2.$173.GatPoly vin2.$439.Metal1 147.386703234
Rred_3164 vin2.$173.GatPoly vin2.$441.Metal1 19.3496497775
Rred_3165 vin2.$173.GatPoly vin2.$449.Metal1 16.8857192322
Rred_3166 vin2.$173.GatPoly vin2.$636.Metal2 12405.3841055
Rred_3167 vin2.$173.GatPoly vin2.$640.Metal2 2301.94136839
Rred_3168 vin2.$173.GatPoly vin2.P17.GatPoly 19.176544151
Rred_3169 vin2.$177.GatPoly vin2.$181.GatPoly 33.2847407407
Rred_3170 vin2.$177.GatPoly vin2.$449.Metal1 16.8901542286
Rred_3171 vin2.$177.GatPoly vin2.$457.Metal1 20.489591646
Rred_3172 vin2.$177.GatPoly vin2.$645.Metal2 2115.07400678
Rred_3173 vin2.$177.GatPoly vin2.$649.Metal2 23421.3890021
Rred_3174 vin2.$177.GatPoly vin2.P18.GatPoly 19.9708444444
Rred_3175 vin2.$178.GatPoly vin2.$448.Metal1 80.9291851852
Rred_3176 vin2.$178.GatPoly vin2.$452.Metal1 32.0018746339
Rred_3177 vin2.$178.GatPoly vin2.$456.Metal1 8.16033769425
Rred_3178 vin2.$178.GatPoly vin2.$648.Metal2 877.519802179
Rred_3179 vin2.$178.GatPoly vin2.$653.Metal2 295.150090209
Rred_3180 vin2.$178.GatPoly vin2.P38.GatPoly 22.26
Rred_3181 vin2.$178.GatPoly vin2.P39.GatPoly 365.628758224
Rred_3182 vin2.$181.GatPoly vin2.$457.Metal1 8.0987663346
Rred_3183 vin2.$181.GatPoly vin2.$649.Metal2 456.549538848
Rred_3184 vin2.$181.GatPoly vin2.$654.Metal2 158.542646647
Rred_3185 vin2.$181.GatPoly vin2.P18.GatPoly 19.9708444444
Rred_3186 vin2.$181.GatPoly vin2.P19.GatPoly 86.7094752085
Rred_3187 vin2.$202.Metal1 vin2.$206.Metal1 0.178496116933
Rred_3188 vin2.$202.Metal1 vin2.$477.Metal2 15.3809322347
Rred_3189 vin2.$202.Metal1 vin2.$479.Metal2 3.67675955388
Rred_3190 vin2.$202.Metal1 vin2.$483.Metal2 20.9909233253
Rred_3191 vin2.$202.Metal1 vin2.$8.GatPoly 8.15512705888
Rred_3192 vin2.$202.Metal1 vin2.P20.GatPoly 41.4017255522
Rred_3193 vin2.$203.Metal1 vin2.$211.Metal1 0.362310386809
Rred_3194 vin2.$203.Metal1 vin2.$477.Metal2 15.7883328011
Rred_3195 vin2.$203.Metal1 vin2.$480.Metal2 3.68923170446
Rred_3196 vin2.$203.Metal1 vin2.$484.Metal2 11.4454036843
Rred_3197 vin2.$203.Metal1 vin2.$7.GatPoly 8.08946310818
Rred_3198 vin2.$203.Metal1 vin2.P0.GatPoly 21.8775056486
Rred_3199 vin2.$203.Metal1 vin2.P1.GatPoly 37.76
Rred_3200 vin2.$206.Metal1 vin2.$210.Metal1 0.178675191093
Rred_3201 vin2.$206.Metal1 vin2.$479.Metal2 137.607164021
Rred_3202 vin2.$206.Metal1 vin2.$483.Metal2 12.426647102
Rred_3203 vin2.$206.Metal1 vin2.$8.GatPoly 32.0018746339
Rred_3204 vin2.$210.Metal1 vin2.$218.Metal1 0.362653569415
Rred_3205 vin2.$210.Metal1 vin2.$483.Metal2 26.726552795
Rred_3206 vin2.$210.Metal1 vin2.$488.Metal2 11.5186194376
Rred_3207 vin2.$210.Metal1 vin2.$492.Metal2 148.012303013
Rred_3208 vin2.$210.Metal1 vin2.$8.GatPoly 80.9291851852
Rred_3209 vin2.$211.Metal1 vin2.$219.Metal1 0.362653569415
Rred_3210 vin2.$211.Metal1 vin2.$480.Metal2 279.314226443
Rred_3211 vin2.$211.Metal1 vin2.$484.Metal2 12.9766510302
Rred_3212 vin2.$211.Metal1 vin2.$489.Metal2 11.5186194376
Rred_3213 vin2.$211.Metal1 vin2.$493.Metal2 148.012303013
Rred_3214 vin2.$218.Metal1 vin2.$226.Metal1 0.39094415179
Rred_3215 vin2.$218.Metal1 vin2.$26.GatPoly 115.651204718
Rred_3216 vin2.$218.Metal1 vin2.$488.Metal2 12.8905653645
Rred_3217 vin2.$218.Metal1 vin2.$492.Metal2 9.17818171348
Rred_3218 vin2.$219.Metal1 vin2.$223.Metal1 0.178129923539
Rred_3219 vin2.$219.Metal1 vin2.$23.GatPoly 147.386703234
Rred_3220 vin2.$219.Metal1 vin2.$489.Metal2 12.8905653645
Rred_3221 vin2.$219.Metal1 vin2.$493.Metal2 18.9451496641
Rred_3222 vin2.$219.Metal1 vin2.P2.GatPoly 36.2581717142
Rred_3223 vin2.$223.Metal1 vin2.$229.Metal1 0.36174266925
Rred_3224 vin2.$223.Metal1 vin2.$23.GatPoly 16.2158441731
Rred_3225 vin2.$223.Metal1 vin2.$493.Metal2 9.42324175824
Rred_3226 vin2.$223.Metal1 vin2.$498.Metal2 21.8084097251
Rred_3227 vin2.$223.Metal1 vin2.P2.GatPoly 81.1351604514
Rred_3228 vin2.$226.Metal1 vin2.$232.Metal1 0.331848942782
Rred_3229 vin2.$226.Metal1 vin2.$26.GatPoly 14.2581745852
Rred_3230 vin2.$226.Metal1 vin2.$492.Metal2 11.1591689028
Rred_3231 vin2.$226.Metal1 vin2.$495.Metal2 38.1149573586
Rred_3232 vin2.$226.Metal1 vin2.$499.Metal2 12.4168010073
Rred_3233 vin2.$229.Metal1 vin2.$23.GatPoly 16.5931436324
Rred_3234 vin2.$229.Metal1 vin2.$233.Metal1 0.178852088262
Rred_3235 vin2.$229.Metal1 vin2.$237.Metal1 4036.92165822
Rred_3236 vin2.$229.Metal1 vin2.$25.GatPoly 42.9916688453
Rred_3237 vin2.$229.Metal1 vin2.$498.Metal2 9.12759240183
Rred_3238 vin2.$229.Metal1 vin2.$504.Metal2 43.9859302507
Rred_3239 vin2.$23.GatPoly vin2.$233.Metal1 365.429185185
Rred_3240 vin2.$23.GatPoly vin2.$25.GatPoly 22.7378159671
Rred_3241 vin2.$23.GatPoly vin2.$498.Metal2 1836.80456241
Rred_3242 vin2.$23.GatPoly vin2.P2.GatPoly 42.9114848609
Rred_3243 vin2.$232.Metal1 vin2.$236.Metal1 0.178949087371
Rred_3244 vin2.$232.Metal1 vin2.$24.GatPoly 17.6980392157
Rred_3245 vin2.$232.Metal1 vin2.$26.GatPoly 27.2939474766
Rred_3246 vin2.$232.Metal1 vin2.$499.Metal2 10.4731205828
Rred_3247 vin2.$232.Metal1 vin2.$503.Metal2 42.814045977
Rred_3248 vin2.$233.Metal1 vin2.$237.Metal1 0.17894182666
Rred_3249 vin2.$233.Metal1 vin2.$25.GatPoly 17.0002205452
Rred_3250 vin2.$233.Metal1 vin2.$498.Metal2 23.8007022261
Rred_3251 vin2.$233.Metal1 vin2.$504.Metal2 22.6413748687
Rred_3252 vin2.$236.Metal1 vin2.$24.GatPoly 30.0016540887
Rred_3253 vin2.$236.Metal1 vin2.$240.Metal1 0.178504947966
Rred_3254 vin2.$236.Metal1 vin2.$36.GatPoly 85.9869629629
Rred_3255 vin2.$236.Metal1 vin2.$499.Metal2 31.8360854701
Rred_3256 vin2.$236.Metal1 vin2.$503.Metal2 17.9090803107
Rred_3257 vin2.$237.Metal1 vin2.$241.Metal1 0.178504947966
Rred_3258 vin2.$237.Metal1 vin2.$25.GatPoly 30.0016540887
Rred_3259 vin2.$237.Metal1 vin2.$37.GatPoly 85.9869629629
Rred_3260 vin2.$237.Metal1 vin2.$498.Metal2 48.5088769371
Rred_3261 vin2.$237.Metal1 vin2.$504.Metal2 15.140503946
Rred_3262 vin2.$24.GatPoly vin2.$240.Metal1 75.8708496732
Rred_3263 vin2.$24.GatPoly vin2.$26.GatPoly 9.36029629629
Rred_3264 vin2.$24.GatPoly vin2.$36.GatPoly 40.1272493827
Rred_3265 vin2.$24.GatPoly vin2.P23.GatPoly 22.26
Rred_3266 vin2.$240.Metal1 vin2.$246.Metal1 0.36182906056
Rred_3267 vin2.$240.Metal1 vin2.$36.GatPoly 15.6802121879
Rred_3268 vin2.$240.Metal1 vin2.$503.Metal2 11.5864555256
Rred_3269 vin2.$240.Metal1 vin2.$508.Metal2 18.0168451015
Rred_3270 vin2.$241.Metal1 vin2.$247.Metal1 0.36182906056
Rred_3271 vin2.$241.Metal1 vin2.$25.GatPoly 75.8708496732
Rred_3272 vin2.$241.Metal1 vin2.$37.GatPoly 15.6802121879
Rred_3273 vin2.$241.Metal1 vin2.$504.Metal2 11.5864555256
Rred_3274 vin2.$241.Metal1 vin2.$509.Metal2 18.0168451015
Rred_3275 vin2.$246.Metal1 vin2.$250.Metal1 0.178459879632
Rred_3276 vin2.$246.Metal1 vin2.$36.GatPoly 16.5099701104
Rred_3277 vin2.$246.Metal1 vin2.$42.GatPoly 96.2644412107
Rred_3278 vin2.$246.Metal1 vin2.$508.Metal2 10.1769943283
Rred_3279 vin2.$246.Metal1 vin2.$512.Metal2 22.5350597402
Rred_3280 vin2.$246.Metal1 vin2.P24.GatPoly 119.564647066
Rred_3281 vin2.$247.Metal1 vin2.$251.Metal1 0.17852453123
Rred_3282 vin2.$247.Metal1 vin2.$37.GatPoly 18.6069469566
Rred_3283 vin2.$247.Metal1 vin2.$43.GatPoly 152.644058952
Rred_3284 vin2.$247.Metal1 vin2.$509.Metal2 10.1769943283
Rred_3285 vin2.$247.Metal1 vin2.$513.Metal2 22.5350597402
Rred_3286 vin2.$247.Metal1 vin2.P4.GatPoly 40.541385869
Rred_3287 vin2.$25.GatPoly vin2.$37.GatPoly 40.1272493827
Rred_3288 vin2.$25.GatPoly vin2.P3.GatPoly 4.76
Rred_3289 vin2.$250.Metal1 vin2.$258.Metal1 0.362824398622
Rred_3290 vin2.$250.Metal1 vin2.$36.GatPoly 96.2644412107
Rred_3291 vin2.$250.Metal1 vin2.$42.GatPoly 15.8678203345
Rred_3292 vin2.$250.Metal1 vin2.$508.Metal2 95.3406373629
Rred_3293 vin2.$250.Metal1 vin2.$512.Metal2 10.1192256903
Rred_3294 vin2.$250.Metal1 vin2.$517.Metal2 46.1776507338
Rred_3295 vin2.$250.Metal1 vin2.P24.GatPoly 212.715280069
Rred_3296 vin2.$251.Metal1 vin2.$259.Metal1 0.362824398622
Rred_3297 vin2.$251.Metal1 vin2.$37.GatPoly 152.644058952
Rred_3298 vin2.$251.Metal1 vin2.$43.GatPoly 16.4300806005
Rred_3299 vin2.$251.Metal1 vin2.$509.Metal2 95.3406373629
Rred_3300 vin2.$251.Metal1 vin2.$513.Metal2 10.1192256903
Rred_3301 vin2.$251.Metal1 vin2.$518.Metal2 46.1776507338
Rred_3302 vin2.$251.Metal1 vin2.P4.GatPoly 72.1264392205
Rred_3303 vin2.$258.Metal1 vin2.$262.Metal1 0.178557568839
Rred_3304 vin2.$258.Metal1 vin2.$42.GatPoly 16.3459334659
Rred_3305 vin2.$258.Metal1 vin2.$44.GatPoly 48.0500043573
Rred_3306 vin2.$258.Metal1 vin2.$512.Metal2 46.1776507338
Rred_3307 vin2.$258.Metal1 vin2.$517.Metal2 11.3207867366
Rred_3308 vin2.$258.Metal1 vin2.$519.Metal2 47.2209706961
Rred_3309 vin2.$259.Metal1 vin2.$263.Metal1 0.178550748274
Rred_3310 vin2.$259.Metal1 vin2.$265.Metal1 7610.30667437
Rred_3311 vin2.$259.Metal1 vin2.$43.GatPoly 16.3459334659
Rred_3312 vin2.$259.Metal1 vin2.$47.GatPoly 48.0500043573
Rred_3313 vin2.$259.Metal1 vin2.$513.Metal2 46.1776507338
Rred_3314 vin2.$259.Metal1 vin2.$518.Metal2 9.7817715397
Rred_3315 vin2.$259.Metal1 vin2.$524.Metal2 145.280351752
Rred_3316 vin2.$26.GatPoly vin2.$492.Metal2 6114.14760608
Rred_3317 vin2.$26.GatPoly vin2.$499.Metal2 2664.67413314
Rred_3318 vin2.$262.Metal1 vin2.$264.Metal1 0.180739583769
Rred_3319 vin2.$262.Metal1 vin2.$42.GatPoly 204.212518518
Rred_3320 vin2.$262.Metal1 vin2.$44.GatPoly 18.8410085241
Rred_3321 vin2.$262.Metal1 vin2.$519.Metal2 11.1613203463
Rred_3322 vin2.$262.Metal1 vin2.$52.GatPoly 2936.27252746
Rred_3323 vin2.$263.Metal1 vin2.$265.Metal1 0.180721425263
Rred_3324 vin2.$263.Metal1 vin2.$43.GatPoly 204.212518518
Rred_3325 vin2.$263.Metal1 vin2.$47.GatPoly 18.8410085241
Rred_3326 vin2.$263.Metal1 vin2.$518.Metal2 17.0071631934
Rred_3327 vin2.$263.Metal1 vin2.$524.Metal2 34.3389922323
Rred_3328 vin2.$263.Metal1 vin2.$53.GatPoly 2936.27252746
Rred_3329 vin2.$264.Metal1 vin2.$272.Metal1 0.358969093271
Rred_3330 vin2.$264.Metal1 vin2.$44.GatPoly 33.0203657934
Rred_3331 vin2.$264.Metal1 vin2.$519.Metal2 17.6141428574
Rred_3332 vin2.$264.Metal1 vin2.$52.GatPoly 17.7474001705
Rred_3333 vin2.$264.Metal1 vin2.$525.Metal2 10.4000814367
Rred_3334 vin2.$265.Metal1 vin2.$273.Metal1 0.358974281487
Rred_3335 vin2.$265.Metal1 vin2.$47.GatPoly 33.0203657934
Rred_3336 vin2.$265.Metal1 vin2.$518.Metal2 27.6894597146
Rred_3337 vin2.$265.Metal1 vin2.$524.Metal2 8.62947986197
Rred_3338 vin2.$265.Metal1 vin2.$53.GatPoly 17.7474958524
Rred_3339 vin2.$272.Metal1 vin2.$276.Metal1 0.178843777497
Rred_3340 vin2.$272.Metal1 vin2.$280.Metal1 4137.53229591
Rred_3341 vin2.$272.Metal1 vin2.$519.Metal2 844.325347394
Rred_3342 vin2.$272.Metal1 vin2.$52.GatPoly 16.3265000824
Rred_3343 vin2.$272.Metal1 vin2.$525.Metal2 9.30100123455
Rred_3344 vin2.$272.Metal1 vin2.$532.Metal2 49.717844922
Rred_3345 vin2.$272.Metal1 vin2.$56.GatPoly 50.5791721133
Rred_3346 vin2.$273.Metal1 vin2.$281.Metal1 0.362797942164
Rred_3347 vin2.$273.Metal1 vin2.$524.Metal2 15.0113662187
Rred_3348 vin2.$273.Metal1 vin2.$529.Metal2 10.3514401745
Rred_3349 vin2.$273.Metal1 vin2.$53.GatPoly 16.9633899809
Rred_3350 vin2.$273.Metal1 vin2.$533.Metal2 100.688434264
Rred_3351 vin2.$273.Metal1 vin2.$59.GatPoly 16.8812213797
Rred_3352 vin2.$276.Metal1 vin2.$280.Metal1 0.178898601437
Rred_3353 vin2.$276.Metal1 vin2.$52.GatPoly 171.969185185
Rred_3354 vin2.$276.Metal1 vin2.$525.Metal2 22.3566696457
Rred_3355 vin2.$276.Metal1 vin2.$532.Metal2 24.1058961615
Rred_3356 vin2.$276.Metal1 vin2.$56.GatPoly 20.0005513629
Rred_3357 vin2.$280.Metal1 vin2.$284.Metal1 0.178398933563
Rred_3358 vin2.$280.Metal1 vin2.$525.Metal2 43.4328267333
Rred_3359 vin2.$280.Metal1 vin2.$532.Metal2 15.7349129944
Rred_3360 vin2.$280.Metal1 vin2.$56.GatPoly 27.001323271
Rred_3361 vin2.$280.Metal1 vin2.$64.GatPoly 96.7347407407
Rred_3362 vin2.$281.Metal1 vin2.$285.Metal1 0.178374896227
Rred_3363 vin2.$281.Metal1 vin2.$529.Metal2 14.7413390447
Rred_3364 vin2.$281.Metal1 vin2.$533.Metal2 15.9997708552
Rred_3365 vin2.$281.Metal1 vin2.$59.GatPoly 18.1851091752
Rred_3366 vin2.$281.Metal1 vin2.$65.GatPoly 84.9923100066
Rred_3367 vin2.$281.Metal1 vin2.P6.GatPoly 92.2851475241
Rred_3368 vin2.$284.Metal1 vin2.$290.Metal1 0.361824121591
Rred_3369 vin2.$284.Metal1 vin2.$532.Metal2 10.7656516291
Rred_3370 vin2.$284.Metal1 vin2.$537.Metal2 19.1286039107
Rred_3371 vin2.$284.Metal1 vin2.$56.GatPoly 68.2833464052
Rred_3372 vin2.$284.Metal1 vin2.$64.GatPoly 15.7999014456
Rred_3373 vin2.$285.Metal1 vin2.$291.Metal1 0.361824121591
Rred_3374 vin2.$285.Metal1 vin2.$533.Metal2 10.7656516291
Rred_3375 vin2.$285.Metal1 vin2.$538.Metal2 19.1286039107
Rred_3376 vin2.$285.Metal1 vin2.$59.GatPoly 114.401413815
Rred_3377 vin2.$285.Metal1 vin2.$65.GatPoly 15.6601627124
Rred_3378 vin2.$285.Metal1 vin2.P6.GatPoly 233.378884183
Rred_3379 vin2.$290.Metal1 vin2.$294.Metal1 0.17857627571
Rred_3380 vin2.$290.Metal1 vin2.$537.Metal2 10.1777438502
Rred_3381 vin2.$290.Metal1 vin2.$541.Metal2 24.3181269841
Rred_3382 vin2.$290.Metal1 vin2.$64.GatPoly 16.2930131079
Rred_3383 vin2.$290.Metal1 vin2.$72.GatPoly 97.3021776078
Rred_3384 vin2.$290.Metal1 vin2.P27.GatPoly 137.244791849
Rred_3385 vin2.$291.Metal1 vin2.$299.Metal1 0.362653569415
Rred_3386 vin2.$291.Metal1 vin2.$538.Metal2 9.52216809103
Rred_3387 vin2.$291.Metal1 vin2.$542.Metal2 12.8905653645
Rred_3388 vin2.$291.Metal1 vin2.$65.GatPoly 18.2531011901
Rred_3389 vin2.$291.Metal1 vin2.$71.GatPoly 20.4860406756
Rred_3390 vin2.$291.Metal1 vin2.P7.GatPoly 58.2686631016
Rred_3391 vin2.$294.Metal1 vin2.$302.Metal1 0.362799427562
Rred_3392 vin2.$294.Metal1 vin2.$537.Metal2 72.9543809522
Rred_3393 vin2.$294.Metal1 vin2.$541.Metal2 10.1293546422
Rred_3394 vin2.$294.Metal1 vin2.$546.Metal2 54.2048156595
Rred_3395 vin2.$294.Metal1 vin2.$64.GatPoly 97.3021776078
Rred_3396 vin2.$294.Metal1 vin2.$72.GatPoly 15.9974348707
Rred_3397 vin2.$294.Metal1 vin2.P27.GatPoly 177.329872844
Rred_3398 vin2.$299.Metal1 vin2.$303.Metal1 0.178668868145
Rred_3399 vin2.$299.Metal1 vin2.$538.Metal2 148.012303013
Rred_3400 vin2.$299.Metal1 vin2.$542.Metal2 9.91391002973
Rred_3401 vin2.$299.Metal1 vin2.$544.Metal2 136.676492583
Rred_3402 vin2.$299.Metal1 vin2.$549.Metal2 63.5012825511
Rred_3403 vin2.$299.Metal1 vin2.$71.GatPoly 15.5987328054
Rred_3404 vin2.$299.Metal1 vin2.$79.GatPoly 80.9291851852
Rred_3405 vin2.$302.Metal1 vin2.$306.Metal1 0.178371493384
Rred_3406 vin2.$302.Metal1 vin2.$541.Metal2 40.2164761345
Rred_3407 vin2.$302.Metal1 vin2.$546.Metal2 10.1082003498
Rred_3408 vin2.$302.Metal1 vin2.$550.Metal2 137.607164021
Rred_3409 vin2.$302.Metal1 vin2.$72.GatPoly 16.0835537092
Rred_3410 vin2.$302.Metal1 vin2.$76.GatPoly 55.6375076253
Rred_3411 vin2.$303.Metal1 vin2.$311.Metal1 0.375564027363
Rred_3412 vin2.$303.Metal1 vin2.$542.Metal2 36.3717608362
Rred_3413 vin2.$303.Metal1 vin2.$544.Metal2 69.856873987
Rred_3414 vin2.$303.Metal1 vin2.$549.Metal2 10.5831998195
Rred_3415 vin2.$303.Metal1 vin2.$71.GatPoly 80.9291851852
Rred_3416 vin2.$303.Metal1 vin2.$79.GatPoly 15.334097558
Rred_3417 vin2.$303.Metal1 vin2.$81.GatPoly 430.191522254
Rred_3418 vin2.$306.Metal1 vin2.$312.Metal1 0.36146618849
Rred_3419 vin2.$306.Metal1 vin2.$546.Metal2 20.9909233253
Rred_3420 vin2.$306.Metal1 vin2.$550.Metal2 10.1668380754
Rred_3421 vin2.$306.Metal1 vin2.$72.GatPoly 135.119661376
Rred_3422 vin2.$306.Metal1 vin2.$76.GatPoly 15.9311738026
Rred_3423 vin2.$306.Metal1 vin2.$82.GatPoly 98.1690707437
Rred_3424 vin2.$311.Metal1 vin2.$317.Metal1 0.34812443664
Rred_3425 vin2.$311.Metal1 vin2.$549.Metal2 9.92591643291
Rred_3426 vin2.$311.Metal1 vin2.$553.Metal2 10.4176943967
Rred_3427 vin2.$311.Metal1 vin2.$79.GatPoly 31.5600123225
Rred_3428 vin2.$311.Metal1 vin2.$81.GatPoly 15.5718406742
Rred_3429 vin2.$311.Metal1 vin2.$83.GatPoly 29.2042852009
Rred_3430 vin2.$312.Metal1 vin2.$316.Metal1 0.178799366164
Rred_3431 vin2.$312.Metal1 vin2.$550.Metal2 11.008714331
Rred_3432 vin2.$312.Metal1 vin2.$555.Metal2 57.4004804448
Rred_3433 vin2.$312.Metal1 vin2.$557.Metal2 33.6812736494
Rred_3434 vin2.$312.Metal1 vin2.$76.GatPoly 57.8243567653
Rred_3435 vin2.$312.Metal1 vin2.$82.GatPoly 13.0141464528
Rred_3436 vin2.$316.Metal1 vin2.$320.Metal1 0.178838571508
Rred_3437 vin2.$316.Metal1 vin2.$550.Metal2 80.5238780093
Rred_3438 vin2.$316.Metal1 vin2.$555.Metal2 148.032817989
Rred_3439 vin2.$316.Metal1 vin2.$557.Metal2 14.6154515868
Rred_3440 vin2.$316.Metal1 vin2.$82.GatPoly 33.8281181896
Rred_3441 vin2.$316.Metal1 vin2.$86.GatPoly 58.1666753812
Rred_3442 vin2.$317.Metal1 vin2.$321.Metal1 0.17879442307
Rred_3443 vin2.$317.Metal1 vin2.$553.Metal2 14.5517176343
Rred_3444 vin2.$317.Metal1 vin2.$558.Metal2 17.5721428571
Rred_3445 vin2.$317.Metal1 vin2.$83.GatPoly 16.0793926449
Rred_3446 vin2.$317.Metal1 vin2.$91.GatPoly 132.252722286
Rred_3447 vin2.$317.Metal1 vin2.P9.GatPoly 149.886418591
Rred_3448 vin2.$320.Metal1 vin2.$324.Metal1 0.178840374465
Rred_3449 vin2.$320.Metal1 vin2.$557.Metal2 14.1682801538
Rred_3450 vin2.$320.Metal1 vin2.$561.Metal2 59.0882403627
Rred_3451 vin2.$320.Metal1 vin2.$82.GatPoly 123.604185185
Rred_3452 vin2.$320.Metal1 vin2.$86.GatPoly 23.0008821806
Rred_3453 vin2.$321.Metal1 vin2.$329.Metal1 0.362169844265
Rred_3454 vin2.$321.Metal1 vin2.$558.Metal2 11.2057192849
Rred_3455 vin2.$321.Metal1 vin2.$562.Metal2 24.2669420704
Rred_3456 vin2.$321.Metal1 vin2.$83.GatPoly 93.4499675813
Rred_3457 vin2.$321.Metal1 vin2.$91.GatPoly 19.2438881958
Rred_3458 vin2.$321.Metal1 vin2.P9.GatPoly 59.2696734323
Rred_3459 vin2.$324.Metal1 vin2.$330.Metal1 0.361795734713
Rred_3460 vin2.$324.Metal1 vin2.$557.Metal2 26.4011286728
Rred_3461 vin2.$324.Metal1 vin2.$561.Metal2 10.1761275149
Rred_3462 vin2.$324.Metal1 vin2.$86.GatPoly 27.1411764706
Rred_3463 vin2.$324.Metal1 vin2.$92.GatPoly 19.1121432091
Rred_3464 vin2.$329.Metal1 vin2.$335.Metal1 0.361795734713
Rred_3465 vin2.$329.Metal1 vin2.$558.Metal2 53.4649554857
Rred_3466 vin2.$329.Metal1 vin2.$562.Metal2 8.0753915984
Rred_3467 vin2.$329.Metal1 vin2.$567.Metal2 20.3813394518
Rred_3468 vin2.$329.Metal1 vin2.$91.GatPoly 16.8684682797
Rred_3469 vin2.$329.Metal1 vin2.$95.GatPoly 16.8807966702
Rred_3470 vin2.$330.Metal1 vin2.$334.Metal1 0.178273944544
Rred_3471 vin2.$330.Metal1 vin2.$561.Metal2 20.3813394518
Rred_3472 vin2.$330.Metal1 vin2.$566.Metal2 10.0511202186
Rred_3473 vin2.$330.Metal1 vin2.$92.GatPoly 15.9520155185
Rred_3474 vin2.$330.Metal1 vin2.$96.GatPoly 60.6958431373
Rred_3475 vin2.$334.Metal1 vin2.$338.Metal1 0.178840374465
Rred_3476 vin2.$334.Metal1 vin2.$566.Metal2 20.2863564567
Rred_3477 vin2.$334.Metal1 vin2.$570.Metal2 26.4011286728
Rred_3478 vin2.$334.Metal1 vin2.$92.GatPoly 114.647703704
Rred_3479 vin2.$334.Metal1 vin2.$96.GatPoly 24.0009924532
Rred_3480 vin2.$335.Metal1 vin2.$343.Metal1 0.362750607287
Rred_3481 vin2.$335.Metal1 vin2.$567.Metal2 9.3791763802
Rred_3482 vin2.$335.Metal1 vin2.$571.Metal2 13.7550931008
Rred_3483 vin2.$335.Metal1 vin2.$95.GatPoly 17.6321930648
Rred_3484 vin2.$335.Metal1 vin2.P10.GatPoly 75.5061764706
Rred_3485 vin2.$338.Metal1 vin2.$342.Metal1 0.178838571508
Rred_3486 vin2.$338.Metal1 vin2.$566.Metal2 59.0882403627
Rred_3487 vin2.$338.Metal1 vin2.$570.Metal2 14.1682801538
Rred_3488 vin2.$338.Metal1 vin2.$96.GatPoly 23.0008821806
Rred_3489 vin2.$342.Metal1 vin2.$346.Metal1 0.178799366164
Rred_3490 vin2.$342.Metal1 vin2.$570.Metal2 14.6154515868
Rred_3491 vin2.$342.Metal1 vin2.$573.Metal2 148.032817989
Rred_3492 vin2.$342.Metal1 vin2.$577.Metal2 80.5238780093
Rred_3493 vin2.$342.Metal1 vin2.$96.GatPoly 58.1666753812
Rred_3494 vin2.$343.Metal1 vin2.$349.Metal1 0.34723110095
Rred_3495 vin2.$343.Metal1 vin2.$567.Metal2 119.851544368
Rred_3496 vin2.$343.Metal1 vin2.$571.Metal2 10.9045148683
Rred_3497 vin2.$343.Metal1 vin2.$576.Metal2 14.531155051
Rred_3498 vin2.$346.Metal1 vin2.$352.Metal1 0.36146618849
Rred_3499 vin2.$346.Metal1 vin2.$570.Metal2 33.6812736494
Rred_3500 vin2.$346.Metal1 vin2.$573.Metal2 57.4004804448
Rred_3501 vin2.$346.Metal1 vin2.$577.Metal2 11.008714331
Rred_3502 vin2.$349.Metal1 vin2.$357.Metal1 0.375564027363
Rred_3503 vin2.$349.Metal1 vin2.$576.Metal2 10.4114631896
Rred_3504 vin2.$349.Metal1 vin2.$580.Metal2 9.92591643291
Rred_3505 vin2.$352.Metal1 vin2.$356.Metal1 0.178371493384
Rred_3506 vin2.$352.Metal1 vin2.$577.Metal2 10.1668380754
Rred_3507 vin2.$352.Metal1 vin2.$581.Metal2 20.9909233253
Rred_3508 vin2.$356.Metal1 vin2.$364.Metal1 0.362799427562
Rred_3509 vin2.$356.Metal1 vin2.$577.Metal2 137.607164021
Rred_3510 vin2.$356.Metal1 vin2.$581.Metal2 10.1082003498
Rred_3511 vin2.$356.Metal1 vin2.$586.Metal2 40.2164761345
Rred_3512 vin2.$357.Metal1 vin2.$361.Metal1 0.178668868145
Rred_3513 vin2.$357.Metal1 vin2.$580.Metal2 10.5831998195
Rred_3514 vin2.$357.Metal1 vin2.$584.Metal2 69.856873987
Rred_3515 vin2.$357.Metal1 vin2.$587.Metal2 36.3717608362
Rred_3516 vin2.$36.GatPoly vin2.$42.GatPoly 50.9131933514
Rred_3517 vin2.$36.GatPoly vin2.$508.Metal2 1563.02782058
Rred_3518 vin2.$36.GatPoly vin2.P24.GatPoly 63.2364133369
Rred_3519 vin2.$361.Metal1 vin2.$369.Metal1 0.362653569415
Rred_3520 vin2.$361.Metal1 vin2.$580.Metal2 63.5012825511
Rred_3521 vin2.$361.Metal1 vin2.$584.Metal2 136.676492583
Rred_3522 vin2.$361.Metal1 vin2.$587.Metal2 9.91391002973
Rred_3523 vin2.$361.Metal1 vin2.$591.Metal2 148.012303013
Rred_3524 vin2.$364.Metal1 vin2.$368.Metal1 0.17857627571
Rred_3525 vin2.$364.Metal1 vin2.$581.Metal2 54.2048156595
Rred_3526 vin2.$364.Metal1 vin2.$586.Metal2 10.1293546422
Rred_3527 vin2.$364.Metal1 vin2.$590.Metal2 72.9543809522
Rred_3528 vin2.$364.Metal1 vin2.P32.GatPoly 177.329872844
Rred_3529 vin2.$368.Metal1 vin2.$374.Metal1 0.361824121591
Rred_3530 vin2.$368.Metal1 vin2.$586.Metal2 24.3181269841
Rred_3531 vin2.$368.Metal1 vin2.$590.Metal2 10.1777438502
Rred_3532 vin2.$368.Metal1 vin2.P32.GatPoly 137.244791849
Rred_3533 vin2.$369.Metal1 vin2.$375.Metal1 0.361824121591
Rred_3534 vin2.$369.Metal1 vin2.$587.Metal2 12.8905653645
Rred_3535 vin2.$369.Metal1 vin2.$591.Metal2 9.52216809103
Rred_3536 vin2.$369.Metal1 vin2.P12.GatPoly 58.2686631016
Rred_3537 vin2.$37.GatPoly vin2.$43.GatPoly 80.7317467344
Rred_3538 vin2.$37.GatPoly vin2.$509.Metal2 1563.02782058
Rred_3539 vin2.$37.GatPoly vin2.P4.GatPoly 21.4418885263
Rred_3540 vin2.$374.Metal1 vin2.$378.Metal1 0.178398933563
Rred_3541 vin2.$374.Metal1 vin2.$590.Metal2 19.1286039107
Rred_3542 vin2.$374.Metal1 vin2.$595.Metal2 10.7656516291
Rred_3543 vin2.$375.Metal1 vin2.$379.Metal1 0.178374896227
Rred_3544 vin2.$375.Metal1 vin2.$591.Metal2 19.1286039107
Rred_3545 vin2.$375.Metal1 vin2.$596.Metal2 10.7656516291
Rred_3546 vin2.$375.Metal1 vin2.P13.GatPoly 233.378884183
Rred_3547 vin2.$378.Metal1 vin2.$382.Metal1 0.178898601437
Rred_3548 vin2.$378.Metal1 vin2.$386.Metal1 4137.53229591
Rred_3549 vin2.$378.Metal1 vin2.$595.Metal2 15.7349129944
Rred_3550 vin2.$378.Metal1 vin2.$601.Metal2 43.4328267333
Rred_3551 vin2.$379.Metal1 vin2.$387.Metal1 0.362797942164
Rred_3552 vin2.$379.Metal1 vin2.$596.Metal2 15.9997708552
Rred_3553 vin2.$379.Metal1 vin2.$600.Metal2 14.7413390447
Rred_3554 vin2.$379.Metal1 vin2.P13.GatPoly 92.2851475241
Rred_3555 vin2.$382.Metal1 vin2.$386.Metal1 0.178843777497
Rred_3556 vin2.$382.Metal1 vin2.$595.Metal2 24.1058961615
Rred_3557 vin2.$382.Metal1 vin2.$601.Metal2 22.3566696457
Rred_3558 vin2.$386.Metal1 vin2.$392.Metal1 0.358969093271
Rred_3559 vin2.$386.Metal1 vin2.$595.Metal2 49.717844922
Rred_3560 vin2.$386.Metal1 vin2.$601.Metal2 9.30100123455
Rred_3561 vin2.$386.Metal1 vin2.$608.Metal2 844.325347394
Rred_3562 vin2.$387.Metal1 vin2.$393.Metal1 0.358974281487
Rred_3563 vin2.$387.Metal1 vin2.$596.Metal2 100.688434264
Rred_3564 vin2.$387.Metal1 vin2.$600.Metal2 10.3514401745
Rred_3565 vin2.$387.Metal1 vin2.$605.Metal2 15.0113662187
Rred_3566 vin2.$392.Metal1 vin2.$396.Metal1 0.180739583769
Rred_3567 vin2.$392.Metal1 vin2.$601.Metal2 10.4000814367
Rred_3568 vin2.$392.Metal1 vin2.$608.Metal2 17.6141428574
Rred_3569 vin2.$393.Metal1 vin2.$397.Metal1 0.180721425263
Rred_3570 vin2.$393.Metal1 vin2.$401.Metal1 7610.30667437
Rred_3571 vin2.$393.Metal1 vin2.$605.Metal2 8.62947986197
Rred_3572 vin2.$393.Metal1 vin2.$611.Metal2 27.6894597146
Rred_3573 vin2.$396.Metal1 vin2.$400.Metal1 0.178557568839
Rred_3574 vin2.$396.Metal1 vin2.$608.Metal2 11.1613203463
Rred_3575 vin2.$397.Metal1 vin2.$401.Metal1 0.178550748274
Rred_3576 vin2.$397.Metal1 vin2.$605.Metal2 34.3389922323
Rred_3577 vin2.$397.Metal1 vin2.$611.Metal2 17.0071631934
Rred_3578 vin2.$400.Metal1 vin2.$408.Metal1 0.362824398622
Rred_3579 vin2.$400.Metal1 vin2.$608.Metal2 47.2209706961
Rred_3580 vin2.$400.Metal1 vin2.$610.Metal2 11.3207867366
Rred_3581 vin2.$400.Metal1 vin2.$615.Metal2 46.1776507338
Rred_3582 vin2.$401.Metal1 vin2.$409.Metal1 0.362824398622
Rred_3583 vin2.$401.Metal1 vin2.$605.Metal2 145.280351752
Rred_3584 vin2.$401.Metal1 vin2.$611.Metal2 9.7817715397
Rred_3585 vin2.$401.Metal1 vin2.$616.Metal2 46.1776507338
Rred_3586 vin2.$408.Metal1 vin2.$412.Metal1 0.178459879632
Rred_3587 vin2.$408.Metal1 vin2.$610.Metal2 46.1776507338
Rred_3588 vin2.$408.Metal1 vin2.$615.Metal2 10.1192256903
Rred_3589 vin2.$408.Metal1 vin2.$619.Metal2 95.3406373629
Rred_3590 vin2.$408.Metal1 vin2.P35.GatPoly 212.715280069
Rred_3591 vin2.$409.Metal1 vin2.$413.Metal1 0.17852453123
Rred_3592 vin2.$409.Metal1 vin2.$611.Metal2 46.1776507338
Rred_3593 vin2.$409.Metal1 vin2.$616.Metal2 10.1192256903
Rred_3594 vin2.$409.Metal1 vin2.$620.Metal2 95.3406373629
Rred_3595 vin2.$409.Metal1 vin2.P15.GatPoly 72.1264392205
Rred_3596 vin2.$412.Metal1 vin2.$418.Metal1 0.36182906056
Rred_3597 vin2.$412.Metal1 vin2.$615.Metal2 22.5350597402
Rred_3598 vin2.$412.Metal1 vin2.$619.Metal2 10.1769943283
Rred_3599 vin2.$412.Metal1 vin2.P35.GatPoly 119.564647066
Rred_3600 vin2.$413.Metal1 vin2.$419.Metal1 0.36182906056
Rred_3601 vin2.$413.Metal1 vin2.$616.Metal2 22.5350597402
Rred_3602 vin2.$413.Metal1 vin2.$620.Metal2 10.1769943283
Rred_3603 vin2.$413.Metal1 vin2.P15.GatPoly 40.541385869
Rred_3604 vin2.$418.Metal1 vin2.$422.Metal1 0.178504947966
Rred_3605 vin2.$418.Metal1 vin2.$619.Metal2 18.0168451015
Rred_3606 vin2.$418.Metal1 vin2.$624.Metal2 11.5864555256
Rred_3607 vin2.$419.Metal1 vin2.$423.Metal1 0.178504947966
Rred_3608 vin2.$419.Metal1 vin2.$620.Metal2 18.0168451015
Rred_3609 vin2.$419.Metal1 vin2.$625.Metal2 11.5864555256
Rred_3610 vin2.$42.GatPoly vin2.$44.GatPoly 25.4131134156
Rred_3611 vin2.$42.GatPoly vin2.$512.Metal2 3870.9558658
Rred_3612 vin2.$42.GatPoly vin2.$517.Metal2 3870.9558658
Rred_3613 vin2.$42.GatPoly vin2.P24.GatPoly 112.502748125
Rred_3614 vin2.$422.Metal1 vin2.$426.Metal1 0.178949087371
Rred_3615 vin2.$422.Metal1 vin2.$624.Metal2 17.9090803107
Rred_3616 vin2.$422.Metal1 vin2.$628.Metal2 31.8360854701
Rred_3617 vin2.$423.Metal1 vin2.$427.Metal1 0.17894182666
Rred_3618 vin2.$423.Metal1 vin2.$431.Metal1 4036.92165822
Rred_3619 vin2.$423.Metal1 vin2.$625.Metal2 15.140503946
Rred_3620 vin2.$423.Metal1 vin2.$631.Metal2 48.5088769371
Rred_3621 vin2.$426.Metal1 vin2.$432.Metal1 0.331848942782
Rred_3622 vin2.$426.Metal1 vin2.$624.Metal2 42.814045977
Rred_3623 vin2.$426.Metal1 vin2.$628.Metal2 10.4731205828
Rred_3624 vin2.$427.Metal1 vin2.$431.Metal1 0.178852088262
Rred_3625 vin2.$427.Metal1 vin2.$625.Metal2 22.6413748687
Rred_3626 vin2.$427.Metal1 vin2.$631.Metal2 23.8007022261
Rred_3627 vin2.$43.GatPoly vin2.$47.GatPoly 25.4131134156
Rred_3628 vin2.$43.GatPoly vin2.$513.Metal2 3870.9558658
Rred_3629 vin2.$43.GatPoly vin2.$518.Metal2 3870.9558658
Rred_3630 vin2.$43.GatPoly vin2.P4.GatPoly 38.1468722988
Rred_3631 vin2.$431.Metal1 vin2.$439.Metal1 0.36174266925
Rred_3632 vin2.$431.Metal1 vin2.$625.Metal2 43.9859302507
Rred_3633 vin2.$431.Metal1 vin2.$631.Metal2 9.12759240183
Rred_3634 vin2.$432.Metal1 vin2.$440.Metal1 0.39094415179
Rred_3635 vin2.$432.Metal1 vin2.$628.Metal2 12.4168010073
Rred_3636 vin2.$432.Metal1 vin2.$633.Metal2 38.1149573586
Rred_3637 vin2.$432.Metal1 vin2.$635.Metal2 11.1591689028
Rred_3638 vin2.$439.Metal1 vin2.$441.Metal1 0.178129923539
Rred_3639 vin2.$439.Metal1 vin2.$631.Metal2 21.8084097251
Rred_3640 vin2.$439.Metal1 vin2.$636.Metal2 9.42324175824
Rred_3641 vin2.$439.Metal1 vin2.P17.GatPoly 81.1351604514
Rred_3642 vin2.$44.GatPoly vin2.$52.GatPoly 17.2080405764
Rred_3643 vin2.$44.GatPoly vin2.P25.GatPoly 22.26
Rred_3644 vin2.$440.Metal1 vin2.$448.Metal1 0.362653569415
Rred_3645 vin2.$440.Metal1 vin2.$635.Metal2 9.17818171348
Rred_3646 vin2.$440.Metal1 vin2.$639.Metal2 12.8905653645
Rred_3647 vin2.$441.Metal1 vin2.$449.Metal1 0.362653569415
Rred_3648 vin2.$441.Metal1 vin2.$636.Metal2 18.9451496641
Rred_3649 vin2.$441.Metal1 vin2.$640.Metal2 12.8905653645
Rred_3650 vin2.$441.Metal1 vin2.P17.GatPoly 36.2581717142
Rred_3651 vin2.$448.Metal1 vin2.$452.Metal1 0.178675191093
Rred_3652 vin2.$448.Metal1 vin2.$635.Metal2 148.012303013
Rred_3653 vin2.$448.Metal1 vin2.$639.Metal2 11.5186194376
Rred_3654 vin2.$448.Metal1 vin2.$644.Metal2 26.726552795
Rred_3655 vin2.$449.Metal1 vin2.$457.Metal1 0.362310386809
Rred_3656 vin2.$449.Metal1 vin2.$636.Metal2 148.012303013
Rred_3657 vin2.$449.Metal1 vin2.$640.Metal2 11.5186194376
Rred_3658 vin2.$449.Metal1 vin2.$645.Metal2 12.9766510302
Rred_3659 vin2.$449.Metal1 vin2.$649.Metal2 279.314226443
Rred_3660 vin2.$452.Metal1 vin2.$456.Metal1 0.178496116933
Rred_3661 vin2.$452.Metal1 vin2.$644.Metal2 12.426647102
Rred_3662 vin2.$452.Metal1 vin2.$648.Metal2 137.607164021
Rred_3663 vin2.$456.Metal1 vin2.$644.Metal2 20.9909233253
Rred_3664 vin2.$456.Metal1 vin2.$648.Metal2 6.62883717454
Rred_3665 vin2.$456.Metal1 vin2.$653.Metal2 5.24434565257
Rred_3666 vin2.$456.Metal1 vin2.P39.GatPoly 41.5022353547
Rred_3667 vin2.$457.Metal1 vin2.$645.Metal2 11.4454036843
Rred_3668 vin2.$457.Metal1 vin2.$649.Metal2 6.53320320366
Rred_3669 vin2.$457.Metal1 vin2.$654.Metal2 5.38299903212
Rred_3670 vin2.$457.Metal1 vin2.P18.GatPoly 37.76
Rred_3671 vin2.$457.Metal1 vin2.P19.GatPoly 21.9316993903
Rred_3672 vin2.$47.GatPoly vin2.$53.GatPoly 17.2080405764
Rred_3673 vin2.$47.GatPoly vin2.P5.GatPoly 4.76
Rred_3674 vin2.$477.Metal2 vin2.$479.Metal2 0.396375994988
Rred_3675 vin2.$477.Metal2 vin2.$480.Metal2 0.396394780345
Rred_3676 vin2.$477.Metal2 vin2.$486.Metal2 0.12144
Rred_3677 vin2.$477.Metal2 vin2.$7.GatPoly 465.005483652
Rred_3678 vin2.$477.Metal2 vin2.$8.GatPoly 865.63392982
Rred_3679 vin2.$477.Metal2 vin2.P0.GatPoly 584.620514403
Rred_3680 vin2.$477.Metal2 vin2.P20.GatPoly 1158.69091838
Rred_3681 vin2.$479.Metal2 vin2.$483.Metal2 0.346891446111
Rred_3682 vin2.$479.Metal2 vin2.$8.GatPoly 303.791569168
Rred_3683 vin2.$479.Metal2 vin2.P20.GatPoly 472.14281189
Rred_3684 vin2.$480.Metal2 vin2.$484.Metal2 0.346885244507
Rred_3685 vin2.$480.Metal2 vin2.$7.GatPoly 161.378216951
Rred_3686 vin2.$480.Metal2 vin2.P0.GatPoly 240.616715671
Rred_3687 vin2.$483.Metal2 vin2.$486.Metal2 0.692446258504
Rred_3688 vin2.$483.Metal2 vin2.$488.Metal2 0.200294372294
Rred_3689 vin2.$484.Metal2 vin2.$486.Metal2 0.692446258504
Rred_3690 vin2.$484.Metal2 vin2.$489.Metal2 0.200294372294
Rred_3691 vin2.$486.Metal2 vin2.$488.Metal2 0.515651469098
Rred_3692 vin2.$486.Metal2 vin2.$489.Metal2 0.515651469098
Rred_3693 vin2.$486.Metal2 vin2.$495.Metal2 0.12144
Rred_3694 vin2.$488.Metal2 vin2.$492.Metal2 0.346876010592
Rred_3695 vin2.$489.Metal2 vin2.$493.Metal2 0.346876010592
Rred_3696 vin2.$492.Metal2 vin2.$495.Metal2 0.643273146381
Rred_3697 vin2.$492.Metal2 vin2.$499.Metal2 0.463026148652
Rred_3698 vin2.$493.Metal2 vin2.$495.Metal2 4.31912380951
Rred_3699 vin2.$493.Metal2 vin2.$498.Metal2 0.178476190476
Rred_3700 vin2.$495.Metal2 vin2.$498.Metal2 0.280462585034
Rred_3701 vin2.$495.Metal2 vin2.$499.Metal2 0.727612519313
Rred_3702 vin2.$495.Metal2 vin2.$506.Metal2 0.12144
Rred_3703 vin2.$498.Metal2 vin2.$504.Metal2 0.528548299458
Rred_3704 vin2.$499.Metal2 vin2.$503.Metal2 0.346883084067
Rred_3705 vin2.$503.Metal2 vin2.$506.Metal2 0.417099415205
Rred_3706 vin2.$503.Metal2 vin2.$508.Metal2 0.196484848485
Rred_3707 vin2.$504.Metal2 vin2.$506.Metal2 0.417099415205
Rred_3708 vin2.$504.Metal2 vin2.$509.Metal2 0.196484848485
Rred_3709 vin2.$506.Metal2 vin2.$508.Metal2 0.950986666669
Rred_3710 vin2.$506.Metal2 vin2.$509.Metal2 0.950986666669
Rred_3711 vin2.$506.Metal2 vin2.$515.Metal2 0.12144
Rred_3712 vin2.$508.Metal2 vin2.$512.Metal2 0.3468888772
Rred_3713 vin2.$509.Metal2 vin2.$513.Metal2 0.3468888772
Rred_3714 vin2.$512.Metal2 vin2.$515.Metal2 0.885199294533
Rred_3715 vin2.$512.Metal2 vin2.$517.Metal2 0.19751717122
Rred_3716 vin2.$513.Metal2 vin2.$515.Metal2 0.885199294533
Rred_3717 vin2.$513.Metal2 vin2.$518.Metal2 0.19751717122
Rred_3718 vin2.$515.Metal2 vin2.$517.Metal2 0.434552380953
Rred_3719 vin2.$515.Metal2 vin2.$518.Metal2 0.434552380953
Rred_3720 vin2.$515.Metal2 vin2.$524.Metal2 0.793988220725
Rred_3721 vin2.$515.Metal2 vin2.$525.Metal2 0.747094537052
Rred_3722 vin2.$515.Metal2 vin2.$529.Metal2 20.9083564791
Rred_3723 vin2.$515.Metal2 vin2.$535.Metal2 0.357864457583
Rred_3724 vin2.$517.Metal2 vin2.$519.Metal2 0.17180952381
Rred_3725 vin2.$518.Metal2 vin2.$524.Metal2 0.528590320902
Rred_3726 vin2.$519.Metal2 vin2.$52.GatPoly 111904.93744
Rred_3727 vin2.$519.Metal2 vin2.$525.Metal2 0.353544628822
Rred_3728 vin2.$52.GatPoly vin2.$525.Metal2 2027.68731673
Rred_3729 vin2.$52.GatPoly vin2.$56.GatPoly 26.7507621399
Rred_3730 vin2.$524.Metal2 vin2.$525.Metal2 1.65756685141
Rred_3731 vin2.$524.Metal2 vin2.$529.Metal2 0.17524885292
Rred_3732 vin2.$524.Metal2 vin2.$53.GatPoly 1989.57191416
Rred_3733 vin2.$524.Metal2 vin2.$535.Metal2 0.793988220725
Rred_3734 vin2.$525.Metal2 vin2.$529.Metal2 43.6492604206
Rred_3735 vin2.$525.Metal2 vin2.$532.Metal2 0.521902039577
Rred_3736 vin2.$525.Metal2 vin2.$535.Metal2 0.747094537052
Rred_3737 vin2.$529.Metal2 vin2.$533.Metal2 0.346869470833
Rred_3738 vin2.$529.Metal2 vin2.$535.Metal2 20.9083564791
Rred_3739 vin2.$529.Metal2 vin2.$59.GatPoly 2525.70222612
Rred_3740 vin2.$53.GatPoly vin2.$59.GatPoly 20.0625185185
Rred_3741 vin2.$532.Metal2 vin2.$535.Metal2 0.493407191448
Rred_3742 vin2.$532.Metal2 vin2.$537.Metal2 0.19980952381
Rred_3743 vin2.$533.Metal2 vin2.$535.Metal2 0.493407191448
Rred_3744 vin2.$533.Metal2 vin2.$538.Metal2 0.19980952381
Rred_3745 vin2.$533.Metal2 vin2.$59.GatPoly 8439.59448869
Rred_3746 vin2.$535.Metal2 vin2.$537.Metal2 0.732634920637
Rred_3747 vin2.$535.Metal2 vin2.$538.Metal2 0.732634920637
Rred_3748 vin2.$535.Metal2 vin2.$544.Metal2 0.12144
Rred_3749 vin2.$537.Metal2 vin2.$541.Metal2 0.346886758096
Rred_3750 vin2.$537.Metal2 vin2.$64.GatPoly 1611.09899248
Rred_3751 vin2.$538.Metal2 vin2.$542.Metal2 0.346876010592
Rred_3752 vin2.$538.Metal2 vin2.$65.GatPoly 1611.09899248
Rred_3753 vin2.$538.Metal2 vin2.$71.GatPoly 12405.3841055
Rred_3754 vin2.$541.Metal2 vin2.$544.Metal2 1.22615538847
Rred_3755 vin2.$541.Metal2 vin2.$546.Metal2 0.192530627203
Rred_3756 vin2.$541.Metal2 vin2.$72.GatPoly 3372.27982918
Rred_3757 vin2.$542.Metal2 vin2.$544.Metal2 0.546093875877
Rred_3758 vin2.$542.Metal2 vin2.$549.Metal2 0.457460174986
Rred_3759 vin2.$542.Metal2 vin2.$71.GatPoly 2301.94136839
Rred_3760 vin2.$544.Metal2 vin2.$546.Metal2 0.369792894936
Rred_3761 vin2.$544.Metal2 vin2.$549.Metal2 0.878613986878
Rred_3762 vin2.$544.Metal2 vin2.$555.Metal2 0.12144
Rred_3763 vin2.$546.Metal2 vin2.$550.Metal2 0.346891446111
Rred_3764 vin2.$546.Metal2 vin2.$72.GatPoly 4543.078818
Rred_3765 vin2.$549.Metal2 vin2.$553.Metal2 0.346898882339
Rred_3766 vin2.$549.Metal2 vin2.$79.GatPoly 1714.75888267
Rred_3767 vin2.$549.Metal2 vin2.$81.GatPoly 25055.8390465
Rred_3768 vin2.$550.Metal2 vin2.$555.Metal2 0.786467062936
Rred_3769 vin2.$550.Metal2 vin2.$557.Metal2 0.461480673293
Rred_3770 vin2.$550.Metal2 vin2.$76.GatPoly 3154.05582356
Rred_3771 vin2.$550.Metal2 vin2.$82.GatPoly 5361.89490005
Rred_3772 vin2.$553.Metal2 vin2.$555.Metal2 0.315849765258
Rred_3773 vin2.$553.Metal2 vin2.$558.Metal2 0.185333333333
Rred_3774 vin2.$553.Metal2 vin2.$83.GatPoly 2219.44741188
Rred_3775 vin2.$555.Metal2 vin2.$557.Metal2 0.599073779942
Rred_3776 vin2.$555.Metal2 vin2.$558.Metal2 2.03866666667
Rred_3777 vin2.$555.Metal2 vin2.$564.Metal2 0.12144
Rred_3778 vin2.$557.Metal2 vin2.$561.Metal2 0.346885087058
Rred_3779 vin2.$558.Metal2 vin2.$562.Metal2 0.346865293749
Rred_3780 vin2.$558.Metal2 vin2.$91.GatPoly 4494.85080275
Rred_3781 vin2.$56.GatPoly vin2.$64.GatPoly 36.1143032099
Rred_3782 vin2.$56.GatPoly vin2.P26.GatPoly 22.26
Rred_3783 vin2.$561.Metal2 vin2.$564.Metal2 0.592952380953
Rred_3784 vin2.$561.Metal2 vin2.$566.Metal2 0.200917748918
Rred_3785 vin2.$561.Metal2 vin2.$92.GatPoly 1716.610141
Rred_3786 vin2.$562.Metal2 vin2.$564.Metal2 0.592952380953
Rred_3787 vin2.$562.Metal2 vin2.$567.Metal2 0.200917748918
Rred_3788 vin2.$562.Metal2 vin2.$91.GatPoly 3453.79724991
Rred_3789 vin2.$564.Metal2 vin2.$566.Metal2 0.592952380953
Rred_3790 vin2.$564.Metal2 vin2.$567.Metal2 0.592952380953
Rred_3791 vin2.$564.Metal2 vin2.$573.Metal2 0.12144
Rred_3792 vin2.$566.Metal2 vin2.$570.Metal2 0.346885087058
Rred_3793 vin2.$567.Metal2 vin2.$571.Metal2 0.346872405043
Rred_3794 vin2.$567.Metal2 vin2.$95.GatPoly 1716.610141
Rred_3795 vin2.$570.Metal2 vin2.$573.Metal2 0.599073779942
Rred_3796 vin2.$570.Metal2 vin2.$577.Metal2 0.461480673293
Rred_3797 vin2.$571.Metal2 vin2.$573.Metal2 2.03866666667
Rred_3798 vin2.$571.Metal2 vin2.$576.Metal2 0.185333333333
Rred_3799 vin2.$573.Metal2 vin2.$576.Metal2 0.315849765258
Rred_3800 vin2.$573.Metal2 vin2.$577.Metal2 0.786467062936
Rred_3801 vin2.$573.Metal2 vin2.$584.Metal2 0.12144
Rred_3802 vin2.$576.Metal2 vin2.$580.Metal2 0.346898882339
Rred_3803 vin2.$577.Metal2 vin2.$581.Metal2 0.346891446111
Rred_3804 vin2.$580.Metal2 vin2.$584.Metal2 0.878613986878
Rred_3805 vin2.$580.Metal2 vin2.$587.Metal2 0.457460174986
Rred_3806 vin2.$581.Metal2 vin2.$584.Metal2 0.369792894936
Rred_3807 vin2.$581.Metal2 vin2.$586.Metal2 0.192530627203
Rred_3808 vin2.$584.Metal2 vin2.$586.Metal2 1.22615538847
Rred_3809 vin2.$584.Metal2 vin2.$587.Metal2 0.546093875877
Rred_3810 vin2.$584.Metal2 vin2.$593.Metal2 0.12144
Rred_3811 vin2.$586.Metal2 vin2.$590.Metal2 0.346886758096
Rred_3812 vin2.$587.Metal2 vin2.$591.Metal2 0.346876010592
Rred_3813 vin2.$59.GatPoly vin2.$65.GatPoly 60.50563664
Rred_3814 vin2.$59.GatPoly vin2.P6.GatPoly 7.97486881396
Rred_3815 vin2.$590.Metal2 vin2.$593.Metal2 0.732634920637
Rred_3816 vin2.$590.Metal2 vin2.$595.Metal2 0.19980952381
Rred_3817 vin2.$591.Metal2 vin2.$593.Metal2 0.732634920637
Rred_3818 vin2.$591.Metal2 vin2.$596.Metal2 0.19980952381
Rred_3819 vin2.$593.Metal2 vin2.$595.Metal2 0.493407191448
Rred_3820 vin2.$593.Metal2 vin2.$596.Metal2 0.493407191448
Rred_3821 vin2.$593.Metal2 vin2.$600.Metal2 20.9083564791
Rred_3822 vin2.$593.Metal2 vin2.$601.Metal2 0.747094537052
Rred_3823 vin2.$593.Metal2 vin2.$605.Metal2 0.793988220725
Rred_3824 vin2.$593.Metal2 vin2.$613.Metal2 0.357864457583
Rred_3825 vin2.$595.Metal2 vin2.$601.Metal2 0.521902039577
Rred_3826 vin2.$596.Metal2 vin2.$600.Metal2 0.346869470833
Rred_3827 vin2.$600.Metal2 vin2.$601.Metal2 43.6492604206
Rred_3828 vin2.$600.Metal2 vin2.$605.Metal2 0.17524885292
Rred_3829 vin2.$600.Metal2 vin2.$613.Metal2 20.9083564791
Rred_3830 vin2.$601.Metal2 vin2.$605.Metal2 1.65756685141
Rred_3831 vin2.$601.Metal2 vin2.$608.Metal2 0.353544628822
Rred_3832 vin2.$601.Metal2 vin2.$613.Metal2 0.747094537052
Rred_3833 vin2.$605.Metal2 vin2.$611.Metal2 0.528590320902
Rred_3834 vin2.$605.Metal2 vin2.$613.Metal2 0.793988220725
Rred_3835 vin2.$608.Metal2 vin2.$610.Metal2 0.17180952381
Rred_3836 vin2.$610.Metal2 vin2.$613.Metal2 0.434552380953
Rred_3837 vin2.$610.Metal2 vin2.$615.Metal2 0.19751717122
Rred_3838 vin2.$611.Metal2 vin2.$613.Metal2 0.434552380953
Rred_3839 vin2.$611.Metal2 vin2.$616.Metal2 0.19751717122
Rred_3840 vin2.$613.Metal2 vin2.$615.Metal2 0.885199294533
Rred_3841 vin2.$613.Metal2 vin2.$616.Metal2 0.885199294533
Rred_3842 vin2.$613.Metal2 vin2.$622.Metal2 0.12144
Rred_3843 vin2.$615.Metal2 vin2.$619.Metal2 0.3468888772
Rred_3844 vin2.$616.Metal2 vin2.$620.Metal2 0.3468888772
Rred_3845 vin2.$619.Metal2 vin2.$622.Metal2 0.950986666669
Rred_3846 vin2.$619.Metal2 vin2.$624.Metal2 0.196484848485
Rred_3847 vin2.$620.Metal2 vin2.$622.Metal2 0.950986666669
Rred_3848 vin2.$620.Metal2 vin2.$625.Metal2 0.196484848485
Rred_3849 vin2.$622.Metal2 vin2.$624.Metal2 0.417099415205
Rred_3850 vin2.$622.Metal2 vin2.$625.Metal2 0.417099415205
Rred_3851 vin2.$622.Metal2 vin2.$633.Metal2 0.12144
Rred_3852 vin2.$624.Metal2 vin2.$628.Metal2 0.346883084067
Rred_3853 vin2.$625.Metal2 vin2.$631.Metal2 0.528548299458
Rred_3854 vin2.$628.Metal2 vin2.$633.Metal2 0.727612519313
Rred_3855 vin2.$628.Metal2 vin2.$635.Metal2 0.463026148652
Rred_3856 vin2.$631.Metal2 vin2.$633.Metal2 0.280462585034
Rred_3857 vin2.$631.Metal2 vin2.$636.Metal2 0.178476190476
Rred_3858 vin2.$633.Metal2 vin2.$635.Metal2 0.643273146381
Rred_3859 vin2.$633.Metal2 vin2.$636.Metal2 4.31912380951
Rred_3860 vin2.$633.Metal2 vin2.$642.Metal2 0.12144
Rred_3861 vin2.$635.Metal2 vin2.$639.Metal2 0.346876010592
Rred_3862 vin2.$636.Metal2 vin2.$640.Metal2 0.346876010592
Rred_3863 vin2.$639.Metal2 vin2.$642.Metal2 0.515651469098
Rred_3864 vin2.$639.Metal2 vin2.$644.Metal2 0.200294372294
Rred_3865 vin2.$64.GatPoly vin2.$72.GatPoly 51.4620406015
Rred_3866 vin2.$64.GatPoly vin2.P27.GatPoly 72.5872454666
Rred_3867 vin2.$640.Metal2 vin2.$642.Metal2 0.515651469098
Rred_3868 vin2.$640.Metal2 vin2.$645.Metal2 0.200294372294
Rred_3869 vin2.$642.Metal2 vin2.$644.Metal2 0.692446258504
Rred_3870 vin2.$642.Metal2 vin2.$645.Metal2 0.692446258504
Rred_3871 vin2.$642.Metal2 vin2.$648.Metal2 2.98963708333
Rred_3872 vin2.$642.Metal2 vin2.$649.Metal2 3.5599249307
Rred_3873 vin2.$642.Metal2 vin2.$653.Metal2 0.781905083333
Rred_3874 vin2.$642.Metal2 vin2.$654.Metal2 0.931057289569
Rred_3875 vin2.$644.Metal2 vin2.$648.Metal2 0.346891446111
Rred_3876 vin2.$645.Metal2 vin2.$649.Metal2 0.346885244507
Rred_3877 vin2.$648.Metal2 vin2.$649.Metal2 53.5446887191
Rred_3878 vin2.$648.Metal2 vin2.$653.Metal2 0.182219103574
Rred_3879 vin2.$648.Metal2 vin2.$654.Metal2 14.0039955112
Rred_3880 vin2.$648.Metal2 vin2.P39.GatPoly 1960.12022876
Rred_3881 vin2.$649.Metal2 vin2.$653.Metal2 14.0039955112
Rred_3882 vin2.$649.Metal2 vin2.$654.Metal2 0.180822929899
Rred_3883 vin2.$649.Metal2 vin2.P19.GatPoly 1031.5624039
Rred_3884 vin2.$65.GatPoly vin2.$71.GatPoly 33.2347189542
Rred_3885 vin2.$65.GatPoly vin2.P6.GatPoly 123.431498746
Rred_3886 vin2.$65.GatPoly vin2.P7.GatPoly 30.8176484848
Rred_3887 vin2.$653.Metal2 vin2.$654.Metal2 3.66258344139
Rred_3888 vin2.$653.Metal2 vin2.P39.GatPoly 395.072001344
Rred_3889 vin2.$654.Metal2 vin2.P19.GatPoly 199.325141092
Rred_3890 vin2.$7.GatPoly vin2.P0.GatPoly 86.6806517579
Rred_3891 vin2.$7.GatPoly vin2.P1.GatPoly 19.9708444444
Rred_3892 vin2.$71.GatPoly vin2.$79.GatPoly 42.8025468312
Rred_3893 vin2.$71.GatPoly vin2.P7.GatPoly 12.9518899643
Rred_3894 vin2.$72.GatPoly vin2.$76.GatPoly 29.4260595885
Rred_3895 vin2.$72.GatPoly vin2.P27.GatPoly 93.7877994151
Rred_3896 vin2.$76.GatPoly vin2.$82.GatPoly 15.0537042157
Rred_3897 vin2.$76.GatPoly vin2.P28.GatPoly 22.26
Rred_3898 vin2.$79.GatPoly vin2.$81.GatPoly 11.1325184116
Rred_3899 vin2.$79.GatPoly vin2.P8.GatPoly 11.3586666667
Rred_3900 vin2.$8.GatPoly vin2.P20.GatPoly 365.489864519
Rred_3901 vin2.$8.GatPoly vin2.P21.GatPoly 22.26
Rred_3902 vin2.$81.GatPoly vin2.$83.GatPoly 7.93333333333
Rred_3903 vin2.$81.GatPoly vin2.P8.GatPoly 16.2266666667
Rred_3904 vin2.$82.GatPoly vin2.$86.GatPoly 30.7637083127
Rred_3905 vin2.$83.GatPoly vin2.$91.GatPoly 69.9469953425
Rred_3906 vin2.$83.GatPoly vin2.P9.GatPoly 79.2732613881
Rred_3907 vin2.$86.GatPoly vin2.$92.GatPoly 14.3546666667
Rred_3908 vin2.$86.GatPoly vin2.P29.GatPoly 22.26
Rred_3909 vin2.$91.GatPoly vin2.$95.GatPoly 20.0625185185
Rred_3910 vin2.$91.GatPoly vin2.P9.GatPoly 10.8227426436
Rred_3911 vin2.$92.GatPoly vin2.$96.GatPoly 32.101357037
Rred_3912 vin2.$95.GatPoly vin2.P10.GatPoly 39.9343777778
Rred_3913 vin2.$96.GatPoly vin2.P30.GatPoly 22.26
Rred_3914 vin3 vin3.$477.Metal2 1.24696
Rred_3915 vin3.$10.GatPoly vin3.$16.GatPoly 20.0625185185
Rred_3916 vin3.$10.GatPoly vin3.$202.Metal1 20.489591646
Rred_3917 vin3.$10.GatPoly vin3.$210.Metal1 16.8901542286
Rred_3918 vin3.$10.GatPoly vin3.$479.Metal2 23421.3890021
Rred_3919 vin3.$10.GatPoly vin3.$483.Metal2 2115.07400678
Rred_3920 vin3.$10.GatPoly vin3.$6.GatPoly 33.2847407407
Rred_3921 vin3.$10.GatPoly vin3.P1.GatPoly 19.9708444444
Rred_3922 vin3.$100.GatPoly vin3.$108.GatPoly 42.7425970977
Rred_3923 vin3.$100.GatPoly vin3.$334.Metal1 20.0890603495
Rred_3924 vin3.$100.GatPoly vin3.$342.Metal1 14.2883104861
Rred_3925 vin3.$100.GatPoly vin3.$348.Metal1 157.344579311
Rred_3926 vin3.$100.GatPoly vin3.$566.Metal2 10044.7987195
Rred_3927 vin3.$100.GatPoly vin3.$570.Metal2 2408.55915615
Rred_3928 vin3.$100.GatPoly vin3.$575.Metal2 11957.7663662
Rred_3929 vin3.$100.GatPoly vin3.$94.GatPoly 31.32108061
Rred_3930 vin3.$100.GatPoly vin3.P10.GatPoly 10.3860540384
Rred_3931 vin3.$105.GatPoly vin3.$107.GatPoly 15.0537042157
Rred_3932 vin3.$105.GatPoly vin3.$339.Metal1 123.604185185
Rred_3933 vin3.$105.GatPoly vin3.$343.Metal1 33.8281181896
Rred_3934 vin3.$105.GatPoly vin3.$347.Metal1 13.0141464528
Rred_3935 vin3.$105.GatPoly vin3.$353.Metal1 98.1690707437
Rred_3936 vin3.$105.GatPoly vin3.$578.Metal2 5361.89490005
Rred_3937 vin3.$105.GatPoly vin3.$97.GatPoly 30.7637083127
Rred_3938 vin3.$107.GatPoly vin3.$115.GatPoly 29.4260595885
Rred_3939 vin3.$107.GatPoly vin3.$347.Metal1 57.8243567653
Rred_3940 vin3.$107.GatPoly vin3.$353.Metal1 15.9311738026
Rred_3941 vin3.$107.GatPoly vin3.$357.Metal1 55.6375076253
Rred_3942 vin3.$107.GatPoly vin3.$578.Metal2 3154.05582356
Rred_3943 vin3.$107.GatPoly vin3.P31.GatPoly 22.26
Rred_3944 vin3.$108.GatPoly vin3.$110.GatPoly 11.1325184116
Rred_3945 vin3.$108.GatPoly vin3.$342.Metal1 36.757635223
Rred_3946 vin3.$108.GatPoly vin3.$348.Metal1 12.4547299484
Rred_3947 vin3.$108.GatPoly vin3.$356.Metal1 430.191522254
Rred_3948 vin3.$108.GatPoly vin3.$575.Metal2 4728.46648928
Rred_3949 vin3.$108.GatPoly vin3.$579.Metal2 25055.8390465
Rred_3950 vin3.$108.GatPoly vin3.P11.GatPoly 16.2266666667
Rred_3951 vin3.$110.GatPoly vin3.$118.GatPoly 42.8025468312
Rred_3952 vin3.$110.GatPoly vin3.$348.Metal1 31.5600123225
Rred_3953 vin3.$110.GatPoly vin3.$356.Metal1 15.334097558
Rred_3954 vin3.$110.GatPoly vin3.$360.Metal1 80.9291851852
Rred_3955 vin3.$110.GatPoly vin3.$579.Metal2 1714.75888267
Rred_3956 vin3.$110.GatPoly vin3.P11.GatPoly 11.3586666667
Rred_3957 vin3.$115.GatPoly vin3.$123.GatPoly 51.4620406015
Rred_3958 vin3.$115.GatPoly vin3.$353.Metal1 135.119661376
Rred_3959 vin3.$115.GatPoly vin3.$357.Metal1 16.0835537092
Rred_3960 vin3.$115.GatPoly vin3.$365.Metal1 15.9974348707
Rred_3961 vin3.$115.GatPoly vin3.$369.Metal1 97.3021776078
Rred_3962 vin3.$115.GatPoly vin3.$582.Metal2 4543.078818
Rred_3963 vin3.$115.GatPoly vin3.$587.Metal2 3372.27982918
Rred_3964 vin3.$115.GatPoly vin3.P32.GatPoly 93.7877994151
Rred_3965 vin3.$118.GatPoly vin3.$122.GatPoly 33.2347189542
Rred_3966 vin3.$118.GatPoly vin3.$356.Metal1 80.9291851852
Rred_3967 vin3.$118.GatPoly vin3.$360.Metal1 15.5987328054
Rred_3968 vin3.$118.GatPoly vin3.$368.Metal1 20.4860406756
Rred_3969 vin3.$118.GatPoly vin3.$586.Metal2 2301.94136839
Rred_3970 vin3.$118.GatPoly vin3.$590.Metal2 12405.3841055
Rred_3971 vin3.$118.GatPoly vin3.P12.GatPoly 12.9518899643
Rred_3972 vin3.$122.GatPoly vin3.$130.GatPoly 60.50563664
Rred_3973 vin3.$122.GatPoly vin3.$368.Metal1 18.2531011901
Rred_3974 vin3.$122.GatPoly vin3.$374.Metal1 15.6601627124
Rred_3975 vin3.$122.GatPoly vin3.$378.Metal1 84.9923100066
Rred_3976 vin3.$122.GatPoly vin3.$590.Metal2 1611.09899248
Rred_3977 vin3.$122.GatPoly vin3.P12.GatPoly 30.8176484848
Rred_3978 vin3.$122.GatPoly vin3.P13.GatPoly 123.431498746
Rred_3979 vin3.$123.GatPoly vin3.$127.GatPoly 36.1143032099
Rred_3980 vin3.$123.GatPoly vin3.$365.Metal1 97.3021776078
Rred_3981 vin3.$123.GatPoly vin3.$369.Metal1 16.2930131079
Rred_3982 vin3.$123.GatPoly vin3.$375.Metal1 15.7999014456
Rred_3983 vin3.$123.GatPoly vin3.$379.Metal1 96.7347407407
Rred_3984 vin3.$123.GatPoly vin3.$591.Metal2 1611.09899248
Rred_3985 vin3.$123.GatPoly vin3.P32.GatPoly 72.5872454666
Rred_3986 vin3.$127.GatPoly vin3.$135.GatPoly 26.7507621399
Rred_3987 vin3.$127.GatPoly vin3.$375.Metal1 68.2833464052
Rred_3988 vin3.$127.GatPoly vin3.$379.Metal1 27.001323271
Rred_3989 vin3.$127.GatPoly vin3.$383.Metal1 20.0005513629
Rred_3990 vin3.$127.GatPoly vin3.$387.Metal1 50.5791721133
Rred_3991 vin3.$127.GatPoly vin3.P33.GatPoly 22.26
Rred_3992 vin3.$130.GatPoly vin3.$134.GatPoly 20.0625185185
Rred_3993 vin3.$130.GatPoly vin3.$374.Metal1 114.401413815
Rred_3994 vin3.$130.GatPoly vin3.$378.Metal1 18.1851091752
Rred_3995 vin3.$130.GatPoly vin3.$386.Metal1 16.8812213797
Rred_3996 vin3.$130.GatPoly vin3.$595.Metal2 8439.59448869
Rred_3997 vin3.$130.GatPoly vin3.$599.Metal2 2525.70222612
Rred_3998 vin3.$130.GatPoly vin3.P13.GatPoly 7.97486881396
Rred_3999 vin3.$134.GatPoly vin3.$136.GatPoly 17.2080405764
Rred_4000 vin3.$134.GatPoly vin3.$386.Metal1 16.9633899809
Rred_4001 vin3.$134.GatPoly vin3.$392.Metal1 17.7474958524
Rred_4002 vin3.$134.GatPoly vin3.$396.Metal1 2936.27252746
Rred_4003 vin3.$134.GatPoly vin3.$604.Metal2 1989.57191416
Rred_4004 vin3.$135.GatPoly vin3.$137.GatPoly 17.2080405764
Rred_4005 vin3.$135.GatPoly vin3.$383.Metal1 171.969185185
Rred_4006 vin3.$135.GatPoly vin3.$387.Metal1 16.3265000824
Rred_4007 vin3.$135.GatPoly vin3.$393.Metal1 17.7474001705
Rred_4008 vin3.$135.GatPoly vin3.$397.Metal1 2936.27252746
Rred_4009 vin3.$135.GatPoly vin3.$603.Metal2 2027.68731673
Rred_4010 vin3.$135.GatPoly vin3.$609.Metal2 111904.93744
Rred_4011 vin3.$136.GatPoly vin3.$144.GatPoly 25.4131134156
Rred_4012 vin3.$136.GatPoly vin3.$392.Metal1 33.0203657934
Rred_4013 vin3.$136.GatPoly vin3.$396.Metal1 18.8410085241
Rred_4014 vin3.$136.GatPoly vin3.$400.Metal1 48.0500043573
Rred_4015 vin3.$136.GatPoly vin3.P14.GatPoly 4.76
Rred_4016 vin3.$137.GatPoly vin3.$145.GatPoly 25.4131134156
Rred_4017 vin3.$137.GatPoly vin3.$393.Metal1 33.0203657934
Rred_4018 vin3.$137.GatPoly vin3.$397.Metal1 18.8410085241
Rred_4019 vin3.$137.GatPoly vin3.$401.Metal1 48.0500043573
Rred_4020 vin3.$137.GatPoly vin3.P34.GatPoly 22.26
Rred_4021 vin3.$144.GatPoly vin3.$152.GatPoly 80.7317467344
Rred_4022 vin3.$144.GatPoly vin3.$396.Metal1 204.212518518
Rred_4023 vin3.$144.GatPoly vin3.$400.Metal1 16.3459334659
Rred_4024 vin3.$144.GatPoly vin3.$408.Metal1 16.4300806005
Rred_4025 vin3.$144.GatPoly vin3.$412.Metal1 152.644058952
Rred_4026 vin3.$144.GatPoly vin3.$610.Metal2 3870.9558658
Rred_4027 vin3.$144.GatPoly vin3.$615.Metal2 3870.9558658
Rred_4028 vin3.$144.GatPoly vin3.P15.GatPoly 38.1468722988
Rred_4029 vin3.$145.GatPoly vin3.$153.GatPoly 50.9131933514
Rred_4030 vin3.$145.GatPoly vin3.$397.Metal1 204.212518518
Rred_4031 vin3.$145.GatPoly vin3.$401.Metal1 16.3459334659
Rred_4032 vin3.$145.GatPoly vin3.$409.Metal1 15.8678203345
Rred_4033 vin3.$145.GatPoly vin3.$413.Metal1 96.2644412107
Rred_4034 vin3.$145.GatPoly vin3.$611.Metal2 3870.9558658
Rred_4035 vin3.$145.GatPoly vin3.$616.Metal2 3870.9558658
Rred_4036 vin3.$145.GatPoly vin3.P35.GatPoly 112.502748125
Rred_4037 vin3.$15.GatPoly vin3.$17.GatPoly 8.64681481481
Rred_4038 vin3.$15.GatPoly vin3.$219.Metal1 12.6296021429
Rred_4039 vin3.$15.GatPoly vin3.$227.Metal1 37.7619085138
Rred_4040 vin3.$15.GatPoly vin3.$27.GatPoly 41.3580961617
Rred_4041 vin3.$15.GatPoly vin3.$493.Metal2 2934.89262124
Rred_4042 vin3.$15.GatPoly vin3.P22.GatPoly 22.26
Rred_4043 vin3.$152.GatPoly vin3.$156.GatPoly 40.1272493827
Rred_4044 vin3.$152.GatPoly vin3.$408.Metal1 152.644058952
Rred_4045 vin3.$152.GatPoly vin3.$412.Metal1 18.6069469566
Rred_4046 vin3.$152.GatPoly vin3.$418.Metal1 15.6802121879
Rred_4047 vin3.$152.GatPoly vin3.$422.Metal1 85.9869629629
Rred_4048 vin3.$152.GatPoly vin3.$619.Metal2 1563.02782058
Rred_4049 vin3.$152.GatPoly vin3.P15.GatPoly 21.4418885263
Rred_4050 vin3.$153.GatPoly vin3.$157.GatPoly 40.1272493827
Rred_4051 vin3.$153.GatPoly vin3.$409.Metal1 96.2644412107
Rred_4052 vin3.$153.GatPoly vin3.$413.Metal1 16.5099701104
Rred_4053 vin3.$153.GatPoly vin3.$419.Metal1 15.6802121879
Rred_4054 vin3.$153.GatPoly vin3.$423.Metal1 85.9869629629
Rred_4055 vin3.$153.GatPoly vin3.$620.Metal2 1563.02782058
Rred_4056 vin3.$153.GatPoly vin3.P35.GatPoly 63.2364133369
Rred_4057 vin3.$156.GatPoly vin3.$164.GatPoly 22.7378159671
Rred_4058 vin3.$156.GatPoly vin3.$418.Metal1 75.8708496732
Rred_4059 vin3.$156.GatPoly vin3.$422.Metal1 30.0016540887
Rred_4060 vin3.$156.GatPoly vin3.$426.Metal1 17.0002205452
Rred_4061 vin3.$156.GatPoly vin3.$430.Metal1 42.9916688453
Rred_4062 vin3.$156.GatPoly vin3.P16.GatPoly 4.76
Rred_4063 vin3.$157.GatPoly vin3.$163.GatPoly 9.36029629629
Rred_4064 vin3.$157.GatPoly vin3.$419.Metal1 75.8708496732
Rred_4065 vin3.$157.GatPoly vin3.$423.Metal1 30.0016540887
Rred_4066 vin3.$157.GatPoly vin3.$427.Metal1 17.6980392157
Rred_4067 vin3.$157.GatPoly vin3.P36.GatPoly 22.26
Rred_4068 vin3.$16.GatPoly vin3.$210.Metal1 16.8857192322
Rred_4069 vin3.$16.GatPoly vin3.$218.Metal1 19.3496497775
Rred_4070 vin3.$16.GatPoly vin3.$22.GatPoly 77.9511897103
Rred_4071 vin3.$16.GatPoly vin3.$222.Metal1 147.386703234
Rred_4072 vin3.$16.GatPoly vin3.$488.Metal2 2301.94136839
Rred_4073 vin3.$16.GatPoly vin3.$492.Metal2 12405.3841055
Rred_4074 vin3.$16.GatPoly vin3.P2.GatPoly 19.176544151
Rred_4075 vin3.$163.GatPoly vin3.$167.GatPoly 41.3580961617
Rred_4076 vin3.$163.GatPoly vin3.$427.Metal1 27.2939474766
Rred_4077 vin3.$163.GatPoly vin3.$433.Metal1 14.2581745852
Rred_4078 vin3.$163.GatPoly vin3.$441.Metal1 115.651204718
Rred_4079 vin3.$163.GatPoly vin3.$629.Metal2 2664.67413314
Rred_4080 vin3.$163.GatPoly vin3.$636.Metal2 6114.14760608
Rred_4081 vin3.$164.GatPoly vin3.$172.GatPoly 77.9511897103
Rred_4082 vin3.$164.GatPoly vin3.$426.Metal1 365.429185185
Rred_4083 vin3.$164.GatPoly vin3.$430.Metal1 16.5931436324
Rred_4084 vin3.$164.GatPoly vin3.$437.Metal1 16.2158441731
Rred_4085 vin3.$164.GatPoly vin3.$440.Metal1 147.386703234
Rred_4086 vin3.$164.GatPoly vin3.$630.Metal2 1836.80456241
Rred_4087 vin3.$164.GatPoly vin3.P17.GatPoly 42.9114848609
Rred_4088 vin3.$167.GatPoly vin3.$173.GatPoly 8.64681481481
Rred_4089 vin3.$167.GatPoly vin3.$433.Metal1 37.7619085138
Rred_4090 vin3.$167.GatPoly vin3.$441.Metal1 12.6296021429
Rred_4091 vin3.$167.GatPoly vin3.$636.Metal2 2934.89262124
Rred_4092 vin3.$167.GatPoly vin3.P37.GatPoly 22.26
Rred_4093 vin3.$17.GatPoly vin3.$207.Metal1 80.9291851852
Rred_4094 vin3.$17.GatPoly vin3.$211.Metal1 15.5987328054
Rred_4095 vin3.$17.GatPoly vin3.$219.Metal1 27.3987871831
Rred_4096 vin3.$17.GatPoly vin3.$489.Metal2 2301.94136839
Rred_4097 vin3.$17.GatPoly vin3.$493.Metal2 12405.3841055
Rred_4098 vin3.$17.GatPoly vin3.$9.GatPoly 42.8025468312
Rred_4099 vin3.$172.GatPoly vin3.$176.GatPoly 20.0625185185
Rred_4100 vin3.$172.GatPoly vin3.$437.Metal1 147.386703234
Rred_4101 vin3.$172.GatPoly vin3.$440.Metal1 19.3496497775
Rred_4102 vin3.$172.GatPoly vin3.$448.Metal1 16.8857192322
Rred_4103 vin3.$172.GatPoly vin3.$635.Metal2 12405.3841055
Rred_4104 vin3.$172.GatPoly vin3.$639.Metal2 2301.94136839
Rred_4105 vin3.$172.GatPoly vin3.P17.GatPoly 19.176544151
Rred_4106 vin3.$173.GatPoly vin3.$179.GatPoly 42.8025468312
Rred_4107 vin3.$173.GatPoly vin3.$441.Metal1 27.3987871831
Rred_4108 vin3.$173.GatPoly vin3.$449.Metal1 15.5987328054
Rred_4109 vin3.$173.GatPoly vin3.$453.Metal1 80.9291851852
Rred_4110 vin3.$173.GatPoly vin3.$636.Metal2 12405.3841055
Rred_4111 vin3.$173.GatPoly vin3.$640.Metal2 2301.94136839
Rred_4112 vin3.$176.GatPoly vin3.$180.GatPoly 33.2847407407
Rred_4113 vin3.$176.GatPoly vin3.$448.Metal1 16.8901542286
Rred_4114 vin3.$176.GatPoly vin3.$456.Metal1 20.489591646
Rred_4115 vin3.$176.GatPoly vin3.$644.Metal2 2115.07400678
Rred_4116 vin3.$176.GatPoly vin3.$648.Metal2 23421.3890021
Rred_4117 vin3.$176.GatPoly vin3.P18.GatPoly 19.9708444444
Rred_4118 vin3.$179.GatPoly vin3.$449.Metal1 80.9291851852
Rred_4119 vin3.$179.GatPoly vin3.$453.Metal1 32.0018746339
Rred_4120 vin3.$179.GatPoly vin3.$457.Metal1 8.16033769425
Rred_4121 vin3.$179.GatPoly vin3.$649.Metal2 877.519802179
Rred_4122 vin3.$179.GatPoly vin3.$654.Metal2 295.150090209
Rred_4123 vin3.$179.GatPoly vin3.P38.GatPoly 22.26
Rred_4124 vin3.$179.GatPoly vin3.P39.GatPoly 365.628758224
Rred_4125 vin3.$180.GatPoly vin3.$456.Metal1 8.0987663346
Rred_4126 vin3.$180.GatPoly vin3.$648.Metal2 456.549538848
Rred_4127 vin3.$180.GatPoly vin3.$653.Metal2 158.542646647
Rred_4128 vin3.$180.GatPoly vin3.P18.GatPoly 19.9708444444
Rred_4129 vin3.$180.GatPoly vin3.P19.GatPoly 86.7094752085
Rred_4130 vin3.$202.Metal1 vin3.$210.Metal1 0.362310386809
Rred_4131 vin3.$202.Metal1 vin3.$477.Metal2 15.7883328011
Rred_4132 vin3.$202.Metal1 vin3.$479.Metal2 3.68923170446
Rred_4133 vin3.$202.Metal1 vin3.$483.Metal2 11.4454036843
Rred_4134 vin3.$202.Metal1 vin3.$6.GatPoly 8.08946310818
Rred_4135 vin3.$202.Metal1 vin3.P0.GatPoly 21.8775056486
Rred_4136 vin3.$202.Metal1 vin3.P1.GatPoly 37.76
Rred_4137 vin3.$203.Metal1 vin3.$207.Metal1 0.178496116933
Rred_4138 vin3.$203.Metal1 vin3.$477.Metal2 15.3809322347
Rred_4139 vin3.$203.Metal1 vin3.$480.Metal2 3.67675955388
Rred_4140 vin3.$203.Metal1 vin3.$484.Metal2 20.9909233253
Rred_4141 vin3.$203.Metal1 vin3.$9.GatPoly 8.15512705888
Rred_4142 vin3.$203.Metal1 vin3.P20.GatPoly 41.4017255522
Rred_4143 vin3.$207.Metal1 vin3.$211.Metal1 0.178675191093
Rred_4144 vin3.$207.Metal1 vin3.$480.Metal2 137.607164021
Rred_4145 vin3.$207.Metal1 vin3.$484.Metal2 12.426647102
Rred_4146 vin3.$207.Metal1 vin3.$9.GatPoly 32.0018746339
Rred_4147 vin3.$210.Metal1 vin3.$218.Metal1 0.362653569415
Rred_4148 vin3.$210.Metal1 vin3.$479.Metal2 279.314226443
Rred_4149 vin3.$210.Metal1 vin3.$483.Metal2 12.9766510302
Rred_4150 vin3.$210.Metal1 vin3.$488.Metal2 11.5186194376
Rred_4151 vin3.$210.Metal1 vin3.$492.Metal2 148.012303013
Rred_4152 vin3.$211.Metal1 vin3.$219.Metal1 0.362653569415
Rred_4153 vin3.$211.Metal1 vin3.$484.Metal2 26.726552795
Rred_4154 vin3.$211.Metal1 vin3.$489.Metal2 11.5186194376
Rred_4155 vin3.$211.Metal1 vin3.$493.Metal2 148.012303013
Rred_4156 vin3.$211.Metal1 vin3.$9.GatPoly 80.9291851852
Rred_4157 vin3.$218.Metal1 vin3.$22.GatPoly 147.386703234
Rred_4158 vin3.$218.Metal1 vin3.$222.Metal1 0.178129923539
Rred_4159 vin3.$218.Metal1 vin3.$488.Metal2 12.8905653645
Rred_4160 vin3.$218.Metal1 vin3.$492.Metal2 18.9451496641
Rred_4161 vin3.$218.Metal1 vin3.P2.GatPoly 36.2581717142
Rred_4162 vin3.$219.Metal1 vin3.$227.Metal1 0.39094415179
Rred_4163 vin3.$219.Metal1 vin3.$27.GatPoly 115.651204718
Rred_4164 vin3.$219.Metal1 vin3.$489.Metal2 12.8905653645
Rred_4165 vin3.$219.Metal1 vin3.$493.Metal2 9.17818171348
Rred_4166 vin3.$22.GatPoly vin3.$222.Metal1 16.2158441731
Rred_4167 vin3.$22.GatPoly vin3.$228.Metal1 16.5931436324
Rred_4168 vin3.$22.GatPoly vin3.$232.Metal1 365.429185185
Rred_4169 vin3.$22.GatPoly vin3.$24.GatPoly 22.7378159671
Rred_4170 vin3.$22.GatPoly vin3.$497.Metal2 1836.80456241
Rred_4171 vin3.$22.GatPoly vin3.P2.GatPoly 42.9114848609
Rred_4172 vin3.$222.Metal1 vin3.$228.Metal1 0.36174266925
Rred_4173 vin3.$222.Metal1 vin3.$492.Metal2 9.42324175824
Rred_4174 vin3.$222.Metal1 vin3.$497.Metal2 21.8084097251
Rred_4175 vin3.$222.Metal1 vin3.P2.GatPoly 81.1351604514
Rred_4176 vin3.$227.Metal1 vin3.$233.Metal1 0.331848942782
Rred_4177 vin3.$227.Metal1 vin3.$27.GatPoly 14.2581745852
Rred_4178 vin3.$227.Metal1 vin3.$493.Metal2 11.1591689028
Rred_4179 vin3.$227.Metal1 vin3.$495.Metal2 38.1149573586
Rred_4180 vin3.$227.Metal1 vin3.$500.Metal2 12.4168010073
Rred_4181 vin3.$228.Metal1 vin3.$232.Metal1 0.178852088262
Rred_4182 vin3.$228.Metal1 vin3.$236.Metal1 4036.92165822
Rred_4183 vin3.$228.Metal1 vin3.$24.GatPoly 42.9916688453
Rred_4184 vin3.$228.Metal1 vin3.$497.Metal2 9.12759240183
Rred_4185 vin3.$228.Metal1 vin3.$503.Metal2 43.9859302507
Rred_4186 vin3.$232.Metal1 vin3.$236.Metal1 0.17894182666
Rred_4187 vin3.$232.Metal1 vin3.$24.GatPoly 17.0002205452
Rred_4188 vin3.$232.Metal1 vin3.$497.Metal2 23.8007022261
Rred_4189 vin3.$232.Metal1 vin3.$503.Metal2 22.6413748687
Rred_4190 vin3.$233.Metal1 vin3.$237.Metal1 0.178949087371
Rred_4191 vin3.$233.Metal1 vin3.$25.GatPoly 17.6980392157
Rred_4192 vin3.$233.Metal1 vin3.$27.GatPoly 27.2939474766
Rred_4193 vin3.$233.Metal1 vin3.$500.Metal2 10.4731205828
Rred_4194 vin3.$233.Metal1 vin3.$504.Metal2 42.814045977
Rred_4195 vin3.$236.Metal1 vin3.$24.GatPoly 30.0016540887
Rred_4196 vin3.$236.Metal1 vin3.$240.Metal1 0.178504947966
Rred_4197 vin3.$236.Metal1 vin3.$36.GatPoly 85.9869629629
Rred_4198 vin3.$236.Metal1 vin3.$497.Metal2 48.5088769371
Rred_4199 vin3.$236.Metal1 vin3.$503.Metal2 15.140503946
Rred_4200 vin3.$237.Metal1 vin3.$241.Metal1 0.178504947966
Rred_4201 vin3.$237.Metal1 vin3.$25.GatPoly 30.0016540887
Rred_4202 vin3.$237.Metal1 vin3.$37.GatPoly 85.9869629629
Rred_4203 vin3.$237.Metal1 vin3.$500.Metal2 31.8360854701
Rred_4204 vin3.$237.Metal1 vin3.$504.Metal2 17.9090803107
Rred_4205 vin3.$24.GatPoly vin3.$240.Metal1 75.8708496732
Rred_4206 vin3.$24.GatPoly vin3.$36.GatPoly 40.1272493827
Rred_4207 vin3.$24.GatPoly vin3.P3.GatPoly 4.76
Rred_4208 vin3.$240.Metal1 vin3.$246.Metal1 0.36182906056
Rred_4209 vin3.$240.Metal1 vin3.$36.GatPoly 15.6802121879
Rred_4210 vin3.$240.Metal1 vin3.$503.Metal2 11.5864555256
Rred_4211 vin3.$240.Metal1 vin3.$508.Metal2 18.0168451015
Rred_4212 vin3.$241.Metal1 vin3.$247.Metal1 0.36182906056
Rred_4213 vin3.$241.Metal1 vin3.$25.GatPoly 75.8708496732
Rred_4214 vin3.$241.Metal1 vin3.$37.GatPoly 15.6802121879
Rred_4215 vin3.$241.Metal1 vin3.$504.Metal2 11.5864555256
Rred_4216 vin3.$241.Metal1 vin3.$509.Metal2 18.0168451015
Rred_4217 vin3.$246.Metal1 vin3.$250.Metal1 0.17852453123
Rred_4218 vin3.$246.Metal1 vin3.$36.GatPoly 18.6069469566
Rred_4219 vin3.$246.Metal1 vin3.$42.GatPoly 152.644058952
Rred_4220 vin3.$246.Metal1 vin3.$508.Metal2 10.1769943283
Rred_4221 vin3.$246.Metal1 vin3.$512.Metal2 22.5350597402
Rred_4222 vin3.$246.Metal1 vin3.P4.GatPoly 40.541385869
Rred_4223 vin3.$247.Metal1 vin3.$251.Metal1 0.178459879632
Rred_4224 vin3.$247.Metal1 vin3.$37.GatPoly 16.5099701104
Rred_4225 vin3.$247.Metal1 vin3.$43.GatPoly 96.2644412107
Rred_4226 vin3.$247.Metal1 vin3.$509.Metal2 10.1769943283
Rred_4227 vin3.$247.Metal1 vin3.$513.Metal2 22.5350597402
Rred_4228 vin3.$247.Metal1 vin3.P24.GatPoly 119.564647066
Rred_4229 vin3.$25.GatPoly vin3.$27.GatPoly 9.36029629629
Rred_4230 vin3.$25.GatPoly vin3.$37.GatPoly 40.1272493827
Rred_4231 vin3.$25.GatPoly vin3.P23.GatPoly 22.26
Rred_4232 vin3.$250.Metal1 vin3.$258.Metal1 0.362824398622
Rred_4233 vin3.$250.Metal1 vin3.$36.GatPoly 152.644058952
Rred_4234 vin3.$250.Metal1 vin3.$42.GatPoly 16.4300806005
Rred_4235 vin3.$250.Metal1 vin3.$508.Metal2 95.3406373629
Rred_4236 vin3.$250.Metal1 vin3.$512.Metal2 10.1192256903
Rred_4237 vin3.$250.Metal1 vin3.$517.Metal2 46.1776507338
Rred_4238 vin3.$250.Metal1 vin3.P4.GatPoly 72.1264392205
Rred_4239 vin3.$251.Metal1 vin3.$259.Metal1 0.362824398622
Rred_4240 vin3.$251.Metal1 vin3.$37.GatPoly 96.2644412107
Rred_4241 vin3.$251.Metal1 vin3.$43.GatPoly 15.8678203345
Rred_4242 vin3.$251.Metal1 vin3.$509.Metal2 95.3406373629
Rred_4243 vin3.$251.Metal1 vin3.$513.Metal2 10.1192256903
Rred_4244 vin3.$251.Metal1 vin3.$518.Metal2 46.1776507338
Rred_4245 vin3.$251.Metal1 vin3.P24.GatPoly 212.715280069
Rred_4246 vin3.$258.Metal1 vin3.$262.Metal1 0.178550748274
Rred_4247 vin3.$258.Metal1 vin3.$264.Metal1 7610.30667437
Rred_4248 vin3.$258.Metal1 vin3.$42.GatPoly 16.3459334659
Rred_4249 vin3.$258.Metal1 vin3.$44.GatPoly 48.0500043573
Rred_4250 vin3.$258.Metal1 vin3.$512.Metal2 46.1776507338
Rred_4251 vin3.$258.Metal1 vin3.$517.Metal2 9.7817715397
Rred_4252 vin3.$258.Metal1 vin3.$523.Metal2 145.280351752
Rred_4253 vin3.$259.Metal1 vin3.$263.Metal1 0.178557568839
Rred_4254 vin3.$259.Metal1 vin3.$43.GatPoly 16.3459334659
Rred_4255 vin3.$259.Metal1 vin3.$47.GatPoly 48.0500043573
Rred_4256 vin3.$259.Metal1 vin3.$513.Metal2 46.1776507338
Rred_4257 vin3.$259.Metal1 vin3.$518.Metal2 11.3207867366
Rred_4258 vin3.$259.Metal1 vin3.$520.Metal2 47.2209706961
Rred_4259 vin3.$262.Metal1 vin3.$264.Metal1 0.180721425263
Rred_4260 vin3.$262.Metal1 vin3.$42.GatPoly 204.212518518
Rred_4261 vin3.$262.Metal1 vin3.$44.GatPoly 18.8410085241
Rred_4262 vin3.$262.Metal1 vin3.$517.Metal2 17.0071631934
Rred_4263 vin3.$262.Metal1 vin3.$52.GatPoly 2936.27252746
Rred_4264 vin3.$262.Metal1 vin3.$523.Metal2 34.3389922323
Rred_4265 vin3.$263.Metal1 vin3.$265.Metal1 0.180739583769
Rred_4266 vin3.$263.Metal1 vin3.$43.GatPoly 204.212518518
Rred_4267 vin3.$263.Metal1 vin3.$47.GatPoly 18.8410085241
Rred_4268 vin3.$263.Metal1 vin3.$520.Metal2 11.1613203463
Rred_4269 vin3.$263.Metal1 vin3.$53.GatPoly 2936.27252746
Rred_4270 vin3.$264.Metal1 vin3.$272.Metal1 0.358974281487
Rred_4271 vin3.$264.Metal1 vin3.$44.GatPoly 33.0203657934
Rred_4272 vin3.$264.Metal1 vin3.$517.Metal2 27.6894597146
Rred_4273 vin3.$264.Metal1 vin3.$52.GatPoly 17.7474958524
Rred_4274 vin3.$264.Metal1 vin3.$523.Metal2 8.62947986197
Rred_4275 vin3.$265.Metal1 vin3.$273.Metal1 0.358969093271
Rred_4276 vin3.$265.Metal1 vin3.$47.GatPoly 33.0203657934
Rred_4277 vin3.$265.Metal1 vin3.$520.Metal2 17.6141428574
Rred_4278 vin3.$265.Metal1 vin3.$527.Metal2 10.4000814367
Rred_4279 vin3.$265.Metal1 vin3.$53.GatPoly 17.7474001705
Rred_4280 vin3.$27.GatPoly vin3.$493.Metal2 6114.14760608
Rred_4281 vin3.$27.GatPoly vin3.$500.Metal2 2664.67413314
Rred_4282 vin3.$272.Metal1 vin3.$280.Metal1 0.362797942164
Rred_4283 vin3.$272.Metal1 vin3.$52.GatPoly 16.9633899809
Rred_4284 vin3.$272.Metal1 vin3.$523.Metal2 15.0113662187
Rred_4285 vin3.$272.Metal1 vin3.$528.Metal2 10.3514401745
Rred_4286 vin3.$272.Metal1 vin3.$532.Metal2 100.688434264
Rred_4287 vin3.$272.Metal1 vin3.$58.GatPoly 16.8812213797
Rred_4288 vin3.$273.Metal1 vin3.$277.Metal1 0.178843777497
Rred_4289 vin3.$273.Metal1 vin3.$281.Metal1 4137.53229591
Rred_4290 vin3.$273.Metal1 vin3.$520.Metal2 844.325347394
Rred_4291 vin3.$273.Metal1 vin3.$527.Metal2 9.30100123455
Rred_4292 vin3.$273.Metal1 vin3.$53.GatPoly 16.3265000824
Rred_4293 vin3.$273.Metal1 vin3.$533.Metal2 49.717844922
Rred_4294 vin3.$273.Metal1 vin3.$57.GatPoly 50.5791721133
Rred_4295 vin3.$277.Metal1 vin3.$281.Metal1 0.178898601437
Rred_4296 vin3.$277.Metal1 vin3.$527.Metal2 22.3566696457
Rred_4297 vin3.$277.Metal1 vin3.$53.GatPoly 171.969185185
Rred_4298 vin3.$277.Metal1 vin3.$533.Metal2 24.1058961615
Rred_4299 vin3.$277.Metal1 vin3.$57.GatPoly 20.0005513629
Rred_4300 vin3.$280.Metal1 vin3.$284.Metal1 0.178374896227
Rred_4301 vin3.$280.Metal1 vin3.$528.Metal2 14.7413390447
Rred_4302 vin3.$280.Metal1 vin3.$532.Metal2 15.9997708552
Rred_4303 vin3.$280.Metal1 vin3.$58.GatPoly 18.1851091752
Rred_4304 vin3.$280.Metal1 vin3.$64.GatPoly 84.9923100066
Rred_4305 vin3.$280.Metal1 vin3.P6.GatPoly 92.2851475241
Rred_4306 vin3.$281.Metal1 vin3.$285.Metal1 0.178398933563
Rred_4307 vin3.$281.Metal1 vin3.$527.Metal2 43.4328267333
Rred_4308 vin3.$281.Metal1 vin3.$533.Metal2 15.7349129944
Rred_4309 vin3.$281.Metal1 vin3.$57.GatPoly 27.001323271
Rred_4310 vin3.$281.Metal1 vin3.$65.GatPoly 96.7347407407
Rred_4311 vin3.$284.Metal1 vin3.$290.Metal1 0.361824121591
Rred_4312 vin3.$284.Metal1 vin3.$532.Metal2 10.7656516291
Rred_4313 vin3.$284.Metal1 vin3.$537.Metal2 19.1286039107
Rred_4314 vin3.$284.Metal1 vin3.$58.GatPoly 114.401413815
Rred_4315 vin3.$284.Metal1 vin3.$64.GatPoly 15.6601627124
Rred_4316 vin3.$284.Metal1 vin3.P6.GatPoly 233.378884183
Rred_4317 vin3.$285.Metal1 vin3.$291.Metal1 0.361824121591
Rred_4318 vin3.$285.Metal1 vin3.$533.Metal2 10.7656516291
Rred_4319 vin3.$285.Metal1 vin3.$538.Metal2 19.1286039107
Rred_4320 vin3.$285.Metal1 vin3.$57.GatPoly 68.2833464052
Rred_4321 vin3.$285.Metal1 vin3.$65.GatPoly 15.7999014456
Rred_4322 vin3.$290.Metal1 vin3.$298.Metal1 0.362653569415
Rred_4323 vin3.$290.Metal1 vin3.$537.Metal2 9.52216809103
Rred_4324 vin3.$290.Metal1 vin3.$541.Metal2 12.8905653645
Rred_4325 vin3.$290.Metal1 vin3.$64.GatPoly 18.2531011901
Rred_4326 vin3.$290.Metal1 vin3.$70.GatPoly 20.4860406756
Rred_4327 vin3.$290.Metal1 vin3.P7.GatPoly 58.2686631016
Rred_4328 vin3.$291.Metal1 vin3.$295.Metal1 0.17857627571
Rred_4329 vin3.$291.Metal1 vin3.$538.Metal2 10.1777438502
Rred_4330 vin3.$291.Metal1 vin3.$542.Metal2 24.3181269841
Rred_4331 vin3.$291.Metal1 vin3.$65.GatPoly 16.2930131079
Rred_4332 vin3.$291.Metal1 vin3.$73.GatPoly 97.3021776078
Rred_4333 vin3.$291.Metal1 vin3.P27.GatPoly 137.244791849
Rred_4334 vin3.$295.Metal1 vin3.$303.Metal1 0.362799427562
Rred_4335 vin3.$295.Metal1 vin3.$538.Metal2 72.9543809522
Rred_4336 vin3.$295.Metal1 vin3.$542.Metal2 10.1293546422
Rred_4337 vin3.$295.Metal1 vin3.$547.Metal2 54.2048156595
Rred_4338 vin3.$295.Metal1 vin3.$65.GatPoly 97.3021776078
Rred_4339 vin3.$295.Metal1 vin3.$73.GatPoly 15.9974348707
Rred_4340 vin3.$295.Metal1 vin3.P27.GatPoly 177.329872844
Rred_4341 vin3.$298.Metal1 vin3.$302.Metal1 0.178668868145
Rred_4342 vin3.$298.Metal1 vin3.$537.Metal2 148.012303013
Rred_4343 vin3.$298.Metal1 vin3.$541.Metal2 9.91391002973
Rred_4344 vin3.$298.Metal1 vin3.$544.Metal2 136.676492583
Rred_4345 vin3.$298.Metal1 vin3.$548.Metal2 63.5012825511
Rred_4346 vin3.$298.Metal1 vin3.$70.GatPoly 15.5987328054
Rred_4347 vin3.$298.Metal1 vin3.$78.GatPoly 80.9291851852
Rred_4348 vin3.$302.Metal1 vin3.$310.Metal1 0.375564027363
Rred_4349 vin3.$302.Metal1 vin3.$541.Metal2 36.3717608362
Rred_4350 vin3.$302.Metal1 vin3.$544.Metal2 69.856873987
Rred_4351 vin3.$302.Metal1 vin3.$548.Metal2 10.5831998195
Rred_4352 vin3.$302.Metal1 vin3.$70.GatPoly 80.9291851852
Rred_4353 vin3.$302.Metal1 vin3.$78.GatPoly 15.334097558
Rred_4354 vin3.$302.Metal1 vin3.$80.GatPoly 430.191522254
Rred_4355 vin3.$303.Metal1 vin3.$307.Metal1 0.178371493384
Rred_4356 vin3.$303.Metal1 vin3.$542.Metal2 40.2164761345
Rred_4357 vin3.$303.Metal1 vin3.$547.Metal2 10.1082003498
Rred_4358 vin3.$303.Metal1 vin3.$551.Metal2 137.607164021
Rred_4359 vin3.$303.Metal1 vin3.$73.GatPoly 16.0835537092
Rred_4360 vin3.$303.Metal1 vin3.$77.GatPoly 55.6375076253
Rred_4361 vin3.$307.Metal1 vin3.$313.Metal1 0.36146618849
Rred_4362 vin3.$307.Metal1 vin3.$547.Metal2 20.9909233253
Rred_4363 vin3.$307.Metal1 vin3.$551.Metal2 10.1668380754
Rred_4364 vin3.$307.Metal1 vin3.$73.GatPoly 135.119661376
Rred_4365 vin3.$307.Metal1 vin3.$77.GatPoly 15.9311738026
Rred_4366 vin3.$307.Metal1 vin3.$83.GatPoly 98.1690707437
Rred_4367 vin3.$310.Metal1 vin3.$316.Metal1 0.34812443664
Rred_4368 vin3.$310.Metal1 vin3.$548.Metal2 9.92591643291
Rred_4369 vin3.$310.Metal1 vin3.$552.Metal2 10.4176943967
Rred_4370 vin3.$310.Metal1 vin3.$78.GatPoly 31.5600123225
Rred_4371 vin3.$310.Metal1 vin3.$80.GatPoly 15.5718406742
Rred_4372 vin3.$310.Metal1 vin3.$82.GatPoly 29.2042852009
Rred_4373 vin3.$313.Metal1 vin3.$317.Metal1 0.178799366164
Rred_4374 vin3.$313.Metal1 vin3.$551.Metal2 11.008714331
Rred_4375 vin3.$313.Metal1 vin3.$555.Metal2 57.4004804448
Rred_4376 vin3.$313.Metal1 vin3.$558.Metal2 33.6812736494
Rred_4377 vin3.$313.Metal1 vin3.$77.GatPoly 57.8243567653
Rred_4378 vin3.$313.Metal1 vin3.$83.GatPoly 13.0141464528
Rred_4379 vin3.$316.Metal1 vin3.$320.Metal1 0.17879442307
Rred_4380 vin3.$316.Metal1 vin3.$552.Metal2 14.5517176343
Rred_4381 vin3.$316.Metal1 vin3.$557.Metal2 17.5721428571
Rred_4382 vin3.$316.Metal1 vin3.$82.GatPoly 16.0793926449
Rred_4383 vin3.$316.Metal1 vin3.$90.GatPoly 132.252722286
Rred_4384 vin3.$316.Metal1 vin3.P9.GatPoly 149.886418591
Rred_4385 vin3.$317.Metal1 vin3.$321.Metal1 0.178838571508
Rred_4386 vin3.$317.Metal1 vin3.$551.Metal2 80.5238780093
Rred_4387 vin3.$317.Metal1 vin3.$555.Metal2 148.032817989
Rred_4388 vin3.$317.Metal1 vin3.$558.Metal2 14.6154515868
Rred_4389 vin3.$317.Metal1 vin3.$83.GatPoly 33.8281181896
Rred_4390 vin3.$317.Metal1 vin3.$87.GatPoly 58.1666753812
Rred_4391 vin3.$320.Metal1 vin3.$328.Metal1 0.362169844265
Rred_4392 vin3.$320.Metal1 vin3.$557.Metal2 11.2057192849
Rred_4393 vin3.$320.Metal1 vin3.$561.Metal2 24.2669420704
Rred_4394 vin3.$320.Metal1 vin3.$82.GatPoly 93.4499675813
Rred_4395 vin3.$320.Metal1 vin3.$90.GatPoly 19.2438881958
Rred_4396 vin3.$320.Metal1 vin3.P9.GatPoly 59.2696734323
Rred_4397 vin3.$321.Metal1 vin3.$325.Metal1 0.178840374465
Rred_4398 vin3.$321.Metal1 vin3.$558.Metal2 14.1682801538
Rred_4399 vin3.$321.Metal1 vin3.$562.Metal2 59.0882403627
Rred_4400 vin3.$321.Metal1 vin3.$83.GatPoly 123.604185185
Rred_4401 vin3.$321.Metal1 vin3.$87.GatPoly 23.0008821806
Rred_4402 vin3.$325.Metal1 vin3.$331.Metal1 0.361795734713
Rred_4403 vin3.$325.Metal1 vin3.$558.Metal2 26.4011286728
Rred_4404 vin3.$325.Metal1 vin3.$562.Metal2 10.1761275149
Rred_4405 vin3.$325.Metal1 vin3.$87.GatPoly 27.1411764706
Rred_4406 vin3.$325.Metal1 vin3.$93.GatPoly 19.1121432091
Rred_4407 vin3.$328.Metal1 vin3.$334.Metal1 0.361795734713
Rred_4408 vin3.$328.Metal1 vin3.$557.Metal2 53.4649554857
Rred_4409 vin3.$328.Metal1 vin3.$561.Metal2 8.0753915984
Rred_4410 vin3.$328.Metal1 vin3.$566.Metal2 20.3813394518
Rred_4411 vin3.$328.Metal1 vin3.$90.GatPoly 16.8684682797
Rred_4412 vin3.$328.Metal1 vin3.$94.GatPoly 16.8807966702
Rred_4413 vin3.$331.Metal1 vin3.$335.Metal1 0.178273944544
Rred_4414 vin3.$331.Metal1 vin3.$562.Metal2 20.3813394518
Rred_4415 vin3.$331.Metal1 vin3.$567.Metal2 10.0511202186
Rred_4416 vin3.$331.Metal1 vin3.$93.GatPoly 15.9520155185
Rred_4417 vin3.$331.Metal1 vin3.$97.GatPoly 60.6958431373
Rred_4418 vin3.$334.Metal1 vin3.$342.Metal1 0.362750607287
Rred_4419 vin3.$334.Metal1 vin3.$566.Metal2 9.3791763802
Rred_4420 vin3.$334.Metal1 vin3.$570.Metal2 13.7550931008
Rred_4421 vin3.$334.Metal1 vin3.$94.GatPoly 17.6321930648
Rred_4422 vin3.$334.Metal1 vin3.P10.GatPoly 75.5061764706
Rred_4423 vin3.$335.Metal1 vin3.$339.Metal1 0.178840374465
Rred_4424 vin3.$335.Metal1 vin3.$567.Metal2 20.2863564567
Rred_4425 vin3.$335.Metal1 vin3.$571.Metal2 26.4011286728
Rred_4426 vin3.$335.Metal1 vin3.$93.GatPoly 114.647703704
Rred_4427 vin3.$335.Metal1 vin3.$97.GatPoly 24.0009924532
Rred_4428 vin3.$339.Metal1 vin3.$343.Metal1 0.178838571508
Rred_4429 vin3.$339.Metal1 vin3.$567.Metal2 59.0882403627
Rred_4430 vin3.$339.Metal1 vin3.$571.Metal2 14.1682801538
Rred_4431 vin3.$339.Metal1 vin3.$97.GatPoly 23.0008821806
Rred_4432 vin3.$342.Metal1 vin3.$348.Metal1 0.34723110095
Rred_4433 vin3.$342.Metal1 vin3.$566.Metal2 119.851544368
Rred_4434 vin3.$342.Metal1 vin3.$570.Metal2 10.9045148683
Rred_4435 vin3.$342.Metal1 vin3.$575.Metal2 14.531155051
Rred_4436 vin3.$343.Metal1 vin3.$347.Metal1 0.178799366164
Rred_4437 vin3.$343.Metal1 vin3.$571.Metal2 14.6154515868
Rred_4438 vin3.$343.Metal1 vin3.$573.Metal2 148.032817989
Rred_4439 vin3.$343.Metal1 vin3.$578.Metal2 80.5238780093
Rred_4440 vin3.$343.Metal1 vin3.$97.GatPoly 58.1666753812
Rred_4441 vin3.$347.Metal1 vin3.$353.Metal1 0.36146618849
Rred_4442 vin3.$347.Metal1 vin3.$571.Metal2 33.6812736494
Rred_4443 vin3.$347.Metal1 vin3.$573.Metal2 57.4004804448
Rred_4444 vin3.$347.Metal1 vin3.$578.Metal2 11.008714331
Rred_4445 vin3.$348.Metal1 vin3.$356.Metal1 0.375564027363
Rred_4446 vin3.$348.Metal1 vin3.$575.Metal2 10.4114631896
Rred_4447 vin3.$348.Metal1 vin3.$579.Metal2 9.92591643291
Rred_4448 vin3.$353.Metal1 vin3.$357.Metal1 0.178371493384
Rred_4449 vin3.$353.Metal1 vin3.$578.Metal2 10.1668380754
Rred_4450 vin3.$353.Metal1 vin3.$582.Metal2 20.9909233253
Rred_4451 vin3.$356.Metal1 vin3.$360.Metal1 0.178668868145
Rred_4452 vin3.$356.Metal1 vin3.$579.Metal2 10.5831998195
Rred_4453 vin3.$356.Metal1 vin3.$584.Metal2 69.856873987
Rred_4454 vin3.$356.Metal1 vin3.$586.Metal2 36.3717608362
Rred_4455 vin3.$357.Metal1 vin3.$365.Metal1 0.362799427562
Rred_4456 vin3.$357.Metal1 vin3.$578.Metal2 137.607164021
Rred_4457 vin3.$357.Metal1 vin3.$582.Metal2 10.1082003498
Rred_4458 vin3.$357.Metal1 vin3.$587.Metal2 40.2164761345
Rred_4459 vin3.$36.GatPoly vin3.$42.GatPoly 80.7317467344
Rred_4460 vin3.$36.GatPoly vin3.$508.Metal2 1563.02782058
Rred_4461 vin3.$36.GatPoly vin3.P4.GatPoly 21.4418885263
Rred_4462 vin3.$360.Metal1 vin3.$368.Metal1 0.362653569415
Rred_4463 vin3.$360.Metal1 vin3.$579.Metal2 63.5012825511
Rred_4464 vin3.$360.Metal1 vin3.$584.Metal2 136.676492583
Rred_4465 vin3.$360.Metal1 vin3.$586.Metal2 9.91391002973
Rred_4466 vin3.$360.Metal1 vin3.$590.Metal2 148.012303013
Rred_4467 vin3.$365.Metal1 vin3.$369.Metal1 0.17857627571
Rred_4468 vin3.$365.Metal1 vin3.$582.Metal2 54.2048156595
Rred_4469 vin3.$365.Metal1 vin3.$587.Metal2 10.1293546422
Rred_4470 vin3.$365.Metal1 vin3.$591.Metal2 72.9543809522
Rred_4471 vin3.$365.Metal1 vin3.P32.GatPoly 177.329872844
Rred_4472 vin3.$368.Metal1 vin3.$374.Metal1 0.361824121591
Rred_4473 vin3.$368.Metal1 vin3.$586.Metal2 12.8905653645
Rred_4474 vin3.$368.Metal1 vin3.$590.Metal2 9.52216809103
Rred_4475 vin3.$368.Metal1 vin3.P12.GatPoly 58.2686631016
Rred_4476 vin3.$369.Metal1 vin3.$375.Metal1 0.361824121591
Rred_4477 vin3.$369.Metal1 vin3.$587.Metal2 24.3181269841
Rred_4478 vin3.$369.Metal1 vin3.$591.Metal2 10.1777438502
Rred_4479 vin3.$369.Metal1 vin3.P32.GatPoly 137.244791849
Rred_4480 vin3.$37.GatPoly vin3.$43.GatPoly 50.9131933514
Rred_4481 vin3.$37.GatPoly vin3.$509.Metal2 1563.02782058
Rred_4482 vin3.$37.GatPoly vin3.P24.GatPoly 63.2364133369
Rred_4483 vin3.$374.Metal1 vin3.$378.Metal1 0.178374896227
Rred_4484 vin3.$374.Metal1 vin3.$590.Metal2 19.1286039107
Rred_4485 vin3.$374.Metal1 vin3.$595.Metal2 10.7656516291
Rred_4486 vin3.$374.Metal1 vin3.P13.GatPoly 233.378884183
Rred_4487 vin3.$375.Metal1 vin3.$379.Metal1 0.178398933563
Rred_4488 vin3.$375.Metal1 vin3.$591.Metal2 19.1286039107
Rred_4489 vin3.$375.Metal1 vin3.$596.Metal2 10.7656516291
Rred_4490 vin3.$378.Metal1 vin3.$386.Metal1 0.362797942164
Rred_4491 vin3.$378.Metal1 vin3.$595.Metal2 15.9997708552
Rred_4492 vin3.$378.Metal1 vin3.$599.Metal2 14.7413390447
Rred_4493 vin3.$378.Metal1 vin3.P13.GatPoly 92.2851475241
Rred_4494 vin3.$379.Metal1 vin3.$383.Metal1 0.178898601437
Rred_4495 vin3.$379.Metal1 vin3.$387.Metal1 4137.53229591
Rred_4496 vin3.$379.Metal1 vin3.$596.Metal2 15.7349129944
Rred_4497 vin3.$379.Metal1 vin3.$603.Metal2 43.4328267333
Rred_4498 vin3.$383.Metal1 vin3.$387.Metal1 0.178843777497
Rred_4499 vin3.$383.Metal1 vin3.$596.Metal2 24.1058961615
Rred_4500 vin3.$383.Metal1 vin3.$603.Metal2 22.3566696457
Rred_4501 vin3.$386.Metal1 vin3.$392.Metal1 0.358974281487
Rred_4502 vin3.$386.Metal1 vin3.$595.Metal2 100.688434264
Rred_4503 vin3.$386.Metal1 vin3.$599.Metal2 10.3514401745
Rred_4504 vin3.$386.Metal1 vin3.$604.Metal2 15.0113662187
Rred_4505 vin3.$387.Metal1 vin3.$393.Metal1 0.358969093271
Rred_4506 vin3.$387.Metal1 vin3.$596.Metal2 49.717844922
Rred_4507 vin3.$387.Metal1 vin3.$603.Metal2 9.30100123455
Rred_4508 vin3.$387.Metal1 vin3.$609.Metal2 844.325347394
Rred_4509 vin3.$392.Metal1 vin3.$396.Metal1 0.180721425263
Rred_4510 vin3.$392.Metal1 vin3.$400.Metal1 7610.30667437
Rred_4511 vin3.$392.Metal1 vin3.$604.Metal2 8.62947986197
Rred_4512 vin3.$392.Metal1 vin3.$610.Metal2 27.6894597146
Rred_4513 vin3.$393.Metal1 vin3.$397.Metal1 0.180739583769
Rred_4514 vin3.$393.Metal1 vin3.$603.Metal2 10.4000814367
Rred_4515 vin3.$393.Metal1 vin3.$609.Metal2 17.6141428574
Rred_4516 vin3.$396.Metal1 vin3.$400.Metal1 0.178550748274
Rred_4517 vin3.$396.Metal1 vin3.$604.Metal2 34.3389922323
Rred_4518 vin3.$396.Metal1 vin3.$610.Metal2 17.0071631934
Rred_4519 vin3.$397.Metal1 vin3.$401.Metal1 0.178557568839
Rred_4520 vin3.$397.Metal1 vin3.$609.Metal2 11.1613203463
Rred_4521 vin3.$400.Metal1 vin3.$408.Metal1 0.362824398622
Rred_4522 vin3.$400.Metal1 vin3.$604.Metal2 145.280351752
Rred_4523 vin3.$400.Metal1 vin3.$610.Metal2 9.7817715397
Rred_4524 vin3.$400.Metal1 vin3.$615.Metal2 46.1776507338
Rred_4525 vin3.$401.Metal1 vin3.$409.Metal1 0.362824398622
Rred_4526 vin3.$401.Metal1 vin3.$609.Metal2 47.2209706961
Rred_4527 vin3.$401.Metal1 vin3.$611.Metal2 11.3207867366
Rred_4528 vin3.$401.Metal1 vin3.$616.Metal2 46.1776507338
Rred_4529 vin3.$408.Metal1 vin3.$412.Metal1 0.17852453123
Rred_4530 vin3.$408.Metal1 vin3.$610.Metal2 46.1776507338
Rred_4531 vin3.$408.Metal1 vin3.$615.Metal2 10.1192256903
Rred_4532 vin3.$408.Metal1 vin3.$619.Metal2 95.3406373629
Rred_4533 vin3.$408.Metal1 vin3.P15.GatPoly 72.1264392205
Rred_4534 vin3.$409.Metal1 vin3.$413.Metal1 0.178459879632
Rred_4535 vin3.$409.Metal1 vin3.$611.Metal2 46.1776507338
Rred_4536 vin3.$409.Metal1 vin3.$616.Metal2 10.1192256903
Rred_4537 vin3.$409.Metal1 vin3.$620.Metal2 95.3406373629
Rred_4538 vin3.$409.Metal1 vin3.P35.GatPoly 212.715280069
Rred_4539 vin3.$412.Metal1 vin3.$418.Metal1 0.36182906056
Rred_4540 vin3.$412.Metal1 vin3.$615.Metal2 22.5350597402
Rred_4541 vin3.$412.Metal1 vin3.$619.Metal2 10.1769943283
Rred_4542 vin3.$412.Metal1 vin3.P15.GatPoly 40.541385869
Rred_4543 vin3.$413.Metal1 vin3.$419.Metal1 0.36182906056
Rred_4544 vin3.$413.Metal1 vin3.$616.Metal2 22.5350597402
Rred_4545 vin3.$413.Metal1 vin3.$620.Metal2 10.1769943283
Rred_4546 vin3.$413.Metal1 vin3.P35.GatPoly 119.564647066
Rred_4547 vin3.$418.Metal1 vin3.$422.Metal1 0.178504947966
Rred_4548 vin3.$418.Metal1 vin3.$619.Metal2 18.0168451015
Rred_4549 vin3.$418.Metal1 vin3.$624.Metal2 11.5864555256
Rred_4550 vin3.$419.Metal1 vin3.$423.Metal1 0.178504947966
Rred_4551 vin3.$419.Metal1 vin3.$620.Metal2 18.0168451015
Rred_4552 vin3.$419.Metal1 vin3.$625.Metal2 11.5864555256
Rred_4553 vin3.$42.GatPoly vin3.$44.GatPoly 25.4131134156
Rred_4554 vin3.$42.GatPoly vin3.$512.Metal2 3870.9558658
Rred_4555 vin3.$42.GatPoly vin3.$517.Metal2 3870.9558658
Rred_4556 vin3.$42.GatPoly vin3.P4.GatPoly 38.1468722988
Rred_4557 vin3.$422.Metal1 vin3.$426.Metal1 0.17894182666
Rred_4558 vin3.$422.Metal1 vin3.$430.Metal1 4036.92165822
Rred_4559 vin3.$422.Metal1 vin3.$624.Metal2 15.140503946
Rred_4560 vin3.$422.Metal1 vin3.$630.Metal2 48.5088769371
Rred_4561 vin3.$423.Metal1 vin3.$427.Metal1 0.178949087371
Rred_4562 vin3.$423.Metal1 vin3.$625.Metal2 17.9090803107
Rred_4563 vin3.$423.Metal1 vin3.$629.Metal2 31.8360854701
Rred_4564 vin3.$426.Metal1 vin3.$430.Metal1 0.178852088262
Rred_4565 vin3.$426.Metal1 vin3.$624.Metal2 22.6413748687
Rred_4566 vin3.$426.Metal1 vin3.$630.Metal2 23.8007022261
Rred_4567 vin3.$427.Metal1 vin3.$433.Metal1 0.331848942782
Rred_4568 vin3.$427.Metal1 vin3.$625.Metal2 42.814045977
Rred_4569 vin3.$427.Metal1 vin3.$629.Metal2 10.4731205828
Rred_4570 vin3.$43.GatPoly vin3.$47.GatPoly 25.4131134156
Rred_4571 vin3.$43.GatPoly vin3.$513.Metal2 3870.9558658
Rred_4572 vin3.$43.GatPoly vin3.$518.Metal2 3870.9558658
Rred_4573 vin3.$43.GatPoly vin3.P24.GatPoly 112.502748125
Rred_4574 vin3.$430.Metal1 vin3.$437.Metal1 0.36174266925
Rred_4575 vin3.$430.Metal1 vin3.$624.Metal2 43.9859302507
Rred_4576 vin3.$430.Metal1 vin3.$630.Metal2 9.12759240183
Rred_4577 vin3.$433.Metal1 vin3.$441.Metal1 0.39094415179
Rred_4578 vin3.$433.Metal1 vin3.$629.Metal2 12.4168010073
Rred_4579 vin3.$433.Metal1 vin3.$633.Metal2 38.1149573586
Rred_4580 vin3.$433.Metal1 vin3.$636.Metal2 11.1591689028
Rred_4581 vin3.$437.Metal1 vin3.$440.Metal1 0.178129923539
Rred_4582 vin3.$437.Metal1 vin3.$630.Metal2 21.8084097251
Rred_4583 vin3.$437.Metal1 vin3.$635.Metal2 9.42324175824
Rred_4584 vin3.$437.Metal1 vin3.P17.GatPoly 81.1351604514
Rred_4585 vin3.$44.GatPoly vin3.$52.GatPoly 17.2080405764
Rred_4586 vin3.$44.GatPoly vin3.P5.GatPoly 4.76
Rred_4587 vin3.$440.Metal1 vin3.$448.Metal1 0.362653569415
Rred_4588 vin3.$440.Metal1 vin3.$635.Metal2 18.9451496641
Rred_4589 vin3.$440.Metal1 vin3.$639.Metal2 12.8905653645
Rred_4590 vin3.$440.Metal1 vin3.P17.GatPoly 36.2581717142
Rred_4591 vin3.$441.Metal1 vin3.$449.Metal1 0.362653569415
Rred_4592 vin3.$441.Metal1 vin3.$636.Metal2 9.17818171348
Rred_4593 vin3.$441.Metal1 vin3.$640.Metal2 12.8905653645
Rred_4594 vin3.$448.Metal1 vin3.$456.Metal1 0.362310386809
Rred_4595 vin3.$448.Metal1 vin3.$635.Metal2 148.012303013
Rred_4596 vin3.$448.Metal1 vin3.$639.Metal2 11.5186194376
Rred_4597 vin3.$448.Metal1 vin3.$644.Metal2 12.9766510302
Rred_4598 vin3.$448.Metal1 vin3.$648.Metal2 279.314226443
Rred_4599 vin3.$449.Metal1 vin3.$453.Metal1 0.178675191093
Rred_4600 vin3.$449.Metal1 vin3.$636.Metal2 148.012303013
Rred_4601 vin3.$449.Metal1 vin3.$640.Metal2 11.5186194376
Rred_4602 vin3.$449.Metal1 vin3.$645.Metal2 26.726552795
Rred_4603 vin3.$453.Metal1 vin3.$457.Metal1 0.178496116933
Rred_4604 vin3.$453.Metal1 vin3.$645.Metal2 12.426647102
Rred_4605 vin3.$453.Metal1 vin3.$649.Metal2 137.607164021
Rred_4606 vin3.$456.Metal1 vin3.$644.Metal2 11.4454036843
Rred_4607 vin3.$456.Metal1 vin3.$648.Metal2 6.53320320366
Rred_4608 vin3.$456.Metal1 vin3.$653.Metal2 5.38299903212
Rred_4609 vin3.$456.Metal1 vin3.P18.GatPoly 37.76
Rred_4610 vin3.$456.Metal1 vin3.P19.GatPoly 21.9316993903
Rred_4611 vin3.$457.Metal1 vin3.$645.Metal2 20.9909233253
Rred_4612 vin3.$457.Metal1 vin3.$649.Metal2 6.62883717454
Rred_4613 vin3.$457.Metal1 vin3.$654.Metal2 5.24434565257
Rred_4614 vin3.$457.Metal1 vin3.P39.GatPoly 41.5022353547
Rred_4615 vin3.$47.GatPoly vin3.$53.GatPoly 17.2080405764
Rred_4616 vin3.$47.GatPoly vin3.P25.GatPoly 22.26
Rred_4617 vin3.$477.Metal2 vin3.$479.Metal2 0.396394780345
Rred_4618 vin3.$477.Metal2 vin3.$480.Metal2 0.396375994988
Rred_4619 vin3.$477.Metal2 vin3.$486.Metal2 0.12144
Rred_4620 vin3.$477.Metal2 vin3.$6.GatPoly 465.005483652
Rred_4621 vin3.$477.Metal2 vin3.$9.GatPoly 865.63392982
Rred_4622 vin3.$477.Metal2 vin3.P0.GatPoly 584.620514403
Rred_4623 vin3.$477.Metal2 vin3.P20.GatPoly 1158.69091838
Rred_4624 vin3.$479.Metal2 vin3.$483.Metal2 0.346885244507
Rred_4625 vin3.$479.Metal2 vin3.$6.GatPoly 161.378216951
Rred_4626 vin3.$479.Metal2 vin3.P0.GatPoly 240.616715671
Rred_4627 vin3.$480.Metal2 vin3.$484.Metal2 0.346891446111
Rred_4628 vin3.$480.Metal2 vin3.$9.GatPoly 303.791569168
Rred_4629 vin3.$480.Metal2 vin3.P20.GatPoly 472.14281189
Rred_4630 vin3.$483.Metal2 vin3.$486.Metal2 0.692446258504
Rred_4631 vin3.$483.Metal2 vin3.$488.Metal2 0.200294372294
Rred_4632 vin3.$484.Metal2 vin3.$486.Metal2 0.692446258504
Rred_4633 vin3.$484.Metal2 vin3.$489.Metal2 0.200294372294
Rred_4634 vin3.$486.Metal2 vin3.$488.Metal2 0.515651469098
Rred_4635 vin3.$486.Metal2 vin3.$489.Metal2 0.515651469098
Rred_4636 vin3.$486.Metal2 vin3.$495.Metal2 0.12144
Rred_4637 vin3.$488.Metal2 vin3.$492.Metal2 0.346876010592
Rred_4638 vin3.$489.Metal2 vin3.$493.Metal2 0.346876010592
Rred_4639 vin3.$492.Metal2 vin3.$495.Metal2 4.31912380951
Rred_4640 vin3.$492.Metal2 vin3.$497.Metal2 0.178476190476
Rred_4641 vin3.$493.Metal2 vin3.$495.Metal2 0.643273146381
Rred_4642 vin3.$493.Metal2 vin3.$500.Metal2 0.463026148652
Rred_4643 vin3.$495.Metal2 vin3.$497.Metal2 0.280462585034
Rred_4644 vin3.$495.Metal2 vin3.$500.Metal2 0.727612519313
Rred_4645 vin3.$495.Metal2 vin3.$506.Metal2 0.12144
Rred_4646 vin3.$497.Metal2 vin3.$503.Metal2 0.528548299458
Rred_4647 vin3.$500.Metal2 vin3.$504.Metal2 0.346883084067
Rred_4648 vin3.$503.Metal2 vin3.$506.Metal2 0.417099415205
Rred_4649 vin3.$503.Metal2 vin3.$508.Metal2 0.196484848485
Rred_4650 vin3.$504.Metal2 vin3.$506.Metal2 0.417099415205
Rred_4651 vin3.$504.Metal2 vin3.$509.Metal2 0.196484848485
Rred_4652 vin3.$506.Metal2 vin3.$508.Metal2 0.950986666669
Rred_4653 vin3.$506.Metal2 vin3.$509.Metal2 0.950986666669
Rred_4654 vin3.$506.Metal2 vin3.$515.Metal2 0.12144
Rred_4655 vin3.$508.Metal2 vin3.$512.Metal2 0.3468888772
Rred_4656 vin3.$509.Metal2 vin3.$513.Metal2 0.3468888772
Rred_4657 vin3.$512.Metal2 vin3.$515.Metal2 0.885199294533
Rred_4658 vin3.$512.Metal2 vin3.$517.Metal2 0.19751717122
Rred_4659 vin3.$513.Metal2 vin3.$515.Metal2 0.885199294533
Rred_4660 vin3.$513.Metal2 vin3.$518.Metal2 0.19751717122
Rred_4661 vin3.$515.Metal2 vin3.$517.Metal2 0.434552380953
Rred_4662 vin3.$515.Metal2 vin3.$518.Metal2 0.434552380953
Rred_4663 vin3.$515.Metal2 vin3.$523.Metal2 0.793988220725
Rred_4664 vin3.$515.Metal2 vin3.$527.Metal2 0.747094537052
Rred_4665 vin3.$515.Metal2 vin3.$528.Metal2 20.9083564791
Rred_4666 vin3.$515.Metal2 vin3.$535.Metal2 0.357864457583
Rred_4667 vin3.$517.Metal2 vin3.$523.Metal2 0.528590320902
Rred_4668 vin3.$518.Metal2 vin3.$520.Metal2 0.17180952381
Rred_4669 vin3.$52.GatPoly vin3.$523.Metal2 1989.57191416
Rred_4670 vin3.$52.GatPoly vin3.$58.GatPoly 20.0625185185
Rred_4671 vin3.$520.Metal2 vin3.$527.Metal2 0.353544628822
Rred_4672 vin3.$520.Metal2 vin3.$53.GatPoly 111904.93744
Rred_4673 vin3.$523.Metal2 vin3.$527.Metal2 1.65756685141
Rred_4674 vin3.$523.Metal2 vin3.$528.Metal2 0.17524885292
Rred_4675 vin3.$523.Metal2 vin3.$535.Metal2 0.793988220725
Rred_4676 vin3.$527.Metal2 vin3.$528.Metal2 43.6492604206
Rred_4677 vin3.$527.Metal2 vin3.$53.GatPoly 2027.68731673
Rred_4678 vin3.$527.Metal2 vin3.$533.Metal2 0.521902039577
Rred_4679 vin3.$527.Metal2 vin3.$535.Metal2 0.747094537052
Rred_4680 vin3.$528.Metal2 vin3.$532.Metal2 0.346869470833
Rred_4681 vin3.$528.Metal2 vin3.$535.Metal2 20.9083564791
Rred_4682 vin3.$528.Metal2 vin3.$58.GatPoly 2525.70222612
Rred_4683 vin3.$53.GatPoly vin3.$57.GatPoly 26.7507621399
Rred_4684 vin3.$532.Metal2 vin3.$535.Metal2 0.493407191448
Rred_4685 vin3.$532.Metal2 vin3.$537.Metal2 0.19980952381
Rred_4686 vin3.$532.Metal2 vin3.$58.GatPoly 8439.59448869
Rred_4687 vin3.$533.Metal2 vin3.$535.Metal2 0.493407191448
Rred_4688 vin3.$533.Metal2 vin3.$538.Metal2 0.19980952381
Rred_4689 vin3.$535.Metal2 vin3.$537.Metal2 0.732634920637
Rred_4690 vin3.$535.Metal2 vin3.$538.Metal2 0.732634920637
Rred_4691 vin3.$535.Metal2 vin3.$544.Metal2 0.12144
Rred_4692 vin3.$537.Metal2 vin3.$541.Metal2 0.346876010592
Rred_4693 vin3.$537.Metal2 vin3.$64.GatPoly 1611.09899248
Rred_4694 vin3.$537.Metal2 vin3.$70.GatPoly 12405.3841055
Rred_4695 vin3.$538.Metal2 vin3.$542.Metal2 0.346886758096
Rred_4696 vin3.$538.Metal2 vin3.$65.GatPoly 1611.09899248
Rred_4697 vin3.$541.Metal2 vin3.$544.Metal2 0.546093875877
Rred_4698 vin3.$541.Metal2 vin3.$548.Metal2 0.457460174986
Rred_4699 vin3.$541.Metal2 vin3.$70.GatPoly 2301.94136839
Rred_4700 vin3.$542.Metal2 vin3.$544.Metal2 1.22615538847
Rred_4701 vin3.$542.Metal2 vin3.$547.Metal2 0.192530627203
Rred_4702 vin3.$542.Metal2 vin3.$73.GatPoly 3372.27982918
Rred_4703 vin3.$544.Metal2 vin3.$547.Metal2 0.369792894936
Rred_4704 vin3.$544.Metal2 vin3.$548.Metal2 0.878613986878
Rred_4705 vin3.$544.Metal2 vin3.$555.Metal2 0.12144
Rred_4706 vin3.$547.Metal2 vin3.$551.Metal2 0.346891446111
Rred_4707 vin3.$547.Metal2 vin3.$73.GatPoly 4543.078818
Rred_4708 vin3.$548.Metal2 vin3.$552.Metal2 0.346898882339
Rred_4709 vin3.$548.Metal2 vin3.$78.GatPoly 1714.75888267
Rred_4710 vin3.$548.Metal2 vin3.$80.GatPoly 25055.8390465
Rred_4711 vin3.$551.Metal2 vin3.$555.Metal2 0.786467062936
Rred_4712 vin3.$551.Metal2 vin3.$558.Metal2 0.461480673293
Rred_4713 vin3.$551.Metal2 vin3.$77.GatPoly 3154.05582356
Rred_4714 vin3.$551.Metal2 vin3.$83.GatPoly 5361.89490005
Rred_4715 vin3.$552.Metal2 vin3.$555.Metal2 0.315849765258
Rred_4716 vin3.$552.Metal2 vin3.$557.Metal2 0.185333333333
Rred_4717 vin3.$552.Metal2 vin3.$82.GatPoly 2219.44741188
Rred_4718 vin3.$555.Metal2 vin3.$557.Metal2 2.03866666667
Rred_4719 vin3.$555.Metal2 vin3.$558.Metal2 0.599073779942
Rred_4720 vin3.$555.Metal2 vin3.$564.Metal2 0.12144
Rred_4721 vin3.$557.Metal2 vin3.$561.Metal2 0.346865293749
Rred_4722 vin3.$557.Metal2 vin3.$90.GatPoly 4494.85080275
Rred_4723 vin3.$558.Metal2 vin3.$562.Metal2 0.346885087058
Rred_4724 vin3.$561.Metal2 vin3.$564.Metal2 0.592952380953
Rred_4725 vin3.$561.Metal2 vin3.$566.Metal2 0.200917748918
Rred_4726 vin3.$561.Metal2 vin3.$90.GatPoly 3453.79724991
Rred_4727 vin3.$562.Metal2 vin3.$564.Metal2 0.592952380953
Rred_4728 vin3.$562.Metal2 vin3.$567.Metal2 0.200917748918
Rred_4729 vin3.$562.Metal2 vin3.$93.GatPoly 1716.610141
Rred_4730 vin3.$564.Metal2 vin3.$566.Metal2 0.592952380953
Rred_4731 vin3.$564.Metal2 vin3.$567.Metal2 0.592952380953
Rred_4732 vin3.$564.Metal2 vin3.$573.Metal2 0.12144
Rred_4733 vin3.$566.Metal2 vin3.$570.Metal2 0.346872405043
Rred_4734 vin3.$566.Metal2 vin3.$94.GatPoly 1716.610141
Rred_4735 vin3.$567.Metal2 vin3.$571.Metal2 0.346885087058
Rred_4736 vin3.$57.GatPoly vin3.$65.GatPoly 36.1143032099
Rred_4737 vin3.$57.GatPoly vin3.P26.GatPoly 22.26
Rred_4738 vin3.$570.Metal2 vin3.$573.Metal2 2.03866666667
Rred_4739 vin3.$570.Metal2 vin3.$575.Metal2 0.185333333333
Rred_4740 vin3.$571.Metal2 vin3.$573.Metal2 0.599073779942
Rred_4741 vin3.$571.Metal2 vin3.$578.Metal2 0.461480673293
Rred_4742 vin3.$573.Metal2 vin3.$575.Metal2 0.315849765258
Rred_4743 vin3.$573.Metal2 vin3.$578.Metal2 0.786467062936
Rred_4744 vin3.$573.Metal2 vin3.$584.Metal2 0.12144
Rred_4745 vin3.$575.Metal2 vin3.$579.Metal2 0.346898882339
Rred_4746 vin3.$578.Metal2 vin3.$582.Metal2 0.346891446111
Rred_4747 vin3.$579.Metal2 vin3.$584.Metal2 0.878613986878
Rred_4748 vin3.$579.Metal2 vin3.$586.Metal2 0.457460174986
Rred_4749 vin3.$58.GatPoly vin3.$64.GatPoly 60.50563664
Rred_4750 vin3.$58.GatPoly vin3.P6.GatPoly 7.97486881396
Rred_4751 vin3.$582.Metal2 vin3.$584.Metal2 0.369792894936
Rred_4752 vin3.$582.Metal2 vin3.$587.Metal2 0.192530627203
Rred_4753 vin3.$584.Metal2 vin3.$586.Metal2 0.546093875877
Rred_4754 vin3.$584.Metal2 vin3.$587.Metal2 1.22615538847
Rred_4755 vin3.$584.Metal2 vin3.$593.Metal2 0.12144
Rred_4756 vin3.$586.Metal2 vin3.$590.Metal2 0.346876010592
Rred_4757 vin3.$587.Metal2 vin3.$591.Metal2 0.346886758096
Rred_4758 vin3.$590.Metal2 vin3.$593.Metal2 0.732634920637
Rred_4759 vin3.$590.Metal2 vin3.$595.Metal2 0.19980952381
Rred_4760 vin3.$591.Metal2 vin3.$593.Metal2 0.732634920637
Rred_4761 vin3.$591.Metal2 vin3.$596.Metal2 0.19980952381
Rred_4762 vin3.$593.Metal2 vin3.$595.Metal2 0.493407191448
Rred_4763 vin3.$593.Metal2 vin3.$596.Metal2 0.493407191448
Rred_4764 vin3.$593.Metal2 vin3.$599.Metal2 20.9083564791
Rred_4765 vin3.$593.Metal2 vin3.$603.Metal2 0.747094537052
Rred_4766 vin3.$593.Metal2 vin3.$604.Metal2 0.793988220725
Rred_4767 vin3.$593.Metal2 vin3.$613.Metal2 0.357864457583
Rred_4768 vin3.$595.Metal2 vin3.$599.Metal2 0.346869470833
Rred_4769 vin3.$596.Metal2 vin3.$603.Metal2 0.521902039577
Rred_4770 vin3.$599.Metal2 vin3.$603.Metal2 43.6492604206
Rred_4771 vin3.$599.Metal2 vin3.$604.Metal2 0.17524885292
Rred_4772 vin3.$599.Metal2 vin3.$613.Metal2 20.9083564791
Rred_4773 vin3.$6.GatPoly vin3.P0.GatPoly 86.6806517579
Rred_4774 vin3.$6.GatPoly vin3.P1.GatPoly 19.9708444444
Rred_4775 vin3.$603.Metal2 vin3.$604.Metal2 1.65756685141
Rred_4776 vin3.$603.Metal2 vin3.$609.Metal2 0.353544628822
Rred_4777 vin3.$603.Metal2 vin3.$613.Metal2 0.747094537052
Rred_4778 vin3.$604.Metal2 vin3.$610.Metal2 0.528590320902
Rred_4779 vin3.$604.Metal2 vin3.$613.Metal2 0.793988220725
Rred_4780 vin3.$609.Metal2 vin3.$611.Metal2 0.17180952381
Rred_4781 vin3.$610.Metal2 vin3.$613.Metal2 0.434552380953
Rred_4782 vin3.$610.Metal2 vin3.$615.Metal2 0.19751717122
Rred_4783 vin3.$611.Metal2 vin3.$613.Metal2 0.434552380953
Rred_4784 vin3.$611.Metal2 vin3.$616.Metal2 0.19751717122
Rred_4785 vin3.$613.Metal2 vin3.$615.Metal2 0.885199294533
Rred_4786 vin3.$613.Metal2 vin3.$616.Metal2 0.885199294533
Rred_4787 vin3.$613.Metal2 vin3.$622.Metal2 0.12144
Rred_4788 vin3.$615.Metal2 vin3.$619.Metal2 0.3468888772
Rred_4789 vin3.$616.Metal2 vin3.$620.Metal2 0.3468888772
Rred_4790 vin3.$619.Metal2 vin3.$622.Metal2 0.950986666669
Rred_4791 vin3.$619.Metal2 vin3.$624.Metal2 0.196484848485
Rred_4792 vin3.$620.Metal2 vin3.$622.Metal2 0.950986666669
Rred_4793 vin3.$620.Metal2 vin3.$625.Metal2 0.196484848485
Rred_4794 vin3.$622.Metal2 vin3.$624.Metal2 0.417099415205
Rred_4795 vin3.$622.Metal2 vin3.$625.Metal2 0.417099415205
Rred_4796 vin3.$622.Metal2 vin3.$633.Metal2 0.12144
Rred_4797 vin3.$624.Metal2 vin3.$630.Metal2 0.528548299458
Rred_4798 vin3.$625.Metal2 vin3.$629.Metal2 0.346883084067
Rred_4799 vin3.$629.Metal2 vin3.$633.Metal2 0.727612519313
Rred_4800 vin3.$629.Metal2 vin3.$636.Metal2 0.463026148652
Rred_4801 vin3.$630.Metal2 vin3.$633.Metal2 0.280462585034
Rred_4802 vin3.$630.Metal2 vin3.$635.Metal2 0.178476190476
Rred_4803 vin3.$633.Metal2 vin3.$635.Metal2 4.31912380951
Rred_4804 vin3.$633.Metal2 vin3.$636.Metal2 0.643273146381
Rred_4805 vin3.$633.Metal2 vin3.$642.Metal2 0.12144
Rred_4806 vin3.$635.Metal2 vin3.$639.Metal2 0.346876010592
Rred_4807 vin3.$636.Metal2 vin3.$640.Metal2 0.346876010592
Rred_4808 vin3.$639.Metal2 vin3.$642.Metal2 0.515651469098
Rred_4809 vin3.$639.Metal2 vin3.$644.Metal2 0.200294372294
Rred_4810 vin3.$64.GatPoly vin3.$70.GatPoly 33.2347189542
Rred_4811 vin3.$64.GatPoly vin3.P6.GatPoly 123.431498746
Rred_4812 vin3.$64.GatPoly vin3.P7.GatPoly 30.8176484848
Rred_4813 vin3.$640.Metal2 vin3.$642.Metal2 0.515651469098
Rred_4814 vin3.$640.Metal2 vin3.$645.Metal2 0.200294372294
Rred_4815 vin3.$642.Metal2 vin3.$644.Metal2 0.692446258504
Rred_4816 vin3.$642.Metal2 vin3.$645.Metal2 0.692446258504
Rred_4817 vin3.$642.Metal2 vin3.$648.Metal2 2.98963708333
Rred_4818 vin3.$642.Metal2 vin3.$649.Metal2 3.5599249307
Rred_4819 vin3.$642.Metal2 vin3.$653.Metal2 0.781905083333
Rred_4820 vin3.$642.Metal2 vin3.$654.Metal2 0.931057289569
Rred_4821 vin3.$644.Metal2 vin3.$648.Metal2 0.346885244507
Rred_4822 vin3.$645.Metal2 vin3.$649.Metal2 0.346891446111
Rred_4823 vin3.$648.Metal2 vin3.$649.Metal2 53.5446887191
Rred_4824 vin3.$648.Metal2 vin3.$653.Metal2 0.182222484268
Rred_4825 vin3.$648.Metal2 vin3.$654.Metal2 14.0039955112
Rred_4826 vin3.$648.Metal2 vin3.P19.GatPoly 1031.5624039
Rred_4827 vin3.$649.Metal2 vin3.$653.Metal2 14.0039955112
Rred_4828 vin3.$649.Metal2 vin3.$654.Metal2 0.180819600935
Rred_4829 vin3.$649.Metal2 vin3.P39.GatPoly 1960.12022876
Rred_4830 vin3.$65.GatPoly vin3.$73.GatPoly 51.4620406015
Rred_4831 vin3.$65.GatPoly vin3.P27.GatPoly 72.5872454666
Rred_4832 vin3.$653.Metal2 vin3.$654.Metal2 3.66258344139
Rred_4833 vin3.$653.Metal2 vin3.P19.GatPoly 199.325141092
Rred_4834 vin3.$654.Metal2 vin3.P39.GatPoly 395.072001344
Rred_4835 vin3.$70.GatPoly vin3.$78.GatPoly 42.8025468312
Rred_4836 vin3.$70.GatPoly vin3.P7.GatPoly 12.9518899643
Rred_4837 vin3.$73.GatPoly vin3.$77.GatPoly 29.4260595885
Rred_4838 vin3.$73.GatPoly vin3.P27.GatPoly 93.7877994151
Rred_4839 vin3.$77.GatPoly vin3.$83.GatPoly 15.0537042157
Rred_4840 vin3.$77.GatPoly vin3.P28.GatPoly 22.26
Rred_4841 vin3.$78.GatPoly vin3.$80.GatPoly 11.1325184116
Rred_4842 vin3.$78.GatPoly vin3.P8.GatPoly 11.3586666667
Rred_4843 vin3.$80.GatPoly vin3.$82.GatPoly 7.93333333333
Rred_4844 vin3.$80.GatPoly vin3.P8.GatPoly 16.2266666667
Rred_4845 vin3.$82.GatPoly vin3.$90.GatPoly 69.9469953425
Rred_4846 vin3.$82.GatPoly vin3.P9.GatPoly 79.2732613881
Rred_4847 vin3.$83.GatPoly vin3.$87.GatPoly 30.7637083127
Rred_4848 vin3.$87.GatPoly vin3.$93.GatPoly 14.3546666667
Rred_4849 vin3.$87.GatPoly vin3.P29.GatPoly 22.26
Rred_4850 vin3.$9.GatPoly vin3.P20.GatPoly 365.489864519
Rred_4851 vin3.$9.GatPoly vin3.P21.GatPoly 22.26
Rred_4852 vin3.$90.GatPoly vin3.$94.GatPoly 20.0625185185
Rred_4853 vin3.$90.GatPoly vin3.P9.GatPoly 10.8227426436
Rred_4854 vin3.$93.GatPoly vin3.$97.GatPoly 32.101357037
Rred_4855 vin3.$94.GatPoly vin3.P10.GatPoly 39.9343777778
Rred_4856 vin3.$97.GatPoly vin3.P30.GatPoly 22.26
Rred_4857 vin4 vin4.$477.Metal2 1.24696
Rred_4858 vin4.$103.GatPoly vin4.$109.GatPoly 20.0625185185
Rred_4859 vin4.$103.GatPoly vin4.$335.Metal1 158.710238626
Rred_4860 vin4.$103.GatPoly vin4.$339.Metal1 17.3193062589
Rred_4861 vin4.$103.GatPoly vin4.$347.Metal1 16.8757273465
Rred_4862 vin4.$103.GatPoly vin4.$571.Metal2 2987.58348254
Rred_4863 vin4.$103.GatPoly vin4.$576.Metal2 5498.19357361
Rred_4864 vin4.$103.GatPoly vin4.$95.GatPoly 83.9400817622
Rred_4865 vin4.$103.GatPoly vin4.P10.GatPoly 27.8344874504
Rred_4866 vin4.$104.GatPoly vin4.$106.GatPoly 15.0537042157
Rred_4867 vin4.$104.GatPoly vin4.$338.Metal1 123.604185185
Rred_4868 vin4.$104.GatPoly vin4.$342.Metal1 33.8281181896
Rred_4869 vin4.$104.GatPoly vin4.$346.Metal1 13.0141464528
Rred_4870 vin4.$104.GatPoly vin4.$352.Metal1 98.1690707437
Rred_4871 vin4.$104.GatPoly vin4.$577.Metal2 5361.89490005
Rred_4872 vin4.$104.GatPoly vin4.$96.GatPoly 30.7637083127
Rred_4873 vin4.$106.GatPoly vin4.$114.GatPoly 29.4260595885
Rred_4874 vin4.$106.GatPoly vin4.$346.Metal1 57.8243567653
Rred_4875 vin4.$106.GatPoly vin4.$352.Metal1 15.9311738026
Rred_4876 vin4.$106.GatPoly vin4.$356.Metal1 55.6375076253
Rred_4877 vin4.$106.GatPoly vin4.$577.Metal2 3154.05582356
Rred_4878 vin4.$106.GatPoly vin4.P31.GatPoly 22.26
Rred_4879 vin4.$109.GatPoly vin4.$111.GatPoly 11.1325184116
Rred_4880 vin4.$109.GatPoly vin4.$347.Metal1 37.9333333333
Rred_4881 vin4.$109.GatPoly vin4.$349.Metal1 15.5718406742
Rred_4882 vin4.$109.GatPoly vin4.$357.Metal1 430.191522254
Rred_4883 vin4.$109.GatPoly vin4.$580.Metal2 25055.8390465
Rred_4884 vin4.$109.GatPoly vin4.P11.GatPoly 16.2266666667
Rred_4885 vin4.$11.GatPoly vin4.$17.GatPoly 20.0625185185
Rred_4886 vin4.$11.GatPoly vin4.$203.Metal1 20.489591646
Rred_4887 vin4.$11.GatPoly vin4.$211.Metal1 16.8901542286
Rred_4888 vin4.$11.GatPoly vin4.$480.Metal2 23421.3890021
Rred_4889 vin4.$11.GatPoly vin4.$484.Metal2 2115.07400678
Rred_4890 vin4.$11.GatPoly vin4.$7.GatPoly 33.2847407407
Rred_4891 vin4.$11.GatPoly vin4.P1.GatPoly 19.9708444444
Rred_4892 vin4.$111.GatPoly vin4.$119.GatPoly 42.8025468312
Rred_4893 vin4.$111.GatPoly vin4.$349.Metal1 31.5600123225
Rred_4894 vin4.$111.GatPoly vin4.$357.Metal1 15.334097558
Rred_4895 vin4.$111.GatPoly vin4.$361.Metal1 80.9291851852
Rred_4896 vin4.$111.GatPoly vin4.$580.Metal2 1714.75888267
Rred_4897 vin4.$111.GatPoly vin4.P11.GatPoly 11.3586666667
Rred_4898 vin4.$114.GatPoly vin4.$122.GatPoly 51.4620406015
Rred_4899 vin4.$114.GatPoly vin4.$352.Metal1 135.119661376
Rred_4900 vin4.$114.GatPoly vin4.$356.Metal1 16.0835537092
Rred_4901 vin4.$114.GatPoly vin4.$364.Metal1 15.9974348707
Rred_4902 vin4.$114.GatPoly vin4.$368.Metal1 97.3021776078
Rred_4903 vin4.$114.GatPoly vin4.$581.Metal2 4543.078818
Rred_4904 vin4.$114.GatPoly vin4.$586.Metal2 3372.27982918
Rred_4905 vin4.$114.GatPoly vin4.P32.GatPoly 93.7877994151
Rred_4906 vin4.$119.GatPoly vin4.$123.GatPoly 33.2347189542
Rred_4907 vin4.$119.GatPoly vin4.$357.Metal1 80.9291851852
Rred_4908 vin4.$119.GatPoly vin4.$361.Metal1 15.5987328054
Rred_4909 vin4.$119.GatPoly vin4.$369.Metal1 20.4860406756
Rred_4910 vin4.$119.GatPoly vin4.$587.Metal2 2301.94136839
Rred_4911 vin4.$119.GatPoly vin4.$591.Metal2 12405.3841055
Rred_4912 vin4.$119.GatPoly vin4.P12.GatPoly 12.9518899643
Rred_4913 vin4.$122.GatPoly vin4.$126.GatPoly 36.1143032099
Rred_4914 vin4.$122.GatPoly vin4.$364.Metal1 97.3021776078
Rred_4915 vin4.$122.GatPoly vin4.$368.Metal1 16.2930131079
Rred_4916 vin4.$122.GatPoly vin4.$374.Metal1 15.7999014456
Rred_4917 vin4.$122.GatPoly vin4.$378.Metal1 96.7347407407
Rred_4918 vin4.$122.GatPoly vin4.$590.Metal2 1611.09899248
Rred_4919 vin4.$122.GatPoly vin4.P32.GatPoly 72.5872454666
Rred_4920 vin4.$123.GatPoly vin4.$131.GatPoly 60.50563664
Rred_4921 vin4.$123.GatPoly vin4.$369.Metal1 18.2531011901
Rred_4922 vin4.$123.GatPoly vin4.$375.Metal1 15.6601627124
Rred_4923 vin4.$123.GatPoly vin4.$379.Metal1 84.9923100066
Rred_4924 vin4.$123.GatPoly vin4.$591.Metal2 1611.09899248
Rred_4925 vin4.$123.GatPoly vin4.P12.GatPoly 30.8176484848
Rred_4926 vin4.$123.GatPoly vin4.P13.GatPoly 123.431498746
Rred_4927 vin4.$126.GatPoly vin4.$134.GatPoly 26.7507621399
Rred_4928 vin4.$126.GatPoly vin4.$374.Metal1 68.2833464052
Rred_4929 vin4.$126.GatPoly vin4.$378.Metal1 27.001323271
Rred_4930 vin4.$126.GatPoly vin4.$382.Metal1 20.0005513629
Rred_4931 vin4.$126.GatPoly vin4.$386.Metal1 50.5791721133
Rred_4932 vin4.$126.GatPoly vin4.P33.GatPoly 22.26
Rred_4933 vin4.$131.GatPoly vin4.$135.GatPoly 20.0625185185
Rred_4934 vin4.$131.GatPoly vin4.$375.Metal1 114.401413815
Rred_4935 vin4.$131.GatPoly vin4.$379.Metal1 18.1851091752
Rred_4936 vin4.$131.GatPoly vin4.$387.Metal1 16.8812213797
Rred_4937 vin4.$131.GatPoly vin4.$596.Metal2 8439.59448869
Rred_4938 vin4.$131.GatPoly vin4.$600.Metal2 2525.70222612
Rred_4939 vin4.$131.GatPoly vin4.P13.GatPoly 7.97486881396
Rred_4940 vin4.$134.GatPoly vin4.$136.GatPoly 17.2080405764
Rred_4941 vin4.$134.GatPoly vin4.$382.Metal1 171.969185185
Rred_4942 vin4.$134.GatPoly vin4.$386.Metal1 16.3265000824
Rred_4943 vin4.$134.GatPoly vin4.$392.Metal1 17.7474001705
Rred_4944 vin4.$134.GatPoly vin4.$396.Metal1 2936.27252746
Rred_4945 vin4.$134.GatPoly vin4.$601.Metal2 2027.68731673
Rred_4946 vin4.$134.GatPoly vin4.$608.Metal2 111904.93744
Rred_4947 vin4.$135.GatPoly vin4.$137.GatPoly 17.2080405764
Rred_4948 vin4.$135.GatPoly vin4.$387.Metal1 16.9633899809
Rred_4949 vin4.$135.GatPoly vin4.$393.Metal1 17.7474958524
Rred_4950 vin4.$135.GatPoly vin4.$397.Metal1 2936.27252746
Rred_4951 vin4.$135.GatPoly vin4.$605.Metal2 1989.57191416
Rred_4952 vin4.$136.GatPoly vin4.$144.GatPoly 25.4131134156
Rred_4953 vin4.$136.GatPoly vin4.$392.Metal1 33.0203657934
Rred_4954 vin4.$136.GatPoly vin4.$396.Metal1 18.8410085241
Rred_4955 vin4.$136.GatPoly vin4.$400.Metal1 48.0500043573
Rred_4956 vin4.$136.GatPoly vin4.P34.GatPoly 22.26
Rred_4957 vin4.$137.GatPoly vin4.$145.GatPoly 25.4131134156
Rred_4958 vin4.$137.GatPoly vin4.$393.Metal1 33.0203657934
Rred_4959 vin4.$137.GatPoly vin4.$397.Metal1 18.8410085241
Rred_4960 vin4.$137.GatPoly vin4.$401.Metal1 48.0500043573
Rred_4961 vin4.$137.GatPoly vin4.P14.GatPoly 4.76
Rred_4962 vin4.$14.GatPoly vin4.$16.GatPoly 8.64681481481
Rred_4963 vin4.$14.GatPoly vin4.$218.Metal1 12.6296021429
Rred_4964 vin4.$14.GatPoly vin4.$226.Metal1 37.7619085138
Rred_4965 vin4.$14.GatPoly vin4.$26.GatPoly 41.3580961617
Rred_4966 vin4.$14.GatPoly vin4.$492.Metal2 2934.89262124
Rred_4967 vin4.$14.GatPoly vin4.P22.GatPoly 22.26
Rred_4968 vin4.$144.GatPoly vin4.$152.GatPoly 50.9131933514
Rred_4969 vin4.$144.GatPoly vin4.$396.Metal1 204.212518518
Rred_4970 vin4.$144.GatPoly vin4.$400.Metal1 16.3459334659
Rred_4971 vin4.$144.GatPoly vin4.$408.Metal1 15.8678203345
Rred_4972 vin4.$144.GatPoly vin4.$412.Metal1 96.2644412107
Rred_4973 vin4.$144.GatPoly vin4.$610.Metal2 3870.9558658
Rred_4974 vin4.$144.GatPoly vin4.$615.Metal2 3870.9558658
Rred_4975 vin4.$144.GatPoly vin4.P35.GatPoly 112.502748125
Rred_4976 vin4.$145.GatPoly vin4.$153.GatPoly 80.7317467344
Rred_4977 vin4.$145.GatPoly vin4.$397.Metal1 204.212518518
Rred_4978 vin4.$145.GatPoly vin4.$401.Metal1 16.3459334659
Rred_4979 vin4.$145.GatPoly vin4.$409.Metal1 16.4300806005
Rred_4980 vin4.$145.GatPoly vin4.$413.Metal1 152.644058952
Rred_4981 vin4.$145.GatPoly vin4.$611.Metal2 3870.9558658
Rred_4982 vin4.$145.GatPoly vin4.$616.Metal2 3870.9558658
Rred_4983 vin4.$145.GatPoly vin4.P15.GatPoly 38.1468722988
Rred_4984 vin4.$152.GatPoly vin4.$156.GatPoly 40.1272493827
Rred_4985 vin4.$152.GatPoly vin4.$408.Metal1 96.2644412107
Rred_4986 vin4.$152.GatPoly vin4.$412.Metal1 16.5099701104
Rred_4987 vin4.$152.GatPoly vin4.$418.Metal1 15.6802121879
Rred_4988 vin4.$152.GatPoly vin4.$422.Metal1 85.9869629629
Rred_4989 vin4.$152.GatPoly vin4.$619.Metal2 1563.02782058
Rred_4990 vin4.$152.GatPoly vin4.P35.GatPoly 63.2364133369
Rred_4991 vin4.$153.GatPoly vin4.$157.GatPoly 40.1272493827
Rred_4992 vin4.$153.GatPoly vin4.$409.Metal1 152.644058952
Rred_4993 vin4.$153.GatPoly vin4.$413.Metal1 18.6069469566
Rred_4994 vin4.$153.GatPoly vin4.$419.Metal1 15.6802121879
Rred_4995 vin4.$153.GatPoly vin4.$423.Metal1 85.9869629629
Rred_4996 vin4.$153.GatPoly vin4.$620.Metal2 1563.02782058
Rred_4997 vin4.$153.GatPoly vin4.P15.GatPoly 21.4418885263
Rred_4998 vin4.$156.GatPoly vin4.$162.GatPoly 9.36029629629
Rred_4999 vin4.$156.GatPoly vin4.$418.Metal1 75.8708496732
Rred_5000 vin4.$156.GatPoly vin4.$422.Metal1 30.0016540887
Rred_5001 vin4.$156.GatPoly vin4.$426.Metal1 17.6980392157
Rred_5002 vin4.$156.GatPoly vin4.P36.GatPoly 22.26
Rred_5003 vin4.$157.GatPoly vin4.$165.GatPoly 22.7378159671
Rred_5004 vin4.$157.GatPoly vin4.$419.Metal1 75.8708496732
Rred_5005 vin4.$157.GatPoly vin4.$423.Metal1 30.0016540887
Rred_5006 vin4.$157.GatPoly vin4.$427.Metal1 17.0002205452
Rred_5007 vin4.$157.GatPoly vin4.$431.Metal1 42.9916688453
Rred_5008 vin4.$157.GatPoly vin4.P16.GatPoly 4.76
Rred_5009 vin4.$16.GatPoly vin4.$206.Metal1 80.9291851852
Rred_5010 vin4.$16.GatPoly vin4.$210.Metal1 15.5987328054
Rred_5011 vin4.$16.GatPoly vin4.$218.Metal1 27.3987871831
Rred_5012 vin4.$16.GatPoly vin4.$488.Metal2 2301.94136839
Rred_5013 vin4.$16.GatPoly vin4.$492.Metal2 12405.3841055
Rred_5014 vin4.$16.GatPoly vin4.$8.GatPoly 42.8025468312
Rred_5015 vin4.$162.GatPoly vin4.$166.GatPoly 41.3580961617
Rred_5016 vin4.$162.GatPoly vin4.$426.Metal1 27.2939474766
Rred_5017 vin4.$162.GatPoly vin4.$432.Metal1 14.2581745852
Rred_5018 vin4.$162.GatPoly vin4.$440.Metal1 115.651204718
Rred_5019 vin4.$162.GatPoly vin4.$628.Metal2 2664.67413314
Rred_5020 vin4.$162.GatPoly vin4.$635.Metal2 6114.14760608
Rred_5021 vin4.$165.GatPoly vin4.$173.GatPoly 77.9511897103
Rred_5022 vin4.$165.GatPoly vin4.$427.Metal1 365.429185185
Rred_5023 vin4.$165.GatPoly vin4.$431.Metal1 16.5931436324
Rred_5024 vin4.$165.GatPoly vin4.$439.Metal1 16.2158441731
Rred_5025 vin4.$165.GatPoly vin4.$441.Metal1 147.386703234
Rred_5026 vin4.$165.GatPoly vin4.$631.Metal2 1836.80456241
Rred_5027 vin4.$165.GatPoly vin4.P17.GatPoly 42.9114848609
Rred_5028 vin4.$166.GatPoly vin4.$172.GatPoly 8.64681481481
Rred_5029 vin4.$166.GatPoly vin4.$432.Metal1 37.7619085138
Rred_5030 vin4.$166.GatPoly vin4.$440.Metal1 12.6296021429
Rred_5031 vin4.$166.GatPoly vin4.$635.Metal2 2934.89262124
Rred_5032 vin4.$166.GatPoly vin4.P37.GatPoly 22.26
Rred_5033 vin4.$17.GatPoly vin4.$211.Metal1 16.8857192322
Rred_5034 vin4.$17.GatPoly vin4.$219.Metal1 19.3496497775
Rred_5035 vin4.$17.GatPoly vin4.$223.Metal1 147.386703234
Rred_5036 vin4.$17.GatPoly vin4.$23.GatPoly 77.9511897103
Rred_5037 vin4.$17.GatPoly vin4.$489.Metal2 2301.94136839
Rred_5038 vin4.$17.GatPoly vin4.$493.Metal2 12405.3841055
Rred_5039 vin4.$17.GatPoly vin4.P2.GatPoly 19.176544151
Rred_5040 vin4.$172.GatPoly vin4.$178.GatPoly 42.8025468312
Rred_5041 vin4.$172.GatPoly vin4.$440.Metal1 27.3987871831
Rred_5042 vin4.$172.GatPoly vin4.$448.Metal1 15.5987328054
Rred_5043 vin4.$172.GatPoly vin4.$452.Metal1 80.9291851852
Rred_5044 vin4.$172.GatPoly vin4.$635.Metal2 12405.3841055
Rred_5045 vin4.$172.GatPoly vin4.$639.Metal2 2301.94136839
Rred_5046 vin4.$173.GatPoly vin4.$177.GatPoly 20.0625185185
Rred_5047 vin4.$173.GatPoly vin4.$439.Metal1 147.386703234
Rred_5048 vin4.$173.GatPoly vin4.$441.Metal1 19.3496497775
Rred_5049 vin4.$173.GatPoly vin4.$449.Metal1 16.8857192322
Rred_5050 vin4.$173.GatPoly vin4.$636.Metal2 12405.3841055
Rred_5051 vin4.$173.GatPoly vin4.$640.Metal2 2301.94136839
Rred_5052 vin4.$173.GatPoly vin4.P17.GatPoly 19.176544151
Rred_5053 vin4.$177.GatPoly vin4.$181.GatPoly 33.2847407407
Rred_5054 vin4.$177.GatPoly vin4.$449.Metal1 16.8901542286
Rred_5055 vin4.$177.GatPoly vin4.$457.Metal1 20.489591646
Rred_5056 vin4.$177.GatPoly vin4.$645.Metal2 2115.07400678
Rred_5057 vin4.$177.GatPoly vin4.$649.Metal2 23421.3890021
Rred_5058 vin4.$177.GatPoly vin4.P18.GatPoly 19.9708444444
Rred_5059 vin4.$178.GatPoly vin4.$448.Metal1 80.9291851852
Rred_5060 vin4.$178.GatPoly vin4.$452.Metal1 32.0018746339
Rred_5061 vin4.$178.GatPoly vin4.$456.Metal1 8.16033769425
Rred_5062 vin4.$178.GatPoly vin4.$648.Metal2 877.519802179
Rred_5063 vin4.$178.GatPoly vin4.$653.Metal2 295.150090209
Rred_5064 vin4.$178.GatPoly vin4.P38.GatPoly 22.26
Rred_5065 vin4.$178.GatPoly vin4.P39.GatPoly 365.628758224
Rred_5066 vin4.$181.GatPoly vin4.$457.Metal1 8.0987663346
Rred_5067 vin4.$181.GatPoly vin4.$649.Metal2 456.549538848
Rred_5068 vin4.$181.GatPoly vin4.$654.Metal2 158.542646647
Rred_5069 vin4.$181.GatPoly vin4.P18.GatPoly 19.9708444444
Rred_5070 vin4.$181.GatPoly vin4.P19.GatPoly 86.7094752085
Rred_5071 vin4.$202.Metal1 vin4.$206.Metal1 0.178496116933
Rred_5072 vin4.$202.Metal1 vin4.$477.Metal2 15.3809322347
Rred_5073 vin4.$202.Metal1 vin4.$479.Metal2 3.67675955388
Rred_5074 vin4.$202.Metal1 vin4.$483.Metal2 20.9909233253
Rred_5075 vin4.$202.Metal1 vin4.$8.GatPoly 8.15512705888
Rred_5076 vin4.$202.Metal1 vin4.P20.GatPoly 41.4017255522
Rred_5077 vin4.$203.Metal1 vin4.$211.Metal1 0.362310386809
Rred_5078 vin4.$203.Metal1 vin4.$477.Metal2 15.7883328011
Rred_5079 vin4.$203.Metal1 vin4.$480.Metal2 3.68923170446
Rred_5080 vin4.$203.Metal1 vin4.$484.Metal2 11.4454036843
Rred_5081 vin4.$203.Metal1 vin4.$7.GatPoly 8.08946310818
Rred_5082 vin4.$203.Metal1 vin4.P0.GatPoly 21.8775056486
Rred_5083 vin4.$203.Metal1 vin4.P1.GatPoly 37.76
Rred_5084 vin4.$206.Metal1 vin4.$210.Metal1 0.178675191093
Rred_5085 vin4.$206.Metal1 vin4.$479.Metal2 137.607164021
Rred_5086 vin4.$206.Metal1 vin4.$483.Metal2 12.426647102
Rred_5087 vin4.$206.Metal1 vin4.$8.GatPoly 32.0018746339
Rred_5088 vin4.$210.Metal1 vin4.$218.Metal1 0.362653569415
Rred_5089 vin4.$210.Metal1 vin4.$483.Metal2 26.726552795
Rred_5090 vin4.$210.Metal1 vin4.$488.Metal2 11.5186194376
Rred_5091 vin4.$210.Metal1 vin4.$492.Metal2 148.012303013
Rred_5092 vin4.$210.Metal1 vin4.$8.GatPoly 80.9291851852
Rred_5093 vin4.$211.Metal1 vin4.$219.Metal1 0.362653569415
Rred_5094 vin4.$211.Metal1 vin4.$480.Metal2 279.314226443
Rred_5095 vin4.$211.Metal1 vin4.$484.Metal2 12.9766510302
Rred_5096 vin4.$211.Metal1 vin4.$489.Metal2 11.5186194376
Rred_5097 vin4.$211.Metal1 vin4.$493.Metal2 148.012303013
Rred_5098 vin4.$218.Metal1 vin4.$226.Metal1 0.39094415179
Rred_5099 vin4.$218.Metal1 vin4.$26.GatPoly 115.651204718
Rred_5100 vin4.$218.Metal1 vin4.$488.Metal2 12.8905653645
Rred_5101 vin4.$218.Metal1 vin4.$492.Metal2 9.17818171348
Rred_5102 vin4.$219.Metal1 vin4.$223.Metal1 0.178129923539
Rred_5103 vin4.$219.Metal1 vin4.$23.GatPoly 147.386703234
Rred_5104 vin4.$219.Metal1 vin4.$489.Metal2 12.8905653645
Rred_5105 vin4.$219.Metal1 vin4.$493.Metal2 18.9451496641
Rred_5106 vin4.$219.Metal1 vin4.P2.GatPoly 36.2581717142
Rred_5107 vin4.$223.Metal1 vin4.$229.Metal1 0.36174266925
Rred_5108 vin4.$223.Metal1 vin4.$23.GatPoly 16.2158441731
Rred_5109 vin4.$223.Metal1 vin4.$493.Metal2 9.42324175824
Rred_5110 vin4.$223.Metal1 vin4.$498.Metal2 21.8084097251
Rred_5111 vin4.$223.Metal1 vin4.P2.GatPoly 81.1351604514
Rred_5112 vin4.$226.Metal1 vin4.$232.Metal1 0.331848942782
Rred_5113 vin4.$226.Metal1 vin4.$26.GatPoly 14.2581745852
Rred_5114 vin4.$226.Metal1 vin4.$492.Metal2 11.1591689028
Rred_5115 vin4.$226.Metal1 vin4.$495.Metal2 38.1149573586
Rred_5116 vin4.$226.Metal1 vin4.$499.Metal2 12.4168010073
Rred_5117 vin4.$229.Metal1 vin4.$23.GatPoly 16.5931436324
Rred_5118 vin4.$229.Metal1 vin4.$233.Metal1 0.178852088262
Rred_5119 vin4.$229.Metal1 vin4.$237.Metal1 4036.92165822
Rred_5120 vin4.$229.Metal1 vin4.$25.GatPoly 42.9916688453
Rred_5121 vin4.$229.Metal1 vin4.$498.Metal2 9.12759240183
Rred_5122 vin4.$229.Metal1 vin4.$504.Metal2 43.9859302507
Rred_5123 vin4.$23.GatPoly vin4.$233.Metal1 365.429185185
Rred_5124 vin4.$23.GatPoly vin4.$25.GatPoly 22.7378159671
Rred_5125 vin4.$23.GatPoly vin4.$498.Metal2 1836.80456241
Rred_5126 vin4.$23.GatPoly vin4.P2.GatPoly 42.9114848609
Rred_5127 vin4.$232.Metal1 vin4.$236.Metal1 0.178949087371
Rred_5128 vin4.$232.Metal1 vin4.$24.GatPoly 17.6980392157
Rred_5129 vin4.$232.Metal1 vin4.$26.GatPoly 27.2939474766
Rred_5130 vin4.$232.Metal1 vin4.$499.Metal2 10.4731205828
Rred_5131 vin4.$232.Metal1 vin4.$503.Metal2 42.814045977
Rred_5132 vin4.$233.Metal1 vin4.$237.Metal1 0.17894182666
Rred_5133 vin4.$233.Metal1 vin4.$25.GatPoly 17.0002205452
Rred_5134 vin4.$233.Metal1 vin4.$498.Metal2 23.8007022261
Rred_5135 vin4.$233.Metal1 vin4.$504.Metal2 22.6413748687
Rred_5136 vin4.$236.Metal1 vin4.$24.GatPoly 30.0016540887
Rred_5137 vin4.$236.Metal1 vin4.$240.Metal1 0.178504947966
Rred_5138 vin4.$236.Metal1 vin4.$36.GatPoly 85.9869629629
Rred_5139 vin4.$236.Metal1 vin4.$499.Metal2 31.8360854701
Rred_5140 vin4.$236.Metal1 vin4.$503.Metal2 17.9090803107
Rred_5141 vin4.$237.Metal1 vin4.$241.Metal1 0.178504947966
Rred_5142 vin4.$237.Metal1 vin4.$25.GatPoly 30.0016540887
Rred_5143 vin4.$237.Metal1 vin4.$37.GatPoly 85.9869629629
Rred_5144 vin4.$237.Metal1 vin4.$498.Metal2 48.5088769371
Rred_5145 vin4.$237.Metal1 vin4.$504.Metal2 15.140503946
Rred_5146 vin4.$24.GatPoly vin4.$240.Metal1 75.8708496732
Rred_5147 vin4.$24.GatPoly vin4.$26.GatPoly 9.36029629629
Rred_5148 vin4.$24.GatPoly vin4.$36.GatPoly 40.1272493827
Rred_5149 vin4.$24.GatPoly vin4.P23.GatPoly 22.26
Rred_5150 vin4.$240.Metal1 vin4.$246.Metal1 0.36182906056
Rred_5151 vin4.$240.Metal1 vin4.$36.GatPoly 15.6802121879
Rred_5152 vin4.$240.Metal1 vin4.$503.Metal2 11.5864555256
Rred_5153 vin4.$240.Metal1 vin4.$508.Metal2 18.0168451015
Rred_5154 vin4.$241.Metal1 vin4.$247.Metal1 0.36182906056
Rred_5155 vin4.$241.Metal1 vin4.$25.GatPoly 75.8708496732
Rred_5156 vin4.$241.Metal1 vin4.$37.GatPoly 15.6802121879
Rred_5157 vin4.$241.Metal1 vin4.$504.Metal2 11.5864555256
Rred_5158 vin4.$241.Metal1 vin4.$509.Metal2 18.0168451015
Rred_5159 vin4.$246.Metal1 vin4.$250.Metal1 0.178459879632
Rred_5160 vin4.$246.Metal1 vin4.$36.GatPoly 16.5099701104
Rred_5161 vin4.$246.Metal1 vin4.$42.GatPoly 96.2644412107
Rred_5162 vin4.$246.Metal1 vin4.$508.Metal2 10.1769943283
Rred_5163 vin4.$246.Metal1 vin4.$512.Metal2 22.5350597402
Rred_5164 vin4.$246.Metal1 vin4.P24.GatPoly 119.564647066
Rred_5165 vin4.$247.Metal1 vin4.$251.Metal1 0.17852453123
Rred_5166 vin4.$247.Metal1 vin4.$37.GatPoly 18.6069469566
Rred_5167 vin4.$247.Metal1 vin4.$43.GatPoly 152.644058952
Rred_5168 vin4.$247.Metal1 vin4.$509.Metal2 10.1769943283
Rred_5169 vin4.$247.Metal1 vin4.$513.Metal2 22.5350597402
Rred_5170 vin4.$247.Metal1 vin4.P4.GatPoly 40.541385869
Rred_5171 vin4.$25.GatPoly vin4.$37.GatPoly 40.1272493827
Rred_5172 vin4.$25.GatPoly vin4.P3.GatPoly 4.76
Rred_5173 vin4.$250.Metal1 vin4.$258.Metal1 0.362824398622
Rred_5174 vin4.$250.Metal1 vin4.$36.GatPoly 96.2644412107
Rred_5175 vin4.$250.Metal1 vin4.$42.GatPoly 15.8678203345
Rred_5176 vin4.$250.Metal1 vin4.$508.Metal2 95.3406373629
Rred_5177 vin4.$250.Metal1 vin4.$512.Metal2 10.1192256903
Rred_5178 vin4.$250.Metal1 vin4.$517.Metal2 46.1776507338
Rred_5179 vin4.$250.Metal1 vin4.P24.GatPoly 212.715280069
Rred_5180 vin4.$251.Metal1 vin4.$259.Metal1 0.362824398622
Rred_5181 vin4.$251.Metal1 vin4.$37.GatPoly 152.644058952
Rred_5182 vin4.$251.Metal1 vin4.$43.GatPoly 16.4300806005
Rred_5183 vin4.$251.Metal1 vin4.$509.Metal2 95.3406373629
Rred_5184 vin4.$251.Metal1 vin4.$513.Metal2 10.1192256903
Rred_5185 vin4.$251.Metal1 vin4.$518.Metal2 46.1776507338
Rred_5186 vin4.$251.Metal1 vin4.P4.GatPoly 72.1264392205
Rred_5187 vin4.$258.Metal1 vin4.$262.Metal1 0.178557568839
Rred_5188 vin4.$258.Metal1 vin4.$42.GatPoly 16.3459334659
Rred_5189 vin4.$258.Metal1 vin4.$44.GatPoly 48.0500043573
Rred_5190 vin4.$258.Metal1 vin4.$512.Metal2 46.1776507338
Rred_5191 vin4.$258.Metal1 vin4.$517.Metal2 11.3207867366
Rred_5192 vin4.$258.Metal1 vin4.$519.Metal2 47.2209706961
Rred_5193 vin4.$259.Metal1 vin4.$263.Metal1 0.178550748274
Rred_5194 vin4.$259.Metal1 vin4.$265.Metal1 7610.30667437
Rred_5195 vin4.$259.Metal1 vin4.$43.GatPoly 16.3459334659
Rred_5196 vin4.$259.Metal1 vin4.$47.GatPoly 48.0500043573
Rred_5197 vin4.$259.Metal1 vin4.$513.Metal2 46.1776507338
Rred_5198 vin4.$259.Metal1 vin4.$518.Metal2 9.7817715397
Rred_5199 vin4.$259.Metal1 vin4.$524.Metal2 145.280351752
Rred_5200 vin4.$26.GatPoly vin4.$492.Metal2 6114.14760608
Rred_5201 vin4.$26.GatPoly vin4.$499.Metal2 2664.67413314
Rred_5202 vin4.$262.Metal1 vin4.$264.Metal1 0.180739583769
Rred_5203 vin4.$262.Metal1 vin4.$42.GatPoly 204.212518518
Rred_5204 vin4.$262.Metal1 vin4.$44.GatPoly 18.8410085241
Rred_5205 vin4.$262.Metal1 vin4.$519.Metal2 11.1613203463
Rred_5206 vin4.$262.Metal1 vin4.$52.GatPoly 2936.27252746
Rred_5207 vin4.$263.Metal1 vin4.$265.Metal1 0.180721425263
Rred_5208 vin4.$263.Metal1 vin4.$43.GatPoly 204.212518518
Rred_5209 vin4.$263.Metal1 vin4.$47.GatPoly 18.8410085241
Rred_5210 vin4.$263.Metal1 vin4.$518.Metal2 17.0071631934
Rred_5211 vin4.$263.Metal1 vin4.$524.Metal2 34.3389922323
Rred_5212 vin4.$263.Metal1 vin4.$53.GatPoly 2936.27252746
Rred_5213 vin4.$264.Metal1 vin4.$272.Metal1 0.358969093271
Rred_5214 vin4.$264.Metal1 vin4.$44.GatPoly 33.0203657934
Rred_5215 vin4.$264.Metal1 vin4.$519.Metal2 17.6141428574
Rred_5216 vin4.$264.Metal1 vin4.$52.GatPoly 17.7474001705
Rred_5217 vin4.$264.Metal1 vin4.$525.Metal2 10.4000814367
Rred_5218 vin4.$265.Metal1 vin4.$273.Metal1 0.358974281487
Rred_5219 vin4.$265.Metal1 vin4.$47.GatPoly 33.0203657934
Rred_5220 vin4.$265.Metal1 vin4.$518.Metal2 27.6894597146
Rred_5221 vin4.$265.Metal1 vin4.$524.Metal2 8.62947986197
Rred_5222 vin4.$265.Metal1 vin4.$53.GatPoly 17.7474958524
Rred_5223 vin4.$272.Metal1 vin4.$276.Metal1 0.178843777497
Rred_5224 vin4.$272.Metal1 vin4.$280.Metal1 4137.53229591
Rred_5225 vin4.$272.Metal1 vin4.$519.Metal2 844.325347394
Rred_5226 vin4.$272.Metal1 vin4.$52.GatPoly 16.3265000824
Rred_5227 vin4.$272.Metal1 vin4.$525.Metal2 9.30100123455
Rred_5228 vin4.$272.Metal1 vin4.$532.Metal2 49.717844922
Rred_5229 vin4.$272.Metal1 vin4.$56.GatPoly 50.5791721133
Rred_5230 vin4.$273.Metal1 vin4.$281.Metal1 0.362797942164
Rred_5231 vin4.$273.Metal1 vin4.$524.Metal2 15.0113662187
Rred_5232 vin4.$273.Metal1 vin4.$529.Metal2 10.3514401745
Rred_5233 vin4.$273.Metal1 vin4.$53.GatPoly 16.9633899809
Rred_5234 vin4.$273.Metal1 vin4.$533.Metal2 100.688434264
Rred_5235 vin4.$273.Metal1 vin4.$59.GatPoly 16.8812213797
Rred_5236 vin4.$276.Metal1 vin4.$280.Metal1 0.178898601437
Rred_5237 vin4.$276.Metal1 vin4.$52.GatPoly 171.969185185
Rred_5238 vin4.$276.Metal1 vin4.$525.Metal2 22.3566696457
Rred_5239 vin4.$276.Metal1 vin4.$532.Metal2 24.1058961615
Rred_5240 vin4.$276.Metal1 vin4.$56.GatPoly 20.0005513629
Rred_5241 vin4.$280.Metal1 vin4.$284.Metal1 0.178398933563
Rred_5242 vin4.$280.Metal1 vin4.$525.Metal2 43.4328267333
Rred_5243 vin4.$280.Metal1 vin4.$532.Metal2 15.7349129944
Rred_5244 vin4.$280.Metal1 vin4.$56.GatPoly 27.001323271
Rred_5245 vin4.$280.Metal1 vin4.$64.GatPoly 96.7347407407
Rred_5246 vin4.$281.Metal1 vin4.$285.Metal1 0.178374896227
Rred_5247 vin4.$281.Metal1 vin4.$529.Metal2 14.7413390447
Rred_5248 vin4.$281.Metal1 vin4.$533.Metal2 15.9997708552
Rred_5249 vin4.$281.Metal1 vin4.$59.GatPoly 18.1851091752
Rred_5250 vin4.$281.Metal1 vin4.$65.GatPoly 84.9923100066
Rred_5251 vin4.$281.Metal1 vin4.P6.GatPoly 92.2851475241
Rred_5252 vin4.$284.Metal1 vin4.$290.Metal1 0.361824121591
Rred_5253 vin4.$284.Metal1 vin4.$532.Metal2 10.7656516291
Rred_5254 vin4.$284.Metal1 vin4.$537.Metal2 19.1286039107
Rred_5255 vin4.$284.Metal1 vin4.$56.GatPoly 68.2833464052
Rred_5256 vin4.$284.Metal1 vin4.$64.GatPoly 15.7999014456
Rred_5257 vin4.$285.Metal1 vin4.$291.Metal1 0.361824121591
Rred_5258 vin4.$285.Metal1 vin4.$533.Metal2 10.7656516291
Rred_5259 vin4.$285.Metal1 vin4.$538.Metal2 19.1286039107
Rred_5260 vin4.$285.Metal1 vin4.$59.GatPoly 114.401413815
Rred_5261 vin4.$285.Metal1 vin4.$65.GatPoly 15.6601627124
Rred_5262 vin4.$285.Metal1 vin4.P6.GatPoly 233.378884183
Rred_5263 vin4.$290.Metal1 vin4.$294.Metal1 0.17857627571
Rred_5264 vin4.$290.Metal1 vin4.$537.Metal2 10.1777438502
Rred_5265 vin4.$290.Metal1 vin4.$541.Metal2 24.3181269841
Rred_5266 vin4.$290.Metal1 vin4.$64.GatPoly 16.2930131079
Rred_5267 vin4.$290.Metal1 vin4.$72.GatPoly 97.3021776078
Rred_5268 vin4.$290.Metal1 vin4.P27.GatPoly 137.244791849
Rred_5269 vin4.$291.Metal1 vin4.$299.Metal1 0.362653569415
Rred_5270 vin4.$291.Metal1 vin4.$538.Metal2 9.52216809103
Rred_5271 vin4.$291.Metal1 vin4.$542.Metal2 12.8905653645
Rred_5272 vin4.$291.Metal1 vin4.$65.GatPoly 18.2531011901
Rred_5273 vin4.$291.Metal1 vin4.$71.GatPoly 20.4860406756
Rred_5274 vin4.$291.Metal1 vin4.P7.GatPoly 58.2686631016
Rred_5275 vin4.$294.Metal1 vin4.$302.Metal1 0.362799427562
Rred_5276 vin4.$294.Metal1 vin4.$537.Metal2 72.9543809522
Rred_5277 vin4.$294.Metal1 vin4.$541.Metal2 10.1293546422
Rred_5278 vin4.$294.Metal1 vin4.$546.Metal2 54.2048156595
Rred_5279 vin4.$294.Metal1 vin4.$64.GatPoly 97.3021776078
Rred_5280 vin4.$294.Metal1 vin4.$72.GatPoly 15.9974348707
Rred_5281 vin4.$294.Metal1 vin4.P27.GatPoly 177.329872844
Rred_5282 vin4.$299.Metal1 vin4.$303.Metal1 0.178668868145
Rred_5283 vin4.$299.Metal1 vin4.$538.Metal2 148.012303013
Rred_5284 vin4.$299.Metal1 vin4.$542.Metal2 9.91391002973
Rred_5285 vin4.$299.Metal1 vin4.$544.Metal2 136.676492583
Rred_5286 vin4.$299.Metal1 vin4.$549.Metal2 63.5012825511
Rred_5287 vin4.$299.Metal1 vin4.$71.GatPoly 15.5987328054
Rred_5288 vin4.$299.Metal1 vin4.$79.GatPoly 80.9291851852
Rred_5289 vin4.$302.Metal1 vin4.$306.Metal1 0.178371493384
Rred_5290 vin4.$302.Metal1 vin4.$541.Metal2 40.2164761345
Rred_5291 vin4.$302.Metal1 vin4.$546.Metal2 10.1082003498
Rred_5292 vin4.$302.Metal1 vin4.$550.Metal2 137.607164021
Rred_5293 vin4.$302.Metal1 vin4.$72.GatPoly 16.0835537092
Rred_5294 vin4.$302.Metal1 vin4.$76.GatPoly 55.6375076253
Rred_5295 vin4.$303.Metal1 vin4.$311.Metal1 0.375564027363
Rred_5296 vin4.$303.Metal1 vin4.$542.Metal2 36.3717608362
Rred_5297 vin4.$303.Metal1 vin4.$544.Metal2 69.856873987
Rred_5298 vin4.$303.Metal1 vin4.$549.Metal2 10.5831998195
Rred_5299 vin4.$303.Metal1 vin4.$71.GatPoly 80.9291851852
Rred_5300 vin4.$303.Metal1 vin4.$79.GatPoly 15.334097558
Rred_5301 vin4.$303.Metal1 vin4.$81.GatPoly 430.191522254
Rred_5302 vin4.$306.Metal1 vin4.$312.Metal1 0.36146618849
Rred_5303 vin4.$306.Metal1 vin4.$546.Metal2 20.9909233253
Rred_5304 vin4.$306.Metal1 vin4.$550.Metal2 10.1668380754
Rred_5305 vin4.$306.Metal1 vin4.$72.GatPoly 135.119661376
Rred_5306 vin4.$306.Metal1 vin4.$76.GatPoly 15.9311738026
Rred_5307 vin4.$306.Metal1 vin4.$82.GatPoly 98.1690707437
Rred_5308 vin4.$311.Metal1 vin4.$313.Metal1 0.165
Rred_5309 vin4.$311.Metal1 vin4.$549.Metal2 9.92591643291
Rred_5310 vin4.$311.Metal1 vin4.$553.Metal2 18.1718095238
Rred_5311 vin4.$311.Metal1 vin4.$79.GatPoly 31.5600123225
Rred_5312 vin4.$311.Metal1 vin4.$81.GatPoly 15.5718406742
Rred_5313 vin4.$312.Metal1 vin4.$316.Metal1 0.178799366164
Rred_5314 vin4.$312.Metal1 vin4.$550.Metal2 11.008714331
Rred_5315 vin4.$312.Metal1 vin4.$555.Metal2 57.4004804448
Rred_5316 vin4.$312.Metal1 vin4.$557.Metal2 33.6812736494
Rred_5317 vin4.$312.Metal1 vin4.$76.GatPoly 57.8243567653
Rred_5318 vin4.$312.Metal1 vin4.$82.GatPoly 13.0141464528
Rred_5319 vin4.$313.Metal1 vin4.$321.Metal1 0.362724514501
Rred_5320 vin4.$313.Metal1 vin4.$553.Metal2 10.5257138212
Rred_5321 vin4.$313.Metal1 vin4.$558.Metal2 35.6129523328
Rred_5322 vin4.$313.Metal1 vin4.$81.GatPoly 37.9333333333
Rred_5323 vin4.$313.Metal1 vin4.$85.GatPoly 16.8757273465
Rred_5324 vin4.$316.Metal1 vin4.$320.Metal1 0.178838571508
Rred_5325 vin4.$316.Metal1 vin4.$550.Metal2 80.5238780093
Rred_5326 vin4.$316.Metal1 vin4.$555.Metal2 148.032817989
Rred_5327 vin4.$316.Metal1 vin4.$557.Metal2 14.6154515868
Rred_5328 vin4.$316.Metal1 vin4.$82.GatPoly 33.8281181896
Rred_5329 vin4.$316.Metal1 vin4.$86.GatPoly 58.1666753812
Rred_5330 vin4.$320.Metal1 vin4.$324.Metal1 0.178840374465
Rred_5331 vin4.$320.Metal1 vin4.$557.Metal2 14.1682801538
Rred_5332 vin4.$320.Metal1 vin4.$561.Metal2 59.0882403627
Rred_5333 vin4.$320.Metal1 vin4.$82.GatPoly 123.604185185
Rred_5334 vin4.$320.Metal1 vin4.$86.GatPoly 23.0008821806
Rred_5335 vin4.$321.Metal1 vin4.$329.Metal1 0.362169844265
Rred_5336 vin4.$321.Metal1 vin4.$553.Metal2 65.6028069289
Rred_5337 vin4.$321.Metal1 vin4.$558.Metal2 8.52565576862
Rred_5338 vin4.$321.Metal1 vin4.$562.Metal2 24.2669420704
Rred_5339 vin4.$321.Metal1 vin4.$85.GatPoly 17.7993670334
Rred_5340 vin4.$321.Metal1 vin4.$91.GatPoly 20.2758380631
Rred_5341 vin4.$321.Metal1 vin4.P9.GatPoly 68.7832679738
Rred_5342 vin4.$324.Metal1 vin4.$330.Metal1 0.361795734713
Rred_5343 vin4.$324.Metal1 vin4.$557.Metal2 26.4011286728
Rred_5344 vin4.$324.Metal1 vin4.$561.Metal2 10.1761275149
Rred_5345 vin4.$324.Metal1 vin4.$86.GatPoly 27.1411764706
Rred_5346 vin4.$324.Metal1 vin4.$92.GatPoly 19.1121432091
Rred_5347 vin4.$329.Metal1 vin4.$335.Metal1 0.361795734713
Rred_5348 vin4.$329.Metal1 vin4.$558.Metal2 53.4649554857
Rred_5349 vin4.$329.Metal1 vin4.$562.Metal2 8.0753915984
Rred_5350 vin4.$329.Metal1 vin4.$567.Metal2 20.3813394518
Rred_5351 vin4.$329.Metal1 vin4.$91.GatPoly 16.8684682797
Rred_5352 vin4.$329.Metal1 vin4.$95.GatPoly 16.8807966702
Rred_5353 vin4.$330.Metal1 vin4.$334.Metal1 0.178273944544
Rred_5354 vin4.$330.Metal1 vin4.$561.Metal2 20.3813394518
Rred_5355 vin4.$330.Metal1 vin4.$566.Metal2 10.0511202186
Rred_5356 vin4.$330.Metal1 vin4.$92.GatPoly 15.9520155185
Rred_5357 vin4.$330.Metal1 vin4.$96.GatPoly 60.6958431373
Rred_5358 vin4.$334.Metal1 vin4.$338.Metal1 0.178840374465
Rred_5359 vin4.$334.Metal1 vin4.$566.Metal2 20.2863564567
Rred_5360 vin4.$334.Metal1 vin4.$570.Metal2 26.4011286728
Rred_5361 vin4.$334.Metal1 vin4.$92.GatPoly 114.647703704
Rred_5362 vin4.$334.Metal1 vin4.$96.GatPoly 24.0009924532
Rred_5363 vin4.$335.Metal1 vin4.$339.Metal1 0.178733854286
Rred_5364 vin4.$335.Metal1 vin4.$567.Metal2 10.1761275149
Rred_5365 vin4.$335.Metal1 vin4.$571.Metal2 26.4011286728
Rred_5366 vin4.$335.Metal1 vin4.$95.GatPoly 17.1496072721
Rred_5367 vin4.$335.Metal1 vin4.P10.GatPoly 55.3808723806
Rred_5368 vin4.$338.Metal1 vin4.$342.Metal1 0.178838571508
Rred_5369 vin4.$338.Metal1 vin4.$566.Metal2 59.0882403627
Rred_5370 vin4.$338.Metal1 vin4.$570.Metal2 14.1682801538
Rred_5371 vin4.$338.Metal1 vin4.$96.GatPoly 23.0008821806
Rred_5372 vin4.$339.Metal1 vin4.$347.Metal1 0.362724514501
Rred_5373 vin4.$339.Metal1 vin4.$567.Metal2 59.0882403627
Rred_5374 vin4.$339.Metal1 vin4.$571.Metal2 10.1385860384
Rred_5375 vin4.$339.Metal1 vin4.$576.Metal2 65.6028069289
Rred_5376 vin4.$339.Metal1 vin4.$95.GatPoly 158.710238626
Rred_5377 vin4.$339.Metal1 vin4.P10.GatPoly 52.6282325743
Rred_5378 vin4.$342.Metal1 vin4.$346.Metal1 0.178799366164
Rred_5379 vin4.$342.Metal1 vin4.$570.Metal2 14.6154515868
Rred_5380 vin4.$342.Metal1 vin4.$573.Metal2 148.032817989
Rred_5381 vin4.$342.Metal1 vin4.$577.Metal2 80.5238780093
Rred_5382 vin4.$342.Metal1 vin4.$96.GatPoly 58.1666753812
Rred_5383 vin4.$346.Metal1 vin4.$352.Metal1 0.36146618849
Rred_5384 vin4.$346.Metal1 vin4.$570.Metal2 33.6812736494
Rred_5385 vin4.$346.Metal1 vin4.$573.Metal2 57.4004804448
Rred_5386 vin4.$346.Metal1 vin4.$577.Metal2 11.008714331
Rred_5387 vin4.$347.Metal1 vin4.$349.Metal1 0.165
Rred_5388 vin4.$347.Metal1 vin4.$571.Metal2 35.6129523328
Rred_5389 vin4.$347.Metal1 vin4.$576.Metal2 10.5257138212
Rred_5390 vin4.$349.Metal1 vin4.$357.Metal1 0.375564027363
Rred_5391 vin4.$349.Metal1 vin4.$576.Metal2 18.1718095238
Rred_5392 vin4.$349.Metal1 vin4.$580.Metal2 9.92591643291
Rred_5393 vin4.$352.Metal1 vin4.$356.Metal1 0.178371493384
Rred_5394 vin4.$352.Metal1 vin4.$577.Metal2 10.1668380754
Rred_5395 vin4.$352.Metal1 vin4.$581.Metal2 20.9909233253
Rred_5396 vin4.$356.Metal1 vin4.$364.Metal1 0.362799427562
Rred_5397 vin4.$356.Metal1 vin4.$577.Metal2 137.607164021
Rred_5398 vin4.$356.Metal1 vin4.$581.Metal2 10.1082003498
Rred_5399 vin4.$356.Metal1 vin4.$586.Metal2 40.2164761345
Rred_5400 vin4.$357.Metal1 vin4.$361.Metal1 0.178668868145
Rred_5401 vin4.$357.Metal1 vin4.$580.Metal2 10.5831998195
Rred_5402 vin4.$357.Metal1 vin4.$584.Metal2 69.856873987
Rred_5403 vin4.$357.Metal1 vin4.$587.Metal2 36.3717608362
Rred_5404 vin4.$36.GatPoly vin4.$42.GatPoly 50.9131933514
Rred_5405 vin4.$36.GatPoly vin4.$508.Metal2 1563.02782058
Rred_5406 vin4.$36.GatPoly vin4.P24.GatPoly 63.2364133369
Rred_5407 vin4.$361.Metal1 vin4.$369.Metal1 0.362653569415
Rred_5408 vin4.$361.Metal1 vin4.$580.Metal2 63.5012825511
Rred_5409 vin4.$361.Metal1 vin4.$584.Metal2 136.676492583
Rred_5410 vin4.$361.Metal1 vin4.$587.Metal2 9.91391002973
Rred_5411 vin4.$361.Metal1 vin4.$591.Metal2 148.012303013
Rred_5412 vin4.$364.Metal1 vin4.$368.Metal1 0.17857627571
Rred_5413 vin4.$364.Metal1 vin4.$581.Metal2 54.2048156595
Rred_5414 vin4.$364.Metal1 vin4.$586.Metal2 10.1293546422
Rred_5415 vin4.$364.Metal1 vin4.$590.Metal2 72.9543809522
Rred_5416 vin4.$364.Metal1 vin4.P32.GatPoly 177.329872844
Rred_5417 vin4.$368.Metal1 vin4.$374.Metal1 0.361824121591
Rred_5418 vin4.$368.Metal1 vin4.$586.Metal2 24.3181269841
Rred_5419 vin4.$368.Metal1 vin4.$590.Metal2 10.1777438502
Rred_5420 vin4.$368.Metal1 vin4.P32.GatPoly 137.244791849
Rred_5421 vin4.$369.Metal1 vin4.$375.Metal1 0.361824121591
Rred_5422 vin4.$369.Metal1 vin4.$587.Metal2 12.8905653645
Rred_5423 vin4.$369.Metal1 vin4.$591.Metal2 9.52216809103
Rred_5424 vin4.$369.Metal1 vin4.P12.GatPoly 58.2686631016
Rred_5425 vin4.$37.GatPoly vin4.$43.GatPoly 80.7317467344
Rred_5426 vin4.$37.GatPoly vin4.$509.Metal2 1563.02782058
Rred_5427 vin4.$37.GatPoly vin4.P4.GatPoly 21.4418885263
Rred_5428 vin4.$374.Metal1 vin4.$378.Metal1 0.178398933563
Rred_5429 vin4.$374.Metal1 vin4.$590.Metal2 19.1286039107
Rred_5430 vin4.$374.Metal1 vin4.$595.Metal2 10.7656516291
Rred_5431 vin4.$375.Metal1 vin4.$379.Metal1 0.178374896227
Rred_5432 vin4.$375.Metal1 vin4.$591.Metal2 19.1286039107
Rred_5433 vin4.$375.Metal1 vin4.$596.Metal2 10.7656516291
Rred_5434 vin4.$375.Metal1 vin4.P13.GatPoly 233.378884183
Rred_5435 vin4.$378.Metal1 vin4.$382.Metal1 0.178898601437
Rred_5436 vin4.$378.Metal1 vin4.$386.Metal1 4137.53229591
Rred_5437 vin4.$378.Metal1 vin4.$595.Metal2 15.7349129944
Rred_5438 vin4.$378.Metal1 vin4.$601.Metal2 43.4328267333
Rred_5439 vin4.$379.Metal1 vin4.$387.Metal1 0.362797942164
Rred_5440 vin4.$379.Metal1 vin4.$596.Metal2 15.9997708552
Rred_5441 vin4.$379.Metal1 vin4.$600.Metal2 14.7413390447
Rred_5442 vin4.$379.Metal1 vin4.P13.GatPoly 92.2851475241
Rred_5443 vin4.$382.Metal1 vin4.$386.Metal1 0.178843777497
Rred_5444 vin4.$382.Metal1 vin4.$595.Metal2 24.1058961615
Rred_5445 vin4.$382.Metal1 vin4.$601.Metal2 22.3566696457
Rred_5446 vin4.$386.Metal1 vin4.$392.Metal1 0.358969093271
Rred_5447 vin4.$386.Metal1 vin4.$595.Metal2 49.717844922
Rred_5448 vin4.$386.Metal1 vin4.$601.Metal2 9.30100123455
Rred_5449 vin4.$386.Metal1 vin4.$608.Metal2 844.325347394
Rred_5450 vin4.$387.Metal1 vin4.$393.Metal1 0.358974281487
Rred_5451 vin4.$387.Metal1 vin4.$596.Metal2 100.688434264
Rred_5452 vin4.$387.Metal1 vin4.$600.Metal2 10.3514401745
Rred_5453 vin4.$387.Metal1 vin4.$605.Metal2 15.0113662187
Rred_5454 vin4.$392.Metal1 vin4.$396.Metal1 0.180739583769
Rred_5455 vin4.$392.Metal1 vin4.$601.Metal2 10.4000814367
Rred_5456 vin4.$392.Metal1 vin4.$608.Metal2 17.6141428574
Rred_5457 vin4.$393.Metal1 vin4.$397.Metal1 0.180721425263
Rred_5458 vin4.$393.Metal1 vin4.$401.Metal1 7610.30667437
Rred_5459 vin4.$393.Metal1 vin4.$605.Metal2 8.62947986197
Rred_5460 vin4.$393.Metal1 vin4.$611.Metal2 27.6894597146
Rred_5461 vin4.$396.Metal1 vin4.$400.Metal1 0.178557568839
Rred_5462 vin4.$396.Metal1 vin4.$608.Metal2 11.1613203463
Rred_5463 vin4.$397.Metal1 vin4.$401.Metal1 0.178550748274
Rred_5464 vin4.$397.Metal1 vin4.$605.Metal2 34.3389922323
Rred_5465 vin4.$397.Metal1 vin4.$611.Metal2 17.0071631934
Rred_5466 vin4.$400.Metal1 vin4.$408.Metal1 0.362824398622
Rred_5467 vin4.$400.Metal1 vin4.$608.Metal2 47.2209706961
Rred_5468 vin4.$400.Metal1 vin4.$610.Metal2 11.3207867366
Rred_5469 vin4.$400.Metal1 vin4.$615.Metal2 46.1776507338
Rred_5470 vin4.$401.Metal1 vin4.$409.Metal1 0.362824398622
Rred_5471 vin4.$401.Metal1 vin4.$605.Metal2 145.280351752
Rred_5472 vin4.$401.Metal1 vin4.$611.Metal2 9.7817715397
Rred_5473 vin4.$401.Metal1 vin4.$616.Metal2 46.1776507338
Rred_5474 vin4.$408.Metal1 vin4.$412.Metal1 0.178459879632
Rred_5475 vin4.$408.Metal1 vin4.$610.Metal2 46.1776507338
Rred_5476 vin4.$408.Metal1 vin4.$615.Metal2 10.1192256903
Rred_5477 vin4.$408.Metal1 vin4.$619.Metal2 95.3406373629
Rred_5478 vin4.$408.Metal1 vin4.P35.GatPoly 212.715280069
Rred_5479 vin4.$409.Metal1 vin4.$413.Metal1 0.17852453123
Rred_5480 vin4.$409.Metal1 vin4.$611.Metal2 46.1776507338
Rred_5481 vin4.$409.Metal1 vin4.$616.Metal2 10.1192256903
Rred_5482 vin4.$409.Metal1 vin4.$620.Metal2 95.3406373629
Rred_5483 vin4.$409.Metal1 vin4.P15.GatPoly 72.1264392205
Rred_5484 vin4.$412.Metal1 vin4.$418.Metal1 0.36182906056
Rred_5485 vin4.$412.Metal1 vin4.$615.Metal2 22.5350597402
Rred_5486 vin4.$412.Metal1 vin4.$619.Metal2 10.1769943283
Rred_5487 vin4.$412.Metal1 vin4.P35.GatPoly 119.564647066
Rred_5488 vin4.$413.Metal1 vin4.$419.Metal1 0.36182906056
Rred_5489 vin4.$413.Metal1 vin4.$616.Metal2 22.5350597402
Rred_5490 vin4.$413.Metal1 vin4.$620.Metal2 10.1769943283
Rred_5491 vin4.$413.Metal1 vin4.P15.GatPoly 40.541385869
Rred_5492 vin4.$418.Metal1 vin4.$422.Metal1 0.178504947966
Rred_5493 vin4.$418.Metal1 vin4.$619.Metal2 18.0168451015
Rred_5494 vin4.$418.Metal1 vin4.$624.Metal2 11.5864555256
Rred_5495 vin4.$419.Metal1 vin4.$423.Metal1 0.178504947966
Rred_5496 vin4.$419.Metal1 vin4.$620.Metal2 18.0168451015
Rred_5497 vin4.$419.Metal1 vin4.$625.Metal2 11.5864555256
Rred_5498 vin4.$42.GatPoly vin4.$44.GatPoly 25.4131134156
Rred_5499 vin4.$42.GatPoly vin4.$512.Metal2 3870.9558658
Rred_5500 vin4.$42.GatPoly vin4.$517.Metal2 3870.9558658
Rred_5501 vin4.$42.GatPoly vin4.P24.GatPoly 112.502748125
Rred_5502 vin4.$422.Metal1 vin4.$426.Metal1 0.178949087371
Rred_5503 vin4.$422.Metal1 vin4.$624.Metal2 17.9090803107
Rred_5504 vin4.$422.Metal1 vin4.$628.Metal2 31.8360854701
Rred_5505 vin4.$423.Metal1 vin4.$427.Metal1 0.17894182666
Rred_5506 vin4.$423.Metal1 vin4.$431.Metal1 4036.92165822
Rred_5507 vin4.$423.Metal1 vin4.$625.Metal2 15.140503946
Rred_5508 vin4.$423.Metal1 vin4.$631.Metal2 48.5088769371
Rred_5509 vin4.$426.Metal1 vin4.$432.Metal1 0.331848942782
Rred_5510 vin4.$426.Metal1 vin4.$624.Metal2 42.814045977
Rred_5511 vin4.$426.Metal1 vin4.$628.Metal2 10.4731205828
Rred_5512 vin4.$427.Metal1 vin4.$431.Metal1 0.178852088262
Rred_5513 vin4.$427.Metal1 vin4.$625.Metal2 22.6413748687
Rred_5514 vin4.$427.Metal1 vin4.$631.Metal2 23.8007022261
Rred_5515 vin4.$43.GatPoly vin4.$47.GatPoly 25.4131134156
Rred_5516 vin4.$43.GatPoly vin4.$513.Metal2 3870.9558658
Rred_5517 vin4.$43.GatPoly vin4.$518.Metal2 3870.9558658
Rred_5518 vin4.$43.GatPoly vin4.P4.GatPoly 38.1468722988
Rred_5519 vin4.$431.Metal1 vin4.$439.Metal1 0.36174266925
Rred_5520 vin4.$431.Metal1 vin4.$625.Metal2 43.9859302507
Rred_5521 vin4.$431.Metal1 vin4.$631.Metal2 9.12759240183
Rred_5522 vin4.$432.Metal1 vin4.$440.Metal1 0.39094415179
Rred_5523 vin4.$432.Metal1 vin4.$628.Metal2 12.4168010073
Rred_5524 vin4.$432.Metal1 vin4.$633.Metal2 38.1149573586
Rred_5525 vin4.$432.Metal1 vin4.$635.Metal2 11.1591689028
Rred_5526 vin4.$439.Metal1 vin4.$441.Metal1 0.178129923539
Rred_5527 vin4.$439.Metal1 vin4.$631.Metal2 21.8084097251
Rred_5528 vin4.$439.Metal1 vin4.$636.Metal2 9.42324175824
Rred_5529 vin4.$439.Metal1 vin4.P17.GatPoly 81.1351604514
Rred_5530 vin4.$44.GatPoly vin4.$52.GatPoly 17.2080405764
Rred_5531 vin4.$44.GatPoly vin4.P25.GatPoly 22.26
Rred_5532 vin4.$440.Metal1 vin4.$448.Metal1 0.362653569415
Rred_5533 vin4.$440.Metal1 vin4.$635.Metal2 9.17818171348
Rred_5534 vin4.$440.Metal1 vin4.$639.Metal2 12.8905653645
Rred_5535 vin4.$441.Metal1 vin4.$449.Metal1 0.362653569415
Rred_5536 vin4.$441.Metal1 vin4.$636.Metal2 18.9451496641
Rred_5537 vin4.$441.Metal1 vin4.$640.Metal2 12.8905653645
Rred_5538 vin4.$441.Metal1 vin4.P17.GatPoly 36.2581717142
Rred_5539 vin4.$448.Metal1 vin4.$452.Metal1 0.178675191093
Rred_5540 vin4.$448.Metal1 vin4.$635.Metal2 148.012303013
Rred_5541 vin4.$448.Metal1 vin4.$639.Metal2 11.5186194376
Rred_5542 vin4.$448.Metal1 vin4.$644.Metal2 26.726552795
Rred_5543 vin4.$449.Metal1 vin4.$457.Metal1 0.362310386809
Rred_5544 vin4.$449.Metal1 vin4.$636.Metal2 148.012303013
Rred_5545 vin4.$449.Metal1 vin4.$640.Metal2 11.5186194376
Rred_5546 vin4.$449.Metal1 vin4.$645.Metal2 12.9766510302
Rred_5547 vin4.$449.Metal1 vin4.$649.Metal2 279.314226443
Rred_5548 vin4.$452.Metal1 vin4.$456.Metal1 0.178496116933
Rred_5549 vin4.$452.Metal1 vin4.$644.Metal2 12.426647102
Rred_5550 vin4.$452.Metal1 vin4.$648.Metal2 137.607164021
Rred_5551 vin4.$456.Metal1 vin4.$644.Metal2 20.9909233253
Rred_5552 vin4.$456.Metal1 vin4.$648.Metal2 6.62883717454
Rred_5553 vin4.$456.Metal1 vin4.$653.Metal2 5.24434565257
Rred_5554 vin4.$456.Metal1 vin4.P39.GatPoly 41.5022353547
Rred_5555 vin4.$457.Metal1 vin4.$645.Metal2 11.4454036843
Rred_5556 vin4.$457.Metal1 vin4.$649.Metal2 6.53320320366
Rred_5557 vin4.$457.Metal1 vin4.$654.Metal2 5.38299903212
Rred_5558 vin4.$457.Metal1 vin4.P18.GatPoly 37.76
Rred_5559 vin4.$457.Metal1 vin4.P19.GatPoly 21.9316993903
Rred_5560 vin4.$47.GatPoly vin4.$53.GatPoly 17.2080405764
Rred_5561 vin4.$47.GatPoly vin4.P5.GatPoly 4.76
Rred_5562 vin4.$477.Metal2 vin4.$479.Metal2 0.396375994988
Rred_5563 vin4.$477.Metal2 vin4.$480.Metal2 0.396394780345
Rred_5564 vin4.$477.Metal2 vin4.$486.Metal2 0.12144
Rred_5565 vin4.$477.Metal2 vin4.$7.GatPoly 465.005483652
Rred_5566 vin4.$477.Metal2 vin4.$8.GatPoly 865.63392982
Rred_5567 vin4.$477.Metal2 vin4.P0.GatPoly 584.620514403
Rred_5568 vin4.$477.Metal2 vin4.P20.GatPoly 1158.69091838
Rred_5569 vin4.$479.Metal2 vin4.$483.Metal2 0.346891446111
Rred_5570 vin4.$479.Metal2 vin4.$8.GatPoly 303.791569168
Rred_5571 vin4.$479.Metal2 vin4.P20.GatPoly 472.14281189
Rred_5572 vin4.$480.Metal2 vin4.$484.Metal2 0.346885244507
Rred_5573 vin4.$480.Metal2 vin4.$7.GatPoly 161.378216951
Rred_5574 vin4.$480.Metal2 vin4.P0.GatPoly 240.616715671
Rred_5575 vin4.$483.Metal2 vin4.$486.Metal2 0.692446258504
Rred_5576 vin4.$483.Metal2 vin4.$488.Metal2 0.200294372294
Rred_5577 vin4.$484.Metal2 vin4.$486.Metal2 0.692446258504
Rred_5578 vin4.$484.Metal2 vin4.$489.Metal2 0.200294372294
Rred_5579 vin4.$486.Metal2 vin4.$488.Metal2 0.515651469098
Rred_5580 vin4.$486.Metal2 vin4.$489.Metal2 0.515651469098
Rred_5581 vin4.$486.Metal2 vin4.$495.Metal2 0.12144
Rred_5582 vin4.$488.Metal2 vin4.$492.Metal2 0.346876010592
Rred_5583 vin4.$489.Metal2 vin4.$493.Metal2 0.346876010592
Rred_5584 vin4.$492.Metal2 vin4.$495.Metal2 0.643273146381
Rred_5585 vin4.$492.Metal2 vin4.$499.Metal2 0.463026148652
Rred_5586 vin4.$493.Metal2 vin4.$495.Metal2 4.31912380951
Rred_5587 vin4.$493.Metal2 vin4.$498.Metal2 0.178476190476
Rred_5588 vin4.$495.Metal2 vin4.$498.Metal2 0.280462585034
Rred_5589 vin4.$495.Metal2 vin4.$499.Metal2 0.727612519313
Rred_5590 vin4.$495.Metal2 vin4.$506.Metal2 0.12144
Rred_5591 vin4.$498.Metal2 vin4.$504.Metal2 0.528548299458
Rred_5592 vin4.$499.Metal2 vin4.$503.Metal2 0.346883084067
Rred_5593 vin4.$503.Metal2 vin4.$506.Metal2 0.417099415205
Rred_5594 vin4.$503.Metal2 vin4.$508.Metal2 0.196484848485
Rred_5595 vin4.$504.Metal2 vin4.$506.Metal2 0.417099415205
Rred_5596 vin4.$504.Metal2 vin4.$509.Metal2 0.196484848485
Rred_5597 vin4.$506.Metal2 vin4.$508.Metal2 0.950986666669
Rred_5598 vin4.$506.Metal2 vin4.$509.Metal2 0.950986666669
Rred_5599 vin4.$506.Metal2 vin4.$515.Metal2 0.12144
Rred_5600 vin4.$508.Metal2 vin4.$512.Metal2 0.3468888772
Rred_5601 vin4.$509.Metal2 vin4.$513.Metal2 0.3468888772
Rred_5602 vin4.$512.Metal2 vin4.$515.Metal2 0.885199294533
Rred_5603 vin4.$512.Metal2 vin4.$517.Metal2 0.19751717122
Rred_5604 vin4.$513.Metal2 vin4.$515.Metal2 0.885199294533
Rred_5605 vin4.$513.Metal2 vin4.$518.Metal2 0.19751717122
Rred_5606 vin4.$515.Metal2 vin4.$517.Metal2 0.434552380953
Rred_5607 vin4.$515.Metal2 vin4.$518.Metal2 0.434552380953
Rred_5608 vin4.$515.Metal2 vin4.$524.Metal2 0.793988220725
Rred_5609 vin4.$515.Metal2 vin4.$525.Metal2 0.747094537052
Rred_5610 vin4.$515.Metal2 vin4.$529.Metal2 20.9083564791
Rred_5611 vin4.$515.Metal2 vin4.$535.Metal2 0.357864457583
Rred_5612 vin4.$517.Metal2 vin4.$519.Metal2 0.17180952381
Rred_5613 vin4.$518.Metal2 vin4.$524.Metal2 0.528590320902
Rred_5614 vin4.$519.Metal2 vin4.$52.GatPoly 111904.93744
Rred_5615 vin4.$519.Metal2 vin4.$525.Metal2 0.353544628822
Rred_5616 vin4.$52.GatPoly vin4.$525.Metal2 2027.68731673
Rred_5617 vin4.$52.GatPoly vin4.$56.GatPoly 26.7507621399
Rred_5618 vin4.$524.Metal2 vin4.$525.Metal2 1.65756685141
Rred_5619 vin4.$524.Metal2 vin4.$529.Metal2 0.17524885292
Rred_5620 vin4.$524.Metal2 vin4.$53.GatPoly 1989.57191416
Rred_5621 vin4.$524.Metal2 vin4.$535.Metal2 0.793988220725
Rred_5622 vin4.$525.Metal2 vin4.$529.Metal2 43.6492604206
Rred_5623 vin4.$525.Metal2 vin4.$532.Metal2 0.521902039577
Rred_5624 vin4.$525.Metal2 vin4.$535.Metal2 0.747094537052
Rred_5625 vin4.$529.Metal2 vin4.$533.Metal2 0.346869470833
Rred_5626 vin4.$529.Metal2 vin4.$535.Metal2 20.9083564791
Rred_5627 vin4.$529.Metal2 vin4.$59.GatPoly 2525.70222612
Rred_5628 vin4.$53.GatPoly vin4.$59.GatPoly 20.0625185185
Rred_5629 vin4.$532.Metal2 vin4.$535.Metal2 0.493407191448
Rred_5630 vin4.$532.Metal2 vin4.$537.Metal2 0.19980952381
Rred_5631 vin4.$533.Metal2 vin4.$535.Metal2 0.493407191448
Rred_5632 vin4.$533.Metal2 vin4.$538.Metal2 0.19980952381
Rred_5633 vin4.$533.Metal2 vin4.$59.GatPoly 8439.59448869
Rred_5634 vin4.$535.Metal2 vin4.$537.Metal2 0.732634920637
Rred_5635 vin4.$535.Metal2 vin4.$538.Metal2 0.732634920637
Rred_5636 vin4.$535.Metal2 vin4.$544.Metal2 0.12144
Rred_5637 vin4.$537.Metal2 vin4.$541.Metal2 0.346886758096
Rred_5638 vin4.$537.Metal2 vin4.$64.GatPoly 1611.09899248
Rred_5639 vin4.$538.Metal2 vin4.$542.Metal2 0.346876010592
Rred_5640 vin4.$538.Metal2 vin4.$65.GatPoly 1611.09899248
Rred_5641 vin4.$538.Metal2 vin4.$71.GatPoly 12405.3841055
Rred_5642 vin4.$541.Metal2 vin4.$544.Metal2 1.22615538847
Rred_5643 vin4.$541.Metal2 vin4.$546.Metal2 0.192530627203
Rred_5644 vin4.$541.Metal2 vin4.$72.GatPoly 3372.27982918
Rred_5645 vin4.$542.Metal2 vin4.$544.Metal2 0.546093875877
Rred_5646 vin4.$542.Metal2 vin4.$549.Metal2 0.457460174986
Rred_5647 vin4.$542.Metal2 vin4.$71.GatPoly 2301.94136839
Rred_5648 vin4.$544.Metal2 vin4.$546.Metal2 0.369792894936
Rred_5649 vin4.$544.Metal2 vin4.$549.Metal2 0.878613986878
Rred_5650 vin4.$544.Metal2 vin4.$555.Metal2 0.12144
Rred_5651 vin4.$546.Metal2 vin4.$550.Metal2 0.346891446111
Rred_5652 vin4.$546.Metal2 vin4.$72.GatPoly 4543.078818
Rred_5653 vin4.$549.Metal2 vin4.$553.Metal2 0.346898882339
Rred_5654 vin4.$549.Metal2 vin4.$79.GatPoly 1714.75888267
Rred_5655 vin4.$549.Metal2 vin4.$81.GatPoly 25055.8390465
Rred_5656 vin4.$550.Metal2 vin4.$555.Metal2 0.786467062936
Rred_5657 vin4.$550.Metal2 vin4.$557.Metal2 0.461480673293
Rred_5658 vin4.$550.Metal2 vin4.$76.GatPoly 3154.05582356
Rred_5659 vin4.$550.Metal2 vin4.$82.GatPoly 5361.89490005
Rred_5660 vin4.$553.Metal2 vin4.$555.Metal2 0.315849765258
Rred_5661 vin4.$553.Metal2 vin4.$558.Metal2 0.185328000708
Rred_5662 vin4.$553.Metal2 vin4.$85.GatPoly 5498.19357361
Rred_5663 vin4.$555.Metal2 vin4.$557.Metal2 0.599073779942
Rred_5664 vin4.$555.Metal2 vin4.$558.Metal2 2.03866666667
Rred_5665 vin4.$555.Metal2 vin4.$564.Metal2 0.12144
Rred_5666 vin4.$557.Metal2 vin4.$561.Metal2 0.346885087058
Rred_5667 vin4.$558.Metal2 vin4.$562.Metal2 0.346865293749
Rred_5668 vin4.$558.Metal2 vin4.$85.GatPoly 2987.58348254
Rred_5669 vin4.$558.Metal2 vin4.$91.GatPoly 4494.85080275
Rred_5670 vin4.$56.GatPoly vin4.$64.GatPoly 36.1143032099
Rred_5671 vin4.$56.GatPoly vin4.P26.GatPoly 22.26
Rred_5672 vin4.$561.Metal2 vin4.$564.Metal2 0.592952380953
Rred_5673 vin4.$561.Metal2 vin4.$566.Metal2 0.200917748918
Rred_5674 vin4.$561.Metal2 vin4.$92.GatPoly 1716.610141
Rred_5675 vin4.$562.Metal2 vin4.$564.Metal2 0.592952380953
Rred_5676 vin4.$562.Metal2 vin4.$567.Metal2 0.200917748918
Rred_5677 vin4.$562.Metal2 vin4.$91.GatPoly 3453.79724991
Rred_5678 vin4.$564.Metal2 vin4.$566.Metal2 0.592952380953
Rred_5679 vin4.$564.Metal2 vin4.$567.Metal2 0.592952380953
Rred_5680 vin4.$564.Metal2 vin4.$573.Metal2 0.12144
Rred_5681 vin4.$566.Metal2 vin4.$570.Metal2 0.346885087058
Rred_5682 vin4.$567.Metal2 vin4.$571.Metal2 0.346885087058
Rred_5683 vin4.$567.Metal2 vin4.$95.GatPoly 1716.610141
Rred_5684 vin4.$570.Metal2 vin4.$573.Metal2 0.599073779942
Rred_5685 vin4.$570.Metal2 vin4.$577.Metal2 0.461480673293
Rred_5686 vin4.$571.Metal2 vin4.$573.Metal2 2.03866666667
Rred_5687 vin4.$571.Metal2 vin4.$576.Metal2 0.185328000708
Rred_5688 vin4.$573.Metal2 vin4.$576.Metal2 0.315849765258
Rred_5689 vin4.$573.Metal2 vin4.$577.Metal2 0.786467062936
Rred_5690 vin4.$573.Metal2 vin4.$584.Metal2 0.12144
Rred_5691 vin4.$576.Metal2 vin4.$580.Metal2 0.346898882339
Rred_5692 vin4.$577.Metal2 vin4.$581.Metal2 0.346891446111
Rred_5693 vin4.$580.Metal2 vin4.$584.Metal2 0.878613986878
Rred_5694 vin4.$580.Metal2 vin4.$587.Metal2 0.457460174986
Rred_5695 vin4.$581.Metal2 vin4.$584.Metal2 0.369792894936
Rred_5696 vin4.$581.Metal2 vin4.$586.Metal2 0.192530627203
Rred_5697 vin4.$584.Metal2 vin4.$586.Metal2 1.22615538847
Rred_5698 vin4.$584.Metal2 vin4.$587.Metal2 0.546093875877
Rred_5699 vin4.$584.Metal2 vin4.$593.Metal2 0.12144
Rred_5700 vin4.$586.Metal2 vin4.$590.Metal2 0.346886758096
Rred_5701 vin4.$587.Metal2 vin4.$591.Metal2 0.346876010592
Rred_5702 vin4.$59.GatPoly vin4.$65.GatPoly 60.50563664
Rred_5703 vin4.$59.GatPoly vin4.P6.GatPoly 7.97486881396
Rred_5704 vin4.$590.Metal2 vin4.$593.Metal2 0.732634920637
Rred_5705 vin4.$590.Metal2 vin4.$595.Metal2 0.19980952381
Rred_5706 vin4.$591.Metal2 vin4.$593.Metal2 0.732634920637
Rred_5707 vin4.$591.Metal2 vin4.$596.Metal2 0.19980952381
Rred_5708 vin4.$593.Metal2 vin4.$595.Metal2 0.493407191448
Rred_5709 vin4.$593.Metal2 vin4.$596.Metal2 0.493407191448
Rred_5710 vin4.$593.Metal2 vin4.$600.Metal2 20.9083564791
Rred_5711 vin4.$593.Metal2 vin4.$601.Metal2 0.747094537052
Rred_5712 vin4.$593.Metal2 vin4.$605.Metal2 0.793988220725
Rred_5713 vin4.$593.Metal2 vin4.$613.Metal2 0.357864457583
Rred_5714 vin4.$595.Metal2 vin4.$601.Metal2 0.521902039577
Rred_5715 vin4.$596.Metal2 vin4.$600.Metal2 0.346869470833
Rred_5716 vin4.$600.Metal2 vin4.$601.Metal2 43.6492604206
Rred_5717 vin4.$600.Metal2 vin4.$605.Metal2 0.17524885292
Rred_5718 vin4.$600.Metal2 vin4.$613.Metal2 20.9083564791
Rred_5719 vin4.$601.Metal2 vin4.$605.Metal2 1.65756685141
Rred_5720 vin4.$601.Metal2 vin4.$608.Metal2 0.353544628822
Rred_5721 vin4.$601.Metal2 vin4.$613.Metal2 0.747094537052
Rred_5722 vin4.$605.Metal2 vin4.$611.Metal2 0.528590320902
Rred_5723 vin4.$605.Metal2 vin4.$613.Metal2 0.793988220725
Rred_5724 vin4.$608.Metal2 vin4.$610.Metal2 0.17180952381
Rred_5725 vin4.$610.Metal2 vin4.$613.Metal2 0.434552380953
Rred_5726 vin4.$610.Metal2 vin4.$615.Metal2 0.19751717122
Rred_5727 vin4.$611.Metal2 vin4.$613.Metal2 0.434552380953
Rred_5728 vin4.$611.Metal2 vin4.$616.Metal2 0.19751717122
Rred_5729 vin4.$613.Metal2 vin4.$615.Metal2 0.885199294533
Rred_5730 vin4.$613.Metal2 vin4.$616.Metal2 0.885199294533
Rred_5731 vin4.$613.Metal2 vin4.$622.Metal2 0.12144
Rred_5732 vin4.$615.Metal2 vin4.$619.Metal2 0.3468888772
Rred_5733 vin4.$616.Metal2 vin4.$620.Metal2 0.3468888772
Rred_5734 vin4.$619.Metal2 vin4.$622.Metal2 0.950986666669
Rred_5735 vin4.$619.Metal2 vin4.$624.Metal2 0.196484848485
Rred_5736 vin4.$620.Metal2 vin4.$622.Metal2 0.950986666669
Rred_5737 vin4.$620.Metal2 vin4.$625.Metal2 0.196484848485
Rred_5738 vin4.$622.Metal2 vin4.$624.Metal2 0.417099415205
Rred_5739 vin4.$622.Metal2 vin4.$625.Metal2 0.417099415205
Rred_5740 vin4.$622.Metal2 vin4.$633.Metal2 0.12144
Rred_5741 vin4.$624.Metal2 vin4.$628.Metal2 0.346883084067
Rred_5742 vin4.$625.Metal2 vin4.$631.Metal2 0.528548299458
Rred_5743 vin4.$628.Metal2 vin4.$633.Metal2 0.727612519313
Rred_5744 vin4.$628.Metal2 vin4.$635.Metal2 0.463026148652
Rred_5745 vin4.$631.Metal2 vin4.$633.Metal2 0.280462585034
Rred_5746 vin4.$631.Metal2 vin4.$636.Metal2 0.178476190476
Rred_5747 vin4.$633.Metal2 vin4.$635.Metal2 0.643273146381
Rred_5748 vin4.$633.Metal2 vin4.$636.Metal2 4.31912380951
Rred_5749 vin4.$633.Metal2 vin4.$642.Metal2 0.12144
Rred_5750 vin4.$635.Metal2 vin4.$639.Metal2 0.346876010592
Rred_5751 vin4.$636.Metal2 vin4.$640.Metal2 0.346876010592
Rred_5752 vin4.$639.Metal2 vin4.$642.Metal2 0.515651469098
Rred_5753 vin4.$639.Metal2 vin4.$644.Metal2 0.200294372294
Rred_5754 vin4.$64.GatPoly vin4.$72.GatPoly 51.4620406015
Rred_5755 vin4.$64.GatPoly vin4.P27.GatPoly 72.5872454666
Rred_5756 vin4.$640.Metal2 vin4.$642.Metal2 0.515651469098
Rred_5757 vin4.$640.Metal2 vin4.$645.Metal2 0.200294372294
Rred_5758 vin4.$642.Metal2 vin4.$644.Metal2 0.692446258504
Rred_5759 vin4.$642.Metal2 vin4.$645.Metal2 0.692446258504
Rred_5760 vin4.$642.Metal2 vin4.$648.Metal2 2.98963708333
Rred_5761 vin4.$642.Metal2 vin4.$649.Metal2 3.5599249307
Rred_5762 vin4.$642.Metal2 vin4.$653.Metal2 0.781905083333
Rred_5763 vin4.$642.Metal2 vin4.$654.Metal2 0.931057289569
Rred_5764 vin4.$644.Metal2 vin4.$648.Metal2 0.346891446111
Rred_5765 vin4.$645.Metal2 vin4.$649.Metal2 0.346885244507
Rred_5766 vin4.$648.Metal2 vin4.$649.Metal2 53.5446887191
Rred_5767 vin4.$648.Metal2 vin4.$653.Metal2 0.182219103574
Rred_5768 vin4.$648.Metal2 vin4.$654.Metal2 14.0039955112
Rred_5769 vin4.$648.Metal2 vin4.P39.GatPoly 1960.12022876
Rred_5770 vin4.$649.Metal2 vin4.$653.Metal2 14.0039955112
Rred_5771 vin4.$649.Metal2 vin4.$654.Metal2 0.180822929899
Rred_5772 vin4.$649.Metal2 vin4.P19.GatPoly 1031.5624039
Rred_5773 vin4.$65.GatPoly vin4.$71.GatPoly 33.2347189542
Rred_5774 vin4.$65.GatPoly vin4.P6.GatPoly 123.431498746
Rred_5775 vin4.$65.GatPoly vin4.P7.GatPoly 30.8176484848
Rred_5776 vin4.$653.Metal2 vin4.$654.Metal2 3.66258344139
Rred_5777 vin4.$653.Metal2 vin4.P39.GatPoly 395.072001344
Rred_5778 vin4.$654.Metal2 vin4.P19.GatPoly 199.325141092
Rred_5779 vin4.$7.GatPoly vin4.P0.GatPoly 86.6806517579
Rred_5780 vin4.$7.GatPoly vin4.P1.GatPoly 19.9708444444
Rred_5781 vin4.$71.GatPoly vin4.$79.GatPoly 42.8025468312
Rred_5782 vin4.$71.GatPoly vin4.P7.GatPoly 12.9518899643
Rred_5783 vin4.$72.GatPoly vin4.$76.GatPoly 29.4260595885
Rred_5784 vin4.$72.GatPoly vin4.P27.GatPoly 93.7877994151
Rred_5785 vin4.$76.GatPoly vin4.$82.GatPoly 15.0537042157
Rred_5786 vin4.$76.GatPoly vin4.P28.GatPoly 22.26
Rred_5787 vin4.$79.GatPoly vin4.$81.GatPoly 11.1325184116
Rred_5788 vin4.$79.GatPoly vin4.P8.GatPoly 11.3586666667
Rred_5789 vin4.$8.GatPoly vin4.P20.GatPoly 365.489864519
Rred_5790 vin4.$8.GatPoly vin4.P21.GatPoly 22.26
Rred_5791 vin4.$81.GatPoly vin4.$85.GatPoly 20.0625185185
Rred_5792 vin4.$81.GatPoly vin4.P8.GatPoly 16.2266666667
Rred_5793 vin4.$82.GatPoly vin4.$86.GatPoly 30.7637083127
Rred_5794 vin4.$85.GatPoly vin4.$91.GatPoly 32.0988583878
Rred_5795 vin4.$85.GatPoly vin4.P9.GatPoly 36.3787061728
Rred_5796 vin4.$86.GatPoly vin4.$92.GatPoly 14.3546666667
Rred_5797 vin4.$86.GatPoly vin4.P29.GatPoly 22.26
Rred_5798 vin4.$91.GatPoly vin4.$95.GatPoly 20.0625185185
Rred_5799 vin4.$91.GatPoly vin4.P9.GatPoly 11.2006811616
Rred_5800 vin4.$92.GatPoly vin4.$96.GatPoly 32.101357037
Rred_5801 vin4.$95.GatPoly vin4.P10.GatPoly 29.2903280591
Rred_5802 vin4.$96.GatPoly vin4.P30.GatPoly 22.26
Rred_5803 vout1 vout1.$1424.Metal3 1.06110528292
Rred_5804 vout1 vout1.P18.nSD 67.3543907145
Rred_5805 vout1 vout1.P18.pSD 12.4360281964
Rred_5806 vout1.$1226.Metal3 vout1.$1292.Metal3 0.340332136788
Rred_5807 vout1.$1226.Metal3 vout1.P0.nSD 13.3422870835
Rred_5808 vout1.$1226.Metal3 vout1.P0.pSD 2.51085853912
Rred_5809 vout1.$1226.Metal3 vout1.P2.nSD 12.2645927271
Rred_5810 vout1.$1226.Metal3 vout1.P2.pSD 2.24411350379
Rred_5811 vout1.$1226.Metal3 vout1.P4.nSD 10.2779838345
Rred_5812 vout1.$1226.Metal3 vout1.P4.pSD 1.88061379842
Rred_5813 vout1.$1226.Metal3 vout1.P6.nSD 21.6028174423
Rred_5814 vout1.$1226.Metal3 vout1.P6.pSD 3.95277490422
Rred_5815 vout1.$1292.Metal3 vout1.$1358.Metal3 0.34020673713
Rred_5816 vout1.$1292.Metal3 vout1.P10.nSD 21.5948576124
Rred_5817 vout1.$1292.Metal3 vout1.P10.pSD 3.98718265158
Rred_5818 vout1.$1292.Metal3 vout1.P6.nSD 21.6028174423
Rred_5819 vout1.$1292.Metal3 vout1.P6.pSD 3.95277490422
Rred_5820 vout1.$1292.Metal3 vout1.P8.nSD 10.2779838345
Rred_5821 vout1.$1292.Metal3 vout1.P8.pSD 1.88061379842
Rred_5822 vout1.$1358.Metal3 vout1.$1424.Metal3 0.34020673713
Rred_5823 vout1.$1358.Metal3 vout1.P10.nSD 21.5948576124
Rred_5824 vout1.$1358.Metal3 vout1.P10.pSD 3.98718265158
Rred_5825 vout1.$1358.Metal3 vout1.P12.nSD 10.2779838345
Rred_5826 vout1.$1358.Metal3 vout1.P12.pSD 1.89768321577
Rred_5827 vout1.$1358.Metal3 vout1.P14.nSD 21.5948576124
Rred_5828 vout1.$1358.Metal3 vout1.P14.pSD 3.98718265158
Rred_5829 vout1.$1424.Metal3 vout1.P14.nSD 21.5948576124
Rred_5830 vout1.$1424.Metal3 vout1.P14.pSD 3.98718265158
Rred_5831 vout1.$1424.Metal3 vout1.P16.nSD 10.2779838345
Rred_5832 vout1.$1424.Metal3 vout1.P16.pSD 1.89768321577
Rred_5833 vout1.$1424.Metal3 vout1.P18.nSD 13.354749883
Rred_5834 vout1.$1424.Metal3 vout1.P18.pSD 2.46576421135
Rred_5835 vout1.P0.nSD vout1.P0.pSD 84.3225466509
Rred_5836 vout1.P0.nSD vout1.P2.nSD 846.910887838
Rred_5837 vout1.P0.nSD vout1.P2.pSD 154.963495502
Rred_5838 vout1.P0.pSD vout1.P2.nSD 159.378479963
Rred_5839 vout1.P0.pSD vout1.P2.pSD 29.1622728172
Rred_5840 vout1.P10.nSD vout1.P10.pSD 253.089172665
Rred_5841 vout1.P14.nSD vout1.P14.pSD 253.089172665
Rred_5842 vout1.P18.nSD vout1.P18.pSD 156.516086363
Rred_5843 vout1.P2.nSD vout1.P2.pSD 142.446654611
Rred_5844 vout1.P6.nSD vout1.P6.pSD 250.905117137
Rred_5845 vout2 vout2.$1424.Metal3 1.06110528292
Rred_5846 vout2 vout2.P18.nSD 67.3543907145
Rred_5847 vout2 vout2.P18.pSD 12.4360281964
Rred_5848 vout2.$1226.Metal3 vout2.$1292.Metal3 0.340332136788
Rred_5849 vout2.$1226.Metal3 vout2.P0.nSD 13.3422870835
Rred_5850 vout2.$1226.Metal3 vout2.P0.pSD 2.51085853912
Rred_5851 vout2.$1226.Metal3 vout2.P2.nSD 12.2645927271
Rred_5852 vout2.$1226.Metal3 vout2.P2.pSD 2.24411350379
Rred_5853 vout2.$1226.Metal3 vout2.P4.nSD 10.2779838345
Rred_5854 vout2.$1226.Metal3 vout2.P4.pSD 1.88061379842
Rred_5855 vout2.$1226.Metal3 vout2.P6.nSD 21.6028174423
Rred_5856 vout2.$1226.Metal3 vout2.P6.pSD 3.95277490422
Rred_5857 vout2.$1292.Metal3 vout2.$1358.Metal3 0.34020673713
Rred_5858 vout2.$1292.Metal3 vout2.P10.nSD 21.5948576124
Rred_5859 vout2.$1292.Metal3 vout2.P10.pSD 3.98718265158
Rred_5860 vout2.$1292.Metal3 vout2.P6.nSD 21.6028174423
Rred_5861 vout2.$1292.Metal3 vout2.P6.pSD 3.95277490422
Rred_5862 vout2.$1292.Metal3 vout2.P8.nSD 10.2779838345
Rred_5863 vout2.$1292.Metal3 vout2.P8.pSD 1.88061379842
Rred_5864 vout2.$1358.Metal3 vout2.$1424.Metal3 0.34020673713
Rred_5865 vout2.$1358.Metal3 vout2.P10.nSD 21.5948576124
Rred_5866 vout2.$1358.Metal3 vout2.P10.pSD 3.98718265158
Rred_5867 vout2.$1358.Metal3 vout2.P12.nSD 10.2779838345
Rred_5868 vout2.$1358.Metal3 vout2.P12.pSD 1.89768321577
Rred_5869 vout2.$1358.Metal3 vout2.P14.nSD 21.5948576124
Rred_5870 vout2.$1358.Metal3 vout2.P14.pSD 3.98718265158
Rred_5871 vout2.$1424.Metal3 vout2.P14.nSD 21.5948576124
Rred_5872 vout2.$1424.Metal3 vout2.P14.pSD 3.98718265158
Rred_5873 vout2.$1424.Metal3 vout2.P16.nSD 10.2779838345
Rred_5874 vout2.$1424.Metal3 vout2.P16.pSD 1.89768321577
Rred_5875 vout2.$1424.Metal3 vout2.P18.nSD 13.354749883
Rred_5876 vout2.$1424.Metal3 vout2.P18.pSD 2.46576421135
Rred_5877 vout2.P0.nSD vout2.P0.pSD 84.3225466509
Rred_5878 vout2.P0.nSD vout2.P2.nSD 846.910887838
Rred_5879 vout2.P0.nSD vout2.P2.pSD 154.963495502
Rred_5880 vout2.P0.pSD vout2.P2.nSD 159.378479963
Rred_5881 vout2.P0.pSD vout2.P2.pSD 29.1622728172
Rred_5882 vout2.P10.nSD vout2.P10.pSD 253.089172665
Rred_5883 vout2.P14.nSD vout2.P14.pSD 253.089172665
Rred_5884 vout2.P18.nSD vout2.P18.pSD 156.516086363
Rred_5885 vout2.P2.nSD vout2.P2.pSD 142.446654611
Rred_5886 vout2.P6.nSD vout2.P6.pSD 250.905117137
Rred_5887 vout3 vout3.$1424.Metal3 1.06110528292
Rred_5888 vout3 vout3.P18.nSD 67.3543907145
Rred_5889 vout3 vout3.P18.pSD 12.4360281964
Rred_5890 vout3.$1226.Metal3 vout3.$1292.Metal3 0.340332136788
Rred_5891 vout3.$1226.Metal3 vout3.P0.nSD 13.3422870835
Rred_5892 vout3.$1226.Metal3 vout3.P0.pSD 2.51085853912
Rred_5893 vout3.$1226.Metal3 vout3.P2.nSD 12.2645927271
Rred_5894 vout3.$1226.Metal3 vout3.P2.pSD 2.24411350379
Rred_5895 vout3.$1226.Metal3 vout3.P4.nSD 10.2779838345
Rred_5896 vout3.$1226.Metal3 vout3.P4.pSD 1.88061379842
Rred_5897 vout3.$1226.Metal3 vout3.P6.nSD 21.6028174423
Rred_5898 vout3.$1226.Metal3 vout3.P6.pSD 3.95277490422
Rred_5899 vout3.$1292.Metal3 vout3.$1358.Metal3 0.34020673713
Rred_5900 vout3.$1292.Metal3 vout3.P10.nSD 21.5948576124
Rred_5901 vout3.$1292.Metal3 vout3.P10.pSD 3.98718265158
Rred_5902 vout3.$1292.Metal3 vout3.P6.nSD 21.6028174423
Rred_5903 vout3.$1292.Metal3 vout3.P6.pSD 3.95277490422
Rred_5904 vout3.$1292.Metal3 vout3.P8.nSD 10.2779838345
Rred_5905 vout3.$1292.Metal3 vout3.P8.pSD 1.88061379842
Rred_5906 vout3.$1358.Metal3 vout3.$1424.Metal3 0.34020673713
Rred_5907 vout3.$1358.Metal3 vout3.P10.nSD 21.5948576124
Rred_5908 vout3.$1358.Metal3 vout3.P10.pSD 3.98718265158
Rred_5909 vout3.$1358.Metal3 vout3.P12.nSD 10.2779838345
Rred_5910 vout3.$1358.Metal3 vout3.P12.pSD 1.89768321577
Rred_5911 vout3.$1358.Metal3 vout3.P14.nSD 21.5948576124
Rred_5912 vout3.$1358.Metal3 vout3.P14.pSD 3.98718265158
Rred_5913 vout3.$1424.Metal3 vout3.P14.nSD 21.5948576124
Rred_5914 vout3.$1424.Metal3 vout3.P14.pSD 3.98718265158
Rred_5915 vout3.$1424.Metal3 vout3.P16.nSD 10.2779838345
Rred_5916 vout3.$1424.Metal3 vout3.P16.pSD 1.89768321577
Rred_5917 vout3.$1424.Metal3 vout3.P18.nSD 13.354749883
Rred_5918 vout3.$1424.Metal3 vout3.P18.pSD 2.46576421135
Rred_5919 vout3.P0.nSD vout3.P0.pSD 84.3225466509
Rred_5920 vout3.P0.nSD vout3.P2.nSD 846.910887838
Rred_5921 vout3.P0.nSD vout3.P2.pSD 154.963495502
Rred_5922 vout3.P0.pSD vout3.P2.nSD 159.378479963
Rred_5923 vout3.P0.pSD vout3.P2.pSD 29.1622728172
Rred_5924 vout3.P10.nSD vout3.P10.pSD 253.089172665
Rred_5925 vout3.P14.nSD vout3.P14.pSD 253.089172665
Rred_5926 vout3.P18.nSD vout3.P18.pSD 156.516086363
Rred_5927 vout3.P2.nSD vout3.P2.pSD 142.446654611
Rred_5928 vout3.P6.nSD vout3.P6.pSD 250.905117137
Rred_5929 vout4 vout4.$1424.Metal3 1.06110528292
Rred_5930 vout4 vout4.P18.nSD 67.3543907145
Rred_5931 vout4 vout4.P18.pSD 12.4360281964
Rred_5932 vout4.$1226.Metal3 vout4.$1292.Metal3 0.340332136788
Rred_5933 vout4.$1226.Metal3 vout4.P0.nSD 13.3422870835
Rred_5934 vout4.$1226.Metal3 vout4.P0.pSD 2.51085853912
Rred_5935 vout4.$1226.Metal3 vout4.P2.nSD 12.2645927271
Rred_5936 vout4.$1226.Metal3 vout4.P2.pSD 2.24411350379
Rred_5937 vout4.$1226.Metal3 vout4.P4.nSD 10.2779838345
Rred_5938 vout4.$1226.Metal3 vout4.P4.pSD 1.88061379842
Rred_5939 vout4.$1226.Metal3 vout4.P6.nSD 21.6028174423
Rred_5940 vout4.$1226.Metal3 vout4.P6.pSD 3.95277490422
Rred_5941 vout4.$1292.Metal3 vout4.$1358.Metal3 0.34020673713
Rred_5942 vout4.$1292.Metal3 vout4.P10.nSD 21.5948576124
Rred_5943 vout4.$1292.Metal3 vout4.P10.pSD 3.98718265158
Rred_5944 vout4.$1292.Metal3 vout4.P6.nSD 21.6028174423
Rred_5945 vout4.$1292.Metal3 vout4.P6.pSD 3.95277490422
Rred_5946 vout4.$1292.Metal3 vout4.P8.nSD 10.2779838345
Rred_5947 vout4.$1292.Metal3 vout4.P8.pSD 1.88061379842
Rred_5948 vout4.$1358.Metal3 vout4.$1424.Metal3 0.34020673713
Rred_5949 vout4.$1358.Metal3 vout4.P10.nSD 21.5948576124
Rred_5950 vout4.$1358.Metal3 vout4.P10.pSD 3.98718265158
Rred_5951 vout4.$1358.Metal3 vout4.P12.nSD 10.2779838345
Rred_5952 vout4.$1358.Metal3 vout4.P12.pSD 1.89768321577
Rred_5953 vout4.$1358.Metal3 vout4.P14.nSD 21.5948576124
Rred_5954 vout4.$1358.Metal3 vout4.P14.pSD 3.98718265158
Rred_5955 vout4.$1424.Metal3 vout4.P14.nSD 21.5948576124
Rred_5956 vout4.$1424.Metal3 vout4.P14.pSD 3.98718265158
Rred_5957 vout4.$1424.Metal3 vout4.P16.nSD 10.2779838345
Rred_5958 vout4.$1424.Metal3 vout4.P16.pSD 1.89768321577
Rred_5959 vout4.$1424.Metal3 vout4.P18.nSD 13.354749883
Rred_5960 vout4.$1424.Metal3 vout4.P18.pSD 2.46576421135
Rred_5961 vout4.P0.nSD vout4.P0.pSD 84.3225466509
Rred_5962 vout4.P0.nSD vout4.P2.nSD 846.910887838
Rred_5963 vout4.P0.nSD vout4.P2.pSD 154.963495502
Rred_5964 vout4.P0.pSD vout4.P2.nSD 159.378479963
Rred_5965 vout4.P0.pSD vout4.P2.pSD 29.1622728172
Rred_5966 vout4.P10.nSD vout4.P10.pSD 253.089172665
Rred_5967 vout4.P14.nSD vout4.P14.pSD 253.089172665
Rred_5968 vout4.P18.nSD vout4.P18.pSD 156.516086363
Rred_5969 vout4.P2.nSD vout4.P2.pSD 142.446654611
Rred_5970 vout4.P6.nSD vout4.P6.pSD 250.905117137
Rred_5971 VSS VSS.$1069.Metal1 0.0377145269726
Rred_5972 VSS VSS.$1078.Metal1 0.0377145269726
Rred_5973 VSS VSS.$1084.Metal1 0.0168574201471
Rred_5974 VSS VSS.$1160.Metal1 0.0168574201471
Rred_5975 VSS VSS.$1165.Metal1 0.0377145269726
Rred_5976 VSS VSS.$1174.Metal1 0.0377145269726
Rred_5977 VSS VSS.$3250.Metal2 2.47618061706
Rred_5978 VSS VSS.$3260.Metal2 1.27941900116
Rred_5979 VSS VSS.$3276.Metal2 2.47618061706
Rred_5980 VSS VSS.$3282.Metal2 2.47618061706
Rred_5981 VSS VSS.$3292.Metal2 1.27941900116
Rred_5982 VSS VSS.$3308.Metal2 2.47618061706
Rred_5983 VSS VSS.$4355.Metal3 7.52297571863
Rred_5984 VSS VSS.$4358.Metal3 3.65677770007
Rred_5985 VSS VSS.$4364.Metal3 7.52297571863
Rred_5986 VSS VSS.$5279.Metal3 7.52297571863
Rred_5987 VSS VSS.$5282.Metal3 3.65677770007
Rred_5988 VSS VSS.$5288.Metal3 7.52297571863
Rred_5989 VSS VSS.P0.pSD 11.1592793613
Rred_5990 VSS VSS.P1.pSD 11.1592793613
Rred_5991 VSS VSS.P11.nSD 6.30771894549
Rred_5992 VSS VSS.P2.pSD 13.7924346658
Rred_5993 VSS VSS.P3.pSD 13.7924346658
Rred_5994 VSS VSS.P35.nSD 6.30771894549
Rred_5995 VSS VSS.P59.nSD 6.30771894549
Rred_5996 VSS VSS.P83.nSD 6.30771894549
Rred_5997 VSS.$1024.Metal1 VSS.$1044.Metal1 0.0104060460767
Rred_5998 VSS.$1024.Metal1 VSS.$3157.Metal2 1.68172377179
Rred_5999 VSS.$1024.Metal1 VSS.$3205.Metal2 5.02378616276
Rred_6000 VSS.$1024.Metal1 VSS.$4778.Metal3 626.580868414
Rred_6001 VSS.$1024.Metal1 VSS.$996.Metal1 0.0208598118236
Rred_6002 VSS.$1024.Metal1 VSS.P2.pSD 11.3482094588
Rred_6003 VSS.$1024.Metal1 VSS.P3.pSD 11.3482094588
Rred_6004 VSS.$1029.Metal1 VSS.$1069.Metal1 0.0503811526048
Rred_6005 VSS.$1029.Metal1 VSS.$3151.Metal2 3.01958212153
Rred_6006 VSS.$1029.Metal1 VSS.$3199.Metal2 3.01951752004
Rred_6007 VSS.$1029.Metal1 VSS.$4751.Metal3 1532.86667717
Rred_6008 VSS.$1029.Metal1 VSS.$4799.Metal3 1532.86667717
Rred_6009 VSS.$1029.Metal1 VSS.$981.Metal1 0.0503777081793
Rred_6010 VSS.$1029.Metal1 VSS.P1.pSD 7.26225858493
Rred_6011 VSS.$1038.Metal1 VSS.$1078.Metal1 0.0503811526048
Rred_6012 VSS.$1038.Metal1 VSS.$3169.Metal2 3.01958212153
Rred_6013 VSS.$1038.Metal1 VSS.$3217.Metal2 3.01951752004
Rred_6014 VSS.$1038.Metal1 VSS.$4760.Metal3 1532.86667717
Rred_6015 VSS.$1038.Metal1 VSS.$4808.Metal3 1532.86667717
Rred_6016 VSS.$1038.Metal1 VSS.$990.Metal1 0.0503777081793
Rred_6017 VSS.$1038.Metal1 VSS.P0.pSD 7.26225858493
Rred_6018 VSS.$1044.Metal1 VSS.$1064.Metal1 0.0104061145833
Rred_6019 VSS.$1044.Metal1 VSS.$3157.Metal2 7.62871232124
Rred_6020 VSS.$1044.Metal1 VSS.$3205.Metal2 2.52939521146
Rred_6021 VSS.$1044.Metal1 VSS.$4778.Metal3 951.474652036
Rred_6022 VSS.$1044.Metal1 VSS.P2.pSD 17
Rred_6023 VSS.$1044.Metal1 VSS.P3.pSD 17
Rred_6024 VSS.$1064.Metal1 VSS.$1084.Metal1 0.0103999705414
Rred_6025 VSS.$1064.Metal1 VSS.$3205.Metal2 2.15309979481
Rred_6026 VSS.$1064.Metal1 VSS.$3260.Metal2 15.8349980554
Rred_6027 VSS.$1064.Metal1 VSS.$4802.Metal3 1974.98589936
Rred_6028 VSS.$1064.Metal1 VSS.P2.pSD 17
Rred_6029 VSS.$1064.Metal1 VSS.P3.pSD 17
Rred_6030 VSS.$1069.Metal1 VSS.$3199.Metal2 3.01954777595
Rred_6031 VSS.$1069.Metal1 VSS.$3250.Metal2 3.62232745188
Rred_6032 VSS.$1069.Metal1 VSS.$4799.Metal3 754.337028826
Rred_6033 VSS.$1069.Metal1 VSS.P1.pSD 7.92296418153
Rred_6034 VSS.$1078.Metal1 VSS.$3217.Metal2 3.01954777595
Rred_6035 VSS.$1078.Metal1 VSS.$3276.Metal2 3.62232745188
Rred_6036 VSS.$1078.Metal1 VSS.$4808.Metal3 754.337028826
Rred_6037 VSS.$1078.Metal1 VSS.P0.pSD 7.92296418153
Rred_6038 VSS.$1084.Metal1 VSS.$3205.Metal2 3.74281772218
Rred_6039 VSS.$1084.Metal1 VSS.$3260.Metal2 1.94212947093
Rred_6040 VSS.$1084.Metal1 VSS.$4802.Metal3 466.81484894
Rred_6041 VSS.$1084.Metal1 VSS.P2.pSD 12.312761802
Rred_6042 VSS.$1084.Metal1 VSS.P3.pSD 12.312761802
Rred_6043 VSS.$109.Metal1 VSS.$158.Metal1 0.0768271189887
Rred_6044 VSS.$109.Metal1 VSS.$2228.Metal2 2.03586767206
Rred_6045 VSS.$109.Metal1 VSS.$2230.Metal2 1.5
Rred_6046 VSS.$109.Metal1 VSS.$2232.Metal2 3.3280559388
Rred_6047 VSS.$109.Metal1 VSS.$68.Metal1 0.0353857262576
Rred_6048 VSS.$109.Metal1 VSS.P3.pSD 5.60218236415
Rred_6049 VSS.$112.Metal1 VSS.$159.Metal1 0.0768271189887
Rred_6050 VSS.$112.Metal1 VSS.$2234.Metal2 3.3280559388
Rred_6051 VSS.$112.Metal1 VSS.$2236.Metal2 1.5
Rred_6052 VSS.$112.Metal1 VSS.$2238.Metal2 2.03586767206
Rred_6053 VSS.$112.Metal1 VSS.$68.Metal1 0.0353857262576
Rred_6054 VSS.$112.Metal1 VSS.P2.pSD 5.60218236415
Rred_6055 VSS.$1160.Metal1 VSS.$1180.Metal1 0.0103999705414
Rred_6056 VSS.$1160.Metal1 VSS.$3292.Metal2 1.94212947093
Rred_6057 VSS.$1160.Metal1 VSS.$3344.Metal2 3.74281772218
Rred_6058 VSS.$1160.Metal1 VSS.$4838.Metal3 466.81484894
Rred_6059 VSS.$1160.Metal1 VSS.P2.pSD 12.312761802
Rred_6060 VSS.$1160.Metal1 VSS.P3.pSD 12.312761802
Rred_6061 VSS.$1165.Metal1 VSS.$1205.Metal1 0.0503811526048
Rred_6062 VSS.$1165.Metal1 VSS.$3282.Metal2 3.62232745188
Rred_6063 VSS.$1165.Metal1 VSS.$3338.Metal2 3.01954777595
Rred_6064 VSS.$1165.Metal1 VSS.$4835.Metal3 754.337028826
Rred_6065 VSS.$1165.Metal1 VSS.P1.pSD 7.92296418153
Rred_6066 VSS.$1174.Metal1 VSS.$1214.Metal1 0.0503811526048
Rred_6067 VSS.$1174.Metal1 VSS.$3308.Metal2 3.62232745188
Rred_6068 VSS.$1174.Metal1 VSS.$3356.Metal2 3.01954777595
Rred_6069 VSS.$1174.Metal1 VSS.$4844.Metal3 754.337028826
Rred_6070 VSS.$1174.Metal1 VSS.P0.pSD 7.92296418153
Rred_6071 VSS.$1180.Metal1 VSS.$1200.Metal1 0.0104061145833
Rred_6072 VSS.$1180.Metal1 VSS.$3292.Metal2 15.8349980554
Rred_6073 VSS.$1180.Metal1 VSS.$3344.Metal2 2.15309979481
Rred_6074 VSS.$1180.Metal1 VSS.$4838.Metal3 1974.98589936
Rred_6075 VSS.$1180.Metal1 VSS.P2.pSD 17
Rred_6076 VSS.$1180.Metal1 VSS.P3.pSD 17
Rred_6077 VSS.$1200.Metal1 VSS.$1220.Metal1 0.0104060460767
Rred_6078 VSS.$1200.Metal1 VSS.$3344.Metal2 2.52939521146
Rred_6079 VSS.$1200.Metal1 VSS.$3392.Metal2 7.62871232124
Rred_6080 VSS.$1200.Metal1 VSS.$4862.Metal3 951.474652036
Rred_6081 VSS.$1200.Metal1 VSS.P2.pSD 17
Rred_6082 VSS.$1200.Metal1 VSS.P3.pSD 17
Rred_6083 VSS.$1205.Metal1 VSS.$1245.Metal1 0.0503777081793
Rred_6084 VSS.$1205.Metal1 VSS.$3338.Metal2 3.01951752004
Rred_6085 VSS.$1205.Metal1 VSS.$3386.Metal2 3.01958212153
Rred_6086 VSS.$1205.Metal1 VSS.$4835.Metal3 1532.86667717
Rred_6087 VSS.$1205.Metal1 VSS.$4883.Metal3 1532.86667717
Rred_6088 VSS.$1205.Metal1 VSS.P1.pSD 7.26225858493
Rred_6089 VSS.$1214.Metal1 VSS.$1254.Metal1 0.0503777081793
Rred_6090 VSS.$1214.Metal1 VSS.$3356.Metal2 3.01951752004
Rred_6091 VSS.$1214.Metal1 VSS.$3404.Metal2 3.01958212153
Rred_6092 VSS.$1214.Metal1 VSS.$4844.Metal3 1532.86667717
Rred_6093 VSS.$1214.Metal1 VSS.$4892.Metal3 1532.86667717
Rred_6094 VSS.$1214.Metal1 VSS.P0.pSD 7.26225858493
Rred_6095 VSS.$1220.Metal1 VSS.$1260.Metal1 0.0208598118236
Rred_6096 VSS.$1220.Metal1 VSS.$3344.Metal2 5.02378616276
Rred_6097 VSS.$1220.Metal1 VSS.$3392.Metal2 1.68172377179
Rred_6098 VSS.$1220.Metal1 VSS.$4862.Metal3 626.580868414
Rred_6099 VSS.$1220.Metal1 VSS.P2.pSD 11.3482094588
Rred_6100 VSS.$1220.Metal1 VSS.P3.pSD 11.3482094588
Rred_6101 VSS.$1245.Metal1 VSS.$1265.Metal1 0.0309221197347
Rred_6102 VSS.$1245.Metal1 VSS.$3386.Metal2 3.01950933626
Rred_6103 VSS.$1245.Metal1 VSS.$3445.Metal2 4.38743601401
Rred_6104 VSS.$1245.Metal1 VSS.$4883.Metal3 754.337028826
Rred_6105 VSS.$1245.Metal1 VSS.P1.pSD 8.20885719669
Rred_6106 VSS.$1254.Metal1 VSS.$1267.Metal1 0.0309221197347
Rred_6107 VSS.$1254.Metal1 VSS.$3404.Metal2 3.01950933626
Rred_6108 VSS.$1254.Metal1 VSS.$3463.Metal2 4.38743601401
Rred_6109 VSS.$1254.Metal1 VSS.$4892.Metal3 754.337028826
Rred_6110 VSS.$1254.Metal1 VSS.P0.pSD 8.20885719669
Rred_6111 VSS.$1260.Metal1 VSS.$1279.Metal1 0.0103899273095
Rred_6112 VSS.$1260.Metal1 VSS.$3392.Metal2 1.68255549341
Rred_6113 VSS.$1260.Metal1 VSS.$3451.Metal2 3.06949523821
Rred_6114 VSS.$1260.Metal1 VSS.$4886.Metal3 382.836157757
Rred_6115 VSS.$1260.Metal1 VSS.P2.pSD 11.3441704394
Rred_6116 VSS.$1260.Metal1 VSS.P3.pSD 11.3441704394
Rred_6117 VSS.$1265.Metal1 VSS.$1364.Metal1 0.0702143752481
Rred_6118 VSS.$1265.Metal1 VSS.$3445.Metal2 1.81641905763
Rred_6119 VSS.$1265.Metal1 VSS.$3477.Metal2 3.08894169111
Rred_6120 VSS.$1265.Metal1 VSS.$3501.Metal2 8.40441758816
Rred_6121 VSS.$1265.Metal1 VSS.P1.pSD 7.38084443077
Rred_6122 VSS.$1265.Metal1 VSS.P37.nSD 6.30803357837
Rred_6123 VSS.$1266.Metal1 VSS.$1279.Metal1 0.00519887924383
Rred_6124 VSS.$1266.Metal1 VSS.$1311.Metal1 0.00519444444444
Rred_6125 VSS.$1266.Metal1 VSS.$3435.Metal2 1.36787183383
Rred_6126 VSS.$1266.Metal1 VSS.$3451.Metal2 3.40290277778
Rred_6127 VSS.$1266.Metal1 VSS.P61.nSD 6.30881361412
Rred_6128 VSS.$1266.Metal1 VSS.P85.nSD 6.30881361412
Rred_6129 VSS.$1267.Metal1 VSS.$1373.Metal1 0.0702143752481
Rred_6130 VSS.$1267.Metal1 VSS.$3463.Metal2 1.81641905763
Rred_6131 VSS.$1267.Metal1 VSS.$3495.Metal2 3.08894169111
Rred_6132 VSS.$1267.Metal1 VSS.$3519.Metal2 8.40441758816
Rred_6133 VSS.$1267.Metal1 VSS.P0.pSD 7.38084443077
Rred_6134 VSS.$1267.Metal1 VSS.P13.nSD 6.30803357837
Rred_6135 VSS.$1279.Metal1 VSS.$3392.Metal2 205.656180959
Rred_6136 VSS.$1279.Metal1 VSS.$3451.Metal2 2.6518607363
Rred_6137 VSS.$1279.Metal1 VSS.$4886.Metal3 25650.0225697
Rred_6138 VSS.$1279.Metal1 VSS.P2.pSD 17
Rred_6139 VSS.$1279.Metal1 VSS.P3.pSD 17
Rred_6140 VSS.$1311.Metal1 VSS.$1339.Metal1 0.0104064271562
Rred_6141 VSS.$1311.Metal1 VSS.$3435.Metal2 4.66484882808
Rred_6142 VSS.$1311.Metal1 VSS.$3507.Metal2 6.07170799846
Rred_6143 VSS.$1311.Metal1 VSS.$4910.Metal3 757.280653908
Rred_6144 VSS.$1311.Metal1 VSS.P2.pSD 17
Rred_6145 VSS.$1311.Metal1 VSS.P3.pSD 17
Rred_6146 VSS.$1339.Metal1 VSS.$1359.Metal1 0.0104056166409
Rred_6147 VSS.$1339.Metal1 VSS.$3435.Metal2 6.27341738947
Rred_6148 VSS.$1339.Metal1 VSS.$3507.Metal2 2.72351925575
Rred_6149 VSS.$1339.Metal1 VSS.$4910.Metal3 1018.41191388
Rred_6150 VSS.$1339.Metal1 VSS.P2.pSD 17
Rred_6151 VSS.$1339.Metal1 VSS.P3.pSD 17
Rred_6152 VSS.$1359.Metal1 VSS.$1379.Metal1 0.0103986066457
Rred_6153 VSS.$1359.Metal1 VSS.$3507.Metal2 2.10822082493
Rred_6154 VSS.$1359.Metal1 VSS.$3555.Metal2 18.7116343669
Rred_6155 VSS.$1359.Metal1 VSS.$4934.Metal3 2333.76814442
Rred_6156 VSS.$1359.Metal1 VSS.P2.pSD 17
Rred_6157 VSS.$1359.Metal1 VSS.P3.pSD 17
Rred_6158 VSS.$1364.Metal1 VSS.$1412.Metal1 0.0503803330447
Rred_6159 VSS.$1364.Metal1 VSS.$3477.Metal2 10.9394227231
Rred_6160 VSS.$1364.Metal1 VSS.$3501.Metal2 2.65496903055
Rred_6161 VSS.$1364.Metal1 VSS.$3549.Metal2 3.01971402219
Rred_6162 VSS.$1364.Metal1 VSS.$4931.Metal3 754.337028826
Rred_6163 VSS.$1364.Metal1 VSS.P1.pSD 5.88287853378
Rred_6164 VSS.$1373.Metal1 VSS.$1421.Metal1 0.0503803330447
Rred_6165 VSS.$1373.Metal1 VSS.$3495.Metal2 10.9394227231
Rred_6166 VSS.$1373.Metal1 VSS.$3519.Metal2 2.65496903055
Rred_6167 VSS.$1373.Metal1 VSS.$3567.Metal2 3.01971402219
Rred_6168 VSS.$1373.Metal1 VSS.$4940.Metal3 754.337028826
Rred_6169 VSS.$1373.Metal1 VSS.P0.pSD 5.88287853378
Rred_6170 VSS.$1379.Metal1 VSS.$1407.Metal1 0.0208622916459
Rred_6171 VSS.$1379.Metal1 VSS.$3507.Metal2 3.61101715853
Rred_6172 VSS.$1379.Metal1 VSS.$3555.Metal2 1.6827454053
Rred_6173 VSS.$1379.Metal1 VSS.$4934.Metal3 450.376308574
Rred_6174 VSS.$1379.Metal1 VSS.P2.pSD 11.3475561438
Rred_6175 VSS.$1379.Metal1 VSS.P3.pSD 11.3475561438
Rred_6176 VSS.$1407.Metal1 VSS.$1427.Metal1 0.0104023263612
Rred_6177 VSS.$1407.Metal1 VSS.$3555.Metal2 1.68254336609
Rred_6178 VSS.$1407.Metal1 VSS.$3603.Metal2 4.0372863795
Rred_6179 VSS.$1407.Metal1 VSS.$4958.Metal3 503.541815624
Rred_6180 VSS.$1407.Metal1 VSS.P2.pSD 11.3486579358
Rred_6181 VSS.$1407.Metal1 VSS.P3.pSD 11.3486579358
Rred_6182 VSS.$1412.Metal1 VSS.$1463.Metal1 0.0506589847236
Rred_6183 VSS.$1412.Metal1 VSS.$1466.Metal1 9.03177327646
Rred_6184 VSS.$1412.Metal1 VSS.$3549.Metal2 3.01974283614
Rred_6185 VSS.$1412.Metal1 VSS.$3597.Metal2 3.01971984652
Rred_6186 VSS.$1412.Metal1 VSS.$4955.Metal3 754.337028826
Rred_6187 VSS.$1412.Metal1 VSS.P1.pSD 7.07871769757
Rred_6188 VSS.$1421.Metal1 VSS.$1483.Metal1 9.03177327646
Rred_6189 VSS.$1421.Metal1 VSS.$1484.Metal1 0.0506589847236
Rred_6190 VSS.$1421.Metal1 VSS.$3567.Metal2 3.01974283614
Rred_6191 VSS.$1421.Metal1 VSS.$3615.Metal2 3.01971984652
Rred_6192 VSS.$1421.Metal1 VSS.$4964.Metal3 754.337028826
Rred_6193 VSS.$1421.Metal1 VSS.P0.pSD 7.07871769757
Rred_6194 VSS.$1427.Metal1 VSS.$1445.Metal1 0.016851519775
Rred_6195 VSS.$1427.Metal1 VSS.$3555.Metal2 12.1118591385
Rred_6196 VSS.$1427.Metal1 VSS.$3603.Metal2 1.78503067067
Rred_6197 VSS.$1427.Metal1 VSS.$4958.Metal3 1510.62544687
Rred_6198 VSS.$1427.Metal1 VSS.P2.pSD 12.3119108098
Rred_6199 VSS.$1427.Metal1 VSS.P3.pSD 12.3119108098
Rred_6200 VSS.$1445.Metal1 VSS.$1490.Metal1 0.00397329591049
Rred_6201 VSS.$1445.Metal1 VSS.$3603.Metal2 4.67062837212
Rred_6202 VSS.$1445.Metal1 VSS.$3638.Metal2 0.772991676355
Rred_6203 VSS.$1445.Metal1 VSS.P2.pSD 27.5279211787
Rred_6204 VSS.$1445.Metal1 VSS.P3.pSD 27.5279211787
Rred_6205 VSS.$1445.Metal1 VSS.P63.nSD 6.30865895516
Rred_6206 VSS.$1445.Metal1 VSS.P87.nSD 6.30865895516
Rred_6207 VSS.$1463.Metal1 VSS.$1466.Metal1 0.167409064586
Rred_6208 VSS.$1463.Metal1 VSS.$1503.Metal1 0.0250630082153
Rred_6209 VSS.$1463.Metal1 VSS.$3597.Metal2 6.06349778471
Rred_6210 VSS.$1463.Metal1 VSS.$3632.Metal2 3
Rred_6211 VSS.$1463.Metal1 VSS.P1.pSD 9.73144918941
Rred_6212 VSS.$1466.Metal1 VSS.$3597.Metal2 64.3262932227
Rred_6213 VSS.$1466.Metal1 VSS.$3632.Metal2 2.59732263903
Rred_6214 VSS.$1466.Metal1 VSS.P1.pSD 2949.4084597
Rred_6215 VSS.$1466.Metal1 VSS.P39.nSD 5.76848282367
Rred_6216 VSS.$1483.Metal1 VSS.$1484.Metal1 0.167409064586
Rred_6217 VSS.$1483.Metal1 VSS.$3615.Metal2 64.3262932227
Rred_6218 VSS.$1483.Metal1 VSS.$3650.Metal2 2.59732263903
Rred_6219 VSS.$1483.Metal1 VSS.P0.pSD 2949.4084597
Rred_6220 VSS.$1483.Metal1 VSS.P15.nSD 5.76848282367
Rred_6221 VSS.$1484.Metal1 VSS.$1512.Metal1 0.0250630082153
Rred_6222 VSS.$1484.Metal1 VSS.$3615.Metal2 6.06349778471
Rred_6223 VSS.$1484.Metal1 VSS.$3650.Metal2 3
Rred_6224 VSS.$1484.Metal1 VSS.P0.pSD 9.73144918941
Rred_6225 VSS.$1490.Metal1 VSS.$1518.Metal1 0.0103971187595
Rred_6226 VSS.$1490.Metal1 VSS.$3638.Metal2 8.28951071668
Rred_6227 VSS.$1490.Metal1 VSS.$3694.Metal2 22.8665030121
Rred_6228 VSS.$1490.Metal1 VSS.$4994.Metal3 2851.97515394
Rred_6229 VSS.$1490.Metal1 VSS.P2.pSD 17
Rred_6230 VSS.$1490.Metal1 VSS.P3.pSD 17
Rred_6231 VSS.$1503.Metal1 VSS.$1571.Metal1 0.0762090520027
Rred_6232 VSS.$1503.Metal1 VSS.$3632.Metal2 6.04810666667
Rred_6233 VSS.$1503.Metal1 VSS.$3688.Metal2 2.59271359665
Rred_6234 VSS.$1503.Metal1 VSS.$3712.Metal2 9.12157587534
Rred_6235 VSS.$1503.Metal1 VSS.$4991.Metal3 754.337028826
Rred_6236 VSS.$1503.Metal1 VSS.P1.pSD 6.90274731842
Rred_6237 VSS.$1512.Metal1 VSS.$1580.Metal1 0.0762090520027
Rred_6238 VSS.$1512.Metal1 VSS.$3650.Metal2 6.04810666667
Rred_6239 VSS.$1512.Metal1 VSS.$3706.Metal2 2.59271359665
Rred_6240 VSS.$1512.Metal1 VSS.$3730.Metal2 9.12157587534
Rred_6241 VSS.$1512.Metal1 VSS.$5000.Metal3 754.337028826
Rred_6242 VSS.$1512.Metal1 VSS.P0.pSD 6.90274731842
Rred_6243 VSS.$1518.Metal1 VSS.$1546.Metal1 0.0208620449569
Rred_6244 VSS.$1518.Metal1 VSS.$3638.Metal2 3.48811062896
Rred_6245 VSS.$1518.Metal1 VSS.$3694.Metal2 1.6827530387
Rred_6246 VSS.$1518.Metal1 VSS.$4994.Metal3 435.047057381
Rred_6247 VSS.$1518.Metal1 VSS.P2.pSD 11.3468336065
Rred_6248 VSS.$1518.Metal1 VSS.P3.pSD 11.3468336065
Rred_6249 VSS.$1546.Metal1 VSS.$1566.Metal1 0.0104033759002
Rred_6250 VSS.$1546.Metal1 VSS.$3694.Metal2 2.80561924706
Rred_6251 VSS.$1546.Metal1 VSS.$3718.Metal2 2.08453543084
Rred_6252 VSS.$1546.Metal1 VSS.P2.pSD 11.3486133252
Rred_6253 VSS.$1546.Metal1 VSS.P3.pSD 11.3486133252
Rred_6254 VSS.$1566.Metal1 VSS.$1586.Metal1 0.0104067900198
Rred_6255 VSS.$1566.Metal1 VSS.$3718.Metal2 2.80957031149
Rred_6256 VSS.$1566.Metal1 VSS.$3766.Metal2 5.88542737535
Rred_6257 VSS.$1566.Metal1 VSS.$5030.Metal3 734.047205903
Rred_6258 VSS.$1566.Metal1 VSS.P2.pSD 17
Rred_6259 VSS.$1566.Metal1 VSS.P3.pSD 17
Rred_6260 VSS.$157.Metal1 VSS.$2226.Metal2 0.997337569251
Rred_6261 VSS.$157.Metal1 VSS.$25.Metal1 0.0936634849612
Rred_6262 VSS.$157.Metal1 VSS.$29.Metal1 0.167228127478
Rred_6263 VSS.$157.Metal1 VSS.P1.pSD 4.71741315312
Rred_6264 VSS.$157.Metal1 VSS.P2.GatPoly 10.81
Rred_6265 VSS.$157.Metal1 VSS.P24.nSD 5.83762681657
Rred_6266 VSS.$157.Metal1 VSS.P25.nSD 5.83762681657
Rred_6267 VSS.$1571.Metal1 VSS.$1623.Metal1 0.0683250058824
Rred_6268 VSS.$1571.Metal1 VSS.$3688.Metal2 9.12272515148
Rred_6269 VSS.$1571.Metal1 VSS.$3712.Metal2 2.59268795112
Rred_6270 VSS.$1571.Metal1 VSS.$3760.Metal2 2.67778185654
Rred_6271 VSS.$1571.Metal1 VSS.$3784.Metal2 11.7676017942
Rred_6272 VSS.$1571.Metal1 VSS.$5027.Metal3 754.337028826
Rred_6273 VSS.$1571.Metal1 VSS.P1.pSD 5.02273893954
Rred_6274 VSS.$158.Metal1 VSS.$2228.Metal2 0.910168493798
Rred_6275 VSS.$158.Metal1 VSS.P3.pSD 4.38886229893
Rred_6276 VSS.$158.Metal1 VSS.P6.GatPoly 10.81
Rred_6277 VSS.$158.Metal1 VSS.P72.nSD 5.84344809862
Rred_6278 VSS.$158.Metal1 VSS.P73.nSD 5.84344809862
Rred_6279 VSS.$1580.Metal1 VSS.$1625.Metal1 0.0683250058824
Rred_6280 VSS.$1580.Metal1 VSS.$3706.Metal2 9.12272515148
Rred_6281 VSS.$1580.Metal1 VSS.$3730.Metal2 2.59268795112
Rred_6282 VSS.$1580.Metal1 VSS.$3778.Metal2 2.67778185654
Rred_6283 VSS.$1580.Metal1 VSS.$3802.Metal2 11.7676017942
Rred_6284 VSS.$1580.Metal1 VSS.$5036.Metal3 754.337028826
Rred_6285 VSS.$1580.Metal1 VSS.P0.pSD 5.02273893954
Rred_6286 VSS.$1586.Metal1 VSS.$1606.Metal1 0.0104042472994
Rred_6287 VSS.$1586.Metal1 VSS.$3718.Metal2 6.24211994354
Rred_6288 VSS.$1586.Metal1 VSS.$3766.Metal2 2.73388061437
Rred_6289 VSS.$1586.Metal1 VSS.$5030.Metal3 778.534915351
Rred_6290 VSS.$1586.Metal1 VSS.P2.pSD 17
Rred_6291 VSS.$1586.Metal1 VSS.P3.pSD 17
Rred_6292 VSS.$159.Metal1 VSS.$2238.Metal2 0.910168493798
Rred_6293 VSS.$159.Metal1 VSS.P2.pSD 4.38886229893
Rred_6294 VSS.$159.Metal1 VSS.P4.GatPoly 10.81
Rred_6295 VSS.$159.Metal1 VSS.P48.nSD 5.84344809862
Rred_6296 VSS.$159.Metal1 VSS.P49.nSD 5.84344809862
Rred_6297 VSS.$160.Metal1 VSS.$2240.Metal2 0.997337569251
Rred_6298 VSS.$160.Metal1 VSS.$27.Metal1 0.0936634849612
Rred_6299 VSS.$160.Metal1 VSS.$66.Metal1 0.167228127478
Rred_6300 VSS.$160.Metal1 VSS.P0.GatPoly 10.81
Rred_6301 VSS.$160.Metal1 VSS.P0.nSD 5.83762681657
Rred_6302 VSS.$160.Metal1 VSS.P0.pSD 4.71741315312
Rred_6303 VSS.$160.Metal1 VSS.P1.nSD 5.83762681657
Rred_6304 VSS.$1606.Metal1 VSS.$1629.Metal1 0.0103955116044
Rred_6305 VSS.$1606.Metal1 VSS.$3766.Metal2 2.04899284099
Rred_6306 VSS.$1606.Metal1 VSS.$3809.Metal2 24.8786208245
Rred_6307 VSS.$1606.Metal1 VSS.$5054.Metal3 4463.86737281
Rred_6308 VSS.$1606.Metal1 VSS.P2.pSD 17
Rred_6309 VSS.$1606.Metal1 VSS.P3.pSD 17
Rred_6310 VSS.$1623.Metal1 VSS.$1690.Metal1 0.0327769863206
Rred_6311 VSS.$1623.Metal1 VSS.$3760.Metal2 8.17787238273
Rred_6312 VSS.$1623.Metal1 VSS.$3784.Metal2 2.8010161252
Rred_6313 VSS.$1623.Metal1 VSS.$3819.Metal2 1.9666454863
Rred_6314 VSS.$1623.Metal1 VSS.P1.pSD 7.04259645641
Rred_6315 VSS.$1623.Metal1 VSS.P41.nSD 6.30788530775
Rred_6316 VSS.$1624.Metal1 VSS.$1629.Metal1 0.00763888888889
Rred_6317 VSS.$1624.Metal1 VSS.$1685.Metal1 0.0131659822165
Rred_6318 VSS.$1624.Metal1 VSS.$3809.Metal2 1.36787183383
Rred_6319 VSS.$1624.Metal1 VSS.$3825.Metal2 2.11911487241
Rred_6320 VSS.$1624.Metal1 VSS.P2.pSD 21.5305642393
Rred_6321 VSS.$1624.Metal1 VSS.P3.pSD 21.5305642393
Rred_6322 VSS.$1624.Metal1 VSS.P65.nSD 6.30881361412
Rred_6323 VSS.$1624.Metal1 VSS.P89.nSD 6.30881361412
Rred_6324 VSS.$1625.Metal1 VSS.$1699.Metal1 0.0327769863206
Rred_6325 VSS.$1625.Metal1 VSS.$3778.Metal2 8.17787238273
Rred_6326 VSS.$1625.Metal1 VSS.$3802.Metal2 2.8010161252
Rred_6327 VSS.$1625.Metal1 VSS.$3837.Metal2 1.9666454863
Rred_6328 VSS.$1625.Metal1 VSS.P0.pSD 7.04259645641
Rred_6329 VSS.$1625.Metal1 VSS.P17.nSD 6.30788530775
Rred_6330 VSS.$1629.Metal1 VSS.$3766.Metal2 4.10708321922
Rred_6331 VSS.$1629.Metal1 VSS.$3809.Metal2 2.85492370116
Rred_6332 VSS.$1629.Metal1 VSS.$5054.Metal3 512.247075567
Rred_6333 VSS.$1629.Metal1 VSS.P2.pSD 17
Rred_6334 VSS.$1629.Metal1 VSS.P3.pSD 17
Rred_6335 VSS.$1685.Metal1 VSS.$1705.Metal1 0.010404186219
Rred_6336 VSS.$1685.Metal1 VSS.$3825.Metal2 2.37168738593
Rred_6337 VSS.$1685.Metal1 VSS.$3881.Metal2 4.38166848966
Rred_6338 VSS.$1685.Metal1 VSS.$5078.Metal3 546.494129806
Rred_6339 VSS.$1685.Metal1 VSS.P2.pSD 14.0627009151
Rred_6340 VSS.$1685.Metal1 VSS.P3.pSD 14.0627009151
Rred_6341 VSS.$1690.Metal1 VSS.$1730.Metal1 0.0503816845649
Rred_6342 VSS.$1690.Metal1 VSS.$3819.Metal2 4.11465861119
Rred_6343 VSS.$1690.Metal1 VSS.$3875.Metal2 3.01958494445
Rred_6344 VSS.$1690.Metal1 VSS.$5075.Metal3 754.337028826
Rred_6345 VSS.$1690.Metal1 VSS.P1.pSD 8.58558123775
Rred_6346 VSS.$1699.Metal1 VSS.$1739.Metal1 0.0503816845649
Rred_6347 VSS.$1699.Metal1 VSS.$3837.Metal2 4.11465861119
Rred_6348 VSS.$1699.Metal1 VSS.$3893.Metal2 3.01958494445
Rred_6349 VSS.$1699.Metal1 VSS.$5084.Metal3 754.337028826
Rred_6350 VSS.$1699.Metal1 VSS.P0.pSD 8.58558123775
Rred_6351 VSS.$1705.Metal1 VSS.$1725.Metal1 0.0104068614969
Rred_6352 VSS.$1705.Metal1 VSS.$3825.Metal2 9.80659138163
Rred_6353 VSS.$1705.Metal1 VSS.$3881.Metal2 2.35325729591
Rred_6354 VSS.$1705.Metal1 VSS.$5078.Metal3 1223.10590957
Rred_6355 VSS.$1705.Metal1 VSS.P2.pSD 17
Rred_6356 VSS.$1705.Metal1 VSS.P3.pSD 17
Rred_6357 VSS.$1725.Metal1 VSS.$1745.Metal1 0.0104033182853
Rred_6358 VSS.$1725.Metal1 VSS.$3881.Metal2 2.29983953107
Rred_6359 VSS.$1725.Metal1 VSS.$3929.Metal2 10.8379599635
Rred_6360 VSS.$1725.Metal1 VSS.$5102.Metal3 1351.74112626
Rred_6361 VSS.$1725.Metal1 VSS.P2.pSD 17
Rred_6362 VSS.$1725.Metal1 VSS.P3.pSD 17
Rred_6363 VSS.$173.Metal1 VSS.$2226.Metal2 9
Rred_6364 VSS.$173.Metal1 VSS.$2286.Metal2 7.90420544109
Rred_6365 VSS.$173.Metal1 VSS.$2342.Metal2 3.6595857574
Rred_6366 VSS.$173.Metal1 VSS.$25.Metal1 0.0485952995856
Rred_6367 VSS.$173.Metal1 VSS.$257.Metal1 0.0614259096926
Rred_6368 VSS.$173.Metal1 VSS.$4391.Metal3 1140.21644565
Rred_6369 VSS.$173.Metal1 VSS.P1.pSD 221.142882408
Rred_6370 VSS.$1730.Metal1 VSS.$1778.Metal1 0.0503800743211
Rred_6371 VSS.$1730.Metal1 VSS.$3875.Metal2 3.01948047742
Rred_6372 VSS.$1730.Metal1 VSS.$3923.Metal2 3.019631914
Rred_6373 VSS.$1730.Metal1 VSS.$5075.Metal3 1532.86667717
Rred_6374 VSS.$1730.Metal1 VSS.$5123.Metal3 1532.86667717
Rred_6375 VSS.$1730.Metal1 VSS.P1.pSD 7.11445842696
Rred_6376 VSS.$1739.Metal1 VSS.$1787.Metal1 0.0503800743211
Rred_6377 VSS.$1739.Metal1 VSS.$3893.Metal2 3.01948047742
Rred_6378 VSS.$1739.Metal1 VSS.$3941.Metal2 3.019631914
Rred_6379 VSS.$1739.Metal1 VSS.$5084.Metal3 1532.86667717
Rred_6380 VSS.$1739.Metal1 VSS.$5132.Metal3 1532.86667717
Rred_6381 VSS.$1739.Metal1 VSS.P0.pSD 7.11445842696
Rred_6382 VSS.$1745.Metal1 VSS.$1773.Metal1 0.0208620449569
Rred_6383 VSS.$1745.Metal1 VSS.$3881.Metal2 4.20247427156
Rred_6384 VSS.$1745.Metal1 VSS.$3929.Metal2 1.68241800287
Rred_6385 VSS.$1745.Metal1 VSS.$5102.Metal3 524.144518347
Rred_6386 VSS.$1745.Metal1 VSS.P2.pSD 11.3486133252
Rred_6387 VSS.$1745.Metal1 VSS.P3.pSD 11.3486133252
Rred_6388 VSS.$1773.Metal1 VSS.$1793.Metal1 0.0103971187595
Rred_6389 VSS.$1773.Metal1 VSS.$3929.Metal2 1.6827530387
Rred_6390 VSS.$1773.Metal1 VSS.$3988.Metal2 3.48811062896
Rred_6391 VSS.$1773.Metal1 VSS.$5126.Metal3 435.047057381
Rred_6392 VSS.$1773.Metal1 VSS.P2.pSD 11.3468336065
Rred_6393 VSS.$1773.Metal1 VSS.P3.pSD 11.3468336065
Rred_6394 VSS.$1778.Metal1 VSS.$1798.Metal1 0.0358581386467
Rred_6395 VSS.$1778.Metal1 VSS.$3923.Metal2 3.01967577385
Rred_6396 VSS.$1778.Metal1 VSS.$3982.Metal2 3.7770714324
Rred_6397 VSS.$1778.Metal1 VSS.$5123.Metal3 754.337028826
Rred_6398 VSS.$1778.Metal1 VSS.P1.pSD 8.1616300373
Rred_6399 VSS.$1787.Metal1 VSS.$1800.Metal1 0.0358581386467
Rred_6400 VSS.$1787.Metal1 VSS.$3941.Metal2 3.01967577385
Rred_6401 VSS.$1787.Metal1 VSS.$4000.Metal2 3.7770714324
Rred_6402 VSS.$1787.Metal1 VSS.$5132.Metal3 754.337028826
Rred_6403 VSS.$1787.Metal1 VSS.P0.pSD 8.1616300373
Rred_6404 VSS.$1793.Metal1 VSS.$1799.Metal1 0.00887363747428
Rred_6405 VSS.$1793.Metal1 VSS.$3929.Metal2 22.8665030121
Rred_6406 VSS.$1793.Metal1 VSS.$3988.Metal2 2.24485514274
Rred_6407 VSS.$1793.Metal1 VSS.$5126.Metal3 2851.97515394
Rred_6408 VSS.$1793.Metal1 VSS.P2.pSD 17
Rred_6409 VSS.$1793.Metal1 VSS.P3.pSD 17
Rred_6410 VSS.$1798.Metal1 VSS.$1869.Metal1 0.0395650532209
Rred_6411 VSS.$1798.Metal1 VSS.$3982.Metal2 2.26229116801
Rred_6412 VSS.$1798.Metal1 VSS.$4014.Metal2 2.72599957429
Rred_6413 VSS.$1798.Metal1 VSS.P1.pSD 9.3483204091
Rred_6414 VSS.$1798.Metal1 VSS.P43.nSD 6.30774233271
Rred_6415 VSS.$1799.Metal1 VSS.$1864.Metal1 0.0119412090979
Rred_6416 VSS.$1799.Metal1 VSS.$3988.Metal2 1.4660861415
Rred_6417 VSS.$1799.Metal1 VSS.$4020.Metal2 1.73683794071
Rred_6418 VSS.$1799.Metal1 VSS.P2.pSD 19.5066478997
Rred_6419 VSS.$1799.Metal1 VSS.P3.pSD 19.5066478997
Rred_6420 VSS.$1799.Metal1 VSS.P67.nSD 6.30774233271
Rred_6421 VSS.$1799.Metal1 VSS.P91.nSD 6.30774233271
Rred_6422 VSS.$1800.Metal1 VSS.$1878.Metal1 0.0395650532209
Rred_6423 VSS.$1800.Metal1 VSS.$4000.Metal2 2.26229116801
Rred_6424 VSS.$1800.Metal1 VSS.$4032.Metal2 2.72599957429
Rred_6425 VSS.$1800.Metal1 VSS.P0.pSD 9.3483204091
Rred_6426 VSS.$1800.Metal1 VSS.P19.nSD 6.30774233271
Rred_6427 VSS.$182.Metal1 VSS.$2240.Metal2 9
Rred_6428 VSS.$182.Metal1 VSS.$2306.Metal2 7.90420544109
Rred_6429 VSS.$182.Metal1 VSS.$2360.Metal2 3.6595857574
Rred_6430 VSS.$182.Metal1 VSS.$266.Metal1 0.0614259096926
Rred_6431 VSS.$182.Metal1 VSS.$27.Metal1 0.0485952995856
Rred_6432 VSS.$182.Metal1 VSS.$4400.Metal3 1140.21644565
Rred_6433 VSS.$182.Metal1 VSS.P0.pSD 221.142882408
Rred_6434 VSS.$1864.Metal1 VSS.$1884.Metal1 0.0104023263612
Rred_6435 VSS.$1864.Metal1 VSS.$4020.Metal2 2.06823431305
Rred_6436 VSS.$1864.Metal1 VSS.$4068.Metal2 12.1118591385
Rred_6437 VSS.$1864.Metal1 VSS.$5162.Metal3 1510.62544687
Rred_6438 VSS.$1864.Metal1 VSS.P2.pSD 15.0717018687
Rred_6439 VSS.$1864.Metal1 VSS.P3.pSD 15.0717018687
Rred_6440 VSS.$1869.Metal1 VSS.$1917.Metal1 0.0503803330447
Rred_6441 VSS.$1869.Metal1 VSS.$4014.Metal2 3.49223384788
Rred_6442 VSS.$1869.Metal1 VSS.$4062.Metal2 3.01974283614
Rred_6443 VSS.$1869.Metal1 VSS.$5159.Metal3 754.337028826
Rred_6444 VSS.$1869.Metal1 VSS.P1.pSD 8.00989158551
Rred_6445 VSS.$1878.Metal1 VSS.$1926.Metal1 0.0503803330447
Rred_6446 VSS.$1878.Metal1 VSS.$4032.Metal2 3.49223384788
Rred_6447 VSS.$1878.Metal1 VSS.$4080.Metal2 3.01974283614
Rred_6448 VSS.$1878.Metal1 VSS.$5168.Metal3 754.337028826
Rred_6449 VSS.$1878.Metal1 VSS.P0.pSD 8.00989158551
Rred_6450 VSS.$1884.Metal1 VSS.$1912.Metal1 0.0208622916459
Rred_6451 VSS.$1884.Metal1 VSS.$4020.Metal2 4.0372863795
Rred_6452 VSS.$1884.Metal1 VSS.$4068.Metal2 1.68254336609
Rred_6453 VSS.$1884.Metal1 VSS.$5162.Metal3 503.541815624
Rred_6454 VSS.$1884.Metal1 VSS.P2.pSD 11.3486579358
Rred_6455 VSS.$1884.Metal1 VSS.P3.pSD 11.3486579358
Rred_6456 VSS.$1912.Metal1 VSS.$1932.Metal1 0.0103986066457
Rred_6457 VSS.$1912.Metal1 VSS.$4068.Metal2 1.6827454053
Rred_6458 VSS.$1912.Metal1 VSS.$4116.Metal2 3.61101715853
Rred_6459 VSS.$1912.Metal1 VSS.$5186.Metal3 450.376308574
Rred_6460 VSS.$1912.Metal1 VSS.P2.pSD 11.3475561438
Rred_6461 VSS.$1912.Metal1 VSS.P3.pSD 11.3475561438
Rred_6462 VSS.$1917.Metal1 VSS.$1977.Metal1 0.0762245508578
Rred_6463 VSS.$1917.Metal1 VSS.$4062.Metal2 3.01971402219
Rred_6464 VSS.$1917.Metal1 VSS.$4110.Metal2 2.59239467043
Rred_6465 VSS.$1917.Metal1 VSS.$4134.Metal2 9.11679557973
Rred_6466 VSS.$1917.Metal1 VSS.$5183.Metal3 754.337028826
Rred_6467 VSS.$1917.Metal1 VSS.P1.pSD 5.6382048292
Rred_6468 VSS.$1926.Metal1 VSS.$1986.Metal1 0.0762245508578
Rred_6469 VSS.$1926.Metal1 VSS.$4080.Metal2 3.01971402219
Rred_6470 VSS.$1926.Metal1 VSS.$4128.Metal2 2.59239467043
Rred_6471 VSS.$1926.Metal1 VSS.$4152.Metal2 9.11679557973
Rred_6472 VSS.$1926.Metal1 VSS.$5192.Metal3 754.337028826
Rred_6473 VSS.$1926.Metal1 VSS.P0.pSD 5.6382048292
Rred_6474 VSS.$1932.Metal1 VSS.$1952.Metal1 0.0104056166409
Rred_6475 VSS.$1932.Metal1 VSS.$4068.Metal2 18.7116343669
Rred_6476 VSS.$1932.Metal1 VSS.$4116.Metal2 2.10822082493
Rred_6477 VSS.$1932.Metal1 VSS.$5186.Metal3 2333.76814442
Rred_6478 VSS.$1932.Metal1 VSS.P2.pSD 17
Rred_6479 VSS.$1932.Metal1 VSS.P3.pSD 17
Rred_6480 VSS.$1952.Metal1 VSS.$1990.Metal1 0.0173172140803
Rred_6481 VSS.$1952.Metal1 VSS.$4116.Metal2 4.08656944445
Rred_6482 VSS.$1952.Metal1 VSS.$4140.Metal2 2.29688757973
Rred_6483 VSS.$1952.Metal1 VSS.P2.pSD 12.168900225
Rred_6484 VSS.$1952.Metal1 VSS.P3.pSD 12.168900225
Rred_6485 VSS.$1977.Metal1 VSS.$2064.Metal1 0.0614259096926
Rred_6486 VSS.$1977.Metal1 VSS.$4110.Metal2 9.1238147974
Rred_6487 VSS.$1977.Metal1 VSS.$4134.Metal2 2.53962814341
Rred_6488 VSS.$1977.Metal1 VSS.$4195.Metal2 2.95445918098
Rred_6489 VSS.$1977.Metal1 VSS.$5219.Metal3 718.572763736
Rred_6490 VSS.$1977.Metal1 VSS.P1.pSD 6.98493275728
Rred_6491 VSS.$1981.Metal1 VSS.$1990.Metal1 0.0353857262576
Rred_6492 VSS.$1981.Metal1 VSS.$2021.Metal1 0.0768271189887
Rred_6493 VSS.$1981.Metal1 VSS.$4164.Metal2 2.03586767206
Rred_6494 VSS.$1981.Metal1 VSS.$4166.Metal2 1.5
Rred_6495 VSS.$1981.Metal1 VSS.$4168.Metal2 3.3280559388
Rred_6496 VSS.$1981.Metal1 VSS.P3.pSD 5.60218236415
Rred_6497 VSS.$1984.Metal1 VSS.$1990.Metal1 0.0353857262576
Rred_6498 VSS.$1984.Metal1 VSS.$2022.Metal1 0.0768271189887
Rred_6499 VSS.$1984.Metal1 VSS.$4170.Metal2 3.3280559388
Rred_6500 VSS.$1984.Metal1 VSS.$4172.Metal2 1.5
Rred_6501 VSS.$1984.Metal1 VSS.$4174.Metal2 2.03586767206
Rred_6502 VSS.$1984.Metal1 VSS.P2.pSD 5.60218236415
Rred_6503 VSS.$1986.Metal1 VSS.$2073.Metal1 0.0614259096926
Rred_6504 VSS.$1986.Metal1 VSS.$4128.Metal2 9.1238147974
Rred_6505 VSS.$1986.Metal1 VSS.$4152.Metal2 2.53962814341
Rred_6506 VSS.$1986.Metal1 VSS.$4213.Metal2 2.95445918098
Rred_6507 VSS.$1986.Metal1 VSS.$5228.Metal3 718.572763736
Rred_6508 VSS.$1986.Metal1 VSS.P0.pSD 6.98493275728
Rred_6509 VSS.$1989.Metal1 VSS.$2020.Metal1 0.081629027807
Rred_6510 VSS.$1989.Metal1 VSS.$2064.Metal1 0.0484719316724
Rred_6511 VSS.$1989.Metal1 VSS.$29.Metal1 49793.7675428
Rred_6512 VSS.$1989.Metal1 VSS.$4227.Metal2 2.92905108677
Rred_6513 VSS.$1989.Metal1 VSS.$4251.Metal2 1.86709958866
Rred_6514 VSS.$1989.Metal1 VSS.$5243.Metal3 2904.85725231
Rred_6515 VSS.$1989.Metal1 VSS.$5279.Metal3 618.28891113
Rred_6516 VSS.$1989.Metal1 VSS.P1.pSD 3.03193419188
Rred_6517 VSS.$1990.Metal1 VSS.$4140.Metal2 4.35957836987
Rred_6518 VSS.$1990.Metal1 VSS.$4168.Metal2 2.75985126631
Rred_6519 VSS.$1990.Metal1 VSS.$4170.Metal2 2.75985126631
Rred_6520 VSS.$1990.Metal1 VSS.$68.Metal1 12459.6851126
Rred_6521 VSS.$1990.Metal1 VSS.P2.pSD 1.87782619881
Rred_6522 VSS.$1990.Metal1 VSS.P3.pSD 1.87782619881
Rred_6523 VSS.$1991.Metal1 VSS.$2023.Metal1 0.081629027807
Rred_6524 VSS.$1991.Metal1 VSS.$2073.Metal1 0.0484719316724
Rred_6525 VSS.$1991.Metal1 VSS.$4241.Metal2 2.92905108677
Rred_6526 VSS.$1991.Metal1 VSS.$4271.Metal2 1.86709958866
Rred_6527 VSS.$1991.Metal1 VSS.$5252.Metal3 2904.85725231
Rred_6528 VSS.$1991.Metal1 VSS.$5288.Metal3 618.28891113
Rred_6529 VSS.$1991.Metal1 VSS.$66.Metal1 49793.7675428
Rred_6530 VSS.$1991.Metal1 VSS.P0.pSD 3.03193419188
Rred_6531 VSS.$2020.Metal1 VSS.$29.Metal1 19887.2925794
Rred_6532 VSS.$2020.Metal1 VSS.$4227.Metal2 0.986951650171
Rred_6533 VSS.$2020.Metal1 VSS.P1.pSD 1.50112056579
Rred_6534 VSS.$2020.Metal1 VSS.P3.GatPoly 10.81
Rred_6535 VSS.$2020.Metal1 VSS.P45.nSD 5.83762681657
Rred_6536 VSS.$2020.Metal1 VSS.P47.nSD 5.83762681657
Rred_6537 VSS.$2021.Metal1 VSS.$4164.Metal2 0.910168493798
Rred_6538 VSS.$2021.Metal1 VSS.P3.pSD 4.38886229893
Rred_6539 VSS.$2021.Metal1 VSS.P7.GatPoly 10.81
Rred_6540 VSS.$2021.Metal1 VSS.P93.nSD 5.84344809862
Rred_6541 VSS.$2021.Metal1 VSS.P95.nSD 5.84344809862
Rred_6542 VSS.$2022.Metal1 VSS.$4174.Metal2 0.910168493798
Rred_6543 VSS.$2022.Metal1 VSS.P2.pSD 4.38886229893
Rred_6544 VSS.$2022.Metal1 VSS.P5.GatPoly 10.81
Rred_6545 VSS.$2022.Metal1 VSS.P69.nSD 5.84344809862
Rred_6546 VSS.$2022.Metal1 VSS.P71.nSD 5.84344809862
Rred_6547 VSS.$2023.Metal1 VSS.$4241.Metal2 0.986951650171
Rred_6548 VSS.$2023.Metal1 VSS.$66.Metal1 19887.2925794
Rred_6549 VSS.$2023.Metal1 VSS.P0.pSD 1.50112056579
Rred_6550 VSS.$2023.Metal1 VSS.P1.GatPoly 10.81
Rred_6551 VSS.$2023.Metal1 VSS.P21.nSD 5.83762681657
Rred_6552 VSS.$2023.Metal1 VSS.P23.nSD 5.83762681657
Rred_6553 VSS.$2064.Metal1 VSS.$4195.Metal2 3.6595857574
Rred_6554 VSS.$2064.Metal1 VSS.$4227.Metal2 9
Rred_6555 VSS.$2064.Metal1 VSS.$4251.Metal2 7.93471036776
Rred_6556 VSS.$2064.Metal1 VSS.$5243.Metal3 1140.21644565
Rred_6557 VSS.$2064.Metal1 VSS.P1.pSD 221.142882408
Rred_6558 VSS.$2073.Metal1 VSS.$4213.Metal2 3.6595857574
Rred_6559 VSS.$2073.Metal1 VSS.$4241.Metal2 9
Rred_6560 VSS.$2073.Metal1 VSS.$4271.Metal2 7.93471036776
Rred_6561 VSS.$2073.Metal1 VSS.$5252.Metal3 1140.21644565
Rred_6562 VSS.$2073.Metal1 VSS.P0.pSD 221.142882408
Rred_6563 VSS.$2226.Metal2 VSS.$2286.Metal2 0.0279793175581
Rred_6564 VSS.$2226.Metal2 VSS.$25.Metal1 2.95307346431
Rred_6565 VSS.$2226.Metal2 VSS.$29.Metal1 62.4616340464
Rred_6566 VSS.$2226.Metal2 VSS.$4355.Metal3 3.31690530685
Rred_6567 VSS.$2226.Metal2 VSS.$4391.Metal3 4.21530648499
Rred_6568 VSS.$2226.Metal2 VSS.P1.pSD 1005.08870278
Rred_6569 VSS.$2226.Metal2 VSS.P24.nSD 301.318005877
Rred_6570 VSS.$2226.Metal2 VSS.P25.nSD 301.318005877
Rred_6571 VSS.$2228.Metal2 VSS.$2230.Metal2 0.013640831758
Rred_6572 VSS.$2228.Metal2 VSS.$4358.Metal3 9
Rred_6573 VSS.$2228.Metal2 VSS.$4370.Metal3 9
Rred_6574 VSS.$2228.Metal2 VSS.$4382.Metal3 9
Rred_6575 VSS.$2228.Metal2 VSS.$4394.Metal3 9
Rred_6576 VSS.$2228.Metal2 VSS.$4406.Metal3 9
Rred_6577 VSS.$2228.Metal2 VSS.$4418.Metal3 9
Rred_6578 VSS.$2228.Metal2 VSS.P3.pSD 436.932959332
Rred_6579 VSS.$2228.Metal2 VSS.P72.nSD 291.496550811
Rred_6580 VSS.$2228.Metal2 VSS.P73.nSD 291.496550811
Rred_6581 VSS.$2230.Metal2 VSS.$2232.Metal2 0.013640831758
Rred_6582 VSS.$2230.Metal2 VSS.$4358.Metal3 9
Rred_6583 VSS.$2230.Metal2 VSS.$4370.Metal3 9
Rred_6584 VSS.$2230.Metal2 VSS.$4382.Metal3 9
Rred_6585 VSS.$2230.Metal2 VSS.$4394.Metal3 9
Rred_6586 VSS.$2230.Metal2 VSS.$4406.Metal3 9
Rred_6587 VSS.$2230.Metal2 VSS.$4418.Metal3 9
Rred_6588 VSS.$2232.Metal2 VSS.$2234.Metal2 0.0344136795057
Rred_6589 VSS.$2232.Metal2 VSS.$2409.Metal2 0.0330185759294
Rred_6590 VSS.$2232.Metal2 VSS.$4358.Metal3 9
Rred_6591 VSS.$2232.Metal2 VSS.$4370.Metal3 9
Rred_6592 VSS.$2232.Metal2 VSS.$4382.Metal3 9
Rred_6593 VSS.$2232.Metal2 VSS.$4394.Metal3 9
Rred_6594 VSS.$2232.Metal2 VSS.$4406.Metal3 9
Rred_6595 VSS.$2232.Metal2 VSS.$4418.Metal3 9
Rred_6596 VSS.$2232.Metal2 VSS.$68.Metal1 2.75985126631
Rred_6597 VSS.$2234.Metal2 VSS.$2236.Metal2 0.013640831758
Rred_6598 VSS.$2234.Metal2 VSS.$2409.Metal2 0.0330185759294
Rred_6599 VSS.$2234.Metal2 VSS.$4358.Metal3 9
Rred_6600 VSS.$2234.Metal2 VSS.$4370.Metal3 9
Rred_6601 VSS.$2234.Metal2 VSS.$4382.Metal3 9
Rred_6602 VSS.$2234.Metal2 VSS.$4394.Metal3 9
Rred_6603 VSS.$2234.Metal2 VSS.$4406.Metal3 9
Rred_6604 VSS.$2234.Metal2 VSS.$4418.Metal3 9
Rred_6605 VSS.$2234.Metal2 VSS.$68.Metal1 2.75985126631
Rred_6606 VSS.$2236.Metal2 VSS.$2238.Metal2 0.013640831758
Rred_6607 VSS.$2236.Metal2 VSS.$4358.Metal3 9
Rred_6608 VSS.$2236.Metal2 VSS.$4370.Metal3 9
Rred_6609 VSS.$2236.Metal2 VSS.$4382.Metal3 9
Rred_6610 VSS.$2236.Metal2 VSS.$4394.Metal3 9
Rred_6611 VSS.$2236.Metal2 VSS.$4406.Metal3 9
Rred_6612 VSS.$2236.Metal2 VSS.$4418.Metal3 9
Rred_6613 VSS.$2238.Metal2 VSS.$4358.Metal3 9
Rred_6614 VSS.$2238.Metal2 VSS.$4370.Metal3 9
Rred_6615 VSS.$2238.Metal2 VSS.$4382.Metal3 9
Rred_6616 VSS.$2238.Metal2 VSS.$4394.Metal3 9
Rred_6617 VSS.$2238.Metal2 VSS.$4406.Metal3 9
Rred_6618 VSS.$2238.Metal2 VSS.$4418.Metal3 9
Rred_6619 VSS.$2238.Metal2 VSS.P2.pSD 436.932959332
Rred_6620 VSS.$2238.Metal2 VSS.P48.nSD 291.496550811
Rred_6621 VSS.$2238.Metal2 VSS.P49.nSD 291.496550811
Rred_6622 VSS.$2240.Metal2 VSS.$2306.Metal2 0.0279793175581
Rred_6623 VSS.$2240.Metal2 VSS.$27.Metal1 2.95307346431
Rred_6624 VSS.$2240.Metal2 VSS.$4364.Metal3 3.31690530685
Rred_6625 VSS.$2240.Metal2 VSS.$4400.Metal3 4.21530648499
Rred_6626 VSS.$2240.Metal2 VSS.$66.Metal1 62.4616340464
Rred_6627 VSS.$2240.Metal2 VSS.P0.nSD 301.318005877
Rred_6628 VSS.$2240.Metal2 VSS.P0.pSD 1005.08870278
Rred_6629 VSS.$2240.Metal2 VSS.P1.nSD 301.318005877
Rred_6630 VSS.$2286.Metal2 VSS.$2342.Metal2 0.0731564027084
Rred_6631 VSS.$2286.Metal2 VSS.$25.Metal1 1.87391095525
Rred_6632 VSS.$2286.Metal2 VSS.$4355.Metal3 2.78351554278
Rred_6633 VSS.$2286.Metal2 VSS.$4391.Metal3 3.31863399651
Rred_6634 VSS.$2306.Metal2 VSS.$2360.Metal2 0.0731564027084
Rred_6635 VSS.$2306.Metal2 VSS.$27.Metal1 1.87391095525
Rred_6636 VSS.$2306.Metal2 VSS.$4364.Metal3 2.78351554278
Rred_6637 VSS.$2306.Metal2 VSS.$4400.Metal3 3.31863399651
Rred_6638 VSS.$2342.Metal2 VSS.$2403.Metal2 0.051071228228
Rred_6639 VSS.$2342.Metal2 VSS.$257.Metal1 2.95445918098
Rred_6640 VSS.$2342.Metal2 VSS.$4391.Metal3 3.46009554039
Rred_6641 VSS.$2342.Metal2 VSS.$4415.Metal3 3.0949188449
Rred_6642 VSS.$2342.Metal2 VSS.P1.pSD 19850.6262899
Rred_6643 VSS.$2360.Metal2 VSS.$2421.Metal2 0.051071228228
Rred_6644 VSS.$2360.Metal2 VSS.$266.Metal1 2.95445918098
Rred_6645 VSS.$2360.Metal2 VSS.$4400.Metal3 3.46009554039
Rred_6646 VSS.$2360.Metal2 VSS.$4424.Metal3 3.0949188449
Rred_6647 VSS.$2360.Metal2 VSS.P0.pSD 19850.6262899
Rred_6648 VSS.$2403.Metal2 VSS.$2427.Metal2 0.0240522932358
Rred_6649 VSS.$2403.Metal2 VSS.$257.Metal1 2.53962814341
Rred_6650 VSS.$2403.Metal2 VSS.$317.Metal1 9.11679557973
Rred_6651 VSS.$2403.Metal2 VSS.$4415.Metal3 2.53685126265
Rred_6652 VSS.$2403.Metal2 VSS.$4451.Metal3 9.09640618761
Rred_6653 VSS.$2403.Metal2 VSS.P1.pSD 1755.06325379
Rred_6654 VSS.$2409.Metal2 VSS.$2433.Metal2 0.0120264116929
Rred_6655 VSS.$2409.Metal2 VSS.$292.Metal1 2.29688757973
Rred_6656 VSS.$2409.Metal2 VSS.$4418.Metal3 2.26502132807
Rred_6657 VSS.$2409.Metal2 VSS.$4454.Metal3 4.54820309381
Rred_6658 VSS.$2409.Metal2 VSS.$68.Metal1 4.35957836987
Rred_6659 VSS.$2409.Metal2 VSS.P2.pSD 10780.0483328
Rred_6660 VSS.$2409.Metal2 VSS.P3.pSD 10780.0483328
Rred_6661 VSS.$2421.Metal2 VSS.$2445.Metal2 0.0240522932358
Rred_6662 VSS.$2421.Metal2 VSS.$266.Metal1 2.53962814341
Rred_6663 VSS.$2421.Metal2 VSS.$326.Metal1 9.11679557973
Rred_6664 VSS.$2421.Metal2 VSS.$4424.Metal3 2.53685126265
Rred_6665 VSS.$2421.Metal2 VSS.$4460.Metal3 9.09640618761
Rred_6666 VSS.$2421.Metal2 VSS.P0.pSD 1755.06325379
Rred_6667 VSS.$2427.Metal2 VSS.$2475.Metal2 0.0484923752296
Rred_6668 VSS.$2427.Metal2 VSS.$257.Metal1 9.1238147974
Rred_6669 VSS.$2427.Metal2 VSS.$317.Metal1 2.59239467043
Rred_6670 VSS.$2427.Metal2 VSS.$4415.Metal3 9.09640618761
Rred_6671 VSS.$2427.Metal2 VSS.$4451.Metal3 2.59007321156
Rred_6672 VSS.$2427.Metal2 VSS.P1.pSD 1755.63484102
Rred_6673 VSS.$2433.Metal2 VSS.$2481.Metal2 0.0242460971418
Rred_6674 VSS.$2433.Metal2 VSS.$292.Metal1 4.08656944445
Rred_6675 VSS.$2433.Metal2 VSS.$312.Metal1 2.10822082493
Rred_6676 VSS.$2433.Metal2 VSS.$332.Metal1 3.61101715853
Rred_6677 VSS.$2433.Metal2 VSS.$4418.Metal3 4.54820309381
Rred_6678 VSS.$2433.Metal2 VSS.$4454.Metal3 1.29503453635
Rred_6679 VSS.$2445.Metal2 VSS.$2493.Metal2 0.0484923752296
Rred_6680 VSS.$2445.Metal2 VSS.$266.Metal1 9.1238147974
Rred_6681 VSS.$2445.Metal2 VSS.$326.Metal1 2.59239467043
Rred_6682 VSS.$2445.Metal2 VSS.$4424.Metal3 9.09640618761
Rred_6683 VSS.$2445.Metal2 VSS.$4460.Metal3 2.59007321156
Rred_6684 VSS.$2445.Metal2 VSS.P0.pSD 1755.63484102
Rred_6685 VSS.$2475.Metal2 VSS.$2526.Metal2 0.0484923752296
Rred_6686 VSS.$2475.Metal2 VSS.$317.Metal1 3.01971402219
Rred_6687 VSS.$2475.Metal2 VSS.$365.Metal1 3.01974283614
Rred_6688 VSS.$2475.Metal2 VSS.$4451.Metal3 3.01802801866
Rred_6689 VSS.$2475.Metal2 VSS.$4475.Metal3 3.01802801866
Rred_6690 VSS.$2475.Metal2 VSS.P1.pSD 3135.41320954
Rred_6691 VSS.$2481.Metal2 VSS.$2532.Metal2 0.0242460625559
Rred_6692 VSS.$2481.Metal2 VSS.$312.Metal1 18.7116343669
Rred_6693 VSS.$2481.Metal2 VSS.$332.Metal1 1.6827454053
Rred_6694 VSS.$2481.Metal2 VSS.$360.Metal1 1.68254336609
Rred_6695 VSS.$2481.Metal2 VSS.$380.Metal1 12.1118591385
Rred_6696 VSS.$2481.Metal2 VSS.$4454.Metal3 1.50901119954
Rred_6697 VSS.$2481.Metal2 VSS.$4478.Metal3 1.50901012541
Rred_6698 VSS.$2481.Metal2 VSS.P2.pSD 5156.55371387
Rred_6699 VSS.$2481.Metal2 VSS.P3.pSD 5156.55371387
Rred_6700 VSS.$2493.Metal2 VSS.$2544.Metal2 0.0484923752296
Rred_6701 VSS.$2493.Metal2 VSS.$326.Metal1 3.01971402219
Rred_6702 VSS.$2493.Metal2 VSS.$374.Metal1 3.01974283614
Rred_6703 VSS.$2493.Metal2 VSS.$4460.Metal3 3.01802801866
Rred_6704 VSS.$2493.Metal2 VSS.$4484.Metal3 3.01802801866
Rred_6705 VSS.$2493.Metal2 VSS.P0.pSD 3135.41320954
Rred_6706 VSS.$25.Metal1 VSS.$29.Metal1 0.41870548608
Rred_6707 VSS.$25.Metal1 VSS.$4355.Metal3 614.264905619
Rred_6708 VSS.$25.Metal1 VSS.$4391.Metal3 2889.544017
Rred_6709 VSS.$25.Metal1 VSS.P1.pSD 6.73751432021
Rred_6710 VSS.$2526.Metal2 VSS.$2558.Metal2 0.0241063349611
Rred_6711 VSS.$2526.Metal2 VSS.$365.Metal1 3.49223384788
Rred_6712 VSS.$2526.Metal2 VSS.$385.Metal1 2.72599957429
Rred_6713 VSS.$2526.Metal2 VSS.$4475.Metal3 2.59007321156
Rred_6714 VSS.$2526.Metal2 VSS.$4511.Metal3 9.09640618761
Rred_6715 VSS.$2526.Metal2 VSS.P1.pSD 6716.86096755
Rred_6716 VSS.$2526.Metal2 VSS.P27.nSD 187.198318732
Rred_6717 VSS.$2532.Metal2 VSS.$2564.Metal2 0.0120531674805
Rred_6718 VSS.$2532.Metal2 VSS.$360.Metal1 4.0372863795
Rred_6719 VSS.$2532.Metal2 VSS.$380.Metal1 2.06823431305
Rred_6720 VSS.$2532.Metal2 VSS.$386.Metal1 1.73683794071
Rred_6721 VSS.$2532.Metal2 VSS.$4478.Metal3 1.29503374524
Rred_6722 VSS.$2532.Metal2 VSS.$4514.Metal3 4.54820309381
Rred_6723 VSS.$2532.Metal2 VSS.P2.pSD 42082.9728891
Rred_6724 VSS.$2532.Metal2 VSS.P3.pSD 42082.9728891
Rred_6725 VSS.$2532.Metal2 VSS.P51.nSD 187.198318732
Rred_6726 VSS.$2532.Metal2 VSS.P75.nSD 187.198318732
Rred_6727 VSS.$2544.Metal2 VSS.$2576.Metal2 0.0241063349611
Rred_6728 VSS.$2544.Metal2 VSS.$374.Metal1 3.49223384788
Rred_6729 VSS.$2544.Metal2 VSS.$387.Metal1 2.72599957429
Rred_6730 VSS.$2544.Metal2 VSS.$4484.Metal3 2.59007321156
Rred_6731 VSS.$2544.Metal2 VSS.$4520.Metal3 9.09640618761
Rred_6732 VSS.$2544.Metal2 VSS.P0.pSD 6716.86096755
Rred_6733 VSS.$2544.Metal2 VSS.P3.nSD 187.198318732
Rred_6734 VSS.$2558.Metal2 VSS.$2614.Metal2 0.0484923752296
Rred_6735 VSS.$2558.Metal2 VSS.$385.Metal1 2.26229116801
Rred_6736 VSS.$2558.Metal2 VSS.$4475.Metal3 9.09640618761
Rred_6737 VSS.$2558.Metal2 VSS.$4511.Metal3 2.59007321156
Rred_6738 VSS.$2558.Metal2 VSS.$456.Metal1 3.7770714324
Rred_6739 VSS.$2558.Metal2 VSS.P1.pSD 9485.44026575
Rred_6740 VSS.$2558.Metal2 VSS.P27.nSD 139.403003311
Rred_6741 VSS.$2564.Metal2 VSS.$2620.Metal2 0.0242461109832
Rred_6742 VSS.$2564.Metal2 VSS.$386.Metal1 1.4660861415
Rred_6743 VSS.$2564.Metal2 VSS.$4478.Metal3 4.54820309381
Rred_6744 VSS.$2564.Metal2 VSS.$451.Metal1 2.24485514274
Rred_6745 VSS.$2564.Metal2 VSS.$4514.Metal3 1.29503485295
Rred_6746 VSS.$2564.Metal2 VSS.$471.Metal1 3.48811062896
Rred_6747 VSS.$2564.Metal2 VSS.P51.nSD 139.403003311
Rred_6748 VSS.$2564.Metal2 VSS.P75.nSD 139.403003311
Rred_6749 VSS.$257.Metal1 VSS.$317.Metal1 0.0762245508578
Rred_6750 VSS.$257.Metal1 VSS.$4415.Metal3 718.572763736
Rred_6751 VSS.$257.Metal1 VSS.P1.pSD 6.98493275728
Rred_6752 VSS.$2576.Metal2 VSS.$2632.Metal2 0.0484923752296
Rred_6753 VSS.$2576.Metal2 VSS.$387.Metal1 2.26229116801
Rred_6754 VSS.$2576.Metal2 VSS.$4484.Metal3 9.09640618761
Rred_6755 VSS.$2576.Metal2 VSS.$4520.Metal3 2.59007321156
Rred_6756 VSS.$2576.Metal2 VSS.$465.Metal1 3.7770714324
Rred_6757 VSS.$2576.Metal2 VSS.P0.pSD 9485.44026575
Rred_6758 VSS.$2576.Metal2 VSS.P3.nSD 139.403003311
Rred_6759 VSS.$2614.Metal2 VSS.$2662.Metal2 0.048486239739
Rred_6760 VSS.$2614.Metal2 VSS.$4511.Metal3 2.02265962076
Rred_6761 VSS.$2614.Metal2 VSS.$4559.Metal3 6.13284832082
Rred_6762 VSS.$2614.Metal2 VSS.$456.Metal1 3.01967577385
Rred_6763 VSS.$2614.Metal2 VSS.$504.Metal1 3.019631914
Rred_6764 VSS.$2614.Metal2 VSS.P1.pSD 3195.13122738
Rred_6765 VSS.$2620.Metal2 VSS.$2668.Metal2 0.0242460533372
Rred_6766 VSS.$2620.Metal2 VSS.$451.Metal1 22.8665030121
Rred_6767 VSS.$2620.Metal2 VSS.$4514.Metal3 1.5090116294
Rred_6768 VSS.$2620.Metal2 VSS.$4538.Metal3 1.50900983911
Rred_6769 VSS.$2620.Metal2 VSS.$471.Metal1 1.6827530387
Rred_6770 VSS.$2620.Metal2 VSS.$499.Metal1 1.68241800287
Rred_6771 VSS.$2620.Metal2 VSS.$519.Metal1 10.8379599635
Rred_6772 VSS.$2620.Metal2 VSS.P2.pSD 5320.19092171
Rred_6773 VSS.$2620.Metal2 VSS.P3.pSD 5320.19092171
Rred_6774 VSS.$2632.Metal2 VSS.$2680.Metal2 0.048486239739
Rred_6775 VSS.$2632.Metal2 VSS.$4520.Metal3 2.02265962076
Rred_6776 VSS.$2632.Metal2 VSS.$4568.Metal3 6.13284832082
Rred_6777 VSS.$2632.Metal2 VSS.$465.Metal1 3.01967577385
Rred_6778 VSS.$2632.Metal2 VSS.$513.Metal1 3.019631914
Rred_6779 VSS.$2632.Metal2 VSS.P0.pSD 3195.13122738
Rred_6780 VSS.$266.Metal1 VSS.$326.Metal1 0.0762245508578
Rred_6781 VSS.$266.Metal1 VSS.$4424.Metal3 718.572763736
Rred_6782 VSS.$266.Metal1 VSS.P0.pSD 6.98493275728
Rred_6783 VSS.$2662.Metal2 VSS.$2721.Metal2 0.0484923752296
Rred_6784 VSS.$2662.Metal2 VSS.$4511.Metal3 6.13284832082
Rred_6785 VSS.$2662.Metal2 VSS.$4559.Metal3 2.02265962076
Rred_6786 VSS.$2662.Metal2 VSS.$504.Metal1 3.01948047742
Rred_6787 VSS.$2662.Metal2 VSS.$544.Metal1 3.01958494445
Rred_6788 VSS.$2662.Metal2 VSS.P1.pSD 3494.79852872
Rred_6789 VSS.$2668.Metal2 VSS.$2727.Metal2 0.0242460452723
Rred_6790 VSS.$2668.Metal2 VSS.$4538.Metal3 1.50900983911
Rred_6791 VSS.$2668.Metal2 VSS.$4562.Metal3 1.50900958864
Rred_6792 VSS.$2668.Metal2 VSS.$499.Metal1 4.20247427156
Rred_6793 VSS.$2668.Metal2 VSS.$519.Metal1 2.29983953107
Rred_6794 VSS.$2668.Metal2 VSS.$539.Metal1 2.35325729591
Rred_6795 VSS.$2668.Metal2 VSS.$559.Metal1 4.38166848966
Rred_6796 VSS.$2680.Metal2 VSS.$2739.Metal2 0.0484923752296
Rred_6797 VSS.$2680.Metal2 VSS.$4520.Metal3 6.13284832082
Rred_6798 VSS.$2680.Metal2 VSS.$4568.Metal3 2.02265962076
Rred_6799 VSS.$2680.Metal2 VSS.$513.Metal1 3.01948047742
Rred_6800 VSS.$2680.Metal2 VSS.$553.Metal1 3.01958494445
Rred_6801 VSS.$2680.Metal2 VSS.P0.pSD 3494.79852872
Rred_6802 VSS.$27.Metal1 VSS.$4364.Metal3 614.264905619
Rred_6803 VSS.$27.Metal1 VSS.$4400.Metal3 2889.544017
Rred_6804 VSS.$27.Metal1 VSS.$66.Metal1 0.41870548608
Rred_6805 VSS.$27.Metal1 VSS.P0.pSD 6.73751432021
Rred_6806 VSS.$2711.Metal2 VSS.$2727.Metal2 0.00366666666667
Rred_6807 VSS.$2711.Metal2 VSS.$2783.Metal2 0.0205206810691
Rred_6808 VSS.$2711.Metal2 VSS.$4586.Metal3 2.55939758344
Rred_6809 VSS.$2711.Metal2 VSS.$565.Metal1 1.36787183383
Rred_6810 VSS.$2711.Metal2 VSS.$618.Metal1 2.85492370116
Rred_6811 VSS.$2711.Metal2 VSS.$638.Metal1 24.8786208245
Rred_6812 VSS.$2711.Metal2 VSS.P53.nSD 79.7243507049
Rred_6813 VSS.$2711.Metal2 VSS.P77.nSD 79.7243507049
Rred_6814 VSS.$2721.Metal2 VSS.$2753.Metal2 0.0240989264962
Rred_6815 VSS.$2721.Metal2 VSS.$2777.Metal2 1526.81857051
Rred_6816 VSS.$2721.Metal2 VSS.$4559.Metal3 2.42113023107
Rred_6817 VSS.$2721.Metal2 VSS.$4607.Metal3 12.2416920053
Rred_6818 VSS.$2721.Metal2 VSS.$544.Metal1 4.11465861119
Rred_6819 VSS.$2721.Metal2 VSS.$564.Metal1 1.9666454863
Rred_6820 VSS.$2721.Metal2 VSS.P1.pSD 8945.64126452
Rred_6821 VSS.$2721.Metal2 VSS.P29.nSD 114.91221067
Rred_6822 VSS.$2727.Metal2 VSS.$4562.Metal3 1.50900958864
Rred_6823 VSS.$2727.Metal2 VSS.$4586.Metal3 3.01202666667
Rred_6824 VSS.$2727.Metal2 VSS.$539.Metal1 9.80659138163
Rred_6825 VSS.$2727.Metal2 VSS.$559.Metal1 2.37168738593
Rred_6826 VSS.$2727.Metal2 VSS.$565.Metal1 2.11911487241
Rred_6827 VSS.$2727.Metal2 VSS.P2.pSD 13099.9828476
Rred_6828 VSS.$2727.Metal2 VSS.P3.pSD 13099.9828476
Rred_6829 VSS.$2739.Metal2 VSS.$2771.Metal2 0.0240989264962
Rred_6830 VSS.$2739.Metal2 VSS.$2795.Metal2 1526.81857051
Rred_6831 VSS.$2739.Metal2 VSS.$4568.Metal3 2.42113023107
Rred_6832 VSS.$2739.Metal2 VSS.$4616.Metal3 12.2416920053
Rred_6833 VSS.$2739.Metal2 VSS.$553.Metal1 4.11465861119
Rred_6834 VSS.$2739.Metal2 VSS.$566.Metal1 1.9666454863
Rred_6835 VSS.$2739.Metal2 VSS.P0.pSD 8945.64126452
Rred_6836 VSS.$2739.Metal2 VSS.P5.nSD 114.91221067
Rred_6837 VSS.$2753.Metal2 VSS.$2777.Metal2 0.024052161712
Rred_6838 VSS.$2753.Metal2 VSS.$4559.Metal3 6.09640618761
Rred_6839 VSS.$2753.Metal2 VSS.$4607.Metal3 6.09640618761
Rred_6840 VSS.$2753.Metal2 VSS.$564.Metal1 2.8010161252
Rred_6841 VSS.$2753.Metal2 VSS.$663.Metal1 11.7676017942
Rred_6842 VSS.$2753.Metal2 VSS.P1.pSD 2314.81399662
Rred_6843 VSS.$2753.Metal2 VSS.P29.nSD 261.999840327
Rred_6844 VSS.$2771.Metal2 VSS.$2795.Metal2 0.024052161712
Rred_6845 VSS.$2771.Metal2 VSS.$4568.Metal3 6.09640618761
Rred_6846 VSS.$2771.Metal2 VSS.$4616.Metal3 6.09640618761
Rred_6847 VSS.$2771.Metal2 VSS.$566.Metal1 2.8010161252
Rred_6848 VSS.$2771.Metal2 VSS.$672.Metal1 11.7676017942
Rred_6849 VSS.$2771.Metal2 VSS.P0.pSD 2314.81399662
Rred_6850 VSS.$2771.Metal2 VSS.P5.nSD 261.999840327
Rred_6851 VSS.$2777.Metal2 VSS.$2825.Metal2 0.0484923752296
Rred_6852 VSS.$2777.Metal2 VSS.$4559.Metal3 12.2416920053
Rred_6853 VSS.$2777.Metal2 VSS.$4607.Metal3 2.42113023107
Rred_6854 VSS.$2777.Metal2 VSS.$564.Metal1 8.17787238273
Rred_6855 VSS.$2777.Metal2 VSS.$663.Metal1 2.67778185654
Rred_6856 VSS.$2777.Metal2 VSS.P1.pSD 1995.73669521
Rred_6857 VSS.$2783.Metal2 VSS.$2831.Metal2 0.0242460210856
Rred_6858 VSS.$2783.Metal2 VSS.$4586.Metal3 1.65673098428
Rred_6859 VSS.$2783.Metal2 VSS.$4610.Metal3 1.50900883748
Rred_6860 VSS.$2783.Metal2 VSS.$618.Metal1 4.10708321922
Rred_6861 VSS.$2783.Metal2 VSS.$638.Metal1 2.04899284099
Rred_6862 VSS.$2783.Metal2 VSS.$658.Metal1 2.73388061437
Rred_6863 VSS.$2783.Metal2 VSS.$678.Metal1 5.88542737535
Rred_6864 VSS.$2795.Metal2 VSS.$2843.Metal2 0.0484923752296
Rred_6865 VSS.$2795.Metal2 VSS.$4568.Metal3 12.2416920053
Rred_6866 VSS.$2795.Metal2 VSS.$4616.Metal3 2.42113023107
Rred_6867 VSS.$2795.Metal2 VSS.$566.Metal1 8.17787238273
Rred_6868 VSS.$2795.Metal2 VSS.$672.Metal1 2.67778185654
Rred_6869 VSS.$2795.Metal2 VSS.P0.pSD 1995.73669521
Rred_6870 VSS.$2825.Metal2 VSS.$2849.Metal2 0.0240522935581
Rred_6871 VSS.$2825.Metal2 VSS.$4607.Metal3 2.59007321156
Rred_6872 VSS.$2825.Metal2 VSS.$4643.Metal3 9.09640618761
Rred_6873 VSS.$2825.Metal2 VSS.$663.Metal1 2.59268795112
Rred_6874 VSS.$2825.Metal2 VSS.$731.Metal1 9.12157587534
Rred_6875 VSS.$2825.Metal2 VSS.P1.pSD 1703.0815892
Rred_6876 VSS.$2831.Metal2 VSS.$2855.Metal2 0.0120264116929
Rred_6877 VSS.$2831.Metal2 VSS.$4610.Metal3 1.29503279667
Rred_6878 VSS.$2831.Metal2 VSS.$4646.Metal3 4.54820309381
Rred_6879 VSS.$2831.Metal2 VSS.$658.Metal1 6.24211994354
Rred_6880 VSS.$2831.Metal2 VSS.$678.Metal1 2.80957031149
Rred_6881 VSS.$2831.Metal2 VSS.$698.Metal1 2.08453543084
Rred_6882 VSS.$2843.Metal2 VSS.$2867.Metal2 0.0240522935581
Rred_6883 VSS.$2843.Metal2 VSS.$4616.Metal3 2.59007321156
Rred_6884 VSS.$2843.Metal2 VSS.$4652.Metal3 9.09640618761
Rred_6885 VSS.$2843.Metal2 VSS.$672.Metal1 2.59268795112
Rred_6886 VSS.$2843.Metal2 VSS.$740.Metal1 9.12157587534
Rred_6887 VSS.$2843.Metal2 VSS.P0.pSD 1703.0815892
Rred_6888 VSS.$2849.Metal2 VSS.$2908.Metal2 0.0484923752296
Rred_6889 VSS.$2849.Metal2 VSS.$4607.Metal3 9.09640618761
Rred_6890 VSS.$2849.Metal2 VSS.$4643.Metal3 2.59007321156
Rred_6891 VSS.$2849.Metal2 VSS.$663.Metal1 9.12272515148
Rred_6892 VSS.$2849.Metal2 VSS.$731.Metal1 2.59271359665
Rred_6893 VSS.$2849.Metal2 VSS.P1.pSD 1652.72593386
Rred_6894 VSS.$2855.Metal2 VSS.$2914.Metal2 0.0242461109832
Rred_6895 VSS.$2855.Metal2 VSS.$4610.Metal3 4.54820309381
Rred_6896 VSS.$2855.Metal2 VSS.$4646.Metal3 1.29503485295
Rred_6897 VSS.$2855.Metal2 VSS.$698.Metal1 2.80561924706
Rred_6898 VSS.$2855.Metal2 VSS.$726.Metal1 1.6827530387
Rred_6899 VSS.$2855.Metal2 VSS.$757.Metal1 22.8665030121
Rred_6900 VSS.$2855.Metal2 VSS.P2.pSD 5320.19092171
Rred_6901 VSS.$2855.Metal2 VSS.P3.pSD 5320.19092171
Rred_6902 VSS.$2867.Metal2 VSS.$2926.Metal2 0.0484923752296
Rred_6903 VSS.$2867.Metal2 VSS.$4616.Metal3 9.09640618761
Rred_6904 VSS.$2867.Metal2 VSS.$4652.Metal3 2.59007321156
Rred_6905 VSS.$2867.Metal2 VSS.$672.Metal1 9.12272515148
Rred_6906 VSS.$2867.Metal2 VSS.$740.Metal1 2.59271359665
Rred_6907 VSS.$2867.Metal2 VSS.P0.pSD 1652.72593386
Rred_6908 VSS.$29.Metal1 VSS.$4227.Metal2 7428133.11373
Rred_6909 VSS.$29.Metal1 VSS.P1.pSD 1.45104374835
Rred_6910 VSS.$2908.Metal2 VSS.$2940.Metal2 0.0240610199399
Rred_6911 VSS.$2908.Metal2 VSS.$4643.Metal3 2.59007321156
Rred_6912 VSS.$2908.Metal2 VSS.$4679.Metal3 9.09640618761
Rred_6913 VSS.$2908.Metal2 VSS.$731.Metal1 6.04810666667
Rred_6914 VSS.$2908.Metal2 VSS.$762.Metal1 3
Rred_6915 VSS.$2908.Metal2 VSS.$774.Metal1 2.59732263903
Rred_6916 VSS.$2908.Metal2 VSS.P31.nSD 474.710255865
Rred_6917 VSS.$2914.Metal2 VSS.$2946.Metal2 0.0120302664783
Rred_6918 VSS.$2914.Metal2 VSS.$4646.Metal3 1.29503485295
Rred_6919 VSS.$2914.Metal2 VSS.$4682.Metal3 4.54820309381
Rred_6920 VSS.$2914.Metal2 VSS.$726.Metal1 3.48811062896
Rred_6921 VSS.$2914.Metal2 VSS.$744.Metal1 0.772991676355
Rred_6922 VSS.$2914.Metal2 VSS.$757.Metal1 8.28951071668
Rred_6923 VSS.$2914.Metal2 VSS.P55.nSD 82.7783824313
Rred_6924 VSS.$2914.Metal2 VSS.P79.nSD 82.7783824313
Rred_6925 VSS.$292.Metal1 VSS.$312.Metal1 0.0104056166409
Rred_6926 VSS.$292.Metal1 VSS.$68.Metal1 0.0173172140803
Rred_6927 VSS.$292.Metal1 VSS.P2.pSD 12.168900225
Rred_6928 VSS.$292.Metal1 VSS.P3.pSD 12.168900225
Rred_6929 VSS.$2926.Metal2 VSS.$2958.Metal2 0.0240610199399
Rred_6930 VSS.$2926.Metal2 VSS.$4652.Metal3 2.59007321156
Rred_6931 VSS.$2926.Metal2 VSS.$4688.Metal3 9.09640618761
Rred_6932 VSS.$2926.Metal2 VSS.$740.Metal1 6.04810666667
Rred_6933 VSS.$2926.Metal2 VSS.$771.Metal1 3
Rred_6934 VSS.$2926.Metal2 VSS.$785.Metal1 2.59732263903
Rred_6935 VSS.$2926.Metal2 VSS.P7.nSD 474.710255865
Rred_6936 VSS.$2940.Metal2 VSS.$2988.Metal2 0.0484923752296
Rred_6937 VSS.$2940.Metal2 VSS.$4643.Metal3 9.09640618761
Rred_6938 VSS.$2940.Metal2 VSS.$4679.Metal3 2.59007321156
Rred_6939 VSS.$2940.Metal2 VSS.$762.Metal1 6.06349778471
Rred_6940 VSS.$2940.Metal2 VSS.$774.Metal1 64.3262932227
Rred_6941 VSS.$2940.Metal2 VSS.$822.Metal1 3.01971984652
Rred_6942 VSS.$2940.Metal2 VSS.P1.pSD 3495.42631106
Rred_6943 VSS.$2940.Metal2 VSS.P31.nSD 12500.7034044
Rred_6944 VSS.$2946.Metal2 VSS.$2994.Metal2 0.0242460625559
Rred_6945 VSS.$2946.Metal2 VSS.$4646.Metal3 4.54820309381
Rred_6946 VSS.$2946.Metal2 VSS.$4682.Metal3 1.29503374524
Rred_6947 VSS.$2946.Metal2 VSS.$744.Metal1 4.67062837212
Rred_6948 VSS.$2946.Metal2 VSS.$817.Metal1 1.78503067067
Rred_6949 VSS.$2946.Metal2 VSS.$837.Metal1 4.0372863795
Rred_6950 VSS.$2946.Metal2 VSS.P2.pSD 14139.9506297
Rred_6951 VSS.$2946.Metal2 VSS.P3.pSD 14139.9506297
Rred_6952 VSS.$2946.Metal2 VSS.P55.nSD 2179.83073736
Rred_6953 VSS.$2946.Metal2 VSS.P79.nSD 2179.83073736
Rred_6954 VSS.$2958.Metal2 VSS.$3006.Metal2 0.0484923752296
Rred_6955 VSS.$2958.Metal2 VSS.$4652.Metal3 9.09640618761
Rred_6956 VSS.$2958.Metal2 VSS.$4688.Metal3 2.59007321156
Rred_6957 VSS.$2958.Metal2 VSS.$771.Metal1 6.06349778471
Rred_6958 VSS.$2958.Metal2 VSS.$785.Metal1 64.3262932227
Rred_6959 VSS.$2958.Metal2 VSS.$831.Metal1 3.01971984652
Rred_6960 VSS.$2958.Metal2 VSS.P0.pSD 3495.42631106
Rred_6961 VSS.$2958.Metal2 VSS.P7.nSD 12500.7034044
Rred_6962 VSS.$2988.Metal2 VSS.$3036.Metal2 0.0484923752296
Rred_6963 VSS.$2988.Metal2 VSS.$4679.Metal3 3.01802801866
Rred_6964 VSS.$2988.Metal2 VSS.$4703.Metal3 3.01802801866
Rred_6965 VSS.$2988.Metal2 VSS.$822.Metal1 3.01974283614
Rred_6966 VSS.$2988.Metal2 VSS.$870.Metal1 3.01971402219
Rred_6967 VSS.$2988.Metal2 VSS.P1.pSD 3135.41320954
Rred_6968 VSS.$2994.Metal2 VSS.$3042.Metal2 0.0242460971418
Rred_6969 VSS.$2994.Metal2 VSS.$4682.Metal3 1.50901012541
Rred_6970 VSS.$2994.Metal2 VSS.$4706.Metal3 1.50901119954
Rred_6971 VSS.$2994.Metal2 VSS.$817.Metal1 12.1118591385
Rred_6972 VSS.$2994.Metal2 VSS.$837.Metal1 1.68254336609
Rred_6973 VSS.$2994.Metal2 VSS.$865.Metal1 1.6827454053
Rred_6974 VSS.$2994.Metal2 VSS.$885.Metal1 18.7116343669
Rred_6975 VSS.$2994.Metal2 VSS.P2.pSD 5156.55371387
Rred_6976 VSS.$2994.Metal2 VSS.P3.pSD 5156.55371387
Rred_6977 VSS.$3006.Metal2 VSS.$3054.Metal2 0.0484923752296
Rred_6978 VSS.$3006.Metal2 VSS.$4688.Metal3 3.01802801866
Rred_6979 VSS.$3006.Metal2 VSS.$4712.Metal3 3.01802801866
Rred_6980 VSS.$3006.Metal2 VSS.$831.Metal1 3.01974283614
Rred_6981 VSS.$3006.Metal2 VSS.$879.Metal1 3.01971402219
Rred_6982 VSS.$3006.Metal2 VSS.P0.pSD 3135.41320954
Rred_6983 VSS.$3036.Metal2 VSS.$3060.Metal2 0.0240521306384
Rred_6984 VSS.$3036.Metal2 VSS.$3095.Metal2 1526.81857051
Rred_6985 VSS.$3036.Metal2 VSS.$4703.Metal3 2.42113023107
Rred_6986 VSS.$3036.Metal2 VSS.$4751.Metal3 12.2416920053
Rred_6987 VSS.$3036.Metal2 VSS.$870.Metal1 2.65496903055
Rred_6988 VSS.$3036.Metal2 VSS.$922.Metal1 8.40441758816
Rred_6989 VSS.$3036.Metal2 VSS.P1.pSD 1968.63194526
Rred_6990 VSS.$3042.Metal2 VSS.$3085.Metal2 0.0214147099109
Rred_6991 VSS.$3042.Metal2 VSS.$4706.Metal3 1.50901119954
Rred_6992 VSS.$3042.Metal2 VSS.$4730.Metal3 1.6138009324
Rred_6993 VSS.$3042.Metal2 VSS.$865.Metal1 3.61101715853
Rred_6994 VSS.$3042.Metal2 VSS.$885.Metal1 2.10822082493
Rred_6995 VSS.$3042.Metal2 VSS.$905.Metal1 2.72351925575
Rred_6996 VSS.$3042.Metal2 VSS.$936.Metal1 6.07170799846
Rred_6997 VSS.$3054.Metal2 VSS.$3078.Metal2 0.0240521306384
Rred_6998 VSS.$3054.Metal2 VSS.$3113.Metal2 1526.81857051
Rred_6999 VSS.$3054.Metal2 VSS.$4712.Metal3 2.42113023107
Rred_7000 VSS.$3054.Metal2 VSS.$4760.Metal3 12.2416920053
Rred_7001 VSS.$3054.Metal2 VSS.$879.Metal1 2.65496903055
Rred_7002 VSS.$3054.Metal2 VSS.$924.Metal1 8.40441758816
Rred_7003 VSS.$3054.Metal2 VSS.P0.pSD 1968.63194526
Rred_7004 VSS.$3060.Metal2 VSS.$3095.Metal2 0.0240915098495
Rred_7005 VSS.$3060.Metal2 VSS.$4703.Metal3 6.09640618761
Rred_7006 VSS.$3060.Metal2 VSS.$4751.Metal3 6.09640618761
Rred_7007 VSS.$3060.Metal2 VSS.$870.Metal1 10.9394227231
Rred_7008 VSS.$3060.Metal2 VSS.$922.Metal1 3.08894169111
Rred_7009 VSS.$3060.Metal2 VSS.P1.pSD 2242.65392533
Rred_7010 VSS.$3060.Metal2 VSS.P33.nSD 344.630533059
Rred_7011 VSS.$3078.Metal2 VSS.$3113.Metal2 0.0240915098495
Rred_7012 VSS.$3078.Metal2 VSS.$4712.Metal3 6.09640618761
Rred_7013 VSS.$3078.Metal2 VSS.$4760.Metal3 6.09640618761
Rred_7014 VSS.$3078.Metal2 VSS.$879.Metal1 10.9394227231
Rred_7015 VSS.$3078.Metal2 VSS.$924.Metal1 3.08894169111
Rred_7016 VSS.$3078.Metal2 VSS.P0.pSD 2242.65392533
Rred_7017 VSS.$3078.Metal2 VSS.P10.nSD 344.630533059
Rred_7018 VSS.$3085.Metal2 VSS.$3101.Metal2 0.00278666666667
Rred_7019 VSS.$3085.Metal2 VSS.$4730.Metal3 2.67090339797
Rred_7020 VSS.$3085.Metal2 VSS.$905.Metal1 6.27341738947
Rred_7021 VSS.$3085.Metal2 VSS.$923.Metal1 1.36787183383
Rred_7022 VSS.$3085.Metal2 VSS.$936.Metal1 4.66484882808
Rred_7023 VSS.$3085.Metal2 VSS.P57.nSD 79.7243507049
Rred_7024 VSS.$3085.Metal2 VSS.P81.nSD 79.7243507049
Rred_7025 VSS.$3095.Metal2 VSS.$3151.Metal2 0.0484923752296
Rred_7026 VSS.$3095.Metal2 VSS.$4703.Metal3 12.2416920053
Rred_7027 VSS.$3095.Metal2 VSS.$4751.Metal3 2.42113023107
Rred_7028 VSS.$3095.Metal2 VSS.$922.Metal1 1.81641905763
Rred_7029 VSS.$3095.Metal2 VSS.$981.Metal1 4.38743601401
Rred_7030 VSS.$3095.Metal2 VSS.P1.pSD 13268.7698479
Rred_7031 VSS.$3095.Metal2 VSS.P33.nSD 103.93619251
Rred_7032 VSS.$3101.Metal2 VSS.$3157.Metal2 0.024246177939
Rred_7033 VSS.$3101.Metal2 VSS.$4730.Metal3 3.01202666667
Rred_7034 VSS.$3101.Metal2 VSS.$4754.Metal3 1.50901370883
Rred_7035 VSS.$3101.Metal2 VSS.$923.Metal1 3.40290277778
Rred_7036 VSS.$3101.Metal2 VSS.$968.Metal1 2.6518607363
Rred_7037 VSS.$3101.Metal2 VSS.$996.Metal1 3.06949523821
Rred_7038 VSS.$3113.Metal2 VSS.$3169.Metal2 0.0484923752296
Rred_7039 VSS.$3113.Metal2 VSS.$4712.Metal3 12.2416920053
Rred_7040 VSS.$3113.Metal2 VSS.$4760.Metal3 2.42113023107
Rred_7041 VSS.$3113.Metal2 VSS.$924.Metal1 1.81641905763
Rred_7042 VSS.$3113.Metal2 VSS.$990.Metal1 4.38743601401
Rred_7043 VSS.$3113.Metal2 VSS.P0.pSD 13268.7698479
Rred_7044 VSS.$3113.Metal2 VSS.P10.nSD 103.93619251
Rred_7045 VSS.$312.Metal1 VSS.$332.Metal1 0.0103986066457
Rred_7046 VSS.$312.Metal1 VSS.$4454.Metal3 2333.76814442
Rred_7047 VSS.$312.Metal1 VSS.P2.pSD 17
Rred_7048 VSS.$312.Metal1 VSS.P3.pSD 17
Rred_7049 VSS.$3151.Metal2 VSS.$3199.Metal2 0.048486239739
Rred_7050 VSS.$3151.Metal2 VSS.$4751.Metal3 2.02265962076
Rred_7051 VSS.$3151.Metal2 VSS.$4799.Metal3 6.13284832082
Rred_7052 VSS.$3151.Metal2 VSS.$981.Metal1 3.01950933626
Rred_7053 VSS.$3151.Metal2 VSS.P1.pSD 3458.67092853
Rred_7054 VSS.$3157.Metal2 VSS.$3205.Metal2 0.0242460279948
Rred_7055 VSS.$3157.Metal2 VSS.$4754.Metal3 1.50901370883
Rred_7056 VSS.$3157.Metal2 VSS.$4778.Metal3 1.50900905206
Rred_7057 VSS.$3157.Metal2 VSS.$968.Metal1 205.656180959
Rred_7058 VSS.$3157.Metal2 VSS.$996.Metal1 1.68255549341
Rred_7059 VSS.$3157.Metal2 VSS.P2.pSD 6093.38455073
Rred_7060 VSS.$3157.Metal2 VSS.P3.pSD 6093.38455073
Rred_7061 VSS.$3169.Metal2 VSS.$3217.Metal2 0.048486239739
Rred_7062 VSS.$3169.Metal2 VSS.$4760.Metal3 2.02265962076
Rred_7063 VSS.$3169.Metal2 VSS.$4808.Metal3 6.13284832082
Rred_7064 VSS.$3169.Metal2 VSS.$990.Metal1 3.01950933626
Rred_7065 VSS.$3169.Metal2 VSS.P0.pSD 3458.67092853
Rred_7066 VSS.$317.Metal1 VSS.$365.Metal1 0.0503803330447
Rred_7067 VSS.$317.Metal1 VSS.$4451.Metal3 754.337028826
Rred_7068 VSS.$317.Metal1 VSS.P1.pSD 5.6382048292
Rred_7069 VSS.$3199.Metal2 VSS.$3250.Metal2 0.0484923752296
Rred_7070 VSS.$3199.Metal2 VSS.$4751.Metal3 6.13284832082
Rred_7071 VSS.$3199.Metal2 VSS.$4799.Metal3 2.02265962076
Rred_7072 VSS.$3199.Metal2 VSS.P1.pSD 3494.78766436
Rred_7073 VSS.$3205.Metal2 VSS.$3260.Metal2 0.0242460844575
Rred_7074 VSS.$3205.Metal2 VSS.$4778.Metal3 1.50900905206
Rred_7075 VSS.$3205.Metal2 VSS.$4802.Metal3 1.5090108056
Rred_7076 VSS.$3217.Metal2 VSS.$3276.Metal2 0.0484923752296
Rred_7077 VSS.$3217.Metal2 VSS.$4760.Metal3 6.13284832082
Rred_7078 VSS.$3217.Metal2 VSS.$4808.Metal3 2.02265962076
Rred_7079 VSS.$3217.Metal2 VSS.P0.pSD 3494.78766436
Rred_7080 VSS.$3250.Metal2 VSS.$3282.Metal2 0.024107506035
Rred_7081 VSS.$3250.Metal2 VSS.$4799.Metal3 2.59007321156
Rred_7082 VSS.$3250.Metal2 VSS.$4835.Metal3 9.09640618761
Rred_7083 VSS.$3250.Metal2 VSS.P1.pSD 5344.57725506
Rred_7084 VSS.$3250.Metal2 VSS.P35.nSD 159.811206158
Rred_7085 VSS.$326.Metal1 VSS.$374.Metal1 0.0503803330447
Rred_7086 VSS.$326.Metal1 VSS.$4460.Metal3 754.337028826
Rred_7087 VSS.$326.Metal1 VSS.P0.pSD 5.6382048292
Rred_7088 VSS.$3260.Metal2 VSS.$3292.Metal2 0.0120537530175
Rred_7089 VSS.$3260.Metal2 VSS.$4802.Metal3 1.29503424621
Rred_7090 VSS.$3260.Metal2 VSS.$4838.Metal3 4.54820309381
Rred_7091 VSS.$3260.Metal2 VSS.P2.pSD 6605.68932994
Rred_7092 VSS.$3260.Metal2 VSS.P3.pSD 6605.68932994
Rred_7093 VSS.$3260.Metal2 VSS.P59.nSD 159.811206158
Rred_7094 VSS.$3260.Metal2 VSS.P83.nSD 159.811206158
Rred_7095 VSS.$3276.Metal2 VSS.$3308.Metal2 0.024107506035
Rred_7096 VSS.$3276.Metal2 VSS.$4808.Metal3 2.59007321156
Rred_7097 VSS.$3276.Metal2 VSS.$4844.Metal3 9.09640618761
Rred_7098 VSS.$3276.Metal2 VSS.P0.pSD 5344.57725506
Rred_7099 VSS.$3276.Metal2 VSS.P11.nSD 159.811206158
Rred_7100 VSS.$3282.Metal2 VSS.$3338.Metal2 0.0484923752296
Rred_7101 VSS.$3282.Metal2 VSS.$4799.Metal3 9.09640618761
Rred_7102 VSS.$3282.Metal2 VSS.$4835.Metal3 2.59007321156
Rred_7103 VSS.$3282.Metal2 VSS.P1.pSD 5344.57725506
Rred_7104 VSS.$3282.Metal2 VSS.P35.nSD 159.811206158
Rred_7105 VSS.$3292.Metal2 VSS.$3344.Metal2 0.0242460844575
Rred_7106 VSS.$3292.Metal2 VSS.$4802.Metal3 4.54820309381
Rred_7107 VSS.$3292.Metal2 VSS.$4838.Metal3 1.29503424621
Rred_7108 VSS.$3292.Metal2 VSS.P2.pSD 6605.68932994
Rred_7109 VSS.$3292.Metal2 VSS.P3.pSD 6605.68932994
Rred_7110 VSS.$3292.Metal2 VSS.P59.nSD 159.811206158
Rred_7111 VSS.$3292.Metal2 VSS.P83.nSD 159.811206158
Rred_7112 VSS.$3308.Metal2 VSS.$3356.Metal2 0.0484923752296
Rred_7113 VSS.$3308.Metal2 VSS.$4808.Metal3 9.09640618761
Rred_7114 VSS.$3308.Metal2 VSS.$4844.Metal3 2.59007321156
Rred_7115 VSS.$3308.Metal2 VSS.P0.pSD 5344.57725506
Rred_7116 VSS.$3308.Metal2 VSS.P11.nSD 159.811206158
Rred_7117 VSS.$332.Metal1 VSS.$360.Metal1 0.0208622916459
Rred_7118 VSS.$332.Metal1 VSS.$4454.Metal3 450.376308574
Rred_7119 VSS.$332.Metal1 VSS.P2.pSD 11.3475561438
Rred_7120 VSS.$332.Metal1 VSS.P3.pSD 11.3475561438
Rred_7121 VSS.$3338.Metal2 VSS.$3386.Metal2 0.048486239739
Rred_7122 VSS.$3338.Metal2 VSS.$4835.Metal3 2.02265962076
Rred_7123 VSS.$3338.Metal2 VSS.$4883.Metal3 6.13284832082
Rred_7124 VSS.$3338.Metal2 VSS.P1.pSD 3494.78766436
Rred_7125 VSS.$3344.Metal2 VSS.$3392.Metal2 0.0242460279948
Rred_7126 VSS.$3344.Metal2 VSS.$4838.Metal3 1.5090108056
Rred_7127 VSS.$3344.Metal2 VSS.$4862.Metal3 1.50900905206
Rred_7128 VSS.$3356.Metal2 VSS.$3404.Metal2 0.048486239739
Rred_7129 VSS.$3356.Metal2 VSS.$4844.Metal3 2.02265962076
Rred_7130 VSS.$3356.Metal2 VSS.$4892.Metal3 6.13284832082
Rred_7131 VSS.$3356.Metal2 VSS.P0.pSD 3494.78766436
Rred_7132 VSS.$3386.Metal2 VSS.$3445.Metal2 0.0484923752296
Rred_7133 VSS.$3386.Metal2 VSS.$4835.Metal3 6.13284832082
Rred_7134 VSS.$3386.Metal2 VSS.$4883.Metal3 2.02265962076
Rred_7135 VSS.$3386.Metal2 VSS.P1.pSD 3458.67092853
Rred_7136 VSS.$3392.Metal2 VSS.$3451.Metal2 0.024246177939
Rred_7137 VSS.$3392.Metal2 VSS.$4862.Metal3 1.50900905206
Rred_7138 VSS.$3392.Metal2 VSS.$4886.Metal3 1.50901370883
Rred_7139 VSS.$3392.Metal2 VSS.P2.pSD 6093.38455073
Rred_7140 VSS.$3392.Metal2 VSS.P3.pSD 6093.38455073
Rred_7141 VSS.$3404.Metal2 VSS.$3463.Metal2 0.0484923752296
Rred_7142 VSS.$3404.Metal2 VSS.$4844.Metal3 6.13284832082
Rred_7143 VSS.$3404.Metal2 VSS.$4892.Metal3 2.02265962076
Rred_7144 VSS.$3404.Metal2 VSS.P0.pSD 3458.67092853
Rred_7145 VSS.$3435.Metal2 VSS.$3451.Metal2 0.00278666666667
Rred_7146 VSS.$3435.Metal2 VSS.$3507.Metal2 0.0214147099109
Rred_7147 VSS.$3435.Metal2 VSS.$4910.Metal3 2.67090339797
Rred_7148 VSS.$3435.Metal2 VSS.P61.nSD 79.7243507049
Rred_7149 VSS.$3435.Metal2 VSS.P85.nSD 79.7243507049
Rred_7150 VSS.$3445.Metal2 VSS.$3477.Metal2 0.0240915098495
Rred_7151 VSS.$3445.Metal2 VSS.$3501.Metal2 1526.81857051
Rred_7152 VSS.$3445.Metal2 VSS.$4883.Metal3 2.42113023107
Rred_7153 VSS.$3445.Metal2 VSS.$4931.Metal3 12.2416920053
Rred_7154 VSS.$3445.Metal2 VSS.P1.pSD 13268.7698479
Rred_7155 VSS.$3445.Metal2 VSS.P37.nSD 103.93619251
Rred_7156 VSS.$3451.Metal2 VSS.$4886.Metal3 1.50901370883
Rred_7157 VSS.$3451.Metal2 VSS.$4910.Metal3 3.01202666667
Rred_7158 VSS.$3463.Metal2 VSS.$3495.Metal2 0.0240915098495
Rred_7159 VSS.$3463.Metal2 VSS.$3519.Metal2 1526.81857051
Rred_7160 VSS.$3463.Metal2 VSS.$4892.Metal3 2.42113023107
Rred_7161 VSS.$3463.Metal2 VSS.$4940.Metal3 12.2416920053
Rred_7162 VSS.$3463.Metal2 VSS.P0.pSD 13268.7698479
Rred_7163 VSS.$3463.Metal2 VSS.P13.nSD 103.93619251
Rred_7164 VSS.$3477.Metal2 VSS.$3501.Metal2 0.0240521306384
Rred_7165 VSS.$3477.Metal2 VSS.$4883.Metal3 6.09640618761
Rred_7166 VSS.$3477.Metal2 VSS.$4931.Metal3 6.09640618761
Rred_7167 VSS.$3477.Metal2 VSS.P1.pSD 2242.65392533
Rred_7168 VSS.$3477.Metal2 VSS.P37.nSD 344.630533059
Rred_7169 VSS.$3495.Metal2 VSS.$3519.Metal2 0.0240521306384
Rred_7170 VSS.$3495.Metal2 VSS.$4892.Metal3 6.09640618761
Rred_7171 VSS.$3495.Metal2 VSS.$4940.Metal3 6.09640618761
Rred_7172 VSS.$3495.Metal2 VSS.P0.pSD 2242.65392533
Rred_7173 VSS.$3495.Metal2 VSS.P13.nSD 344.630533059
Rred_7174 VSS.$3501.Metal2 VSS.$3549.Metal2 0.0484923752296
Rred_7175 VSS.$3501.Metal2 VSS.$4883.Metal3 12.2416920053
Rred_7176 VSS.$3501.Metal2 VSS.$4931.Metal3 2.42113023107
Rred_7177 VSS.$3501.Metal2 VSS.P1.pSD 1968.63194526
Rred_7178 VSS.$3507.Metal2 VSS.$3555.Metal2 0.0242460971418
Rred_7179 VSS.$3507.Metal2 VSS.$4910.Metal3 1.6138009324
Rred_7180 VSS.$3507.Metal2 VSS.$4934.Metal3 1.50901119954
Rred_7181 VSS.$3519.Metal2 VSS.$3567.Metal2 0.0484923752296
Rred_7182 VSS.$3519.Metal2 VSS.$4892.Metal3 12.2416920053
Rred_7183 VSS.$3519.Metal2 VSS.$4940.Metal3 2.42113023107
Rred_7184 VSS.$3519.Metal2 VSS.P0.pSD 1968.63194526
Rred_7185 VSS.$3549.Metal2 VSS.$3597.Metal2 0.0484923752296
Rred_7186 VSS.$3549.Metal2 VSS.$4931.Metal3 3.01802801866
Rred_7187 VSS.$3549.Metal2 VSS.$4955.Metal3 3.01802801866
Rred_7188 VSS.$3549.Metal2 VSS.P1.pSD 3135.41320954
Rred_7189 VSS.$3555.Metal2 VSS.$3603.Metal2 0.0242460625559
Rred_7190 VSS.$3555.Metal2 VSS.$4934.Metal3 1.50901119954
Rred_7191 VSS.$3555.Metal2 VSS.$4958.Metal3 1.50901012541
Rred_7192 VSS.$3555.Metal2 VSS.P2.pSD 5156.55371387
Rred_7193 VSS.$3555.Metal2 VSS.P3.pSD 5156.55371387
Rred_7194 VSS.$3567.Metal2 VSS.$3615.Metal2 0.0484923752296
Rred_7195 VSS.$3567.Metal2 VSS.$4940.Metal3 3.01802801866
Rred_7196 VSS.$3567.Metal2 VSS.$4964.Metal3 3.01802801866
Rred_7197 VSS.$3567.Metal2 VSS.P0.pSD 3135.41320954
Rred_7198 VSS.$3597.Metal2 VSS.$3632.Metal2 0.0240610199399
Rred_7199 VSS.$3597.Metal2 VSS.$4955.Metal3 2.59007321156
Rred_7200 VSS.$3597.Metal2 VSS.$4991.Metal3 9.09640618761
Rred_7201 VSS.$3597.Metal2 VSS.P1.pSD 3495.42631106
Rred_7202 VSS.$3597.Metal2 VSS.P39.nSD 12500.7034044
Rred_7203 VSS.$360.Metal1 VSS.$380.Metal1 0.0104023263612
Rred_7204 VSS.$360.Metal1 VSS.$4478.Metal3 503.541815624
Rred_7205 VSS.$360.Metal1 VSS.P2.pSD 11.3486579358
Rred_7206 VSS.$360.Metal1 VSS.P3.pSD 11.3486579358
Rred_7207 VSS.$3603.Metal2 VSS.$3638.Metal2 0.0120302664783
Rred_7208 VSS.$3603.Metal2 VSS.$4958.Metal3 1.29503374524
Rred_7209 VSS.$3603.Metal2 VSS.$4994.Metal3 4.54820309381
Rred_7210 VSS.$3603.Metal2 VSS.P2.pSD 14139.9506297
Rred_7211 VSS.$3603.Metal2 VSS.P3.pSD 14139.9506297
Rred_7212 VSS.$3603.Metal2 VSS.P63.nSD 2179.83073736
Rred_7213 VSS.$3603.Metal2 VSS.P87.nSD 2179.83073736
Rred_7214 VSS.$3615.Metal2 VSS.$3650.Metal2 0.0240610199399
Rred_7215 VSS.$3615.Metal2 VSS.$4964.Metal3 2.59007321156
Rred_7216 VSS.$3615.Metal2 VSS.$5000.Metal3 9.09640618761
Rred_7217 VSS.$3615.Metal2 VSS.P0.pSD 3495.42631106
Rred_7218 VSS.$3615.Metal2 VSS.P15.nSD 12500.7034044
Rred_7219 VSS.$3632.Metal2 VSS.$3688.Metal2 0.0484923752296
Rred_7220 VSS.$3632.Metal2 VSS.$4955.Metal3 9.09640618761
Rred_7221 VSS.$3632.Metal2 VSS.$4991.Metal3 2.59007321156
Rred_7222 VSS.$3632.Metal2 VSS.P39.nSD 474.710255865
Rred_7223 VSS.$3638.Metal2 VSS.$3694.Metal2 0.0242461109832
Rred_7224 VSS.$3638.Metal2 VSS.$4958.Metal3 4.54820309381
Rred_7225 VSS.$3638.Metal2 VSS.$4994.Metal3 1.29503485295
Rred_7226 VSS.$3638.Metal2 VSS.P63.nSD 82.7783824313
Rred_7227 VSS.$3638.Metal2 VSS.P87.nSD 82.7783824313
Rred_7228 VSS.$365.Metal1 VSS.$385.Metal1 0.0395650532209
Rred_7229 VSS.$365.Metal1 VSS.$4475.Metal3 754.337028826
Rred_7230 VSS.$365.Metal1 VSS.P1.pSD 8.00989158551
Rred_7231 VSS.$3650.Metal2 VSS.$3706.Metal2 0.0484923752296
Rred_7232 VSS.$3650.Metal2 VSS.$4964.Metal3 9.09640618761
Rred_7233 VSS.$3650.Metal2 VSS.$5000.Metal3 2.59007321156
Rred_7234 VSS.$3650.Metal2 VSS.P15.nSD 474.710255865
Rred_7235 VSS.$3688.Metal2 VSS.$3712.Metal2 0.0240522935581
Rred_7236 VSS.$3688.Metal2 VSS.$4991.Metal3 2.59007321156
Rred_7237 VSS.$3688.Metal2 VSS.$5027.Metal3 9.09640618761
Rred_7238 VSS.$3688.Metal2 VSS.P1.pSD 1652.72593386
Rred_7239 VSS.$3694.Metal2 VSS.$3718.Metal2 0.0120264116929
Rred_7240 VSS.$3694.Metal2 VSS.$4994.Metal3 1.29503485295
Rred_7241 VSS.$3694.Metal2 VSS.$5030.Metal3 4.54820309381
Rred_7242 VSS.$3694.Metal2 VSS.P2.pSD 5320.19092171
Rred_7243 VSS.$3694.Metal2 VSS.P3.pSD 5320.19092171
Rred_7244 VSS.$3706.Metal2 VSS.$3730.Metal2 0.0240522935581
Rred_7245 VSS.$3706.Metal2 VSS.$5000.Metal3 2.59007321156
Rred_7246 VSS.$3706.Metal2 VSS.$5036.Metal3 9.09640618761
Rred_7247 VSS.$3706.Metal2 VSS.P0.pSD 1652.72593386
Rred_7248 VSS.$3712.Metal2 VSS.$3760.Metal2 0.0484923752296
Rred_7249 VSS.$3712.Metal2 VSS.$4991.Metal3 9.09640618761
Rred_7250 VSS.$3712.Metal2 VSS.$5027.Metal3 2.59007321156
Rred_7251 VSS.$3712.Metal2 VSS.P1.pSD 1703.0815892
Rred_7252 VSS.$3718.Metal2 VSS.$3766.Metal2 0.0242460210856
Rred_7253 VSS.$3718.Metal2 VSS.$4994.Metal3 4.54820309381
Rred_7254 VSS.$3718.Metal2 VSS.$5030.Metal3 1.29503279667
Rred_7255 VSS.$3730.Metal2 VSS.$3778.Metal2 0.0484923752296
Rred_7256 VSS.$3730.Metal2 VSS.$5000.Metal3 9.09640618761
Rred_7257 VSS.$3730.Metal2 VSS.$5036.Metal3 2.59007321156
Rred_7258 VSS.$3730.Metal2 VSS.P0.pSD 1703.0815892
Rred_7259 VSS.$374.Metal1 VSS.$387.Metal1 0.0395650532209
Rred_7260 VSS.$374.Metal1 VSS.$4484.Metal3 754.337028826
Rred_7261 VSS.$374.Metal1 VSS.P0.pSD 8.00989158551
Rred_7262 VSS.$3760.Metal2 VSS.$3784.Metal2 0.024052161712
Rred_7263 VSS.$3760.Metal2 VSS.$3819.Metal2 1526.81857051
Rred_7264 VSS.$3760.Metal2 VSS.$5027.Metal3 2.42113023107
Rred_7265 VSS.$3760.Metal2 VSS.$5075.Metal3 12.2416920053
Rred_7266 VSS.$3760.Metal2 VSS.P1.pSD 1995.73669521
Rred_7267 VSS.$3766.Metal2 VSS.$3809.Metal2 0.0205206810691
Rred_7268 VSS.$3766.Metal2 VSS.$5030.Metal3 1.50900883748
Rred_7269 VSS.$3766.Metal2 VSS.$5054.Metal3 1.65673098428
Rred_7270 VSS.$3778.Metal2 VSS.$3802.Metal2 0.024052161712
Rred_7271 VSS.$3778.Metal2 VSS.$3837.Metal2 1526.81857051
Rred_7272 VSS.$3778.Metal2 VSS.$5036.Metal3 2.42113023107
Rred_7273 VSS.$3778.Metal2 VSS.$5084.Metal3 12.2416920053
Rred_7274 VSS.$3778.Metal2 VSS.P0.pSD 1995.73669521
Rred_7275 VSS.$3784.Metal2 VSS.$3819.Metal2 0.0240989264962
Rred_7276 VSS.$3784.Metal2 VSS.$5027.Metal3 6.09640618761
Rred_7277 VSS.$3784.Metal2 VSS.$5075.Metal3 6.09640618761
Rred_7278 VSS.$3784.Metal2 VSS.P1.pSD 2314.81399662
Rred_7279 VSS.$3784.Metal2 VSS.P41.nSD 261.999840327
Rred_7280 VSS.$380.Metal1 VSS.$386.Metal1 0.0119412090979
Rred_7281 VSS.$380.Metal1 VSS.$4478.Metal3 1510.62544687
Rred_7282 VSS.$380.Metal1 VSS.P2.pSD 15.0717018687
Rred_7283 VSS.$380.Metal1 VSS.P3.pSD 15.0717018687
Rred_7284 VSS.$3802.Metal2 VSS.$3837.Metal2 0.0240989264962
Rred_7285 VSS.$3802.Metal2 VSS.$5036.Metal3 6.09640618761
Rred_7286 VSS.$3802.Metal2 VSS.$5084.Metal3 6.09640618761
Rred_7287 VSS.$3802.Metal2 VSS.P0.pSD 2314.81399662
Rred_7288 VSS.$3802.Metal2 VSS.P17.nSD 261.999840327
Rred_7289 VSS.$3809.Metal2 VSS.$3825.Metal2 0.00366666666667
Rred_7290 VSS.$3809.Metal2 VSS.$5054.Metal3 2.55939758344
Rred_7291 VSS.$3809.Metal2 VSS.P65.nSD 79.7243507049
Rred_7292 VSS.$3809.Metal2 VSS.P89.nSD 79.7243507049
Rred_7293 VSS.$3819.Metal2 VSS.$3875.Metal2 0.0484923752296
Rred_7294 VSS.$3819.Metal2 VSS.$5027.Metal3 12.2416920053
Rred_7295 VSS.$3819.Metal2 VSS.$5075.Metal3 2.42113023107
Rred_7296 VSS.$3819.Metal2 VSS.P1.pSD 8945.64126452
Rred_7297 VSS.$3819.Metal2 VSS.P41.nSD 114.91221067
Rred_7298 VSS.$3825.Metal2 VSS.$3881.Metal2 0.0242460452723
Rred_7299 VSS.$3825.Metal2 VSS.$5054.Metal3 3.01202666667
Rred_7300 VSS.$3825.Metal2 VSS.$5078.Metal3 1.50900958864
Rred_7301 VSS.$3825.Metal2 VSS.P2.pSD 13099.9828476
Rred_7302 VSS.$3825.Metal2 VSS.P3.pSD 13099.9828476
Rred_7303 VSS.$3837.Metal2 VSS.$3893.Metal2 0.0484923752296
Rred_7304 VSS.$3837.Metal2 VSS.$5036.Metal3 12.2416920053
Rred_7305 VSS.$3837.Metal2 VSS.$5084.Metal3 2.42113023107
Rred_7306 VSS.$3837.Metal2 VSS.P0.pSD 8945.64126452
Rred_7307 VSS.$3837.Metal2 VSS.P17.nSD 114.91221067
Rred_7308 VSS.$385.Metal1 VSS.$456.Metal1 0.0358581386467
Rred_7309 VSS.$385.Metal1 VSS.P1.pSD 9.3483204091
Rred_7310 VSS.$385.Metal1 VSS.P27.nSD 6.30774233271
Rred_7311 VSS.$386.Metal1 VSS.$451.Metal1 0.00887363747428
Rred_7312 VSS.$386.Metal1 VSS.P2.pSD 19.5066478997
Rred_7313 VSS.$386.Metal1 VSS.P3.pSD 19.5066478997
Rred_7314 VSS.$386.Metal1 VSS.P51.nSD 6.30774233271
Rred_7315 VSS.$386.Metal1 VSS.P75.nSD 6.30774233271
Rred_7316 VSS.$387.Metal1 VSS.$465.Metal1 0.0358581386467
Rred_7317 VSS.$387.Metal1 VSS.P0.pSD 9.3483204091
Rred_7318 VSS.$387.Metal1 VSS.P3.nSD 6.30774233271
Rred_7319 VSS.$3875.Metal2 VSS.$3923.Metal2 0.048486239739
Rred_7320 VSS.$3875.Metal2 VSS.$5075.Metal3 2.02265962076
Rred_7321 VSS.$3875.Metal2 VSS.$5123.Metal3 6.13284832082
Rred_7322 VSS.$3875.Metal2 VSS.P1.pSD 3494.79852872
Rred_7323 VSS.$3881.Metal2 VSS.$3929.Metal2 0.0242460533372
Rred_7324 VSS.$3881.Metal2 VSS.$5078.Metal3 1.50900958864
Rred_7325 VSS.$3881.Metal2 VSS.$5102.Metal3 1.50900983911
Rred_7326 VSS.$3893.Metal2 VSS.$3941.Metal2 0.048486239739
Rred_7327 VSS.$3893.Metal2 VSS.$5084.Metal3 2.02265962076
Rred_7328 VSS.$3893.Metal2 VSS.$5132.Metal3 6.13284832082
Rred_7329 VSS.$3893.Metal2 VSS.P0.pSD 3494.79852872
Rred_7330 VSS.$3923.Metal2 VSS.$3982.Metal2 0.0484923752296
Rred_7331 VSS.$3923.Metal2 VSS.$5075.Metal3 6.13284832082
Rred_7332 VSS.$3923.Metal2 VSS.$5123.Metal3 2.02265962076
Rred_7333 VSS.$3923.Metal2 VSS.P1.pSD 3195.13122738
Rred_7334 VSS.$3929.Metal2 VSS.$3988.Metal2 0.0242461109832
Rred_7335 VSS.$3929.Metal2 VSS.$5102.Metal3 1.50900983911
Rred_7336 VSS.$3929.Metal2 VSS.$5126.Metal3 1.5090116294
Rred_7337 VSS.$3929.Metal2 VSS.P2.pSD 5320.19092171
Rred_7338 VSS.$3929.Metal2 VSS.P3.pSD 5320.19092171
Rred_7339 VSS.$3941.Metal2 VSS.$4000.Metal2 0.0484923752296
Rred_7340 VSS.$3941.Metal2 VSS.$5084.Metal3 6.13284832082
Rred_7341 VSS.$3941.Metal2 VSS.$5132.Metal3 2.02265962076
Rred_7342 VSS.$3941.Metal2 VSS.P0.pSD 3195.13122738
Rred_7343 VSS.$3982.Metal2 VSS.$4014.Metal2 0.0241063349611
Rred_7344 VSS.$3982.Metal2 VSS.$5123.Metal3 2.59007321156
Rred_7345 VSS.$3982.Metal2 VSS.$5159.Metal3 9.09640618761
Rred_7346 VSS.$3982.Metal2 VSS.P1.pSD 9485.44026575
Rred_7347 VSS.$3982.Metal2 VSS.P43.nSD 139.403003311
Rred_7348 VSS.$3988.Metal2 VSS.$4020.Metal2 0.0120531674805
Rred_7349 VSS.$3988.Metal2 VSS.$5126.Metal3 1.29503485295
Rred_7350 VSS.$3988.Metal2 VSS.$5162.Metal3 4.54820309381
Rred_7351 VSS.$3988.Metal2 VSS.P67.nSD 139.403003311
Rred_7352 VSS.$3988.Metal2 VSS.P91.nSD 139.403003311
Rred_7353 VSS.$4000.Metal2 VSS.$4032.Metal2 0.0241063349611
Rred_7354 VSS.$4000.Metal2 VSS.$5132.Metal3 2.59007321156
Rred_7355 VSS.$4000.Metal2 VSS.$5168.Metal3 9.09640618761
Rred_7356 VSS.$4000.Metal2 VSS.P0.pSD 9485.44026575
Rred_7357 VSS.$4000.Metal2 VSS.P19.nSD 139.403003311
Rred_7358 VSS.$4014.Metal2 VSS.$4062.Metal2 0.0484923752296
Rred_7359 VSS.$4014.Metal2 VSS.$5123.Metal3 9.09640618761
Rred_7360 VSS.$4014.Metal2 VSS.$5159.Metal3 2.59007321156
Rred_7361 VSS.$4014.Metal2 VSS.P1.pSD 6716.86096755
Rred_7362 VSS.$4014.Metal2 VSS.P43.nSD 187.198318732
Rred_7363 VSS.$4020.Metal2 VSS.$4068.Metal2 0.0242460625559
Rred_7364 VSS.$4020.Metal2 VSS.$5126.Metal3 4.54820309381
Rred_7365 VSS.$4020.Metal2 VSS.$5162.Metal3 1.29503374524
Rred_7366 VSS.$4020.Metal2 VSS.P2.pSD 42082.9728891
Rred_7367 VSS.$4020.Metal2 VSS.P3.pSD 42082.9728891
Rred_7368 VSS.$4020.Metal2 VSS.P67.nSD 187.198318732
Rred_7369 VSS.$4020.Metal2 VSS.P91.nSD 187.198318732
Rred_7370 VSS.$4032.Metal2 VSS.$4080.Metal2 0.0484923752296
Rred_7371 VSS.$4032.Metal2 VSS.$5132.Metal3 9.09640618761
Rred_7372 VSS.$4032.Metal2 VSS.$5168.Metal3 2.59007321156
Rred_7373 VSS.$4032.Metal2 VSS.P0.pSD 6716.86096755
Rred_7374 VSS.$4032.Metal2 VSS.P19.nSD 187.198318732
Rred_7375 VSS.$4062.Metal2 VSS.$4110.Metal2 0.0484923752296
Rred_7376 VSS.$4062.Metal2 VSS.$5159.Metal3 3.01802801866
Rred_7377 VSS.$4062.Metal2 VSS.$5183.Metal3 3.01802801866
Rred_7378 VSS.$4062.Metal2 VSS.P1.pSD 3135.41320954
Rred_7379 VSS.$4068.Metal2 VSS.$4116.Metal2 0.0242460971418
Rred_7380 VSS.$4068.Metal2 VSS.$5162.Metal3 1.50901012541
Rred_7381 VSS.$4068.Metal2 VSS.$5186.Metal3 1.50901119954
Rred_7382 VSS.$4068.Metal2 VSS.P2.pSD 5156.55371387
Rred_7383 VSS.$4068.Metal2 VSS.P3.pSD 5156.55371387
Rred_7384 VSS.$4080.Metal2 VSS.$4128.Metal2 0.0484923752296
Rred_7385 VSS.$4080.Metal2 VSS.$5168.Metal3 3.01802801866
Rred_7386 VSS.$4080.Metal2 VSS.$5192.Metal3 3.01802801866
Rred_7387 VSS.$4080.Metal2 VSS.P0.pSD 3135.41320954
Rred_7388 VSS.$4110.Metal2 VSS.$4134.Metal2 0.0240522932358
Rred_7389 VSS.$4110.Metal2 VSS.$5183.Metal3 2.59007321156
Rred_7390 VSS.$4110.Metal2 VSS.$5219.Metal3 9.09640618761
Rred_7391 VSS.$4110.Metal2 VSS.P1.pSD 1755.63484102
Rred_7392 VSS.$4116.Metal2 VSS.$4140.Metal2 0.0120264116929
Rred_7393 VSS.$4116.Metal2 VSS.$5186.Metal3 1.29503453635
Rred_7394 VSS.$4116.Metal2 VSS.$5222.Metal3 4.54820309381
Rred_7395 VSS.$4128.Metal2 VSS.$4152.Metal2 0.0240522932358
Rred_7396 VSS.$4128.Metal2 VSS.$5192.Metal3 2.59007321156
Rred_7397 VSS.$4128.Metal2 VSS.$5228.Metal3 9.09640618761
Rred_7398 VSS.$4128.Metal2 VSS.P0.pSD 1755.63484102
Rred_7399 VSS.$4134.Metal2 VSS.$4195.Metal2 0.051071228228
Rred_7400 VSS.$4134.Metal2 VSS.$5183.Metal3 9.09640618761
Rred_7401 VSS.$4134.Metal2 VSS.$5219.Metal3 2.53685126265
Rred_7402 VSS.$4134.Metal2 VSS.P1.pSD 1755.06325379
Rred_7403 VSS.$4140.Metal2 VSS.$4168.Metal2 0.0330185759294
Rred_7404 VSS.$4140.Metal2 VSS.$4170.Metal2 0.0330185759294
Rred_7405 VSS.$4140.Metal2 VSS.$5186.Metal3 4.54820309381
Rred_7406 VSS.$4140.Metal2 VSS.$5222.Metal3 2.26502132807
Rred_7407 VSS.$4140.Metal2 VSS.P2.pSD 10780.0483328
Rred_7408 VSS.$4140.Metal2 VSS.P3.pSD 10780.0483328
Rred_7409 VSS.$4152.Metal2 VSS.$4213.Metal2 0.051071228228
Rred_7410 VSS.$4152.Metal2 VSS.$5192.Metal3 9.09640618761
Rred_7411 VSS.$4152.Metal2 VSS.$5228.Metal3 2.53685126265
Rred_7412 VSS.$4152.Metal2 VSS.P0.pSD 1755.06325379
Rred_7413 VSS.$4164.Metal2 VSS.$4166.Metal2 0.013640831758
Rred_7414 VSS.$4164.Metal2 VSS.$5222.Metal3 9
Rred_7415 VSS.$4164.Metal2 VSS.$5234.Metal3 9
Rred_7416 VSS.$4164.Metal2 VSS.$5246.Metal3 9
Rred_7417 VSS.$4164.Metal2 VSS.$5258.Metal3 9
Rred_7418 VSS.$4164.Metal2 VSS.$5270.Metal3 9
Rred_7419 VSS.$4164.Metal2 VSS.$5282.Metal3 9
Rred_7420 VSS.$4164.Metal2 VSS.P3.pSD 436.932959332
Rred_7421 VSS.$4164.Metal2 VSS.P93.nSD 291.496550811
Rred_7422 VSS.$4164.Metal2 VSS.P95.nSD 291.496550811
Rred_7423 VSS.$4166.Metal2 VSS.$4168.Metal2 0.013640831758
Rred_7424 VSS.$4166.Metal2 VSS.$5222.Metal3 9
Rred_7425 VSS.$4166.Metal2 VSS.$5234.Metal3 9
Rred_7426 VSS.$4166.Metal2 VSS.$5246.Metal3 9
Rred_7427 VSS.$4166.Metal2 VSS.$5258.Metal3 9
Rred_7428 VSS.$4166.Metal2 VSS.$5270.Metal3 9
Rred_7429 VSS.$4166.Metal2 VSS.$5282.Metal3 9
Rred_7430 VSS.$4168.Metal2 VSS.$4170.Metal2 0.0344136795057
Rred_7431 VSS.$4168.Metal2 VSS.$5222.Metal3 9
Rred_7432 VSS.$4168.Metal2 VSS.$5234.Metal3 9
Rred_7433 VSS.$4168.Metal2 VSS.$5246.Metal3 9
Rred_7434 VSS.$4168.Metal2 VSS.$5258.Metal3 9
Rred_7435 VSS.$4168.Metal2 VSS.$5270.Metal3 9
Rred_7436 VSS.$4168.Metal2 VSS.$5282.Metal3 9
Rred_7437 VSS.$4170.Metal2 VSS.$4172.Metal2 0.013640831758
Rred_7438 VSS.$4170.Metal2 VSS.$5222.Metal3 9
Rred_7439 VSS.$4170.Metal2 VSS.$5234.Metal3 9
Rred_7440 VSS.$4170.Metal2 VSS.$5246.Metal3 9
Rred_7441 VSS.$4170.Metal2 VSS.$5258.Metal3 9
Rred_7442 VSS.$4170.Metal2 VSS.$5270.Metal3 9
Rred_7443 VSS.$4170.Metal2 VSS.$5282.Metal3 9
Rred_7444 VSS.$4172.Metal2 VSS.$4174.Metal2 0.013640831758
Rred_7445 VSS.$4172.Metal2 VSS.$5222.Metal3 9
Rred_7446 VSS.$4172.Metal2 VSS.$5234.Metal3 9
Rred_7447 VSS.$4172.Metal2 VSS.$5246.Metal3 9
Rred_7448 VSS.$4172.Metal2 VSS.$5258.Metal3 9
Rred_7449 VSS.$4172.Metal2 VSS.$5270.Metal3 9
Rred_7450 VSS.$4172.Metal2 VSS.$5282.Metal3 9
Rred_7451 VSS.$4174.Metal2 VSS.$5222.Metal3 9
Rred_7452 VSS.$4174.Metal2 VSS.$5234.Metal3 9
Rred_7453 VSS.$4174.Metal2 VSS.$5246.Metal3 9
Rred_7454 VSS.$4174.Metal2 VSS.$5258.Metal3 9
Rred_7455 VSS.$4174.Metal2 VSS.$5270.Metal3 9
Rred_7456 VSS.$4174.Metal2 VSS.$5282.Metal3 9
Rred_7457 VSS.$4174.Metal2 VSS.P2.pSD 436.932959332
Rred_7458 VSS.$4174.Metal2 VSS.P69.nSD 291.496550811
Rred_7459 VSS.$4174.Metal2 VSS.P71.nSD 291.496550811
Rred_7460 VSS.$4195.Metal2 VSS.$4251.Metal2 0.0731564027084
Rred_7461 VSS.$4195.Metal2 VSS.$5219.Metal3 3.0949188449
Rred_7462 VSS.$4195.Metal2 VSS.$5243.Metal3 3.46009554039
Rred_7463 VSS.$4195.Metal2 VSS.P1.pSD 19850.6262899
Rred_7464 VSS.$4213.Metal2 VSS.$4271.Metal2 0.0731564027084
Rred_7465 VSS.$4213.Metal2 VSS.$5228.Metal3 3.0949188449
Rred_7466 VSS.$4213.Metal2 VSS.$5252.Metal3 3.46009554039
Rred_7467 VSS.$4213.Metal2 VSS.P0.pSD 19850.6262899
Rred_7468 VSS.$4227.Metal2 VSS.$4251.Metal2 0.0278597436121
Rred_7469 VSS.$4227.Metal2 VSS.$5243.Metal3 4.21955749704
Rred_7470 VSS.$4227.Metal2 VSS.$5279.Metal3 3.33021285585
Rred_7471 VSS.$4227.Metal2 VSS.P1.pSD 452.297785058
Rred_7472 VSS.$4227.Metal2 VSS.P45.nSD 301.318005877
Rred_7473 VSS.$4227.Metal2 VSS.P47.nSD 301.318005877
Rred_7474 VSS.$4241.Metal2 VSS.$4271.Metal2 0.0278597436121
Rred_7475 VSS.$4241.Metal2 VSS.$5252.Metal3 4.21955749704
Rred_7476 VSS.$4241.Metal2 VSS.$5288.Metal3 3.33021285585
Rred_7477 VSS.$4241.Metal2 VSS.$66.Metal1 7428133.11373
Rred_7478 VSS.$4241.Metal2 VSS.P0.pSD 452.297785058
Rred_7479 VSS.$4241.Metal2 VSS.P21.nSD 301.318005877
Rred_7480 VSS.$4241.Metal2 VSS.P23.nSD 301.318005877
Rred_7481 VSS.$4251.Metal2 VSS.$5243.Metal3 3.3159637394
Rred_7482 VSS.$4251.Metal2 VSS.$5279.Metal3 2.77404917107
Rred_7483 VSS.$4271.Metal2 VSS.$5252.Metal3 3.3159637394
Rred_7484 VSS.$4271.Metal2 VSS.$5288.Metal3 2.77404917107
Rred_7485 VSS.$4355.Metal3 VSS.$4358.Metal3 18346.4169973
Rred_7486 VSS.$4355.Metal3 VSS.$4364.Metal3 41259539.9573
Rred_7487 VSS.$4355.Metal3 VSS.$4391.Metal3 0.0729315939569
Rred_7488 VSS.$4358.Metal3 VSS.$4364.Metal3 18346.4169973
Rred_7489 VSS.$4358.Metal3 VSS.$4370.Metal3 0.0120266666667
Rred_7490 VSS.$4364.Metal3 VSS.$4400.Metal3 0.0729315939569
Rred_7491 VSS.$4370.Metal3 VSS.$4382.Metal3 0.0120266666667
Rred_7492 VSS.$4382.Metal3 VSS.$4394.Metal3 0.0120266666667
Rred_7493 VSS.$4391.Metal3 VSS.$4415.Metal3 0.0482995209481
Rred_7494 VSS.$4394.Metal3 VSS.$4406.Metal3 0.0120266666667
Rred_7495 VSS.$4400.Metal3 VSS.$4424.Metal3 0.0482995209481
Rred_7496 VSS.$4406.Metal3 VSS.$4418.Metal3 0.0120266666667
Rred_7497 VSS.$4415.Metal3 VSS.$4451.Metal3 0.0729329633886
Rred_7498 VSS.$4418.Metal3 VSS.$4454.Metal3 0.0364664816945
Rred_7499 VSS.$4424.Metal3 VSS.$4460.Metal3 0.0729329633886
Rred_7500 VSS.$4451.Metal3 VSS.$4475.Metal3 0.0482995209481
Rred_7501 VSS.$4454.Metal3 VSS.$4478.Metal3 0.0241497604741
Rred_7502 VSS.$4460.Metal3 VSS.$4484.Metal3 0.0482995209481
Rred_7503 VSS.$4475.Metal3 VSS.$4511.Metal3 0.0729329633886
Rred_7504 VSS.$4478.Metal3 VSS.$4514.Metal3 0.0364664816945
Rred_7505 VSS.$4484.Metal3 VSS.$4520.Metal3 0.0729329633886
Rred_7506 VSS.$451.Metal1 VSS.$4514.Metal3 2851.97515394
Rred_7507 VSS.$451.Metal1 VSS.$471.Metal1 0.0103971187595
Rred_7508 VSS.$451.Metal1 VSS.P2.pSD 17
Rred_7509 VSS.$451.Metal1 VSS.P3.pSD 17
Rred_7510 VSS.$4511.Metal3 VSS.$4559.Metal3 0.0981480735474
Rred_7511 VSS.$4511.Metal3 VSS.$456.Metal1 754.337028826
Rred_7512 VSS.$4511.Metal3 VSS.$504.Metal1 1532.86667717
Rred_7513 VSS.$4514.Metal3 VSS.$4538.Metal3 0.0241497604741
Rred_7514 VSS.$4514.Metal3 VSS.$471.Metal1 435.047057381
Rred_7515 VSS.$4520.Metal3 VSS.$4568.Metal3 0.0981480735474
Rred_7516 VSS.$4520.Metal3 VSS.$465.Metal1 754.337028826
Rred_7517 VSS.$4520.Metal3 VSS.$513.Metal1 1532.86667717
Rred_7518 VSS.$4538.Metal3 VSS.$4562.Metal3 0.0241497604741
Rred_7519 VSS.$4538.Metal3 VSS.$499.Metal1 524.144518347
Rred_7520 VSS.$4538.Metal3 VSS.$519.Metal1 1351.74112626
Rred_7521 VSS.$4559.Metal3 VSS.$4607.Metal3 0.0981511661222
Rred_7522 VSS.$4559.Metal3 VSS.$504.Metal1 1532.86667717
Rred_7523 VSS.$4559.Metal3 VSS.$544.Metal1 754.337028826
Rred_7524 VSS.$456.Metal1 VSS.$504.Metal1 0.0503800743211
Rred_7525 VSS.$456.Metal1 VSS.P1.pSD 8.1616300373
Rred_7526 VSS.$4562.Metal3 VSS.$4586.Metal3 0.0241497604741
Rred_7527 VSS.$4562.Metal3 VSS.$539.Metal1 1223.10590957
Rred_7528 VSS.$4562.Metal3 VSS.$559.Metal1 546.494129806
Rred_7529 VSS.$4568.Metal3 VSS.$4616.Metal3 0.0981511661222
Rred_7530 VSS.$4568.Metal3 VSS.$513.Metal1 1532.86667717
Rred_7531 VSS.$4568.Metal3 VSS.$553.Metal1 754.337028826
Rred_7532 VSS.$4586.Metal3 VSS.$4610.Metal3 0.0241497604741
Rred_7533 VSS.$4586.Metal3 VSS.$618.Metal1 512.247075567
Rred_7534 VSS.$4586.Metal3 VSS.$638.Metal1 4463.86737281
Rred_7535 VSS.$4607.Metal3 VSS.$4643.Metal3 0.0729329633886
Rred_7536 VSS.$4607.Metal3 VSS.$663.Metal1 754.337028826
Rred_7537 VSS.$4610.Metal3 VSS.$4646.Metal3 0.0364664816945
Rred_7538 VSS.$4610.Metal3 VSS.$658.Metal1 778.534915351
Rred_7539 VSS.$4610.Metal3 VSS.$678.Metal1 734.047205903
Rred_7540 VSS.$4616.Metal3 VSS.$4652.Metal3 0.0729329633886
Rred_7541 VSS.$4616.Metal3 VSS.$672.Metal1 754.337028826
Rred_7542 VSS.$4643.Metal3 VSS.$4679.Metal3 0.0729329633886
Rred_7543 VSS.$4643.Metal3 VSS.$731.Metal1 754.337028826
Rred_7544 VSS.$4646.Metal3 VSS.$4682.Metal3 0.0364664816945
Rred_7545 VSS.$4646.Metal3 VSS.$726.Metal1 435.047057381
Rred_7546 VSS.$4646.Metal3 VSS.$757.Metal1 2851.97515394
Rred_7547 VSS.$465.Metal1 VSS.$513.Metal1 0.0503800743211
Rred_7548 VSS.$465.Metal1 VSS.P0.pSD 8.1616300373
Rred_7549 VSS.$4652.Metal3 VSS.$4688.Metal3 0.0729329633886
Rred_7550 VSS.$4652.Metal3 VSS.$740.Metal1 754.337028826
Rred_7551 VSS.$4679.Metal3 VSS.$4703.Metal3 0.0482995209481
Rred_7552 VSS.$4679.Metal3 VSS.$822.Metal1 754.337028826
Rred_7553 VSS.$4682.Metal3 VSS.$4706.Metal3 0.0241497604741
Rred_7554 VSS.$4682.Metal3 VSS.$817.Metal1 1510.62544687
Rred_7555 VSS.$4682.Metal3 VSS.$837.Metal1 503.541815624
Rred_7556 VSS.$4688.Metal3 VSS.$4712.Metal3 0.0482995209481
Rred_7557 VSS.$4688.Metal3 VSS.$831.Metal1 754.337028826
Rred_7558 VSS.$4703.Metal3 VSS.$4751.Metal3 0.0981511661222
Rred_7559 VSS.$4703.Metal3 VSS.$870.Metal1 754.337028826
Rred_7560 VSS.$4706.Metal3 VSS.$4730.Metal3 0.0241497604741
Rred_7561 VSS.$4706.Metal3 VSS.$865.Metal1 450.376308574
Rred_7562 VSS.$4706.Metal3 VSS.$885.Metal1 2333.76814442
Rred_7563 VSS.$471.Metal1 VSS.$499.Metal1 0.0208620449569
Rred_7564 VSS.$471.Metal1 VSS.P2.pSD 11.3468336065
Rred_7565 VSS.$471.Metal1 VSS.P3.pSD 11.3468336065
Rred_7566 VSS.$4712.Metal3 VSS.$4760.Metal3 0.0981511661222
Rred_7567 VSS.$4712.Metal3 VSS.$879.Metal1 754.337028826
Rred_7568 VSS.$4730.Metal3 VSS.$4754.Metal3 0.0241497604741
Rred_7569 VSS.$4730.Metal3 VSS.$905.Metal1 1018.41191388
Rred_7570 VSS.$4730.Metal3 VSS.$936.Metal1 757.280653908
Rred_7571 VSS.$4751.Metal3 VSS.$4799.Metal3 0.0981480735474
Rred_7572 VSS.$4751.Metal3 VSS.$981.Metal1 754.337028826
Rred_7573 VSS.$4754.Metal3 VSS.$4778.Metal3 0.0241497604741
Rred_7574 VSS.$4754.Metal3 VSS.$968.Metal1 25650.0225697
Rred_7575 VSS.$4754.Metal3 VSS.$996.Metal1 382.836157757
Rred_7576 VSS.$4760.Metal3 VSS.$4808.Metal3 0.0981480735474
Rred_7577 VSS.$4760.Metal3 VSS.$990.Metal1 754.337028826
Rred_7578 VSS.$4778.Metal3 VSS.$4802.Metal3 0.0241497604741
Rred_7579 VSS.$4799.Metal3 VSS.$4835.Metal3 0.0729329633886
Rred_7580 VSS.$4802.Metal3 VSS.$4838.Metal3 0.0364664816945
Rred_7581 VSS.$4808.Metal3 VSS.$4844.Metal3 0.0729329633886
Rred_7582 VSS.$4835.Metal3 VSS.$4883.Metal3 0.0981480735474
Rred_7583 VSS.$4838.Metal3 VSS.$4862.Metal3 0.0241497604741
Rred_7584 VSS.$4844.Metal3 VSS.$4892.Metal3 0.0981480735474
Rred_7585 VSS.$4862.Metal3 VSS.$4886.Metal3 0.0241497604741
Rred_7586 VSS.$4883.Metal3 VSS.$4931.Metal3 0.0981511661222
Rred_7587 VSS.$4886.Metal3 VSS.$4910.Metal3 0.0241497604741
Rred_7588 VSS.$4892.Metal3 VSS.$4940.Metal3 0.0981511661222
Rred_7589 VSS.$4910.Metal3 VSS.$4934.Metal3 0.0241497604741
Rred_7590 VSS.$4931.Metal3 VSS.$4955.Metal3 0.0482995209481
Rred_7591 VSS.$4934.Metal3 VSS.$4958.Metal3 0.0241497604741
Rred_7592 VSS.$4940.Metal3 VSS.$4964.Metal3 0.0482995209481
Rred_7593 VSS.$4955.Metal3 VSS.$4991.Metal3 0.0729329633886
Rred_7594 VSS.$4958.Metal3 VSS.$4994.Metal3 0.0364664816945
Rred_7595 VSS.$4964.Metal3 VSS.$5000.Metal3 0.0729329633886
Rred_7596 VSS.$499.Metal1 VSS.$519.Metal1 0.0104033182853
Rred_7597 VSS.$499.Metal1 VSS.P2.pSD 11.3486133252
Rred_7598 VSS.$499.Metal1 VSS.P3.pSD 11.3486133252
Rred_7599 VSS.$4991.Metal3 VSS.$5027.Metal3 0.0729329633886
Rred_7600 VSS.$4994.Metal3 VSS.$5030.Metal3 0.0364664816945
Rred_7601 VSS.$5000.Metal3 VSS.$5036.Metal3 0.0729329633886
Rred_7602 VSS.$5027.Metal3 VSS.$5075.Metal3 0.0981511661222
Rred_7603 VSS.$5030.Metal3 VSS.$5054.Metal3 0.0241497604741
Rred_7604 VSS.$5036.Metal3 VSS.$5084.Metal3 0.0981511661222
Rred_7605 VSS.$504.Metal1 VSS.$544.Metal1 0.0503816845649
Rred_7606 VSS.$504.Metal1 VSS.P1.pSD 7.11445842696
Rred_7607 VSS.$5054.Metal3 VSS.$5078.Metal3 0.0241497604741
Rred_7608 VSS.$5075.Metal3 VSS.$5123.Metal3 0.0981480735474
Rred_7609 VSS.$5078.Metal3 VSS.$5102.Metal3 0.0241497604741
Rred_7610 VSS.$5084.Metal3 VSS.$5132.Metal3 0.0981480735474
Rred_7611 VSS.$5102.Metal3 VSS.$5126.Metal3 0.0241497604741
Rred_7612 VSS.$5123.Metal3 VSS.$5159.Metal3 0.0729329633886
Rred_7613 VSS.$5126.Metal3 VSS.$5162.Metal3 0.0364664816945
Rred_7614 VSS.$513.Metal1 VSS.$553.Metal1 0.0503816845649
Rred_7615 VSS.$513.Metal1 VSS.P0.pSD 7.11445842696
Rred_7616 VSS.$5132.Metal3 VSS.$5168.Metal3 0.0729329633886
Rred_7617 VSS.$5159.Metal3 VSS.$5183.Metal3 0.0482995209481
Rred_7618 VSS.$5162.Metal3 VSS.$5186.Metal3 0.0241497604741
Rred_7619 VSS.$5168.Metal3 VSS.$5192.Metal3 0.0482995209481
Rred_7620 VSS.$5183.Metal3 VSS.$5219.Metal3 0.0729329633886
Rred_7621 VSS.$5186.Metal3 VSS.$5222.Metal3 0.0364664816945
Rred_7622 VSS.$519.Metal1 VSS.$539.Metal1 0.0104068614969
Rred_7623 VSS.$519.Metal1 VSS.P2.pSD 17
Rred_7624 VSS.$519.Metal1 VSS.P3.pSD 17
Rred_7625 VSS.$5192.Metal3 VSS.$5228.Metal3 0.0729329633886
Rred_7626 VSS.$5219.Metal3 VSS.$5243.Metal3 0.0482995209481
Rred_7627 VSS.$5222.Metal3 VSS.$5234.Metal3 0.0120266666667
Rred_7628 VSS.$5228.Metal3 VSS.$5252.Metal3 0.0482995209481
Rred_7629 VSS.$5234.Metal3 VSS.$5246.Metal3 0.0120266666667
Rred_7630 VSS.$5243.Metal3 VSS.$5279.Metal3 0.0729316024848
Rred_7631 VSS.$5246.Metal3 VSS.$5258.Metal3 0.0120266666667
Rred_7632 VSS.$5252.Metal3 VSS.$5288.Metal3 0.0729316024848
Rred_7633 VSS.$5258.Metal3 VSS.$5270.Metal3 0.0120266666667
Rred_7634 VSS.$5270.Metal3 VSS.$5282.Metal3 0.0120266666667
Rred_7635 VSS.$5279.Metal3 VSS.$5282.Metal3 18346.4169973
Rred_7636 VSS.$5279.Metal3 VSS.$5288.Metal3 41259539.9573
Rred_7637 VSS.$5282.Metal3 VSS.$5288.Metal3 18346.4169973
Rred_7638 VSS.$539.Metal1 VSS.$559.Metal1 0.010404186219
Rred_7639 VSS.$539.Metal1 VSS.P2.pSD 17
Rred_7640 VSS.$539.Metal1 VSS.P3.pSD 17
Rred_7641 VSS.$544.Metal1 VSS.$564.Metal1 0.0327769863206
Rred_7642 VSS.$544.Metal1 VSS.P1.pSD 8.58558123775
Rred_7643 VSS.$553.Metal1 VSS.$566.Metal1 0.0327769863206
Rred_7644 VSS.$553.Metal1 VSS.P0.pSD 8.58558123775
Rred_7645 VSS.$559.Metal1 VSS.$565.Metal1 0.0131659822165
Rred_7646 VSS.$559.Metal1 VSS.P2.pSD 14.0627009151
Rred_7647 VSS.$559.Metal1 VSS.P3.pSD 14.0627009151
Rred_7648 VSS.$564.Metal1 VSS.$663.Metal1 0.0683250058824
Rred_7649 VSS.$564.Metal1 VSS.P1.pSD 7.04259645641
Rred_7650 VSS.$564.Metal1 VSS.P29.nSD 6.30788530775
Rred_7651 VSS.$565.Metal1 VSS.$618.Metal1 0.00763888888889
Rred_7652 VSS.$565.Metal1 VSS.P2.pSD 21.5305642393
Rred_7653 VSS.$565.Metal1 VSS.P3.pSD 21.5305642393
Rred_7654 VSS.$565.Metal1 VSS.P53.nSD 6.30881361412
Rred_7655 VSS.$565.Metal1 VSS.P77.nSD 6.30881361412
Rred_7656 VSS.$566.Metal1 VSS.$672.Metal1 0.0683250058824
Rred_7657 VSS.$566.Metal1 VSS.P0.pSD 7.04259645641
Rred_7658 VSS.$566.Metal1 VSS.P5.nSD 6.30788530775
Rred_7659 VSS.$618.Metal1 VSS.$638.Metal1 0.0103955116044
Rred_7660 VSS.$618.Metal1 VSS.P2.pSD 17
Rred_7661 VSS.$618.Metal1 VSS.P3.pSD 17
Rred_7662 VSS.$638.Metal1 VSS.$658.Metal1 0.0104042472994
Rred_7663 VSS.$638.Metal1 VSS.P2.pSD 17
Rred_7664 VSS.$638.Metal1 VSS.P3.pSD 17
Rred_7665 VSS.$658.Metal1 VSS.$678.Metal1 0.0104067900198
Rred_7666 VSS.$658.Metal1 VSS.P2.pSD 17
Rred_7667 VSS.$658.Metal1 VSS.P3.pSD 17
Rred_7668 VSS.$66.Metal1 VSS.P0.pSD 1.45104374835
Rred_7669 VSS.$663.Metal1 VSS.$731.Metal1 0.0762090520027
Rred_7670 VSS.$663.Metal1 VSS.P1.pSD 5.02273893954
Rred_7671 VSS.$672.Metal1 VSS.$740.Metal1 0.0762090520027
Rred_7672 VSS.$672.Metal1 VSS.P0.pSD 5.02273893954
Rred_7673 VSS.$678.Metal1 VSS.$698.Metal1 0.0104033759002
Rred_7674 VSS.$678.Metal1 VSS.P2.pSD 17
Rred_7675 VSS.$678.Metal1 VSS.P3.pSD 17
Rred_7676 VSS.$68.Metal1 VSS.P2.pSD 1.87782619881
Rred_7677 VSS.$68.Metal1 VSS.P3.pSD 1.87782619881
Rred_7678 VSS.$698.Metal1 VSS.$726.Metal1 0.0208620449569
Rred_7679 VSS.$698.Metal1 VSS.P2.pSD 11.3486133252
Rred_7680 VSS.$698.Metal1 VSS.P3.pSD 11.3486133252
Rred_7681 VSS.$726.Metal1 VSS.$757.Metal1 0.0103971187595
Rred_7682 VSS.$726.Metal1 VSS.P2.pSD 11.3468336065
Rred_7683 VSS.$726.Metal1 VSS.P3.pSD 11.3468336065
Rred_7684 VSS.$731.Metal1 VSS.$762.Metal1 0.0250630082153
Rred_7685 VSS.$731.Metal1 VSS.P1.pSD 6.90274731842
Rred_7686 VSS.$740.Metal1 VSS.$771.Metal1 0.0250630082153
Rred_7687 VSS.$740.Metal1 VSS.P0.pSD 6.90274731842
Rred_7688 VSS.$744.Metal1 VSS.$757.Metal1 0.00397329591049
Rred_7689 VSS.$744.Metal1 VSS.$817.Metal1 0.016851519775
Rred_7690 VSS.$744.Metal1 VSS.P2.pSD 27.5279211787
Rred_7691 VSS.$744.Metal1 VSS.P3.pSD 27.5279211787
Rred_7692 VSS.$744.Metal1 VSS.P55.nSD 6.30865895516
Rred_7693 VSS.$744.Metal1 VSS.P79.nSD 6.30865895516
Rred_7694 VSS.$757.Metal1 VSS.P2.pSD 17
Rred_7695 VSS.$757.Metal1 VSS.P3.pSD 17
Rred_7696 VSS.$762.Metal1 VSS.$774.Metal1 0.167409064586
Rred_7697 VSS.$762.Metal1 VSS.$822.Metal1 0.0506589847236
Rred_7698 VSS.$762.Metal1 VSS.P1.pSD 9.73144918941
Rred_7699 VSS.$771.Metal1 VSS.$785.Metal1 0.167409064586
Rred_7700 VSS.$771.Metal1 VSS.$831.Metal1 0.0506589847236
Rred_7701 VSS.$771.Metal1 VSS.P0.pSD 9.73144918941
Rred_7702 VSS.$774.Metal1 VSS.$822.Metal1 9.03177327646
Rred_7703 VSS.$774.Metal1 VSS.P1.pSD 2949.4084597
Rred_7704 VSS.$774.Metal1 VSS.P31.nSD 5.76848282367
Rred_7705 VSS.$785.Metal1 VSS.$831.Metal1 9.03177327646
Rred_7706 VSS.$785.Metal1 VSS.P0.pSD 2949.4084597
Rred_7707 VSS.$785.Metal1 VSS.P7.nSD 5.76848282367
Rred_7708 VSS.$817.Metal1 VSS.$837.Metal1 0.0104023263612
Rred_7709 VSS.$817.Metal1 VSS.P2.pSD 12.3119108098
Rred_7710 VSS.$817.Metal1 VSS.P3.pSD 12.3119108098
Rred_7711 VSS.$822.Metal1 VSS.$870.Metal1 0.0503803330447
Rred_7712 VSS.$822.Metal1 VSS.P1.pSD 7.07871769757
Rred_7713 VSS.$831.Metal1 VSS.$879.Metal1 0.0503803330447
Rred_7714 VSS.$831.Metal1 VSS.P0.pSD 7.07871769757
Rred_7715 VSS.$837.Metal1 VSS.$865.Metal1 0.0208622916459
Rred_7716 VSS.$837.Metal1 VSS.P2.pSD 11.3486579358
Rred_7717 VSS.$837.Metal1 VSS.P3.pSD 11.3486579358
Rred_7718 VSS.$865.Metal1 VSS.$885.Metal1 0.0103986066457
Rred_7719 VSS.$865.Metal1 VSS.P2.pSD 11.3475561438
Rred_7720 VSS.$865.Metal1 VSS.P3.pSD 11.3475561438
Rred_7721 VSS.$870.Metal1 VSS.$922.Metal1 0.0702143752481
Rred_7722 VSS.$870.Metal1 VSS.P1.pSD 5.88287853378
Rred_7723 VSS.$879.Metal1 VSS.$924.Metal1 0.0702143752481
Rred_7724 VSS.$879.Metal1 VSS.P0.pSD 5.88287853378
Rred_7725 VSS.$885.Metal1 VSS.$905.Metal1 0.0104056166409
Rred_7726 VSS.$885.Metal1 VSS.P2.pSD 17
Rred_7727 VSS.$885.Metal1 VSS.P3.pSD 17
Rred_7728 VSS.$905.Metal1 VSS.$936.Metal1 0.0104064271562
Rred_7729 VSS.$905.Metal1 VSS.P2.pSD 17
Rred_7730 VSS.$905.Metal1 VSS.P3.pSD 17
Rred_7731 VSS.$922.Metal1 VSS.$981.Metal1 0.0309221197347
Rred_7732 VSS.$922.Metal1 VSS.P1.pSD 7.38084443077
Rred_7733 VSS.$922.Metal1 VSS.P33.nSD 6.30803357837
Rred_7734 VSS.$923.Metal1 VSS.$936.Metal1 0.00519444444444
Rred_7735 VSS.$923.Metal1 VSS.$968.Metal1 0.00519887924383
Rred_7736 VSS.$923.Metal1 VSS.P57.nSD 6.30881361412
Rred_7737 VSS.$923.Metal1 VSS.P81.nSD 6.30881361412
Rred_7738 VSS.$924.Metal1 VSS.$990.Metal1 0.0309221197347
Rred_7739 VSS.$924.Metal1 VSS.P0.pSD 7.38084443077
Rred_7740 VSS.$924.Metal1 VSS.P10.nSD 6.30803357837
Rred_7741 VSS.$936.Metal1 VSS.P2.pSD 17
Rred_7742 VSS.$936.Metal1 VSS.P3.pSD 17
Rred_7743 VSS.$968.Metal1 VSS.$996.Metal1 0.0103899273095
Rred_7744 VSS.$968.Metal1 VSS.P2.pSD 17
Rred_7745 VSS.$968.Metal1 VSS.P3.pSD 17
Rred_7746 VSS.$981.Metal1 VSS.P1.pSD 8.20885719669
Rred_7747 VSS.$990.Metal1 VSS.P0.pSD 8.20885719669
Rred_7748 VSS.$996.Metal1 VSS.P2.pSD 11.3441704394
Rred_7749 VSS.$996.Metal1 VSS.P3.pSD 11.3441704394
Rred_7750 VSS.P0.nSD VSS.P1.nSD 1081.46283191
Rred_7751 VSS.P2.pSD VSS.P3.pSD 3487.56736558
Rred_7752 VSS.P21.nSD VSS.P23.nSD 1081.46283191
Rred_7753 VSS.P24.nSD VSS.P25.nSD 1081.46283191
Rred_7754 VSS.P45.nSD VSS.P47.nSD 1081.46283191
Rred_7755 VSS.P48.nSD VSS.P49.nSD 1048.11904075
Rred_7756 VSS.P51.nSD VSS.P75.nSD 2165028.68674
Rred_7757 VSS.P55.nSD VSS.P79.nSD 14998756.3449
Rred_7758 VSS.P59.nSD VSS.P83.nSD 2118765.7394
Rred_7759 VSS.P63.nSD VSS.P87.nSD 14998756.3449
Rred_7760 VSS.P67.nSD VSS.P91.nSD 2165028.68674
Rred_7761 VSS.P69.nSD VSS.P71.nSD 1048.11904075
Rred_7762 VSS.P72.nSD VSS.P73.nSD 1048.11904075
Rred_7763 VSS.P93.nSD VSS.P95.nSD 1048.11904075
.ENDS inverter_top_pex

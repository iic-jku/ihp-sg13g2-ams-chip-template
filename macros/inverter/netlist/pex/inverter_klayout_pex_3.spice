*********************************************************
*** NGSPICE file created by KLayout-PEX 0.9.0
*** -----------------------------------------------------
***     Extraction Engine: KPEX/2.5D
***     Technology: ihp_sg13g2
***     Date: 2026-11-13 08:58:51
*********************************************************

.SUBCKT inverter_pex VDD vin vout VSS
X$1 VSS.P1.nSD VSS.P0.GatPoly VSS.P0.nSD VSS sg13_lv_nmos w=1e-06 l=1e-06
+ as=3.4e-13 ad=1.9e-13 ps=2.68e-06 pd=1.38e-06
X$2 vout.P0.nSD vin.P0.GatPoly VSS.P1.nSD VSS sg13_lv_nmos w=1e-06 l=1e-06
+ as=1.9e-13 ad=1.9e-13 ps=1.38e-06 pd=1.38e-06
X$3 VSS.P3.nSD vin.P1.GatPoly vout.P0.nSD VSS sg13_lv_nmos w=1e-06 l=1e-06
+ as=1.9e-13 ad=1.9e-13 ps=1.38e-06 pd=1.38e-06
X$4 vout.P2.nSD vin.P2.GatPoly VSS.P3.nSD VSS sg13_lv_nmos w=1e-06 l=1e-06
+ as=1.9e-13 ad=1.9e-13 ps=1.38e-06 pd=1.38e-06
X$5 VSS.P5.nSD vin.P3.GatPoly vout.P2.nSD VSS sg13_lv_nmos w=1e-06 l=1e-06
+ as=1.9e-13 ad=1.9e-13 ps=1.38e-06 pd=1.38e-06
X$6 vout.P4.nSD vin.P4.GatPoly VSS.P5.nSD VSS sg13_lv_nmos w=1e-06 l=1e-06
+ as=1.9e-13 ad=1.9e-13 ps=1.38e-06 pd=1.38e-06
X$7 VSS.P7.nSD vin.P5.GatPoly vout.P4.nSD VSS sg13_lv_nmos w=1e-06 l=1e-06
+ as=1.9e-13 ad=1.9e-13 ps=1.38e-06 pd=1.38e-06
X$8 vout.P6.nSD vin.P6.GatPoly VSS.P7.nSD VSS sg13_lv_nmos w=1e-06 l=1e-06
+ as=1.9e-13 ad=1.9e-13 ps=1.38e-06 pd=1.38e-06
X$9 VSS.P10.nSD vin.P7.GatPoly vout.P6.nSD VSS sg13_lv_nmos w=1e-06 l=1e-06
+ as=1.9e-13 ad=1.9e-13 ps=1.38e-06 pd=1.38e-06
X$10 vout.P8.nSD vin.P8.GatPoly VSS.P10.nSD VSS sg13_lv_nmos w=1e-06 l=1e-06
+ as=1.9e-13 ad=1.9e-13 ps=1.38e-06 pd=1.38e-06
X$11 VSS.P11.nSD vin.P9.GatPoly vout.P8.nSD VSS sg13_lv_nmos w=1e-06 l=1e-06
+ as=1.9e-13 ad=1.9e-13 ps=1.38e-06 pd=1.38e-06
X$12 vout.P10.nSD vin.P10.GatPoly VSS.P11.nSD VSS sg13_lv_nmos w=1e-06 l=1e-06
+ as=1.9e-13 ad=1.9e-13 ps=1.38e-06 pd=1.38e-06
X$13 VSS.P13.nSD vin.P11.GatPoly vout.P10.nSD VSS sg13_lv_nmos w=1e-06 l=1e-06
+ as=1.9e-13 ad=1.9e-13 ps=1.38e-06 pd=1.38e-06
X$14 vout.P12.nSD vin.P12.GatPoly VSS.P13.nSD VSS sg13_lv_nmos w=1e-06 l=1e-06
+ as=1.9e-13 ad=1.9e-13 ps=1.38e-06 pd=1.38e-06
X$15 VSS.P15.nSD vin.P13.GatPoly vout.P12.nSD VSS sg13_lv_nmos w=1e-06 l=1e-06
+ as=1.9e-13 ad=1.9e-13 ps=1.38e-06 pd=1.38e-06
X$16 vout.P14.nSD vin.P14.GatPoly VSS.P15.nSD VSS sg13_lv_nmos w=1e-06 l=1e-06
+ as=1.9e-13 ad=1.9e-13 ps=1.38e-06 pd=1.38e-06
X$17 VSS.P17.nSD vin.P15.GatPoly vout.P14.nSD VSS sg13_lv_nmos w=1e-06 l=1e-06
+ as=1.9e-13 ad=1.9e-13 ps=1.38e-06 pd=1.38e-06
X$18 vout.P16.nSD vin.P16.GatPoly VSS.P17.nSD VSS sg13_lv_nmos w=1e-06 l=1e-06
+ as=1.9e-13 ad=1.9e-13 ps=1.38e-06 pd=1.38e-06
X$19 VSS.P19.nSD vin.P17.GatPoly vout.P16.nSD VSS sg13_lv_nmos w=1e-06 l=1e-06
+ as=1.9e-13 ad=1.9e-13 ps=1.38e-06 pd=1.38e-06
X$20 vout.P18.nSD vin.P18.GatPoly VSS.P19.nSD VSS sg13_lv_nmos w=1e-06 l=1e-06
+ as=1.9e-13 ad=1.9e-13 ps=1.38e-06 pd=1.38e-06
X$21 VSS.P21.nSD vin.P19.GatPoly vout.P18.nSD VSS sg13_lv_nmos w=1e-06 l=1e-06
+ as=1.9e-13 ad=1.9e-13 ps=1.38e-06 pd=1.38e-06
X$22 VSS.P23.nSD VSS.P1.GatPoly VSS.P21.nSD VSS sg13_lv_nmos w=1e-06 l=1e-06
+ as=1.9e-13 ad=3.4e-13 ps=1.38e-06 pd=2.68e-06
X$23 VSS.P0.pSD VSS ptap1
X$24 VDD.P1.pSD VDD.P0.GatPoly VDD.P0.pSD \$I57 sg13_lv_pmos w=6e-06 l=1e-06
+ as=2.04e-12 ad=1.14e-12 ps=1.268e-05 pd=6.38e-06
X$25 vout.P0.pSD vin.P20.GatPoly VDD.P1.pSD \$I57 sg13_lv_pmos w=6e-06 l=1e-06
+ as=1.14e-12 ad=1.14e-12 ps=6.38e-06 pd=6.38e-06
X$26 VDD.P3.pSD vin.P21.GatPoly vout.P0.pSD \$I57 sg13_lv_pmos w=6e-06 l=1e-06
+ as=1.14e-12 ad=1.14e-12 ps=6.38e-06 pd=6.38e-06
X$27 vout.P2.pSD vin.P22.GatPoly VDD.P3.pSD \$I57 sg13_lv_pmos w=6e-06 l=1e-06
+ as=1.14e-12 ad=1.14e-12 ps=6.38e-06 pd=6.38e-06
X$28 VDD.P5.pSD vin.P23.GatPoly vout.P2.pSD \$I57 sg13_lv_pmos w=6e-06 l=1e-06
+ as=1.14e-12 ad=1.14e-12 ps=6.38e-06 pd=6.38e-06
X$29 vout.P4.pSD vin.P24.GatPoly VDD.P5.pSD \$I57 sg13_lv_pmos w=6e-06 l=1e-06
+ as=1.14e-12 ad=1.14e-12 ps=6.38e-06 pd=6.38e-06
X$30 VDD.P7.pSD vin.P25.GatPoly vout.P4.pSD \$I57 sg13_lv_pmos w=6e-06 l=1e-06
+ as=1.14e-12 ad=1.14e-12 ps=6.38e-06 pd=6.38e-06
X$31 vout.P6.pSD vin.P26.GatPoly VDD.P7.pSD \$I57 sg13_lv_pmos w=6e-06 l=1e-06
+ as=1.14e-12 ad=1.14e-12 ps=6.38e-06 pd=6.38e-06
X$32 VDD.P10.pSD vin.P27.GatPoly vout.P6.pSD \$I57 sg13_lv_pmos w=6e-06 l=1e-06
+ as=1.14e-12 ad=1.14e-12 ps=6.38e-06 pd=6.38e-06
X$33 vout.P8.pSD vin.P28.GatPoly VDD.P10.pSD \$I57 sg13_lv_pmos w=6e-06 l=1e-06
+ as=1.14e-12 ad=1.14e-12 ps=6.38e-06 pd=6.38e-06
X$34 VDD.P11.pSD vin.P29.GatPoly vout.P8.pSD \$I57 sg13_lv_pmos w=6e-06 l=1e-06
+ as=1.14e-12 ad=1.14e-12 ps=6.38e-06 pd=6.38e-06
X$35 vout.P10.pSD vin.P30.GatPoly VDD.P11.pSD \$I57 sg13_lv_pmos w=6e-06
+ l=1e-06 as=1.14e-12 ad=1.14e-12 ps=6.38e-06 pd=6.38e-06
X$36 VDD.P13.pSD vin.P31.GatPoly vout.P10.pSD \$I57 sg13_lv_pmos w=6e-06
+ l=1e-06 as=1.14e-12 ad=1.14e-12 ps=6.38e-06 pd=6.38e-06
X$37 vout.P12.pSD vin.P32.GatPoly VDD.P13.pSD \$I57 sg13_lv_pmos w=6e-06
+ l=1e-06 as=1.14e-12 ad=1.14e-12 ps=6.38e-06 pd=6.38e-06
X$38 VDD.P15.pSD vin.P33.GatPoly vout.P12.pSD \$I57 sg13_lv_pmos w=6e-06
+ l=1e-06 as=1.14e-12 ad=1.14e-12 ps=6.38e-06 pd=6.38e-06
X$39 vout.P14.pSD vin.P34.GatPoly VDD.P15.pSD \$I57 sg13_lv_pmos w=6e-06
+ l=1e-06 as=1.14e-12 ad=1.14e-12 ps=6.38e-06 pd=6.38e-06
X$40 VDD.P17.pSD vin.P35.GatPoly vout.P14.pSD \$I57 sg13_lv_pmos w=6e-06
+ l=1e-06 as=1.14e-12 ad=1.14e-12 ps=6.38e-06 pd=6.38e-06
X$41 vout.P16.pSD vin.P36.GatPoly VDD.P17.pSD \$I57 sg13_lv_pmos w=6e-06
+ l=1e-06 as=1.14e-12 ad=1.14e-12 ps=6.38e-06 pd=6.38e-06
X$42 VDD.P19.pSD vin.P37.GatPoly vout.P16.pSD \$I57 sg13_lv_pmos w=6e-06
+ l=1e-06 as=1.14e-12 ad=1.14e-12 ps=6.38e-06 pd=6.38e-06
X$43 vout.P18.pSD vin.P38.GatPoly VDD.P19.pSD \$I57 sg13_lv_pmos w=6e-06
+ l=1e-06 as=1.14e-12 ad=1.14e-12 ps=6.38e-06 pd=6.38e-06
X$44 VDD.P21.pSD vin.P39.GatPoly vout.P18.pSD \$I57 sg13_lv_pmos w=6e-06
+ l=1e-06 as=1.14e-12 ad=1.14e-12 ps=6.38e-06 pd=6.38e-06
X$45 VDD.P23.pSD VDD.P1.GatPoly VDD.P21.pSD \$I57 sg13_lv_pmos w=6e-06 l=1e-06
+ as=1.14e-12 ad=2.04e-12 ps=6.38e-06 pd=1.268e-05
X$46 VDD.P0.nSD \$I57 ntap1
* netlist reduce (TICER tau=0.1ps max degree 5, floating max degree 64): 4920 R, 10355 C, 2974 nodes -> 2076 R, 7820 C, 616 nodes
Cred_1 \$I57 VDD 0.00271052f
Cred_2 \$I57 VDD.$100.Metal1 0.14442f
Cred_3 \$I57 VDD.$1000.Metal1 0.00543125f
Cred_4 \$I57 VDD.$1001.Metal1 0.00546095f
Cred_5 \$I57 VDD.$1002.Metal1 0.0326817f
Cred_6 \$I57 VDD.$1003.Metal1 0.0402152f
Cred_7 \$I57 VDD.$1004.Metal1 0.0109279f
Cred_8 \$I57 VDD.$1005.Metal1 0.0110337f
Cred_9 \$I57 VDD.$1006.Metal1 0.0122547f
Cred_10 \$I57 VDD.$1007.Metal1 0.0211132f
Cred_11 \$I57 VDD.$1056.Metal2 0.00798689f
Cred_12 \$I57 VDD.$1065.Metal2 0.0236961f
Cred_13 \$I57 VDD.$1068.Metal2 0.00365637f
Cred_14 \$I57 VDD.$1070.Metal2 0.00292576f
Cred_15 \$I57 VDD.$1072.Metal2 0.00292023f
Cred_16 \$I57 VDD.$1074.Metal2 0.00219825f
Cred_17 \$I57 VDD.$1075.Metal2 0.0101514f
Cred_18 \$I57 VDD.$1110.Metal2 0.000531099f
Cred_19 \$I57 VDD.$1137.Metal2 0.00385243f
Cred_20 \$I57 VDD.$1149.Metal2 0.00485208f
Cred_21 \$I57 VDD.$1161.Metal2 0.0033223f
Cred_22 \$I57 VDD.$1167.Metal2 0.0095864f
Cred_23 \$I57 VDD.$1188.Metal2 0.0138401f
Cred_24 \$I57 VDD.$1214.Metal2 0.00457031f
Cred_25 \$I57 VDD.$1226.Metal2 0.00448248f
Cred_26 \$I57 VDD.$1253.Metal2 0.0159273f
Cred_27 \$I57 VDD.$1273.Metal2 0.00766519f
Cred_28 \$I57 VDD.$1285.Metal2 0.00470331f
Cred_29 \$I57 VDD.$1297.Metal2 0.004164f
Cred_30 \$I57 VDD.$130.Metal1 0.0448177f
Cred_31 \$I57 VDD.$131.Metal1 0.00545925f
Cred_32 \$I57 VDD.$132.Metal1 0.00561277f
Cred_33 \$I57 VDD.$1324.Metal2 0.0200002f
Cred_34 \$I57 VDD.$133.Metal1 0.00558038f
Cred_35 \$I57 VDD.$134.Metal1 0.00543125f
Cred_36 \$I57 VDD.$1344.Metal2 0.0020704f
Cred_37 \$I57 VDD.$135.Metal1 0.00546095f
Cred_38 \$I57 VDD.$1350.Metal2 0.00341898f
Cred_39 \$I57 VDD.$136.Metal1 0.0326817f
Cred_40 \$I57 VDD.$1362.Metal2 0.00472919f
Cred_41 \$I57 VDD.$137.Metal1 0.0402152f
Cred_42 \$I57 VDD.$1374.Metal2 0.00607053f
Cred_43 \$I57 VDD.$138.Metal1 0.0109279f
Cred_44 \$I57 VDD.$139.Metal1 0.0110337f
Cred_45 \$I57 VDD.$1395.Metal2 0.0174099f
Cred_46 \$I57 VDD.$140.Metal1 0.0122547f
Cred_47 \$I57 VDD.$141.Metal1 0.0211132f
Cred_48 \$I57 VDD.$142.Metal1 0.0215639f
Cred_49 \$I57 VDD.$1421.Metal2 0.00440278f
Cred_50 \$I57 VDD.$1433.Metal2 0.00463935f
Cred_51 \$I57 VDD.$1460.Metal2 0.0120136f
Cred_52 \$I57 VDD.$1480.Metal2 0.012013f
Cred_53 \$I57 VDD.$1492.Metal2 0.00463906f
Cred_54 \$I57 VDD.$1504.Metal2 0.00440278f
Cred_55 \$I57 VDD.$152.Metal1 0.0185186f
Cred_56 \$I57 VDD.$1531.Metal2 0.0174099f
Cred_57 \$I57 VDD.$1551.Metal2 0.00607053f
Cred_58 \$I57 VDD.$1563.Metal2 0.00472919f
Cred_59 \$I57 VDD.$1575.Metal2 0.00341898f
Cred_60 \$I57 VDD.$1581.Metal2 0.0020704f
Cred_61 \$I57 VDD.$1602.Metal2 0.0200002f
Cred_62 \$I57 VDD.$1628.Metal2 0.004164f
Cred_63 \$I57 VDD.$164.Metal1 0.0239983f
Cred_64 \$I57 VDD.$1640.Metal2 0.00470331f
Cred_65 \$I57 VDD.$1652.Metal2 0.00766519f
Cred_66 \$I57 VDD.$1673.Metal2 0.0159273f
Cred_67 \$I57 VDD.$1699.Metal2 0.00448248f
Cred_68 \$I57 VDD.$1711.Metal2 0.00458291f
Cred_69 \$I57 VDD.$1738.Metal2 0.0138432f
Cred_70 \$I57 VDD.$1758.Metal2 0.0106063f
Cred_71 \$I57 VDD.$177.Metal1 0.0520533f
Cred_72 \$I57 VDD.$1770.Metal2 0.00339001f
Cred_73 \$I57 VDD.$1776.Metal2 0.00378805f
Cred_74 \$I57 VDD.$1788.Metal2 0.00385243f
Cred_75 \$I57 VDD.$1803.Metal2 0.0236961f
Cred_76 \$I57 VDD.$1806.Metal2 0.00365637f
Cred_77 \$I57 VDD.$1808.Metal2 0.00292576f
Cred_78 \$I57 VDD.$1810.Metal2 0.00292023f
Cred_79 \$I57 VDD.$1812.Metal2 0.00219825f
Cred_80 \$I57 VDD.$1813.Metal2 0.0101514f
Cred_81 \$I57 VDD.$1815.Metal2 0.000531103f
Cred_82 \$I57 VDD.$1822.Metal2 0.00798689f
Cred_83 \$I57 VDD.$1884.Metal3 0.00227856f
Cred_84 \$I57 VDD.$1896.Metal3 0.00422929f
Cred_85 \$I57 VDD.$1902.Metal3 0.00369886f
Cred_86 \$I57 VDD.$1914.Metal3 0.00278548f
Cred_87 \$I57 VDD.$1920.Metal3 0.00461386f
Cred_88 \$I57 VDD.$1932.Metal3 0.00278484f
Cred_89 \$I57 VDD.$1941.Metal3 0.0041762f
Cred_90 \$I57 VDD.$1947.Metal3 0.00300342f
Cred_91 \$I57 VDD.$1959.Metal3 0.00511708f
Cred_92 \$I57 VDD.$1968.Metal3 0.00277228f
Cred_93 \$I57 VDD.$1980.Metal3 0.00560307f
Cred_94 \$I57 VDD.$2001.Metal3 0.00558448f
Cred_95 \$I57 VDD.$2013.Metal3 0.00277228f
Cred_96 \$I57 VDD.$2022.Metal3 0.00511708f
Cred_97 \$I57 VDD.$2034.Metal3 0.00300342f
Cred_98 \$I57 VDD.$2040.Metal3 0.0041762f
Cred_99 \$I57 VDD.$2049.Metal3 0.00278484f
Cred_100 \$I57 VDD.$2061.Metal3 0.00540131f
Cred_101 \$I57 VDD.$2070.Metal3 0.00158122f
Cred_102 \$I57 VDD.$2076.Metal3 0.0032767f
Cred_103 \$I57 VDD.$2085.Metal3 0.00504837f
Cred_104 \$I57 VDD.$2097.Metal3 0.00227856f
Cred_105 \$I57 VDD.$230.Metal1 0.0188467f
Cred_106 \$I57 VDD.$242.Metal1 0.0191783f
Cred_107 \$I57 VDD.$252.Metal1 0.0190959f
Cred_108 \$I57 VDD.$257.Metal1 0.0463099f
Cred_109 \$I57 VDD.$315.Metal1 0.0190258f
Cred_110 \$I57 VDD.$325.Metal1 0.0193299f
Cred_111 \$I57 VDD.$337.Metal1 0.0309992f
Cred_112 \$I57 VDD.$376.Metal1 0.0162618f
Cred_113 \$I57 VDD.$393.Metal1 0.0299236f
Cred_114 \$I57 VDD.$403.Metal1 0.0195544f
Cred_115 \$I57 VDD.$415.Metal1 0.0180486f
Cred_116 \$I57 VDD.$423.Metal1 0.0499548f
Cred_117 \$I57 VDD.$476.Metal1 0.0164902f
Cred_118 \$I57 VDD.$488.Metal1 0.0189056f
Cred_119 \$I57 VDD.$498.Metal1 0.0137482f
Cred_120 \$I57 VDD.$518.Metal1 0.0284809f
Cred_121 \$I57 VDD.$554.Metal1 0.0284809f
Cred_122 \$I57 VDD.$561.Metal1 0.0137482f
Cred_123 \$I57 VDD.$571.Metal1 0.0189056f
Cred_124 \$I57 VDD.$581.Metal1 0.0164902f
Cred_125 \$I57 VDD.$586.Metal1 0.0499548f
Cred_126 \$I57 VDD.$644.Metal1 0.0180486f
Cred_127 \$I57 VDD.$656.Metal1 0.0195544f
Cred_128 \$I57 VDD.$666.Metal1 0.0299236f
Cred_129 \$I57 VDD.$7.Metal1 0.0181857f
Cred_130 \$I57 VDD.$702.Metal1 0.0162618f
Cred_131 \$I57 VDD.$722.Metal1 0.0309992f
Cred_132 \$I57 VDD.$734.Metal1 0.0193299f
Cred_133 \$I57 VDD.$744.Metal1 0.0190258f
Cred_134 \$I57 VDD.$754.Metal1 0.0463099f
Cred_135 \$I57 VDD.$807.Metal1 0.0190959f
Cred_136 \$I57 VDD.$817.Metal1 0.0191783f
Cred_137 \$I57 VDD.$829.Metal1 0.0188468f
Cred_138 \$I57 VDD.$834.Metal1 0.0462737f
Cred_139 \$I57 VDD.$890.Metal1 0.0248625f
Cred_140 \$I57 VDD.$907.Metal1 0.0234068f
Cred_141 \$I57 VDD.$917.Metal1 0.0215639f
Cred_142 \$I57 VDD.$920.Metal1 0.0181857f
Cred_143 \$I57 VDD.$940.Metal1 0.0448177f
Cred_144 \$I57 VDD.$941.Metal1 0.00545925f
Cred_145 \$I57 VDD.$942.Metal1 0.00561277f
Cred_146 \$I57 VDD.$943.Metal1 0.00558038f
Cred_147 \$I57 VDD.$95.Metal1 0.00605547f
Cred_148 \$I57 VDD.$954.Metal1 0.127196f
Cred_149 \$I57 VDD.$965.Metal1 0.00605547f
Cred_150 \$I57 VDD.P0.GatPoly 0.0717755f
Cred_151 \$I57 VDD.P0.nSD 0.494446f
Cred_152 \$I57 VDD.P0.pSD 0.000455958f
Cred_153 \$I57 VDD.P1.GatPoly 0.068081f
Cred_154 \$I57 VDD.P1.pSD 0.000455958f
Cred_155 \$I57 VDD.P10.pSD 0.00176981f
Cred_156 \$I57 VDD.P11.pSD 0.00188001f
Cred_157 \$I57 VDD.P13.pSD 0.00176981f
Cred_158 \$I57 VDD.P15.pSD 0.000679721f
Cred_159 \$I57 VDD.P17.pSD 0.00177478f
Cred_160 \$I57 VDD.P19.pSD 0.00180255f
Cred_161 \$I57 VDD.P21.pSD 0.000455958f
Cred_162 \$I57 VDD.P23.pSD 0.000455958f
Cred_163 \$I57 VDD.P3.pSD 0.00180255f
Cred_164 \$I57 VDD.P5.pSD 0.00177478f
Cred_165 \$I57 VDD.P7.pSD 0.000679721f
Cred_166 \$I57 vin 0.0156061f
Cred_167 \$I57 vin.$10.GatPoly 0.00187135f
Cred_168 \$I57 vin.$102.GatPoly 0.00209038f
Cred_169 \$I57 vin.$105.GatPoly 0.0394527f
Cred_170 \$I57 vin.$107.GatPoly 0.0347266f
Cred_171 \$I57 vin.$108.GatPoly 0.00161526f
Cred_172 \$I57 vin.$110.GatPoly 0.0019005f
Cred_173 \$I57 vin.$115.GatPoly 0.046052f
Cred_174 \$I57 vin.$118.GatPoly 0.00218197f
Cred_175 \$I57 vin.$122.GatPoly 0.00221263f
Cred_176 \$I57 vin.$123.GatPoly 0.047458f
Cred_177 \$I57 vin.$127.GatPoly 0.034098f
Cred_178 \$I57 vin.$130.GatPoly 0.00215085f
Cred_179 \$I57 vin.$133.GatPoly 0.0343914f
Cred_180 \$I57 vin.$134.GatPoly 0.00195466f
Cred_181 \$I57 vin.$136.GatPoly 0.0018188f
Cred_182 \$I57 vin.$139.GatPoly 0.0408654f
Cred_183 \$I57 vin.$144.GatPoly 0.00226845f
Cred_184 \$I57 vin.$145.GatPoly 0.0483142f
Cred_185 \$I57 vin.$15.GatPoly 0.0354345f
Cred_186 \$I57 vin.$152.GatPoly 0.00231382f
Cred_187 \$I57 vin.$153.GatPoly 0.0480778f
Cred_188 \$I57 vin.$156.GatPoly 0.0022411f
Cred_189 \$I57 vin.$157.GatPoly 0.0348624f
Cred_190 \$I57 vin.$16.GatPoly 0.00202454f
Cred_191 \$I57 vin.$163.GatPoly 0.0375323f
Cred_192 \$I57 vin.$164.GatPoly 0.00221542f
Cred_193 \$I57 vin.$167.GatPoly 0.0354345f
Cred_194 \$I57 vin.$17.GatPoly 0.0362878f
Cred_195 \$I57 vin.$172.GatPoly 0.00202454f
Cred_196 \$I57 vin.$173.GatPoly 0.0362878f
Cred_197 \$I57 vin.$176.GatPoly 0.00187135f
Cred_198 \$I57 vin.$179.GatPoly 0.0589132f
Cred_199 \$I57 vin.$180.GatPoly 0.00248506f
Cred_200 \$I57 vin.$199.Metal1 0.104412f
Cred_201 \$I57 vin.$202.Metal1 0.00190525f
Cred_202 \$I57 vin.$207.Metal1 0.00936437f
Cred_203 \$I57 vin.$210.Metal1 0.000222197f
Cred_204 \$I57 vin.$211.Metal1 0.00971314f
Cred_205 \$I57 vin.$218.Metal1 0.000239156f
Cred_206 \$I57 vin.$219.Metal1 0.00587479f
Cred_207 \$I57 vin.$22.GatPoly 0.00221542f
Cred_208 \$I57 vin.$222.Metal1 0.000332495f
Cred_209 \$I57 vin.$227.Metal1 0.0130132f
Cred_210 \$I57 vin.$228.Metal1 0.000272556f
Cred_211 \$I57 vin.$232.Metal1 8.93619e-05f
Cred_212 \$I57 vin.$233.Metal1 0.00217431f
Cred_213 \$I57 vin.$236.Metal1 0.000375631f
Cred_214 \$I57 vin.$237.Metal1 0.00662845f
Cred_215 \$I57 vin.$24.GatPoly 0.0022411f
Cred_216 \$I57 vin.$240.Metal1 0.000376367f
Cred_217 \$I57 vin.$241.Metal1 0.0101019f
Cred_218 \$I57 vin.$246.Metal1 0.000256985f
Cred_219 \$I57 vin.$247.Metal1 0.00783791f
Cred_220 \$I57 vin.$25.GatPoly 0.0348624f
Cred_221 \$I57 vin.$250.Metal1 0.000323075f
Cred_222 \$I57 vin.$251.Metal1 0.00760957f
Cred_223 \$I57 vin.$258.Metal1 0.000293399f
Cred_224 \$I57 vin.$259.Metal1 0.00931762f
Cred_225 \$I57 vin.$262.Metal1 0.000161874f
Cred_226 \$I57 vin.$263.Metal1 0.00778279f
Cred_227 \$I57 vin.$264.Metal1 0.000216641f
Cred_228 \$I57 vin.$269.Metal1 0.00781493f
Cred_229 \$I57 vin.$27.GatPoly 0.0375323f
Cred_230 \$I57 vin.$272.Metal1 0.000230649f
Cred_231 \$I57 vin.$277.Metal1 0.00326355f
Cred_232 \$I57 vin.$280.Metal1 0.000381284f
Cred_233 \$I57 vin.$281.Metal1 0.00546468f
Cred_234 \$I57 vin.$284.Metal1 0.00038142f
Cred_235 \$I57 vin.$285.Metal1 0.0089922f
Cred_236 \$I57 vin.$290.Metal1 0.00020553f
Cred_237 \$I57 vin.$291.Metal1 0.00688446f
Cred_238 \$I57 vin.$295.Metal1 0.00842845f
Cred_239 \$I57 vin.$298.Metal1 0.000381509f
Cred_240 \$I57 vin.$302.Metal1 0.000381509f
Cred_241 \$I57 vin.$303.Metal1 0.00913208f
Cred_242 \$I57 vin.$307.Metal1 0.004918f
Cred_243 \$I57 vin.$312.Metal1 0.000230649f
Cred_244 \$I57 vin.$313.Metal1 0.00358592f
Cred_245 \$I57 vin.$317.Metal1 0.00805587f
Cred_246 \$I57 vin.$320.Metal1 0.000218137f
Cred_247 \$I57 vin.$321.Metal1 0.00398433f
Cred_248 \$I57 vin.$325.Metal1 0.00541196f
Cred_249 \$I57 vin.$328.Metal1 0.000230649f
Cred_250 \$I57 vin.$329.Metal1 0.00869119f
Cred_251 \$I57 vin.$334.Metal1 0.000297425f
Cred_252 \$I57 vin.$335.Metal1 0.00427146f
Cred_253 \$I57 vin.$338.Metal1 0.000291646f
Cred_254 \$I57 vin.$339.Metal1 0.00398433f
Cred_255 \$I57 vin.$343.Metal1 0.00805587f
Cred_256 \$I57 vin.$346.Metal1 0.000230649f
Cred_257 \$I57 vin.$347.Metal1 0.00358592f
Cred_258 \$I57 vin.$353.Metal1 0.004918f
Cred_259 \$I57 vin.$356.Metal1 0.000381509f
Cred_260 \$I57 vin.$357.Metal1 0.00913208f
Cred_261 \$I57 vin.$36.GatPoly 0.00231382f
Cred_262 \$I57 vin.$360.Metal1 0.000381509f
Cred_263 \$I57 vin.$365.Metal1 0.00842845f
Cred_264 \$I57 vin.$368.Metal1 0.00020553f
Cred_265 \$I57 vin.$369.Metal1 0.00688446f
Cred_266 \$I57 vin.$37.GatPoly 0.0480778f
Cred_267 \$I57 vin.$374.Metal1 0.00038142f
Cred_268 \$I57 vin.$375.Metal1 0.0089922f
Cred_269 \$I57 vin.$378.Metal1 0.000381284f
Cred_270 \$I57 vin.$379.Metal1 0.00546468f
Cred_271 \$I57 vin.$383.Metal1 0.00326355f
Cred_272 \$I57 vin.$386.Metal1 0.000230649f
Cred_273 \$I57 vin.$391.Metal1 0.00781493f
Cred_274 \$I57 vin.$392.Metal1 0.000216641f
Cred_275 \$I57 vin.$396.Metal1 0.000161874f
Cred_276 \$I57 vin.$397.Metal1 0.00778279f
Cred_277 \$I57 vin.$400.Metal1 0.000293399f
Cred_278 \$I57 vin.$401.Metal1 0.00931762f
Cred_279 \$I57 vin.$408.Metal1 0.000323075f
Cred_280 \$I57 vin.$409.Metal1 0.00760957f
Cred_281 \$I57 vin.$412.Metal1 0.000256985f
Cred_282 \$I57 vin.$413.Metal1 0.00783791f
Cred_283 \$I57 vin.$418.Metal1 0.000376367f
Cred_284 \$I57 vin.$419.Metal1 0.0101019f
Cred_285 \$I57 vin.$42.GatPoly 0.00226845f
Cred_286 \$I57 vin.$422.Metal1 0.000375631f
Cred_287 \$I57 vin.$423.Metal1 0.00662845f
Cred_288 \$I57 vin.$426.Metal1 8.93619e-05f
Cred_289 \$I57 vin.$427.Metal1 0.00217431f
Cred_290 \$I57 vin.$43.GatPoly 0.0483142f
Cred_291 \$I57 vin.$430.Metal1 0.000272556f
Cred_292 \$I57 vin.$433.Metal1 0.0130132f
Cred_293 \$I57 vin.$437.Metal1 0.000332495f
Cred_294 \$I57 vin.$44.GatPoly 0.0018188f
Cred_295 \$I57 vin.$440.Metal1 0.000239156f
Cred_296 \$I57 vin.$441.Metal1 0.00587479f
Cred_297 \$I57 vin.$448.Metal1 0.000222197f
Cred_298 \$I57 vin.$449.Metal1 0.00970289f
Cred_299 \$I57 vin.$453.Metal1 0.00934743f
Cred_300 \$I57 vin.$456.Metal1 0.00188965f
Cred_301 \$I57 vin.$457.Metal1 0.0796752f
Cred_302 \$I57 vin.$476.Metal2 0.0026672f
Cred_303 \$I57 vin.$478.Metal2 0.0270245f
Cred_304 \$I57 vin.$481.Metal2 1.63756e-05f
Cred_305 \$I57 vin.$482.Metal2 0.00428228f
Cred_306 \$I57 vin.$486.Metal2 0.0116159f
Cred_307 \$I57 vin.$489.Metal2 0.00667057f
Cred_308 \$I57 vin.$493.Metal2 0.00520917f
Cred_309 \$I57 vin.$495.Metal2 0.0121437f
Cred_310 \$I57 vin.$500.Metal2 0.00505366f
Cred_311 \$I57 vin.$504.Metal2 0.00590336f
Cred_312 \$I57 vin.$506.Metal2 0.0113501f
Cred_313 \$I57 vin.$509.Metal2 0.0040564f
Cred_314 \$I57 vin.$51.GatPoly 0.0408654f
Cred_315 \$I57 vin.$513.Metal2 0.00413162f
Cred_316 \$I57 vin.$515.Metal2 0.0112555f
Cred_317 \$I57 vin.$518.Metal2 0.00467555f
Cred_318 \$I57 vin.$52.GatPoly 0.00195466f
Cred_319 \$I57 vin.$520.Metal2 0.00300643f
Cred_320 \$I57 vin.$524.Metal2 0.00703491f
Cred_321 \$I57 vin.$526.Metal2 0.0107547f
Cred_322 \$I57 vin.$529.Metal2 0.00282594f
Cred_323 \$I57 vin.$533.Metal2 0.00538299f
Cred_324 \$I57 vin.$535.Metal2 0.0113025f
Cred_325 \$I57 vin.$538.Metal2 0.00448294f
Cred_326 \$I57 vin.$542.Metal2 0.00370062f
Cred_327 \$I57 vin.$544.Metal2 0.0112687f
Cred_328 \$I57 vin.$547.Metal2 0.00632344f
Cred_329 \$I57 vin.$55.GatPoly 0.0343914f
Cred_330 \$I57 vin.$551.Metal2 0.00490891f
Cred_331 \$I57 vin.$555.Metal2 0.0120747f
Cred_332 \$I57 vin.$558.Metal2 0.0051112f
Cred_333 \$I57 vin.$562.Metal2 0.00495834f
Cred_334 \$I57 vin.$564.Metal2 0.0114413f
Cred_335 \$I57 vin.$567.Metal2 0.00497152f
Cred_336 \$I57 vin.$57.GatPoly 0.034098f
Cred_337 \$I57 vin.$571.Metal2 0.0051112f
Cred_338 \$I57 vin.$573.Metal2 0.0120747f
Cred_339 \$I57 vin.$578.Metal2 0.00490891f
Cred_340 \$I57 vin.$58.GatPoly 0.00215085f
Cred_341 \$I57 vin.$582.Metal2 0.00632344f
Cred_342 \$I57 vin.$584.Metal2 0.0112687f
Cred_343 \$I57 vin.$587.Metal2 0.00370062f
Cred_344 \$I57 vin.$591.Metal2 0.00448294f
Cred_345 \$I57 vin.$593.Metal2 0.0113025f
Cred_346 \$I57 vin.$596.Metal2 0.00538299f
Cred_347 \$I57 vin.$6.GatPoly 0.00248558f
Cred_348 \$I57 vin.$600.Metal2 0.00282594f
Cred_349 \$I57 vin.$602.Metal2 0.0107547f
Cred_350 \$I57 vin.$605.Metal2 0.00703491f
Cred_351 \$I57 vin.$609.Metal2 0.00300643f
Cred_352 \$I57 vin.$611.Metal2 0.00467555f
Cred_353 \$I57 vin.$613.Metal2 0.0112555f
Cred_354 \$I57 vin.$616.Metal2 0.00413162f
Cred_355 \$I57 vin.$620.Metal2 0.0040564f
Cred_356 \$I57 vin.$622.Metal2 0.0113501f
Cred_357 \$I57 vin.$625.Metal2 0.00590336f
Cred_358 \$I57 vin.$629.Metal2 0.00505366f
Cred_359 \$I57 vin.$633.Metal2 0.0121437f
Cred_360 \$I57 vin.$636.Metal2 0.00520917f
Cred_361 \$I57 vin.$64.GatPoly 0.00221263f
Cred_362 \$I57 vin.$640.Metal2 0.00530213f
Cred_363 \$I57 vin.$642.Metal2 0.0217144f
Cred_364 \$I57 vin.$645.Metal2 0.00462726f
Cred_365 \$I57 vin.$648.Metal2 0.000720861f
Cred_366 \$I57 vin.$649.Metal2 0.00671721f
Cred_367 \$I57 vin.$65.GatPoly 0.047458f
Cred_368 \$I57 vin.$653.Metal2 0.00494529f
Cred_369 \$I57 vin.$654.Metal2 0.0265873f
Cred_370 \$I57 vin.$7.GatPoly 0.0550221f
Cred_371 \$I57 vin.$70.GatPoly 0.00218197f
Cred_372 \$I57 vin.$73.GatPoly 0.046052f
Cred_373 \$I57 vin.$77.GatPoly 0.0347266f
Cred_374 \$I57 vin.$78.GatPoly 0.0019005f
Cred_375 \$I57 vin.$80.GatPoly 0.00161526f
Cred_376 \$I57 vin.$83.GatPoly 0.0394527f
Cred_377 \$I57 vin.$84.GatPoly 0.00195139f
Cred_378 \$I57 vin.$87.GatPoly 0.0411501f
Cred_379 \$I57 vin.$9.GatPoly 0.0351072f
Cred_380 \$I57 vin.$90.GatPoly 0.00190669f
Cred_381 \$I57 vin.$94.GatPoly 0.00210131f
Cred_382 \$I57 vin.$95.GatPoly 0.0393997f
Cred_383 \$I57 vin.$97.GatPoly 0.0344233f
Cred_384 \$I57 vin.P0.GatPoly 0.00165878f
Cred_385 \$I57 vin.P1.GatPoly 0.000468416f
Cred_386 \$I57 vin.P10.GatPoly 0.000655459f
Cred_387 \$I57 vin.P12.GatPoly 0.000303549f
Cred_388 \$I57 vin.P13.GatPoly 0.000262544f
Cred_389 \$I57 vin.P15.GatPoly 0.000681508f
Cred_390 \$I57 vin.P17.GatPoly 0.000705818f
Cred_391 \$I57 vin.P18.GatPoly 0.000468416f
Cred_392 \$I57 vin.P19.GatPoly 0.00165836f
Cred_393 \$I57 vin.P2.GatPoly 0.000705818f
Cred_394 \$I57 vin.P20.GatPoly 0.0846876f
Cred_395 \$I57 vin.P21.GatPoly 0.0486028f
Cred_396 \$I57 vin.P22.GatPoly 0.0486028f
Cred_397 \$I57 vin.P23.GatPoly 0.0486028f
Cred_398 \$I57 vin.P24.GatPoly 0.053166f
Cred_399 \$I57 vin.P25.GatPoly 0.0524783f
Cred_400 \$I57 vin.P26.GatPoly 0.0486028f
Cred_401 \$I57 vin.P27.GatPoly 0.0532657f
Cred_402 \$I57 vin.P28.GatPoly 0.0486028f
Cred_403 \$I57 vin.P29.GatPoly 0.0486028f
Cred_404 \$I57 vin.P30.GatPoly 0.0486028f
Cred_405 \$I57 vin.P31.GatPoly 0.0486028f
Cred_406 \$I57 vin.P32.GatPoly 0.0532657f
Cred_407 \$I57 vin.P33.GatPoly 0.0486028f
Cred_408 \$I57 vin.P34.GatPoly 0.0524783f
Cred_409 \$I57 vin.P35.GatPoly 0.053166f
Cred_410 \$I57 vin.P36.GatPoly 0.0486028f
Cred_411 \$I57 vin.P37.GatPoly 0.0486028f
Cred_412 \$I57 vin.P38.GatPoly 0.0486028f
Cred_413 \$I57 vin.P39.GatPoly 0.0678302f
Cred_414 \$I57 vin.P4.GatPoly 0.000681508f
Cred_415 \$I57 vin.P6.GatPoly 0.000262544f
Cred_416 \$I57 vin.P7.GatPoly 0.000303549f
Cred_417 \$I57 vin.P9.GatPoly 0.000257147f
Cred_418 \$I57 vout 0.0406507f
Cred_419 \$I57 vout.$1226.Metal3 0.0717956f
Cred_420 \$I57 vout.$1292.Metal3 0.0386617f
Cred_421 \$I57 vout.$1358.Metal3 0.0388025f
Cred_422 \$I57 vout.$1424.Metal3 0.0295424f
Cred_423 \$I57 vout.P0.nSD 0.0010213f
Cred_424 \$I57 vout.P0.pSD 0.0110229f
Cred_425 \$I57 vout.P10.nSD 0.000149057f
Cred_426 \$I57 vout.P10.pSD 0.0051644f
Cred_427 \$I57 vout.P12.pSD 0.00435709f
Cred_428 \$I57 vout.P14.nSD 0.000149057f
Cred_429 \$I57 vout.P14.pSD 0.0051644f
Cred_430 \$I57 vout.P16.pSD 0.00435709f
Cred_431 \$I57 vout.P18.pSD 0.00531792f
Cred_432 \$I57 vout.P2.nSD 0.00067105f
Cred_433 \$I57 vout.P2.pSD 0.00811751f
Cred_434 \$I57 vout.P4.pSD 0.00445006f
Cred_435 \$I57 vout.P6.nSD 0.000148306f
Cred_436 \$I57 vout.P6.pSD 0.00526059f
Cred_437 \$I57 vout.P8.pSD 0.00445006f
Cred_438 \$I57 VSS.$1040.Metal2 1.47239e-05f
Cred_439 \$I57 VSS.$1055.Metal2 4.34256e-05f
Cred_440 \$I57 VSS.$1066.Metal2 0.0123458f
Cred_441 \$I57 VSS.$1100.Metal3 0.00693376f
Cred_442 \$I57 VSS.$1112.Metal3 0.000898077f
Cred_443 \$I57 VSS.$1301.Metal3 0.000898077f
Cred_444 \$I57 VSS.$1313.Metal3 0.00693376f
Cred_445 \$I57 VSS.$18.Metal1 0.00679143f
Cred_446 \$I57 VSS.$40.Metal1 0.00312745f
Cred_447 \$I57 VSS.$44.Metal1 8.92498e-07f
Cred_448 \$I57 VSS.$498.Metal1 6.0365e-08f
Cred_449 \$I57 VSS.$501.Metal1 1.35996e-06f
Cred_450 \$I57 VSS.$509.Metal1 0.000716466f
Cred_451 \$I57 VSS.$520.Metal1 2.27976e-07f
Cred_452 \$I57 VSS.$551.Metal1 0.0100814f
Cred_453 \$I57 VSS.$564.Metal2 0.00856761f
Cred_454 \$I57 VSS.$590.Metal2 4.3427e-05f
Cred_455 \$I57 VSS.$605.Metal2 1.47239e-05f
Cred_456 \$I57 VSS.$65.Metal1 6.0365e-08f
Cred_457 \$I57 VSS.P0.GatPoly 0.00325334f
Cred_458 \$I57 VSS.P0.nSD 2.08918e-06f
Cred_459 \$I57 VSS.P0.pSD 0.163188f
Cred_460 \$I57 VSS.P1.GatPoly 0.00325334f
Cred_461 \$I57 VSS.P1.nSD 2.08918e-06f
Cred_462 \$I57 VSS.P21.nSD 3.02577e-06f
Cred_463 \$I57 VSS.P23.nSD 3.02577e-06f
Cred_464 VSS VDD 0.0438203f
Cred_465 VSS VDD.$100.Metal1 0.0527109f
Cred_466 VSS VDD.$1000.Metal1 1.67949e-05f
Cred_467 VSS VDD.$1001.Metal1 3.26872e-06f
Cred_468 VSS VDD.$1002.Metal1 0.0435299f
Cred_469 VSS VDD.$1003.Metal1 0.056562f
Cred_470 VSS VDD.$1004.Metal1 0.011336f
Cred_471 VSS VDD.$1005.Metal1 0.0116121f
Cred_472 VSS VDD.$1006.Metal1 0.0119213f
Cred_473 VSS VDD.$1007.Metal1 0.014611f
Cred_474 VSS VDD.$1056.Metal2 0.114715f
Cred_475 VSS VDD.$1065.Metal2 0.0799457f
Cred_476 VSS VDD.$1068.Metal2 0.0319887f
Cred_477 VSS VDD.$1070.Metal2 0.0256199f
Cred_478 VSS VDD.$1072.Metal2 0.0256237f
Cred_479 VSS VDD.$1074.Metal2 0.0192275f
Cred_480 VSS VDD.$1075.Metal2 0.0271606f
Cred_481 VSS VDD.$1110.Metal2 0.0512395f
Cred_482 VSS VDD.$1137.Metal2 0.0291927f
Cred_483 VSS VDD.$1149.Metal2 0.0286377f
Cred_484 VSS VDD.$1161.Metal2 0.0217453f
Cred_485 VSS VDD.$1167.Metal2 0.0146671f
Cred_486 VSS VDD.$1188.Metal2 0.0216005f
Cred_487 VSS VDD.$1214.Metal2 0.0286377f
Cred_488 VSS VDD.$1226.Metal2 0.0288406f
Cred_489 VSS VDD.$1253.Metal2 0.0216842f
Cred_490 VSS VDD.$1273.Metal2 0.0215287f
Cred_491 VSS VDD.$1285.Metal2 0.0287399f
Cred_492 VSS VDD.$1297.Metal2 0.0286377f
Cred_493 VSS VDD.$130.Metal1 0.00121295f
Cred_494 VSS VDD.$131.Metal1 4.8992e-05f
Cred_495 VSS VDD.$132.Metal1 1.63642e-05f
Cred_496 VSS VDD.$1324.Metal2 0.0216455f
Cred_497 VSS VDD.$133.Metal1 1.22577e-05f
Cred_498 VSS VDD.$134.Metal1 1.67949e-05f
Cred_499 VSS VDD.$1344.Metal2 0.0144856f
Cred_500 VSS VDD.$135.Metal1 3.26872e-06f
Cred_501 VSS VDD.$1350.Metal2 0.021655f
Cred_502 VSS VDD.$136.Metal1 0.0435299f
Cred_503 VSS VDD.$1362.Metal2 0.0287398f
Cred_504 VSS VDD.$137.Metal1 0.056562f
Cred_505 VSS VDD.$1374.Metal2 0.0215353f
Cred_506 VSS VDD.$138.Metal1 0.011336f
Cred_507 VSS VDD.$139.Metal1 0.0116121f
Cred_508 VSS VDD.$1395.Metal2 0.0216718f
Cred_509 VSS VDD.$140.Metal1 0.0119213f
Cred_510 VSS VDD.$141.Metal1 0.014611f
Cred_511 VSS VDD.$142.Metal1 0.0668939f
Cred_512 VSS VDD.$1421.Metal2 0.0288406f
Cred_513 VSS VDD.$1433.Metal2 0.0288001f
Cred_514 VSS VDD.$1460.Metal2 0.0215385f
Cred_515 VSS VDD.$1480.Metal2 0.0215288f
Cred_516 VSS VDD.$1492.Metal2 0.0287952f
Cred_517 VSS VDD.$1504.Metal2 0.0288406f
Cred_518 VSS VDD.$152.Metal1 0.0653752f
Cred_519 VSS VDD.$1531.Metal2 0.0216718f
Cred_520 VSS VDD.$1551.Metal2 0.0215353f
Cred_521 VSS VDD.$1563.Metal2 0.0287398f
Cred_522 VSS VDD.$1575.Metal2 0.021655f
Cred_523 VSS VDD.$1581.Metal2 0.0144856f
Cred_524 VSS VDD.$1602.Metal2 0.0216455f
Cred_525 VSS VDD.$1628.Metal2 0.0286377f
Cred_526 VSS VDD.$164.Metal1 0.0761779f
Cred_527 VSS VDD.$1640.Metal2 0.0287399f
Cred_528 VSS VDD.$1652.Metal2 0.0215287f
Cred_529 VSS VDD.$1673.Metal2 0.0216842f
Cred_530 VSS VDD.$1699.Metal2 0.0288406f
Cred_531 VSS VDD.$1711.Metal2 0.0287398f
Cred_532 VSS VDD.$1738.Metal2 0.0214986f
Cred_533 VSS VDD.$1758.Metal2 0.0215168f
Cred_534 VSS VDD.$177.Metal1 0.0607852f
Cred_535 VSS VDD.$1770.Metal2 0.0217392f
Cred_536 VSS VDD.$1776.Metal2 0.0217393f
Cred_537 VSS VDD.$1788.Metal2 0.0291927f
Cred_538 VSS VDD.$1803.Metal2 0.0799457f
Cred_539 VSS VDD.$1806.Metal2 0.0319887f
Cred_540 VSS VDD.$1808.Metal2 0.0256199f
Cred_541 VSS VDD.$1810.Metal2 0.0256237f
Cred_542 VSS VDD.$1812.Metal2 0.0192275f
Cred_543 VSS VDD.$1813.Metal2 0.0271606f
Cred_544 VSS VDD.$1815.Metal2 0.0512419f
Cred_545 VSS VDD.$1822.Metal2 0.114714f
Cred_546 VSS VDD.$1884.Metal3 0.12538f
Cred_547 VSS VDD.$1896.Metal3 0.0384479f
Cred_548 VSS VDD.$1902.Metal3 0.0384182f
Cred_549 VSS VDD.$1914.Metal3 0.0384182f
Cred_550 VSS VDD.$1920.Metal3 0.0384465f
Cred_551 VSS VDD.$1932.Metal3 0.0447912f
Cred_552 VSS VDD.$1941.Metal3 0.032149f
Cred_553 VSS VDD.$1947.Metal3 0.0384182f
Cred_554 VSS VDD.$1959.Metal3 0.0448006f
Cred_555 VSS VDD.$1968.Metal3 0.0447912f
Cred_556 VSS VDD.$1980.Metal3 0.048591f
Cred_557 VSS VDD.$2001.Metal3 0.0482905f
Cred_558 VSS VDD.$2013.Metal3 0.0447912f
Cred_559 VSS VDD.$2022.Metal3 0.0448006f
Cred_560 VSS VDD.$2034.Metal3 0.0384182f
Cred_561 VSS VDD.$2040.Metal3 0.032149f
Cred_562 VSS VDD.$2049.Metal3 0.0447912f
Cred_563 VSS VDD.$2061.Metal3 0.044829f
Cred_564 VSS VDD.$2070.Metal3 0.0321112f
Cred_565 VSS VDD.$2076.Metal3 0.0321301f
Cred_566 VSS VDD.$2085.Metal3 0.0448115f
Cred_567 VSS VDD.$2097.Metal3 0.125381f
Cred_568 VSS VDD.$230.Metal1 0.0588464f
Cred_569 VSS VDD.$242.Metal1 0.0653691f
Cred_570 VSS VDD.$252.Metal1 0.0567147f
Cred_571 VSS VDD.$257.Metal1 0.0442695f
Cred_572 VSS VDD.$315.Metal1 0.0624526f
Cred_573 VSS VDD.$325.Metal1 0.0653691f
Cred_574 VSS VDD.$337.Metal1 0.064228f
Cred_575 VSS VDD.$376.Metal1 0.00238302f
Cred_576 VSS VDD.$393.Metal1 0.0640832f
Cred_577 VSS VDD.$403.Metal1 0.0653718f
Cred_578 VSS VDD.$415.Metal1 0.0632452f
Cred_579 VSS VDD.$423.Metal1 0.0449693f
Cred_580 VSS VDD.$476.Metal1 0.0552315f
Cred_581 VSS VDD.$488.Metal1 0.0653692f
Cred_582 VSS VDD.$498.Metal1 0.0490842f
Cred_583 VSS VDD.$518.Metal1 0.032739f
Cred_584 VSS VDD.$554.Metal1 0.032739f
Cred_585 VSS VDD.$561.Metal1 0.0490842f
Cred_586 VSS VDD.$571.Metal1 0.0653692f
Cred_587 VSS VDD.$581.Metal1 0.0552315f
Cred_588 VSS VDD.$586.Metal1 0.0449693f
Cred_589 VSS VDD.$644.Metal1 0.0632452f
Cred_590 VSS VDD.$656.Metal1 0.0653718f
Cred_591 VSS VDD.$666.Metal1 0.0640832f
Cred_592 VSS VDD.$7.Metal1 0.170483f
Cred_593 VSS VDD.$702.Metal1 0.00238302f
Cred_594 VSS VDD.$722.Metal1 0.064228f
Cred_595 VSS VDD.$734.Metal1 0.0653691f
Cred_596 VSS VDD.$744.Metal1 0.0624526f
Cred_597 VSS VDD.$754.Metal1 0.0442695f
Cred_598 VSS VDD.$807.Metal1 0.0567147f
Cred_599 VSS VDD.$817.Metal1 0.0653691f
Cred_600 VSS VDD.$829.Metal1 0.0588468f
Cred_601 VSS VDD.$834.Metal1 0.0436229f
Cred_602 VSS VDD.$890.Metal1 0.0770891f
Cred_603 VSS VDD.$907.Metal1 0.0814973f
Cred_604 VSS VDD.$917.Metal1 0.0668939f
Cred_605 VSS VDD.$920.Metal1 0.170544f
Cred_606 VSS VDD.$940.Metal1 0.00121295f
Cred_607 VSS VDD.$941.Metal1 4.8992e-05f
Cred_608 VSS VDD.$942.Metal1 1.63642e-05f
Cred_609 VSS VDD.$943.Metal1 1.22577e-05f
Cred_610 VSS VDD.$95.Metal1 0.0514212f
Cred_611 VSS VDD.$954.Metal1 0.0527109f
Cred_612 VSS VDD.$965.Metal1 0.0513587f
Cred_613 VSS VDD.P0.GatPoly 0.0104968f
Cred_614 VSS VDD.P0.nSD 0.458699f
Cred_615 VSS VDD.P0.pSD 1.44825e-05f
Cred_616 VSS VDD.P1.GatPoly 0.0104968f
Cred_617 VSS VDD.P1.pSD 1.44825e-05f
Cred_618 VSS VDD.P21.pSD 1.44825e-05f
Cred_619 VSS VDD.P23.pSD 1.44825e-05f
Cred_620 VSS vin 0.0316088f
Cred_621 VSS vin.$10.GatPoly 0.0412404f
Cred_622 VSS vin.$102.GatPoly 0.0474579f
Cred_623 VSS vin.$105.GatPoly 0.00471984f
Cred_624 VSS vin.$107.GatPoly 0.00372194f
Cred_625 VSS vin.$108.GatPoly 0.032479f
Cred_626 VSS vin.$110.GatPoly 0.038912f
Cred_627 VSS vin.$115.GatPoly 0.00541043f
Cred_628 VSS vin.$118.GatPoly 0.0446869f
Cred_629 VSS vin.$122.GatPoly 0.0500585f
Cred_630 VSS vin.$123.GatPoly 0.0055245f
Cred_631 VSS vin.$127.GatPoly 0.00368824f
Cred_632 VSS vin.$130.GatPoly 0.042876f
Cred_633 VSS vin.$133.GatPoly 0.00402384f
Cred_634 VSS vin.$134.GatPoly 0.0446987f
Cred_635 VSS vin.$136.GatPoly 0.0401314f
Cred_636 VSS vin.$139.GatPoly 0.00493038f
Cred_637 VSS vin.$144.GatPoly 0.0509512f
Cred_638 VSS vin.$145.GatPoly 0.00563999f
Cred_639 VSS vin.$15.GatPoly 0.00401297f
Cred_640 VSS vin.$152.GatPoly 0.0514271f
Cred_641 VSS vin.$153.GatPoly 0.00556598f
Cred_642 VSS vin.$156.GatPoly 0.0486503f
Cred_643 VSS vin.$157.GatPoly 0.00389019f
Cred_644 VSS vin.$16.GatPoly 0.0438957f
Cred_645 VSS vin.$163.GatPoly 0.00439885f
Cred_646 VSS vin.$164.GatPoly 0.0504331f
Cred_647 VSS vin.$167.GatPoly 0.00401297f
Cred_648 VSS vin.$17.GatPoly 0.00430007f
Cred_649 VSS vin.$172.GatPoly 0.0438957f
Cred_650 VSS vin.$173.GatPoly 0.00430007f
Cred_651 VSS vin.$176.GatPoly 0.0412405f
Cred_652 VSS vin.$179.GatPoly 0.00683124f
Cred_653 VSS vin.$180.GatPoly 0.0564178f
Cred_654 VSS vin.$199.Metal1 0.00629228f
Cred_655 VSS vin.$202.Metal1 0.0694966f
Cred_656 VSS vin.$207.Metal1 0.000870897f
Cred_657 VSS vin.$210.Metal1 0.0124208f
Cred_658 VSS vin.$211.Metal1 0.000870897f
Cred_659 VSS vin.$218.Metal1 0.0112539f
Cred_660 VSS vin.$219.Metal1 0.000583166f
Cred_661 VSS vin.$22.GatPoly 0.0504331f
Cred_662 VSS vin.$222.Metal1 0.011958f
Cred_663 VSS vin.$227.Metal1 0.0011807f
Cred_664 VSS vin.$228.Metal1 0.0114261f
Cred_665 VSS vin.$232.Metal1 0.00606566f
Cred_666 VSS vin.$233.Metal1 0.000132767f
Cred_667 VSS vin.$236.Metal1 0.0114185f
Cred_668 VSS vin.$237.Metal1 0.00081967f
Cred_669 VSS vin.$24.GatPoly 0.0486503f
Cred_670 VSS vin.$240.Metal1 0.0140643f
Cred_671 VSS vin.$241.Metal1 0.00085064f
Cred_672 VSS vin.$246.Metal1 0.0112516f
Cred_673 VSS vin.$247.Metal1 0.000761638f
Cred_674 VSS vin.$25.GatPoly 0.00389019f
Cred_675 VSS vin.$250.Metal1 0.0118971f
Cred_676 VSS vin.$251.Metal1 0.000809484f
Cred_677 VSS vin.$258.Metal1 0.0118136f
Cred_678 VSS vin.$259.Metal1 0.000841941f
Cred_679 VSS vin.$262.Metal1 0.00734266f
Cred_680 VSS vin.$263.Metal1 0.000797671f
Cred_681 VSS vin.$264.Metal1 0.00968448f
Cred_682 VSS vin.$269.Metal1 0.000526517f
Cred_683 VSS vin.$27.GatPoly 0.00439885f
Cred_684 VSS vin.$272.Metal1 0.0130314f
Cred_685 VSS vin.$277.Metal1 0.000270143f
Cred_686 VSS vin.$280.Metal1 0.0142319f
Cred_687 VSS vin.$281.Metal1 0.0007286f
Cred_688 VSS vin.$284.Metal1 0.0139312f
Cred_689 VSS vin.$285.Metal1 0.000814628f
Cred_690 VSS vin.$290.Metal1 0.0121092f
Cred_691 VSS vin.$291.Metal1 0.000775713f
Cred_692 VSS vin.$295.Metal1 0.000797229f
Cred_693 VSS vin.$298.Metal1 0.0149848f
Cred_694 VSS vin.$302.Metal1 0.0150914f
Cred_695 VSS vin.$303.Metal1 0.000732782f
Cred_696 VSS vin.$307.Metal1 0.000725069f
Cred_697 VSS vin.$310.Metal1 0.00666114f
Cred_698 VSS vin.$312.Metal1 0.0106803f
Cred_699 VSS vin.$313.Metal1 0.000203177f
Cred_700 VSS vin.$317.Metal1 0.000751998f
Cred_701 VSS vin.$320.Metal1 0.012354f
Cred_702 VSS vin.$321.Metal1 0.000570215f
Cred_703 VSS vin.$325.Metal1 0.000614761f
Cred_704 VSS vin.$328.Metal1 0.0128933f
Cred_705 VSS vin.$329.Metal1 0.000769613f
Cred_706 VSS vin.$334.Metal1 0.0116593f
Cred_707 VSS vin.$335.Metal1 0.000389582f
Cred_708 VSS vin.$338.Metal1 0.0114706f
Cred_709 VSS vin.$339.Metal1 0.000570215f
Cred_710 VSS vin.$343.Metal1 0.000751998f
Cred_711 VSS vin.$346.Metal1 0.0106803f
Cred_712 VSS vin.$347.Metal1 0.000203177f
Cred_713 VSS vin.$348.Metal1 0.00666114f
Cred_714 VSS vin.$353.Metal1 0.000725069f
Cred_715 VSS vin.$356.Metal1 0.0150914f
Cred_716 VSS vin.$357.Metal1 0.000732782f
Cred_717 VSS vin.$36.GatPoly 0.0514271f
Cred_718 VSS vin.$360.Metal1 0.0149848f
Cred_719 VSS vin.$365.Metal1 0.000797229f
Cred_720 VSS vin.$368.Metal1 0.0121092f
Cred_721 VSS vin.$369.Metal1 0.000775713f
Cred_722 VSS vin.$37.GatPoly 0.00556598f
Cred_723 VSS vin.$374.Metal1 0.0139312f
Cred_724 VSS vin.$375.Metal1 0.000814628f
Cred_725 VSS vin.$378.Metal1 0.0142319f
Cred_726 VSS vin.$379.Metal1 0.0007286f
Cred_727 VSS vin.$383.Metal1 0.000270143f
Cred_728 VSS vin.$386.Metal1 0.0130314f
Cred_729 VSS vin.$391.Metal1 0.000526517f
Cred_730 VSS vin.$392.Metal1 0.00968448f
Cred_731 VSS vin.$396.Metal1 0.00734266f
Cred_732 VSS vin.$397.Metal1 0.000797671f
Cred_733 VSS vin.$400.Metal1 0.0118136f
Cred_734 VSS vin.$401.Metal1 0.000841941f
Cred_735 VSS vin.$408.Metal1 0.0118971f
Cred_736 VSS vin.$409.Metal1 0.000809484f
Cred_737 VSS vin.$412.Metal1 0.0112516f
Cred_738 VSS vin.$413.Metal1 0.000761638f
Cred_739 VSS vin.$418.Metal1 0.0140643f
Cred_740 VSS vin.$419.Metal1 0.00085064f
Cred_741 VSS vin.$42.GatPoly 0.0509512f
Cred_742 VSS vin.$422.Metal1 0.0114185f
Cred_743 VSS vin.$423.Metal1 0.00081967f
Cred_744 VSS vin.$426.Metal1 0.00606566f
Cred_745 VSS vin.$427.Metal1 0.000132767f
Cred_746 VSS vin.$43.GatPoly 0.00563999f
Cred_747 VSS vin.$430.Metal1 0.0114261f
Cred_748 VSS vin.$433.Metal1 0.0011807f
Cred_749 VSS vin.$437.Metal1 0.011958f
Cred_750 VSS vin.$44.GatPoly 0.0401314f
Cred_751 VSS vin.$440.Metal1 0.0112539f
Cred_752 VSS vin.$441.Metal1 0.000583166f
Cred_753 VSS vin.$448.Metal1 0.012424f
Cred_754 VSS vin.$449.Metal1 0.000870897f
Cred_755 VSS vin.$453.Metal1 0.000870897f
Cred_756 VSS vin.$456.Metal1 0.0684805f
Cred_757 VSS vin.$457.Metal1 0.00810796f
Cred_758 VSS vin.$476.Metal2 0.0458882f
Cred_759 VSS vin.$478.Metal2 0.0118611f
Cred_760 VSS vin.$481.Metal2 0.00649703f
Cred_761 VSS vin.$483.Metal2 0.00606617f
Cred_762 VSS vin.$486.Metal2 0.0177891f
Cred_763 VSS vin.$488.Metal2 0.00955834f
Cred_764 VSS vin.$492.Metal2 0.00628182f
Cred_765 VSS vin.$493.Metal2 9.67152e-06f
Cred_766 VSS vin.$495.Metal2 0.0171181f
Cred_767 VSS vin.$497.Metal2 0.014658f
Cred_768 VSS vin.$503.Metal2 0.0124485f
Cred_769 VSS vin.$506.Metal2 0.0180858f
Cred_770 VSS vin.$508.Metal2 0.00781651f
Cred_771 VSS vin.$51.GatPoly 0.00493038f
Cred_772 VSS vin.$512.Metal2 0.00796155f
Cred_773 VSS vin.$515.Metal2 0.0181303f
Cred_774 VSS vin.$517.Metal2 0.0122169f
Cred_775 VSS vin.$52.GatPoly 0.0446987f
Cred_776 VSS vin.$523.Metal2 0.015031f
Cred_777 VSS vin.$526.Metal2 0.0169469f
Cred_778 VSS vin.$528.Metal2 0.00613575f
Cred_779 VSS vin.$532.Metal2 0.00970609f
Cred_780 VSS vin.$535.Metal2 0.0182267f
Cred_781 VSS vin.$537.Metal2 0.00845707f
Cred_782 VSS vin.$541.Metal2 0.0107115f
Cred_783 VSS vin.$544.Metal2 0.0196746f
Cred_784 VSS vin.$548.Metal2 0.010226f
Cred_785 VSS vin.$55.GatPoly 0.00402384f
Cred_786 VSS vin.$551.Metal2 3.72491e-06f
Cred_787 VSS vin.$552.Metal2 0.0122465f
Cred_788 VSS vin.$555.Metal2 0.0175395f
Cred_789 VSS vin.$557.Metal2 0.00674023f
Cred_790 VSS vin.$561.Metal2 0.00907184f
Cred_791 VSS vin.$564.Metal2 0.0182726f
Cred_792 VSS vin.$566.Metal2 0.0090817f
Cred_793 VSS vin.$57.GatPoly 0.00368824f
Cred_794 VSS vin.$570.Metal2 0.0067251f
Cred_795 VSS vin.$573.Metal2 0.0175395f
Cred_796 VSS vin.$575.Metal2 0.0122465f
Cred_797 VSS vin.$578.Metal2 3.72491e-06f
Cred_798 VSS vin.$579.Metal2 0.010226f
Cred_799 VSS vin.$58.GatPoly 0.042876f
Cred_800 VSS vin.$584.Metal2 0.0196746f
Cred_801 VSS vin.$586.Metal2 0.0107115f
Cred_802 VSS vin.$590.Metal2 0.00845707f
Cred_803 VSS vin.$593.Metal2 0.0182267f
Cred_804 VSS vin.$595.Metal2 0.00970609f
Cred_805 VSS vin.$599.Metal2 0.00613575f
Cred_806 VSS vin.$6.GatPoly 0.0566493f
Cred_807 VSS vin.$602.Metal2 0.0169469f
Cred_808 VSS vin.$604.Metal2 0.015031f
Cred_809 VSS vin.$610.Metal2 0.0122169f
Cred_810 VSS vin.$613.Metal2 0.0181303f
Cred_811 VSS vin.$615.Metal2 0.00796155f
Cred_812 VSS vin.$619.Metal2 0.00781651f
Cred_813 VSS vin.$622.Metal2 0.0180858f
Cred_814 VSS vin.$624.Metal2 0.0124485f
Cred_815 VSS vin.$630.Metal2 0.014658f
Cred_816 VSS vin.$633.Metal2 0.0171181f
Cred_817 VSS vin.$635.Metal2 0.00628182f
Cred_818 VSS vin.$636.Metal2 9.67152e-06f
Cred_819 VSS vin.$639.Metal2 0.00955834f
Cred_820 VSS vin.$64.GatPoly 0.0500585f
Cred_821 VSS vin.$642.Metal2 0.0396781f
Cred_822 VSS vin.$644.Metal2 0.00861136f
Cred_823 VSS vin.$648.Metal2 0.0120016f
Cred_824 VSS vin.$649.Metal2 0.00213371f
Cred_825 VSS vin.$65.GatPoly 0.0055245f
Cred_826 VSS vin.$653.Metal2 0.042661f
Cred_827 VSS vin.$654.Metal2 0.0152272f
Cred_828 VSS vin.$7.GatPoly 0.00521627f
Cred_829 VSS vin.$70.GatPoly 0.0446869f
Cred_830 VSS vin.$73.GatPoly 0.00541043f
Cred_831 VSS vin.$77.GatPoly 0.00372194f
Cred_832 VSS vin.$78.GatPoly 0.038912f
Cred_833 VSS vin.$80.GatPoly 0.032479f
Cred_834 VSS vin.$83.GatPoly 0.00471984f
Cred_835 VSS vin.$84.GatPoly 0.0449057f
Cred_836 VSS vin.$87.GatPoly 0.00448662f
Cred_837 VSS vin.$9.GatPoly 0.0041642f
Cred_838 VSS vin.$90.GatPoly 0.0376289f
Cred_839 VSS vin.$94.GatPoly 0.0477467f
Cred_840 VSS vin.$95.GatPoly 0.0047093f
Cred_841 VSS vin.$97.GatPoly 0.00368241f
Cred_842 VSS vin.P0.GatPoly 0.105879f
Cred_843 VSS vin.P1.GatPoly 0.0706767f
Cred_844 VSS vin.P10.GatPoly 0.0763447f
Cred_845 VSS vin.P11.GatPoly 0.0643087f
Cred_846 VSS vin.P12.GatPoly 0.0697338f
Cred_847 VSS vin.P13.GatPoly 0.0693924f
Cred_848 VSS vin.P14.GatPoly 0.0615393f
Cred_849 VSS vin.P15.GatPoly 0.0763836f
Cred_850 VSS vin.P16.GatPoly 0.0615393f
Cred_851 VSS vin.P17.GatPoly 0.0764428f
Cred_852 VSS vin.P18.GatPoly 0.0706767f
Cred_853 VSS vin.P19.GatPoly 0.104362f
Cred_854 VSS vin.P2.GatPoly 0.0764428f
Cred_855 VSS vin.P20.GatPoly 0.013177f
Cred_856 VSS vin.P21.GatPoly 0.0112432f
Cred_857 VSS vin.P22.GatPoly 0.0112432f
Cred_858 VSS vin.P23.GatPoly 0.0112432f
Cred_859 VSS vin.P24.GatPoly 0.0117366f
Cred_860 VSS vin.P25.GatPoly 0.0116295f
Cred_861 VSS vin.P26.GatPoly 0.0112432f
Cred_862 VSS vin.P27.GatPoly 0.0117313f
Cred_863 VSS vin.P28.GatPoly 0.0112432f
Cred_864 VSS vin.P29.GatPoly 0.0112432f
Cred_865 VSS vin.P3.GatPoly 0.0615393f
Cred_866 VSS vin.P30.GatPoly 0.0112432f
Cred_867 VSS vin.P31.GatPoly 0.0112432f
Cred_868 VSS vin.P32.GatPoly 0.0117313f
Cred_869 VSS vin.P33.GatPoly 0.0112432f
Cred_870 VSS vin.P34.GatPoly 0.0116295f
Cred_871 VSS vin.P35.GatPoly 0.0117366f
Cred_872 VSS vin.P36.GatPoly 0.0112432f
Cred_873 VSS vin.P37.GatPoly 0.0112432f
Cred_874 VSS vin.P38.GatPoly 0.0112432f
Cred_875 VSS vin.P39.GatPoly 0.0133184f
Cred_876 VSS vin.P4.GatPoly 0.0763836f
Cred_877 VSS vin.P5.GatPoly 0.0615393f
Cred_878 VSS vin.P6.GatPoly 0.0693924f
Cred_879 VSS vin.P7.GatPoly 0.0697338f
Cred_880 VSS vin.P8.GatPoly 0.0643087f
Cred_881 VSS vin.P9.GatPoly 0.0690307f
Cred_882 VSS vout 0.0880835f
Cred_883 VSS vout.$1226.Metal3 0.132803f
Cred_884 VSS vout.$1292.Metal3 0.0592027f
Cred_885 VSS vout.$1358.Metal3 0.059208f
Cred_886 VSS vout.$1424.Metal3 0.0447924f
Cred_887 VSS vout.P0.nSD 0.00682574f
Cred_888 VSS vout.P0.pSD 0.0126467f
Cred_889 VSS vout.P10.nSD 0.00438958f
Cred_890 VSS vout.P10.pSD 0.00123185f
Cred_891 VSS vout.P12.nSD 0.00416214f
Cred_892 VSS vout.P14.nSD 0.00438958f
Cred_893 VSS vout.P14.pSD 0.00123185f
Cred_894 VSS vout.P16.nSD 0.00416214f
Cred_895 VSS vout.P18.nSD 0.00454641f
Cred_896 VSS vout.P18.pSD 0.000469975f
Cred_897 VSS vout.P2.nSD 0.00554909f
Cred_898 VSS vout.P2.pSD 0.00757998f
Cred_899 VSS vout.P4.nSD 0.00416214f
Cred_900 VSS vout.P6.nSD 0.0043895f
Cred_901 VSS vout.P6.pSD 0.00124258f
Cred_902 VSS vout.P8.nSD 0.00416214f
Cred_904 VSS VSS.$1002.Metal2 0.0394312f
Cred_905 VSS VSS.$1010.Metal2 0.0275207f
Cred_906 VSS VSS.$1016.Metal2 0.0261051f
Cred_907 VSS VSS.$1028.Metal2 0.0348236f
Cred_908 VSS VSS.$1040.Metal2 0.0360624f
Cred_909 VSS VSS.$1055.Metal2 0.0525929f
Cred_910 VSS VSS.$1066.Metal2 0.200926f
Cred_911 VSS VSS.$1100.Metal3 0.141098f
Cred_912 VSS VSS.$1112.Metal3 0.0472633f
Cred_913 VSS VSS.$1118.Metal3 0.0441842f
Cred_914 VSS VSS.$1130.Metal3 0.0435841f
Cred_915 VSS VSS.$1136.Metal3 0.0448261f
Cred_916 VSS VSS.$1148.Metal3 0.0504565f
Cred_917 VSS VSS.$115.Metal1 0.0804589f
Cred_918 VSS VSS.$1157.Metal3 0.0521111f
Cred_919 VSS VSS.$1169.Metal3 0.0431753f
Cred_920 VSS VSS.$1175.Metal3 0.0378058f
Cred_921 VSS VSS.$1184.Metal3 0.0505328f
Cred_922 VSS VSS.$1196.Metal3 0.0563715f
Cred_923 VSS VSS.$1217.Metal3 0.0563715f
Cred_924 VSS VSS.$1229.Metal3 0.0505328f
Cred_925 VSS VSS.$1238.Metal3 0.0520147f
Cred_926 VSS VSS.$1250.Metal3 0.0432692f
Cred_927 VSS VSS.$1256.Metal3 0.0378103f
Cred_928 VSS VSS.$1265.Metal3 0.0504565f
Cred_929 VSS VSS.$127.Metal1 0.0869041f
Cred_930 VSS VSS.$1277.Metal3 0.0448261f
Cred_931 VSS VSS.$1283.Metal3 0.0435841f
Cred_932 VSS VSS.$1295.Metal3 0.0441842f
Cred_933 VSS VSS.$1301.Metal3 0.0472633f
Cred_934 VSS VSS.$1313.Metal3 0.141064f
Cred_935 VSS VSS.$137.Metal1 0.0798481f
Cred_936 VSS VSS.$142.Metal1 0.103386f
Cred_937 VSS VSS.$162.Metal1 0.0840371f
Cred_938 VSS VSS.$172.Metal1 0.0872339f
Cred_939 VSS VSS.$18.Metal1 0.249988f
Cred_940 VSS VSS.$184.Metal1 0.101334f
Cred_941 VSS VSS.$195.Metal1 0.0260772f
Cred_942 VSS VSS.$202.Metal1 0.0976727f
Cred_943 VSS VSS.$212.Metal1 0.0873882f
Cred_944 VSS VSS.$224.Metal1 0.0868592f
Cred_945 VSS VSS.$232.Metal1 0.101999f
Cred_946 VSS VSS.$247.Metal1 0.0784718f
Cred_947 VSS VSS.$259.Metal1 0.0866284f
Cred_948 VSS VSS.$269.Metal1 0.0646316f
Cred_949 VSS VSS.$275.Metal1 0.069195f
Cred_950 VSS VSS.$285.Metal1 0.069195f
Cred_951 VSS VSS.$294.Metal1 0.0646316f
Cred_952 VSS VSS.$304.Metal1 0.0866284f
Cred_953 VSS VSS.$314.Metal1 0.0784718f
Cred_954 VSS VSS.$319.Metal1 0.101999f
Cred_955 VSS VSS.$339.Metal1 0.0868592f
Cred_956 VSS VSS.$349.Metal1 0.0873882f
Cred_957 VSS VSS.$361.Metal1 0.0976727f
Cred_958 VSS VSS.$372.Metal1 0.0260772f
Cred_959 VSS VSS.$379.Metal1 0.101333f
Cred_960 VSS VSS.$391.Metal1 0.0872339f
Cred_961 VSS VSS.$40.Metal1 0.17987f
Cred_962 VSS VSS.$401.Metal1 0.0840371f
Cred_963 VSS VSS.$409.Metal1 0.103386f
Cred_964 VSS VSS.$426.Metal1 0.0798481f
Cred_965 VSS VSS.$436.Metal1 0.0869041f
Cred_966 VSS VSS.$44.Metal1 0.138958f
Cred_967 VSS VSS.$448.Metal1 0.0804589f
Cred_968 VSS VSS.$453.Metal1 0.127418f
Cred_969 VSS VSS.$476.Metal1 0.103861f
Cred_970 VSS VSS.$488.Metal1 0.0866137f
Cred_971 VSS VSS.$498.Metal1 0.092531f
Cred_972 VSS VSS.$501.Metal1 0.191305f
Cred_973 VSS VSS.$509.Metal1 0.173442f
Cred_974 VSS VSS.$520.Metal1 0.0576291f
Cred_975 VSS VSS.$551.Metal1 0.155121f
Cred_976 VSS VSS.$564.Metal2 0.203385f
Cred_977 VSS VSS.$590.Metal2 0.0531585f
Cred_978 VSS VSS.$605.Metal2 0.0360624f
Cred_979 VSS VSS.$617.Metal2 0.0348236f
Cred_980 VSS VSS.$629.Metal2 0.0261051f
Cred_981 VSS VSS.$636.Metal2 0.0275207f
Cred_982 VSS VSS.$644.Metal2 0.0394312f
Cred_983 VSS VSS.$65.Metal1 0.092531f
Cred_984 VSS VSS.$658.Metal2 0.0345438f
Cred_985 VSS VSS.$670.Metal2 0.0346422f
Cred_986 VSS VSS.$685.Metal2 0.042021f
Cred_987 VSS VSS.$693.Metal2 0.0322934f
Cred_988 VSS VSS.$705.Metal2 0.0347897f
Cred_989 VSS VSS.$717.Metal2 0.0342718f
Cred_990 VSS VSS.$732.Metal2 0.0478988f
Cred_991 VSS VSS.$740.Metal2 0.0169423f
Cred_992 VSS VSS.$746.Metal2 0.0259796f
Cred_993 VSS VSS.$75.Metal1 0.0866137f
Cred_994 VSS VSS.$758.Metal2 0.0348145f
Cred_995 VSS VSS.$770.Metal2 0.0304771f
Cred_996 VSS VSS.$779.Metal2 0.0438945f
Cred_997 VSS VSS.$793.Metal2 0.0345456f
Cred_998 VSS VSS.$805.Metal2 0.0347903f
Cred_999 VSS VSS.$818.Metal2 0.0370218f
Cred_1000 VSS VSS.$826.Metal2 0.0370218f
Cred_1001 VSS VSS.$840.Metal2 0.0347903f
Cred_1002 VSS VSS.$85.Metal1 0.103861f
Cred_1003 VSS VSS.$852.Metal2 0.0345456f
Cred_1004 VSS VSS.$867.Metal2 0.0438945f
Cred_1005 VSS VSS.$875.Metal2 0.0304771f
Cred_1006 VSS VSS.$887.Metal2 0.0348145f
Cred_1007 VSS VSS.$899.Metal2 0.0260935f
Cred_1008 VSS VSS.$905.Metal2 0.017171f
Cred_1009 VSS VSS.$914.Metal2 0.0477839f
Cred_1010 VSS VSS.$928.Metal2 0.034043f
Cred_1011 VSS VSS.$940.Metal2 0.0347897f
Cred_1012 VSS VSS.$952.Metal2 0.0322934f
Cred_1013 VSS VSS.$961.Metal2 0.042021f
Cred_1014 VSS VSS.$97.Metal1 0.127418f
Cred_1015 VSS VSS.$975.Metal2 0.0346422f
Cred_1016 VSS VSS.$987.Metal2 0.0345438f
Cred_1017 VSS VSS.P0.GatPoly 0.113512f
Cred_1018 VSS VSS.P0.nSD 0.000241438f
Cred_1019 VSS VSS.P0.pSD 0.678561f
Cred_1020 VSS VSS.P1.GatPoly 0.110509f
Cred_1021 VSS VSS.P1.nSD 0.000241438f
Cred_1022 VSS VSS.P10.nSD 0.000578251f
Cred_1023 VSS VSS.P11.nSD 0.000622847f
Cred_1024 VSS VSS.P13.nSD 0.000578251f
Cred_1025 VSS VSS.P15.nSD 2.11135e-05f
Cred_1026 VSS VSS.P17.nSD 0.000578534f
Cred_1027 VSS VSS.P19.nSD 0.000587179f
Cred_1028 VSS VSS.P21.nSD 0.000241438f
Cred_1029 VSS VSS.P23.nSD 0.000241438f
Cred_1030 VSS VSS.P3.nSD 0.000587179f
Cred_1031 VSS VSS.P5.nSD 0.000578534f
Cred_1032 VSS VSS.P7.nSD 2.11135e-05f
Cred_1033 VDD vin.$321.Metal1 1.42567e-08f
Cred_1034 VDD vin.$325.Metal1 3.19078e-08f
Cred_1035 VDD vin.$335.Metal1 3.237e-08f
Cred_1036 VDD vin.$339.Metal1 1.44632e-08f
Cred_1037 VDD vin.$558.Metal2 2.42848e-06f
Cred_1038 VDD vin.$562.Metal2 2.42848e-06f
Cred_1039 VDD vin.$567.Metal2 2.46365e-06f
Cred_1040 VDD vin.$571.Metal2 2.46365e-06f
Cred_1041 VDD vin.P29.GatPoly 0.00849842f
Cred_1042 VDD vin.P30.GatPoly 0.00862152f
Cred_1043 VDD vout.$1292.Metal3 0.0100112f
Cred_1044 VDD vout.$1358.Metal3 0.00325047f
Cred_1045 VDD vout.P10.nSD 5.12081e-05f
Cred_1046 VDD vout.P10.pSD 0.000983176f
Cred_1047 VDD vout.P8.pSD 0.000666992f
Cred_1048 VDD.$100.Metal1 vin.P20.GatPoly 0.0427304f
Cred_1049 VDD.$100.Metal1 vin.P21.GatPoly 0.00424279f
Cred_1050 VDD.$100.Metal1 vin.P22.GatPoly 0.00235528f
Cred_1051 VDD.$100.Metal1 vin.P23.GatPoly 0.00163009f
Cred_1052 VDD.$100.Metal1 vin.P24.GatPoly 0.00124635f
Cred_1053 VDD.$100.Metal1 vin.P25.GatPoly 0.00100885f
Cred_1054 VDD.$1000.Metal1 vin.P39.GatPoly 0.0123219f
Cred_1055 VDD.$1000.Metal1 vout 0.00507457f
Cred_1056 VDD.$1000.Metal1 vout.P18.pSD 0.00484119f
Cred_1057 VDD.$1001.Metal1 vin.P39.GatPoly 0.0123188f
Cred_1058 VDD.$1001.Metal1 vout 0.00500484f
Cred_1059 VDD.$1001.Metal1 vout.P18.pSD 0.00477939f
Cred_1060 VDD.$1002.Metal1 vin 1.86004e-06f
Cred_1061 VDD.$1002.Metal1 vin.$105.GatPoly 1.03809e-05f
Cred_1062 VDD.$1002.Metal1 vin.$107.GatPoly 9.84365e-06f
Cred_1063 VDD.$1002.Metal1 vin.$115.GatPoly 1.74446e-05f
Cred_1064 VDD.$1002.Metal1 vin.$123.GatPoly 2.29387e-05f
Cred_1065 VDD.$1002.Metal1 vin.$127.GatPoly 1.79666e-05f
Cred_1066 VDD.$1002.Metal1 vin.$133.GatPoly 2.39836e-05f
Cred_1067 VDD.$1002.Metal1 vin.$139.GatPoly 3.47838e-05f
Cred_1068 VDD.$1002.Metal1 vin.$145.GatPoly 5.03827e-05f
Cred_1069 VDD.$1002.Metal1 vin.$15.GatPoly 4.7137e-07f
Cred_1070 VDD.$1002.Metal1 vin.$153.GatPoly 6.46229e-05f
Cred_1071 VDD.$1002.Metal1 vin.$157.GatPoly 5.33443e-05f
Cred_1072 VDD.$1002.Metal1 vin.$163.GatPoly 7.56093e-05f
Cred_1073 VDD.$1002.Metal1 vin.$167.GatPoly 8.00896e-05f
Cred_1074 VDD.$1002.Metal1 vin.$17.GatPoly 4.3277e-07f
Cred_1075 VDD.$1002.Metal1 vin.$173.GatPoly 0.000103586f
Cred_1076 VDD.$1002.Metal1 vin.$179.GatPoly 0.00027405f
Cred_1077 VDD.$1002.Metal1 vin.$199.Metal1 1.01056e-05f
Cred_1078 VDD.$1002.Metal1 vin.$207.Metal1 4.57663e-06f
Cred_1079 VDD.$1002.Metal1 vin.$211.Metal1 5.03368e-06f
Cred_1080 VDD.$1002.Metal1 vin.$219.Metal1 8.23873e-06f
Cred_1081 VDD.$1002.Metal1 vin.$227.Metal1 9.28205e-06f
Cred_1082 VDD.$1002.Metal1 vin.$233.Metal1 7.63134e-06f
Cred_1083 VDD.$1002.Metal1 vin.$237.Metal1 6.10126e-06f
Cred_1084 VDD.$1002.Metal1 vin.$241.Metal1 9.84723e-06f
Cred_1085 VDD.$1002.Metal1 vin.$247.Metal1 1.1375e-05f
Cred_1086 VDD.$1002.Metal1 vin.$25.GatPoly 6.24154e-07f
Cred_1087 VDD.$1002.Metal1 vin.$251.Metal1 1.295e-05f
Cred_1088 VDD.$1002.Metal1 vin.$259.Metal1 1.45711e-05f
Cred_1089 VDD.$1002.Metal1 vin.$263.Metal1 1.70828e-05f
Cred_1090 VDD.$1002.Metal1 vin.$269.Metal1 2.57236e-05f
Cred_1091 VDD.$1002.Metal1 vin.$27.GatPoly 6.28889e-07f
Cred_1092 VDD.$1002.Metal1 vin.$277.Metal1 2.23431e-05f
Cred_1093 VDD.$1002.Metal1 vin.$281.Metal1 1.74015e-05f
Cred_1094 VDD.$1002.Metal1 vin.$285.Metal1 2.74613e-05f
Cred_1095 VDD.$1002.Metal1 vin.$291.Metal1 3.28221e-05f
Cred_1096 VDD.$1002.Metal1 vin.$295.Metal1 3.62116e-05f
Cred_1097 VDD.$1002.Metal1 vin.$303.Metal1 4.01585e-05f
Cred_1098 VDD.$1002.Metal1 vin.$307.Metal1 4.86046e-05f
Cred_1099 VDD.$1002.Metal1 vin.$313.Metal1 5.26472e-05f
Cred_1100 VDD.$1002.Metal1 vin.$317.Metal1 3.91708e-05f
Cred_1101 VDD.$1002.Metal1 vin.$321.Metal1 4.36522e-05f
Cred_1102 VDD.$1002.Metal1 vin.$325.Metal1 4.7795e-05f
Cred_1103 VDD.$1002.Metal1 vin.$329.Metal1 7.68127e-05f
Cred_1104 VDD.$1002.Metal1 vin.$335.Metal1 8.82467e-05f
Cred_1105 VDD.$1002.Metal1 vin.$339.Metal1 6.7258e-05f
Cred_1106 VDD.$1002.Metal1 vin.$343.Metal1 7.09154e-05f
Cred_1107 VDD.$1002.Metal1 vin.$347.Metal1 0.000119554f
Cred_1108 VDD.$1002.Metal1 vin.$353.Metal1 0.000138731f
Cred_1109 VDD.$1002.Metal1 vin.$357.Metal1 0.000152966f
Cred_1110 VDD.$1002.Metal1 vin.$365.Metal1 0.00017344f
Cred_1111 VDD.$1002.Metal1 vin.$369.Metal1 0.000206153f
Cred_1112 VDD.$1002.Metal1 vin.$37.GatPoly 1.13778e-06f
Cred_1113 VDD.$1002.Metal1 vin.$375.Metal1 0.00021885f
Cred_1114 VDD.$1002.Metal1 vin.$379.Metal1 0.000175197f
Cred_1115 VDD.$1002.Metal1 vin.$383.Metal1 0.000280633f
Cred_1116 VDD.$1002.Metal1 vin.$391.Metal1 0.000428277f
Cred_1117 VDD.$1002.Metal1 vin.$397.Metal1 0.000380629f
Cred_1118 VDD.$1002.Metal1 vin.$401.Metal1 0.000433033f
Cred_1119 VDD.$1002.Metal1 vin.$409.Metal1 0.000482486f
Cred_1120 VDD.$1002.Metal1 vin.$413.Metal1 0.000557543f
Cred_1121 VDD.$1002.Metal1 vin.$419.Metal1 0.00061219f
Cred_1122 VDD.$1002.Metal1 vin.$423.Metal1 0.000480245f
Cred_1123 VDD.$1002.Metal1 vin.$427.Metal1 0.000739479f
Cred_1124 VDD.$1002.Metal1 vin.$43.GatPoly 1.49593e-06f
Cred_1125 VDD.$1002.Metal1 vin.$433.Metal1 0.00119556f
Cred_1126 VDD.$1002.Metal1 vin.$441.Metal1 0.00150103f
Cred_1127 VDD.$1002.Metal1 vin.$449.Metal1 0.00123398f
Cred_1128 VDD.$1002.Metal1 vin.$453.Metal1 0.000938856f
Cred_1129 VDD.$1002.Metal1 vin.$457.Metal1 0.00578637f
Cred_1130 VDD.$1002.Metal1 vin.$476.Metal2 8.37224e-09f
Cred_1131 VDD.$1002.Metal1 vin.$478.Metal2 2.60117e-06f
Cred_1132 VDD.$1002.Metal1 vin.$482.Metal2 1.32027e-06f
Cred_1133 VDD.$1002.Metal1 vin.$486.Metal2 4.28146e-06f
Cred_1134 VDD.$1002.Metal1 vin.$489.Metal2 2.47145e-06f
Cred_1135 VDD.$1002.Metal1 vin.$493.Metal2 2.55832e-06f
Cred_1136 VDD.$1002.Metal1 vin.$495.Metal2 6.43567e-06f
Cred_1137 VDD.$1002.Metal1 vin.$500.Metal2 3.01966e-06f
Cred_1138 VDD.$1002.Metal1 vin.$504.Metal2 4.09868e-06f
Cred_1139 VDD.$1002.Metal1 vin.$506.Metal2 8.39267e-06f
Cred_1140 VDD.$1002.Metal1 vin.$509.Metal2 3.02833e-06f
Cred_1141 VDD.$1002.Metal1 vin.$51.GatPoly 1.67476e-06f
Cred_1142 VDD.$1002.Metal1 vin.$513.Metal2 4.0208e-06f
Cred_1143 VDD.$1002.Metal1 vin.$515.Metal2 1.18718e-05f
Cred_1144 VDD.$1002.Metal1 vin.$518.Metal2 5.03521e-06f
Cred_1145 VDD.$1002.Metal1 vin.$520.Metal2 3.14385e-06f
Cred_1146 VDD.$1002.Metal1 vin.$524.Metal2 1.12388e-05f
Cred_1147 VDD.$1002.Metal1 vin.$526.Metal2 1.57297e-05f
Cred_1148 VDD.$1002.Metal1 vin.$529.Metal2 4.73432e-06f
Cred_1149 VDD.$1002.Metal1 vin.$533.Metal2 1.06557e-05f
Cred_1150 VDD.$1002.Metal1 vin.$535.Metal2 2.38981e-05f
Cred_1151 VDD.$1002.Metal1 vin.$538.Metal2 9.35513e-06f
Cred_1152 VDD.$1002.Metal1 vin.$542.Metal2 1.00822e-05f
Cred_1153 VDD.$1002.Metal1 vin.$544.Metal2 3.17905e-05f
Cred_1154 VDD.$1002.Metal1 vin.$547.Metal2 1.91602e-05f
Cred_1155 VDD.$1002.Metal1 vin.$55.GatPoly 1.63937e-06f
Cred_1156 VDD.$1002.Metal1 vin.$551.Metal2 2.03886e-05f
Cred_1157 VDD.$1002.Metal1 vin.$555.Metal2 5.22902e-05f
Cred_1158 VDD.$1002.Metal1 vin.$558.Metal2 2.48243e-05f
Cred_1159 VDD.$1002.Metal1 vin.$562.Metal2 2.75355e-05f
Cred_1160 VDD.$1002.Metal1 vin.$564.Metal2 6.8075e-05f
Cred_1161 VDD.$1002.Metal1 vin.$567.Metal2 3.06315e-05f
Cred_1162 VDD.$1002.Metal1 vin.$57.GatPoly 1.66734e-06f
Cred_1163 VDD.$1002.Metal1 vin.$571.Metal2 4.27462e-05f
Cred_1164 VDD.$1002.Metal1 vin.$573.Metal2 0.000102902f
Cred_1165 VDD.$1002.Metal1 vin.$578.Metal2 4.64045e-05f
Cred_1166 VDD.$1002.Metal1 vin.$582.Metal2 7.33723e-05f
Cred_1167 VDD.$1002.Metal1 vin.$584.Metal2 0.000127038f
Cred_1168 VDD.$1002.Metal1 vin.$587.Metal2 4.7194e-05f
Cred_1169 VDD.$1002.Metal1 vin.$591.Metal2 6.92135e-05f
Cred_1170 VDD.$1002.Metal1 vin.$593.Metal2 0.000191869f
Cred_1171 VDD.$1002.Metal1 vin.$596.Metal2 9.47923e-05f
Cred_1172 VDD.$1002.Metal1 vin.$600.Metal2 5.85586e-05f
Cred_1173 VDD.$1002.Metal1 vin.$602.Metal2 0.000251753f
Cred_1174 VDD.$1002.Metal1 vin.$605.Metal2 0.000191318f
Cred_1175 VDD.$1002.Metal1 vin.$609.Metal2 7.18461e-05f
Cred_1176 VDD.$1002.Metal1 vin.$611.Metal2 0.000164694f
Cred_1177 VDD.$1002.Metal1 vin.$613.Metal2 0.000382268f
Cred_1178 VDD.$1002.Metal1 vin.$616.Metal2 0.000150186f
Cred_1179 VDD.$1002.Metal1 vin.$620.Metal2 0.000172978f
Cred_1180 VDD.$1002.Metal1 vin.$622.Metal2 0.000538335f
Cred_1181 VDD.$1002.Metal1 vin.$625.Metal2 0.000285298f
Cred_1182 VDD.$1002.Metal1 vin.$629.Metal2 0.000335989f
Cred_1183 VDD.$1002.Metal1 vin.$633.Metal2 0.000829802f
Cred_1184 VDD.$1002.Metal1 vin.$636.Metal2 0.000376294f
Cred_1185 VDD.$1002.Metal1 vin.$640.Metal2 0.000483053f
Cred_1186 VDD.$1002.Metal1 vin.$642.Metal2 0.00164161f
Cred_1187 VDD.$1002.Metal1 vin.$645.Metal2 0.000443139f
Cred_1188 VDD.$1002.Metal1 vin.$648.Metal2 3.68186e-05f
Cred_1189 VDD.$1002.Metal1 vin.$649.Metal2 0.00062829f
Cred_1190 VDD.$1002.Metal1 vin.$65.GatPoly 3.16118e-06f
Cred_1191 VDD.$1002.Metal1 vin.$653.Metal2 0.000140777f
Cred_1192 VDD.$1002.Metal1 vin.$654.Metal2 0.00176184f
Cred_1193 VDD.$1002.Metal1 vin.$7.GatPoly 4.07287e-07f
Cred_1194 VDD.$1002.Metal1 vin.$73.GatPoly 3.99406e-06f
Cred_1195 VDD.$1002.Metal1 vin.$77.GatPoly 3.30442e-06f
Cred_1196 VDD.$1002.Metal1 vin.$83.GatPoly 4.88659e-06f
Cred_1197 VDD.$1002.Metal1 vin.$87.GatPoly 5.6949e-06f
Cred_1198 VDD.$1002.Metal1 vin.$9.GatPoly 3.52546e-07f
Cred_1199 VDD.$1002.Metal1 vin.$95.GatPoly 8.27247e-06f
Cred_1200 VDD.$1002.Metal1 vin.$97.GatPoly 6.72811e-06f
Cred_1201 VDD.$1002.Metal1 vin.P20.GatPoly 9.81026e-07f
Cred_1202 VDD.$1002.Metal1 vin.P24.GatPoly 1.09297e-07f
Cred_1203 VDD.$1002.Metal1 vin.P25.GatPoly 1.14046e-07f
Cred_1204 VDD.$1002.Metal1 vin.P27.GatPoly 3.04067e-07f
Cred_1205 VDD.$1002.Metal1 vin.P32.GatPoly 1.72351e-06f
Cred_1206 VDD.$1002.Metal1 vin.P34.GatPoly 2.8729e-06f
Cred_1207 VDD.$1002.Metal1 vin.P35.GatPoly 4.89063e-06f
Cred_1208 VDD.$1002.Metal1 vin.P39.GatPoly 0.0132553f
Cred_1209 VDD.$1002.Metal1 vout 0.00586704f
Cred_1210 VDD.$1002.Metal1 vout.$1226.Metal3 1.23713e-05f
Cred_1211 VDD.$1002.Metal1 vout.$1292.Metal3 4.45108e-05f
Cred_1212 VDD.$1002.Metal1 vout.$1358.Metal3 0.000185056f
Cred_1213 VDD.$1002.Metal1 vout.$1424.Metal3 0.000404193f
Cred_1214 VDD.$1002.Metal1 vout.P0.nSD 5.65133e-08f
Cred_1215 VDD.$1002.Metal1 vout.P0.pSD 3.20609e-07f
Cred_1216 VDD.$1002.Metal1 vout.P10.nSD 3.18114e-07f
Cred_1217 VDD.$1002.Metal1 vout.P10.pSD 1.72292e-06f
Cred_1218 VDD.$1002.Metal1 vout.P14.nSD 1.26584e-06f
Cred_1219 VDD.$1002.Metal1 vout.P14.pSD 6.85586e-06f
Cred_1220 VDD.$1002.Metal1 vout.P18.pSD 0.00445926f
Cred_1221 VDD.$1002.Metal1 vout.P2.nSD 4.3856e-08f
Cred_1222 VDD.$1002.Metal1 vout.P2.pSD 2.39683e-07f
Cred_1223 VDD.$1002.Metal1 vout.P6.nSD 7.36383e-08f
Cred_1224 VDD.$1002.Metal1 vout.P6.pSD 4.0245e-07f
Cred_1225 VDD.$1002.Metal1 VSS.$1040.Metal2 1.52627e-07f
Cred_1226 VDD.$1002.Metal1 VSS.$1066.Metal2 0.000128652f
Cred_1227 VDD.$1002.Metal1 VSS.$18.Metal1 8.24262e-06f
Cred_1228 VDD.$1002.Metal1 VSS.$40.Metal1 3.6479e-06f
Cred_1229 VDD.$1002.Metal1 VSS.$488.Metal1 1.82679e-05f
Cred_1230 VDD.$1002.Metal1 VSS.$498.Metal1 3.83167e-05f
Cred_1231 VDD.$1002.Metal1 VSS.$509.Metal1 0.000716459f
Cred_1232 VDD.$1002.Metal1 VSS.$551.Metal1 0.00311942f
Cred_1233 VDD.$1002.Metal1 VSS.$564.Metal2 3.65645e-08f
Cred_1234 VDD.$1002.Metal1 VSS.$605.Metal2 1.74624e-10f
Cred_1235 VDD.$1002.Metal1 VSS.$65.Metal1 4.3839e-08f
Cred_1236 VDD.$1002.Metal1 VSS.$75.Metal1 2.09007e-08f
Cred_1237 VDD.$1002.Metal1 VSS.P0.nSD 2.95402e-09f
Cred_1238 VDD.$1002.Metal1 VSS.P0.pSD 0.00988788f
Cred_1239 VDD.$1002.Metal1 VSS.P1.nSD 2.95402e-09f
Cred_1240 VDD.$1002.Metal1 VSS.P21.nSD 4.65098e-06f
Cred_1241 VDD.$1002.Metal1 VSS.P23.nSD 4.65098e-06f
Cred_1242 VDD.$1003.Metal1 vin 2.08417e-06f
Cred_1243 VDD.$1003.Metal1 vin.$105.GatPoly 1.16318e-05f
Cred_1244 VDD.$1003.Metal1 vin.$107.GatPoly 1.10297e-05f
Cred_1245 VDD.$1003.Metal1 vin.$115.GatPoly 1.95465e-05f
Cred_1246 VDD.$1003.Metal1 vin.$123.GatPoly 2.57026e-05f
Cred_1247 VDD.$1003.Metal1 vin.$127.GatPoly 2.01315e-05f
Cred_1248 VDD.$1003.Metal1 vin.$133.GatPoly 2.68734e-05f
Cred_1249 VDD.$1003.Metal1 vin.$139.GatPoly 3.8975e-05f
Cred_1250 VDD.$1003.Metal1 vin.$145.GatPoly 5.64535e-05f
Cred_1251 VDD.$1003.Metal1 vin.$15.GatPoly 5.28167e-07f
Cred_1252 VDD.$1003.Metal1 vin.$153.GatPoly 7.24095e-05f
Cred_1253 VDD.$1003.Metal1 vin.$157.GatPoly 5.97719e-05f
Cred_1254 VDD.$1003.Metal1 vin.$163.GatPoly 8.47198e-05f
Cred_1255 VDD.$1003.Metal1 vin.$167.GatPoly 8.97398e-05f
Cred_1256 VDD.$1003.Metal1 vin.$17.GatPoly 4.84916e-07f
Cred_1257 VDD.$1003.Metal1 vin.$173.GatPoly 0.000116068f
Cred_1258 VDD.$1003.Metal1 vin.$179.GatPoly 0.000307071f
Cred_1259 VDD.$1003.Metal1 vin.$199.Metal1 1.13233e-05f
Cred_1260 VDD.$1003.Metal1 vin.$207.Metal1 5.12808e-06f
Cred_1261 VDD.$1003.Metal1 vin.$211.Metal1 5.64021e-06f
Cred_1262 VDD.$1003.Metal1 vin.$219.Metal1 9.23144e-06f
Cred_1263 VDD.$1003.Metal1 vin.$227.Metal1 1.04005e-05f
Cred_1264 VDD.$1003.Metal1 vin.$233.Metal1 8.55087e-06f
Cred_1265 VDD.$1003.Metal1 vin.$237.Metal1 6.83642e-06f
Cred_1266 VDD.$1003.Metal1 vin.$241.Metal1 1.10338e-05f
Cred_1267 VDD.$1003.Metal1 vin.$247.Metal1 1.27456e-05f
Cred_1268 VDD.$1003.Metal1 vin.$25.GatPoly 6.99361e-07f
Cred_1269 VDD.$1003.Metal1 vin.$251.Metal1 1.45104e-05f
Cred_1270 VDD.$1003.Metal1 vin.$259.Metal1 1.63269e-05f
Cred_1271 VDD.$1003.Metal1 vin.$263.Metal1 1.91411e-05f
Cred_1272 VDD.$1003.Metal1 vin.$269.Metal1 2.88231e-05f
Cred_1273 VDD.$1003.Metal1 vin.$27.GatPoly 7.04666e-07f
Cred_1274 VDD.$1003.Metal1 vin.$277.Metal1 2.50353e-05f
Cred_1275 VDD.$1003.Metal1 vin.$281.Metal1 1.94982e-05f
Cred_1276 VDD.$1003.Metal1 vin.$285.Metal1 3.07702e-05f
Cred_1277 VDD.$1003.Metal1 vin.$291.Metal1 3.67769e-05f
Cred_1278 VDD.$1003.Metal1 vin.$295.Metal1 4.05749e-05f
Cred_1279 VDD.$1003.Metal1 vin.$303.Metal1 4.49973e-05f
Cred_1280 VDD.$1003.Metal1 vin.$307.Metal1 5.44611e-05f
Cred_1281 VDD.$1003.Metal1 vin.$313.Metal1 5.89908e-05f
Cred_1282 VDD.$1003.Metal1 vin.$317.Metal1 4.38906e-05f
Cred_1283 VDD.$1003.Metal1 vin.$321.Metal1 4.8912e-05f
Cred_1284 VDD.$1003.Metal1 vin.$325.Metal1 5.3554e-05f
Cred_1285 VDD.$1003.Metal1 vin.$329.Metal1 8.60681e-05f
Cred_1286 VDD.$1003.Metal1 vin.$335.Metal1 9.88798e-05f
Cred_1287 VDD.$1003.Metal1 vin.$339.Metal1 7.53622e-05f
Cred_1288 VDD.$1003.Metal1 vin.$343.Metal1 7.94602e-05f
Cred_1289 VDD.$1003.Metal1 vin.$347.Metal1 0.000133959f
Cred_1290 VDD.$1003.Metal1 vin.$353.Metal1 0.000155447f
Cred_1291 VDD.$1003.Metal1 vin.$357.Metal1 0.000171397f
Cred_1292 VDD.$1003.Metal1 vin.$365.Metal1 0.000194339f
Cred_1293 VDD.$1003.Metal1 vin.$369.Metal1 0.000230993f
Cred_1294 VDD.$1003.Metal1 vin.$37.GatPoly 1.27487e-06f
Cred_1295 VDD.$1003.Metal1 vin.$375.Metal1 0.00024522f
Cred_1296 VDD.$1003.Metal1 vin.$379.Metal1 0.000196307f
Cred_1297 VDD.$1003.Metal1 vin.$383.Metal1 0.000314448f
Cred_1298 VDD.$1003.Metal1 vin.$391.Metal1 0.000479882f
Cred_1299 VDD.$1003.Metal1 vin.$397.Metal1 0.000426493f
Cred_1300 VDD.$1003.Metal1 vin.$401.Metal1 0.00048521f
Cred_1301 VDD.$1003.Metal1 vin.$409.Metal1 0.000540622f
Cred_1302 VDD.$1003.Metal1 vin.$413.Metal1 0.000624723f
Cred_1303 VDD.$1003.Metal1 vin.$419.Metal1 0.000685955f
Cred_1304 VDD.$1003.Metal1 vin.$423.Metal1 0.000538111f
Cred_1305 VDD.$1003.Metal1 vin.$427.Metal1 0.000828581f
Cred_1306 VDD.$1003.Metal1 vin.$43.GatPoly 1.67618e-06f
Cred_1307 VDD.$1003.Metal1 vin.$433.Metal1 0.00133962f
Cred_1308 VDD.$1003.Metal1 vin.$441.Metal1 0.00168189f
Cred_1309 VDD.$1003.Metal1 vin.$449.Metal1 0.00138266f
Cred_1310 VDD.$1003.Metal1 vin.$453.Metal1 0.00105198f
Cred_1311 VDD.$1003.Metal1 vin.$457.Metal1 0.00648359f
Cred_1312 VDD.$1003.Metal1 vin.$476.Metal2 9.38104e-09f
Cred_1313 VDD.$1003.Metal1 vin.$478.Metal2 2.9146e-06f
Cred_1314 VDD.$1003.Metal1 vin.$482.Metal2 1.47936e-06f
Cred_1315 VDD.$1003.Metal1 vin.$486.Metal2 4.79735e-06f
Cred_1316 VDD.$1003.Metal1 vin.$489.Metal2 2.76924e-06f
Cred_1317 VDD.$1003.Metal1 vin.$493.Metal2 2.86658e-06f
Cred_1318 VDD.$1003.Metal1 vin.$495.Metal2 7.21113e-06f
Cred_1319 VDD.$1003.Metal1 vin.$500.Metal2 3.38351e-06f
Cred_1320 VDD.$1003.Metal1 vin.$504.Metal2 4.59254e-06f
Cred_1321 VDD.$1003.Metal1 vin.$506.Metal2 9.40393e-06f
Cred_1322 VDD.$1003.Metal1 vin.$509.Metal2 3.39322e-06f
Cred_1323 VDD.$1003.Metal1 vin.$51.GatPoly 1.87656e-06f
Cred_1324 VDD.$1003.Metal1 vin.$513.Metal2 4.50528e-06f
Cred_1325 VDD.$1003.Metal1 vin.$515.Metal2 1.33023e-05f
Cred_1326 VDD.$1003.Metal1 vin.$518.Metal2 5.64192e-06f
Cred_1327 VDD.$1003.Metal1 vin.$520.Metal2 3.52266e-06f
Cred_1328 VDD.$1003.Metal1 vin.$524.Metal2 1.2593e-05f
Cred_1329 VDD.$1003.Metal1 vin.$526.Metal2 1.7625e-05f
Cred_1330 VDD.$1003.Metal1 vin.$529.Metal2 5.30477e-06f
Cred_1331 VDD.$1003.Metal1 vin.$533.Metal2 1.19396e-05f
Cred_1332 VDD.$1003.Metal1 vin.$535.Metal2 2.67776e-05f
Cred_1333 VDD.$1003.Metal1 vin.$538.Metal2 1.04824e-05f
Cred_1334 VDD.$1003.Metal1 vin.$542.Metal2 1.1297e-05f
Cred_1335 VDD.$1003.Metal1 vin.$544.Metal2 3.56211e-05f
Cred_1336 VDD.$1003.Metal1 vin.$547.Metal2 2.14689e-05f
Cred_1337 VDD.$1003.Metal1 vin.$55.GatPoly 1.8369e-06f
Cred_1338 VDD.$1003.Metal1 vin.$551.Metal2 2.28453e-05f
Cred_1339 VDD.$1003.Metal1 vin.$555.Metal2 5.85909e-05f
Cred_1340 VDD.$1003.Metal1 vin.$558.Metal2 2.78155e-05f
Cred_1341 VDD.$1003.Metal1 vin.$562.Metal2 3.08534e-05f
Cred_1342 VDD.$1003.Metal1 vin.$564.Metal2 7.62776e-05f
Cred_1343 VDD.$1003.Metal1 vin.$567.Metal2 3.43224e-05f
Cred_1344 VDD.$1003.Metal1 vin.$57.GatPoly 1.86824e-06f
Cred_1345 VDD.$1003.Metal1 vin.$571.Metal2 4.78968e-05f
Cred_1346 VDD.$1003.Metal1 vin.$573.Metal2 0.000115301f
Cred_1347 VDD.$1003.Metal1 vin.$578.Metal2 5.1996e-05f
Cred_1348 VDD.$1003.Metal1 vin.$582.Metal2 8.22132e-05f
Cred_1349 VDD.$1003.Metal1 vin.$584.Metal2 0.000142345f
Cred_1350 VDD.$1003.Metal1 vin.$587.Metal2 5.28805e-05f
Cred_1351 VDD.$1003.Metal1 vin.$591.Metal2 7.75533e-05f
Cred_1352 VDD.$1003.Metal1 vin.$593.Metal2 0.000214988f
Cred_1353 VDD.$1003.Metal1 vin.$596.Metal2 0.000106214f
Cred_1354 VDD.$1003.Metal1 vin.$600.Metal2 6.56145e-05f
Cred_1355 VDD.$1003.Metal1 vin.$602.Metal2 0.000282088f
Cred_1356 VDD.$1003.Metal1 vin.$605.Metal2 0.000214371f
Cred_1357 VDD.$1003.Metal1 vin.$609.Metal2 8.0503e-05f
Cred_1358 VDD.$1003.Metal1 vin.$611.Metal2 0.000184539f
Cred_1359 VDD.$1003.Metal1 vin.$613.Metal2 0.000428329f
Cred_1360 VDD.$1003.Metal1 vin.$616.Metal2 0.000168282f
Cred_1361 VDD.$1003.Metal1 vin.$620.Metal2 0.000193821f
Cred_1362 VDD.$1003.Metal1 vin.$622.Metal2 0.000603201f
Cred_1363 VDD.$1003.Metal1 vin.$625.Metal2 0.000319674f
Cred_1364 VDD.$1003.Metal1 vin.$629.Metal2 0.000376473f
Cred_1365 VDD.$1003.Metal1 vin.$633.Metal2 0.000929788f
Cred_1366 VDD.$1003.Metal1 vin.$636.Metal2 0.000421635f
Cred_1367 VDD.$1003.Metal1 vin.$640.Metal2 0.000541258f
Cred_1368 VDD.$1003.Metal1 vin.$642.Metal2 0.00183941f
Cred_1369 VDD.$1003.Metal1 vin.$645.Metal2 0.000496535f
Cred_1370 VDD.$1003.Metal1 vin.$648.Metal2 4.12551e-05f
Cred_1371 VDD.$1003.Metal1 vin.$649.Metal2 0.000703995f
Cred_1372 VDD.$1003.Metal1 vin.$65.GatPoly 3.54208e-06f
Cred_1373 VDD.$1003.Metal1 vin.$653.Metal2 0.00015774f
Cred_1374 VDD.$1003.Metal1 vin.$654.Metal2 0.00197413f
Cred_1375 VDD.$1003.Metal1 vin.$7.GatPoly 4.56362e-07f
Cred_1376 VDD.$1003.Metal1 vin.$73.GatPoly 4.47531e-06f
Cred_1377 VDD.$1003.Metal1 vin.$77.GatPoly 3.70258e-06f
Cred_1378 VDD.$1003.Metal1 vin.$83.GatPoly 5.47539e-06f
Cred_1379 VDD.$1003.Metal1 vin.$87.GatPoly 6.3811e-06f
Cred_1380 VDD.$1003.Metal1 vin.$9.GatPoly 3.95026e-07f
Cred_1381 VDD.$1003.Metal1 vin.$95.GatPoly 9.26925e-06f
Cred_1382 VDD.$1003.Metal1 vin.$97.GatPoly 7.5388e-06f
Cred_1383 VDD.$1003.Metal1 vin.P20.GatPoly 1.09923e-06f
Cred_1384 VDD.$1003.Metal1 vin.P24.GatPoly 1.22466e-07f
Cred_1385 VDD.$1003.Metal1 vin.P25.GatPoly 1.27788e-07f
Cred_1386 VDD.$1003.Metal1 vin.P27.GatPoly 3.40705e-07f
Cred_1387 VDD.$1003.Metal1 vin.P32.GatPoly 1.93118e-06f
Cred_1388 VDD.$1003.Metal1 vin.P34.GatPoly 3.21906e-06f
Cred_1389 VDD.$1003.Metal1 vin.P35.GatPoly 5.47992e-06f
Cred_1390 VDD.$1003.Metal1 vin.P39.GatPoly 0.0133466f
Cred_1391 VDD.$1003.Metal1 vout 0.00635083f
Cred_1392 VDD.$1003.Metal1 vout.$1226.Metal3 1.38619e-05f
Cred_1393 VDD.$1003.Metal1 vout.$1292.Metal3 4.98741e-05f
Cred_1394 VDD.$1003.Metal1 vout.$1358.Metal3 0.000207354f
Cred_1395 VDD.$1003.Metal1 vout.$1424.Metal3 0.000452895f
Cred_1396 VDD.$1003.Metal1 vout.P0.nSD 6.33228e-08f
Cred_1397 VDD.$1003.Metal1 vout.P0.pSD 3.59241e-07f
Cred_1398 VDD.$1003.Metal1 vout.P10.nSD 3.56444e-07f
Cred_1399 VDD.$1003.Metal1 vout.P10.pSD 1.93053e-06f
Cred_1400 VDD.$1003.Metal1 vout.P14.nSD 1.41836e-06f
Cred_1401 VDD.$1003.Metal1 vout.P14.pSD 7.68195e-06f
Cred_1402 VDD.$1003.Metal1 vout.P18.pSD 0.00480253f
Cred_1403 VDD.$1003.Metal1 vout.P2.nSD 4.91404e-08f
Cred_1404 VDD.$1003.Metal1 vout.P2.pSD 2.68563e-07f
Cred_1405 VDD.$1003.Metal1 vout.P6.nSD 8.25112e-08f
Cred_1406 VDD.$1003.Metal1 vout.P6.pSD 4.50943e-07f
Cred_1407 VDD.$1003.Metal1 VSS.$1040.Metal2 1.71018e-07f
Cred_1408 VDD.$1003.Metal1 VSS.$1066.Metal2 0.000144154f
Cred_1409 VDD.$1003.Metal1 VSS.$18.Metal1 9.23581e-06f
Cred_1410 VDD.$1003.Metal1 VSS.$40.Metal1 4.08745e-06f
Cred_1411 VDD.$1003.Metal1 VSS.$488.Metal1 2.04691e-05f
Cred_1412 VDD.$1003.Metal1 VSS.$498.Metal1 4.29336e-05f
Cred_1413 VDD.$1003.Metal1 VSS.$509.Metal1 0.000802787f
Cred_1414 VDD.$1003.Metal1 VSS.$551.Metal1 0.00349529f
Cred_1415 VDD.$1003.Metal1 VSS.$564.Metal2 4.09703e-08f
Cred_1416 VDD.$1003.Metal1 VSS.$605.Metal2 1.95665e-10f
Cred_1417 VDD.$1003.Metal1 VSS.$65.Metal1 4.91213e-08f
Cred_1418 VDD.$1003.Metal1 VSS.$75.Metal1 2.34192e-08f
Cred_1419 VDD.$1003.Metal1 VSS.P0.nSD 3.30996e-09f
Cred_1420 VDD.$1003.Metal1 VSS.P0.pSD 0.0110793f
Cred_1421 VDD.$1003.Metal1 VSS.P1.nSD 3.30996e-09f
Cred_1422 VDD.$1003.Metal1 VSS.P21.nSD 5.21139e-06f
Cred_1423 VDD.$1003.Metal1 VSS.P23.nSD 5.21139e-06f
Cred_1424 VDD.$1004.Metal1 vin.P39.GatPoly 0.0123238f
Cred_1425 VDD.$1004.Metal1 vout 0.00489591f
Cred_1426 VDD.$1004.Metal1 vout.P18.pSD 0.00464839f
Cred_1427 VDD.$1005.Metal1 vin.P39.GatPoly 0.0123161f
Cred_1428 VDD.$1005.Metal1 vout 0.00502323f
Cred_1429 VDD.$1005.Metal1 vout.P18.pSD 0.00478202f
Cred_1430 VDD.$1006.Metal1 vin.P39.GatPoly 0.0124007f
Cred_1431 VDD.$1006.Metal1 vout 0.00509634f
Cred_1432 VDD.$1006.Metal1 vout.P18.pSD 0.00485423f
Cred_1433 VDD.$1007.Metal1 vin.P39.GatPoly 0.0178048f
Cred_1434 VDD.$1007.Metal1 vout 0.00460865f
Cred_1435 VDD.$1007.Metal1 vout.P18.pSD 0.00438839f
Cred_1436 VDD.$1056.Metal2 vin.P20.GatPoly 0.000401236f
Cred_1437 VDD.$1065.Metal2 vin.$199.Metal1 0.0102751f
Cred_1438 VDD.$1065.Metal2 vin.$478.Metal2 0.000665706f
Cred_1439 VDD.$1065.Metal2 vin.$7.GatPoly 0.00217847f
Cred_1440 VDD.$1065.Metal2 vin.P20.GatPoly 0.0146034f
Cred_1441 VDD.$1065.Metal2 vout.$1226.Metal3 0.0788325f
Cred_1442 VDD.$1065.Metal2 vout.P0.nSD 0.00234738f
Cred_1443 VDD.$1065.Metal2 vout.P0.pSD 0.0444362f
Cred_1444 VDD.$1065.Metal2 vout.P2.nSD 0.00124193f
Cred_1445 VDD.$1065.Metal2 vout.P2.pSD 0.00678744f
Cred_1446 VDD.$1065.Metal2 VSS.$1100.Metal3 0.00467288f
Cred_1447 VDD.$1065.Metal2 VSS.$18.Metal1 0.000583116f
Cred_1448 VDD.$1065.Metal2 VSS.$40.Metal1 0.00245812f
Cred_1449 VDD.$1065.Metal2 VSS.$44.Metal1 1.20516e-06f
Cred_1450 VDD.$1065.Metal2 VSS.$551.Metal1 2.445e-07f
Cred_1451 VDD.$1065.Metal2 VSS.$564.Metal2 0.038221f
Cred_1452 VDD.$1065.Metal2 VSS.$590.Metal2 3.29912e-05f
Cred_1453 VDD.$1065.Metal2 VSS.P0.nSD 9.42785e-06f
Cred_1454 VDD.$1065.Metal2 VSS.P0.pSD 0.00121708f
Cred_1455 VDD.$1065.Metal2 VSS.P1.nSD 9.42785e-06f
Cred_1456 VDD.$1068.Metal2 vin.P20.GatPoly 0.012132f
Cred_1457 VDD.$1068.Metal2 vout.$1226.Metal3 0.0356005f
Cred_1458 VDD.$1068.Metal2 vout.P0.nSD 0.00106007f
Cred_1459 VDD.$1068.Metal2 vout.P0.pSD 0.0216028f
Cred_1460 VDD.$1068.Metal2 vout.P2.nSD 0.000560852f
Cred_1461 VDD.$1068.Metal2 vout.P2.pSD 0.00306518f
Cred_1462 VDD.$1070.Metal2 vin.P20.GatPoly 0.0097142f
Cred_1463 VDD.$1070.Metal2 vout.$1226.Metal3 0.0280247f
Cred_1464 VDD.$1070.Metal2 vout.P0.nSD 0.000834488f
Cred_1465 VDD.$1070.Metal2 vout.P0.pSD 0.0176462f
Cred_1466 VDD.$1070.Metal2 vout.P2.nSD 0.000441504f
Cred_1467 VDD.$1070.Metal2 vout.P2.pSD 0.00241292f
Cred_1468 VDD.$1072.Metal2 vin.P20.GatPoly 0.00970713f
Cred_1469 VDD.$1072.Metal2 vout.$1226.Metal3 0.0278157f
Cred_1470 VDD.$1072.Metal2 vout.P0.nSD 0.000828265f
Cred_1471 VDD.$1072.Metal2 vout.P0.pSD 0.0178772f
Cred_1472 VDD.$1072.Metal2 vout.P2.nSD 0.000438211f
Cred_1473 VDD.$1072.Metal2 vout.P2.pSD 0.00239492f
Cred_1474 VDD.$1074.Metal2 vin.P20.GatPoly 0.00728892f
Cred_1475 VDD.$1074.Metal2 vout.$1226.Metal3 0.0207914f
Cred_1476 VDD.$1074.Metal2 vout.P0.nSD 0.000619103f
Cred_1477 VDD.$1074.Metal2 vout.P0.pSD 0.0135061f
Cred_1478 VDD.$1074.Metal2 vout.P2.nSD 0.000327549f
Cred_1479 VDD.$1074.Metal2 vout.P2.pSD 0.00179013f
Cred_1480 VDD.$1075.Metal2 vin.P20.GatPoly 0.00837826f
Cred_1481 VDD.$1075.Metal2 vout.$1226.Metal3 0.0176816f
Cred_1482 VDD.$1075.Metal2 vout.P0.nSD 0.000526503f
Cred_1483 VDD.$1075.Metal2 vout.P0.pSD 0.0116349f
Cred_1484 VDD.$1075.Metal2 vout.P2.nSD 0.000278557f
Cred_1485 VDD.$1075.Metal2 vout.P2.pSD 0.00152238f
Cred_1486 VDD.$1110.Metal2 vin.P20.GatPoly 0.00104074f
Cred_1487 VDD.$1137.Metal2 vin.$199.Metal1 2.50851e-05f
Cred_1488 VDD.$1137.Metal2 vin.$478.Metal2 0.00101194f
Cred_1489 VDD.$1137.Metal2 vin.$7.GatPoly 3.56259e-07f
Cred_1490 VDD.$1137.Metal2 vin.P20.GatPoly 0.0174942f
Cred_1491 VDD.$1137.Metal2 vout.$1226.Metal3 0.000833471f
Cred_1492 VDD.$1137.Metal2 vout.P0.nSD 2.48181e-05f
Cred_1493 VDD.$1137.Metal2 vout.P0.pSD 0.000339247f
Cred_1494 VDD.$1137.Metal2 vout.P2.nSD 1.31306e-05f
Cred_1495 VDD.$1137.Metal2 vout.P2.pSD 7.17615e-05f
Cred_1496 VDD.$1149.Metal2 vin.$199.Metal1 2.99845e-05f
Cred_1497 VDD.$1149.Metal2 vin.$478.Metal2 0.00133571f
Cred_1498 VDD.$1149.Metal2 vin.$482.Metal2 0.000256647f
Cred_1499 VDD.$1149.Metal2 vin.$7.GatPoly 3.56259e-07f
Cred_1500 VDD.$1149.Metal2 vin.P20.GatPoly 0.00503557f
Cred_1501 VDD.$1149.Metal2 vin.P21.GatPoly 0.00295259f
Cred_1502 VDD.$1149.Metal2 vout.$1226.Metal3 0.01115f
Cred_1503 VDD.$1149.Metal2 vout.P0.nSD 0.000332013f
Cred_1504 VDD.$1149.Metal2 vout.P0.pSD 0.00815355f
Cred_1505 VDD.$1149.Metal2 vout.P2.nSD 0.000175658f
Cred_1506 VDD.$1149.Metal2 vout.P2.pSD 0.000960013f
Cred_1507 VDD.$1161.Metal2 vin.$199.Metal1 4.89938e-06f
Cred_1508 VDD.$1161.Metal2 vin.$478.Metal2 0.00032377f
Cred_1509 VDD.$1161.Metal2 vin.$482.Metal2 0.00245579f
Cred_1510 VDD.$1161.Metal2 vin.P21.GatPoly 0.0137178f
Cred_1511 VDD.$1161.Metal2 vin.P22.GatPoly 3.46849e-06f
Cred_1512 VDD.$1161.Metal2 vout.$1226.Metal3 0.00261284f
Cred_1513 VDD.$1161.Metal2 vout.P0.nSD 7.78022e-05f
Cred_1514 VDD.$1161.Metal2 vout.P0.pSD 0.00172926f
Cred_1515 VDD.$1161.Metal2 vout.P2.nSD 4.11629e-05f
Cred_1516 VDD.$1161.Metal2 vout.P2.pSD 0.000224965f
Cred_1517 VDD.$1167.Metal2 vin.$15.GatPoly 0.0116364f
Cred_1518 VDD.$1167.Metal2 vin.$17.GatPoly 0.00245961f
Cred_1519 VDD.$1167.Metal2 vin.$207.Metal1 0.00302565f
Cred_1520 VDD.$1167.Metal2 vin.$211.Metal1 0.00710998f
Cred_1521 VDD.$1167.Metal2 vin.$219.Metal1 0.0011306f
Cred_1522 VDD.$1167.Metal2 vin.$482.Metal2 0.00380896f
Cred_1523 VDD.$1167.Metal2 vin.$483.Metal2 0.000268744f
Cred_1524 VDD.$1167.Metal2 vin.$486.Metal2 0.00268534f
Cred_1525 VDD.$1167.Metal2 vin.$488.Metal2 0.000303653f
Cred_1526 VDD.$1167.Metal2 vin.$489.Metal2 0.0130652f
Cred_1527 VDD.$1167.Metal2 vin.$493.Metal2 2.77014e-06f
Cred_1528 VDD.$1167.Metal2 vin.$9.GatPoly 0.010576f
Cred_1529 VDD.$1167.Metal2 vin.P20.GatPoly 0.000556007f
Cred_1530 VDD.$1167.Metal2 vin.P21.GatPoly 0.0417296f
Cred_1531 VDD.$1167.Metal2 vin.P22.GatPoly 0.03944f
Cred_1532 VDD.$1167.Metal2 vin.P23.GatPoly 0.000504254f
Cred_1533 VDD.$1167.Metal2 vout.$1226.Metal3 0.142075f
Cred_1534 VDD.$1167.Metal2 vout.P0.nSD 0.0031222f
Cred_1535 VDD.$1167.Metal2 vout.P0.pSD 0.0579984f
Cred_1536 VDD.$1167.Metal2 vout.P2.nSD 0.00223825f
Cred_1537 VDD.$1167.Metal2 vout.P2.pSD 0.0487223f
Cred_1538 VDD.$1188.Metal2 vin.$15.GatPoly 0.0156261f
Cred_1539 VDD.$1188.Metal2 vin.$17.GatPoly 0.00330292f
Cred_1540 VDD.$1188.Metal2 vin.$207.Metal1 0.00406301f
Cred_1541 VDD.$1188.Metal2 vin.$211.Metal1 0.00954892f
Cred_1542 VDD.$1188.Metal2 vin.$219.Metal1 0.00152696f
Cred_1543 VDD.$1188.Metal2 vin.$482.Metal2 0.0051149f
Cred_1544 VDD.$1188.Metal2 vin.$483.Metal2 0.000360885f
Cred_1545 VDD.$1188.Metal2 vin.$486.Metal2 0.00360603f
Cred_1546 VDD.$1188.Metal2 vin.$488.Metal2 0.000407762f
Cred_1547 VDD.$1188.Metal2 vin.$489.Metal2 0.0180701f
Cred_1548 VDD.$1188.Metal2 vin.$493.Metal2 0.000529102f
Cred_1549 VDD.$1188.Metal2 vin.$9.GatPoly 0.0142021f
Cred_1550 VDD.$1188.Metal2 vin.P20.GatPoly 0.000746638f
Cred_1551 VDD.$1188.Metal2 vin.P21.GatPoly 0.0532492f
Cred_1552 VDD.$1188.Metal2 vin.P22.GatPoly 0.0580956f
Cred_1553 VDD.$1188.Metal2 vin.P23.GatPoly 0.000677141f
Cred_1554 VDD.$1188.Metal2 vout.$1226.Metal3 0.190768f
Cred_1555 VDD.$1188.Metal2 vout.P0.nSD 0.00419214f
Cred_1556 VDD.$1188.Metal2 vout.P0.pSD 0.0778808f
Cred_1557 VDD.$1188.Metal2 vout.P2.nSD 0.00300538f
Cred_1558 VDD.$1188.Metal2 vout.P2.pSD 0.0654256f
Cred_1559 VDD.$1214.Metal2 vin.$17.GatPoly 1.4691e-08f
Cred_1560 VDD.$1214.Metal2 vin.$211.Metal1 1.2313e-06f
Cred_1561 VDD.$1214.Metal2 vin.$219.Metal1 8.72709e-06f
Cred_1562 VDD.$1214.Metal2 vin.$489.Metal2 0.000525395f
Cred_1563 VDD.$1214.Metal2 vin.$493.Metal2 0.00202723f
Cred_1564 VDD.$1214.Metal2 vin.P22.GatPoly 0.0126804f
Cred_1565 VDD.$1214.Metal2 vout.$1226.Metal3 0.00889619f
Cred_1566 VDD.$1214.Metal2 vout.P0.nSD 0.000128831f
Cred_1567 VDD.$1214.Metal2 vout.P0.pSD 0.000684585f
Cred_1568 VDD.$1214.Metal2 vout.P2.nSD 0.000140151f
Cred_1569 VDD.$1214.Metal2 vout.P2.pSD 0.00476899f
Cred_1570 VDD.$1226.Metal2 vin.$233.Metal1 3.89146e-06f
Cred_1571 VDD.$1226.Metal2 vin.$237.Metal1 5.23334e-06f
Cred_1572 VDD.$1226.Metal2 vin.$500.Metal2 0.00225034f
Cred_1573 VDD.$1226.Metal2 vin.$504.Metal2 0.000480303f
Cred_1574 VDD.$1226.Metal2 vin.P23.GatPoly 0.0135491f
Cred_1575 VDD.$1226.Metal2 vout.$1226.Metal3 0.00789829f
Cred_1576 VDD.$1226.Metal2 vout.P0.nSD 0.00011438f
Cred_1577 VDD.$1226.Metal2 vout.P0.pSD 0.000607794f
Cred_1578 VDD.$1226.Metal2 vout.P2.nSD 0.00012443f
Cred_1579 VDD.$1226.Metal2 vout.P2.pSD 0.00414183f
Cred_1580 VDD.$1253.Metal2 vin.$233.Metal1 3.89146e-06f
Cred_1581 VDD.$1253.Metal2 vin.$237.Metal1 0.00264365f
Cred_1582 VDD.$1253.Metal2 vin.$241.Metal1 0.0116473f
Cred_1583 VDD.$1253.Metal2 vin.$247.Metal1 0.00584252f
Cred_1584 VDD.$1253.Metal2 vin.$25.GatPoly 0.0200408f
Cred_1585 VDD.$1253.Metal2 vin.$251.Metal1 0.00197146f
Cred_1586 VDD.$1253.Metal2 vin.$37.GatPoly 0.0104572f
Cred_1587 VDD.$1253.Metal2 vin.$43.GatPoly 0.00372755f
Cred_1588 VDD.$1253.Metal2 vin.$500.Metal2 0.000480303f
Cred_1589 VDD.$1253.Metal2 vin.$503.Metal2 0.000527048f
Cred_1590 VDD.$1253.Metal2 vin.$504.Metal2 0.0189637f
Cred_1591 VDD.$1253.Metal2 vin.$506.Metal2 0.00266057f
Cred_1592 VDD.$1253.Metal2 vin.$508.Metal2 0.000383903f
Cred_1593 VDD.$1253.Metal2 vin.$509.Metal2 0.0110931f
Cred_1594 VDD.$1253.Metal2 vin.P22.GatPoly 0.000821871f
Cred_1595 VDD.$1253.Metal2 vin.P23.GatPoly 0.0687055f
Cred_1596 VDD.$1253.Metal2 vin.P24.GatPoly 0.0658192f
Cred_1597 VDD.$1253.Metal2 vin.P25.GatPoly 0.000821871f
Cred_1598 VDD.$1253.Metal2 vout.$1226.Metal3 0.265422f
Cred_1599 VDD.$1253.Metal2 vout.P0.nSD 0.00174934f
Cred_1600 VDD.$1253.Metal2 vout.P0.pSD 0.00929572f
Cred_1601 VDD.$1253.Metal2 vout.P2.nSD 0.00190306f
Cred_1602 VDD.$1253.Metal2 vout.P2.pSD 0.069744f
Cred_1603 VDD.$1253.Metal2 vout.P4.pSD 0.0601097f
Cred_1604 VDD.$1273.Metal2 vin.$237.Metal1 0.0011572f
Cred_1605 VDD.$1273.Metal2 vin.$241.Metal1 0.00510846f
Cred_1606 VDD.$1273.Metal2 vin.$247.Metal1 0.00257082f
Cred_1607 VDD.$1273.Metal2 vin.$25.GatPoly 0.00878981f
Cred_1608 VDD.$1273.Metal2 vin.$251.Metal1 0.000866641f
Cred_1609 VDD.$1273.Metal2 vin.$37.GatPoly 0.0045865f
Cred_1610 VDD.$1273.Metal2 vin.$43.GatPoly 0.00163489f
Cred_1611 VDD.$1273.Metal2 vin.$503.Metal2 0.000231161f
Cred_1612 VDD.$1273.Metal2 vin.$504.Metal2 0.00810676f
Cred_1613 VDD.$1273.Metal2 vin.$506.Metal2 0.00116692f
Cred_1614 VDD.$1273.Metal2 vin.$508.Metal2 0.000168378f
Cred_1615 VDD.$1273.Metal2 vin.$509.Metal2 0.00540567f
Cred_1616 VDD.$1273.Metal2 vin.$513.Metal2 0.000540282f
Cred_1617 VDD.$1273.Metal2 vin.P22.GatPoly 0.00036047f
Cred_1618 VDD.$1273.Metal2 vin.P23.GatPoly 0.0280358f
Cred_1619 VDD.$1273.Metal2 vin.P24.GatPoly 0.0379316f
Cred_1620 VDD.$1273.Metal2 vin.P25.GatPoly 0.00036047f
Cred_1621 VDD.$1273.Metal2 vout.$1226.Metal3 0.116413f
Cred_1622 VDD.$1273.Metal2 vout.P0.nSD 0.000766869f
Cred_1623 VDD.$1273.Metal2 vout.P0.pSD 0.00407501f
Cred_1624 VDD.$1273.Metal2 vout.P2.nSD 0.000834254f
Cred_1625 VDD.$1273.Metal2 vout.P2.pSD 0.0305839f
Cred_1626 VDD.$1273.Metal2 vout.P4.pSD 0.0263679f
Cred_1627 VDD.$1285.Metal2 vin.$247.Metal1 8.3169e-06f
Cred_1628 VDD.$1285.Metal2 vin.$251.Metal1 1.96581e-06f
Cred_1629 VDD.$1285.Metal2 vin.$509.Metal2 0.000540294f
Cred_1630 VDD.$1285.Metal2 vin.$513.Metal2 0.000540294f
Cred_1631 VDD.$1285.Metal2 vin.P24.GatPoly 0.0109148f
Cred_1632 VDD.$1285.Metal2 vin.P25.GatPoly 0.000513126f
Cred_1633 VDD.$1285.Metal2 vout.$1226.Metal3 0.0129665f
Cred_1634 VDD.$1285.Metal2 vout.P4.pSD 0.00508524f
Cred_1635 VDD.$1297.Metal2 vin.$263.Metal1 3.43442e-06f
Cred_1636 VDD.$1297.Metal2 vin.$269.Metal1 3.53755e-06f
Cred_1637 VDD.$1297.Metal2 vin.$51.GatPoly 4.0777e-08f
Cred_1638 VDD.$1297.Metal2 vin.$520.Metal2 0.00257011f
Cred_1639 VDD.$1297.Metal2 vin.$524.Metal2 0.000370966f
Cred_1640 VDD.$1297.Metal2 vin.P25.GatPoly 0.0148191f
Cred_1641 VDD.$1297.Metal2 vout.$1226.Metal3 0.00676483f
Cred_1642 VDD.$1297.Metal2 vout.P4.pSD 0.00241725f
Cred_1643 VDD.$130.Metal1 vin.$199.Metal1 0.0251623f
Cred_1644 VDD.$130.Metal1 vin.$478.Metal2 0.00163022f
Cred_1645 VDD.$130.Metal1 vin.$7.GatPoly 0.00533475f
Cred_1646 VDD.$130.Metal1 vin.P20.GatPoly 0.0376117f
Cred_1647 VDD.$130.Metal1 vout.$1226.Metal3 0.0223393f
Cred_1648 VDD.$130.Metal1 vout.P0.nSD 0.000665193f
Cred_1649 VDD.$130.Metal1 vout.P0.pSD 0.0297589f
Cred_1650 VDD.$130.Metal1 vout.P2.nSD 0.000351935f
Cred_1651 VDD.$130.Metal1 vout.P2.pSD 0.0019234f
Cred_1652 VDD.$130.Metal1 VSS.$18.Metal1 0.00230976f
Cred_1653 VDD.$130.Metal1 VSS.$40.Metal1 0.000952049f
Cred_1654 VDD.$130.Metal1 VSS.$551.Metal1 1.98594e-06f
Cred_1655 VDD.$130.Metal1 VSS.$564.Metal2 0.000963592f
Cred_1656 VDD.$130.Metal1 VSS.P0.nSD 2.38867e-07f
Cred_1657 VDD.$130.Metal1 VSS.P0.pSD 0.00811054f
Cred_1658 VDD.$130.Metal1 VSS.P1.nSD 2.38867e-07f
Cred_1659 VDD.$131.Metal1 vin.P20.GatPoly 0.0123329f
Cred_1660 VDD.$131.Metal1 vout.$1226.Metal3 0.00392215f
Cred_1661 VDD.$131.Metal1 vout.P0.nSD 0.000116789f
Cred_1662 VDD.$131.Metal1 vout.P0.pSD 0.00532944f
Cred_1663 VDD.$131.Metal1 vout.P2.nSD 6.17898e-05f
Cred_1664 VDD.$131.Metal1 vout.P2.pSD 0.000337695f
Cred_1665 VDD.$132.Metal1 vin.P20.GatPoly 0.0124067f
Cred_1666 VDD.$132.Metal1 vout.$1226.Metal3 0.00391159f
Cred_1667 VDD.$132.Metal1 vout.P0.nSD 0.000116475f
Cred_1668 VDD.$132.Metal1 vout.P0.pSD 0.00534617f
Cred_1669 VDD.$132.Metal1 vout.P2.nSD 6.16235e-05f
Cred_1670 VDD.$132.Metal1 vout.P2.pSD 0.000336786f
Cred_1671 VDD.$1324.Metal2 vin.$259.Metal1 0.00148763f
Cred_1672 VDD.$1324.Metal2 vin.$263.Metal1 0.00454068f
Cred_1673 VDD.$1324.Metal2 vin.$269.Metal1 0.0151715f
Cred_1674 VDD.$1324.Metal2 vin.$277.Metal1 0.00334684f
Cred_1675 VDD.$1324.Metal2 vin.$43.GatPoly 0.00281274f
Cred_1676 VDD.$1324.Metal2 vin.$51.GatPoly 0.0130725f
Cred_1677 VDD.$1324.Metal2 vin.$520.Metal2 0.00301898f
Cred_1678 VDD.$1324.Metal2 vin.$523.Metal2 0.000707297f
Cred_1679 VDD.$1324.Metal2 vin.$524.Metal2 0.0279338f
Cred_1680 VDD.$1324.Metal2 vin.$526.Metal2 0.00331154f
Cred_1681 VDD.$1324.Metal2 vin.$528.Metal2 2.68594e-05f
Cred_1682 VDD.$1324.Metal2 vin.$529.Metal2 0.00710277f
Cred_1683 VDD.$1324.Metal2 vin.$55.GatPoly 0.00451003f
Cred_1684 VDD.$1324.Metal2 vin.$57.GatPoly 0.0226445f
Cred_1685 VDD.$1324.Metal2 vin.P24.GatPoly 0.00100239f
Cred_1686 VDD.$1324.Metal2 vin.P25.GatPoly 0.0758843f
Cred_1687 VDD.$1324.Metal2 vin.P26.GatPoly 0.0691105f
Cred_1688 VDD.$1324.Metal2 vin.P27.GatPoly 0.00100239f
Cred_1689 VDD.$1324.Metal2 vout.$1226.Metal3 0.268905f
Cred_1690 VDD.$1324.Metal2 vout.$1292.Metal3 0.0869188f
Cred_1691 VDD.$1324.Metal2 vout.P4.pSD 0.0738071f
Cred_1692 VDD.$1324.Metal2 vout.P6.nSD 0.00136932f
Cred_1693 VDD.$1324.Metal2 vout.P6.pSD 0.0801377f
Cred_1694 VDD.$133.Metal1 vin.P20.GatPoly 0.0124057f
Cred_1695 VDD.$133.Metal1 vout.$1226.Metal3 0.00390483f
Cred_1696 VDD.$133.Metal1 vout.P0.nSD 0.000116273f
Cred_1697 VDD.$133.Metal1 vout.P0.pSD 0.00534639f
Cred_1698 VDD.$133.Metal1 vout.P2.nSD 6.15169e-05f
Cred_1699 VDD.$133.Metal1 vout.P2.pSD 0.000336204f
Cred_1700 VDD.$134.Metal1 vin.P20.GatPoly 0.0123219f
Cred_1701 VDD.$134.Metal1 vout.$1226.Metal3 0.00387998f
Cred_1702 VDD.$134.Metal1 vout.P0.nSD 0.000115533f
Cred_1703 VDD.$134.Metal1 vout.P0.pSD 0.00531606f
Cred_1704 VDD.$134.Metal1 vout.P2.nSD 6.11254e-05f
Cred_1705 VDD.$134.Metal1 vout.P2.pSD 0.000334064f
Cred_1706 VDD.$1344.Metal2 vin.$259.Metal1 5.64922e-05f
Cred_1707 VDD.$1344.Metal2 vin.$263.Metal1 0.0001723f
Cred_1708 VDD.$1344.Metal2 vin.$269.Metal1 0.000575999f
Cred_1709 VDD.$1344.Metal2 vin.$277.Metal1 0.000127095f
Cred_1710 VDD.$1344.Metal2 vin.$43.GatPoly 0.000106813f
Cred_1711 VDD.$1344.Metal2 vin.$51.GatPoly 0.000496421f
Cred_1712 VDD.$1344.Metal2 vin.$520.Metal2 0.000100558f
Cred_1713 VDD.$1344.Metal2 vin.$523.Metal2 2.68594e-05f
Cred_1714 VDD.$1344.Metal2 vin.$524.Metal2 0.00104669f
Cred_1715 VDD.$1344.Metal2 vin.$526.Metal2 0.000125755f
Cred_1716 VDD.$1344.Metal2 vin.$528.Metal2 1.01998e-06f
Cred_1717 VDD.$1344.Metal2 vin.$529.Metal2 0.00164377f
Cred_1718 VDD.$1344.Metal2 vin.$55.GatPoly 0.000171267f
Cred_1719 VDD.$1344.Metal2 vin.$57.GatPoly 0.000859917f
Cred_1720 VDD.$1344.Metal2 vin.P24.GatPoly 3.80654e-05f
Cred_1721 VDD.$1344.Metal2 vin.P25.GatPoly 0.00274447f
Cred_1722 VDD.$1344.Metal2 vin.P26.GatPoly 0.00933798f
Cred_1723 VDD.$1344.Metal2 vin.P27.GatPoly 3.80654e-05f
Cred_1724 VDD.$1344.Metal2 vout.$1226.Metal3 0.0102383f
Cred_1725 VDD.$1344.Metal2 vout.$1292.Metal3 0.00332266f
Cred_1726 VDD.$1344.Metal2 vout.P4.pSD 0.0028028f
Cred_1727 VDD.$1344.Metal2 vout.P6.nSD 5.23454e-05f
Cred_1728 VDD.$1344.Metal2 vout.P6.pSD 0.00304844f
Cred_1729 VDD.$135.Metal1 vin.P20.GatPoly 0.0123188f
Cred_1730 VDD.$135.Metal1 vout.$1226.Metal3 0.00386205f
Cred_1731 VDD.$135.Metal1 vout.P0.nSD 0.000115f
Cred_1732 VDD.$135.Metal1 vout.P0.pSD 0.00531187f
Cred_1733 VDD.$135.Metal1 vout.P2.nSD 6.08429e-05f
Cred_1734 VDD.$135.Metal1 vout.P2.pSD 0.000332521f
Cred_1735 VDD.$1350.Metal2 vin.$277.Metal1 7.60954e-06f
Cred_1736 VDD.$1350.Metal2 vin.$281.Metal1 1.30884e-05f
Cred_1737 VDD.$1350.Metal2 vin.$529.Metal2 0.00108922f
Cred_1738 VDD.$1350.Metal2 vin.$533.Metal2 0.00108922f
Cred_1739 VDD.$1350.Metal2 vin.P26.GatPoly 0.0116388f
Cred_1740 VDD.$1350.Metal2 vout.$1226.Metal3 0.00295021f
Cred_1741 VDD.$1350.Metal2 vout.$1292.Metal3 0.00294768f
Cred_1742 VDD.$1350.Metal2 vout.P6.nSD 4.64379e-05f
Cred_1743 VDD.$1350.Metal2 vout.P6.pSD 0.00251262f
Cred_1744 VDD.$136.Metal1 vin 0.000850787f
Cred_1745 VDD.$136.Metal1 vin.$105.GatPoly 4.88659e-06f
Cred_1746 VDD.$136.Metal1 vin.$107.GatPoly 3.30442e-06f
Cred_1747 VDD.$136.Metal1 vin.$115.GatPoly 3.99406e-06f
Cred_1748 VDD.$136.Metal1 vin.$123.GatPoly 3.16118e-06f
Cred_1749 VDD.$136.Metal1 vin.$127.GatPoly 1.66734e-06f
Cred_1750 VDD.$136.Metal1 vin.$133.GatPoly 1.63937e-06f
Cred_1751 VDD.$136.Metal1 vin.$139.GatPoly 1.67476e-06f
Cred_1752 VDD.$136.Metal1 vin.$145.GatPoly 1.49593e-06f
Cred_1753 VDD.$136.Metal1 vin.$15.GatPoly 8.00896e-05f
Cred_1754 VDD.$136.Metal1 vin.$153.GatPoly 1.13778e-06f
Cred_1755 VDD.$136.Metal1 vin.$157.GatPoly 6.24154e-07f
Cred_1756 VDD.$136.Metal1 vin.$163.GatPoly 6.28889e-07f
Cred_1757 VDD.$136.Metal1 vin.$167.GatPoly 4.7137e-07f
Cred_1758 VDD.$136.Metal1 vin.$17.GatPoly 0.000103586f
Cred_1759 VDD.$136.Metal1 vin.$173.GatPoly 4.3277e-07f
Cred_1760 VDD.$136.Metal1 vin.$179.GatPoly 6.26625e-07f
Cred_1761 VDD.$136.Metal1 vin.$199.Metal1 0.00548359f
Cred_1762 VDD.$136.Metal1 vin.$207.Metal1 0.00148523f
Cred_1763 VDD.$136.Metal1 vin.$211.Metal1 0.00123493f
Cred_1764 VDD.$136.Metal1 vin.$219.Metal1 0.00150103f
Cred_1765 VDD.$136.Metal1 vin.$227.Metal1 0.00119556f
Cred_1766 VDD.$136.Metal1 vin.$233.Metal1 0.000739479f
Cred_1767 VDD.$136.Metal1 vin.$237.Metal1 0.000480245f
Cred_1768 VDD.$136.Metal1 vin.$241.Metal1 0.00061219f
Cred_1769 VDD.$136.Metal1 vin.$247.Metal1 0.000557543f
Cred_1770 VDD.$136.Metal1 vin.$25.GatPoly 5.33443e-05f
Cred_1771 VDD.$136.Metal1 vin.$251.Metal1 0.000482486f
Cred_1772 VDD.$136.Metal1 vin.$259.Metal1 0.000433033f
Cred_1773 VDD.$136.Metal1 vin.$263.Metal1 0.000380629f
Cred_1774 VDD.$136.Metal1 vin.$269.Metal1 0.000428277f
Cred_1775 VDD.$136.Metal1 vin.$27.GatPoly 7.56093e-05f
Cred_1776 VDD.$136.Metal1 vin.$277.Metal1 0.000280633f
Cred_1777 VDD.$136.Metal1 vin.$281.Metal1 0.000175197f
Cred_1778 VDD.$136.Metal1 vin.$285.Metal1 0.00021885f
Cred_1779 VDD.$136.Metal1 vin.$291.Metal1 0.000206153f
Cred_1780 VDD.$136.Metal1 vin.$295.Metal1 0.00017344f
Cred_1781 VDD.$136.Metal1 vin.$303.Metal1 0.000152966f
Cred_1782 VDD.$136.Metal1 vin.$307.Metal1 0.000138731f
Cred_1783 VDD.$136.Metal1 vin.$313.Metal1 0.000119554f
Cred_1784 VDD.$136.Metal1 vin.$317.Metal1 7.09154e-05f
Cred_1785 VDD.$136.Metal1 vin.$321.Metal1 6.7258e-05f
Cred_1786 VDD.$136.Metal1 vin.$325.Metal1 6.19293e-05f
Cred_1787 VDD.$136.Metal1 vin.$329.Metal1 7.97241e-05f
Cred_1788 VDD.$136.Metal1 vin.$335.Metal1 7.15078e-05f
Cred_1789 VDD.$136.Metal1 vin.$339.Metal1 4.36522e-05f
Cred_1790 VDD.$136.Metal1 vin.$343.Metal1 3.91708e-05f
Cred_1791 VDD.$136.Metal1 vin.$347.Metal1 5.26472e-05f
Cred_1792 VDD.$136.Metal1 vin.$353.Metal1 4.86046e-05f
Cred_1793 VDD.$136.Metal1 vin.$357.Metal1 4.01585e-05f
Cred_1794 VDD.$136.Metal1 vin.$365.Metal1 3.62116e-05f
Cred_1795 VDD.$136.Metal1 vin.$369.Metal1 3.28221e-05f
Cred_1796 VDD.$136.Metal1 vin.$37.GatPoly 6.46229e-05f
Cred_1797 VDD.$136.Metal1 vin.$375.Metal1 2.74613e-05f
Cred_1798 VDD.$136.Metal1 vin.$379.Metal1 1.74015e-05f
Cred_1799 VDD.$136.Metal1 vin.$383.Metal1 2.23431e-05f
Cred_1800 VDD.$136.Metal1 vin.$391.Metal1 2.57236e-05f
Cred_1801 VDD.$136.Metal1 vin.$397.Metal1 1.70828e-05f
Cred_1802 VDD.$136.Metal1 vin.$401.Metal1 1.45711e-05f
Cred_1803 VDD.$136.Metal1 vin.$409.Metal1 1.295e-05f
Cred_1804 VDD.$136.Metal1 vin.$413.Metal1 1.1375e-05f
Cred_1805 VDD.$136.Metal1 vin.$419.Metal1 9.84723e-06f
Cred_1806 VDD.$136.Metal1 vin.$423.Metal1 6.10126e-06f
Cred_1807 VDD.$136.Metal1 vin.$427.Metal1 7.63134e-06f
Cred_1808 VDD.$136.Metal1 vin.$43.GatPoly 5.03827e-05f
Cred_1809 VDD.$136.Metal1 vin.$433.Metal1 9.28205e-06f
Cred_1810 VDD.$136.Metal1 vin.$441.Metal1 8.23873e-06f
Cred_1811 VDD.$136.Metal1 vin.$449.Metal1 5.03019e-06f
Cred_1812 VDD.$136.Metal1 vin.$453.Metal1 3.07412e-06f
Cred_1813 VDD.$136.Metal1 vin.$457.Metal1 1.12075e-05f
Cred_1814 VDD.$136.Metal1 vin.$476.Metal2 5.69397e-06f
Cred_1815 VDD.$136.Metal1 vin.$478.Metal2 0.00185483f
Cred_1816 VDD.$136.Metal1 vin.$482.Metal2 0.000434348f
Cred_1817 VDD.$136.Metal1 vin.$486.Metal2 0.00109736f
Cred_1818 VDD.$136.Metal1 vin.$489.Metal2 0.000609995f
Cred_1819 VDD.$136.Metal1 vin.$493.Metal2 0.000376294f
Cred_1820 VDD.$136.Metal1 vin.$495.Metal2 0.000829802f
Cred_1821 VDD.$136.Metal1 vin.$500.Metal2 0.000335989f
Cred_1822 VDD.$136.Metal1 vin.$504.Metal2 0.000285298f
Cred_1823 VDD.$136.Metal1 vin.$506.Metal2 0.000538335f
Cred_1824 VDD.$136.Metal1 vin.$509.Metal2 0.000172978f
Cred_1825 VDD.$136.Metal1 vin.$51.GatPoly 3.47838e-05f
Cred_1826 VDD.$136.Metal1 vin.$513.Metal2 0.000150186f
Cred_1827 VDD.$136.Metal1 vin.$515.Metal2 0.000382268f
Cred_1828 VDD.$136.Metal1 vin.$518.Metal2 0.000164694f
Cred_1829 VDD.$136.Metal1 vin.$520.Metal2 7.18461e-05f
Cred_1830 VDD.$136.Metal1 vin.$524.Metal2 0.000191318f
Cred_1831 VDD.$136.Metal1 vin.$526.Metal2 0.000251753f
Cred_1832 VDD.$136.Metal1 vin.$529.Metal2 5.85586e-05f
Cred_1833 VDD.$136.Metal1 vin.$533.Metal2 9.47923e-05f
Cred_1834 VDD.$136.Metal1 vin.$535.Metal2 0.000191869f
Cred_1835 VDD.$136.Metal1 vin.$538.Metal2 6.92135e-05f
Cred_1836 VDD.$136.Metal1 vin.$542.Metal2 4.7194e-05f
Cred_1837 VDD.$136.Metal1 vin.$544.Metal2 0.000127038f
Cred_1838 VDD.$136.Metal1 vin.$547.Metal2 7.33723e-05f
Cred_1839 VDD.$136.Metal1 vin.$55.GatPoly 2.39836e-05f
Cred_1840 VDD.$136.Metal1 vin.$551.Metal2 4.64045e-05f
Cred_1841 VDD.$136.Metal1 vin.$555.Metal2 0.000102902f
Cred_1842 VDD.$136.Metal1 vin.$558.Metal2 4.27462e-05f
Cred_1843 VDD.$136.Metal1 vin.$562.Metal2 3.01573e-05f
Cred_1844 VDD.$136.Metal1 vin.$564.Metal2 6.8075e-05f
Cred_1845 VDD.$136.Metal1 vin.$567.Metal2 2.79626e-05f
Cred_1846 VDD.$136.Metal1 vin.$57.GatPoly 1.79666e-05f
Cred_1847 VDD.$136.Metal1 vin.$571.Metal2 2.48243e-05f
Cred_1848 VDD.$136.Metal1 vin.$573.Metal2 5.22902e-05f
Cred_1849 VDD.$136.Metal1 vin.$578.Metal2 2.03886e-05f
Cred_1850 VDD.$136.Metal1 vin.$582.Metal2 1.91602e-05f
Cred_1851 VDD.$136.Metal1 vin.$584.Metal2 3.17905e-05f
Cred_1852 VDD.$136.Metal1 vin.$587.Metal2 1.00822e-05f
Cred_1853 VDD.$136.Metal1 vin.$591.Metal2 9.35513e-06f
Cred_1854 VDD.$136.Metal1 vin.$593.Metal2 2.38981e-05f
Cred_1855 VDD.$136.Metal1 vin.$596.Metal2 1.06557e-05f
Cred_1856 VDD.$136.Metal1 vin.$600.Metal2 4.73432e-06f
Cred_1857 VDD.$136.Metal1 vin.$602.Metal2 1.57297e-05f
Cred_1858 VDD.$136.Metal1 vin.$605.Metal2 1.12388e-05f
Cred_1859 VDD.$136.Metal1 vin.$609.Metal2 3.14385e-06f
Cred_1860 VDD.$136.Metal1 vin.$611.Metal2 5.03521e-06f
Cred_1861 VDD.$136.Metal1 vin.$613.Metal2 1.18718e-05f
Cred_1862 VDD.$136.Metal1 vin.$616.Metal2 4.0208e-06f
Cred_1863 VDD.$136.Metal1 vin.$620.Metal2 3.02833e-06f
Cred_1864 VDD.$136.Metal1 vin.$622.Metal2 8.39267e-06f
Cred_1865 VDD.$136.Metal1 vin.$625.Metal2 4.09868e-06f
Cred_1866 VDD.$136.Metal1 vin.$629.Metal2 3.01966e-06f
Cred_1867 VDD.$136.Metal1 vin.$633.Metal2 6.43567e-06f
Cred_1868 VDD.$136.Metal1 vin.$636.Metal2 2.55832e-06f
Cred_1869 VDD.$136.Metal1 vin.$640.Metal2 2.00603e-06f
Cred_1870 VDD.$136.Metal1 vin.$642.Metal2 5.36257e-06f
Cred_1871 VDD.$136.Metal1 vin.$645.Metal2 1.51226e-06f
Cred_1872 VDD.$136.Metal1 vin.$648.Metal2 7.59624e-08f
Cred_1873 VDD.$136.Metal1 vin.$649.Metal2 1.19061e-06f
Cred_1874 VDD.$136.Metal1 vin.$65.GatPoly 2.29387e-05f
Cred_1875 VDD.$136.Metal1 vin.$653.Metal2 2.90444e-07f
Cred_1876 VDD.$136.Metal1 vin.$654.Metal2 2.59343e-06f
Cred_1877 VDD.$136.Metal1 vin.$7.GatPoly 0.000219133f
Cred_1878 VDD.$136.Metal1 vin.$73.GatPoly 1.74446e-05f
Cred_1879 VDD.$136.Metal1 vin.$77.GatPoly 9.84365e-06f
Cred_1880 VDD.$136.Metal1 vin.$83.GatPoly 1.03809e-05f
Cred_1881 VDD.$136.Metal1 vin.$87.GatPoly 8.14351e-06f
Cred_1882 VDD.$136.Metal1 vin.$9.GatPoly 0.000120424f
Cred_1883 VDD.$136.Metal1 vin.$95.GatPoly 7.82842e-06f
Cred_1884 VDD.$136.Metal1 vin.$97.GatPoly 4.46387e-06f
Cred_1885 VDD.$136.Metal1 vin.P20.GatPoly 0.0132278f
Cred_1886 VDD.$136.Metal1 vin.P24.GatPoly 4.89063e-06f
Cred_1887 VDD.$136.Metal1 vin.P25.GatPoly 2.8729e-06f
Cred_1888 VDD.$136.Metal1 vin.P27.GatPoly 1.72351e-06f
Cred_1889 VDD.$136.Metal1 vin.P32.GatPoly 3.04067e-07f
Cred_1890 VDD.$136.Metal1 vin.P34.GatPoly 1.14046e-07f
Cred_1891 VDD.$136.Metal1 vin.P35.GatPoly 1.09297e-07f
Cred_1892 VDD.$136.Metal1 vin.P39.GatPoly 1.02976e-06f
Cred_1893 VDD.$136.Metal1 vout 1.51834e-06f
Cred_1894 VDD.$136.Metal1 vout.$1226.Metal3 0.00491837f
Cred_1895 VDD.$136.Metal1 vout.$1292.Metal3 8.65368e-05f
Cred_1896 VDD.$136.Metal1 vout.$1358.Metal3 2.32596e-05f
Cred_1897 VDD.$136.Metal1 vout.$1424.Metal3 5.00098e-06f
Cred_1898 VDD.$136.Metal1 vout.P0.nSD 0.000137331f
Cred_1899 VDD.$136.Metal1 vout.P0.pSD 0.00530731f
Cred_1900 VDD.$136.Metal1 vout.P10.nSD 1.59261e-07f
Cred_1901 VDD.$136.Metal1 vout.P10.pSD 8.62566e-07f
Cred_1902 VDD.$136.Metal1 vout.P14.nSD 3.98291e-08f
Cred_1903 VDD.$136.Metal1 vout.P14.pSD 2.15717e-07f
Cred_1904 VDD.$136.Metal1 vout.P2.nSD 7.44387e-05f
Cred_1905 VDD.$136.Metal1 vout.P2.pSD 0.000406825f
Cred_1906 VDD.$136.Metal1 vout.P6.nSD 5.85858e-07f
Cred_1907 VDD.$136.Metal1 vout.P6.pSD 3.20185e-06f
Cred_1908 VDD.$136.Metal1 VSS.$1040.Metal2 1.74624e-10f
Cred_1909 VDD.$136.Metal1 VSS.$1066.Metal2 3.65645e-08f
Cred_1910 VDD.$136.Metal1 VSS.$18.Metal1 0.00210124f
Cred_1911 VDD.$136.Metal1 VSS.$40.Metal1 0.0015311f
Cred_1912 VDD.$136.Metal1 VSS.$488.Metal1 2.09007e-08f
Cred_1913 VDD.$136.Metal1 VSS.$498.Metal1 4.3839e-08f
Cred_1914 VDD.$136.Metal1 VSS.$509.Metal1 4.52263e-07f
Cred_1915 VDD.$136.Metal1 VSS.$551.Metal1 1.22609e-05f
Cred_1916 VDD.$136.Metal1 VSS.$564.Metal2 0.000128652f
Cred_1917 VDD.$136.Metal1 VSS.$605.Metal2 1.52627e-07f
Cred_1918 VDD.$136.Metal1 VSS.$65.Metal1 3.83167e-05f
Cred_1919 VDD.$136.Metal1 VSS.$75.Metal1 1.82679e-05f
Cred_1920 VDD.$136.Metal1 VSS.P0.nSD 4.65098e-06f
Cred_1921 VDD.$136.Metal1 VSS.P0.pSD 0.0100906f
Cred_1922 VDD.$136.Metal1 VSS.P1.nSD 4.65098e-06f
Cred_1923 VDD.$136.Metal1 VSS.P21.nSD 2.95402e-09f
Cred_1924 VDD.$136.Metal1 VSS.P23.nSD 2.95402e-09f
Cred_1925 VDD.$1362.Metal2 vin.$291.Metal1 7.70709e-06f
Cred_1926 VDD.$1362.Metal2 vin.$295.Metal1 2.56903e-06f
Cred_1927 VDD.$1362.Metal2 vin.$538.Metal2 0.000540297f
Cred_1928 VDD.$1362.Metal2 vin.$542.Metal2 0.000540297f
Cred_1929 VDD.$1362.Metal2 vin.P26.GatPoly 0.000898184f
Cred_1930 VDD.$1362.Metal2 vin.P27.GatPoly 0.00997148f
Cred_1931 VDD.$1362.Metal2 vout.$1226.Metal3 0.00624682f
Cred_1932 VDD.$1362.Metal2 vout.$1292.Metal3 0.00624682f
Cred_1933 VDD.$1362.Metal2 vout.P6.nSD 9.84127e-05f
Cred_1934 VDD.$1362.Metal2 vout.P6.pSD 0.00579896f
Cred_1935 VDD.$137.Metal1 vin 0.000953301f
Cred_1936 VDD.$137.Metal1 vin.$105.GatPoly 5.47539e-06f
Cred_1937 VDD.$137.Metal1 vin.$107.GatPoly 3.70258e-06f
Cred_1938 VDD.$137.Metal1 vin.$115.GatPoly 4.47531e-06f
Cred_1939 VDD.$137.Metal1 vin.$123.GatPoly 3.54208e-06f
Cred_1940 VDD.$137.Metal1 vin.$127.GatPoly 1.86824e-06f
Cred_1941 VDD.$137.Metal1 vin.$133.GatPoly 1.8369e-06f
Cred_1942 VDD.$137.Metal1 vin.$139.GatPoly 1.87656e-06f
Cred_1943 VDD.$137.Metal1 vin.$145.GatPoly 1.67618e-06f
Cred_1944 VDD.$137.Metal1 vin.$15.GatPoly 8.97398e-05f
Cred_1945 VDD.$137.Metal1 vin.$153.GatPoly 1.27487e-06f
Cred_1946 VDD.$137.Metal1 vin.$157.GatPoly 6.99361e-07f
Cred_1947 VDD.$137.Metal1 vin.$163.GatPoly 7.04666e-07f
Cred_1948 VDD.$137.Metal1 vin.$167.GatPoly 5.28167e-07f
Cred_1949 VDD.$137.Metal1 vin.$17.GatPoly 0.000116068f
Cred_1950 VDD.$137.Metal1 vin.$173.GatPoly 4.84916e-07f
Cred_1951 VDD.$137.Metal1 vin.$179.GatPoly 7.02129e-07f
Cred_1952 VDD.$137.Metal1 vin.$199.Metal1 0.00614432f
Cred_1953 VDD.$137.Metal1 vin.$207.Metal1 0.00166419f
Cred_1954 VDD.$137.Metal1 vin.$211.Metal1 0.00138373f
Cred_1955 VDD.$137.Metal1 vin.$219.Metal1 0.00168189f
Cred_1956 VDD.$137.Metal1 vin.$227.Metal1 0.00133962f
Cred_1957 VDD.$137.Metal1 vin.$233.Metal1 0.000828581f
Cred_1958 VDD.$137.Metal1 vin.$237.Metal1 0.000538111f
Cred_1959 VDD.$137.Metal1 vin.$241.Metal1 0.000685955f
Cred_1960 VDD.$137.Metal1 vin.$247.Metal1 0.000624723f
Cred_1961 VDD.$137.Metal1 vin.$25.GatPoly 5.97719e-05f
Cred_1962 VDD.$137.Metal1 vin.$251.Metal1 0.000540622f
Cred_1963 VDD.$137.Metal1 vin.$259.Metal1 0.00048521f
Cred_1964 VDD.$137.Metal1 vin.$263.Metal1 0.000426493f
Cred_1965 VDD.$137.Metal1 vin.$269.Metal1 0.000479882f
Cred_1966 VDD.$137.Metal1 vin.$27.GatPoly 8.47198e-05f
Cred_1967 VDD.$137.Metal1 vin.$277.Metal1 0.000314448f
Cred_1968 VDD.$137.Metal1 vin.$281.Metal1 0.000196307f
Cred_1969 VDD.$137.Metal1 vin.$285.Metal1 0.00024522f
Cred_1970 VDD.$137.Metal1 vin.$291.Metal1 0.000230993f
Cred_1971 VDD.$137.Metal1 vin.$295.Metal1 0.000194339f
Cred_1972 VDD.$137.Metal1 vin.$303.Metal1 0.000171397f
Cred_1973 VDD.$137.Metal1 vin.$307.Metal1 0.000155447f
Cred_1974 VDD.$137.Metal1 vin.$313.Metal1 0.000133959f
Cred_1975 VDD.$137.Metal1 vin.$317.Metal1 7.94602e-05f
Cred_1976 VDD.$137.Metal1 vin.$321.Metal1 7.53622e-05f
Cred_1977 VDD.$137.Metal1 vin.$325.Metal1 6.93914e-05f
Cred_1978 VDD.$137.Metal1 vin.$329.Metal1 8.93303e-05f
Cred_1979 VDD.$137.Metal1 vin.$335.Metal1 8.0124e-05f
Cred_1980 VDD.$137.Metal1 vin.$339.Metal1 4.8912e-05f
Cred_1981 VDD.$137.Metal1 vin.$343.Metal1 4.38906e-05f
Cred_1982 VDD.$137.Metal1 vin.$347.Metal1 5.89908e-05f
Cred_1983 VDD.$137.Metal1 vin.$353.Metal1 5.44611e-05f
Cred_1984 VDD.$137.Metal1 vin.$357.Metal1 4.49973e-05f
Cred_1985 VDD.$137.Metal1 vin.$365.Metal1 4.05749e-05f
Cred_1986 VDD.$137.Metal1 vin.$369.Metal1 3.67769e-05f
Cred_1987 VDD.$137.Metal1 vin.$37.GatPoly 7.24095e-05f
Cred_1988 VDD.$137.Metal1 vin.$375.Metal1 3.07702e-05f
Cred_1989 VDD.$137.Metal1 vin.$379.Metal1 1.94982e-05f
Cred_1990 VDD.$137.Metal1 vin.$383.Metal1 2.50353e-05f
Cred_1991 VDD.$137.Metal1 vin.$391.Metal1 2.88231e-05f
Cred_1992 VDD.$137.Metal1 vin.$397.Metal1 1.91411e-05f
Cred_1993 VDD.$137.Metal1 vin.$401.Metal1 1.63269e-05f
Cred_1994 VDD.$137.Metal1 vin.$409.Metal1 1.45104e-05f
Cred_1995 VDD.$137.Metal1 vin.$413.Metal1 1.27456e-05f
Cred_1996 VDD.$137.Metal1 vin.$419.Metal1 1.10338e-05f
Cred_1997 VDD.$137.Metal1 vin.$423.Metal1 6.83642e-06f
Cred_1998 VDD.$137.Metal1 vin.$427.Metal1 8.55087e-06f
Cred_1999 VDD.$137.Metal1 vin.$43.GatPoly 5.64535e-05f
Cred_2000 VDD.$137.Metal1 vin.$433.Metal1 1.04005e-05f
Cred_2001 VDD.$137.Metal1 vin.$441.Metal1 9.23144e-06f
Cred_2002 VDD.$137.Metal1 vin.$449.Metal1 5.6363e-06f
Cred_2003 VDD.$137.Metal1 vin.$453.Metal1 3.44453e-06f
Cred_2004 VDD.$137.Metal1 vin.$457.Metal1 1.2558e-05f
Cred_2005 VDD.$137.Metal1 vin.$476.Metal2 6.38005e-06f
Cred_2006 VDD.$137.Metal1 vin.$478.Metal2 0.00207833f
Cred_2007 VDD.$137.Metal1 vin.$482.Metal2 0.000486684f
Cred_2008 VDD.$137.Metal1 vin.$486.Metal2 0.00122959f
Cred_2009 VDD.$137.Metal1 vin.$489.Metal2 0.000683496f
Cred_2010 VDD.$137.Metal1 vin.$493.Metal2 0.000421635f
Cred_2011 VDD.$137.Metal1 vin.$495.Metal2 0.000929788f
Cred_2012 VDD.$137.Metal1 vin.$500.Metal2 0.000376473f
Cred_2013 VDD.$137.Metal1 vin.$504.Metal2 0.000319674f
Cred_2014 VDD.$137.Metal1 vin.$506.Metal2 0.000603201f
Cred_2015 VDD.$137.Metal1 vin.$509.Metal2 0.000193821f
Cred_2016 VDD.$137.Metal1 vin.$51.GatPoly 3.8975e-05f
Cred_2017 VDD.$137.Metal1 vin.$513.Metal2 0.000168282f
Cred_2018 VDD.$137.Metal1 vin.$515.Metal2 0.000428329f
Cred_2019 VDD.$137.Metal1 vin.$518.Metal2 0.000184539f
Cred_2020 VDD.$137.Metal1 vin.$520.Metal2 8.0503e-05f
Cred_2021 VDD.$137.Metal1 vin.$524.Metal2 0.000214371f
Cred_2022 VDD.$137.Metal1 vin.$526.Metal2 0.000282088f
Cred_2023 VDD.$137.Metal1 vin.$529.Metal2 6.56145e-05f
Cred_2024 VDD.$137.Metal1 vin.$533.Metal2 0.000106214f
Cred_2025 VDD.$137.Metal1 vin.$535.Metal2 0.000214988f
Cred_2026 VDD.$137.Metal1 vin.$538.Metal2 7.75533e-05f
Cred_2027 VDD.$137.Metal1 vin.$542.Metal2 5.28805e-05f
Cred_2028 VDD.$137.Metal1 vin.$544.Metal2 0.000142345f
Cred_2029 VDD.$137.Metal1 vin.$547.Metal2 8.22132e-05f
Cred_2030 VDD.$137.Metal1 vin.$55.GatPoly 2.68734e-05f
Cred_2031 VDD.$137.Metal1 vin.$551.Metal2 5.1996e-05f
Cred_2032 VDD.$137.Metal1 vin.$555.Metal2 0.000115301f
Cred_2033 VDD.$137.Metal1 vin.$558.Metal2 4.78968e-05f
Cred_2034 VDD.$137.Metal1 vin.$562.Metal2 3.37911e-05f
Cred_2035 VDD.$137.Metal1 vin.$564.Metal2 7.62776e-05f
Cred_2036 VDD.$137.Metal1 vin.$567.Metal2 3.13319e-05f
Cred_2037 VDD.$137.Metal1 vin.$57.GatPoly 2.01315e-05f
Cred_2038 VDD.$137.Metal1 vin.$571.Metal2 2.78155e-05f
Cred_2039 VDD.$137.Metal1 vin.$573.Metal2 5.85909e-05f
Cred_2040 VDD.$137.Metal1 vin.$578.Metal2 2.28453e-05f
Cred_2041 VDD.$137.Metal1 vin.$582.Metal2 2.14689e-05f
Cred_2042 VDD.$137.Metal1 vin.$584.Metal2 3.56211e-05f
Cred_2043 VDD.$137.Metal1 vin.$587.Metal2 1.1297e-05f
Cred_2044 VDD.$137.Metal1 vin.$591.Metal2 1.04824e-05f
Cred_2045 VDD.$137.Metal1 vin.$593.Metal2 2.67776e-05f
Cred_2046 VDD.$137.Metal1 vin.$596.Metal2 1.19396e-05f
Cred_2047 VDD.$137.Metal1 vin.$600.Metal2 5.30477e-06f
Cred_2048 VDD.$137.Metal1 vin.$602.Metal2 1.7625e-05f
Cred_2049 VDD.$137.Metal1 vin.$605.Metal2 1.2593e-05f
Cred_2050 VDD.$137.Metal1 vin.$609.Metal2 3.52266e-06f
Cred_2051 VDD.$137.Metal1 vin.$611.Metal2 5.64192e-06f
Cred_2052 VDD.$137.Metal1 vin.$613.Metal2 1.33023e-05f
Cred_2053 VDD.$137.Metal1 vin.$616.Metal2 4.50528e-06f
Cred_2054 VDD.$137.Metal1 vin.$620.Metal2 3.39322e-06f
Cred_2055 VDD.$137.Metal1 vin.$622.Metal2 9.40393e-06f
Cred_2056 VDD.$137.Metal1 vin.$625.Metal2 4.59254e-06f
Cred_2057 VDD.$137.Metal1 vin.$629.Metal2 3.38351e-06f
Cred_2058 VDD.$137.Metal1 vin.$633.Metal2 7.21113e-06f
Cred_2059 VDD.$137.Metal1 vin.$636.Metal2 2.86658e-06f
Cred_2060 VDD.$137.Metal1 vin.$640.Metal2 2.24774e-06f
Cred_2061 VDD.$137.Metal1 vin.$642.Metal2 6.00872e-06f
Cred_2062 VDD.$137.Metal1 vin.$645.Metal2 1.69448e-06f
Cred_2063 VDD.$137.Metal1 vin.$648.Metal2 8.51154e-08f
Cred_2064 VDD.$137.Metal1 vin.$649.Metal2 1.33407e-06f
Cred_2065 VDD.$137.Metal1 vin.$65.GatPoly 2.57026e-05f
Cred_2066 VDD.$137.Metal1 vin.$653.Metal2 3.25441e-07f
Cred_2067 VDD.$137.Metal1 vin.$654.Metal2 2.90592e-06f
Cred_2068 VDD.$137.Metal1 vin.$7.GatPoly 0.000245537f
Cred_2069 VDD.$137.Metal1 vin.$73.GatPoly 1.95465e-05f
Cred_2070 VDD.$137.Metal1 vin.$77.GatPoly 1.10297e-05f
Cred_2071 VDD.$137.Metal1 vin.$83.GatPoly 1.16318e-05f
Cred_2072 VDD.$137.Metal1 vin.$87.GatPoly 9.12476e-06f
Cred_2073 VDD.$137.Metal1 vin.$9.GatPoly 0.000134935f
Cred_2074 VDD.$137.Metal1 vin.$95.GatPoly 8.77169e-06f
Cred_2075 VDD.$137.Metal1 vin.$97.GatPoly 5.00174e-06f
Cred_2076 VDD.$137.Metal1 vin.P20.GatPoly 0.0133157f
Cred_2077 VDD.$137.Metal1 vin.P24.GatPoly 5.47992e-06f
Cred_2078 VDD.$137.Metal1 vin.P25.GatPoly 3.21906e-06f
Cred_2079 VDD.$137.Metal1 vin.P27.GatPoly 1.93118e-06f
Cred_2080 VDD.$137.Metal1 vin.P32.GatPoly 3.40705e-07f
Cred_2081 VDD.$137.Metal1 vin.P34.GatPoly 1.27788e-07f
Cred_2082 VDD.$137.Metal1 vin.P35.GatPoly 1.22466e-07f
Cred_2083 VDD.$137.Metal1 vin.P39.GatPoly 1.15384e-06f
Cred_2084 VDD.$137.Metal1 vout 1.70129e-06f
Cred_2085 VDD.$137.Metal1 vout.$1226.Metal3 0.00518873f
Cred_2086 VDD.$137.Metal1 vout.$1292.Metal3 9.69639e-05f
Cred_2087 VDD.$137.Metal1 vout.$1358.Metal3 2.60623e-05f
Cred_2088 VDD.$137.Metal1 vout.$1424.Metal3 5.60357e-06f
Cred_2089 VDD.$137.Metal1 vout.P0.nSD 0.000144283f
Cred_2090 VDD.$137.Metal1 vout.P0.pSD 0.00553965f
Cred_2091 VDD.$137.Metal1 vout.P10.nSD 1.7845e-07f
Cred_2092 VDD.$137.Metal1 vout.P10.pSD 9.665e-07f
Cred_2093 VDD.$137.Metal1 vout.P14.nSD 4.46282e-08f
Cred_2094 VDD.$137.Metal1 vout.P14.pSD 2.41709e-07f
Cred_2095 VDD.$137.Metal1 vout.P2.nSD 7.83312e-05f
Cred_2096 VDD.$137.Metal1 vout.P2.pSD 0.000428098f
Cred_2097 VDD.$137.Metal1 vout.P6.nSD 6.5645e-07f
Cred_2098 VDD.$137.Metal1 vout.P6.pSD 3.58765e-06f
Cred_2099 VDD.$137.Metal1 VSS.$1040.Metal2 1.95665e-10f
Cred_2100 VDD.$137.Metal1 VSS.$1066.Metal2 4.09703e-08f
Cred_2101 VDD.$137.Metal1 VSS.$18.Metal1 0.00235442f
Cred_2102 VDD.$137.Metal1 VSS.$40.Metal1 0.00171559f
Cred_2103 VDD.$137.Metal1 VSS.$488.Metal1 2.34192e-08f
Cred_2104 VDD.$137.Metal1 VSS.$498.Metal1 4.91213e-08f
Cred_2105 VDD.$137.Metal1 VSS.$509.Metal1 5.06758e-07f
Cred_2106 VDD.$137.Metal1 VSS.$551.Metal1 1.37382e-05f
Cred_2107 VDD.$137.Metal1 VSS.$564.Metal2 0.000144154f
Cred_2108 VDD.$137.Metal1 VSS.$605.Metal2 1.71018e-07f
Cred_2109 VDD.$137.Metal1 VSS.$65.Metal1 4.29336e-05f
Cred_2110 VDD.$137.Metal1 VSS.$75.Metal1 2.04691e-05f
Cred_2111 VDD.$137.Metal1 VSS.P0.nSD 5.21139e-06f
Cred_2112 VDD.$137.Metal1 VSS.P0.pSD 0.0113064f
Cred_2113 VDD.$137.Metal1 VSS.P1.nSD 5.21139e-06f
Cred_2114 VDD.$137.Metal1 VSS.P21.nSD 3.30996e-09f
Cred_2115 VDD.$137.Metal1 VSS.P23.nSD 3.30996e-09f
Cred_2116 VDD.$1374.Metal2 vin.$291.Metal1 0.00103133f
Cred_2117 VDD.$1374.Metal2 vin.$295.Metal1 0.00246267f
Cred_2118 VDD.$1374.Metal2 vin.$298.Metal1 4.54844e-07f
Cred_2119 VDD.$1374.Metal2 vin.$302.Metal1 8.89912e-07f
Cred_2120 VDD.$1374.Metal2 vin.$303.Metal1 0.00376316f
Cred_2121 VDD.$1374.Metal2 vin.$307.Metal1 5.92823e-05f
Cred_2122 VDD.$1374.Metal2 vin.$538.Metal2 0.000540286f
Cred_2123 VDD.$1374.Metal2 vin.$541.Metal2 6.31381e-05f
Cred_2124 VDD.$1374.Metal2 vin.$542.Metal2 0.00372716f
Cred_2125 VDD.$1374.Metal2 vin.$544.Metal2 0.000892489f
Cred_2126 VDD.$1374.Metal2 vin.$547.Metal2 0.00661164f
Cred_2127 VDD.$1374.Metal2 vin.$548.Metal2 7.07551e-05f
Cred_2128 VDD.$1374.Metal2 vin.$551.Metal2 7.5194e-05f
Cred_2129 VDD.$1374.Metal2 vin.$65.GatPoly 0.00193542f
Cred_2130 VDD.$1374.Metal2 vin.$73.GatPoly 0.00297644f
Cred_2131 VDD.$1374.Metal2 vin.$77.GatPoly 0.00653033f
Cred_2132 VDD.$1374.Metal2 vin.P26.GatPoly 0.000274185f
Cred_2133 VDD.$1374.Metal2 vin.P27.GatPoly 0.0319771f
Cred_2134 VDD.$1374.Metal2 vin.P28.GatPoly 0.0212949f
Cred_2135 VDD.$1374.Metal2 vin.P29.GatPoly 0.000274185f
Cred_2136 VDD.$1374.Metal2 vout.$1226.Metal3 0.0227786f
Cred_2137 VDD.$1374.Metal2 vout.$1292.Metal3 0.0705476f
Cred_2138 VDD.$1374.Metal2 vout.P6.nSD 0.000358855f
Cred_2139 VDD.$1374.Metal2 vout.P6.pSD 0.0220749f
Cred_2140 VDD.$1374.Metal2 vout.P8.pSD 0.0197244f
Cred_2141 VDD.$138.Metal1 vin.P20.GatPoly 0.0123238f
Cred_2142 VDD.$138.Metal1 vout.$1226.Metal3 0.00351717f
Cred_2143 VDD.$138.Metal1 vout.P0.nSD 0.00010473f
Cred_2144 VDD.$138.Metal1 vout.P0.pSD 0.00485333f
Cred_2145 VDD.$138.Metal1 vout.P2.nSD 5.54096e-05f
Cred_2146 VDD.$138.Metal1 vout.P2.pSD 0.000302826f
Cred_2147 VDD.$139.Metal1 vin.P20.GatPoly 0.0123161f
Cred_2148 VDD.$139.Metal1 vout.$1226.Metal3 0.00384498f
Cred_2149 VDD.$139.Metal1 vout.P0.nSD 0.000114491f
Cred_2150 VDD.$139.Metal1 vout.P0.pSD 0.00533243f
Cred_2151 VDD.$139.Metal1 vout.P2.nSD 6.05741e-05f
Cred_2152 VDD.$139.Metal1 vout.P2.pSD 0.000331051f
Cred_2153 VDD.$1395.Metal2 vin.$291.Metal1 0.00339412f
Cred_2154 VDD.$1395.Metal2 vin.$295.Metal1 0.00815716f
Cred_2155 VDD.$1395.Metal2 vin.$298.Metal1 1.50817e-06f
Cred_2156 VDD.$1395.Metal2 vin.$302.Metal1 2.95076e-06f
Cred_2157 VDD.$1395.Metal2 vin.$303.Metal1 0.012479f
Cred_2158 VDD.$1395.Metal2 vin.$307.Metal1 0.000204038f
Cred_2159 VDD.$1395.Metal2 vin.$541.Metal2 0.000209353f
Cred_2160 VDD.$1395.Metal2 vin.$542.Metal2 0.010567f
Cred_2161 VDD.$1395.Metal2 vin.$544.Metal2 0.00295931f
Cred_2162 VDD.$1395.Metal2 vin.$547.Metal2 0.0223749f
Cred_2163 VDD.$1395.Metal2 vin.$548.Metal2 0.000234609f
Cred_2164 VDD.$1395.Metal2 vin.$551.Metal2 0.000701392f
Cred_2165 VDD.$1395.Metal2 vin.$65.GatPoly 0.00641745f
Cred_2166 VDD.$1395.Metal2 vin.$73.GatPoly 0.00986924f
Cred_2167 VDD.$1395.Metal2 vin.$77.GatPoly 0.0216532f
Cred_2168 VDD.$1395.Metal2 vin.P26.GatPoly 0.000909138f
Cred_2169 VDD.$1395.Metal2 vin.P27.GatPoly 0.0730297f
Cred_2170 VDD.$1395.Metal2 vin.P28.GatPoly 0.075114f
Cred_2171 VDD.$1395.Metal2 vin.P29.GatPoly 0.000909138f
Cred_2172 VDD.$1395.Metal2 vout.$1226.Metal3 0.0754845f
Cred_2173 VDD.$1395.Metal2 vout.$1292.Metal3 0.233944f
Cred_2174 VDD.$1395.Metal2 vout.P6.nSD 0.00118919f
Cred_2175 VDD.$1395.Metal2 vout.P6.pSD 0.0731771f
Cred_2176 VDD.$1395.Metal2 vout.P8.pSD 0.0654087f
Cred_2177 VDD.$140.Metal1 vin.P20.GatPoly 0.0124007f
Cred_2178 VDD.$140.Metal1 vout.$1226.Metal3 0.00386108f
Cred_2179 VDD.$140.Metal1 vout.P0.nSD 0.000114971f
Cred_2180 VDD.$140.Metal1 vout.P0.pSD 0.00537198f
Cred_2181 VDD.$140.Metal1 vout.P2.nSD 6.08277e-05f
Cred_2182 VDD.$140.Metal1 vout.P2.pSD 0.000332437f
Cred_2183 VDD.$141.Metal1 vin.P20.GatPoly 0.0178048f
Cred_2184 VDD.$141.Metal1 vout.$1226.Metal3 0.00342796f
Cred_2185 VDD.$141.Metal1 vout.P0.nSD 0.000102074f
Cred_2186 VDD.$141.Metal1 vout.P0.pSD 0.00477521f
Cred_2187 VDD.$141.Metal1 vout.P2.nSD 5.40044e-05f
Cred_2188 VDD.$141.Metal1 vout.P2.pSD 0.000295146f
Cred_2189 VDD.$142.Metal1 vin.P20.GatPoly 0.00972284f
Cred_2190 VDD.$1421.Metal2 vin.$303.Metal1 1.1396e-06f
Cred_2191 VDD.$1421.Metal2 vin.$307.Metal1 7.47072e-06f
Cred_2192 VDD.$1421.Metal2 vin.$547.Metal2 0.000452065f
Cred_2193 VDD.$1421.Metal2 vin.$551.Metal2 0.00238301f
Cred_2194 VDD.$1421.Metal2 vin.P28.GatPoly 0.0139927f
Cred_2195 VDD.$1421.Metal2 vout.$1292.Metal3 0.00866835f
Cred_2196 VDD.$1421.Metal2 vout.P8.pSD 0.00313104f
Cred_2197 VDD.$1433.Metal2 vin.$321.Metal1 3.17194e-06f
Cred_2198 VDD.$1433.Metal2 vin.$325.Metal1 7.0991e-06f
Cred_2199 VDD.$1433.Metal2 vin.$558.Metal2 0.00188125f
Cred_2200 VDD.$1433.Metal2 vin.$562.Metal2 0.000540306f
Cred_2201 VDD.$1433.Metal2 vin.P29.GatPoly 0.0121203f
Cred_2202 VDD.$1433.Metal2 vout.$1292.Metal3 0.0114319f
Cred_2203 VDD.$1433.Metal2 vout.P8.pSD 0.00434184f
Cred_2204 VDD.$1460.Metal2 vin.$321.Metal1 3.17191e-06f
Cred_2205 VDD.$1460.Metal2 vin.$325.Metal1 0.000386868f
Cred_2206 VDD.$1460.Metal2 vin.$329.Metal1 0.0086482f
Cred_2207 VDD.$1460.Metal2 vin.$335.Metal1 0.00286512f
Cred_2208 VDD.$1460.Metal2 vin.$558.Metal2 0.000540302f
Cred_2209 VDD.$1460.Metal2 vin.$561.Metal2 0.000337225f
Cred_2210 VDD.$1460.Metal2 vin.$562.Metal2 0.0111552f
Cred_2211 VDD.$1460.Metal2 vin.$564.Metal2 0.00206413f
Cred_2212 VDD.$1460.Metal2 vin.$566.Metal2 0.000337225f
Cred_2213 VDD.$1460.Metal2 vin.$567.Metal2 0.0103314f
Cred_2214 VDD.$1460.Metal2 vin.$87.GatPoly 0.0141241f
Cred_2215 VDD.$1460.Metal2 vin.$95.GatPoly 0.00322652f
Cred_2216 VDD.$1460.Metal2 vin.$97.GatPoly 0.0135822f
Cred_2217 VDD.$1460.Metal2 vin.P28.GatPoly 0.000593044f
Cred_2218 VDD.$1460.Metal2 vin.P29.GatPoly 0.0517362f
Cred_2219 VDD.$1460.Metal2 vin.P30.GatPoly 0.0463964f
Cred_2220 VDD.$1460.Metal2 vin.P31.GatPoly 0.000593044f
Cred_2221 VDD.$1460.Metal2 vout.$1292.Metal3 0.15211f
Cred_2222 VDD.$1460.Metal2 vout.$1358.Metal3 0.0486758f
Cred_2223 VDD.$1460.Metal2 vout.P10.nSD 0.000766841f
Cred_2224 VDD.$1460.Metal2 vout.P10.pSD 0.0476419f
Cred_2225 VDD.$1460.Metal2 vout.P8.pSD 0.0434969f
Cred_2226 VDD.$1480.Metal2 vin.$325.Metal1 0.000379769f
Cred_2227 VDD.$1480.Metal2 vin.$329.Metal1 0.0086482f
Cred_2228 VDD.$1480.Metal2 vin.$335.Metal1 0.00287222f
Cred_2229 VDD.$1480.Metal2 vin.$339.Metal1 3.1719e-06f
Cred_2230 VDD.$1480.Metal2 vin.$561.Metal2 0.000337225f
Cred_2231 VDD.$1480.Metal2 vin.$562.Metal2 0.0106149f
Cred_2232 VDD.$1480.Metal2 vin.$564.Metal2 0.00206413f
Cred_2233 VDD.$1480.Metal2 vin.$566.Metal2 0.000337225f
Cred_2234 VDD.$1480.Metal2 vin.$567.Metal2 0.0108717f
Cred_2235 VDD.$1480.Metal2 vin.$571.Metal2 0.000540301f
Cred_2236 VDD.$1480.Metal2 vin.$87.GatPoly 0.0141241f
Cred_2237 VDD.$1480.Metal2 vin.$95.GatPoly 0.00322652f
Cred_2238 VDD.$1480.Metal2 vin.$97.GatPoly 0.0135822f
Cred_2239 VDD.$1480.Metal2 vin.P28.GatPoly 0.000593044f
Cred_2240 VDD.$1480.Metal2 vin.P29.GatPoly 0.0463964f
Cred_2241 VDD.$1480.Metal2 vin.P30.GatPoly 0.0517324f
Cred_2242 VDD.$1480.Metal2 vin.P31.GatPoly 0.000593044f
Cred_2243 VDD.$1480.Metal2 vout.$1292.Metal3 0.152077f
Cred_2244 VDD.$1480.Metal2 vout.$1358.Metal3 0.0487028f
Cred_2245 VDD.$1480.Metal2 vout.P10.nSD 0.000767266f
Cred_2246 VDD.$1480.Metal2 vout.P10.pSD 0.0476511f
Cred_2247 VDD.$1480.Metal2 vout.P8.pSD 0.04349f
Cred_2248 VDD.$1492.Metal2 vin.$335.Metal1 7.09909e-06f
Cred_2249 VDD.$1492.Metal2 vin.$339.Metal1 3.17193e-06f
Cred_2250 VDD.$1492.Metal2 vin.$567.Metal2 0.000540306f
Cred_2251 VDD.$1492.Metal2 vin.$571.Metal2 0.00188125f
Cred_2252 VDD.$1492.Metal2 vin.P30.GatPoly 0.0121184f
Cred_2253 VDD.$1492.Metal2 vout.$1292.Metal3 0.00539868f
Cred_2254 VDD.$1492.Metal2 vout.$1358.Metal3 0.00539868f
Cred_2255 VDD.$1492.Metal2 vout.P10.nSD 8.50511e-05f
Cred_2256 VDD.$1492.Metal2 vout.P10.pSD 0.00488792f
Cred_2257 VDD.$1504.Metal2 vin.$353.Metal1 7.47072e-06f
Cred_2258 VDD.$1504.Metal2 vin.$357.Metal1 1.1396e-06f
Cred_2259 VDD.$1504.Metal2 vin.$578.Metal2 0.00238301f
Cred_2260 VDD.$1504.Metal2 vin.$582.Metal2 0.000452065f
Cred_2261 VDD.$1504.Metal2 vin.P31.GatPoly 0.0139927f
Cred_2262 VDD.$1504.Metal2 vout.$1292.Metal3 0.00409414f
Cred_2263 VDD.$1504.Metal2 vout.$1358.Metal3 0.00409414f
Cred_2264 VDD.$1504.Metal2 vout.P10.nSD 6.44993e-05f
Cred_2265 VDD.$1504.Metal2 vout.P10.pSD 0.00354661f
Cred_2266 VDD.$152.Metal1 vin.$199.Metal1 2.01126e-07f
Cred_2267 VDD.$152.Metal1 vin.$478.Metal2 8.11349e-06f
Cred_2268 VDD.$152.Metal1 vin.$7.GatPoly 2.85641e-09f
Cred_2269 VDD.$152.Metal1 vin.P20.GatPoly 0.0205356f
Cred_2270 VDD.$152.Metal1 vin.P21.GatPoly 9.09265e-05f
Cred_2271 VDD.$152.Metal1 vout.$1226.Metal3 0.00633296f
Cred_2272 VDD.$152.Metal1 vout.P0.nSD 0.000188576f
Cred_2273 VDD.$152.Metal1 vout.P0.pSD 0.00641523f
Cred_2274 VDD.$152.Metal1 vout.P2.nSD 9.97699e-05f
Cred_2275 VDD.$152.Metal1 vout.P2.pSD 0.000545265f
Cred_2276 VDD.$1531.Metal2 vin.$107.GatPoly 0.0216532f
Cred_2277 VDD.$1531.Metal2 vin.$115.GatPoly 0.00986924f
Cred_2278 VDD.$1531.Metal2 vin.$123.GatPoly 0.00641745f
Cred_2279 VDD.$1531.Metal2 vin.$353.Metal1 0.000204038f
Cred_2280 VDD.$1531.Metal2 vin.$356.Metal1 2.95076e-06f
Cred_2281 VDD.$1531.Metal2 vin.$357.Metal1 0.012479f
Cred_2282 VDD.$1531.Metal2 vin.$360.Metal1 1.50817e-06f
Cred_2283 VDD.$1531.Metal2 vin.$365.Metal1 0.00815716f
Cred_2284 VDD.$1531.Metal2 vin.$369.Metal1 0.00339412f
Cred_2285 VDD.$1531.Metal2 vin.$578.Metal2 0.000701392f
Cred_2286 VDD.$1531.Metal2 vin.$579.Metal2 0.000234609f
Cred_2287 VDD.$1531.Metal2 vin.$582.Metal2 0.0223749f
Cred_2288 VDD.$1531.Metal2 vin.$584.Metal2 0.00295931f
Cred_2289 VDD.$1531.Metal2 vin.$586.Metal2 0.000209353f
Cred_2290 VDD.$1531.Metal2 vin.$587.Metal2 0.010567f
Cred_2291 VDD.$1531.Metal2 vin.P30.GatPoly 0.000909138f
Cred_2292 VDD.$1531.Metal2 vin.P31.GatPoly 0.075114f
Cred_2293 VDD.$1531.Metal2 vin.P32.GatPoly 0.0730297f
Cred_2294 VDD.$1531.Metal2 vin.P33.GatPoly 0.000909138f
Cred_2295 VDD.$1531.Metal2 vout.$1292.Metal3 0.0749428f
Cred_2296 VDD.$1531.Metal2 vout.$1358.Metal3 0.232551f
Cred_2297 VDD.$1531.Metal2 vout.P10.nSD 0.00118065f
Cred_2298 VDD.$1531.Metal2 vout.P10.pSD 0.0741594f
Cred_2299 VDD.$1531.Metal2 vout.P12.pSD 0.0667285f
Cred_2300 VDD.$1551.Metal2 vin.$107.GatPoly 0.00653033f
Cred_2301 VDD.$1551.Metal2 vin.$115.GatPoly 0.00297644f
Cred_2302 VDD.$1551.Metal2 vin.$123.GatPoly 0.00193542f
Cred_2303 VDD.$1551.Metal2 vin.$353.Metal1 5.92823e-05f
Cred_2304 VDD.$1551.Metal2 vin.$356.Metal1 8.89912e-07f
Cred_2305 VDD.$1551.Metal2 vin.$357.Metal1 0.00376316f
Cred_2306 VDD.$1551.Metal2 vin.$360.Metal1 4.54844e-07f
Cred_2307 VDD.$1551.Metal2 vin.$365.Metal1 0.00246267f
Cred_2308 VDD.$1551.Metal2 vin.$369.Metal1 0.00103133f
Cred_2309 VDD.$1551.Metal2 vin.$578.Metal2 7.5194e-05f
Cred_2310 VDD.$1551.Metal2 vin.$579.Metal2 7.07551e-05f
Cred_2311 VDD.$1551.Metal2 vin.$582.Metal2 0.00661164f
Cred_2312 VDD.$1551.Metal2 vin.$584.Metal2 0.000892489f
Cred_2313 VDD.$1551.Metal2 vin.$586.Metal2 6.31381e-05f
Cred_2314 VDD.$1551.Metal2 vin.$587.Metal2 0.00372716f
Cred_2315 VDD.$1551.Metal2 vin.$591.Metal2 0.000540286f
Cred_2316 VDD.$1551.Metal2 vin.P30.GatPoly 0.000274185f
Cred_2317 VDD.$1551.Metal2 vin.P31.GatPoly 0.0212949f
Cred_2318 VDD.$1551.Metal2 vin.P32.GatPoly 0.0319771f
Cred_2319 VDD.$1551.Metal2 vin.P33.GatPoly 0.000274185f
Cred_2320 VDD.$1551.Metal2 vout.$1292.Metal3 0.0225921f
Cred_2321 VDD.$1551.Metal2 vout.$1358.Metal3 0.0701547f
Cred_2322 VDD.$1551.Metal2 vout.P10.nSD 0.000355917f
Cred_2323 VDD.$1551.Metal2 vout.P10.pSD 0.0223625f
Cred_2324 VDD.$1551.Metal2 vout.P12.pSD 0.0201295f
Cred_2325 VDD.$1563.Metal2 vin.$365.Metal1 2.56903e-06f
Cred_2326 VDD.$1563.Metal2 vin.$369.Metal1 7.70709e-06f
Cred_2327 VDD.$1563.Metal2 vin.$587.Metal2 0.000540297f
Cred_2328 VDD.$1563.Metal2 vin.$591.Metal2 0.000540297f
Cred_2329 VDD.$1563.Metal2 vin.P32.GatPoly 0.00997148f
Cred_2330 VDD.$1563.Metal2 vin.P33.GatPoly 0.000898184f
Cred_2331 VDD.$1563.Metal2 vout.$1358.Metal3 0.0130419f
Cred_2332 VDD.$1563.Metal2 vout.P12.pSD 0.0053612f
Cred_2333 VDD.$1575.Metal2 vin.$379.Metal1 1.30884e-05f
Cred_2334 VDD.$1575.Metal2 vin.$383.Metal1 7.60954e-06f
Cred_2335 VDD.$1575.Metal2 vin.$596.Metal2 0.00108922f
Cred_2336 VDD.$1575.Metal2 vin.$600.Metal2 0.00108922f
Cred_2337 VDD.$1575.Metal2 vin.P33.GatPoly 0.0116388f
Cred_2338 VDD.$1575.Metal2 vout.$1358.Metal3 0.00614953f
Cred_2339 VDD.$1575.Metal2 vout.$1424.Metal3 1.20343e-06f
Cred_2340 VDD.$1575.Metal2 vout.P12.pSD 0.0023061f
Cred_2341 VDD.$1575.Metal2 vout.P14.nSD 1.89588e-08f
Cred_2342 VDD.$1575.Metal2 vout.P14.pSD 1.02682e-07f
Cred_2343 VDD.$1581.Metal2 vin.$127.GatPoly 0.000859917f
Cred_2344 VDD.$1581.Metal2 vin.$133.GatPoly 0.000171267f
Cred_2345 VDD.$1581.Metal2 vin.$139.GatPoly 0.000496421f
Cred_2346 VDD.$1581.Metal2 vin.$145.GatPoly 0.000106813f
Cred_2347 VDD.$1581.Metal2 vin.$383.Metal1 0.000127095f
Cred_2348 VDD.$1581.Metal2 vin.$391.Metal1 0.000575999f
Cred_2349 VDD.$1581.Metal2 vin.$397.Metal1 0.0001723f
Cred_2350 VDD.$1581.Metal2 vin.$401.Metal1 5.64922e-05f
Cred_2351 VDD.$1581.Metal2 vin.$599.Metal2 1.01998e-06f
Cred_2352 VDD.$1581.Metal2 vin.$600.Metal2 0.00164377f
Cred_2353 VDD.$1581.Metal2 vin.$602.Metal2 0.000125755f
Cred_2354 VDD.$1581.Metal2 vin.$604.Metal2 2.68594e-05f
Cred_2355 VDD.$1581.Metal2 vin.$605.Metal2 0.00104669f
Cred_2356 VDD.$1581.Metal2 vin.$609.Metal2 0.000100558f
Cred_2357 VDD.$1581.Metal2 vin.P32.GatPoly 3.80654e-05f
Cred_2358 VDD.$1581.Metal2 vin.P33.GatPoly 0.00933798f
Cred_2359 VDD.$1581.Metal2 vin.P34.GatPoly 0.00274447f
Cred_2360 VDD.$1581.Metal2 vin.P35.GatPoly 3.80654e-05f
Cred_2361 VDD.$1581.Metal2 vout.$1358.Metal3 0.0101753f
Cred_2362 VDD.$1581.Metal2 vout.$1424.Metal3 0.00327144f
Cred_2363 VDD.$1581.Metal2 vout.P12.pSD 0.00285501f
Cred_2364 VDD.$1581.Metal2 vout.P14.nSD 5.15385e-05f
Cred_2365 VDD.$1581.Metal2 vout.P14.pSD 0.00309316f
Cred_2366 VDD.$1602.Metal2 vin.$127.GatPoly 0.0226445f
Cred_2367 VDD.$1602.Metal2 vin.$133.GatPoly 0.00451003f
Cred_2368 VDD.$1602.Metal2 vin.$139.GatPoly 0.0130725f
Cred_2369 VDD.$1602.Metal2 vin.$145.GatPoly 0.00281274f
Cred_2370 VDD.$1602.Metal2 vin.$383.Metal1 0.00334684f
Cred_2371 VDD.$1602.Metal2 vin.$391.Metal1 0.0151715f
Cred_2372 VDD.$1602.Metal2 vin.$397.Metal1 0.00454068f
Cred_2373 VDD.$1602.Metal2 vin.$401.Metal1 0.00148763f
Cred_2374 VDD.$1602.Metal2 vin.$599.Metal2 2.68594e-05f
Cred_2375 VDD.$1602.Metal2 vin.$600.Metal2 0.00710277f
Cred_2376 VDD.$1602.Metal2 vin.$602.Metal2 0.00331154f
Cred_2377 VDD.$1602.Metal2 vin.$604.Metal2 0.000707297f
Cred_2378 VDD.$1602.Metal2 vin.$605.Metal2 0.0279338f
Cred_2379 VDD.$1602.Metal2 vin.$609.Metal2 0.00301898f
Cred_2380 VDD.$1602.Metal2 vin.P32.GatPoly 0.00100239f
Cred_2381 VDD.$1602.Metal2 vin.P33.GatPoly 0.0691105f
Cred_2382 VDD.$1602.Metal2 vin.P34.GatPoly 0.0758843f
Cred_2383 VDD.$1602.Metal2 vin.P35.GatPoly 0.00100239f
Cred_2384 VDD.$1602.Metal2 vout.$1358.Metal3 0.266678f
Cred_2385 VDD.$1602.Metal2 vout.$1424.Metal3 0.0860881f
Cred_2386 VDD.$1602.Metal2 vout.P12.pSD 0.0750899f
Cred_2387 VDD.$1602.Metal2 vout.P14.nSD 0.00135624f
Cred_2388 VDD.$1602.Metal2 vout.P14.pSD 0.081448f
Cred_2389 VDD.$1628.Metal2 vin.$139.GatPoly 4.0777e-08f
Cred_2390 VDD.$1628.Metal2 vin.$391.Metal1 3.53755e-06f
Cred_2391 VDD.$1628.Metal2 vin.$397.Metal1 3.43442e-06f
Cred_2392 VDD.$1628.Metal2 vin.$605.Metal2 0.000370966f
Cred_2393 VDD.$1628.Metal2 vin.$609.Metal2 0.00257011f
Cred_2394 VDD.$1628.Metal2 vin.P34.GatPoly 0.0148191f
Cred_2395 VDD.$1628.Metal2 vout.$1358.Metal3 0.00319496f
Cred_2396 VDD.$1628.Metal2 vout.$1424.Metal3 0.00319496f
Cred_2397 VDD.$1628.Metal2 vout.P14.nSD 5.03336e-05f
Cred_2398 VDD.$1628.Metal2 vout.P14.pSD 0.00274182f
Cred_2399 VDD.$164.Metal1 vin.$199.Metal1 3.92822e-08f
Cred_2400 VDD.$164.Metal1 vin.$478.Metal2 2.59592e-06f
Cred_2401 VDD.$164.Metal1 vin.$482.Metal2 2.05774e-06f
Cred_2402 VDD.$164.Metal1 vin.P20.GatPoly 0.000986861f
Cred_2403 VDD.$164.Metal1 vin.P21.GatPoly 0.0198393f
Cred_2404 VDD.$164.Metal1 vout.$1226.Metal3 0.00906829f
Cred_2405 VDD.$164.Metal1 vout.P0.nSD 0.000270025f
Cred_2406 VDD.$164.Metal1 vout.P0.pSD 0.00955767f
Cred_2407 VDD.$164.Metal1 vout.P2.nSD 0.000142862f
Cred_2408 VDD.$164.Metal1 vout.P2.pSD 0.000780776f
Cred_2409 VDD.$1640.Metal2 vin.$409.Metal1 1.96581e-06f
Cred_2410 VDD.$1640.Metal2 vin.$413.Metal1 8.3169e-06f
Cred_2411 VDD.$1640.Metal2 vin.$616.Metal2 0.000540294f
Cred_2412 VDD.$1640.Metal2 vin.$620.Metal2 0.000540294f
Cred_2413 VDD.$1640.Metal2 vin.P34.GatPoly 0.000513126f
Cred_2414 VDD.$1640.Metal2 vin.P35.GatPoly 0.0109148f
Cred_2415 VDD.$1640.Metal2 vout.$1358.Metal3 0.00611947f
Cred_2416 VDD.$1640.Metal2 vout.$1424.Metal3 0.00611947f
Cred_2417 VDD.$1640.Metal2 vout.P14.nSD 9.64064e-05f
Cred_2418 VDD.$1640.Metal2 vout.P14.pSD 0.00570157f
Cred_2419 VDD.$1652.Metal2 vin.$145.GatPoly 0.00163489f
Cred_2420 VDD.$1652.Metal2 vin.$153.GatPoly 0.0045865f
Cred_2421 VDD.$1652.Metal2 vin.$157.GatPoly 0.00878981f
Cred_2422 VDD.$1652.Metal2 vin.$409.Metal1 0.000866641f
Cred_2423 VDD.$1652.Metal2 vin.$413.Metal1 0.00257082f
Cred_2424 VDD.$1652.Metal2 vin.$419.Metal1 0.00510846f
Cred_2425 VDD.$1652.Metal2 vin.$423.Metal1 0.0011572f
Cred_2426 VDD.$1652.Metal2 vin.$616.Metal2 0.000540282f
Cred_2427 VDD.$1652.Metal2 vin.$619.Metal2 0.000168378f
Cred_2428 VDD.$1652.Metal2 vin.$620.Metal2 0.00540567f
Cred_2429 VDD.$1652.Metal2 vin.$622.Metal2 0.00116692f
Cred_2430 VDD.$1652.Metal2 vin.$624.Metal2 0.000231161f
Cred_2431 VDD.$1652.Metal2 vin.$625.Metal2 0.00810676f
Cred_2432 VDD.$1652.Metal2 vin.P34.GatPoly 0.00036047f
Cred_2433 VDD.$1652.Metal2 vin.P35.GatPoly 0.0379316f
Cred_2434 VDD.$1652.Metal2 vin.P36.GatPoly 0.0280358f
Cred_2435 VDD.$1652.Metal2 vin.P37.GatPoly 0.00036047f
Cred_2436 VDD.$1652.Metal2 vout.$1358.Metal3 0.0297132f
Cred_2437 VDD.$1652.Metal2 vout.$1424.Metal3 0.0919056f
Cred_2438 VDD.$1652.Metal2 vout.P14.nSD 0.000468104f
Cred_2439 VDD.$1652.Metal2 vout.P14.pSD 0.0294047f
Cred_2440 VDD.$1652.Metal2 vout.P16.pSD 0.0264917f
Cred_2441 VDD.$1673.Metal2 vin.$145.GatPoly 0.00372755f
Cred_2442 VDD.$1673.Metal2 vin.$153.GatPoly 0.0104572f
Cred_2443 VDD.$1673.Metal2 vin.$157.GatPoly 0.0200408f
Cred_2444 VDD.$1673.Metal2 vin.$409.Metal1 0.00197146f
Cred_2445 VDD.$1673.Metal2 vin.$413.Metal1 0.00584252f
Cred_2446 VDD.$1673.Metal2 vin.$419.Metal1 0.0116473f
Cred_2447 VDD.$1673.Metal2 vin.$423.Metal1 0.00264365f
Cred_2448 VDD.$1673.Metal2 vin.$427.Metal1 3.89146e-06f
Cred_2449 VDD.$1673.Metal2 vin.$619.Metal2 0.000383903f
Cred_2450 VDD.$1673.Metal2 vin.$620.Metal2 0.0110931f
Cred_2451 VDD.$1673.Metal2 vin.$622.Metal2 0.00266057f
Cred_2452 VDD.$1673.Metal2 vin.$624.Metal2 0.000527048f
Cred_2453 VDD.$1673.Metal2 vin.$625.Metal2 0.0189637f
Cred_2454 VDD.$1673.Metal2 vin.$629.Metal2 0.000480303f
Cred_2455 VDD.$1673.Metal2 vin.P34.GatPoly 0.000821871f
Cred_2456 VDD.$1673.Metal2 vin.P35.GatPoly 0.0658192f
Cred_2457 VDD.$1673.Metal2 vin.P36.GatPoly 0.0687055f
Cred_2458 VDD.$1673.Metal2 vin.P37.GatPoly 0.000821871f
Cred_2459 VDD.$1673.Metal2 vout.$1358.Metal3 0.06772f
Cred_2460 VDD.$1673.Metal2 vout.$1424.Metal3 0.209591f
Cred_2461 VDD.$1673.Metal2 vout.P14.nSD 0.00106687f
Cred_2462 VDD.$1673.Metal2 vout.P14.pSD 0.0670319f
Cred_2463 VDD.$1673.Metal2 vout.P16.pSD 0.0604091f
Cred_2464 VDD.$1699.Metal2 vin.$423.Metal1 5.23334e-06f
Cred_2465 VDD.$1699.Metal2 vin.$427.Metal1 3.89146e-06f
Cred_2466 VDD.$1699.Metal2 vin.$625.Metal2 0.000480303f
Cred_2467 VDD.$1699.Metal2 vin.$629.Metal2 0.00225034f
Cred_2468 VDD.$1699.Metal2 vin.P36.GatPoly 0.0135491f
Cred_2469 VDD.$1699.Metal2 vout.$1424.Metal3 0.00935318f
Cred_2470 VDD.$1699.Metal2 vout.P16.pSD 0.00353355f
Cred_2471 VDD.$1711.Metal2 vin.$173.GatPoly 1.46916e-08f
Cred_2472 VDD.$1711.Metal2 vin.$441.Metal1 8.72746e-06f
Cred_2473 VDD.$1711.Metal2 vin.$449.Metal1 1.23135e-06f
Cred_2474 VDD.$1711.Metal2 vin.$636.Metal2 0.00202725f
Cred_2475 VDD.$1711.Metal2 vin.$640.Metal2 0.000525417f
Cred_2476 VDD.$1711.Metal2 vin.P37.GatPoly 0.0127423f
Cred_2477 VDD.$1711.Metal2 vout.$1424.Metal3 0.0105767f
Cred_2478 VDD.$1711.Metal2 vout.P16.pSD 0.00408932f
Cred_2479 VDD.$1738.Metal2 vin.$167.GatPoly 0.0156261f
Cred_2480 VDD.$1738.Metal2 vin.$173.GatPoly 0.00330292f
Cred_2481 VDD.$1738.Metal2 vin.$179.GatPoly 0.0142021f
Cred_2482 VDD.$1738.Metal2 vin.$441.Metal1 0.00152696f
Cred_2483 VDD.$1738.Metal2 vin.$449.Metal1 0.00951604f
Cred_2484 VDD.$1738.Metal2 vin.$453.Metal1 0.00399868f
Cred_2485 VDD.$1738.Metal2 vin.$636.Metal2 0.000529113f
Cred_2486 VDD.$1738.Metal2 vin.$639.Metal2 0.000407762f
Cred_2487 VDD.$1738.Metal2 vin.$640.Metal2 0.0136826f
Cred_2488 VDD.$1738.Metal2 vin.$642.Metal2 0.00233692f
Cred_2489 VDD.$1738.Metal2 vin.$644.Metal2 0.000360885f
Cred_2490 VDD.$1738.Metal2 vin.$645.Metal2 0.0108687f
Cred_2491 VDD.$1738.Metal2 vin.P36.GatPoly 0.000677141f
Cred_2492 VDD.$1738.Metal2 vin.P37.GatPoly 0.0579986f
Cred_2493 VDD.$1738.Metal2 vin.P38.GatPoly 0.0533333f
Cred_2494 VDD.$1738.Metal2 vin.P39.GatPoly 0.000746638f
Cred_2495 VDD.$1738.Metal2 vout 0.11415f
Cred_2496 VDD.$1738.Metal2 vout.$1424.Metal3 0.119494f
Cred_2497 VDD.$1738.Metal2 vout.P16.pSD 0.0505062f
Cred_2498 VDD.$1738.Metal2 vout.P18.pSD 0.0555486f
Cred_2499 VDD.$1758.Metal2 vin.$167.GatPoly 0.0116364f
Cred_2500 VDD.$1758.Metal2 vin.$173.GatPoly 0.00245961f
Cred_2501 VDD.$1758.Metal2 vin.$179.GatPoly 0.010576f
Cred_2502 VDD.$1758.Metal2 vin.$441.Metal1 0.0011306f
Cred_2503 VDD.$1758.Metal2 vin.$449.Metal1 0.0070855f
Cred_2504 VDD.$1758.Metal2 vin.$453.Metal1 0.0029791f
Cred_2505 VDD.$1758.Metal2 vin.$457.Metal1 8.92833e-06f
Cred_2506 VDD.$1758.Metal2 vin.$636.Metal2 2.77014e-06f
Cred_2507 VDD.$1758.Metal2 vin.$639.Metal2 0.000303653f
Cred_2508 VDD.$1758.Metal2 vin.$640.Metal2 0.00979793f
Cred_2509 VDD.$1758.Metal2 vin.$642.Metal2 0.00174026f
Cred_2510 VDD.$1758.Metal2 vin.$644.Metal2 0.000268744f
Cred_2511 VDD.$1758.Metal2 vin.$645.Metal2 0.00863398f
Cred_2512 VDD.$1758.Metal2 vin.$649.Metal2 0.000540267f
Cred_2513 VDD.$1758.Metal2 vin.P36.GatPoly 0.000504254f
Cred_2514 VDD.$1758.Metal2 vin.P37.GatPoly 0.0393457f
Cred_2515 VDD.$1758.Metal2 vin.P38.GatPoly 0.0469959f
Cred_2516 VDD.$1758.Metal2 vin.P39.GatPoly 0.000556007f
Cred_2517 VDD.$1758.Metal2 vout 0.0850052f
Cred_2518 VDD.$1758.Metal2 vout.$1424.Metal3 0.0889695f
Cred_2519 VDD.$1758.Metal2 vout.P16.pSD 0.0376088f
Cred_2520 VDD.$1758.Metal2 vout.P18.pSD 0.041366f
Cred_2521 VDD.$177.Metal1 vin.$15.GatPoly 0.0263992f
Cred_2522 VDD.$177.Metal1 vin.$17.GatPoly 0.00707618f
Cred_2523 VDD.$177.Metal1 vin.$207.Metal1 0.00788772f
Cred_2524 VDD.$177.Metal1 vin.$211.Metal1 0.018603f
Cred_2525 VDD.$177.Metal1 vin.$219.Metal1 0.00289811f
Cred_2526 VDD.$177.Metal1 vin.$482.Metal2 0.00527497f
Cred_2527 VDD.$177.Metal1 vin.$483.Metal2 0.000371729f
Cred_2528 VDD.$177.Metal1 vin.$486.Metal2 0.00371596f
Cred_2529 VDD.$177.Metal1 vin.$488.Metal2 0.000420015f
Cred_2530 VDD.$177.Metal1 vin.$489.Metal2 0.01811f
Cred_2531 VDD.$177.Metal1 vin.$493.Metal2 7.10082e-06f
Cred_2532 VDD.$177.Metal1 vin.$9.GatPoly 0.0239169f
Cred_2533 VDD.$177.Metal1 vin.P20.GatPoly 0.00114642f
Cred_2534 VDD.$177.Metal1 vin.P21.GatPoly 0.150061f
Cred_2535 VDD.$177.Metal1 vin.P22.GatPoly 0.140189f
Cred_2536 VDD.$177.Metal1 vin.P23.GatPoly 0.0010558f
Cred_2537 VDD.$177.Metal1 vout.$1226.Metal3 0.211373f
Cred_2538 VDD.$177.Metal1 vout.P0.nSD 0.0046397f
Cred_2539 VDD.$177.Metal1 vout.P0.pSD 0.106723f
Cred_2540 VDD.$177.Metal1 vout.P2.nSD 0.00332998f
Cred_2541 VDD.$177.Metal1 vout.P2.pSD 0.0917309f
Cred_2542 VDD.$1770.Metal2 vin.$453.Metal1 1.36195e-06f
Cred_2543 VDD.$1770.Metal2 vin.$457.Metal1 8.92833e-06f
Cred_2544 VDD.$1770.Metal2 vin.$645.Metal2 0.000540267f
Cred_2545 VDD.$1770.Metal2 vin.$649.Metal2 0.00172029f
Cred_2546 VDD.$1770.Metal2 vin.P38.GatPoly 0.0112749f
Cred_2547 VDD.$1770.Metal2 vin.P39.GatPoly 5.44962e-06f
Cred_2548 VDD.$1770.Metal2 vout 0.00685648f
Cred_2549 VDD.$1770.Metal2 vout.P18.pSD 0.00277232f
Cred_2550 VDD.$1776.Metal2 vin.$179.GatPoly 3.1296e-07f
Cred_2551 VDD.$1776.Metal2 vin.$457.Metal1 1.65877e-05f
Cred_2552 VDD.$1776.Metal2 vin.$649.Metal2 3.52424e-07f
Cred_2553 VDD.$1776.Metal2 vin.$654.Metal2 0.00102009f
Cred_2554 VDD.$1776.Metal2 vin.P38.GatPoly 3.13461e-05f
Cred_2555 VDD.$1776.Metal2 vin.P39.GatPoly 0.00503831f
Cred_2556 VDD.$1776.Metal2 vout 0.0110418f
Cred_2557 VDD.$1776.Metal2 vout.P18.pSD 0.00518525f
Cred_2558 VDD.$1788.Metal2 vin.$179.GatPoly 3.1296e-07f
Cred_2559 VDD.$1788.Metal2 vin.$457.Metal1 1.65877e-05f
Cred_2560 VDD.$1788.Metal2 vin.$649.Metal2 3.52424e-07f
Cred_2561 VDD.$1788.Metal2 vin.$654.Metal2 0.00102009f
Cred_2562 VDD.$1788.Metal2 vin.P39.GatPoly 0.0174943f
Cred_2563 VDD.$1788.Metal2 vout 0.00106607f
Cred_2564 VDD.$1788.Metal2 vout.P18.pSD 0.000216355f
Cred_2565 VDD.$1803.Metal2 vin.$179.GatPoly 0.00119255f
Cred_2566 VDD.$1803.Metal2 vin.$457.Metal1 0.0105062f
Cred_2567 VDD.$1803.Metal2 vin.$649.Metal2 0.000222452f
Cred_2568 VDD.$1803.Metal2 vin.$654.Metal2 0.00110368f
Cred_2569 VDD.$1803.Metal2 vin.P39.GatPoly 0.0146978f
Cred_2570 VDD.$1803.Metal2 vout 0.101299f
Cred_2571 VDD.$1803.Metal2 vout.P18.pSD 0.0326079f
Cred_2572 VDD.$1803.Metal2 VSS.$1055.Metal2 3.29958e-05f
Cred_2573 VDD.$1803.Metal2 VSS.$1066.Metal2 0.0395643f
Cred_2574 VDD.$1803.Metal2 VSS.$1313.Metal3 0.00467288f
Cred_2575 VDD.$1803.Metal2 VSS.$18.Metal1 1.60179e-07f
Cred_2576 VDD.$1803.Metal2 VSS.$40.Metal1 6.2101e-08f
Cred_2577 VDD.$1803.Metal2 VSS.$501.Metal1 1.84395e-06f
Cred_2578 VDD.$1803.Metal2 VSS.$509.Metal1 0.00231125f
Cred_2579 VDD.$1803.Metal2 VSS.$520.Metal1 3.04215e-07f
Cred_2580 VDD.$1803.Metal2 VSS.$551.Metal1 0.000864325f
Cred_2581 VDD.$1803.Metal2 VSS.P0.pSD 0.00116071f
Cred_2582 VDD.$1803.Metal2 VSS.P21.nSD 9.76085e-06f
Cred_2583 VDD.$1803.Metal2 VSS.P23.nSD 9.76085e-06f
Cred_2584 VDD.$1806.Metal2 vin.P39.GatPoly 0.012132f
Cred_2585 VDD.$1806.Metal2 vout 0.0452213f
Cred_2586 VDD.$1806.Metal2 vout.P18.pSD 0.0161454f
Cred_2587 VDD.$1808.Metal2 vin.P39.GatPoly 0.0097142f
Cred_2588 VDD.$1808.Metal2 vout 0.0355185f
Cred_2589 VDD.$1808.Metal2 vout.P18.pSD 0.0133365f
Cred_2590 VDD.$1810.Metal2 vin.P39.GatPoly 0.00970713f
Cred_2591 VDD.$1810.Metal2 vout 0.0350871f
Cred_2592 VDD.$1810.Metal2 vout.P18.pSD 0.0135708f
Cred_2593 VDD.$1812.Metal2 vin.P39.GatPoly 0.00728892f
Cred_2594 VDD.$1812.Metal2 vout 0.0263847f
Cred_2595 VDD.$1812.Metal2 vout.P18.pSD 0.0103358f
Cred_2596 VDD.$1813.Metal2 vin.P39.GatPoly 0.00837826f
Cred_2597 VDD.$1813.Metal2 vout 0.0226423f
Cred_2598 VDD.$1813.Metal2 vout.P18.pSD 0.00900166f
Cred_2599 VDD.$1815.Metal2 vin.P39.GatPoly 0.00104074f
Cred_2600 VDD.$1822.Metal2 vin.P39.GatPoly 0.000401236f
Cred_2601 VDD.$1884.Metal3 vin.P20.GatPoly 0.00357372f
Cred_2602 VDD.$1896.Metal3 vin.$199.Metal1 2.01126e-07f
Cred_2603 VDD.$1896.Metal3 vin.$478.Metal2 8.11349e-06f
Cred_2604 VDD.$1896.Metal3 vin.$7.GatPoly 2.85641e-09f
Cred_2605 VDD.$1896.Metal3 vin.P20.GatPoly 0.014158f
Cred_2606 VDD.$1896.Metal3 vout.$1226.Metal3 0.0108022f
Cred_2607 VDD.$1896.Metal3 vout.P0.nSD 0.000321654f
Cred_2608 VDD.$1896.Metal3 vout.P0.pSD 0.00503866f
Cred_2609 VDD.$1896.Metal3 vout.P2.nSD 0.000170178f
Cred_2610 VDD.$1896.Metal3 vout.P2.pSD 0.000930061f
Cred_2611 VDD.$1902.Metal3 vin.$199.Metal1 3.92822e-08f
Cred_2612 VDD.$1902.Metal3 vin.$478.Metal2 2.59592e-06f
Cred_2613 VDD.$1902.Metal3 vin.$482.Metal2 2.05774e-06f
Cred_2614 VDD.$1902.Metal3 vin.P21.GatPoly 0.0105106f
Cred_2615 VDD.$1902.Metal3 vin.P22.GatPoly 0.0004326f
Cred_2616 VDD.$1902.Metal3 vout.$1226.Metal3 0.0178394f
Cred_2617 VDD.$1902.Metal3 vout.P0.nSD 0.000531201f
Cred_2618 VDD.$1902.Metal3 vout.P0.pSD 0.00752215f
Cred_2619 VDD.$1902.Metal3 vout.P2.nSD 0.000281043f
Cred_2620 VDD.$1902.Metal3 vout.P2.pSD 0.00153597f
Cred_2621 VDD.$1914.Metal3 vin.$17.GatPoly 1.17789e-10f
Cred_2622 VDD.$1914.Metal3 vin.$211.Metal1 9.87226e-09f
Cred_2623 VDD.$1914.Metal3 vin.$219.Metal1 6.99719e-08f
Cred_2624 VDD.$1914.Metal3 vin.$489.Metal2 4.2125e-06f
Cred_2625 VDD.$1914.Metal3 vin.$493.Metal2 4.2124e-06f
Cred_2626 VDD.$1914.Metal3 vin.P21.GatPoly 0.00414704f
Cred_2627 VDD.$1914.Metal3 vin.P22.GatPoly 0.0130386f
Cred_2628 VDD.$1914.Metal3 vout.$1226.Metal3 0.00902337f
Cred_2629 VDD.$1914.Metal3 vout.P0.nSD 0.000166067f
Cred_2630 VDD.$1914.Metal3 vout.P0.pSD 0.000882455f
Cred_2631 VDD.$1914.Metal3 vout.P2.nSD 0.000142155f
Cred_2632 VDD.$1914.Metal3 vout.P2.pSD 0.00188153f
Cred_2633 VDD.$1920.Metal3 vin.$233.Metal1 1.53532e-08f
Cred_2634 VDD.$1920.Metal3 vin.$237.Metal1 2.06475e-08f
Cred_2635 VDD.$1920.Metal3 vin.$500.Metal2 1.89497e-06f
Cred_2636 VDD.$1920.Metal3 vin.$504.Metal2 1.89497e-06f
Cred_2637 VDD.$1920.Metal3 vin.P22.GatPoly 0.00134656f
Cred_2638 VDD.$1920.Metal3 vin.P23.GatPoly 0.00801103f
Cred_2639 VDD.$1920.Metal3 vout.$1226.Metal3 0.0246283f
Cred_2640 VDD.$1920.Metal3 vout.P0.nSD 0.000356657f
Cred_2641 VDD.$1920.Metal3 vout.P0.pSD 0.00189522f
Cred_2642 VDD.$1920.Metal3 vout.P2.nSD 0.000387996f
Cred_2643 VDD.$1920.Metal3 vout.P2.pSD 0.00759354f
Cred_2644 VDD.$1932.Metal3 vin.$233.Metal1 1.53532e-08f
Cred_2645 VDD.$1932.Metal3 vin.$237.Metal1 2.06475e-08f
Cred_2646 VDD.$1932.Metal3 vin.$247.Metal1 4.41596e-08f
Cred_2647 VDD.$1932.Metal3 vin.$251.Metal1 1.04377e-08f
Cred_2648 VDD.$1932.Metal3 vin.$500.Metal2 1.89497e-06f
Cred_2649 VDD.$1932.Metal3 vin.$504.Metal2 1.89497e-06f
Cred_2650 VDD.$1932.Metal3 vin.$509.Metal2 2.86876e-06f
Cred_2651 VDD.$1932.Metal3 vin.$513.Metal2 2.86876e-06f
Cred_2652 VDD.$1932.Metal3 vin.P23.GatPoly 0.00606445f
Cred_2653 VDD.$1932.Metal3 vin.P24.GatPoly 0.011099f
Cred_2654 VDD.$1932.Metal3 vout.$1226.Metal3 0.0132179f
Cred_2655 VDD.$1932.Metal3 vout.P0.nSD 6.09185e-05f
Cred_2656 VDD.$1932.Metal3 vout.P0.pSD 0.000323711f
Cred_2657 VDD.$1932.Metal3 vout.P2.nSD 6.62714e-05f
Cred_2658 VDD.$1932.Metal3 vout.P2.pSD 0.000835956f
Cred_2659 VDD.$1932.Metal3 vout.P4.pSD 0.00100504f
Cred_2660 VDD.$1941.Metal3 vin.$247.Metal1 2.19916e-08f
Cred_2661 VDD.$1941.Metal3 vin.$251.Metal1 5.19803e-09f
Cred_2662 VDD.$1941.Metal3 vin.$509.Metal2 1.42865e-06f
Cred_2663 VDD.$1941.Metal3 vin.$513.Metal2 1.42865e-06f
Cred_2664 VDD.$1941.Metal3 vin.P24.GatPoly 0.00326681f
Cred_2665 VDD.$1941.Metal3 vin.P25.GatPoly 0.0032554f
Cred_2666 VDD.$1941.Metal3 vout.$1226.Metal3 0.0283234f
Cred_2667 VDD.$1941.Metal3 vout.P4.pSD 0.00529677f
Cred_2668 VDD.$1947.Metal3 vin.$263.Metal1 2.75364e-08f
Cred_2669 VDD.$1947.Metal3 vin.$269.Metal1 2.83633e-08f
Cred_2670 VDD.$1947.Metal3 vin.$51.GatPoly 3.26941e-10f
Cred_2671 VDD.$1947.Metal3 vin.$520.Metal2 2.97432e-06f
Cred_2672 VDD.$1947.Metal3 vin.$524.Metal2 2.97432e-06f
Cred_2673 VDD.$1947.Metal3 vin.P25.GatPoly 0.01135f
Cred_2674 VDD.$1947.Metal3 vin.P26.GatPoly 0.00537381f
Cred_2675 VDD.$1947.Metal3 vout.$1226.Metal3 0.00843498f
Cred_2676 VDD.$1947.Metal3 vout.$1292.Metal3 0.00165789f
Cred_2677 VDD.$1947.Metal3 vout.P4.pSD 0.000530738f
Cred_2678 VDD.$1947.Metal3 vout.P6.nSD 2.61185e-05f
Cred_2679 VDD.$1947.Metal3 vout.P6.pSD 0.000354946f
Cred_2680 VDD.$1959.Metal3 vin.$291.Metal1 2.03792e-08f
Cred_2681 VDD.$1959.Metal3 vin.$295.Metal1 6.79306e-09f
Cred_2682 VDD.$1959.Metal3 vin.$538.Metal2 1.42866e-06f
Cred_2683 VDD.$1959.Metal3 vin.$542.Metal2 1.42866e-06f
Cred_2684 VDD.$1959.Metal3 vin.P26.GatPoly 0.00898812f
Cred_2685 VDD.$1959.Metal3 vin.P27.GatPoly 0.00303116f
Cred_2686 VDD.$1959.Metal3 vout.$1226.Metal3 0.0151598f
Cred_2687 VDD.$1959.Metal3 vout.$1292.Metal3 0.0148445f
Cred_2688 VDD.$1959.Metal3 vout.P6.nSD 0.000233861f
Cred_2689 VDD.$1959.Metal3 vout.P6.pSD 0.00677025f
Cred_2690 VDD.$1968.Metal3 vin.$291.Metal1 4.09217e-08f
Cred_2691 VDD.$1968.Metal3 vin.$295.Metal1 1.36406e-08f
Cred_2692 VDD.$1968.Metal3 vin.$303.Metal1 4.49615e-09f
Cred_2693 VDD.$1968.Metal3 vin.$307.Metal1 2.94748e-08f
Cred_2694 VDD.$1968.Metal3 vin.$538.Metal2 2.86877e-06f
Cred_2695 VDD.$1968.Metal3 vin.$542.Metal2 2.86877e-06f
Cred_2696 VDD.$1968.Metal3 vin.$547.Metal2 1.78356e-06f
Cred_2697 VDD.$1968.Metal3 vin.$551.Metal2 1.78356e-06f
Cred_2698 VDD.$1968.Metal3 vin.P27.GatPoly 0.0113824f
Cred_2699 VDD.$1968.Metal3 vin.P28.GatPoly 0.00611441f
Cred_2700 VDD.$1968.Metal3 vout.$1226.Metal3 0.0045127f
Cred_2701 VDD.$1968.Metal3 vout.$1292.Metal3 0.00918933f
Cred_2702 VDD.$1968.Metal3 vout.P6.nSD 7.10933e-05f
Cred_2703 VDD.$1968.Metal3 vout.P6.pSD 0.00150979f
Cred_2704 VDD.$1968.Metal3 vout.P8.pSD 0.000431873f
Cred_2705 VDD.$1980.Metal3 vin.$303.Metal1 4.49615e-09f
Cred_2706 VDD.$1980.Metal3 vin.$307.Metal1 2.94748e-08f
Cred_2707 VDD.$1980.Metal3 vin.$321.Metal1 1.08528e-08f
Cred_2708 VDD.$1980.Metal3 vin.$325.Metal1 2.42897e-08f
Cred_2709 VDD.$1980.Metal3 vin.$547.Metal2 1.78356e-06f
Cred_2710 VDD.$1980.Metal3 vin.$551.Metal2 1.78356e-06f
Cred_2711 VDD.$1980.Metal3 vin.$558.Metal2 1.84867e-06f
Cred_2712 VDD.$1980.Metal3 vin.$562.Metal2 1.84867e-06f
Cred_2713 VDD.$1980.Metal3 vin.P28.GatPoly 0.00841682f
Cred_2714 VDD.$1980.Metal3 vin.P29.GatPoly 0.00618333f
Cred_2715 VDD.$1980.Metal3 vout.$1292.Metal3 0.0330853f
Cred_2716 VDD.$1980.Metal3 vout.P8.pSD 0.0059389f
Cred_2717 VDD.$2001.Metal3 vin.$335.Metal1 2.38488e-08f
Cred_2718 VDD.$2001.Metal3 vin.$339.Metal1 1.06559e-08f
Cred_2719 VDD.$2001.Metal3 vin.$353.Metal1 2.94748e-08f
Cred_2720 VDD.$2001.Metal3 vin.$357.Metal1 4.49615e-09f
Cred_2721 VDD.$2001.Metal3 vin.$567.Metal2 1.81511e-06f
Cred_2722 VDD.$2001.Metal3 vin.$571.Metal2 1.81511e-06f
Cred_2723 VDD.$2001.Metal3 vin.$578.Metal2 1.78356e-06f
Cred_2724 VDD.$2001.Metal3 vin.$582.Metal2 1.78356e-06f
Cred_2725 VDD.$2001.Metal3 vin.P30.GatPoly 0.00606591f
Cred_2726 VDD.$2001.Metal3 vin.P31.GatPoly 0.00841682f
Cred_2727 VDD.$2001.Metal3 vout.$1292.Metal3 0.015725f
Cred_2728 VDD.$2001.Metal3 vout.$1358.Metal3 0.015725f
Cred_2729 VDD.$2001.Metal3 vout.P10.nSD 0.000247733f
Cred_2730 VDD.$2001.Metal3 vout.P10.pSD 0.00758939f
Cred_2731 VDD.$2013.Metal3 vin.$353.Metal1 2.94748e-08f
Cred_2732 VDD.$2013.Metal3 vin.$357.Metal1 4.49615e-09f
Cred_2733 VDD.$2013.Metal3 vin.$365.Metal1 1.36406e-08f
Cred_2734 VDD.$2013.Metal3 vin.$369.Metal1 4.09217e-08f
Cred_2735 VDD.$2013.Metal3 vin.$578.Metal2 1.78356e-06f
Cred_2736 VDD.$2013.Metal3 vin.$582.Metal2 1.78356e-06f
Cred_2737 VDD.$2013.Metal3 vin.$587.Metal2 2.86877e-06f
Cred_2738 VDD.$2013.Metal3 vin.$591.Metal2 2.86877e-06f
Cred_2739 VDD.$2013.Metal3 vin.P31.GatPoly 0.00611441f
Cred_2740 VDD.$2013.Metal3 vin.P32.GatPoly 0.0113824f
Cred_2741 VDD.$2013.Metal3 vout.$1292.Metal3 0.00221696f
Cred_2742 VDD.$2013.Metal3 vout.$1358.Metal3 0.0121575f
Cred_2743 VDD.$2013.Metal3 vout.P10.nSD 3.49261e-05f
Cred_2744 VDD.$2013.Metal3 vout.P10.pSD 0.000639657f
Cred_2745 VDD.$2013.Metal3 vout.P12.pSD 0.00127401f
Cred_2746 VDD.$2022.Metal3 vin.$365.Metal1 6.79306e-09f
Cred_2747 VDD.$2022.Metal3 vin.$369.Metal1 2.03792e-08f
Cred_2748 VDD.$2022.Metal3 vin.$587.Metal2 1.42866e-06f
Cred_2749 VDD.$2022.Metal3 vin.$591.Metal2 1.42866e-06f
Cred_2750 VDD.$2022.Metal3 vin.P32.GatPoly 0.00303116f
Cred_2751 VDD.$2022.Metal3 vin.P33.GatPoly 0.00898812f
Cred_2752 VDD.$2022.Metal3 vout.$1358.Metal3 0.0312043f
Cred_2753 VDD.$2022.Metal3 vout.$1424.Metal3 0.000150095f
Cred_2754 VDD.$2022.Metal3 vout.P12.pSD 0.00574712f
Cred_2755 VDD.$2022.Metal3 vout.P14.nSD 2.3646e-06f
Cred_2756 VDD.$2022.Metal3 vout.P14.pSD 1.28068e-05f
Cred_2757 VDD.$2034.Metal3 vin.$139.GatPoly 3.26941e-10f
Cred_2758 VDD.$2034.Metal3 vin.$391.Metal1 2.83633e-08f
Cred_2759 VDD.$2034.Metal3 vin.$397.Metal1 2.75364e-08f
Cred_2760 VDD.$2034.Metal3 vin.$605.Metal2 2.97432e-06f
Cred_2761 VDD.$2034.Metal3 vin.$609.Metal2 2.97432e-06f
Cred_2762 VDD.$2034.Metal3 vin.P33.GatPoly 0.00537381f
Cred_2763 VDD.$2034.Metal3 vin.P34.GatPoly 0.01135f
Cred_2764 VDD.$2034.Metal3 vout.$1358.Metal3 0.00669012f
Cred_2765 VDD.$2034.Metal3 vout.$1424.Metal3 0.00321464f
Cred_2766 VDD.$2034.Metal3 vout.P12.pSD 0.000221352f
Cred_2767 VDD.$2034.Metal3 vout.P14.nSD 5.06436e-05f
Cred_2768 VDD.$2034.Metal3 vout.P14.pSD 0.000827912f
Cred_2769 VDD.$2040.Metal3 vin.$409.Metal1 5.19803e-09f
Cred_2770 VDD.$2040.Metal3 vin.$413.Metal1 2.19916e-08f
Cred_2771 VDD.$2040.Metal3 vin.$616.Metal2 1.42865e-06f
Cred_2772 VDD.$2040.Metal3 vin.$620.Metal2 1.42865e-06f
Cred_2773 VDD.$2040.Metal3 vin.P34.GatPoly 0.0032554f
Cred_2774 VDD.$2040.Metal3 vin.P35.GatPoly 0.00326681f
Cred_2775 VDD.$2040.Metal3 vout.$1358.Metal3 0.0139162f
Cred_2776 VDD.$2040.Metal3 vout.$1424.Metal3 0.0139162f
Cred_2777 VDD.$2040.Metal3 vout.P14.nSD 0.000219237f
Cred_2778 VDD.$2040.Metal3 vout.P14.pSD 0.00694911f
Cred_2779 VDD.$2049.Metal3 vin.$409.Metal1 1.04377e-08f
Cred_2780 VDD.$2049.Metal3 vin.$413.Metal1 4.41596e-08f
Cred_2781 VDD.$2049.Metal3 vin.$423.Metal1 2.06475e-08f
Cred_2782 VDD.$2049.Metal3 vin.$427.Metal1 1.53532e-08f
Cred_2783 VDD.$2049.Metal3 vin.$616.Metal2 2.86876e-06f
Cred_2784 VDD.$2049.Metal3 vin.$620.Metal2 2.86876e-06f
Cred_2785 VDD.$2049.Metal3 vin.$625.Metal2 1.89497e-06f
Cred_2786 VDD.$2049.Metal3 vin.$629.Metal2 1.89497e-06f
Cred_2787 VDD.$2049.Metal3 vin.P35.GatPoly 0.011099f
Cred_2788 VDD.$2049.Metal3 vin.P36.GatPoly 0.00606445f
Cred_2789 VDD.$2049.Metal3 vout.$1358.Metal3 0.00401826f
Cred_2790 VDD.$2049.Metal3 vout.$1424.Metal3 0.00901755f
Cred_2791 VDD.$2049.Metal3 vout.P14.nSD 6.3304e-05f
Cred_2792 VDD.$2049.Metal3 vout.P14.pSD 0.00128238f
Cred_2793 VDD.$2049.Metal3 vout.P16.pSD 0.000494196f
Cred_2794 VDD.$2061.Metal3 vin.$173.GatPoly 3.88476e-11f
Cred_2795 VDD.$2061.Metal3 vin.$423.Metal1 2.06475e-08f
Cred_2796 VDD.$2061.Metal3 vin.$427.Metal1 1.53532e-08f
Cred_2797 VDD.$2061.Metal3 vin.$441.Metal1 2.30773e-08f
Cred_2798 VDD.$2061.Metal3 vin.$449.Metal1 3.25595e-09f
Cred_2799 VDD.$2061.Metal3 vin.$625.Metal2 1.89497e-06f
Cred_2800 VDD.$2061.Metal3 vin.$629.Metal2 1.89497e-06f
Cred_2801 VDD.$2061.Metal3 vin.$636.Metal2 1.38928e-06f
Cred_2802 VDD.$2061.Metal3 vin.$640.Metal2 1.38931e-06f
Cred_2803 VDD.$2061.Metal3 vin.P36.GatPoly 0.00801103f
Cred_2804 VDD.$2061.Metal3 vin.P37.GatPoly 0.00521418f
Cred_2805 VDD.$2061.Metal3 vout.$1424.Metal3 0.0323836f
Cred_2806 VDD.$2061.Metal3 vout.P16.pSD 0.00621411f
Cred_2807 VDD.$2070.Metal3 vin.$173.GatPoly 7.80068e-11f
Cred_2808 VDD.$2070.Metal3 vin.$441.Metal1 4.63396e-08f
Cred_2809 VDD.$2070.Metal3 vin.$449.Metal1 6.538e-09f
Cred_2810 VDD.$2070.Metal3 vin.$636.Metal2 2.7897e-06f
Cred_2811 VDD.$2070.Metal3 vin.$640.Metal2 2.78977e-06f
Cred_2812 VDD.$2070.Metal3 vin.P37.GatPoly 0.00953149f
Cred_2813 VDD.$2070.Metal3 vin.P38.GatPoly 0.00163262f
Cred_2814 VDD.$2070.Metal3 vout.$1424.Metal3 0.00766878f
Cred_2815 VDD.$2070.Metal3 vout.P16.pSD 0.000763089f
Cred_2816 VDD.$2076.Metal3 vin.$453.Metal1 1.09198e-08f
Cred_2817 VDD.$2076.Metal3 vin.$457.Metal1 7.15854e-08f
Cred_2818 VDD.$2076.Metal3 vin.$645.Metal2 4.33174e-06f
Cred_2819 VDD.$2076.Metal3 vin.$649.Metal2 4.33174e-06f
Cred_2820 VDD.$2076.Metal3 vin.P38.GatPoly 0.0128027f
Cred_2821 VDD.$2076.Metal3 vout 0.0152981f
Cred_2822 VDD.$2076.Metal3 vout.P18.pSD 0.00321487f
Cred_2823 VDD.$2085.Metal3 vin.$179.GatPoly 2.50925e-09f
Cred_2824 VDD.$2085.Metal3 vin.$457.Metal1 1.32996e-07f
Cred_2825 VDD.$2085.Metal3 vin.$649.Metal2 2.82566e-09f
Cred_2826 VDD.$2085.Metal3 vin.$654.Metal2 8.17889e-06f
Cred_2827 VDD.$2085.Metal3 vin.P38.GatPoly 0.00039274f
Cred_2828 VDD.$2085.Metal3 vin.P39.GatPoly 0.014158f
Cred_2829 VDD.$2085.Metal3 vout 0.0202631f
Cred_2830 VDD.$2085.Metal3 vout.P18.pSD 0.00504951f
Cred_2831 VDD.$2097.Metal3 vin.P39.GatPoly 0.00357372f
Cred_2832 VDD.$230.Metal1 vin.$17.GatPoly 1.17789e-10f
Cred_2833 VDD.$230.Metal1 vin.$211.Metal1 9.87226e-09f
Cred_2834 VDD.$230.Metal1 vin.$219.Metal1 6.99719e-08f
Cred_2835 VDD.$230.Metal1 vin.$489.Metal2 4.2125e-06f
Cred_2836 VDD.$230.Metal1 vin.$493.Metal2 4.2124e-06f
Cred_2837 VDD.$230.Metal1 vin.P22.GatPoly 0.0209564f
Cred_2838 VDD.$230.Metal1 vout.$1226.Metal3 0.0024415f
Cred_2839 VDD.$230.Metal1 vout.P0.nSD 3.53567e-05f
Cred_2840 VDD.$230.Metal1 vout.P0.pSD 0.000187879f
Cred_2841 VDD.$230.Metal1 vout.P2.nSD 3.84635e-05f
Cred_2842 VDD.$230.Metal1 vout.P2.pSD 0.00183667f
Cred_2843 VDD.$242.Metal1 vin.P22.GatPoly 0.00581998f
Cred_2844 VDD.$242.Metal1 vin.P23.GatPoly 0.00723714f
Cred_2845 VDD.$242.Metal1 vout.$1226.Metal3 0.0126261f
Cred_2846 VDD.$242.Metal1 vout.P0.nSD 0.000182845f
Cred_2847 VDD.$242.Metal1 vout.P0.pSD 0.000971608f
Cred_2848 VDD.$242.Metal1 vout.P2.nSD 0.000198912f
Cred_2849 VDD.$242.Metal1 vout.P2.pSD 0.0111692f
Cred_2850 VDD.$252.Metal1 vin.$233.Metal1 3.11999e-08f
Cred_2851 VDD.$252.Metal1 vin.$237.Metal1 4.19584e-08f
Cred_2852 VDD.$252.Metal1 vin.$500.Metal2 3.85084e-06f
Cred_2853 VDD.$252.Metal1 vin.$504.Metal2 3.85084e-06f
Cred_2854 VDD.$252.Metal1 vin.P23.GatPoly 0.020045f
Cred_2855 VDD.$252.Metal1 vout.$1226.Metal3 0.00182466f
Cred_2856 VDD.$252.Metal1 vout.P0.nSD 2.64239e-05f
Cred_2857 VDD.$252.Metal1 vout.P0.pSD 0.000140412f
Cred_2858 VDD.$252.Metal1 vout.P2.nSD 2.87458e-05f
Cred_2859 VDD.$252.Metal1 vout.P2.pSD 0.00146991f
Cred_2860 VDD.$257.Metal1 vin.$237.Metal1 0.00428125f
Cred_2861 VDD.$257.Metal1 vin.$241.Metal1 0.0186649f
Cred_2862 VDD.$257.Metal1 vin.$247.Metal1 0.00854531f
Cred_2863 VDD.$257.Metal1 vin.$25.GatPoly 0.0283599f
Cred_2864 VDD.$257.Metal1 vin.$251.Metal1 0.00274003f
Cred_2865 VDD.$257.Metal1 vin.$37.GatPoly 0.0162307f
Cred_2866 VDD.$257.Metal1 vin.$43.GatPoly 0.00518074f
Cred_2867 VDD.$257.Metal1 vin.$503.Metal2 0.000446843f
Cred_2868 VDD.$257.Metal1 vin.$504.Metal2 0.0156811f
Cred_2869 VDD.$257.Metal1 vin.$506.Metal2 0.00225569f
Cred_2870 VDD.$257.Metal1 vin.$508.Metal2 0.000325481f
Cred_2871 VDD.$257.Metal1 vin.$509.Metal2 0.00943879f
Cred_2872 VDD.$257.Metal1 vin.P22.GatPoly 0.00105511f
Cred_2873 VDD.$257.Metal1 vin.P23.GatPoly 0.139688f
Cred_2874 VDD.$257.Metal1 vin.P24.GatPoly 0.146578f
Cred_2875 VDD.$257.Metal1 vin.P25.GatPoly 0.00105511f
Cred_2876 VDD.$257.Metal1 vout.$1226.Metal3 0.241075f
Cred_2877 VDD.$257.Metal1 vout.P0.nSD 0.00158748f
Cred_2878 VDD.$257.Metal1 vout.P0.pSD 0.00843562f
Cred_2879 VDD.$257.Metal1 vout.P2.nSD 0.00172698f
Cred_2880 VDD.$257.Metal1 vout.P2.pSD 0.0828494f
Cred_2881 VDD.$257.Metal1 vout.P4.pSD 0.0740594f
Cred_2882 VDD.$315.Metal1 vin.$247.Metal1 6.66817e-08f
Cred_2883 VDD.$315.Metal1 vin.$251.Metal1 1.57611e-08f
Cred_2884 VDD.$315.Metal1 vin.$509.Metal2 4.33186e-06f
Cred_2885 VDD.$315.Metal1 vin.$513.Metal2 4.33186e-06f
Cred_2886 VDD.$315.Metal1 vin.P24.GatPoly 0.0217261f
Cred_2887 VDD.$315.Metal1 vout.$1226.Metal3 0.00470607f
Cred_2888 VDD.$315.Metal1 vout.P4.pSD 0.00270458f
Cred_2889 VDD.$325.Metal1 vin.P24.GatPoly 0.00371716f
Cred_2890 VDD.$325.Metal1 vin.P25.GatPoly 0.0105611f
Cred_2891 VDD.$325.Metal1 vout.$1226.Metal3 0.0147891f
Cred_2892 VDD.$325.Metal1 vout.P4.pSD 0.00980793f
Cred_2893 VDD.$337.Metal1 vin.$263.Metal1 2.75364e-08f
Cred_2894 VDD.$337.Metal1 vin.$269.Metal1 2.83633e-08f
Cred_2895 VDD.$337.Metal1 vin.$51.GatPoly 3.26941e-10f
Cred_2896 VDD.$337.Metal1 vin.$520.Metal2 2.97432e-06f
Cred_2897 VDD.$337.Metal1 vin.$524.Metal2 2.97432e-06f
Cred_2898 VDD.$337.Metal1 vin.P25.GatPoly 0.0199847f
Cred_2899 VDD.$337.Metal1 vin.P26.GatPoly 0.000377447f
Cred_2900 VDD.$337.Metal1 vout.$1226.Metal3 0.00148921f
Cred_2901 VDD.$337.Metal1 vout.P4.pSD 0.000678888f
Cred_2902 VDD.$376.Metal1 vin.$259.Metal1 0.00211539f
Cred_2903 VDD.$376.Metal1 vin.$263.Metal1 0.00659954f
Cred_2904 VDD.$376.Metal1 vin.$269.Metal1 0.0252167f
Cred_2905 VDD.$376.Metal1 vin.$277.Metal1 0.00548355f
Cred_2906 VDD.$376.Metal1 vin.$43.GatPoly 0.00399969f
Cred_2907 VDD.$376.Metal1 vin.$51.GatPoly 0.0195973f
Cred_2908 VDD.$376.Metal1 vin.$520.Metal2 0.00216232f
Cred_2909 VDD.$376.Metal1 vin.$523.Metal2 0.000575922f
Cred_2910 VDD.$376.Metal1 vin.$524.Metal2 0.0224755f
Cred_2911 VDD.$376.Metal1 vin.$526.Metal2 0.00269645f
Cred_2912 VDD.$376.Metal1 vin.$528.Metal2 2.18705e-05f
Cred_2913 VDD.$376.Metal1 vin.$529.Metal2 0.00581479f
Cred_2914 VDD.$376.Metal1 vin.$55.GatPoly 0.00886219f
Cred_2915 VDD.$376.Metal1 vin.$57.GatPoly 0.0321081f
Cred_2916 VDD.$376.Metal1 vin.P24.GatPoly 0.0012978f
Cred_2917 VDD.$376.Metal1 vin.P25.GatPoly 0.173068f
Cred_2918 VDD.$376.Metal1 vin.P26.GatPoly 0.168705f
Cred_2919 VDD.$376.Metal1 vin.P27.GatPoly 0.0012978f
Cred_2920 VDD.$376.Metal1 vout.$1226.Metal3 0.237585f
Cred_2921 VDD.$376.Metal1 vout.$1292.Metal3 0.0756726f
Cred_2922 VDD.$376.Metal1 vout.P4.pSD 0.092526f
Cred_2923 VDD.$376.Metal1 vout.P6.nSD 0.00119215f
Cred_2924 VDD.$376.Metal1 vout.P6.pSD 0.0953637f
Cred_2925 VDD.$393.Metal1 vin.P26.GatPoly 0.0191901f
Cred_2926 VDD.$393.Metal1 vout.$1226.Metal3 0.000376301f
Cred_2927 VDD.$393.Metal1 vout.$1292.Metal3 0.000376301f
Cred_2928 VDD.$393.Metal1 vout.P6.nSD 5.92827e-06f
Cred_2929 VDD.$393.Metal1 vout.P6.pSD 0.000152972f
Cred_2930 VDD.$403.Metal1 vin.P26.GatPoly 0.0106554f
Cred_2931 VDD.$403.Metal1 vin.P27.GatPoly 0.00368917f
Cred_2932 VDD.$403.Metal1 vout.$1226.Metal3 0.00717756f
Cred_2933 VDD.$403.Metal1 vout.$1292.Metal3 0.00717756f
Cred_2934 VDD.$403.Metal1 vout.P6.nSD 0.000113076f
Cred_2935 VDD.$403.Metal1 vout.P6.pSD 0.011084f
Cred_2936 VDD.$415.Metal1 vin.$291.Metal1 6.17924e-08f
Cred_2937 VDD.$415.Metal1 vin.$295.Metal1 2.05975e-08f
Cred_2938 VDD.$415.Metal1 vin.$538.Metal2 4.33189e-06f
Cred_2939 VDD.$415.Metal1 vin.$542.Metal2 4.33189e-06f
Cred_2940 VDD.$415.Metal1 vin.P27.GatPoly 0.0221384f
Cred_2941 VDD.$415.Metal1 vout.$1226.Metal3 0.00236534f
Cred_2942 VDD.$415.Metal1 vout.$1292.Metal3 0.00236534f
Cred_2943 VDD.$415.Metal1 vout.P6.nSD 3.72637e-05f
Cred_2944 VDD.$415.Metal1 vout.P6.pSD 0.00312681f
Cred_2945 VDD.$423.Metal1 vin.$291.Metal1 0.00426384f
Cred_2946 VDD.$423.Metal1 vin.$295.Metal1 0.0111542f
Cred_2947 VDD.$423.Metal1 vin.$298.Metal1 1.15474e-06f
Cred_2948 VDD.$423.Metal1 vin.$302.Metal1 2.25926e-06f
Cred_2949 VDD.$423.Metal1 vin.$303.Metal1 0.0178435f
Cred_2950 VDD.$423.Metal1 vin.$307.Metal1 0.000307461f
Cred_2951 VDD.$423.Metal1 vin.$541.Metal2 0.000160292f
Cred_2952 VDD.$423.Metal1 vin.$542.Metal2 0.00812334f
Cred_2953 VDD.$423.Metal1 vin.$544.Metal2 0.00226581f
Cred_2954 VDD.$423.Metal1 vin.$547.Metal2 0.0168174f
Cred_2955 VDD.$423.Metal1 vin.$548.Metal2 0.00017963f
Cred_2956 VDD.$423.Metal1 vin.$551.Metal2 0.000190899f
Cred_2957 VDD.$423.Metal1 vin.$65.GatPoly 0.00806188f
Cred_2958 VDD.$423.Metal1 vin.$73.GatPoly 0.0145131f
Cred_2959 VDD.$423.Metal1 vin.$77.GatPoly 0.0274631f
Cred_2960 VDD.$423.Metal1 vin.P26.GatPoly 0.0010544f
Cred_2961 VDD.$423.Metal1 vin.P27.GatPoly 0.146476f
Cred_2962 VDD.$423.Metal1 vin.P28.GatPoly 0.138473f
Cred_2963 VDD.$423.Metal1 vin.P29.GatPoly 0.0010544f
Cred_2964 VDD.$423.Metal1 vout.$1226.Metal3 0.062657f
Cred_2965 VDD.$423.Metal1 vout.$1292.Metal3 0.1917f
Cred_2966 VDD.$423.Metal1 vout.P6.nSD 0.000987102f
Cred_2967 VDD.$423.Metal1 vout.P6.pSD 0.0805737f
Cred_2968 VDD.$423.Metal1 vout.P8.pSD 0.07217f
Cred_2969 VDD.$476.Metal1 vin.$303.Metal1 9.13679e-09f
Cred_2970 VDD.$476.Metal1 vin.$307.Metal1 5.98967e-08f
Cred_2971 VDD.$476.Metal1 vin.$547.Metal2 3.62444e-06f
Cred_2972 VDD.$476.Metal1 vin.$551.Metal2 3.62444e-06f
Cred_2973 VDD.$476.Metal1 vin.P28.GatPoly 0.0206265f
Cred_2974 VDD.$476.Metal1 vout.$1292.Metal3 0.00222513f
Cred_2975 VDD.$476.Metal1 vout.P8.pSD 0.00112417f
Cred_2976 VDD.$488.Metal1 vin.P28.GatPoly 0.00726881f
Cred_2977 VDD.$488.Metal1 vin.P29.GatPoly 0.0047074f
Cred_2978 VDD.$488.Metal1 vout.$1292.Metal3 0.0150016f
Cred_2979 VDD.$488.Metal1 vout.P8.pSD 0.0104519f
Cred_2980 VDD.$498.Metal1 vin.$321.Metal1 2.54312e-08f
Cred_2981 VDD.$498.Metal1 vin.$325.Metal1 5.69174e-08f
Cred_2982 VDD.$498.Metal1 vin.$558.Metal2 4.33194e-06f
Cred_2983 VDD.$498.Metal1 vin.$562.Metal2 4.33194e-06f
Cred_2984 VDD.$498.Metal1 vin.P29.GatPoly 0.019035f
Cred_2985 VDD.$498.Metal1 vout.$1292.Metal3 0.00361944f
Cred_2986 VDD.$498.Metal1 vout.P8.pSD 0.00193198f
Cred_2987 VDD.$518.Metal1 vin.$325.Metal1 0.000440723f
Cred_2988 VDD.$518.Metal1 vin.$329.Metal1 0.00944804f
Cred_2989 VDD.$518.Metal1 vin.$335.Metal1 0.0030957f
Cred_2990 VDD.$518.Metal1 vin.$561.Metal2 0.000197082f
Cred_2991 VDD.$518.Metal1 vin.$562.Metal2 0.00620559f
Cred_2992 VDD.$518.Metal1 vin.$564.Metal2 0.00120633f
Cred_2993 VDD.$518.Metal1 vin.$566.Metal2 0.000197082f
Cred_2994 VDD.$518.Metal1 vin.$567.Metal2 0.00606313f
Cred_2995 VDD.$518.Metal1 vin.$87.GatPoly 0.0136753f
Cred_2996 VDD.$518.Metal1 vin.$95.GatPoly 0.00412178f
Cred_2997 VDD.$518.Metal1 vin.$97.GatPoly 0.0129812f
Cred_2998 VDD.$518.Metal1 vin.P28.GatPoly 0.000523882f
Cred_2999 VDD.$518.Metal1 vin.P29.GatPoly 0.0743899f
Cred_3000 VDD.$518.Metal1 vin.P30.GatPoly 0.0677807f
Cred_3001 VDD.$518.Metal1 vin.P31.GatPoly 0.000523882f
Cred_3002 VDD.$518.Metal1 vout.$1292.Metal3 0.0958372f
Cred_3003 VDD.$518.Metal1 vout.$1358.Metal3 0.0303665f
Cred_3004 VDD.$518.Metal1 vout.P10.nSD 0.000478395f
Cred_3005 VDD.$518.Metal1 vout.P10.pSD 0.0391192f
Cred_3006 VDD.$518.Metal1 vout.P8.pSD 0.0373545f
Cred_3007 VDD.$554.Metal1 vin.$325.Metal1 0.000440723f
Cred_3008 VDD.$554.Metal1 vin.$329.Metal1 0.00944804f
Cred_3009 VDD.$554.Metal1 vin.$335.Metal1 0.0030957f
Cred_3010 VDD.$554.Metal1 vin.$561.Metal2 0.000197082f
Cred_3011 VDD.$554.Metal1 vin.$562.Metal2 0.00620559f
Cred_3012 VDD.$554.Metal1 vin.$564.Metal2 0.00120633f
Cred_3013 VDD.$554.Metal1 vin.$566.Metal2 0.000197082f
Cred_3014 VDD.$554.Metal1 vin.$567.Metal2 0.00606313f
Cred_3015 VDD.$554.Metal1 vin.$87.GatPoly 0.0136753f
Cred_3016 VDD.$554.Metal1 vin.$95.GatPoly 0.00412178f
Cred_3017 VDD.$554.Metal1 vin.$97.GatPoly 0.0129812f
Cred_3018 VDD.$554.Metal1 vin.P28.GatPoly 0.000523882f
Cred_3019 VDD.$554.Metal1 vin.P29.GatPoly 0.0677807f
Cred_3020 VDD.$554.Metal1 vin.P30.GatPoly 0.0743899f
Cred_3021 VDD.$554.Metal1 vin.P31.GatPoly 0.000523882f
Cred_3022 VDD.$554.Metal1 vout.$1292.Metal3 0.0958372f
Cred_3023 VDD.$554.Metal1 vout.$1358.Metal3 0.0303665f
Cred_3024 VDD.$554.Metal1 vout.P10.nSD 0.000478395f
Cred_3025 VDD.$554.Metal1 vout.P10.pSD 0.0391192f
Cred_3026 VDD.$554.Metal1 vout.P8.pSD 0.0373545f
Cred_3027 VDD.$561.Metal1 vin.$335.Metal1 5.69174e-08f
Cred_3028 VDD.$561.Metal1 vin.$339.Metal1 2.54312e-08f
Cred_3029 VDD.$561.Metal1 vin.$567.Metal2 4.33194e-06f
Cred_3030 VDD.$561.Metal1 vin.$571.Metal2 4.33194e-06f
Cred_3031 VDD.$561.Metal1 vin.P30.GatPoly 0.019035f
Cred_3032 VDD.$561.Metal1 vout.$1292.Metal3 0.00166438f
Cred_3033 VDD.$561.Metal1 vout.$1358.Metal3 0.00166438f
Cred_3034 VDD.$561.Metal1 vout.P10.nSD 2.62207e-05f
Cred_3035 VDD.$561.Metal1 vout.P10.pSD 0.00198186f
Cred_3036 VDD.$571.Metal1 vin.P30.GatPoly 0.0047074f
Cred_3037 VDD.$571.Metal1 vin.P31.GatPoly 0.00726881f
Cred_3038 VDD.$571.Metal1 vout.$1292.Metal3 0.00697882f
Cred_3039 VDD.$571.Metal1 vout.$1358.Metal3 0.00697882f
Cred_3040 VDD.$571.Metal1 vout.P10.nSD 0.000109945f
Cred_3041 VDD.$571.Metal1 vout.P10.pSD 0.0107401f
Cred_3042 VDD.$581.Metal1 vin.$353.Metal1 5.98967e-08f
Cred_3043 VDD.$581.Metal1 vin.$357.Metal1 9.13679e-09f
Cred_3044 VDD.$581.Metal1 vin.$578.Metal2 3.62444e-06f
Cred_3045 VDD.$581.Metal1 vin.$582.Metal2 3.62444e-06f
Cred_3046 VDD.$581.Metal1 vin.P31.GatPoly 0.0206265f
Cred_3047 VDD.$581.Metal1 vout.$1292.Metal3 0.00105599f
Cred_3048 VDD.$581.Metal1 vout.$1358.Metal3 0.00105599f
Cred_3049 VDD.$581.Metal1 vout.P10.nSD 1.66361e-05f
Cred_3050 VDD.$581.Metal1 vout.P10.pSD 0.00122069f
Cred_3051 VDD.$586.Metal1 vin.$107.GatPoly 0.0274631f
Cred_3052 VDD.$586.Metal1 vin.$115.GatPoly 0.0145131f
Cred_3053 VDD.$586.Metal1 vin.$123.GatPoly 0.00806188f
Cred_3054 VDD.$586.Metal1 vin.$353.Metal1 0.000307461f
Cred_3055 VDD.$586.Metal1 vin.$356.Metal1 2.25926e-06f
Cred_3056 VDD.$586.Metal1 vin.$357.Metal1 0.0178435f
Cred_3057 VDD.$586.Metal1 vin.$360.Metal1 1.15474e-06f
Cred_3058 VDD.$586.Metal1 vin.$365.Metal1 0.0111542f
Cred_3059 VDD.$586.Metal1 vin.$369.Metal1 0.00426384f
Cred_3060 VDD.$586.Metal1 vin.$578.Metal2 0.000190899f
Cred_3061 VDD.$586.Metal1 vin.$579.Metal2 0.00017963f
Cred_3062 VDD.$586.Metal1 vin.$582.Metal2 0.0168174f
Cred_3063 VDD.$586.Metal1 vin.$584.Metal2 0.00226581f
Cred_3064 VDD.$586.Metal1 vin.$586.Metal2 0.000160292f
Cred_3065 VDD.$586.Metal1 vin.$587.Metal2 0.00812334f
Cred_3066 VDD.$586.Metal1 vin.P30.GatPoly 0.0010544f
Cred_3067 VDD.$586.Metal1 vin.P31.GatPoly 0.138473f
Cred_3068 VDD.$586.Metal1 vin.P32.GatPoly 0.146476f
Cred_3069 VDD.$586.Metal1 vin.P33.GatPoly 0.0010544f
Cred_3070 VDD.$586.Metal1 vout.$1292.Metal3 0.0620622f
Cred_3071 VDD.$586.Metal1 vout.$1358.Metal3 0.190792f
Cred_3072 VDD.$586.Metal1 vout.P10.nSD 0.000977732f
Cred_3073 VDD.$586.Metal1 vout.P10.pSD 0.0810546f
Cred_3074 VDD.$586.Metal1 vout.P12.pSD 0.0735443f
Cred_3075 VDD.$644.Metal1 vin.$365.Metal1 2.05975e-08f
Cred_3076 VDD.$644.Metal1 vin.$369.Metal1 6.17924e-08f
Cred_3077 VDD.$644.Metal1 vin.$587.Metal2 4.33189e-06f
Cred_3078 VDD.$644.Metal1 vin.$591.Metal2 4.33189e-06f
Cred_3079 VDD.$644.Metal1 vin.P32.GatPoly 0.0221384f
Cred_3080 VDD.$644.Metal1 vout.$1358.Metal3 0.0049557f
Cred_3081 VDD.$644.Metal1 vout.P12.pSD 0.00292337f
Cred_3082 VDD.$656.Metal1 vin.P32.GatPoly 0.00368917f
Cred_3083 VDD.$656.Metal1 vin.P33.GatPoly 0.0106554f
Cred_3084 VDD.$656.Metal1 vout.$1358.Metal3 0.0146403f
Cred_3085 VDD.$656.Metal1 vout.P12.pSD 0.0100648f
Cred_3086 VDD.$666.Metal1 vin.P33.GatPoly 0.0191901f
Cred_3087 VDD.$666.Metal1 vout.$1358.Metal3 0.000784078f
Cred_3088 VDD.$666.Metal1 vout.P12.pSD 0.000127424f
Cred_3089 VDD.$702.Metal1 vin.$127.GatPoly 0.0321081f
Cred_3090 VDD.$702.Metal1 vin.$133.GatPoly 0.00886219f
Cred_3091 VDD.$702.Metal1 vin.$139.GatPoly 0.0195973f
Cred_3092 VDD.$702.Metal1 vin.$145.GatPoly 0.00399969f
Cred_3093 VDD.$702.Metal1 vin.$383.Metal1 0.00548355f
Cred_3094 VDD.$702.Metal1 vin.$391.Metal1 0.0252167f
Cred_3095 VDD.$702.Metal1 vin.$397.Metal1 0.00659954f
Cred_3096 VDD.$702.Metal1 vin.$401.Metal1 0.00211539f
Cred_3097 VDD.$702.Metal1 vin.$599.Metal2 2.18705e-05f
Cred_3098 VDD.$702.Metal1 vin.$600.Metal2 0.00581479f
Cred_3099 VDD.$702.Metal1 vin.$602.Metal2 0.00269645f
Cred_3100 VDD.$702.Metal1 vin.$604.Metal2 0.000575922f
Cred_3101 VDD.$702.Metal1 vin.$605.Metal2 0.0224755f
Cred_3102 VDD.$702.Metal1 vin.$609.Metal2 0.00216232f
Cred_3103 VDD.$702.Metal1 vin.P32.GatPoly 0.0012978f
Cred_3104 VDD.$702.Metal1 vin.P33.GatPoly 0.168705f
Cred_3105 VDD.$702.Metal1 vin.P34.GatPoly 0.173068f
Cred_3106 VDD.$702.Metal1 vin.P35.GatPoly 0.0012978f
Cred_3107 VDD.$702.Metal1 vout.$1358.Metal3 0.235561f
Cred_3108 VDD.$702.Metal1 vout.$1424.Metal3 0.0752461f
Cred_3109 VDD.$702.Metal1 vout.P12.pSD 0.0932378f
Cred_3110 VDD.$702.Metal1 vout.P14.nSD 0.00118543f
Cred_3111 VDD.$702.Metal1 vout.P14.pSD 0.096918f
Cred_3112 VDD.$722.Metal1 vin.$139.GatPoly 3.26941e-10f
Cred_3113 VDD.$722.Metal1 vin.$391.Metal1 2.83633e-08f
Cred_3114 VDD.$722.Metal1 vin.$397.Metal1 2.75364e-08f
Cred_3115 VDD.$722.Metal1 vin.$605.Metal2 2.97432e-06f
Cred_3116 VDD.$722.Metal1 vin.$609.Metal2 2.97432e-06f
Cred_3117 VDD.$722.Metal1 vin.P33.GatPoly 0.000377447f
Cred_3118 VDD.$722.Metal1 vin.P34.GatPoly 0.0199847f
Cred_3119 VDD.$722.Metal1 vout.$1358.Metal3 0.000706154f
Cred_3120 VDD.$722.Metal1 vout.$1424.Metal3 0.000706154f
Cred_3121 VDD.$722.Metal1 vout.P14.nSD 1.11248e-05f
Cred_3122 VDD.$722.Metal1 vout.P14.pSD 0.000744669f
Cred_3123 VDD.$734.Metal1 vin.P34.GatPoly 0.0105611f
Cred_3124 VDD.$734.Metal1 vin.P35.GatPoly 0.00371716f
Cred_3125 VDD.$734.Metal1 vout.$1358.Metal3 0.00688437f
Cred_3126 VDD.$734.Metal1 vout.$1424.Metal3 0.00688437f
Cred_3127 VDD.$734.Metal1 vout.P14.nSD 0.000108457f
Cred_3128 VDD.$734.Metal1 vout.P14.pSD 0.0101163f
Cred_3129 VDD.$744.Metal1 vin.$409.Metal1 1.57611e-08f
Cred_3130 VDD.$744.Metal1 vin.$413.Metal1 6.66817e-08f
Cred_3131 VDD.$744.Metal1 vin.$616.Metal2 4.33186e-06f
Cred_3132 VDD.$744.Metal1 vin.$620.Metal2 4.33186e-06f
Cred_3133 VDD.$744.Metal1 vin.P35.GatPoly 0.0217261f
Cred_3134 VDD.$744.Metal1 vout.$1358.Metal3 0.00217138f
Cred_3135 VDD.$744.Metal1 vout.$1424.Metal3 0.00217138f
Cred_3136 VDD.$744.Metal1 vout.P14.nSD 3.42081e-05f
Cred_3137 VDD.$744.Metal1 vout.P14.pSD 0.00277722f
Cred_3138 VDD.$754.Metal1 vin.$145.GatPoly 0.00518074f
Cred_3139 VDD.$754.Metal1 vin.$153.GatPoly 0.0162307f
Cred_3140 VDD.$754.Metal1 vin.$157.GatPoly 0.0283599f
Cred_3141 VDD.$754.Metal1 vin.$409.Metal1 0.00274003f
Cred_3142 VDD.$754.Metal1 vin.$413.Metal1 0.00854531f
Cred_3143 VDD.$754.Metal1 vin.$419.Metal1 0.0186649f
Cred_3144 VDD.$754.Metal1 vin.$423.Metal1 0.00428125f
Cred_3145 VDD.$754.Metal1 vin.$619.Metal2 0.000325481f
Cred_3146 VDD.$754.Metal1 vin.$620.Metal2 0.00943879f
Cred_3147 VDD.$754.Metal1 vin.$622.Metal2 0.00225569f
Cred_3148 VDD.$754.Metal1 vin.$624.Metal2 0.000446843f
Cred_3149 VDD.$754.Metal1 vin.$625.Metal2 0.0156811f
Cred_3150 VDD.$754.Metal1 vin.P34.GatPoly 0.00105511f
Cred_3151 VDD.$754.Metal1 vin.P35.GatPoly 0.146578f
Cred_3152 VDD.$754.Metal1 vin.P36.GatPoly 0.139688f
Cred_3153 VDD.$754.Metal1 vin.P37.GatPoly 0.00105511f
Cred_3154 VDD.$754.Metal1 vout.$1358.Metal3 0.062121f
Cred_3155 VDD.$754.Metal1 vout.$1424.Metal3 0.190508f
Cred_3156 VDD.$754.Metal1 vout.P14.nSD 0.000978658f
Cred_3157 VDD.$754.Metal1 vout.P14.pSD 0.0811128f
Cred_3158 VDD.$754.Metal1 vout.P16.pSD 0.0736207f
Cred_3159 VDD.$807.Metal1 vin.$423.Metal1 4.19584e-08f
Cred_3160 VDD.$807.Metal1 vin.$427.Metal1 3.11999e-08f
Cred_3161 VDD.$807.Metal1 vin.$625.Metal2 3.85084e-06f
Cred_3162 VDD.$807.Metal1 vin.$629.Metal2 3.85084e-06f
Cred_3163 VDD.$807.Metal1 vin.P36.GatPoly 0.020045f
Cred_3164 VDD.$807.Metal1 vout.$1424.Metal3 0.00217447f
Cred_3165 VDD.$807.Metal1 vout.P16.pSD 0.00131568f
Cred_3166 VDD.$817.Metal1 vin.P36.GatPoly 0.00723714f
Cred_3167 VDD.$817.Metal1 vin.P37.GatPoly 0.00581998f
Cred_3168 VDD.$817.Metal1 vout.$1424.Metal3 0.0146597f
Cred_3169 VDD.$817.Metal1 vout.P16.pSD 0.00972672f
Cred_3170 VDD.$829.Metal1 vin.$173.GatPoly 1.17791e-10f
Cred_3171 VDD.$829.Metal1 vin.$441.Metal1 6.99734e-08f
Cred_3172 VDD.$829.Metal1 vin.$449.Metal1 9.87247e-09f
Cred_3173 VDD.$829.Metal1 vin.$636.Metal2 4.21248e-06f
Cred_3174 VDD.$829.Metal1 vin.$640.Metal2 4.21259e-06f
Cred_3175 VDD.$829.Metal1 vin.P37.GatPoly 0.0209566f
Cred_3176 VDD.$829.Metal1 vout.$1424.Metal3 0.00285555f
Cred_3177 VDD.$829.Metal1 vout.P16.pSD 0.00158507f
Cred_3178 VDD.$834.Metal1 vin.$167.GatPoly 0.0263992f
Cred_3179 VDD.$834.Metal1 vin.$173.GatPoly 0.00707618f
Cred_3180 VDD.$834.Metal1 vin.$179.GatPoly 0.0239169f
Cred_3181 VDD.$834.Metal1 vin.$441.Metal1 0.00289811f
Cred_3182 VDD.$834.Metal1 vin.$449.Metal1 0.0185691f
Cred_3183 VDD.$834.Metal1 vin.$453.Metal1 0.00782138f
Cred_3184 VDD.$834.Metal1 vin.$636.Metal2 7.10082e-06f
Cred_3185 VDD.$834.Metal1 vin.$639.Metal2 0.000420015f
Cred_3186 VDD.$834.Metal1 vin.$640.Metal2 0.0135852f
Cred_3187 VDD.$834.Metal1 vin.$642.Metal2 0.00240714f
Cred_3188 VDD.$834.Metal1 vin.$644.Metal2 0.000371729f
Cred_3189 VDD.$834.Metal1 vin.$645.Metal2 0.0112088f
Cred_3190 VDD.$834.Metal1 vin.P36.GatPoly 0.0010558f
Cred_3191 VDD.$834.Metal1 vin.P37.GatPoly 0.139781f
Cred_3192 VDD.$834.Metal1 vin.P38.GatPoly 0.144243f
Cred_3193 VDD.$834.Metal1 vin.P39.GatPoly 0.00114642f
Cred_3194 VDD.$834.Metal1 vout 0.12687f
Cred_3195 VDD.$834.Metal1 vout.$1424.Metal3 0.132265f
Cred_3196 VDD.$834.Metal1 vout.P16.pSD 0.0758295f
Cred_3197 VDD.$834.Metal1 vout.P18.pSD 0.0812228f
Cred_3198 VDD.$890.Metal1 vin.$453.Metal1 1.09198e-08f
Cred_3199 VDD.$890.Metal1 vin.$457.Metal1 7.15854e-08f
Cred_3200 VDD.$890.Metal1 vin.$645.Metal2 4.33174e-06f
Cred_3201 VDD.$890.Metal1 vin.$649.Metal2 4.33174e-06f
Cred_3202 VDD.$890.Metal1 vin.P38.GatPoly 0.0228314f
Cred_3203 VDD.$890.Metal1 vin.P39.GatPoly 0.000652347f
Cred_3204 VDD.$890.Metal1 vout 0.00756098f
Cred_3205 VDD.$890.Metal1 vout.P18.pSD 0.00522004f
Cred_3206 VDD.$907.Metal1 vin.$179.GatPoly 2.50925e-09f
Cred_3207 VDD.$907.Metal1 vin.$457.Metal1 1.32996e-07f
Cred_3208 VDD.$907.Metal1 vin.$649.Metal2 2.82566e-09f
Cred_3209 VDD.$907.Metal1 vin.$654.Metal2 8.17889e-06f
Cred_3210 VDD.$907.Metal1 vin.P38.GatPoly 0.0033751f
Cred_3211 VDD.$907.Metal1 vin.P39.GatPoly 0.0208601f
Cred_3212 VDD.$907.Metal1 vout 0.0117487f
Cred_3213 VDD.$907.Metal1 vout.P18.pSD 0.00785017f
Cred_3214 VDD.$917.Metal1 vin.P39.GatPoly 0.00972284f
Cred_3215 VDD.$940.Metal1 vin.$179.GatPoly 0.00292039f
Cred_3216 VDD.$940.Metal1 vin.$457.Metal1 0.0257282f
Cred_3217 VDD.$940.Metal1 vin.$649.Metal2 0.000544751f
Cred_3218 VDD.$940.Metal1 vin.$654.Metal2 0.00270274f
Cred_3219 VDD.$940.Metal1 vin.P39.GatPoly 0.0378428f
Cred_3220 VDD.$940.Metal1 vout 0.0287992f
Cred_3221 VDD.$940.Metal1 vout.P18.pSD 0.0271264f
Cred_3222 VDD.$940.Metal1 VSS.$1066.Metal2 0.000997626f
Cred_3223 VDD.$940.Metal1 VSS.$18.Metal1 1.31981e-06f
Cred_3224 VDD.$940.Metal1 VSS.$40.Metal1 5.11688e-07f
Cred_3225 VDD.$940.Metal1 VSS.$509.Metal1 5.85587e-05f
Cred_3226 VDD.$940.Metal1 VSS.$551.Metal1 0.00342898f
Cred_3227 VDD.$940.Metal1 VSS.P0.pSD 0.00788696f
Cred_3228 VDD.$940.Metal1 VSS.P21.nSD 2.47304e-07f
Cred_3229 VDD.$940.Metal1 VSS.P23.nSD 2.47304e-07f
Cred_3230 VDD.$941.Metal1 vin.P39.GatPoly 0.0123329f
Cred_3231 VDD.$941.Metal1 vout 0.00474615f
Cred_3232 VDD.$941.Metal1 vout.P18.pSD 0.00452001f
Cred_3233 VDD.$942.Metal1 vin.P39.GatPoly 0.0124067f
Cred_3234 VDD.$942.Metal1 vout 0.00496409f
Cred_3235 VDD.$942.Metal1 vout.P18.pSD 0.00474856f
Cred_3236 VDD.$943.Metal1 vin.P39.GatPoly 0.0124057f
Cred_3237 VDD.$943.Metal1 vout 0.00509891f
Cred_3238 VDD.$943.Metal1 vout.P18.pSD 0.00487536f
Cred_3239 VDD.$954.Metal1 vin.P34.GatPoly 0.00100885f
Cred_3240 VDD.$954.Metal1 vin.P35.GatPoly 0.00124635f
Cred_3241 VDD.$954.Metal1 vin.P36.GatPoly 0.00163009f
Cred_3242 VDD.$954.Metal1 vin.P37.GatPoly 0.00235528f
Cred_3243 VDD.$954.Metal1 vin.P38.GatPoly 0.00424279f
Cred_3244 VDD.$954.Metal1 vin.P39.GatPoly 0.0427304f
Cred_3245 VDD.P0.GatPoly vin.$15.GatPoly 0.00165679f
Cred_3246 VDD.P0.GatPoly vin.$17.GatPoly 0.00127999f
Cred_3247 VDD.P0.GatPoly vin.$199.Metal1 0.0300406f
Cred_3248 VDD.P0.GatPoly vin.$25.GatPoly 0.00112451f
Cred_3249 VDD.P0.GatPoly vin.$478.Metal2 0.00194628f
Cred_3250 VDD.P0.GatPoly vin.$7.GatPoly 0.0115219f
Cred_3251 VDD.P0.GatPoly vin.P20.GatPoly 0.139468f
Cred_3252 VDD.P0.GatPoly vin.P21.GatPoly 0.0117656f
Cred_3253 VDD.P0.GatPoly vin.P22.GatPoly 0.00645507f
Cred_3254 VDD.P0.GatPoly vin.P23.GatPoly 0.00446757f
Cred_3255 VDD.P0.GatPoly vin.P24.GatPoly 0.00341583f
Cred_3256 VDD.P0.GatPoly vin.P25.GatPoly 0.00276493f
Cred_3257 VDD.P0.GatPoly vout.$1226.Metal3 0.00087663f
Cred_3258 VDD.P0.GatPoly vout.P0.nSD 2.61033e-05f
Cred_3259 VDD.P0.GatPoly vout.P0.pSD 0.000243428f
Cred_3260 VDD.P0.GatPoly vout.P2.nSD 1.38105e-05f
Cred_3261 VDD.P0.GatPoly vout.P2.pSD 7.54775e-05f
Cred_3262 VDD.P0.GatPoly VSS.P0.GatPoly 0.00472147f
Cred_3263 VDD.P0.nSD vin 0.0219243f
Cred_3264 VDD.P0.nSD vin.$105.GatPoly 0.00423652f
Cred_3265 VDD.P0.nSD vin.$107.GatPoly 0.00339416f
Cred_3266 VDD.P0.nSD vin.$115.GatPoly 0.00495909f
Cred_3267 VDD.P0.nSD vin.$123.GatPoly 0.00505139f
Cred_3268 VDD.P0.nSD vin.$127.GatPoly 0.00324647f
Cred_3269 VDD.P0.nSD vin.$133.GatPoly 0.00371535f
Cred_3270 VDD.P0.nSD vin.$139.GatPoly 0.0045062f
Cred_3271 VDD.P0.nSD vin.$145.GatPoly 0.00509865f
Cred_3272 VDD.P0.nSD vin.$15.GatPoly 0.00352234f
Cred_3273 VDD.P0.nSD vin.$153.GatPoly 0.00500546f
Cred_3274 VDD.P0.nSD vin.$157.GatPoly 0.0033537f
Cred_3275 VDD.P0.nSD vin.$163.GatPoly 0.00398173f
Cred_3276 VDD.P0.nSD vin.$167.GatPoly 0.00352234f
Cred_3277 VDD.P0.nSD vin.$17.GatPoly 0.00380348f
Cred_3278 VDD.P0.nSD vin.$173.GatPoly 0.00380348f
Cred_3279 VDD.P0.nSD vin.$179.GatPoly 0.00721249f
Cred_3280 VDD.P0.nSD vin.$199.Metal1 0.128403f
Cred_3281 VDD.P0.nSD vin.$207.Metal1 0.0464092f
Cred_3282 VDD.P0.nSD vin.$211.Metal1 0.0447733f
Cred_3283 VDD.P0.nSD vin.$219.Metal1 0.0635895f
Cred_3284 VDD.P0.nSD vin.$227.Metal1 0.0607205f
Cred_3285 VDD.P0.nSD vin.$233.Metal1 0.0435884f
Cred_3286 VDD.P0.nSD vin.$237.Metal1 0.0315439f
Cred_3287 VDD.P0.nSD vin.$241.Metal1 0.0453756f
Cred_3288 VDD.P0.nSD vin.$247.Metal1 0.04668f
Cred_3289 VDD.P0.nSD vin.$25.GatPoly 0.0033537f
Cred_3290 VDD.P0.nSD vin.$251.Metal1 0.046468f
Cred_3291 VDD.P0.nSD vin.$259.Metal1 0.0468115f
Cred_3292 VDD.P0.nSD vin.$263.Metal1 0.0476448f
Cred_3293 VDD.P0.nSD vin.$269.Metal1 0.0620705f
Cred_3294 VDD.P0.nSD vin.$27.GatPoly 0.00398173f
Cred_3295 VDD.P0.nSD vin.$277.Metal1 0.0469489f
Cred_3296 VDD.P0.nSD vin.$281.Metal1 0.0328065f
Cred_3297 VDD.P0.nSD vin.$285.Metal1 0.0460734f
Cred_3298 VDD.P0.nSD vin.$291.Metal1 0.0489212f
Cred_3299 VDD.P0.nSD vin.$295.Metal1 0.0471534f
Cred_3300 VDD.P0.nSD vin.$303.Metal1 0.0466578f
Cred_3301 VDD.P0.nSD vin.$307.Metal1 0.0489026f
Cred_3302 VDD.P0.nSD vin.$313.Metal1 0.047232f
Cred_3303 VDD.P0.nSD vin.$317.Metal1 0.0313881f
Cred_3304 VDD.P0.nSD vin.$321.Metal1 0.032263f
Cred_3305 VDD.P0.nSD vin.$325.Metal1 0.032386f
Cred_3306 VDD.P0.nSD vin.$329.Metal1 0.0465203f
Cred_3307 VDD.P0.nSD vin.$335.Metal1 0.0472549f
Cred_3308 VDD.P0.nSD vin.$339.Metal1 0.032263f
Cred_3309 VDD.P0.nSD vin.$343.Metal1 0.0313881f
Cred_3310 VDD.P0.nSD vin.$347.Metal1 0.047232f
Cred_3311 VDD.P0.nSD vin.$353.Metal1 0.0489026f
Cred_3312 VDD.P0.nSD vin.$357.Metal1 0.0466578f
Cred_3313 VDD.P0.nSD vin.$365.Metal1 0.0471534f
Cred_3314 VDD.P0.nSD vin.$369.Metal1 0.0489212f
Cred_3315 VDD.P0.nSD vin.$37.GatPoly 0.00500546f
Cred_3316 VDD.P0.nSD vin.$375.Metal1 0.0460734f
Cred_3317 VDD.P0.nSD vin.$379.Metal1 0.0328065f
Cred_3318 VDD.P0.nSD vin.$383.Metal1 0.0469489f
Cred_3319 VDD.P0.nSD vin.$391.Metal1 0.0620705f
Cred_3320 VDD.P0.nSD vin.$397.Metal1 0.0476448f
Cred_3321 VDD.P0.nSD vin.$401.Metal1 0.0468115f
Cred_3322 VDD.P0.nSD vin.$409.Metal1 0.046468f
Cred_3323 VDD.P0.nSD vin.$413.Metal1 0.04668f
Cred_3324 VDD.P0.nSD vin.$419.Metal1 0.0453756f
Cred_3325 VDD.P0.nSD vin.$423.Metal1 0.0315439f
Cred_3326 VDD.P0.nSD vin.$427.Metal1 0.0435884f
Cred_3327 VDD.P0.nSD vin.$43.GatPoly 0.00509865f
Cred_3328 VDD.P0.nSD vin.$433.Metal1 0.0607205f
Cred_3329 VDD.P0.nSD vin.$441.Metal1 0.0635895f
Cred_3330 VDD.P0.nSD vin.$449.Metal1 0.0447409f
Cred_3331 VDD.P0.nSD vin.$453.Metal1 0.0303288f
Cred_3332 VDD.P0.nSD vin.$457.Metal1 0.139116f
Cred_3333 VDD.P0.nSD vin.$476.Metal2 0.000116168f
Cred_3334 VDD.P0.nSD vin.$478.Metal2 0.0363624f
Cred_3335 VDD.P0.nSD vin.$482.Metal2 0.0133965f
Cred_3336 VDD.P0.nSD vin.$486.Metal2 0.0387038f
Cred_3337 VDD.P0.nSD vin.$489.Metal2 0.0218537f
Cred_3338 VDD.P0.nSD vin.$493.Metal2 0.0177248f
Cred_3339 VDD.P0.nSD vin.$495.Metal2 0.0419629f
Cred_3340 VDD.P0.nSD vin.$500.Metal2 0.0182825f
Cred_3341 VDD.P0.nSD vin.$504.Metal2 0.0197798f
Cred_3342 VDD.P0.nSD vin.$506.Metal2 0.0390806f
Cred_3343 VDD.P0.nSD vin.$509.Metal2 0.0132822f
Cred_3344 VDD.P0.nSD vin.$51.GatPoly 0.0045062f
Cred_3345 VDD.P0.nSD vin.$513.Metal2 0.0143537f
Cred_3346 VDD.P0.nSD vin.$515.Metal2 0.0394935f
Cred_3347 VDD.P0.nSD vin.$518.Metal2 0.0168084f
Cred_3348 VDD.P0.nSD vin.$520.Metal2 0.00888233f
Cred_3349 VDD.P0.nSD vin.$524.Metal2 0.0272076f
Cred_3350 VDD.P0.nSD vin.$526.Metal2 0.0371169f
Cred_3351 VDD.P0.nSD vin.$529.Metal2 0.00985009f
Cred_3352 VDD.P0.nSD vin.$533.Metal2 0.0187316f
Cred_3353 VDD.P0.nSD vin.$535.Metal2 0.0400649f
Cred_3354 VDD.P0.nSD vin.$538.Metal2 0.0149895f
Cred_3355 VDD.P0.nSD vin.$542.Metal2 0.0128665f
Cred_3356 VDD.P0.nSD vin.$544.Metal2 0.0376816f
Cred_3357 VDD.P0.nSD vin.$547.Metal2 0.0220318f
Cred_3358 VDD.P0.nSD vin.$55.GatPoly 0.00371535f
Cred_3359 VDD.P0.nSD vin.$551.Metal2 0.0181631f
Cred_3360 VDD.P0.nSD vin.$555.Metal2 0.0434691f
Cred_3361 VDD.P0.nSD vin.$558.Metal2 0.0192493f
Cred_3362 VDD.P0.nSD vin.$562.Metal2 0.0170411f
Cred_3363 VDD.P0.nSD vin.$564.Metal2 0.0403256f
Cred_3364 VDD.P0.nSD vin.$567.Metal2 0.0173089f
Cred_3365 VDD.P0.nSD vin.$57.GatPoly 0.00324647f
Cred_3366 VDD.P0.nSD vin.$571.Metal2 0.0192493f
Cred_3367 VDD.P0.nSD vin.$573.Metal2 0.0434691f
Cred_3368 VDD.P0.nSD vin.$578.Metal2 0.0181631f
Cred_3369 VDD.P0.nSD vin.$582.Metal2 0.0220318f
Cred_3370 VDD.P0.nSD vin.$584.Metal2 0.0376816f
Cred_3371 VDD.P0.nSD vin.$587.Metal2 0.0128665f
Cred_3372 VDD.P0.nSD vin.$591.Metal2 0.0149895f
Cred_3373 VDD.P0.nSD vin.$593.Metal2 0.0400649f
Cred_3374 VDD.P0.nSD vin.$596.Metal2 0.0187316f
Cred_3375 VDD.P0.nSD vin.$600.Metal2 0.00985009f
Cred_3376 VDD.P0.nSD vin.$602.Metal2 0.0371169f
Cred_3377 VDD.P0.nSD vin.$605.Metal2 0.0272076f
Cred_3378 VDD.P0.nSD vin.$609.Metal2 0.00888233f
Cred_3379 VDD.P0.nSD vin.$611.Metal2 0.0168084f
Cred_3380 VDD.P0.nSD vin.$613.Metal2 0.0394935f
Cred_3381 VDD.P0.nSD vin.$616.Metal2 0.0143537f
Cred_3382 VDD.P0.nSD vin.$620.Metal2 0.0132822f
Cred_3383 VDD.P0.nSD vin.$622.Metal2 0.0390806f
Cred_3384 VDD.P0.nSD vin.$625.Metal2 0.0197798f
Cred_3385 VDD.P0.nSD vin.$629.Metal2 0.0182825f
Cred_3386 VDD.P0.nSD vin.$633.Metal2 0.0419629f
Cred_3387 VDD.P0.nSD vin.$636.Metal2 0.0177248f
Cred_3388 VDD.P0.nSD vin.$640.Metal2 0.0175386f
Cred_3389 VDD.P0.nSD vin.$642.Metal2 0.0519956f
Cred_3390 VDD.P0.nSD vin.$645.Metal2 0.0145079f
Cred_3391 VDD.P0.nSD vin.$648.Metal2 0.000914071f
Cred_3392 VDD.P0.nSD vin.$649.Metal2 0.0146392f
Cred_3393 VDD.P0.nSD vin.$65.GatPoly 0.00505139f
Cred_3394 VDD.P0.nSD vin.$653.Metal2 0.00349498f
Cred_3395 VDD.P0.nSD vin.$654.Metal2 0.0356656f
Cred_3396 VDD.P0.nSD vin.$7.GatPoly 0.00518285f
Cred_3397 VDD.P0.nSD vin.$73.GatPoly 0.00495909f
Cred_3398 VDD.P0.nSD vin.$77.GatPoly 0.00339416f
Cred_3399 VDD.P0.nSD vin.$83.GatPoly 0.00423652f
Cred_3400 VDD.P0.nSD vin.$87.GatPoly 0.00404448f
Cred_3401 VDD.P0.nSD vin.$9.GatPoly 0.00366083f
Cred_3402 VDD.P0.nSD vin.$95.GatPoly 0.00477809f
Cred_3403 VDD.P0.nSD vin.$97.GatPoly 0.00325917f
Cred_3404 VDD.P0.nSD vin.P20.GatPoly 0.0152619f
Cred_3405 VDD.P0.nSD vin.P21.GatPoly 2.9652e-05f
Cred_3406 VDD.P0.nSD vin.P22.GatPoly 1.60723e-05f
Cred_3407 VDD.P0.nSD vin.P23.GatPoly 1.79782e-05f
Cred_3408 VDD.P0.nSD vin.P24.GatPoly 0.000447683f
Cred_3409 VDD.P0.nSD vin.P25.GatPoly 0.000353936f
Cred_3410 VDD.P0.nSD vin.P26.GatPoly 1.87577e-05f
Cred_3411 VDD.P0.nSD vin.P27.GatPoly 0.000449821f
Cred_3412 VDD.P0.nSD vin.P28.GatPoly 1.35425e-05f
Cred_3413 VDD.P0.nSD vin.P29.GatPoly 1.27979e-05f
Cred_3414 VDD.P0.nSD vin.P30.GatPoly 1.27979e-05f
Cred_3415 VDD.P0.nSD vin.P31.GatPoly 1.35425e-05f
Cred_3416 VDD.P0.nSD vin.P32.GatPoly 0.000449821f
Cred_3417 VDD.P0.nSD vin.P33.GatPoly 1.87577e-05f
Cred_3418 VDD.P0.nSD vin.P34.GatPoly 0.000353936f
Cred_3419 VDD.P0.nSD vin.P35.GatPoly 0.000447683f
Cred_3420 VDD.P0.nSD vin.P36.GatPoly 1.79782e-05f
Cred_3421 VDD.P0.nSD vin.P37.GatPoly 1.60723e-05f
Cred_3422 VDD.P0.nSD vin.P38.GatPoly 2.68472e-05f
Cred_3423 VDD.P0.nSD vin.P39.GatPoly 0.0158959f
Cred_3424 VDD.P0.nSD vout 0.0218071f
Cred_3425 VDD.P0.nSD vout.$1226.Metal3 0.0495263f
Cred_3426 VDD.P0.nSD vout.$1292.Metal3 0.032346f
Cred_3427 VDD.P0.nSD vout.$1358.Metal3 0.0341739f
Cred_3428 VDD.P0.nSD vout.$1424.Metal3 0.0243709f
Cred_3429 VDD.P0.nSD vout.P0.nSD 0.000597954f
Cred_3430 VDD.P0.nSD vout.P0.pSD 0.00355358f
Cred_3431 VDD.P0.nSD vout.P10.nSD 0.000131977f
Cred_3432 VDD.P0.nSD vout.P10.pSD 0.000724213f
Cred_3433 VDD.P0.nSD vout.P12.pSD 6.72852e-06f
Cred_3434 VDD.P0.nSD vout.P14.nSD 0.000130219f
Cred_3435 VDD.P0.nSD vout.P14.pSD 0.000714416f
Cred_3436 VDD.P0.nSD vout.P16.pSD 8.54713e-06f
Cred_3437 VDD.P0.nSD vout.P18.pSD 2.34742e-05f
Cred_3438 VDD.P0.nSD vout.P2.nSD 0.000406054f
Cred_3439 VDD.P0.nSD vout.P2.pSD 0.00222791f
Cred_3440 VDD.P0.nSD vout.P4.pSD 9.47932e-06f
Cred_3441 VDD.P0.nSD vout.P6.nSD 0.0001214f
Cred_3442 VDD.P0.nSD vout.P6.pSD 0.000670227f
Cred_3443 VDD.P0.nSD vout.P8.pSD 9.72328e-06f
Cred_3444 VDD.P0.nSD VSS.$1040.Metal2 2.78478e-06f
Cred_3445 VDD.P0.nSD VSS.$1066.Metal2 0.00100696f
Cred_3446 VDD.P0.nSD VSS.$18.Metal1 0.0348395f
Cred_3447 VDD.P0.nSD VSS.$40.Metal1 0.0227061f
Cred_3448 VDD.P0.nSD VSS.$488.Metal1 0.000333311f
Cred_3449 VDD.P0.nSD VSS.$498.Metal1 0.000699114f
Cred_3450 VDD.P0.nSD VSS.$509.Metal1 0.00919892f
Cred_3451 VDD.P0.nSD VSS.$551.Metal1 0.0517218f
Cred_3452 VDD.P0.nSD VSS.$564.Metal2 0.00100696f
Cred_3453 VDD.P0.nSD VSS.$605.Metal2 2.78478e-06f
Cred_3454 VDD.P0.nSD VSS.$65.Metal1 0.000699114f
Cred_3455 VDD.P0.nSD VSS.$75.Metal1 0.000333311f
Cred_3456 VDD.P0.nSD VSS.P0.nSD 5.99415e-05f
Cred_3457 VDD.P0.nSD VSS.P0.pSD 0.844343f
Cred_3458 VDD.P0.nSD VSS.P1.nSD 5.99415e-05f
Cred_3459 VDD.P0.nSD VSS.P21.nSD 5.99415e-05f
Cred_3460 VDD.P0.nSD VSS.P23.nSD 5.99415e-05f
Cred_3461 VDD.P0.pSD vin.$199.Metal1 0.000306819f
Cred_3462 VDD.P0.pSD vin.$478.Metal2 1.98783e-05f
Cred_3463 VDD.P0.pSD vin.$7.GatPoly 6.505e-05f
Cred_3464 VDD.P0.pSD vin.P20.GatPoly 0.000209561f
Cred_3465 VDD.P0.pSD vout.$1226.Metal3 0.00019718f
Cred_3466 VDD.P0.pSD vout.P0.nSD 5.8714e-06f
Cred_3467 VDD.P0.pSD vout.P0.pSD 0.000260269f
Cred_3468 VDD.P0.pSD vout.P2.nSD 3.10639e-06f
Cred_3469 VDD.P0.pSD vout.P2.pSD 1.69771e-05f
Cred_3470 VDD.P0.pSD VSS.$18.Metal1 3.34738e-05f
Cred_3471 VDD.P0.pSD VSS.$40.Metal1 1.36931e-05f
Cred_3472 VDD.P0.pSD VSS.$551.Metal1 2.88375e-08f
Cred_3473 VDD.P0.pSD VSS.$564.Metal2 1.21887e-05f
Cred_3474 VDD.P0.pSD VSS.P0.nSD 3.02149e-09f
Cred_3475 VDD.P0.pSD VSS.P0.pSD 0.000117688f
Cred_3476 VDD.P0.pSD VSS.P1.nSD 3.02149e-09f
Cred_3477 VDD.P1.GatPoly vin.$157.GatPoly 0.00112451f
Cred_3478 VDD.P1.GatPoly vin.$167.GatPoly 0.00165679f
Cred_3479 VDD.P1.GatPoly vin.$173.GatPoly 0.00127999f
Cred_3480 VDD.P1.GatPoly vin.$179.GatPoly 0.00605832f
Cred_3481 VDD.P1.GatPoly vin.$457.Metal1 0.0330005f
Cred_3482 VDD.P1.GatPoly vin.$649.Metal2 0.000696951f
Cred_3483 VDD.P1.GatPoly vin.$654.Metal2 0.00336524f
Cred_3484 VDD.P1.GatPoly vin.P34.GatPoly 0.00276493f
Cred_3485 VDD.P1.GatPoly vin.P35.GatPoly 0.00341583f
Cred_3486 VDD.P1.GatPoly vin.P36.GatPoly 0.00446757f
Cred_3487 VDD.P1.GatPoly vin.P37.GatPoly 0.00645507f
Cred_3488 VDD.P1.GatPoly vin.P38.GatPoly 0.0117656f
Cred_3489 VDD.P1.GatPoly vin.P39.GatPoly 0.139856f
Cred_3490 VDD.P1.GatPoly vout 0.00112112f
Cred_3491 VDD.P1.GatPoly vout.P18.pSD 0.000114329f
Cred_3492 VDD.P1.GatPoly VSS.P1.GatPoly 0.00472147f
Cred_3493 VDD.P1.pSD vin.$199.Metal1 0.000306819f
Cred_3494 VDD.P1.pSD vin.$478.Metal2 1.98783e-05f
Cred_3495 VDD.P1.pSD vin.$7.GatPoly 6.505e-05f
Cred_3496 VDD.P1.pSD vin.P20.GatPoly 0.000209561f
Cred_3497 VDD.P1.pSD vout.$1226.Metal3 0.00019718f
Cred_3498 VDD.P1.pSD vout.P0.nSD 5.8714e-06f
Cred_3499 VDD.P1.pSD vout.P0.pSD 0.000260269f
Cred_3500 VDD.P1.pSD vout.P2.nSD 3.10639e-06f
Cred_3501 VDD.P1.pSD vout.P2.pSD 1.69771e-05f
Cred_3502 VDD.P1.pSD VSS.$18.Metal1 3.34738e-05f
Cred_3503 VDD.P1.pSD VSS.$40.Metal1 1.36931e-05f
Cred_3504 VDD.P1.pSD VSS.$551.Metal1 2.88375e-08f
Cred_3505 VDD.P1.pSD VSS.$564.Metal2 1.21887e-05f
Cred_3506 VDD.P1.pSD VSS.P0.nSD 3.02149e-09f
Cred_3507 VDD.P1.pSD VSS.P0.pSD 0.000117688f
Cred_3508 VDD.P1.pSD VSS.P1.nSD 3.02149e-09f
Cred_3509 VDD.P10.pSD vin.$291.Metal1 0.00311169f
Cred_3510 VDD.P10.pSD vin.$295.Metal1 0.00859506f
Cred_3511 VDD.P10.pSD vin.$298.Metal1 6.65046e-07f
Cred_3512 VDD.P10.pSD vin.$302.Metal1 1.30118e-06f
Cred_3513 VDD.P10.pSD vin.$303.Metal1 0.0139387f
Cred_3514 VDD.P10.pSD vin.$307.Metal1 0.000212075f
Cred_3515 VDD.P10.pSD vin.$541.Metal2 9.23168e-05f
Cred_3516 VDD.P10.pSD vin.$542.Metal2 0.00469347f
Cred_3517 VDD.P10.pSD vin.$544.Metal2 0.00130495f
Cred_3518 VDD.P10.pSD vin.$547.Metal2 0.00970034f
Cred_3519 VDD.P10.pSD vin.$548.Metal2 0.000103454f
Cred_3520 VDD.P10.pSD vin.$551.Metal2 0.000109944f
Cred_3521 VDD.P10.pSD vin.$65.GatPoly 0.00588345f
Cred_3522 VDD.P10.pSD vin.$73.GatPoly 0.00983818f
Cred_3523 VDD.P10.pSD vin.$77.GatPoly 0.0199763f
Cred_3524 VDD.P10.pSD vin.P26.GatPoly 0.000153818f
Cred_3525 VDD.P10.pSD vin.P27.GatPoly 0.0525264f
Cred_3526 VDD.P10.pSD vin.P28.GatPoly 0.0492772f
Cred_3527 VDD.P10.pSD vin.P29.GatPoly 0.000153818f
Cred_3528 VDD.P10.pSD vout.$1226.Metal3 0.0298291f
Cred_3529 VDD.P10.pSD vout.$1292.Metal3 0.091429f
Cred_3530 VDD.P10.pSD vout.P6.nSD 0.00046993f
Cred_3531 VDD.P10.pSD vout.P6.pSD 0.0370113f
Cred_3532 VDD.P10.pSD vout.P8.pSD 0.0331292f
Cred_3533 VDD.P11.pSD vin.$325.Metal1 0.000644171f
Cred_3534 VDD.P11.pSD vin.$329.Metal1 0.0148527f
Cred_3535 VDD.P11.pSD vin.$335.Metal1 0.0049314f
Cred_3536 VDD.P11.pSD vin.$561.Metal2 0.000229846f
Cred_3537 VDD.P11.pSD vin.$562.Metal2 0.0072391f
Cred_3538 VDD.P11.pSD vin.$564.Metal2 0.00140687f
Cred_3539 VDD.P11.pSD vin.$566.Metal2 0.000229846f
Cred_3540 VDD.P11.pSD vin.$567.Metal2 0.00709456f
Cred_3541 VDD.P11.pSD vin.$87.GatPoly 0.0200547f
Cred_3542 VDD.P11.pSD vin.$95.GatPoly 0.00535517f
Cred_3543 VDD.P11.pSD vin.$97.GatPoly 0.0191556f
Cred_3544 VDD.P11.pSD vin.P28.GatPoly 0.000157689f
Cred_3545 VDD.P11.pSD vin.P29.GatPoly 0.0497312f
Cred_3546 VDD.P11.pSD vin.P30.GatPoly 0.0497312f
Cred_3547 VDD.P11.pSD vin.P31.GatPoly 0.000157689f
Cred_3548 VDD.P11.pSD vout.$1292.Metal3 0.092509f
Cred_3549 VDD.P11.pSD vout.$1358.Metal3 0.0293005f
Cred_3550 VDD.P11.pSD vout.P10.nSD 0.000461602f
Cred_3551 VDD.P11.pSD vout.P10.pSD 0.0365669f
Cred_3552 VDD.P11.pSD vout.P8.pSD 0.0347202f
Cred_3553 VDD.P13.pSD vin.$107.GatPoly 0.0199763f
Cred_3554 VDD.P13.pSD vin.$115.GatPoly 0.00983818f
Cred_3555 VDD.P13.pSD vin.$123.GatPoly 0.00588345f
Cred_3556 VDD.P13.pSD vin.$353.Metal1 0.000212075f
Cred_3557 VDD.P13.pSD vin.$356.Metal1 1.30118e-06f
Cred_3558 VDD.P13.pSD vin.$357.Metal1 0.0139387f
Cred_3559 VDD.P13.pSD vin.$360.Metal1 6.65046e-07f
Cred_3560 VDD.P13.pSD vin.$365.Metal1 0.00859506f
Cred_3561 VDD.P13.pSD vin.$369.Metal1 0.00311169f
Cred_3562 VDD.P13.pSD vin.$578.Metal2 0.000109944f
Cred_3563 VDD.P13.pSD vin.$579.Metal2 0.000103454f
Cred_3564 VDD.P13.pSD vin.$582.Metal2 0.00970034f
Cred_3565 VDD.P13.pSD vin.$584.Metal2 0.00130495f
Cred_3566 VDD.P13.pSD vin.$586.Metal2 9.23168e-05f
Cred_3567 VDD.P13.pSD vin.$587.Metal2 0.00469347f
Cred_3568 VDD.P13.pSD vin.P30.GatPoly 0.000153818f
Cred_3569 VDD.P13.pSD vin.P31.GatPoly 0.0492772f
Cred_3570 VDD.P13.pSD vin.P32.GatPoly 0.0525264f
Cred_3571 VDD.P13.pSD vin.P33.GatPoly 0.000153818f
Cred_3572 VDD.P13.pSD vout.$1292.Metal3 0.0295394f
Cred_3573 VDD.P13.pSD vout.$1358.Metal3 0.0908012f
Cred_3574 VDD.P13.pSD vout.P10.nSD 0.000465366f
Cred_3575 VDD.P13.pSD vout.P10.pSD 0.0374102f
Cred_3576 VDD.P13.pSD vout.P12.pSD 0.0338109f
Cred_3577 VDD.P15.pSD vin.$127.GatPoly 0.0165372f
Cred_3578 VDD.P15.pSD vin.$133.GatPoly 0.00402803f
Cred_3579 VDD.P15.pSD vin.$139.GatPoly 0.00977271f
Cred_3580 VDD.P15.pSD vin.$145.GatPoly 0.00206339f
Cred_3581 VDD.P15.pSD vin.$383.Metal1 0.00308355f
Cred_3582 VDD.P15.pSD vin.$391.Metal1 0.0139283f
Cred_3583 VDD.P15.pSD vin.$397.Metal1 0.00345926f
Cred_3584 VDD.P15.pSD vin.$401.Metal1 0.00109131f
Cred_3585 VDD.P15.pSD vin.$599.Metal2 8.54457e-06f
Cred_3586 VDD.P15.pSD vin.$600.Metal2 0.00228246f
Cred_3587 VDD.P15.pSD vin.$602.Metal2 0.00105347f
Cred_3588 VDD.P15.pSD vin.$604.Metal2 0.000225007f
Cred_3589 VDD.P15.pSD vin.$605.Metal2 0.00879194f
Cred_3590 VDD.P15.pSD vin.$609.Metal2 0.000846898f
Cred_3591 VDD.P15.pSD vin.P32.GatPoly 5.32858e-05f
Cred_3592 VDD.P15.pSD vin.P33.GatPoly 0.0362972f
Cred_3593 VDD.P15.pSD vin.P34.GatPoly 0.0386502f
Cred_3594 VDD.P15.pSD vin.P35.GatPoly 5.32858e-05f
Cred_3595 VDD.P15.pSD vout.$1358.Metal3 0.0728588f
Cred_3596 VDD.P15.pSD vout.$1424.Metal3 0.023269f
Cred_3597 VDD.P15.pSD vout.P12.pSD 0.0276641f
Cred_3598 VDD.P15.pSD vout.P14.nSD 0.000366582f
Cred_3599 VDD.P15.pSD vout.P14.pSD 0.0287765f
Cred_3600 VDD.P17.pSD vin.$145.GatPoly 0.00377812f
Cred_3601 VDD.P17.pSD vin.$153.GatPoly 0.0113029f
Cred_3602 VDD.P17.pSD vin.$157.GatPoly 0.0205361f
Cred_3603 VDD.P17.pSD vin.$409.Metal1 0.0019982f
Cred_3604 VDD.P17.pSD vin.$413.Metal1 0.00644544f
Cred_3605 VDD.P17.pSD vin.$419.Metal1 0.0143654f
Cred_3606 VDD.P17.pSD vin.$423.Metal1 0.00324576f
Cred_3607 VDD.P17.pSD vin.$619.Metal2 0.000187388f
Cred_3608 VDD.P17.pSD vin.$620.Metal2 0.0054497f
Cred_3609 VDD.P17.pSD vin.$622.Metal2 0.00129866f
Cred_3610 VDD.P17.pSD vin.$624.Metal2 0.000257258f
Cred_3611 VDD.P17.pSD vin.$625.Metal2 0.00903277f
Cred_3612 VDD.P17.pSD vin.P34.GatPoly 0.000154087f
Cred_3613 VDD.P17.pSD vin.P35.GatPoly 0.052343f
Cred_3614 VDD.P17.pSD vin.P36.GatPoly 0.0492372f
Cred_3615 VDD.P17.pSD vin.P37.GatPoly 0.000154087f
Cred_3616 VDD.P17.pSD vout.$1358.Metal3 0.0295616f
Cred_3617 VDD.P17.pSD vout.$1424.Metal3 0.090649f
Cred_3618 VDD.P17.pSD vout.P14.nSD 0.000465715f
Cred_3619 VDD.P17.pSD vout.P14.pSD 0.0374321f
Cred_3620 VDD.P17.pSD vout.P16.pSD 0.0338406f
Cred_3621 VDD.P19.pSD vin.$167.GatPoly 0.0192566f
Cred_3622 VDD.P19.pSD vin.$173.GatPoly 0.00483152f
Cred_3623 VDD.P19.pSD vin.$179.GatPoly 0.0172188f
Cred_3624 VDD.P19.pSD vin.$441.Metal1 0.00228155f
Cred_3625 VDD.P19.pSD vin.$449.Metal1 0.0142331f
Cred_3626 VDD.P19.pSD vin.$453.Metal1 0.00596378f
Cred_3627 VDD.P19.pSD vin.$636.Metal2 5.59016e-06f
Cred_3628 VDD.P19.pSD vin.$639.Metal2 0.00024173f
Cred_3629 VDD.P19.pSD vin.$640.Metal2 0.00783368f
Cred_3630 VDD.P19.pSD vin.$642.Metal2 0.00138538f
Cred_3631 VDD.P19.pSD vin.$644.Metal2 0.000213941f
Cred_3632 VDD.P19.pSD vin.$645.Metal2 0.00645724f
Cred_3633 VDD.P19.pSD vin.P36.GatPoly 0.000154346f
Cred_3634 VDD.P19.pSD vin.P37.GatPoly 0.0491859f
Cred_3635 VDD.P19.pSD vin.P38.GatPoly 0.0502657f
Cred_3636 VDD.P19.pSD vin.P39.GatPoly 0.000168637f
Cred_3637 VDD.P19.pSD vout 0.0603865f
Cred_3638 VDD.P19.pSD vout.$1424.Metal3 0.0628919f
Cred_3639 VDD.P19.pSD vout.P16.pSD 0.0348817f
Cred_3640 VDD.P19.pSD vout.P18.pSD 0.037496f
Cred_3641 VDD.P21.pSD vin.$179.GatPoly 3.56101e-05f
Cred_3642 VDD.P21.pSD vin.$457.Metal1 0.00031372f
Cred_3643 VDD.P21.pSD vin.$649.Metal2 6.6425e-06f
Cred_3644 VDD.P21.pSD vin.$654.Metal2 3.29563e-05f
Cred_3645 VDD.P21.pSD vin.P39.GatPoly 0.000212379f
Cred_3646 VDD.P21.pSD vout 0.000251108f
Cred_3647 VDD.P21.pSD vout.P18.pSD 0.000234751f
Cred_3648 VDD.P21.pSD VSS.$1066.Metal2 1.26192e-05f
Cred_3649 VDD.P21.pSD VSS.$18.Metal1 1.91653e-08f
Cred_3650 VDD.P21.pSD VSS.$40.Metal1 7.43032e-09f
Cred_3651 VDD.P21.pSD VSS.$509.Metal1 7.40722e-07f
Cred_3652 VDD.P21.pSD VSS.$551.Metal1 4.96939e-05f
Cred_3653 VDD.P21.pSD VSS.P0.pSD 0.000114447f
Cred_3654 VDD.P21.pSD VSS.P21.nSD 3.12821e-09f
Cred_3655 VDD.P21.pSD VSS.P23.nSD 3.12821e-09f
Cred_3656 VDD.P23.pSD vin.$179.GatPoly 3.56101e-05f
Cred_3657 VDD.P23.pSD vin.$457.Metal1 0.00031372f
Cred_3658 VDD.P23.pSD vin.$649.Metal2 6.6425e-06f
Cred_3659 VDD.P23.pSD vin.$654.Metal2 3.29563e-05f
Cred_3660 VDD.P23.pSD vin.P39.GatPoly 0.000212379f
Cred_3661 VDD.P23.pSD vout 0.000251108f
Cred_3662 VDD.P23.pSD vout.P18.pSD 0.000234751f
Cred_3663 VDD.P23.pSD VSS.$1066.Metal2 1.26192e-05f
Cred_3664 VDD.P23.pSD VSS.$18.Metal1 1.91653e-08f
Cred_3665 VDD.P23.pSD VSS.$40.Metal1 7.43032e-09f
Cred_3666 VDD.P23.pSD VSS.$509.Metal1 7.40722e-07f
Cred_3667 VDD.P23.pSD VSS.$551.Metal1 4.96939e-05f
Cred_3668 VDD.P23.pSD VSS.P0.pSD 0.000114447f
Cred_3669 VDD.P23.pSD VSS.P21.nSD 3.12821e-09f
Cred_3670 VDD.P23.pSD VSS.P23.nSD 3.12821e-09f
Cred_3671 VDD.P3.pSD vin.$15.GatPoly 0.0192566f
Cred_3672 VDD.P3.pSD vin.$17.GatPoly 0.00483152f
Cred_3673 VDD.P3.pSD vin.$207.Metal1 0.006002f
Cred_3674 VDD.P3.pSD vin.$211.Metal1 0.0142527f
Cred_3675 VDD.P3.pSD vin.$219.Metal1 0.00228155f
Cred_3676 VDD.P3.pSD vin.$482.Metal2 0.00303883f
Cred_3677 VDD.P3.pSD vin.$483.Metal2 0.000213941f
Cred_3678 VDD.P3.pSD vin.$486.Metal2 0.00213937f
Cred_3679 VDD.P3.pSD vin.$488.Metal2 0.00024173f
Cred_3680 VDD.P3.pSD vin.$489.Metal2 0.0104403f
Cred_3681 VDD.P3.pSD vin.$493.Metal2 5.59016e-06f
Cred_3682 VDD.P3.pSD vin.$9.GatPoly 0.0172188f
Cred_3683 VDD.P3.pSD vin.P20.GatPoly 0.000168637f
Cred_3684 VDD.P3.pSD vin.P21.GatPoly 0.0501162f
Cred_3685 VDD.P3.pSD vin.P22.GatPoly 0.0493355f
Cred_3686 VDD.P3.pSD vin.P23.GatPoly 0.000154346f
Cred_3687 VDD.P3.pSD vout.$1226.Metal3 0.100699f
Cred_3688 VDD.P3.pSD vout.P0.nSD 0.00221391f
Cred_3689 VDD.P3.pSD vout.P0.pSD 0.0497821f
Cred_3690 VDD.P3.pSD vout.P2.nSD 0.00158643f
Cred_3691 VDD.P3.pSD vout.P2.pSD 0.0420959f
Cred_3692 VDD.P5.pSD vin.$237.Metal1 0.00324576f
Cred_3693 VDD.P5.pSD vin.$241.Metal1 0.0143654f
Cred_3694 VDD.P5.pSD vin.$247.Metal1 0.00644544f
Cred_3695 VDD.P5.pSD vin.$25.GatPoly 0.0205361f
Cred_3696 VDD.P5.pSD vin.$251.Metal1 0.0019982f
Cred_3697 VDD.P5.pSD vin.$37.GatPoly 0.0113029f
Cred_3698 VDD.P5.pSD vin.$43.GatPoly 0.00377812f
Cred_3699 VDD.P5.pSD vin.$503.Metal2 0.000257258f
Cred_3700 VDD.P5.pSD vin.$504.Metal2 0.00903277f
Cred_3701 VDD.P5.pSD vin.$506.Metal2 0.00129866f
Cred_3702 VDD.P5.pSD vin.$508.Metal2 0.000187388f
Cred_3703 VDD.P5.pSD vin.$509.Metal2 0.0054497f
Cred_3704 VDD.P5.pSD vin.P22.GatPoly 0.000154087f
Cred_3705 VDD.P5.pSD vin.P23.GatPoly 0.0492372f
Cred_3706 VDD.P5.pSD vin.P24.GatPoly 0.052343f
Cred_3707 VDD.P5.pSD vin.P25.GatPoly 0.000154087f
Cred_3708 VDD.P5.pSD vout.$1226.Metal3 0.114953f
Cred_3709 VDD.P5.pSD vout.P0.nSD 0.00075246f
Cred_3710 VDD.P5.pSD vout.P0.pSD 0.00399845f
Cred_3711 VDD.P5.pSD vout.P2.nSD 0.000818579f
Cred_3712 VDD.P5.pSD vout.P2.pSD 0.0378453f
Cred_3713 VDD.P5.pSD vout.P4.pSD 0.0342479f
Cred_3714 VDD.P7.pSD vin.$259.Metal1 0.00109131f
Cred_3715 VDD.P7.pSD vin.$263.Metal1 0.00345926f
Cred_3716 VDD.P7.pSD vin.$269.Metal1 0.0139283f
Cred_3717 VDD.P7.pSD vin.$277.Metal1 0.00308355f
Cred_3718 VDD.P7.pSD vin.$43.GatPoly 0.00206339f
Cred_3719 VDD.P7.pSD vin.$51.GatPoly 0.00977271f
Cred_3720 VDD.P7.pSD vin.$520.Metal2 0.000846898f
Cred_3721 VDD.P7.pSD vin.$523.Metal2 0.000225007f
Cred_3722 VDD.P7.pSD vin.$524.Metal2 0.00879194f
Cred_3723 VDD.P7.pSD vin.$526.Metal2 0.00105347f
Cred_3724 VDD.P7.pSD vin.$528.Metal2 8.54457e-06f
Cred_3725 VDD.P7.pSD vin.$529.Metal2 0.00228246f
Cred_3726 VDD.P7.pSD vin.$55.GatPoly 0.00402803f
Cred_3727 VDD.P7.pSD vin.$57.GatPoly 0.0165372f
Cred_3728 VDD.P7.pSD vin.P24.GatPoly 5.32858e-05f
Cred_3729 VDD.P7.pSD vin.P25.GatPoly 0.0386502f
Cred_3730 VDD.P7.pSD vin.P26.GatPoly 0.0362972f
Cred_3731 VDD.P7.pSD vin.P27.GatPoly 5.32858e-05f
Cred_3732 VDD.P7.pSD vout.$1226.Metal3 0.073594f
Cred_3733 VDD.P7.pSD vout.$1292.Metal3 0.0234964f
Cred_3734 VDD.P7.pSD vout.P4.pSD 0.0272733f
Cred_3735 VDD.P7.pSD vout.P6.nSD 0.000370164f
Cred_3736 VDD.P7.pSD vout.P6.pSD 0.0282788f
Cred_3737 vin vout.$1226.Metal3 0.0731171f
Cred_3738 vin vout.P0.nSD 0.00317682f
Cred_3739 vin vout.P0.pSD 0.0126832f
Cred_3740 vin vout.P2.nSD 0.00115189f
Cred_3741 vin vout.P2.pSD 0.00629535f
Cred_3742 vin VSS.$1118.Metal3 4.23861e-06f
Cred_3743 vin VSS.$18.Metal1 0.00492305f
Cred_3744 vin VSS.$40.Metal1 0.00190865f
Cred_3745 vin VSS.$551.Metal1 1.24418e-05f
Cred_3746 vin VSS.$617.Metal2 0.000528651f
Cred_3747 vin VSS.$629.Metal2 0.000528651f
Cred_3748 vin VSS.$85.Metal1 4.23861e-06f
Cred_3749 vin VSS.P0.pSD 0.0327715f
Cred_3750 vin.$10.GatPoly vout.$1226.Metal3 0.000725026f
Cred_3751 vin.$10.GatPoly vout.P0.nSD 0.00027141f
Cred_3752 vin.$10.GatPoly vout.P0.pSD 9.54653e-05f
Cred_3753 vin.$10.GatPoly vout.P2.nSD 1.40729e-05f
Cred_3754 vin.$10.GatPoly vout.P2.pSD 6.24244e-05f
Cred_3755 vin.$10.GatPoly VSS.$18.Metal1 0.000260556f
Cred_3756 vin.$10.GatPoly VSS.$40.Metal1 0.000101017f
Cred_3757 vin.$10.GatPoly VSS.$551.Metal1 1.24171e-06f
Cred_3758 vin.$10.GatPoly VSS.$629.Metal2 3.78163e-08f
Cred_3759 vin.$10.GatPoly VSS.$636.Metal2 0.000234991f
Cred_3760 vin.$10.GatPoly VSS.$644.Metal2 0.000315513f
Cred_3761 vin.$10.GatPoly VSS.$85.Metal1 4.74554e-06f
Cred_3762 vin.$10.GatPoly VSS.$97.Metal1 0.00881409f
Cred_3763 vin.$10.GatPoly VSS.P0.pSD 0.00259356f
Cred_3764 vin.$10.GatPoly VSS.P3.nSD 0.000234236f
Cred_3765 vin.$102.GatPoly vout.$1292.Metal3 0.00437671f
Cred_3766 vin.$102.GatPoly vout.$1358.Metal3 0.00412931f
Cred_3767 vin.$102.GatPoly vout.P10.nSD 0.00589333f
Cred_3768 vin.$102.GatPoly vout.P10.pSD 0.000352334f
Cred_3769 vin.$102.GatPoly vout.P8.nSD 2.31981e-06f
Cred_3770 vin.$102.GatPoly VSS.$18.Metal1 1.41804e-05f
Cred_3771 vin.$102.GatPoly VSS.$275.Metal1 0.000354244f
Cred_3772 vin.$102.GatPoly VSS.$285.Metal1 0.000354244f
Cred_3773 vin.$102.GatPoly VSS.$294.Metal1 2.33684e-06f
Cred_3774 vin.$102.GatPoly VSS.$304.Metal1 1.17616e-06f
Cred_3775 vin.$102.GatPoly VSS.$40.Metal1 5.4977e-06f
Cred_3776 vin.$102.GatPoly VSS.$551.Metal1 3.86945e-05f
Cred_3777 vin.$102.GatPoly VSS.$818.Metal2 0.00015167f
Cred_3778 vin.$102.GatPoly VSS.$826.Metal2 0.00015167f
Cred_3779 vin.$102.GatPoly VSS.$840.Metal2 9.82676e-09f
Cred_3780 vin.$102.GatPoly VSS.P0.pSD 0.00375484f
Cred_3781 vin.$102.GatPoly VSS.P11.nSD 2.73042e-05f
Cred_3782 vin.$105.GatPoly vout.$1292.Metal3 0.00515956f
Cred_3783 vin.$105.GatPoly vout.$1358.Metal3 0.00515956f
Cred_3784 vin.$105.GatPoly vout.P10.nSD 8.12841e-05f
Cred_3785 vin.$105.GatPoly vout.P10.pSD 0.00995189f
Cred_3786 vin.$107.GatPoly vout.$1292.Metal3 0.0245601f
Cred_3787 vin.$107.GatPoly vout.$1358.Metal3 0.0306014f
Cred_3788 vin.$107.GatPoly vout.P10.nSD 0.000386922f
Cred_3789 vin.$107.GatPoly vout.P10.pSD 0.0349196f
Cred_3790 vin.$107.GatPoly vout.P12.pSD 0.000459679f
Cred_3791 vin.$108.GatPoly vout.$1292.Metal3 0.00169029f
Cred_3792 vin.$108.GatPoly vout.$1358.Metal3 0.00211277f
Cred_3793 vin.$108.GatPoly vout.P10.nSD 0.00223585f
Cred_3794 vin.$108.GatPoly vout.P10.pSD 0.000144224f
Cred_3795 vin.$108.GatPoly vout.P12.nSD 3.9615e-06f
Cred_3796 vin.$108.GatPoly VSS.$18.Metal1 8.41276e-06f
Cred_3797 vin.$108.GatPoly VSS.$304.Metal1 8.22307e-07f
Cred_3798 vin.$108.GatPoly VSS.$314.Metal1 2.68438e-06f
Cred_3799 vin.$108.GatPoly VSS.$319.Metal1 0.0011942f
Cred_3800 vin.$108.GatPoly VSS.$40.Metal1 3.2616e-06f
Cred_3801 vin.$108.GatPoly VSS.$551.Metal1 3.07161e-05f
Cred_3802 vin.$108.GatPoly VSS.$852.Metal2 6.87002e-09f
Cred_3803 vin.$108.GatPoly VSS.$867.Metal2 0.000396189f
Cred_3804 vin.$108.GatPoly VSS.$875.Metal2 0.000119486f
Cred_3805 vin.$108.GatPoly VSS.P0.pSD 0.00257967f
Cred_3806 vin.$108.GatPoly VSS.P13.nSD 4.46895e-05f
Cred_3807 vin.$110.GatPoly vout.$1292.Metal3 0.00115831f
Cred_3808 vin.$110.GatPoly vout.$1358.Metal3 0.00176185f
Cred_3809 vin.$110.GatPoly vout.P10.nSD 0.00102786f
Cred_3810 vin.$110.GatPoly vout.P10.pSD 9.88329e-05f
Cred_3811 vin.$110.GatPoly vout.P12.nSD 5.65929e-06f
Cred_3812 vin.$110.GatPoly VSS.$18.Metal1 8.25763e-06f
Cred_3813 vin.$110.GatPoly VSS.$304.Metal1 5.40462e-07f
Cred_3814 vin.$110.GatPoly VSS.$314.Metal1 2.34016e-05f
Cred_3815 vin.$110.GatPoly VSS.$319.Metal1 0.00735147f
Cred_3816 vin.$110.GatPoly VSS.$40.Metal1 3.20146e-06f
Cred_3817 vin.$110.GatPoly VSS.$551.Metal1 4.10482e-05f
Cred_3818 vin.$110.GatPoly VSS.$852.Metal2 4.51533e-09f
Cred_3819 vin.$110.GatPoly VSS.$867.Metal2 0.000815121f
Cred_3820 vin.$110.GatPoly VSS.$875.Metal2 0.00024583f
Cred_3821 vin.$110.GatPoly VSS.P0.pSD 0.0029495f
Cred_3822 vin.$110.GatPoly VSS.P13.nSD 0.000202463f
Cred_3823 vin.$115.GatPoly vout.$1292.Metal3 0.000684693f
Cred_3824 vin.$115.GatPoly vout.$1358.Metal3 0.0129107f
Cred_3825 vin.$115.GatPoly vout.P10.nSD 1.07867e-05f
Cred_3826 vin.$115.GatPoly vout.P10.pSD 0.000167831f
Cred_3827 vin.$115.GatPoly vout.P12.pSD 0.00775715f
Cred_3828 vin.$118.GatPoly vout.$1292.Metal3 0.000255597f
Cred_3829 vin.$118.GatPoly vout.$1358.Metal3 0.00240216f
Cred_3830 vin.$118.GatPoly vout.P10.nSD 9.06234e-06f
Cred_3831 vin.$118.GatPoly vout.P10.pSD 2.18088e-05f
Cred_3832 vin.$118.GatPoly vout.P12.nSD 0.000863949f
Cred_3833 vin.$118.GatPoly VSS.$1229.Metal3 3.33825e-10f
Cred_3834 vin.$118.GatPoly VSS.$1238.Metal3 1.66246e-10f
Cred_3835 vin.$118.GatPoly VSS.$18.Metal1 7.8857e-06f
Cred_3836 vin.$118.GatPoly VSS.$319.Metal1 0.00826858f
Cred_3837 vin.$118.GatPoly VSS.$339.Metal1 1.31594e-05f
Cred_3838 vin.$118.GatPoly VSS.$349.Metal1 2.45925e-07f
Cred_3839 vin.$118.GatPoly VSS.$40.Metal1 3.05726e-06f
Cred_3840 vin.$118.GatPoly VSS.$551.Metal1 5.72026e-05f
Cred_3841 vin.$118.GatPoly VSS.$867.Metal2 0.000792338f
Cred_3842 vin.$118.GatPoly VSS.$875.Metal2 0.000239054f
Cred_3843 vin.$118.GatPoly VSS.$887.Metal2 6.49261e-08f
Cred_3844 vin.$118.GatPoly VSS.P0.pSD 0.00339461f
Cred_3845 vin.$118.GatPoly VSS.P13.nSD 0.000220104f
Cred_3846 vin.$122.GatPoly vout.$1292.Metal3 0.000107421f
Cred_3847 vin.$122.GatPoly vout.$1358.Metal3 0.00914931f
Cred_3848 vin.$122.GatPoly vout.$1424.Metal3 2.68202e-05f
Cred_3849 vin.$122.GatPoly vout.P10.nSD 3.80867e-06f
Cred_3850 vin.$122.GatPoly vout.P10.pSD 9.1657e-06f
Cred_3851 vin.$122.GatPoly vout.P12.nSD 0.00595188f
Cred_3852 vin.$122.GatPoly vout.P14.nSD 9.50927e-07f
Cred_3853 vin.$122.GatPoly vout.P14.pSD 2.28844e-06f
Cred_3854 vin.$122.GatPoly VSS.$18.Metal1 6.88615e-06f
Cred_3855 vin.$122.GatPoly VSS.$319.Metal1 0.000635715f
Cred_3856 vin.$122.GatPoly VSS.$372.Metal1 0.000169442f
Cred_3857 vin.$122.GatPoly VSS.$40.Metal1 2.66974e-06f
Cred_3858 vin.$122.GatPoly VSS.$551.Metal1 7.77564e-05f
Cred_3859 vin.$122.GatPoly VSS.$867.Metal2 0.000209086f
Cred_3860 vin.$122.GatPoly VSS.$875.Metal2 6.30577e-05f
Cred_3861 vin.$122.GatPoly VSS.$905.Metal2 2.10673e-06f
Cred_3862 vin.$122.GatPoly VSS.$914.Metal2 5.54771e-05f
Cred_3863 vin.$122.GatPoly VSS.P0.pSD 0.00368652f
Cred_3864 vin.$122.GatPoly VSS.P13.nSD 2.37904e-05f
Cred_3865 vin.$122.GatPoly VSS.P15.nSD 1.40859e-06f
Cred_3866 vin.$123.GatPoly vout.$1292.Metal3 0.000884672f
Cred_3867 vin.$123.GatPoly vout.$1358.Metal3 0.0275482f
Cred_3868 vin.$123.GatPoly vout.P10.nSD 1.39372e-05f
Cred_3869 vin.$123.GatPoly vout.P10.pSD 0.000216849f
Cred_3870 vin.$123.GatPoly vout.P12.pSD 0.0189773f
Cred_3871 vin.$127.GatPoly vout.$1358.Metal3 0.0565582f
Cred_3872 vin.$127.GatPoly vout.$1424.Metal3 0.00288481f
Cred_3873 vin.$127.GatPoly vout.P12.pSD 0.0347371f
Cred_3874 vin.$127.GatPoly vout.P14.nSD 4.54475e-05f
Cred_3875 vin.$127.GatPoly vout.P14.pSD 0.000707121f
Cred_3876 vin.$130.GatPoly vout.$1358.Metal3 0.00471629f
Cred_3877 vin.$130.GatPoly vout.$1424.Metal3 0.000415112f
Cred_3878 vin.$130.GatPoly vout.P12.nSD 0.00211726f
Cred_3879 vin.$130.GatPoly vout.P14.nSD 1.4718e-05f
Cred_3880 vin.$130.GatPoly vout.P14.pSD 3.54194e-05f
Cred_3881 vin.$130.GatPoly VSS.$18.Metal1 4.99829e-06f
Cred_3882 vin.$130.GatPoly VSS.$349.Metal1 5.95524e-06f
Cred_3883 vin.$130.GatPoly VSS.$361.Metal1 0.000387046f
Cred_3884 vin.$130.GatPoly VSS.$372.Metal1 0.00519177f
Cred_3885 vin.$130.GatPoly VSS.$379.Metal1 0.000344001f
Cred_3886 vin.$130.GatPoly VSS.$40.Metal1 1.93782e-06f
Cred_3887 vin.$130.GatPoly VSS.$551.Metal1 8.77049e-05f
Cred_3888 vin.$130.GatPoly VSS.$899.Metal2 2.21923e-07f
Cred_3889 vin.$130.GatPoly VSS.$905.Metal2 3.46719e-05f
Cred_3890 vin.$130.GatPoly VSS.$914.Metal2 0.0009159f
Cred_3891 vin.$130.GatPoly VSS.P0.pSD 0.00332151f
Cred_3892 vin.$130.GatPoly VSS.P15.nSD 4.47129e-05f
Cred_3893 vin.$134.GatPoly VSS.$18.Metal1 3.84636e-06f
Cred_3894 vin.$134.GatPoly VSS.$361.Metal1 0.00271141f
Cred_3895 vin.$134.GatPoly VSS.$372.Metal1 0.00730333f
Cred_3896 vin.$134.GatPoly VSS.$379.Metal1 0.00251947f
Cred_3897 vin.$134.GatPoly VSS.$391.Metal1 7.2267e-09f
Cred_3898 vin.$134.GatPoly VSS.$40.Metal1 1.49122e-06f
Cred_3899 vin.$134.GatPoly VSS.$551.Metal1 9.68988e-05f
Cred_3900 vin.$134.GatPoly VSS.$905.Metal2 5.6685e-06f
Cred_3901 vin.$134.GatPoly VSS.$914.Metal2 0.000170318f
Cred_3902 vin.$134.GatPoly VSS.$928.Metal2 6.03721e-11f
Cred_3903 vin.$134.GatPoly VSS.P0.pSD 0.00305562f
Cred_3904 vin.$134.GatPoly VSS.P15.nSD 6.47854e-05f
Cred_3905 vin.$136.GatPoly vout.$1358.Metal3 0.00502695f
Cred_3906 vin.$136.GatPoly vout.$1424.Metal3 0.0035657f
Cred_3907 vin.$136.GatPoly vout.P12.nSD 1.37019e-05f
Cred_3908 vin.$136.GatPoly vout.P14.nSD 0.00343669f
Cred_3909 vin.$136.GatPoly vout.P14.pSD 0.000304244f
Cred_3910 vin.$136.GatPoly VSS.$18.Metal1 2.86847e-06f
Cred_3911 vin.$136.GatPoly VSS.$372.Metal1 0.00535348f
Cred_3912 vin.$136.GatPoly VSS.$379.Metal1 1.63556e-07f
Cred_3913 vin.$136.GatPoly VSS.$391.Metal1 9.4503e-09f
Cred_3914 vin.$136.GatPoly VSS.$40.Metal1 1.1121e-06f
Cred_3915 vin.$136.GatPoly VSS.$551.Metal1 0.000101055f
Cred_3916 vin.$136.GatPoly VSS.$905.Metal2 5.54176e-05f
Cred_3917 vin.$136.GatPoly VSS.$914.Metal2 0.00145933f
Cred_3918 vin.$136.GatPoly VSS.$928.Metal2 7.89482e-11f
Cred_3919 vin.$136.GatPoly VSS.P0.pSD 0.00267578f
Cred_3920 vin.$136.GatPoly VSS.P15.nSD 4.45761e-05f
Cred_3921 vin.$139.GatPoly vout.$1358.Metal3 0.0161972f
Cred_3922 vin.$139.GatPoly vout.$1424.Metal3 0.0130997f
Cred_3923 vin.$139.GatPoly vout.P12.pSD 0.000235574f
Cred_3924 vin.$139.GatPoly vout.P14.nSD 0.000206374f
Cred_3925 vin.$139.GatPoly vout.P14.pSD 0.0187518f
Cred_3926 vin.$139.GatPoly VSS.$1250.Metal3 2.419e-10f
Cred_3927 vin.$139.GatPoly VSS.$379.Metal1 2.419e-10f
Cred_3928 vin.$139.GatPoly VSS.$914.Metal2 3.01705e-08f
Cred_3929 vin.$139.GatPoly VSS.$928.Metal2 3.01705e-08f
Cred_3930 vin.$144.GatPoly vout.$1358.Metal3 0.00358296f
Cred_3931 vin.$144.GatPoly vout.$1424.Metal3 0.00376529f
Cred_3932 vin.$144.GatPoly vout.P14.nSD 0.00546899f
Cred_3933 vin.$144.GatPoly vout.P14.pSD 0.000305716f
Cred_3934 vin.$144.GatPoly vout.P16.nSD 1.70974e-06f
Cred_3935 vin.$144.GatPoly VSS.$18.Metal1 3.51163e-06f
Cred_3936 vin.$144.GatPoly VSS.$40.Metal1 1.36145e-06f
Cred_3937 vin.$144.GatPoly VSS.$409.Metal1 0.000498602f
Cred_3938 vin.$144.GatPoly VSS.$551.Metal1 0.000176373f
Cred_3939 vin.$144.GatPoly VSS.$952.Metal2 6.65975e-05f
Cred_3940 vin.$144.GatPoly VSS.$961.Metal2 0.000151842f
Cred_3941 vin.$144.GatPoly VSS.P0.pSD 0.00388206f
Cred_3942 vin.$144.GatPoly VSS.P17.nSD 1.86578e-05f
Cred_3943 vin.$145.GatPoly vout.$1358.Metal3 0.0138059f
Cred_3944 vin.$145.GatPoly vout.$1424.Metal3 0.0142658f
Cred_3945 vin.$145.GatPoly vout.P12.pSD 5.62368e-05f
Cred_3946 vin.$145.GatPoly vout.P14.nSD 0.00020585f
Cred_3947 vin.$145.GatPoly vout.P14.pSD 0.0207168f
Cred_3948 vin.$145.GatPoly vout.P16.pSD 9.12091e-05f
Cred_3949 vin.$15.GatPoly vout.$1226.Metal3 0.0508914f
Cred_3950 vin.$15.GatPoly vout.P0.nSD 0.000804659f
Cred_3951 vin.$15.GatPoly vout.P0.pSD 0.00489118f
Cred_3952 vin.$15.GatPoly vout.P2.nSD 0.000801746f
Cred_3953 vin.$15.GatPoly vout.P2.pSD 0.0392188f
Cred_3954 vin.$152.GatPoly vout.$1358.Metal3 0.000666057f
Cred_3955 vin.$152.GatPoly vout.$1424.Metal3 0.000990448f
Cred_3956 vin.$152.GatPoly vout.P14.nSD 0.000635643f
Cred_3957 vin.$152.GatPoly vout.P14.pSD 5.68314e-05f
Cred_3958 vin.$152.GatPoly vout.P16.nSD 3.04177e-06f
Cred_3959 vin.$152.GatPoly VSS.$18.Metal1 2.43709e-06f
Cred_3960 vin.$152.GatPoly VSS.$40.Metal1 9.44851e-07f
Cred_3961 vin.$152.GatPoly VSS.$409.Metal1 0.0122567f
Cred_3962 vin.$152.GatPoly VSS.$551.Metal1 0.000209817f
Cred_3963 vin.$152.GatPoly VSS.$952.Metal2 0.000325023f
Cred_3964 vin.$152.GatPoly VSS.$961.Metal2 0.000741053f
Cred_3965 vin.$152.GatPoly VSS.P0.pSD 0.00347871f
Cred_3966 vin.$152.GatPoly VSS.P17.nSD 0.000322917f
Cred_3967 vin.$153.GatPoly vout.$1358.Metal3 0.0089109f
Cred_3968 vin.$153.GatPoly vout.$1424.Metal3 0.0110445f
Cred_3969 vin.$153.GatPoly vout.P14.nSD 0.000140383f
Cred_3970 vin.$153.GatPoly vout.P14.pSD 0.0127054f
Cred_3971 vin.$153.GatPoly vout.P16.pSD 0.000162268f
Cred_3972 vin.$156.GatPoly vout.$1358.Metal3 0.000695475f
Cred_3973 vin.$156.GatPoly vout.$1424.Metal3 0.00812177f
Cred_3974 vin.$156.GatPoly vout.P14.nSD 2.46585e-05f
Cred_3975 vin.$156.GatPoly vout.P14.pSD 5.93415e-05f
Cred_3976 vin.$156.GatPoly vout.P16.nSD 0.00329961f
Cred_3977 vin.$156.GatPoly VSS.$18.Metal1 1.80668e-06f
Cred_3978 vin.$156.GatPoly VSS.$40.Metal1 7.00443e-07f
Cred_3979 vin.$156.GatPoly VSS.$409.Metal1 0.00688597f
Cred_3980 vin.$156.GatPoly VSS.$551.Metal1 0.000242872f
Cred_3981 vin.$156.GatPoly VSS.$952.Metal2 0.000582784f
Cred_3982 vin.$156.GatPoly VSS.$961.Metal2 0.00132875f
Cred_3983 vin.$156.GatPoly VSS.P0.pSD 0.00317853f
Cred_3984 vin.$156.GatPoly VSS.P17.nSD 0.000217628f
Cred_3985 vin.$157.GatPoly vout.$1358.Metal3 0.00288481f
Cred_3986 vin.$157.GatPoly vout.$1424.Metal3 0.054598f
Cred_3987 vin.$157.GatPoly vout.P14.nSD 4.54475e-05f
Cred_3988 vin.$157.GatPoly vout.P14.pSD 0.000707121f
Cred_3989 vin.$157.GatPoly vout.P16.pSD 0.0329013f
Cred_3990 vin.$16.GatPoly vout.$1226.Metal3 0.00170382f
Cred_3991 vin.$16.GatPoly vout.P0.nSD 3.46629e-05f
Cred_3992 vin.$16.GatPoly vout.P0.pSD 0.000153822f
Cred_3993 vin.$16.GatPoly vout.P2.nSD 0.00073975f
Cred_3994 vin.$16.GatPoly vout.P2.pSD 0.000146698f
Cred_3995 vin.$16.GatPoly VSS.$1130.Metal3 4.92964e-10f
Cred_3996 vin.$16.GatPoly VSS.$115.Metal1 6.89279e-06f
Cred_3997 vin.$16.GatPoly VSS.$127.Metal1 1.69472e-07f
Cred_3998 vin.$16.GatPoly VSS.$18.Metal1 0.000239704f
Cred_3999 vin.$16.GatPoly VSS.$40.Metal1 9.29325e-05f
Cred_4000 vin.$16.GatPoly VSS.$551.Metal1 1.60213e-06f
Cred_4001 vin.$16.GatPoly VSS.$636.Metal2 0.000421386f
Cred_4002 vin.$16.GatPoly VSS.$644.Metal2 0.000565937f
Cred_4003 vin.$16.GatPoly VSS.$658.Metal2 6.28996e-08f
Cred_4004 vin.$16.GatPoly VSS.$97.Metal1 0.0098294f
Cred_4005 vin.$16.GatPoly VSS.P0.pSD 0.0028784f
Cred_4006 vin.$16.GatPoly VSS.P3.nSD 0.000272449f
Cred_4007 vin.$163.GatPoly vout.$1424.Metal3 0.00965734f
Cred_4008 vin.$163.GatPoly vout.P16.pSD 0.0075445f
Cred_4009 vin.$164.GatPoly vout 0.000161056f
Cred_4010 vin.$164.GatPoly vout.$1424.Metal3 0.00803226f
Cred_4011 vin.$164.GatPoly vout.P16.nSD 0.00546245f
Cred_4012 vin.$164.GatPoly vout.P18.nSD 2.55412e-06f
Cred_4013 vin.$164.GatPoly VSS.$1002.Metal2 0.000111808f
Cred_4014 vin.$164.GatPoly VSS.$1010.Metal2 8.32614e-05f
Cred_4015 vin.$164.GatPoly VSS.$18.Metal1 1.85524e-06f
Cred_4016 vin.$164.GatPoly VSS.$40.Metal1 7.19271e-07f
Cred_4017 vin.$164.GatPoly VSS.$453.Metal1 0.000453794f
Cred_4018 vin.$164.GatPoly VSS.$551.Metal1 0.000371229f
Cred_4019 vin.$164.GatPoly VSS.P0.pSD 0.00392325f
Cred_4020 vin.$164.GatPoly VSS.P19.nSD 1.69818e-05f
Cred_4021 vin.$167.GatPoly vout 0.0058575f
Cred_4022 vin.$167.GatPoly vout.$1424.Metal3 0.0550237f
Cred_4023 vin.$167.GatPoly vout.P16.pSD 0.0354983f
Cred_4024 vin.$167.GatPoly vout.P18.pSD 0.000664693f
Cred_4025 vin.$17.GatPoly vout.$1226.Metal3 9.88288e-08f
Cred_4026 vin.$17.GatPoly vout.P0.nSD 1.4312e-09f
Cred_4027 vin.$17.GatPoly vout.P0.pSD 7.60514e-09f
Cred_4028 vin.$17.GatPoly vout.P2.nSD 1.55696e-09f
Cred_4029 vin.$17.GatPoly vout.P2.pSD 8.50912e-09f
Cred_4030 vin.$17.GatPoly VSS.$1130.Metal3 9.01013e-11f
Cred_4031 vin.$17.GatPoly VSS.$115.Metal1 9.01013e-11f
Cred_4032 vin.$17.GatPoly VSS.$644.Metal2 1.12377e-08f
Cred_4033 vin.$17.GatPoly VSS.$658.Metal2 1.12377e-08f
Cred_4034 vin.$172.GatPoly vout 0.000360397f
Cred_4035 vin.$172.GatPoly vout.$1424.Metal3 0.00169973f
Cred_4036 vin.$172.GatPoly vout.P16.nSD 0.000712908f
Cred_4037 vin.$172.GatPoly vout.P18.nSD 5.71538e-06f
Cred_4038 vin.$172.GatPoly VSS.$1002.Metal2 0.000565937f
Cred_4039 vin.$172.GatPoly VSS.$1010.Metal2 0.000421386f
Cred_4040 vin.$172.GatPoly VSS.$1283.Metal3 4.92964e-10f
Cred_4041 vin.$172.GatPoly VSS.$18.Metal1 1.07733e-06f
Cred_4042 vin.$172.GatPoly VSS.$40.Metal1 4.17679e-07f
Cred_4043 vin.$172.GatPoly VSS.$436.Metal1 1.69472e-07f
Cred_4044 vin.$172.GatPoly VSS.$448.Metal1 6.89279e-06f
Cred_4045 vin.$172.GatPoly VSS.$453.Metal1 0.0098294f
Cred_4046 vin.$172.GatPoly VSS.$551.Metal1 0.000355855f
Cred_4047 vin.$172.GatPoly VSS.$987.Metal2 6.28996e-08f
Cred_4048 vin.$172.GatPoly VSS.P0.pSD 0.00285529f
Cred_4049 vin.$172.GatPoly VSS.P19.nSD 0.000272449f
Cred_4050 vin.$173.GatPoly vout.$1424.Metal3 1.17931e-07f
Cred_4051 vin.$173.GatPoly VSS.$1002.Metal2 1.12377e-08f
Cred_4052 vin.$173.GatPoly VSS.$1283.Metal3 9.01013e-11f
Cred_4053 vin.$173.GatPoly VSS.$448.Metal1 9.01013e-11f
Cred_4054 vin.$173.GatPoly VSS.$987.Metal2 1.12377e-08f
Cred_4055 vin.$176.GatPoly vout 0.000660739f
Cred_4056 vin.$176.GatPoly vout.$1424.Metal3 0.000282696f
Cred_4057 vin.$176.GatPoly vout.P16.nSD 2.65081e-06f
Cred_4058 vin.$176.GatPoly vout.P18.nSD 0.000253938f
Cred_4059 vin.$176.GatPoly VSS.$1002.Metal2 0.000315513f
Cred_4060 vin.$176.GatPoly VSS.$1010.Metal2 0.000234991f
Cred_4061 vin.$176.GatPoly VSS.$1016.Metal2 1.052e-07f
Cred_4062 vin.$176.GatPoly VSS.$18.Metal1 8.34403e-07f
Cred_4063 vin.$176.GatPoly VSS.$40.Metal1 3.23495e-07f
Cred_4064 vin.$176.GatPoly VSS.$453.Metal1 0.00881409f
Cred_4065 vin.$176.GatPoly VSS.$476.Metal1 4.74556e-06f
Cred_4066 vin.$176.GatPoly VSS.$551.Metal1 0.000386816f
Cred_4067 vin.$176.GatPoly VSS.P0.pSD 0.00256843f
Cred_4068 vin.$176.GatPoly VSS.P19.nSD 0.000234236f
Cred_4069 vin.$179.GatPoly vout 0.0510831f
Cred_4070 vin.$179.GatPoly vout.$1424.Metal3 0.00508226f
Cred_4071 vin.$179.GatPoly vout.P16.pSD 0.000359975f
Cred_4072 vin.$179.GatPoly vout.P18.pSD 0.0368159f
Cred_4073 vin.$179.GatPoly VSS.$1028.Metal2 2.08919e-07f
Cred_4074 vin.$179.GatPoly VSS.$1040.Metal2 9.03152e-05f
Cred_4075 vin.$179.GatPoly VSS.$1055.Metal2 8.35024e-07f
Cred_4076 vin.$179.GatPoly VSS.$1301.Metal3 0.000234715f
Cred_4077 vin.$179.GatPoly VSS.$1313.Metal3 5.35063e-05f
Cred_4078 vin.$179.GatPoly VSS.$488.Metal1 1.67507e-09f
Cred_4079 vin.$179.GatPoly VSS.$498.Metal1 3.59648e-09f
Cred_4080 vin.$180.GatPoly vout 0.00981871f
Cred_4081 vin.$180.GatPoly vout.$1424.Metal3 0.000282696f
Cred_4082 vin.$180.GatPoly vout.P16.nSD 2.65081e-06f
Cred_4083 vin.$180.GatPoly vout.P18.nSD 0.00582262f
Cred_4084 vin.$180.GatPoly VSS.$1002.Metal2 2.72948e-05f
Cred_4085 vin.$180.GatPoly VSS.$1010.Metal2 2.03259e-05f
Cred_4086 vin.$180.GatPoly VSS.$1028.Metal2 1.85316e-06f
Cred_4087 vin.$180.GatPoly VSS.$1040.Metal2 2.84017e-06f
Cred_4088 vin.$180.GatPoly VSS.$1066.Metal2 5.21815e-06f
Cred_4089 vin.$180.GatPoly VSS.$1301.Metal3 1.43337e-08f
Cred_4090 vin.$180.GatPoly VSS.$18.Metal1 1.34177e-06f
Cred_4091 vin.$180.GatPoly VSS.$40.Metal1 5.202e-07f
Cred_4092 vin.$180.GatPoly VSS.$453.Metal1 0.000531044f
Cred_4093 vin.$180.GatPoly VSS.$476.Metal1 3.81953e-05f
Cred_4094 vin.$180.GatPoly VSS.$488.Metal1 0.000101872f
Cred_4095 vin.$180.GatPoly VSS.$498.Metal1 2.15145e-05f
Cred_4096 vin.$180.GatPoly VSS.$509.Metal1 0.000218547f
Cred_4097 vin.$180.GatPoly VSS.$551.Metal1 0.00108696f
Cred_4098 vin.$180.GatPoly VSS.P0.pSD 0.00516458f
Cred_4099 vin.$180.GatPoly VSS.P1.GatPoly 0.00217093f
Cred_4100 vin.$180.GatPoly VSS.P19.nSD 1.99165e-05f
Cred_4101 vin.$180.GatPoly VSS.P21.nSD 1.46536e-06f
Cred_4102 vin.$180.GatPoly VSS.P23.nSD 1.46536e-06f
Cred_4103 vin.$199.Metal1 vout.$1226.Metal3 0.0588927f
Cred_4104 vin.$199.Metal1 vout.P0.nSD 0.00175826f
Cred_4105 vin.$199.Metal1 vout.P0.pSD 0.066999f
Cred_4106 vin.$199.Metal1 vout.P2.nSD 0.0009278f
Cred_4107 vin.$199.Metal1 vout.P2.pSD 0.00507064f
Cred_4108 vin.$199.Metal1 VSS.$1100.Metal3 0.000461014f
Cred_4109 vin.$199.Metal1 VSS.$1112.Metal3 0.00202244f
Cred_4110 vin.$199.Metal1 VSS.$590.Metal2 7.19462e-06f
Cred_4111 vin.$199.Metal1 VSS.$605.Metal2 0.000793107f
Cred_4112 vin.$199.Metal1 VSS.$617.Metal2 1.67458e-05f
Cred_4113 vin.$199.Metal1 VSS.$65.Metal1 3.09875e-08f
Cred_4114 vin.$199.Metal1 VSS.$75.Metal1 1.34264e-07f
Cred_4115 vin.$202.Metal1 vout.$1226.Metal3 0.0349032f
Cred_4116 vin.$202.Metal1 vout.P0.nSD 0.034167f
Cred_4117 vin.$202.Metal1 vout.P0.pSD 0.00551521f
Cred_4118 vin.$202.Metal1 vout.P2.nSD 0.000551269f
Cred_4119 vin.$202.Metal1 vout.P2.pSD 0.00300515f
Cred_4120 vin.$202.Metal1 VSS.$1112.Metal3 5.67139e-07f
Cred_4121 vin.$202.Metal1 VSS.$1118.Metal3 1.14121e-07f
Cred_4122 vin.$202.Metal1 VSS.$18.Metal1 0.0119657f
Cred_4123 vin.$202.Metal1 VSS.$40.Metal1 0.00550388f
Cred_4124 vin.$202.Metal1 VSS.$551.Metal1 3.44606e-05f
Cred_4125 vin.$202.Metal1 VSS.$564.Metal2 2.06488e-05f
Cred_4126 vin.$202.Metal1 VSS.$605.Metal2 0.000110218f
Cred_4127 vin.$202.Metal1 VSS.$617.Metal2 8.68947e-05f
Cred_4128 vin.$202.Metal1 VSS.$629.Metal2 3.19362e-05f
Cred_4129 vin.$202.Metal1 VSS.$636.Metal2 0.000320137f
Cred_4130 vin.$202.Metal1 VSS.$644.Metal2 0.000418935f
Cred_4131 vin.$202.Metal1 VSS.$65.Metal1 0.000593036f
Cred_4132 vin.$202.Metal1 VSS.$75.Metal1 0.00283622f
Cred_4133 vin.$202.Metal1 VSS.$85.Metal1 0.00457796f
Cred_4134 vin.$202.Metal1 VSS.$97.Metal1 0.00985598f
Cred_4135 vin.$202.Metal1 VSS.P0.GatPoly 0.00332172f
Cred_4136 vin.$202.Metal1 VSS.P0.nSD 5.79859e-06f
Cred_4137 vin.$202.Metal1 VSS.P0.pSD 0.0872197f
Cred_4138 vin.$202.Metal1 VSS.P1.nSD 5.79859e-06f
Cred_4139 vin.$202.Metal1 VSS.P3.nSD 0.000312034f
Cred_4140 vin.$207.Metal1 vout.$1226.Metal3 0.000153634f
Cred_4141 vin.$207.Metal1 vout.P0.nSD 4.04334e-06f
Cred_4142 vin.$207.Metal1 vout.P0.pSD 3.84801e-05f
Cred_4143 vin.$207.Metal1 vout.P2.nSD 2.42035e-06f
Cred_4144 vin.$207.Metal1 vout.P2.pSD 1.47508e-05f
Cred_4145 vin.$207.Metal1 VSS.$636.Metal2 4.31717e-06f
Cred_4146 vin.$207.Metal1 VSS.$644.Metal2 5.79735e-06f
Cred_4147 vin.$207.Metal1 VSS.$97.Metal1 8.76004e-07f
Cred_4148 vin.$207.Metal1 VSS.P3.nSD 3.04133e-08f
Cred_4149 vin.$210.Metal1 vout.$1226.Metal3 8.28316e-06f
Cred_4150 vin.$210.Metal1 vout.P0.nSD 1.19953e-07f
Cred_4151 vin.$210.Metal1 vout.P0.pSD 6.37411e-07f
Cred_4152 vin.$210.Metal1 vout.P2.nSD 1.30493e-07f
Cred_4153 vin.$210.Metal1 vout.P2.pSD 7.13176e-07f
Cred_4154 vin.$210.Metal1 VSS.$1130.Metal3 4.13169e-08f
Cred_4155 vin.$210.Metal1 VSS.$115.Metal1 0.000577707f
Cred_4156 vin.$210.Metal1 VSS.$127.Metal1 1.4204e-05f
Cred_4157 vin.$210.Metal1 VSS.$18.Metal1 0.00312128f
Cred_4158 vin.$210.Metal1 VSS.$40.Metal1 0.00121011f
Cred_4159 vin.$210.Metal1 VSS.$551.Metal1 1.76944e-05f
Cred_4160 vin.$210.Metal1 VSS.$629.Metal2 3.17102e-06f
Cred_4161 vin.$210.Metal1 VSS.$636.Metal2 0.00189855f
Cred_4162 vin.$210.Metal1 VSS.$644.Metal2 0.00255196f
Cred_4163 vin.$210.Metal1 VSS.$658.Metal2 5.27182e-06f
Cred_4164 vin.$210.Metal1 VSS.$85.Metal1 0.000397929f
Cred_4165 vin.$210.Metal1 VSS.$97.Metal1 0.0518778f
Cred_4166 vin.$210.Metal1 VSS.P0.pSD 0.0341998f
Cred_4167 vin.$210.Metal1 VSS.P3.nSD 0.0019189f
Cred_4168 vin.$211.Metal1 vout.$1226.Metal3 5.5384e-05f
Cred_4169 vin.$211.Metal1 vout.P0.nSD 1.25087e-06f
Cred_4170 vin.$211.Metal1 vout.P0.pSD 7.51498e-06f
Cred_4171 vin.$211.Metal1 vout.P2.nSD 8.72523e-07f
Cred_4172 vin.$211.Metal1 vout.P2.pSD 5.54699e-06f
Cred_4173 vin.$211.Metal1 VSS.$1130.Metal3 7.55168e-09f
Cred_4174 vin.$211.Metal1 VSS.$115.Metal1 7.55168e-09f
Cred_4175 vin.$211.Metal1 VSS.$636.Metal2 2.20656e-06f
Cred_4176 vin.$211.Metal1 VSS.$644.Metal2 3.90496e-06f
Cred_4177 vin.$211.Metal1 VSS.$658.Metal2 9.41867e-07f
Cred_4178 vin.$211.Metal1 VSS.$97.Metal1 4.47735e-07f
Cred_4179 vin.$211.Metal1 VSS.P3.nSD 1.55446e-08f
Cred_4180 vin.$218.Metal1 vout.$1226.Metal3 0.000959786f
Cred_4181 vin.$218.Metal1 vout.P0.nSD 1.91823e-05f
Cred_4182 vin.$218.Metal1 vout.P0.pSD 8.58687e-05f
Cred_4183 vin.$218.Metal1 vout.P2.nSD 0.00039217f
Cred_4184 vin.$218.Metal1 vout.P2.pSD 8.26371e-05f
Cred_4185 vin.$218.Metal1 VSS.$1130.Metal3 2.92843e-07f
Cred_4186 vin.$218.Metal1 VSS.$115.Metal1 0.00418705f
Cred_4187 vin.$218.Metal1 VSS.$127.Metal1 0.000264111f
Cred_4188 vin.$218.Metal1 VSS.$18.Metal1 0.00208362f
Cred_4189 vin.$218.Metal1 VSS.$40.Metal1 0.000807815f
Cred_4190 vin.$218.Metal1 VSS.$551.Metal1 1.58002e-05f
Cred_4191 vin.$218.Metal1 VSS.$636.Metal2 0.000422139f
Cred_4192 vin.$218.Metal1 VSS.$644.Metal2 0.000604599f
Cred_4193 vin.$218.Metal1 VSS.$658.Metal2 3.87306e-05f
Cred_4194 vin.$218.Metal1 VSS.$97.Metal1 0.00932905f
Cred_4195 vin.$218.Metal1 VSS.P0.pSD 0.0268488f
Cred_4196 vin.$218.Metal1 VSS.P3.nSD 0.000343629f
Cred_4197 vin.$219.Metal1 vout.$1226.Metal3 0.00564565f
Cred_4198 vin.$219.Metal1 vout.P0.nSD 8.17578e-05f
Cred_4199 vin.$219.Metal1 vout.P0.pSD 0.000434447f
Cred_4200 vin.$219.Metal1 vout.P2.nSD 8.89419e-05f
Cred_4201 vin.$219.Metal1 vout.P2.pSD 0.00514285f
Cred_4202 vin.$219.Metal1 VSS.$1130.Metal3 5.35242e-08f
Cred_4203 vin.$219.Metal1 VSS.$115.Metal1 5.35242e-08f
Cred_4204 vin.$219.Metal1 VSS.$644.Metal2 6.6757e-06f
Cred_4205 vin.$219.Metal1 VSS.$658.Metal2 6.6757e-06f
Cred_4206 vin.$22.GatPoly vout.$1226.Metal3 0.00685606f
Cred_4207 vin.$22.GatPoly vout.P0.nSD 0.00010375f
Cred_4208 vin.$22.GatPoly vout.P0.pSD 0.00053774f
Cred_4209 vin.$22.GatPoly vout.P2.nSD 0.00557046f
Cred_4210 vin.$22.GatPoly vout.P2.pSD 0.000590304f
Cred_4211 vin.$22.GatPoly VSS.$18.Metal1 0.00025006f
Cred_4212 vin.$22.GatPoly VSS.$40.Metal1 9.69474e-05f
Cred_4213 vin.$22.GatPoly VSS.$551.Metal1 2.7571e-06f
Cred_4214 vin.$22.GatPoly VSS.$636.Metal2 8.32614e-05f
Cred_4215 vin.$22.GatPoly VSS.$644.Metal2 0.000111808f
Cred_4216 vin.$22.GatPoly VSS.$97.Metal1 0.000453794f
Cred_4217 vin.$22.GatPoly VSS.P0.pSD 0.00394728f
Cred_4218 vin.$22.GatPoly VSS.P3.nSD 1.69818e-05f
Cred_4219 vin.$222.Metal1 vout.$1226.Metal3 0.017145f
Cred_4220 vin.$222.Metal1 vout.P0.nSD 0.000250647f
Cred_4221 vin.$222.Metal1 vout.P0.pSD 0.00132472f
Cred_4222 vin.$222.Metal1 vout.P2.nSD 0.0165034f
Cred_4223 vin.$222.Metal1 vout.P2.pSD 0.00147617f
Cred_4224 vin.$222.Metal1 VSS.$115.Metal1 0.00108489f
Cred_4225 vin.$222.Metal1 VSS.$127.Metal1 0.000959611f
Cred_4226 vin.$222.Metal1 VSS.$18.Metal1 0.0017733f
Cred_4227 vin.$222.Metal1 VSS.$40.Metal1 0.000687502f
Cred_4228 vin.$222.Metal1 VSS.$551.Metal1 1.79127e-05f
Cred_4229 vin.$222.Metal1 VSS.$636.Metal2 4.4036e-05f
Cred_4230 vin.$222.Metal1 VSS.$644.Metal2 5.91341e-05f
Cred_4231 vin.$222.Metal1 VSS.$658.Metal2 8.01663e-06f
Cred_4232 vin.$222.Metal1 VSS.$97.Metal1 0.000240007f
Cred_4233 vin.$222.Metal1 VSS.P0.pSD 0.0267221f
Cred_4234 vin.$222.Metal1 VSS.P3.nSD 8.98148e-06f
Cred_4235 vin.$227.Metal1 vout.$1226.Metal3 0.027956f
Cred_4236 vin.$227.Metal1 vout.P0.nSD 0.000404846f
Cred_4237 vin.$227.Metal1 vout.P0.pSD 0.00215129f
Cred_4238 vin.$227.Metal1 vout.P2.nSD 0.000442907f
Cred_4239 vin.$227.Metal1 vout.P2.pSD 0.0295459f
Cred_4240 vin.$228.Metal1 vout.$1226.Metal3 0.020989f
Cred_4241 vin.$228.Metal1 vout.P0.nSD 0.000303954f
Cred_4242 vin.$228.Metal1 vout.P0.pSD 0.00161516f
Cred_4243 vin.$228.Metal1 vout.P2.nSD 0.0197961f
Cred_4244 vin.$228.Metal1 vout.P2.pSD 0.00180715f
Cred_4245 vin.$228.Metal1 VSS.$1136.Metal3 6.36494e-08f
Cred_4246 vin.$228.Metal1 VSS.$1148.Metal3 6.36494e-08f
Cred_4247 vin.$228.Metal1 VSS.$127.Metal1 0.000232729f
Cred_4248 vin.$228.Metal1 VSS.$137.Metal1 0.000581246f
Cred_4249 vin.$228.Metal1 VSS.$142.Metal1 7.87832e-07f
Cred_4250 vin.$228.Metal1 VSS.$18.Metal1 0.00159506f
Cred_4251 vin.$228.Metal1 VSS.$40.Metal1 0.0006184f
Cred_4252 vin.$228.Metal1 VSS.$551.Metal1 2.05041e-05f
Cred_4253 vin.$228.Metal1 VSS.$670.Metal2 6.39343e-05f
Cred_4254 vin.$228.Metal1 VSS.$685.Metal2 2.24272e-05f
Cred_4255 vin.$228.Metal1 VSS.$693.Metal2 2.76072e-06f
Cred_4256 vin.$228.Metal1 VSS.P0.pSD 0.0273701f
Cred_4257 vin.$228.Metal1 VSS.P5.nSD 2.71306e-08f
Cred_4258 vin.$232.Metal1 vout.$1226.Metal3 0.000612914f
Cred_4259 vin.$232.Metal1 vout.P0.nSD 8.87595e-06f
Cred_4260 vin.$232.Metal1 vout.P0.pSD 4.71653e-05f
Cred_4261 vin.$232.Metal1 vout.P2.nSD 9.94021e-05f
Cred_4262 vin.$232.Metal1 vout.P2.pSD 5.27716e-05f
Cred_4263 vin.$232.Metal1 VSS.$1136.Metal3 1.23653e-07f
Cred_4264 vin.$232.Metal1 VSS.$1148.Metal3 1.23653e-07f
Cred_4265 vin.$232.Metal1 VSS.$127.Metal1 0.000874728f
Cred_4266 vin.$232.Metal1 VSS.$137.Metal1 0.00277761f
Cred_4267 vin.$232.Metal1 VSS.$142.Metal1 0.000146093f
Cred_4268 vin.$232.Metal1 VSS.$18.Metal1 0.000978363f
Cred_4269 vin.$232.Metal1 VSS.$40.Metal1 0.000379308f
Cred_4270 vin.$232.Metal1 VSS.$551.Metal1 1.55972e-05f
Cred_4271 vin.$232.Metal1 VSS.$670.Metal2 8.0625e-05f
Cred_4272 vin.$232.Metal1 VSS.$685.Metal2 4.39379e-05f
Cred_4273 vin.$232.Metal1 VSS.$693.Metal2 5.36333e-06f
Cred_4274 vin.$232.Metal1 VSS.P0.pSD 0.0188552f
Cred_4275 vin.$232.Metal1 VSS.P5.nSD 5.27073e-08f
Cred_4276 vin.$233.Metal1 vout.$1226.Metal3 0.00451174f
Cred_4277 vin.$233.Metal1 vout.P0.nSD 6.53371e-05f
Cred_4278 vin.$233.Metal1 vout.P0.pSD 0.00034719f
Cred_4279 vin.$233.Metal1 vout.P2.nSD 7.10783e-05f
Cred_4280 vin.$233.Metal1 vout.P2.pSD 0.00393497f
Cred_4281 vin.$233.Metal1 VSS.$1136.Metal3 1.22208e-08f
Cred_4282 vin.$233.Metal1 VSS.$1148.Metal3 1.22208e-08f
Cred_4283 vin.$233.Metal1 VSS.$137.Metal1 2.48343e-08f
Cred_4284 vin.$233.Metal1 VSS.$670.Metal2 3.0975e-06f
Cred_4285 vin.$233.Metal1 VSS.$685.Metal2 3.0975e-06f
Cred_4286 vin.$236.Metal1 vout.$1226.Metal3 0.000131038f
Cred_4287 vin.$236.Metal1 vout.P0.nSD 1.89763e-06f
Cred_4288 vin.$236.Metal1 vout.P0.pSD 1.00837e-05f
Cred_4289 vin.$236.Metal1 vout.P2.nSD 1.4642e-05f
Cred_4290 vin.$236.Metal1 vout.P2.pSD 1.12823e-05f
Cred_4291 vin.$236.Metal1 VSS.$1136.Metal3 1.16526e-07f
Cred_4292 vin.$236.Metal1 VSS.$1148.Metal3 1.16526e-07f
Cred_4293 vin.$236.Metal1 VSS.$127.Metal1 5.99642e-09f
Cred_4294 vin.$236.Metal1 VSS.$137.Metal1 0.00194174f
Cred_4295 vin.$236.Metal1 VSS.$142.Metal1 0.0138169f
Cred_4296 vin.$236.Metal1 VSS.$18.Metal1 0.00090243f
Cred_4297 vin.$236.Metal1 VSS.$40.Metal1 0.000349869f
Cred_4298 vin.$236.Metal1 VSS.$551.Metal1 1.69613e-05f
Cred_4299 vin.$236.Metal1 VSS.$670.Metal2 5.01301e-05f
Cred_4300 vin.$236.Metal1 VSS.$685.Metal2 0.000842328f
Cred_4301 vin.$236.Metal1 VSS.$693.Metal2 0.00035596f
Cred_4302 vin.$236.Metal1 VSS.P0.pSD 0.0189874f
Cred_4303 vin.$236.Metal1 VSS.P5.nSD 0.000486954f
Cred_4304 vin.$237.Metal1 vout.$1226.Metal3 3.60497e-05f
Cred_4305 vin.$237.Metal1 vout.P0.nSD 5.22055e-07f
Cred_4306 vin.$237.Metal1 vout.P0.pSD 2.77412e-06f
Cred_4307 vin.$237.Metal1 vout.P2.nSD 5.67929e-07f
Cred_4308 vin.$237.Metal1 vout.P2.pSD 3.10386e-06f
Cred_4309 vin.$237.Metal1 VSS.$1136.Metal3 1.64348e-08f
Cred_4310 vin.$237.Metal1 VSS.$1148.Metal3 1.64348e-08f
Cred_4311 vin.$237.Metal1 VSS.$137.Metal1 3.33978e-08f
Cred_4312 vin.$237.Metal1 VSS.$670.Metal2 4.1656e-06f
Cred_4313 vin.$237.Metal1 VSS.$685.Metal2 4.1656e-06f
Cred_4314 vin.$24.GatPoly vout.$1226.Metal3 0.00768464f
Cred_4315 vin.$24.GatPoly vout.P0.nSD 9.01245e-05f
Cred_4316 vin.$24.GatPoly vout.P0.pSD 0.000478906f
Cred_4317 vin.$24.GatPoly vout.P2.nSD 0.00339765f
Cred_4318 vin.$24.GatPoly vout.P2.pSD 0.000535831f
Cred_4319 vin.$24.GatPoly vout.P4.nSD 1.37019e-05f
Cred_4320 vin.$24.GatPoly VSS.$142.Metal1 0.00688597f
Cred_4321 vin.$24.GatPoly VSS.$18.Metal1 0.000163598f
Cred_4322 vin.$24.GatPoly VSS.$40.Metal1 6.34266e-05f
Cred_4323 vin.$24.GatPoly VSS.$551.Metal1 2.68401e-06f
Cred_4324 vin.$24.GatPoly VSS.$685.Metal2 0.00132875f
Cred_4325 vin.$24.GatPoly VSS.$693.Metal2 0.000582784f
Cred_4326 vin.$24.GatPoly VSS.P0.pSD 0.0031942f
Cred_4327 vin.$24.GatPoly VSS.P5.nSD 0.000217628f
Cred_4328 vin.$240.Metal1 VSS.$142.Metal1 0.0455148f
Cred_4329 vin.$240.Metal1 VSS.$18.Metal1 0.00117159f
Cred_4330 vin.$240.Metal1 VSS.$40.Metal1 0.000454221f
Cred_4331 vin.$240.Metal1 VSS.$551.Metal1 2.79437e-05f
Cred_4332 vin.$240.Metal1 VSS.$685.Metal2 0.00275314f
Cred_4333 vin.$240.Metal1 VSS.$693.Metal2 0.00120752f
Cred_4334 vin.$240.Metal1 VSS.P0.pSD 0.0279411f
Cred_4335 vin.$240.Metal1 VSS.P5.nSD 0.00171597f
Cred_4336 vin.$246.Metal1 vout.$1226.Metal3 0.000952901f
Cred_4337 vin.$246.Metal1 vout.P0.nSD 2.0821e-06f
Cred_4338 vin.$246.Metal1 vout.P0.pSD 1.1064e-05f
Cred_4339 vin.$246.Metal1 vout.P2.nSD 3.87382e-06f
Cred_4340 vin.$246.Metal1 vout.P2.pSD 1.23791e-05f
Cred_4341 vin.$246.Metal1 vout.P4.nSD 0.000330635f
Cred_4342 vin.$246.Metal1 VSS.$1148.Metal3 1.84336e-07f
Cred_4343 vin.$246.Metal1 VSS.$1157.Metal3 9.18001e-08f
Cred_4344 vin.$246.Metal1 VSS.$142.Metal1 0.0116496f
Cred_4345 vin.$246.Metal1 VSS.$162.Metal1 0.00301769f
Cred_4346 vin.$246.Metal1 VSS.$18.Metal1 0.001083f
Cred_4347 vin.$246.Metal1 VSS.$40.Metal1 0.000419875f
Cred_4348 vin.$246.Metal1 VSS.$551.Metal1 3.26891e-05f
Cred_4349 vin.$246.Metal1 VSS.$685.Metal2 0.00080666f
Cred_4350 vin.$246.Metal1 VSS.$693.Metal2 0.000391622f
Cred_4351 vin.$246.Metal1 VSS.$705.Metal2 3.47174e-05f
Cred_4352 vin.$246.Metal1 VSS.P0.pSD 0.0292287f
Cred_4353 vin.$246.Metal1 VSS.P5.nSD 0.000426611f
Cred_4354 vin.$247.Metal1 vout.$1226.Metal3 0.010914f
Cred_4355 vin.$247.Metal1 vout.P0.nSD 1.33466e-05f
Cred_4356 vin.$247.Metal1 vout.P0.pSD 7.09214e-05f
Cred_4357 vin.$247.Metal1 vout.P2.nSD 1.45193e-05f
Cred_4358 vin.$247.Metal1 vout.P2.pSD 0.000156627f
Cred_4359 vin.$247.Metal1 vout.P4.pSD 0.00614943f
Cred_4360 vin.$247.Metal1 VSS.$1148.Metal3 3.28481e-08f
Cred_4361 vin.$247.Metal1 VSS.$1157.Metal3 1.63585e-08f
Cred_4362 vin.$247.Metal1 VSS.$162.Metal1 4.96011e-08f
Cred_4363 vin.$247.Metal1 VSS.$693.Metal2 6.1864e-06f
Cred_4364 vin.$247.Metal1 VSS.$705.Metal2 6.18653e-06f
Cred_4365 vin.$25.GatPoly vout.$1226.Metal3 0.0495841f
Cred_4366 vin.$25.GatPoly vout.P0.nSD 0.000632511f
Cred_4367 vin.$25.GatPoly vout.P0.pSD 0.00336106f
Cred_4368 vin.$25.GatPoly vout.P2.nSD 0.00068809f
Cred_4369 vin.$25.GatPoly vout.P2.pSD 0.0360918f
Cred_4370 vin.$25.GatPoly vout.P4.pSD 0.00041507f
Cred_4371 vin.$250.Metal1 vout.$1226.Metal3 0.0183073f
Cred_4372 vin.$250.Metal1 vout.P0.nSD 1.17033e-06f
Cred_4373 vin.$250.Metal1 vout.P0.pSD 6.21892e-06f
Cred_4374 vin.$250.Metal1 vout.P2.nSD 2.17742e-06f
Cred_4375 vin.$250.Metal1 vout.P2.pSD 6.95812e-06f
Cred_4376 vin.$250.Metal1 vout.P4.nSD 0.0137217f
Cred_4377 vin.$250.Metal1 VSS.$1148.Metal3 4.35704e-08f
Cred_4378 vin.$250.Metal1 VSS.$1157.Metal3 2.16982e-08f
Cred_4379 vin.$250.Metal1 VSS.$142.Metal1 0.000299078f
Cred_4380 vin.$250.Metal1 VSS.$162.Metal1 0.0019782f
Cred_4381 vin.$250.Metal1 VSS.$172.Metal1 0.000712365f
Cred_4382 vin.$250.Metal1 VSS.$18.Metal1 0.000936239f
Cred_4383 vin.$250.Metal1 VSS.$40.Metal1 0.000362977f
Cred_4384 vin.$250.Metal1 VSS.$551.Metal1 3.71291e-05f
Cred_4385 vin.$250.Metal1 VSS.$685.Metal2 8.03077e-05f
Cred_4386 vin.$250.Metal1 VSS.$693.Metal2 4.36338e-05f
Cred_4387 vin.$250.Metal1 VSS.$705.Metal2 1.41576e-05f
Cred_4388 vin.$250.Metal1 VSS.P0.pSD 0.0291339f
Cred_4389 vin.$250.Metal1 VSS.P5.nSD 9.86789e-06f
Cred_4390 vin.$251.Metal1 vout.$1226.Metal3 0.0233189f
Cred_4391 vin.$251.Metal1 vout.P0.nSD 7.50193e-06f
Cred_4392 vin.$251.Metal1 vout.P0.pSD 3.9864e-05f
Cred_4393 vin.$251.Metal1 vout.P2.nSD 8.16113e-06f
Cred_4394 vin.$251.Metal1 vout.P2.pSD 8.80383e-05f
Cred_4395 vin.$251.Metal1 vout.P4.pSD 0.0167983f
Cred_4396 vin.$251.Metal1 VSS.$1148.Metal3 7.7641e-09f
Cred_4397 vin.$251.Metal1 VSS.$1157.Metal3 3.86655e-09f
Cred_4398 vin.$251.Metal1 VSS.$162.Metal1 1.17239e-08f
Cred_4399 vin.$251.Metal1 VSS.$693.Metal2 1.46224e-06f
Cred_4400 vin.$251.Metal1 VSS.$705.Metal2 1.46227e-06f
Cred_4401 vin.$258.Metal1 vout.$1226.Metal3 0.0263216f
Cred_4402 vin.$258.Metal1 vout.P4.nSD 0.0211501f
Cred_4403 vin.$258.Metal1 VSS.$1157.Metal3 1.17999e-08f
Cred_4404 vin.$258.Metal1 VSS.$1169.Metal3 1.17999e-08f
Cred_4405 vin.$258.Metal1 VSS.$172.Metal1 0.000191504f
Cred_4406 vin.$258.Metal1 VSS.$18.Metal1 0.000810038f
Cred_4407 vin.$258.Metal1 VSS.$184.Metal1 0.000216529f
Cred_4408 vin.$258.Metal1 VSS.$195.Metal1 1.74382e-06f
Cred_4409 vin.$258.Metal1 VSS.$40.Metal1 0.000314049f
Cred_4410 vin.$258.Metal1 VSS.$551.Metal1 4.03826e-05f
Cred_4411 vin.$258.Metal1 VSS.$717.Metal2 2.47566e-05f
Cred_4412 vin.$258.Metal1 VSS.$732.Metal2 2.1047e-05f
Cred_4413 vin.$258.Metal1 VSS.$740.Metal2 6.85678e-07f
Cred_4414 vin.$258.Metal1 VSS.P0.pSD 0.0283934f
Cred_4415 vin.$258.Metal1 VSS.P7.nSD 1.01979e-08f
Cred_4416 vin.$259.Metal1 vout.$1226.Metal3 0.0287553f
Cred_4417 vin.$259.Metal1 vout.$1292.Metal3 0.000181335f
Cred_4418 vin.$259.Metal1 vout.P4.pSD 0.0228315f
Cred_4419 vin.$259.Metal1 vout.P6.nSD 2.85677e-06f
Cred_4420 vin.$259.Metal1 vout.P6.pSD 4.23941e-05f
Cred_4421 vin.$262.Metal1 vout.$1226.Metal3 0.000401533f
Cred_4422 vin.$262.Metal1 vout.P4.nSD 0.000133925f
Cred_4423 vin.$262.Metal1 VSS.$1157.Metal3 4.99226e-08f
Cred_4424 vin.$262.Metal1 VSS.$1169.Metal3 4.99226e-08f
Cred_4425 vin.$262.Metal1 VSS.$172.Metal1 0.00177235f
Cred_4426 vin.$262.Metal1 VSS.$18.Metal1 0.000485112f
Cred_4427 vin.$262.Metal1 VSS.$184.Metal1 0.00203176f
Cred_4428 vin.$262.Metal1 VSS.$195.Metal1 1.29688e-05f
Cred_4429 vin.$262.Metal1 VSS.$40.Metal1 0.000188076f
Cred_4430 vin.$262.Metal1 VSS.$551.Metal1 3.05853e-05f
Cred_4431 vin.$262.Metal1 VSS.$717.Metal2 0.000112777f
Cred_4432 vin.$262.Metal1 VSS.$732.Metal2 8.91659e-05f
Cred_4433 vin.$262.Metal1 VSS.$740.Metal2 2.90554e-06f
Cred_4434 vin.$262.Metal1 VSS.P0.pSD 0.0192215f
Cred_4435 vin.$262.Metal1 VSS.P7.nSD 9.00449e-08f
Cred_4436 vin.$263.Metal1 vout.$1226.Metal3 0.0107182f
Cred_4437 vin.$263.Metal1 vout.$1292.Metal3 0.000458577f
Cred_4438 vin.$263.Metal1 vout.P4.pSD 0.00590953f
Cred_4439 vin.$263.Metal1 vout.P6.nSD 7.22446e-06f
Cred_4440 vin.$263.Metal1 vout.P6.pSD 0.00010721f
Cred_4441 vin.$263.Metal1 VSS.$1157.Metal3 1.00262e-08f
Cred_4442 vin.$263.Metal1 VSS.$1169.Metal3 1.00262e-08f
Cred_4443 vin.$263.Metal1 VSS.$184.Metal1 2.03746e-08f
Cred_4444 vin.$263.Metal1 VSS.$717.Metal2 2.54126e-06f
Cred_4445 vin.$263.Metal1 VSS.$732.Metal2 2.54126e-06f
Cred_4446 vin.$264.Metal1 vout.$1226.Metal3 0.000179594f
Cred_4447 vin.$264.Metal1 vout.P4.nSD 2.15579e-06f
Cred_4448 vin.$264.Metal1 VSS.$1157.Metal3 1.25001e-07f
Cred_4449 vin.$264.Metal1 VSS.$1169.Metal3 1.25001e-07f
Cred_4450 vin.$264.Metal1 VSS.$172.Metal1 0.000117423f
Cred_4451 vin.$264.Metal1 VSS.$18.Metal1 0.000624235f
Cred_4452 vin.$264.Metal1 VSS.$184.Metal1 0.00203218f
Cred_4453 vin.$264.Metal1 VSS.$195.Metal1 0.0279878f
Cred_4454 vin.$264.Metal1 VSS.$40.Metal1 0.000242014f
Cred_4455 vin.$264.Metal1 VSS.$551.Metal1 4.95955e-05f
Cred_4456 vin.$264.Metal1 VSS.$717.Metal2 8.50668e-05f
Cred_4457 vin.$264.Metal1 VSS.$732.Metal2 0.000827793f
Cred_4458 vin.$264.Metal1 VSS.$740.Metal2 3.0232e-05f
Cred_4459 vin.$264.Metal1 VSS.P0.pSD 0.0278301f
Cred_4460 vin.$264.Metal1 VSS.P7.nSD 0.000258713f
Cred_4461 vin.$269.Metal1 vout.$1226.Metal3 3.02928e-05f
Cred_4462 vin.$269.Metal1 VSS.$1157.Metal3 1.03273e-08f
Cred_4463 vin.$269.Metal1 VSS.$1169.Metal3 1.03273e-08f
Cred_4464 vin.$269.Metal1 VSS.$184.Metal1 2.09864e-08f
Cred_4465 vin.$269.Metal1 VSS.$717.Metal2 2.61756e-06f
Cred_4466 vin.$269.Metal1 VSS.$732.Metal2 2.61756e-06f
Cred_4467 vin.$27.GatPoly vout.$1226.Metal3 0.0084638f
Cred_4468 vin.$27.GatPoly vout.P0.nSD 0.000122569f
Cred_4469 vin.$27.GatPoly vout.P0.pSD 0.000651311f
Cred_4470 vin.$27.GatPoly vout.P2.nSD 0.000133339f
Cred_4471 vin.$27.GatPoly vout.P2.pSD 0.00833836f
Cred_4472 vin.$272.Metal1 vout.$1226.Metal3 1.15271e-05f
Cred_4473 vin.$272.Metal1 vout.$1292.Metal3 1.15271e-05f
Cred_4474 vin.$272.Metal1 vout.P6.nSD 2.64692e-07f
Cred_4475 vin.$272.Metal1 vout.P6.pSD 9.92474e-07f
Cred_4476 vin.$272.Metal1 VSS.$18.Metal1 0.000725383f
Cred_4477 vin.$272.Metal1 VSS.$184.Metal1 0.000181938f
Cred_4478 vin.$272.Metal1 VSS.$195.Metal1 0.0455289f
Cred_4479 vin.$272.Metal1 VSS.$202.Metal1 0.00226359f
Cred_4480 vin.$272.Metal1 VSS.$212.Metal1 0.000651932f
Cred_4481 vin.$272.Metal1 VSS.$40.Metal1 0.000281229f
Cred_4482 vin.$272.Metal1 VSS.$551.Metal1 7.68817e-05f
Cred_4483 vin.$272.Metal1 VSS.$732.Metal2 0.000985453f
Cred_4484 vin.$272.Metal1 VSS.$740.Metal2 3.73645e-05f
Cred_4485 vin.$272.Metal1 VSS.$746.Metal2 1.98775e-05f
Cred_4486 vin.$272.Metal1 VSS.P0.pSD 0.037451f
Cred_4487 vin.$272.Metal1 VSS.P7.nSD 0.000431708f
Cred_4488 vin.$277.Metal1 vout.$1226.Metal3 2.45804e-05f
Cred_4489 vin.$277.Metal1 vout.$1292.Metal3 2.45804e-05f
Cred_4490 vin.$277.Metal1 vout.P6.nSD 3.87241e-07f
Cred_4491 vin.$277.Metal1 vout.P6.pSD 4.65911e-06f
Cred_4492 vin.$277.Metal1 VSS.$746.Metal2 5.66036e-06f
Cred_4493 vin.$280.Metal1 vout.$1226.Metal3 0.00309907f
Cred_4494 vin.$280.Metal1 vout.$1292.Metal3 0.0030237f
Cred_4495 vin.$280.Metal1 vout.P4.nSD 7.06736e-07f
Cred_4496 vin.$280.Metal1 vout.P6.nSD 0.00402775f
Cred_4497 vin.$280.Metal1 vout.P6.pSD 0.000260339f
Cred_4498 vin.$280.Metal1 VSS.$18.Metal1 0.000487784f
Cred_4499 vin.$280.Metal1 VSS.$195.Metal1 0.00081905f
Cred_4500 vin.$280.Metal1 VSS.$202.Metal1 0.00268409f
Cred_4501 vin.$280.Metal1 VSS.$212.Metal1 0.00244297f
Cred_4502 vin.$280.Metal1 VSS.$40.Metal1 0.000189112f
Cred_4503 vin.$280.Metal1 VSS.$551.Metal1 6.77735e-05f
Cred_4504 vin.$280.Metal1 VSS.$732.Metal2 8.70118e-05f
Cred_4505 vin.$280.Metal1 VSS.$740.Metal2 3.30424e-06f
Cred_4506 vin.$280.Metal1 VSS.$746.Metal2 8.1619e-05f
Cred_4507 vin.$280.Metal1 VSS.P0.pSD 0.0289539f
Cred_4508 vin.$280.Metal1 VSS.P7.nSD 6.85337e-06f
Cred_4509 vin.$281.Metal1 vout.$1226.Metal3 0.00239229f
Cred_4510 vin.$281.Metal1 vout.$1292.Metal3 0.00239229f
Cred_4511 vin.$281.Metal1 vout.P6.nSD 3.76882e-05f
Cred_4512 vin.$281.Metal1 vout.P6.pSD 0.0025562f
Cred_4513 vin.$281.Metal1 VSS.$746.Metal2 9.73581e-06f
Cred_4514 vin.$284.Metal1 vout.$1226.Metal3 0.0145655f
Cred_4515 vin.$284.Metal1 vout.$1292.Metal3 0.0145357f
Cred_4516 vin.$284.Metal1 vout.P4.nSD 2.79465e-07f
Cred_4517 vin.$284.Metal1 vout.P6.nSD 0.0250383f
Cred_4518 vin.$284.Metal1 vout.P6.pSD 0.00125152f
Cred_4519 vin.$284.Metal1 VSS.$18.Metal1 0.000416995f
Cred_4520 vin.$284.Metal1 VSS.$195.Metal1 8.96162e-05f
Cred_4521 vin.$284.Metal1 VSS.$40.Metal1 0.000161668f
Cred_4522 vin.$284.Metal1 VSS.$551.Metal1 7.76548e-05f
Cred_4523 vin.$284.Metal1 VSS.$732.Metal2 2.93412e-05f
Cred_4524 vin.$284.Metal1 VSS.$740.Metal2 1.11422e-06f
Cred_4525 vin.$284.Metal1 VSS.P0.pSD 0.0287277f
Cred_4526 vin.$284.Metal1 VSS.P7.nSD 7.44987e-07f
Cred_4527 vin.$285.Metal1 vout.$1226.Metal3 0.0141293f
Cred_4528 vin.$285.Metal1 vout.$1292.Metal3 0.0141293f
Cred_4529 vin.$285.Metal1 vout.P6.nSD 0.000222594f
Cred_4530 vin.$285.Metal1 vout.P6.pSD 0.026906f
Cred_4531 vin.$290.Metal1 vout.$1226.Metal3 0.00434449f
Cred_4532 vin.$290.Metal1 vout.$1292.Metal3 0.00446386f
Cred_4533 vin.$290.Metal1 vout.P6.nSD 0.00722393f
Cred_4534 vin.$290.Metal1 vout.P6.pSD 0.000374059f
Cred_4535 vin.$290.Metal1 vout.P8.nSD 1.11932e-06f
Cred_4536 vin.$290.Metal1 VSS.$1175.Metal3 9.87577e-08f
Cred_4537 vin.$290.Metal1 VSS.$1184.Metal3 1.98307e-07f
Cred_4538 vin.$290.Metal1 VSS.$18.Metal1 0.000475472f
Cred_4539 vin.$290.Metal1 VSS.$212.Metal1 0.000539422f
Cred_4540 vin.$290.Metal1 VSS.$224.Metal1 0.0045486f
Cred_4541 vin.$290.Metal1 VSS.$232.Metal1 0.00431443f
Cred_4542 vin.$290.Metal1 VSS.$40.Metal1 0.000184339f
Cred_4543 vin.$290.Metal1 VSS.$551.Metal1 0.000118396f
Cred_4544 vin.$290.Metal1 VSS.$758.Metal2 4.18548e-05f
Cred_4545 vin.$290.Metal1 VSS.$770.Metal2 0.000144127f
Cred_4546 vin.$290.Metal1 VSS.$779.Metal2 0.000340307f
Cred_4547 vin.$290.Metal1 VSS.P0.pSD 0.0379128f
Cred_4548 vin.$290.Metal1 VSS.P10.nSD 0.000138973f
Cred_4549 vin.$291.Metal1 vout.$1226.Metal3 0.00842774f
Cred_4550 vin.$291.Metal1 vout.$1292.Metal3 0.00938583f
Cred_4551 vin.$291.Metal1 vout.P6.nSD 0.000132771f
Cred_4552 vin.$291.Metal1 vout.P6.pSD 0.0125555f
Cred_4553 vin.$291.Metal1 vout.P8.pSD 6.73211e-05f
Cred_4554 vin.$291.Metal1 VSS.$1175.Metal3 1.5159e-08f
Cred_4555 vin.$291.Metal1 VSS.$1184.Metal3 3.04396e-08f
Cred_4556 vin.$291.Metal1 VSS.$224.Metal1 4.59643e-08f
Cred_4557 vin.$291.Metal1 VSS.$758.Metal2 5.73291e-06f
Cred_4558 vin.$291.Metal1 VSS.$770.Metal2 5.73279e-06f
Cred_4559 vin.$295.Metal1 vout.$1226.Metal3 0.00311248f
Cred_4560 vin.$295.Metal1 vout.$1292.Metal3 0.003854f
Cred_4561 vin.$295.Metal1 vout.P6.nSD 4.90342e-05f
Cred_4562 vin.$295.Metal1 vout.P6.pSD 0.00430023f
Cred_4563 vin.$295.Metal1 vout.P8.pSD 5.21033e-05f
Cred_4564 vin.$295.Metal1 VSS.$1175.Metal3 5.05301e-09f
Cred_4565 vin.$295.Metal1 VSS.$1184.Metal3 1.01465e-08f
Cred_4566 vin.$295.Metal1 VSS.$224.Metal1 1.53214e-08f
Cred_4567 vin.$295.Metal1 VSS.$758.Metal2 1.91097e-06f
Cred_4568 vin.$295.Metal1 VSS.$770.Metal2 1.91093e-06f
Cred_4569 vin.$298.Metal1 vout.$1226.Metal3 2.63002e-05f
Cred_4570 vin.$298.Metal1 vout.$1292.Metal3 7.42012e-05f
Cred_4571 vin.$298.Metal1 vout.P6.nSD 6.47819e-07f
Cred_4572 vin.$298.Metal1 vout.P6.pSD 2.26444e-06f
Cred_4573 vin.$298.Metal1 vout.P8.nSD 2.11743e-07f
Cred_4574 vin.$298.Metal1 VSS.$1175.Metal3 1.39336e-08f
Cred_4575 vin.$298.Metal1 VSS.$1184.Metal3 2.79789e-08f
Cred_4576 vin.$298.Metal1 VSS.$18.Metal1 0.000309012f
Cred_4577 vin.$298.Metal1 VSS.$212.Metal1 2.06118e-05f
Cred_4578 vin.$298.Metal1 VSS.$224.Metal1 0.00110293f
Cred_4579 vin.$298.Metal1 VSS.$232.Metal1 0.0374145f
Cred_4580 vin.$298.Metal1 VSS.$40.Metal1 0.000119803f
Cred_4581 vin.$298.Metal1 VSS.$551.Metal1 0.000101552f
Cred_4582 vin.$298.Metal1 VSS.$758.Metal2 5.44166e-06f
Cred_4583 vin.$298.Metal1 VSS.$770.Metal2 0.000781696f
Cred_4584 vin.$298.Metal1 VSS.$779.Metal2 0.00256563f
Cred_4585 vin.$298.Metal1 VSS.P0.pSD 0.0283714f
Cred_4586 vin.$298.Metal1 VSS.P10.nSD 0.00138166f
Cred_4587 vin.$302.Metal1 vout.$1226.Metal3 3.93932e-05f
Cred_4588 vin.$302.Metal1 vout.$1292.Metal3 0.000133112f
Cred_4589 vin.$302.Metal1 vout.P6.nSD 1.03488e-06f
Cred_4590 vin.$302.Metal1 vout.P6.pSD 3.39174e-06f
Cred_4591 vin.$302.Metal1 vout.P8.nSD 4.14279e-07f
Cred_4592 vin.$302.Metal1 VSS.$18.Metal1 0.000261718f
Cred_4593 vin.$302.Metal1 VSS.$232.Metal1 0.0336274f
Cred_4594 vin.$302.Metal1 VSS.$247.Metal1 0.00224884f
Cred_4595 vin.$302.Metal1 VSS.$259.Metal1 4.71399e-05f
Cred_4596 vin.$302.Metal1 VSS.$40.Metal1 0.000101467f
Cred_4597 vin.$302.Metal1 VSS.$551.Metal1 0.000114769f
Cred_4598 vin.$302.Metal1 VSS.$770.Metal2 0.000738837f
Cred_4599 vin.$302.Metal1 VSS.$779.Metal2 0.00244983f
Cred_4600 vin.$302.Metal1 VSS.$793.Metal2 3.93834e-07f
Cred_4601 vin.$302.Metal1 VSS.P0.pSD 0.0277926f
Cred_4602 vin.$302.Metal1 VSS.P10.nSD 0.0012559f
Cred_4603 vin.$303.Metal1 vout.$1292.Metal3 9.46932e-06f
Cred_4604 vin.$303.Metal1 VSS.$1184.Metal3 3.50978e-09f
Cred_4605 vin.$303.Metal1 VSS.$1196.Metal3 3.50978e-09f
Cred_4606 vin.$303.Metal1 VSS.$247.Metal1 7.13236e-09f
Cred_4607 vin.$303.Metal1 VSS.$779.Metal2 8.89596e-07f
Cred_4608 vin.$303.Metal1 VSS.$793.Metal2 8.89596e-07f
Cred_4609 vin.$307.Metal1 vout.$1292.Metal3 0.00116973f
Cred_4610 vin.$307.Metal1 vout.P8.pSD 0.000168855f
Cred_4611 vin.$307.Metal1 VSS.$1184.Metal3 2.30086e-08f
Cred_4612 vin.$307.Metal1 VSS.$1196.Metal3 2.30086e-08f
Cred_4613 vin.$307.Metal1 VSS.$247.Metal1 4.67566e-08f
Cred_4614 vin.$307.Metal1 VSS.$779.Metal2 5.83179e-06f
Cred_4615 vin.$307.Metal1 VSS.$793.Metal2 5.83179e-06f
Cred_4616 vin.$310.Metal1 vout.$1292.Metal3 0.00372025f
Cred_4617 vin.$310.Metal1 vout.P8.nSD 0.00205429f
Cred_4618 vin.$310.Metal1 VSS.$18.Metal1 0.000236902f
Cred_4619 vin.$310.Metal1 VSS.$247.Metal1 0.00393282f
Cred_4620 vin.$310.Metal1 VSS.$259.Metal1 0.00156417f
Cred_4621 vin.$310.Metal1 VSS.$40.Metal1 9.18462e-05f
Cred_4622 vin.$310.Metal1 VSS.$551.Metal1 0.000131084f
Cred_4623 vin.$310.Metal1 VSS.$793.Metal2 7.49838e-05f
Cred_4624 vin.$310.Metal1 VSS.P0.pSD 0.0282791f
Cred_4625 vin.$312.Metal1 vout.$1292.Metal3 0.0292921f
Cred_4626 vin.$312.Metal1 vout.P8.nSD 0.0238325f
Cred_4627 vin.$312.Metal1 VSS.$18.Metal1 0.000200781f
Cred_4628 vin.$312.Metal1 VSS.$259.Metal1 9.86687e-05f
Cred_4629 vin.$312.Metal1 VSS.$269.Metal1 0.000196038f
Cred_4630 vin.$312.Metal1 VSS.$40.Metal1 7.78422e-05f
Cred_4631 vin.$312.Metal1 VSS.$551.Metal1 0.000147959f
Cred_4632 vin.$312.Metal1 VSS.$805.Metal2 8.2437e-07f
Cred_4633 vin.$312.Metal1 VSS.P0.pSD 0.0276593f
Cred_4634 vin.$313.Metal1 vout.$1292.Metal3 0.0210815f
Cred_4635 vin.$313.Metal1 vout.P8.pSD 0.017383f
Cred_4636 vin.$317.Metal1 vout.$1292.Metal3 0.0186968f
Cred_4637 vin.$317.Metal1 vout.P8.pSD 0.0154566f
Cred_4638 vin.$320.Metal1 vout.$1292.Metal3 0.0116244f
Cred_4639 vin.$320.Metal1 vout.$1358.Metal3 4.76489e-05f
Cred_4640 vin.$320.Metal1 vout.P10.nSD 1.68942e-06f
Cred_4641 vin.$320.Metal1 vout.P10.pSD 4.06564e-06f
Cred_4642 vin.$320.Metal1 vout.P8.nSD 0.00920727f
Cred_4643 vin.$320.Metal1 VSS 1.24952e-07f
Cred_4644 vin.$320.Metal1 VSS.$1196.Metal3 9.35894e-08f
Cred_4645 vin.$320.Metal1 VSS.$18.Metal1 0.000244411f
Cred_4646 vin.$320.Metal1 VSS.$259.Metal1 0.0011524f
Cred_4647 vin.$320.Metal1 VSS.$269.Metal1 0.00433114f
Cred_4648 vin.$320.Metal1 VSS.$275.Metal1 0.00091562f
Cred_4649 vin.$320.Metal1 VSS.$285.Metal1 0.000531035f
Cred_4650 vin.$320.Metal1 VSS.$40.Metal1 9.47574e-05f
Cred_4651 vin.$320.Metal1 VSS.$551.Metal1 0.000236338f
Cred_4652 vin.$320.Metal1 VSS.$805.Metal2 3.72301e-05f
Cred_4653 vin.$320.Metal1 VSS.$818.Metal2 0.000124741f
Cred_4654 vin.$320.Metal1 VSS.$826.Metal2 9.7139e-05f
Cred_4655 vin.$320.Metal1 VSS.P0.pSD 0.0385192f
Cred_4656 vin.$320.Metal1 VSS.P11.nSD 4.15145e-05f
Cred_4657 vin.$321.Metal1 vout.$1292.Metal3 0.00249587f
Cred_4658 vin.$321.Metal1 vout.P8.pSD 0.00144557f
Cred_4659 vin.$321.Metal1 VSS 1.06811e-08f
Cred_4660 vin.$321.Metal1 VSS.$1196.Metal3 8.00015e-09f
Cred_4661 vin.$321.Metal1 VSS.$269.Metal1 1.8917e-08f
Cred_4662 vin.$321.Metal1 VSS.$805.Metal2 2.35944e-06f
Cred_4663 vin.$321.Metal1 VSS.$818.Metal2 2.35942e-06f
Cred_4664 vin.$325.Metal1 vout.$1292.Metal3 5.71672e-05f
Cred_4665 vin.$325.Metal1 VSS 2.39053e-08f
Cred_4666 vin.$325.Metal1 VSS.$1196.Metal3 1.79051e-08f
Cred_4667 vin.$325.Metal1 VSS.$269.Metal1 4.2338e-08f
Cred_4668 vin.$325.Metal1 VSS.$805.Metal2 5.28066e-06f
Cred_4669 vin.$325.Metal1 VSS.$818.Metal2 5.28061e-06f
Cred_4670 vin.$328.Metal1 vout.$1292.Metal3 2.82293e-05f
Cred_4671 vin.$328.Metal1 VSS 6.56784e-08f
Cred_4672 vin.$328.Metal1 VSS.$1196.Metal3 4.91932e-08f
Cred_4673 vin.$328.Metal1 VSS.$18.Metal1 0.000201226f
Cred_4674 vin.$328.Metal1 VSS.$269.Metal1 0.00152936f
Cred_4675 vin.$328.Metal1 VSS.$275.Metal1 0.0249685f
Cred_4676 vin.$328.Metal1 VSS.$285.Metal1 0.0246803f
Cred_4677 vin.$328.Metal1 VSS.$40.Metal1 7.80149e-05f
Cred_4678 vin.$328.Metal1 VSS.$551.Metal1 0.000273037f
Cred_4679 vin.$328.Metal1 VSS.$805.Metal2 1.45083e-05f
Cred_4680 vin.$328.Metal1 VSS.$818.Metal2 0.00225957f
Cred_4681 vin.$328.Metal1 VSS.$826.Metal2 0.00224506f
Cred_4682 vin.$328.Metal1 VSS.P0.pSD 0.0375425f
Cred_4683 vin.$328.Metal1 VSS.P11.nSD 0.00193489f
Cred_4684 vin.$334.Metal1 vout.$1292.Metal3 0.000390182f
Cred_4685 vin.$334.Metal1 vout.$1358.Metal3 0.00026584f
Cred_4686 vin.$334.Metal1 vout.P10.nSD 0.000209228f
Cred_4687 vin.$334.Metal1 vout.P10.pSD 2.26828e-05f
Cred_4688 vin.$334.Metal1 vout.P8.nSD 1.16594e-06f
Cred_4689 vin.$334.Metal1 VSS 1.33005e-07f
Cred_4690 vin.$334.Metal1 VSS.$1217.Metal3 9.96213e-08f
Cred_4691 vin.$334.Metal1 VSS.$18.Metal1 0.000130513f
Cred_4692 vin.$334.Metal1 VSS.$275.Metal1 0.00866361f
Cred_4693 vin.$334.Metal1 VSS.$285.Metal1 0.00924707f
Cred_4694 vin.$334.Metal1 VSS.$294.Metal1 0.00309711f
Cred_4695 vin.$334.Metal1 VSS.$40.Metal1 5.05995e-05f
Cred_4696 vin.$334.Metal1 VSS.$551.Metal1 0.000238217f
Cred_4697 vin.$334.Metal1 VSS.$818.Metal2 0.000859001f
Cred_4698 vin.$334.Metal1 VSS.$826.Metal2 0.000888382f
Cred_4699 vin.$334.Metal1 VSS.$840.Metal2 2.93808e-05f
Cred_4700 vin.$334.Metal1 VSS.P0.pSD 0.0282804f
Cred_4701 vin.$334.Metal1 VSS.P11.nSD 0.000687847f
Cred_4702 vin.$335.Metal1 vout.$1292.Metal3 2.72085e-05f
Cred_4703 vin.$335.Metal1 vout.$1358.Metal3 2.72085e-05f
Cred_4704 vin.$335.Metal1 vout.P10.nSD 4.28645e-07f
Cred_4705 vin.$335.Metal1 vout.P10.pSD 2.32157e-06f
Cred_4706 vin.$335.Metal1 VSS 2.39053e-08f
Cred_4707 vin.$335.Metal1 VSS.$1217.Metal3 1.79051e-08f
Cred_4708 vin.$335.Metal1 VSS.$294.Metal1 4.2338e-08f
Cred_4709 vin.$335.Metal1 VSS.$826.Metal2 5.28061e-06f
Cred_4710 vin.$335.Metal1 VSS.$840.Metal2 5.28066e-06f
Cred_4711 vin.$338.Metal1 vout.$1292.Metal3 0.00568634f
Cred_4712 vin.$338.Metal1 vout.$1358.Metal3 0.00555549f
Cred_4713 vin.$338.Metal1 vout.P10.nSD 0.00934546f
Cred_4714 vin.$338.Metal1 vout.P10.pSD 0.000474023f
Cred_4715 vin.$338.Metal1 vout.P8.nSD 1.22692e-06f
Cred_4716 vin.$338.Metal1 VSS 5.9428e-08f
Cred_4717 vin.$338.Metal1 VSS.$1217.Metal3 4.45116e-08f
Cred_4718 vin.$338.Metal1 VSS.$18.Metal1 0.00011833f
Cred_4719 vin.$338.Metal1 VSS.$275.Metal1 0.000187356f
Cred_4720 vin.$338.Metal1 VSS.$285.Metal1 0.000284504f
Cred_4721 vin.$338.Metal1 VSS.$294.Metal1 0.00280537f
Cred_4722 vin.$338.Metal1 VSS.$304.Metal1 0.0011524f
Cred_4723 vin.$338.Metal1 VSS.$40.Metal1 4.58762e-05f
Cred_4724 vin.$338.Metal1 VSS.$551.Metal1 0.000284642f
Cred_4725 vin.$338.Metal1 VSS.$818.Metal2 8.02166e-05f
Cred_4726 vin.$338.Metal1 VSS.$826.Metal2 9.3344e-05f
Cred_4727 vin.$338.Metal1 VSS.$840.Metal2 2.27558e-05f
Cred_4728 vin.$338.Metal1 VSS.P0.pSD 0.0294378f
Cred_4729 vin.$338.Metal1 VSS.P11.nSD 1.44409e-05f
Cred_4730 vin.$339.Metal1 vout.$1292.Metal3 0.00116937f
Cred_4731 vin.$339.Metal1 vout.$1358.Metal3 0.00116937f
Cred_4732 vin.$339.Metal1 vout.P10.nSD 1.84223e-05f
Cred_4733 vin.$339.Metal1 vout.P10.pSD 0.00158508f
Cred_4734 vin.$339.Metal1 VSS 1.06811e-08f
Cred_4735 vin.$339.Metal1 VSS.$1217.Metal3 8.00015e-09f
Cred_4736 vin.$339.Metal1 VSS.$294.Metal1 1.8917e-08f
Cred_4737 vin.$339.Metal1 VSS.$826.Metal2 2.35942e-06f
Cred_4738 vin.$339.Metal1 VSS.$840.Metal2 2.35944e-06f
Cred_4739 vin.$343.Metal1 vout.$1292.Metal3 0.00870964f
Cred_4740 vin.$343.Metal1 vout.$1358.Metal3 0.00870964f
Cred_4741 vin.$343.Metal1 vout.P10.nSD 0.000137212f
Cred_4742 vin.$343.Metal1 vout.P10.pSD 0.0165748f
Cred_4743 vin.$346.Metal1 vout.$1292.Metal3 0.0139415f
Cred_4744 vin.$346.Metal1 vout.$1358.Metal3 0.0139415f
Cred_4745 vin.$346.Metal1 vout.P10.nSD 0.0240521f
Cred_4746 vin.$346.Metal1 vout.P10.pSD 0.00118956f
Cred_4747 vin.$346.Metal1 VSS.$18.Metal1 9.96632e-05f
Cred_4748 vin.$346.Metal1 VSS.$294.Metal1 0.000196038f
Cred_4749 vin.$346.Metal1 VSS.$304.Metal1 9.86687e-05f
Cred_4750 vin.$346.Metal1 VSS.$40.Metal1 3.86391e-05f
Cred_4751 vin.$346.Metal1 VSS.$551.Metal1 0.000298073f
Cred_4752 vin.$346.Metal1 VSS.$840.Metal2 8.2437e-07f
Cred_4753 vin.$346.Metal1 VSS.P0.pSD 0.0276495f
Cred_4754 vin.$347.Metal1 vout.$1292.Metal3 0.0094903f
Cred_4755 vin.$347.Metal1 vout.$1358.Metal3 0.0094903f
Cred_4756 vin.$347.Metal1 vout.P10.nSD 0.000149511f
Cred_4757 vin.$347.Metal1 vout.P10.pSD 0.0179847f
Cred_4758 vin.$348.Metal1 vout.$1292.Metal3 0.00177064f
Cred_4759 vin.$348.Metal1 vout.$1358.Metal3 0.00177064f
Cred_4760 vin.$348.Metal1 vout.P10.nSD 0.00208218f
Cred_4761 vin.$348.Metal1 vout.P10.pSD 0.00015108f
Cred_4762 vin.$348.Metal1 VSS.$18.Metal1 8.82963e-05f
Cred_4763 vin.$348.Metal1 VSS.$304.Metal1 0.00156417f
Cred_4764 vin.$348.Metal1 VSS.$314.Metal1 0.00393282f
Cred_4765 vin.$348.Metal1 VSS.$40.Metal1 3.42322e-05f
Cred_4766 vin.$348.Metal1 VSS.$551.Metal1 0.000351697f
Cred_4767 vin.$348.Metal1 VSS.$852.Metal2 7.49838e-05f
Cred_4768 vin.$348.Metal1 VSS.P0.pSD 0.0282647f
Cred_4769 vin.$353.Metal1 vout.$1292.Metal3 0.000552161f
Cred_4770 vin.$353.Metal1 vout.$1358.Metal3 0.000552161f
Cred_4771 vin.$353.Metal1 vout.P10.nSD 8.69878e-06f
Cred_4772 vin.$353.Metal1 vout.P10.pSD 0.000225563f
Cred_4773 vin.$353.Metal1 VSS.$1217.Metal3 2.30086e-08f
Cred_4774 vin.$353.Metal1 VSS.$1229.Metal3 2.30086e-08f
Cred_4775 vin.$353.Metal1 VSS.$314.Metal1 4.67566e-08f
Cred_4776 vin.$353.Metal1 VSS.$852.Metal2 5.83179e-06f
Cred_4777 vin.$353.Metal1 VSS.$867.Metal2 5.83179e-06f
Cred_4778 vin.$356.Metal1 vout.$1292.Metal3 4.46053e-05f
Cred_4779 vin.$356.Metal1 vout.$1358.Metal3 0.000127404f
Cred_4780 vin.$356.Metal1 vout.P10.nSD 1.11699e-06f
Cred_4781 vin.$356.Metal1 vout.P10.pSD 3.80595e-06f
Cred_4782 vin.$356.Metal1 vout.P12.nSD 4.14279e-07f
Cred_4783 vin.$356.Metal1 VSS.$18.Metal1 7.73077e-05f
Cred_4784 vin.$356.Metal1 VSS.$304.Metal1 4.71399e-05f
Cred_4785 vin.$356.Metal1 VSS.$314.Metal1 0.00224884f
Cred_4786 vin.$356.Metal1 VSS.$319.Metal1 0.0336271f
Cred_4787 vin.$356.Metal1 VSS.$40.Metal1 2.99719e-05f
Cred_4788 vin.$356.Metal1 VSS.$551.Metal1 0.000388529f
Cred_4789 vin.$356.Metal1 VSS.$852.Metal2 3.93834e-07f
Cred_4790 vin.$356.Metal1 VSS.$867.Metal2 0.00244689f
Cred_4791 vin.$356.Metal1 VSS.$875.Metal2 0.00073795f
Cred_4792 vin.$356.Metal1 VSS.P0.pSD 0.0277748f
Cred_4793 vin.$356.Metal1 VSS.P13.nSD 0.00125589f
Cred_4794 vin.$357.Metal1 vout.$1292.Metal3 4.50688e-06f
Cred_4795 vin.$357.Metal1 vout.$1358.Metal3 4.50688e-06f
Cred_4796 vin.$357.Metal1 vout.P10.nSD 7.10017e-08f
Cred_4797 vin.$357.Metal1 vout.P10.pSD 3.8455e-07f
Cred_4798 vin.$357.Metal1 VSS.$1217.Metal3 3.50978e-09f
Cred_4799 vin.$357.Metal1 VSS.$1229.Metal3 3.50978e-09f
Cred_4800 vin.$357.Metal1 VSS.$314.Metal1 7.13236e-09f
Cred_4801 vin.$357.Metal1 VSS.$852.Metal2 8.89596e-07f
Cred_4802 vin.$357.Metal1 VSS.$867.Metal2 8.89596e-07f
Cred_4803 vin.$36.GatPoly vout.$1226.Metal3 0.00167129f
Cred_4804 vin.$36.GatPoly vout.P0.nSD 3.93675e-06f
Cred_4805 vin.$36.GatPoly vout.P0.pSD 2.09193e-05f
Cred_4806 vin.$36.GatPoly vout.P2.nSD 7.32444e-06f
Cred_4807 vin.$36.GatPoly vout.P2.pSD 2.34058e-05f
Cred_4808 vin.$36.GatPoly vout.P4.nSD 0.00062515f
Cred_4809 vin.$36.GatPoly VSS.$142.Metal1 0.0122567f
Cred_4810 vin.$36.GatPoly VSS.$18.Metal1 0.000141333f
Cred_4811 vin.$36.GatPoly VSS.$40.Metal1 5.47942e-05f
Cred_4812 vin.$36.GatPoly VSS.$551.Metal1 3.61963e-06f
Cred_4813 vin.$36.GatPoly VSS.$685.Metal2 0.000741053f
Cred_4814 vin.$36.GatPoly VSS.$693.Metal2 0.000325023f
Cred_4815 vin.$36.GatPoly VSS.P0.pSD 0.00349216f
Cred_4816 vin.$36.GatPoly VSS.P5.nSD 0.000322917f
Cred_4817 vin.$360.Metal1 vout.$1292.Metal3 2.27983e-05f
Cred_4818 vin.$360.Metal1 vout.$1358.Metal3 7.80775e-05f
Cred_4819 vin.$360.Metal1 vout.P10.nSD 5.70908e-07f
Cred_4820 vin.$360.Metal1 vout.P10.pSD 1.94526e-06f
Cred_4821 vin.$360.Metal1 vout.P12.nSD 2.33483e-07f
Cred_4822 vin.$360.Metal1 VSS.$1229.Metal3 2.79789e-08f
Cred_4823 vin.$360.Metal1 VSS.$1238.Metal3 1.39336e-08f
Cred_4824 vin.$360.Metal1 VSS.$18.Metal1 6.84036e-05f
Cred_4825 vin.$360.Metal1 VSS.$319.Metal1 0.0374143f
Cred_4826 vin.$360.Metal1 VSS.$339.Metal1 0.00110293f
Cred_4827 vin.$360.Metal1 VSS.$349.Metal1 2.06118e-05f
Cred_4828 vin.$360.Metal1 VSS.$40.Metal1 2.65199e-05f
Cred_4829 vin.$360.Metal1 VSS.$551.Metal1 0.000458744f
Cred_4830 vin.$360.Metal1 VSS.$867.Metal2 0.00256413f
Cred_4831 vin.$360.Metal1 VSS.$875.Metal2 0.000781242f
Cred_4832 vin.$360.Metal1 VSS.$887.Metal2 5.44166e-06f
Cred_4833 vin.$360.Metal1 VSS.P0.pSD 0.0283481f
Cred_4834 vin.$360.Metal1 VSS.P13.nSD 0.00138166f
Cred_4835 vin.$365.Metal1 vout.$1292.Metal3 0.000362127f
Cred_4836 vin.$365.Metal1 vout.$1358.Metal3 0.00685533f
Cred_4837 vin.$365.Metal1 vout.P10.nSD 5.70497e-06f
Cred_4838 vin.$365.Metal1 vout.P10.pSD 8.8764e-05f
Cred_4839 vin.$365.Metal1 vout.P12.pSD 0.00410328f
Cred_4840 vin.$365.Metal1 VSS.$1229.Metal3 1.01465e-08f
Cred_4841 vin.$365.Metal1 VSS.$1238.Metal3 5.05301e-09f
Cred_4842 vin.$365.Metal1 VSS.$339.Metal1 1.53214e-08f
Cred_4843 vin.$365.Metal1 VSS.$875.Metal2 1.91093e-06f
Cred_4844 vin.$365.Metal1 VSS.$887.Metal2 1.91097e-06f
Cred_4845 vin.$368.Metal1 vout.$1292.Metal3 5.68137e-05f
Cred_4846 vin.$368.Metal1 vout.$1358.Metal3 0.0091883f
Cred_4847 vin.$368.Metal1 vout.P10.nSD 2.01437e-06f
Cred_4848 vin.$368.Metal1 vout.P10.pSD 4.84764e-06f
Cred_4849 vin.$368.Metal1 vout.P12.nSD 0.00715549f
Cred_4850 vin.$368.Metal1 VSS.$1229.Metal3 1.98307e-07f
Cred_4851 vin.$368.Metal1 VSS.$1238.Metal3 9.87577e-08f
Cred_4852 vin.$368.Metal1 VSS.$18.Metal1 7.97479e-05f
Cred_4853 vin.$368.Metal1 VSS.$319.Metal1 0.00431443f
Cred_4854 vin.$368.Metal1 VSS.$339.Metal1 0.0045486f
Cred_4855 vin.$368.Metal1 VSS.$349.Metal1 0.000539422f
Cred_4856 vin.$368.Metal1 VSS.$40.Metal1 3.0918e-05f
Cred_4857 vin.$368.Metal1 VSS.$551.Metal1 0.000705869f
Cred_4858 vin.$368.Metal1 VSS.$867.Metal2 0.000340307f
Cred_4859 vin.$368.Metal1 VSS.$875.Metal2 0.000144127f
Cred_4860 vin.$368.Metal1 VSS.$887.Metal2 4.18548e-05f
Cred_4861 vin.$368.Metal1 VSS.P0.pSD 0.0378745f
Cred_4862 vin.$368.Metal1 VSS.P13.nSD 0.000138973f
Cred_4863 vin.$369.Metal1 vout.$1292.Metal3 0.000467893f
Cred_4864 vin.$369.Metal1 vout.$1358.Metal3 0.0179161f
Cred_4865 vin.$369.Metal1 vout.P10.nSD 7.37122e-06f
Cred_4866 vin.$369.Metal1 vout.P10.pSD 0.000114689f
Cred_4867 vin.$369.Metal1 vout.P12.pSD 0.012068f
Cred_4868 vin.$369.Metal1 VSS.$1229.Metal3 3.04396e-08f
Cred_4869 vin.$369.Metal1 VSS.$1238.Metal3 1.5159e-08f
Cred_4870 vin.$369.Metal1 VSS.$339.Metal1 4.59643e-08f
Cred_4871 vin.$369.Metal1 VSS.$875.Metal2 5.73279e-06f
Cred_4872 vin.$369.Metal1 VSS.$887.Metal2 5.73291e-06f
Cred_4873 vin.$37.GatPoly vout.$1226.Metal3 0.0204947f
Cred_4874 vin.$37.GatPoly vout.P0.nSD 2.52351e-05f
Cred_4875 vin.$37.GatPoly vout.P0.pSD 0.000134095f
Cred_4876 vin.$37.GatPoly vout.P2.nSD 2.74525e-05f
Cred_4877 vin.$37.GatPoly vout.P2.pSD 0.000296144f
Cred_4878 vin.$37.GatPoly vout.P4.pSD 0.0116271f
Cred_4879 vin.$374.Metal1 vout.$1358.Metal3 0.0305661f
Cred_4880 vin.$374.Metal1 vout.$1424.Metal3 1.41849e-05f
Cred_4881 vin.$374.Metal1 vout.P12.nSD 0.0248093f
Cred_4882 vin.$374.Metal1 vout.P14.nSD 5.02935e-07f
Cred_4883 vin.$374.Metal1 vout.P14.pSD 1.21033e-06f
Cred_4884 vin.$374.Metal1 VSS.$18.Metal1 5.2305e-05f
Cred_4885 vin.$374.Metal1 VSS.$372.Metal1 8.96162e-05f
Cred_4886 vin.$374.Metal1 VSS.$40.Metal1 2.02785e-05f
Cred_4887 vin.$374.Metal1 VSS.$551.Metal1 0.000619056f
Cred_4888 vin.$374.Metal1 VSS.$905.Metal2 1.11422e-06f
Cred_4889 vin.$374.Metal1 VSS.$914.Metal2 2.93412e-05f
Cred_4890 vin.$374.Metal1 VSS.P0.pSD 0.0286924f
Cred_4891 vin.$374.Metal1 VSS.P15.nSD 7.44987e-07f
Cred_4892 vin.$375.Metal1 vout.$1358.Metal3 0.028582f
Cred_4893 vin.$375.Metal1 vout.P12.pSD 0.0258784f
Cred_4894 vin.$378.Metal1 vout.$1358.Metal3 0.00639125f
Cred_4895 vin.$378.Metal1 vout.$1424.Metal3 3.58721e-05f
Cred_4896 vin.$378.Metal1 vout.P12.nSD 0.00398011f
Cred_4897 vin.$378.Metal1 vout.P14.nSD 1.27187e-06f
Cred_4898 vin.$378.Metal1 vout.P14.pSD 3.06079e-06f
Cred_4899 vin.$378.Metal1 VSS.$18.Metal1 4.56484e-05f
Cred_4900 vin.$378.Metal1 VSS.$349.Metal1 0.00244297f
Cred_4901 vin.$378.Metal1 VSS.$361.Metal1 0.00268409f
Cred_4902 vin.$378.Metal1 VSS.$372.Metal1 0.00081905f
Cred_4903 vin.$378.Metal1 VSS.$40.Metal1 1.76977e-05f
Cred_4904 vin.$378.Metal1 VSS.$551.Metal1 0.000724146f
Cred_4905 vin.$378.Metal1 VSS.$899.Metal2 8.1619e-05f
Cred_4906 vin.$378.Metal1 VSS.$905.Metal2 3.30424e-06f
Cred_4907 vin.$378.Metal1 VSS.$914.Metal2 8.70118e-05f
Cred_4908 vin.$378.Metal1 VSS.P0.pSD 0.0289111f
Cred_4909 vin.$378.Metal1 VSS.P15.nSD 6.85337e-06f
Cred_4910 vin.$379.Metal1 vout.$1358.Metal3 0.00489855f
Cred_4911 vin.$379.Metal1 vout.P12.pSD 0.0023637f
Cred_4912 vin.$379.Metal1 VSS.$899.Metal2 9.73581e-06f
Cred_4913 vin.$383.Metal1 vout.$1358.Metal3 5.1486e-05f
Cred_4914 vin.$383.Metal1 vout.P12.pSD 2.72119e-06f
Cred_4915 vin.$383.Metal1 VSS.$899.Metal2 5.66036e-06f
Cred_4916 vin.$386.Metal1 vout.$1358.Metal3 2.42282e-05f
Cred_4917 vin.$386.Metal1 vout.P12.nSD 8.30937e-08f
Cred_4918 vin.$386.Metal1 VSS.$18.Metal1 5.17819e-05f
Cred_4919 vin.$386.Metal1 VSS.$349.Metal1 0.000651932f
Cred_4920 vin.$386.Metal1 VSS.$361.Metal1 0.00226359f
Cred_4921 vin.$386.Metal1 VSS.$372.Metal1 0.0455289f
Cred_4922 vin.$386.Metal1 VSS.$379.Metal1 0.000181938f
Cred_4923 vin.$386.Metal1 VSS.$40.Metal1 2.00757e-05f
Cred_4924 vin.$386.Metal1 VSS.$551.Metal1 0.00107688f
Cred_4925 vin.$386.Metal1 VSS.$899.Metal2 1.98775e-05f
Cred_4926 vin.$386.Metal1 VSS.$905.Metal2 3.73645e-05f
Cred_4927 vin.$386.Metal1 VSS.$914.Metal2 0.000985453f
Cred_4928 vin.$386.Metal1 VSS.P0.pSD 0.0373858f
Cred_4929 vin.$386.Metal1 VSS.P15.nSD 0.000431708f
Cred_4930 vin.$391.Metal1 vout.$1358.Metal3 1.44177e-05f
Cred_4931 vin.$391.Metal1 vout.$1424.Metal3 1.44177e-05f
Cred_4932 vin.$391.Metal1 vout.P14.nSD 2.27138e-07f
Cred_4933 vin.$391.Metal1 vout.P14.pSD 1.23019e-06f
Cred_4934 vin.$391.Metal1 VSS.$1250.Metal3 2.09857e-08f
Cred_4935 vin.$391.Metal1 VSS.$379.Metal1 2.09857e-08f
Cred_4936 vin.$391.Metal1 VSS.$914.Metal2 2.6174e-06f
Cred_4937 vin.$391.Metal1 VSS.$928.Metal2 2.6174e-06f
Cred_4938 vin.$392.Metal1 vout.$1358.Metal3 8.54771e-05f
Cred_4939 vin.$392.Metal1 vout.$1424.Metal3 8.54771e-05f
Cred_4940 vin.$392.Metal1 vout.P14.nSD 3.5024e-06f
Cred_4941 vin.$392.Metal1 vout.P14.pSD 7.29334e-06f
Cred_4942 vin.$392.Metal1 VSS.$1250.Metal3 2.54011e-07f
Cred_4943 vin.$392.Metal1 VSS.$18.Metal1 3.34027e-05f
Cred_4944 vin.$392.Metal1 VSS.$372.Metal1 0.0279878f
Cred_4945 vin.$392.Metal1 VSS.$379.Metal1 0.00203218f
Cred_4946 vin.$392.Metal1 VSS.$391.Metal1 0.000117423f
Cred_4947 vin.$392.Metal1 VSS.$40.Metal1 1.29501e-05f
Cred_4948 vin.$392.Metal1 VSS.$551.Metal1 0.000926715f
Cred_4949 vin.$392.Metal1 VSS.$905.Metal2 3.0232e-05f
Cred_4950 vin.$392.Metal1 VSS.$914.Metal2 0.000827791f
Cred_4951 vin.$392.Metal1 VSS.$928.Metal2 8.50648e-05f
Cred_4952 vin.$392.Metal1 VSS.P0.pSD 0.0277728f
Cred_4953 vin.$392.Metal1 VSS.P15.nSD 0.000258713f
Cred_4954 vin.$396.Metal1 vout.$1358.Metal3 0.000191108f
Cred_4955 vin.$396.Metal1 vout.$1424.Metal3 0.000191108f
Cred_4956 vin.$396.Metal1 vout.P14.nSD 0.000136936f
Cred_4957 vin.$396.Metal1 vout.P14.pSD 1.63063e-05f
Cred_4958 vin.$396.Metal1 VSS.$1250.Metal3 1.01446e-07f
Cred_4959 vin.$396.Metal1 VSS.$18.Metal1 2.05985e-05f
Cred_4960 vin.$396.Metal1 VSS.$372.Metal1 1.29688e-05f
Cred_4961 vin.$396.Metal1 VSS.$379.Metal1 0.00203176f
Cred_4962 vin.$396.Metal1 VSS.$391.Metal1 0.00177235f
Cred_4963 vin.$396.Metal1 VSS.$40.Metal1 7.98597e-06f
Cred_4964 vin.$396.Metal1 VSS.$551.Metal1 0.000720179f
Cred_4965 vin.$396.Metal1 VSS.$905.Metal2 2.90554e-06f
Cred_4966 vin.$396.Metal1 VSS.$914.Metal2 8.91651e-05f
Cred_4967 vin.$396.Metal1 VSS.$928.Metal2 0.000112776f
Cred_4968 vin.$396.Metal1 VSS.P0.pSD 0.0191766f
Cred_4969 vin.$396.Metal1 VSS.P15.nSD 9.00449e-08f
Cred_4970 vin.$397.Metal1 vout.$1358.Metal3 0.00583067f
Cred_4971 vin.$397.Metal1 vout.$1424.Metal3 0.00484166f
Cred_4972 vin.$397.Metal1 vout.P12.pSD 7.52168e-05f
Cred_4973 vin.$397.Metal1 vout.P14.nSD 7.62759e-05f
Cred_4974 vin.$397.Metal1 vout.P14.pSD 0.00643647f
Cred_4975 vin.$397.Metal1 VSS.$1250.Metal3 2.03739e-08f
Cred_4976 vin.$397.Metal1 VSS.$379.Metal1 2.03739e-08f
Cred_4977 vin.$397.Metal1 VSS.$914.Metal2 2.5411e-06f
Cred_4978 vin.$397.Metal1 VSS.$928.Metal2 2.5411e-06f
Cred_4979 vin.$400.Metal1 vout.$1358.Metal3 0.0125277f
Cred_4980 vin.$400.Metal1 vout.$1424.Metal3 0.0125277f
Cred_4981 vin.$400.Metal1 vout.P14.nSD 0.0213475f
Cred_4982 vin.$400.Metal1 vout.P14.pSD 0.00106892f
Cred_4983 vin.$400.Metal1 VSS.$1250.Metal3 2.39782e-08f
Cred_4984 vin.$400.Metal1 VSS.$18.Metal1 2.71954e-05f
Cred_4985 vin.$400.Metal1 VSS.$372.Metal1 1.74382e-06f
Cred_4986 vin.$400.Metal1 VSS.$379.Metal1 0.000216529f
Cred_4987 vin.$400.Metal1 VSS.$391.Metal1 0.000191504f
Cred_4988 vin.$400.Metal1 VSS.$40.Metal1 1.05436e-05f
Cred_4989 vin.$400.Metal1 VSS.$551.Metal1 0.00120255f
Cred_4990 vin.$400.Metal1 VSS.$905.Metal2 6.85678e-07f
Cred_4991 vin.$400.Metal1 VSS.$914.Metal2 2.10468e-05f
Cred_4992 vin.$400.Metal1 VSS.$928.Metal2 2.47564e-05f
Cred_4993 vin.$400.Metal1 VSS.P0.pSD 0.0283176f
Cred_4994 vin.$400.Metal1 VSS.P15.nSD 1.01979e-08f
Cred_4995 vin.$401.Metal1 vout.$1358.Metal3 0.0134931f
Cred_4996 vin.$401.Metal1 vout.$1424.Metal3 0.013102f
Cred_4997 vin.$401.Metal1 vout.P12.pSD 2.9743e-05f
Cred_4998 vin.$401.Metal1 vout.P14.nSD 0.00020641f
Cred_4999 vin.$401.Metal1 vout.P14.pSD 0.024051f
Cred_5000 vin.$408.Metal1 vout.$1358.Metal3 0.00867483f
Cred_5001 vin.$408.Metal1 vout.$1424.Metal3 0.00877126f
Cred_5002 vin.$408.Metal1 vout.P14.nSD 0.0138584f
Cred_5003 vin.$408.Metal1 vout.P14.pSD 0.00074018f
Cred_5004 vin.$408.Metal1 vout.P16.nSD 9.04262e-07f
Cred_5005 vin.$408.Metal1 VSS.$1256.Metal3 2.16982e-08f
Cred_5006 vin.$408.Metal1 VSS.$1265.Metal3 4.35704e-08f
Cred_5007 vin.$408.Metal1 VSS.$18.Metal1 2.50029e-05f
Cred_5008 vin.$408.Metal1 VSS.$391.Metal1 0.000712365f
Cred_5009 vin.$408.Metal1 VSS.$40.Metal1 9.69354e-06f
Cred_5010 vin.$408.Metal1 VSS.$401.Metal1 0.0019782f
Cred_5011 vin.$408.Metal1 VSS.$409.Metal1 0.000299078f
Cred_5012 vin.$408.Metal1 VSS.$551.Metal1 0.00138991f
Cred_5013 vin.$408.Metal1 VSS.$940.Metal2 1.41576e-05f
Cred_5014 vin.$408.Metal1 VSS.$952.Metal2 4.36338e-05f
Cred_5015 vin.$408.Metal1 VSS.$961.Metal2 8.03077e-05f
Cred_5016 vin.$408.Metal1 VSS.P0.pSD 0.0290456f
Cred_5017 vin.$408.Metal1 VSS.P17.nSD 9.86789e-06f
Cred_5018 vin.$409.Metal1 vout.$1358.Metal3 0.0105106f
Cred_5019 vin.$409.Metal1 vout.$1424.Metal3 0.0111449f
Cred_5020 vin.$409.Metal1 vout.P14.nSD 0.000165585f
Cred_5021 vin.$409.Metal1 vout.P14.pSD 0.0177979f
Cred_5022 vin.$409.Metal1 vout.P16.pSD 4.82395e-05f
Cred_5023 vin.$409.Metal1 VSS.$1256.Metal3 3.86655e-09f
Cred_5024 vin.$409.Metal1 VSS.$1265.Metal3 7.7641e-09f
Cred_5025 vin.$409.Metal1 VSS.$401.Metal1 1.17239e-08f
Cred_5026 vin.$409.Metal1 VSS.$940.Metal2 1.46227e-06f
Cred_5027 vin.$409.Metal1 VSS.$952.Metal2 1.46224e-06f
Cred_5028 vin.$412.Metal1 vout.$1358.Metal3 0.0003851f
Cred_5029 vin.$412.Metal1 vout.$1424.Metal3 0.000556666f
Cred_5030 vin.$412.Metal1 vout.P14.nSD 0.000336702f
Cred_5031 vin.$412.Metal1 vout.P14.pSD 3.28587e-05f
Cred_5032 vin.$412.Metal1 vout.P16.nSD 1.60876e-06f
Cred_5033 vin.$412.Metal1 VSS.$1256.Metal3 9.18001e-08f
Cred_5034 vin.$412.Metal1 VSS.$1265.Metal3 1.84336e-07f
Cred_5035 vin.$412.Metal1 VSS.$18.Metal1 2.20109e-05f
Cred_5036 vin.$412.Metal1 VSS.$40.Metal1 8.53357e-06f
Cred_5037 vin.$412.Metal1 VSS.$401.Metal1 0.00301769f
Cred_5038 vin.$412.Metal1 VSS.$409.Metal1 0.0116496f
Cred_5039 vin.$412.Metal1 VSS.$551.Metal1 0.00160778f
Cred_5040 vin.$412.Metal1 VSS.$940.Metal2 3.47174e-05f
Cred_5041 vin.$412.Metal1 VSS.$952.Metal2 0.000391622f
Cred_5042 vin.$412.Metal1 VSS.$961.Metal2 0.00080666f
Cred_5043 vin.$412.Metal1 VSS.P0.pSD 0.0291259f
Cred_5044 vin.$412.Metal1 VSS.P17.nSD 0.000426611f
Cred_5045 vin.$413.Metal1 vout.$1358.Metal3 0.00474942f
Cred_5046 vin.$413.Metal1 vout.$1424.Metal3 0.00587787f
Cred_5047 vin.$413.Metal1 vout.P14.nSD 7.48227e-05f
Cred_5048 vin.$413.Metal1 vout.P14.pSD 0.00672289f
Cred_5049 vin.$413.Metal1 vout.P16.pSD 8.5822e-05f
Cred_5050 vin.$413.Metal1 VSS.$1256.Metal3 1.63585e-08f
Cred_5051 vin.$413.Metal1 VSS.$1265.Metal3 3.28481e-08f
Cred_5052 vin.$413.Metal1 VSS.$401.Metal1 4.96011e-08f
Cred_5053 vin.$413.Metal1 VSS.$940.Metal2 6.18653e-06f
Cred_5054 vin.$413.Metal1 VSS.$952.Metal2 6.1864e-06f
Cred_5055 vin.$418.Metal1 VSS.$18.Metal1 1.88138e-05f
Cred_5056 vin.$418.Metal1 VSS.$40.Metal1 7.29405e-06f
Cred_5057 vin.$418.Metal1 VSS.$409.Metal1 0.0455148f
Cred_5058 vin.$418.Metal1 VSS.$551.Metal1 0.00173929f
Cred_5059 vin.$418.Metal1 VSS.$952.Metal2 0.00120752f
Cred_5060 vin.$418.Metal1 VSS.$961.Metal2 0.00275314f
Cred_5061 vin.$418.Metal1 VSS.P0.pSD 0.0278294f
Cred_5062 vin.$418.Metal1 VSS.P17.nSD 0.00171597f
Cred_5063 vin.$42.GatPoly vout.$1226.Metal3 0.00768088f
Cred_5064 vin.$42.GatPoly vout.P0.nSD 2.2128e-06f
Cred_5065 vin.$42.GatPoly vout.P0.pSD 1.17585e-05f
Cred_5066 vin.$42.GatPoly vout.P2.nSD 4.11698e-06f
Cred_5067 vin.$42.GatPoly vout.P2.pSD 1.31561e-05f
Cred_5068 vin.$42.GatPoly vout.P4.nSD 0.00541255f
Cred_5069 vin.$42.GatPoly VSS.$142.Metal1 0.000498602f
Cred_5070 vin.$42.GatPoly VSS.$18.Metal1 0.000118805f
Cred_5071 vin.$42.GatPoly VSS.$40.Metal1 4.60602e-05f
Cred_5072 vin.$42.GatPoly VSS.$551.Metal1 5.2146e-06f
Cred_5073 vin.$42.GatPoly VSS.$685.Metal2 0.000151842f
Cred_5074 vin.$42.GatPoly VSS.$693.Metal2 6.65975e-05f
Cred_5075 vin.$42.GatPoly VSS.P0.pSD 0.00389323f
Cred_5076 vin.$42.GatPoly VSS.P5.nSD 1.86578e-05f
Cred_5077 vin.$422.Metal1 vout.$1424.Metal3 0.000156366f
Cred_5078 vin.$422.Metal1 vout.P16.nSD 1.25776e-05f
Cred_5079 vin.$422.Metal1 VSS.$1265.Metal3 1.16526e-07f
Cred_5080 vin.$422.Metal1 VSS.$1277.Metal3 1.16526e-07f
Cred_5081 vin.$422.Metal1 VSS.$18.Metal1 1.14181e-05f
Cred_5082 vin.$422.Metal1 VSS.$40.Metal1 4.42677e-06f
Cred_5083 vin.$422.Metal1 VSS.$409.Metal1 0.0138169f
Cred_5084 vin.$422.Metal1 VSS.$426.Metal1 0.00194174f
Cred_5085 vin.$422.Metal1 VSS.$436.Metal1 5.99642e-09f
Cred_5086 vin.$422.Metal1 VSS.$551.Metal1 0.00133971f
Cred_5087 vin.$422.Metal1 VSS.$952.Metal2 0.00035596f
Cred_5088 vin.$422.Metal1 VSS.$961.Metal2 0.000842328f
Cred_5089 vin.$422.Metal1 VSS.$975.Metal2 5.01301e-05f
Cred_5090 vin.$422.Metal1 VSS.P0.pSD 0.0189011f
Cred_5091 vin.$422.Metal1 VSS.P17.nSD 0.000486954f
Cred_5092 vin.$423.Metal1 vout.$1424.Metal3 4.30176e-05f
Cred_5093 vin.$423.Metal1 VSS.$1265.Metal3 1.64348e-08f
Cred_5094 vin.$423.Metal1 VSS.$1277.Metal3 1.64348e-08f
Cred_5095 vin.$423.Metal1 VSS.$426.Metal1 3.33978e-08f
Cred_5096 vin.$423.Metal1 VSS.$961.Metal2 4.1656e-06f
Cred_5097 vin.$423.Metal1 VSS.$975.Metal2 4.1656e-06f
Cred_5098 vin.$426.Metal1 vout.$1424.Metal3 0.000731383f
Cred_5099 vin.$426.Metal1 vout.P16.nSD 8.97462e-05f
Cred_5100 vin.$426.Metal1 VSS.$1265.Metal3 1.23653e-07f
Cred_5101 vin.$426.Metal1 VSS.$1277.Metal3 1.23653e-07f
Cred_5102 vin.$426.Metal1 VSS.$18.Metal1 1.04987e-05f
Cred_5103 vin.$426.Metal1 VSS.$40.Metal1 4.07031e-06f
Cred_5104 vin.$426.Metal1 VSS.$409.Metal1 0.000146093f
Cred_5105 vin.$426.Metal1 VSS.$426.Metal1 0.00277761f
Cred_5106 vin.$426.Metal1 VSS.$436.Metal1 0.000874728f
Cred_5107 vin.$426.Metal1 VSS.$551.Metal1 0.00145244f
Cred_5108 vin.$426.Metal1 VSS.$952.Metal2 5.36333e-06f
Cred_5109 vin.$426.Metal1 VSS.$961.Metal2 4.39379e-05f
Cred_5110 vin.$426.Metal1 VSS.$975.Metal2 8.0625e-05f
Cred_5111 vin.$426.Metal1 VSS.P0.pSD 0.0187614f
Cred_5112 vin.$426.Metal1 VSS.P17.nSD 5.27073e-08f
Cred_5113 vin.$427.Metal1 vout.$1424.Metal3 0.0052059f
Cred_5114 vin.$427.Metal1 vout.P16.pSD 0.00356692f
Cred_5115 vin.$427.Metal1 VSS.$1265.Metal3 1.22208e-08f
Cred_5116 vin.$427.Metal1 VSS.$1277.Metal3 1.22208e-08f
Cred_5117 vin.$427.Metal1 VSS.$426.Metal1 2.48343e-08f
Cred_5118 vin.$427.Metal1 VSS.$961.Metal2 3.0975e-06f
Cred_5119 vin.$427.Metal1 VSS.$975.Metal2 3.0975e-06f
Cred_5120 vin.$43.GatPoly vout.$1226.Metal3 0.0293601f
Cred_5121 vin.$43.GatPoly vout.$1292.Metal3 0.000342861f
Cred_5122 vin.$43.GatPoly vout.P0.nSD 1.41843e-05f
Cred_5123 vin.$43.GatPoly vout.P0.pSD 7.53732e-05f
Cred_5124 vin.$43.GatPoly vout.P2.nSD 1.54307e-05f
Cred_5125 vin.$43.GatPoly vout.P2.pSD 0.000166459f
Cred_5126 vin.$43.GatPoly vout.P4.pSD 0.0194759f
Cred_5127 vin.$43.GatPoly vout.P6.nSD 5.40146e-06f
Cred_5128 vin.$43.GatPoly vout.P6.pSD 8.0157e-05f
Cred_5129 vin.$430.Metal1 vout.$1424.Metal3 0.025046f
Cred_5130 vin.$430.Metal1 vout.P16.nSD 0.0194654f
Cred_5131 vin.$430.Metal1 VSS.$1265.Metal3 6.36494e-08f
Cred_5132 vin.$430.Metal1 VSS.$1277.Metal3 6.36494e-08f
Cred_5133 vin.$430.Metal1 VSS.$18.Metal1 1.37992e-05f
Cred_5134 vin.$430.Metal1 VSS.$40.Metal1 5.34989e-06f
Cred_5135 vin.$430.Metal1 VSS.$409.Metal1 7.87832e-07f
Cred_5136 vin.$430.Metal1 VSS.$426.Metal1 0.000581246f
Cred_5137 vin.$430.Metal1 VSS.$436.Metal1 0.000232729f
Cred_5138 vin.$430.Metal1 VSS.$551.Metal1 0.00236796f
Cred_5139 vin.$430.Metal1 VSS.$952.Metal2 2.76072e-06f
Cred_5140 vin.$430.Metal1 VSS.$961.Metal2 2.24272e-05f
Cred_5141 vin.$430.Metal1 VSS.$975.Metal2 6.39343e-05f
Cred_5142 vin.$430.Metal1 VSS.P0.pSD 0.0272169f
Cred_5143 vin.$430.Metal1 VSS.P17.nSD 2.71306e-08f
Cred_5144 vin.$433.Metal1 vout.$1424.Metal3 0.0318466f
Cred_5145 vin.$433.Metal1 vout.P16.nSD 2.48653e-06f
Cred_5146 vin.$433.Metal1 vout.P16.pSD 0.0270409f
Cred_5147 vin.$437.Metal1 vout 8.51808e-05f
Cred_5148 vin.$437.Metal1 vout.$1424.Metal3 0.0203801f
Cred_5149 vin.$437.Metal1 vout.P16.nSD 0.0162333f
Cred_5150 vin.$437.Metal1 vout.P18.nSD 1.35085e-06f
Cred_5151 vin.$437.Metal1 VSS.$1002.Metal2 5.91341e-05f
Cred_5152 vin.$437.Metal1 VSS.$1010.Metal2 4.4036e-05f
Cred_5153 vin.$437.Metal1 VSS.$18.Metal1 1.20523e-05f
Cred_5154 vin.$437.Metal1 VSS.$40.Metal1 4.67262e-06f
Cred_5155 vin.$437.Metal1 VSS.$436.Metal1 0.000959611f
Cred_5156 vin.$437.Metal1 VSS.$448.Metal1 0.00108489f
Cred_5157 vin.$437.Metal1 VSS.$453.Metal1 0.000240007f
Cred_5158 vin.$437.Metal1 VSS.$551.Metal1 0.00263257f
Cred_5159 vin.$437.Metal1 VSS.$987.Metal2 8.01663e-06f
Cred_5160 vin.$437.Metal1 VSS.P0.pSD 0.0265515f
Cred_5161 vin.$437.Metal1 VSS.P19.nSD 8.98148e-06f
Cred_5162 vin.$44.GatPoly vout.$1226.Metal3 0.00818704f
Cred_5163 vin.$44.GatPoly vout.$1292.Metal3 0.000695219f
Cred_5164 vin.$44.GatPoly vout.P4.nSD 0.00338051f
Cred_5165 vin.$44.GatPoly vout.P6.nSD 2.46545e-05f
Cred_5166 vin.$44.GatPoly vout.P6.pSD 5.9858e-05f
Cred_5167 vin.$44.GatPoly VSS.$172.Metal1 9.4503e-09f
Cred_5168 vin.$44.GatPoly VSS.$18.Metal1 6.80704e-05f
Cred_5169 vin.$44.GatPoly VSS.$184.Metal1 1.63556e-07f
Cred_5170 vin.$44.GatPoly VSS.$195.Metal1 0.00535348f
Cred_5171 vin.$44.GatPoly VSS.$40.Metal1 2.63907e-05f
Cred_5172 vin.$44.GatPoly VSS.$551.Metal1 4.2592e-06f
Cred_5173 vin.$44.GatPoly VSS.$717.Metal2 7.89482e-11f
Cred_5174 vin.$44.GatPoly VSS.$732.Metal2 0.00145933f
Cred_5175 vin.$44.GatPoly VSS.$740.Metal2 5.54176e-05f
Cred_5176 vin.$44.GatPoly VSS.P0.pSD 0.00268209f
Cred_5177 vin.$44.GatPoly VSS.P7.nSD 4.45761e-05f
Cred_5178 vin.$440.Metal1 vout 0.00019061f
Cred_5179 vin.$440.Metal1 vout.$1424.Metal3 0.000968962f
Cred_5180 vin.$440.Metal1 vout.P16.nSD 0.000377049f
Cred_5181 vin.$440.Metal1 vout.P18.nSD 3.0228e-06f
Cred_5182 vin.$440.Metal1 VSS.$1002.Metal2 0.000604599f
Cred_5183 vin.$440.Metal1 VSS.$1010.Metal2 0.000422139f
Cred_5184 vin.$440.Metal1 VSS.$1283.Metal3 2.92843e-07f
Cred_5185 vin.$440.Metal1 VSS.$18.Metal1 1.06269e-05f
Cred_5186 vin.$440.Metal1 VSS.$40.Metal1 4.12e-06f
Cred_5187 vin.$440.Metal1 VSS.$436.Metal1 0.000264111f
Cred_5188 vin.$440.Metal1 VSS.$448.Metal1 0.00418705f
Cred_5189 vin.$440.Metal1 VSS.$453.Metal1 0.00932905f
Cred_5190 vin.$440.Metal1 VSS.$551.Metal1 0.00309327f
Cred_5191 vin.$440.Metal1 VSS.$987.Metal2 3.87306e-05f
Cred_5192 vin.$440.Metal1 VSS.P0.pSD 0.0266481f
Cred_5193 vin.$440.Metal1 VSS.P19.nSD 0.000343629f
Cred_5194 vin.$441.Metal1 vout.$1424.Metal3 0.00642161f
Cred_5195 vin.$441.Metal1 vout.P16.pSD 0.00459923f
Cred_5196 vin.$441.Metal1 VSS.$1002.Metal2 6.6757e-06f
Cred_5197 vin.$441.Metal1 VSS.$1283.Metal3 5.35242e-08f
Cred_5198 vin.$441.Metal1 VSS.$448.Metal1 5.35242e-08f
Cred_5199 vin.$441.Metal1 VSS.$987.Metal2 6.6757e-06f
Cred_5200 vin.$448.Metal1 vout 5.46805e-06f
Cred_5201 vin.$448.Metal1 vout.$1424.Metal3 9.88419e-06f
Cred_5202 vin.$448.Metal1 vout.P18.nSD 2.49171e-08f
Cred_5203 vin.$448.Metal1 VSS.$1002.Metal2 0.00255196f
Cred_5204 vin.$448.Metal1 VSS.$1010.Metal2 0.00189855f
Cred_5205 vin.$448.Metal1 VSS.$1016.Metal2 8.82139e-06f
Cred_5206 vin.$448.Metal1 VSS.$1283.Metal3 4.13169e-08f
Cred_5207 vin.$448.Metal1 VSS.$18.Metal1 1.18954e-05f
Cred_5208 vin.$448.Metal1 VSS.$40.Metal1 4.6118e-06f
Cred_5209 vin.$448.Metal1 VSS.$436.Metal1 1.4204e-05f
Cred_5210 vin.$448.Metal1 VSS.$448.Metal1 0.000577707f
Cred_5211 vin.$448.Metal1 VSS.$453.Metal1 0.0518779f
Cred_5212 vin.$448.Metal1 VSS.$476.Metal1 0.000397931f
Cred_5213 vin.$448.Metal1 VSS.$551.Metal1 0.00463409f
Cred_5214 vin.$448.Metal1 VSS.$987.Metal2 5.27182e-06f
Cred_5215 vin.$448.Metal1 VSS.P0.pSD 0.0339009f
Cred_5216 vin.$448.Metal1 VSS.P19.nSD 0.0019189f
Cred_5217 vin.$449.Metal1 vout.$1424.Metal3 9.88419e-06f
Cred_5218 vin.$449.Metal1 VSS.$1002.Metal2 9.41867e-07f
Cred_5219 vin.$449.Metal1 VSS.$1283.Metal3 7.55168e-09f
Cred_5220 vin.$449.Metal1 VSS.$448.Metal1 7.55168e-09f
Cred_5221 vin.$449.Metal1 VSS.$987.Metal2 9.41867e-07f
Cred_5222 vin.$453.Metal1 vout 1.11496e-05f
Cred_5223 vin.$453.Metal1 VSS.$1016.Metal2 2.04242e-06f
Cred_5224 vin.$456.Metal1 vout 0.0434047f
Cred_5225 vin.$456.Metal1 vout.$1424.Metal3 0.000149515f
Cred_5226 vin.$456.Metal1 vout.P16.nSD 1.40198e-06f
Cred_5227 vin.$456.Metal1 vout.P18.nSD 0.0329011f
Cred_5228 vin.$456.Metal1 VSS.$1002.Metal2 0.000418944f
Cred_5229 vin.$456.Metal1 VSS.$1010.Metal2 0.000320144f
Cred_5230 vin.$456.Metal1 VSS.$1016.Metal2 9.85515e-05f
Cred_5231 vin.$456.Metal1 VSS.$1028.Metal2 5.18709e-05f
Cred_5232 vin.$456.Metal1 VSS.$1040.Metal2 7.92781e-05f
Cred_5233 vin.$456.Metal1 VSS.$1066.Metal2 2.06305e-05f
Cred_5234 vin.$456.Metal1 VSS.$1301.Metal3 4.00461e-07f
Cred_5235 vin.$456.Metal1 VSS.$18.Metal1 2.31113e-05f
Cred_5236 vin.$456.Metal1 VSS.$40.Metal1 8.96017e-06f
Cred_5237 vin.$456.Metal1 VSS.$453.Metal1 0.00985618f
Cred_5238 vin.$456.Metal1 VSS.$476.Metal1 0.00457711f
Cred_5239 vin.$456.Metal1 VSS.$488.Metal1 0.00283344f
Cred_5240 vin.$456.Metal1 VSS.$498.Metal1 0.000592485f
Cred_5241 vin.$456.Metal1 VSS.$509.Metal1 0.000864049f
Cred_5242 vin.$456.Metal1 VSS.$551.Metal1 0.0177521f
Cred_5243 vin.$456.Metal1 VSS.P0.pSD 0.086021f
Cred_5244 vin.$456.Metal1 VSS.P1.GatPoly 0.00331878f
Cred_5245 vin.$456.Metal1 VSS.P19.nSD 0.000312041f
Cred_5246 vin.$456.Metal1 VSS.P21.nSD 5.79346e-06f
Cred_5247 vin.$456.Metal1 VSS.P23.nSD 5.79346e-06f
Cred_5248 vin.$457.Metal1 vout 0.0810898f
Cred_5249 vin.$457.Metal1 vout.P18.pSD 0.0640806f
Cred_5250 vin.$457.Metal1 VSS.$1016.Metal2 1.33892e-05f
Cred_5251 vin.$457.Metal1 VSS.$1028.Metal2 1.10732e-05f
Cred_5252 vin.$457.Metal1 VSS.$1040.Metal2 0.000804896f
Cred_5253 vin.$457.Metal1 VSS.$1055.Metal2 7.35644e-06f
Cred_5254 vin.$457.Metal1 VSS.$1301.Metal3 0.00206788f
Cred_5255 vin.$457.Metal1 VSS.$1313.Metal3 0.000471383f
Cred_5256 vin.$457.Metal1 VSS.$488.Metal1 8.87828e-08f
Cred_5257 vin.$457.Metal1 VSS.$498.Metal1 3.16845e-08f
Cred_5258 vin.$476.Metal2 vout.$1226.Metal3 0.10416f
Cred_5259 vin.$476.Metal2 vout.P0.nSD 0.025031f
Cred_5260 vin.$476.Metal2 vout.P0.pSD 0.0168875f
Cred_5261 vin.$476.Metal2 vout.P2.nSD 0.00164094f
Cred_5262 vin.$476.Metal2 vout.P2.pSD 0.00896811f
Cred_5263 vin.$476.Metal2 VSS.$1112.Metal3 2.51823e-05f
Cred_5264 vin.$476.Metal2 VSS.$1118.Metal3 8.2307e-06f
Cred_5265 vin.$476.Metal2 VSS.$18.Metal1 0.00327045f
Cred_5266 vin.$476.Metal2 VSS.$40.Metal1 0.00137251f
Cred_5267 vin.$476.Metal2 VSS.$551.Metal1 6.92227e-06f
Cred_5268 vin.$476.Metal2 VSS.$564.Metal2 2.4968e-06f
Cred_5269 vin.$476.Metal2 VSS.$605.Metal2 0.0046744f
Cred_5270 vin.$476.Metal2 VSS.$617.Metal2 0.00416759f
Cred_5271 vin.$476.Metal2 VSS.$629.Metal2 0.00102656f
Cred_5272 vin.$476.Metal2 VSS.$65.Metal1 7.56753e-05f
Cred_5273 vin.$476.Metal2 VSS.$75.Metal1 0.000384812f
Cred_5274 vin.$476.Metal2 VSS.$85.Metal1 0.000103387f
Cred_5275 vin.$476.Metal2 VSS.P0.GatPoly 0.000401654f
Cred_5276 vin.$476.Metal2 VSS.P0.nSD 7.01151e-07f
Cred_5277 vin.$476.Metal2 VSS.P0.pSD 0.0196754f
Cred_5278 vin.$476.Metal2 VSS.P1.nSD 7.01151e-07f
Cred_5279 vin.$478.Metal2 vout.$1226.Metal3 0.0949394f
Cred_5280 vin.$478.Metal2 vout.P0.nSD 0.00329068f
Cred_5281 vin.$478.Metal2 vout.P0.pSD 0.0436995f
Cred_5282 vin.$478.Metal2 vout.P2.nSD 0.00149568f
Cred_5283 vin.$478.Metal2 vout.P2.pSD 0.00817424f
Cred_5284 vin.$478.Metal2 VSS.$1100.Metal3 2.98682e-05f
Cred_5285 vin.$478.Metal2 VSS.$1112.Metal3 0.000136438f
Cred_5286 vin.$478.Metal2 VSS.$18.Metal1 6.08121e-05f
Cred_5287 vin.$478.Metal2 VSS.$40.Metal1 2.35766e-05f
Cred_5288 vin.$478.Metal2 VSS.$551.Metal1 8.47834e-08f
Cred_5289 vin.$478.Metal2 VSS.$590.Metal2 4.66126e-07f
Cred_5290 vin.$478.Metal2 VSS.$605.Metal2 0.000725827f
Cred_5291 vin.$478.Metal2 VSS.$617.Metal2 0.000675528f
Cred_5292 vin.$478.Metal2 VSS.$65.Metal1 2.00762e-09f
Cred_5293 vin.$478.Metal2 VSS.$75.Metal1 5.41623e-06f
Cred_5294 vin.$478.Metal2 VSS.P0.pSD 0.000283699f
Cred_5295 vin.$481.Metal2 vout.$1226.Metal3 0.0195992f
Cred_5296 vin.$481.Metal2 vout.P0.nSD 0.0039433f
Cred_5297 vin.$481.Metal2 vout.P0.pSD 0.00310119f
Cred_5298 vin.$481.Metal2 vout.P2.nSD 0.000308767f
Cred_5299 vin.$481.Metal2 vout.P2.pSD 0.00168748f
Cred_5300 vin.$481.Metal2 VSS.$1112.Metal3 5.28703e-09f
Cred_5301 vin.$481.Metal2 VSS.$1118.Metal3 6.52085e-06f
Cred_5302 vin.$481.Metal2 VSS.$18.Metal1 0.000460132f
Cred_5303 vin.$481.Metal2 VSS.$40.Metal1 0.000186454f
Cred_5304 vin.$481.Metal2 VSS.$551.Metal1 1.64932e-06f
Cred_5305 vin.$481.Metal2 VSS.$564.Metal2 1.92494e-07f
Cred_5306 vin.$481.Metal2 VSS.$605.Metal2 1.02748e-06f
Cred_5307 vin.$481.Metal2 VSS.$617.Metal2 0.000813976f
Cred_5308 vin.$481.Metal2 VSS.$629.Metal2 0.00956605f
Cred_5309 vin.$481.Metal2 VSS.$636.Metal2 8.0099e-07f
Cred_5310 vin.$481.Metal2 VSS.$644.Metal2 1.0594e-06f
Cred_5311 vin.$481.Metal2 VSS.$65.Metal1 5.52845e-06f
Cred_5312 vin.$481.Metal2 VSS.$75.Metal1 2.6421e-05f
Cred_5313 vin.$481.Metal2 VSS.$85.Metal1 2.44264e-05f
Cred_5314 vin.$481.Metal2 VSS.$97.Metal1 2.31332e-05f
Cred_5315 vin.$481.Metal2 VSS.P0.GatPoly 3.0966e-05f
Cred_5316 vin.$481.Metal2 VSS.P0.nSD 5.40561e-08f
Cred_5317 vin.$481.Metal2 VSS.P0.pSD 0.00387343f
Cred_5318 vin.$481.Metal2 VSS.P1.nSD 5.40561e-08f
Cred_5319 vin.$481.Metal2 VSS.P3.nSD 7.89645e-07f
Cred_5320 vin.$482.Metal2 vout.$1226.Metal3 0.0254198f
Cred_5321 vin.$482.Metal2 vout.P0.nSD 0.000840465f
Cred_5322 vin.$482.Metal2 vout.P0.pSD 0.00794985f
Cred_5323 vin.$482.Metal2 vout.P2.nSD 0.000400466f
Cred_5324 vin.$482.Metal2 vout.P2.pSD 0.00230973f
Cred_5325 vin.$482.Metal2 VSS.$629.Metal2 0.00163583f
Cred_5326 vin.$482.Metal2 VSS.$636.Metal2 0.00034325f
Cred_5327 vin.$482.Metal2 VSS.$644.Metal2 0.000460936f
Cred_5328 vin.$482.Metal2 VSS.$97.Metal1 6.96494e-05f
Cred_5329 vin.$482.Metal2 VSS.P3.nSD 2.4181e-06f
Cred_5330 vin.$483.Metal2 vout.$1226.Metal3 0.0162156f
Cred_5331 vin.$483.Metal2 vout.P0.nSD 0.000439822f
Cred_5332 vin.$483.Metal2 vout.P0.pSD 0.00205087f
Cred_5333 vin.$483.Metal2 vout.P2.nSD 0.000304736f
Cred_5334 vin.$483.Metal2 vout.P2.pSD 0.00139616f
Cred_5335 vin.$483.Metal2 VSS.$18.Metal1 0.000335017f
Cred_5336 vin.$483.Metal2 VSS.$40.Metal1 0.000129885f
Cred_5337 vin.$483.Metal2 VSS.$551.Metal1 1.85684e-06f
Cred_5338 vin.$483.Metal2 VSS.$629.Metal2 4.15252e-08f
Cred_5339 vin.$483.Metal2 VSS.$636.Metal2 0.0176518f
Cred_5340 vin.$483.Metal2 VSS.$644.Metal2 0.02209f
Cred_5341 vin.$483.Metal2 VSS.$85.Metal1 5.21097e-06f
Cred_5342 vin.$483.Metal2 VSS.$97.Metal1 0.00351774f
Cred_5343 vin.$483.Metal2 VSS.P0.pSD 0.00359887f
Cred_5344 vin.$483.Metal2 VSS.P3.nSD 0.000122507f
Cred_5345 vin.$486.Metal2 vout.$1226.Metal3 0.101058f
Cred_5346 vin.$486.Metal2 vout.P0.nSD 0.00249178f
Cred_5347 vin.$486.Metal2 vout.P0.pSD 0.0132747f
Cred_5348 vin.$486.Metal2 vout.P2.nSD 0.00161121f
Cred_5349 vin.$486.Metal2 vout.P2.pSD 0.00883102f
Cred_5350 vin.$486.Metal2 VSS.$18.Metal1 0.00425796f
Cred_5351 vin.$486.Metal2 VSS.$40.Metal1 0.0016508f
Cred_5352 vin.$486.Metal2 VSS.$551.Metal1 2.45374e-05f
Cred_5353 vin.$486.Metal2 VSS.$636.Metal2 0.00373561f
Cred_5354 vin.$486.Metal2 VSS.$644.Metal2 0.00501638f
Cred_5355 vin.$486.Metal2 VSS.$97.Metal1 0.000757997f
Cred_5356 vin.$486.Metal2 VSS.P0.pSD 0.0469239f
Cred_5357 vin.$486.Metal2 VSS.P3.nSD 2.63163e-05f
Cred_5358 vin.$488.Metal2 vout.$1226.Metal3 0.0238248f
Cred_5359 vin.$488.Metal2 vout.P0.nSD 0.000576056f
Cred_5360 vin.$488.Metal2 vout.P0.pSD 0.00267665f
Cred_5361 vin.$488.Metal2 vout.P2.nSD 0.000441506f
Cred_5362 vin.$488.Metal2 vout.P2.pSD 0.00205131f
Cred_5363 vin.$488.Metal2 VSS.$1130.Metal3 1.76299e-05f
Cred_5364 vin.$488.Metal2 VSS.$115.Metal1 2.89329e-05f
Cred_5365 vin.$488.Metal2 VSS.$127.Metal1 3.99604e-07f
Cred_5366 vin.$488.Metal2 VSS.$18.Metal1 0.000676104f
Cred_5367 vin.$488.Metal2 VSS.$40.Metal1 0.000262123f
Cred_5368 vin.$488.Metal2 VSS.$551.Metal1 4.20641e-06f
Cred_5369 vin.$488.Metal2 VSS.$636.Metal2 0.0198467f
Cred_5370 vin.$488.Metal2 VSS.$644.Metal2 0.0288501f
Cred_5371 vin.$488.Metal2 VSS.$658.Metal2 0.00219886f
Cred_5372 vin.$488.Metal2 VSS.$97.Metal1 0.00421978f
Cred_5373 vin.$488.Metal2 VSS.P0.pSD 0.00775151f
Cred_5374 vin.$488.Metal2 VSS.P3.nSD 0.00014708f
Cred_5375 vin.$489.Metal2 vout.$1226.Metal3 0.0292417f
Cred_5376 vin.$489.Metal2 vout.P0.nSD 0.000638335f
Cred_5377 vin.$489.Metal2 vout.P0.pSD 0.00389315f
Cred_5378 vin.$489.Metal2 vout.P2.nSD 0.000460675f
Cred_5379 vin.$489.Metal2 vout.P2.pSD 0.0029671f
Cred_5380 vin.$489.Metal2 VSS.$1130.Metal3 3.22231e-06f
Cred_5381 vin.$489.Metal2 VSS.$115.Metal1 3.22231e-06f
Cred_5382 vin.$489.Metal2 VSS.$636.Metal2 0.000991873f
Cred_5383 vin.$489.Metal2 VSS.$644.Metal2 0.00173384f
Cred_5384 vin.$489.Metal2 VSS.$658.Metal2 0.000401895f
Cred_5385 vin.$489.Metal2 VSS.$97.Metal1 0.000201262f
Cred_5386 vin.$489.Metal2 VSS.P3.nSD 6.98746e-06f
Cred_5387 vin.$492.Metal2 vout.$1226.Metal3 0.0328133f
Cred_5388 vin.$492.Metal2 vout.P0.nSD 0.000475188f
Cred_5389 vin.$492.Metal2 vout.P0.pSD 0.00252507f
Cred_5390 vin.$492.Metal2 vout.P2.nSD 0.00552853f
Cred_5391 vin.$492.Metal2 vout.P2.pSD 0.00285275f
Cred_5392 vin.$492.Metal2 VSS.$1130.Metal3 1.76295e-05f
Cred_5393 vin.$492.Metal2 VSS.$115.Metal1 2.36597e-05f
Cred_5394 vin.$492.Metal2 VSS.$127.Metal1 1.08442e-06f
Cred_5395 vin.$492.Metal2 VSS.$18.Metal1 0.000307235f
Cred_5396 vin.$492.Metal2 VSS.$40.Metal1 0.000119114f
Cred_5397 vin.$492.Metal2 VSS.$551.Metal1 2.71818e-06f
Cred_5398 vin.$492.Metal2 VSS.$636.Metal2 7.92869e-07f
Cred_5399 vin.$492.Metal2 VSS.$644.Metal2 0.00219987f
Cred_5400 vin.$492.Metal2 VSS.$658.Metal2 0.00769635f
Cred_5401 vin.$492.Metal2 VSS.$97.Metal1 2.15418e-05f
Cred_5402 vin.$492.Metal2 VSS.P0.pSD 0.0042993f
Cred_5403 vin.$492.Metal2 VSS.P3.nSD 7.92703e-07f
Cred_5404 vin.$493.Metal2 vout.$1226.Metal3 0.0543835f
Cred_5405 vin.$493.Metal2 vout.P0.nSD 0.000787558f
Cred_5406 vin.$493.Metal2 vout.P0.pSD 0.00418495f
Cred_5407 vin.$493.Metal2 vout.P2.nSD 0.0012399f
Cred_5408 vin.$493.Metal2 vout.P2.pSD 0.0167897f
Cred_5409 vin.$493.Metal2 VSS.$1130.Metal3 3.22223e-06f
Cred_5410 vin.$493.Metal2 VSS.$115.Metal1 3.22223e-06f
Cred_5411 vin.$493.Metal2 VSS.$644.Metal2 0.000401885f
Cred_5412 vin.$493.Metal2 VSS.$658.Metal2 0.000401885f
Cred_5413 vin.$495.Metal2 vout.$1226.Metal3 0.136443f
Cred_5414 vin.$495.Metal2 vout.P0.nSD 0.0019759f
Cred_5415 vin.$495.Metal2 vout.P0.pSD 0.0104996f
Cred_5416 vin.$495.Metal2 vout.P2.nSD 0.00420372f
Cred_5417 vin.$495.Metal2 vout.P2.pSD 0.0176915f
Cred_5418 vin.$495.Metal2 VSS.$18.Metal1 0.00302377f
Cred_5419 vin.$495.Metal2 VSS.$40.Metal1 0.0011723f
Cred_5420 vin.$495.Metal2 VSS.$551.Metal1 3.48868e-05f
Cred_5421 vin.$495.Metal2 VSS.$658.Metal2 0.00102137f
Cred_5422 vin.$495.Metal2 VSS.P0.pSD 0.0487393f
Cred_5423 vin.$497.Metal2 vout.$1226.Metal3 0.0839884f
Cred_5424 vin.$497.Metal2 vout.P0.nSD 0.00121628f
Cred_5425 vin.$497.Metal2 vout.P0.pSD 0.00646313f
Cred_5426 vin.$497.Metal2 vout.P2.nSD 0.0162933f
Cred_5427 vin.$497.Metal2 vout.P2.pSD 0.00765545f
Cred_5428 vin.$497.Metal2 VSS.$1136.Metal3 5.29692e-06f
Cred_5429 vin.$497.Metal2 VSS.$1148.Metal3 5.29692e-06f
Cred_5430 vin.$497.Metal2 VSS.$127.Metal1 1.11113e-06f
Cred_5431 vin.$497.Metal2 VSS.$137.Metal1 1.57269e-05f
Cred_5432 vin.$497.Metal2 VSS.$142.Metal1 6.55636e-05f
Cred_5433 vin.$497.Metal2 VSS.$18.Metal1 0.000708117f
Cred_5434 vin.$497.Metal2 VSS.$40.Metal1 0.000274535f
Cred_5435 vin.$497.Metal2 VSS.$551.Metal1 8.5404e-06f
Cred_5436 vin.$497.Metal2 VSS.$670.Metal2 0.00515882f
Cred_5437 vin.$497.Metal2 VSS.$685.Metal2 0.00186639f
Cred_5438 vin.$497.Metal2 VSS.$693.Metal2 0.000229748f
Cred_5439 vin.$497.Metal2 VSS.P0.pSD 0.0116319f
Cred_5440 vin.$497.Metal2 VSS.P5.nSD 2.25782e-06f
Cred_5441 vin.$500.Metal2 vout.$1226.Metal3 0.0489392f
Cred_5442 vin.$500.Metal2 vout.P0.nSD 0.000708716f
Cred_5443 vin.$500.Metal2 vout.P0.pSD 0.003766f
Cred_5444 vin.$500.Metal2 vout.P2.nSD 0.000901245f
Cred_5445 vin.$500.Metal2 vout.P2.pSD 0.0146189f
Cred_5446 vin.$500.Metal2 VSS.$1136.Metal3 1.50835e-06f
Cred_5447 vin.$500.Metal2 VSS.$1148.Metal3 1.50835e-06f
Cred_5448 vin.$500.Metal2 VSS.$137.Metal1 3.06517e-06f
Cred_5449 vin.$500.Metal2 VSS.$670.Metal2 0.00153936f
Cred_5450 vin.$500.Metal2 VSS.$685.Metal2 0.000382309f
Cred_5451 vin.$503.Metal2 vout.$1226.Metal3 0.0395382f
Cred_5452 vin.$503.Metal2 vout.P0.nSD 0.000373099f
Cred_5453 vin.$503.Metal2 vout.P0.pSD 0.00198258f
Cred_5454 vin.$503.Metal2 vout.P2.nSD 0.00162985f
Cred_5455 vin.$503.Metal2 vout.P2.pSD 0.00221824f
Cred_5456 vin.$503.Metal2 vout.P4.nSD 6.96264e-05f
Cred_5457 vin.$503.Metal2 VSS.$1136.Metal3 1.06945e-05f
Cred_5458 vin.$503.Metal2 VSS.$1148.Metal3 1.06945e-05f
Cred_5459 vin.$503.Metal2 VSS.$127.Metal1 5.50336e-07f
Cred_5460 vin.$503.Metal2 VSS.$137.Metal1 2.75255e-05f
Cred_5461 vin.$503.Metal2 VSS.$142.Metal1 0.00449268f
Cred_5462 vin.$503.Metal2 VSS.$18.Metal1 0.000422858f
Cred_5463 vin.$503.Metal2 VSS.$40.Metal1 0.000163941f
Cred_5464 vin.$503.Metal2 VSS.$551.Metal1 8.48434e-06f
Cred_5465 vin.$503.Metal2 VSS.$670.Metal2 0.00460082f
Cred_5466 vin.$503.Metal2 VSS.$685.Metal2 0.038458f
Cred_5467 vin.$503.Metal2 VSS.$693.Metal2 0.0156787f
Cred_5468 vin.$503.Metal2 VSS.P0.pSD 0.00913327f
Cred_5469 vin.$503.Metal2 VSS.P5.nSD 0.000156179f
Cred_5470 vin.$504.Metal2 vout.$1226.Metal3 0.0302342f
Cred_5471 vin.$504.Metal2 vout.P0.nSD 0.000242981f
Cred_5472 vin.$504.Metal2 vout.P0.pSD 0.00129116f
Cred_5473 vin.$504.Metal2 vout.P2.nSD 0.000264332f
Cred_5474 vin.$504.Metal2 vout.P2.pSD 0.00183321f
Cred_5475 vin.$504.Metal2 vout.P4.pSD 0.000388574f
Cred_5476 vin.$504.Metal2 VSS.$1136.Metal3 1.50835e-06f
Cred_5477 vin.$504.Metal2 VSS.$1148.Metal3 1.50835e-06f
Cred_5478 vin.$504.Metal2 VSS.$137.Metal1 3.06517e-06f
Cred_5479 vin.$504.Metal2 VSS.$142.Metal1 0.000127238f
Cred_5480 vin.$504.Metal2 VSS.$670.Metal2 0.000382309f
Cred_5481 vin.$504.Metal2 VSS.$685.Metal2 0.00140722f
Cred_5482 vin.$504.Metal2 VSS.$693.Metal2 0.000449523f
Cred_5483 vin.$504.Metal2 VSS.P5.nSD 4.41762e-06f
Cred_5484 vin.$506.Metal2 vout.$1226.Metal3 0.110189f
Cred_5485 vin.$506.Metal2 vout.P0.nSD 0.000723791f
Cred_5486 vin.$506.Metal2 vout.P0.pSD 0.0038461f
Cred_5487 vin.$506.Metal2 vout.P2.nSD 0.000795516f
Cred_5488 vin.$506.Metal2 vout.P2.pSD 0.00434808f
Cred_5489 vin.$506.Metal2 vout.P4.nSD 8.12535e-06f
Cred_5490 vin.$506.Metal2 vout.P4.pSD 4.48086e-05f
Cred_5491 vin.$506.Metal2 VSS.$142.Metal1 0.000695313f
Cred_5492 vin.$506.Metal2 VSS.$18.Metal1 0.00214719f
Cred_5493 vin.$506.Metal2 VSS.$40.Metal1 0.000832459f
Cred_5494 vin.$506.Metal2 VSS.$551.Metal1 4.9841e-05f
Cred_5495 vin.$506.Metal2 VSS.$685.Metal2 0.00560082f
Cred_5496 vin.$506.Metal2 VSS.$693.Metal2 0.0024565f
Cred_5497 vin.$506.Metal2 VSS.P0.pSD 0.0502526f
Cred_5498 vin.$506.Metal2 VSS.P5.nSD 2.41409e-05f
Cred_5499 vin.$508.Metal2 vout.$1226.Metal3 0.0173829f
Cred_5500 vin.$508.Metal2 vout.P0.nSD 5.46309e-05f
Cred_5501 vin.$508.Metal2 vout.P0.pSD 0.000290299f
Cred_5502 vin.$508.Metal2 vout.P2.nSD 7.66798e-05f
Cred_5503 vin.$508.Metal2 vout.P2.pSD 0.000324806f
Cred_5504 vin.$508.Metal2 vout.P4.nSD 1.72485e-05f
Cred_5505 vin.$508.Metal2 VSS.$1148.Metal3 1.19751e-05f
Cred_5506 vin.$508.Metal2 VSS.$1157.Metal3 5.96364e-06f
Cred_5507 vin.$508.Metal2 VSS.$142.Metal1 0.00295546f
Cred_5508 vin.$508.Metal2 VSS.$162.Metal1 1.96637e-05f
Cred_5509 vin.$508.Metal2 VSS.$18.Metal1 0.000249491f
Cred_5510 vin.$508.Metal2 VSS.$40.Metal1 9.6727e-05f
Cred_5511 vin.$508.Metal2 VSS.$551.Metal1 6.61522e-06f
Cred_5512 vin.$508.Metal2 VSS.$685.Metal2 0.0221092f
Cred_5513 vin.$508.Metal2 VSS.$693.Metal2 0.014709f
Cred_5514 vin.$508.Metal2 VSS.$705.Metal2 0.00225536f
Cred_5515 vin.$508.Metal2 VSS.P0.pSD 0.00624649f
Cred_5516 vin.$508.Metal2 VSS.P5.nSD 0.00010339f
Cred_5517 vin.$509.Metal2 vout.$1226.Metal3 0.0176074f
Cred_5518 vin.$509.Metal2 vout.P0.nSD 5.36857e-05f
Cred_5519 vin.$509.Metal2 vout.P0.pSD 0.000285277f
Cred_5520 vin.$509.Metal2 vout.P2.nSD 5.84031e-05f
Cred_5521 vin.$509.Metal2 vout.P2.pSD 0.000414306f
Cred_5522 vin.$509.Metal2 vout.P4.pSD 9.512e-05f
Cred_5523 vin.$509.Metal2 VSS.$1148.Metal3 2.13392e-06f
Cred_5524 vin.$509.Metal2 VSS.$1157.Metal3 1.0627e-06f
Cred_5525 vin.$509.Metal2 VSS.$142.Metal1 0.000107166f
Cred_5526 vin.$509.Metal2 VSS.$162.Metal1 3.22226e-06f
Cred_5527 vin.$509.Metal2 VSS.$685.Metal2 0.000863233f
Cred_5528 vin.$509.Metal2 VSS.$693.Metal2 0.0007805f
Cred_5529 vin.$509.Metal2 VSS.$705.Metal2 0.000401897f
Cred_5530 vin.$509.Metal2 VSS.P5.nSD 3.72075e-06f
Cred_5531 vin.$51.GatPoly vout.$1226.Metal3 0.0291867f
Cred_5532 vin.$51.GatPoly vout.$1292.Metal3 0.00143624f
Cred_5533 vin.$51.GatPoly vout.P4.pSD 0.0173231f
Cred_5534 vin.$51.GatPoly vout.P6.nSD 2.26266e-05f
Cred_5535 vin.$51.GatPoly vout.P6.pSD 0.000335776f
Cred_5536 vin.$51.GatPoly VSS.$1157.Metal3 1.19041e-10f
Cred_5537 vin.$51.GatPoly VSS.$1169.Metal3 1.19041e-10f
Cred_5538 vin.$51.GatPoly VSS.$184.Metal1 2.41908e-10f
Cred_5539 vin.$51.GatPoly VSS.$717.Metal2 3.01724e-08f
Cred_5540 vin.$51.GatPoly VSS.$732.Metal2 3.01724e-08f
Cred_5541 vin.$512.Metal2 vout.$1226.Metal3 0.0636257f
Cred_5542 vin.$512.Metal2 vout.P4.nSD 0.00836046f
Cred_5543 vin.$512.Metal2 vout.P4.pSD 0.000315093f
Cred_5544 vin.$512.Metal2 VSS.$1148.Metal3 1.19751e-05f
Cred_5545 vin.$512.Metal2 VSS.$1157.Metal3 5.96364e-06f
Cred_5546 vin.$512.Metal2 VSS.$142.Metal1 2.80403e-07f
Cred_5547 vin.$512.Metal2 VSS.$162.Metal1 1.96637e-05f
Cred_5548 vin.$512.Metal2 VSS.$18.Metal1 0.000170378f
Cred_5549 vin.$512.Metal2 VSS.$40.Metal1 6.60549e-05f
Cred_5550 vin.$512.Metal2 VSS.$551.Metal1 6.5338e-06f
Cred_5551 vin.$512.Metal2 VSS.$693.Metal2 0.00225531f
Cred_5552 vin.$512.Metal2 VSS.$705.Metal2 0.00481516f
Cred_5553 vin.$512.Metal2 VSS.P0.pSD 0.00517397f
Cred_5554 vin.$513.Metal2 vout.$1226.Metal3 0.0546131f
Cred_5555 vin.$513.Metal2 vout.P4.nSD 0.000316948f
Cred_5556 vin.$513.Metal2 vout.P4.pSD 0.0101691f
Cred_5557 vin.$513.Metal2 VSS.$1148.Metal3 2.13392e-06f
Cred_5558 vin.$513.Metal2 VSS.$1157.Metal3 1.0627e-06f
Cred_5559 vin.$513.Metal2 VSS.$162.Metal1 3.22226e-06f
Cred_5560 vin.$513.Metal2 VSS.$693.Metal2 0.000401889f
Cred_5561 vin.$513.Metal2 VSS.$705.Metal2 0.000401897f
Cred_5562 vin.$515.Metal2 vout.$1226.Metal3 0.152725f
Cred_5563 vin.$515.Metal2 vout.P4.nSD 0.00205354f
Cred_5564 vin.$515.Metal2 vout.P4.pSD 0.00224993f
Cred_5565 vin.$515.Metal2 VSS.$18.Metal1 0.00155528f
Cred_5566 vin.$515.Metal2 VSS.$40.Metal1 0.000602979f
Cred_5567 vin.$515.Metal2 VSS.$551.Metal1 7.2418e-05f
Cred_5568 vin.$515.Metal2 VSS.P0.pSD 0.0523967f
Cred_5569 vin.$517.Metal2 vout.$1226.Metal3 0.083543f
Cred_5570 vin.$517.Metal2 vout.P4.nSD 0.0126377f
Cred_5571 vin.$517.Metal2 vout.P4.pSD 0.000416805f
Cred_5572 vin.$517.Metal2 VSS.$1157.Metal3 3.24314e-06f
Cred_5573 vin.$517.Metal2 VSS.$1169.Metal3 3.24314e-06f
Cred_5574 vin.$517.Metal2 VSS.$172.Metal1 2.01144e-06f
Cred_5575 vin.$517.Metal2 VSS.$18.Metal1 0.000280319f
Cred_5576 vin.$517.Metal2 VSS.$184.Metal1 8.86453e-06f
Cred_5577 vin.$517.Metal2 VSS.$195.Metal1 0.000479279f
Cred_5578 vin.$517.Metal2 VSS.$40.Metal1 0.000108679f
Cred_5579 vin.$517.Metal2 VSS.$551.Metal1 1.41781e-05f
Cred_5580 vin.$517.Metal2 VSS.$717.Metal2 0.00636454f
Cred_5581 vin.$517.Metal2 VSS.$732.Metal2 0.00578466f
Cred_5582 vin.$517.Metal2 VSS.$740.Metal2 0.000188455f
Cred_5583 vin.$517.Metal2 VSS.P0.pSD 0.00981553f
Cred_5584 vin.$517.Metal2 VSS.P7.nSD 2.80283e-06f
Cred_5585 vin.$518.Metal2 vout.$1226.Metal3 0.0674487f
Cred_5586 vin.$518.Metal2 vout.P4.nSD 0.000381526f
Cred_5587 vin.$518.Metal2 vout.P4.pSD 0.0151329f
Cred_5588 vin.$52.GatPoly VSS.$172.Metal1 7.2267e-09f
Cred_5589 vin.$52.GatPoly VSS.$18.Metal1 6.5271e-05f
Cred_5590 vin.$52.GatPoly VSS.$184.Metal1 0.00251947f
Cred_5591 vin.$52.GatPoly VSS.$195.Metal1 0.00730333f
Cred_5592 vin.$52.GatPoly VSS.$202.Metal1 0.00271141f
Cred_5593 vin.$52.GatPoly VSS.$40.Metal1 2.53054e-05f
Cred_5594 vin.$52.GatPoly VSS.$551.Metal1 5.71091e-06f
Cred_5595 vin.$52.GatPoly VSS.$717.Metal2 6.03721e-11f
Cred_5596 vin.$52.GatPoly VSS.$732.Metal2 0.000170318f
Cred_5597 vin.$52.GatPoly VSS.$740.Metal2 5.6685e-06f
Cred_5598 vin.$52.GatPoly VSS.P0.pSD 0.00306157f
Cred_5599 vin.$52.GatPoly VSS.P7.nSD 6.47854e-05f
Cred_5600 vin.$520.Metal2 vout.$1226.Metal3 0.0192888f
Cred_5601 vin.$520.Metal2 vout.P4.pSD 0.000905053f
Cred_5602 vin.$520.Metal2 VSS.$1157.Metal3 1.08297e-06f
Cred_5603 vin.$520.Metal2 VSS.$1169.Metal3 1.08297e-06f
Cred_5604 vin.$520.Metal2 VSS.$184.Metal1 2.20074e-06f
Cred_5605 vin.$520.Metal2 VSS.$717.Metal2 0.00187043f
Cred_5606 vin.$520.Metal2 VSS.$732.Metal2 0.000274492f
Cred_5607 vin.$523.Metal2 vout.$1226.Metal3 0.0388372f
Cred_5608 vin.$523.Metal2 vout.$1292.Metal3 0.00946188f
Cred_5609 vin.$523.Metal2 vout.P4.nSD 0.000205686f
Cred_5610 vin.$523.Metal2 vout.P6.nSD 0.000241821f
Cred_5611 vin.$523.Metal2 vout.P6.pSD 0.000814663f
Cred_5612 vin.$523.Metal2 VSS.$1157.Metal3 6.54799e-06f
Cred_5613 vin.$523.Metal2 VSS.$1169.Metal3 6.54799e-06f
Cred_5614 vin.$523.Metal2 VSS.$172.Metal1 9.96213e-07f
Cred_5615 vin.$523.Metal2 VSS.$18.Metal1 0.000301657f
Cred_5616 vin.$523.Metal2 VSS.$184.Metal1 1.44327e-05f
Cred_5617 vin.$523.Metal2 VSS.$195.Metal1 0.00595593f
Cred_5618 vin.$523.Metal2 VSS.$40.Metal1 0.000116952f
Cred_5619 vin.$523.Metal2 VSS.$551.Metal1 2.52642e-05f
Cred_5620 vin.$523.Metal2 VSS.$717.Metal2 0.00440473f
Cred_5621 vin.$523.Metal2 VSS.$732.Metal2 0.0600004f
Cred_5622 vin.$523.Metal2 VSS.$740.Metal2 0.00221547f
Cred_5623 vin.$523.Metal2 VSS.P0.pSD 0.0137133f
Cred_5624 vin.$523.Metal2 VSS.P7.nSD 3.6094e-05f
Cred_5625 vin.$524.Metal2 vout.$1226.Metal3 0.031981f
Cred_5626 vin.$524.Metal2 vout.$1292.Metal3 0.00926035f
Cred_5627 vin.$524.Metal2 vout.P4.pSD 0.000516379f
Cred_5628 vin.$524.Metal2 vout.P6.nSD 0.000145888f
Cred_5629 vin.$524.Metal2 vout.P6.pSD 0.00131369f
Cred_5630 vin.$524.Metal2 VSS.$1157.Metal3 1.08297e-06f
Cred_5631 vin.$524.Metal2 VSS.$1169.Metal3 1.08297e-06f
Cred_5632 vin.$524.Metal2 VSS.$184.Metal1 2.20074e-06f
Cred_5633 vin.$524.Metal2 VSS.$195.Metal1 0.000130607f
Cred_5634 vin.$524.Metal2 VSS.$717.Metal2 0.000274492f
Cred_5635 vin.$524.Metal2 VSS.$732.Metal2 0.00162685f
Cred_5636 vin.$524.Metal2 VSS.$740.Metal2 5.13554e-05f
Cred_5637 vin.$524.Metal2 VSS.P7.nSD 7.63791e-07f
Cred_5638 vin.$526.Metal2 vout.$1226.Metal3 0.0833127f
Cred_5639 vin.$526.Metal2 vout.$1292.Metal3 0.026902f
Cred_5640 vin.$526.Metal2 vout.P4.nSD 8.8558e-07f
Cred_5641 vin.$526.Metal2 vout.P4.pSD 4.78883e-06f
Cred_5642 vin.$526.Metal2 vout.P6.nSD 0.000424702f
Cred_5643 vin.$526.Metal2 vout.P6.pSD 0.00232104f
Cred_5644 vin.$526.Metal2 VSS.$18.Metal1 0.00103621f
Cred_5645 vin.$526.Metal2 VSS.$195.Metal1 0.000730182f
Cred_5646 vin.$526.Metal2 VSS.$40.Metal1 0.000401736f
Cred_5647 vin.$526.Metal2 VSS.$551.Metal1 9.57554e-05f
Cred_5648 vin.$526.Metal2 VSS.$732.Metal2 0.0075606f
Cred_5649 vin.$526.Metal2 VSS.$740.Metal2 0.00128862f
Cred_5650 vin.$526.Metal2 VSS.P0.pSD 0.0497141f
Cred_5651 vin.$526.Metal2 VSS.P7.nSD 4.27011e-06f
Cred_5652 vin.$528.Metal2 vout.$1226.Metal3 0.0069343f
Cred_5653 vin.$528.Metal2 vout.$1292.Metal3 0.00640704f
Cred_5654 vin.$528.Metal2 vout.P4.nSD 1.35639e-06f
Cred_5655 vin.$528.Metal2 vout.P6.nSD 0.000126414f
Cred_5656 vin.$528.Metal2 vout.P6.pSD 0.000551644f
Cred_5657 vin.$528.Metal2 VSS.$18.Metal1 7.71331e-05f
Cred_5658 vin.$528.Metal2 VSS.$195.Metal1 0.00184818f
Cred_5659 vin.$528.Metal2 VSS.$202.Metal1 2.42007e-05f
Cred_5660 vin.$528.Metal2 VSS.$212.Metal1 9.84736e-06f
Cred_5661 vin.$528.Metal2 VSS.$40.Metal1 2.99042e-05f
Cred_5662 vin.$528.Metal2 VSS.$551.Metal1 9.64623e-06f
Cred_5663 vin.$528.Metal2 VSS.$732.Metal2 0.0189223f
Cred_5664 vin.$528.Metal2 VSS.$740.Metal2 0.00612f
Cred_5665 vin.$528.Metal2 VSS.$746.Metal2 0.00435848f
Cred_5666 vin.$528.Metal2 VSS.P0.pSD 0.00432979f
Cred_5667 vin.$528.Metal2 VSS.P7.nSD 1.08609e-05f
Cred_5668 vin.$529.Metal2 vout.$1226.Metal3 0.00709785f
Cred_5669 vin.$529.Metal2 vout.$1292.Metal3 0.00657656f
Cred_5670 vin.$529.Metal2 vout.P4.pSD 7.33479e-06f
Cred_5671 vin.$529.Metal2 vout.P6.nSD 0.000103608f
Cred_5672 vin.$529.Metal2 vout.P6.pSD 0.00093754f
Cred_5673 vin.$529.Metal2 VSS.$195.Metal1 4.95976e-06f
Cred_5674 vin.$529.Metal2 VSS.$732.Metal2 5.13554e-05f
Cred_5675 vin.$529.Metal2 VSS.$740.Metal2 1.95021e-06f
Cred_5676 vin.$529.Metal2 VSS.$746.Metal2 0.000810217f
Cred_5677 vin.$529.Metal2 VSS.P7.nSD 2.90047e-08f
Cred_5678 vin.$532.Metal2 vout.$1226.Metal3 0.0367708f
Cred_5679 vin.$532.Metal2 vout.$1292.Metal3 0.0367708f
Cred_5680 vin.$532.Metal2 vout.P6.nSD 0.0123175f
Cred_5681 vin.$532.Metal2 vout.P6.pSD 0.0035671f
Cred_5682 vin.$532.Metal2 VSS.$18.Metal1 0.000118794f
Cred_5683 vin.$532.Metal2 VSS.$195.Metal1 2.13459e-06f
Cred_5684 vin.$532.Metal2 VSS.$202.Metal1 6.75033e-06f
Cred_5685 vin.$532.Metal2 VSS.$212.Metal1 4.34561e-06f
Cred_5686 vin.$532.Metal2 VSS.$40.Metal1 4.60559e-05f
Cred_5687 vin.$532.Metal2 VSS.$551.Metal1 1.9483e-05f
Cred_5688 vin.$532.Metal2 VSS.$732.Metal2 4.61604e-08f
Cred_5689 vin.$532.Metal2 VSS.$740.Metal2 1.75293e-09f
Cred_5690 vin.$532.Metal2 VSS.$746.Metal2 0.00435831f
Cred_5691 vin.$532.Metal2 VSS.P0.pSD 0.00761288f
Cred_5692 vin.$532.Metal2 VSS.P7.nSD 1.79055e-08f
Cred_5693 vin.$533.Metal2 vout.$1226.Metal3 0.0341952f
Cred_5694 vin.$533.Metal2 vout.$1292.Metal3 0.0341952f
Cred_5695 vin.$533.Metal2 vout.P6.nSD 0.000924233f
Cred_5696 vin.$533.Metal2 vout.P6.pSD 0.0173673f
Cred_5697 vin.$533.Metal2 VSS.$746.Metal2 0.000810217f
Cred_5698 vin.$535.Metal2 vout.$1226.Metal3 0.0734189f
Cred_5699 vin.$535.Metal2 vout.$1292.Metal3 0.0734189f
Cred_5700 vin.$535.Metal2 vout.P6.nSD 0.00328536f
Cred_5701 vin.$535.Metal2 vout.P6.pSD 0.00867854f
Cred_5702 vin.$535.Metal2 VSS.$18.Metal1 0.000796359f
Cred_5703 vin.$535.Metal2 VSS.$40.Metal1 0.000308746f
Cred_5704 vin.$535.Metal2 VSS.$551.Metal1 0.000149382f
Cred_5705 vin.$535.Metal2 VSS.P0.pSD 0.0548318f
Cred_5706 vin.$537.Metal2 vout.$1226.Metal3 0.0303429f
Cred_5707 vin.$537.Metal2 vout.$1292.Metal3 0.0303429f
Cred_5708 vin.$537.Metal2 vout.P6.nSD 0.00966579f
Cred_5709 vin.$537.Metal2 vout.P6.pSD 0.00295353f
Cred_5710 vin.$537.Metal2 VSS.$1175.Metal3 5.94534e-06f
Cred_5711 vin.$537.Metal2 VSS.$1184.Metal3 1.19383e-05f
Cred_5712 vin.$537.Metal2 VSS.$18.Metal1 8.65577e-05f
Cred_5713 vin.$537.Metal2 VSS.$212.Metal1 3.57945e-07f
Cred_5714 vin.$537.Metal2 VSS.$224.Metal1 2.37908e-05f
Cred_5715 vin.$537.Metal2 VSS.$232.Metal1 9.74723e-06f
Cred_5716 vin.$537.Metal2 VSS.$40.Metal1 3.35581e-05f
Cred_5717 vin.$537.Metal2 VSS.$551.Metal1 1.79559e-05f
Cred_5718 vin.$537.Metal2 VSS.$758.Metal2 0.00423072f
Cred_5719 vin.$537.Metal2 VSS.$770.Metal2 0.00224857f
Cred_5720 vin.$537.Metal2 VSS.$779.Metal2 5.6286e-07f
Cred_5721 vin.$537.Metal2 VSS.P0.pSD 0.00624127f
Cred_5722 vin.$537.Metal2 VSS.P10.nSD 3.09677e-07f
Cred_5723 vin.$538.Metal2 vout.$1226.Metal3 0.0281663f
Cred_5724 vin.$538.Metal2 vout.$1292.Metal3 0.0281663f
Cred_5725 vin.$538.Metal2 vout.P6.nSD 0.000781345f
Cred_5726 vin.$538.Metal2 vout.P6.pSD 0.013718f
Cred_5727 vin.$538.Metal2 VSS.$1175.Metal3 1.06271e-06f
Cred_5728 vin.$538.Metal2 VSS.$1184.Metal3 2.13394e-06f
Cred_5729 vin.$538.Metal2 VSS.$224.Metal1 3.22228e-06f
Cred_5730 vin.$538.Metal2 VSS.$758.Metal2 0.0004019f
Cred_5731 vin.$538.Metal2 VSS.$770.Metal2 0.000401891f
Cred_5732 vin.$541.Metal2 vout.$1226.Metal3 0.00926624f
Cred_5733 vin.$541.Metal2 vout.$1292.Metal3 0.0191528f
Cred_5734 vin.$541.Metal2 vout.P6.nSD 0.000195658f
Cred_5735 vin.$541.Metal2 vout.P6.pSD 0.000797819f
Cred_5736 vin.$541.Metal2 vout.P8.nSD 4.04007e-05f
Cred_5737 vin.$541.Metal2 VSS.$1175.Metal3 5.94549e-06f
Cred_5738 vin.$541.Metal2 VSS.$1184.Metal3 1.19386e-05f
Cred_5739 vin.$541.Metal2 VSS.$18.Metal1 8.47509e-05f
Cred_5740 vin.$541.Metal2 VSS.$212.Metal1 5.79876e-07f
Cred_5741 vin.$541.Metal2 VSS.$224.Metal1 3.56663e-05f
Cred_5742 vin.$541.Metal2 VSS.$232.Metal1 0.00432635f
Cred_5743 vin.$541.Metal2 VSS.$40.Metal1 3.28577e-05f
Cred_5744 vin.$541.Metal2 VSS.$551.Metal1 2.78043e-05f
Cred_5745 vin.$541.Metal2 VSS.$758.Metal2 0.0022485f
Cred_5746 vin.$541.Metal2 VSS.$770.Metal2 0.0168846f
Cred_5747 vin.$541.Metal2 VSS.$779.Metal2 0.037431f
Cred_5748 vin.$541.Metal2 VSS.P0.pSD 0.00768425f
Cred_5749 vin.$541.Metal2 VSS.P10.nSD 0.000150461f
Cred_5750 vin.$542.Metal2 vout.$1226.Metal3 0.00635656f
Cred_5751 vin.$542.Metal2 vout.$1292.Metal3 0.00954455f
Cred_5752 vin.$542.Metal2 vout.P6.nSD 0.000100142f
Cred_5753 vin.$542.Metal2 vout.P6.pSD 0.000729225f
Cred_5754 vin.$542.Metal2 vout.P8.pSD 6.03461e-05f
Cred_5755 vin.$542.Metal2 VSS.$1175.Metal3 1.06271e-06f
Cred_5756 vin.$542.Metal2 VSS.$1184.Metal3 2.13394e-06f
Cred_5757 vin.$542.Metal2 VSS.$224.Metal1 3.22228e-06f
Cred_5758 vin.$542.Metal2 VSS.$232.Metal1 9.93277e-05f
Cred_5759 vin.$542.Metal2 VSS.$758.Metal2 0.0004019f
Cred_5760 vin.$542.Metal2 VSS.$770.Metal2 0.000669595f
Cred_5761 vin.$542.Metal2 VSS.$779.Metal2 0.00088765f
Cred_5762 vin.$542.Metal2 VSS.P10.nSD 3.44875e-06f
Cred_5763 vin.$544.Metal2 vout.$1226.Metal3 0.0297878f
Cred_5764 vin.$544.Metal2 vout.$1292.Metal3 0.0920643f
Cred_5765 vin.$544.Metal2 vout.P6.nSD 0.000490314f
Cred_5766 vin.$544.Metal2 vout.P6.pSD 0.00259613f
Cred_5767 vin.$544.Metal2 vout.P8.nSD 2.10351e-05f
Cred_5768 vin.$544.Metal2 vout.P8.pSD 3.14199e-05f
Cred_5769 vin.$544.Metal2 VSS.$18.Metal1 0.000542152f
Cred_5770 vin.$544.Metal2 VSS.$232.Metal1 0.00154554f
Cred_5771 vin.$544.Metal2 VSS.$40.Metal1 0.000210191f
Cred_5772 vin.$544.Metal2 VSS.$551.Metal1 0.000201898f
Cred_5773 vin.$544.Metal2 VSS.$770.Metal2 0.00513319f
Cred_5774 vin.$544.Metal2 VSS.$779.Metal2 0.013683f
Cred_5775 vin.$544.Metal2 VSS.P0.pSD 0.0527671f
Cred_5776 vin.$544.Metal2 VSS.P10.nSD 5.37248e-05f
Cred_5777 vin.$547.Metal2 vout.$1226.Metal3 0.00727116f
Cred_5778 vin.$547.Metal2 vout.$1292.Metal3 0.0283734f
Cred_5779 vin.$547.Metal2 vout.P6.nSD 0.00011455f
Cred_5780 vin.$547.Metal2 vout.P6.pSD 0.00106278f
Cred_5781 vin.$547.Metal2 vout.P8.pSD 0.000436736f
Cred_5782 vin.$547.Metal2 VSS.$1184.Metal3 1.39228e-06f
Cred_5783 vin.$547.Metal2 VSS.$1196.Metal3 1.39228e-06f
Cred_5784 vin.$547.Metal2 VSS.$232.Metal1 0.00011038f
Cred_5785 vin.$547.Metal2 VSS.$247.Metal1 2.82931e-06f
Cred_5786 vin.$547.Metal2 VSS.$770.Metal2 0.000297493f
Cred_5787 vin.$547.Metal2 VSS.$779.Metal2 0.00133931f
Cred_5788 vin.$547.Metal2 VSS.$793.Metal2 0.000352891f
Cred_5789 vin.$547.Metal2 VSS.P10.nSD 3.83251e-06f
Cred_5790 vin.$548.Metal2 vout.$1226.Metal3 0.00313208f
Cred_5791 vin.$548.Metal2 vout.$1292.Metal3 0.0304395f
Cred_5792 vin.$548.Metal2 vout.P6.nSD 8.22815e-05f
Cred_5793 vin.$548.Metal2 vout.P6.pSD 0.00026967f
Cred_5794 vin.$548.Metal2 vout.P8.nSD 0.00135898f
Cred_5795 vin.$548.Metal2 VSS.$1184.Metal3 1.4914e-05f
Cred_5796 vin.$548.Metal2 VSS.$1196.Metal3 1.4914e-05f
Cred_5797 vin.$548.Metal2 VSS.$18.Metal1 7.38636e-05f
Cred_5798 vin.$548.Metal2 VSS.$232.Metal1 0.00237309f
Cred_5799 vin.$548.Metal2 VSS.$247.Metal1 6.89183e-05f
Cred_5800 vin.$548.Metal2 VSS.$259.Metal1 8.0936e-07f
Cred_5801 vin.$548.Metal2 VSS.$40.Metal1 2.86367e-05f
Cred_5802 vin.$548.Metal2 VSS.$551.Metal1 3.27912e-05f
Cred_5803 vin.$548.Metal2 VSS.$770.Metal2 0.00631225f
Cred_5804 vin.$548.Metal2 VSS.$779.Metal2 0.0247102f
Cred_5805 vin.$548.Metal2 VSS.$793.Metal2 0.0070235f
Cred_5806 vin.$548.Metal2 VSS.P0.pSD 0.00782701f
Cred_5807 vin.$548.Metal2 VSS.P10.nSD 8.253e-05f
Cred_5808 vin.$551.Metal2 vout.$1292.Metal3 0.0568342f
Cred_5809 vin.$551.Metal2 vout.P8.pSD 0.00997748f
Cred_5810 vin.$551.Metal2 VSS.$1184.Metal3 1.39228e-06f
Cred_5811 vin.$551.Metal2 VSS.$1196.Metal3 1.39228e-06f
Cred_5812 vin.$551.Metal2 VSS.$247.Metal1 2.82931e-06f
Cred_5813 vin.$551.Metal2 VSS.$779.Metal2 0.000352891f
Cred_5814 vin.$551.Metal2 VSS.$793.Metal2 0.00162964f
Cred_5815 vin.$552.Metal2 vout.$1292.Metal3 0.0882989f
Cred_5816 vin.$552.Metal2 vout.P8.nSD 0.0139987f
Cred_5817 vin.$552.Metal2 VSS.$18.Metal1 7.33464e-05f
Cred_5818 vin.$552.Metal2 VSS.$259.Metal1 5.45549e-07f
Cred_5819 vin.$552.Metal2 VSS.$269.Metal1 1.08391e-06f
Cred_5820 vin.$552.Metal2 VSS.$40.Metal1 2.84362e-05f
Cred_5821 vin.$552.Metal2 VSS.$551.Metal1 5.49782e-05f
Cred_5822 vin.$552.Metal2 VSS.$793.Metal2 0.00324337f
Cred_5823 vin.$552.Metal2 VSS.$805.Metal2 4.55803e-09f
Cred_5824 vin.$552.Metal2 VSS.P0.pSD 0.0101075f
Cred_5825 vin.$555.Metal2 vout.$1292.Metal3 0.163312f
Cred_5826 vin.$555.Metal2 vout.P8.nSD 0.00196358f
Cred_5827 vin.$555.Metal2 vout.P8.pSD 0.00581508f
Cred_5828 vin.$555.Metal2 VSS.$18.Metal1 0.000383693f
Cred_5829 vin.$555.Metal2 VSS.$40.Metal1 0.000148756f
Cred_5830 vin.$555.Metal2 VSS.$551.Metal1 0.000285427f
Cred_5831 vin.$555.Metal2 VSS.$805.Metal2 0.00109768f
Cred_5832 vin.$555.Metal2 VSS.P0.pSD 0.0528964f
Cred_5833 vin.$557.Metal2 vout.$1292.Metal3 0.0441032f
Cred_5834 vin.$557.Metal2 vout.P8.nSD 0.00598206f
Cred_5835 vin.$557.Metal2 VSS 1.01234e-05f
Cred_5836 vin.$557.Metal2 VSS.$1196.Metal3 7.58242e-06f
Cred_5837 vin.$557.Metal2 VSS.$18.Metal1 3.29315e-05f
Cred_5838 vin.$557.Metal2 VSS.$259.Metal1 2.92434e-06f
Cred_5839 vin.$557.Metal2 VSS.$269.Metal1 3.75671e-05f
Cred_5840 vin.$557.Metal2 VSS.$275.Metal1 5.23132e-06f
Cred_5841 vin.$557.Metal2 VSS.$285.Metal1 2.62616e-06f
Cred_5842 vin.$557.Metal2 VSS.$40.Metal1 1.27675e-05f
Cred_5843 vin.$557.Metal2 VSS.$551.Metal1 3.14688e-05f
Cred_5844 vin.$557.Metal2 VSS.$805.Metal2 0.00656263f
Cred_5845 vin.$557.Metal2 VSS.$818.Metal2 0.00223647f
Cred_5846 vin.$557.Metal2 VSS.$826.Metal2 2.42256e-07f
Cred_5847 vin.$557.Metal2 VSS.P0.pSD 0.00514536f
Cred_5848 vin.$557.Metal2 VSS.P11.nSD 2.06371e-07f
Cred_5849 vin.$558.Metal2 vout.$1292.Metal3 0.0688856f
Cred_5850 vin.$558.Metal2 vout.P8.nSD 0.000258514f
Cred_5851 vin.$558.Metal2 vout.P8.pSD 0.0134711f
Cred_5852 vin.$558.Metal2 VSS 1.81941e-06f
Cred_5853 vin.$558.Metal2 VSS.$1196.Metal3 1.36274e-06f
Cred_5854 vin.$558.Metal2 VSS.$269.Metal1 3.22231e-06f
Cred_5855 vin.$558.Metal2 VSS.$805.Metal2 0.000401907f
Cred_5856 vin.$558.Metal2 VSS.$818.Metal2 0.000401903f
Cred_5857 vin.$561.Metal2 vout.$1292.Metal3 0.0245685f
Cred_5858 vin.$561.Metal2 vout.$1358.Metal3 0.00529631f
Cred_5859 vin.$561.Metal2 vout.P10.nSD 0.000147194f
Cred_5860 vin.$561.Metal2 vout.P10.pSD 0.000451908f
Cred_5861 vin.$561.Metal2 vout.P8.nSD 6.37557e-05f
Cred_5862 vin.$561.Metal2 VSS 1.01235e-05f
Cred_5863 vin.$561.Metal2 VSS.$1196.Metal3 7.58252e-06f
Cred_5864 vin.$561.Metal2 VSS.$18.Metal1 4.3898e-05f
Cred_5865 vin.$561.Metal2 VSS.$269.Metal1 3.48723e-05f
Cred_5866 vin.$561.Metal2 VSS.$275.Metal1 0.00187114f
Cred_5867 vin.$561.Metal2 VSS.$285.Metal1 0.00186795f
Cred_5868 vin.$561.Metal2 VSS.$40.Metal1 1.70191e-05f
Cred_5869 vin.$561.Metal2 VSS.$551.Metal1 5.82717e-05f
Cred_5870 vin.$561.Metal2 VSS.$805.Metal2 0.00223628f
Cred_5871 vin.$561.Metal2 VSS.$818.Metal2 0.0236664f
Cred_5872 vin.$561.Metal2 VSS.$826.Metal2 0.0214302f
Cred_5873 vin.$561.Metal2 VSS.P0.pSD 0.00806933f
Cred_5874 vin.$561.Metal2 VSS.P11.nSD 0.000133958f
Cred_5875 vin.$562.Metal2 vout.$1292.Metal3 0.0235855f
Cred_5876 vin.$562.Metal2 vout.$1358.Metal3 0.00487651f
Cred_5877 vin.$562.Metal2 vout.P10.nSD 7.68249e-05f
Cred_5878 vin.$562.Metal2 vout.P10.pSD 0.000770605f
Cred_5879 vin.$562.Metal2 vout.P8.pSD 0.000342097f
Cred_5880 vin.$562.Metal2 VSS 1.81941e-06f
Cred_5881 vin.$562.Metal2 VSS.$1196.Metal3 1.36274e-06f
Cred_5882 vin.$562.Metal2 VSS.$269.Metal1 3.22231e-06f
Cred_5883 vin.$562.Metal2 VSS.$275.Metal1 7.23493e-05f
Cred_5884 vin.$562.Metal2 VSS.$285.Metal1 7.23493e-05f
Cred_5885 vin.$562.Metal2 VSS.$805.Metal2 0.000401907f
Cred_5886 vin.$562.Metal2 VSS.$818.Metal2 0.00123967f
Cred_5887 vin.$562.Metal2 VSS.$826.Metal2 0.000837769f
Cred_5888 vin.$562.Metal2 VSS.P11.nSD 5.1838e-06f
Cred_5889 vin.$564.Metal2 vout.$1292.Metal3 0.0927825f
Cred_5890 vin.$564.Metal2 vout.$1358.Metal3 0.0298845f
Cred_5891 vin.$564.Metal2 vout.P10.nSD 0.000492406f
Cred_5892 vin.$564.Metal2 vout.P10.pSD 0.00267003f
Cred_5893 vin.$564.Metal2 vout.P8.nSD 2.16032e-05f
Cred_5894 vin.$564.Metal2 vout.P8.pSD 0.000115917f
Cred_5895 vin.$564.Metal2 VSS.$18.Metal1 0.000272908f
Cred_5896 vin.$564.Metal2 VSS.$275.Metal1 0.000372483f
Cred_5897 vin.$564.Metal2 VSS.$285.Metal1 0.000372483f
Cred_5898 vin.$564.Metal2 VSS.$40.Metal1 0.000105806f
Cred_5899 vin.$564.Metal2 VSS.$551.Metal1 0.000403628f
Cred_5900 vin.$564.Metal2 VSS.$818.Metal2 0.00431316f
Cred_5901 vin.$564.Metal2 VSS.$826.Metal2 0.00431316f
Cred_5902 vin.$564.Metal2 VSS.P0.pSD 0.0530119f
Cred_5903 vin.$564.Metal2 VSS.P11.nSD 2.66882e-05f
Cred_5904 vin.$566.Metal2 vout.$1292.Metal3 0.0203004f
Cred_5905 vin.$566.Metal2 vout.$1358.Metal3 0.00917239f
Cred_5906 vin.$566.Metal2 vout.P10.nSD 0.000208258f
Cred_5907 vin.$566.Metal2 vout.P10.pSD 0.000782635f
Cred_5908 vin.$566.Metal2 vout.P8.nSD 6.37557e-05f
Cred_5909 vin.$566.Metal2 VSS 1.01229e-05f
Cred_5910 vin.$566.Metal2 VSS.$1217.Metal3 7.58209e-06f
Cred_5911 vin.$566.Metal2 VSS.$18.Metal1 3.96803e-05f
Cred_5912 vin.$566.Metal2 VSS.$275.Metal1 0.00194042f
Cred_5913 vin.$566.Metal2 VSS.$285.Metal1 0.00194108f
Cred_5914 vin.$566.Metal2 VSS.$294.Metal1 2.14214e-05f
Cred_5915 vin.$566.Metal2 VSS.$40.Metal1 1.53839e-05f
Cred_5916 vin.$566.Metal2 VSS.$551.Metal1 6.57797e-05f
Cred_5917 vin.$566.Metal2 VSS.$818.Metal2 0.0207387f
Cred_5918 vin.$566.Metal2 VSS.$826.Metal2 0.0229749f
Cred_5919 vin.$566.Metal2 VSS.$840.Metal2 0.00223615f
Cred_5920 vin.$566.Metal2 VSS.P0.pSD 0.0081514f
Cred_5921 vin.$566.Metal2 VSS.P11.nSD 0.000140204f
Cred_5922 vin.$567.Metal2 vout.$1292.Metal3 0.0193176f
Cred_5923 vin.$567.Metal2 vout.$1358.Metal3 0.00875259f
Cred_5924 vin.$567.Metal2 vout.P10.nSD 0.000137889f
Cred_5925 vin.$567.Metal2 vout.P10.pSD 0.00110133f
Cred_5926 vin.$567.Metal2 vout.P8.pSD 0.000342097f
Cred_5927 vin.$567.Metal2 VSS 1.81941e-06f
Cred_5928 vin.$567.Metal2 VSS.$1217.Metal3 1.36274e-06f
Cred_5929 vin.$567.Metal2 VSS.$275.Metal1 7.23493e-05f
Cred_5930 vin.$567.Metal2 VSS.$285.Metal1 7.23493e-05f
Cred_5931 vin.$567.Metal2 VSS.$294.Metal1 3.22231e-06f
Cred_5932 vin.$567.Metal2 VSS.$818.Metal2 0.000837769f
Cred_5933 vin.$567.Metal2 VSS.$826.Metal2 0.00123967f
Cred_5934 vin.$567.Metal2 VSS.$840.Metal2 0.000401907f
Cred_5935 vin.$567.Metal2 VSS.P11.nSD 5.1838e-06f
Cred_5936 vin.$57.GatPoly vout.$1226.Metal3 0.0315818f
Cred_5937 vin.$57.GatPoly vout.$1292.Metal3 0.0256747f
Cred_5938 vin.$57.GatPoly vout.P4.pSD 0.00041507f
Cred_5939 vin.$57.GatPoly vout.P6.nSD 0.000404481f
Cred_5940 vin.$57.GatPoly vout.P6.pSD 0.0362094f
Cred_5941 vin.$570.Metal2 vout.$1292.Metal3 0.0209907f
Cred_5942 vin.$570.Metal2 vout.$1358.Metal3 0.0209907f
Cred_5943 vin.$570.Metal2 vout.P10.nSD 0.00631275f
Cred_5944 vin.$570.Metal2 vout.P10.pSD 0.00179103f
Cred_5945 vin.$570.Metal2 VSS 1.01229e-05f
Cred_5946 vin.$570.Metal2 VSS.$1217.Metal3 7.58209e-06f
Cred_5947 vin.$570.Metal2 VSS.$18.Metal1 2.09171e-05f
Cred_5948 vin.$570.Metal2 VSS.$285.Metal1 6.58078e-07f
Cred_5949 vin.$570.Metal2 VSS.$294.Metal1 2.72316e-05f
Cred_5950 vin.$570.Metal2 VSS.$304.Metal1 2.92434e-06f
Cred_5951 vin.$570.Metal2 VSS.$40.Metal1 8.10949e-06f
Cred_5952 vin.$570.Metal2 VSS.$551.Metal1 4.83529e-05f
Cred_5953 vin.$570.Metal2 VSS.$826.Metal2 0.00223613f
Cred_5954 vin.$570.Metal2 VSS.$840.Metal2 0.00656253f
Cred_5955 vin.$570.Metal2 VSS.P0.pSD 0.00508203f
Cred_5956 vin.$571.Metal2 vout.$1292.Metal3 0.0329293f
Cred_5957 vin.$571.Metal2 vout.$1358.Metal3 0.0329293f
Cred_5958 vin.$571.Metal2 vout.P10.nSD 0.000777284f
Cred_5959 vin.$571.Metal2 vout.P10.pSD 0.0166069f
Cred_5960 vin.$571.Metal2 VSS 1.81941e-06f
Cred_5961 vin.$571.Metal2 VSS.$1217.Metal3 1.36274e-06f
Cred_5962 vin.$571.Metal2 VSS.$294.Metal1 3.22231e-06f
Cred_5963 vin.$571.Metal2 VSS.$826.Metal2 0.000401903f
Cred_5964 vin.$571.Metal2 VSS.$840.Metal2 0.000401907f
Cred_5965 vin.$573.Metal2 vout.$1292.Metal3 0.0781775f
Cred_5966 vin.$573.Metal2 vout.$1358.Metal3 0.0781775f
Cred_5967 vin.$573.Metal2 vout.P10.nSD 0.00319519f
Cred_5968 vin.$573.Metal2 vout.P10.pSD 0.0124742f
Cred_5969 vin.$573.Metal2 VSS.$18.Metal1 0.00019226f
Cred_5970 vin.$573.Metal2 VSS.$40.Metal1 7.45388e-05f
Cred_5971 vin.$573.Metal2 VSS.$551.Metal1 0.000569618f
Cred_5972 vin.$573.Metal2 VSS.$840.Metal2 0.00109768f
Cred_5973 vin.$573.Metal2 VSS.P0.pSD 0.0528779f
Cred_5974 vin.$575.Metal2 vout.$1292.Metal3 0.0427233f
Cred_5975 vin.$575.Metal2 vout.$1358.Metal3 0.0427233f
Cred_5976 vin.$575.Metal2 vout.P10.nSD 0.0151074f
Cred_5977 vin.$575.Metal2 vout.P10.pSD 0.00364537f
Cred_5978 vin.$575.Metal2 VSS.$18.Metal1 3.70327e-05f
Cred_5979 vin.$575.Metal2 VSS.$294.Metal1 1.08391e-06f
Cred_5980 vin.$575.Metal2 VSS.$304.Metal1 5.45549e-07f
Cred_5981 vin.$575.Metal2 VSS.$40.Metal1 1.43575e-05f
Cred_5982 vin.$575.Metal2 VSS.$551.Metal1 0.000108888f
Cred_5983 vin.$575.Metal2 VSS.$840.Metal2 4.55803e-09f
Cred_5984 vin.$575.Metal2 VSS.$852.Metal2 0.00324337f
Cred_5985 vin.$575.Metal2 VSS.P0.pSD 0.010104f
Cred_5986 vin.$578.Metal2 vout.$1292.Metal3 0.0261172f
Cred_5987 vin.$578.Metal2 vout.$1358.Metal3 0.0261172f
Cred_5988 vin.$578.Metal2 vout.P10.nSD 0.000411452f
Cred_5989 vin.$578.Metal2 vout.P10.pSD 0.0120664f
Cred_5990 vin.$578.Metal2 VSS.$1217.Metal3 1.39228e-06f
Cred_5991 vin.$578.Metal2 VSS.$1229.Metal3 1.39228e-06f
Cred_5992 vin.$578.Metal2 VSS.$314.Metal1 2.82931e-06f
Cred_5993 vin.$578.Metal2 VSS.$852.Metal2 0.00162964f
Cred_5994 vin.$578.Metal2 VSS.$867.Metal2 0.000352891f
Cred_5995 vin.$579.Metal2 vout.$1292.Metal3 0.0129968f
Cred_5996 vin.$579.Metal2 vout.$1358.Metal3 0.01958f
Cred_5997 vin.$579.Metal2 vout.P10.nSD 0.00156373f
Cred_5998 vin.$579.Metal2 vout.P10.pSD 0.00110896f
Cred_5999 vin.$579.Metal2 vout.P12.nSD 3.29385e-05f
Cred_6000 vin.$579.Metal2 VSS.$1217.Metal3 1.4914e-05f
Cred_6001 vin.$579.Metal2 VSS.$1229.Metal3 1.4914e-05f
Cred_6002 vin.$579.Metal2 VSS.$18.Metal1 2.2207e-05f
Cred_6003 vin.$579.Metal2 VSS.$304.Metal1 8.0936e-07f
Cred_6004 vin.$579.Metal2 VSS.$314.Metal1 6.89183e-05f
Cred_6005 vin.$579.Metal2 VSS.$319.Metal1 0.00234692f
Cred_6006 vin.$579.Metal2 VSS.$40.Metal1 8.6096e-06f
Cred_6007 vin.$579.Metal2 VSS.$551.Metal1 0.000108952f
Cred_6008 vin.$579.Metal2 VSS.$852.Metal2 0.0070235f
Cred_6009 vin.$579.Metal2 VSS.$867.Metal2 0.0244763f
Cred_6010 vin.$579.Metal2 VSS.$875.Metal2 0.00624171f
Cred_6011 vin.$579.Metal2 VSS.P0.pSD 0.00782254f
Cred_6012 vin.$579.Metal2 VSS.P13.nSD 8.16213e-05f
Cred_6013 vin.$58.GatPoly vout.$1226.Metal3 0.00291855f
Cred_6014 vin.$58.GatPoly vout.$1292.Metal3 0.00204637f
Cred_6015 vin.$58.GatPoly vout.P4.nSD 8.17834e-06f
Cred_6016 vin.$58.GatPoly vout.P6.nSD 0.0021495f
Cred_6017 vin.$58.GatPoly vout.P6.pSD 0.000176192f
Cred_6018 vin.$58.GatPoly VSS.$18.Metal1 5.9078e-05f
Cred_6019 vin.$58.GatPoly VSS.$184.Metal1 0.000344001f
Cred_6020 vin.$58.GatPoly VSS.$195.Metal1 0.00519177f
Cred_6021 vin.$58.GatPoly VSS.$202.Metal1 0.000387046f
Cred_6022 vin.$58.GatPoly VSS.$212.Metal1 5.95524e-06f
Cred_6023 vin.$58.GatPoly VSS.$40.Metal1 2.29043e-05f
Cred_6024 vin.$58.GatPoly VSS.$551.Metal1 7.42095e-06f
Cred_6025 vin.$58.GatPoly VSS.$732.Metal2 0.0009159f
Cred_6026 vin.$58.GatPoly VSS.$740.Metal2 3.46719e-05f
Cred_6027 vin.$58.GatPoly VSS.$746.Metal2 2.21923e-07f
Cred_6028 vin.$58.GatPoly VSS.P0.pSD 0.00332675f
Cred_6029 vin.$58.GatPoly VSS.P7.nSD 4.47129e-05f
Cred_6030 vin.$582.Metal2 vout.$1292.Metal3 0.0100282f
Cred_6031 vin.$582.Metal2 vout.$1358.Metal3 0.0252789f
Cred_6032 vin.$582.Metal2 vout.P10.nSD 0.000157985f
Cred_6033 vin.$582.Metal2 vout.P10.pSD 0.00132459f
Cred_6034 vin.$582.Metal2 vout.P12.pSD 0.000468932f
Cred_6035 vin.$582.Metal2 VSS.$1217.Metal3 1.39228e-06f
Cred_6036 vin.$582.Metal2 VSS.$1229.Metal3 1.39228e-06f
Cred_6037 vin.$582.Metal2 VSS.$314.Metal1 2.82931e-06f
Cred_6038 vin.$582.Metal2 VSS.$319.Metal1 0.00011038f
Cred_6039 vin.$582.Metal2 VSS.$852.Metal2 0.000352891f
Cred_6040 vin.$582.Metal2 VSS.$867.Metal2 0.00133931f
Cred_6041 vin.$582.Metal2 VSS.$875.Metal2 0.000297493f
Cred_6042 vin.$582.Metal2 VSS.P13.nSD 3.83251e-06f
Cred_6043 vin.$584.Metal2 vout.$1292.Metal3 0.0296407f
Cred_6044 vin.$584.Metal2 vout.$1358.Metal3 0.0922511f
Cred_6045 vin.$584.Metal2 vout.P10.nSD 0.000487996f
Cred_6046 vin.$584.Metal2 vout.P10.pSD 0.00255968f
Cred_6047 vin.$584.Metal2 vout.P12.nSD 2.10351e-05f
Cred_6048 vin.$584.Metal2 vout.P12.pSD 3.05905e-05f
Cred_6049 vin.$584.Metal2 VSS.$18.Metal1 0.000136313f
Cred_6050 vin.$584.Metal2 VSS.$319.Metal1 0.00153338f
Cred_6051 vin.$584.Metal2 VSS.$40.Metal1 5.28482e-05f
Cred_6052 vin.$584.Metal2 VSS.$551.Metal1 0.000802979f
Cred_6053 vin.$584.Metal2 VSS.$867.Metal2 0.0135744f
Cred_6054 vin.$584.Metal2 VSS.$875.Metal2 0.00510042f
Cred_6055 vin.$584.Metal2 VSS.P0.pSD 0.0527291f
Cred_6056 vin.$584.Metal2 VSS.P13.nSD 5.33026e-05f
Cred_6057 vin.$586.Metal2 vout.$1292.Metal3 0.00470548f
Cred_6058 vin.$586.Metal2 vout.$1358.Metal3 0.0241818f
Cred_6059 vin.$586.Metal2 vout.P10.nSD 0.000114531f
Cred_6060 vin.$586.Metal2 vout.P10.pSD 0.000401496f
Cred_6061 vin.$586.Metal2 vout.P12.nSD 4.96776e-05f
Cred_6062 vin.$586.Metal2 VSS.$1229.Metal3 1.19386e-05f
Cred_6063 vin.$586.Metal2 VSS.$1238.Metal3 5.94549e-06f
Cred_6064 vin.$586.Metal2 VSS.$18.Metal1 1.89205e-05f
Cred_6065 vin.$586.Metal2 VSS.$319.Metal1 0.004303f
Cred_6066 vin.$586.Metal2 VSS.$339.Metal1 3.56663e-05f
Cred_6067 vin.$586.Metal2 VSS.$349.Metal1 5.79876e-07f
Cred_6068 vin.$586.Metal2 VSS.$40.Metal1 7.33543e-06f
Cred_6069 vin.$586.Metal2 VSS.$551.Metal1 0.000124687f
Cred_6070 vin.$586.Metal2 VSS.$867.Metal2 0.0372223f
Cred_6071 vin.$586.Metal2 VSS.$875.Metal2 0.0168217f
Cred_6072 vin.$586.Metal2 VSS.$887.Metal2 0.0022485f
Cred_6073 vin.$586.Metal2 VSS.P0.pSD 0.00767872f
Cred_6074 vin.$586.Metal2 VSS.P13.nSD 0.00014965f
Cred_6075 vin.$587.Metal2 vout.$1292.Metal3 0.00151807f
Cred_6076 vin.$587.Metal2 vout.$1358.Metal3 0.0152229f
Cred_6077 vin.$587.Metal2 vout.P10.nSD 2.39158e-05f
Cred_6078 vin.$587.Metal2 vout.P10.pSD 0.000188283f
Cred_6079 vin.$587.Metal2 vout.P12.pSD 0.000187244f
Cred_6080 vin.$587.Metal2 VSS.$1229.Metal3 2.13394e-06f
Cred_6081 vin.$587.Metal2 VSS.$1238.Metal3 1.06271e-06f
Cred_6082 vin.$587.Metal2 VSS.$319.Metal1 9.93277e-05f
Cred_6083 vin.$587.Metal2 VSS.$339.Metal1 3.22228e-06f
Cred_6084 vin.$587.Metal2 VSS.$867.Metal2 0.00088765f
Cred_6085 vin.$587.Metal2 VSS.$875.Metal2 0.000669595f
Cred_6086 vin.$587.Metal2 VSS.$887.Metal2 0.0004019f
Cred_6087 vin.$587.Metal2 VSS.P13.nSD 3.44875e-06f
Cred_6088 vin.$590.Metal2 vout.$1358.Metal3 0.063768f
Cred_6089 vin.$590.Metal2 vout.P12.nSD 0.00918776f
Cred_6090 vin.$590.Metal2 vout.P12.pSD 0.000349306f
Cred_6091 vin.$590.Metal2 VSS.$1229.Metal3 1.19383e-05f
Cred_6092 vin.$590.Metal2 VSS.$1238.Metal3 5.94534e-06f
Cred_6093 vin.$590.Metal2 VSS.$18.Metal1 1.20944e-05f
Cred_6094 vin.$590.Metal2 VSS.$319.Metal1 9.74723e-06f
Cred_6095 vin.$590.Metal2 VSS.$339.Metal1 2.37908e-05f
Cred_6096 vin.$590.Metal2 VSS.$349.Metal1 3.57945e-07f
Cred_6097 vin.$590.Metal2 VSS.$40.Metal1 4.68896e-06f
Cred_6098 vin.$590.Metal2 VSS.$551.Metal1 0.0001285f
Cred_6099 vin.$590.Metal2 VSS.$867.Metal2 5.6286e-07f
Cred_6100 vin.$590.Metal2 VSS.$875.Metal2 0.00224857f
Cred_6101 vin.$590.Metal2 VSS.$887.Metal2 0.00423072f
Cred_6102 vin.$590.Metal2 VSS.P0.pSD 0.00623405f
Cred_6103 vin.$590.Metal2 VSS.P13.nSD 3.09677e-07f
Cred_6104 vin.$591.Metal2 vout.$1358.Metal3 0.0573484f
Cred_6105 vin.$591.Metal2 vout.P12.nSD 0.000337611f
Cred_6106 vin.$591.Metal2 vout.P12.pSD 0.0114764f
Cred_6107 vin.$591.Metal2 VSS.$1229.Metal3 2.13394e-06f
Cred_6108 vin.$591.Metal2 VSS.$1238.Metal3 1.06271e-06f
Cred_6109 vin.$591.Metal2 VSS.$339.Metal1 3.22228e-06f
Cred_6110 vin.$591.Metal2 VSS.$875.Metal2 0.000401891f
Cred_6111 vin.$591.Metal2 VSS.$887.Metal2 0.0004019f
Cred_6112 vin.$593.Metal2 vout.$1358.Metal3 0.154857f
Cred_6113 vin.$593.Metal2 vout.P12.nSD 0.00212871f
Cred_6114 vin.$593.Metal2 vout.P12.pSD 0.00234758f
Cred_6115 vin.$593.Metal2 VSS.$18.Metal1 0.000100617f
Cred_6116 vin.$593.Metal2 VSS.$40.Metal1 3.9009e-05f
Cred_6117 vin.$593.Metal2 VSS.$551.Metal1 0.00118224f
Cred_6118 vin.$593.Metal2 VSS.P0.pSD 0.0547644f
Cred_6119 vin.$595.Metal2 vout.$1358.Metal3 0.0772772f
Cred_6120 vin.$595.Metal2 vout.P12.nSD 0.0117382f
Cred_6121 vin.$595.Metal2 vout.P12.pSD 0.00041089f
Cred_6122 vin.$595.Metal2 VSS.$18.Metal1 1.31228e-05f
Cred_6123 vin.$595.Metal2 VSS.$349.Metal1 4.34561e-06f
Cred_6124 vin.$595.Metal2 VSS.$361.Metal1 6.75033e-06f
Cred_6125 vin.$595.Metal2 VSS.$372.Metal1 2.13459e-06f
Cred_6126 vin.$595.Metal2 VSS.$40.Metal1 5.08767e-06f
Cred_6127 vin.$595.Metal2 VSS.$551.Metal1 0.000176357f
Cred_6128 vin.$595.Metal2 VSS.$899.Metal2 0.00435831f
Cred_6129 vin.$595.Metal2 VSS.$905.Metal2 1.75293e-09f
Cred_6130 vin.$595.Metal2 VSS.$914.Metal2 4.61604e-08f
Cred_6131 vin.$595.Metal2 VSS.P0.pSD 0.00760265f
Cred_6132 vin.$595.Metal2 VSS.P15.nSD 1.79055e-08f
Cred_6133 vin.$596.Metal2 vout.$1358.Metal3 0.0726842f
Cred_6134 vin.$596.Metal2 vout.P12.nSD 0.000385519f
Cred_6135 vin.$596.Metal2 vout.P12.pSD 0.0148625f
Cred_6136 vin.$596.Metal2 VSS.$899.Metal2 0.000810217f
Cred_6137 vin.$599.Metal2 vout.$1358.Metal3 0.0137176f
Cred_6138 vin.$599.Metal2 vout.$1424.Metal3 0.000250947f
Cred_6139 vin.$599.Metal2 vout.P12.nSD 2.54766e-05f
Cred_6140 vin.$599.Metal2 vout.P14.nSD 5.30983e-06f
Cred_6141 vin.$599.Metal2 vout.P14.pSD 2.14121e-05f
Cred_6142 vin.$599.Metal2 VSS.$18.Metal1 6.50281e-06f
Cred_6143 vin.$599.Metal2 VSS.$349.Metal1 9.84736e-06f
Cred_6144 vin.$599.Metal2 VSS.$361.Metal1 2.42007e-05f
Cred_6145 vin.$599.Metal2 VSS.$372.Metal1 0.00184818f
Cred_6146 vin.$599.Metal2 VSS.$40.Metal1 2.52112e-06f
Cred_6147 vin.$599.Metal2 VSS.$551.Metal1 0.000114365f
Cred_6148 vin.$599.Metal2 VSS.$899.Metal2 0.00435848f
Cred_6149 vin.$599.Metal2 VSS.$905.Metal2 0.00612f
Cred_6150 vin.$599.Metal2 VSS.$914.Metal2 0.0189223f
Cred_6151 vin.$599.Metal2 VSS.P0.pSD 0.00432309f
Cred_6152 vin.$599.Metal2 VSS.P15.nSD 1.08609e-05f
Cred_6153 vin.$6.GatPoly vout.$1226.Metal3 0.00778681f
Cred_6154 vin.$6.GatPoly vout.P0.nSD 0.00605587f
Cred_6155 vin.$6.GatPoly vout.P0.pSD 0.00121294f
Cred_6156 vin.$6.GatPoly vout.P2.nSD 0.000125325f
Cred_6157 vin.$6.GatPoly vout.P2.pSD 0.000670441f
Cred_6158 vin.$6.GatPoly VSS.$1112.Metal3 1.99918e-08f
Cred_6159 vin.$6.GatPoly VSS.$1118.Metal3 2.45493e-09f
Cred_6160 vin.$6.GatPoly VSS.$18.Metal1 0.000732529f
Cred_6161 vin.$6.GatPoly VSS.$40.Metal1 0.00050257f
Cred_6162 vin.$6.GatPoly VSS.$551.Metal1 2.00119e-06f
Cred_6163 vin.$6.GatPoly VSS.$564.Metal2 5.21872e-06f
Cred_6164 vin.$6.GatPoly VSS.$605.Metal2 3.89044e-06f
Cred_6165 vin.$6.GatPoly VSS.$617.Metal2 2.86509e-06f
Cred_6166 vin.$6.GatPoly VSS.$629.Metal2 3.06185e-07f
Cred_6167 vin.$6.GatPoly VSS.$636.Metal2 2.03259e-05f
Cred_6168 vin.$6.GatPoly VSS.$644.Metal2 2.72948e-05f
Cred_6169 vin.$6.GatPoly VSS.$65.Metal1 2.1532e-05f
Cred_6170 vin.$6.GatPoly VSS.$75.Metal1 0.000101961f
Cred_6171 vin.$6.GatPoly VSS.$85.Metal1 3.82205e-05f
Cred_6172 vin.$6.GatPoly VSS.$97.Metal1 0.000531044f
Cred_6173 vin.$6.GatPoly VSS.P0.GatPoly 0.00217102f
Cred_6174 vin.$6.GatPoly VSS.P0.nSD 1.46552e-06f
Cred_6175 vin.$6.GatPoly VSS.P0.pSD 0.00523766f
Cred_6176 vin.$6.GatPoly VSS.P1.nSD 1.46552e-06f
Cred_6177 vin.$6.GatPoly VSS.P3.nSD 1.99165e-05f
Cred_6178 vin.$600.Metal2 vout.$1358.Metal3 0.0140467f
Cred_6179 vin.$600.Metal2 vout.$1424.Metal3 0.000248465f
Cred_6180 vin.$600.Metal2 vout.P12.pSD 0.000396077f
Cred_6181 vin.$600.Metal2 vout.P14.nSD 3.91434e-06f
Cred_6182 vin.$600.Metal2 vout.P14.pSD 2.77698e-05f
Cred_6183 vin.$600.Metal2 VSS.$372.Metal1 4.95976e-06f
Cred_6184 vin.$600.Metal2 VSS.$899.Metal2 0.000810217f
Cred_6185 vin.$600.Metal2 VSS.$905.Metal2 1.95021e-06f
Cred_6186 vin.$600.Metal2 VSS.$914.Metal2 5.13554e-05f
Cred_6187 vin.$600.Metal2 VSS.P15.nSD 2.90047e-08f
Cred_6188 vin.$602.Metal2 vout.$1358.Metal3 0.0833933f
Cred_6189 vin.$602.Metal2 vout.$1424.Metal3 0.0268487f
Cred_6190 vin.$602.Metal2 vout.P12.nSD 8.8558e-07f
Cred_6191 vin.$602.Metal2 vout.P12.pSD 4.28917e-06f
Cred_6192 vin.$602.Metal2 vout.P14.nSD 0.000423861f
Cred_6193 vin.$602.Metal2 vout.P14.pSD 0.00229515f
Cred_6194 vin.$602.Metal2 VSS.$18.Metal1 6.44965e-05f
Cred_6195 vin.$602.Metal2 VSS.$372.Metal1 0.000730182f
Cred_6196 vin.$602.Metal2 VSS.$40.Metal1 2.50051e-05f
Cred_6197 vin.$602.Metal2 VSS.$551.Metal1 0.00153823f
Cred_6198 vin.$602.Metal2 VSS.$905.Metal2 0.00128862f
Cred_6199 vin.$602.Metal2 VSS.$914.Metal2 0.0075606f
Cred_6200 vin.$602.Metal2 VSS.P0.pSD 0.0496201f
Cred_6201 vin.$602.Metal2 VSS.P15.nSD 4.27011e-06f
Cred_6202 vin.$604.Metal2 vout.$1358.Metal3 0.0338686f
Cred_6203 vin.$604.Metal2 vout.$1424.Metal3 0.0139811f
Cred_6204 vin.$604.Metal2 vout.P12.nSD 9.27585e-05f
Cred_6205 vin.$604.Metal2 vout.P14.nSD 0.000425945f
Cred_6206 vin.$604.Metal2 vout.P14.pSD 0.00119294f
Cred_6207 vin.$604.Metal2 VSS.$1250.Metal3 1.3306e-05f
Cred_6208 vin.$604.Metal2 VSS.$18.Metal1 1.71658e-05f
Cred_6209 vin.$604.Metal2 VSS.$372.Metal1 0.00595593f
Cred_6210 vin.$604.Metal2 VSS.$379.Metal1 1.44323e-05f
Cred_6211 vin.$604.Metal2 VSS.$391.Metal1 9.96213e-07f
Cred_6212 vin.$604.Metal2 VSS.$40.Metal1 6.65513e-06f
Cred_6213 vin.$604.Metal2 VSS.$551.Metal1 0.000444035f
Cred_6214 vin.$604.Metal2 VSS.$905.Metal2 0.00221547f
Cred_6215 vin.$604.Metal2 VSS.$914.Metal2 0.0600003f
Cred_6216 vin.$604.Metal2 VSS.$928.Metal2 0.00440462f
Cred_6217 vin.$604.Metal2 VSS.P0.pSD 0.0136893f
Cred_6218 vin.$604.Metal2 VSS.P15.nSD 3.6094e-05f
Cred_6219 vin.$605.Metal2 vout.$1358.Metal3 0.0302318f
Cred_6220 vin.$605.Metal2 vout.$1424.Metal3 0.010799f
Cred_6221 vin.$605.Metal2 vout.P12.pSD 0.000547418f
Cred_6222 vin.$605.Metal2 vout.P14.nSD 0.000170128f
Cred_6223 vin.$605.Metal2 vout.P14.pSD 0.00146884f
Cred_6224 vin.$605.Metal2 VSS.$1250.Metal3 2.20067e-06f
Cred_6225 vin.$605.Metal2 VSS.$372.Metal1 0.000130607f
Cred_6226 vin.$605.Metal2 VSS.$379.Metal1 2.20067e-06f
Cred_6227 vin.$605.Metal2 VSS.$905.Metal2 5.13554e-05f
Cred_6228 vin.$605.Metal2 VSS.$914.Metal2 0.00162683f
Cred_6229 vin.$605.Metal2 VSS.$928.Metal2 0.000274474f
Cred_6230 vin.$605.Metal2 VSS.P15.nSD 7.63791e-07f
Cred_6231 vin.$609.Metal2 vout.$1358.Metal3 0.0091502f
Cred_6232 vin.$609.Metal2 vout.$1424.Metal3 0.0091502f
Cred_6233 vin.$609.Metal2 vout.P14.nSD 0.000144153f
Cred_6234 vin.$609.Metal2 vout.P14.pSD 0.0017493f
Cred_6235 vin.$609.Metal2 VSS.$1250.Metal3 2.20067e-06f
Cred_6236 vin.$609.Metal2 VSS.$379.Metal1 2.20067e-06f
Cred_6237 vin.$609.Metal2 VSS.$914.Metal2 0.000274474f
Cred_6238 vin.$609.Metal2 VSS.$928.Metal2 0.00187041f
Cred_6239 vin.$610.Metal2 vout.$1358.Metal3 0.0397571f
Cred_6240 vin.$610.Metal2 vout.$1424.Metal3 0.0397571f
Cred_6241 vin.$610.Metal2 vout.P14.nSD 0.013264f
Cred_6242 vin.$610.Metal2 vout.P14.pSD 0.00381921f
Cred_6243 vin.$610.Metal2 VSS.$1250.Metal3 6.59028e-06f
Cred_6244 vin.$610.Metal2 VSS.$18.Metal1 9.54821e-06f
Cred_6245 vin.$610.Metal2 VSS.$372.Metal1 0.000479279f
Cred_6246 vin.$610.Metal2 VSS.$379.Metal1 8.86433e-06f
Cred_6247 vin.$610.Metal2 VSS.$391.Metal1 2.01144e-06f
Cred_6248 vin.$610.Metal2 VSS.$40.Metal1 3.70181e-06f
Cred_6249 vin.$610.Metal2 VSS.$551.Metal1 0.000416151f
Cred_6250 vin.$610.Metal2 VSS.$905.Metal2 0.000188455f
Cred_6251 vin.$610.Metal2 VSS.$914.Metal2 0.00578461f
Cred_6252 vin.$610.Metal2 VSS.$928.Metal2 0.00636449f
Cred_6253 vin.$610.Metal2 VSS.P0.pSD 0.00978931f
Cred_6254 vin.$610.Metal2 VSS.P15.nSD 2.80283e-06f
Cred_6255 vin.$611.Metal2 vout.$1358.Metal3 0.0323225f
Cred_6256 vin.$611.Metal2 vout.$1424.Metal3 0.0323225f
Cred_6257 vin.$611.Metal2 vout.P14.nSD 0.000890737f
Cred_6258 vin.$611.Metal2 vout.P14.pSD 0.0182838f
Cred_6259 vin.$613.Metal2 vout.$1358.Metal3 0.0730941f
Cred_6260 vin.$613.Metal2 vout.$1424.Metal3 0.0730941f
Cred_6261 vin.$613.Metal2 vout.P14.nSD 0.00320506f
Cred_6262 vin.$613.Metal2 vout.P14.pSD 0.00849352f
Cred_6263 vin.$613.Metal2 VSS.$18.Metal1 4.87687e-05f
Cred_6264 vin.$613.Metal2 VSS.$40.Metal1 1.89075e-05f
Cred_6265 vin.$613.Metal2 VSS.$551.Metal1 0.00230892f
Cred_6266 vin.$613.Metal2 VSS.P0.pSD 0.0522508f
Cred_6267 vin.$615.Metal2 vout.$1358.Metal3 0.0302787f
Cred_6268 vin.$615.Metal2 vout.$1424.Metal3 0.0302787f
Cred_6269 vin.$615.Metal2 vout.P14.nSD 0.00883747f
Cred_6270 vin.$615.Metal2 vout.P14.pSD 0.00290628f
Cred_6271 vin.$615.Metal2 VSS.$1256.Metal3 5.96364e-06f
Cred_6272 vin.$615.Metal2 VSS.$1265.Metal3 1.19751e-05f
Cred_6273 vin.$615.Metal2 VSS.$18.Metal1 4.39984e-06f
Cred_6274 vin.$615.Metal2 VSS.$40.Metal1 1.7058e-06f
Cred_6275 vin.$615.Metal2 VSS.$401.Metal1 1.96637e-05f
Cred_6276 vin.$615.Metal2 VSS.$409.Metal1 2.80403e-07f
Cred_6277 vin.$615.Metal2 VSS.$551.Metal1 0.000252936f
Cred_6278 vin.$615.Metal2 VSS.$940.Metal2 0.00481516f
Cred_6279 vin.$615.Metal2 VSS.$952.Metal2 0.00225531f
Cred_6280 vin.$615.Metal2 VSS.P0.pSD 0.0051579f
Cred_6281 vin.$616.Metal2 vout.$1358.Metal3 0.0254407f
Cred_6282 vin.$616.Metal2 vout.$1424.Metal3 0.0254407f
Cred_6283 vin.$616.Metal2 vout.P14.nSD 0.000717743f
Cred_6284 vin.$616.Metal2 vout.P14.pSD 0.0125547f
Cred_6285 vin.$616.Metal2 VSS.$1256.Metal3 1.0627e-06f
Cred_6286 vin.$616.Metal2 VSS.$1265.Metal3 2.13392e-06f
Cred_6287 vin.$616.Metal2 VSS.$401.Metal1 3.22226e-06f
Cred_6288 vin.$616.Metal2 VSS.$940.Metal2 0.000401897f
Cred_6289 vin.$616.Metal2 VSS.$952.Metal2 0.000401889f
Cred_6290 vin.$619.Metal2 vout.$1358.Metal3 0.00647786f
Cred_6291 vin.$619.Metal2 vout.$1424.Metal3 0.0109795f
Cred_6292 vin.$619.Metal2 vout.P14.nSD 0.000119301f
Cred_6293 vin.$619.Metal2 vout.P14.pSD 0.000552724f
Cred_6294 vin.$619.Metal2 vout.P16.nSD 1.72485e-05f
Cred_6295 vin.$619.Metal2 VSS.$1256.Metal3 5.96364e-06f
Cred_6296 vin.$619.Metal2 VSS.$1265.Metal3 1.19751e-05f
Cred_6297 vin.$619.Metal2 VSS.$18.Metal1 4.45407e-06f
Cred_6298 vin.$619.Metal2 VSS.$40.Metal1 1.72683e-06f
Cred_6299 vin.$619.Metal2 VSS.$401.Metal1 1.96637e-05f
Cred_6300 vin.$619.Metal2 VSS.$409.Metal1 0.00295546f
Cred_6301 vin.$619.Metal2 VSS.$551.Metal1 0.000370385f
Cred_6302 vin.$619.Metal2 VSS.$940.Metal2 0.00225536f
Cred_6303 vin.$619.Metal2 VSS.$952.Metal2 0.014709f
Cred_6304 vin.$619.Metal2 VSS.$961.Metal2 0.0221092f
Cred_6305 vin.$619.Metal2 VSS.P0.pSD 0.00622276f
Cred_6306 vin.$619.Metal2 VSS.P17.nSD 0.00010339f
Cred_6307 vin.$620.Metal2 vout.$1358.Metal3 0.006682f
Cred_6308 vin.$620.Metal2 vout.$1424.Metal3 0.0111051f
Cred_6309 vin.$620.Metal2 vout.P14.nSD 0.000105269f
Cred_6310 vin.$620.Metal2 vout.P14.pSD 0.00066595f
Cred_6311 vin.$620.Metal2 vout.P16.pSD 9.5808e-05f
Cred_6312 vin.$620.Metal2 VSS.$1256.Metal3 1.0627e-06f
Cred_6313 vin.$620.Metal2 VSS.$1265.Metal3 2.13392e-06f
Cred_6314 vin.$620.Metal2 VSS.$401.Metal1 3.22226e-06f
Cred_6315 vin.$620.Metal2 VSS.$409.Metal1 0.000107166f
Cred_6316 vin.$620.Metal2 VSS.$940.Metal2 0.000401897f
Cred_6317 vin.$620.Metal2 VSS.$952.Metal2 0.0007805f
Cred_6318 vin.$620.Metal2 VSS.$961.Metal2 0.000863233f
Cred_6319 vin.$620.Metal2 VSS.P17.nSD 3.72075e-06f
Cred_6320 vin.$622.Metal2 vout.$1358.Metal3 0.028656f
Cred_6321 vin.$622.Metal2 vout.$1424.Metal3 0.0882964f
Cred_6322 vin.$622.Metal2 vout.P14.nSD 0.000459574f
Cred_6323 vin.$622.Metal2 vout.P14.pSD 0.00249021f
Cred_6324 vin.$622.Metal2 vout.P16.nSD 8.12535e-06f
Cred_6325 vin.$622.Metal2 vout.P16.pSD 4.51327e-05f
Cred_6326 vin.$622.Metal2 VSS.$18.Metal1 3.35562e-05f
Cred_6327 vin.$622.Metal2 VSS.$40.Metal1 1.30097e-05f
Cred_6328 vin.$622.Metal2 VSS.$409.Metal1 0.000695313f
Cred_6329 vin.$622.Metal2 VSS.$551.Metal1 0.00318764f
Cred_6330 vin.$622.Metal2 VSS.$952.Metal2 0.0024565f
Cred_6331 vin.$622.Metal2 VSS.$961.Metal2 0.00560082f
Cred_6332 vin.$622.Metal2 VSS.P0.pSD 0.0500479f
Cred_6333 vin.$622.Metal2 VSS.P17.nSD 2.41409e-05f
Cred_6334 vin.$624.Metal2 vout.$1358.Metal3 0.00655592f
Cred_6335 vin.$624.Metal2 vout.$1424.Metal3 0.0372994f
Cred_6336 vin.$624.Metal2 vout.P14.nSD 0.000172909f
Cred_6337 vin.$624.Metal2 vout.P14.pSD 0.000559385f
Cred_6338 vin.$624.Metal2 vout.P16.nSD 0.00122397f
Cred_6339 vin.$624.Metal2 VSS.$1265.Metal3 1.06945e-05f
Cred_6340 vin.$624.Metal2 VSS.$1277.Metal3 1.06945e-05f
Cred_6341 vin.$624.Metal2 VSS.$18.Metal1 5.71176e-06f
Cred_6342 vin.$624.Metal2 VSS.$40.Metal1 2.21443e-06f
Cred_6343 vin.$624.Metal2 VSS.$409.Metal1 0.00449268f
Cred_6344 vin.$624.Metal2 VSS.$426.Metal1 2.75255e-05f
Cred_6345 vin.$624.Metal2 VSS.$436.Metal1 5.50336e-07f
Cred_6346 vin.$624.Metal2 VSS.$551.Metal1 0.000627759f
Cred_6347 vin.$624.Metal2 VSS.$952.Metal2 0.0156787f
Cred_6348 vin.$624.Metal2 VSS.$961.Metal2 0.038458f
Cred_6349 vin.$624.Metal2 VSS.$975.Metal2 0.00460082f
Cred_6350 vin.$624.Metal2 VSS.P0.pSD 0.00909287f
Cred_6351 vin.$624.Metal2 VSS.P17.nSD 0.000156179f
Cred_6352 vin.$625.Metal2 vout.$1358.Metal3 0.00639042f
Cred_6353 vin.$625.Metal2 vout.$1424.Metal3 0.0263834f
Cred_6354 vin.$625.Metal2 vout.P14.nSD 0.000100675f
Cred_6355 vin.$625.Metal2 vout.P14.pSD 0.000962598f
Cred_6356 vin.$625.Metal2 vout.P16.pSD 0.000417335f
Cred_6357 vin.$625.Metal2 VSS.$1265.Metal3 1.50835e-06f
Cred_6358 vin.$625.Metal2 VSS.$1277.Metal3 1.50835e-06f
Cred_6359 vin.$625.Metal2 VSS.$409.Metal1 0.000127238f
Cred_6360 vin.$625.Metal2 VSS.$426.Metal1 3.06517e-06f
Cred_6361 vin.$625.Metal2 VSS.$952.Metal2 0.000449523f
Cred_6362 vin.$625.Metal2 VSS.$961.Metal2 0.00140722f
Cred_6363 vin.$625.Metal2 VSS.$975.Metal2 0.000382309f
Cred_6364 vin.$625.Metal2 VSS.P17.nSD 4.41762e-06f
Cred_6365 vin.$629.Metal2 vout.$1424.Metal3 0.0581218f
Cred_6366 vin.$629.Metal2 vout.P16.nSD 0.000130254f
Cred_6367 vin.$629.Metal2 vout.P16.pSD 0.0106801f
Cred_6368 vin.$629.Metal2 VSS.$1265.Metal3 1.50835e-06f
Cred_6369 vin.$629.Metal2 VSS.$1277.Metal3 1.50835e-06f
Cred_6370 vin.$629.Metal2 VSS.$426.Metal1 3.06517e-06f
Cred_6371 vin.$629.Metal2 VSS.$961.Metal2 0.000382309f
Cred_6372 vin.$629.Metal2 VSS.$975.Metal2 0.00153936f
Cred_6373 vin.$630.Metal2 vout.$1424.Metal3 0.100212f
Cred_6374 vin.$630.Metal2 vout.P16.nSD 0.0149702f
Cred_6375 vin.$630.Metal2 vout.P16.pSD 0.000434383f
Cred_6376 vin.$630.Metal2 VSS.$1265.Metal3 5.29692e-06f
Cred_6377 vin.$630.Metal2 VSS.$1277.Metal3 5.29692e-06f
Cred_6378 vin.$630.Metal2 VSS.$18.Metal1 5.74731e-06f
Cred_6379 vin.$630.Metal2 VSS.$40.Metal1 2.22822e-06f
Cred_6380 vin.$630.Metal2 VSS.$409.Metal1 6.55636e-05f
Cred_6381 vin.$630.Metal2 VSS.$426.Metal1 1.57269e-05f
Cred_6382 vin.$630.Metal2 VSS.$436.Metal1 1.11113e-06f
Cred_6383 vin.$630.Metal2 VSS.$551.Metal1 0.00105124f
Cred_6384 vin.$630.Metal2 VSS.$952.Metal2 0.000229748f
Cred_6385 vin.$630.Metal2 VSS.$961.Metal2 0.00186639f
Cred_6386 vin.$630.Metal2 VSS.$975.Metal2 0.00515882f
Cred_6387 vin.$630.Metal2 VSS.P0.pSD 0.0115638f
Cred_6388 vin.$630.Metal2 VSS.P17.nSD 2.25782e-06f
Cred_6389 vin.$633.Metal2 vout.$1424.Metal3 0.164465f
Cred_6390 vin.$633.Metal2 vout.P16.nSD 0.0020542f
Cred_6391 vin.$633.Metal2 vout.P16.pSD 0.00605822f
Cred_6392 vin.$633.Metal2 VSS.$18.Metal1 2.34763e-05f
Cred_6393 vin.$633.Metal2 VSS.$40.Metal1 9.10169e-06f
Cred_6394 vin.$633.Metal2 VSS.$551.Metal1 0.00448897f
Cred_6395 vin.$633.Metal2 VSS.$987.Metal2 0.00102137f
Cred_6396 vin.$633.Metal2 VSS.P0.pSD 0.0484487f
Cred_6397 vin.$635.Metal2 vout.$1424.Metal3 0.039155f
Cred_6398 vin.$635.Metal2 vout.P16.nSD 0.00501158f
Cred_6399 vin.$635.Metal2 vout.P16.pSD 2.82067e-05f
Cred_6400 vin.$635.Metal2 VSS.$1002.Metal2 0.00219987f
Cred_6401 vin.$635.Metal2 VSS.$1010.Metal2 7.92869e-07f
Cred_6402 vin.$635.Metal2 VSS.$1283.Metal3 1.76295e-05f
Cred_6403 vin.$635.Metal2 VSS.$18.Metal1 1.82858e-06f
Cred_6404 vin.$635.Metal2 VSS.$40.Metal1 7.08935e-07f
Cred_6405 vin.$635.Metal2 VSS.$436.Metal1 1.08442e-06f
Cred_6406 vin.$635.Metal2 VSS.$448.Metal1 2.36597e-05f
Cred_6407 vin.$635.Metal2 VSS.$453.Metal1 2.15418e-05f
Cred_6408 vin.$635.Metal2 VSS.$551.Metal1 0.00045611f
Cred_6409 vin.$635.Metal2 VSS.$987.Metal2 0.00769635f
Cred_6410 vin.$635.Metal2 VSS.P0.pSD 0.00426972f
Cred_6411 vin.$635.Metal2 VSS.P19.nSD 7.92703e-07f
Cred_6412 vin.$636.Metal2 vout.$1424.Metal3 0.0645759f
Cred_6413 vin.$636.Metal2 vout.P16.nSD 0.000383135f
Cred_6414 vin.$636.Metal2 vout.P16.pSD 0.0124196f
Cred_6415 vin.$636.Metal2 VSS.$1002.Metal2 0.000401885f
Cred_6416 vin.$636.Metal2 VSS.$1283.Metal3 3.22223e-06f
Cred_6417 vin.$636.Metal2 VSS.$448.Metal1 3.22223e-06f
Cred_6418 vin.$636.Metal2 VSS.$987.Metal2 0.000401885f
Cred_6419 vin.$639.Metal2 vout 0.0112131f
Cred_6420 vin.$639.Metal2 vout.$1424.Metal3 0.020398f
Cred_6421 vin.$639.Metal2 vout.P16.nSD 6.61685e-05f
Cred_6422 vin.$639.Metal2 vout.P18.nSD 0.00014205f
Cred_6423 vin.$639.Metal2 VSS.$1002.Metal2 0.0288501f
Cred_6424 vin.$639.Metal2 VSS.$1010.Metal2 0.0198467f
Cred_6425 vin.$639.Metal2 VSS.$1283.Metal3 1.76299e-05f
Cred_6426 vin.$639.Metal2 VSS.$18.Metal1 2.82819e-06f
Cred_6427 vin.$639.Metal2 VSS.$40.Metal1 1.09648e-06f
Cred_6428 vin.$639.Metal2 VSS.$436.Metal1 3.99604e-07f
Cred_6429 vin.$639.Metal2 VSS.$448.Metal1 2.89329e-05f
Cred_6430 vin.$639.Metal2 VSS.$453.Metal1 0.00421978f
Cred_6431 vin.$639.Metal2 VSS.$551.Metal1 0.00100372f
Cred_6432 vin.$639.Metal2 VSS.$987.Metal2 0.00219886f
Cred_6433 vin.$639.Metal2 VSS.P0.pSD 0.0076863f
Cred_6434 vin.$639.Metal2 VSS.P19.nSD 0.00014708f
Cred_6435 vin.$64.GatPoly vout.$1226.Metal3 0.00434545f
Cred_6436 vin.$64.GatPoly vout.$1292.Metal3 0.0045148f
Cred_6437 vin.$64.GatPoly vout.P4.nSD 5.284e-07f
Cred_6438 vin.$64.GatPoly vout.P6.nSD 0.00601945f
Cred_6439 vin.$64.GatPoly vout.P6.pSD 0.00036929f
Cred_6440 vin.$64.GatPoly vout.P8.nSD 2.11636e-06f
Cred_6441 vin.$64.GatPoly VSS.$18.Metal1 5.23766e-05f
Cred_6442 vin.$64.GatPoly VSS.$195.Metal1 0.000169442f
Cred_6443 vin.$64.GatPoly VSS.$232.Metal1 0.000635715f
Cred_6444 vin.$64.GatPoly VSS.$40.Metal1 2.03062e-05f
Cred_6445 vin.$64.GatPoly VSS.$551.Metal1 1.02235e-05f
Cred_6446 vin.$64.GatPoly VSS.$732.Metal2 5.54771e-05f
Cred_6447 vin.$64.GatPoly VSS.$740.Metal2 2.10673e-06f
Cred_6448 vin.$64.GatPoly VSS.$770.Metal2 6.30577e-05f
Cred_6449 vin.$64.GatPoly VSS.$779.Metal2 0.000209086f
Cred_6450 vin.$64.GatPoly VSS.P0.pSD 0.00369092f
Cred_6451 vin.$64.GatPoly VSS.P10.nSD 2.37904e-05f
Cred_6452 vin.$64.GatPoly VSS.P7.nSD 1.40859e-06f
Cred_6453 vin.$640.Metal2 vout 0.0085656f
Cred_6454 vin.$640.Metal2 vout.$1424.Metal3 0.0206345f
Cred_6455 vin.$640.Metal2 vout.P16.pSD 0.000360945f
Cred_6456 vin.$640.Metal2 vout.P18.pSD 0.000539635f
Cred_6457 vin.$640.Metal2 VSS.$1002.Metal2 0.00133846f
Cred_6458 vin.$640.Metal2 VSS.$1010.Metal2 0.000697438f
Cred_6459 vin.$640.Metal2 VSS.$1283.Metal3 3.22231e-06f
Cred_6460 vin.$640.Metal2 VSS.$448.Metal1 3.22231e-06f
Cred_6461 vin.$640.Metal2 VSS.$453.Metal1 0.000141518f
Cred_6462 vin.$640.Metal2 VSS.$987.Metal2 0.000401895f
Cred_6463 vin.$640.Metal2 VSS.P19.nSD 4.91325e-06f
Cred_6464 vin.$642.Metal2 vout 0.112424f
Cred_6465 vin.$642.Metal2 vout.$1424.Metal3 0.0741165f
Cred_6466 vin.$642.Metal2 vout.P16.nSD 1.91397e-05f
Cred_6467 vin.$642.Metal2 vout.P16.pSD 0.000104406f
Cred_6468 vin.$642.Metal2 vout.P18.nSD 0.000733094f
Cred_6469 vin.$642.Metal2 vout.P18.pSD 0.00089223f
Cred_6470 vin.$642.Metal2 VSS.$1002.Metal2 0.00490202f
Cred_6471 vin.$642.Metal2 VSS.$1010.Metal2 0.00365044f
Cred_6472 vin.$642.Metal2 VSS.$1016.Metal2 0.000332483f
Cred_6473 vin.$642.Metal2 VSS.$1028.Metal2 0.000332483f
Cred_6474 vin.$642.Metal2 VSS.$1295.Metal3 2.66577e-06f
Cred_6475 vin.$642.Metal2 VSS.$18.Metal1 2.17892e-05f
Cred_6476 vin.$642.Metal2 VSS.$40.Metal1 8.44761e-06f
Cred_6477 vin.$642.Metal2 VSS.$453.Metal1 0.000740716f
Cred_6478 vin.$642.Metal2 VSS.$476.Metal1 2.66577e-06f
Cred_6479 vin.$642.Metal2 VSS.$551.Metal1 0.0110739f
Cred_6480 vin.$642.Metal2 VSS.P0.pSD 0.0671739f
Cred_6481 vin.$642.Metal2 VSS.P19.nSD 2.57163e-05f
Cred_6482 vin.$644.Metal2 vout 0.016349f
Cred_6483 vin.$644.Metal2 vout.$1424.Metal3 0.00946631f
Cred_6484 vin.$644.Metal2 vout.P16.nSD 4.92744e-05f
Cred_6485 vin.$644.Metal2 vout.P18.nSD 0.00018287f
Cred_6486 vin.$644.Metal2 VSS.$1002.Metal2 0.0220905f
Cred_6487 vin.$644.Metal2 VSS.$1010.Metal2 0.0176522f
Cred_6488 vin.$644.Metal2 VSS.$1016.Metal2 0.00454976f
Cred_6489 vin.$644.Metal2 VSS.$18.Metal1 1.77605e-06f
Cred_6490 vin.$644.Metal2 VSS.$40.Metal1 6.88568e-07f
Cred_6491 vin.$644.Metal2 VSS.$453.Metal1 0.0035292f
Cred_6492 vin.$644.Metal2 VSS.$476.Metal1 6.77989e-06f
Cred_6493 vin.$644.Metal2 VSS.$551.Metal1 0.00079314f
Cred_6494 vin.$644.Metal2 VSS.P0.pSD 0.00533217f
Cred_6495 vin.$644.Metal2 VSS.P19.nSD 0.000122898f
Cred_6496 vin.$645.Metal2 vout 0.0146216f
Cred_6497 vin.$645.Metal2 vout.$1424.Metal3 0.00964247f
Cred_6498 vin.$645.Metal2 vout.P16.pSD 0.000268789f
Cred_6499 vin.$645.Metal2 vout.P18.pSD 0.000494713f
Cred_6500 vin.$645.Metal2 VSS.$1002.Metal2 0.000979447f
Cred_6501 vin.$645.Metal2 VSS.$1010.Metal2 0.000729376f
Cred_6502 vin.$645.Metal2 VSS.$1016.Metal2 0.000810199f
Cred_6503 vin.$645.Metal2 VSS.$453.Metal1 0.000147999f
Cred_6504 vin.$645.Metal2 VSS.P19.nSD 5.13824e-06f
Cred_6505 vin.$648.Metal2 vout 0.0533609f
Cred_6506 vin.$648.Metal2 vout.P18.nSD 0.00779139f
Cred_6507 vin.$648.Metal2 vout.P18.pSD 4.89422e-05f
Cred_6508 vin.$648.Metal2 VSS.$1002.Metal2 5.24705e-07f
Cred_6509 vin.$648.Metal2 VSS.$1010.Metal2 3.96718e-07f
Cred_6510 vin.$648.Metal2 VSS.$1016.Metal2 0.00642628f
Cred_6511 vin.$648.Metal2 VSS.$1028.Metal2 0.00187774f
Cred_6512 vin.$648.Metal2 VSS.$1040.Metal2 1.6855e-06f
Cred_6513 vin.$648.Metal2 VSS.$1066.Metal2 4.38619e-07f
Cred_6514 vin.$648.Metal2 VSS.$1295.Metal3 1.50464e-05f
Cred_6515 vin.$648.Metal2 VSS.$1301.Metal3 8.51406e-09f
Cred_6516 vin.$648.Metal2 VSS.$18.Metal1 1.93197e-06f
Cred_6517 vin.$648.Metal2 VSS.$40.Metal1 7.49018e-07f
Cred_6518 vin.$648.Metal2 VSS.$453.Metal1 1.14575e-05f
Cred_6519 vin.$648.Metal2 VSS.$476.Metal1 5.02107e-05f
Cred_6520 vin.$648.Metal2 VSS.$488.Metal1 6.01972e-05f
Cred_6521 vin.$648.Metal2 VSS.$498.Metal1 1.25966e-05f
Cred_6522 vin.$648.Metal2 VSS.$509.Metal1 1.83703e-05f
Cred_6523 vin.$648.Metal2 VSS.$551.Metal1 0.00158013f
Cred_6524 vin.$648.Metal2 VSS.P0.pSD 0.00731154f
Cred_6525 vin.$648.Metal2 VSS.P1.GatPoly 7.05595e-05f
Cred_6526 vin.$648.Metal2 VSS.P19.nSD 3.91099e-07f
Cred_6527 vin.$648.Metal2 VSS.P21.nSD 1.23173e-07f
Cred_6528 vin.$648.Metal2 VSS.P23.nSD 1.23173e-07f
Cred_6529 vin.$649.Metal2 vout 0.0497979f
Cred_6530 vin.$649.Metal2 vout.P18.nSD 0.000323667f
Cred_6531 vin.$649.Metal2 vout.P18.pSD 0.0109171f
Cred_6532 vin.$649.Metal2 VSS.$1016.Metal2 0.000828763f
Cred_6533 vin.$649.Metal2 VSS.$1028.Metal2 1.87992e-05f
Cred_6534 vin.$649.Metal2 VSS.$1040.Metal2 1.70431e-05f
Cred_6535 vin.$649.Metal2 VSS.$1055.Metal2 1.5576e-07f
Cred_6536 vin.$649.Metal2 VSS.$1295.Metal3 1.48842e-07f
Cred_6537 vin.$649.Metal2 VSS.$1301.Metal3 4.37839e-05f
Cred_6538 vin.$649.Metal2 VSS.$1313.Metal3 9.98074e-06f
Cred_6539 vin.$649.Metal2 VSS.$18.Metal1 2.79841e-07f
Cred_6540 vin.$649.Metal2 VSS.$40.Metal1 1.08493e-07f
Cred_6541 vin.$649.Metal2 VSS.$476.Metal1 1.48842e-07f
Cred_6542 vin.$649.Metal2 VSS.$488.Metal1 1.88629e-09f
Cred_6543 vin.$649.Metal2 VSS.$498.Metal1 6.70865e-10f
Cred_6544 vin.$649.Metal2 VSS.$551.Metal1 0.000256532f
Cred_6545 vin.$649.Metal2 VSS.P0.pSD 0.00110091f
Cred_6546 vin.$65.GatPoly vout.$1226.Metal3 0.0129341f
Cred_6547 vin.$65.GatPoly vout.$1292.Metal3 0.0147456f
Cred_6548 vin.$65.GatPoly vout.P6.nSD 0.000203765f
Cred_6549 vin.$65.GatPoly vout.P6.pSD 0.0198964f
Cred_6550 vin.$65.GatPoly vout.P8.pSD 0.000127288f
Cred_6551 vin.$653.Metal2 vout 0.117816f
Cred_6552 vin.$653.Metal2 vout.P18.nSD 0.0178664f
Cred_6553 vin.$653.Metal2 vout.P18.pSD 0.000604934f
Cred_6554 vin.$653.Metal2 VSS.$1016.Metal2 8.45197e-05f
Cred_6555 vin.$653.Metal2 VSS.$1028.Metal2 0.00324719f
Cred_6556 vin.$653.Metal2 VSS.$1040.Metal2 0.00470657f
Cred_6557 vin.$653.Metal2 VSS.$1066.Metal2 2.26997e-06f
Cred_6558 vin.$653.Metal2 VSS.$1295.Metal3 6.7766e-07f
Cred_6559 vin.$653.Metal2 VSS.$1301.Metal3 2.53559e-05f
Cred_6560 vin.$653.Metal2 VSS.$18.Metal1 4.94811e-06f
Cred_6561 vin.$653.Metal2 VSS.$40.Metal1 1.91837e-06f
Cred_6562 vin.$653.Metal2 VSS.$476.Metal1 7.778e-05f
Cred_6563 vin.$653.Metal2 VSS.$488.Metal1 0.00035398f
Cred_6564 vin.$653.Metal2 VSS.$498.Metal1 6.91891e-05f
Cred_6565 vin.$653.Metal2 VSS.$509.Metal1 9.50711e-05f
Cred_6566 vin.$653.Metal2 VSS.$551.Metal1 0.00501568f
Cred_6567 vin.$653.Metal2 VSS.P0.pSD 0.0203915f
Cred_6568 vin.$653.Metal2 VSS.P1.GatPoly 0.000365165f
Cred_6569 vin.$653.Metal2 VSS.P21.nSD 6.37453e-07f
Cred_6570 vin.$653.Metal2 VSS.P23.nSD 6.37453e-07f
Cred_6571 vin.$654.Metal2 vout 0.110029f
Cred_6572 vin.$654.Metal2 vout.P18.nSD 0.000447888f
Cred_6573 vin.$654.Metal2 vout.P18.pSD 0.0264208f
Cred_6574 vin.$654.Metal2 VSS.$1016.Metal2 7.09799e-05f
Cred_6575 vin.$654.Metal2 VSS.$1028.Metal2 0.000751953f
Cred_6576 vin.$654.Metal2 VSS.$1040.Metal2 0.000764364f
Cred_6577 vin.$654.Metal2 VSS.$1055.Metal2 7.72793e-07f
Cred_6578 vin.$654.Metal2 VSS.$1295.Metal3 5.69101e-07f
Cred_6579 vin.$654.Metal2 VSS.$1301.Metal3 0.000222681f
Cred_6580 vin.$654.Metal2 VSS.$1313.Metal3 4.95187e-05f
Cred_6581 vin.$654.Metal2 VSS.$18.Metal1 1.06998e-06f
Cred_6582 vin.$654.Metal2 VSS.$40.Metal1 4.14827e-07f
Cred_6583 vin.$654.Metal2 VSS.$476.Metal1 5.69101e-07f
Cred_6584 vin.$654.Metal2 VSS.$488.Metal1 5.45989e-06f
Cred_6585 vin.$654.Metal2 VSS.$498.Metal1 3.32845e-09f
Cred_6586 vin.$654.Metal2 VSS.$551.Metal1 0.000980858f
Cred_6587 vin.$654.Metal2 VSS.P0.pSD 0.00420934f
Cred_6588 vin.$7.GatPoly vout.$1226.Metal3 0.0232553f
Cred_6589 vin.$7.GatPoly vout.P0.nSD 0.000692496f
Cred_6590 vin.$7.GatPoly vout.P0.pSD 0.0253827f
Cred_6591 vin.$7.GatPoly vout.P2.nSD 0.000366365f
Cred_6592 vin.$7.GatPoly vout.P2.pSD 0.00200227f
Cred_6593 vin.$7.GatPoly VSS.$1100.Metal3 9.77414e-05f
Cred_6594 vin.$7.GatPoly VSS.$1112.Metal3 0.000428759f
Cred_6595 vin.$7.GatPoly VSS.$590.Metal2 1.52536e-06f
Cred_6596 vin.$7.GatPoly VSS.$605.Metal2 0.000164837f
Cred_6597 vin.$7.GatPoly VSS.$617.Metal2 2.37824e-07f
Cred_6598 vin.$7.GatPoly VSS.$65.Metal1 6.56978e-09f
Cred_6599 vin.$7.GatPoly VSS.$75.Metal1 1.90682e-09f
Cred_6600 vin.$70.GatPoly vout.$1226.Metal3 0.00102127f
Cred_6601 vin.$70.GatPoly vout.$1292.Metal3 0.0015583f
Cred_6602 vin.$70.GatPoly vout.P6.nSD 0.000880038f
Cred_6603 vin.$70.GatPoly vout.P6.pSD 8.79312e-05f
Cred_6604 vin.$70.GatPoly vout.P8.nSD 5.03565e-06f
Cred_6605 vin.$70.GatPoly VSS.$1175.Metal3 1.66246e-10f
Cred_6606 vin.$70.GatPoly VSS.$1184.Metal3 3.33825e-10f
Cred_6607 vin.$70.GatPoly VSS.$18.Metal1 3.85316e-05f
Cred_6608 vin.$70.GatPoly VSS.$212.Metal1 2.45925e-07f
Cred_6609 vin.$70.GatPoly VSS.$224.Metal1 1.31594e-05f
Cred_6610 vin.$70.GatPoly VSS.$232.Metal1 0.00826858f
Cred_6611 vin.$70.GatPoly VSS.$40.Metal1 1.49386e-05f
Cred_6612 vin.$70.GatPoly VSS.$551.Metal1 1.17073e-05f
Cred_6613 vin.$70.GatPoly VSS.$758.Metal2 6.49261e-08f
Cred_6614 vin.$70.GatPoly VSS.$770.Metal2 0.000239054f
Cred_6615 vin.$70.GatPoly VSS.$779.Metal2 0.000792338f
Cred_6616 vin.$70.GatPoly VSS.P0.pSD 0.00339758f
Cred_6617 vin.$70.GatPoly VSS.P10.nSD 0.000220104f
Cred_6618 vin.$73.GatPoly vout.$1226.Metal3 0.00586211f
Cred_6619 vin.$73.GatPoly vout.$1292.Metal3 0.00726413f
Cred_6620 vin.$73.GatPoly vout.P6.nSD 9.2352e-05f
Cred_6621 vin.$73.GatPoly vout.P6.pSD 0.00812762f
Cred_6622 vin.$73.GatPoly vout.P8.pSD 9.85146e-05f
Cred_6623 vin.$77.GatPoly vout.$1226.Metal3 0.00280086f
Cred_6624 vin.$77.GatPoly vout.$1292.Metal3 0.0548185f
Cred_6625 vin.$77.GatPoly vout.P6.nSD 4.4125e-05f
Cred_6626 vin.$77.GatPoly vout.P6.pSD 0.000655105f
Cred_6627 vin.$77.GatPoly vout.P8.pSD 0.0322649f
Cred_6628 vin.$78.GatPoly vout.$1226.Metal3 0.000287145f
Cred_6629 vin.$78.GatPoly vout.$1292.Metal3 0.00272085f
Cred_6630 vin.$78.GatPoly vout.P6.nSD 1.0183e-05f
Cred_6631 vin.$78.GatPoly vout.P6.pSD 2.47231e-05f
Cred_6632 vin.$78.GatPoly vout.P8.nSD 0.00100962f
Cred_6633 vin.$78.GatPoly VSS.$18.Metal1 2.765e-05f
Cred_6634 vin.$78.GatPoly VSS.$232.Metal1 0.00735147f
Cred_6635 vin.$78.GatPoly VSS.$247.Metal1 2.34016e-05f
Cred_6636 vin.$78.GatPoly VSS.$259.Metal1 5.40462e-07f
Cred_6637 vin.$78.GatPoly VSS.$40.Metal1 1.07198e-05f
Cred_6638 vin.$78.GatPoly VSS.$551.Metal1 1.22593e-05f
Cred_6639 vin.$78.GatPoly VSS.$770.Metal2 0.00024583f
Cred_6640 vin.$78.GatPoly VSS.$779.Metal2 0.000815121f
Cred_6641 vin.$78.GatPoly VSS.$793.Metal2 4.51533e-09f
Cred_6642 vin.$78.GatPoly VSS.P0.pSD 0.00295137f
Cred_6643 vin.$78.GatPoly VSS.P10.nSD 0.000202463f
Cred_6644 vin.$80.GatPoly vout.$1226.Metal3 0.000201002f
Cred_6645 vin.$80.GatPoly vout.$1292.Metal3 0.00375244f
Cred_6646 vin.$80.GatPoly vout.P6.nSD 7.12809e-06f
Cred_6647 vin.$80.GatPoly vout.P6.pSD 1.73062e-05f
Cred_6648 vin.$80.GatPoly vout.P8.nSD 0.00220923f
Cred_6649 vin.$80.GatPoly VSS.$18.Metal1 2.06903e-05f
Cred_6650 vin.$80.GatPoly VSS.$232.Metal1 0.0011942f
Cred_6651 vin.$80.GatPoly VSS.$247.Metal1 2.68438e-06f
Cred_6652 vin.$80.GatPoly VSS.$259.Metal1 8.22307e-07f
Cred_6653 vin.$80.GatPoly VSS.$40.Metal1 8.02156e-06f
Cred_6654 vin.$80.GatPoly VSS.$551.Metal1 1.24895e-05f
Cred_6655 vin.$80.GatPoly VSS.$770.Metal2 0.000119486f
Cred_6656 vin.$80.GatPoly VSS.$779.Metal2 0.000396189f
Cred_6657 vin.$80.GatPoly VSS.$793.Metal2 6.87002e-09f
Cred_6658 vin.$80.GatPoly VSS.P0.pSD 0.00258086f
Cred_6659 vin.$80.GatPoly VSS.P10.nSD 4.46895e-05f
Cred_6660 vin.$83.GatPoly vout.$1292.Metal3 0.0110275f
Cred_6661 vin.$83.GatPoly vout.P8.pSD 0.00931187f
Cred_6662 vin.$84.GatPoly vout.$1292.Metal3 0.0085318f
Cred_6663 vin.$84.GatPoly vout.$1358.Metal3 9.00924e-05f
Cred_6664 vin.$84.GatPoly vout.P10.nSD 3.19428e-06f
Cred_6665 vin.$84.GatPoly vout.P10.pSD 7.68714e-06f
Cred_6666 vin.$84.GatPoly vout.P8.nSD 0.00573247f
Cred_6667 vin.$84.GatPoly VSS.$18.Metal1 2.48485e-05f
Cred_6668 vin.$84.GatPoly VSS.$259.Metal1 1.17616e-06f
Cred_6669 vin.$84.GatPoly VSS.$269.Metal1 2.33684e-06f
Cred_6670 vin.$84.GatPoly VSS.$275.Metal1 0.000271043f
Cred_6671 vin.$84.GatPoly VSS.$285.Metal1 0.000271043f
Cred_6672 vin.$84.GatPoly VSS.$40.Metal1 9.63369e-06f
Cred_6673 vin.$84.GatPoly VSS.$551.Metal1 1.97256e-05f
Cred_6674 vin.$84.GatPoly VSS.$805.Metal2 9.82676e-09f
Cred_6675 vin.$84.GatPoly VSS.$818.Metal2 0.000116047f
Cred_6676 vin.$84.GatPoly VSS.$826.Metal2 0.000116047f
Cred_6677 vin.$84.GatPoly VSS.P0.pSD 0.00355215f
Cred_6678 vin.$84.GatPoly VSS.P11.nSD 2.08913e-05f
Cred_6679 vin.$87.GatPoly vout.$1292.Metal3 0.0567834f
Cred_6680 vin.$87.GatPoly vout.$1358.Metal3 0.00287824f
Cred_6681 vin.$87.GatPoly vout.P10.nSD 4.5344e-05f
Cred_6682 vin.$87.GatPoly vout.P10.pSD 0.000705664f
Cred_6683 vin.$87.GatPoly vout.P8.pSD 0.0336727f
Cred_6684 vin.$9.GatPoly vout.$1226.Metal3 0.0328277f
Cred_6685 vin.$9.GatPoly vout.P0.nSD 0.000902961f
Cred_6686 vin.$9.GatPoly vout.P0.pSD 0.0285007f
Cred_6687 vin.$9.GatPoly vout.P2.nSD 0.000517169f
Cred_6688 vin.$9.GatPoly vout.P2.pSD 0.00323297f
Cred_6689 vin.$90.GatPoly vout.$1292.Metal3 0.002772f
Cred_6690 vin.$90.GatPoly vout.$1358.Metal3 0.000292611f
Cred_6691 vin.$90.GatPoly vout.P10.nSD 1.03747e-05f
Cred_6692 vin.$90.GatPoly vout.P10.pSD 2.49671e-05f
Cred_6693 vin.$90.GatPoly vout.P8.nSD 0.0010138f
Cred_6694 vin.$90.GatPoly VSS 7.81226e-10f
Cred_6695 vin.$90.GatPoly VSS.$1196.Metal3 5.85139e-10f
Cred_6696 vin.$90.GatPoly VSS.$18.Metal1 1.76456e-05f
Cred_6697 vin.$90.GatPoly VSS.$269.Metal1 1.81913e-05f
Cred_6698 vin.$90.GatPoly VSS.$275.Metal1 0.00266477f
Cred_6699 vin.$90.GatPoly VSS.$285.Metal1 0.00266134f
Cred_6700 vin.$90.GatPoly VSS.$40.Metal1 6.84113e-06f
Cred_6701 vin.$90.GatPoly VSS.$551.Metal1 2.03056e-05f
Cred_6702 vin.$90.GatPoly VSS.$805.Metal2 1.72572e-07f
Cred_6703 vin.$90.GatPoly VSS.$818.Metal2 0.000481561f
Cred_6704 vin.$90.GatPoly VSS.$826.Metal2 0.000481389f
Cred_6705 vin.$90.GatPoly VSS.P0.pSD 0.00303516f
Cred_6706 vin.$90.GatPoly VSS.P11.nSD 0.000157299f
Cred_6707 vin.$94.GatPoly vout.$1292.Metal3 0.000686295f
Cred_6708 vin.$94.GatPoly vout.$1358.Metal3 0.000451194f
Cred_6709 vin.$94.GatPoly vout.P10.nSD 0.000394788f
Cred_6710 vin.$94.GatPoly vout.P10.pSD 3.84982e-05f
Cred_6711 vin.$94.GatPoly vout.P8.nSD 2.20451e-06f
Cred_6712 vin.$94.GatPoly VSS.$18.Metal1 1.77275e-05f
Cred_6713 vin.$94.GatPoly VSS.$275.Metal1 0.00669692f
Cred_6714 vin.$94.GatPoly VSS.$285.Metal1 0.00669692f
Cred_6715 vin.$94.GatPoly VSS.$40.Metal1 6.87289e-06f
Cred_6716 vin.$94.GatPoly VSS.$551.Metal1 2.92777e-05f
Cred_6717 vin.$94.GatPoly VSS.$818.Metal2 0.000519765f
Cred_6718 vin.$94.GatPoly VSS.$826.Metal2 0.000519765f
Cred_6719 vin.$94.GatPoly VSS.P0.pSD 0.00364748f
Cred_6720 vin.$94.GatPoly VSS.P11.nSD 0.000347593f
Cred_6721 vin.$97.GatPoly vout.$1292.Metal3 0.0314419f
Cred_6722 vin.$97.GatPoly vout.$1358.Metal3 0.0255487f
Cred_6723 vin.$97.GatPoly vout.P10.nSD 0.000402496f
Cred_6724 vin.$97.GatPoly vout.P10.pSD 0.0366452f
Cred_6725 vin.$97.GatPoly vout.P8.pSD 0.000414296f
Cred_6726 vin.P0.GatPoly vout.$1226.Metal3 0.0354043f
Cred_6727 vin.P0.GatPoly vout.P0.nSD 0.0266874f
Cred_6728 vin.P0.GatPoly vout.P0.pSD 0.00560207f
Cred_6729 vin.P0.GatPoly vout.P2.nSD 0.000557762f
Cred_6730 vin.P0.GatPoly vout.P2.pSD 0.00304829f
Cred_6731 vin.P0.GatPoly VSS.$1100.Metal3 0.00104245f
Cred_6732 vin.P0.GatPoly VSS.$1112.Metal3 0.00526914f
Cred_6733 vin.P0.GatPoly VSS.$1118.Metal3 1.08685e-09f
Cred_6734 vin.P0.GatPoly VSS.$18.Metal1 0.00190162f
Cred_6735 vin.P0.GatPoly VSS.$40.Metal1 0.0466531f
Cred_6736 vin.P0.GatPoly VSS.$551.Metal1 3.42226e-06f
Cred_6737 vin.P0.GatPoly VSS.$564.Metal2 0.0121779f
Cred_6738 vin.P0.GatPoly VSS.$590.Metal2 0.000513858f
Cred_6739 vin.P0.GatPoly VSS.$605.Metal2 0.00836454f
Cred_6740 vin.P0.GatPoly VSS.$617.Metal2 0.00207668f
Cred_6741 vin.P0.GatPoly VSS.$629.Metal2 1.35555e-07f
Cred_6742 vin.P0.GatPoly VSS.$636.Metal2 0.00059206f
Cred_6743 vin.P0.GatPoly VSS.$644.Metal2 0.000795051f
Cred_6744 vin.P0.GatPoly VSS.$65.Metal1 0.00612084f
Cred_6745 vin.P0.GatPoly VSS.$75.Metal1 0.0127986f
Cred_6746 vin.P0.GatPoly VSS.$85.Metal1 0.000520991f
Cred_6747 vin.P0.GatPoly VSS.$97.Metal1 0.000105054f
Cred_6748 vin.P0.GatPoly VSS.P0.GatPoly 0.0413455f
Cred_6749 vin.P0.GatPoly VSS.P0.nSD 0.000196828f
Cred_6750 vin.P0.GatPoly VSS.P0.pSD 0.0107136f
Cred_6751 vin.P0.GatPoly VSS.P1.nSD 0.000196828f
Cred_6752 vin.P0.GatPoly VSS.P3.nSD 3.60494e-06f
Cred_6753 vin.P1.GatPoly vout.$1226.Metal3 0.0365198f
Cred_6754 vin.P1.GatPoly vout.P0.nSD 0.0227802f
Cred_6755 vin.P1.GatPoly vout.P0.pSD 0.00551797f
Cred_6756 vin.P1.GatPoly vout.P2.nSD 0.00061447f
Cred_6757 vin.P1.GatPoly vout.P2.pSD 0.00314434f
Cred_6758 vin.P1.GatPoly VSS.$1118.Metal3 0.00292108f
Cred_6759 vin.P1.GatPoly VSS.$1130.Metal3 0.000960272f
Cred_6760 vin.P1.GatPoly VSS.$18.Metal1 6.68665e-05f
Cred_6761 vin.P1.GatPoly VSS.$40.Metal1 0.000741559f
Cred_6762 vin.P1.GatPoly VSS.$551.Metal1 2.63377e-07f
Cred_6763 vin.P1.GatPoly VSS.$617.Metal2 0.00117367f
Cred_6764 vin.P1.GatPoly VSS.$629.Metal2 0.00609126f
Cred_6765 vin.P1.GatPoly VSS.$636.Metal2 0.00606527f
Cred_6766 vin.P1.GatPoly VSS.$644.Metal2 0.0080821f
Cred_6767 vin.P1.GatPoly VSS.$75.Metal1 4.49595e-05f
Cred_6768 vin.P1.GatPoly VSS.$85.Metal1 0.0124816f
Cred_6769 vin.P1.GatPoly VSS.$97.Metal1 0.0608068f
Cred_6770 vin.P1.GatPoly VSS.P0.GatPoly 0.00247791f
Cred_6771 vin.P1.GatPoly VSS.P0.pSD 0.000617316f
Cred_6772 vin.P1.GatPoly VSS.P3.nSD 0.00174028f
Cred_6773 vin.P10.GatPoly vout.$1292.Metal3 0.024214f
Cred_6774 vin.P10.GatPoly vout.$1358.Metal3 0.0204263f
Cred_6775 vin.P10.GatPoly vout.P10.nSD 0.0214836f
Cred_6776 vin.P10.GatPoly vout.P10.pSD 0.00174288f
Cred_6777 vin.P10.GatPoly vout.P8.nSD 3.87847e-05f
Cred_6778 vin.P10.GatPoly VSS 0.0022234f
Cred_6779 vin.P10.GatPoly VSS.$1217.Metal3 0.00166533f
Cred_6780 vin.P10.GatPoly VSS.$18.Metal1 4.1028e-06f
Cred_6781 vin.P10.GatPoly VSS.$275.Metal1 0.025497f
Cred_6782 vin.P10.GatPoly VSS.$285.Metal1 0.0300532f
Cred_6783 vin.P10.GatPoly VSS.$294.Metal1 0.0119483f
Cred_6784 vin.P10.GatPoly VSS.$304.Metal1 0.00306498f
Cred_6785 vin.P10.GatPoly VSS.$319.Metal1 9.08914e-05f
Cred_6786 vin.P10.GatPoly VSS.$40.Metal1 1.59064e-06f
Cred_6787 vin.P10.GatPoly VSS.$551.Metal1 8.74513e-06f
Cred_6788 vin.P10.GatPoly VSS.$818.Metal2 0.00703869f
Cred_6789 vin.P10.GatPoly VSS.$826.Metal2 0.00946269f
Cred_6790 vin.P10.GatPoly VSS.$840.Metal2 0.00517373f
Cred_6791 vin.P10.GatPoly VSS.$867.Metal2 0.000929772f
Cred_6792 vin.P10.GatPoly VSS.$875.Metal2 0.000280407f
Cred_6793 vin.P10.GatPoly VSS.P0.pSD 0.000968932f
Cred_6794 vin.P10.GatPoly VSS.P11.nSD 0.00172625f
Cred_6795 vin.P10.GatPoly VSS.P13.nSD 3.11894e-06f
Cred_6796 vin.P11.GatPoly vout.$1292.Metal3 0.0200117f
Cred_6797 vin.P11.GatPoly vout.$1358.Metal3 0.0235046f
Cred_6798 vin.P11.GatPoly vout.P10.nSD 0.0212585f
Cred_6799 vin.P11.GatPoly vout.P10.pSD 0.0017075f
Cred_6800 vin.P11.GatPoly vout.P12.nSD 3.60204e-05f
Cred_6801 vin.P11.GatPoly VSS.$1217.Metal3 0.00310713f
Cred_6802 vin.P11.GatPoly VSS.$1229.Metal3 0.00216249f
Cred_6803 vin.P11.GatPoly VSS.$275.Metal1 4.56781e-05f
Cred_6804 vin.P11.GatPoly VSS.$285.Metal1 4.56781e-05f
Cred_6805 vin.P11.GatPoly VSS.$304.Metal1 0.00363803f
Cred_6806 vin.P11.GatPoly VSS.$314.Metal1 0.0133596f
Cred_6807 vin.P11.GatPoly VSS.$319.Metal1 0.0501439f
Cred_6808 vin.P11.GatPoly VSS.$818.Metal2 0.000604799f
Cred_6809 vin.P11.GatPoly VSS.$826.Metal2 0.000604799f
Cred_6810 vin.P11.GatPoly VSS.$852.Metal2 0.00596115f
Cred_6811 vin.P11.GatPoly VSS.$867.Metal2 0.0123889f
Cred_6812 vin.P11.GatPoly VSS.$875.Metal2 0.00311877f
Cred_6813 vin.P11.GatPoly VSS.P0.pSD 7.94272e-06f
Cred_6814 vin.P11.GatPoly VSS.P11.nSD 3.23588e-06f
Cred_6815 vin.P11.GatPoly VSS.P13.nSD 0.00158054f
Cred_6816 vin.P12.GatPoly vout.$1292.Metal3 0.00174096f
Cred_6817 vin.P12.GatPoly vout.$1358.Metal3 0.0441019f
Cred_6818 vin.P12.GatPoly vout.P10.nSD 6.49943e-05f
Cred_6819 vin.P12.GatPoly vout.P10.pSD 0.000148547f
Cred_6820 vin.P12.GatPoly vout.P12.nSD 0.0209145f
Cred_6821 vin.P12.GatPoly VSS.$1229.Metal3 0.00392147f
Cred_6822 vin.P12.GatPoly VSS.$1238.Metal3 0.00116352f
Cred_6823 vin.P12.GatPoly VSS.$18.Metal1 9.10426e-07f
Cred_6824 vin.P12.GatPoly VSS.$319.Metal1 0.0522397f
Cred_6825 vin.P12.GatPoly VSS.$339.Metal1 0.0138943f
Cred_6826 vin.P12.GatPoly VSS.$349.Metal1 0.00190323f
Cred_6827 vin.P12.GatPoly VSS.$372.Metal1 9.77419e-05f
Cred_6828 vin.P12.GatPoly VSS.$40.Metal1 3.52969e-07f
Cred_6829 vin.P12.GatPoly VSS.$551.Metal1 8.25658e-06f
Cred_6830 vin.P12.GatPoly VSS.$867.Metal2 0.0104598f
Cred_6831 vin.P12.GatPoly VSS.$875.Metal2 0.00759902f
Cred_6832 vin.P12.GatPoly VSS.$887.Metal2 0.0038569f
Cred_6833 vin.P12.GatPoly VSS.$905.Metal2 4.41188e-05f
Cred_6834 vin.P12.GatPoly VSS.$914.Metal2 0.00116179f
Cred_6835 vin.P12.GatPoly VSS.P0.pSD 0.000450202f
Cred_6836 vin.P12.GatPoly VSS.P13.nSD 0.00158185f
Cred_6837 vin.P12.GatPoly VSS.P15.nSD 5.34783e-07f
Cred_6838 vin.P13.GatPoly vout.$1358.Metal3 0.0438781f
Cred_6839 vin.P13.GatPoly vout.$1424.Metal3 0.0016688f
Cred_6840 vin.P13.GatPoly vout.P12.nSD 0.0210652f
Cred_6841 vin.P13.GatPoly vout.P14.nSD 6.2436e-05f
Cred_6842 vin.P13.GatPoly vout.P14.pSD 0.000142391f
Cred_6843 vin.P13.GatPoly VSS.$1238.Metal3 0.00328762f
Cred_6844 vin.P13.GatPoly VSS.$1250.Metal3 0.00186687f
Cred_6845 vin.P13.GatPoly VSS.$18.Metal1 6.8971e-07f
Cred_6846 vin.P13.GatPoly VSS.$319.Metal1 9.08914e-05f
Cred_6847 vin.P13.GatPoly VSS.$349.Metal1 0.00662219f
Cred_6848 vin.P13.GatPoly VSS.$361.Metal1 0.0125795f
Cred_6849 vin.P13.GatPoly VSS.$372.Metal1 0.0526906f
Cred_6850 vin.P13.GatPoly VSS.$40.Metal1 2.67399e-07f
Cred_6851 vin.P13.GatPoly VSS.$551.Metal1 9.86538e-06f
Cred_6852 vin.P13.GatPoly VSS.$867.Metal2 0.000929772f
Cred_6853 vin.P13.GatPoly VSS.$875.Metal2 0.000280407f
Cred_6854 vin.P13.GatPoly VSS.$899.Metal2 0.00490436f
Cred_6855 vin.P13.GatPoly VSS.$905.Metal2 0.00336048f
Cred_6856 vin.P13.GatPoly VSS.$914.Metal2 0.00996729f
Cred_6857 vin.P13.GatPoly VSS.P0.pSD 0.000425636f
Cred_6858 vin.P13.GatPoly VSS.P13.nSD 3.11894e-06f
Cred_6859 vin.P13.GatPoly VSS.P15.nSD 0.000211876f
Cred_6860 vin.P14.GatPoly vout.$1358.Metal3 0.0221373f
Cred_6861 vin.P14.GatPoly vout.$1424.Metal3 0.0190586f
Cred_6862 vin.P14.GatPoly vout.P12.nSD 3.21366e-05f
Cred_6863 vin.P14.GatPoly vout.P14.nSD 0.0202809f
Cred_6864 vin.P14.GatPoly vout.P14.pSD 0.00162617f
Cred_6865 vin.P14.GatPoly VSS.$1250.Metal3 0.0040449f
Cred_6866 vin.P14.GatPoly VSS.$1256.Metal3 0.00129152f
Cred_6867 vin.P14.GatPoly VSS.$372.Metal1 0.0525714f
Cred_6868 vin.P14.GatPoly VSS.$379.Metal1 0.0131072f
Cred_6869 vin.P14.GatPoly VSS.$391.Metal1 0.00636954f
Cred_6870 vin.P14.GatPoly VSS.$409.Metal1 9.12515e-05f
Cred_6871 vin.P14.GatPoly VSS.$905.Metal2 0.000362799f
Cred_6872 vin.P14.GatPoly VSS.$914.Metal2 0.0111939f
Cred_6873 vin.P14.GatPoly VSS.$928.Metal2 0.00640991f
Cred_6874 vin.P14.GatPoly VSS.$952.Metal2 0.000368844f
Cred_6875 vin.P14.GatPoly VSS.$961.Metal2 0.000840964f
Cred_6876 vin.P14.GatPoly VSS.P0.pSD 9.43958e-06f
Cred_6877 vin.P14.GatPoly VSS.P15.nSD 0.000209653f
Cred_6878 vin.P14.GatPoly VSS.P17.nSD 3.1313e-06f
Cred_6879 vin.P15.GatPoly vout.$1358.Metal3 0.0208553f
Cred_6880 vin.P15.GatPoly vout.$1424.Metal3 0.0246205f
Cred_6881 vin.P15.GatPoly vout.P14.nSD 0.0222923f
Cred_6882 vin.P15.GatPoly vout.P14.pSD 0.00177948f
Cred_6883 vin.P15.GatPoly vout.P16.nSD 3.8574e-05f
Cred_6884 vin.P15.GatPoly VSS.$1256.Metal3 0.00124462f
Cred_6885 vin.P15.GatPoly VSS.$1265.Metal3 0.00380459f
Cred_6886 vin.P15.GatPoly VSS.$18.Metal1 7.55719e-07f
Cred_6887 vin.P15.GatPoly VSS.$372.Metal1 9.77419e-05f
Cred_6888 vin.P15.GatPoly VSS.$391.Metal1 0.00245705f
Cred_6889 vin.P15.GatPoly VSS.$40.Metal1 2.9299e-07f
Cred_6890 vin.P15.GatPoly VSS.$401.Metal1 0.0137725f
Cred_6891 vin.P15.GatPoly VSS.$409.Metal1 0.0529182f
Cred_6892 vin.P15.GatPoly VSS.$551.Metal1 5.03167e-05f
Cred_6893 vin.P15.GatPoly VSS.$905.Metal2 4.41188e-05f
Cred_6894 vin.P15.GatPoly VSS.$914.Metal2 0.00116179f
Cred_6895 vin.P15.GatPoly VSS.$940.Metal2 0.00421713f
Cred_6896 vin.P15.GatPoly VSS.$952.Metal2 0.00828526f
Cred_6897 vin.P15.GatPoly VSS.$961.Metal2 0.00957111f
Cred_6898 vin.P15.GatPoly VSS.P0.pSD 0.000969177f
Cred_6899 vin.P15.GatPoly VSS.P15.nSD 5.34783e-07f
Cred_6900 vin.P15.GatPoly VSS.P17.nSD 0.00160549f
Cred_6901 vin.P16.GatPoly vout.$1358.Metal3 0.00146532f
Cred_6902 vin.P16.GatPoly vout.$1424.Metal3 0.0415173f
Cred_6903 vin.P16.GatPoly vout.P14.nSD 5.52212e-05f
Cred_6904 vin.P16.GatPoly vout.P14.pSD 0.000125028f
Cred_6905 vin.P16.GatPoly vout.P16.nSD 0.0199875f
Cred_6906 vin.P16.GatPoly VSS.$1002.Metal2 0.00069322f
Cred_6907 vin.P16.GatPoly VSS.$1010.Metal2 0.000516228f
Cred_6908 vin.P16.GatPoly VSS.$1265.Metal3 0.00223927f
Cred_6909 vin.P16.GatPoly VSS.$1277.Metal3 0.00304519f
Cred_6910 vin.P16.GatPoly VSS.$409.Metal1 0.0507412f
Cred_6911 vin.P16.GatPoly VSS.$426.Metal1 0.012594f
Cred_6912 vin.P16.GatPoly VSS.$436.Metal1 0.00427216f
Cred_6913 vin.P16.GatPoly VSS.$453.Metal1 9.15988e-05f
Cred_6914 vin.P16.GatPoly VSS.$952.Metal2 0.00396552f
Cred_6915 vin.P16.GatPoly VSS.$961.Metal2 0.0112197f
Cred_6916 vin.P16.GatPoly VSS.$975.Metal2 0.00579128f
Cred_6917 vin.P16.GatPoly VSS.P0.pSD 1.08137e-05f
Cred_6918 vin.P16.GatPoly VSS.P17.nSD 0.00156039f
Cred_6919 vin.P16.GatPoly VSS.P19.nSD 3.14321e-06f
Cred_6920 vin.P17.GatPoly vout 0.00371378f
Cred_6921 vin.P17.GatPoly vout.$1424.Metal3 0.0432279f
Cred_6922 vin.P17.GatPoly vout.P16.nSD 0.0213543f
Cred_6923 vin.P17.GatPoly vout.P18.nSD 6.21629e-05f
Cred_6924 vin.P17.GatPoly VSS.$1002.Metal2 0.0102301f
Cred_6925 vin.P17.GatPoly VSS.$1010.Metal2 0.00587023f
Cred_6926 vin.P17.GatPoly VSS.$1277.Metal3 0.000600861f
Cred_6927 vin.P17.GatPoly VSS.$1283.Metal3 0.00453804f
Cred_6928 vin.P17.GatPoly VSS.$18.Metal1 3.9182e-07f
Cred_6929 vin.P17.GatPoly VSS.$40.Metal1 1.51907e-07f
Cred_6930 vin.P17.GatPoly VSS.$409.Metal1 9.12515e-05f
Cred_6931 vin.P17.GatPoly VSS.$436.Metal1 0.00353299f
Cred_6932 vin.P17.GatPoly VSS.$448.Metal1 0.0131358f
Cred_6933 vin.P17.GatPoly VSS.$453.Metal1 0.0524354f
Cred_6934 vin.P17.GatPoly VSS.$551.Metal1 0.00010417f
Cred_6935 vin.P17.GatPoly VSS.$952.Metal2 0.000368844f
Cred_6936 vin.P17.GatPoly VSS.$961.Metal2 0.000840964f
Cred_6937 vin.P17.GatPoly VSS.$987.Metal2 0.00544389f
Cred_6938 vin.P17.GatPoly VSS.P0.pSD 0.000953657f
Cred_6939 vin.P17.GatPoly VSS.P1.GatPoly 0.001027f
Cred_6940 vin.P17.GatPoly VSS.P17.nSD 3.1313e-06f
Cred_6941 vin.P17.GatPoly VSS.P19.nSD 0.00161166f
Cred_6942 vin.P18.GatPoly vout 0.0423222f
Cred_6943 vin.P18.GatPoly vout.$1424.Metal3 0.00382507f
Cred_6944 vin.P18.GatPoly vout.P16.nSD 3.91348e-05f
Cred_6945 vin.P18.GatPoly vout.P18.nSD 0.0218175f
Cred_6946 vin.P18.GatPoly VSS.$1002.Metal2 0.00801917f
Cred_6947 vin.P18.GatPoly VSS.$1010.Metal2 0.00601841f
Cred_6948 vin.P18.GatPoly VSS.$1016.Metal2 0.00609126f
Cred_6949 vin.P18.GatPoly VSS.$1028.Metal2 0.00117367f
Cred_6950 vin.P18.GatPoly VSS.$1283.Metal3 0.000960272f
Cred_6951 vin.P18.GatPoly VSS.$1295.Metal3 0.00292108f
Cred_6952 vin.P18.GatPoly VSS.$18.Metal1 1.76892e-07f
Cred_6953 vin.P18.GatPoly VSS.$40.Metal1 6.85805e-08f
Cred_6954 vin.P18.GatPoly VSS.$453.Metal1 0.0593473f
Cred_6955 vin.P18.GatPoly VSS.$476.Metal1 0.0124816f
Cred_6956 vin.P18.GatPoly VSS.$488.Metal1 4.49595e-05f
Cred_6957 vin.P18.GatPoly VSS.$509.Metal1 0.000715635f
Cred_6958 vin.P18.GatPoly VSS.$551.Metal1 9.92675e-05f
Cred_6959 vin.P18.GatPoly VSS.P0.pSD 0.000610857f
Cred_6960 vin.P18.GatPoly VSS.P1.GatPoly 0.00247791f
Cred_6961 vin.P18.GatPoly VSS.P19.nSD 0.00169472f
Cred_6962 vin.P19.GatPoly vout 0.0455926f
Cred_6963 vin.P19.GatPoly vout.P18.nSD 0.0256274f
Cred_6964 vin.P19.GatPoly VSS.$1002.Metal2 0.000795051f
Cred_6965 vin.P19.GatPoly VSS.$1010.Metal2 0.00059206f
Cred_6966 vin.P19.GatPoly VSS.$1028.Metal2 0.00207599f
Cred_6967 vin.P19.GatPoly VSS.$1040.Metal2 0.00836371f
Cred_6968 vin.P19.GatPoly VSS.$1055.Metal2 0.000513858f
Cred_6969 vin.P19.GatPoly VSS.$1066.Metal2 0.0121779f
Cred_6970 vin.P19.GatPoly VSS.$1301.Metal3 0.00526914f
Cred_6971 vin.P19.GatPoly VSS.$1313.Metal3 0.00104245f
Cred_6972 vin.P19.GatPoly VSS.$18.Metal1 2.29008e-06f
Cred_6973 vin.P19.GatPoly VSS.$40.Metal1 8.87858e-07f
Cred_6974 vin.P19.GatPoly VSS.$453.Metal1 0.000105054f
Cred_6975 vin.P19.GatPoly VSS.$476.Metal1 0.000520974f
Cred_6976 vin.P19.GatPoly VSS.$488.Metal1 0.0127985f
Cred_6977 vin.P19.GatPoly VSS.$498.Metal1 0.00612083f
Cred_6978 vin.P19.GatPoly VSS.$509.Metal1 0.0459158f
Cred_6979 vin.P19.GatPoly VSS.$551.Metal1 0.00282267f
Cred_6980 vin.P19.GatPoly VSS.P0.pSD 0.010528f
Cred_6981 vin.P19.GatPoly VSS.P1.GatPoly 0.0413454f
Cred_6982 vin.P19.GatPoly VSS.P19.nSD 3.60494e-06f
Cred_6983 vin.P19.GatPoly VSS.P21.nSD 0.000196828f
Cred_6984 vin.P19.GatPoly VSS.P23.nSD 0.000196828f
Cred_6985 vin.P2.GatPoly vout.$1226.Metal3 0.0391051f
Cred_6986 vin.P2.GatPoly vout.P0.nSD 0.000672504f
Cred_6987 vin.P2.GatPoly vout.P0.pSD 0.00324325f
Cred_6988 vin.P2.GatPoly vout.P2.nSD 0.0219704f
Cred_6989 vin.P2.GatPoly vout.P2.pSD 0.00336693f
Cred_6990 vin.P2.GatPoly VSS.$1130.Metal3 0.00453804f
Cred_6991 vin.P2.GatPoly VSS.$1136.Metal3 0.000600861f
Cred_6992 vin.P2.GatPoly VSS.$115.Metal1 0.0131358f
Cred_6993 vin.P2.GatPoly VSS.$127.Metal1 0.00353299f
Cred_6994 vin.P2.GatPoly VSS.$142.Metal1 9.12515e-05f
Cred_6995 vin.P2.GatPoly VSS.$18.Metal1 7.0169e-05f
Cred_6996 vin.P2.GatPoly VSS.$40.Metal1 2.72043e-05f
Cred_6997 vin.P2.GatPoly VSS.$551.Metal1 5.82489e-07f
Cred_6998 vin.P2.GatPoly VSS.$636.Metal2 0.00586773f
Cred_6999 vin.P2.GatPoly VSS.$644.Metal2 0.0102268f
Cred_7000 vin.P2.GatPoly VSS.$658.Metal2 0.00544389f
Cred_7001 vin.P2.GatPoly VSS.$685.Metal2 0.000840964f
Cred_7002 vin.P2.GatPoly VSS.$693.Metal2 0.000368844f
Cred_7003 vin.P2.GatPoly VSS.$97.Metal1 0.0523574f
Cred_7004 vin.P2.GatPoly VSS.P0.GatPoly 0.001027f
Cred_7005 vin.P2.GatPoly VSS.P0.pSD 0.000960415f
Cred_7006 vin.P2.GatPoly VSS.P3.nSD 0.00160923f
Cred_7007 vin.P2.GatPoly VSS.P5.nSD 3.1313e-06f
Cred_7008 vin.P20.GatPoly vout.$1226.Metal3 0.157012f
Cred_7009 vin.P20.GatPoly vout.P0.nSD 0.00467532f
Cred_7010 vin.P20.GatPoly vout.P0.pSD 0.170345f
Cred_7011 vin.P20.GatPoly vout.P2.nSD 0.00247357f
Cred_7012 vin.P20.GatPoly vout.P2.pSD 0.0135186f
Cred_7013 vin.P20.GatPoly VSS.$1100.Metal3 0.000205646f
Cred_7014 vin.P20.GatPoly VSS.$1112.Metal3 0.000902095f
Cred_7015 vin.P20.GatPoly VSS.$590.Metal2 3.20932e-06f
Cred_7016 vin.P20.GatPoly VSS.$605.Metal2 0.000346468f
Cred_7017 vin.P20.GatPoly VSS.$617.Metal2 1.54727e-07f
Cred_7018 vin.P20.GatPoly VSS.$65.Metal1 1.38226e-08f
Cred_7019 vin.P20.GatPoly VSS.$75.Metal1 1.24057e-09f
Cred_7020 vin.P21.GatPoly vout.$1226.Metal3 0.161435f
Cred_7021 vin.P21.GatPoly vout.P0.nSD 0.0046029f
Cred_7022 vin.P21.GatPoly vout.P0.pSD 0.153286f
Cred_7023 vin.P21.GatPoly vout.P2.nSD 0.00254325f
Cred_7024 vin.P21.GatPoly vout.P2.pSD 0.0165342f
Cred_7025 vin.P22.GatPoly vout.$1226.Metal3 0.17488f
Cred_7026 vin.P22.GatPoly vout.P0.nSD 0.0027129f
Cred_7027 vin.P22.GatPoly vout.P0.pSD 0.0175646f
Cred_7028 vin.P22.GatPoly vout.P2.nSD 0.00275507f
Cred_7029 vin.P22.GatPoly vout.P2.pSD 0.135894f
Cred_7030 vin.P23.GatPoly vout.$1226.Metal3 0.178832f
Cred_7031 vin.P23.GatPoly vout.P0.nSD 0.00236176f
Cred_7032 vin.P23.GatPoly vout.P0.pSD 0.01255f
Cred_7033 vin.P23.GatPoly vout.P2.nSD 0.00256929f
Cred_7034 vin.P23.GatPoly vout.P2.pSD 0.134878f
Cred_7035 vin.P23.GatPoly vout.P4.pSD 0.00261484f
Cred_7036 vin.P24.GatPoly vout.$1226.Metal3 0.217079f
Cred_7037 vin.P24.GatPoly vout.P0.nSD 0.000202493f
Cred_7038 vin.P24.GatPoly vout.P0.pSD 0.00107601f
Cred_7039 vin.P24.GatPoly vout.P2.nSD 0.000220286f
Cred_7040 vin.P24.GatPoly vout.P2.pSD 0.00388488f
Cred_7041 vin.P24.GatPoly vout.P4.pSD 0.126099f
Cred_7042 vin.P25.GatPoly vout.$1226.Metal3 0.210055f
Cred_7043 vin.P25.GatPoly vout.$1292.Metal3 0.00788219f
Cred_7044 vin.P25.GatPoly vout.P4.pSD 0.125558f
Cred_7045 vin.P25.GatPoly vout.P6.nSD 0.000124177f
Cred_7046 vin.P25.GatPoly vout.P6.pSD 0.00335131f
Cred_7047 vin.P26.GatPoly vout.$1226.Metal3 0.108334f
Cred_7048 vin.P26.GatPoly vout.$1292.Metal3 0.0925898f
Cred_7049 vin.P26.GatPoly vout.P4.pSD 0.00261484f
Cred_7050 vin.P26.GatPoly vout.P6.nSD 0.00145867f
Cred_7051 vin.P26.GatPoly vout.P6.pSD 0.128809f
Cred_7052 vin.P27.GatPoly vout.$1226.Metal3 0.0967459f
Cred_7053 vin.P27.GatPoly vout.$1292.Metal3 0.113484f
Cred_7054 vin.P27.GatPoly vout.P6.nSD 0.00152414f
Cred_7055 vin.P27.GatPoly vout.P6.pSD 0.134571f
Cred_7056 vin.P27.GatPoly vout.P8.pSD 0.00268469f
Cred_7057 vin.P28.GatPoly vout.$1226.Metal3 0.00749076f
Cred_7058 vin.P28.GatPoly vout.$1292.Metal3 0.202101f
Cred_7059 vin.P28.GatPoly vout.P6.nSD 0.00011801f
Cred_7060 vin.P28.GatPoly vout.P6.pSD 0.00325979f
Cred_7061 vin.P28.GatPoly vout.P8.pSD 0.120837f
Cred_7062 vin.P29.GatPoly vout.$1292.Metal3 0.202121f
Cred_7063 vin.P29.GatPoly vout.$1358.Metal3 0.00721441f
Cred_7064 vin.P29.GatPoly vout.P10.nSD 0.000113656f
Cred_7065 vin.P29.GatPoly vout.P10.pSD 0.00325688f
Cred_7066 vin.P29.GatPoly vout.P8.pSD 0.121101f
Cred_7067 vin.P3.GatPoly vout.$1226.Metal3 0.0366431f
Cred_7068 vin.P3.GatPoly vout.P0.nSD 0.000486065f
Cred_7069 vin.P3.GatPoly vout.P0.pSD 0.00258287f
Cred_7070 vin.P3.GatPoly vout.P2.nSD 0.0205162f
Cred_7071 vin.P3.GatPoly vout.P2.pSD 0.00288988f
Cred_7072 vin.P3.GatPoly vout.P4.nSD 3.21366e-05f
Cred_7073 vin.P3.GatPoly VSS.$1136.Metal3 0.00304519f
Cred_7074 vin.P3.GatPoly VSS.$1148.Metal3 0.00223927f
Cred_7075 vin.P3.GatPoly VSS.$127.Metal1 0.00427216f
Cred_7076 vin.P3.GatPoly VSS.$137.Metal1 0.012594f
Cred_7077 vin.P3.GatPoly VSS.$142.Metal1 0.0507412f
Cred_7078 vin.P3.GatPoly VSS.$636.Metal2 0.000516228f
Cred_7079 vin.P3.GatPoly VSS.$644.Metal2 0.00069322f
Cred_7080 vin.P3.GatPoly VSS.$670.Metal2 0.00579128f
Cred_7081 vin.P3.GatPoly VSS.$685.Metal2 0.0112197f
Cred_7082 vin.P3.GatPoly VSS.$693.Metal2 0.00396552f
Cred_7083 vin.P3.GatPoly VSS.$97.Metal1 9.15988e-05f
Cred_7084 vin.P3.GatPoly VSS.P0.pSD 1.08137e-05f
Cred_7085 vin.P3.GatPoly VSS.P3.nSD 3.14321e-06f
Cred_7086 vin.P3.GatPoly VSS.P5.nSD 0.00156039f
Cred_7087 vin.P30.GatPoly vout.$1292.Metal3 0.107853f
Cred_7088 vin.P30.GatPoly vout.$1358.Metal3 0.0921085f
Cred_7089 vin.P30.GatPoly vout.P10.nSD 0.00145108f
Cred_7090 vin.P30.GatPoly vout.P10.pSD 0.129779f
Cred_7091 vin.P30.GatPoly vout.P8.pSD 0.00261484f
Cred_7092 vin.P31.GatPoly vout.$1292.Metal3 0.0922492f
Cred_7093 vin.P31.GatPoly vout.$1358.Metal3 0.107407f
Cred_7094 vin.P31.GatPoly vout.P10.nSD 0.0014533f
Cred_7095 vin.P31.GatPoly vout.P10.pSD 0.130055f
Cred_7096 vin.P31.GatPoly vout.P12.pSD 0.00264131f
Cred_7097 vin.P32.GatPoly vout.$1292.Metal3 0.00769983f
Cred_7098 vin.P32.GatPoly vout.$1358.Metal3 0.210191f
Cred_7099 vin.P32.GatPoly vout.P10.nSD 0.000121304f
Cred_7100 vin.P32.GatPoly vout.P10.pSD 0.00337587f
Cred_7101 vin.P32.GatPoly vout.P12.pSD 0.127683f
Cred_7102 vin.P33.GatPoly vout.$1358.Metal3 0.201037f
Cred_7103 vin.P33.GatPoly vout.$1424.Metal3 0.00721441f
Cred_7104 vin.P33.GatPoly vout.P12.pSD 0.122184f
Cred_7105 vin.P33.GatPoly vout.P14.nSD 0.000113656f
Cred_7106 vin.P33.GatPoly vout.P14.pSD 0.00325688f
Cred_7107 vin.P34.GatPoly vout.$1358.Metal3 0.111822f
Cred_7108 vin.P34.GatPoly vout.$1424.Metal3 0.0958195f
Cred_7109 vin.P34.GatPoly vout.P12.pSD 0.00270551f
Cred_7110 vin.P34.GatPoly vout.P14.nSD 0.00150955f
Cred_7111 vin.P34.GatPoly vout.P14.pSD 0.135165f
Cred_7112 vin.P35.GatPoly vout.$1358.Metal3 0.0962818f
Cred_7113 vin.P35.GatPoly vout.$1424.Metal3 0.112405f
Cred_7114 vin.P35.GatPoly vout.P14.nSD 0.00151683f
Cred_7115 vin.P35.GatPoly vout.P14.pSD 0.135805f
Cred_7116 vin.P35.GatPoly vout.P16.pSD 0.00271475f
Cred_7117 vin.P36.GatPoly vout.$1358.Metal3 0.00721441f
Cred_7118 vin.P36.GatPoly vout.$1424.Metal3 0.201532f
Cred_7119 vin.P36.GatPoly vout.P14.nSD 0.000113656f
Cred_7120 vin.P36.GatPoly vout.P14.pSD 0.00325688f
Cred_7121 vin.P36.GatPoly vout.P16.pSD 0.122625f
Cred_7122 vin.P37.GatPoly vout 0.0146486f
Cred_7123 vin.P37.GatPoly vout.$1424.Metal3 0.193823f
Cred_7124 vin.P37.GatPoly vout.P16.pSD 0.122184f
Cred_7125 vin.P37.GatPoly vout.P18.pSD 0.00315078f
Cred_7126 vin.P38.GatPoly vout 0.190492f
Cred_7127 vin.P38.GatPoly vout.$1424.Metal3 0.015158f
Cred_7128 vin.P38.GatPoly vout.P16.pSD 0.00264131f
Cred_7129 vin.P38.GatPoly vout.P18.pSD 0.130109f
Cred_7130 vin.P39.GatPoly vout 0.202702f
Cred_7131 vin.P39.GatPoly vout.P18.pSD 0.147794f
Cred_7132 vin.P39.GatPoly VSS.$1028.Metal2 1.75872e-07f
Cred_7133 vin.P39.GatPoly VSS.$1040.Metal2 0.00035362f
Cred_7134 vin.P39.GatPoly VSS.$1055.Metal2 3.27541e-06f
Cred_7135 vin.P39.GatPoly VSS.$1301.Metal3 0.000920672f
Cred_7136 vin.P39.GatPoly VSS.$1313.Metal3 0.00020988f
Cred_7137 vin.P39.GatPoly VSS.$488.Metal1 1.4101e-09f
Cred_7138 vin.P39.GatPoly VSS.$498.Metal1 1.41073e-08f
Cred_7139 vin.P4.GatPoly vout.$1226.Metal3 0.0469739f
Cred_7140 vin.P4.GatPoly vout.P0.nSD 4.56947e-05f
Cred_7141 vin.P4.GatPoly vout.P0.pSD 0.000242814f
Cred_7142 vin.P4.GatPoly vout.P2.nSD 8.82839e-05f
Cred_7143 vin.P4.GatPoly vout.P2.pSD 0.000271676f
Cred_7144 vin.P4.GatPoly vout.P4.nSD 0.0219637f
Cred_7145 vin.P4.GatPoly VSS.$1148.Metal3 0.00380459f
Cred_7146 vin.P4.GatPoly VSS.$1157.Metal3 0.00124462f
Cred_7147 vin.P4.GatPoly VSS.$142.Metal1 0.0529182f
Cred_7148 vin.P4.GatPoly VSS.$162.Metal1 0.0137725f
Cred_7149 vin.P4.GatPoly VSS.$172.Metal1 0.00245705f
Cred_7150 vin.P4.GatPoly VSS.$18.Metal1 3.38933e-05f
Cred_7151 vin.P4.GatPoly VSS.$195.Metal1 9.77419e-05f
Cred_7152 vin.P4.GatPoly VSS.$40.Metal1 1.31403e-05f
Cred_7153 vin.P4.GatPoly VSS.$551.Metal1 1.1223e-06f
Cred_7154 vin.P4.GatPoly VSS.$685.Metal2 0.00957111f
Cred_7155 vin.P4.GatPoly VSS.$693.Metal2 0.00828526f
Cred_7156 vin.P4.GatPoly VSS.$705.Metal2 0.00421713f
Cred_7157 vin.P4.GatPoly VSS.$732.Metal2 0.00116179f
Cred_7158 vin.P4.GatPoly VSS.$740.Metal2 4.41188e-05f
Cred_7159 vin.P4.GatPoly VSS.P0.pSD 0.000972387f
Cred_7160 vin.P4.GatPoly VSS.P5.nSD 0.00160549f
Cred_7161 vin.P4.GatPoly VSS.P7.nSD 5.34783e-07f
Cred_7162 vin.P5.GatPoly vout.$1226.Metal3 0.0415084f
Cred_7163 vin.P5.GatPoly vout.$1292.Metal3 0.00146478f
Cred_7164 vin.P5.GatPoly vout.P4.nSD 0.0199807f
Cred_7165 vin.P5.GatPoly vout.P6.nSD 5.52127e-05f
Cred_7166 vin.P5.GatPoly vout.P6.pSD 0.000126117f
Cred_7167 vin.P5.GatPoly VSS.$1157.Metal3 0.00328205f
Cred_7168 vin.P5.GatPoly VSS.$1169.Metal3 0.00199053f
Cred_7169 vin.P5.GatPoly VSS.$142.Metal1 9.12515e-05f
Cred_7170 vin.P5.GatPoly VSS.$172.Metal1 0.00636954f
Cred_7171 vin.P5.GatPoly VSS.$184.Metal1 0.0131074f
Cred_7172 vin.P5.GatPoly VSS.$195.Metal1 0.0525714f
Cred_7173 vin.P5.GatPoly VSS.$685.Metal2 0.000840964f
Cred_7174 vin.P5.GatPoly VSS.$693.Metal2 0.000368844f
Cred_7175 vin.P5.GatPoly VSS.$717.Metal2 0.00644176f
Cred_7176 vin.P5.GatPoly VSS.$732.Metal2 0.0112258f
Cred_7177 vin.P5.GatPoly VSS.$740.Metal2 0.000362799f
Cred_7178 vin.P5.GatPoly VSS.P0.pSD 9.43958e-06f
Cred_7179 vin.P5.GatPoly VSS.P5.nSD 3.1313e-06f
Cred_7180 vin.P5.GatPoly VSS.P7.nSD 0.000209653f
Cred_7181 vin.P6.GatPoly vout.$1226.Metal3 0.0235882f
Cred_7182 vin.P6.GatPoly vout.$1292.Metal3 0.020082f
Cred_7183 vin.P6.GatPoly vout.P4.nSD 3.61456e-05f
Cred_7184 vin.P6.GatPoly vout.P6.nSD 0.0213815f
Cred_7185 vin.P6.GatPoly vout.P6.pSD 0.00172905f
Cred_7186 vin.P6.GatPoly VSS.$1169.Metal3 0.00379373f
Cred_7187 vin.P6.GatPoly VSS.$1175.Metal3 0.00142075f
Cred_7188 vin.P6.GatPoly VSS.$18.Metal1 6.64531e-06f
Cred_7189 vin.P6.GatPoly VSS.$195.Metal1 0.0526906f
Cred_7190 vin.P6.GatPoly VSS.$202.Metal1 0.0125795f
Cred_7191 vin.P6.GatPoly VSS.$212.Metal1 0.00662219f
Cred_7192 vin.P6.GatPoly VSS.$232.Metal1 9.08914e-05f
Cred_7193 vin.P6.GatPoly VSS.$40.Metal1 2.57637e-06f
Cred_7194 vin.P6.GatPoly VSS.$551.Metal1 1.02399e-06f
Cred_7195 vin.P6.GatPoly VSS.$732.Metal2 0.00995232f
Cred_7196 vin.P6.GatPoly VSS.$740.Metal2 0.00333043f
Cred_7197 vin.P6.GatPoly VSS.$746.Metal2 0.00488939f
Cred_7198 vin.P6.GatPoly VSS.$770.Metal2 0.000280407f
Cred_7199 vin.P6.GatPoly VSS.$779.Metal2 0.000929772f
Cred_7200 vin.P6.GatPoly VSS.P0.pSD 0.000426213f
Cred_7201 vin.P6.GatPoly VSS.P10.nSD 3.11894e-06f
Cred_7202 vin.P6.GatPoly VSS.P7.nSD 0.000211876f
Cred_7203 vin.P7.GatPoly vout.$1226.Metal3 0.0201541f
Cred_7204 vin.P7.GatPoly vout.$1292.Metal3 0.023812f
Cred_7205 vin.P7.GatPoly vout.P6.nSD 0.021232f
Cred_7206 vin.P7.GatPoly vout.P6.pSD 0.00173526f
Cred_7207 vin.P7.GatPoly vout.P8.nSD 3.75672e-05f
Cred_7208 vin.P7.GatPoly VSS.$1175.Metal3 0.00116352f
Cred_7209 vin.P7.GatPoly VSS.$1184.Metal3 0.00392147f
Cred_7210 vin.P7.GatPoly VSS.$18.Metal1 5.56162e-06f
Cred_7211 vin.P7.GatPoly VSS.$195.Metal1 9.77419e-05f
Cred_7212 vin.P7.GatPoly VSS.$212.Metal1 0.00190323f
Cred_7213 vin.P7.GatPoly VSS.$224.Metal1 0.0138943f
Cred_7214 vin.P7.GatPoly VSS.$232.Metal1 0.0522397f
Cred_7215 vin.P7.GatPoly VSS.$40.Metal1 2.15622e-06f
Cred_7216 vin.P7.GatPoly VSS.$551.Metal1 1.35165e-06f
Cred_7217 vin.P7.GatPoly VSS.$732.Metal2 0.00116179f
Cred_7218 vin.P7.GatPoly VSS.$740.Metal2 4.41188e-05f
Cred_7219 vin.P7.GatPoly VSS.$758.Metal2 0.0038569f
Cred_7220 vin.P7.GatPoly VSS.$770.Metal2 0.00759902f
Cred_7221 vin.P7.GatPoly VSS.$779.Metal2 0.0104598f
Cred_7222 vin.P7.GatPoly VSS.P0.pSD 0.000450653f
Cred_7223 vin.P7.GatPoly VSS.P10.nSD 0.00158185f
Cred_7224 vin.P7.GatPoly VSS.P7.nSD 5.34783e-07f
Cred_7225 vin.P8.GatPoly vout.$1226.Metal3 0.00166184f
Cred_7226 vin.P8.GatPoly vout.$1292.Metal3 0.0437079f
Cred_7227 vin.P8.GatPoly vout.P6.nSD 6.22011e-05f
Cred_7228 vin.P8.GatPoly vout.P6.pSD 0.000143083f
Cred_7229 vin.P8.GatPoly vout.P8.nSD 0.0209432f
Cred_7230 vin.P8.GatPoly VSS.$1184.Metal3 0.00216249f
Cred_7231 vin.P8.GatPoly VSS.$1196.Metal3 0.00310713f
Cred_7232 vin.P8.GatPoly VSS.$232.Metal1 0.0501439f
Cred_7233 vin.P8.GatPoly VSS.$247.Metal1 0.0133596f
Cred_7234 vin.P8.GatPoly VSS.$259.Metal1 0.00363803f
Cred_7235 vin.P8.GatPoly VSS.$275.Metal1 4.56781e-05f
Cred_7236 vin.P8.GatPoly VSS.$285.Metal1 4.56781e-05f
Cred_7237 vin.P8.GatPoly VSS.$770.Metal2 0.00311877f
Cred_7238 vin.P8.GatPoly VSS.$779.Metal2 0.0123889f
Cred_7239 vin.P8.GatPoly VSS.$793.Metal2 0.00596115f
Cred_7240 vin.P8.GatPoly VSS.$818.Metal2 0.000604799f
Cred_7241 vin.P8.GatPoly VSS.$826.Metal2 0.000604799f
Cred_7242 vin.P8.GatPoly VSS.P0.pSD 7.94272e-06f
Cred_7243 vin.P8.GatPoly VSS.P10.nSD 0.00158054f
Cred_7244 vin.P8.GatPoly VSS.P11.nSD 3.23588e-06f
Cred_7245 vin.P9.GatPoly vout.$1292.Metal3 0.0439693f
Cred_7246 vin.P9.GatPoly vout.$1358.Metal3 0.0017235f
Cred_7247 vin.P9.GatPoly vout.P10.nSD 6.43754e-05f
Cred_7248 vin.P9.GatPoly vout.P10.pSD 0.000147058f
Cred_7249 vin.P9.GatPoly vout.P8.nSD 0.0208872f
Cred_7250 vin.P9.GatPoly VSS 0.0022234f
Cred_7251 vin.P9.GatPoly VSS.$1196.Metal3 0.00166533f
Cred_7252 vin.P9.GatPoly VSS.$18.Metal1 2.4059e-06f
Cred_7253 vin.P9.GatPoly VSS.$232.Metal1 9.08914e-05f
Cred_7254 vin.P9.GatPoly VSS.$259.Metal1 0.00306498f
Cred_7255 vin.P9.GatPoly VSS.$269.Metal1 0.0119483f
Cred_7256 vin.P9.GatPoly VSS.$275.Metal1 0.0292614f
Cred_7257 vin.P9.GatPoly VSS.$285.Metal1 0.0247052f
Cred_7258 vin.P9.GatPoly VSS.$40.Metal1 9.32759e-07f
Cred_7259 vin.P9.GatPoly VSS.$551.Metal1 2.28983e-06f
Cred_7260 vin.P9.GatPoly VSS.$770.Metal2 0.000280407f
Cred_7261 vin.P9.GatPoly VSS.$779.Metal2 0.000929772f
Cred_7262 vin.P9.GatPoly VSS.$805.Metal2 0.00517373f
Cred_7263 vin.P9.GatPoly VSS.$818.Metal2 0.00931953f
Cred_7264 vin.P9.GatPoly VSS.$826.Metal2 0.00689554f
Cred_7265 vin.P9.GatPoly VSS.P0.pSD 0.000384942f
Cred_7266 vin.P9.GatPoly VSS.P10.nSD 3.11894e-06f
Cred_7267 vin.P9.GatPoly VSS.P11.nSD 0.00167382f
Cred_7268 vout VSS.$1002.Metal2 0.0344797f
Cred_7269 vout VSS.$1010.Metal2 0.0257202f
Cred_7270 vout VSS.$1016.Metal2 0.00274615f
Cred_7271 vout VSS.$1028.Metal2 0.0131507f
Cred_7272 vout VSS.$1040.Metal2 0.000701567f
Cred_7273 vout VSS.$1066.Metal2 0.0551388f
Cred_7274 vout VSS.$1283.Metal3 0.00431945f
Cred_7275 vout VSS.$1295.Metal3 0.0284856f
Cred_7276 vout VSS.$1301.Metal3 0.0151004f
Cred_7277 vout VSS.$18.Metal1 3.3047e-06f
Cred_7278 vout VSS.$40.Metal1 1.28122e-06f
Cred_7279 vout VSS.$453.Metal1 0.0242045f
Cred_7280 vout VSS.$476.Metal1 0.00914916f
Cred_7281 vout VSS.$488.Metal1 0.00548028f
Cred_7282 vout VSS.$509.Metal1 0.0182253f
Cred_7283 vout VSS.$551.Metal1 0.00440326f
Cred_7284 vout VSS.P0.pSD 0.0149793f
Cred_7285 vout VSS.P1.GatPoly 0.00121616f
Cred_7286 vout VSS.P19.nSD 0.000831831f
Cred_7287 vout VSS.P21.nSD 9.46076e-05f
Cred_7288 vout VSS.P23.nSD 9.46076e-05f
Cred_7289 vout.$1226.Metal3 VSS.$1112.Metal3 0.011707f
Cred_7290 vout.$1226.Metal3 VSS.$1118.Metal3 0.0236286f
Cred_7291 vout.$1226.Metal3 VSS.$1130.Metal3 0.0205125f
Cred_7292 vout.$1226.Metal3 VSS.$1136.Metal3 0.028883f
Cred_7293 vout.$1226.Metal3 VSS.$1148.Metal3 0.0262196f
Cred_7294 vout.$1226.Metal3 VSS.$115.Metal1 0.00143431f
Cred_7295 vout.$1226.Metal3 VSS.$1157.Metal3 0.037681f
Cred_7296 vout.$1226.Metal3 VSS.$1169.Metal3 0.0152513f
Cred_7297 vout.$1226.Metal3 VSS.$1175.Metal3 0.0148839f
Cred_7298 vout.$1226.Metal3 VSS.$1184.Metal3 0.00794511f
Cred_7299 vout.$1226.Metal3 VSS.$1196.Metal3 0.000191033f
Cred_7300 vout.$1226.Metal3 VSS.$127.Metal1 0.0101588f
Cred_7301 vout.$1226.Metal3 VSS.$137.Metal1 0.00150148f
Cred_7302 vout.$1226.Metal3 VSS.$142.Metal1 0.0445797f
Cred_7303 vout.$1226.Metal3 VSS.$162.Metal1 0.00303436f
Cred_7304 vout.$1226.Metal3 VSS.$172.Metal1 0.0116204f
Cred_7305 vout.$1226.Metal3 VSS.$18.Metal1 0.00285835f
Cred_7306 vout.$1226.Metal3 VSS.$184.Metal1 0.00078629f
Cred_7307 vout.$1226.Metal3 VSS.$195.Metal1 0.039046f
Cred_7308 vout.$1226.Metal3 VSS.$212.Metal1 0.00571023f
Cred_7309 vout.$1226.Metal3 VSS.$224.Metal1 0.0016274f
Cred_7310 vout.$1226.Metal3 VSS.$232.Metal1 0.0115734f
Cred_7311 vout.$1226.Metal3 VSS.$247.Metal1 1.22317e-08f
Cred_7312 vout.$1226.Metal3 VSS.$40.Metal1 0.0151931f
Cred_7313 vout.$1226.Metal3 VSS.$551.Metal1 3.31449e-05f
Cred_7314 vout.$1226.Metal3 VSS.$564.Metal2 0.0419857f
Cred_7315 vout.$1226.Metal3 VSS.$605.Metal2 0.00054391f
Cred_7316 vout.$1226.Metal3 VSS.$617.Metal2 0.0101954f
Cred_7317 vout.$1226.Metal3 VSS.$629.Metal2 0.00214141f
Cred_7318 vout.$1226.Metal3 VSS.$636.Metal2 0.0430427f
Cred_7319 vout.$1226.Metal3 VSS.$644.Metal2 0.0577559f
Cred_7320 vout.$1226.Metal3 VSS.$658.Metal2 0.00747607f
Cred_7321 vout.$1226.Metal3 VSS.$670.Metal2 0.00657857f
Cred_7322 vout.$1226.Metal3 VSS.$685.Metal2 0.0775834f
Cred_7323 vout.$1226.Metal3 VSS.$693.Metal2 0.0340114f
Cred_7324 vout.$1226.Metal3 VSS.$705.Metal2 0.0122905f
Cred_7325 vout.$1226.Metal3 VSS.$717.Metal2 0.00497092f
Cred_7326 vout.$1226.Metal3 VSS.$732.Metal2 0.0831234f
Cred_7327 vout.$1226.Metal3 VSS.$740.Metal2 0.00315199f
Cred_7328 vout.$1226.Metal3 VSS.$746.Metal2 0.00222416f
Cred_7329 vout.$1226.Metal3 VSS.$75.Metal1 0.00424874f
Cred_7330 vout.$1226.Metal3 VSS.$758.Metal2 0.00602652f
Cred_7331 vout.$1226.Metal3 VSS.$770.Metal2 0.00652161f
Cred_7332 vout.$1226.Metal3 VSS.$779.Metal2 0.0215716f
Cred_7333 vout.$1226.Metal3 VSS.$793.Metal2 3.05723e-06f
Cred_7334 vout.$1226.Metal3 VSS.$85.Metal1 0.00709314f
Cred_7335 vout.$1226.Metal3 VSS.$97.Metal1 0.0395069f
Cred_7336 vout.$1226.Metal3 VSS.P0.GatPoly 0.000942865f
Cred_7337 vout.$1226.Metal3 VSS.P0.nSD 7.31582e-05f
Cred_7338 vout.$1226.Metal3 VSS.P0.pSD 0.0315412f
Cred_7339 vout.$1226.Metal3 VSS.P1.nSD 7.31582e-05f
Cred_7340 vout.$1226.Metal3 VSS.P10.nSD 0.000397737f
Cred_7341 vout.$1226.Metal3 VSS.P3.nSD 0.0013578f
Cred_7342 vout.$1226.Metal3 VSS.P5.nSD 0.00153122f
Cred_7343 vout.$1226.Metal3 VSS.P7.nSD 0.000214872f
Cred_7344 vout.$1292.Metal3 VSS 0.0213941f
Cred_7345 vout.$1292.Metal3 VSS.$1157.Metal3 0.000329966f
Cred_7346 vout.$1292.Metal3 VSS.$1169.Metal3 0.00754201f
Cred_7347 vout.$1292.Metal3 VSS.$1175.Metal3 0.0148839f
Cred_7348 vout.$1292.Metal3 VSS.$1184.Metal3 0.0169262f
Cred_7349 vout.$1292.Metal3 VSS.$1196.Metal3 0.0416335f
Cred_7350 vout.$1292.Metal3 VSS.$1217.Metal3 0.0192775f
Cred_7351 vout.$1292.Metal3 VSS.$1229.Metal3 0.0042745f
Cred_7352 vout.$1292.Metal3 VSS.$18.Metal1 0.000141366f
Cred_7353 vout.$1292.Metal3 VSS.$184.Metal1 2.11275e-08f
Cred_7354 vout.$1292.Metal3 VSS.$195.Metal1 0.0125235f
Cred_7355 vout.$1292.Metal3 VSS.$212.Metal1 0.00571023f
Cred_7356 vout.$1292.Metal3 VSS.$224.Metal1 0.0016274f
Cred_7357 vout.$1292.Metal3 VSS.$232.Metal1 0.035782f
Cred_7358 vout.$1292.Metal3 VSS.$247.Metal1 0.00124702f
Cred_7359 vout.$1292.Metal3 VSS.$259.Metal1 0.0122343f
Cred_7360 vout.$1292.Metal3 VSS.$269.Metal1 0.0019424f
Cred_7361 vout.$1292.Metal3 VSS.$275.Metal1 0.0178931f
Cred_7362 vout.$1292.Metal3 VSS.$285.Metal1 0.0178931f
Cred_7363 vout.$1292.Metal3 VSS.$294.Metal1 0.000924448f
Cred_7364 vout.$1292.Metal3 VSS.$304.Metal1 0.00582285f
Cred_7365 vout.$1292.Metal3 VSS.$314.Metal1 0.000593509f
Cred_7366 vout.$1292.Metal3 VSS.$319.Metal1 0.0115776f
Cred_7367 vout.$1292.Metal3 VSS.$40.Metal1 5.48073e-05f
Cred_7368 vout.$1292.Metal3 VSS.$551.Metal1 0.000105255f
Cred_7369 vout.$1292.Metal3 VSS.$717.Metal2 5.28067e-06f
Cred_7370 vout.$1292.Metal3 VSS.$732.Metal2 0.0276261f
Cred_7371 vout.$1292.Metal3 VSS.$740.Metal2 0.00104869f
Cred_7372 vout.$1292.Metal3 VSS.$746.Metal2 0.00222416f
Cred_7373 vout.$1292.Metal3 VSS.$758.Metal2 0.00602652f
Cred_7374 vout.$1292.Metal3 VSS.$770.Metal2 0.0209952f
Cred_7375 vout.$1292.Metal3 VSS.$779.Metal2 0.0696888f
Cred_7376 vout.$1292.Metal3 VSS.$793.Metal2 0.00712489f
Cred_7377 vout.$1292.Metal3 VSS.$805.Metal2 0.0097592f
Cred_7378 vout.$1292.Metal3 VSS.$818.Metal2 0.0444931f
Cred_7379 vout.$1292.Metal3 VSS.$826.Metal2 0.0444298f
Cred_7380 vout.$1292.Metal3 VSS.$840.Metal2 0.0046377f
Cred_7381 vout.$1292.Metal3 VSS.$852.Metal2 0.00338961f
Cred_7382 vout.$1292.Metal3 VSS.$867.Metal2 0.0216334f
Cred_7383 vout.$1292.Metal3 VSS.$875.Metal2 0.00650627f
Cred_7384 vout.$1292.Metal3 VSS.P0.pSD 0.0172954f
Cred_7385 vout.$1292.Metal3 VSS.P10.nSD 0.00122845f
Cred_7386 vout.$1292.Metal3 VSS.P11.nSD 0.00126882f
Cred_7387 vout.$1292.Metal3 VSS.P13.nSD 0.000397883f
Cred_7388 vout.$1292.Metal3 VSS.P7.nSD 6.85043e-05f
Cred_7389 vout.$1358.Metal3 VSS 0.00720773f
Cred_7390 vout.$1358.Metal3 VSS.$1217.Metal3 0.019679f
Cred_7391 vout.$1358.Metal3 VSS.$1229.Metal3 0.024633f
Cred_7392 vout.$1358.Metal3 VSS.$1238.Metal3 0.0371477f
Cred_7393 vout.$1358.Metal3 VSS.$1250.Metal3 0.0145463f
Cred_7394 vout.$1358.Metal3 VSS.$1256.Metal3 0.0151582f
Cred_7395 vout.$1358.Metal3 VSS.$1265.Metal3 0.00738557f
Cred_7396 vout.$1358.Metal3 VSS.$1277.Metal3 0.000138985f
Cred_7397 vout.$1358.Metal3 VSS.$18.Metal1 3.58491e-05f
Cred_7398 vout.$1358.Metal3 VSS.$275.Metal1 0.00575153f
Cred_7399 vout.$1358.Metal3 VSS.$285.Metal1 0.00575153f
Cred_7400 vout.$1358.Metal3 VSS.$294.Metal1 0.000924448f
Cred_7401 vout.$1358.Metal3 VSS.$304.Metal1 0.00582285f
Cred_7402 vout.$1358.Metal3 VSS.$314.Metal1 0.000593535f
Cred_7403 vout.$1358.Metal3 VSS.$319.Metal1 0.0357239f
Cred_7404 vout.$1358.Metal3 VSS.$339.Metal1 0.00342056f
Cred_7405 vout.$1358.Metal3 VSS.$349.Metal1 0.0120021f
Cred_7406 vout.$1358.Metal3 VSS.$372.Metal1 0.0389859f
Cred_7407 vout.$1358.Metal3 VSS.$379.Metal1 0.000374036f
Cred_7408 vout.$1358.Metal3 VSS.$391.Metal1 0.00553067f
Cred_7409 vout.$1358.Metal3 VSS.$40.Metal1 1.38986e-05f
Cred_7410 vout.$1358.Metal3 VSS.$401.Metal1 0.00144418f
Cred_7411 vout.$1358.Metal3 VSS.$409.Metal1 0.011586f
Cred_7412 vout.$1358.Metal3 VSS.$426.Metal1 8.89907e-09f
Cred_7413 vout.$1358.Metal3 VSS.$551.Metal1 0.000446101f
Cred_7414 vout.$1358.Metal3 VSS.$818.Metal2 0.0148684f
Cred_7415 vout.$1358.Metal3 VSS.$826.Metal2 0.0149225f
Cred_7416 vout.$1358.Metal3 VSS.$840.Metal2 0.0046377f
Cred_7417 vout.$1358.Metal3 VSS.$852.Metal2 0.00339603f
Cred_7418 vout.$1358.Metal3 VSS.$867.Metal2 0.0690804f
Cred_7419 vout.$1358.Metal3 VSS.$875.Metal2 0.0208504f
Cred_7420 vout.$1358.Metal3 VSS.$887.Metal2 0.0126735f
Cred_7421 vout.$1358.Metal3 VSS.$899.Metal2 0.00472462f
Cred_7422 vout.$1358.Metal3 VSS.$905.Metal2 0.00325732f
Cred_7423 vout.$1358.Metal3 VSS.$914.Metal2 0.0832125f
Cred_7424 vout.$1358.Metal3 VSS.$928.Metal2 0.00231708f
Cred_7425 vout.$1358.Metal3 VSS.$940.Metal2 0.00584427f
Cred_7426 vout.$1358.Metal3 VSS.$952.Metal2 0.00857438f
Cred_7427 vout.$1358.Metal3 VSS.$961.Metal2 0.0195173f
Cred_7428 vout.$1358.Metal3 VSS.$975.Metal2 2.22427e-06f
Cred_7429 vout.$1358.Metal3 VSS.P0.pSD 0.0176299f
Cred_7430 vout.$1358.Metal3 VSS.P11.nSD 0.00040744f
Cred_7431 vout.$1358.Metal3 VSS.P13.nSD 0.00122643f
Cred_7432 vout.$1358.Metal3 VSS.P15.nSD 0.000214756f
Cred_7433 vout.$1358.Metal3 VSS.P17.nSD 0.00039817f
Cred_7434 vout.$1424.Metal3 VSS.$1002.Metal2 0.0378465f
Cred_7435 vout.$1424.Metal3 VSS.$1010.Metal2 0.0281806f
Cred_7436 vout.$1424.Metal3 VSS.$1016.Metal2 1.16418e-05f
Cred_7437 vout.$1424.Metal3 VSS.$1238.Metal3 0.000382195f
Cred_7438 vout.$1424.Metal3 VSS.$1250.Metal3 0.00731403f
Cred_7439 vout.$1424.Metal3 VSS.$1256.Metal3 0.0151582f
Cred_7440 vout.$1424.Metal3 VSS.$1265.Metal3 0.0168435f
Cred_7441 vout.$1424.Metal3 VSS.$1277.Metal3 0.0342563f
Cred_7442 vout.$1424.Metal3 VSS.$1283.Metal3 0.0166908f
Cred_7443 vout.$1424.Metal3 VSS.$1295.Metal3 0.001452f
Cred_7444 vout.$1424.Metal3 VSS.$18.Metal1 8.37147e-06f
Cred_7445 vout.$1424.Metal3 VSS.$372.Metal1 0.0124634f
Cred_7446 vout.$1424.Metal3 VSS.$379.Metal1 0.000374036f
Cred_7447 vout.$1424.Metal3 VSS.$391.Metal1 0.00553067f
Cred_7448 vout.$1424.Metal3 VSS.$40.Metal1 3.24559e-06f
Cred_7449 vout.$1424.Metal3 VSS.$401.Metal1 0.00144418f
Cred_7450 vout.$1424.Metal3 VSS.$409.Metal1 0.0350706f
Cred_7451 vout.$1424.Metal3 VSS.$426.Metal1 0.00179168f
Cred_7452 vout.$1424.Metal3 VSS.$436.Metal1 0.0121224f
Cred_7453 vout.$1424.Metal3 VSS.$448.Metal1 0.00171154f
Cred_7454 vout.$1424.Metal3 VSS.$453.Metal1 0.0249288f
Cred_7455 vout.$1424.Metal3 VSS.$551.Metal1 0.00102126f
Cred_7456 vout.$1424.Metal3 VSS.$899.Metal2 3.06435e-06f
Cred_7457 vout.$1424.Metal3 VSS.$905.Metal2 0.00106026f
Cred_7458 vout.$1424.Metal3 VSS.$914.Metal2 0.0277675f
Cred_7459 vout.$1424.Metal3 VSS.$928.Metal2 0.00231708f
Cred_7460 vout.$1424.Metal3 VSS.$940.Metal2 0.00584427f
Cred_7461 vout.$1424.Metal3 VSS.$952.Metal2 0.0265344f
Cred_7462 vout.$1424.Metal3 VSS.$961.Metal2 0.0605978f
Cred_7463 vout.$1424.Metal3 VSS.$975.Metal2 0.00784677f
Cred_7464 vout.$1424.Metal3 VSS.$987.Metal2 0.0089211f
Cred_7465 vout.$1424.Metal3 VSS.P0.pSD 0.0131557f
Cred_7466 vout.$1424.Metal3 VSS.P15.nSD 6.83883e-05f
Cred_7467 vout.$1424.Metal3 VSS.P17.nSD 0.00120528f
Cred_7468 vout.$1424.Metal3 VSS.P19.nSD 0.000856809f
Cred_7469 vout.P0.nSD VSS.$1112.Metal3 0.000616807f
Cred_7470 vout.P0.nSD VSS.$1118.Metal3 0.00108151f
Cred_7471 vout.P0.nSD VSS.$1130.Metal3 0.000387181f
Cred_7472 vout.P0.nSD VSS.$1136.Metal3 0.000414042f
Cred_7473 vout.P0.nSD VSS.$1148.Metal3 0.00011478f
Cred_7474 vout.P0.nSD VSS.$115.Metal1 2.0771e-05f
Cred_7475 vout.P0.nSD VSS.$127.Metal1 0.000147115f
Cred_7476 vout.P0.nSD VSS.$137.Metal1 2.17435e-05f
Cred_7477 vout.P0.nSD VSS.$142.Metal1 0.000285006f
Cred_7478 vout.P0.nSD VSS.$18.Metal1 6.86479e-05f
Cred_7479 vout.P0.nSD VSS.$40.Metal1 0.0133987f
Cred_7480 vout.P0.nSD VSS.$551.Metal1 1.80263e-07f
Cred_7481 vout.P0.nSD VSS.$564.Metal2 0.0105219f
Cred_7482 vout.P0.nSD VSS.$605.Metal2 0.000230515f
Cred_7483 vout.P0.nSD VSS.$617.Metal2 0.00431376f
Cred_7484 vout.P0.nSD VSS.$629.Metal2 0.000885273f
Cred_7485 vout.P0.nSD VSS.$636.Metal2 0.00662244f
Cred_7486 vout.P0.nSD VSS.$644.Metal2 0.00889166f
Cred_7487 vout.P0.nSD VSS.$658.Metal2 0.000108265f
Cred_7488 vout.P0.nSD VSS.$670.Metal2 9.52003e-05f
Cred_7489 vout.P0.nSD VSS.$685.Metal2 0.000498548f
Cred_7490 vout.P0.nSD VSS.$693.Metal2 0.00021796f
Cred_7491 vout.P0.nSD VSS.$75.Metal1 0.00398946f
Cred_7492 vout.P0.nSD VSS.$85.Metal1 0.00606431f
Cred_7493 vout.P0.nSD VSS.$97.Metal1 0.018586f
Cred_7494 vout.P0.nSD VSS.P0.GatPoly 4.73622e-05f
Cred_7495 vout.P0.nSD VSS.P0.nSD 7.15446e-05f
Cred_7496 vout.P0.nSD VSS.P0.pSD 0.000435561f
Cred_7497 vout.P0.nSD VSS.P1.nSD 7.15446e-05f
Cred_7498 vout.P0.nSD VSS.P3.nSD 0.000638325f
Cred_7499 vout.P0.nSD VSS.P5.nSD 9.79499e-06f
Cred_7500 vout.P0.pSD VSS.$1112.Metal3 0.0018524f
Cred_7501 vout.P0.pSD VSS.$1118.Metal3 0.00370642f
Cred_7502 vout.P0.pSD VSS.$1130.Metal3 0.00205742f
Cred_7503 vout.P0.pSD VSS.$1136.Metal3 0.00220015f
Cred_7504 vout.P0.pSD VSS.$1148.Metal3 0.000609925f
Cred_7505 vout.P0.pSD VSS.$115.Metal1 0.000110374f
Cred_7506 vout.P0.pSD VSS.$127.Metal1 0.000781747f
Cred_7507 vout.P0.pSD VSS.$137.Metal1 0.000115541f
Cred_7508 vout.P0.pSD VSS.$142.Metal1 0.00151447f
Cred_7509 vout.P0.pSD VSS.$18.Metal1 0.000364783f
Cred_7510 vout.P0.pSD VSS.$40.Metal1 0.00237008f
Cred_7511 vout.P0.pSD VSS.$551.Metal1 9.5789e-07f
Cred_7512 vout.P0.pSD VSS.$564.Metal2 0.00664336f
Cred_7513 vout.P0.pSD VSS.$605.Metal2 8.60624e-05f
Cred_7514 vout.P0.pSD VSS.$617.Metal2 0.00161322f
Cred_7515 vout.P0.pSD VSS.$629.Metal2 0.000338575f
Cred_7516 vout.P0.pSD VSS.$636.Metal2 0.00510081f
Cred_7517 vout.P0.pSD VSS.$644.Metal2 0.00684257f
Cred_7518 vout.P0.pSD VSS.$658.Metal2 0.000575303f
Cred_7519 vout.P0.pSD VSS.$670.Metal2 0.000505879f
Cred_7520 vout.P0.pSD VSS.$685.Metal2 0.0026492f
Cred_7521 vout.P0.pSD VSS.$693.Metal2 0.0011582f
Cred_7522 vout.P0.pSD VSS.$75.Metal1 0.000672275f
Cred_7523 vout.P0.pSD VSS.$85.Metal1 0.00112234f
Cred_7524 vout.P0.pSD VSS.$97.Metal1 0.00464832f
Cred_7525 vout.P0.pSD VSS.P0.GatPoly 0.000149189f
Cred_7526 vout.P0.pSD VSS.P0.nSD 1.15758e-05f
Cred_7527 vout.P0.pSD VSS.P0.pSD 0.00228225f
Cred_7528 vout.P0.pSD VSS.P1.nSD 1.15758e-05f
Cred_7529 vout.P0.pSD VSS.P3.nSD 0.000159751f
Cred_7530 vout.P0.pSD VSS.P5.nSD 5.2049e-05f
Cred_7531 vout.P10.nSD VSS 0.000154331f
Cred_7532 vout.P10.nSD VSS.$1217.Metal3 0.000656439f
Cred_7533 vout.P10.nSD VSS.$1229.Metal3 9.00543e-05f
Cred_7534 vout.P10.nSD VSS.$18.Metal1 2.41888e-07f
Cred_7535 vout.P10.nSD VSS.$275.Metal1 0.00835214f
Cred_7536 vout.P10.nSD VSS.$285.Metal1 0.00835214f
Cred_7537 vout.P10.nSD VSS.$294.Metal1 0.00122507f
Cred_7538 vout.P10.nSD VSS.$304.Metal1 0.00768836f
Cred_7539 vout.P10.nSD VSS.$314.Metal1 0.000783063f
Cred_7540 vout.P10.nSD VSS.$319.Metal1 0.0170854f
Cred_7541 vout.P10.nSD VSS.$40.Metal1 9.37792e-08f
Cred_7542 vout.P10.nSD VSS.$551.Metal1 7.22827e-07f
Cred_7543 vout.P10.nSD VSS.$818.Metal2 0.00642375f
Cred_7544 vout.P10.nSD VSS.$826.Metal2 0.00642501f
Cred_7545 vout.P10.nSD VSS.$840.Metal2 0.00292795f
Cred_7546 vout.P10.nSD VSS.$852.Metal2 0.00212882f
Cred_7547 vout.P10.nSD VSS.$867.Metal2 0.00980539f
Cred_7548 vout.P10.nSD VSS.$875.Metal2 0.00295679f
Cred_7549 vout.P10.nSD VSS.P0.pSD 7.33184e-05f
Cred_7550 vout.P10.nSD VSS.P11.nSD 0.000591032f
Cred_7551 vout.P10.nSD VSS.P13.nSD 0.000586773f
Cred_7552 vout.P10.pSD VSS 0.000615f
Cred_7553 vout.P10.pSD VSS.$1217.Metal3 0.00164485f
Cred_7554 vout.P10.pSD VSS.$1229.Metal3 0.000364722f
Cred_7555 vout.P10.pSD VSS.$18.Metal1 1.31008e-06f
Cred_7556 vout.P10.pSD VSS.$275.Metal1 0.00049075f
Cred_7557 vout.P10.pSD VSS.$285.Metal1 0.00049075f
Cred_7558 vout.P10.pSD VSS.$294.Metal1 7.88786e-05f
Cred_7559 vout.P10.pSD VSS.$304.Metal1 0.000496835f
Cred_7560 vout.P10.pSD VSS.$314.Metal1 5.06412e-05f
Cred_7561 vout.P10.pSD VSS.$319.Metal1 0.000987864f
Cred_7562 vout.P10.pSD VSS.$40.Metal1 5.07915e-07f
Cred_7563 vout.P10.pSD VSS.$551.Metal1 3.91488e-06f
Cred_7564 vout.P10.pSD VSS.$818.Metal2 0.00126864f
Cred_7565 vout.P10.pSD VSS.$826.Metal2 0.00127327f
Cred_7566 vout.P10.pSD VSS.$840.Metal2 0.000395712f
Cred_7567 vout.P10.pSD VSS.$852.Metal2 0.000289219f
Cred_7568 vout.P10.pSD VSS.$867.Metal2 0.00184587f
Cred_7569 vout.P10.pSD VSS.$875.Metal2 0.000555148f
Cred_7570 vout.P10.pSD VSS.P0.pSD 0.000360442f
Cred_7571 vout.P10.pSD VSS.P11.nSD 3.47648e-05f
Cred_7572 vout.P10.pSD VSS.P13.nSD 3.39494e-05f
Cred_7573 vout.P12.nSD VSS.$1229.Metal3 6.87255e-05f
Cred_7574 vout.P12.nSD VSS.$1238.Metal3 0.000325381f
Cred_7575 vout.P12.nSD VSS.$1250.Metal3 1.23028e-05f
Cred_7576 vout.P12.nSD VSS.$319.Metal1 0.0165688f
Cred_7577 vout.P12.nSD VSS.$339.Metal1 0.00212323f
Cred_7578 vout.P12.nSD VSS.$349.Metal1 0.00745787f
Cred_7579 vout.P12.nSD VSS.$372.Metal1 0.018469f
Cred_7580 vout.P12.nSD VSS.$867.Metal2 0.00948269f
Cred_7581 vout.P12.nSD VSS.$875.Metal2 0.00286013f
Cred_7582 vout.P12.nSD VSS.$887.Metal2 0.00373548f
Cred_7583 vout.P12.nSD VSS.$899.Metal2 0.00137918f
Cred_7584 vout.P12.nSD VSS.$905.Metal2 0.000411108f
Cred_7585 vout.P12.nSD VSS.$914.Metal2 0.0108207f
Cred_7586 vout.P12.nSD VSS.P0.pSD 4.9094e-06f
Cred_7587 vout.P12.nSD VSS.P13.nSD 0.000567917f
Cred_7588 vout.P12.nSD VSS.P15.nSD 0.000101528f
Cred_7589 vout.P14.nSD VSS.$1238.Metal3 6.02112e-06f
Cred_7590 vout.P14.nSD VSS.$1250.Metal3 0.000145996f
Cred_7591 vout.P14.nSD VSS.$1256.Metal3 0.000563255f
Cred_7592 vout.P14.nSD VSS.$1265.Metal3 0.000168571f
Cred_7593 vout.P14.nSD VSS.$1277.Metal3 2.18957e-06f
Cred_7594 vout.P14.nSD VSS.$18.Metal1 6.68299e-08f
Cred_7595 vout.P14.nSD VSS.$372.Metal1 0.0181792f
Cred_7596 vout.P14.nSD VSS.$379.Metal1 0.000484478f
Cred_7597 vout.P14.nSD VSS.$391.Metal1 0.00725054f
Cred_7598 vout.P14.nSD VSS.$40.Metal1 2.59098e-08f
Cred_7599 vout.P14.nSD VSS.$401.Metal1 0.00204878f
Cred_7600 vout.P14.nSD VSS.$409.Metal1 0.0170892f
Cred_7601 vout.P14.nSD VSS.$426.Metal1 1.40196e-10f
Cred_7602 vout.P14.nSD VSS.$551.Metal1 3.30267e-06f
Cred_7603 vout.P14.nSD VSS.$899.Metal2 4.8276e-08f
Cred_7604 vout.P14.nSD VSS.$905.Metal2 0.000433043f
Cred_7605 vout.P14.nSD VSS.$914.Metal2 0.0114011f
Cred_7606 vout.P14.nSD VSS.$928.Metal2 0.00147448f
Cred_7607 vout.P14.nSD VSS.$940.Metal2 0.00371228f
Cred_7608 vout.P14.nSD VSS.$952.Metal2 0.00388977f
Cred_7609 vout.P14.nSD VSS.$961.Metal2 0.0088677f
Cred_7610 vout.P14.nSD VSS.$975.Metal2 3.50412e-08f
Cred_7611 vout.P14.nSD VSS.P0.pSD 7.93166e-05f
Cred_7612 vout.P14.nSD VSS.P15.nSD 9.91906e-05f
Cred_7613 vout.P14.nSD VSS.P17.nSD 0.000586904f
Cred_7614 vout.P14.pSD VSS.$1238.Metal3 3.26108e-05f
Cred_7615 vout.P14.pSD VSS.$1250.Metal3 0.00062407f
Cred_7616 vout.P14.pSD VSS.$1256.Metal3 0.00129337f
Cred_7617 vout.P14.pSD VSS.$1265.Metal3 0.000630175f
Cred_7618 vout.P14.pSD VSS.$1277.Metal3 1.18589e-05f
Cred_7619 vout.P14.pSD VSS.$18.Metal1 3.61955e-07f
Cred_7620 vout.P14.pSD VSS.$372.Metal1 0.00106344f
Cred_7621 vout.P14.pSD VSS.$379.Metal1 3.19147e-05f
Cred_7622 vout.P14.pSD VSS.$391.Metal1 0.000471905f
Cred_7623 vout.P14.pSD VSS.$40.Metal1 1.40329e-07f
Cred_7624 vout.P14.pSD VSS.$401.Metal1 0.000123225f
Cred_7625 vout.P14.pSD VSS.$409.Metal1 0.000988576f
Cred_7626 vout.P14.pSD VSS.$426.Metal1 7.59314e-10f
Cred_7627 vout.P14.pSD VSS.$551.Metal1 1.78875e-05f
Cred_7628 vout.P14.pSD VSS.$899.Metal2 2.61466e-07f
Cred_7629 vout.P14.pSD VSS.$905.Metal2 9.04671e-05f
Cred_7630 vout.P14.pSD VSS.$914.Metal2 0.00236927f
Cred_7631 vout.P14.pSD VSS.$928.Metal2 0.000197705f
Cred_7632 vout.P14.pSD VSS.$940.Metal2 0.000498663f
Cred_7633 vout.P14.pSD VSS.$952.Metal2 0.00073161f
Cred_7634 vout.P14.pSD VSS.$961.Metal2 0.00166531f
Cred_7635 vout.P14.pSD VSS.$975.Metal2 1.89786e-07f
Cred_7636 vout.P14.pSD VSS.P0.pSD 0.000392906f
Cred_7637 vout.P14.pSD VSS.P15.nSD 5.83524e-06f
Cred_7638 vout.P14.pSD VSS.P17.nSD 3.39739e-05f
Cred_7639 vout.P16.nSD VSS.$1002.Metal2 0.00713694f
Cred_7640 vout.P16.nSD VSS.$1010.Metal2 0.00531474f
Cred_7641 vout.P16.nSD VSS.$1265.Metal3 2.55528e-05f
Cred_7642 vout.P16.nSD VSS.$1277.Metal3 0.000320123f
Cred_7643 vout.P16.nSD VSS.$1283.Metal3 6.15407e-05f
Cred_7644 vout.P16.nSD VSS.$409.Metal1 0.01621f
Cred_7645 vout.P16.nSD VSS.$426.Metal1 0.00106438f
Cred_7646 vout.P16.nSD VSS.$436.Metal1 0.00760633f
Cred_7647 vout.P16.nSD VSS.$448.Metal1 0.00122002f
Cred_7648 vout.P16.nSD VSS.$453.Metal1 0.0169212f
Cred_7649 vout.P16.nSD VSS.$952.Metal2 0.00373698f
Cred_7650 vout.P16.nSD VSS.$961.Metal2 0.00852072f
Cred_7651 vout.P16.nSD VSS.$975.Metal2 0.00228944f
Cred_7652 vout.P16.nSD VSS.$987.Metal2 0.00264229f
Cred_7653 vout.P16.nSD VSS.P0.pSD 6.7298e-06f
Cred_7654 vout.P16.nSD VSS.P17.nSD 0.00055671f
Cred_7655 vout.P16.nSD VSS.P19.nSD 0.000581131f
Cred_7656 vout.P18.nSD VSS.$1002.Metal2 0.00761855f
Cred_7657 vout.P18.nSD VSS.$1010.Metal2 0.00567408f
Cred_7658 vout.P18.nSD VSS.$1016.Metal2 0.000822458f
Cred_7659 vout.P18.nSD VSS.$1028.Metal2 0.00401017f
Cred_7660 vout.P18.nSD VSS.$1040.Metal2 0.000214319f
Cred_7661 vout.P18.nSD VSS.$1066.Metal2 0.00928731f
Cred_7662 vout.P18.nSD VSS.$1283.Metal3 6.85004e-05f
Cred_7663 vout.P18.nSD VSS.$1295.Metal3 0.000496378f
Cred_7664 vout.P18.nSD VSS.$1301.Metal3 0.000268208f
Cred_7665 vout.P18.nSD VSS.$453.Metal1 0.0170152f
Cred_7666 vout.P18.nSD VSS.$476.Metal1 0.0058531f
Cred_7667 vout.P18.nSD VSS.$488.Metal1 0.00386295f
Cred_7668 vout.P18.nSD VSS.$509.Metal1 0.0129536f
Cred_7669 vout.P18.nSD VSS.P0.pSD 6.06857e-06f
Cred_7670 vout.P18.nSD VSS.P1.GatPoly 1.92866e-05f
Cred_7671 vout.P18.nSD VSS.P19.nSD 0.000584366f
Cred_7672 vout.P18.nSD VSS.P21.nSD 6.937e-05f
Cred_7673 vout.P18.nSD VSS.P23.nSD 6.937e-05f
Cred_7674 vout.P2.nSD VSS.$1112.Metal3 0.000184434f
Cred_7675 vout.P2.nSD VSS.$1118.Metal3 0.000372247f
Cred_7676 vout.P2.nSD VSS.$1130.Metal3 0.000384696f
Cred_7677 vout.P2.nSD VSS.$1136.Metal3 0.000770547f
Cred_7678 vout.P2.nSD VSS.$1148.Metal3 0.000150419f
Cred_7679 vout.P2.nSD VSS.$115.Metal1 0.00124262f
Cred_7680 vout.P2.nSD VSS.$127.Metal1 0.00776638f
Cred_7681 vout.P2.nSD VSS.$137.Metal1 0.00108804f
Cred_7682 vout.P2.nSD VSS.$142.Metal1 0.01652f
Cred_7683 vout.P2.nSD VSS.$18.Metal1 3.93942e-05f
Cred_7684 vout.P2.nSD VSS.$40.Metal1 0.000237168f
Cred_7685 vout.P2.nSD VSS.$551.Metal1 1.32796e-07f
Cred_7686 vout.P2.nSD VSS.$564.Metal2 0.000661445f
Cred_7687 vout.P2.nSD VSS.$605.Metal2 8.56879e-06f
Cred_7688 vout.P2.nSD VSS.$617.Metal2 0.00016062f
Cred_7689 vout.P2.nSD VSS.$629.Metal2 3.37359e-05f
Cred_7690 vout.P2.nSD VSS.$636.Metal2 0.00596833f
Cred_7691 vout.P2.nSD VSS.$644.Metal2 0.00801392f
Cred_7692 vout.P2.nSD VSS.$658.Metal2 0.00276007f
Cred_7693 vout.P2.nSD VSS.$670.Metal2 0.002393f
Cred_7694 vout.P2.nSD VSS.$685.Metal2 0.00906308f
Cred_7695 vout.P2.nSD VSS.$693.Metal2 0.00397409f
Cred_7696 vout.P2.nSD VSS.$75.Metal1 6.69349e-05f
Cred_7697 vout.P2.nSD VSS.$85.Metal1 0.000111746f
Cred_7698 vout.P2.nSD VSS.$97.Metal1 0.0168469f
Cred_7699 vout.P2.nSD VSS.P0.GatPoly 1.4854e-05f
Cred_7700 vout.P2.nSD VSS.P0.nSD 1.15254e-06f
Cred_7701 vout.P2.nSD VSS.P0.pSD 0.000284726f
Cred_7702 vout.P2.nSD VSS.P1.nSD 1.15254e-06f
Cred_7703 vout.P2.nSD VSS.P3.nSD 0.000578601f
Cred_7704 vout.P2.nSD VSS.P5.nSD 0.000567366f
Cred_7705 vout.P2.pSD VSS.$1112.Metal3 0.00100797f
Cred_7706 vout.P2.pSD VSS.$1118.Metal3 0.00203441f
Cred_7707 vout.P2.pSD VSS.$1130.Metal3 0.00176612f
Cred_7708 vout.P2.pSD VSS.$1136.Metal3 0.00246167f
Cred_7709 vout.P2.pSD VSS.$1148.Metal3 0.000682423f
Cred_7710 vout.P2.pSD VSS.$115.Metal1 0.000123493f
Cred_7711 vout.P2.pSD VSS.$127.Metal1 0.000874669f
Cred_7712 vout.P2.pSD VSS.$137.Metal1 0.000129275f
Cred_7713 vout.P2.pSD VSS.$142.Metal1 0.00169449f
Cred_7714 vout.P2.pSD VSS.$18.Metal1 0.000215298f
Cred_7715 vout.P2.pSD VSS.$40.Metal1 0.00129618f
Cred_7716 vout.P2.pSD VSS.$551.Metal1 7.25761e-07f
Cred_7717 vout.P2.pSD VSS.$564.Metal2 0.00361495f
Cred_7718 vout.P2.pSD VSS.$605.Metal2 4.68304e-05f
Cred_7719 vout.P2.pSD VSS.$617.Metal2 0.000877823f
Cred_7720 vout.P2.pSD VSS.$629.Metal2 0.000184375f
Cred_7721 vout.P2.pSD VSS.$636.Metal2 0.00370596f
Cred_7722 vout.P2.pSD VSS.$644.Metal2 0.00497276f
Cred_7723 vout.P2.pSD VSS.$658.Metal2 0.000643686f
Cred_7724 vout.P2.pSD VSS.$670.Metal2 0.00056601f
Cred_7725 vout.P2.pSD VSS.$685.Metal2 0.00296409f
Cred_7726 vout.P2.pSD VSS.$693.Metal2 0.00129587f
Cred_7727 vout.P2.pSD VSS.$75.Metal1 0.000365815f
Cred_7728 vout.P2.pSD VSS.$85.Metal1 0.000610716f
Cred_7729 vout.P2.pSD VSS.$97.Metal1 0.00340152f
Cred_7730 vout.P2.pSD VSS.P0.GatPoly 8.11802e-05f
Cred_7731 vout.P2.pSD VSS.P0.nSD 6.29889e-06f
Cred_7732 vout.P2.pSD VSS.P0.pSD 0.00151931f
Cred_7733 vout.P2.pSD VSS.P1.nSD 6.29889e-06f
Cred_7734 vout.P2.pSD VSS.P3.nSD 0.000116906f
Cred_7735 vout.P2.pSD VSS.P5.nSD 5.82357e-05f
Cred_7736 vout.P4.nSD VSS.$1148.Metal3 5.84855e-05f
Cred_7737 vout.P4.nSD VSS.$1157.Metal3 0.000333176f
Cred_7738 vout.P4.nSD VSS.$1169.Metal3 1.51424e-05f
Cred_7739 vout.P4.nSD VSS.$142.Metal1 0.0171591f
Cred_7740 vout.P4.nSD VSS.$162.Metal1 0.00202602f
Cred_7741 vout.P4.nSD VSS.$172.Metal1 0.00716341f
Cred_7742 vout.P4.nSD VSS.$184.Metal1 0.000478587f
Cred_7743 vout.P4.nSD VSS.$195.Metal1 0.018469f
Cred_7744 vout.P4.nSD VSS.$685.Metal2 0.00868299f
Cred_7745 vout.P4.nSD VSS.$693.Metal2 0.00380856f
Cred_7746 vout.P4.nSD VSS.$705.Metal2 0.00362033f
Cred_7747 vout.P4.nSD VSS.$717.Metal2 0.00143822f
Cred_7748 vout.P4.nSD VSS.$732.Metal2 0.0108209f
Cred_7749 vout.P4.nSD VSS.$740.Metal2 0.00041091f
Cred_7750 vout.P4.nSD VSS.P0.pSD 6.77208e-06f
Cred_7751 vout.P4.nSD VSS.P5.nSD 0.000588551f
Cred_7752 vout.P4.nSD VSS.P7.nSD 0.000101528f
Cred_7753 vout.P6.nSD VSS.$1157.Metal3 5.19831e-06f
Cred_7754 vout.P6.nSD VSS.$1169.Metal3 0.000143818f
Cred_7755 vout.P6.nSD VSS.$1175.Metal3 0.00055137f
Cred_7756 vout.P6.nSD VSS.$1184.Metal3 0.000190174f
Cred_7757 vout.P6.nSD VSS.$1196.Metal3 3.00955e-06f
Cred_7758 vout.P6.nSD VSS.$18.Metal1 9.62205e-07f
Cred_7759 vout.P6.nSD VSS.$184.Metal1 3.32843e-10f
Cred_7760 vout.P6.nSD VSS.$195.Metal1 0.0183007f
Cred_7761 vout.P6.nSD VSS.$212.Metal1 0.00754783f
Cred_7762 vout.P6.nSD VSS.$224.Metal1 0.00214887f
Cred_7763 vout.P6.nSD VSS.$232.Metal1 0.0170854f
Cred_7764 vout.P6.nSD VSS.$247.Metal1 1.92698e-10f
Cred_7765 vout.P6.nSD VSS.$40.Metal1 3.73044e-07f
Cred_7766 vout.P6.nSD VSS.$551.Metal1 1.80862e-07f
Cred_7767 vout.P6.nSD VSS.$717.Metal2 8.31921e-08f
Cred_7768 vout.P6.nSD VSS.$732.Metal2 0.0113001f
Cred_7769 vout.P6.nSD VSS.$740.Metal2 0.00042911f
Cred_7770 vout.P6.nSD VSS.$746.Metal2 0.00141412f
Cred_7771 vout.P6.nSD VSS.$758.Metal2 0.00383035f
Cred_7772 vout.P6.nSD VSS.$770.Metal2 0.00295729f
Cred_7773 vout.P6.nSD VSS.$779.Metal2 0.00980406f
Cred_7774 vout.P6.nSD VSS.$793.Metal2 4.81638e-08f
Cred_7775 vout.P6.nSD VSS.P0.pSD 7.0955e-05f
Cred_7776 vout.P6.nSD VSS.P10.nSD 0.000586771f
Cred_7777 vout.P6.nSD VSS.P7.nSD 9.94871e-05f
Cred_7778 vout.P6.pSD VSS.$1157.Metal3 2.841e-05f
Cred_7779 vout.P6.pSD VSS.$1169.Metal3 0.000649363f
Cred_7780 vout.P6.pSD VSS.$1175.Metal3 0.0012815f
Cred_7781 vout.P6.pSD VSS.$1184.Metal3 0.000684071f
Cred_7782 vout.P6.pSD VSS.$1196.Metal3 1.64479e-05f
Cred_7783 vout.P6.pSD VSS.$18.Metal1 5.25867e-06f
Cred_7784 vout.P6.pSD VSS.$184.Metal1 1.81906e-09f
Cred_7785 vout.P6.pSD VSS.$195.Metal1 0.00107827f
Cred_7786 vout.P6.pSD VSS.$212.Metal1 0.000491648f
Cred_7787 vout.P6.pSD VSS.$224.Metal1 0.000140118f
Cred_7788 vout.P6.pSD VSS.$232.Metal1 0.000996463f
Cred_7789 vout.P6.pSD VSS.$247.Metal1 1.05314e-09f
Cred_7790 vout.P6.pSD VSS.$40.Metal1 2.03877e-06f
Cred_7791 vout.P6.pSD VSS.$551.Metal1 9.88455e-07f
Cred_7792 vout.P6.pSD VSS.$717.Metal2 4.54664e-07f
Cred_7793 vout.P6.pSD VSS.$732.Metal2 0.00237859f
Cred_7794 vout.P6.pSD VSS.$740.Metal2 9.02915e-05f
Cred_7795 vout.P6.pSD VSS.$746.Metal2 0.0001915f
Cred_7796 vout.P6.pSD VSS.$758.Metal2 0.00051888f
Cred_7797 vout.P6.pSD VSS.$770.Metal2 0.000561508f
Cred_7798 vout.P6.pSD VSS.$779.Metal2 0.00185731f
Cred_7799 vout.P6.pSD VSS.$793.Metal2 2.63226e-07f
Cred_7800 vout.P6.pSD VSS.P0.pSD 0.000360954f
Cred_7801 vout.P6.pSD VSS.P10.nSD 3.4245e-05f
Cred_7802 vout.P6.pSD VSS.P7.nSD 5.89819e-06f
Cred_7803 vout.P8.nSD VSS 4.07803e-05f
Cred_7804 vout.P8.nSD VSS.$1184.Metal3 2.27136e-05f
Cred_7805 vout.P8.nSD VSS.$1196.Metal3 0.000352741f
Cred_7806 vout.P8.nSD VSS.$232.Metal1 0.0165694f
Cred_7807 vout.P8.nSD VSS.$247.Metal1 0.000773713f
Cred_7808 vout.P8.nSD VSS.$259.Metal1 0.00759662f
Cred_7809 vout.P8.nSD VSS.$269.Metal1 0.0012105f
Cred_7810 vout.P8.nSD VSS.$275.Metal1 0.00842778f
Cred_7811 vout.P8.nSD VSS.$285.Metal1 0.00842778f
Cred_7812 vout.P8.nSD VSS.$770.Metal2 0.00286143f
Cred_7813 vout.P8.nSD VSS.$779.Metal2 0.00948827f
Cred_7814 vout.P8.nSD VSS.$793.Metal2 0.00207542f
Cred_7815 vout.P8.nSD VSS.$805.Metal2 0.00285489f
Cred_7816 vout.P8.nSD VSS.$818.Metal2 0.00617489f
Cred_7817 vout.P8.nSD VSS.$826.Metal2 0.00617448f
Cred_7818 vout.P8.nSD VSS.P0.pSD 6.76801e-06f
Cred_7819 vout.P8.nSD VSS.P10.nSD 0.000567937f
Cred_7820 vout.P8.nSD VSS.P11.nSD 0.00059751f
Rred_1 VDD VDD.$1433.Metal2 5.38343985652
Rred_2 VDD VDD.$1460.Metal2 2.66763109015
Rred_3 VDD VDD.$1480.Metal2 2.62954381678
Rred_4 VDD VDD.$1492.Metal2 5.30657744993
Rred_5 VDD VDD.$1980.Metal3 0.0861547886619
Rred_6 VDD VDD.$2001.Metal3 0.0849247081608
Rred_7 VDD VDD.$498.Metal1 1345.55676791
Rred_8 VDD VDD.$561.Metal1 1326.34549516
Rred_9 VDD.$100.Metal1 VDD.$1056.Metal2 4.54656835116
Rred_10 VDD.$100.Metal1 VDD.$1075.Metal2 4.89436627892
Rred_11 VDD.$100.Metal1 VDD.$141.Metal1 0.020632954956
Rred_12 VDD.$100.Metal1 VDD.$7.Metal1 0.0701908834403
Rred_13 VDD.$100.Metal1 VDD.P0.GatPoly 28.31
Rred_14 VDD.$100.Metal1 VDD.P0.nSD 2.73195937241
Rred_15 VDD.$1000.Metal1 VDD.$1001.Metal1 0.0158290758923
Rred_16 VDD.$1000.Metal1 VDD.$1806.Metal2 10.41608585
Rred_17 VDD.$1000.Metal1 VDD.$1808.Metal2 5.4068653571
Rred_18 VDD.$1000.Metal1 VDD.$943.Metal1 0.0159137912113
Rred_19 VDD.$1000.Metal1 VDD.P21.pSD 17
Rred_20 VDD.$1000.Metal1 VDD.P23.pSD 17
Rred_21 VDD.$1001.Metal1 VDD.$1002.Metal1 0.0157412444284
Rred_22 VDD.$1001.Metal1 VDD.$1808.Metal2 3.80618631613
Rred_23 VDD.$1001.Metal1 VDD.$1810.Metal2 53.5184929349
Rred_24 VDD.$1001.Metal1 VDD.P21.pSD 17
Rred_25 VDD.$1001.Metal1 VDD.P23.pSD 17
Rred_26 VDD.$1002.Metal1 VDD.$1003.Metal1 0.0159085107792
Rred_27 VDD.$1002.Metal1 VDD.$136.Metal1 263709.937499
Rred_28 VDD.$1002.Metal1 VDD.$137.Metal1 235351.598981
Rred_29 VDD.$1002.Metal1 VDD.$1808.Metal2 6.77889319703
Rred_30 VDD.$1002.Metal1 VDD.$1810.Metal2 6.77889319703
Rred_31 VDD.$1002.Metal1 VDD.P0.nSD 3.86907391766
Rred_32 VDD.$1002.Metal1 VDD.P21.pSD 17
Rred_33 VDD.$1002.Metal1 VDD.P23.pSD 17
Rred_34 VDD.$1003.Metal1 VDD.$1004.Metal1 0.0155789539273
Rred_35 VDD.$1003.Metal1 VDD.$136.Metal1 235351.598981
Rred_36 VDD.$1003.Metal1 VDD.$137.Metal1 210042.805622
Rred_37 VDD.$1003.Metal1 VDD.$1810.Metal2 3.08767233209
Rred_38 VDD.$1003.Metal1 VDD.P0.nSD 2.94741596689
Rred_39 VDD.$1003.Metal1 VDD.P21.pSD 17
Rred_40 VDD.$1003.Metal1 VDD.P23.pSD 17
Rred_41 VDD.$1004.Metal1 VDD.$1005.Metal1 0.0155108907521
Rred_42 VDD.$1004.Metal1 VDD.$1810.Metal2 6.89310803174
Rred_43 VDD.$1004.Metal1 VDD.$1812.Metal2 7.37123754963
Rred_44 VDD.$1004.Metal1 VDD.P0.nSD 16.3172656581
Rred_45 VDD.$1004.Metal1 VDD.P21.pSD 17
Rred_46 VDD.$1004.Metal1 VDD.P23.pSD 17
Rred_47 VDD.$1005.Metal1 VDD.$1006.Metal1 0.0154395891466
Rred_48 VDD.$1005.Metal1 VDD.$1810.Metal2 32.8041725716
Rred_49 VDD.$1005.Metal1 VDD.$1812.Metal2 3.98898736996
Rred_50 VDD.$1005.Metal1 VDD.P0.nSD 16.3143271817
Rred_51 VDD.$1005.Metal1 VDD.P21.pSD 17
Rred_52 VDD.$1005.Metal1 VDD.P23.pSD 17
Rred_53 VDD.$1006.Metal1 VDD.$1007.Metal1 0.0155816060967
Rred_54 VDD.$1006.Metal1 VDD.$1812.Metal2 8.8707765581
Rred_55 VDD.$1006.Metal1 VDD.$1813.Metal2 5.85264550961
Rred_56 VDD.$1006.Metal1 VDD.P0.nSD 15.8839141938
Rred_57 VDD.$1006.Metal1 VDD.P21.pSD 17
Rred_58 VDD.$1006.Metal1 VDD.P23.pSD 17
Rred_59 VDD.$1007.Metal1 VDD.$1813.Metal2 6.17167416666
Rred_60 VDD.$1007.Metal1 VDD.$954.Metal1 0.020632954956
Rred_61 VDD.$1007.Metal1 VDD.P0.nSD 12.9598007829
Rred_62 VDD.$1007.Metal1 VDD.P21.pSD 17
Rred_63 VDD.$1007.Metal1 VDD.P23.pSD 17
Rred_64 VDD.$1056.Metal2 VDD.$1075.Metal2 0.0578379960744
Rred_65 VDD.$1056.Metal2 VDD.$1110.Metal2 0.103798884402
Rred_66 VDD.$1056.Metal2 VDD.$1884.Metal3 1.02173185202
Rred_67 VDD.$1056.Metal2 VDD.$7.Metal1 1.40821085669
Rred_68 VDD.$1056.Metal2 VDD.$95.Metal1 4.99307079321
Rred_69 VDD.$1056.Metal2 VDD.P0.nSD 1091.26144766
Rred_70 VDD.$1065.Metal2 VDD.$1068.Metal2 0.0411706648738
Rred_71 VDD.$1065.Metal2 VDD.$130.Metal1 0.700228681675
Rred_72 VDD.$1065.Metal2 VDD.$131.Metal1 9.31990773858
Rred_73 VDD.$1065.Metal2 VDD.$132.Metal1 32.1191993917
Rred_74 VDD.$1065.Metal2 VDD.P0.pSD 81.5609832592
Rred_75 VDD.$1065.Metal2 VDD.P1.pSD 81.5609832592
Rred_76 VDD.$1068.Metal2 VDD.$1070.Metal2 0.0273436075727
Rred_77 VDD.$1068.Metal2 VDD.$130.Metal1 10.3785482619
Rred_78 VDD.$1068.Metal2 VDD.$131.Metal1 5.78843856548
Rred_79 VDD.$1068.Metal2 VDD.$132.Metal1 3.97201546971
Rred_80 VDD.$1068.Metal2 VDD.$133.Metal1 4.68143389538
Rred_81 VDD.$1068.Metal2 VDD.$134.Metal1 10.41608585
Rred_82 VDD.$1070.Metal2 VDD.$1072.Metal2 0.0273436551723
Rred_83 VDD.$1070.Metal2 VDD.$133.Metal1 14.2716146512
Rred_84 VDD.$1070.Metal2 VDD.$134.Metal1 5.4068653571
Rred_85 VDD.$1070.Metal2 VDD.$135.Metal1 3.80618631613
Rred_86 VDD.$1070.Metal2 VDD.$136.Metal1 6.77889319703
Rred_87 VDD.$1072.Metal2 VDD.$1074.Metal2 0.0273436396529
Rred_88 VDD.$1072.Metal2 VDD.$135.Metal1 53.5184929349
Rred_89 VDD.$1072.Metal2 VDD.$136.Metal1 6.77889319703
Rred_90 VDD.$1072.Metal2 VDD.$137.Metal1 3.08767233209
Rred_91 VDD.$1072.Metal2 VDD.$138.Metal1 6.89310803174
Rred_92 VDD.$1072.Metal2 VDD.$139.Metal1 32.8041725716
Rred_93 VDD.$1072.Metal2 VDD.P0.nSD 47062.5487072
Rred_94 VDD.$1074.Metal2 VDD.$1075.Metal2 0.013640831758
Rred_95 VDD.$1074.Metal2 VDD.$138.Metal1 7.37123754963
Rred_96 VDD.$1074.Metal2 VDD.$139.Metal1 3.98898736996
Rred_97 VDD.$1074.Metal2 VDD.$140.Metal1 8.8707765581
Rred_98 VDD.$1074.Metal2 VDD.P0.nSD 35631.5035777
Rred_99 VDD.$1075.Metal2 VDD.$140.Metal1 5.85264550961
Rred_100 VDD.$1075.Metal2 VDD.$141.Metal1 6.17167416666
Rred_101 VDD.$1075.Metal2 VDD.P0.nSD 118137.610072
Rred_102 VDD.$1110.Metal2 VDD.$1137.Metal2 0.0510644296849
Rred_103 VDD.$1110.Metal2 VDD.$142.Metal1 2.95436589276
Rred_104 VDD.$1110.Metal2 VDD.$1884.Metal3 1.6088056551
Rred_105 VDD.$1110.Metal2 VDD.$1896.Metal3 6.28908610428
Rred_106 VDD.$1110.Metal2 VDD.$7.Metal1 6.95262064139
Rred_107 VDD.$1110.Metal2 VDD.$95.Metal1 3.25361662596
Rred_108 VDD.$1110.Metal2 VDD.P0.nSD 19850.6262899
Rred_109 VDD.$1137.Metal2 VDD.$1149.Metal2 0.0484923752296
Rred_110 VDD.$1137.Metal2 VDD.$142.Metal1 2.94790913599
Rred_111 VDD.$1137.Metal2 VDD.$152.Metal1 3.01904338824
Rred_112 VDD.$1137.Metal2 VDD.$1884.Metal3 5.9864931645
Rred_113 VDD.$1137.Metal2 VDD.$1896.Metal3 2.00648138157
Rred_114 VDD.$1137.Metal2 VDD.P0.nSD 3492.71336707
Rred_115 VDD.$1149.Metal2 VDD.$1161.Metal2 0.0484923752296
Rred_116 VDD.$1149.Metal2 VDD.$152.Metal1 3.01968780352
Rred_117 VDD.$1149.Metal2 VDD.$164.Metal1 3.01955296281
Rred_118 VDD.$1149.Metal2 VDD.$1896.Metal3 3.01802801866
Rred_119 VDD.$1149.Metal2 VDD.$1902.Metal3 3.01802801866
Rred_120 VDD.$1149.Metal2 VDD.P0.nSD 3388.78527683
Rred_121 VDD.$1161.Metal2 VDD.$1167.Metal2 0.0240522173681
Rred_122 VDD.$1161.Metal2 VDD.$1188.Metal2 1526.81857051
Rred_123 VDD.$1161.Metal2 VDD.$164.Metal1 2.71938063724
Rred_124 VDD.$1161.Metal2 VDD.$177.Metal1 7.80034714992
Rred_125 VDD.$1161.Metal2 VDD.$1902.Metal3 2.42113023107
Rred_126 VDD.$1161.Metal2 VDD.$1914.Metal3 12.2416920053
Rred_127 VDD.$1161.Metal2 VDD.P0.nSD 2274.81996338
Rred_128 VDD.$1167.Metal2 VDD.$1188.Metal2 0.0241973575823
Rred_129 VDD.$1167.Metal2 VDD.$164.Metal1 13.6104867163
Rred_130 VDD.$1167.Metal2 VDD.$177.Metal1 1.74523594052
Rred_131 VDD.$1167.Metal2 VDD.$1902.Metal3 6.09640618761
Rred_132 VDD.$1167.Metal2 VDD.$1914.Metal3 6.09640618761
Rred_133 VDD.$1167.Metal2 VDD.P0.nSD 3241.87394578
Rred_134 VDD.$1167.Metal2 VDD.P3.pSD 8.42198716888
Rred_135 VDD.$1188.Metal2 VDD.$1214.Metal2 0.0484923752296
Rred_136 VDD.$1188.Metal2 VDD.$177.Metal1 1.52354430552
Rred_137 VDD.$1188.Metal2 VDD.$1902.Metal3 12.2416920053
Rred_138 VDD.$1188.Metal2 VDD.$1914.Metal3 2.42113023107
Rred_139 VDD.$1188.Metal2 VDD.$230.Metal1 3.7770714324
Rred_140 VDD.$1188.Metal2 VDD.P0.nSD 9485.44026575
Rred_141 VDD.$1188.Metal2 VDD.P3.pSD 6.27169257258
Rred_142 VDD.$1214.Metal2 VDD.$1226.Metal2 0.0484923752296
Rred_143 VDD.$1214.Metal2 VDD.$1914.Metal3 3.01802801866
Rred_144 VDD.$1214.Metal2 VDD.$1920.Metal3 3.01802801866
Rred_145 VDD.$1214.Metal2 VDD.$230.Metal1 3.01967577385
Rred_146 VDD.$1214.Metal2 VDD.$242.Metal1 3.01972711398
Rred_147 VDD.$1214.Metal2 VDD.P0.nSD 3195.13122738
Rred_148 VDD.$1226.Metal2 VDD.$1253.Metal2 0.048486239739
Rred_149 VDD.$1226.Metal2 VDD.$1920.Metal3 2.02265962076
Rred_150 VDD.$1226.Metal2 VDD.$1932.Metal3 6.13284832082
Rred_151 VDD.$1226.Metal2 VDD.$242.Metal1 3.01957566786
Rred_152 VDD.$1226.Metal2 VDD.$252.Metal1 3.01948975343
Rred_153 VDD.$1226.Metal2 VDD.P0.nSD 3494.79852872
Rred_154 VDD.$1253.Metal2 VDD.$1273.Metal2 0.0241787630619
Rred_155 VDD.$1253.Metal2 VDD.$1920.Metal3 6.13284832082
Rred_156 VDD.$1253.Metal2 VDD.$1932.Metal3 3.03898200552
Rred_157 VDD.$1253.Metal2 VDD.$252.Metal1 4.11448185927
Rred_158 VDD.$1253.Metal2 VDD.$257.Metal1 1.3008069774
Rred_159 VDD.$1253.Metal2 VDD.P0.nSD 8945.64126452
Rred_160 VDD.$1253.Metal2 VDD.P5.pSD 5.16725721254
Rred_161 VDD.$1273.Metal2 VDD.$1285.Metal2 0.0484903231735
Rred_162 VDD.$1273.Metal2 VDD.$1932.Metal3 2.2581929014
Rred_163 VDD.$1273.Metal2 VDD.$1941.Metal3 18.3382910472
Rred_164 VDD.$1273.Metal2 VDD.$257.Metal1 2.37397431591
Rred_165 VDD.$1273.Metal2 VDD.$315.Metal1 3.31716881667
Rred_166 VDD.$1273.Metal2 VDD.P0.nSD 4397.77171266
Rred_167 VDD.$1273.Metal2 VDD.P5.pSD 11.7813464446
Rred_168 VDD.$1285.Metal2 VDD.$1297.Metal2 0.0484923752296
Rred_169 VDD.$1285.Metal2 VDD.$1932.Metal3 4.55716898563
Rred_170 VDD.$1285.Metal2 VDD.$1941.Metal3 2.26952241344
Rred_171 VDD.$1285.Metal2 VDD.$315.Metal1 3.01952114749
Rred_172 VDD.$1285.Metal2 VDD.$325.Metal1 3.01957566786
Rred_173 VDD.$1285.Metal2 VDD.P0.nSD 3494.79852872
Rred_174 VDD.$1297.Metal2 VDD.$1324.Metal2 0.0484923752296
Rred_175 VDD.$1297.Metal2 VDD.$1941.Metal3 3.01802801866
Rred_176 VDD.$1297.Metal2 VDD.$1947.Metal3 3.01802801866
Rred_177 VDD.$1297.Metal2 VDD.$325.Metal1 3.01972711398
Rred_178 VDD.$1297.Metal2 VDD.$337.Metal1 3.01967577385
Rred_179 VDD.$1297.Metal2 VDD.P0.nSD 3195.13122738
Rred_180 VDD.$130.Metal1 VDD.$131.Metal1 0.0161506228679
Rred_181 VDD.$130.Metal1 VDD.$132.Metal1 8096.80052639
Rred_182 VDD.$130.Metal1 VDD.P0.pSD 2.98631324733
Rred_183 VDD.$130.Metal1 VDD.P1.pSD 2.98631324733
Rred_184 VDD.$131.Metal1 VDD.$132.Metal1 0.0160753900045
Rred_185 VDD.$131.Metal1 VDD.P0.pSD 17
Rred_186 VDD.$131.Metal1 VDD.P1.pSD 17
Rred_187 VDD.$132.Metal1 VDD.$133.Metal1 0.0162217048716
Rred_188 VDD.$132.Metal1 VDD.P0.pSD 17
Rred_189 VDD.$132.Metal1 VDD.P1.pSD 17
Rred_190 VDD.$1324.Metal2 VDD.$1344.Metal2 0.0240755530593
Rred_191 VDD.$1324.Metal2 VDD.$1350.Metal2 1526.81857051
Rred_192 VDD.$1324.Metal2 VDD.$1947.Metal3 2.42113023107
Rred_193 VDD.$1324.Metal2 VDD.$1959.Metal3 12.2416920053
Rred_194 VDD.$1324.Metal2 VDD.$337.Metal1 3.12941777057
Rred_195 VDD.$1324.Metal2 VDD.$376.Metal1 1.10227134052
Rred_196 VDD.$1324.Metal2 VDD.$393.Metal1 6.52275239628
Rred_197 VDD.$1324.Metal2 VDD.P0.nSD 3766.67576338
Rred_198 VDD.$1324.Metal2 VDD.P7.pSD 4.95634054678
Rred_199 VDD.$133.Metal1 VDD.$134.Metal1 0.0159137912113
Rred_200 VDD.$133.Metal1 VDD.P0.pSD 17
Rred_201 VDD.$133.Metal1 VDD.P1.pSD 17
Rred_202 VDD.$134.Metal1 VDD.$135.Metal1 0.0158290758923
Rred_203 VDD.$134.Metal1 VDD.P0.pSD 17
Rred_204 VDD.$134.Metal1 VDD.P1.pSD 17
Rred_205 VDD.$1344.Metal2 VDD.$1350.Metal2 0.024052572452
Rred_206 VDD.$1344.Metal2 VDD.$1947.Metal3 6.09640618761
Rred_207 VDD.$1344.Metal2 VDD.$1959.Metal3 6.09640618761
Rred_208 VDD.$1344.Metal2 VDD.$376.Metal1 29.8240991355
Rred_209 VDD.$1344.Metal2 VDD.$393.Metal1 3
Rred_210 VDD.$1344.Metal2 VDD.P7.pSD 130.516967732
Rred_211 VDD.$135.Metal1 VDD.$136.Metal1 0.0157412444284
Rred_212 VDD.$135.Metal1 VDD.P0.pSD 17
Rred_213 VDD.$135.Metal1 VDD.P1.pSD 17
Rred_214 VDD.$1350.Metal2 VDD.$1362.Metal2 0.0484923752296
Rred_215 VDD.$1350.Metal2 VDD.$1947.Metal3 12.2416920053
Rred_216 VDD.$1350.Metal2 VDD.$1959.Metal3 2.42113023107
Rred_217 VDD.$1350.Metal2 VDD.$393.Metal1 6.03055400695
Rred_218 VDD.$1350.Metal2 VDD.$403.Metal1 3.01950107943
Rred_219 VDD.$1350.Metal2 VDD.P0.nSD 3494.73334028
Rred_220 VDD.$136.Metal1 VDD.$137.Metal1 0.0159085107792
Rred_221 VDD.$136.Metal1 VDD.P0.nSD 3.86907391766
Rred_222 VDD.$136.Metal1 VDD.P0.pSD 17
Rred_223 VDD.$136.Metal1 VDD.P1.pSD 17
Rred_224 VDD.$1362.Metal2 VDD.$1374.Metal2 0.0484903231735
Rred_225 VDD.$1362.Metal2 VDD.$1959.Metal3 2.26952241344
Rred_226 VDD.$1362.Metal2 VDD.$1968.Metal3 4.55716898563
Rred_227 VDD.$1362.Metal2 VDD.$403.Metal1 3.01955296281
Rred_228 VDD.$1362.Metal2 VDD.$415.Metal1 3.01962400221
Rred_229 VDD.$1362.Metal2 VDD.P0.nSD 3388.78527683
Rred_230 VDD.$137.Metal1 VDD.$138.Metal1 0.0155789539273
Rred_231 VDD.$137.Metal1 VDD.P0.nSD 2.94741596689
Rred_232 VDD.$137.Metal1 VDD.P0.pSD 17
Rred_233 VDD.$137.Metal1 VDD.P1.pSD 17
Rred_234 VDD.$1374.Metal2 VDD.$1395.Metal2 0.0241586943053
Rred_235 VDD.$1374.Metal2 VDD.$1959.Metal3 18.3382910472
Rred_236 VDD.$1374.Metal2 VDD.$1968.Metal3 2.2581929014
Rred_237 VDD.$1374.Metal2 VDD.$415.Metal1 3.23056548644
Rred_238 VDD.$1374.Metal2 VDD.$423.Metal1 2.78445224755
Rred_239 VDD.$1374.Metal2 VDD.P0.nSD 4421.73574461
Rred_240 VDD.$1374.Metal2 VDD.P10.pSD 15.4889049215
Rred_241 VDD.$138.Metal1 VDD.$139.Metal1 0.0155108907521
Rred_242 VDD.$138.Metal1 VDD.P0.nSD 16.3172656581
Rred_243 VDD.$138.Metal1 VDD.P0.pSD 17
Rred_244 VDD.$138.Metal1 VDD.P1.pSD 17
Rred_245 VDD.$139.Metal1 VDD.$140.Metal1 0.0154395891466
Rred_246 VDD.$139.Metal1 VDD.P0.nSD 16.3143271817
Rred_247 VDD.$139.Metal1 VDD.P0.pSD 17
Rred_248 VDD.$139.Metal1 VDD.P1.pSD 17
Rred_249 VDD.$1395.Metal2 VDD.$1421.Metal2 0.048486239739
Rred_250 VDD.$1395.Metal2 VDD.$1968.Metal3 3.03898200552
Rred_251 VDD.$1395.Metal2 VDD.$1980.Metal3 6.13284832082
Rred_252 VDD.$1395.Metal2 VDD.$423.Metal1 1.19247785605
Rred_253 VDD.$1395.Metal2 VDD.$476.Metal1 4.38723505065
Rred_254 VDD.$1395.Metal2 VDD.P0.nSD 13268.7698479
Rred_255 VDD.$1395.Metal2 VDD.P10.pSD 4.67125703981
Rred_256 VDD.$140.Metal1 VDD.$141.Metal1 0.0155816060967
Rred_257 VDD.$140.Metal1 VDD.P0.nSD 15.8839141938
Rred_258 VDD.$140.Metal1 VDD.P0.pSD 17
Rred_259 VDD.$140.Metal1 VDD.P1.pSD 17
Rred_260 VDD.$141.Metal1 VDD.P0.nSD 12.9598007829
Rred_261 VDD.$141.Metal1 VDD.P0.pSD 17
Rred_262 VDD.$141.Metal1 VDD.P1.pSD 17
Rred_263 VDD.$142.Metal1 VDD.$152.Metal1 0.0504002983711
Rred_264 VDD.$142.Metal1 VDD.$1884.Metal3 1460.18884818
Rred_265 VDD.$142.Metal1 VDD.$1896.Metal3 1460.18884818
Rred_266 VDD.$142.Metal1 VDD.$95.Metal1 0.0614259096926
Rred_267 VDD.$142.Metal1 VDD.P0.nSD 9.15239107815
Rred_268 VDD.$1421.Metal2 VDD.$1433.Metal2 0.0484923752296
Rred_269 VDD.$1421.Metal2 VDD.$1968.Metal3 6.13284832082
Rred_270 VDD.$1421.Metal2 VDD.$1980.Metal3 2.02265962076
Rred_271 VDD.$1421.Metal2 VDD.$476.Metal1 3.01941415001
Rred_272 VDD.$1421.Metal2 VDD.$488.Metal1 3.01967731838
Rred_273 VDD.$1421.Metal2 VDD.P0.nSD 3458.67092853
Rred_274 VDD.$1433.Metal2 VDD.$1460.Metal2 0.0484878836934
Rred_275 VDD.$1433.Metal2 VDD.$1980.Metal3 2.11529527724
Rred_276 VDD.$1433.Metal2 VDD.$488.Metal1 3.01961271281
Rred_277 VDD.$1433.Metal2 VDD.$498.Metal1 3.01946522648
Rred_278 VDD.$1433.Metal2 VDD.P0.nSD 3494.78766436
Rred_279 VDD.$1460.Metal2 VDD.$1480.Metal2 0.0242007999596
Rred_280 VDD.$1460.Metal2 VDD.$1980.Metal3 8.37782604988
Rred_281 VDD.$1460.Metal2 VDD.$498.Metal1 6.04782711321
Rred_282 VDD.$1460.Metal2 VDD.$518.Metal1 1.93591900068
Rred_283 VDD.$1460.Metal2 VDD.$554.Metal1 5.45800273264
Rred_284 VDD.$1460.Metal2 VDD.P11.pSD 7.131239507
Rred_285 VDD.$1480.Metal2 VDD.$1492.Metal2 0.0484880785653
Rred_286 VDD.$1480.Metal2 VDD.$2001.Metal3 8.75783120169
Rred_287 VDD.$1480.Metal2 VDD.$518.Metal1 5.45800273264
Rred_288 VDD.$1480.Metal2 VDD.$554.Metal1 1.93591900068
Rred_289 VDD.$1480.Metal2 VDD.$561.Metal1 6.04783924259
Rred_290 VDD.$1480.Metal2 VDD.P11.pSD 7.131239507
Rred_291 VDD.$1492.Metal2 VDD.$1504.Metal2 0.0484923752296
Rred_292 VDD.$1492.Metal2 VDD.$2001.Metal3 2.12684133089
Rred_293 VDD.$1492.Metal2 VDD.$561.Metal1 3.01946672466
Rred_294 VDD.$1492.Metal2 VDD.$571.Metal1 3.01961271281
Rred_295 VDD.$1492.Metal2 VDD.P0.nSD 3494.78766436
Rred_296 VDD.$1504.Metal2 VDD.$1531.Metal2 0.048486239739
Rred_297 VDD.$1504.Metal2 VDD.$2001.Metal3 2.02265962076
Rred_298 VDD.$1504.Metal2 VDD.$2013.Metal3 6.13284832082
Rred_299 VDD.$1504.Metal2 VDD.$571.Metal1 3.01967731838
Rred_300 VDD.$1504.Metal2 VDD.$581.Metal1 3.01941415001
Rred_301 VDD.$1504.Metal2 VDD.P0.nSD 3458.67092853
Rred_302 VDD.$152.Metal1 VDD.$164.Metal1 0.0503784994019
Rred_303 VDD.$152.Metal1 VDD.$1896.Metal3 754.337028826
Rred_304 VDD.$152.Metal1 VDD.P0.nSD 7.22369241746
Rred_305 VDD.$1531.Metal2 VDD.$1551.Metal2 0.0241586943053
Rred_306 VDD.$1531.Metal2 VDD.$2001.Metal3 6.13284832082
Rred_307 VDD.$1531.Metal2 VDD.$2013.Metal3 3.03898200552
Rred_308 VDD.$1531.Metal2 VDD.$581.Metal1 4.38723505065
Rred_309 VDD.$1531.Metal2 VDD.$586.Metal1 1.19247785605
Rred_310 VDD.$1531.Metal2 VDD.P0.nSD 13268.7698479
Rred_311 VDD.$1531.Metal2 VDD.P13.pSD 4.67125703981
Rred_312 VDD.$1551.Metal2 VDD.$1563.Metal2 0.0484903231735
Rred_313 VDD.$1551.Metal2 VDD.$2013.Metal3 2.2581929014
Rred_314 VDD.$1551.Metal2 VDD.$2022.Metal3 18.3382910472
Rred_315 VDD.$1551.Metal2 VDD.$586.Metal1 2.78445224755
Rred_316 VDD.$1551.Metal2 VDD.$644.Metal1 3.23056548644
Rred_317 VDD.$1551.Metal2 VDD.P0.nSD 4421.73574461
Rred_318 VDD.$1551.Metal2 VDD.P13.pSD 15.4889049215
Rred_319 VDD.$1563.Metal2 VDD.$1575.Metal2 0.0484923752296
Rred_320 VDD.$1563.Metal2 VDD.$2013.Metal3 4.55716898563
Rred_321 VDD.$1563.Metal2 VDD.$2022.Metal3 2.26952241344
Rred_322 VDD.$1563.Metal2 VDD.$644.Metal1 3.01962400221
Rred_323 VDD.$1563.Metal2 VDD.$656.Metal1 3.01955296281
Rred_324 VDD.$1563.Metal2 VDD.P0.nSD 3388.78527683
Rred_325 VDD.$1575.Metal2 VDD.$1581.Metal2 0.024052572452
Rred_326 VDD.$1575.Metal2 VDD.$1602.Metal2 1526.81857051
Rred_327 VDD.$1575.Metal2 VDD.$2022.Metal3 2.42113023107
Rred_328 VDD.$1575.Metal2 VDD.$2034.Metal3 12.2416920053
Rred_329 VDD.$1575.Metal2 VDD.$656.Metal1 3.01950107943
Rred_330 VDD.$1575.Metal2 VDD.$666.Metal1 6.03055400695
Rred_331 VDD.$1575.Metal2 VDD.P0.nSD 3494.73334028
Rred_332 VDD.$1581.Metal2 VDD.$1602.Metal2 0.0240755530593
Rred_333 VDD.$1581.Metal2 VDD.$2022.Metal3 6.09640618761
Rred_334 VDD.$1581.Metal2 VDD.$2034.Metal3 6.09640618761
Rred_335 VDD.$1581.Metal2 VDD.$666.Metal1 3
Rred_336 VDD.$1581.Metal2 VDD.$702.Metal1 29.8240991355
Rred_337 VDD.$1581.Metal2 VDD.P15.pSD 130.516967732
Rred_338 VDD.$1602.Metal2 VDD.$1628.Metal2 0.0484923752296
Rred_339 VDD.$1602.Metal2 VDD.$2022.Metal3 12.2416920053
Rred_340 VDD.$1602.Metal2 VDD.$2034.Metal3 2.42113023107
Rred_341 VDD.$1602.Metal2 VDD.$666.Metal1 6.52275239628
Rred_342 VDD.$1602.Metal2 VDD.$702.Metal1 1.10227134052
Rred_343 VDD.$1602.Metal2 VDD.$722.Metal1 3.12941777057
Rred_344 VDD.$1602.Metal2 VDD.P0.nSD 3766.67576338
Rred_345 VDD.$1602.Metal2 VDD.P15.pSD 4.95634054678
Rred_346 VDD.$1628.Metal2 VDD.$1640.Metal2 0.0484923752296
Rred_347 VDD.$1628.Metal2 VDD.$2034.Metal3 3.01802801866
Rred_348 VDD.$1628.Metal2 VDD.$2040.Metal3 3.01802801866
Rred_349 VDD.$1628.Metal2 VDD.$722.Metal1 3.01967577385
Rred_350 VDD.$1628.Metal2 VDD.$734.Metal1 3.01972711398
Rred_351 VDD.$1628.Metal2 VDD.P0.nSD 3195.13122738
Rred_352 VDD.$164.Metal1 VDD.$177.Metal1 0.0651631230407
Rred_353 VDD.$164.Metal1 VDD.$1902.Metal3 754.337028826
Rred_354 VDD.$164.Metal1 VDD.P0.nSD 6.07179088948
Rred_355 VDD.$1640.Metal2 VDD.$1652.Metal2 0.0484903231735
Rred_356 VDD.$1640.Metal2 VDD.$2040.Metal3 2.26952241344
Rred_357 VDD.$1640.Metal2 VDD.$2049.Metal3 4.55716898563
Rred_358 VDD.$1640.Metal2 VDD.$734.Metal1 3.01957566786
Rred_359 VDD.$1640.Metal2 VDD.$744.Metal1 3.01952114749
Rred_360 VDD.$1640.Metal2 VDD.P0.nSD 3494.79852872
Rred_361 VDD.$1652.Metal2 VDD.$1673.Metal2 0.0241787630619
Rred_362 VDD.$1652.Metal2 VDD.$2040.Metal3 18.3382910472
Rred_363 VDD.$1652.Metal2 VDD.$2049.Metal3 2.2581929014
Rred_364 VDD.$1652.Metal2 VDD.$744.Metal1 3.31716881667
Rred_365 VDD.$1652.Metal2 VDD.$754.Metal1 2.37397431591
Rred_366 VDD.$1652.Metal2 VDD.P0.nSD 4397.77171266
Rred_367 VDD.$1652.Metal2 VDD.P17.pSD 11.7813464446
Rred_368 VDD.$1673.Metal2 VDD.$1699.Metal2 0.048486239739
Rred_369 VDD.$1673.Metal2 VDD.$2049.Metal3 3.03898200552
Rred_370 VDD.$1673.Metal2 VDD.$2061.Metal3 6.13284832082
Rred_371 VDD.$1673.Metal2 VDD.$754.Metal1 1.3008069774
Rred_372 VDD.$1673.Metal2 VDD.$807.Metal1 4.11448185927
Rred_373 VDD.$1673.Metal2 VDD.P0.nSD 8945.64126452
Rred_374 VDD.$1673.Metal2 VDD.P17.pSD 5.16725721254
Rred_375 VDD.$1699.Metal2 VDD.$1711.Metal2 0.0484923752296
Rred_376 VDD.$1699.Metal2 VDD.$2049.Metal3 6.13284832082
Rred_377 VDD.$1699.Metal2 VDD.$2061.Metal3 2.02265962076
Rred_378 VDD.$1699.Metal2 VDD.$807.Metal1 3.01948975343
Rred_379 VDD.$1699.Metal2 VDD.$817.Metal1 3.01957566786
Rred_380 VDD.$1699.Metal2 VDD.P0.nSD 3494.79852872
Rred_381 VDD.$1711.Metal2 VDD.$1738.Metal2 0.0484903231735
Rred_382 VDD.$1711.Metal2 VDD.$2061.Metal3 2.26952241344
Rred_383 VDD.$1711.Metal2 VDD.$2070.Metal3 4.55716898563
Rred_384 VDD.$1711.Metal2 VDD.$817.Metal1 3.01972711398
Rred_385 VDD.$1711.Metal2 VDD.$829.Metal1 3.01961197305
Rred_386 VDD.$1711.Metal2 VDD.P0.nSD 3195.13122738
Rred_387 VDD.$1738.Metal2 VDD.$1758.Metal2 0.0241981276516
Rred_388 VDD.$1738.Metal2 VDD.$2061.Metal3 18.3382910472
Rred_389 VDD.$1738.Metal2 VDD.$2070.Metal3 2.2581929014
Rred_390 VDD.$1738.Metal2 VDD.$829.Metal1 3.77702162164
Rred_391 VDD.$1738.Metal2 VDD.$834.Metal1 1.52354430552
Rred_392 VDD.$1738.Metal2 VDD.P0.nSD 9485.44026575
Rred_393 VDD.$1738.Metal2 VDD.P19.pSD 6.27169257258
Rred_394 VDD.$1758.Metal2 VDD.$1770.Metal2 0.0484923752296
Rred_395 VDD.$1758.Metal2 VDD.$2070.Metal3 6.02405333333
Rred_396 VDD.$1758.Metal2 VDD.$2076.Metal3 3.01802801866
Rred_397 VDD.$1758.Metal2 VDD.$834.Metal1 1.89952029576
Rred_398 VDD.$1758.Metal2 VDD.$890.Metal1 3.49223384788
Rred_399 VDD.$1758.Metal2 VDD.P0.nSD 6716.86096755
Rred_400 VDD.$1758.Metal2 VDD.P19.pSD 8.42198716888
Rred_401 VDD.$177.Metal1 VDD.$230.Metal1 0.0358581386467
Rred_402 VDD.$177.Metal1 VDD.P0.nSD 7.12742262762
Rred_403 VDD.$177.Metal1 VDD.P3.pSD 1.98810169492
Rred_404 VDD.$1770.Metal2 VDD.$1776.Metal2 0.0240522935925
Rred_405 VDD.$1770.Metal2 VDD.$2076.Metal3 2.59007321156
Rred_406 VDD.$1770.Metal2 VDD.$2085.Metal3 9.09640618761
Rred_407 VDD.$1770.Metal2 VDD.$890.Metal1 2.59278877719
Rred_408 VDD.$1770.Metal2 VDD.$907.Metal1 9.1229350887
Rred_409 VDD.$1770.Metal2 VDD.P0.nSD 1615.78353041
Rred_410 VDD.$1776.Metal2 VDD.$1788.Metal2 0.0484923752296
Rred_411 VDD.$1776.Metal2 VDD.$2076.Metal3 9.09640618761
Rred_412 VDD.$1776.Metal2 VDD.$2085.Metal3 2.59007321156
Rred_413 VDD.$1776.Metal2 VDD.$890.Metal1 9.1222953887
Rred_414 VDD.$1776.Metal2 VDD.$907.Metal1 2.59273486386
Rred_415 VDD.$1776.Metal2 VDD.P0.nSD 1658.39650424
Rred_416 VDD.$1788.Metal2 VDD.$1815.Metal2 0.0510644296849
Rred_417 VDD.$1788.Metal2 VDD.$2085.Metal3 2.00648138157
Rred_418 VDD.$1788.Metal2 VDD.$2097.Metal3 5.9864931645
Rred_419 VDD.$1788.Metal2 VDD.$907.Metal1 3.01904338824
Rred_420 VDD.$1788.Metal2 VDD.$917.Metal1 2.94790913599
Rred_421 VDD.$1788.Metal2 VDD.P0.nSD 3492.71336707
Rred_422 VDD.$1803.Metal2 VDD.$1806.Metal2 0.0411706648738
Rred_423 VDD.$1803.Metal2 VDD.$940.Metal1 0.700228681675
Rred_424 VDD.$1803.Metal2 VDD.$941.Metal1 9.31990773858
Rred_425 VDD.$1803.Metal2 VDD.$942.Metal1 32.1191993917
Rred_426 VDD.$1803.Metal2 VDD.P21.pSD 81.5609832592
Rred_427 VDD.$1803.Metal2 VDD.P23.pSD 81.5609832592
Rred_428 VDD.$1806.Metal2 VDD.$1808.Metal2 0.0273436075727
Rred_429 VDD.$1806.Metal2 VDD.$940.Metal1 10.3785482619
Rred_430 VDD.$1806.Metal2 VDD.$941.Metal1 5.78843856548
Rred_431 VDD.$1806.Metal2 VDD.$942.Metal1 3.97201546971
Rred_432 VDD.$1806.Metal2 VDD.$943.Metal1 4.68143389538
Rred_433 VDD.$1808.Metal2 VDD.$1810.Metal2 0.0273436551723
Rred_434 VDD.$1808.Metal2 VDD.$943.Metal1 14.2716146512
Rred_435 VDD.$1810.Metal2 VDD.$1812.Metal2 0.0273436396529
Rred_436 VDD.$1810.Metal2 VDD.P0.nSD 47062.5487072
Rred_437 VDD.$1812.Metal2 VDD.$1813.Metal2 0.013640831758
Rred_438 VDD.$1812.Metal2 VDD.P0.nSD 35631.5035777
Rred_439 VDD.$1813.Metal2 VDD.$1822.Metal2 0.0578379960744
Rred_440 VDD.$1813.Metal2 VDD.$954.Metal1 4.89436627892
Rred_441 VDD.$1813.Metal2 VDD.P0.nSD 118137.610072
Rred_442 VDD.$1815.Metal2 VDD.$1822.Metal2 0.103673812951
Rred_443 VDD.$1815.Metal2 VDD.$2085.Metal3 6.28908610428
Rred_444 VDD.$1815.Metal2 VDD.$2097.Metal3 1.60920372739
Rred_445 VDD.$1815.Metal2 VDD.$917.Metal1 2.95436589276
Rred_446 VDD.$1815.Metal2 VDD.$920.Metal1 6.94869457099
Rred_447 VDD.$1815.Metal2 VDD.$965.Metal1 3.25611045081
Rred_448 VDD.$1815.Metal2 VDD.P0.nSD 19850.6262899
Rred_449 VDD.$1822.Metal2 VDD.$2097.Metal3 1.02156962801
Rred_450 VDD.$1822.Metal2 VDD.$920.Metal1 1.40743756011
Rred_451 VDD.$1822.Metal2 VDD.$954.Metal1 4.54656835116
Rred_452 VDD.$1822.Metal2 VDD.$965.Metal1 4.99895247992
Rred_453 VDD.$1822.Metal2 VDD.P0.nSD 1091.26144766
Rred_454 VDD.$1884.Metal3 VDD.$1896.Metal3 0.0981479196261
Rred_455 VDD.$1884.Metal3 VDD.$7.Metal1 115.265153614
Rred_456 VDD.$1884.Metal3 VDD.$95.Metal1 402.66920167
Rred_457 VDD.$1896.Metal3 VDD.$1902.Metal3 0.0482995209481
Rred_458 VDD.$1902.Metal3 VDD.$1914.Metal3 0.0981511661222
Rred_459 VDD.$1914.Metal3 VDD.$1920.Metal3 0.0482995209481
Rred_460 VDD.$1914.Metal3 VDD.$230.Metal1 754.337028826
Rred_461 VDD.$1920.Metal3 VDD.$1932.Metal3 0.0981480735474
Rred_462 VDD.$1920.Metal3 VDD.$242.Metal1 754.337028826
Rred_463 VDD.$1920.Metal3 VDD.$252.Metal1 1532.86667717
Rred_464 VDD.$1932.Metal3 VDD.$1941.Metal3 0.0729314232753
Rred_465 VDD.$1932.Metal3 VDD.$252.Metal1 1532.86667717
Rred_466 VDD.$1932.Metal3 VDD.$315.Metal1 1139.03558589
Rred_467 VDD.$1941.Metal3 VDD.$1947.Metal3 0.0482995209481
Rred_468 VDD.$1941.Metal3 VDD.$315.Metal1 2287.203706
Rred_469 VDD.$1941.Metal3 VDD.$325.Metal1 754.337028826
Rred_470 VDD.$1947.Metal3 VDD.$1959.Metal3 0.0981511661222
Rred_471 VDD.$1947.Metal3 VDD.$337.Metal1 754.337028826
Rred_472 VDD.$1959.Metal3 VDD.$1968.Metal3 0.0729314232753
Rred_473 VDD.$1959.Metal3 VDD.$403.Metal1 754.337028826
Rred_474 VDD.$1959.Metal3 VDD.$415.Metal1 2287.203706
Rred_475 VDD.$1968.Metal3 VDD.$1980.Metal3 0.0981480735474
Rred_476 VDD.$1968.Metal3 VDD.$415.Metal1 1139.03558589
Rred_477 VDD.$1968.Metal3 VDD.$476.Metal1 1532.86667717
Rred_478 VDD.$1980.Metal3 VDD.$476.Metal1 1532.86667717
Rred_479 VDD.$1980.Metal3 VDD.$488.Metal1 754.337028826
Rred_480 VDD.$1980.Metal3 VDD.$498.Metal1 1767.57248443
Rred_481 VDD.$2001.Metal3 VDD.$2013.Metal3 0.0981480735474
Rred_482 VDD.$2001.Metal3 VDD.$561.Metal1 1800.24588827
Rred_483 VDD.$2001.Metal3 VDD.$571.Metal1 754.337028826
Rred_484 VDD.$2001.Metal3 VDD.$581.Metal1 1532.86667717
Rred_485 VDD.$2013.Metal3 VDD.$2022.Metal3 0.0729314232753
Rred_486 VDD.$2013.Metal3 VDD.$581.Metal1 1532.86667717
Rred_487 VDD.$2013.Metal3 VDD.$644.Metal1 1139.03558589
Rred_488 VDD.$2022.Metal3 VDD.$2034.Metal3 0.0981511661222
Rred_489 VDD.$2022.Metal3 VDD.$644.Metal1 2287.203706
Rred_490 VDD.$2022.Metal3 VDD.$656.Metal1 754.337028826
Rred_491 VDD.$2034.Metal3 VDD.$2040.Metal3 0.0482995209481
Rred_492 VDD.$2034.Metal3 VDD.$722.Metal1 754.337028826
Rred_493 VDD.$2040.Metal3 VDD.$2049.Metal3 0.0729314232753
Rred_494 VDD.$2040.Metal3 VDD.$734.Metal1 754.337028826
Rred_495 VDD.$2040.Metal3 VDD.$744.Metal1 2287.203706
Rred_496 VDD.$2049.Metal3 VDD.$2061.Metal3 0.0981480735474
Rred_497 VDD.$2049.Metal3 VDD.$744.Metal1 1139.03558589
Rred_498 VDD.$2049.Metal3 VDD.$807.Metal1 1532.86667717
Rred_499 VDD.$2061.Metal3 VDD.$2070.Metal3 0.0729314232753
Rred_500 VDD.$2061.Metal3 VDD.$807.Metal1 1532.86667717
Rred_501 VDD.$2061.Metal3 VDD.$817.Metal1 754.337028826
Rred_502 VDD.$2061.Metal3 VDD.$829.Metal1 2287.203706
Rred_503 VDD.$2070.Metal3 VDD.$2076.Metal3 0.0482995209481
Rred_504 VDD.$2070.Metal3 VDD.$829.Metal1 1139.03558589
Rred_505 VDD.$2076.Metal3 VDD.$2085.Metal3 0.0729329633886
Rred_506 VDD.$2076.Metal3 VDD.$890.Metal1 754.337028826
Rred_507 VDD.$2085.Metal3 VDD.$2097.Metal3 0.0981479196261
Rred_508 VDD.$2085.Metal3 VDD.$907.Metal1 754.337028826
Rred_509 VDD.$2085.Metal3 VDD.$917.Metal1 1460.18884818
Rred_510 VDD.$2097.Metal3 VDD.$917.Metal1 1460.18884818
Rred_511 VDD.$2097.Metal3 VDD.$920.Metal1 115.175412516
Rred_512 VDD.$2097.Metal3 VDD.$965.Metal1 403.904198058
Rred_513 VDD.$230.Metal1 VDD.$242.Metal1 0.0503800743211
Rred_514 VDD.$230.Metal1 VDD.P0.nSD 8.1616300373
Rred_515 VDD.$242.Metal1 VDD.$252.Metal1 0.0503816845649
Rred_516 VDD.$242.Metal1 VDD.P0.nSD 7.11445842696
Rred_517 VDD.$252.Metal1 VDD.$257.Metal1 0.0327769863206
Rred_518 VDD.$252.Metal1 VDD.P0.nSD 8.58558123775
Rred_519 VDD.$257.Metal1 VDD.$315.Metal1 0.0426557962487
Rred_520 VDD.$257.Metal1 VDD.P0.nSD 9.36743965424
Rred_521 VDD.$257.Metal1 VDD.P5.pSD 1.98874159732
Rred_522 VDD.$315.Metal1 VDD.$325.Metal1 0.0503816845649
Rred_523 VDD.$315.Metal1 VDD.P0.nSD 7.67389633993
Rred_524 VDD.$325.Metal1 VDD.$337.Metal1 0.0503800743211
Rred_525 VDD.$325.Metal1 VDD.P0.nSD 7.11445842696
Rred_526 VDD.$337.Metal1 VDD.$376.Metal1 0.344327320702
Rred_527 VDD.$337.Metal1 VDD.$393.Metal1 0.0544932656316
Rred_528 VDD.$337.Metal1 VDD.P0.nSD 7.0579789329
Rred_529 VDD.$376.Metal1 VDD.$393.Metal1 0.319936894383
Rred_530 VDD.$376.Metal1 VDD.P0.nSD 193.857361467
Rred_531 VDD.$376.Metal1 VDD.P7.pSD 1.61395011284
Rred_532 VDD.$393.Metal1 VDD.$403.Metal1 0.0503784928037
Rred_533 VDD.$393.Metal1 VDD.P0.nSD 7.42506595209
Rred_534 VDD.$403.Metal1 VDD.$415.Metal1 0.0503784994019
Rred_535 VDD.$403.Metal1 VDD.P0.nSD 6.83399526978
Rred_536 VDD.$415.Metal1 VDD.$423.Metal1 0.0445112576733
Rred_537 VDD.$415.Metal1 VDD.P0.nSD 7.62000951606
Rred_538 VDD.$423.Metal1 VDD.$476.Metal1 0.0309221197347
Rred_539 VDD.$423.Metal1 VDD.P0.nSD 9.87658715042
Rred_540 VDD.$423.Metal1 VDD.P10.pSD 1.98940628725
Rred_541 VDD.$476.Metal1 VDD.$488.Metal1 0.0503777081793
Rred_542 VDD.$476.Metal1 VDD.P0.nSD 8.20885719669
Rred_543 VDD.$488.Metal1 VDD.$498.Metal1 0.0503811526048
Rred_544 VDD.$488.Metal1 VDD.P0.nSD 7.26225858493
Rred_545 VDD.$498.Metal1 VDD.$518.Metal1 0.0250609268302
Rred_546 VDD.$498.Metal1 VDD.P0.nSD 9.6323051046
Rred_547 VDD.$518.Metal1 VDD.$554.Metal1 0.0252504167418
Rred_548 VDD.$518.Metal1 VDD.P0.nSD 14.8304595603
Rred_549 VDD.$518.Metal1 VDD.P11.pSD 4.00691620324
Rred_550 VDD.$554.Metal1 VDD.$561.Metal1 0.0250609268302
Rred_551 VDD.$554.Metal1 VDD.P0.nSD 14.8304595603
Rred_552 VDD.$554.Metal1 VDD.P11.pSD 4.00691620324
Rred_553 VDD.$561.Metal1 VDD.$571.Metal1 0.0503811526048
Rred_554 VDD.$561.Metal1 VDD.P0.nSD 9.6323051046
Rred_555 VDD.$571.Metal1 VDD.$581.Metal1 0.0503777081793
Rred_556 VDD.$571.Metal1 VDD.P0.nSD 7.26225858493
Rred_557 VDD.$581.Metal1 VDD.$586.Metal1 0.0309221197347
Rred_558 VDD.$581.Metal1 VDD.P0.nSD 8.20885719669
Rred_559 VDD.$586.Metal1 VDD.$644.Metal1 0.0445112576733
Rred_560 VDD.$586.Metal1 VDD.P0.nSD 9.87658715042
Rred_561 VDD.$586.Metal1 VDD.P13.pSD 1.98940628725
Rred_562 VDD.$644.Metal1 VDD.$656.Metal1 0.0503784994019
Rred_563 VDD.$644.Metal1 VDD.P0.nSD 7.62000951606
Rred_564 VDD.$656.Metal1 VDD.$666.Metal1 0.0503784928037
Rred_565 VDD.$656.Metal1 VDD.P0.nSD 6.83399526978
Rred_566 VDD.$666.Metal1 VDD.$702.Metal1 0.319936894383
Rred_567 VDD.$666.Metal1 VDD.$722.Metal1 0.0544932656316
Rred_568 VDD.$666.Metal1 VDD.P0.nSD 7.42506595209
Rred_569 VDD.$7.Metal1 VDD.$95.Metal1 0.0485921561394
Rred_570 VDD.$7.Metal1 VDD.P0.nSD 7.08029400794
Rred_571 VDD.$702.Metal1 VDD.$722.Metal1 0.344327320702
Rred_572 VDD.$702.Metal1 VDD.P0.nSD 193.857361467
Rred_573 VDD.$702.Metal1 VDD.P15.pSD 1.61395011284
Rred_574 VDD.$722.Metal1 VDD.$734.Metal1 0.0503800743211
Rred_575 VDD.$722.Metal1 VDD.P0.nSD 7.0579789329
Rred_576 VDD.$734.Metal1 VDD.$744.Metal1 0.0503816845649
Rred_577 VDD.$734.Metal1 VDD.P0.nSD 7.11445842696
Rred_578 VDD.$744.Metal1 VDD.$754.Metal1 0.0426557962487
Rred_579 VDD.$744.Metal1 VDD.P0.nSD 7.67389633993
Rred_580 VDD.$754.Metal1 VDD.$807.Metal1 0.0327769863206
Rred_581 VDD.$754.Metal1 VDD.P0.nSD 9.36743965424
Rred_582 VDD.$754.Metal1 VDD.P17.pSD 1.98874159732
Rred_583 VDD.$807.Metal1 VDD.$817.Metal1 0.0503816845649
Rred_584 VDD.$807.Metal1 VDD.P0.nSD 8.58558123775
Rred_585 VDD.$817.Metal1 VDD.$829.Metal1 0.0503800743211
Rred_586 VDD.$817.Metal1 VDD.P0.nSD 7.11445842696
Rred_587 VDD.$829.Metal1 VDD.$834.Metal1 0.0358581386467
Rred_588 VDD.$829.Metal1 VDD.P0.nSD 8.1616300373
Rred_589 VDD.$834.Metal1 VDD.$890.Metal1 0.0395650532209
Rred_590 VDD.$834.Metal1 VDD.P0.nSD 9.3483204091
Rred_591 VDD.$834.Metal1 VDD.P19.pSD 1.98810169492
Rred_592 VDD.$890.Metal1 VDD.$907.Metal1 0.0762118570177
Rred_593 VDD.$890.Metal1 VDD.P0.nSD 6.22076112495
Rred_594 VDD.$907.Metal1 VDD.$917.Metal1 0.0504002983711
Rred_595 VDD.$907.Metal1 VDD.P0.nSD 5.70489527206
Rred_596 VDD.$917.Metal1 VDD.$965.Metal1 0.0614259096926
Rred_597 VDD.$917.Metal1 VDD.P0.nSD 9.15239107815
Rred_598 VDD.$920.Metal1 VDD.$954.Metal1 0.0701908834403
Rred_599 VDD.$920.Metal1 VDD.$965.Metal1 0.0484688144286
Rred_600 VDD.$920.Metal1 VDD.P0.nSD 7.08029400794
Rred_601 VDD.$940.Metal1 VDD.$941.Metal1 0.0161506228679
Rred_602 VDD.$940.Metal1 VDD.$942.Metal1 8096.80052639
Rred_603 VDD.$940.Metal1 VDD.P21.pSD 2.98631324733
Rred_604 VDD.$940.Metal1 VDD.P23.pSD 2.98631324733
Rred_605 VDD.$941.Metal1 VDD.$942.Metal1 0.0160753900045
Rred_606 VDD.$941.Metal1 VDD.P21.pSD 17
Rred_607 VDD.$941.Metal1 VDD.P23.pSD 17
Rred_608 VDD.$942.Metal1 VDD.$943.Metal1 0.0162217048716
Rred_609 VDD.$942.Metal1 VDD.P21.pSD 17
Rred_610 VDD.$942.Metal1 VDD.P23.pSD 17
Rred_611 VDD.$943.Metal1 VDD.P21.pSD 17
Rred_612 VDD.$943.Metal1 VDD.P23.pSD 17
Rred_613 VDD.$95.Metal1 VDD.P0.nSD 221.142882408
Rred_614 VDD.$954.Metal1 VDD.P0.nSD 2.73195937241
Rred_615 VDD.$954.Metal1 VDD.P1.GatPoly 28.31
Rred_616 VDD.$965.Metal1 VDD.P0.nSD 221.142882408
Rred_617 VDD.P0.pSD VDD.P1.pSD 343.680487506
Rred_618 VDD.P21.pSD VDD.P23.pSD 343.680487506
Rred_619 vin vin.$476.Metal2 0.383359862282
Rred_620 vin vin.$478.Metal2 0.462198005117
Rred_621 vin vin.$486.Metal2 0.113101642234
Rred_622 vin.$10.GatPoly vin.$16.GatPoly 20.0625185185
Rred_623 vin.$10.GatPoly vin.$202.Metal1 20.4899101814
Rred_624 vin.$10.GatPoly vin.$210.Metal1 16.8901693557
Rred_625 vin.$10.GatPoly vin.$481.Metal2 11600.2404591
Rred_626 vin.$10.GatPoly vin.$483.Metal2 2325.0407717
Rred_627 vin.$10.GatPoly vin.$6.GatPoly 33.2847407407
Rred_628 vin.$10.GatPoly vin.P1.GatPoly 19.9708444444
Rred_629 vin.$102.GatPoly vin.$108.GatPoly 20.0625185185
Rred_630 vin.$102.GatPoly vin.$334.Metal1 158.710238626
Rred_631 vin.$102.GatPoly vin.$338.Metal1 17.3193062589
Rred_632 vin.$102.GatPoly vin.$346.Metal1 16.8757273465
Rred_633 vin.$102.GatPoly vin.$570.Metal2 2987.58348254
Rred_634 vin.$102.GatPoly vin.$575.Metal2 5498.19357361
Rred_635 vin.$102.GatPoly vin.$94.GatPoly 83.9400817622
Rred_636 vin.$102.GatPoly vin.P10.GatPoly 27.8344874504
Rred_637 vin.$105.GatPoly vin.$107.GatPoly 15.0537042157
Rred_638 vin.$105.GatPoly vin.$339.Metal1 123.604185185
Rred_639 vin.$105.GatPoly vin.$343.Metal1 33.8281181896
Rred_640 vin.$105.GatPoly vin.$347.Metal1 13.0141464528
Rred_641 vin.$105.GatPoly vin.$353.Metal1 98.1690707437
Rred_642 vin.$105.GatPoly vin.$578.Metal2 5361.89490005
Rred_643 vin.$105.GatPoly vin.$97.GatPoly 30.7637083127
Rred_644 vin.$107.GatPoly vin.$115.GatPoly 29.4260595885
Rred_645 vin.$107.GatPoly vin.$347.Metal1 57.8243567653
Rred_646 vin.$107.GatPoly vin.$353.Metal1 15.9311738026
Rred_647 vin.$107.GatPoly vin.$357.Metal1 55.6375076253
Rred_648 vin.$107.GatPoly vin.$578.Metal2 3154.05582356
Rred_649 vin.$107.GatPoly vin.P31.GatPoly 22.26
Rred_650 vin.$108.GatPoly vin.$110.GatPoly 11.1325184116
Rred_651 vin.$108.GatPoly vin.$346.Metal1 37.9333333333
Rred_652 vin.$108.GatPoly vin.$348.Metal1 15.5718406742
Rred_653 vin.$108.GatPoly vin.$356.Metal1 430.191522254
Rred_654 vin.$108.GatPoly vin.$579.Metal2 25055.8390465
Rred_655 vin.$108.GatPoly vin.P11.GatPoly 16.2266666667
Rred_656 vin.$110.GatPoly vin.$118.GatPoly 42.8025468312
Rred_657 vin.$110.GatPoly vin.$348.Metal1 31.5600123225
Rred_658 vin.$110.GatPoly vin.$356.Metal1 15.334097558
Rred_659 vin.$110.GatPoly vin.$360.Metal1 80.9291851852
Rred_660 vin.$110.GatPoly vin.$579.Metal2 1714.75888267
Rred_661 vin.$110.GatPoly vin.P11.GatPoly 11.3586666667
Rred_662 vin.$115.GatPoly vin.$123.GatPoly 51.4620406015
Rred_663 vin.$115.GatPoly vin.$353.Metal1 135.119661376
Rred_664 vin.$115.GatPoly vin.$357.Metal1 16.0835537092
Rred_665 vin.$115.GatPoly vin.$365.Metal1 15.9974348707
Rred_666 vin.$115.GatPoly vin.$369.Metal1 97.3021776078
Rred_667 vin.$115.GatPoly vin.$582.Metal2 4543.078818
Rred_668 vin.$115.GatPoly vin.$587.Metal2 3372.27982918
Rred_669 vin.$115.GatPoly vin.P32.GatPoly 93.7877994151
Rred_670 vin.$118.GatPoly vin.$122.GatPoly 33.2347189542
Rred_671 vin.$118.GatPoly vin.$356.Metal1 80.9291851852
Rred_672 vin.$118.GatPoly vin.$360.Metal1 15.5987328054
Rred_673 vin.$118.GatPoly vin.$368.Metal1 20.4860406756
Rred_674 vin.$118.GatPoly vin.$586.Metal2 2301.94136839
Rred_675 vin.$118.GatPoly vin.$590.Metal2 12405.3841055
Rred_676 vin.$118.GatPoly vin.P12.GatPoly 12.9518899643
Rred_677 vin.$122.GatPoly vin.$130.GatPoly 60.50563664
Rred_678 vin.$122.GatPoly vin.$368.Metal1 18.2531011901
Rred_679 vin.$122.GatPoly vin.$374.Metal1 15.6601627124
Rred_680 vin.$122.GatPoly vin.$378.Metal1 84.9923100066
Rred_681 vin.$122.GatPoly vin.$590.Metal2 1611.09899248
Rred_682 vin.$122.GatPoly vin.P12.GatPoly 30.8176484848
Rred_683 vin.$122.GatPoly vin.P13.GatPoly 123.431498746
Rred_684 vin.$123.GatPoly vin.$127.GatPoly 36.1143032099
Rred_685 vin.$123.GatPoly vin.$365.Metal1 97.3021776078
Rred_686 vin.$123.GatPoly vin.$369.Metal1 16.2930131079
Rred_687 vin.$123.GatPoly vin.$375.Metal1 15.7999014456
Rred_688 vin.$123.GatPoly vin.$379.Metal1 96.7347407407
Rred_689 vin.$123.GatPoly vin.$591.Metal2 1611.09899248
Rred_690 vin.$123.GatPoly vin.P32.GatPoly 72.5872454666
Rred_691 vin.$127.GatPoly vin.$133.GatPoly 11.5007407407
Rred_692 vin.$127.GatPoly vin.$375.Metal1 68.2833464052
Rred_693 vin.$127.GatPoly vin.$379.Metal1 27.001323271
Rred_694 vin.$127.GatPoly vin.$383.Metal1 21.7450980392
Rred_695 vin.$127.GatPoly vin.P33.GatPoly 22.26
Rred_696 vin.$130.GatPoly vin.$134.GatPoly 20.0625185185
Rred_697 vin.$130.GatPoly vin.$374.Metal1 114.401413815
Rred_698 vin.$130.GatPoly vin.$378.Metal1 18.1851091752
Rred_699 vin.$130.GatPoly vin.$386.Metal1 16.8812213797
Rred_700 vin.$130.GatPoly vin.$595.Metal2 8439.59448869
Rred_701 vin.$130.GatPoly vin.$599.Metal2 2525.70222612
Rred_702 vin.$130.GatPoly vin.P13.GatPoly 7.97486881396
Rred_703 vin.$133.GatPoly vin.$139.GatPoly 20.0625185185
Rred_704 vin.$133.GatPoly vin.$383.Metal1 21.56043852
Rred_705 vin.$133.GatPoly vin.$391.Metal1 16.8734596927
Rred_706 vin.$133.GatPoly vin.$600.Metal2 2681.79641039
Rred_707 vin.$133.GatPoly vin.$605.Metal2 6962.69289808
Rred_708 vin.$134.GatPoly vin.$136.GatPoly 17.2080405764
Rred_709 vin.$134.GatPoly vin.$386.Metal1 16.9633899809
Rred_710 vin.$134.GatPoly vin.$392.Metal1 17.7474958524
Rred_711 vin.$134.GatPoly vin.$396.Metal1 2936.27252746
Rred_712 vin.$134.GatPoly vin.$604.Metal2 1989.57191416
Rred_713 vin.$136.GatPoly vin.$144.GatPoly 25.4131134156
Rred_714 vin.$136.GatPoly vin.$392.Metal1 33.0203657934
Rred_715 vin.$136.GatPoly vin.$396.Metal1 18.8410085241
Rred_716 vin.$136.GatPoly vin.$400.Metal1 48.0500043573
Rred_717 vin.$136.GatPoly vin.P14.GatPoly 4.76
Rred_718 vin.$139.GatPoly vin.$145.GatPoly 49.728552584
Rred_719 vin.$139.GatPoly vin.$391.Metal1 16.8979026397
Rred_720 vin.$139.GatPoly vin.$397.Metal1 16.7441738501
Rred_721 vin.$139.GatPoly vin.$401.Metal1 94.0245742134
Rred_722 vin.$139.GatPoly vin.$605.Metal2 3155.60314934
Rred_723 vin.$139.GatPoly vin.$609.Metal2 3155.60314934
Rred_724 vin.$139.GatPoly vin.P34.GatPoly 43.5585188802
Rred_725 vin.$144.GatPoly vin.$152.GatPoly 80.7317467344
Rred_726 vin.$144.GatPoly vin.$396.Metal1 204.212518518
Rred_727 vin.$144.GatPoly vin.$400.Metal1 16.3459334659
Rred_728 vin.$144.GatPoly vin.$408.Metal1 16.4300806005
Rred_729 vin.$144.GatPoly vin.$412.Metal1 152.644058952
Rred_730 vin.$144.GatPoly vin.$610.Metal2 3870.9558658
Rred_731 vin.$144.GatPoly vin.$615.Metal2 3870.9558658
Rred_732 vin.$144.GatPoly vin.P15.GatPoly 38.1468722988
Rred_733 vin.$145.GatPoly vin.$153.GatPoly 50.9131933514
Rred_734 vin.$145.GatPoly vin.$397.Metal1 88.3584740173
Rred_735 vin.$145.GatPoly vin.$401.Metal1 15.6945892453
Rred_736 vin.$145.GatPoly vin.$409.Metal1 15.8678203345
Rred_737 vin.$145.GatPoly vin.$413.Metal1 96.2644412107
Rred_738 vin.$145.GatPoly vin.$611.Metal2 3870.9558658
Rred_739 vin.$145.GatPoly vin.$616.Metal2 3870.9558658
Rred_740 vin.$145.GatPoly vin.P34.GatPoly 182.46553525
Rred_741 vin.$145.GatPoly vin.P35.GatPoly 112.502748125
Rred_742 vin.$15.GatPoly vin.$17.GatPoly 8.64681481481
Rred_743 vin.$15.GatPoly vin.$219.Metal1 12.6296021429
Rred_744 vin.$15.GatPoly vin.$227.Metal1 37.7619085138
Rred_745 vin.$15.GatPoly vin.$27.GatPoly 41.3580961617
Rred_746 vin.$15.GatPoly vin.$493.Metal2 2934.89262124
Rred_747 vin.$15.GatPoly vin.P22.GatPoly 22.26
Rred_748 vin.$152.GatPoly vin.$156.GatPoly 40.1272493827
Rred_749 vin.$152.GatPoly vin.$408.Metal1 152.644058952
Rred_750 vin.$152.GatPoly vin.$412.Metal1 18.6069469566
Rred_751 vin.$152.GatPoly vin.$418.Metal1 15.6802121879
Rred_752 vin.$152.GatPoly vin.$422.Metal1 85.9869629629
Rred_753 vin.$152.GatPoly vin.$619.Metal2 1563.02782058
Rred_754 vin.$152.GatPoly vin.P15.GatPoly 21.4418885263
Rred_755 vin.$153.GatPoly vin.$157.GatPoly 40.1272493827
Rred_756 vin.$153.GatPoly vin.$409.Metal1 96.2644412107
Rred_757 vin.$153.GatPoly vin.$413.Metal1 16.5099701104
Rred_758 vin.$153.GatPoly vin.$419.Metal1 15.6802121879
Rred_759 vin.$153.GatPoly vin.$423.Metal1 85.9869629629
Rred_760 vin.$153.GatPoly vin.$620.Metal2 1563.02782058
Rred_761 vin.$153.GatPoly vin.P35.GatPoly 63.2364133369
Rred_762 vin.$156.GatPoly vin.$164.GatPoly 22.7378159671
Rred_763 vin.$156.GatPoly vin.$418.Metal1 75.8708496732
Rred_764 vin.$156.GatPoly vin.$422.Metal1 30.0016540887
Rred_765 vin.$156.GatPoly vin.$426.Metal1 17.0002205452
Rred_766 vin.$156.GatPoly vin.$430.Metal1 42.9916688453
Rred_767 vin.$156.GatPoly vin.P16.GatPoly 4.76
Rred_768 vin.$157.GatPoly vin.$163.GatPoly 9.36029629629
Rred_769 vin.$157.GatPoly vin.$419.Metal1 75.8708496732
Rred_770 vin.$157.GatPoly vin.$423.Metal1 30.0016540887
Rred_771 vin.$157.GatPoly vin.$427.Metal1 17.6980392157
Rred_772 vin.$157.GatPoly vin.P36.GatPoly 22.26
Rred_773 vin.$16.GatPoly vin.$210.Metal1 16.8857192322
Rred_774 vin.$16.GatPoly vin.$218.Metal1 19.3496497775
Rred_775 vin.$16.GatPoly vin.$22.GatPoly 77.9511897103
Rred_776 vin.$16.GatPoly vin.$222.Metal1 147.386703234
Rred_777 vin.$16.GatPoly vin.$488.Metal2 2301.94136839
Rred_778 vin.$16.GatPoly vin.$492.Metal2 12405.3841055
Rred_779 vin.$16.GatPoly vin.P2.GatPoly 19.176544151
Rred_780 vin.$163.GatPoly vin.$167.GatPoly 41.3580961617
Rred_781 vin.$163.GatPoly vin.$427.Metal1 27.2939474766
Rred_782 vin.$163.GatPoly vin.$433.Metal1 14.2581745852
Rred_783 vin.$163.GatPoly vin.$441.Metal1 115.651204718
Rred_784 vin.$163.GatPoly vin.$629.Metal2 2664.67413314
Rred_785 vin.$163.GatPoly vin.$636.Metal2 6114.14760608
Rred_786 vin.$164.GatPoly vin.$172.GatPoly 77.9511897103
Rred_787 vin.$164.GatPoly vin.$426.Metal1 365.429185185
Rred_788 vin.$164.GatPoly vin.$430.Metal1 16.5931436324
Rred_789 vin.$164.GatPoly vin.$437.Metal1 16.2158441731
Rred_790 vin.$164.GatPoly vin.$440.Metal1 147.386703234
Rred_791 vin.$164.GatPoly vin.$630.Metal2 1836.80456241
Rred_792 vin.$164.GatPoly vin.P17.GatPoly 42.9114848609
Rred_793 vin.$167.GatPoly vin.$173.GatPoly 8.64681481481
Rred_794 vin.$167.GatPoly vin.$433.Metal1 37.7619085138
Rred_795 vin.$167.GatPoly vin.$441.Metal1 12.6296021429
Rred_796 vin.$167.GatPoly vin.$636.Metal2 2934.89262124
Rred_797 vin.$167.GatPoly vin.P37.GatPoly 22.26
Rred_798 vin.$17.GatPoly vin.$207.Metal1 80.9291851852
Rred_799 vin.$17.GatPoly vin.$211.Metal1 15.5987328054
Rred_800 vin.$17.GatPoly vin.$219.Metal1 27.3987871831
Rred_801 vin.$17.GatPoly vin.$489.Metal2 2301.94136839
Rred_802 vin.$17.GatPoly vin.$493.Metal2 12405.3841055
Rred_803 vin.$17.GatPoly vin.$9.GatPoly 42.8025468312
Rred_804 vin.$172.GatPoly vin.$176.GatPoly 20.0625185185
Rred_805 vin.$172.GatPoly vin.$437.Metal1 147.386703234
Rred_806 vin.$172.GatPoly vin.$440.Metal1 19.3496497775
Rred_807 vin.$172.GatPoly vin.$448.Metal1 16.8857192322
Rred_808 vin.$172.GatPoly vin.$635.Metal2 12405.3841055
Rred_809 vin.$172.GatPoly vin.$639.Metal2 2301.94136839
Rred_810 vin.$172.GatPoly vin.P17.GatPoly 19.176544151
Rred_811 vin.$173.GatPoly vin.$179.GatPoly 42.8025468312
Rred_812 vin.$173.GatPoly vin.$441.Metal1 27.3987871831
Rred_813 vin.$173.GatPoly vin.$449.Metal1 15.5987328054
Rred_814 vin.$173.GatPoly vin.$453.Metal1 80.9291851852
Rred_815 vin.$173.GatPoly vin.$636.Metal2 12405.3841055
Rred_816 vin.$173.GatPoly vin.$640.Metal2 2301.94136839
Rred_817 vin.$176.GatPoly vin.$180.GatPoly 33.2847407407
Rred_818 vin.$176.GatPoly vin.$448.Metal1 16.8901542286
Rred_819 vin.$176.GatPoly vin.$456.Metal1 20.489591646
Rred_820 vin.$176.GatPoly vin.$644.Metal2 2115.07400678
Rred_821 vin.$176.GatPoly vin.$648.Metal2 23421.3890021
Rred_822 vin.$176.GatPoly vin.P18.GatPoly 19.9708444444
Rred_823 vin.$179.GatPoly vin.$449.Metal1 80.9291851852
Rred_824 vin.$179.GatPoly vin.$453.Metal1 32.0018746339
Rred_825 vin.$179.GatPoly vin.$457.Metal1 8.16033769425
Rred_826 vin.$179.GatPoly vin.$649.Metal2 877.519802179
Rred_827 vin.$179.GatPoly vin.$654.Metal2 295.150090209
Rred_828 vin.$179.GatPoly vin.P38.GatPoly 22.26
Rred_829 vin.$179.GatPoly vin.P39.GatPoly 365.628758224
Rred_830 vin.$180.GatPoly vin.$456.Metal1 8.0987663346
Rred_831 vin.$180.GatPoly vin.$648.Metal2 456.549538848
Rred_832 vin.$180.GatPoly vin.$653.Metal2 158.542646647
Rred_833 vin.$180.GatPoly vin.P18.GatPoly 19.9708444444
Rred_834 vin.$180.GatPoly vin.P19.GatPoly 86.7094752085
Rred_835 vin.$199.Metal1 vin.$207.Metal1 0.375564027363
Rred_836 vin.$199.Metal1 vin.$478.Metal2 3.78805926628
Rred_837 vin.$199.Metal1 vin.$482.Metal2 10.5892283293
Rred_838 vin.$199.Metal1 vin.$7.GatPoly 8.40742338009
Rred_839 vin.$199.Metal1 vin.$9.GatPoly 31.5600123225
Rred_840 vin.$199.Metal1 vin.P20.GatPoly 42.4356900032
Rred_841 vin.$202.Metal1 vin.$210.Metal1 0.362318738522
Rred_842 vin.$202.Metal1 vin.$476.Metal2 4.15223424267
Rred_843 vin.$202.Metal1 vin.$481.Metal2 6.75208772039
Rred_844 vin.$202.Metal1 vin.$483.Metal2 27.6679763963
Rred_845 vin.$202.Metal1 vin.$6.GatPoly 8.09494705917
Rred_846 vin.$202.Metal1 vin.P0.GatPoly 21.9122811939
Rred_847 vin.$202.Metal1 vin.P1.GatPoly 37.76
Rred_848 vin.$207.Metal1 vin.$211.Metal1 0.178668121137
Rred_849 vin.$207.Metal1 vin.$482.Metal2 10.1906073209
Rred_850 vin.$207.Metal1 vin.$486.Metal2 116.98703911
Rred_851 vin.$207.Metal1 vin.$489.Metal2 33.8392261889
Rred_852 vin.$207.Metal1 vin.$7.GatPoly 430.191522254
Rred_853 vin.$207.Metal1 vin.$9.GatPoly 15.334097558
Rred_854 vin.$210.Metal1 vin.$218.Metal1 0.362653569415
Rred_855 vin.$210.Metal1 vin.$481.Metal2 138.339881981
Rred_856 vin.$210.Metal1 vin.$483.Metal2 13.6089175956
Rred_857 vin.$210.Metal1 vin.$488.Metal2 11.5186194376
Rred_858 vin.$210.Metal1 vin.$492.Metal2 148.012303013
Rred_859 vin.$211.Metal1 vin.$219.Metal1 0.362653569415
Rred_860 vin.$211.Metal1 vin.$482.Metal2 56.7915325123
Rred_861 vin.$211.Metal1 vin.$486.Metal2 228.887685216
Rred_862 vin.$211.Metal1 vin.$489.Metal2 9.81161105877
Rred_863 vin.$211.Metal1 vin.$493.Metal2 148.012303013
Rred_864 vin.$211.Metal1 vin.$9.GatPoly 80.9291851852
Rred_865 vin.$218.Metal1 vin.$22.GatPoly 147.386703234
Rred_866 vin.$218.Metal1 vin.$222.Metal1 0.178129923539
Rred_867 vin.$218.Metal1 vin.$488.Metal2 12.8905653645
Rred_868 vin.$218.Metal1 vin.$492.Metal2 18.9451496641
Rred_869 vin.$218.Metal1 vin.P2.GatPoly 36.2581717142
Rred_870 vin.$219.Metal1 vin.$227.Metal1 0.39094415179
Rred_871 vin.$219.Metal1 vin.$27.GatPoly 115.651204718
Rred_872 vin.$219.Metal1 vin.$489.Metal2 12.8905653645
Rred_873 vin.$219.Metal1 vin.$493.Metal2 9.17818171348
Rred_874 vin.$22.GatPoly vin.$222.Metal1 16.2158441731
Rred_875 vin.$22.GatPoly vin.$228.Metal1 16.5931436324
Rred_876 vin.$22.GatPoly vin.$232.Metal1 365.429185185
Rred_877 vin.$22.GatPoly vin.$24.GatPoly 22.7378159671
Rred_878 vin.$22.GatPoly vin.$497.Metal2 1836.80456241
Rred_879 vin.$22.GatPoly vin.P2.GatPoly 42.9114848609
Rred_880 vin.$222.Metal1 vin.$228.Metal1 0.36174266925
Rred_881 vin.$222.Metal1 vin.$492.Metal2 9.42324175824
Rred_882 vin.$222.Metal1 vin.$497.Metal2 21.8084097251
Rred_883 vin.$222.Metal1 vin.P2.GatPoly 81.1351604514
Rred_884 vin.$227.Metal1 vin.$233.Metal1 0.331848942782
Rred_885 vin.$227.Metal1 vin.$27.GatPoly 14.2581745852
Rred_886 vin.$227.Metal1 vin.$493.Metal2 11.1591689028
Rred_887 vin.$227.Metal1 vin.$495.Metal2 38.1149573586
Rred_888 vin.$227.Metal1 vin.$500.Metal2 12.4168010073
Rred_889 vin.$228.Metal1 vin.$232.Metal1 0.178852088262
Rred_890 vin.$228.Metal1 vin.$236.Metal1 4036.92165822
Rred_891 vin.$228.Metal1 vin.$24.GatPoly 42.9916688453
Rred_892 vin.$228.Metal1 vin.$497.Metal2 9.12759240183
Rred_893 vin.$228.Metal1 vin.$503.Metal2 43.9859302507
Rred_894 vin.$232.Metal1 vin.$236.Metal1 0.17894182666
Rred_895 vin.$232.Metal1 vin.$24.GatPoly 17.0002205452
Rred_896 vin.$232.Metal1 vin.$497.Metal2 23.8007022261
Rred_897 vin.$232.Metal1 vin.$503.Metal2 22.6413748687
Rred_898 vin.$233.Metal1 vin.$237.Metal1 0.178949087371
Rred_899 vin.$233.Metal1 vin.$25.GatPoly 17.6980392157
Rred_900 vin.$233.Metal1 vin.$27.GatPoly 27.2939474766
Rred_901 vin.$233.Metal1 vin.$500.Metal2 10.4731205828
Rred_902 vin.$233.Metal1 vin.$504.Metal2 42.814045977
Rred_903 vin.$236.Metal1 vin.$24.GatPoly 30.0016540887
Rred_904 vin.$236.Metal1 vin.$240.Metal1 0.178504947966
Rred_905 vin.$236.Metal1 vin.$36.GatPoly 85.9869629629
Rred_906 vin.$236.Metal1 vin.$497.Metal2 48.5088769371
Rred_907 vin.$236.Metal1 vin.$503.Metal2 15.140503946
Rred_908 vin.$237.Metal1 vin.$241.Metal1 0.178504947966
Rred_909 vin.$237.Metal1 vin.$25.GatPoly 30.0016540887
Rred_910 vin.$237.Metal1 vin.$37.GatPoly 85.9869629629
Rred_911 vin.$237.Metal1 vin.$500.Metal2 31.8360854701
Rred_912 vin.$237.Metal1 vin.$504.Metal2 17.9090803107
Rred_913 vin.$24.GatPoly vin.$240.Metal1 75.8708496732
Rred_914 vin.$24.GatPoly vin.$36.GatPoly 40.1272493827
Rred_915 vin.$24.GatPoly vin.P3.GatPoly 4.76
Rred_916 vin.$240.Metal1 vin.$246.Metal1 0.36182906056
Rred_917 vin.$240.Metal1 vin.$36.GatPoly 15.6802121879
Rred_918 vin.$240.Metal1 vin.$503.Metal2 11.5864555256
Rred_919 vin.$240.Metal1 vin.$508.Metal2 18.0168451015
Rred_920 vin.$241.Metal1 vin.$247.Metal1 0.36182906056
Rred_921 vin.$241.Metal1 vin.$25.GatPoly 75.8708496732
Rred_922 vin.$241.Metal1 vin.$37.GatPoly 15.6802121879
Rred_923 vin.$241.Metal1 vin.$504.Metal2 11.5864555256
Rred_924 vin.$241.Metal1 vin.$509.Metal2 18.0168451015
Rred_925 vin.$246.Metal1 vin.$250.Metal1 0.17852453123
Rred_926 vin.$246.Metal1 vin.$36.GatPoly 18.6069469566
Rred_927 vin.$246.Metal1 vin.$42.GatPoly 152.644058952
Rred_928 vin.$246.Metal1 vin.$508.Metal2 10.1769943283
Rred_929 vin.$246.Metal1 vin.$512.Metal2 22.5350597402
Rred_930 vin.$246.Metal1 vin.P4.GatPoly 40.541385869
Rred_931 vin.$247.Metal1 vin.$251.Metal1 0.178459879632
Rred_932 vin.$247.Metal1 vin.$37.GatPoly 16.5099701104
Rred_933 vin.$247.Metal1 vin.$43.GatPoly 96.2644412107
Rred_934 vin.$247.Metal1 vin.$509.Metal2 10.1769943283
Rred_935 vin.$247.Metal1 vin.$513.Metal2 22.5350597402
Rred_936 vin.$247.Metal1 vin.P24.GatPoly 119.564647066
Rred_937 vin.$25.GatPoly vin.$27.GatPoly 9.36029629629
Rred_938 vin.$25.GatPoly vin.$37.GatPoly 40.1272493827
Rred_939 vin.$25.GatPoly vin.P23.GatPoly 22.26
Rred_940 vin.$250.Metal1 vin.$258.Metal1 0.362824398622
Rred_941 vin.$250.Metal1 vin.$36.GatPoly 152.644058952
Rred_942 vin.$250.Metal1 vin.$42.GatPoly 16.4300806005
Rred_943 vin.$250.Metal1 vin.$508.Metal2 95.3406373629
Rred_944 vin.$250.Metal1 vin.$512.Metal2 10.1192256903
Rred_945 vin.$250.Metal1 vin.$517.Metal2 46.1776507338
Rred_946 vin.$250.Metal1 vin.P4.GatPoly 72.1264392205
Rred_947 vin.$251.Metal1 vin.$259.Metal1 0.362824398622
Rred_948 vin.$251.Metal1 vin.$37.GatPoly 96.2644412107
Rred_949 vin.$251.Metal1 vin.$43.GatPoly 15.8678203345
Rred_950 vin.$251.Metal1 vin.$509.Metal2 95.3406373629
Rred_951 vin.$251.Metal1 vin.$513.Metal2 10.1192256903
Rred_952 vin.$251.Metal1 vin.$518.Metal2 46.1776507338
Rred_953 vin.$251.Metal1 vin.P24.GatPoly 212.715280069
Rred_954 vin.$258.Metal1 vin.$262.Metal1 0.178550748274
Rred_955 vin.$258.Metal1 vin.$264.Metal1 7610.30667437
Rred_956 vin.$258.Metal1 vin.$42.GatPoly 16.3459334659
Rred_957 vin.$258.Metal1 vin.$44.GatPoly 48.0500043573
Rred_958 vin.$258.Metal1 vin.$512.Metal2 46.1776507338
Rred_959 vin.$258.Metal1 vin.$517.Metal2 9.7817715397
Rred_960 vin.$258.Metal1 vin.$523.Metal2 145.280351752
Rred_961 vin.$259.Metal1 vin.$263.Metal1 0.178449366077
Rred_962 vin.$259.Metal1 vin.$43.GatPoly 15.6945892453
Rred_963 vin.$259.Metal1 vin.$51.GatPoly 94.0245742134
Rred_964 vin.$259.Metal1 vin.$513.Metal2 46.1776507338
Rred_965 vin.$259.Metal1 vin.$518.Metal2 11.3207867366
Rred_966 vin.$259.Metal1 vin.$520.Metal2 47.2209706961
Rred_967 vin.$259.Metal1 vin.P25.GatPoly 344.997860768
Rred_968 vin.$262.Metal1 vin.$264.Metal1 0.180721425263
Rred_969 vin.$262.Metal1 vin.$42.GatPoly 204.212518518
Rred_970 vin.$262.Metal1 vin.$44.GatPoly 18.8410085241
Rred_971 vin.$262.Metal1 vin.$517.Metal2 17.0071631934
Rred_972 vin.$262.Metal1 vin.$52.GatPoly 2936.27252746
Rred_973 vin.$262.Metal1 vin.$523.Metal2 34.3389922323
Rred_974 vin.$263.Metal1 vin.$269.Metal1 0.36179574156
Rred_975 vin.$263.Metal1 vin.$43.GatPoly 88.3584740173
Rred_976 vin.$263.Metal1 vin.$51.GatPoly 16.7441738501
Rred_977 vin.$263.Metal1 vin.$520.Metal2 8.59951511509
Rred_978 vin.$263.Metal1 vin.$524.Metal2 37.466526281
Rred_979 vin.$263.Metal1 vin.P25.GatPoly 136.42270417
Rred_980 vin.$264.Metal1 vin.$272.Metal1 0.358974281487
Rred_981 vin.$264.Metal1 vin.$44.GatPoly 33.0203657934
Rred_982 vin.$264.Metal1 vin.$517.Metal2 27.6894597146
Rred_983 vin.$264.Metal1 vin.$52.GatPoly 17.7474958524
Rred_984 vin.$264.Metal1 vin.$523.Metal2 8.62947986197
Rred_985 vin.$269.Metal1 vin.$277.Metal1 0.362599659797
Rred_986 vin.$269.Metal1 vin.$51.GatPoly 16.8979026397
Rred_987 vin.$269.Metal1 vin.$520.Metal2 36.3742809915
Rred_988 vin.$269.Metal1 vin.$524.Metal2 7.94564138892
Rred_989 vin.$269.Metal1 vin.$529.Metal2 31.9493406534
Rred_990 vin.$269.Metal1 vin.$55.GatPoly 16.8734596927
Rred_991 vin.$27.GatPoly vin.$493.Metal2 6114.14760608
Rred_992 vin.$27.GatPoly vin.$500.Metal2 2664.67413314
Rred_993 vin.$272.Metal1 vin.$280.Metal1 0.362797942164
Rred_994 vin.$272.Metal1 vin.$52.GatPoly 16.9633899809
Rred_995 vin.$272.Metal1 vin.$523.Metal2 15.0113662187
Rred_996 vin.$272.Metal1 vin.$528.Metal2 10.3514401745
Rred_997 vin.$272.Metal1 vin.$532.Metal2 100.688434264
Rred_998 vin.$272.Metal1 vin.$58.GatPoly 16.8812213797
Rred_999 vin.$277.Metal1 vin.$281.Metal1 0.17890681013
Rred_1000 vin.$277.Metal1 vin.$524.Metal2 83.0682856989
Rred_1001 vin.$277.Metal1 vin.$529.Metal2 10.1469188401
Rred_1002 vin.$277.Metal1 vin.$533.Metal2 49.65256
Rred_1003 vin.$277.Metal1 vin.$55.GatPoly 21.56043852
Rred_1004 vin.$277.Metal1 vin.$57.GatPoly 21.7450980392
Rred_1005 vin.$280.Metal1 vin.$284.Metal1 0.178374896227
Rred_1006 vin.$280.Metal1 vin.$528.Metal2 14.7413390447
Rred_1007 vin.$280.Metal1 vin.$532.Metal2 15.9997708552
Rred_1008 vin.$280.Metal1 vin.$58.GatPoly 18.1851091752
Rred_1009 vin.$280.Metal1 vin.$64.GatPoly 84.9923100066
Rred_1010 vin.$280.Metal1 vin.P6.GatPoly 92.2851475241
Rred_1011 vin.$281.Metal1 vin.$285.Metal1 0.178398933563
Rred_1012 vin.$281.Metal1 vin.$529.Metal2 28.8677674419
Rred_1013 vin.$281.Metal1 vin.$533.Metal2 19.0235339939
Rred_1014 vin.$281.Metal1 vin.$57.GatPoly 27.001323271
Rred_1015 vin.$281.Metal1 vin.$65.GatPoly 96.7347407407
Rred_1016 vin.$284.Metal1 vin.$290.Metal1 0.361824121591
Rred_1017 vin.$284.Metal1 vin.$532.Metal2 10.7656516291
Rred_1018 vin.$284.Metal1 vin.$537.Metal2 19.1286039107
Rred_1019 vin.$284.Metal1 vin.$58.GatPoly 114.401413815
Rred_1020 vin.$284.Metal1 vin.$64.GatPoly 15.6601627124
Rred_1021 vin.$284.Metal1 vin.P6.GatPoly 233.378884183
Rred_1022 vin.$285.Metal1 vin.$291.Metal1 0.361824121591
Rred_1023 vin.$285.Metal1 vin.$533.Metal2 10.7656516291
Rred_1024 vin.$285.Metal1 vin.$538.Metal2 19.1286039107
Rred_1025 vin.$285.Metal1 vin.$57.GatPoly 68.2833464052
Rred_1026 vin.$285.Metal1 vin.$65.GatPoly 15.7999014456
Rred_1027 vin.$290.Metal1 vin.$298.Metal1 0.362653569415
Rred_1028 vin.$290.Metal1 vin.$537.Metal2 9.52216809103
Rred_1029 vin.$290.Metal1 vin.$541.Metal2 12.8905653645
Rred_1030 vin.$290.Metal1 vin.$64.GatPoly 18.2531011901
Rred_1031 vin.$290.Metal1 vin.$70.GatPoly 20.4860406756
Rred_1032 vin.$290.Metal1 vin.P7.GatPoly 58.2686631016
Rred_1033 vin.$291.Metal1 vin.$295.Metal1 0.17857627571
Rred_1034 vin.$291.Metal1 vin.$538.Metal2 10.1777438502
Rred_1035 vin.$291.Metal1 vin.$542.Metal2 24.3181269841
Rred_1036 vin.$291.Metal1 vin.$65.GatPoly 16.2930131079
Rred_1037 vin.$291.Metal1 vin.$73.GatPoly 97.3021776078
Rred_1038 vin.$291.Metal1 vin.P27.GatPoly 137.244791849
Rred_1039 vin.$295.Metal1 vin.$303.Metal1 0.362799427562
Rred_1040 vin.$295.Metal1 vin.$538.Metal2 72.9543809522
Rred_1041 vin.$295.Metal1 vin.$542.Metal2 10.1293546422
Rred_1042 vin.$295.Metal1 vin.$547.Metal2 54.2048156595
Rred_1043 vin.$295.Metal1 vin.$65.GatPoly 97.3021776078
Rred_1044 vin.$295.Metal1 vin.$73.GatPoly 15.9974348707
Rred_1045 vin.$295.Metal1 vin.P27.GatPoly 177.329872844
Rred_1046 vin.$298.Metal1 vin.$302.Metal1 0.178668868145
Rred_1047 vin.$298.Metal1 vin.$537.Metal2 148.012303013
Rred_1048 vin.$298.Metal1 vin.$541.Metal2 9.91391002973
Rred_1049 vin.$298.Metal1 vin.$544.Metal2 136.676492583
Rred_1050 vin.$298.Metal1 vin.$548.Metal2 63.5012825511
Rred_1051 vin.$298.Metal1 vin.$70.GatPoly 15.5987328054
Rred_1052 vin.$298.Metal1 vin.$78.GatPoly 80.9291851852
Rred_1053 vin.$302.Metal1 vin.$310.Metal1 0.375564027363
Rred_1054 vin.$302.Metal1 vin.$541.Metal2 36.3717608362
Rred_1055 vin.$302.Metal1 vin.$544.Metal2 69.856873987
Rred_1056 vin.$302.Metal1 vin.$548.Metal2 10.5831998195
Rred_1057 vin.$302.Metal1 vin.$70.GatPoly 80.9291851852
Rred_1058 vin.$302.Metal1 vin.$78.GatPoly 15.334097558
Rred_1059 vin.$302.Metal1 vin.$80.GatPoly 430.191522254
Rred_1060 vin.$303.Metal1 vin.$307.Metal1 0.178371493384
Rred_1061 vin.$303.Metal1 vin.$542.Metal2 40.2164761345
Rred_1062 vin.$303.Metal1 vin.$547.Metal2 10.1082003498
Rred_1063 vin.$303.Metal1 vin.$551.Metal2 137.607164021
Rred_1064 vin.$303.Metal1 vin.$73.GatPoly 16.0835537092
Rred_1065 vin.$303.Metal1 vin.$77.GatPoly 55.6375076253
Rred_1066 vin.$307.Metal1 vin.$313.Metal1 0.36146618849
Rred_1067 vin.$307.Metal1 vin.$547.Metal2 20.9909233253
Rred_1068 vin.$307.Metal1 vin.$551.Metal2 10.1668380754
Rred_1069 vin.$307.Metal1 vin.$73.GatPoly 135.119661376
Rred_1070 vin.$307.Metal1 vin.$77.GatPoly 15.9311738026
Rred_1071 vin.$307.Metal1 vin.$83.GatPoly 98.1690707437
Rred_1072 vin.$310.Metal1 vin.$312.Metal1 0.165
Rred_1073 vin.$310.Metal1 vin.$548.Metal2 9.92591643291
Rred_1074 vin.$310.Metal1 vin.$552.Metal2 18.1718095238
Rred_1075 vin.$310.Metal1 vin.$78.GatPoly 31.5600123225
Rred_1076 vin.$310.Metal1 vin.$80.GatPoly 15.5718406742
Rred_1077 vin.$312.Metal1 vin.$320.Metal1 0.362724514501
Rred_1078 vin.$312.Metal1 vin.$552.Metal2 10.5257138212
Rred_1079 vin.$312.Metal1 vin.$557.Metal2 35.6129523328
Rred_1080 vin.$312.Metal1 vin.$80.GatPoly 37.9333333333
Rred_1081 vin.$312.Metal1 vin.$84.GatPoly 16.8757273465
Rred_1082 vin.$313.Metal1 vin.$317.Metal1 0.178799366164
Rred_1083 vin.$313.Metal1 vin.$551.Metal2 11.008714331
Rred_1084 vin.$313.Metal1 vin.$555.Metal2 57.4004804448
Rred_1085 vin.$313.Metal1 vin.$558.Metal2 33.6812736494
Rred_1086 vin.$313.Metal1 vin.$77.GatPoly 57.8243567653
Rred_1087 vin.$313.Metal1 vin.$83.GatPoly 13.0141464528
Rred_1088 vin.$317.Metal1 vin.$321.Metal1 0.178838571508
Rred_1089 vin.$317.Metal1 vin.$551.Metal2 80.5238780093
Rred_1090 vin.$317.Metal1 vin.$555.Metal2 148.032817989
Rred_1091 vin.$317.Metal1 vin.$558.Metal2 14.6154515868
Rred_1092 vin.$317.Metal1 vin.$83.GatPoly 33.8281181896
Rred_1093 vin.$317.Metal1 vin.$87.GatPoly 58.1666753812
Rred_1094 vin.$320.Metal1 vin.$328.Metal1 0.362169844265
Rred_1095 vin.$320.Metal1 vin.$552.Metal2 65.6028069289
Rred_1096 vin.$320.Metal1 vin.$557.Metal2 8.52565576862
Rred_1097 vin.$320.Metal1 vin.$561.Metal2 24.2669420704
Rred_1098 vin.$320.Metal1 vin.$84.GatPoly 17.7993670334
Rred_1099 vin.$320.Metal1 vin.$90.GatPoly 20.2758380631
Rred_1100 vin.$320.Metal1 vin.P9.GatPoly 68.7832679738
Rred_1101 vin.$321.Metal1 vin.$325.Metal1 0.178840374465
Rred_1102 vin.$321.Metal1 vin.$558.Metal2 14.1682801538
Rred_1103 vin.$321.Metal1 vin.$562.Metal2 59.0882403627
Rred_1104 vin.$321.Metal1 vin.$83.GatPoly 123.604185185
Rred_1105 vin.$321.Metal1 vin.$87.GatPoly 23.0008821806
Rred_1106 vin.$325.Metal1 vin.$329.Metal1 0.178273944544
Rred_1107 vin.$325.Metal1 vin.$558.Metal2 26.4011286728
Rred_1108 vin.$325.Metal1 vin.$562.Metal2 20.2863564567
Rred_1109 vin.$325.Metal1 vin.$87.GatPoly 24.0009924532
Rred_1110 vin.$325.Metal1 vin.$95.GatPoly 114.647703704
Rred_1111 vin.$328.Metal1 vin.$334.Metal1 0.361795734713
Rred_1112 vin.$328.Metal1 vin.$557.Metal2 53.4649554857
Rred_1113 vin.$328.Metal1 vin.$561.Metal2 8.0753915984
Rred_1114 vin.$328.Metal1 vin.$566.Metal2 20.3813394518
Rred_1115 vin.$328.Metal1 vin.$90.GatPoly 16.8684682797
Rred_1116 vin.$328.Metal1 vin.$94.GatPoly 16.8807966702
Rred_1117 vin.$329.Metal1 vin.$335.Metal1 0.361795734713
Rred_1118 vin.$329.Metal1 vin.$562.Metal2 10.0511202186
Rred_1119 vin.$329.Metal1 vin.$567.Metal2 20.3813394518
Rred_1120 vin.$329.Metal1 vin.$87.GatPoly 60.6958431373
Rred_1121 vin.$329.Metal1 vin.$95.GatPoly 15.9520155185
Rred_1122 vin.$334.Metal1 vin.$338.Metal1 0.178733854286
Rred_1123 vin.$334.Metal1 vin.$566.Metal2 10.1761275149
Rred_1124 vin.$334.Metal1 vin.$570.Metal2 26.4011286728
Rred_1125 vin.$334.Metal1 vin.$94.GatPoly 17.1496072721
Rred_1126 vin.$334.Metal1 vin.P10.GatPoly 55.3808723806
Rred_1127 vin.$335.Metal1 vin.$339.Metal1 0.178840374465
Rred_1128 vin.$335.Metal1 vin.$567.Metal2 10.1761275149
Rred_1129 vin.$335.Metal1 vin.$571.Metal2 26.4011286728
Rred_1130 vin.$335.Metal1 vin.$95.GatPoly 19.1121432091
Rred_1131 vin.$335.Metal1 vin.$97.GatPoly 27.1411764706
Rred_1132 vin.$338.Metal1 vin.$346.Metal1 0.362724514501
Rred_1133 vin.$338.Metal1 vin.$566.Metal2 59.0882403627
Rred_1134 vin.$338.Metal1 vin.$570.Metal2 10.1385860384
Rred_1135 vin.$338.Metal1 vin.$575.Metal2 65.6028069289
Rred_1136 vin.$338.Metal1 vin.$94.GatPoly 158.710238626
Rred_1137 vin.$338.Metal1 vin.P10.GatPoly 52.6282325743
Rred_1138 vin.$339.Metal1 vin.$343.Metal1 0.178838571508
Rred_1139 vin.$339.Metal1 vin.$567.Metal2 59.0882403627
Rred_1140 vin.$339.Metal1 vin.$571.Metal2 14.1682801538
Rred_1141 vin.$339.Metal1 vin.$97.GatPoly 23.0008821806
Rred_1142 vin.$343.Metal1 vin.$347.Metal1 0.178799366164
Rred_1143 vin.$343.Metal1 vin.$571.Metal2 14.6154515868
Rred_1144 vin.$343.Metal1 vin.$573.Metal2 148.032817989
Rred_1145 vin.$343.Metal1 vin.$578.Metal2 80.5238780093
Rred_1146 vin.$343.Metal1 vin.$97.GatPoly 58.1666753812
Rred_1147 vin.$346.Metal1 vin.$348.Metal1 0.165
Rred_1148 vin.$346.Metal1 vin.$570.Metal2 35.6129523328
Rred_1149 vin.$346.Metal1 vin.$575.Metal2 10.5257138212
Rred_1150 vin.$347.Metal1 vin.$353.Metal1 0.36146618849
Rred_1151 vin.$347.Metal1 vin.$571.Metal2 33.6812736494
Rred_1152 vin.$347.Metal1 vin.$573.Metal2 57.4004804448
Rred_1153 vin.$347.Metal1 vin.$578.Metal2 11.008714331
Rred_1154 vin.$348.Metal1 vin.$356.Metal1 0.375564027363
Rred_1155 vin.$348.Metal1 vin.$575.Metal2 18.1718095238
Rred_1156 vin.$348.Metal1 vin.$579.Metal2 9.92591643291
Rred_1157 vin.$353.Metal1 vin.$357.Metal1 0.178371493384
Rred_1158 vin.$353.Metal1 vin.$578.Metal2 10.1668380754
Rred_1159 vin.$353.Metal1 vin.$582.Metal2 20.9909233253
Rred_1160 vin.$356.Metal1 vin.$360.Metal1 0.178668868145
Rred_1161 vin.$356.Metal1 vin.$579.Metal2 10.5831998195
Rred_1162 vin.$356.Metal1 vin.$584.Metal2 69.856873987
Rred_1163 vin.$356.Metal1 vin.$586.Metal2 36.3717608362
Rred_1164 vin.$357.Metal1 vin.$365.Metal1 0.362799427562
Rred_1165 vin.$357.Metal1 vin.$578.Metal2 137.607164021
Rred_1166 vin.$357.Metal1 vin.$582.Metal2 10.1082003498
Rred_1167 vin.$357.Metal1 vin.$587.Metal2 40.2164761345
Rred_1168 vin.$36.GatPoly vin.$42.GatPoly 80.7317467344
Rred_1169 vin.$36.GatPoly vin.$508.Metal2 1563.02782058
Rred_1170 vin.$36.GatPoly vin.P4.GatPoly 21.4418885263
Rred_1171 vin.$360.Metal1 vin.$368.Metal1 0.362653569415
Rred_1172 vin.$360.Metal1 vin.$579.Metal2 63.5012825511
Rred_1173 vin.$360.Metal1 vin.$584.Metal2 136.676492583
Rred_1174 vin.$360.Metal1 vin.$586.Metal2 9.91391002973
Rred_1175 vin.$360.Metal1 vin.$590.Metal2 148.012303013
Rred_1176 vin.$365.Metal1 vin.$369.Metal1 0.17857627571
Rred_1177 vin.$365.Metal1 vin.$582.Metal2 54.2048156595
Rred_1178 vin.$365.Metal1 vin.$587.Metal2 10.1293546422
Rred_1179 vin.$365.Metal1 vin.$591.Metal2 72.9543809522
Rred_1180 vin.$365.Metal1 vin.P32.GatPoly 177.329872844
Rred_1181 vin.$368.Metal1 vin.$374.Metal1 0.361824121591
Rred_1182 vin.$368.Metal1 vin.$586.Metal2 12.8905653645
Rred_1183 vin.$368.Metal1 vin.$590.Metal2 9.52216809103
Rred_1184 vin.$368.Metal1 vin.P12.GatPoly 58.2686631016
Rred_1185 vin.$369.Metal1 vin.$375.Metal1 0.361824121591
Rred_1186 vin.$369.Metal1 vin.$587.Metal2 24.3181269841
Rred_1187 vin.$369.Metal1 vin.$591.Metal2 10.1777438502
Rred_1188 vin.$369.Metal1 vin.P32.GatPoly 137.244791849
Rred_1189 vin.$37.GatPoly vin.$43.GatPoly 50.9131933514
Rred_1190 vin.$37.GatPoly vin.$509.Metal2 1563.02782058
Rred_1191 vin.$37.GatPoly vin.P24.GatPoly 63.2364133369
Rred_1192 vin.$374.Metal1 vin.$378.Metal1 0.178374896227
Rred_1193 vin.$374.Metal1 vin.$590.Metal2 19.1286039107
Rred_1194 vin.$374.Metal1 vin.$595.Metal2 10.7656516291
Rred_1195 vin.$374.Metal1 vin.P13.GatPoly 233.378884183
Rred_1196 vin.$375.Metal1 vin.$379.Metal1 0.178398933563
Rred_1197 vin.$375.Metal1 vin.$591.Metal2 19.1286039107
Rred_1198 vin.$375.Metal1 vin.$596.Metal2 10.7656516291
Rred_1199 vin.$378.Metal1 vin.$386.Metal1 0.362797942164
Rred_1200 vin.$378.Metal1 vin.$595.Metal2 15.9997708552
Rred_1201 vin.$378.Metal1 vin.$599.Metal2 14.7413390447
Rred_1202 vin.$378.Metal1 vin.P13.GatPoly 92.2851475241
Rred_1203 vin.$379.Metal1 vin.$383.Metal1 0.17890681013
Rred_1204 vin.$379.Metal1 vin.$596.Metal2 19.0235339939
Rred_1205 vin.$379.Metal1 vin.$600.Metal2 28.8677674419
Rred_1206 vin.$383.Metal1 vin.$391.Metal1 0.362599659797
Rred_1207 vin.$383.Metal1 vin.$596.Metal2 49.65256
Rred_1208 vin.$383.Metal1 vin.$600.Metal2 10.1469188401
Rred_1209 vin.$383.Metal1 vin.$605.Metal2 83.0682856989
Rred_1210 vin.$386.Metal1 vin.$392.Metal1 0.358974281487
Rred_1211 vin.$386.Metal1 vin.$595.Metal2 100.688434264
Rred_1212 vin.$386.Metal1 vin.$599.Metal2 10.3514401745
Rred_1213 vin.$386.Metal1 vin.$604.Metal2 15.0113662187
Rred_1214 vin.$391.Metal1 vin.$397.Metal1 0.36179574156
Rred_1215 vin.$391.Metal1 vin.$600.Metal2 31.9493406534
Rred_1216 vin.$391.Metal1 vin.$605.Metal2 7.94564138892
Rred_1217 vin.$391.Metal1 vin.$609.Metal2 36.3742809915
Rred_1218 vin.$392.Metal1 vin.$396.Metal1 0.180721425263
Rred_1219 vin.$392.Metal1 vin.$400.Metal1 7610.30667437
Rred_1220 vin.$392.Metal1 vin.$604.Metal2 8.62947986197
Rred_1221 vin.$392.Metal1 vin.$610.Metal2 27.6894597146
Rred_1222 vin.$396.Metal1 vin.$400.Metal1 0.178550748274
Rred_1223 vin.$396.Metal1 vin.$604.Metal2 34.3389922323
Rred_1224 vin.$396.Metal1 vin.$610.Metal2 17.0071631934
Rred_1225 vin.$397.Metal1 vin.$401.Metal1 0.178449366077
Rred_1226 vin.$397.Metal1 vin.$605.Metal2 37.466526281
Rred_1227 vin.$397.Metal1 vin.$609.Metal2 8.59951511509
Rred_1228 vin.$397.Metal1 vin.P34.GatPoly 136.42270417
Rred_1229 vin.$400.Metal1 vin.$408.Metal1 0.362824398622
Rred_1230 vin.$400.Metal1 vin.$604.Metal2 145.280351752
Rred_1231 vin.$400.Metal1 vin.$610.Metal2 9.7817715397
Rred_1232 vin.$400.Metal1 vin.$615.Metal2 46.1776507338
Rred_1233 vin.$401.Metal1 vin.$409.Metal1 0.362824398622
Rred_1234 vin.$401.Metal1 vin.$609.Metal2 47.2209706961
Rred_1235 vin.$401.Metal1 vin.$611.Metal2 11.3207867366
Rred_1236 vin.$401.Metal1 vin.$616.Metal2 46.1776507338
Rred_1237 vin.$401.Metal1 vin.P34.GatPoly 344.997860768
Rred_1238 vin.$408.Metal1 vin.$412.Metal1 0.17852453123
Rred_1239 vin.$408.Metal1 vin.$610.Metal2 46.1776507338
Rred_1240 vin.$408.Metal1 vin.$615.Metal2 10.1192256903
Rred_1241 vin.$408.Metal1 vin.$619.Metal2 95.3406373629
Rred_1242 vin.$408.Metal1 vin.P15.GatPoly 72.1264392205
Rred_1243 vin.$409.Metal1 vin.$413.Metal1 0.178459879632
Rred_1244 vin.$409.Metal1 vin.$611.Metal2 46.1776507338
Rred_1245 vin.$409.Metal1 vin.$616.Metal2 10.1192256903
Rred_1246 vin.$409.Metal1 vin.$620.Metal2 95.3406373629
Rred_1247 vin.$409.Metal1 vin.P35.GatPoly 212.715280069
Rred_1248 vin.$412.Metal1 vin.$418.Metal1 0.36182906056
Rred_1249 vin.$412.Metal1 vin.$615.Metal2 22.5350597402
Rred_1250 vin.$412.Metal1 vin.$619.Metal2 10.1769943283
Rred_1251 vin.$412.Metal1 vin.P15.GatPoly 40.541385869
Rred_1252 vin.$413.Metal1 vin.$419.Metal1 0.36182906056
Rred_1253 vin.$413.Metal1 vin.$616.Metal2 22.5350597402
Rred_1254 vin.$413.Metal1 vin.$620.Metal2 10.1769943283
Rred_1255 vin.$413.Metal1 vin.P35.GatPoly 119.564647066
Rred_1256 vin.$418.Metal1 vin.$422.Metal1 0.178504947966
Rred_1257 vin.$418.Metal1 vin.$619.Metal2 18.0168451015
Rred_1258 vin.$418.Metal1 vin.$624.Metal2 11.5864555256
Rred_1259 vin.$419.Metal1 vin.$423.Metal1 0.178504947966
Rred_1260 vin.$419.Metal1 vin.$620.Metal2 18.0168451015
Rred_1261 vin.$419.Metal1 vin.$625.Metal2 11.5864555256
Rred_1262 vin.$42.GatPoly vin.$44.GatPoly 25.4131134156
Rred_1263 vin.$42.GatPoly vin.$512.Metal2 3870.9558658
Rred_1264 vin.$42.GatPoly vin.$517.Metal2 3870.9558658
Rred_1265 vin.$42.GatPoly vin.P4.GatPoly 38.1468722988
Rred_1266 vin.$422.Metal1 vin.$426.Metal1 0.17894182666
Rred_1267 vin.$422.Metal1 vin.$430.Metal1 4036.92165822
Rred_1268 vin.$422.Metal1 vin.$624.Metal2 15.140503946
Rred_1269 vin.$422.Metal1 vin.$630.Metal2 48.5088769371
Rred_1270 vin.$423.Metal1 vin.$427.Metal1 0.178949087371
Rred_1271 vin.$423.Metal1 vin.$625.Metal2 17.9090803107
Rred_1272 vin.$423.Metal1 vin.$629.Metal2 31.8360854701
Rred_1273 vin.$426.Metal1 vin.$430.Metal1 0.178852088262
Rred_1274 vin.$426.Metal1 vin.$624.Metal2 22.6413748687
Rred_1275 vin.$426.Metal1 vin.$630.Metal2 23.8007022261
Rred_1276 vin.$427.Metal1 vin.$433.Metal1 0.331848942782
Rred_1277 vin.$427.Metal1 vin.$625.Metal2 42.814045977
Rred_1278 vin.$427.Metal1 vin.$629.Metal2 10.4731205828
Rred_1279 vin.$43.GatPoly vin.$51.GatPoly 49.728552584
Rred_1280 vin.$43.GatPoly vin.$513.Metal2 3870.9558658
Rred_1281 vin.$43.GatPoly vin.$518.Metal2 3870.9558658
Rred_1282 vin.$43.GatPoly vin.P24.GatPoly 112.502748125
Rred_1283 vin.$43.GatPoly vin.P25.GatPoly 182.46553525
Rred_1284 vin.$430.Metal1 vin.$437.Metal1 0.36174266925
Rred_1285 vin.$430.Metal1 vin.$624.Metal2 43.9859302507
Rred_1286 vin.$430.Metal1 vin.$630.Metal2 9.12759240183
Rred_1287 vin.$433.Metal1 vin.$441.Metal1 0.39094415179
Rred_1288 vin.$433.Metal1 vin.$629.Metal2 12.4168010073
Rred_1289 vin.$433.Metal1 vin.$633.Metal2 38.1149573586
Rred_1290 vin.$433.Metal1 vin.$636.Metal2 11.1591689028
Rred_1291 vin.$437.Metal1 vin.$440.Metal1 0.178129923539
Rred_1292 vin.$437.Metal1 vin.$630.Metal2 21.8084097251
Rred_1293 vin.$437.Metal1 vin.$635.Metal2 9.42324175824
Rred_1294 vin.$437.Metal1 vin.P17.GatPoly 81.1351604514
Rred_1295 vin.$44.GatPoly vin.$52.GatPoly 17.2080405764
Rred_1296 vin.$44.GatPoly vin.P5.GatPoly 4.76
Rred_1297 vin.$440.Metal1 vin.$448.Metal1 0.362653569415
Rred_1298 vin.$440.Metal1 vin.$635.Metal2 18.9451496641
Rred_1299 vin.$440.Metal1 vin.$639.Metal2 12.8905653645
Rred_1300 vin.$440.Metal1 vin.P17.GatPoly 36.2581717142
Rred_1301 vin.$441.Metal1 vin.$449.Metal1 0.362653569415
Rred_1302 vin.$441.Metal1 vin.$636.Metal2 9.17818171348
Rred_1303 vin.$441.Metal1 vin.$640.Metal2 12.8905653645
Rred_1304 vin.$448.Metal1 vin.$456.Metal1 0.362310386809
Rred_1305 vin.$448.Metal1 vin.$635.Metal2 148.012303013
Rred_1306 vin.$448.Metal1 vin.$639.Metal2 11.5186194376
Rred_1307 vin.$448.Metal1 vin.$644.Metal2 12.9766510302
Rred_1308 vin.$448.Metal1 vin.$648.Metal2 279.314226443
Rred_1309 vin.$449.Metal1 vin.$453.Metal1 0.178675191093
Rred_1310 vin.$449.Metal1 vin.$636.Metal2 148.012303013
Rred_1311 vin.$449.Metal1 vin.$640.Metal2 11.5186194376
Rred_1312 vin.$449.Metal1 vin.$645.Metal2 26.726552795
Rred_1313 vin.$453.Metal1 vin.$457.Metal1 0.178496116933
Rred_1314 vin.$453.Metal1 vin.$645.Metal2 12.426647102
Rred_1315 vin.$453.Metal1 vin.$649.Metal2 137.607164021
Rred_1316 vin.$456.Metal1 vin.$644.Metal2 11.4454036843
Rred_1317 vin.$456.Metal1 vin.$648.Metal2 6.53320320366
Rred_1318 vin.$456.Metal1 vin.$653.Metal2 5.38299903212
Rred_1319 vin.$456.Metal1 vin.P18.GatPoly 37.76
Rred_1320 vin.$456.Metal1 vin.P19.GatPoly 21.9316993903
Rred_1321 vin.$457.Metal1 vin.$645.Metal2 20.9909233253
Rred_1322 vin.$457.Metal1 vin.$649.Metal2 6.62883717454
Rred_1323 vin.$457.Metal1 vin.$654.Metal2 5.24434565257
Rred_1324 vin.$457.Metal1 vin.P39.GatPoly 41.5022353547
Rred_1325 vin.$476.Metal2 vin.$478.Metal2 14.0345533852
Rred_1326 vin.$476.Metal2 vin.$481.Metal2 0.310383427653
Rred_1327 vin.$476.Metal2 vin.$6.GatPoly 133.769710264
Rred_1328 vin.$476.Metal2 vin.P0.GatPoly 181.216908754
Rred_1329 vin.$478.Metal2 vin.$482.Metal2 0.310599868985
Rred_1330 vin.$478.Metal2 vin.$7.GatPoly 388.085789519
Rred_1331 vin.$478.Metal2 vin.P20.GatPoly 654.991948339
Rred_1332 vin.$481.Metal2 vin.$483.Metal2 0.171806729636
Rred_1333 vin.$481.Metal2 vin.$6.GatPoly 1040.63139805
Rred_1334 vin.$481.Metal2 vin.P0.GatPoly 2350.52753623
Rred_1335 vin.$482.Metal2 vin.$486.Metal2 1.47138632148
Rred_1336 vin.$482.Metal2 vin.$489.Metal2 0.42560761365
Rred_1337 vin.$482.Metal2 vin.$7.GatPoly 25055.8390465
Rred_1338 vin.$482.Metal2 vin.$9.GatPoly 1714.75888267
Rred_1339 vin.$483.Metal2 vin.$486.Metal2 0.692446258504
Rred_1340 vin.$483.Metal2 vin.$488.Metal2 0.200294372294
Rred_1341 vin.$486.Metal2 vin.$488.Metal2 0.515651469098
Rred_1342 vin.$486.Metal2 vin.$489.Metal2 0.3964679684
Rred_1343 vin.$486.Metal2 vin.$495.Metal2 0.12144
Rred_1344 vin.$488.Metal2 vin.$492.Metal2 0.346876010592
Rred_1345 vin.$489.Metal2 vin.$493.Metal2 0.346876010592
Rred_1346 vin.$492.Metal2 vin.$495.Metal2 4.31912380951
Rred_1347 vin.$492.Metal2 vin.$497.Metal2 0.178476190476
Rred_1348 vin.$493.Metal2 vin.$495.Metal2 0.643273146381
Rred_1349 vin.$493.Metal2 vin.$500.Metal2 0.463026148652
Rred_1350 vin.$495.Metal2 vin.$497.Metal2 0.280462585034
Rred_1351 vin.$495.Metal2 vin.$500.Metal2 0.727612519313
Rred_1352 vin.$495.Metal2 vin.$506.Metal2 0.12144
Rred_1353 vin.$497.Metal2 vin.$503.Metal2 0.528548299458
Rred_1354 vin.$500.Metal2 vin.$504.Metal2 0.346883084067
Rred_1355 vin.$503.Metal2 vin.$506.Metal2 0.417099415205
Rred_1356 vin.$503.Metal2 vin.$508.Metal2 0.196484848485
Rred_1357 vin.$504.Metal2 vin.$506.Metal2 0.417099415205
Rred_1358 vin.$504.Metal2 vin.$509.Metal2 0.196484848485
Rred_1359 vin.$506.Metal2 vin.$508.Metal2 0.950986666669
Rred_1360 vin.$506.Metal2 vin.$509.Metal2 0.950986666669
Rred_1361 vin.$506.Metal2 vin.$515.Metal2 0.12144
Rred_1362 vin.$508.Metal2 vin.$512.Metal2 0.3468888772
Rred_1363 vin.$509.Metal2 vin.$513.Metal2 0.3468888772
Rred_1364 vin.$51.GatPoly vin.$520.Metal2 3155.60314934
Rred_1365 vin.$51.GatPoly vin.$524.Metal2 3155.60314934
Rred_1366 vin.$51.GatPoly vin.$55.GatPoly 20.0625185185
Rred_1367 vin.$51.GatPoly vin.P25.GatPoly 43.5585188802
Rred_1368 vin.$512.Metal2 vin.$515.Metal2 0.885199294533
Rred_1369 vin.$512.Metal2 vin.$517.Metal2 0.19751717122
Rred_1370 vin.$513.Metal2 vin.$515.Metal2 0.885199294533
Rred_1371 vin.$513.Metal2 vin.$518.Metal2 0.19751717122
Rred_1372 vin.$515.Metal2 vin.$517.Metal2 0.434552380953
Rred_1373 vin.$515.Metal2 vin.$518.Metal2 0.434552380953
Rred_1374 vin.$515.Metal2 vin.$526.Metal2 0.12144
Rred_1375 vin.$517.Metal2 vin.$523.Metal2 0.528590320902
Rred_1376 vin.$518.Metal2 vin.$520.Metal2 0.17180952381
Rred_1377 vin.$52.GatPoly vin.$523.Metal2 1989.57191416
Rred_1378 vin.$52.GatPoly vin.$58.GatPoly 20.0625185185
Rred_1379 vin.$520.Metal2 vin.$524.Metal2 0.346866938184
Rred_1380 vin.$523.Metal2 vin.$526.Metal2 0.269437010247
Rred_1381 vin.$523.Metal2 vin.$528.Metal2 0.175913419914
Rred_1382 vin.$524.Metal2 vin.$526.Metal2 0.269437010247
Rred_1383 vin.$524.Metal2 vin.$529.Metal2 0.175909192081
Rred_1384 vin.$524.Metal2 vin.$55.GatPoly 6962.69289808
Rred_1385 vin.$526.Metal2 vin.$528.Metal2 7.09517460319
Rred_1386 vin.$526.Metal2 vin.$529.Metal2 7.09517460319
Rred_1387 vin.$526.Metal2 vin.$535.Metal2 0.12144
Rred_1388 vin.$528.Metal2 vin.$532.Metal2 0.346869470833
Rred_1389 vin.$528.Metal2 vin.$58.GatPoly 2525.70222612
Rred_1390 vin.$529.Metal2 vin.$533.Metal2 0.346883862716
Rred_1391 vin.$529.Metal2 vin.$55.GatPoly 2681.79641039
Rred_1392 vin.$532.Metal2 vin.$535.Metal2 0.493407191448
Rred_1393 vin.$532.Metal2 vin.$537.Metal2 0.19980952381
Rred_1394 vin.$532.Metal2 vin.$58.GatPoly 8439.59448869
Rred_1395 vin.$533.Metal2 vin.$535.Metal2 0.493407191448
Rred_1396 vin.$533.Metal2 vin.$538.Metal2 0.19980952381
Rred_1397 vin.$535.Metal2 vin.$537.Metal2 0.732634920637
Rred_1398 vin.$535.Metal2 vin.$538.Metal2 0.732634920637
Rred_1399 vin.$535.Metal2 vin.$544.Metal2 0.12144
Rred_1400 vin.$537.Metal2 vin.$541.Metal2 0.346876010592
Rred_1401 vin.$537.Metal2 vin.$64.GatPoly 1611.09899248
Rred_1402 vin.$537.Metal2 vin.$70.GatPoly 12405.3841055
Rred_1403 vin.$538.Metal2 vin.$542.Metal2 0.346886758096
Rred_1404 vin.$538.Metal2 vin.$65.GatPoly 1611.09899248
Rred_1405 vin.$541.Metal2 vin.$544.Metal2 0.546093875877
Rred_1406 vin.$541.Metal2 vin.$548.Metal2 0.457460174986
Rred_1407 vin.$541.Metal2 vin.$70.GatPoly 2301.94136839
Rred_1408 vin.$542.Metal2 vin.$544.Metal2 1.22615538847
Rred_1409 vin.$542.Metal2 vin.$547.Metal2 0.192530627203
Rred_1410 vin.$542.Metal2 vin.$73.GatPoly 3372.27982918
Rred_1411 vin.$544.Metal2 vin.$547.Metal2 0.369792894936
Rred_1412 vin.$544.Metal2 vin.$548.Metal2 0.878613986878
Rred_1413 vin.$544.Metal2 vin.$555.Metal2 0.12144
Rred_1414 vin.$547.Metal2 vin.$551.Metal2 0.346891446111
Rred_1415 vin.$547.Metal2 vin.$73.GatPoly 4543.078818
Rred_1416 vin.$548.Metal2 vin.$552.Metal2 0.346898882339
Rred_1417 vin.$548.Metal2 vin.$78.GatPoly 1714.75888267
Rred_1418 vin.$548.Metal2 vin.$80.GatPoly 25055.8390465
Rred_1419 vin.$55.GatPoly vin.$57.GatPoly 11.5007407407
Rred_1420 vin.$551.Metal2 vin.$555.Metal2 0.786467062936
Rred_1421 vin.$551.Metal2 vin.$558.Metal2 0.461480673293
Rred_1422 vin.$551.Metal2 vin.$77.GatPoly 3154.05582356
Rred_1423 vin.$551.Metal2 vin.$83.GatPoly 5361.89490005
Rred_1424 vin.$552.Metal2 vin.$555.Metal2 0.315849765258
Rred_1425 vin.$552.Metal2 vin.$557.Metal2 0.185328000708
Rred_1426 vin.$552.Metal2 vin.$84.GatPoly 5498.19357361
Rred_1427 vin.$555.Metal2 vin.$557.Metal2 2.03866666667
Rred_1428 vin.$555.Metal2 vin.$558.Metal2 0.599073779942
Rred_1429 vin.$555.Metal2 vin.$564.Metal2 0.12144
Rred_1430 vin.$557.Metal2 vin.$561.Metal2 0.346865293749
Rred_1431 vin.$557.Metal2 vin.$84.GatPoly 2987.58348254
Rred_1432 vin.$557.Metal2 vin.$90.GatPoly 4494.85080275
Rred_1433 vin.$558.Metal2 vin.$562.Metal2 0.346885087058
Rred_1434 vin.$561.Metal2 vin.$564.Metal2 0.592952380953
Rred_1435 vin.$561.Metal2 vin.$566.Metal2 0.200917748918
Rred_1436 vin.$561.Metal2 vin.$90.GatPoly 3453.79724991
Rred_1437 vin.$562.Metal2 vin.$564.Metal2 0.592952380953
Rred_1438 vin.$562.Metal2 vin.$567.Metal2 0.200917748918
Rred_1439 vin.$564.Metal2 vin.$566.Metal2 0.592952380953
Rred_1440 vin.$564.Metal2 vin.$567.Metal2 0.592952380953
Rred_1441 vin.$564.Metal2 vin.$573.Metal2 0.12144
Rred_1442 vin.$566.Metal2 vin.$570.Metal2 0.346885087058
Rred_1443 vin.$566.Metal2 vin.$94.GatPoly 1716.610141
Rred_1444 vin.$567.Metal2 vin.$571.Metal2 0.346885087058
Rred_1445 vin.$567.Metal2 vin.$95.GatPoly 1716.610141
Rred_1446 vin.$57.GatPoly vin.$65.GatPoly 36.1143032099
Rred_1447 vin.$57.GatPoly vin.P26.GatPoly 22.26
Rred_1448 vin.$570.Metal2 vin.$573.Metal2 2.03866666667
Rred_1449 vin.$570.Metal2 vin.$575.Metal2 0.185328000708
Rred_1450 vin.$571.Metal2 vin.$573.Metal2 0.599073779942
Rred_1451 vin.$571.Metal2 vin.$578.Metal2 0.461480673293
Rred_1452 vin.$573.Metal2 vin.$575.Metal2 0.315849765258
Rred_1453 vin.$573.Metal2 vin.$578.Metal2 0.786467062936
Rred_1454 vin.$573.Metal2 vin.$584.Metal2 0.12144
Rred_1455 vin.$575.Metal2 vin.$579.Metal2 0.346898882339
Rred_1456 vin.$578.Metal2 vin.$582.Metal2 0.346891446111
Rred_1457 vin.$579.Metal2 vin.$584.Metal2 0.878613986878
Rred_1458 vin.$579.Metal2 vin.$586.Metal2 0.457460174986
Rred_1459 vin.$58.GatPoly vin.$64.GatPoly 60.50563664
Rred_1460 vin.$58.GatPoly vin.P6.GatPoly 7.97486881396
Rred_1461 vin.$582.Metal2 vin.$584.Metal2 0.369792894936
Rred_1462 vin.$582.Metal2 vin.$587.Metal2 0.192530627203
Rred_1463 vin.$584.Metal2 vin.$586.Metal2 0.546093875877
Rred_1464 vin.$584.Metal2 vin.$587.Metal2 1.22615538847
Rred_1465 vin.$584.Metal2 vin.$593.Metal2 0.12144
Rred_1466 vin.$586.Metal2 vin.$590.Metal2 0.346876010592
Rred_1467 vin.$587.Metal2 vin.$591.Metal2 0.346886758096
Rred_1468 vin.$590.Metal2 vin.$593.Metal2 0.732634920637
Rred_1469 vin.$590.Metal2 vin.$595.Metal2 0.19980952381
Rred_1470 vin.$591.Metal2 vin.$593.Metal2 0.732634920637
Rred_1471 vin.$591.Metal2 vin.$596.Metal2 0.19980952381
Rred_1472 vin.$593.Metal2 vin.$595.Metal2 0.493407191448
Rred_1473 vin.$593.Metal2 vin.$596.Metal2 0.493407191448
Rred_1474 vin.$593.Metal2 vin.$602.Metal2 0.12144
Rred_1475 vin.$595.Metal2 vin.$599.Metal2 0.346869470833
Rred_1476 vin.$596.Metal2 vin.$600.Metal2 0.346883862716
Rred_1477 vin.$599.Metal2 vin.$602.Metal2 7.09517460319
Rred_1478 vin.$599.Metal2 vin.$604.Metal2 0.175913419914
Rred_1479 vin.$6.GatPoly vin.P0.GatPoly 86.6998579537
Rred_1480 vin.$6.GatPoly vin.P1.GatPoly 19.9708444444
Rred_1481 vin.$600.Metal2 vin.$602.Metal2 7.09517460319
Rred_1482 vin.$600.Metal2 vin.$605.Metal2 0.175909192081
Rred_1483 vin.$602.Metal2 vin.$604.Metal2 0.269437010247
Rred_1484 vin.$602.Metal2 vin.$605.Metal2 0.269437010247
Rred_1485 vin.$602.Metal2 vin.$613.Metal2 0.12144
Rred_1486 vin.$604.Metal2 vin.$610.Metal2 0.528590320902
Rred_1487 vin.$605.Metal2 vin.$609.Metal2 0.346866938184
Rred_1488 vin.$609.Metal2 vin.$611.Metal2 0.17180952381
Rred_1489 vin.$610.Metal2 vin.$613.Metal2 0.434552380953
Rred_1490 vin.$610.Metal2 vin.$615.Metal2 0.19751717122
Rred_1491 vin.$611.Metal2 vin.$613.Metal2 0.434552380953
Rred_1492 vin.$611.Metal2 vin.$616.Metal2 0.19751717122
Rred_1493 vin.$613.Metal2 vin.$615.Metal2 0.885199294533
Rred_1494 vin.$613.Metal2 vin.$616.Metal2 0.885199294533
Rred_1495 vin.$613.Metal2 vin.$622.Metal2 0.12144
Rred_1496 vin.$615.Metal2 vin.$619.Metal2 0.3468888772
Rred_1497 vin.$616.Metal2 vin.$620.Metal2 0.3468888772
Rred_1498 vin.$619.Metal2 vin.$622.Metal2 0.950986666669
Rred_1499 vin.$619.Metal2 vin.$624.Metal2 0.196484848485
Rred_1500 vin.$620.Metal2 vin.$622.Metal2 0.950986666669
Rred_1501 vin.$620.Metal2 vin.$625.Metal2 0.196484848485
Rred_1502 vin.$622.Metal2 vin.$624.Metal2 0.417099415205
Rred_1503 vin.$622.Metal2 vin.$625.Metal2 0.417099415205
Rred_1504 vin.$622.Metal2 vin.$633.Metal2 0.12144
Rred_1505 vin.$624.Metal2 vin.$630.Metal2 0.528548299458
Rred_1506 vin.$625.Metal2 vin.$629.Metal2 0.346883084067
Rred_1507 vin.$629.Metal2 vin.$633.Metal2 0.727612519313
Rred_1508 vin.$629.Metal2 vin.$636.Metal2 0.463026148652
Rred_1509 vin.$630.Metal2 vin.$633.Metal2 0.280462585034
Rred_1510 vin.$630.Metal2 vin.$635.Metal2 0.178476190476
Rred_1511 vin.$633.Metal2 vin.$635.Metal2 4.31912380951
Rred_1512 vin.$633.Metal2 vin.$636.Metal2 0.643273146381
Rred_1513 vin.$633.Metal2 vin.$642.Metal2 0.12144
Rred_1514 vin.$635.Metal2 vin.$639.Metal2 0.346876010592
Rred_1515 vin.$636.Metal2 vin.$640.Metal2 0.346876010592
Rred_1516 vin.$639.Metal2 vin.$642.Metal2 0.515651469098
Rred_1517 vin.$639.Metal2 vin.$644.Metal2 0.200294372294
Rred_1518 vin.$64.GatPoly vin.$70.GatPoly 33.2347189542
Rred_1519 vin.$64.GatPoly vin.P6.GatPoly 123.431498746
Rred_1520 vin.$64.GatPoly vin.P7.GatPoly 30.8176484848
Rred_1521 vin.$640.Metal2 vin.$642.Metal2 0.515651469098
Rred_1522 vin.$640.Metal2 vin.$645.Metal2 0.200294372294
Rred_1523 vin.$642.Metal2 vin.$644.Metal2 0.692446258504
Rred_1524 vin.$642.Metal2 vin.$645.Metal2 0.692446258504
Rred_1525 vin.$642.Metal2 vin.$648.Metal2 2.98963708333
Rred_1526 vin.$642.Metal2 vin.$649.Metal2 3.5599249307
Rred_1527 vin.$642.Metal2 vin.$653.Metal2 0.781905083333
Rred_1528 vin.$642.Metal2 vin.$654.Metal2 0.931057289569
Rred_1529 vin.$644.Metal2 vin.$648.Metal2 0.346885244507
Rred_1530 vin.$645.Metal2 vin.$649.Metal2 0.346891446111
Rred_1531 vin.$648.Metal2 vin.$649.Metal2 53.5446887191
Rred_1532 vin.$648.Metal2 vin.$653.Metal2 0.182222484268
Rred_1533 vin.$648.Metal2 vin.$654.Metal2 14.0039955112
Rred_1534 vin.$648.Metal2 vin.P19.GatPoly 1031.5624039
Rred_1535 vin.$649.Metal2 vin.$653.Metal2 14.0039955112
Rred_1536 vin.$649.Metal2 vin.$654.Metal2 0.180819600935
Rred_1537 vin.$649.Metal2 vin.P39.GatPoly 1960.12022876
Rred_1538 vin.$65.GatPoly vin.$73.GatPoly 51.4620406015
Rred_1539 vin.$65.GatPoly vin.P27.GatPoly 72.5872454666
Rred_1540 vin.$653.Metal2 vin.$654.Metal2 3.66258344139
Rred_1541 vin.$653.Metal2 vin.P19.GatPoly 199.325141092
Rred_1542 vin.$654.Metal2 vin.P39.GatPoly 395.072001344
Rred_1543 vin.$7.GatPoly vin.$9.GatPoly 7.93159272489
Rred_1544 vin.$7.GatPoly vin.P20.GatPoly 200.155301199
Rred_1545 vin.$70.GatPoly vin.$78.GatPoly 42.8025468312
Rred_1546 vin.$70.GatPoly vin.P7.GatPoly 12.9518899643
Rred_1547 vin.$73.GatPoly vin.$77.GatPoly 29.4260595885
Rred_1548 vin.$73.GatPoly vin.P27.GatPoly 93.7877994151
Rred_1549 vin.$77.GatPoly vin.$83.GatPoly 15.0537042157
Rred_1550 vin.$77.GatPoly vin.P28.GatPoly 22.26
Rred_1551 vin.$78.GatPoly vin.$80.GatPoly 11.1325184116
Rred_1552 vin.$78.GatPoly vin.P8.GatPoly 11.3586666667
Rred_1553 vin.$80.GatPoly vin.$84.GatPoly 20.0625185185
Rred_1554 vin.$80.GatPoly vin.P8.GatPoly 16.2266666667
Rred_1555 vin.$83.GatPoly vin.$87.GatPoly 30.7637083127
Rred_1556 vin.$84.GatPoly vin.$90.GatPoly 32.0988583878
Rred_1557 vin.$84.GatPoly vin.P9.GatPoly 36.3787061728
Rred_1558 vin.$87.GatPoly vin.$95.GatPoly 32.101357037
Rred_1559 vin.$87.GatPoly vin.P29.GatPoly 22.26
Rred_1560 vin.$9.GatPoly vin.P21.GatPoly 22.26
Rred_1561 vin.$90.GatPoly vin.$94.GatPoly 20.0625185185
Rred_1562 vin.$90.GatPoly vin.P9.GatPoly 11.2006811616
Rred_1563 vin.$94.GatPoly vin.P10.GatPoly 29.2903280591
Rred_1564 vin.$95.GatPoly vin.$97.GatPoly 14.3546666667
Rred_1565 vin.$97.GatPoly vin.P30.GatPoly 22.26
Rred_1566 vout vout.$1424.Metal3 0.132586666667
Rred_1567 vout vout.P18.nSD 10.3439838345
Rred_1568 vout vout.P18.pSD 1.96368321577
Rred_1569 vout.$1226.Metal3 vout.$1292.Metal3 0.340332136788
Rred_1570 vout.$1226.Metal3 vout.P0.nSD 13.3422870835
Rred_1571 vout.$1226.Metal3 vout.P0.pSD 2.51085853912
Rred_1572 vout.$1226.Metal3 vout.P2.nSD 12.2645927271
Rred_1573 vout.$1226.Metal3 vout.P2.pSD 2.24411350379
Rred_1574 vout.$1226.Metal3 vout.P4.nSD 10.2779838345
Rred_1575 vout.$1226.Metal3 vout.P4.pSD 1.88061379842
Rred_1576 vout.$1226.Metal3 vout.P6.nSD 21.6028174423
Rred_1577 vout.$1226.Metal3 vout.P6.pSD 3.95277490422
Rred_1578 vout.$1292.Metal3 vout.$1358.Metal3 0.34020673713
Rred_1579 vout.$1292.Metal3 vout.P10.nSD 21.5948576124
Rred_1580 vout.$1292.Metal3 vout.P10.pSD 3.98718265158
Rred_1581 vout.$1292.Metal3 vout.P6.nSD 21.6028174423
Rred_1582 vout.$1292.Metal3 vout.P6.pSD 3.95277490422
Rred_1583 vout.$1292.Metal3 vout.P8.nSD 10.2779838345
Rred_1584 vout.$1292.Metal3 vout.P8.pSD 1.88061379842
Rred_1585 vout.$1358.Metal3 vout.$1424.Metal3 0.34020673713
Rred_1586 vout.$1358.Metal3 vout.P10.nSD 21.5948576124
Rred_1587 vout.$1358.Metal3 vout.P10.pSD 3.98718265158
Rred_1588 vout.$1358.Metal3 vout.P12.nSD 10.2779838345
Rred_1589 vout.$1358.Metal3 vout.P12.pSD 1.89768321577
Rred_1590 vout.$1358.Metal3 vout.P14.nSD 21.5948576124
Rred_1591 vout.$1358.Metal3 vout.P14.pSD 3.98718265158
Rred_1592 vout.$1424.Metal3 vout.P14.nSD 21.5948576124
Rred_1593 vout.$1424.Metal3 vout.P14.pSD 3.98718265158
Rred_1594 vout.$1424.Metal3 vout.P16.nSD 10.2779838345
Rred_1595 vout.$1424.Metal3 vout.P16.pSD 1.89768321577
Rred_1596 vout.P0.nSD vout.P0.pSD 84.3225466509
Rred_1597 vout.P0.nSD vout.P2.nSD 846.910887838
Rred_1598 vout.P0.nSD vout.P2.pSD 154.963495502
Rred_1599 vout.P0.pSD vout.P2.nSD 159.378479963
Rred_1600 vout.P0.pSD vout.P2.pSD 29.1622728172
Rred_1601 vout.P10.nSD vout.P10.pSD 253.089172665
Rred_1602 vout.P14.nSD vout.P14.pSD 253.089172665
Rred_1603 vout.P2.nSD vout.P2.pSD 142.446654611
Rred_1604 vout.P6.nSD vout.P6.pSD 250.905117137
Rred_1605 VSS VSS.$1196.Metal3 0.0855397484114
Rred_1606 VSS VSS.$1217.Metal3 0.0855397484114
Rred_1607 VSS VSS.$269.Metal1 1335.95113153
Rred_1608 VSS VSS.$294.Metal1 1335.95113153
Rred_1609 VSS VSS.$805.Metal2 5.34500865323
Rred_1610 VSS VSS.$818.Metal2 2.64858745346
Rred_1611 VSS VSS.$826.Metal2 2.64858745346
Rred_1612 VSS VSS.$840.Metal2 5.34500865323
Rred_1613 VSS.$1002.Metal2 VSS.$1010.Metal2 0.0241060829096
Rred_1614 VSS.$1002.Metal2 VSS.$1016.Metal2 1526.81857051
Rred_1615 VSS.$1002.Metal2 VSS.$1283.Metal3 2.42113023107
Rred_1616 VSS.$1002.Metal2 VSS.$1295.Metal3 12.2416920053
Rred_1617 VSS.$1002.Metal2 VSS.$448.Metal1 3.7770714324
Rred_1618 VSS.$1002.Metal2 VSS.$453.Metal1 2.26229116801
Rred_1619 VSS.$1002.Metal2 VSS.$987.Metal2 0.0484923752296
Rred_1620 VSS.$1002.Metal2 VSS.P0.pSD 9485.44026575
Rred_1621 VSS.$1002.Metal2 VSS.P19.nSD 139.403003311
Rred_1622 VSS.$1010.Metal2 VSS.$1016.Metal2 0.0240522173681
Rred_1623 VSS.$1010.Metal2 VSS.$1283.Metal3 6.09640618761
Rred_1624 VSS.$1010.Metal2 VSS.$1295.Metal3 6.09640618761
Rred_1625 VSS.$1010.Metal2 VSS.$453.Metal1 2.41909553325
Rred_1626 VSS.$1010.Metal2 VSS.$476.Metal1 13.6104867163
Rred_1627 VSS.$1010.Metal2 VSS.P0.pSD 3241.87394578
Rred_1628 VSS.$1010.Metal2 VSS.P19.nSD 187.198318732
Rred_1629 VSS.$1016.Metal2 VSS.$1028.Metal2 0.0484923752296
Rred_1630 VSS.$1016.Metal2 VSS.$1283.Metal3 12.2416920053
Rred_1631 VSS.$1016.Metal2 VSS.$1295.Metal3 2.42113023107
Rred_1632 VSS.$1016.Metal2 VSS.$453.Metal1 7.80034714992
Rred_1633 VSS.$1016.Metal2 VSS.$476.Metal1 2.71938063724
Rred_1634 VSS.$1016.Metal2 VSS.P0.pSD 2274.81996338
Rred_1635 VSS.$1028.Metal2 VSS.$1040.Metal2 0.0484923752296
Rred_1636 VSS.$1028.Metal2 VSS.$1295.Metal3 3.01802801866
Rred_1637 VSS.$1028.Metal2 VSS.$1301.Metal3 3.01802801866
Rred_1638 VSS.$1028.Metal2 VSS.$476.Metal1 3.01955296281
Rred_1639 VSS.$1028.Metal2 VSS.$488.Metal1 3.01968780352
Rred_1640 VSS.$1028.Metal2 VSS.P0.pSD 3388.78527683
Rred_1641 VSS.$1040.Metal2 VSS.$1055.Metal2 0.0510644296849
Rred_1642 VSS.$1040.Metal2 VSS.$1301.Metal3 2.00648138157
Rred_1643 VSS.$1040.Metal2 VSS.$1313.Metal3 5.9864931645
Rred_1644 VSS.$1040.Metal2 VSS.$488.Metal1 3.01904338824
Rred_1645 VSS.$1040.Metal2 VSS.$498.Metal1 2.94790913599
Rred_1646 VSS.$1040.Metal2 VSS.P0.pSD 3492.71336707
Rred_1647 VSS.$1055.Metal2 VSS.$1066.Metal2 0.103673773614
Rred_1648 VSS.$1055.Metal2 VSS.$1301.Metal3 6.28908610428
Rred_1649 VSS.$1055.Metal2 VSS.$1313.Metal3 1.60920358029
Rred_1650 VSS.$1055.Metal2 VSS.$498.Metal1 2.95436589276
Rred_1651 VSS.$1055.Metal2 VSS.$501.Metal1 6.94892289997
Rred_1652 VSS.$1055.Metal2 VSS.$520.Metal1 3.25611035278
Rred_1653 VSS.$1055.Metal2 VSS.P0.pSD 19850.6262899
Rred_1654 VSS.$1066.Metal2 VSS.$1313.Metal3 1.02156941164
Rred_1655 VSS.$1066.Metal2 VSS.$501.Metal1 1.39823028975
Rred_1656 VSS.$1066.Metal2 VSS.$509.Metal1 0.997337569251
Rred_1657 VSS.$1066.Metal2 VSS.$520.Metal1 4.9989516367
Rred_1658 VSS.$1066.Metal2 VSS.$551.Metal1 62.4616340464
Rred_1659 VSS.$1066.Metal2 VSS.P0.pSD 1005.08870278
Rred_1660 VSS.$1066.Metal2 VSS.P21.nSD 301.318005877
Rred_1661 VSS.$1066.Metal2 VSS.P23.nSD 301.318005877
Rred_1662 VSS.$1100.Metal3 VSS.$1112.Metal3 0.0981479196261
Rred_1663 VSS.$1100.Metal3 VSS.$18.Metal1 234.194043055
Rred_1664 VSS.$1100.Metal3 VSS.$44.Metal1 148.796404135
Rred_1665 VSS.$1100.Metal3 VSS.$564.Metal2 1.02158878798
Rred_1666 VSS.$1100.Metal3 VSS.$590.Metal2 1.6087288666
Rred_1667 VSS.$1100.Metal3 VSS.$605.Metal2 5.9864931645
Rred_1668 VSS.$1100.Metal3 VSS.$65.Metal1 1460.18884818
Rred_1669 VSS.$1112.Metal3 VSS.$1118.Metal3 0.0482995209481
Rred_1670 VSS.$1112.Metal3 VSS.$590.Metal2 6.28908610428
Rred_1671 VSS.$1112.Metal3 VSS.$605.Metal2 2.00648138157
Rred_1672 VSS.$1112.Metal3 VSS.$617.Metal2 3.01802801866
Rred_1673 VSS.$1112.Metal3 VSS.$65.Metal1 1460.18884818
Rred_1674 VSS.$1112.Metal3 VSS.$75.Metal1 754.337028826
Rred_1675 VSS.$1118.Metal3 VSS.$1130.Metal3 0.0981511661222
Rred_1676 VSS.$1118.Metal3 VSS.$617.Metal2 3.01802801866
Rred_1677 VSS.$1118.Metal3 VSS.$629.Metal2 2.42113023107
Rred_1678 VSS.$1118.Metal3 VSS.$636.Metal2 6.09640618761
Rred_1679 VSS.$1118.Metal3 VSS.$644.Metal2 12.2416920053
Rred_1680 VSS.$1118.Metal3 VSS.$85.Metal1 754.337028826
Rred_1681 VSS.$1130.Metal3 VSS.$1136.Metal3 0.0482995209481
Rred_1682 VSS.$1130.Metal3 VSS.$115.Metal1 754.337028826
Rred_1683 VSS.$1130.Metal3 VSS.$629.Metal2 12.2416920053
Rred_1684 VSS.$1130.Metal3 VSS.$636.Metal2 6.09640618761
Rred_1685 VSS.$1130.Metal3 VSS.$644.Metal2 2.42113023107
Rred_1686 VSS.$1130.Metal3 VSS.$658.Metal2 3.01802801866
Rred_1687 VSS.$1136.Metal3 VSS.$1148.Metal3 0.0981480735474
Rred_1688 VSS.$1136.Metal3 VSS.$127.Metal1 754.337028826
Rred_1689 VSS.$1136.Metal3 VSS.$137.Metal1 1532.86667717
Rred_1690 VSS.$1136.Metal3 VSS.$658.Metal2 3.01802801866
Rred_1691 VSS.$1136.Metal3 VSS.$670.Metal2 2.02265962076
Rred_1692 VSS.$1136.Metal3 VSS.$685.Metal2 6.13284832082
Rred_1693 VSS.$1148.Metal3 VSS.$1157.Metal3 0.0729314232753
Rred_1694 VSS.$1148.Metal3 VSS.$137.Metal1 1532.86667717
Rred_1695 VSS.$1148.Metal3 VSS.$162.Metal1 1139.03558589
Rred_1696 VSS.$1148.Metal3 VSS.$670.Metal2 6.13284832082
Rred_1697 VSS.$1148.Metal3 VSS.$685.Metal2 3.03898200552
Rred_1698 VSS.$1148.Metal3 VSS.$693.Metal2 2.2581929014
Rred_1699 VSS.$1148.Metal3 VSS.$705.Metal2 4.55716898563
Rred_1700 VSS.$115.Metal1 VSS.$127.Metal1 0.0503800743211
Rred_1701 VSS.$115.Metal1 VSS.$644.Metal2 3.7770714324
Rred_1702 VSS.$115.Metal1 VSS.$658.Metal2 3.01967577385
Rred_1703 VSS.$115.Metal1 VSS.$97.Metal1 0.0358581386467
Rred_1704 VSS.$115.Metal1 VSS.P0.pSD 8.1616300373
Rred_1705 VSS.$1157.Metal3 VSS.$1169.Metal3 0.0981480735474
Rred_1706 VSS.$1157.Metal3 VSS.$162.Metal1 2287.203706
Rred_1707 VSS.$1157.Metal3 VSS.$172.Metal1 754.337028826
Rred_1708 VSS.$1157.Metal3 VSS.$184.Metal1 1532.86667717
Rred_1709 VSS.$1157.Metal3 VSS.$693.Metal2 18.3382910472
Rred_1710 VSS.$1157.Metal3 VSS.$705.Metal2 2.26952241344
Rred_1711 VSS.$1157.Metal3 VSS.$717.Metal2 2.02265962076
Rred_1712 VSS.$1157.Metal3 VSS.$732.Metal2 6.13284832082
Rred_1713 VSS.$1169.Metal3 VSS.$1175.Metal3 0.0482995209481
Rred_1714 VSS.$1169.Metal3 VSS.$184.Metal1 1532.86667717
Rred_1715 VSS.$1169.Metal3 VSS.$717.Metal2 6.13284832082
Rred_1716 VSS.$1169.Metal3 VSS.$732.Metal2 3.03898200552
Rred_1717 VSS.$1169.Metal3 VSS.$740.Metal2 3
Rred_1718 VSS.$1169.Metal3 VSS.$746.Metal2 6.02405333333
Rred_1719 VSS.$1175.Metal3 VSS.$1184.Metal3 0.0729314232753
Rred_1720 VSS.$1175.Metal3 VSS.$212.Metal1 754.337028826
Rred_1721 VSS.$1175.Metal3 VSS.$224.Metal1 2287.203706
Rred_1722 VSS.$1175.Metal3 VSS.$746.Metal2 3.01802801866
Rred_1723 VSS.$1175.Metal3 VSS.$758.Metal2 2.26952241344
Rred_1724 VSS.$1175.Metal3 VSS.$770.Metal2 18.3382910472
Rred_1725 VSS.$1184.Metal3 VSS.$1196.Metal3 0.0981480735474
Rred_1726 VSS.$1184.Metal3 VSS.$224.Metal1 1139.03558589
Rred_1727 VSS.$1184.Metal3 VSS.$247.Metal1 1532.86667717
Rred_1728 VSS.$1184.Metal3 VSS.$758.Metal2 4.55716898563
Rred_1729 VSS.$1184.Metal3 VSS.$770.Metal2 2.2581929014
Rred_1730 VSS.$1184.Metal3 VSS.$779.Metal2 3.03898200552
Rred_1731 VSS.$1184.Metal3 VSS.$793.Metal2 6.13284832082
Rred_1732 VSS.$1196.Metal3 VSS.$247.Metal1 1532.86667717
Rred_1733 VSS.$1196.Metal3 VSS.$259.Metal1 754.337028826
Rred_1734 VSS.$1196.Metal3 VSS.$269.Metal1 1783.64213282
Rred_1735 VSS.$1196.Metal3 VSS.$779.Metal2 6.13284832082
Rred_1736 VSS.$1196.Metal3 VSS.$793.Metal2 2.02265962076
Rred_1737 VSS.$1196.Metal3 VSS.$805.Metal2 2.12101108372
Rred_1738 VSS.$1196.Metal3 VSS.$818.Metal2 8.56224982524
Rred_1739 VSS.$1217.Metal3 VSS.$1229.Metal3 0.0981480735474
Rred_1740 VSS.$1217.Metal3 VSS.$294.Metal1 1783.64213282
Rred_1741 VSS.$1217.Metal3 VSS.$304.Metal1 754.337028826
Rred_1742 VSS.$1217.Metal3 VSS.$314.Metal1 1532.86667717
Rred_1743 VSS.$1217.Metal3 VSS.$826.Metal2 8.56224982524
Rred_1744 VSS.$1217.Metal3 VSS.$840.Metal2 2.12101108372
Rred_1745 VSS.$1217.Metal3 VSS.$852.Metal2 2.02265962076
Rred_1746 VSS.$1217.Metal3 VSS.$867.Metal2 6.13284832082
Rred_1747 VSS.$1229.Metal3 VSS.$1238.Metal3 0.0729314232753
Rred_1748 VSS.$1229.Metal3 VSS.$314.Metal1 1532.86667717
Rred_1749 VSS.$1229.Metal3 VSS.$339.Metal1 1139.03558589
Rred_1750 VSS.$1229.Metal3 VSS.$852.Metal2 6.13284832082
Rred_1751 VSS.$1229.Metal3 VSS.$867.Metal2 3.03898200552
Rred_1752 VSS.$1229.Metal3 VSS.$875.Metal2 2.2581929014
Rred_1753 VSS.$1229.Metal3 VSS.$887.Metal2 4.55716898563
Rred_1754 VSS.$1238.Metal3 VSS.$1250.Metal3 0.0981511661222
Rred_1755 VSS.$1238.Metal3 VSS.$339.Metal1 2287.203706
Rred_1756 VSS.$1238.Metal3 VSS.$349.Metal1 754.337028826
Rred_1757 VSS.$1238.Metal3 VSS.$875.Metal2 18.3382910472
Rred_1758 VSS.$1238.Metal3 VSS.$887.Metal2 2.26952241344
Rred_1759 VSS.$1238.Metal3 VSS.$899.Metal2 2.42113023107
Rred_1760 VSS.$1238.Metal3 VSS.$905.Metal2 6.09640618761
Rred_1761 VSS.$1238.Metal3 VSS.$914.Metal2 12.2416920053
Rred_1762 VSS.$1250.Metal3 VSS.$1256.Metal3 0.0482995209481
Rred_1763 VSS.$1250.Metal3 VSS.$379.Metal1 754.337028826
Rred_1764 VSS.$1250.Metal3 VSS.$899.Metal2 12.2416920053
Rred_1765 VSS.$1250.Metal3 VSS.$905.Metal2 6.09640618761
Rred_1766 VSS.$1250.Metal3 VSS.$914.Metal2 2.42113023107
Rred_1767 VSS.$1250.Metal3 VSS.$928.Metal2 3.01802801866
Rred_1768 VSS.$1256.Metal3 VSS.$1265.Metal3 0.0729314232753
Rred_1769 VSS.$1256.Metal3 VSS.$391.Metal1 754.337028826
Rred_1770 VSS.$1256.Metal3 VSS.$401.Metal1 2287.203706
Rred_1771 VSS.$1256.Metal3 VSS.$928.Metal2 3.01802801866
Rred_1772 VSS.$1256.Metal3 VSS.$940.Metal2 2.26952241344
Rred_1773 VSS.$1256.Metal3 VSS.$952.Metal2 18.3382910472
Rred_1774 VSS.$1265.Metal3 VSS.$1277.Metal3 0.0981480735474
Rred_1775 VSS.$1265.Metal3 VSS.$401.Metal1 1139.03558589
Rred_1776 VSS.$1265.Metal3 VSS.$426.Metal1 1532.86667717
Rred_1777 VSS.$1265.Metal3 VSS.$940.Metal2 4.55716898563
Rred_1778 VSS.$1265.Metal3 VSS.$952.Metal2 2.2581929014
Rred_1779 VSS.$1265.Metal3 VSS.$961.Metal2 3.03898200552
Rred_1780 VSS.$1265.Metal3 VSS.$975.Metal2 6.13284832082
Rred_1781 VSS.$127.Metal1 VSS.$137.Metal1 0.0503816845649
Rred_1782 VSS.$127.Metal1 VSS.$658.Metal2 3.01972711398
Rred_1783 VSS.$127.Metal1 VSS.$670.Metal2 3.01957566786
Rred_1784 VSS.$127.Metal1 VSS.P0.pSD 7.11445842696
Rred_1785 VSS.$1277.Metal3 VSS.$1283.Metal3 0.0482995209481
Rred_1786 VSS.$1277.Metal3 VSS.$426.Metal1 1532.86667717
Rred_1787 VSS.$1277.Metal3 VSS.$436.Metal1 754.337028826
Rred_1788 VSS.$1277.Metal3 VSS.$961.Metal2 6.13284832082
Rred_1789 VSS.$1277.Metal3 VSS.$975.Metal2 2.02265962076
Rred_1790 VSS.$1277.Metal3 VSS.$987.Metal2 3.01802801866
Rred_1791 VSS.$1283.Metal3 VSS.$1295.Metal3 0.0981511661222
Rred_1792 VSS.$1283.Metal3 VSS.$448.Metal1 754.337028826
Rred_1793 VSS.$1283.Metal3 VSS.$987.Metal2 3.01802801866
Rred_1794 VSS.$1295.Metal3 VSS.$1301.Metal3 0.0482995209481
Rred_1795 VSS.$1295.Metal3 VSS.$476.Metal1 754.337028826
Rred_1796 VSS.$1301.Metal3 VSS.$1313.Metal3 0.0981479196261
Rred_1797 VSS.$1301.Metal3 VSS.$488.Metal1 754.337028826
Rred_1798 VSS.$1301.Metal3 VSS.$498.Metal1 1460.18884818
Rred_1799 VSS.$1313.Metal3 VSS.$498.Metal1 1460.18884818
Rred_1800 VSS.$1313.Metal3 VSS.$501.Metal1 115.178966137
Rred_1801 VSS.$1313.Metal3 VSS.$520.Metal1 403.904112613
Rred_1802 VSS.$137.Metal1 VSS.$142.Metal1 0.0327769863206
Rred_1803 VSS.$137.Metal1 VSS.$670.Metal2 3.01948975343
Rred_1804 VSS.$137.Metal1 VSS.$685.Metal2 4.11448185927
Rred_1805 VSS.$137.Metal1 VSS.P0.pSD 8.58558123775
Rred_1806 VSS.$142.Metal1 VSS.$162.Metal1 0.0426557962487
Rred_1807 VSS.$142.Metal1 VSS.$685.Metal2 1.9666454863
Rred_1808 VSS.$142.Metal1 VSS.$693.Metal2 3.2564856991
Rred_1809 VSS.$142.Metal1 VSS.P0.pSD 9.36743965424
Rred_1810 VSS.$142.Metal1 VSS.P5.nSD 6.30788530775
Rred_1811 VSS.$162.Metal1 VSS.$172.Metal1 0.0503816845649
Rred_1812 VSS.$162.Metal1 VSS.$693.Metal2 3.31716881667
Rred_1813 VSS.$162.Metal1 VSS.$705.Metal2 3.01952114749
Rred_1814 VSS.$162.Metal1 VSS.P0.pSD 7.67389633993
Rred_1815 VSS.$172.Metal1 VSS.$184.Metal1 0.0503800743211
Rred_1816 VSS.$172.Metal1 VSS.$705.Metal2 3.01957566786
Rred_1817 VSS.$172.Metal1 VSS.$717.Metal2 3.01972711398
Rred_1818 VSS.$172.Metal1 VSS.P0.pSD 7.11445842696
Rred_1819 VSS.$18.Metal1 VSS.$40.Metal1 0.0318980239163
Rred_1820 VSS.$18.Metal1 VSS.$44.Metal1 0.0987257804324
Rred_1821 VSS.$18.Metal1 VSS.$551.Metal1 19457.8182619
Rred_1822 VSS.$18.Metal1 VSS.$564.Metal2 2.14511415999
Rred_1823 VSS.$18.Metal1 VSS.$590.Metal2 14.1262601288
Rred_1824 VSS.$18.Metal1 VSS.P0.pSD 1.1847833052
Rred_1825 VSS.$184.Metal1 VSS.$195.Metal1 0.366960061347
Rred_1826 VSS.$184.Metal1 VSS.$202.Metal1 0.0542202622361
Rred_1827 VSS.$184.Metal1 VSS.$717.Metal2 3.0195805771
Rred_1828 VSS.$184.Metal1 VSS.$732.Metal2 3.12230753979
Rred_1829 VSS.$184.Metal1 VSS.P0.pSD 7.05039072587
Rred_1830 VSS.$195.Metal1 VSS.$202.Metal1 0.340966444808
Rred_1831 VSS.$195.Metal1 VSS.$732.Metal2 2.45231360784
Rred_1832 VSS.$195.Metal1 VSS.$740.Metal2 68.3961628278
Rred_1833 VSS.$195.Metal1 VSS.P0.pSD 206.599665433
Rred_1834 VSS.$195.Metal1 VSS.P7.nSD 5.76848282367
Rred_1835 VSS.$202.Metal1 VSS.$212.Metal1 0.0503784928037
Rred_1836 VSS.$202.Metal1 VSS.$732.Metal2 6.49007434824
Rred_1837 VSS.$202.Metal1 VSS.$740.Metal2 3
Rred_1838 VSS.$202.Metal1 VSS.$746.Metal2 6.03055400695
Rred_1839 VSS.$202.Metal1 VSS.P0.pSD 7.41602894719
Rred_1840 VSS.$212.Metal1 VSS.$224.Metal1 0.0503784994019
Rred_1841 VSS.$212.Metal1 VSS.$746.Metal2 3.01950107943
Rred_1842 VSS.$212.Metal1 VSS.$758.Metal2 3.01955296281
Rred_1843 VSS.$212.Metal1 VSS.P0.pSD 6.83399526978
Rred_1844 VSS.$224.Metal1 VSS.$232.Metal1 0.0445112576733
Rred_1845 VSS.$224.Metal1 VSS.$758.Metal2 3.01962400221
Rred_1846 VSS.$224.Metal1 VSS.$770.Metal2 3.23056548644
Rred_1847 VSS.$224.Metal1 VSS.P0.pSD 7.62000951606
Rred_1848 VSS.$232.Metal1 VSS.$247.Metal1 0.0309221197347
Rred_1849 VSS.$232.Metal1 VSS.$770.Metal2 3.67291977736
Rred_1850 VSS.$232.Metal1 VSS.$779.Metal2 1.81641905763
Rred_1851 VSS.$232.Metal1 VSS.P0.pSD 9.87658715042
Rred_1852 VSS.$232.Metal1 VSS.P10.nSD 6.30803357837
Rred_1853 VSS.$247.Metal1 VSS.$259.Metal1 0.0503777081793
Rred_1854 VSS.$247.Metal1 VSS.$779.Metal2 4.38723505065
Rred_1855 VSS.$247.Metal1 VSS.$793.Metal2 3.01941415001
Rred_1856 VSS.$247.Metal1 VSS.P0.pSD 8.20885719669
Rred_1857 VSS.$259.Metal1 VSS.$269.Metal1 0.0503811526048
Rred_1858 VSS.$259.Metal1 VSS.$793.Metal2 3.01967731838
Rred_1859 VSS.$259.Metal1 VSS.$805.Metal2 3.01961271281
Rred_1860 VSS.$259.Metal1 VSS.P0.pSD 7.26225858493
Rred_1861 VSS.$269.Metal1 VSS.$275.Metal1 0.0250609268302
Rred_1862 VSS.$269.Metal1 VSS.$805.Metal2 3.01946597019
Rred_1863 VSS.$269.Metal1 VSS.$818.Metal2 6.04783313429
Rred_1864 VSS.$269.Metal1 VSS.P0.pSD 9.6323051046
Rred_1865 VSS.$275.Metal1 VSS.$285.Metal1 0.025137675271
Rred_1866 VSS.$275.Metal1 VSS.$818.Metal2 2.35731732677
Rred_1867 VSS.$275.Metal1 VSS.$826.Metal2 11.0038005922
Rred_1868 VSS.$275.Metal1 VSS.P0.pSD 14.8304595603
Rred_1869 VSS.$275.Metal1 VSS.P11.nSD 12.6567850552
Rred_1870 VSS.$285.Metal1 VSS.$294.Metal1 0.0250609268302
Rred_1871 VSS.$285.Metal1 VSS.$818.Metal2 11.0038005922
Rred_1872 VSS.$285.Metal1 VSS.$826.Metal2 2.35731732677
Rred_1873 VSS.$285.Metal1 VSS.P0.pSD 14.8304595603
Rred_1874 VSS.$285.Metal1 VSS.P11.nSD 12.6567850552
Rred_1875 VSS.$294.Metal1 VSS.$304.Metal1 0.0503811526048
Rred_1876 VSS.$294.Metal1 VSS.$826.Metal2 6.04783313429
Rred_1877 VSS.$294.Metal1 VSS.$840.Metal2 3.01946597019
Rred_1878 VSS.$294.Metal1 VSS.P0.pSD 9.6323051046
Rred_1879 VSS.$304.Metal1 VSS.$314.Metal1 0.0503777081793
Rred_1880 VSS.$304.Metal1 VSS.$840.Metal2 3.01961271281
Rred_1881 VSS.$304.Metal1 VSS.$852.Metal2 3.01967731838
Rred_1882 VSS.$304.Metal1 VSS.P0.pSD 7.26225858493
Rred_1883 VSS.$314.Metal1 VSS.$319.Metal1 0.0309221197347
Rred_1884 VSS.$314.Metal1 VSS.$852.Metal2 3.01941415001
Rred_1885 VSS.$314.Metal1 VSS.$867.Metal2 4.38723505065
Rred_1886 VSS.$314.Metal1 VSS.P0.pSD 8.20885719669
Rred_1887 VSS.$319.Metal1 VSS.$339.Metal1 0.0445112576733
Rred_1888 VSS.$319.Metal1 VSS.$867.Metal2 1.81641905763
Rred_1889 VSS.$319.Metal1 VSS.$875.Metal2 3.67291977736
Rred_1890 VSS.$319.Metal1 VSS.P0.pSD 9.87658715042
Rred_1891 VSS.$319.Metal1 VSS.P13.nSD 6.30803357837
Rred_1892 VSS.$339.Metal1 VSS.$349.Metal1 0.0503784994019
Rred_1893 VSS.$339.Metal1 VSS.$875.Metal2 3.23056548644
Rred_1894 VSS.$339.Metal1 VSS.$887.Metal2 3.01962400221
Rred_1895 VSS.$339.Metal1 VSS.P0.pSD 7.62000951606
Rred_1896 VSS.$349.Metal1 VSS.$361.Metal1 0.0503784928037
Rred_1897 VSS.$349.Metal1 VSS.$887.Metal2 3.01955296281
Rred_1898 VSS.$349.Metal1 VSS.$899.Metal2 3.01950107943
Rred_1899 VSS.$349.Metal1 VSS.P0.pSD 6.83399526978
Rred_1900 VSS.$361.Metal1 VSS.$372.Metal1 0.340966444808
Rred_1901 VSS.$361.Metal1 VSS.$379.Metal1 0.0542202622361
Rred_1902 VSS.$361.Metal1 VSS.$899.Metal2 6.03055400695
Rred_1903 VSS.$361.Metal1 VSS.$905.Metal2 3
Rred_1904 VSS.$361.Metal1 VSS.$914.Metal2 6.49007434824
Rred_1905 VSS.$361.Metal1 VSS.P0.pSD 7.41602894719
Rred_1906 VSS.$372.Metal1 VSS.$379.Metal1 0.366960061347
Rred_1907 VSS.$372.Metal1 VSS.$905.Metal2 68.3961628278
Rred_1908 VSS.$372.Metal1 VSS.$914.Metal2 2.45231360784
Rred_1909 VSS.$372.Metal1 VSS.P0.pSD 206.599665433
Rred_1910 VSS.$372.Metal1 VSS.P15.nSD 5.76848282367
Rred_1911 VSS.$379.Metal1 VSS.$391.Metal1 0.0503800743211
Rred_1912 VSS.$379.Metal1 VSS.$914.Metal2 3.12240932406
Rred_1913 VSS.$379.Metal1 VSS.$928.Metal2 3.01967577385
Rred_1914 VSS.$379.Metal1 VSS.P0.pSD 7.05039072587
Rred_1915 VSS.$391.Metal1 VSS.$401.Metal1 0.0503816845649
Rred_1916 VSS.$391.Metal1 VSS.$928.Metal2 3.01972711398
Rred_1917 VSS.$391.Metal1 VSS.$940.Metal2 3.01957566786
Rred_1918 VSS.$391.Metal1 VSS.P0.pSD 7.11445842696
Rred_1919 VSS.$40.Metal1 VSS.$551.Metal1 50188.2285435
Rred_1920 VSS.$40.Metal1 VSS.$564.Metal2 1.07399788472
Rred_1921 VSS.$40.Metal1 VSS.P0.GatPoly 10.81
Rred_1922 VSS.$40.Metal1 VSS.P0.nSD 5.83762681657
Rred_1923 VSS.$40.Metal1 VSS.P0.pSD 5.96693251408
Rred_1924 VSS.$40.Metal1 VSS.P1.nSD 5.83762681657
Rred_1925 VSS.$401.Metal1 VSS.$409.Metal1 0.0426557962487
Rred_1926 VSS.$401.Metal1 VSS.$940.Metal2 3.01952114749
Rred_1927 VSS.$401.Metal1 VSS.$952.Metal2 3.31716881667
Rred_1928 VSS.$401.Metal1 VSS.P0.pSD 7.67389633993
Rred_1929 VSS.$409.Metal1 VSS.$426.Metal1 0.0327769863206
Rred_1930 VSS.$409.Metal1 VSS.$952.Metal2 3.2564856991
Rred_1931 VSS.$409.Metal1 VSS.$961.Metal2 1.9666454863
Rred_1932 VSS.$409.Metal1 VSS.P0.pSD 9.36743965424
Rred_1933 VSS.$409.Metal1 VSS.P17.nSD 6.30788530775
Rred_1934 VSS.$426.Metal1 VSS.$436.Metal1 0.0503816845649
Rred_1935 VSS.$426.Metal1 VSS.$961.Metal2 4.11448185927
Rred_1936 VSS.$426.Metal1 VSS.$975.Metal2 3.01948975343
Rred_1937 VSS.$426.Metal1 VSS.P0.pSD 8.58558123775
Rred_1938 VSS.$436.Metal1 VSS.$448.Metal1 0.0503800743211
Rred_1939 VSS.$436.Metal1 VSS.$975.Metal2 3.01957566786
Rred_1940 VSS.$436.Metal1 VSS.$987.Metal2 3.01972711398
Rred_1941 VSS.$436.Metal1 VSS.P0.pSD 7.11445842696
Rred_1942 VSS.$44.Metal1 VSS.$564.Metal2 1.90505228735
Rred_1943 VSS.$44.Metal1 VSS.$590.Metal2 2.64832844804
Rred_1944 VSS.$44.Metal1 VSS.$65.Metal1 0.0614259096926
Rred_1945 VSS.$44.Metal1 VSS.P0.pSD 221.142882408
Rred_1946 VSS.$448.Metal1 VSS.$453.Metal1 0.0358581386467
Rred_1947 VSS.$448.Metal1 VSS.$987.Metal2 3.01967577385
Rred_1948 VSS.$448.Metal1 VSS.P0.pSD 8.1616300373
Rred_1949 VSS.$453.Metal1 VSS.$476.Metal1 0.0651631230407
Rred_1950 VSS.$453.Metal1 VSS.P0.pSD 7.12742262762
Rred_1951 VSS.$453.Metal1 VSS.P19.nSD 6.30774233271
Rred_1952 VSS.$476.Metal1 VSS.$488.Metal1 0.0503784994019
Rred_1953 VSS.$476.Metal1 VSS.P0.pSD 6.07179088948
Rred_1954 VSS.$488.Metal1 VSS.$498.Metal1 0.0504002983711
Rred_1955 VSS.$488.Metal1 VSS.P0.pSD 7.22369241746
Rred_1956 VSS.$498.Metal1 VSS.$520.Metal1 0.0614259096926
Rred_1957 VSS.$498.Metal1 VSS.P0.pSD 9.15239107815
Rred_1958 VSS.$501.Metal1 VSS.$509.Metal1 0.0936634849612
Rred_1959 VSS.$501.Metal1 VSS.$520.Metal1 0.0484688145311
Rred_1960 VSS.$501.Metal1 VSS.$551.Metal1 0.41870548608
Rred_1961 VSS.$501.Metal1 VSS.P0.pSD 6.73751432021
Rred_1962 VSS.$509.Metal1 VSS.$551.Metal1 0.167228127478
Rred_1963 VSS.$509.Metal1 VSS.P0.pSD 4.71741315312
Rred_1964 VSS.$509.Metal1 VSS.P1.GatPoly 10.81
Rred_1965 VSS.$509.Metal1 VSS.P21.nSD 5.83762681657
Rred_1966 VSS.$509.Metal1 VSS.P23.nSD 5.83762681657
Rred_1967 VSS.$520.Metal1 VSS.P0.pSD 221.142882408
Rred_1968 VSS.$551.Metal1 VSS.P0.pSD 1.45104546928
Rred_1969 VSS.$564.Metal2 VSS.$590.Metal2 0.103774405557
Rred_1970 VSS.$564.Metal2 VSS.P0.nSD 301.318005877
Rred_1971 VSS.$564.Metal2 VSS.P1.nSD 301.318005877
Rred_1972 VSS.$590.Metal2 VSS.$605.Metal2 0.0510644296849
Rred_1973 VSS.$590.Metal2 VSS.$65.Metal1 2.95436589276
Rred_1974 VSS.$590.Metal2 VSS.P0.pSD 19850.6262899
Rred_1975 VSS.$605.Metal2 VSS.$617.Metal2 0.0484923752296
Rred_1976 VSS.$605.Metal2 VSS.$65.Metal1 2.94790913599
Rred_1977 VSS.$605.Metal2 VSS.$75.Metal1 3.01904338824
Rred_1978 VSS.$605.Metal2 VSS.P0.pSD 3492.71336707
Rred_1979 VSS.$617.Metal2 VSS.$629.Metal2 0.0484923752296
Rred_1980 VSS.$617.Metal2 VSS.$75.Metal1 3.01968780352
Rred_1981 VSS.$617.Metal2 VSS.$85.Metal1 3.01955296281
Rred_1982 VSS.$617.Metal2 VSS.P0.pSD 3388.78527683
Rred_1983 VSS.$629.Metal2 VSS.$636.Metal2 0.0240522173681
Rred_1984 VSS.$629.Metal2 VSS.$644.Metal2 1526.81857051
Rred_1985 VSS.$629.Metal2 VSS.$85.Metal1 2.71938063724
Rred_1986 VSS.$629.Metal2 VSS.$97.Metal1 7.80034714992
Rred_1987 VSS.$629.Metal2 VSS.P0.pSD 2274.81996338
Rred_1988 VSS.$636.Metal2 VSS.$644.Metal2 0.0241060829096
Rred_1989 VSS.$636.Metal2 VSS.$85.Metal1 13.6104867163
Rred_1990 VSS.$636.Metal2 VSS.$97.Metal1 2.41909553325
Rred_1991 VSS.$636.Metal2 VSS.P0.pSD 3241.87394578
Rred_1992 VSS.$636.Metal2 VSS.P3.nSD 187.198318732
Rred_1993 VSS.$644.Metal2 VSS.$658.Metal2 0.0484923752296
Rred_1994 VSS.$644.Metal2 VSS.$97.Metal1 2.26229116801
Rred_1995 VSS.$644.Metal2 VSS.P0.pSD 9485.44026575
Rred_1996 VSS.$644.Metal2 VSS.P3.nSD 139.403003311
Rred_1997 VSS.$65.Metal1 VSS.$75.Metal1 0.0504002983711
Rred_1998 VSS.$65.Metal1 VSS.P0.pSD 9.15239107815
Rred_1999 VSS.$658.Metal2 VSS.$670.Metal2 0.0484923752296
Rred_2000 VSS.$658.Metal2 VSS.P0.pSD 3195.13122738
Rred_2001 VSS.$670.Metal2 VSS.$685.Metal2 0.048486239739
Rred_2002 VSS.$670.Metal2 VSS.P0.pSD 3494.79852872
Rred_2003 VSS.$685.Metal2 VSS.$693.Metal2 0.0240996903131
Rred_2004 VSS.$685.Metal2 VSS.P0.pSD 8945.64126452
Rred_2005 VSS.$685.Metal2 VSS.P5.nSD 114.91221067
Rred_2006 VSS.$693.Metal2 VSS.$705.Metal2 0.0484903231735
Rred_2007 VSS.$693.Metal2 VSS.P0.pSD 4397.77171266
Rred_2008 VSS.$693.Metal2 VSS.P5.nSD 261.999840327
Rred_2009 VSS.$705.Metal2 VSS.$717.Metal2 0.0484923752296
Rred_2010 VSS.$705.Metal2 VSS.P0.pSD 3494.79852872
Rred_2011 VSS.$717.Metal2 VSS.$732.Metal2 0.048486239739
Rred_2012 VSS.$717.Metal2 VSS.P0.pSD 3195.13122738
Rred_2013 VSS.$732.Metal2 VSS.$740.Metal2 0.0240615302351
Rred_2014 VSS.$732.Metal2 VSS.P0.pSD 3748.68726061
Rred_2015 VSS.$732.Metal2 VSS.P7.nSD 474.710255865
Rred_2016 VSS.$740.Metal2 VSS.$746.Metal2 0.0240533333333
Rred_2017 VSS.$740.Metal2 VSS.P7.nSD 12500.7034044
Rred_2018 VSS.$746.Metal2 VSS.$758.Metal2 0.0484923752296
Rred_2019 VSS.$746.Metal2 VSS.P0.pSD 3494.73334028
Rred_2020 VSS.$75.Metal1 VSS.$85.Metal1 0.0503784994019
Rred_2021 VSS.$75.Metal1 VSS.P0.pSD 7.22369241746
Rred_2022 VSS.$758.Metal2 VSS.$770.Metal2 0.0484903231735
Rred_2023 VSS.$758.Metal2 VSS.P0.pSD 3388.78527683
Rred_2024 VSS.$770.Metal2 VSS.$779.Metal2 0.0240922731963
Rred_2025 VSS.$770.Metal2 VSS.P0.pSD 4421.73574461
Rred_2026 VSS.$770.Metal2 VSS.P10.nSD 344.630533059
Rred_2027 VSS.$779.Metal2 VSS.$793.Metal2 0.048486239739
Rred_2028 VSS.$779.Metal2 VSS.P0.pSD 13268.7698479
Rred_2029 VSS.$779.Metal2 VSS.P10.nSD 103.93619251
Rred_2030 VSS.$793.Metal2 VSS.$805.Metal2 0.0484923752296
Rred_2031 VSS.$793.Metal2 VSS.P0.pSD 3458.67092853
Rred_2032 VSS.$805.Metal2 VSS.$818.Metal2 0.0484879804286
Rred_2033 VSS.$805.Metal2 VSS.P0.pSD 3494.78766436
Rred_2034 VSS.$818.Metal2 VSS.$826.Metal2 0.0241078976447
Rred_2035 VSS.$818.Metal2 VSS.P11.nSD 155.330735642
Rred_2036 VSS.$826.Metal2 VSS.$840.Metal2 0.0484879804286
Rred_2037 VSS.$826.Metal2 VSS.P11.nSD 155.330735642
Rred_2038 VSS.$840.Metal2 VSS.$852.Metal2 0.0484923752296
Rred_2039 VSS.$840.Metal2 VSS.P0.pSD 3494.78766436
Rred_2040 VSS.$85.Metal1 VSS.$97.Metal1 0.0651631230407
Rred_2041 VSS.$85.Metal1 VSS.P0.pSD 6.07179088948
Rred_2042 VSS.$852.Metal2 VSS.$867.Metal2 0.048486239739
Rred_2043 VSS.$852.Metal2 VSS.P0.pSD 3458.67092853
Rred_2044 VSS.$867.Metal2 VSS.$875.Metal2 0.0240922731963
Rred_2045 VSS.$867.Metal2 VSS.P0.pSD 13268.7698479
Rred_2046 VSS.$867.Metal2 VSS.P13.nSD 103.93619251
Rred_2047 VSS.$875.Metal2 VSS.$887.Metal2 0.0484903231735
Rred_2048 VSS.$875.Metal2 VSS.P0.pSD 4421.73574461
Rred_2049 VSS.$875.Metal2 VSS.P13.nSD 344.630533059
Rred_2050 VSS.$887.Metal2 VSS.$899.Metal2 0.0484923752296
Rred_2051 VSS.$887.Metal2 VSS.P0.pSD 3388.78527683
Rred_2052 VSS.$899.Metal2 VSS.$905.Metal2 0.024052572452
Rred_2053 VSS.$899.Metal2 VSS.$914.Metal2 1526.81857051
Rred_2054 VSS.$899.Metal2 VSS.P0.pSD 3494.73334028
Rred_2055 VSS.$905.Metal2 VSS.$914.Metal2 0.0240607688351
Rred_2056 VSS.$905.Metal2 VSS.P15.nSD 12500.7034044
Rred_2057 VSS.$914.Metal2 VSS.$928.Metal2 0.0484923752296
Rred_2058 VSS.$914.Metal2 VSS.P0.pSD 3748.68726061
Rred_2059 VSS.$914.Metal2 VSS.P15.nSD 474.710255865
Rred_2060 VSS.$928.Metal2 VSS.$940.Metal2 0.0484923752296
Rred_2061 VSS.$928.Metal2 VSS.P0.pSD 3195.13122738
Rred_2062 VSS.$940.Metal2 VSS.$952.Metal2 0.0484903231735
Rred_2063 VSS.$940.Metal2 VSS.P0.pSD 3494.79852872
Rred_2064 VSS.$952.Metal2 VSS.$961.Metal2 0.0240996903131
Rred_2065 VSS.$952.Metal2 VSS.P0.pSD 4397.77171266
Rred_2066 VSS.$952.Metal2 VSS.P17.nSD 261.999840327
Rred_2067 VSS.$961.Metal2 VSS.$975.Metal2 0.048486239739
Rred_2068 VSS.$961.Metal2 VSS.P0.pSD 8945.64126452
Rred_2069 VSS.$961.Metal2 VSS.P17.nSD 114.91221067
Rred_2070 VSS.$97.Metal1 VSS.P0.pSD 7.12742262762
Rred_2071 VSS.$97.Metal1 VSS.P3.nSD 6.30774233271
Rred_2072 VSS.$975.Metal2 VSS.$987.Metal2 0.0484923752296
Rred_2073 VSS.$975.Metal2 VSS.P0.pSD 3494.79852872
Rred_2074 VSS.$987.Metal2 VSS.P0.pSD 3195.13122738
Rred_2075 VSS.P0.nSD VSS.P1.nSD 1081.46283191
Rred_2076 VSS.P21.nSD VSS.P23.nSD 1081.46283191
.ENDS inverter_pex

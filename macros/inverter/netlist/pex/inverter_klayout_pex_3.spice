*********************************************************
*** NGSPICE file created by KLayout-PEX 0.7.0
*** -----------------------------------------------------
***     Extraction Engine: KPEX/2.5D
***     Technology: ihp_sg13g2
***     Date: 2026-11-06 17:42:51
*********************************************************

.SUBCKT inverter_pex VDD vin vout VSS
X$1 VSS.P1.nSD VSS.P0.GatPoly VSS.P0.nSD VSS sg13_lv_nmos w=1e-06 l=1e-06
+ as=3.4e-13 ad=1.9e-13 ps=2.68e-06 pd=1.38e-06
X$2 vout.P0.nSD vin.P0.GatPoly VSS.P1.nSD VSS sg13_lv_nmos w=1e-06 l=1e-06
+ as=1.9e-13 ad=1.9e-13 ps=1.38e-06 pd=1.38e-06
X$3 VSS.P3.nSD vin.P1.GatPoly vout.P0.nSD VSS sg13_lv_nmos w=1e-06 l=1e-06
+ as=1.9e-13 ad=1.9e-13 ps=1.38e-06 pd=1.38e-06
X$4 vout.P2.nSD vin.P2.GatPoly VSS.P3.nSD VSS sg13_lv_nmos w=1e-06 l=1e-06
+ as=1.9e-13 ad=1.9e-13 ps=1.38e-06 pd=1.38e-06
X$5 VSS.P5.nSD vin.P3.GatPoly vout.P2.nSD VSS sg13_lv_nmos w=1e-06 l=1e-06
+ as=1.9e-13 ad=1.9e-13 ps=1.38e-06 pd=1.38e-06
X$6 vout.P4.nSD vin.P4.GatPoly VSS.P5.nSD VSS sg13_lv_nmos w=1e-06 l=1e-06
+ as=1.9e-13 ad=1.9e-13 ps=1.38e-06 pd=1.38e-06
X$7 VSS.P7.nSD vin.P5.GatPoly vout.P4.nSD VSS sg13_lv_nmos w=1e-06 l=1e-06
+ as=1.9e-13 ad=1.9e-13 ps=1.38e-06 pd=1.38e-06
X$8 vout.P6.nSD vin.P6.GatPoly VSS.P7.nSD VSS sg13_lv_nmos w=1e-06 l=1e-06
+ as=1.9e-13 ad=1.9e-13 ps=1.38e-06 pd=1.38e-06
X$9 VSS.P10.nSD vin.P7.GatPoly vout.P6.nSD VSS sg13_lv_nmos w=1e-06 l=1e-06
+ as=1.9e-13 ad=1.9e-13 ps=1.38e-06 pd=1.38e-06
X$10 vout.P8.nSD vin.P8.GatPoly VSS.P10.nSD VSS sg13_lv_nmos w=1e-06 l=1e-06
+ as=1.9e-13 ad=1.9e-13 ps=1.38e-06 pd=1.38e-06
X$11 VSS.P11.nSD vin.P9.GatPoly vout.P8.nSD VSS sg13_lv_nmos w=1e-06 l=1e-06
+ as=1.9e-13 ad=1.9e-13 ps=1.38e-06 pd=1.38e-06
X$12 vout.P10.nSD vin.P10.GatPoly VSS.P11.nSD VSS sg13_lv_nmos w=1e-06 l=1e-06
+ as=1.9e-13 ad=1.9e-13 ps=1.38e-06 pd=1.38e-06
X$13 VSS.P13.nSD vin.P11.GatPoly vout.P10.nSD VSS sg13_lv_nmos w=1e-06 l=1e-06
+ as=1.9e-13 ad=1.9e-13 ps=1.38e-06 pd=1.38e-06
X$14 vout.P12.nSD vin.P12.GatPoly VSS.P13.nSD VSS sg13_lv_nmos w=1e-06 l=1e-06
+ as=1.9e-13 ad=1.9e-13 ps=1.38e-06 pd=1.38e-06
X$15 VSS.P15.nSD vin.P13.GatPoly vout.P12.nSD VSS sg13_lv_nmos w=1e-06 l=1e-06
+ as=1.9e-13 ad=1.9e-13 ps=1.38e-06 pd=1.38e-06
X$16 vout.P14.nSD vin.P14.GatPoly VSS.P15.nSD VSS sg13_lv_nmos w=1e-06 l=1e-06
+ as=1.9e-13 ad=1.9e-13 ps=1.38e-06 pd=1.38e-06
X$17 VSS.P17.nSD vin.P15.GatPoly vout.P14.nSD VSS sg13_lv_nmos w=1e-06 l=1e-06
+ as=1.9e-13 ad=1.9e-13 ps=1.38e-06 pd=1.38e-06
X$18 vout.P16.nSD vin.P16.GatPoly VSS.P17.nSD VSS sg13_lv_nmos w=1e-06 l=1e-06
+ as=1.9e-13 ad=1.9e-13 ps=1.38e-06 pd=1.38e-06
X$19 VSS.P19.nSD vin.P17.GatPoly vout.P16.nSD VSS sg13_lv_nmos w=1e-06 l=1e-06
+ as=1.9e-13 ad=1.9e-13 ps=1.38e-06 pd=1.38e-06
X$20 vout.P18.nSD vin.P18.GatPoly VSS.P19.nSD VSS sg13_lv_nmos w=1e-06 l=1e-06
+ as=1.9e-13 ad=1.9e-13 ps=1.38e-06 pd=1.38e-06
X$21 VSS.P21.nSD vin.P19.GatPoly vout.P18.nSD VSS sg13_lv_nmos w=1e-06 l=1e-06
+ as=1.9e-13 ad=1.9e-13 ps=1.38e-06 pd=1.38e-06
X$22 VSS.P23.nSD VSS.P1.GatPoly VSS.P21.nSD VSS sg13_lv_nmos w=1e-06 l=1e-06
+ as=1.9e-13 ad=3.4e-13 ps=1.38e-06 pd=2.68e-06
X$23 VSS.P0.pSD VSS ptap1
X$24 VDD.P1.pSD VDD.P0.GatPoly VDD.P0.pSD \$I57 sg13_lv_pmos w=6e-06 l=1e-06
+ as=2.04e-12 ad=1.14e-12 ps=1.268e-05 pd=6.38e-06
X$25 vout.P0.pSD vin.P20.GatPoly VDD.P1.pSD \$I57 sg13_lv_pmos w=6e-06 l=1e-06
+ as=1.14e-12 ad=1.14e-12 ps=6.38e-06 pd=6.38e-06
X$26 VDD.P3.pSD vin.P21.GatPoly vout.P0.pSD \$I57 sg13_lv_pmos w=6e-06 l=1e-06
+ as=1.14e-12 ad=1.14e-12 ps=6.38e-06 pd=6.38e-06
X$27 vout.P2.pSD vin.P22.GatPoly VDD.P3.pSD \$I57 sg13_lv_pmos w=6e-06 l=1e-06
+ as=1.14e-12 ad=1.14e-12 ps=6.38e-06 pd=6.38e-06
X$28 VDD.P5.pSD vin.P23.GatPoly vout.P2.pSD \$I57 sg13_lv_pmos w=6e-06 l=1e-06
+ as=1.14e-12 ad=1.14e-12 ps=6.38e-06 pd=6.38e-06
X$29 vout.P4.pSD vin.P24.GatPoly VDD.P5.pSD \$I57 sg13_lv_pmos w=6e-06 l=1e-06
+ as=1.14e-12 ad=1.14e-12 ps=6.38e-06 pd=6.38e-06
X$30 VDD.P7.pSD vin.P25.GatPoly vout.P4.pSD \$I57 sg13_lv_pmos w=6e-06 l=1e-06
+ as=1.14e-12 ad=1.14e-12 ps=6.38e-06 pd=6.38e-06
X$31 vout.P6.pSD vin.P26.GatPoly VDD.P7.pSD \$I57 sg13_lv_pmos w=6e-06 l=1e-06
+ as=1.14e-12 ad=1.14e-12 ps=6.38e-06 pd=6.38e-06
X$32 VDD.P10.pSD vin.P27.GatPoly vout.P6.pSD \$I57 sg13_lv_pmos w=6e-06 l=1e-06
+ as=1.14e-12 ad=1.14e-12 ps=6.38e-06 pd=6.38e-06
X$33 vout.P8.pSD vin.P28.GatPoly VDD.P10.pSD \$I57 sg13_lv_pmos w=6e-06 l=1e-06
+ as=1.14e-12 ad=1.14e-12 ps=6.38e-06 pd=6.38e-06
X$34 VDD.P11.pSD vin.P29.GatPoly vout.P8.pSD \$I57 sg13_lv_pmos w=6e-06 l=1e-06
+ as=1.14e-12 ad=1.14e-12 ps=6.38e-06 pd=6.38e-06
X$35 vout.P10.pSD vin.P30.GatPoly VDD.P11.pSD \$I57 sg13_lv_pmos w=6e-06
+ l=1e-06 as=1.14e-12 ad=1.14e-12 ps=6.38e-06 pd=6.38e-06
X$36 VDD.P13.pSD vin.P31.GatPoly vout.P10.pSD \$I57 sg13_lv_pmos w=6e-06
+ l=1e-06 as=1.14e-12 ad=1.14e-12 ps=6.38e-06 pd=6.38e-06
X$37 vout.P12.pSD vin.P32.GatPoly VDD.P13.pSD \$I57 sg13_lv_pmos w=6e-06
+ l=1e-06 as=1.14e-12 ad=1.14e-12 ps=6.38e-06 pd=6.38e-06
X$38 VDD.P15.pSD vin.P33.GatPoly vout.P12.pSD \$I57 sg13_lv_pmos w=6e-06
+ l=1e-06 as=1.14e-12 ad=1.14e-12 ps=6.38e-06 pd=6.38e-06
X$39 vout.P14.pSD vin.P34.GatPoly VDD.P15.pSD \$I57 sg13_lv_pmos w=6e-06
+ l=1e-06 as=1.14e-12 ad=1.14e-12 ps=6.38e-06 pd=6.38e-06
X$40 VDD.P17.pSD vin.P35.GatPoly vout.P14.pSD \$I57 sg13_lv_pmos w=6e-06
+ l=1e-06 as=1.14e-12 ad=1.14e-12 ps=6.38e-06 pd=6.38e-06
X$41 vout.P16.pSD vin.P36.GatPoly VDD.P17.pSD \$I57 sg13_lv_pmos w=6e-06
+ l=1e-06 as=1.14e-12 ad=1.14e-12 ps=6.38e-06 pd=6.38e-06
X$42 VDD.P19.pSD vin.P37.GatPoly vout.P16.pSD \$I57 sg13_lv_pmos w=6e-06
+ l=1e-06 as=1.14e-12 ad=1.14e-12 ps=6.38e-06 pd=6.38e-06
X$43 vout.P18.pSD vin.P38.GatPoly VDD.P19.pSD \$I57 sg13_lv_pmos w=6e-06
+ l=1e-06 as=1.14e-12 ad=1.14e-12 ps=6.38e-06 pd=6.38e-06
X$44 VDD.P21.pSD vin.P39.GatPoly vout.P18.pSD \$I57 sg13_lv_pmos w=6e-06
+ l=1e-06 as=1.14e-12 ad=1.14e-12 ps=6.38e-06 pd=6.38e-06
X$45 VDD.P23.pSD VDD.P1.GatPoly VDD.P21.pSD \$I57 sg13_lv_pmos w=6e-06 l=1e-06
+ as=1.14e-12 ad=2.04e-12 ps=6.38e-06 pd=1.268e-05
X$46 VDD.P0.nSD \$I57 ntap1
* netlist reduce (TICER tau=0.1ps max degree 5, floating max degree 64): 4920 R, 10098 C, 2974 nodes -> 2081 R, 7111 C, 616 nodes
Cred_1 \$I57 VDD 0.00136223f
Cred_2 \$I57 VDD.$100.Metal1 0.144554f
Cred_3 \$I57 VDD.$1000.Metal1 0.00543125f
Cred_4 \$I57 VDD.$1001.Metal1 0.00546095f
Cred_5 \$I57 VDD.$1002.Metal1 0.0326821f
Cred_6 \$I57 VDD.$1003.Metal1 0.0402157f
Cred_7 \$I57 VDD.$1004.Metal1 0.0109252f
Cred_8 \$I57 VDD.$1005.Metal1 0.0110354f
Cred_9 \$I57 VDD.$1006.Metal1 0.0122558f
Cred_10 \$I57 VDD.$1007.Metal1 0.0211134f
Cred_11 \$I57 VDD.$1056.Metal2 0.0079787f
Cred_12 \$I57 VDD.$1065.Metal2 0.0236737f
Cred_13 \$I57 VDD.$1068.Metal2 0.00365263f
Cred_14 \$I57 VDD.$1070.Metal2 0.00292277f
Cred_15 \$I57 VDD.$1072.Metal2 0.00291724f
Cred_16 \$I57 VDD.$1074.Metal2 0.00219601f
Cred_17 \$I57 VDD.$1075.Metal2 0.010141f
Cred_18 \$I57 VDD.$1110.Metal2 0.000530555f
Cred_19 \$I57 VDD.$1137.Metal2 0.00384846f
Cred_20 \$I57 VDD.$1149.Metal2 0.00484711f
Cred_21 \$I57 VDD.$1161.Metal2 0.00331894f
Cred_22 \$I57 VDD.$1167.Metal2 0.00957734f
Cred_23 \$I57 VDD.$1188.Metal2 0.0138269f
Cred_24 \$I57 VDD.$1214.Metal2 0.00318273f
Cred_25 \$I57 VDD.$1220.Metal2 0.00284031f
Cred_26 \$I57 VDD.$1226.Metal2 0.00315587f
Cred_27 \$I57 VDD.$1253.Metal2 0.0158933f
Cred_28 \$I57 VDD.$1273.Metal2 0.00765147f
Cred_29 \$I57 VDD.$1285.Metal2 0.00471221f
Cred_30 \$I57 VDD.$1297.Metal2 0.00418626f
Cred_31 \$I57 VDD.$130.Metal1 0.0448175f
Cred_32 \$I57 VDD.$131.Metal1 0.00545924f
Cred_33 \$I57 VDD.$132.Metal1 0.00561276f
Cred_34 \$I57 VDD.$1324.Metal2 0.01998f
Cred_35 \$I57 VDD.$133.Metal1 0.00558038f
Cred_36 \$I57 VDD.$134.Metal1 0.00543125f
Cred_37 \$I57 VDD.$1344.Metal2 0.00206826f
Cred_38 \$I57 VDD.$135.Metal1 0.00546095f
Cred_39 \$I57 VDD.$1350.Metal2 0.00341547f
Cred_40 \$I57 VDD.$136.Metal1 0.0326821f
Cred_41 \$I57 VDD.$1362.Metal2 0.00471148f
Cred_42 \$I57 VDD.$137.Metal1 0.0402157f
Cred_43 \$I57 VDD.$1374.Metal2 0.00605834f
Cred_44 \$I57 VDD.$138.Metal1 0.0109279f
Cred_45 \$I57 VDD.$139.Metal1 0.0110338f
Cred_46 \$I57 VDD.$1395.Metal2 0.0173749f
Cred_47 \$I57 VDD.$140.Metal1 0.0122547f
Cred_48 \$I57 VDD.$141.Metal1 0.0211134f
Cred_49 \$I57 VDD.$142.Metal1 0.0215641f
Cred_50 \$I57 VDD.$1421.Metal2 0.00302329f
Cred_51 \$I57 VDD.$1427.Metal2 0.0027904f
Cred_52 \$I57 VDD.$1433.Metal2 0.00333942f
Cred_53 \$I57 VDD.$1460.Metal2 0.0119884f
Cred_54 \$I57 VDD.$1480.Metal2 0.0120016f
Cred_55 \$I57 VDD.$1492.Metal2 0.00463428f
Cred_56 \$I57 VDD.$1504.Metal2 0.00437972f
Cred_57 \$I57 VDD.$152.Metal1 0.0185188f
Cred_58 \$I57 VDD.$1531.Metal2 0.0173781f
Cred_59 \$I57 VDD.$1551.Metal2 0.00504208f
Cred_60 \$I57 VDD.$1557.Metal2 0.00337833f
Cred_61 \$I57 VDD.$1569.Metal2 0.00478115f
Cred_62 \$I57 VDD.$1581.Metal2 0.00316132f
Cred_63 \$I57 VDD.$1602.Metal2 0.0198613f
Cred_64 \$I57 VDD.$1628.Metal2 0.00418626f
Cred_65 \$I57 VDD.$164.Metal1 0.0239986f
Cred_66 \$I57 VDD.$1640.Metal2 0.00471221f
Cred_67 \$I57 VDD.$1652.Metal2 0.00765147f
Cred_68 \$I57 VDD.$1673.Metal2 0.0158933f
Cred_69 \$I57 VDD.$1699.Metal2 0.00448609f
Cred_70 \$I57 VDD.$1711.Metal2 0.00459265f
Cred_71 \$I57 VDD.$1738.Metal2 0.0138237f
Cred_72 \$I57 VDD.$1758.Metal2 0.0105962f
Cred_73 \$I57 VDD.$177.Metal1 0.0520527f
Cred_74 \$I57 VDD.$1770.Metal2 0.00464558f
Cred_75 \$I57 VDD.$1782.Metal2 0.00351689f
Cred_76 \$I57 VDD.$1788.Metal2 0.00282338f
Cred_77 \$I57 VDD.$1803.Metal2 0.0236737f
Cred_78 \$I57 VDD.$1806.Metal2 0.00365263f
Cred_79 \$I57 VDD.$1808.Metal2 0.00292277f
Cred_80 \$I57 VDD.$1810.Metal2 0.00218671f
Cred_81 \$I57 VDD.$1811.Metal2 0.00219545f
Cred_82 \$I57 VDD.$1813.Metal2 0.010872f
Cred_83 \$I57 VDD.$1815.Metal2 0.000543459f
Cred_84 \$I57 VDD.$1822.Metal2 0.0080373f
Cred_85 \$I57 VDD.$1884.Metal3 0.00227392f
Cred_86 \$I57 VDD.$1896.Metal3 0.00422068f
Cred_87 \$I57 VDD.$1902.Metal3 0.00369134f
Cred_88 \$I57 VDD.$1914.Metal3 0.00446266f
Cred_89 \$I57 VDD.$1926.Metal3 0.00406813f
Cred_90 \$I57 VDD.$1935.Metal3 0.0040816f
Cred_91 \$I57 VDD.$1947.Metal3 0.00465484f
Cred_92 \$I57 VDD.$1959.Metal3 0.00430498f
Cred_93 \$I57 VDD.$1965.Metal3 0.00243075f
Cred_94 \$I57 VDD.$1974.Metal3 0.00402488f
Cred_95 \$I57 VDD.$1986.Metal3 0.00406928f
Cred_96 \$I57 VDD.$2001.Metal3 0.00441627f
Cred_97 \$I57 VDD.$2007.Metal3 0.00274336f
Cred_98 \$I57 VDD.$2019.Metal3 0.00371478f
Cred_99 \$I57 VDD.$2025.Metal3 0.00320751f
Cred_100 \$I57 VDD.$2034.Metal3 0.00408348f
Cred_101 \$I57 VDD.$2046.Metal3 0.0040816f
Cred_102 \$I57 VDD.$2055.Metal3 0.00407353f
Cred_103 \$I57 VDD.$2067.Metal3 0.00407101f
Cred_104 \$I57 VDD.$2076.Metal3 0.0024074f
Cred_105 \$I57 VDD.$2082.Metal3 0.00418242f
Cred_106 \$I57 VDD.$2091.Metal3 0.0039398f
Cred_107 \$I57 VDD.$230.Metal1 0.0140261f
Cred_108 \$I57 VDD.$237.Metal1 0.0191762f
Cred_109 \$I57 VDD.$252.Metal1 0.0238145f
Cred_110 \$I57 VDD.$257.Metal1 0.0463092f
Cred_111 \$I57 VDD.$315.Metal1 0.019026f
Cred_112 \$I57 VDD.$325.Metal1 0.0193302f
Cred_113 \$I57 VDD.$337.Metal1 0.0309996f
Cred_114 \$I57 VDD.$376.Metal1 0.0162606f
Cred_115 \$I57 VDD.$393.Metal1 0.029924f
Cred_116 \$I57 VDD.$403.Metal1 0.0195546f
Cred_117 \$I57 VDD.$415.Metal1 0.0180488f
Cred_118 \$I57 VDD.$423.Metal1 0.0499543f
Cred_119 \$I57 VDD.$476.Metal1 0.0119024f
Cred_120 \$I57 VDD.$483.Metal1 0.0186808f
Cred_121 \$I57 VDD.$498.Metal1 0.0184541f
Cred_122 \$I57 VDD.$518.Metal1 0.0284807f
Cred_123 \$I57 VDD.$554.Metal1 0.0284807f
Cred_124 \$I57 VDD.$561.Metal1 0.0137484f
Cred_125 \$I57 VDD.$571.Metal1 0.0189058f
Cred_126 \$I57 VDD.$581.Metal1 0.0164903f
Cred_127 \$I57 VDD.$586.Metal1 0.0546843f
Cred_128 \$I57 VDD.$649.Metal1 0.0231493f
Cred_129 \$I57 VDD.$661.Metal1 0.0200256f
Cred_130 \$I57 VDD.$7.Metal1 0.0181858f
Cred_131 \$I57 VDD.$702.Metal1 0.0141469f
Cred_132 \$I57 VDD.$703.Metal1 0.035392f
Cred_133 \$I57 VDD.$722.Metal1 0.0173418f
Cred_134 \$I57 VDD.$734.Metal1 0.0193302f
Cred_135 \$I57 VDD.$744.Metal1 0.019026f
Cred_136 \$I57 VDD.$754.Metal1 0.0463092f
Cred_137 \$I57 VDD.$807.Metal1 0.019096f
Cred_138 \$I57 VDD.$817.Metal1 0.0191786f
Cred_139 \$I57 VDD.$829.Metal1 0.0188469f
Cred_140 \$I57 VDD.$834.Metal1 0.046273f
Cred_141 \$I57 VDD.$890.Metal1 0.0199494f
Cred_142 \$I57 VDD.$902.Metal1 0.0238919f
Cred_143 \$I57 VDD.$917.Metal1 0.0260103f
Cred_144 \$I57 VDD.$920.Metal1 0.0181863f
Cred_145 \$I57 VDD.$940.Metal1 0.0448175f
Cred_146 \$I57 VDD.$941.Metal1 0.00545924f
Cred_147 \$I57 VDD.$942.Metal1 0.00561276f
Cred_148 \$I57 VDD.$943.Metal1 0.00558038f
Cred_149 \$I57 VDD.$95.Metal1 0.00605549f
Cred_150 \$I57 VDD.$954.Metal1 0.127354f
Cred_151 \$I57 VDD.$965.Metal1 0.00605563f
Cred_152 \$I57 VDD.P0.GatPoly 0.0719375f
Cred_153 \$I57 VDD.P0.nSD 0.494486f
Cred_154 \$I57 VDD.P0.pSD 0.000455958f
Cred_155 \$I57 VDD.P1.GatPoly 0.0682482f
Cred_156 \$I57 VDD.P1.pSD 0.000455958f
Cred_157 \$I57 VDD.P10.pSD 0.00176936f
Cred_158 \$I57 VDD.P11.pSD 0.00187954f
Cred_159 \$I57 VDD.P13.pSD 0.00176936f
Cred_160 \$I57 VDD.P15.pSD 0.000679385f
Cred_161 \$I57 VDD.P17.pSD 0.00177432f
Cred_162 \$I57 VDD.P19.pSD 0.00180207f
Cred_163 \$I57 VDD.P21.pSD 0.000455958f
Cred_164 \$I57 VDD.P23.pSD 0.000455958f
Cred_165 \$I57 VDD.P3.pSD 0.00180207f
Cred_166 \$I57 VDD.P5.pSD 0.00177432f
Cred_167 \$I57 VDD.P7.pSD 0.000679385f
Cred_168 \$I57 vin 0.0155951f
Cred_169 \$I57 vin.$10.GatPoly 0.00187831f
Cred_170 \$I57 vin.$102.GatPoly 0.00209816f
Cred_171 \$I57 vin.$105.GatPoly 0.0395235f
Cred_172 \$I57 vin.$107.GatPoly 0.034766f
Cred_173 \$I57 vin.$108.GatPoly 0.00162127f
Cred_174 \$I57 vin.$110.GatPoly 0.00190757f
Cred_175 \$I57 vin.$115.GatPoly 0.0461296f
Cred_176 \$I57 vin.$118.GatPoly 0.00219009f
Cred_177 \$I57 vin.$122.GatPoly 0.00222086f
Cred_178 \$I57 vin.$123.GatPoly 0.0475351f
Cred_179 \$I57 vin.$127.GatPoly 0.0417679f
Cred_180 \$I57 vin.$130.GatPoly 0.00215885f
Cred_181 \$I57 vin.$134.GatPoly 0.00196193f
Cred_182 \$I57 vin.$135.GatPoly 0.0394474f
Cred_183 \$I57 vin.$136.GatPoly 0.00182557f
Cred_184 \$I57 vin.$137.GatPoly 0.036143f
Cred_185 \$I57 vin.$144.GatPoly 0.00227689f
Cred_186 \$I57 vin.$145.GatPoly 0.044997f
Cred_187 \$I57 vin.$15.GatPoly 0.0354764f
Cred_188 \$I57 vin.$152.GatPoly 0.00232243f
Cred_189 \$I57 vin.$153.GatPoly 0.0481543f
Cred_190 \$I57 vin.$156.GatPoly 0.00224944f
Cred_191 \$I57 vin.$157.GatPoly 0.0349032f
Cred_192 \$I57 vin.$16.GatPoly 0.00203206f
Cred_193 \$I57 vin.$163.GatPoly 0.0375976f
Cred_194 \$I57 vin.$164.GatPoly 0.00222366f
Cred_195 \$I57 vin.$167.GatPoly 0.0354764f
Cred_196 \$I57 vin.$17.GatPoly 0.0363484f
Cred_197 \$I57 vin.$172.GatPoly 0.00203206f
Cred_198 \$I57 vin.$173.GatPoly 0.0363484f
Cred_199 \$I57 vin.$176.GatPoly 0.00187831f
Cred_200 \$I57 vin.$179.GatPoly 0.0589988f
Cred_201 \$I57 vin.$180.GatPoly 0.00249429f
Cred_202 \$I57 vin.$199.Metal1 0.104506f
Cred_203 \$I57 vin.$202.Metal1 0.00191211f
Cred_204 \$I57 vin.$207.Metal1 0.00937666f
Cred_205 \$I57 vin.$210.Metal1 0.000223024f
Cred_206 \$I57 vin.$211.Metal1 0.00972543f
Cred_207 \$I57 vin.$218.Metal1 0.000240046f
Cred_208 \$I57 vin.$219.Metal1 0.00588183f
Cred_209 \$I57 vin.$22.GatPoly 0.00222366f
Cred_210 \$I57 vin.$222.Metal1 0.000333732f
Cred_211 \$I57 vin.$227.Metal1 0.0130305f
Cred_212 \$I57 vin.$228.Metal1 0.00027357f
Cred_213 \$I57 vin.$232.Metal1 8.96946e-05f
Cred_214 \$I57 vin.$233.Metal1 0.00217557f
Cred_215 \$I57 vin.$236.Metal1 0.000377029f
Cred_216 \$I57 vin.$237.Metal1 0.00663819f
Cred_217 \$I57 vin.$24.GatPoly 0.00224944f
Cred_218 \$I57 vin.$240.Metal1 0.000377767f
Cred_219 \$I57 vin.$241.Metal1 0.0101154f
Cred_220 \$I57 vin.$246.Metal1 0.000257941f
Cred_221 \$I57 vin.$247.Metal1 0.00784507f
Cred_222 \$I57 vin.$25.GatPoly 0.0349032f
Cred_223 \$I57 vin.$250.Metal1 0.000324278f
Cred_224 \$I57 vin.$251.Metal1 0.00761718f
Cred_225 \$I57 vin.$258.Metal1 0.00029449f
Cred_226 \$I57 vin.$259.Metal1 0.00753178f
Cred_227 \$I57 vin.$262.Metal1 0.000162477f
Cred_228 \$I57 vin.$263.Metal1 0.0032873f
Cred_229 \$I57 vin.$264.Metal1 0.000217448f
Cred_230 \$I57 vin.$265.Metal1 0.00454978f
Cred_231 \$I57 vin.$27.GatPoly 0.0375976f
Cred_232 \$I57 vin.$272.Metal1 0.000231506f
Cred_233 \$I57 vin.$273.Metal1 0.00856607f
Cred_234 \$I57 vin.$277.Metal1 0.00373913f
Cred_235 \$I57 vin.$280.Metal1 0.000382703f
Cred_236 \$I57 vin.$281.Metal1 0.00548296f
Cred_237 \$I57 vin.$284.Metal1 0.000382839f
Cred_238 \$I57 vin.$285.Metal1 0.00900476f
Cred_239 \$I57 vin.$290.Metal1 0.000206296f
Cred_240 \$I57 vin.$291.Metal1 0.00689173f
Cred_241 \$I57 vin.$295.Metal1 0.00843597f
Cred_242 \$I57 vin.$298.Metal1 0.000382927f
Cred_243 \$I57 vin.$302.Metal1 0.000382927f
Cred_244 \$I57 vin.$303.Metal1 0.00914292f
Cred_245 \$I57 vin.$307.Metal1 0.00492576f
Cred_246 \$I57 vin.$312.Metal1 0.000231506f
Cred_247 \$I57 vin.$313.Metal1 0.00358784f
Cred_248 \$I57 vin.$317.Metal1 0.00806706f
Cred_249 \$I57 vin.$320.Metal1 0.000218949f
Cred_250 \$I57 vin.$321.Metal1 0.00399077f
Cred_251 \$I57 vin.$325.Metal1 0.00427514f
Cred_252 \$I57 vin.$328.Metal1 0.000231506f
Cred_253 \$I57 vin.$331.Metal1 0.00870275f
Cred_254 \$I57 vin.$334.Metal1 0.000298532f
Cred_255 \$I57 vin.$335.Metal1 0.00541898f
Cred_256 \$I57 vin.$338.Metal1 0.000292732f
Cred_257 \$I57 vin.$339.Metal1 0.00399077f
Cred_258 \$I57 vin.$343.Metal1 0.00806706f
Cred_259 \$I57 vin.$346.Metal1 0.000231506f
Cred_260 \$I57 vin.$347.Metal1 0.00358784f
Cred_261 \$I57 vin.$353.Metal1 0.00492576f
Cred_262 \$I57 vin.$356.Metal1 0.000382927f
Cred_263 \$I57 vin.$357.Metal1 0.00914292f
Cred_264 \$I57 vin.$36.GatPoly 0.00232243f
Cred_265 \$I57 vin.$360.Metal1 0.000382927f
Cred_266 \$I57 vin.$365.Metal1 0.00843597f
Cred_267 \$I57 vin.$368.Metal1 0.000206296f
Cred_268 \$I57 vin.$369.Metal1 0.00689173f
Cred_269 \$I57 vin.$37.GatPoly 0.0481543f
Cred_270 \$I57 vin.$374.Metal1 0.000382839f
Cred_271 \$I57 vin.$375.Metal1 0.00900476f
Cred_272 \$I57 vin.$378.Metal1 0.000382703f
Cred_273 \$I57 vin.$379.Metal1 0.00548296f
Cred_274 \$I57 vin.$383.Metal1 0.00373913f
Cred_275 \$I57 vin.$386.Metal1 0.000231506f
Cred_276 \$I57 vin.$387.Metal1 0.00856607f
Cred_277 \$I57 vin.$392.Metal1 0.000217448f
Cred_278 \$I57 vin.$393.Metal1 0.00454978f
Cred_279 \$I57 vin.$396.Metal1 0.000162477f
Cred_280 \$I57 vin.$397.Metal1 0.0032873f
Cred_281 \$I57 vin.$400.Metal1 0.00029449f
Cred_282 \$I57 vin.$401.Metal1 0.00753178f
Cred_283 \$I57 vin.$408.Metal1 0.000324278f
Cred_284 \$I57 vin.$409.Metal1 0.00761718f
Cred_285 \$I57 vin.$412.Metal1 0.000257941f
Cred_286 \$I57 vin.$413.Metal1 0.00784507f
Cred_287 \$I57 vin.$418.Metal1 0.000377767f
Cred_288 \$I57 vin.$419.Metal1 0.0101154f
Cred_289 \$I57 vin.$42.GatPoly 0.00227689f
Cred_290 \$I57 vin.$422.Metal1 0.000377029f
Cred_291 \$I57 vin.$423.Metal1 0.00663819f
Cred_292 \$I57 vin.$426.Metal1 8.96946e-05f
Cred_293 \$I57 vin.$427.Metal1 0.00217557f
Cred_294 \$I57 vin.$43.GatPoly 0.044997f
Cred_295 \$I57 vin.$430.Metal1 0.00027357f
Cred_296 \$I57 vin.$433.Metal1 0.0130305f
Cred_297 \$I57 vin.$437.Metal1 0.000333732f
Cred_298 \$I57 vin.$44.GatPoly 0.00182557f
Cred_299 \$I57 vin.$440.Metal1 0.000240046f
Cred_300 \$I57 vin.$441.Metal1 0.00588183f
Cred_301 \$I57 vin.$448.Metal1 0.000223024f
Cred_302 \$I57 vin.$449.Metal1 0.00971519f
Cred_303 \$I57 vin.$453.Metal1 0.00935973f
Cred_304 \$I57 vin.$456.Metal1 0.00189652f
Cred_305 \$I57 vin.$457.Metal1 0.0797995f
Cred_306 \$I57 vin.$47.GatPoly 0.036143f
Cred_307 \$I57 vin.$476.Metal2 0.00266539f
Cred_308 \$I57 vin.$478.Metal2 0.02701f
Cred_309 \$I57 vin.$481.Metal2 1.64343e-05f
Cred_310 \$I57 vin.$482.Metal2 0.00427817f
Cred_311 \$I57 vin.$486.Metal2 0.0116119f
Cred_312 \$I57 vin.$489.Metal2 0.0066644f
Cred_313 \$I57 vin.$493.Metal2 0.00520449f
Cred_314 \$I57 vin.$495.Metal2 0.0121395f
Cred_315 \$I57 vin.$500.Metal2 0.00504892f
Cred_316 \$I57 vin.$504.Metal2 0.00589792f
Cred_317 \$I57 vin.$506.Metal2 0.0113466f
Cred_318 \$I57 vin.$509.Metal2 0.00405261f
Cred_319 \$I57 vin.$513.Metal2 0.00412776f
Cred_320 \$I57 vin.$515.Metal2 0.0148484f
Cred_321 \$I57 vin.$518.Metal2 0.00467127f
Cred_322 \$I57 vin.$52.GatPoly 0.00196193f
Cred_323 \$I57 vin.$520.Metal2 0.00301828f
Cred_324 \$I57 vin.$523.Metal2 0.00162091f
Cred_325 \$I57 vin.$527.Metal2 0.010855f
Cred_326 \$I57 vin.$528.Metal2 6.15536e-05f
Cred_327 \$I57 vin.$53.GatPoly 0.0394474f
Cred_328 \$I57 vin.$533.Metal2 0.00619595f
Cred_329 \$I57 vin.$535.Metal2 0.0148954f
Cred_330 \$I57 vin.$538.Metal2 0.00447878f
Cred_331 \$I57 vin.$542.Metal2 0.00369713f
Cred_332 \$I57 vin.$544.Metal2 0.0112653f
Cred_333 \$I57 vin.$547.Metal2 0.00631762f
Cred_334 \$I57 vin.$551.Metal2 0.00490436f
Cred_335 \$I57 vin.$555.Metal2 0.0120706f
Cred_336 \$I57 vin.$558.Metal2 0.00510643f
Cred_337 \$I57 vin.$562.Metal2 0.00496692f
Cred_338 \$I57 vin.$564.Metal2 0.0114378f
Cred_339 \$I57 vin.$567.Metal2 0.00495373f
Cred_340 \$I57 vin.$57.GatPoly 0.0417679f
Cred_341 \$I57 vin.$571.Metal2 0.00510643f
Cred_342 \$I57 vin.$573.Metal2 0.0120706f
Cred_343 \$I57 vin.$578.Metal2 0.00490436f
Cred_344 \$I57 vin.$58.GatPoly 0.00215885f
Cred_345 \$I57 vin.$582.Metal2 0.00631762f
Cred_346 \$I57 vin.$584.Metal2 0.0112653f
Cred_347 \$I57 vin.$587.Metal2 0.00369713f
Cred_348 \$I57 vin.$591.Metal2 0.00447878f
Cred_349 \$I57 vin.$593.Metal2 0.0148954f
Cred_350 \$I57 vin.$596.Metal2 0.00619595f
Cred_351 \$I57 vin.$599.Metal2 6.15536e-05f
Cred_352 \$I57 vin.$6.GatPoly 0.00249482f
Cred_353 \$I57 vin.$603.Metal2 0.010855f
Cred_354 \$I57 vin.$604.Metal2 0.00162091f
Cred_355 \$I57 vin.$609.Metal2 0.00301828f
Cred_356 \$I57 vin.$611.Metal2 0.00467127f
Cred_357 \$I57 vin.$613.Metal2 0.0148484f
Cred_358 \$I57 vin.$616.Metal2 0.00412776f
Cred_359 \$I57 vin.$620.Metal2 0.00405261f
Cred_360 \$I57 vin.$622.Metal2 0.0113466f
Cred_361 \$I57 vin.$625.Metal2 0.00589792f
Cred_362 \$I57 vin.$629.Metal2 0.00504892f
Cred_363 \$I57 vin.$633.Metal2 0.0121395f
Cred_364 \$I57 vin.$636.Metal2 0.00520449f
Cred_365 \$I57 vin.$64.GatPoly 0.00222086f
Cred_366 \$I57 vin.$640.Metal2 0.00529723f
Cred_367 \$I57 vin.$642.Metal2 0.0217034f
Cred_368 \$I57 vin.$645.Metal2 0.00462294f
Cred_369 \$I57 vin.$648.Metal2 0.000720493f
Cred_370 \$I57 vin.$649.Metal2 0.0067151f
Cred_371 \$I57 vin.$65.GatPoly 0.0475351f
Cred_372 \$I57 vin.$653.Metal2 0.00494179f
Cred_373 \$I57 vin.$654.Metal2 0.0265804f
Cred_374 \$I57 vin.$7.GatPoly 0.0550973f
Cred_375 \$I57 vin.$70.GatPoly 0.00219009f
Cred_376 \$I57 vin.$73.GatPoly 0.0461296f
Cred_377 \$I57 vin.$77.GatPoly 0.034766f
Cred_378 \$I57 vin.$78.GatPoly 0.00190757f
Cred_379 \$I57 vin.$80.GatPoly 0.00162127f
Cred_380 \$I57 vin.$83.GatPoly 0.0395235f
Cred_381 \$I57 vin.$84.GatPoly 0.00195865f
Cred_382 \$I57 vin.$87.GatPoly 0.0344622f
Cred_383 \$I57 vin.$9.GatPoly 0.0351538f
Cred_384 \$I57 vin.$90.GatPoly 0.00191379f
Cred_385 \$I57 vin.$93.GatPoly 0.0394701f
Cred_386 \$I57 vin.$94.GatPoly 0.00210912f
Cred_387 \$I57 vin.$97.GatPoly 0.0412011f
Cred_388 \$I57 vin.P0.GatPoly 0.00166494f
Cred_389 \$I57 vin.P1.GatPoly 0.00047016f
Cred_390 \$I57 vin.P10.GatPoly 0.0006579f
Cred_391 \$I57 vin.P12.GatPoly 0.000304679f
Cred_392 \$I57 vin.P13.GatPoly 0.000263521f
Cred_393 \$I57 vin.P15.GatPoly 0.000684045f
Cred_394 \$I57 vin.P17.GatPoly 0.000708445f
Cred_395 \$I57 vin.P18.GatPoly 0.00047016f
Cred_396 \$I57 vin.P19.GatPoly 0.00166452f
Cred_397 \$I57 vin.P2.GatPoly 0.000708445f
Cred_398 \$I57 vin.P20.GatPoly 0.0848405f
Cred_399 \$I57 vin.P21.GatPoly 0.0487251f
Cred_400 \$I57 vin.P22.GatPoly 0.0487251f
Cred_401 \$I57 vin.P23.GatPoly 0.0487251f
Cred_402 \$I57 vin.P24.GatPoly 0.0532929f
Cred_403 \$I57 vin.P25.GatPoly 0.0487251f
Cred_404 \$I57 vin.P26.GatPoly 0.0487251f
Cred_405 \$I57 vin.P27.GatPoly 0.0533926f
Cred_406 \$I57 vin.P28.GatPoly 0.0487251f
Cred_407 \$I57 vin.P29.GatPoly 0.0487251f
Cred_408 \$I57 vin.P30.GatPoly 0.0487251f
Cred_409 \$I57 vin.P31.GatPoly 0.0487251f
Cred_410 \$I57 vin.P32.GatPoly 0.0533926f
Cred_411 \$I57 vin.P33.GatPoly 0.0487251f
Cred_412 \$I57 vin.P34.GatPoly 0.0487251f
Cred_413 \$I57 vin.P35.GatPoly 0.0532929f
Cred_414 \$I57 vin.P36.GatPoly 0.0487251f
Cred_415 \$I57 vin.P37.GatPoly 0.0487251f
Cred_416 \$I57 vin.P38.GatPoly 0.0487251f
Cred_417 \$I57 vin.P39.GatPoly 0.0679866f
Cred_418 \$I57 vin.P4.GatPoly 0.000684045f
Cred_419 \$I57 vin.P6.GatPoly 0.000263521f
Cred_420 \$I57 vin.P7.GatPoly 0.000304679f
Cred_421 \$I57 vin.P9.GatPoly 0.000258104f
Cred_422 \$I57 vout 0.0405934f
Cred_423 \$I57 vout.$1226.Metal3 0.0717015f
Cred_424 \$I57 vout.$1292.Metal3 0.038615f
Cred_425 \$I57 vout.$1358.Metal3 0.0387555f
Cred_426 \$I57 vout.$1424.Metal3 0.0295064f
Cred_427 \$I57 vout.P0.nSD 0.00101984f
Cred_428 \$I57 vout.P0.pSD 0.0110114f
Cred_429 \$I57 vout.P10.nSD 0.000148877f
Cred_430 \$I57 vout.P10.pSD 0.0051617f
Cred_431 \$I57 vout.P12.pSD 0.00435537f
Cred_432 \$I57 vout.P14.nSD 0.000148877f
Cred_433 \$I57 vout.P14.pSD 0.0051617f
Cred_434 \$I57 vout.P16.pSD 0.00435537f
Cred_435 \$I57 vout.P18.pSD 0.00531466f
Cred_436 \$I57 vout.P2.nSD 0.000670124f
Cred_437 \$I57 vout.P2.pSD 0.00811059f
Cred_438 \$I57 vout.P4.pSD 0.00444821f
Cred_439 \$I57 vout.P6.nSD 0.000148126f
Cred_440 \$I57 vout.P6.pSD 0.00525775f
Cred_441 \$I57 vout.P8.pSD 0.00444821f
Cred_442 \$I57 VSS.$1055.Metal2 0.000155061f
Cred_443 \$I57 VSS.$1066.Metal2 0.0088247f
Cred_444 \$I57 VSS.$1106.Metal3 0.00744975f
Cred_445 \$I57 VSS.$1307.Metal3 0.00744975f
Cred_446 \$I57 VSS.$18.Metal1 0.00679273f
Cred_447 \$I57 VSS.$40.Metal1 0.00334841f
Cred_448 \$I57 VSS.$44.Metal1 2.7177e-06f
Cred_449 \$I57 VSS.$501.Metal1 3.71747e-06f
Cred_450 \$I57 VSS.$509.Metal1 0.000494181f
Cred_451 \$I57 VSS.$520.Metal1 9.00579e-07f
Cred_452 \$I57 VSS.$551.Metal1 0.0100816f
Cred_453 \$I57 VSS.$564.Metal2 0.0125968f
Cred_454 \$I57 VSS.$590.Metal2 0.000155112f
Cred_455 \$I57 VSS.P0.GatPoly 0.00326544f
Cred_456 \$I57 VSS.P0.nSD 3.0221e-06f
Cred_457 \$I57 VSS.P0.pSD 0.163191f
Cred_458 \$I57 VSS.P1.GatPoly 0.00326544f
Cred_459 \$I57 VSS.P1.nSD 3.0221e-06f
Cred_460 \$I57 VSS.P21.nSD 2.08702e-06f
Cred_461 \$I57 VSS.P23.nSD 2.08702e-06f
Cred_462 VSS VDD 0.0304319f
Cred_463 VSS VDD.$100.Metal1 0.0527685f
Cred_464 VSS VDD.$1000.Metal1 1.67776e-05f
Cred_465 VSS VDD.$1001.Metal1 3.26535e-06f
Cred_466 VSS VDD.$1002.Metal1 0.043531f
Cred_467 VSS VDD.$1003.Metal1 0.0565634f
Cred_468 VSS VDD.$1004.Metal1 0.0113125f
Cred_469 VSS VDD.$1005.Metal1 0.0116263f
Cred_470 VSS VDD.$1006.Metal1 0.0119314f
Cred_471 VSS VDD.$1007.Metal1 0.0146114f
Cred_472 VSS VDD.$1056.Metal2 0.114595f
Cred_473 VSS VDD.$1065.Metal2 0.0798633f
Cred_474 VSS VDD.$1068.Metal2 0.0319558f
Cred_475 VSS VDD.$1070.Metal2 0.0255936f
Cred_476 VSS VDD.$1072.Metal2 0.0255973f
Cred_477 VSS VDD.$1074.Metal2 0.0192077f
Cred_478 VSS VDD.$1075.Metal2 0.0271325f
Cred_479 VSS VDD.$1110.Metal2 0.0511864f
Cred_480 VSS VDD.$1137.Metal2 0.0291626f
Cred_481 VSS VDD.$1149.Metal2 0.0286083f
Cred_482 VSS VDD.$1161.Metal2 0.021723f
Cred_483 VSS VDD.$1167.Metal2 0.0146519f
Cred_484 VSS VDD.$1188.Metal2 0.0215782f
Cred_485 VSS VDD.$1214.Metal2 0.0214966f
Cred_486 VSS VDD.$1220.Metal2 0.0147413f
Cred_487 VSS VDD.$1226.Metal2 0.0217674f
Cred_488 VSS VDD.$1253.Metal2 0.0215101f
Cred_489 VSS VDD.$1273.Metal2 0.021558f
Cred_490 VSS VDD.$1285.Metal2 0.0288108f
Cred_491 VSS VDD.$1297.Metal2 0.0288108f
Cred_492 VSS VDD.$130.Metal1 0.0012117f
Cred_493 VSS VDD.$131.Metal1 4.89416e-05f
Cred_494 VSS VDD.$132.Metal1 1.63474e-05f
Cred_495 VSS VDD.$1324.Metal2 0.0216232f
Cred_496 VSS VDD.$133.Metal1 1.22451e-05f
Cred_497 VSS VDD.$134.Metal1 1.67776e-05f
Cred_498 VSS VDD.$1344.Metal2 0.0144705f
Cred_499 VSS VDD.$135.Metal1 3.26535e-06f
Cred_500 VSS VDD.$1350.Metal2 0.0216327f
Cred_501 VSS VDD.$136.Metal1 0.043531f
Cred_502 VSS VDD.$1362.Metal2 0.0286083f
Cred_503 VSS VDD.$137.Metal1 0.0565634f
Cred_504 VSS VDD.$1374.Metal2 0.0215646f
Cred_505 VSS VDD.$138.Metal1 0.0113362f
Cred_506 VSS VDD.$139.Metal1 0.0116124f
Cred_507 VSS VDD.$1395.Metal2 0.0214977f
Cred_508 VSS VDD.$140.Metal1 0.0119216f
Cred_509 VSS VDD.$141.Metal1 0.0146114f
Cred_510 VSS VDD.$142.Metal1 0.0668947f
Cred_511 VSS VDD.$1421.Metal2 0.0214966f
Cred_512 VSS VDD.$1427.Metal2 0.0147413f
Cred_513 VSS VDD.$1433.Metal2 0.0217674f
Cred_514 VSS VDD.$1460.Metal2 0.0213794f
Cred_515 VSS VDD.$1480.Metal2 0.0215065f
Cred_516 VSS VDD.$1492.Metal2 0.0287655f
Cred_517 VSS VDD.$1504.Metal2 0.0286083f
Cred_518 VSS VDD.$152.Metal1 0.065376f
Cred_519 VSS VDD.$1531.Metal2 0.021548f
Cred_520 VSS VDD.$1551.Metal2 0.0146963f
Cred_521 VSS VDD.$1557.Metal2 0.021745f
Cred_522 VSS VDD.$1569.Metal2 0.0286083f
Cred_523 VSS VDD.$1581.Metal2 0.0215824f
Cred_524 VSS VDD.$1602.Metal2 0.0214463f
Cred_525 VSS VDD.$1628.Metal2 0.0288108f
Cred_526 VSS VDD.$164.Metal1 0.0761788f
Cred_527 VSS VDD.$1640.Metal2 0.0288108f
Cred_528 VSS VDD.$1652.Metal2 0.021558f
Cred_529 VSS VDD.$1673.Metal2 0.0215101f
Cred_530 VSS VDD.$1699.Metal2 0.0288108f
Cred_531 VSS VDD.$1711.Metal2 0.0288108f
Cred_532 VSS VDD.$1738.Metal2 0.0215279f
Cred_533 VSS VDD.$1758.Metal2 0.0215456f
Cred_534 VSS VDD.$177.Metal1 0.060786f
Cred_535 VSS VDD.$1770.Metal2 0.0286083f
Cred_536 VSS VDD.$1782.Metal2 0.0217172f
Cred_537 VSS VDD.$1788.Metal2 0.0220639f
Cred_538 VSS VDD.$1803.Metal2 0.0798633f
Cred_539 VSS VDD.$1806.Metal2 0.0319558f
Cred_540 VSS VDD.$1808.Metal2 0.0255936f
Cred_541 VSS VDD.$1810.Metal2 0.0192036f
Cred_542 VSS VDD.$1811.Metal2 0.0192091f
Cred_543 VSS VDD.$1813.Metal2 0.033525f
Cred_544 VSS VDD.$1815.Metal2 0.0533387f
Cred_545 VSS VDD.$1822.Metal2 0.119563f
Cred_546 VSS VDD.$1884.Metal3 0.125126f
Cred_547 VSS VDD.$1896.Metal3 0.0383695f
Cred_548 VSS VDD.$1902.Metal3 0.0383398f
Cred_549 VSS VDD.$1914.Metal3 0.0509656f
Cred_550 VSS VDD.$1926.Metal3 0.0446904f
Cred_551 VSS VDD.$1935.Metal3 0.0447187f
Cred_552 VSS VDD.$1947.Metal3 0.0509939f
Cred_553 VSS VDD.$1959.Metal3 0.0383398f
Cred_554 VSS VDD.$1965.Metal3 0.0320646f
Cred_555 VSS VDD.$1974.Metal3 0.0446904f
Cred_556 VSS VDD.$1986.Metal3 0.036348f
Cred_557 VSS VDD.$2001.Metal3 0.0355379f
Cred_558 VSS VDD.$2007.Metal3 0.0383398f
Cred_559 VSS VDD.$2019.Metal3 0.0383398f
Cred_560 VSS VDD.$2025.Metal3 0.0320646f
Cred_561 VSS VDD.$2034.Metal3 0.0447187f
Cred_562 VSS VDD.$2046.Metal3 0.0447187f
Cred_563 VSS VDD.$2055.Metal3 0.0447187f
Cred_564 VSS VDD.$2067.Metal3 0.0447187f
Cred_565 VSS VDD.$2076.Metal3 0.0320646f
Cred_566 VSS VDD.$2082.Metal3 0.0320646f
Cred_567 VSS VDD.$2091.Metal3 0.137166f
Cred_568 VSS VDD.$230.Metal1 0.0425604f
Cred_569 VSS VDD.$237.Metal1 0.0651531f
Cred_570 VSS VDD.$252.Metal1 0.0728386f
Cred_571 VSS VDD.$257.Metal1 0.04427f
Cred_572 VSS VDD.$315.Metal1 0.0624529f
Cred_573 VSS VDD.$325.Metal1 0.0653706f
Cred_574 VSS VDD.$337.Metal1 0.0642287f
Cred_575 VSS VDD.$376.Metal1 0.00238305f
Cred_576 VSS VDD.$393.Metal1 0.0640839f
Cred_577 VSS VDD.$403.Metal1 0.0653725f
Cred_578 VSS VDD.$415.Metal1 0.0632455f
Cred_579 VSS VDD.$423.Metal1 0.0449698f
Cred_580 VSS VDD.$476.Metal1 0.0389429f
Cred_581 VSS VDD.$483.Metal1 0.0651521f
Cred_582 VSS VDD.$498.Metal1 0.0652088f
Cred_583 VSS VDD.$518.Metal1 0.0327394f
Cred_584 VSS VDD.$554.Metal1 0.0327394f
Cred_585 VSS VDD.$561.Metal1 0.0490847f
Cred_586 VSS VDD.$571.Metal1 0.06537f
Cred_587 VSS VDD.$581.Metal1 0.0552313f
Cred_588 VSS VDD.$586.Metal1 0.0617118f
Cred_589 VSS VDD.$649.Metal1 0.0788153f
Cred_590 VSS VDD.$661.Metal1 0.065368f
Cred_591 VSS VDD.$7.Metal1 0.170484f
Cred_592 VSS VDD.$702.Metal1 9.72773e-05f
Cred_593 VSS VDD.$703.Metal1 0.0489314f
Cred_594 VSS VDD.$722.Metal1 0.0490827f
Cred_595 VSS VDD.$734.Metal1 0.0653706f
Cred_596 VSS VDD.$744.Metal1 0.0624529f
Cred_597 VSS VDD.$754.Metal1 0.04427f
Cred_598 VSS VDD.$807.Metal1 0.0567145f
Cred_599 VSS VDD.$817.Metal1 0.0653706f
Cred_600 VSS VDD.$829.Metal1 0.058847f
Cred_601 VSS VDD.$834.Metal1 0.0436234f
Cred_602 VSS VDD.$890.Metal1 0.0609673f
Cred_603 VSS VDD.$902.Metal1 0.0815032f
Cred_604 VSS VDD.$917.Metal1 0.0830163f
Cred_605 VSS VDD.$920.Metal1 0.170589f
Cred_606 VSS VDD.$940.Metal1 0.0012117f
Cred_607 VSS VDD.$941.Metal1 4.89416e-05f
Cred_608 VSS VDD.$942.Metal1 1.63474e-05f
Cred_609 VSS VDD.$943.Metal1 1.22451e-05f
Cred_610 VSS VDD.$95.Metal1 0.0514215f
Cred_611 VSS VDD.$954.Metal1 0.0527685f
Cred_612 VSS VDD.$965.Metal1 0.0513716f
Cred_613 VSS VDD.P0.GatPoly 0.0105359f
Cred_614 VSS VDD.P0.nSD 0.458863f
Cred_615 VSS VDD.P0.pSD 1.44675e-05f
Cred_616 VSS VDD.P1.GatPoly 0.0105359f
Cred_617 VSS VDD.P1.pSD 1.44675e-05f
Cred_618 VSS VDD.P21.pSD 1.44675e-05f
Cred_619 VSS VDD.P23.pSD 1.44675e-05f
Cred_620 VSS vin 0.0315845f
Cred_621 VSS vin.$10.GatPoly 0.0413156f
Cred_622 VSS vin.$102.GatPoly 0.0475528f
Cred_623 VSS vin.$105.GatPoly 0.00473739f
Cred_624 VSS vin.$107.GatPoly 0.00373578f
Cred_625 VSS vin.$108.GatPoly 0.0325349f
Cred_626 VSS vin.$110.GatPoly 0.0389814f
Cred_627 VSS vin.$115.GatPoly 0.00543054f
Cred_628 VSS vin.$118.GatPoly 0.0447656f
Cred_629 VSS vin.$122.GatPoly 0.0501571f
Cred_630 VSS vin.$123.GatPoly 0.00554504f
Cred_631 VSS vin.$127.GatPoly 0.00460339f
Cred_632 VSS vin.$130.GatPoly 0.0429479f
Cred_633 VSS vin.$134.GatPoly 0.0447943f
Cred_634 VSS vin.$135.GatPoly 0.00472455f
Cred_635 VSS vin.$136.GatPoly 0.0401879f
Cred_636 VSS vin.$137.GatPoly 0.00394869f
Cred_637 VSS vin.$144.GatPoly 0.0510568f
Cred_638 VSS vin.$145.GatPoly 0.00532136f
Cred_639 VSS vin.$15.GatPoly 0.00402788f
Cred_640 VSS vin.$152.GatPoly 0.0515261f
Cred_641 VSS vin.$153.GatPoly 0.00558667f
Cred_642 VSS vin.$156.GatPoly 0.048725f
Cred_643 VSS vin.$157.GatPoly 0.00390465f
Cred_644 VSS vin.$16.GatPoly 0.0439768f
Cred_645 VSS vin.$163.GatPoly 0.00441521f
Cred_646 VSS vin.$164.GatPoly 0.0505391f
Cred_647 VSS vin.$167.GatPoly 0.00402788f
Cred_648 VSS vin.$17.GatPoly 0.00431606f
Cred_649 VSS vin.$172.GatPoly 0.0439768f
Cred_650 VSS vin.$173.GatPoly 0.00431606f
Cred_651 VSS vin.$176.GatPoly 0.0413156f
Cred_652 VSS vin.$179.GatPoly 0.00685663f
Cred_653 VSS vin.$180.GatPoly 0.0565216f
Cred_654 VSS vin.$199.Metal1 0.00631497f
Cred_655 VSS vin.$202.Metal1 0.0695836f
Cred_656 VSS vin.$207.Metal1 0.000874135f
Cred_657 VSS vin.$210.Metal1 0.0124329f
Cred_658 VSS vin.$211.Metal1 0.000874135f
Cred_659 VSS vin.$218.Metal1 0.0112606f
Cred_660 VSS vin.$219.Metal1 0.000585335f
Cred_661 VSS vin.$22.GatPoly 0.0505391f
Cred_662 VSS vin.$222.Metal1 0.0119673f
Cred_663 VSS vin.$227.Metal1 0.00118509f
Cred_664 VSS vin.$228.Metal1 0.0114373f
Cred_665 VSS vin.$232.Metal1 0.00606853f
Cred_666 VSS vin.$233.Metal1 0.00013326f
Cred_667 VSS vin.$236.Metal1 0.0114323f
Cred_668 VSS vin.$237.Metal1 0.000822718f
Cred_669 VSS vin.$24.GatPoly 0.048725f
Cred_670 VSS vin.$240.Metal1 0.0140838f
Cred_671 VSS vin.$241.Metal1 0.000853803f
Cred_672 VSS vin.$246.Metal1 0.0112588f
Cred_673 VSS vin.$247.Metal1 0.00076447f
Cred_674 VSS vin.$25.GatPoly 0.00390465f
Cred_675 VSS vin.$250.Metal1 0.0119062f
Cred_676 VSS vin.$251.Metal1 0.000812493f
Cred_677 VSS vin.$258.Metal1 0.0118264f
Cred_678 VSS vin.$259.Metal1 0.00066546f
Cred_679 VSS vin.$262.Metal1 0.00734796f
Cred_680 VSS vin.$263.Metal1 0.000353246f
Cred_681 VSS vin.$264.Metal1 0.00969053f
Cred_682 VSS vin.$265.Metal1 0.000464257f
Cred_683 VSS vin.$27.GatPoly 0.00441521f
Cred_684 VSS vin.$272.Metal1 0.0130424f
Cred_685 VSS vin.$273.Metal1 0.000691143f
Cred_686 VSS vin.$277.Metal1 0.00041137f
Cred_687 VSS vin.$280.Metal1 0.0142455f
Cred_688 VSS vin.$281.Metal1 0.000731309f
Cred_689 VSS vin.$284.Metal1 0.0139497f
Cred_690 VSS vin.$285.Metal1 0.000817657f
Cred_691 VSS vin.$290.Metal1 0.012115f
Cred_692 VSS vin.$291.Metal1 0.000778597f
Cred_693 VSS vin.$295.Metal1 0.000800193f
Cred_694 VSS vin.$298.Metal1 0.0150053f
Cred_695 VSS vin.$302.Metal1 0.0151111f
Cred_696 VSS vin.$303.Metal1 0.000735506f
Cred_697 VSS vin.$307.Metal1 0.000727765f
Cred_698 VSS vin.$310.Metal1 0.00666126f
Cred_699 VSS vin.$312.Metal1 0.0106928f
Cred_700 VSS vin.$313.Metal1 0.000203932f
Cred_701 VSS vin.$317.Metal1 0.000754794f
Cred_702 VSS vin.$320.Metal1 0.0123601f
Cred_703 VSS vin.$321.Metal1 0.000572335f
Cred_704 VSS vin.$325.Metal1 0.00039103f
Cred_705 VSS vin.$328.Metal1 0.0129056f
Cred_706 VSS vin.$331.Metal1 0.000772474f
Cred_707 VSS vin.$334.Metal1 0.0116676f
Cred_708 VSS vin.$335.Metal1 0.000617047f
Cred_709 VSS vin.$338.Metal1 0.0114787f
Cred_710 VSS vin.$339.Metal1 0.000572335f
Cred_711 VSS vin.$343.Metal1 0.000754794f
Cred_712 VSS vin.$346.Metal1 0.0106928f
Cred_713 VSS vin.$347.Metal1 0.000203932f
Cred_714 VSS vin.$348.Metal1 0.00666126f
Cred_715 VSS vin.$353.Metal1 0.000727765f
Cred_716 VSS vin.$356.Metal1 0.0151111f
Cred_717 VSS vin.$357.Metal1 0.000735506f
Cred_718 VSS vin.$36.GatPoly 0.0515261f
Cred_719 VSS vin.$360.Metal1 0.0150053f
Cred_720 VSS vin.$365.Metal1 0.000800193f
Cred_721 VSS vin.$368.Metal1 0.012115f
Cred_722 VSS vin.$369.Metal1 0.000778597f
Cred_723 VSS vin.$37.GatPoly 0.00558667f
Cred_724 VSS vin.$374.Metal1 0.0139497f
Cred_725 VSS vin.$375.Metal1 0.000817657f
Cred_726 VSS vin.$378.Metal1 0.0142455f
Cred_727 VSS vin.$379.Metal1 0.000731309f
Cred_728 VSS vin.$383.Metal1 0.00041137f
Cred_729 VSS vin.$386.Metal1 0.0130424f
Cred_730 VSS vin.$387.Metal1 0.000691143f
Cred_731 VSS vin.$392.Metal1 0.00969053f
Cred_732 VSS vin.$393.Metal1 0.000464257f
Cred_733 VSS vin.$396.Metal1 0.00734796f
Cred_734 VSS vin.$397.Metal1 0.000353246f
Cred_735 VSS vin.$400.Metal1 0.0118264f
Cred_736 VSS vin.$401.Metal1 0.00066546f
Cred_737 VSS vin.$408.Metal1 0.0119062f
Cred_738 VSS vin.$409.Metal1 0.000812493f
Cred_739 VSS vin.$412.Metal1 0.0112588f
Cred_740 VSS vin.$413.Metal1 0.00076447f
Cred_741 VSS vin.$418.Metal1 0.0140838f
Cred_742 VSS vin.$419.Metal1 0.000853803f
Cred_743 VSS vin.$42.GatPoly 0.0510568f
Cred_744 VSS vin.$422.Metal1 0.0114323f
Cred_745 VSS vin.$423.Metal1 0.000822718f
Cred_746 VSS vin.$426.Metal1 0.00606853f
Cred_747 VSS vin.$427.Metal1 0.00013326f
Cred_748 VSS vin.$43.GatPoly 0.00532136f
Cred_749 VSS vin.$430.Metal1 0.0114373f
Cred_750 VSS vin.$433.Metal1 0.00118509f
Cred_751 VSS vin.$437.Metal1 0.0119673f
Cred_752 VSS vin.$44.GatPoly 0.0401879f
Cred_753 VSS vin.$440.Metal1 0.0112606f
Cred_754 VSS vin.$441.Metal1 0.000585335f
Cred_755 VSS vin.$448.Metal1 0.0124361f
Cred_756 VSS vin.$449.Metal1 0.000874135f
Cred_757 VSS vin.$453.Metal1 0.000874135f
Cred_758 VSS vin.$456.Metal1 0.0685685f
Cred_759 VSS vin.$457.Metal1 0.00813767f
Cred_760 VSS vin.$47.GatPoly 0.00394869f
Cred_761 VSS vin.$476.Metal2 0.0458587f
Cred_762 VSS vin.$478.Metal2 0.0118507f
Cred_763 VSS vin.$481.Metal2 0.00649168f
Cred_764 VSS vin.$483.Metal2 0.00606056f
Cred_765 VSS vin.$486.Metal2 0.0177843f
Cred_766 VSS vin.$488.Metal2 0.00954933f
Cred_767 VSS vin.$492.Metal2 0.00627543f
Cred_768 VSS vin.$493.Metal2 9.70748e-06f
Cred_769 VSS vin.$495.Metal2 0.0171142f
Cred_770 VSS vin.$497.Metal2 0.0146444f
Cred_771 VSS vin.$503.Metal2 0.0124367f
Cred_772 VSS vin.$506.Metal2 0.018081f
Cred_773 VSS vin.$508.Metal2 0.00780893f
Cred_774 VSS vin.$512.Metal2 0.00795384f
Cred_775 VSS vin.$515.Metal2 0.0238751f
Cred_776 VSS vin.$517.Metal2 0.0122053f
Cred_777 VSS vin.$52.GatPoly 0.0447943f
Cred_778 VSS vin.$523.Metal2 0.0176085f
Cred_779 VSS vin.$527.Metal2 0.0027541f
Cred_780 VSS vin.$528.Metal2 0.00622792f
Cred_781 VSS vin.$53.GatPoly 0.00472455f
Cred_782 VSS vin.$532.Metal2 0.00969695f
Cred_783 VSS vin.$535.Metal2 0.0239715f
Cred_784 VSS vin.$537.Metal2 0.00844897f
Cred_785 VSS vin.$541.Metal2 0.0107013f
Cred_786 VSS vin.$544.Metal2 0.0196685f
Cred_787 VSS vin.$548.Metal2 0.0102159f
Cred_788 VSS vin.$551.Metal2 3.73876e-06f
Cred_789 VSS vin.$552.Metal2 0.0122351f
Cred_790 VSS vin.$555.Metal2 0.0175352f
Cred_791 VSS vin.$557.Metal2 0.00673351f
Cred_792 VSS vin.$561.Metal2 0.00906322f
Cred_793 VSS vin.$564.Metal2 0.0182677f
Cred_794 VSS vin.$566.Metal2 0.00907308f
Cred_795 VSS vin.$57.GatPoly 0.00460339f
Cred_796 VSS vin.$570.Metal2 0.00671838f
Cred_797 VSS vin.$573.Metal2 0.0175352f
Cred_798 VSS vin.$575.Metal2 0.0122351f
Cred_799 VSS vin.$578.Metal2 3.73876e-06f
Cred_800 VSS vin.$579.Metal2 0.0102159f
Cred_801 VSS vin.$58.GatPoly 0.0429479f
Cred_802 VSS vin.$584.Metal2 0.0196685f
Cred_803 VSS vin.$586.Metal2 0.0107013f
Cred_804 VSS vin.$590.Metal2 0.00844897f
Cred_805 VSS vin.$593.Metal2 0.0239715f
Cred_806 VSS vin.$595.Metal2 0.00969695f
Cred_807 VSS vin.$599.Metal2 0.00622792f
Cred_808 VSS vin.$6.GatPoly 0.0567529f
Cred_809 VSS vin.$603.Metal2 0.0027541f
Cred_810 VSS vin.$604.Metal2 0.0176085f
Cred_811 VSS vin.$610.Metal2 0.0122053f
Cred_812 VSS vin.$613.Metal2 0.0238751f
Cred_813 VSS vin.$615.Metal2 0.00795384f
Cred_814 VSS vin.$619.Metal2 0.00780893f
Cred_815 VSS vin.$622.Metal2 0.018081f
Cred_816 VSS vin.$624.Metal2 0.0124367f
Cred_817 VSS vin.$630.Metal2 0.0146444f
Cred_818 VSS vin.$633.Metal2 0.0171142f
Cred_819 VSS vin.$635.Metal2 0.00627543f
Cred_820 VSS vin.$636.Metal2 9.70748e-06f
Cred_821 VSS vin.$639.Metal2 0.00954933f
Cred_822 VSS vin.$64.GatPoly 0.0501571f
Cred_823 VSS vin.$642.Metal2 0.0396561f
Cred_824 VSS vin.$644.Metal2 0.00860312f
Cred_825 VSS vin.$648.Metal2 0.0119929f
Cred_826 VSS vin.$649.Metal2 0.00213259f
Cred_827 VSS vin.$65.GatPoly 0.00554504f
Cred_828 VSS vin.$653.Metal2 0.0426341f
Cred_829 VSS vin.$654.Metal2 0.015216f
Cred_830 VSS vin.$7.GatPoly 0.00523565f
Cred_831 VSS vin.$70.GatPoly 0.0447656f
Cred_832 VSS vin.$73.GatPoly 0.00543054f
Cred_833 VSS vin.$77.GatPoly 0.00373578f
Cred_834 VSS vin.$78.GatPoly 0.0389814f
Cred_835 VSS vin.$80.GatPoly 0.0325349f
Cred_836 VSS vin.$83.GatPoly 0.00473739f
Cred_837 VSS vin.$84.GatPoly 0.0449968f
Cred_838 VSS vin.$87.GatPoly 0.0036961f
Cred_839 VSS vin.$9.GatPoly 0.00417969f
Cred_840 VSS vin.$90.GatPoly 0.0376923f
Cred_841 VSS vin.$93.GatPoly 0.00472681f
Cred_842 VSS vin.$94.GatPoly 0.0478429f
Cred_843 VSS vin.$97.GatPoly 0.0045033f
Cred_844 VSS vin.P0.GatPoly 0.106132f
Cred_845 VSS vin.P1.GatPoly 0.0708599f
Cred_846 VSS vin.P10.GatPoly 0.0765331f
Cred_847 VSS vin.P11.GatPoly 0.064479f
Cred_848 VSS vin.P12.GatPoly 0.0699124f
Cred_849 VSS vin.P13.GatPoly 0.0695719f
Cred_850 VSS vin.P14.GatPoly 0.0617096f
Cred_851 VSS vin.P15.GatPoly 0.0765727f
Cred_852 VSS vin.P16.GatPoly 0.0617096f
Cred_853 VSS vin.P17.GatPoly 0.0766326f
Cred_854 VSS vin.P18.GatPoly 0.0708599f
Cred_855 VSS vin.P19.GatPoly 0.104616f
Cred_856 VSS vin.P2.GatPoly 0.0766326f
Cred_857 VSS vin.P20.GatPoly 0.013226f
Cred_858 VSS vin.P21.GatPoly 0.011285f
Cred_859 VSS vin.P22.GatPoly 0.011285f
Cred_860 VSS vin.P23.GatPoly 0.011285f
Cred_861 VSS vin.P24.GatPoly 0.0117802f
Cred_862 VSS vin.P25.GatPoly 0.011285f
Cred_863 VSS vin.P26.GatPoly 0.011285f
Cred_864 VSS vin.P27.GatPoly 0.0117749f
Cred_865 VSS vin.P28.GatPoly 0.011285f
Cred_866 VSS vin.P29.GatPoly 0.011285f
Cred_867 VSS vin.P3.GatPoly 0.0617096f
Cred_868 VSS vin.P30.GatPoly 0.011285f
Cred_869 VSS vin.P31.GatPoly 0.011285f
Cred_870 VSS vin.P32.GatPoly 0.0117749f
Cred_871 VSS vin.P33.GatPoly 0.011285f
Cred_872 VSS vin.P34.GatPoly 0.011285f
Cred_873 VSS vin.P35.GatPoly 0.0117802f
Cred_874 VSS vin.P36.GatPoly 0.011285f
Cred_875 VSS vin.P37.GatPoly 0.011285f
Cred_876 VSS vin.P38.GatPoly 0.011285f
Cred_877 VSS vin.P39.GatPoly 0.0133679f
Cred_878 VSS vin.P4.GatPoly 0.0765727f
Cred_879 VSS vin.P5.GatPoly 0.0617096f
Cred_880 VSS vin.P6.GatPoly 0.0695719f
Cred_881 VSS vin.P7.GatPoly 0.0699124f
Cred_882 VSS vin.P8.GatPoly 0.064479f
Cred_883 VSS vin.P9.GatPoly 0.0692081f
Cred_884 VSS vout 0.0879385f
Cred_885 VSS vout.$1226.Metal3 0.13261f
Cred_886 VSS vout.$1292.Metal3 0.0591296f
Cred_887 VSS vout.$1358.Metal3 0.0591349f
Cred_888 VSS vout.$1424.Metal3 0.0447371f
Cred_889 VSS vout.P0.nSD 0.00682052f
Cred_890 VSS vout.P0.pSD 0.0126259f
Cred_891 VSS vout.P10.nSD 0.00438845f
Cred_892 VSS vout.P10.pSD 0.00123033f
Cred_893 VSS vout.P12.nSD 0.00416129f
Cred_894 VSS vout.P14.nSD 0.00438845f
Cred_895 VSS vout.P14.pSD 0.00123033f
Cred_896 VSS vout.P16.nSD 0.00416129f
Cred_897 VSS vout.P18.nSD 0.00454491f
Cred_898 VSS vout.P18.pSD 0.000469018f
Cred_899 VSS vout.P2.nSD 0.00554607f
Cred_900 VSS vout.P2.pSD 0.00756812f
Cred_901 VSS vout.P4.nSD 0.00416129f
Cred_902 VSS vout.P6.nSD 0.00438837f
Cred_903 VSS vout.P6.pSD 0.00124104f
Cred_904 VSS vout.P8.nSD 0.00416129f
Cred_906 VSS VSS.$1002.Metal2 0.0393342f
Cred_907 VSS VSS.$1010.Metal2 0.0357289f
Cred_908 VSS VSS.$1022.Metal2 0.0345952f
Cred_909 VSS VSS.$1034.Metal2 0.0262602f
Cred_910 VSS VSS.$1040.Metal2 0.0275419f
Cred_911 VSS VSS.$1055.Metal2 0.0549021f
Cred_912 VSS VSS.$1066.Metal2 0.206242f
Cred_913 VSS VSS.$1106.Metal3 0.156714f
Cred_914 VSS VSS.$1115.Metal3 0.0384362f
Cred_915 VSS VSS.$1121.Metal3 0.0364891f
Cred_916 VSS VSS.$1130.Metal3 0.0512706f
Cred_917 VSS VSS.$1142.Metal3 0.0582977f
Cred_918 VSS VSS.$115.Metal1 0.0804599f
Cred_919 VSS VSS.$1154.Metal3 0.0516406f
Cred_920 VSS VSS.$1163.Metal3 0.0434811f
Cred_921 VSS VSS.$1172.Metal3 0.0368593f
Cred_922 VSS VSS.$1178.Metal3 0.0442195f
Cred_923 VSS VSS.$1190.Metal3 0.043347f
Cred_924 VSS VSS.$1196.Metal3 0.0418251f
Cred_925 VSS VSS.$1217.Metal3 0.0418251f
Cred_926 VSS VSS.$1223.Metal3 0.043347f
Cred_927 VSS VSS.$1235.Metal3 0.0442195f
Cred_928 VSS VSS.$1241.Metal3 0.0368593f
Cred_929 VSS VSS.$1250.Metal3 0.0434811f
Cred_930 VSS VSS.$1259.Metal3 0.0516406f
Cred_931 VSS VSS.$127.Metal1 0.086906f
Cred_932 VSS VSS.$1271.Metal3 0.0582977f
Cred_933 VSS VSS.$1283.Metal3 0.0512706f
Cred_934 VSS VSS.$1292.Metal3 0.0364891f
Cred_935 VSS VSS.$1298.Metal3 0.0384362f
Cred_936 VSS VSS.$1307.Metal3 0.156683f
Cred_937 VSS VSS.$137.Metal1 0.0798481f
Cred_938 VSS VSS.$142.Metal1 0.126278f
Cred_939 VSS VSS.$167.Metal1 0.125745f
Cred_940 VSS VSS.$18.Metal1 0.250016f
Cred_941 VSS VSS.$184.Metal1 0.0925595f
Cred_942 VSS VSS.$192.Metal1 0.0881218f
Cred_943 VSS VSS.$195.Metal1 0.0217448f
Cred_944 VSS VSS.$207.Metal1 0.0879838f
Cred_945 VSS VSS.$219.Metal1 0.106941f
Cred_946 VSS VSS.$232.Metal1 0.125246f
Cred_947 VSS VSS.$247.Metal1 0.078472f
Cred_948 VSS VSS.$259.Metal1 0.0866295f
Cred_949 VSS VSS.$269.Metal1 0.0646325f
Cred_950 VSS VSS.$275.Metal1 0.0691955f
Cred_951 VSS VSS.$285.Metal1 0.0691955f
Cred_952 VSS VSS.$294.Metal1 0.0646325f
Cred_953 VSS VSS.$304.Metal1 0.0866295f
Cred_954 VSS VSS.$314.Metal1 0.078472f
Cred_955 VSS VSS.$319.Metal1 0.125246f
Cred_956 VSS VSS.$344.Metal1 0.106941f
Cred_957 VSS VSS.$356.Metal1 0.0879838f
Cred_958 VSS VSS.$369.Metal1 0.0881218f
Cred_959 VSS VSS.$372.Metal1 0.0217448f
Cred_960 VSS VSS.$379.Metal1 0.0925595f
Cred_961 VSS VSS.$396.Metal1 0.125745f
Cred_962 VSS VSS.$40.Metal1 0.180009f
Cred_963 VSS VSS.$409.Metal1 0.126278f
Cred_964 VSS VSS.$426.Metal1 0.0798481f
Cred_965 VSS VSS.$436.Metal1 0.086906f
Cred_966 VSS VSS.$44.Metal1 0.138997f
Cred_967 VSS VSS.$448.Metal1 0.0804599f
Cred_968 VSS VSS.$453.Metal1 0.103337f
Cred_969 VSS VSS.$471.Metal1 0.0845346f
Cred_970 VSS VSS.$483.Metal1 0.108619f
Cred_971 VSS VSS.$498.Metal1 0.113805f
Cred_972 VSS VSS.$501.Metal1 0.191355f
Cred_973 VSS VSS.$509.Metal1 0.173584f
Cred_974 VSS VSS.$520.Metal1 0.0576434f
Cred_975 VSS VSS.$551.Metal1 0.155125f
Cred_976 VSS VSS.$564.Metal2 0.208702f
Cred_977 VSS VSS.$590.Metal2 0.0554694f
Cred_978 VSS VSS.$605.Metal2 0.0275419f
Cred_979 VSS VSS.$611.Metal2 0.0262602f
Cred_980 VSS VSS.$623.Metal2 0.0345952f
Cred_981 VSS VSS.$636.Metal2 0.0357289f
Cred_982 VSS VSS.$644.Metal2 0.0393342f
Cred_983 VSS VSS.$65.Metal1 0.113805f
Cred_984 VSS VSS.$658.Metal2 0.0347464f
Cred_985 VSS VSS.$670.Metal2 0.0346122f
Cred_986 VSS VSS.$685.Metal2 0.0418581f
Cred_987 VSS VSS.$693.Metal2 0.0240921f
Cred_988 VSS VSS.$699.Metal2 0.026126f
Cred_989 VSS VSS.$711.Metal2 0.0265217f
Cred_990 VSS VSS.$717.Metal2 0.025578f
Cred_991 VSS VSS.$732.Metal2 0.0474236f
Cred_992 VSS VSS.$740.Metal2 0.0256949f
Cred_993 VSS VSS.$752.Metal2 0.034725f
Cred_994 VSS VSS.$764.Metal2 0.0261693f
Cred_995 VSS VSS.$770.Metal2 0.0222951f
Cred_996 VSS VSS.$779.Metal2 0.0437315f
Cred_997 VSS VSS.$793.Metal2 0.0342788f
Cred_998 VSS VSS.$80.Metal1 0.108619f
Cred_999 VSS VSS.$805.Metal2 0.0347543f
Cred_1000 VSS VSS.$818.Metal2 0.0369841f
Cred_1001 VSS VSS.$826.Metal2 0.0369841f
Cred_1002 VSS VSS.$840.Metal2 0.0347543f
Cred_1003 VSS VSS.$852.Metal2 0.0342788f
Cred_1004 VSS VSS.$867.Metal2 0.0437315f
Cred_1005 VSS VSS.$875.Metal2 0.0222951f
Cred_1006 VSS VSS.$881.Metal2 0.0261693f
Cred_1007 VSS VSS.$893.Metal2 0.034725f
Cred_1008 VSS VSS.$905.Metal2 0.0256949f
Cred_1009 VSS VSS.$914.Metal2 0.0474236f
Cred_1010 VSS VSS.$92.Metal1 0.0845346f
Cred_1011 VSS VSS.$928.Metal2 0.025578f
Cred_1012 VSS VSS.$934.Metal2 0.0265217f
Cred_1013 VSS VSS.$946.Metal2 0.026126f
Cred_1014 VSS VSS.$952.Metal2 0.0240921f
Cred_1015 VSS VSS.$961.Metal2 0.0418581f
Cred_1016 VSS VSS.$97.Metal1 0.103337f
Cred_1017 VSS VSS.$975.Metal2 0.0346122f
Cred_1018 VSS VSS.$987.Metal2 0.0347464f
Cred_1019 VSS VSS.P0.GatPoly 0.113789f
Cred_1020 VSS VSS.P0.nSD 0.000241423f
Cred_1021 VSS VSS.P0.pSD 0.679091f
Cred_1022 VSS VSS.P1.GatPoly 0.110789f
Cred_1023 VSS VSS.P1.nSD 0.000241423f
Cred_1024 VSS VSS.P10.nSD 0.00057823f
Cred_1025 VSS VSS.P11.nSD 0.000622825f
Cred_1026 VSS VSS.P13.nSD 0.00057823f
Cred_1027 VSS VSS.P15.nSD 2.11087e-05f
Cred_1028 VSS VSS.P17.nSD 0.000578513f
Cred_1029 VSS VSS.P19.nSD 0.000587156f
Cred_1030 VSS VSS.P21.nSD 0.000241423f
Cred_1031 VSS VSS.P23.nSD 0.000241423f
Cred_1032 VSS VSS.P3.nSD 0.000587156f
Cred_1033 VSS VSS.P5.nSD 0.000578513f
Cred_1034 VSS VSS.P7.nSD 2.11087e-05f
Cred_1035 VDD vin.$335.Metal1 1.71701e-08f
Cred_1036 VDD vin.$339.Metal1 7.67177e-09f
Cred_1037 VDD vin.$567.Metal2 1.30681e-06f
Cred_1038 VDD vin.$571.Metal2 1.30681e-06f
Cred_1039 VDD vin.P29.GatPoly 0.00163573f
Cred_1040 VDD vin.P30.GatPoly 0.00854824f
Cred_1041 VDD vout.$1292.Metal3 0.00076299f
Cred_1042 VDD vout.$1358.Metal3 0.00076299f
Cred_1043 VDD vout.P10.nSD 1.20202e-05f
Cred_1044 VDD vout.P10.pSD 0.000397314f
Cred_1045 VDD.$100.Metal1 vin.P20.GatPoly 0.0220904f
Cred_1046 VDD.$100.Metal1 vin.P21.GatPoly 0.00215135f
Cred_1047 VDD.$100.Metal1 vin.P22.GatPoly 0.00119887f
Cred_1048 VDD.$100.Metal1 vin.P23.GatPoly 0.000830976f
Cred_1049 VDD.$1000.Metal1 vin.P39.GatPoly 0.0122976f
Cred_1050 VDD.$1000.Metal1 vout 0.00275301f
Cred_1051 VDD.$1000.Metal1 vout.P18.pSD 0.00262245f
Cred_1052 VDD.$1001.Metal1 vin.P39.GatPoly 0.0122945f
Cred_1053 VDD.$1001.Metal1 vout 0.00247317f
Cred_1054 VDD.$1001.Metal1 vout.P18.pSD 0.00236099f
Cred_1055 VDD.$1002.Metal1 vin 1.82951e-06f
Cred_1056 VDD.$1002.Metal1 vin.$105.GatPoly 1.0284e-05f
Cred_1057 VDD.$1002.Metal1 vin.$107.GatPoly 9.72127e-06f
Cred_1058 VDD.$1002.Metal1 vin.$115.GatPoly 1.71939e-05f
Cred_1059 VDD.$1002.Metal1 vin.$123.GatPoly 2.26107e-05f
Cred_1060 VDD.$1002.Metal1 vin.$127.GatPoly 2.28131e-05f
Cred_1061 VDD.$1002.Metal1 vin.$135.GatPoly 2.9284e-05f
Cred_1062 VDD.$1002.Metal1 vin.$137.GatPoly 2.821e-05f
Cred_1063 VDD.$1002.Metal1 vin.$145.GatPoly 4.71758e-05f
Cred_1064 VDD.$1002.Metal1 vin.$15.GatPoly 4.64893e-07f
Cred_1065 VDD.$1002.Metal1 vin.$153.GatPoly 6.36974e-05f
Cred_1066 VDD.$1002.Metal1 vin.$157.GatPoly 5.30548e-05f
Cred_1067 VDD.$1002.Metal1 vin.$163.GatPoly 7.41753e-05f
Cred_1068 VDD.$1002.Metal1 vin.$167.GatPoly 7.9059e-05f
Cred_1069 VDD.$1002.Metal1 vin.$17.GatPoly 4.25168e-07f
Cred_1070 VDD.$1002.Metal1 vin.$173.GatPoly 0.000101871f
Cred_1071 VDD.$1002.Metal1 vin.$179.GatPoly 0.000252973f
Cred_1072 VDD.$1002.Metal1 vin.$199.Metal1 7.60056e-06f
Cred_1073 VDD.$1002.Metal1 vin.$207.Metal1 3.37869e-06f
Cred_1074 VDD.$1002.Metal1 vin.$211.Metal1 3.78247e-06f
Cred_1075 VDD.$1002.Metal1 vin.$219.Metal1 6.14067e-06f
Cred_1076 VDD.$1002.Metal1 vin.$227.Metal1 6.94994e-06f
Cred_1077 VDD.$1002.Metal1 vin.$233.Metal1 5.62725e-06f
Cred_1078 VDD.$1002.Metal1 vin.$237.Metal1 4.56442e-06f
Cred_1079 VDD.$1002.Metal1 vin.$241.Metal1 7.36407e-06f
Cred_1080 VDD.$1002.Metal1 vin.$247.Metal1 8.44194e-06f
Cred_1081 VDD.$1002.Metal1 vin.$25.GatPoly 6.20767e-07f
Cred_1082 VDD.$1002.Metal1 vin.$251.Metal1 9.64868e-06f
Cred_1083 VDD.$1002.Metal1 vin.$259.Metal1 1.09087e-05f
Cred_1084 VDD.$1002.Metal1 vin.$263.Metal1 8.24177e-06f
Cred_1085 VDD.$1002.Metal1 vin.$265.Metal1 1.37448e-05f
Cred_1086 VDD.$1002.Metal1 vin.$27.GatPoly 6.16827e-07f
Cred_1087 VDD.$1002.Metal1 vin.$273.Metal1 1.51757e-05f
Cred_1088 VDD.$1002.Metal1 vin.$277.Metal1 1.15635e-05f
Cred_1089 VDD.$1002.Metal1 vin.$281.Metal1 1.3023e-05f
Cred_1090 VDD.$1002.Metal1 vin.$285.Metal1 2.05467e-05f
Cred_1091 VDD.$1002.Metal1 vin.$291.Metal1 2.47971e-05f
Cred_1092 VDD.$1002.Metal1 vin.$295.Metal1 2.69581e-05f
Cred_1093 VDD.$1002.Metal1 vin.$303.Metal1 3.01991e-05f
Cred_1094 VDD.$1002.Metal1 vin.$307.Metal1 3.61595e-05f
Cred_1095 VDD.$1002.Metal1 vin.$313.Metal1 3.93348e-05f
Cred_1096 VDD.$1002.Metal1 vin.$317.Metal1 2.92292e-05f
Cred_1097 VDD.$1002.Metal1 vin.$321.Metal1 3.30403e-05f
Cred_1098 VDD.$1002.Metal1 vin.$325.Metal1 5.24134e-05f
Cred_1099 VDD.$1002.Metal1 vin.$331.Metal1 5.98184e-05f
Cred_1100 VDD.$1002.Metal1 vin.$335.Metal1 4.48902e-05f
Cred_1101 VDD.$1002.Metal1 vin.$339.Metal1 5.09455e-05f
Cred_1102 VDD.$1002.Metal1 vin.$343.Metal1 5.29807e-05f
Cred_1103 VDD.$1002.Metal1 vin.$347.Metal1 8.93146e-05f
Cred_1104 VDD.$1002.Metal1 vin.$353.Metal1 0.000103202f
Cred_1105 VDD.$1002.Metal1 vin.$357.Metal1 0.000114967f
Cred_1106 VDD.$1002.Metal1 vin.$365.Metal1 0.000129219f
Cred_1107 VDD.$1002.Metal1 vin.$369.Metal1 0.00015562f
Cred_1108 VDD.$1002.Metal1 vin.$37.GatPoly 1.12123e-06f
Cred_1109 VDD.$1002.Metal1 vin.$375.Metal1 0.000163895f
Cred_1110 VDD.$1002.Metal1 vin.$379.Metal1 0.000131848f
Cred_1111 VDD.$1002.Metal1 vin.$383.Metal1 0.000137981f
Cred_1112 VDD.$1002.Metal1 vin.$387.Metal1 0.000224873f
Cred_1113 VDD.$1002.Metal1 vin.$393.Metal1 0.000256862f
Cred_1114 VDD.$1002.Metal1 vin.$397.Metal1 0.000193967f
Cred_1115 VDD.$1002.Metal1 vin.$401.Metal1 0.000324246f
Cred_1116 VDD.$1002.Metal1 vin.$409.Metal1 0.00035961f
Cred_1117 VDD.$1002.Metal1 vin.$413.Metal1 0.000413614f
Cred_1118 VDD.$1002.Metal1 vin.$419.Metal1 0.000458264f
Cred_1119 VDD.$1002.Metal1 vin.$423.Metal1 0.00035911f
Cred_1120 VDD.$1002.Metal1 vin.$427.Metal1 0.000545634f
Cred_1121 VDD.$1002.Metal1 vin.$43.GatPoly 1.37551e-06f
Cred_1122 VDD.$1002.Metal1 vin.$433.Metal1 0.00089635f
Cred_1123 VDD.$1002.Metal1 vin.$441.Metal1 0.00111868f
Cred_1124 VDD.$1002.Metal1 vin.$449.Metal1 0.00092771f
Cred_1125 VDD.$1002.Metal1 vin.$453.Metal1 0.000692649f
Cred_1126 VDD.$1002.Metal1 vin.$457.Metal1 0.00429992f
Cred_1127 VDD.$1002.Metal1 vin.$47.GatPoly 1.19489e-06f
Cred_1128 VDD.$1002.Metal1 vin.$476.Metal2 8.20788e-09f
Cred_1129 VDD.$1002.Metal1 vin.$478.Metal2 2.53326e-06f
Cred_1130 VDD.$1002.Metal1 vin.$482.Metal2 1.31101e-06f
Cred_1131 VDD.$1002.Metal1 vin.$486.Metal2 4.21633e-06f
Cred_1132 VDD.$1002.Metal1 vin.$489.Metal2 2.45727e-06f
Cred_1133 VDD.$1002.Metal1 vin.$493.Metal2 2.53977e-06f
Cred_1134 VDD.$1002.Metal1 vin.$495.Metal2 6.34072e-06f
Cred_1135 VDD.$1002.Metal1 vin.$500.Metal2 2.9948e-06f
Cred_1136 VDD.$1002.Metal1 vin.$504.Metal2 4.07823e-06f
Cred_1137 VDD.$1002.Metal1 vin.$506.Metal2 8.25938e-06f
Cred_1138 VDD.$1002.Metal1 vin.$509.Metal2 3.00667e-06f
Cred_1139 VDD.$1002.Metal1 vin.$513.Metal2 4.00158e-06f
Cred_1140 VDD.$1002.Metal1 vin.$515.Metal2 1.68449e-05f
Cred_1141 VDD.$1002.Metal1 vin.$518.Metal2 4.9901e-06f
Cred_1142 VDD.$1002.Metal1 vin.$520.Metal2 3.09876e-06f
Cred_1143 VDD.$1002.Metal1 vin.$523.Metal2 2.32651e-06f
Cred_1144 VDD.$1002.Metal1 vin.$527.Metal2 1.71243e-05f
Cred_1145 VDD.$1002.Metal1 vin.$528.Metal2 8.83486e-08f
Cred_1146 VDD.$1002.Metal1 vin.$53.GatPoly 1.75871e-06f
Cred_1147 VDD.$1002.Metal1 vin.$533.Metal2 1.18951e-05f
Cred_1148 VDD.$1002.Metal1 vin.$535.Metal2 2.86817e-05f
Cred_1149 VDD.$1002.Metal1 vin.$538.Metal2 9.29233e-06f
Cred_1150 VDD.$1002.Metal1 vin.$542.Metal2 1.00255e-05f
Cred_1151 VDD.$1002.Metal1 vin.$544.Metal2 3.12639e-05f
Cred_1152 VDD.$1002.Metal1 vin.$547.Metal2 1.90281e-05f
Cred_1153 VDD.$1002.Metal1 vin.$551.Metal2 2.02051e-05f
Cred_1154 VDD.$1002.Metal1 vin.$555.Metal2 5.15221e-05f
Cred_1155 VDD.$1002.Metal1 vin.$558.Metal2 2.47523e-05f
Cred_1156 VDD.$1002.Metal1 vin.$562.Metal2 2.77967e-05f
Cred_1157 VDD.$1002.Metal1 vin.$564.Metal2 6.70023e-05f
Cred_1158 VDD.$1002.Metal1 vin.$567.Metal2 3.0093e-05f
Cred_1159 VDD.$1002.Metal1 vin.$57.GatPoly 2.01261e-06f
Cred_1160 VDD.$1002.Metal1 vin.$571.Metal2 4.2623e-05f
Cred_1161 VDD.$1002.Metal1 vin.$573.Metal2 0.000101373f
Cred_1162 VDD.$1002.Metal1 vin.$578.Metal2 4.59124e-05f
Cred_1163 VDD.$1002.Metal1 vin.$582.Metal2 7.29088e-05f
Cred_1164 VDD.$1002.Metal1 vin.$584.Metal2 0.00012494f
Cred_1165 VDD.$1002.Metal1 vin.$587.Metal2 4.69421e-05f
Cred_1166 VDD.$1002.Metal1 vin.$591.Metal2 6.87681e-05f
Cred_1167 VDD.$1002.Metal1 vin.$593.Metal2 0.000271404f
Cred_1168 VDD.$1002.Metal1 vin.$596.Metal2 0.000109956f
Cred_1169 VDD.$1002.Metal1 vin.$599.Metal2 1.41297e-06f
Cred_1170 VDD.$1002.Metal1 vin.$603.Metal2 0.000274274f
Cred_1171 VDD.$1002.Metal1 vin.$604.Metal2 3.72083e-05f
Cred_1172 VDD.$1002.Metal1 vin.$609.Metal2 7.09344e-05f
Cred_1173 VDD.$1002.Metal1 vin.$611.Metal2 0.000163333f
Cred_1174 VDD.$1002.Metal1 vin.$613.Metal2 0.000458781f
Cred_1175 VDD.$1002.Metal1 vin.$616.Metal2 0.000149516f
Cred_1176 VDD.$1002.Metal1 vin.$620.Metal2 0.000171772f
Cred_1177 VDD.$1002.Metal1 vin.$622.Metal2 0.000529788f
Cred_1178 VDD.$1002.Metal1 vin.$625.Metal2 0.000283773f
Cred_1179 VDD.$1002.Metal1 vin.$629.Metal2 0.000333631f
Cred_1180 VDD.$1002.Metal1 vin.$633.Metal2 0.000817603f
Cred_1181 VDD.$1002.Metal1 vin.$636.Metal2 0.000373339f
Cred_1182 VDD.$1002.Metal1 vin.$640.Metal2 0.000480202f
Cred_1183 VDD.$1002.Metal1 vin.$642.Metal2 0.00161728f
Cred_1184 VDD.$1002.Metal1 vin.$645.Metal2 0.000442071f
Cred_1185 VDD.$1002.Metal1 vin.$648.Metal2 3.63404e-05f
Cred_1186 VDD.$1002.Metal1 vin.$649.Metal2 0.000606762f
Cred_1187 VDD.$1002.Metal1 vin.$65.GatPoly 3.11532e-06f
Cred_1188 VDD.$1002.Metal1 vin.$653.Metal2 0.000138949f
Cred_1189 VDD.$1002.Metal1 vin.$654.Metal2 0.00167084f
Cred_1190 VDD.$1002.Metal1 vin.$7.GatPoly 3.86068e-07f
Cred_1191 VDD.$1002.Metal1 vin.$73.GatPoly 3.93593e-06f
Cred_1192 VDD.$1002.Metal1 vin.$77.GatPoly 3.25937e-06f
Cred_1193 VDD.$1002.Metal1 vin.$83.GatPoly 4.84412e-06f
Cred_1194 VDD.$1002.Metal1 vin.$87.GatPoly 4.43965e-06f
Cred_1195 VDD.$1002.Metal1 vin.$9.GatPoly 3.46044e-07f
Cred_1196 VDD.$1002.Metal1 vin.$93.GatPoly 7.71484e-06f
Cred_1197 VDD.$1002.Metal1 vin.$97.GatPoly 8.09932e-06f
Cred_1198 VDD.$1002.Metal1 vin.P20.GatPoly 9.68343e-07f
Cred_1199 VDD.$1002.Metal1 vin.P24.GatPoly 1.08704e-07f
Cred_1200 VDD.$1002.Metal1 vin.P27.GatPoly 3.02417e-07f
Cred_1201 VDD.$1002.Metal1 vin.P32.GatPoly 1.71416e-06f
Cred_1202 VDD.$1002.Metal1 vin.P35.GatPoly 4.86409e-06f
Cred_1203 VDD.$1002.Metal1 vin.P39.GatPoly 0.0132149f
Cred_1204 VDD.$1002.Metal1 vout 0.00387321f
Cred_1205 VDD.$1002.Metal1 vout.$1226.Metal3 1.23665e-05f
Cred_1206 VDD.$1002.Metal1 vout.$1292.Metal3 4.44775e-05f
Cred_1207 VDD.$1002.Metal1 vout.$1358.Metal3 0.000184791f
Cred_1208 VDD.$1002.Metal1 vout.$1424.Metal3 0.000403596f
Cred_1209 VDD.$1002.Metal1 vout.P0.nSD 5.64303e-08f
Cred_1210 VDD.$1002.Metal1 vout.P0.pSD 3.20105e-07f
Cred_1211 VDD.$1002.Metal1 vout.P10.nSD 3.17658e-07f
Cred_1212 VDD.$1002.Metal1 vout.P10.pSD 1.72046e-06f
Cred_1213 VDD.$1002.Metal1 vout.P14.nSD 1.26403e-06f
Cred_1214 VDD.$1002.Metal1 vout.P14.pSD 6.84605e-06f
Cred_1215 VDD.$1002.Metal1 vout.P18.pSD 0.00253196f
Cred_1216 VDD.$1002.Metal1 vout.P2.nSD 4.38091e-08f
Cred_1217 VDD.$1002.Metal1 vout.P2.pSD 2.39427e-07f
Cred_1218 VDD.$1002.Metal1 vout.P6.nSD 7.36247e-08f
Cred_1219 VDD.$1002.Metal1 vout.P6.pSD 4.02376e-07f
Cred_1220 VDD.$1002.Metal1 VSS.$1066.Metal2 0.000116677f
Cred_1221 VDD.$1002.Metal1 VSS.$18.Metal1 4.94916e-06f
Cred_1222 VDD.$1002.Metal1 VSS.$40.Metal1 2.06904e-06f
Cred_1223 VDD.$1002.Metal1 VSS.$509.Metal1 0.000215259f
Cred_1224 VDD.$1002.Metal1 VSS.$551.Metal1 0.00198899f
Cred_1225 VDD.$1002.Metal1 VSS.$564.Metal2 2.93519e-08f
Cred_1226 VDD.$1002.Metal1 VSS.P0.nSD 1.00375e-09f
Cred_1227 VDD.$1002.Metal1 VSS.P0.pSD 0.00614836f
Cred_1228 VDD.$1002.Metal1 VSS.P1.nSD 1.00375e-09f
Cred_1229 VDD.$1002.Metal1 VSS.P21.nSD 1.42704e-06f
Cred_1230 VDD.$1002.Metal1 VSS.P23.nSD 1.42704e-06f
Cred_1231 VDD.$1003.Metal1 vin 2.04995e-06f
Cred_1232 VDD.$1003.Metal1 vin.$105.GatPoly 1.15232e-05f
Cred_1233 VDD.$1003.Metal1 vin.$107.GatPoly 1.08926e-05f
Cred_1234 VDD.$1003.Metal1 vin.$115.GatPoly 1.92656e-05f
Cred_1235 VDD.$1003.Metal1 vin.$123.GatPoly 2.53352e-05f
Cred_1236 VDD.$1003.Metal1 vin.$127.GatPoly 2.55619e-05f
Cred_1237 VDD.$1003.Metal1 vin.$135.GatPoly 3.28126e-05f
Cred_1238 VDD.$1003.Metal1 vin.$137.GatPoly 3.16091e-05f
Cred_1239 VDD.$1003.Metal1 vin.$145.GatPoly 5.28602e-05f
Cred_1240 VDD.$1003.Metal1 vin.$15.GatPoly 5.20909e-07f
Cred_1241 VDD.$1003.Metal1 vin.$153.GatPoly 7.13725e-05f
Cred_1242 VDD.$1003.Metal1 vin.$157.GatPoly 5.94476e-05f
Cred_1243 VDD.$1003.Metal1 vin.$163.GatPoly 8.31129e-05f
Cred_1244 VDD.$1003.Metal1 vin.$167.GatPoly 8.85851e-05f
Cred_1245 VDD.$1003.Metal1 vin.$17.GatPoly 4.76398e-07f
Cred_1246 VDD.$1003.Metal1 vin.$173.GatPoly 0.000114146f
Cred_1247 VDD.$1003.Metal1 vin.$179.GatPoly 0.000283455f
Cred_1248 VDD.$1003.Metal1 vin.$199.Metal1 8.51638e-06f
Cred_1249 VDD.$1003.Metal1 vin.$207.Metal1 3.7858e-06f
Cred_1250 VDD.$1003.Metal1 vin.$211.Metal1 4.23823e-06f
Cred_1251 VDD.$1003.Metal1 vin.$219.Metal1 6.88058e-06f
Cred_1252 VDD.$1003.Metal1 vin.$227.Metal1 7.78736e-06f
Cred_1253 VDD.$1003.Metal1 vin.$233.Metal1 6.3053e-06f
Cred_1254 VDD.$1003.Metal1 vin.$237.Metal1 5.1144e-06f
Cred_1255 VDD.$1003.Metal1 vin.$241.Metal1 8.25139e-06f
Cred_1256 VDD.$1003.Metal1 vin.$247.Metal1 9.45914e-06f
Cred_1257 VDD.$1003.Metal1 vin.$25.GatPoly 6.95565e-07f
Cred_1258 VDD.$1003.Metal1 vin.$251.Metal1 1.08113e-05f
Cred_1259 VDD.$1003.Metal1 vin.$259.Metal1 1.22232e-05f
Cred_1260 VDD.$1003.Metal1 vin.$263.Metal1 9.23485e-06f
Cred_1261 VDD.$1003.Metal1 vin.$265.Metal1 1.5401e-05f
Cred_1262 VDD.$1003.Metal1 vin.$27.GatPoly 6.91151e-07f
Cred_1263 VDD.$1003.Metal1 vin.$273.Metal1 1.70042e-05f
Cred_1264 VDD.$1003.Metal1 vin.$277.Metal1 1.29568e-05f
Cred_1265 VDD.$1003.Metal1 vin.$281.Metal1 1.45922e-05f
Cred_1266 VDD.$1003.Metal1 vin.$285.Metal1 2.30225e-05f
Cred_1267 VDD.$1003.Metal1 vin.$291.Metal1 2.7785e-05f
Cred_1268 VDD.$1003.Metal1 vin.$295.Metal1 3.02063e-05f
Cred_1269 VDD.$1003.Metal1 vin.$303.Metal1 3.38379e-05f
Cred_1270 VDD.$1003.Metal1 vin.$307.Metal1 4.05164e-05f
Cred_1271 VDD.$1003.Metal1 vin.$313.Metal1 4.40744e-05f
Cred_1272 VDD.$1003.Metal1 vin.$317.Metal1 3.27511e-05f
Cred_1273 VDD.$1003.Metal1 vin.$321.Metal1 3.70214e-05f
Cred_1274 VDD.$1003.Metal1 vin.$325.Metal1 5.87289e-05f
Cred_1275 VDD.$1003.Metal1 vin.$331.Metal1 6.70261e-05f
Cred_1276 VDD.$1003.Metal1 vin.$335.Metal1 5.02992e-05f
Cred_1277 VDD.$1003.Metal1 vin.$339.Metal1 5.70841e-05f
Cred_1278 VDD.$1003.Metal1 vin.$343.Metal1 5.93645e-05f
Cred_1279 VDD.$1003.Metal1 vin.$347.Metal1 0.000100076f
Cred_1280 VDD.$1003.Metal1 vin.$353.Metal1 0.000115637f
Cred_1281 VDD.$1003.Metal1 vin.$357.Metal1 0.00012882f
Cred_1282 VDD.$1003.Metal1 vin.$365.Metal1 0.000144789f
Cred_1283 VDD.$1003.Metal1 vin.$369.Metal1 0.000174371f
Cred_1284 VDD.$1003.Metal1 vin.$37.GatPoly 1.25633e-06f
Cred_1285 VDD.$1003.Metal1 vin.$375.Metal1 0.000183644f
Cred_1286 VDD.$1003.Metal1 vin.$379.Metal1 0.000147735f
Cred_1287 VDD.$1003.Metal1 vin.$383.Metal1 0.000154607f
Cred_1288 VDD.$1003.Metal1 vin.$387.Metal1 0.000251969f
Cred_1289 VDD.$1003.Metal1 vin.$393.Metal1 0.000287812f
Cred_1290 VDD.$1003.Metal1 vin.$397.Metal1 0.000217339f
Cred_1291 VDD.$1003.Metal1 vin.$401.Metal1 0.000363315f
Cred_1292 VDD.$1003.Metal1 vin.$409.Metal1 0.000402941f
Cred_1293 VDD.$1003.Metal1 vin.$413.Metal1 0.000463452f
Cred_1294 VDD.$1003.Metal1 vin.$419.Metal1 0.000513482f
Cred_1295 VDD.$1003.Metal1 vin.$423.Metal1 0.00040238f
Cred_1296 VDD.$1003.Metal1 vin.$427.Metal1 0.000611379f
Cred_1297 VDD.$1003.Metal1 vin.$43.GatPoly 1.54124e-06f
Cred_1298 VDD.$1003.Metal1 vin.$433.Metal1 0.00100435f
Cred_1299 VDD.$1003.Metal1 vin.$441.Metal1 0.00125348f
Cred_1300 VDD.$1003.Metal1 vin.$449.Metal1 0.00103949f
Cred_1301 VDD.$1003.Metal1 vin.$453.Metal1 0.000776109f
Cred_1302 VDD.$1003.Metal1 vin.$457.Metal1 0.00481804f
Cred_1303 VDD.$1003.Metal1 vin.$47.GatPoly 1.33887e-06f
Cred_1304 VDD.$1003.Metal1 vin.$476.Metal2 9.19688e-09f
Cred_1305 VDD.$1003.Metal1 vin.$478.Metal2 2.8385e-06f
Cred_1306 VDD.$1003.Metal1 vin.$482.Metal2 1.46898e-06f
Cred_1307 VDD.$1003.Metal1 vin.$486.Metal2 4.72437e-06f
Cred_1308 VDD.$1003.Metal1 vin.$489.Metal2 2.75336e-06f
Cred_1309 VDD.$1003.Metal1 vin.$493.Metal2 2.8458e-06f
Cred_1310 VDD.$1003.Metal1 vin.$495.Metal2 7.10473e-06f
Cred_1311 VDD.$1003.Metal1 vin.$500.Metal2 3.35565e-06f
Cred_1312 VDD.$1003.Metal1 vin.$504.Metal2 4.56963e-06f
Cred_1313 VDD.$1003.Metal1 vin.$506.Metal2 9.25458e-06f
Cred_1314 VDD.$1003.Metal1 vin.$509.Metal2 3.36895e-06f
Cred_1315 VDD.$1003.Metal1 vin.$513.Metal2 4.48374e-06f
Cred_1316 VDD.$1003.Metal1 vin.$515.Metal2 1.88746e-05f
Cred_1317 VDD.$1003.Metal1 vin.$518.Metal2 5.59137e-06f
Cred_1318 VDD.$1003.Metal1 vin.$520.Metal2 3.47214e-06f
Cred_1319 VDD.$1003.Metal1 vin.$523.Metal2 2.60684e-06f
Cred_1320 VDD.$1003.Metal1 vin.$527.Metal2 1.91876e-05f
Cred_1321 VDD.$1003.Metal1 vin.$528.Metal2 9.8994e-08f
Cred_1322 VDD.$1003.Metal1 vin.$53.GatPoly 1.97063e-06f
Cred_1323 VDD.$1003.Metal1 vin.$533.Metal2 1.33284e-05f
Cred_1324 VDD.$1003.Metal1 vin.$535.Metal2 3.21376e-05f
Cred_1325 VDD.$1003.Metal1 vin.$538.Metal2 1.0412e-05f
Cred_1326 VDD.$1003.Metal1 vin.$542.Metal2 1.12335e-05f
Cred_1327 VDD.$1003.Metal1 vin.$544.Metal2 3.5031e-05f
Cred_1328 VDD.$1003.Metal1 vin.$547.Metal2 2.13209e-05f
Cred_1329 VDD.$1003.Metal1 vin.$551.Metal2 2.26397e-05f
Cred_1330 VDD.$1003.Metal1 vin.$555.Metal2 5.77302e-05f
Cred_1331 VDD.$1003.Metal1 vin.$558.Metal2 2.77348e-05f
Cred_1332 VDD.$1003.Metal1 vin.$562.Metal2 3.1146e-05f
Cred_1333 VDD.$1003.Metal1 vin.$564.Metal2 7.50757e-05f
Cred_1334 VDD.$1003.Metal1 vin.$567.Metal2 3.3719e-05f
Cred_1335 VDD.$1003.Metal1 vin.$57.GatPoly 2.25512e-06f
Cred_1336 VDD.$1003.Metal1 vin.$571.Metal2 4.77588e-05f
Cred_1337 VDD.$1003.Metal1 vin.$573.Metal2 0.000113588f
Cred_1338 VDD.$1003.Metal1 vin.$578.Metal2 5.14445e-05f
Cred_1339 VDD.$1003.Metal1 vin.$582.Metal2 8.16938e-05f
Cred_1340 VDD.$1003.Metal1 vin.$584.Metal2 0.000139994f
Cred_1341 VDD.$1003.Metal1 vin.$587.Metal2 5.25983e-05f
Cred_1342 VDD.$1003.Metal1 vin.$591.Metal2 7.70543e-05f
Cred_1343 VDD.$1003.Metal1 vin.$593.Metal2 0.000304107f
Cred_1344 VDD.$1003.Metal1 vin.$596.Metal2 0.000123205f
Cred_1345 VDD.$1003.Metal1 vin.$599.Metal2 1.58323e-06f
Cred_1346 VDD.$1003.Metal1 vin.$603.Metal2 0.000307322f
Cred_1347 VDD.$1003.Metal1 vin.$604.Metal2 4.16917e-05f
Cred_1348 VDD.$1003.Metal1 vin.$609.Metal2 7.94816e-05f
Cred_1349 VDD.$1003.Metal1 vin.$611.Metal2 0.000183014f
Cred_1350 VDD.$1003.Metal1 vin.$613.Metal2 0.000514061f
Cred_1351 VDD.$1003.Metal1 vin.$616.Metal2 0.000167532f
Cred_1352 VDD.$1003.Metal1 vin.$620.Metal2 0.00019247f
Cred_1353 VDD.$1003.Metal1 vin.$622.Metal2 0.000593624f
Cred_1354 VDD.$1003.Metal1 vin.$625.Metal2 0.000317966f
Cred_1355 VDD.$1003.Metal1 vin.$629.Metal2 0.000373832f
Cred_1356 VDD.$1003.Metal1 vin.$633.Metal2 0.000916118f
Cred_1357 VDD.$1003.Metal1 vin.$636.Metal2 0.000418324f
Cred_1358 VDD.$1003.Metal1 vin.$640.Metal2 0.000538063f
Cred_1359 VDD.$1003.Metal1 vin.$642.Metal2 0.00181215f
Cred_1360 VDD.$1003.Metal1 vin.$645.Metal2 0.000495338f
Cred_1361 VDD.$1003.Metal1 vin.$648.Metal2 4.07192e-05f
Cred_1362 VDD.$1003.Metal1 vin.$649.Metal2 0.000679873f
Cred_1363 VDD.$1003.Metal1 vin.$65.GatPoly 3.49069e-06f
Cred_1364 VDD.$1003.Metal1 vin.$653.Metal2 0.000155691f
Cred_1365 VDD.$1003.Metal1 vin.$654.Metal2 0.00187217f
Cred_1366 VDD.$1003.Metal1 vin.$7.GatPoly 4.32587e-07f
Cred_1367 VDD.$1003.Metal1 vin.$73.GatPoly 4.41019e-06f
Cred_1368 VDD.$1003.Metal1 vin.$77.GatPoly 3.65211e-06f
Cred_1369 VDD.$1003.Metal1 vin.$83.GatPoly 5.42781e-06f
Cred_1370 VDD.$1003.Metal1 vin.$87.GatPoly 4.9746e-06f
Cred_1371 VDD.$1003.Metal1 vin.$9.GatPoly 3.8774e-07f
Cred_1372 VDD.$1003.Metal1 vin.$93.GatPoly 8.64443e-06f
Cred_1373 VDD.$1003.Metal1 vin.$97.GatPoly 9.07524e-06f
Cred_1374 VDD.$1003.Metal1 vin.P20.GatPoly 1.08502e-06f
Cred_1375 VDD.$1003.Metal1 vin.P24.GatPoly 1.21802e-07f
Cred_1376 VDD.$1003.Metal1 vin.P27.GatPoly 3.38856e-07f
Cred_1377 VDD.$1003.Metal1 vin.P32.GatPoly 1.9207e-06f
Cred_1378 VDD.$1003.Metal1 vin.P35.GatPoly 5.45018e-06f
Cred_1379 VDD.$1003.Metal1 vin.P39.GatPoly 0.0133044f
Cred_1380 VDD.$1003.Metal1 vout 0.0041614f
Cred_1381 VDD.$1003.Metal1 vout.$1226.Metal3 1.38566e-05f
Cred_1382 VDD.$1003.Metal1 vout.$1292.Metal3 4.98367e-05f
Cred_1383 VDD.$1003.Metal1 vout.$1358.Metal3 0.000207058f
Cred_1384 VDD.$1003.Metal1 vout.$1424.Metal3 0.000452227f
Cred_1385 VDD.$1003.Metal1 vout.P0.nSD 6.32297e-08f
Cred_1386 VDD.$1003.Metal1 vout.P0.pSD 3.58676e-07f
Cred_1387 VDD.$1003.Metal1 vout.P10.nSD 3.55934e-07f
Cred_1388 VDD.$1003.Metal1 vout.P10.pSD 1.92776e-06f
Cred_1389 VDD.$1003.Metal1 vout.P14.nSD 1.41633e-06f
Cred_1390 VDD.$1003.Metal1 vout.P14.pSD 7.67095e-06f
Cred_1391 VDD.$1003.Metal1 vout.P18.pSD 0.00268386f
Cred_1392 VDD.$1003.Metal1 vout.P2.nSD 4.90878e-08f
Cred_1393 VDD.$1003.Metal1 vout.P2.pSD 2.68276e-07f
Cred_1394 VDD.$1003.Metal1 vout.P6.nSD 8.2496e-08f
Cred_1395 VDD.$1003.Metal1 vout.P6.pSD 4.5086e-07f
Cred_1396 VDD.$1003.Metal1 VSS.$1066.Metal2 0.000130735f
Cred_1397 VDD.$1003.Metal1 VSS.$18.Metal1 5.54551e-06f
Cred_1398 VDD.$1003.Metal1 VSS.$40.Metal1 2.31834e-06f
Cred_1399 VDD.$1003.Metal1 VSS.$509.Metal1 0.000241196f
Cred_1400 VDD.$1003.Metal1 VSS.$551.Metal1 0.00222865f
Cred_1401 VDD.$1003.Metal1 VSS.$564.Metal2 3.28886e-08f
Cred_1402 VDD.$1003.Metal1 VSS.P0.nSD 1.1247e-09f
Cred_1403 VDD.$1003.Metal1 VSS.P0.pSD 0.0068892f
Cred_1404 VDD.$1003.Metal1 VSS.P1.nSD 1.1247e-09f
Cred_1405 VDD.$1003.Metal1 VSS.P21.nSD 1.59899e-06f
Cred_1406 VDD.$1003.Metal1 VSS.P23.nSD 1.59899e-06f
Cred_1407 VDD.$1004.Metal1 vin.P39.GatPoly 0.0122905f
Cred_1408 VDD.$1004.Metal1 vout 0.00275881f
Cred_1409 VDD.$1004.Metal1 vout.P18.pSD 0.00262968f
Cred_1410 VDD.$1005.Metal1 vin.P39.GatPoly 0.012297f
Cred_1411 VDD.$1005.Metal1 vout 0.00262855f
Cred_1412 VDD.$1005.Metal1 vout.P18.pSD 0.00249223f
Cred_1413 VDD.$1006.Metal1 vin.P39.GatPoly 0.0123799f
Cred_1414 VDD.$1006.Metal1 vout 0.00278276f
Cred_1415 VDD.$1006.Metal1 vout.P18.pSD 0.00264425f
Cred_1416 VDD.$1007.Metal1 vin.P39.GatPoly 0.0177711f
Cred_1417 VDD.$1007.Metal1 vout 0.00267472f
Cred_1418 VDD.$1007.Metal1 vout.P18.pSD 0.00254689f
Cred_1419 VDD.$1056.Metal2 vin.P20.GatPoly 0.000396902f
Cred_1420 VDD.$1065.Metal2 vin.$199.Metal1 0.0101754f
Cred_1421 VDD.$1065.Metal2 vin.$478.Metal2 0.000659247f
Cred_1422 VDD.$1065.Metal2 vin.$7.GatPoly 0.00215733f
Cred_1423 VDD.$1065.Metal2 vin.P20.GatPoly 0.0144536f
Cred_1424 VDD.$1065.Metal2 vout.$1226.Metal3 0.0623076f
Cred_1425 VDD.$1065.Metal2 vout.P0.nSD 0.00185532f
Cred_1426 VDD.$1065.Metal2 vout.P0.pSD 0.0312572f
Cred_1427 VDD.$1065.Metal2 vout.P2.nSD 0.000981598f
Cred_1428 VDD.$1065.Metal2 vout.P2.pSD 0.00536466f
Cred_1429 VDD.$1065.Metal2 VSS.$1106.Metal3 0.00436518f
Cred_1430 VDD.$1065.Metal2 VSS.$18.Metal1 0.000486239f
Cred_1431 VDD.$1065.Metal2 VSS.$40.Metal1 0.00160803f
Cred_1432 VDD.$1065.Metal2 VSS.$44.Metal1 2.62172e-06f
Cred_1433 VDD.$1065.Metal2 VSS.$551.Metal1 1.65531e-07f
Cred_1434 VDD.$1065.Metal2 VSS.$564.Metal2 0.0245906f
Cred_1435 VDD.$1065.Metal2 VSS.$590.Metal2 0.000130514f
Cred_1436 VDD.$1065.Metal2 VSS.P0.nSD 5.99783e-06f
Cred_1437 VDD.$1065.Metal2 VSS.P0.pSD 0.000886912f
Cred_1438 VDD.$1065.Metal2 VSS.P1.nSD 5.99783e-06f
Cred_1439 VDD.$1068.Metal2 vin.P20.GatPoly 0.0120011f
Cred_1440 VDD.$1068.Metal2 vout.$1226.Metal3 0.0279524f
Cred_1441 VDD.$1068.Metal2 vout.P0.nSD 0.000832335f
Cred_1442 VDD.$1068.Metal2 vout.P0.pSD 0.0155183f
Cred_1443 VDD.$1068.Metal2 vout.P2.nSD 0.000440364f
Cred_1444 VDD.$1068.Metal2 vout.P2.pSD 0.00240669f
Cred_1445 VDD.$1070.Metal2 vin.P20.GatPoly 0.00960931f
Cred_1446 VDD.$1070.Metal2 vout.$1226.Metal3 0.0219293f
Cred_1447 VDD.$1070.Metal2 vout.P0.nSD 0.000652985f
Cred_1448 VDD.$1070.Metal2 vout.P0.pSD 0.0127435f
Cred_1449 VDD.$1070.Metal2 vout.P2.nSD 0.000345475f
Cred_1450 VDD.$1070.Metal2 vout.P2.pSD 0.0018881f
Cred_1451 VDD.$1072.Metal2 vin.P20.GatPoly 0.00960226f
Cred_1452 VDD.$1072.Metal2 vout.$1226.Metal3 0.0217405f
Cred_1453 VDD.$1072.Metal2 vout.P0.nSD 0.000647364f
Cred_1454 VDD.$1072.Metal2 vout.P0.pSD 0.0129539f
Cred_1455 VDD.$1072.Metal2 vout.P2.nSD 0.000342501f
Cred_1456 VDD.$1072.Metal2 vout.P2.pSD 0.00187185f
Cred_1457 VDD.$1074.Metal2 vin.P20.GatPoly 0.00721022f
Cred_1458 VDD.$1074.Metal2 vout.$1226.Metal3 0.0162406f
Cred_1459 VDD.$1074.Metal2 vout.P0.nSD 0.000483595f
Cred_1460 VDD.$1074.Metal2 vout.P0.pSD 0.00980199f
Cred_1461 VDD.$1074.Metal2 vout.P2.nSD 0.000255856f
Cred_1462 VDD.$1074.Metal2 vout.P2.pSD 0.00139831f
Cred_1463 VDD.$1075.Metal2 vin.P20.GatPoly 0.00828778f
Cred_1464 VDD.$1075.Metal2 vout.$1226.Metal3 0.0142902f
Cred_1465 VDD.$1075.Metal2 vout.P0.nSD 0.000425516f
Cred_1466 VDD.$1075.Metal2 vout.P0.pSD 0.00865899f
Cred_1467 VDD.$1075.Metal2 vout.P2.nSD 0.000225128f
Cred_1468 VDD.$1075.Metal2 vout.P2.pSD 0.00123038f
Cred_1469 VDD.$1110.Metal2 vin.P20.GatPoly 0.00102962f
Cred_1470 VDD.$1137.Metal2 vin.$199.Metal1 1.33059e-05f
Cred_1471 VDD.$1137.Metal2 vin.$478.Metal2 0.000536764f
Cred_1472 VDD.$1137.Metal2 vin.$7.GatPoly 1.88971e-07f
Cred_1473 VDD.$1137.Metal2 vin.P20.GatPoly 0.01706f
Cred_1474 VDD.$1137.Metal2 vout.$1226.Metal3 0.000814103f
Cred_1475 VDD.$1137.Metal2 vout.P0.nSD 2.42414e-05f
Cred_1476 VDD.$1137.Metal2 vout.P0.pSD 0.000331363f
Cred_1477 VDD.$1137.Metal2 vout.P2.nSD 1.28254e-05f
Cred_1478 VDD.$1137.Metal2 vout.P2.pSD 7.00939e-05f
Cred_1479 VDD.$1149.Metal2 vin.$199.Metal1 1.33059e-05f
Cred_1480 VDD.$1149.Metal2 vin.$478.Metal2 0.000536764f
Cred_1481 VDD.$1149.Metal2 vin.$7.GatPoly 1.88971e-07f
Cred_1482 VDD.$1149.Metal2 vin.P20.GatPoly 0.00498114f
Cred_1483 VDD.$1149.Metal2 vin.P21.GatPoly 0.00323115f
Cred_1484 VDD.$1149.Metal2 vout.$1226.Metal3 0.00717779f
Cred_1485 VDD.$1149.Metal2 vout.P0.nSD 0.000213732f
Cred_1486 VDD.$1149.Metal2 vout.P0.pSD 0.00503842f
Cred_1487 VDD.$1149.Metal2 vout.P2.nSD 0.000113079f
Cred_1488 VDD.$1149.Metal2 vout.P2.pSD 0.000618005f
Cred_1489 VDD.$1161.Metal2 vin.$482.Metal2 0.0011665f
Cred_1490 VDD.$1161.Metal2 vin.P21.GatPoly 0.0138817f
Cred_1491 VDD.$1161.Metal2 vin.P22.GatPoly 3.43903e-06f
Cred_1492 VDD.$1161.Metal2 vout.$1226.Metal3 0.00184345f
Cred_1493 VDD.$1161.Metal2 vout.P0.nSD 5.48922e-05f
Cred_1494 VDD.$1161.Metal2 vout.P0.pSD 0.0011431f
Cred_1495 VDD.$1161.Metal2 vout.P2.nSD 2.90419e-05f
Cred_1496 VDD.$1161.Metal2 vout.P2.pSD 0.000158721f
Cred_1497 VDD.$1167.Metal2 vin.$15.GatPoly 0.0115885f
Cred_1498 VDD.$1167.Metal2 vin.$17.GatPoly 0.00244759f
Cred_1499 VDD.$1167.Metal2 vin.$207.Metal1 0.00263018f
Cred_1500 VDD.$1167.Metal2 vin.$211.Metal1 0.00587731f
Cred_1501 VDD.$1167.Metal2 vin.$219.Metal1 0.000911526f
Cred_1502 VDD.$1167.Metal2 vin.$482.Metal2 0.00320935f
Cred_1503 VDD.$1167.Metal2 vin.$486.Metal2 0.00185341f
Cred_1504 VDD.$1167.Metal2 vin.$489.Metal2 0.0113253f
Cred_1505 VDD.$1167.Metal2 vin.$493.Metal2 2.23338e-06f
Cred_1506 VDD.$1167.Metal2 vin.$9.GatPoly 0.010574f
Cred_1507 VDD.$1167.Metal2 vin.P20.GatPoly 0.000550551f
Cred_1508 VDD.$1167.Metal2 vin.P21.GatPoly 0.041504f
Cred_1509 VDD.$1167.Metal2 vin.P22.GatPoly 0.039235f
Cred_1510 VDD.$1167.Metal2 vin.P23.GatPoly 0.000499317f
Cred_1511 VDD.$1167.Metal2 vout.$1226.Metal3 0.101764f
Cred_1512 VDD.$1167.Metal2 vout.P0.nSD 0.00224917f
Cred_1513 VDD.$1167.Metal2 vout.P0.pSD 0.0390306f
Cred_1514 VDD.$1167.Metal2 vout.P2.nSD 0.0016032f
Cred_1515 VDD.$1167.Metal2 vout.P2.pSD 0.0320284f
Cred_1516 VDD.$1188.Metal2 vin.$15.GatPoly 0.0155617f
Cred_1517 VDD.$1188.Metal2 vin.$17.GatPoly 0.00328677f
Cred_1518 VDD.$1188.Metal2 vin.$207.Metal1 0.00353196f
Cred_1519 VDD.$1188.Metal2 vin.$211.Metal1 0.00789304f
Cred_1520 VDD.$1188.Metal2 vin.$219.Metal1 0.00122868f
Cred_1521 VDD.$1188.Metal2 vin.$482.Metal2 0.0043097f
Cred_1522 VDD.$1188.Metal2 vin.$486.Metal2 0.00248886f
Cred_1523 VDD.$1188.Metal2 vin.$489.Metal2 0.015487f
Cred_1524 VDD.$1188.Metal2 vin.$493.Metal2 0.00028168f
Cred_1525 VDD.$1188.Metal2 vin.$9.GatPoly 0.0141994f
Cred_1526 VDD.$1188.Metal2 vin.P20.GatPoly 0.000739311f
Cred_1527 VDD.$1188.Metal2 vin.P21.GatPoly 0.0529754f
Cred_1528 VDD.$1188.Metal2 vin.P22.GatPoly 0.0577649f
Cred_1529 VDD.$1188.Metal2 vin.P23.GatPoly 0.000670511f
Cred_1530 VDD.$1188.Metal2 vout.$1226.Metal3 0.136655f
Cred_1531 VDD.$1188.Metal2 vout.P0.nSD 0.00302032f
Cred_1532 VDD.$1188.Metal2 vout.P0.pSD 0.0524125f
Cred_1533 VDD.$1188.Metal2 vout.P2.nSD 0.00215287f
Cred_1534 VDD.$1188.Metal2 vout.P2.pSD 0.0430095f
Cred_1535 VDD.$1214.Metal2 vin.$17.GatPoly 7.79259e-09f
Cred_1536 VDD.$1214.Metal2 vin.$211.Metal1 6.53122e-07f
Cred_1537 VDD.$1214.Metal2 vin.$219.Metal1 4.62915e-06f
Cred_1538 VDD.$1214.Metal2 vin.$489.Metal2 0.000278688f
Cred_1539 VDD.$1214.Metal2 vin.$493.Metal2 0.000278681f
Cred_1540 VDD.$1214.Metal2 vin.P22.GatPoly 0.0132971f
Cred_1541 VDD.$1214.Metal2 vin.P23.GatPoly 7.61497e-06f
Cred_1542 VDD.$1214.Metal2 vout.$1226.Metal3 0.00348042f
Cred_1543 VDD.$1214.Metal2 vout.P0.nSD 5.04019e-05f
Cred_1544 VDD.$1214.Metal2 vout.P0.pSD 0.000267827f
Cred_1545 VDD.$1214.Metal2 vout.P2.nSD 5.48307e-05f
Cred_1546 VDD.$1214.Metal2 vout.P2.pSD 0.00147749f
Cred_1547 VDD.$1220.Metal2 vin.P22.GatPoly 1.05776e-05f
Cred_1548 VDD.$1220.Metal2 vin.P23.GatPoly 5.54996e-05f
Cred_1549 VDD.$1220.Metal2 vout.$1226.Metal3 0.00512828f
Cred_1550 VDD.$1220.Metal2 vout.P0.nSD 7.42655e-05f
Cred_1551 VDD.$1220.Metal2 vout.P0.pSD 0.000394635f
Cred_1552 VDD.$1220.Metal2 vout.P2.nSD 8.07912e-05f
Cred_1553 VDD.$1220.Metal2 vout.P2.pSD 0.00311036f
Cred_1554 VDD.$1226.Metal2 vin.$233.Metal1 2.06403e-06f
Cred_1555 VDD.$1226.Metal2 vin.$237.Metal1 2.77577e-06f
Cred_1556 VDD.$1226.Metal2 vin.$500.Metal2 0.000254753f
Cred_1557 VDD.$1226.Metal2 vin.$504.Metal2 0.000254753f
Cred_1558 VDD.$1226.Metal2 vin.P22.GatPoly 5.2677e-06f
Cred_1559 VDD.$1226.Metal2 vin.P23.GatPoly 0.0142741f
Cred_1560 VDD.$1226.Metal2 vout.$1226.Metal3 0.00289923f
Cred_1561 VDD.$1226.Metal2 vout.P0.nSD 4.19854e-05f
Cred_1562 VDD.$1226.Metal2 vout.P0.pSD 0.000223103f
Cred_1563 VDD.$1226.Metal2 vout.P2.nSD 4.56746e-05f
Cred_1564 VDD.$1226.Metal2 vout.P2.pSD 0.00112998f
Cred_1565 VDD.$1253.Metal2 vin.$233.Metal1 2.06403e-06f
Cred_1566 VDD.$1253.Metal2 vin.$237.Metal1 0.00220492f
Cred_1567 VDD.$1253.Metal2 vin.$241.Metal1 0.00954827f
Cred_1568 VDD.$1253.Metal2 vin.$247.Metal1 0.0053756f
Cred_1569 VDD.$1253.Metal2 vin.$25.GatPoly 0.0199595f
Cred_1570 VDD.$1253.Metal2 vin.$251.Metal1 0.00196334f
Cred_1571 VDD.$1253.Metal2 vin.$37.GatPoly 0.0104076f
Cred_1572 VDD.$1253.Metal2 vin.$43.GatPoly 0.00371219f
Cred_1573 VDD.$1253.Metal2 vin.$500.Metal2 0.000254753f
Cred_1574 VDD.$1253.Metal2 vin.$504.Metal2 0.0164039f
Cred_1575 VDD.$1253.Metal2 vin.$506.Metal2 0.00157433f
Cred_1576 VDD.$1253.Metal2 vin.$509.Metal2 0.00930457f
Cred_1577 VDD.$1253.Metal2 vin.P22.GatPoly 0.000813824f
Cred_1578 VDD.$1253.Metal2 vin.P23.GatPoly 0.0682271f
Cred_1579 VDD.$1253.Metal2 vin.P24.GatPoly 0.0655001f
Cred_1580 VDD.$1253.Metal2 vin.P25.GatPoly 0.000813824f
Cred_1581 VDD.$1253.Metal2 vout.$1226.Metal3 0.192197f
Cred_1582 VDD.$1253.Metal2 vout.P0.nSD 0.00126642f
Cred_1583 VDD.$1253.Metal2 vout.P0.pSD 0.00672957f
Cred_1584 VDD.$1253.Metal2 vout.P2.nSD 0.00137771f
Cred_1585 VDD.$1253.Metal2 vout.P2.pSD 0.045533f
Cred_1586 VDD.$1253.Metal2 vout.P4.pSD 0.038663f
Cred_1587 VDD.$1273.Metal2 vin.$237.Metal1 0.000965854f
Cred_1588 VDD.$1273.Metal2 vin.$241.Metal1 0.00418784f
Cred_1589 VDD.$1273.Metal2 vin.$247.Metal1 0.00236213f
Cred_1590 VDD.$1273.Metal2 vin.$25.GatPoly 0.00875418f
Cred_1591 VDD.$1273.Metal2 vin.$251.Metal1 0.000862155f
Cred_1592 VDD.$1273.Metal2 vin.$37.GatPoly 0.00456472f
Cred_1593 VDD.$1273.Metal2 vin.$43.GatPoly 0.00162815f
Cred_1594 VDD.$1273.Metal2 vin.$504.Metal2 0.00708295f
Cred_1595 VDD.$1273.Metal2 vin.$506.Metal2 0.000690494f
Cred_1596 VDD.$1273.Metal2 vin.$509.Metal2 0.00436753f
Cred_1597 VDD.$1273.Metal2 vin.$513.Metal2 0.000286578f
Cred_1598 VDD.$1273.Metal2 vin.P22.GatPoly 0.00035694f
Cred_1599 VDD.$1273.Metal2 vin.P23.GatPoly 0.0278907f
Cred_1600 VDD.$1273.Metal2 vin.P24.GatPoly 0.0376867f
Cred_1601 VDD.$1273.Metal2 vin.P25.GatPoly 0.00035694f
Cred_1602 VDD.$1273.Metal2 vout.$1226.Metal3 0.0842968f
Cred_1603 VDD.$1273.Metal2 vout.P0.nSD 0.00055545f
Cred_1604 VDD.$1273.Metal2 vout.P0.pSD 0.00295157f
Cred_1605 VDD.$1273.Metal2 vout.P2.nSD 0.000604257f
Cred_1606 VDD.$1273.Metal2 vout.P2.pSD 0.0199706f
Cred_1607 VDD.$1273.Metal2 vout.P4.pSD 0.0169575f
Cred_1608 VDD.$1285.Metal2 vin.$247.Metal1 4.41139e-06f
Cred_1609 VDD.$1285.Metal2 vin.$251.Metal1 1.04269e-06f
Cred_1610 VDD.$1285.Metal2 vin.$509.Metal2 0.000286578f
Cred_1611 VDD.$1285.Metal2 vin.$513.Metal2 0.000286578f
Cred_1612 VDD.$1285.Metal2 vin.P24.GatPoly 0.0103275f
Cred_1613 VDD.$1285.Metal2 vin.P25.GatPoly 0.000533f
Cred_1614 VDD.$1285.Metal2 vout.$1226.Metal3 0.00848468f
Cred_1615 VDD.$1285.Metal2 vout.P4.pSD 0.00313315f
Cred_1616 VDD.$1297.Metal2 vin.$520.Metal2 0.0011665f
Cred_1617 VDD.$1297.Metal2 vin.P25.GatPoly 0.014685f
Cred_1618 VDD.$1297.Metal2 vout.$1226.Metal3 0.00484109f
Cred_1619 VDD.$1297.Metal2 vout.P4.pSD 0.00156969f
Cred_1620 VDD.$130.Metal1 vin.$199.Metal1 0.0251111f
Cred_1621 VDD.$130.Metal1 vin.$478.Metal2 0.0016269f
Cred_1622 VDD.$130.Metal1 vin.$7.GatPoly 0.00532391f
Cred_1623 VDD.$130.Metal1 vin.P20.GatPoly 0.0375366f
Cred_1624 VDD.$130.Metal1 vout.$1226.Metal3 0.0128564f
Cred_1625 VDD.$130.Metal1 vout.P0.nSD 0.000382824f
Cred_1626 VDD.$130.Metal1 vout.P0.pSD 0.0168772f
Cred_1627 VDD.$130.Metal1 vout.P2.nSD 0.000202541f
Cred_1628 VDD.$130.Metal1 vout.P2.pSD 0.00110693f
Cred_1629 VDD.$130.Metal1 VSS.$18.Metal1 0.000670872f
Cred_1630 VDD.$130.Metal1 VSS.$40.Metal1 0.000296078f
Cred_1631 VDD.$130.Metal1 VSS.$551.Metal1 6.62e-07f
Cred_1632 VDD.$130.Metal1 VSS.$564.Metal2 0.000613019f
Cred_1633 VDD.$130.Metal1 VSS.P0.nSD 1.51963e-07f
Cred_1634 VDD.$130.Metal1 VSS.P0.pSD 0.00257533f
Cred_1635 VDD.$130.Metal1 VSS.P1.nSD 1.51963e-07f
Cred_1636 VDD.$131.Metal1 vin.P20.GatPoly 0.0123085f
Cred_1637 VDD.$131.Metal1 vout.$1226.Metal3 0.00197115f
Cred_1638 VDD.$131.Metal1 vout.P0.nSD 5.86945e-05f
Cred_1639 VDD.$131.Metal1 vout.P0.pSD 0.00266424f
Cred_1640 VDD.$131.Metal1 vout.P2.nSD 3.10535e-05f
Cred_1641 VDD.$131.Metal1 vout.P2.pSD 0.000169715f
Cred_1642 VDD.$132.Metal1 vin.P20.GatPoly 0.0123822f
Cred_1643 VDD.$132.Metal1 vout.$1226.Metal3 0.0022739f
Cred_1644 VDD.$132.Metal1 vout.P0.nSD 6.77096e-05f
Cred_1645 VDD.$132.Metal1 vout.P0.pSD 0.00310422f
Cred_1646 VDD.$132.Metal1 vout.P2.nSD 3.58232e-05f
Cred_1647 VDD.$132.Metal1 vout.P2.pSD 0.000195782f
Cred_1648 VDD.$1324.Metal2 vin.$265.Metal1 0.00549707f
Cred_1649 VDD.$1324.Metal2 vin.$273.Metal1 0.0103608f
Cred_1650 VDD.$1324.Metal2 vin.$277.Metal1 0.000193051f
Cred_1651 VDD.$1324.Metal2 vin.$281.Metal1 2.39364e-05f
Cred_1652 VDD.$1324.Metal2 vin.$47.GatPoly 0.022959f
Cred_1653 VDD.$1324.Metal2 vin.$515.Metal2 0.000652212f
Cred_1654 VDD.$1324.Metal2 vin.$520.Metal2 0.00282271f
Cred_1655 VDD.$1324.Metal2 vin.$523.Metal2 0.000293964f
Cred_1656 VDD.$1324.Metal2 vin.$527.Metal2 0.0278378f
Cred_1657 VDD.$1324.Metal2 vin.$528.Metal2 1.11632e-05f
Cred_1658 VDD.$1324.Metal2 vin.$53.GatPoly 0.00463733f
Cred_1659 VDD.$1324.Metal2 vin.$533.Metal2 0.00199199f
Cred_1660 VDD.$1324.Metal2 vin.$535.Metal2 0.000652212f
Cred_1661 VDD.$1324.Metal2 vin.$57.GatPoly 0.0234898f
Cred_1662 VDD.$1324.Metal2 vin.P24.GatPoly 0.000991556f
Cred_1663 VDD.$1324.Metal2 vin.P25.GatPoly 0.0722391f
Cred_1664 VDD.$1324.Metal2 vin.P26.GatPoly 0.0687153f
Cred_1665 VDD.$1324.Metal2 vin.P27.GatPoly 0.000991556f
Cred_1666 VDD.$1324.Metal2 vout.$1226.Metal3 0.19391f
Cred_1667 VDD.$1324.Metal2 vout.$1292.Metal3 0.063084f
Cred_1668 VDD.$1324.Metal2 vout.P4.pSD 0.0478761f
Cred_1669 VDD.$1324.Metal2 vout.P6.nSD 0.000993829f
Cred_1670 VDD.$1324.Metal2 vout.P6.pSD 0.051986f
Cred_1671 VDD.$133.Metal1 vin.P20.GatPoly 0.0123812f
Cred_1672 VDD.$133.Metal1 vout.$1226.Metal3 0.00226897f
Cred_1673 VDD.$133.Metal1 vout.P0.nSD 6.75627e-05f
Cred_1674 VDD.$133.Metal1 vout.P0.pSD 0.00310405f
Cred_1675 VDD.$133.Metal1 vout.P2.nSD 3.57455e-05f
Cred_1676 VDD.$133.Metal1 vout.P2.pSD 0.000195357f
Cred_1677 VDD.$134.Metal1 vin.P20.GatPoly 0.0122976f
Cred_1678 VDD.$134.Metal1 vout.$1226.Metal3 0.00225556f
Cred_1679 VDD.$134.Metal1 vout.P0.nSD 6.71635e-05f
Cred_1680 VDD.$134.Metal1 vout.P0.pSD 0.00308688f
Cred_1681 VDD.$134.Metal1 vout.P2.nSD 3.55343e-05f
Cred_1682 VDD.$134.Metal1 vout.P2.pSD 0.000194203f
Cred_1683 VDD.$1344.Metal2 vin.$265.Metal1 0.00020875f
Cred_1684 VDD.$1344.Metal2 vin.$273.Metal1 0.000393447f
Cred_1685 VDD.$1344.Metal2 vin.$277.Metal1 7.33103e-06f
Cred_1686 VDD.$1344.Metal2 vin.$281.Metal1 9.08976e-07f
Cred_1687 VDD.$1344.Metal2 vin.$47.GatPoly 0.000871859f
Cred_1688 VDD.$1344.Metal2 vin.$515.Metal2 2.47676e-05f
Cred_1689 VDD.$1344.Metal2 vin.$520.Metal2 0.000107192f
Cred_1690 VDD.$1344.Metal2 vin.$523.Metal2 1.11632e-05f
Cred_1691 VDD.$1344.Metal2 vin.$527.Metal2 0.00105713f
Cred_1692 VDD.$1344.Metal2 vin.$528.Metal2 4.23918e-07f
Cred_1693 VDD.$1344.Metal2 vin.$53.GatPoly 0.000176101f
Cred_1694 VDD.$1344.Metal2 vin.$533.Metal2 7.56453e-05f
Cred_1695 VDD.$1344.Metal2 vin.$535.Metal2 2.47676e-05f
Cred_1696 VDD.$1344.Metal2 vin.$57.GatPoly 0.000892017f
Cred_1697 VDD.$1344.Metal2 vin.P24.GatPoly 3.7654e-05f
Cred_1698 VDD.$1344.Metal2 vin.P25.GatPoly 0.00260753f
Cred_1699 VDD.$1344.Metal2 vin.P26.GatPoly 0.00925061f
Cred_1700 VDD.$1344.Metal2 vin.P27.GatPoly 3.7654e-05f
Cred_1701 VDD.$1344.Metal2 vout.$1226.Metal3 0.00736758f
Cred_1702 VDD.$1344.Metal2 vout.$1292.Metal3 0.0023995f
Cred_1703 VDD.$1344.Metal2 vout.P4.pSD 0.00181808f
Cred_1704 VDD.$1344.Metal2 vout.P6.nSD 3.78019e-05f
Cred_1705 VDD.$1344.Metal2 vout.P6.pSD 0.0019761f
Cred_1706 VDD.$135.Metal1 vin.P20.GatPoly 0.0122945f
Cred_1707 VDD.$135.Metal1 vout.$1226.Metal3 0.00194273f
Cred_1708 VDD.$135.Metal1 vout.P0.nSD 5.78484e-05f
Cred_1709 VDD.$135.Metal1 vout.P0.pSD 0.00267038f
Cred_1710 VDD.$135.Metal1 vout.P2.nSD 3.06059e-05f
Cred_1711 VDD.$135.Metal1 vout.P2.pSD 0.000167268f
Cred_1712 VDD.$1350.Metal2 vin.$273.Metal1 4.03106e-06f
Cred_1713 VDD.$1350.Metal2 vin.$277.Metal1 8.31397e-06f
Cred_1714 VDD.$1350.Metal2 vin.$281.Metal1 9.14441e-06f
Cred_1715 VDD.$1350.Metal2 vin.$527.Metal2 0.00038401f
Cred_1716 VDD.$1350.Metal2 vin.$533.Metal2 0.000761f
Cred_1717 VDD.$1350.Metal2 vin.P26.GatPoly 0.011514f
Cred_1718 VDD.$1350.Metal2 vout.$1226.Metal3 0.00205775f
Cred_1719 VDD.$1350.Metal2 vout.$1292.Metal3 0.00205775f
Cred_1720 VDD.$1350.Metal2 vout.P6.nSD 3.2418e-05f
Cred_1721 VDD.$1350.Metal2 vout.P6.pSD 0.00163917f
Cred_1722 VDD.$136.Metal1 vin 0.000837359f
Cred_1723 VDD.$136.Metal1 vin.$105.GatPoly 4.84412e-06f
Cred_1724 VDD.$136.Metal1 vin.$107.GatPoly 3.25937e-06f
Cred_1725 VDD.$136.Metal1 vin.$115.GatPoly 3.93593e-06f
Cred_1726 VDD.$136.Metal1 vin.$123.GatPoly 3.11532e-06f
Cred_1727 VDD.$136.Metal1 vin.$127.GatPoly 2.01261e-06f
Cred_1728 VDD.$136.Metal1 vin.$135.GatPoly 1.75871e-06f
Cred_1729 VDD.$136.Metal1 vin.$137.GatPoly 1.19489e-06f
Cred_1730 VDD.$136.Metal1 vin.$145.GatPoly 1.37551e-06f
Cred_1731 VDD.$136.Metal1 vin.$15.GatPoly 7.9059e-05f
Cred_1732 VDD.$136.Metal1 vin.$153.GatPoly 1.12123e-06f
Cred_1733 VDD.$136.Metal1 vin.$157.GatPoly 6.20767e-07f
Cred_1734 VDD.$136.Metal1 vin.$163.GatPoly 6.16827e-07f
Cred_1735 VDD.$136.Metal1 vin.$167.GatPoly 4.64893e-07f
Cred_1736 VDD.$136.Metal1 vin.$17.GatPoly 0.000101871f
Cred_1737 VDD.$136.Metal1 vin.$173.GatPoly 4.25168e-07f
Cred_1738 VDD.$136.Metal1 vin.$179.GatPoly 5.92463e-07f
Cred_1739 VDD.$136.Metal1 vin.$199.Metal1 0.00405918f
Cred_1740 VDD.$136.Metal1 vin.$207.Metal1 0.00109559f
Cred_1741 VDD.$136.Metal1 vin.$211.Metal1 0.000928659f
Cred_1742 VDD.$136.Metal1 vin.$219.Metal1 0.00111868f
Cred_1743 VDD.$136.Metal1 vin.$227.Metal1 0.00089635f
Cred_1744 VDD.$136.Metal1 vin.$233.Metal1 0.000545634f
Cred_1745 VDD.$136.Metal1 vin.$237.Metal1 0.00035911f
Cred_1746 VDD.$136.Metal1 vin.$241.Metal1 0.000458264f
Cred_1747 VDD.$136.Metal1 vin.$247.Metal1 0.000413614f
Cred_1748 VDD.$136.Metal1 vin.$25.GatPoly 5.30548e-05f
Cred_1749 VDD.$136.Metal1 vin.$251.Metal1 0.00035961f
Cred_1750 VDD.$136.Metal1 vin.$259.Metal1 0.000324246f
Cred_1751 VDD.$136.Metal1 vin.$263.Metal1 0.000193967f
Cred_1752 VDD.$136.Metal1 vin.$265.Metal1 0.000256862f
Cred_1753 VDD.$136.Metal1 vin.$27.GatPoly 7.41753e-05f
Cred_1754 VDD.$136.Metal1 vin.$273.Metal1 0.000224873f
Cred_1755 VDD.$136.Metal1 vin.$277.Metal1 0.000137981f
Cred_1756 VDD.$136.Metal1 vin.$281.Metal1 0.000131848f
Cred_1757 VDD.$136.Metal1 vin.$285.Metal1 0.000163895f
Cred_1758 VDD.$136.Metal1 vin.$291.Metal1 0.00015562f
Cred_1759 VDD.$136.Metal1 vin.$295.Metal1 0.000129219f
Cred_1760 VDD.$136.Metal1 vin.$303.Metal1 0.000114967f
Cred_1761 VDD.$136.Metal1 vin.$307.Metal1 0.000103202f
Cred_1762 VDD.$136.Metal1 vin.$313.Metal1 8.93146e-05f
Cred_1763 VDD.$136.Metal1 vin.$317.Metal1 5.29807e-05f
Cred_1764 VDD.$136.Metal1 vin.$321.Metal1 5.09455e-05f
Cred_1765 VDD.$136.Metal1 vin.$325.Metal1 6.4427e-05f
Cred_1766 VDD.$136.Metal1 vin.$331.Metal1 5.76023e-05f
Cred_1767 VDD.$136.Metal1 vin.$335.Metal1 3.48071e-05f
Cred_1768 VDD.$136.Metal1 vin.$339.Metal1 3.30403e-05f
Cred_1769 VDD.$136.Metal1 vin.$343.Metal1 2.92292e-05f
Cred_1770 VDD.$136.Metal1 vin.$347.Metal1 3.93348e-05f
Cred_1771 VDD.$136.Metal1 vin.$353.Metal1 3.61595e-05f
Cred_1772 VDD.$136.Metal1 vin.$357.Metal1 3.01991e-05f
Cred_1773 VDD.$136.Metal1 vin.$365.Metal1 2.69581e-05f
Cred_1774 VDD.$136.Metal1 vin.$369.Metal1 2.47971e-05f
Cred_1775 VDD.$136.Metal1 vin.$37.GatPoly 6.36974e-05f
Cred_1776 VDD.$136.Metal1 vin.$375.Metal1 2.05467e-05f
Cred_1777 VDD.$136.Metal1 vin.$379.Metal1 1.3023e-05f
Cred_1778 VDD.$136.Metal1 vin.$383.Metal1 1.15635e-05f
Cred_1779 VDD.$136.Metal1 vin.$387.Metal1 1.51757e-05f
Cred_1780 VDD.$136.Metal1 vin.$393.Metal1 1.37448e-05f
Cred_1781 VDD.$136.Metal1 vin.$397.Metal1 8.24177e-06f
Cred_1782 VDD.$136.Metal1 vin.$401.Metal1 1.09087e-05f
Cred_1783 VDD.$136.Metal1 vin.$409.Metal1 9.64868e-06f
Cred_1784 VDD.$136.Metal1 vin.$413.Metal1 8.44194e-06f
Cred_1785 VDD.$136.Metal1 vin.$419.Metal1 7.36407e-06f
Cred_1786 VDD.$136.Metal1 vin.$423.Metal1 4.56442e-06f
Cred_1787 VDD.$136.Metal1 vin.$427.Metal1 5.62725e-06f
Cred_1788 VDD.$136.Metal1 vin.$43.GatPoly 4.71758e-05f
Cred_1789 VDD.$136.Metal1 vin.$433.Metal1 6.94994e-06f
Cred_1790 VDD.$136.Metal1 vin.$441.Metal1 6.14067e-06f
Cred_1791 VDD.$136.Metal1 vin.$449.Metal1 3.77899e-06f
Cred_1792 VDD.$136.Metal1 vin.$453.Metal1 2.26995e-06f
Cred_1793 VDD.$136.Metal1 vin.$457.Metal1 8.44016e-06f
Cred_1794 VDD.$136.Metal1 vin.$47.GatPoly 2.821e-05f
Cred_1795 VDD.$136.Metal1 vin.$476.Metal2 5.6079e-06f
Cred_1796 VDD.$136.Metal1 vin.$478.Metal2 0.00181927f
Cred_1797 VDD.$136.Metal1 vin.$482.Metal2 0.000431127f
Cred_1798 VDD.$136.Metal1 vin.$486.Metal2 0.00108081f
Cred_1799 VDD.$136.Metal1 vin.$489.Metal2 0.00060678f
Cred_1800 VDD.$136.Metal1 vin.$493.Metal2 0.000373339f
Cred_1801 VDD.$136.Metal1 vin.$495.Metal2 0.000817603f
Cred_1802 VDD.$136.Metal1 vin.$500.Metal2 0.000333631f
Cred_1803 VDD.$136.Metal1 vin.$504.Metal2 0.000283773f
Cred_1804 VDD.$136.Metal1 vin.$506.Metal2 0.000529788f
Cred_1805 VDD.$136.Metal1 vin.$509.Metal2 0.000171772f
Cred_1806 VDD.$136.Metal1 vin.$513.Metal2 0.000149516f
Cred_1807 VDD.$136.Metal1 vin.$515.Metal2 0.000458781f
Cred_1808 VDD.$136.Metal1 vin.$518.Metal2 0.000163333f
Cred_1809 VDD.$136.Metal1 vin.$520.Metal2 7.09344e-05f
Cred_1810 VDD.$136.Metal1 vin.$523.Metal2 3.72083e-05f
Cred_1811 VDD.$136.Metal1 vin.$527.Metal2 0.000274274f
Cred_1812 VDD.$136.Metal1 vin.$528.Metal2 1.41297e-06f
Cred_1813 VDD.$136.Metal1 vin.$53.GatPoly 2.9284e-05f
Cred_1814 VDD.$136.Metal1 vin.$533.Metal2 0.000109956f
Cred_1815 VDD.$136.Metal1 vin.$535.Metal2 0.000271404f
Cred_1816 VDD.$136.Metal1 vin.$538.Metal2 6.87681e-05f
Cred_1817 VDD.$136.Metal1 vin.$542.Metal2 4.69421e-05f
Cred_1818 VDD.$136.Metal1 vin.$544.Metal2 0.00012494f
Cred_1819 VDD.$136.Metal1 vin.$547.Metal2 7.29088e-05f
Cred_1820 VDD.$136.Metal1 vin.$551.Metal2 4.59124e-05f
Cred_1821 VDD.$136.Metal1 vin.$555.Metal2 0.000101373f
Cred_1822 VDD.$136.Metal1 vin.$558.Metal2 4.2623e-05f
Cred_1823 VDD.$136.Metal1 vin.$562.Metal2 3.04468e-05f
Cred_1824 VDD.$136.Metal1 vin.$564.Metal2 6.70023e-05f
Cred_1825 VDD.$136.Metal1 vin.$567.Metal2 2.74781e-05f
Cred_1826 VDD.$136.Metal1 vin.$57.GatPoly 2.28131e-05f
Cred_1827 VDD.$136.Metal1 vin.$571.Metal2 2.47523e-05f
Cred_1828 VDD.$136.Metal1 vin.$573.Metal2 5.15221e-05f
Cred_1829 VDD.$136.Metal1 vin.$578.Metal2 2.02051e-05f
Cred_1830 VDD.$136.Metal1 vin.$582.Metal2 1.90281e-05f
Cred_1831 VDD.$136.Metal1 vin.$584.Metal2 3.12639e-05f
Cred_1832 VDD.$136.Metal1 vin.$587.Metal2 1.00255e-05f
Cred_1833 VDD.$136.Metal1 vin.$591.Metal2 9.29233e-06f
Cred_1834 VDD.$136.Metal1 vin.$593.Metal2 2.86817e-05f
Cred_1835 VDD.$136.Metal1 vin.$596.Metal2 1.18951e-05f
Cred_1836 VDD.$136.Metal1 vin.$599.Metal2 8.83486e-08f
Cred_1837 VDD.$136.Metal1 vin.$603.Metal2 1.71243e-05f
Cred_1838 VDD.$136.Metal1 vin.$604.Metal2 2.32651e-06f
Cred_1839 VDD.$136.Metal1 vin.$609.Metal2 3.09876e-06f
Cred_1840 VDD.$136.Metal1 vin.$611.Metal2 4.9901e-06f
Cred_1841 VDD.$136.Metal1 vin.$613.Metal2 1.68449e-05f
Cred_1842 VDD.$136.Metal1 vin.$616.Metal2 4.00158e-06f
Cred_1843 VDD.$136.Metal1 vin.$620.Metal2 3.00667e-06f
Cred_1844 VDD.$136.Metal1 vin.$622.Metal2 8.25938e-06f
Cred_1845 VDD.$136.Metal1 vin.$625.Metal2 4.07823e-06f
Cred_1846 VDD.$136.Metal1 vin.$629.Metal2 2.9948e-06f
Cred_1847 VDD.$136.Metal1 vin.$633.Metal2 6.34072e-06f
Cred_1848 VDD.$136.Metal1 vin.$636.Metal2 2.53977e-06f
Cred_1849 VDD.$136.Metal1 vin.$640.Metal2 1.99319e-06f
Cred_1850 VDD.$136.Metal1 vin.$642.Metal2 5.27829e-06f
Cred_1851 VDD.$136.Metal1 vin.$645.Metal2 1.5085e-06f
Cred_1852 VDD.$136.Metal1 vin.$648.Metal2 7.47879e-08f
Cred_1853 VDD.$136.Metal1 vin.$649.Metal2 1.14956e-06f
Cred_1854 VDD.$136.Metal1 vin.$65.GatPoly 2.26107e-05f
Cred_1855 VDD.$136.Metal1 vin.$653.Metal2 2.85954e-07f
Cred_1856 VDD.$136.Metal1 vin.$654.Metal2 2.43912e-06f
Cred_1857 VDD.$136.Metal1 vin.$7.GatPoly 0.000204531f
Cred_1858 VDD.$136.Metal1 vin.$73.GatPoly 1.71939e-05f
Cred_1859 VDD.$136.Metal1 vin.$77.GatPoly 9.72127e-06f
Cred_1860 VDD.$136.Metal1 vin.$83.GatPoly 1.0284e-05f
Cred_1861 VDD.$136.Metal1 vin.$87.GatPoly 6.6916e-06f
Cred_1862 VDD.$136.Metal1 vin.$9.GatPoly 0.000118099f
Cred_1863 VDD.$136.Metal1 vin.$93.GatPoly 8.14863e-06f
Cred_1864 VDD.$136.Metal1 vin.$97.GatPoly 5.66399e-06f
Cred_1865 VDD.$136.Metal1 vin.P20.GatPoly 0.0131936f
Cred_1866 VDD.$136.Metal1 vin.P24.GatPoly 4.86409e-06f
Cred_1867 VDD.$136.Metal1 vin.P27.GatPoly 1.71416e-06f
Cred_1868 VDD.$136.Metal1 vin.P32.GatPoly 3.02417e-07f
Cred_1869 VDD.$136.Metal1 vin.P35.GatPoly 1.08704e-07f
Cred_1870 VDD.$136.Metal1 vin.P39.GatPoly 1.00681e-06f
Cred_1871 VDD.$136.Metal1 vout 1.53578e-06f
Cred_1872 VDD.$136.Metal1 vout.$1226.Metal3 0.00334963f
Cred_1873 VDD.$136.Metal1 vout.$1292.Metal3 8.65083e-05f
Cred_1874 VDD.$136.Metal1 vout.$1358.Metal3 2.32264e-05f
Cred_1875 VDD.$136.Metal1 vout.$1424.Metal3 4.99359e-06f
Cred_1876 VDD.$136.Metal1 vout.P0.nSD 9.06209e-05f
Cred_1877 VDD.$136.Metal1 vout.P0.pSD 0.00315016f
Cred_1878 VDD.$136.Metal1 vout.P10.nSD 1.59033e-07f
Cred_1879 VDD.$136.Metal1 vout.P10.pSD 8.61332e-07f
Cred_1880 VDD.$136.Metal1 vout.P14.nSD 3.97721e-08f
Cred_1881 VDD.$136.Metal1 vout.P14.pSD 2.15408e-07f
Cred_1882 VDD.$136.Metal1 vout.P2.nSD 4.97253e-05f
Cred_1883 VDD.$136.Metal1 vout.P2.pSD 0.00027176f
Cred_1884 VDD.$136.Metal1 vout.P6.nSD 5.8575e-07f
Cred_1885 VDD.$136.Metal1 vout.P6.pSD 3.20126e-06f
Cred_1886 VDD.$136.Metal1 VSS.$1066.Metal2 2.93519e-08f
Cred_1887 VDD.$136.Metal1 VSS.$18.Metal1 0.00133978f
Cred_1888 VDD.$136.Metal1 VSS.$40.Metal1 0.000734688f
Cred_1889 VDD.$136.Metal1 VSS.$509.Metal1 1.50263e-07f
Cred_1890 VDD.$136.Metal1 VSS.$551.Metal1 7.36277e-06f
Cred_1891 VDD.$136.Metal1 VSS.$564.Metal2 0.000116677f
Cred_1892 VDD.$136.Metal1 VSS.P0.nSD 1.42704e-06f
Cred_1893 VDD.$136.Metal1 VSS.P0.pSD 0.00627764f
Cred_1894 VDD.$136.Metal1 VSS.P1.nSD 1.42704e-06f
Cred_1895 VDD.$136.Metal1 VSS.P21.nSD 1.00375e-09f
Cred_1896 VDD.$136.Metal1 VSS.P23.nSD 1.00375e-09f
Cred_1897 VDD.$1362.Metal2 vin.$291.Metal1 4.08793e-06f
Cred_1898 VDD.$1362.Metal2 vin.$295.Metal1 1.36264e-06f
Cred_1899 VDD.$1362.Metal2 vin.$538.Metal2 0.00028658f
Cred_1900 VDD.$1362.Metal2 vin.$542.Metal2 0.00028658f
Cred_1901 VDD.$1362.Metal2 vin.P26.GatPoly 0.000888476f
Cred_1902 VDD.$1362.Metal2 vin.P27.GatPoly 0.00947136f
Cred_1903 VDD.$1362.Metal2 vout.$1226.Metal3 0.00400085f
Cred_1904 VDD.$1362.Metal2 vout.$1292.Metal3 0.00400085f
Cred_1905 VDD.$1362.Metal2 vout.P6.nSD 6.30296e-05f
Cred_1906 VDD.$1362.Metal2 vout.P6.pSD 0.00356668f
Cred_1907 VDD.$137.Metal1 vin 0.000938256f
Cred_1908 VDD.$137.Metal1 vin.$105.GatPoly 5.42781e-06f
Cred_1909 VDD.$137.Metal1 vin.$107.GatPoly 3.65211e-06f
Cred_1910 VDD.$137.Metal1 vin.$115.GatPoly 4.41019e-06f
Cred_1911 VDD.$137.Metal1 vin.$123.GatPoly 3.49069e-06f
Cred_1912 VDD.$137.Metal1 vin.$127.GatPoly 2.25512e-06f
Cred_1913 VDD.$137.Metal1 vin.$135.GatPoly 1.97063e-06f
Cred_1914 VDD.$137.Metal1 vin.$137.GatPoly 1.33887e-06f
Cred_1915 VDD.$137.Metal1 vin.$145.GatPoly 1.54124e-06f
Cred_1916 VDD.$137.Metal1 vin.$15.GatPoly 8.85851e-05f
Cred_1917 VDD.$137.Metal1 vin.$153.GatPoly 1.25633e-06f
Cred_1918 VDD.$137.Metal1 vin.$157.GatPoly 6.95565e-07f
Cred_1919 VDD.$137.Metal1 vin.$163.GatPoly 6.91151e-07f
Cred_1920 VDD.$137.Metal1 vin.$167.GatPoly 5.20909e-07f
Cred_1921 VDD.$137.Metal1 vin.$17.GatPoly 0.000114146f
Cred_1922 VDD.$137.Metal1 vin.$173.GatPoly 4.76398e-07f
Cred_1923 VDD.$137.Metal1 vin.$179.GatPoly 6.63851e-07f
Cred_1924 VDD.$137.Metal1 vin.$199.Metal1 0.00454829f
Cred_1925 VDD.$137.Metal1 vin.$207.Metal1 0.0012276f
Cred_1926 VDD.$137.Metal1 vin.$211.Metal1 0.00104056f
Cred_1927 VDD.$137.Metal1 vin.$219.Metal1 0.00125348f
Cred_1928 VDD.$137.Metal1 vin.$227.Metal1 0.00100435f
Cred_1929 VDD.$137.Metal1 vin.$233.Metal1 0.000611379f
Cred_1930 VDD.$137.Metal1 vin.$237.Metal1 0.00040238f
Cred_1931 VDD.$137.Metal1 vin.$241.Metal1 0.000513482f
Cred_1932 VDD.$137.Metal1 vin.$247.Metal1 0.000463452f
Cred_1933 VDD.$137.Metal1 vin.$25.GatPoly 5.94476e-05f
Cred_1934 VDD.$137.Metal1 vin.$251.Metal1 0.000402941f
Cred_1935 VDD.$137.Metal1 vin.$259.Metal1 0.000363315f
Cred_1936 VDD.$137.Metal1 vin.$263.Metal1 0.000217339f
Cred_1937 VDD.$137.Metal1 vin.$265.Metal1 0.000287812f
Cred_1938 VDD.$137.Metal1 vin.$27.GatPoly 8.31129e-05f
Cred_1939 VDD.$137.Metal1 vin.$273.Metal1 0.000251969f
Cred_1940 VDD.$137.Metal1 vin.$277.Metal1 0.000154607f
Cred_1941 VDD.$137.Metal1 vin.$281.Metal1 0.000147735f
Cred_1942 VDD.$137.Metal1 vin.$285.Metal1 0.000183644f
Cred_1943 VDD.$137.Metal1 vin.$291.Metal1 0.000174371f
Cred_1944 VDD.$137.Metal1 vin.$295.Metal1 0.000144789f
Cred_1945 VDD.$137.Metal1 vin.$303.Metal1 0.00012882f
Cred_1946 VDD.$137.Metal1 vin.$307.Metal1 0.000115637f
Cred_1947 VDD.$137.Metal1 vin.$313.Metal1 0.000100076f
Cred_1948 VDD.$137.Metal1 vin.$317.Metal1 5.93645e-05f
Cred_1949 VDD.$137.Metal1 vin.$321.Metal1 5.70841e-05f
Cred_1950 VDD.$137.Metal1 vin.$325.Metal1 7.21901e-05f
Cred_1951 VDD.$137.Metal1 vin.$331.Metal1 6.4543e-05f
Cred_1952 VDD.$137.Metal1 vin.$335.Metal1 3.90011e-05f
Cred_1953 VDD.$137.Metal1 vin.$339.Metal1 3.70214e-05f
Cred_1954 VDD.$137.Metal1 vin.$343.Metal1 3.27511e-05f
Cred_1955 VDD.$137.Metal1 vin.$347.Metal1 4.40744e-05f
Cred_1956 VDD.$137.Metal1 vin.$353.Metal1 4.05164e-05f
Cred_1957 VDD.$137.Metal1 vin.$357.Metal1 3.38379e-05f
Cred_1958 VDD.$137.Metal1 vin.$365.Metal1 3.02063e-05f
Cred_1959 VDD.$137.Metal1 vin.$369.Metal1 2.7785e-05f
Cred_1960 VDD.$137.Metal1 vin.$37.GatPoly 7.13725e-05f
Cred_1961 VDD.$137.Metal1 vin.$375.Metal1 2.30225e-05f
Cred_1962 VDD.$137.Metal1 vin.$379.Metal1 1.45922e-05f
Cred_1963 VDD.$137.Metal1 vin.$383.Metal1 1.29568e-05f
Cred_1964 VDD.$137.Metal1 vin.$387.Metal1 1.70042e-05f
Cred_1965 VDD.$137.Metal1 vin.$393.Metal1 1.5401e-05f
Cred_1966 VDD.$137.Metal1 vin.$397.Metal1 9.23485e-06f
Cred_1967 VDD.$137.Metal1 vin.$401.Metal1 1.22232e-05f
Cred_1968 VDD.$137.Metal1 vin.$409.Metal1 1.08113e-05f
Cred_1969 VDD.$137.Metal1 vin.$413.Metal1 9.45914e-06f
Cred_1970 VDD.$137.Metal1 vin.$419.Metal1 8.25139e-06f
Cred_1971 VDD.$137.Metal1 vin.$423.Metal1 5.1144e-06f
Cred_1972 VDD.$137.Metal1 vin.$427.Metal1 6.3053e-06f
Cred_1973 VDD.$137.Metal1 vin.$43.GatPoly 5.28602e-05f
Cred_1974 VDD.$137.Metal1 vin.$433.Metal1 7.78736e-06f
Cred_1975 VDD.$137.Metal1 vin.$441.Metal1 6.88058e-06f
Cred_1976 VDD.$137.Metal1 vin.$449.Metal1 4.23433e-06f
Cred_1977 VDD.$137.Metal1 vin.$453.Metal1 2.54346e-06f
Cred_1978 VDD.$137.Metal1 vin.$457.Metal1 9.45714e-06f
Cred_1979 VDD.$137.Metal1 vin.$47.GatPoly 3.16091e-05f
Cred_1980 VDD.$137.Metal1 vin.$476.Metal2 6.28362e-06f
Cred_1981 VDD.$137.Metal1 vin.$478.Metal2 0.00203848f
Cred_1982 VDD.$137.Metal1 vin.$482.Metal2 0.000483075f
Cred_1983 VDD.$137.Metal1 vin.$486.Metal2 0.00121104f
Cred_1984 VDD.$137.Metal1 vin.$489.Metal2 0.000679893f
Cred_1985 VDD.$137.Metal1 vin.$493.Metal2 0.000418324f
Cred_1986 VDD.$137.Metal1 vin.$495.Metal2 0.000916118f
Cred_1987 VDD.$137.Metal1 vin.$500.Metal2 0.000373832f
Cred_1988 VDD.$137.Metal1 vin.$504.Metal2 0.000317966f
Cred_1989 VDD.$137.Metal1 vin.$506.Metal2 0.000593624f
Cred_1990 VDD.$137.Metal1 vin.$509.Metal2 0.00019247f
Cred_1991 VDD.$137.Metal1 vin.$513.Metal2 0.000167532f
Cred_1992 VDD.$137.Metal1 vin.$515.Metal2 0.000514061f
Cred_1993 VDD.$137.Metal1 vin.$518.Metal2 0.000183014f
Cred_1994 VDD.$137.Metal1 vin.$520.Metal2 7.94816e-05f
Cred_1995 VDD.$137.Metal1 vin.$523.Metal2 4.16917e-05f
Cred_1996 VDD.$137.Metal1 vin.$527.Metal2 0.000307322f
Cred_1997 VDD.$137.Metal1 vin.$528.Metal2 1.58323e-06f
Cred_1998 VDD.$137.Metal1 vin.$53.GatPoly 3.28126e-05f
Cred_1999 VDD.$137.Metal1 vin.$533.Metal2 0.000123205f
Cred_2000 VDD.$137.Metal1 vin.$535.Metal2 0.000304107f
Cred_2001 VDD.$137.Metal1 vin.$538.Metal2 7.70543e-05f
Cred_2002 VDD.$137.Metal1 vin.$542.Metal2 5.25983e-05f
Cred_2003 VDD.$137.Metal1 vin.$544.Metal2 0.000139994f
Cred_2004 VDD.$137.Metal1 vin.$547.Metal2 8.16938e-05f
Cred_2005 VDD.$137.Metal1 vin.$551.Metal2 5.14445e-05f
Cred_2006 VDD.$137.Metal1 vin.$555.Metal2 0.000113588f
Cred_2007 VDD.$137.Metal1 vin.$558.Metal2 4.77588e-05f
Cred_2008 VDD.$137.Metal1 vin.$562.Metal2 3.41154e-05f
Cred_2009 VDD.$137.Metal1 vin.$564.Metal2 7.50757e-05f
Cred_2010 VDD.$137.Metal1 vin.$567.Metal2 3.0789e-05f
Cred_2011 VDD.$137.Metal1 vin.$57.GatPoly 2.55619e-05f
Cred_2012 VDD.$137.Metal1 vin.$571.Metal2 2.77348e-05f
Cred_2013 VDD.$137.Metal1 vin.$573.Metal2 5.77302e-05f
Cred_2014 VDD.$137.Metal1 vin.$578.Metal2 2.26397e-05f
Cred_2015 VDD.$137.Metal1 vin.$582.Metal2 2.13209e-05f
Cred_2016 VDD.$137.Metal1 vin.$584.Metal2 3.5031e-05f
Cred_2017 VDD.$137.Metal1 vin.$587.Metal2 1.12335e-05f
Cred_2018 VDD.$137.Metal1 vin.$591.Metal2 1.0412e-05f
Cred_2019 VDD.$137.Metal1 vin.$593.Metal2 3.21376e-05f
Cred_2020 VDD.$137.Metal1 vin.$596.Metal2 1.33284e-05f
Cred_2021 VDD.$137.Metal1 vin.$599.Metal2 9.8994e-08f
Cred_2022 VDD.$137.Metal1 vin.$603.Metal2 1.91876e-05f
Cred_2023 VDD.$137.Metal1 vin.$604.Metal2 2.60684e-06f
Cred_2024 VDD.$137.Metal1 vin.$609.Metal2 3.47214e-06f
Cred_2025 VDD.$137.Metal1 vin.$611.Metal2 5.59137e-06f
Cred_2026 VDD.$137.Metal1 vin.$613.Metal2 1.88746e-05f
Cred_2027 VDD.$137.Metal1 vin.$616.Metal2 4.48374e-06f
Cred_2028 VDD.$137.Metal1 vin.$620.Metal2 3.36895e-06f
Cred_2029 VDD.$137.Metal1 vin.$622.Metal2 9.25458e-06f
Cred_2030 VDD.$137.Metal1 vin.$625.Metal2 4.56963e-06f
Cred_2031 VDD.$137.Metal1 vin.$629.Metal2 3.35565e-06f
Cred_2032 VDD.$137.Metal1 vin.$633.Metal2 7.10473e-06f
Cred_2033 VDD.$137.Metal1 vin.$636.Metal2 2.8458e-06f
Cred_2034 VDD.$137.Metal1 vin.$640.Metal2 2.23335e-06f
Cred_2035 VDD.$137.Metal1 vin.$642.Metal2 5.91429e-06f
Cred_2036 VDD.$137.Metal1 vin.$645.Metal2 1.69027e-06f
Cred_2037 VDD.$137.Metal1 vin.$648.Metal2 8.37993e-08f
Cred_2038 VDD.$137.Metal1 vin.$649.Metal2 1.28807e-06f
Cred_2039 VDD.$137.Metal1 vin.$65.GatPoly 2.53352e-05f
Cred_2040 VDD.$137.Metal1 vin.$653.Metal2 3.20409e-07f
Cred_2041 VDD.$137.Metal1 vin.$654.Metal2 2.73301e-06f
Cred_2042 VDD.$137.Metal1 vin.$7.GatPoly 0.000229175f
Cred_2043 VDD.$137.Metal1 vin.$73.GatPoly 1.92656e-05f
Cred_2044 VDD.$137.Metal1 vin.$77.GatPoly 1.08926e-05f
Cred_2045 VDD.$137.Metal1 vin.$83.GatPoly 1.15232e-05f
Cred_2046 VDD.$137.Metal1 vin.$87.GatPoly 7.49789e-06f
Cred_2047 VDD.$137.Metal1 vin.$9.GatPoly 0.000132329f
Cred_2048 VDD.$137.Metal1 vin.$93.GatPoly 9.13049e-06f
Cred_2049 VDD.$137.Metal1 vin.$97.GatPoly 6.34647e-06f
Cred_2050 VDD.$137.Metal1 vin.P20.GatPoly 0.0132805f
Cred_2051 VDD.$137.Metal1 vin.P24.GatPoly 5.45018e-06f
Cred_2052 VDD.$137.Metal1 vin.P27.GatPoly 1.9207e-06f
Cred_2053 VDD.$137.Metal1 vin.P32.GatPoly 3.38856e-07f
Cred_2054 VDD.$137.Metal1 vin.P35.GatPoly 1.21802e-07f
Cred_2055 VDD.$137.Metal1 vin.P39.GatPoly 1.12813e-06f
Cred_2056 VDD.$137.Metal1 vout 1.72084e-06f
Cred_2057 VDD.$137.Metal1 vout.$1226.Metal3 0.00355986f
Cred_2058 VDD.$137.Metal1 vout.$1292.Metal3 9.69319e-05f
Cred_2059 VDD.$137.Metal1 vout.$1358.Metal3 2.6025e-05f
Cred_2060 VDD.$137.Metal1 vout.$1424.Metal3 5.59528e-06f
Cred_2061 VDD.$137.Metal1 vout.P0.nSD 9.57818e-05f
Cred_2062 VDD.$137.Metal1 vout.P0.pSD 0.00329056f
Cred_2063 VDD.$137.Metal1 vout.P10.nSD 1.78195e-07f
Cred_2064 VDD.$137.Metal1 vout.P10.pSD 9.65117e-07f
Cred_2065 VDD.$137.Metal1 vout.P14.nSD 4.45643e-08f
Cred_2066 VDD.$137.Metal1 vout.P14.pSD 2.41364e-07f
Cred_2067 VDD.$137.Metal1 vout.P2.nSD 5.26704e-05f
Cred_2068 VDD.$137.Metal1 vout.P2.pSD 0.000287856f
Cred_2069 VDD.$137.Metal1 vout.P6.nSD 6.5633e-07f
Cred_2070 VDD.$137.Metal1 vout.P6.pSD 3.58699e-06f
Cred_2071 VDD.$137.Metal1 VSS.$1066.Metal2 3.28886e-08f
Cred_2072 VDD.$137.Metal1 VSS.$18.Metal1 0.00150122f
Cred_2073 VDD.$137.Metal1 VSS.$40.Metal1 0.000823213f
Cred_2074 VDD.$137.Metal1 VSS.$509.Metal1 1.68368e-07f
Cred_2075 VDD.$137.Metal1 VSS.$551.Metal1 8.24993e-06f
Cred_2076 VDD.$137.Metal1 VSS.$564.Metal2 0.000130735f
Cred_2077 VDD.$137.Metal1 VSS.P0.nSD 1.59899e-06f
Cred_2078 VDD.$137.Metal1 VSS.P0.pSD 0.00703406f
Cred_2079 VDD.$137.Metal1 VSS.P1.nSD 1.59899e-06f
Cred_2080 VDD.$137.Metal1 VSS.P21.nSD 1.1247e-09f
Cred_2081 VDD.$137.Metal1 VSS.P23.nSD 1.1247e-09f
Cred_2082 VDD.$1374.Metal2 vin.$291.Metal1 0.00102353f
Cred_2083 VDD.$1374.Metal2 vin.$295.Metal1 0.00214144f
Cred_2084 VDD.$1374.Metal2 vin.$303.Metal1 0.00307999f
Cred_2085 VDD.$1374.Metal2 vin.$307.Metal1 5.88438e-05f
Cred_2086 VDD.$1374.Metal2 vin.$538.Metal2 0.00028658f
Cred_2087 VDD.$1374.Metal2 vin.$542.Metal2 0.00293704f
Cred_2088 VDD.$1374.Metal2 vin.$544.Metal2 0.000501564f
Cred_2089 VDD.$1374.Metal2 vin.$547.Metal2 0.00563964f
Cred_2090 VDD.$1374.Metal2 vin.$551.Metal2 6.35555e-05f
Cred_2091 VDD.$1374.Metal2 vin.$65.GatPoly 0.00192751f
Cred_2092 VDD.$1374.Metal2 vin.$73.GatPoly 0.00296087f
Cred_2093 VDD.$1374.Metal2 vin.$77.GatPoly 0.00650345f
Cred_2094 VDD.$1374.Metal2 vin.P26.GatPoly 0.0002715f
Cred_2095 VDD.$1374.Metal2 vin.P27.GatPoly 0.031763f
Cred_2096 VDD.$1374.Metal2 vin.P28.GatPoly 0.0211852f
Cred_2097 VDD.$1374.Metal2 vin.P29.GatPoly 0.0002715f
Cred_2098 VDD.$1374.Metal2 vout.$1226.Metal3 0.0163338f
Cred_2099 VDD.$1374.Metal2 vout.$1292.Metal3 0.0508722f
Cred_2100 VDD.$1374.Metal2 vout.P6.nSD 0.000257324f
Cred_2101 VDD.$1374.Metal2 vout.P6.pSD 0.0144234f
Cred_2102 VDD.$1374.Metal2 vout.P8.pSD 0.0125749f
Cred_2103 VDD.$138.Metal1 vin.P20.GatPoly 0.0122994f
Cred_2104 VDD.$138.Metal1 vout.$1226.Metal3 0.00204642f
Cred_2105 VDD.$138.Metal1 vout.P0.nSD 6.09359e-05f
Cred_2106 VDD.$138.Metal1 vout.P0.pSD 0.00281914f
Cred_2107 VDD.$138.Metal1 vout.P2.nSD 3.22394e-05f
Cred_2108 VDD.$138.Metal1 vout.P2.pSD 0.000176196f
Cred_2109 VDD.$139.Metal1 vin.P20.GatPoly 0.0122918f
Cred_2110 VDD.$139.Metal1 vout.$1226.Metal3 0.00185547f
Cred_2111 VDD.$139.Metal1 vout.P0.nSD 5.52501e-05f
Cred_2112 VDD.$139.Metal1 vout.P0.pSD 0.00257278f
Cred_2113 VDD.$139.Metal1 vout.P2.nSD 2.92312e-05f
Cred_2114 VDD.$139.Metal1 vout.P2.pSD 0.000159755f
Cred_2115 VDD.$1395.Metal2 vin.$291.Metal1 0.00338024f
Cred_2116 VDD.$1395.Metal2 vin.$295.Metal1 0.00709604f
Cred_2117 VDD.$1395.Metal2 vin.$303.Metal1 0.0102126f
Cred_2118 VDD.$1395.Metal2 vin.$307.Metal1 0.000195114f
Cred_2119 VDD.$1395.Metal2 vin.$542.Metal2 0.00878838f
Cred_2120 VDD.$1395.Metal2 vin.$544.Metal2 0.00166308f
Cred_2121 VDD.$1395.Metal2 vin.$547.Metal2 0.0186998f
Cred_2122 VDD.$1395.Metal2 vin.$551.Metal2 0.000210737f
Cred_2123 VDD.$1395.Metal2 vin.$65.GatPoly 0.00639121f
Cred_2124 VDD.$1395.Metal2 vin.$73.GatPoly 0.00981762f
Cred_2125 VDD.$1395.Metal2 vin.$77.GatPoly 0.0215641f
Cred_2126 VDD.$1395.Metal2 vin.P26.GatPoly 0.000900237f
Cred_2127 VDD.$1395.Metal2 vin.P27.GatPoly 0.0726769f
Cred_2128 VDD.$1395.Metal2 vin.P28.GatPoly 0.0750887f
Cred_2129 VDD.$1395.Metal2 vin.P29.GatPoly 0.000900237f
Cred_2130 VDD.$1395.Metal2 vout.$1226.Metal3 0.0541595f
Cred_2131 VDD.$1395.Metal2 vout.$1292.Metal3 0.168682f
Cred_2132 VDD.$1395.Metal2 vout.P6.nSD 0.000853233f
Cred_2133 VDD.$1395.Metal2 vout.P6.pSD 0.0478251f
Cred_2134 VDD.$1395.Metal2 vout.P8.pSD 0.0416958f
Cred_2135 VDD.$140.Metal1 vin.P20.GatPoly 0.0123762f
Cred_2136 VDD.$140.Metal1 vout.$1226.Metal3 0.00224085f
Cred_2137 VDD.$140.Metal1 vout.P0.nSD 6.67255e-05f
Cred_2138 VDD.$140.Metal1 vout.P0.pSD 0.00311773f
Cred_2139 VDD.$140.Metal1 vout.P2.nSD 3.53025e-05f
Cred_2140 VDD.$140.Metal1 vout.P2.pSD 0.000192936f
Cred_2141 VDD.$141.Metal1 vin.P20.GatPoly 0.0177711f
Cred_2142 VDD.$141.Metal1 vout.$1226.Metal3 0.00198949f
Cred_2143 VDD.$141.Metal1 vout.P0.nSD 5.92407e-05f
Cred_2144 VDD.$141.Metal1 vout.P0.pSD 0.00277139f
Cred_2145 VDD.$141.Metal1 vout.P2.nSD 3.13425e-05f
Cred_2146 VDD.$141.Metal1 vout.P2.pSD 0.000171294f
Cred_2147 VDD.$142.Metal1 vin.P20.GatPoly 0.00972568f
Cred_2148 VDD.$1421.Metal2 vin.$551.Metal2 0.00102424f
Cred_2149 VDD.$1421.Metal2 vin.P28.GatPoly 0.0141881f
Cred_2150 VDD.$1421.Metal2 vin.P29.GatPoly 3.79383e-06f
Cred_2151 VDD.$1421.Metal2 vout.$1292.Metal3 0.00298133f
Cred_2152 VDD.$1421.Metal2 vout.P8.pSD 0.00066557f
Cred_2153 VDD.$1427.Metal2 vin.P28.GatPoly 2.5037e-05f
Cred_2154 VDD.$1427.Metal2 vin.P29.GatPoly 3.40079e-05f
Cred_2155 VDD.$1427.Metal2 vout.$1292.Metal3 0.00612176f
Cred_2156 VDD.$1427.Metal2 vout.P8.pSD 0.00267205f
Cred_2157 VDD.$1433.Metal2 vin.$321.Metal1 1.68241e-06f
Cred_2158 VDD.$1433.Metal2 vin.$325.Metal1 3.7654e-06f
Cred_2159 VDD.$1433.Metal2 vin.$558.Metal2 0.000286582f
Cred_2160 VDD.$1433.Metal2 vin.$562.Metal2 0.000286582f
Cred_2161 VDD.$1433.Metal2 vin.P28.GatPoly 1.24649e-05f
Cred_2162 VDD.$1433.Metal2 vin.P29.GatPoly 0.012636f
Cred_2163 VDD.$1433.Metal2 vout.$1292.Metal3 0.00463738f
Cred_2164 VDD.$1433.Metal2 vout.P8.pSD 0.00139707f
Cred_2165 VDD.$1460.Metal2 vin.$321.Metal1 1.68241e-06f
Cred_2166 VDD.$1460.Metal2 vin.$325.Metal1 0.00231374f
Cred_2167 VDD.$1460.Metal2 vin.$331.Metal1 0.0069716f
Cred_2168 VDD.$1460.Metal2 vin.$335.Metal1 0.000335118f
Cred_2169 VDD.$1460.Metal2 vin.$558.Metal2 0.000286582f
Cred_2170 VDD.$1460.Metal2 vin.$562.Metal2 0.0096397f
Cred_2171 VDD.$1460.Metal2 vin.$564.Metal2 0.00125866f
Cred_2172 VDD.$1460.Metal2 vin.$567.Metal2 0.00866104f
Cred_2173 VDD.$1460.Metal2 vin.$87.GatPoly 0.0135885f
Cred_2174 VDD.$1460.Metal2 vin.$93.GatPoly 0.00320648f
Cred_2175 VDD.$1460.Metal2 vin.$97.GatPoly 0.0141281f
Cred_2176 VDD.$1460.Metal2 vin.P28.GatPoly 0.000587254f
Cred_2177 VDD.$1460.Metal2 vin.P29.GatPoly 0.0513691f
Cred_2178 VDD.$1460.Metal2 vin.P30.GatPoly 0.0461567f
Cred_2179 VDD.$1460.Metal2 vin.P31.GatPoly 0.000587254f
Cred_2180 VDD.$1460.Metal2 vout.$1292.Metal3 0.10907f
Cred_2181 VDD.$1460.Metal2 vout.$1358.Metal3 0.0352553f
Cred_2182 VDD.$1460.Metal2 vout.P10.nSD 0.000555414f
Cred_2183 VDD.$1460.Metal2 vout.P10.pSD 0.0307552f
Cred_2184 VDD.$1460.Metal2 vout.P8.pSD 0.0280687f
Cred_2185 VDD.$1480.Metal2 vin.$325.Metal1 0.00230997f
Cred_2186 VDD.$1480.Metal2 vin.$331.Metal1 0.0069716f
Cred_2187 VDD.$1480.Metal2 vin.$335.Metal1 0.000338884f
Cred_2188 VDD.$1480.Metal2 vin.$339.Metal1 1.68249e-06f
Cred_2189 VDD.$1480.Metal2 vin.$562.Metal2 0.00935312f
Cred_2190 VDD.$1480.Metal2 vin.$564.Metal2 0.00125866f
Cred_2191 VDD.$1480.Metal2 vin.$567.Metal2 0.00894764f
Cred_2192 VDD.$1480.Metal2 vin.$571.Metal2 0.000286594f
Cred_2193 VDD.$1480.Metal2 vin.$87.GatPoly 0.0135885f
Cred_2194 VDD.$1480.Metal2 vin.$93.GatPoly 0.00320648f
Cred_2195 VDD.$1480.Metal2 vin.$97.GatPoly 0.0141281f
Cred_2196 VDD.$1480.Metal2 vin.P28.GatPoly 0.000587254f
Cred_2197 VDD.$1480.Metal2 vin.P29.GatPoly 0.0461567f
Cred_2198 VDD.$1480.Metal2 vin.P30.GatPoly 0.0514352f
Cred_2199 VDD.$1480.Metal2 vin.P31.GatPoly 0.000587254f
Cred_2200 VDD.$1480.Metal2 vout.$1292.Metal3 0.109078f
Cred_2201 VDD.$1480.Metal2 vout.$1358.Metal3 0.0352627f
Cred_2202 VDD.$1480.Metal2 vout.P10.nSD 0.000555531f
Cred_2203 VDD.$1480.Metal2 vout.P10.pSD 0.030759f
Cred_2204 VDD.$1480.Metal2 vout.P8.pSD 0.0280687f
Cred_2205 VDD.$1492.Metal2 vin.$335.Metal1 3.7656e-06f
Cred_2206 VDD.$1492.Metal2 vin.$339.Metal1 1.6825e-06f
Cred_2207 VDD.$1492.Metal2 vin.$567.Metal2 0.000286597f
Cred_2208 VDD.$1492.Metal2 vin.$571.Metal2 0.000286597f
Cred_2209 VDD.$1492.Metal2 vin.P30.GatPoly 0.0126999f
Cred_2210 VDD.$1492.Metal2 vout.$1292.Metal3 0.00356588f
Cred_2211 VDD.$1492.Metal2 vout.$1358.Metal3 0.00356588f
Cred_2212 VDD.$1492.Metal2 vout.P10.nSD 5.61771e-05f
Cred_2213 VDD.$1492.Metal2 vout.P10.pSD 0.00303648f
Cred_2214 VDD.$1504.Metal2 vin.$578.Metal2 0.00102424f
Cred_2215 VDD.$1504.Metal2 vin.P31.GatPoly 0.0142301f
Cred_2216 VDD.$1504.Metal2 vout.$1292.Metal3 0.00279324f
Cred_2217 VDD.$1504.Metal2 vout.$1358.Metal3 0.00279324f
Cred_2218 VDD.$1504.Metal2 vout.P10.nSD 4.4005e-05f
Cred_2219 VDD.$1504.Metal2 vout.P10.pSD 0.0022471f
Cred_2220 VDD.$152.Metal1 vin.$199.Metal1 1.06684e-07f
Cred_2221 VDD.$152.Metal1 vin.$478.Metal2 4.30366e-06f
Cred_2222 VDD.$152.Metal1 vin.$7.GatPoly 1.51513e-09f
Cred_2223 VDD.$152.Metal1 vin.P20.GatPoly 0.0205468f
Cred_2224 VDD.$152.Metal1 vin.P21.GatPoly 9.0853e-05f
Cred_2225 VDD.$152.Metal1 vout.$1226.Metal3 0.00485003f
Cred_2226 VDD.$152.Metal1 vout.P0.nSD 0.000144419f
Cred_2227 VDD.$152.Metal1 vout.P0.pSD 0.00436598f
Cred_2228 VDD.$152.Metal1 vout.P2.nSD 7.64077e-05f
Cred_2229 VDD.$152.Metal1 vout.P2.pSD 0.000417585f
Cred_2230 VDD.$1531.Metal2 vin.$107.GatPoly 0.0215641f
Cred_2231 VDD.$1531.Metal2 vin.$115.GatPoly 0.00981762f
Cred_2232 VDD.$1531.Metal2 vin.$123.GatPoly 0.00639121f
Cred_2233 VDD.$1531.Metal2 vin.$353.Metal1 0.000195114f
Cred_2234 VDD.$1531.Metal2 vin.$357.Metal1 0.0102126f
Cred_2235 VDD.$1531.Metal2 vin.$365.Metal1 0.00709604f
Cred_2236 VDD.$1531.Metal2 vin.$369.Metal1 0.00338024f
Cred_2237 VDD.$1531.Metal2 vin.$578.Metal2 0.000210737f
Cred_2238 VDD.$1531.Metal2 vin.$582.Metal2 0.0186998f
Cred_2239 VDD.$1531.Metal2 vin.$584.Metal2 0.00166308f
Cred_2240 VDD.$1531.Metal2 vin.$587.Metal2 0.00878838f
Cred_2241 VDD.$1531.Metal2 vin.P30.GatPoly 0.000900237f
Cred_2242 VDD.$1531.Metal2 vin.P31.GatPoly 0.0750887f
Cred_2243 VDD.$1531.Metal2 vin.P32.GatPoly 0.0727016f
Cred_2244 VDD.$1531.Metal2 vin.P33.GatPoly 0.000900237f
Cred_2245 VDD.$1531.Metal2 vout.$1292.Metal3 0.053177f
Cred_2246 VDD.$1531.Metal2 vout.$1358.Metal3 0.167349f
Cred_2247 VDD.$1531.Metal2 vout.P10.nSD 0.000837753f
Cred_2248 VDD.$1531.Metal2 vout.P10.pSD 0.0480457f
Cred_2249 VDD.$1531.Metal2 vout.P12.pSD 0.0426052f
Cred_2250 VDD.$1551.Metal2 vin.$107.GatPoly 0.00650345f
Cred_2251 VDD.$1551.Metal2 vin.$115.GatPoly 0.00296087f
Cred_2252 VDD.$1551.Metal2 vin.$123.GatPoly 0.00192751f
Cred_2253 VDD.$1551.Metal2 vin.$353.Metal1 5.88438e-05f
Cred_2254 VDD.$1551.Metal2 vin.$357.Metal1 0.00307999f
Cred_2255 VDD.$1551.Metal2 vin.$365.Metal1 0.00214008f
Cred_2256 VDD.$1551.Metal2 vin.$369.Metal1 0.00101944f
Cred_2257 VDD.$1551.Metal2 vin.$578.Metal2 6.35555e-05f
Cred_2258 VDD.$1551.Metal2 vin.$582.Metal2 0.00563964f
Cred_2259 VDD.$1551.Metal2 vin.$584.Metal2 0.000501564f
Cred_2260 VDD.$1551.Metal2 vin.$587.Metal2 0.00265046f
Cred_2261 VDD.$1551.Metal2 vin.P30.GatPoly 0.0002715f
Cred_2262 VDD.$1551.Metal2 vin.P31.GatPoly 0.0211852f
Cred_2263 VDD.$1551.Metal2 vin.P32.GatPoly 0.0266494f
Cred_2264 VDD.$1551.Metal2 vin.P33.GatPoly 0.0002715f
Cred_2265 VDD.$1551.Metal2 vout.$1292.Metal3 0.0160375f
Cred_2266 VDD.$1551.Metal2 vout.$1358.Metal3 0.0504729f
Cred_2267 VDD.$1551.Metal2 vout.P10.nSD 0.000252656f
Cred_2268 VDD.$1551.Metal2 vout.P10.pSD 0.01449f
Cred_2269 VDD.$1551.Metal2 vout.P12.pSD 0.0128496f
Cred_2270 VDD.$1557.Metal2 vin.$365.Metal1 2.74714e-06f
Cred_2271 VDD.$1557.Metal2 vin.$369.Metal1 8.24142e-06f
Cred_2272 VDD.$1557.Metal2 vin.$587.Metal2 0.000577756f
Cred_2273 VDD.$1557.Metal2 vin.$591.Metal2 0.000577756f
Cred_2274 VDD.$1557.Metal2 vin.P32.GatPoly 0.0127693f
Cred_2275 VDD.$1557.Metal2 vout.$1358.Metal3 0.00273824f
Cred_2276 VDD.$1557.Metal2 vout.P12.pSD 0.00100007f
Cred_2277 VDD.$1569.Metal2 vin.$379.Metal1 4.53584e-06f
Cred_2278 VDD.$1569.Metal2 vin.$383.Metal1 4.12392e-06f
Cred_2279 VDD.$1569.Metal2 vin.$387.Metal1 1.9995e-06f
Cred_2280 VDD.$1569.Metal2 vin.$596.Metal2 0.000377474f
Cred_2281 VDD.$1569.Metal2 vin.$603.Metal2 0.000190478f
Cred_2282 VDD.$1569.Metal2 vin.P32.GatPoly 0.00210282f
Cred_2283 VDD.$1569.Metal2 vin.P33.GatPoly 0.00701147f
Cred_2284 VDD.$1569.Metal2 vout.$1358.Metal3 0.00914307f
Cred_2285 VDD.$1569.Metal2 vout.P12.pSD 0.00366508f
Cred_2286 VDD.$1581.Metal2 vin.$127.GatPoly 0.000892017f
Cred_2287 VDD.$1581.Metal2 vin.$135.GatPoly 0.000176101f
Cred_2288 VDD.$1581.Metal2 vin.$137.GatPoly 0.000871859f
Cred_2289 VDD.$1581.Metal2 vin.$379.Metal1 5.44481e-06f
Cred_2290 VDD.$1581.Metal2 vin.$383.Metal1 1.1455e-05f
Cred_2291 VDD.$1581.Metal2 vin.$387.Metal1 0.000395446f
Cred_2292 VDD.$1581.Metal2 vin.$393.Metal1 0.00020875f
Cred_2293 VDD.$1581.Metal2 vin.$593.Metal2 2.47676e-05f
Cred_2294 VDD.$1581.Metal2 vin.$596.Metal2 0.000453119f
Cred_2295 VDD.$1581.Metal2 vin.$599.Metal2 4.23918e-07f
Cred_2296 VDD.$1581.Metal2 vin.$603.Metal2 0.00124761f
Cred_2297 VDD.$1581.Metal2 vin.$604.Metal2 1.11632e-05f
Cred_2298 VDD.$1581.Metal2 vin.$609.Metal2 0.000107192f
Cred_2299 VDD.$1581.Metal2 vin.$613.Metal2 2.47676e-05f
Cred_2300 VDD.$1581.Metal2 vin.P32.GatPoly 3.7654e-05f
Cred_2301 VDD.$1581.Metal2 vin.P33.GatPoly 0.014458f
Cred_2302 VDD.$1581.Metal2 vin.P34.GatPoly 0.00260753f
Cred_2303 VDD.$1581.Metal2 vin.P35.GatPoly 3.7654e-05f
Cred_2304 VDD.$1581.Metal2 vout.$1358.Metal3 0.0080079f
Cred_2305 VDD.$1581.Metal2 vout.$1424.Metal3 0.00238186f
Cred_2306 VDD.$1581.Metal2 vout.P12.pSD 0.00195714f
Cred_2307 VDD.$1581.Metal2 vout.P14.nSD 3.7524e-05f
Cred_2308 VDD.$1581.Metal2 vout.P14.pSD 0.00200913f
Cred_2309 VDD.$1602.Metal2 vin.$127.GatPoly 0.0234898f
Cred_2310 VDD.$1602.Metal2 vin.$135.GatPoly 0.00463733f
Cred_2311 VDD.$1602.Metal2 vin.$137.GatPoly 0.022959f
Cred_2312 VDD.$1602.Metal2 vin.$379.Metal1 2.39364e-05f
Cred_2313 VDD.$1602.Metal2 vin.$383.Metal1 0.000193051f
Cred_2314 VDD.$1602.Metal2 vin.$387.Metal1 0.0103608f
Cred_2315 VDD.$1602.Metal2 vin.$393.Metal1 0.00549707f
Cred_2316 VDD.$1602.Metal2 vin.$593.Metal2 0.000652212f
Cred_2317 VDD.$1602.Metal2 vin.$596.Metal2 0.00199199f
Cred_2318 VDD.$1602.Metal2 vin.$599.Metal2 1.11632e-05f
Cred_2319 VDD.$1602.Metal2 vin.$603.Metal2 0.0278378f
Cred_2320 VDD.$1602.Metal2 vin.$604.Metal2 0.000293964f
Cred_2321 VDD.$1602.Metal2 vin.$609.Metal2 0.00282271f
Cred_2322 VDD.$1602.Metal2 vin.$613.Metal2 0.000652212f
Cred_2323 VDD.$1602.Metal2 vin.P32.GatPoly 0.000991556f
Cred_2324 VDD.$1602.Metal2 vin.P33.GatPoly 0.0686886f
Cred_2325 VDD.$1602.Metal2 vin.P34.GatPoly 0.0722391f
Cred_2326 VDD.$1602.Metal2 vin.P35.GatPoly 0.000991556f
Cred_2327 VDD.$1602.Metal2 vout.$1358.Metal3 0.191461f
Cred_2328 VDD.$1602.Metal2 vout.$1424.Metal3 0.0627223f
Cred_2329 VDD.$1602.Metal2 vout.P12.pSD 0.0483829f
Cred_2330 VDD.$1602.Metal2 vout.P14.nSD 0.000988131f
Cred_2331 VDD.$1602.Metal2 vout.P14.pSD 0.052907f
Cred_2332 VDD.$1628.Metal2 vin.$609.Metal2 0.0011665f
Cred_2333 VDD.$1628.Metal2 vin.P34.GatPoly 0.014685f
Cred_2334 VDD.$1628.Metal2 vout.$1358.Metal3 0.00229291f
Cred_2335 VDD.$1628.Metal2 vout.$1424.Metal3 0.00229291f
Cred_2336 VDD.$1628.Metal2 vout.P14.nSD 3.61227e-05f
Cred_2337 VDD.$1628.Metal2 vout.P14.pSD 0.00180632f
Cred_2338 VDD.$164.Metal1 vin.P20.GatPoly 0.000986062f
Cred_2339 VDD.$164.Metal1 vin.P21.GatPoly 0.0199393f
Cred_2340 VDD.$164.Metal1 vout.$1226.Metal3 0.00678814f
Cred_2341 VDD.$164.Metal1 vout.P0.nSD 0.000202129f
Cred_2342 VDD.$164.Metal1 vout.P0.pSD 0.0064023f
Cred_2343 VDD.$164.Metal1 vout.P2.nSD 0.000106941f
Cred_2344 VDD.$164.Metal1 vout.P2.pSD 0.000584456f
Cred_2345 VDD.$1640.Metal2 vin.$409.Metal1 1.04269e-06f
Cred_2346 VDD.$1640.Metal2 vin.$413.Metal1 4.41139e-06f
Cred_2347 VDD.$1640.Metal2 vin.$616.Metal2 0.000286578f
Cred_2348 VDD.$1640.Metal2 vin.$620.Metal2 0.000286578f
Cred_2349 VDD.$1640.Metal2 vin.P34.GatPoly 0.000533f
Cred_2350 VDD.$1640.Metal2 vin.P35.GatPoly 0.0103275f
Cred_2351 VDD.$1640.Metal2 vout.$1358.Metal3 0.00401361f
Cred_2352 VDD.$1640.Metal2 vout.$1424.Metal3 0.00401361f
Cred_2353 VDD.$1640.Metal2 vout.P14.nSD 6.32306e-05f
Cred_2354 VDD.$1640.Metal2 vout.P14.pSD 0.00354196f
Cred_2355 VDD.$1652.Metal2 vin.$145.GatPoly 0.00162815f
Cred_2356 VDD.$1652.Metal2 vin.$153.GatPoly 0.00456472f
Cred_2357 VDD.$1652.Metal2 vin.$157.GatPoly 0.00875418f
Cred_2358 VDD.$1652.Metal2 vin.$409.Metal1 0.000862155f
Cred_2359 VDD.$1652.Metal2 vin.$413.Metal1 0.00236213f
Cred_2360 VDD.$1652.Metal2 vin.$419.Metal1 0.00418784f
Cred_2361 VDD.$1652.Metal2 vin.$423.Metal1 0.000965854f
Cred_2362 VDD.$1652.Metal2 vin.$616.Metal2 0.000286578f
Cred_2363 VDD.$1652.Metal2 vin.$620.Metal2 0.00436753f
Cred_2364 VDD.$1652.Metal2 vin.$622.Metal2 0.000690494f
Cred_2365 VDD.$1652.Metal2 vin.$625.Metal2 0.00708295f
Cred_2366 VDD.$1652.Metal2 vin.P34.GatPoly 0.00035694f
Cred_2367 VDD.$1652.Metal2 vin.P35.GatPoly 0.0376867f
Cred_2368 VDD.$1652.Metal2 vin.P36.GatPoly 0.0278907f
Cred_2369 VDD.$1652.Metal2 vin.P37.GatPoly 0.00035694f
Cred_2370 VDD.$1652.Metal2 vout.$1358.Metal3 0.0210845f
Cred_2371 VDD.$1652.Metal2 vout.$1424.Metal3 0.0653781f
Cred_2372 VDD.$1652.Metal2 vout.P14.nSD 0.000332166f
Cred_2373 VDD.$1652.Metal2 vout.P14.pSD 0.0190499f
Cred_2374 VDD.$1652.Metal2 vout.P16.pSD 0.016927f
Cred_2375 VDD.$1673.Metal2 vin.$145.GatPoly 0.00371219f
Cred_2376 VDD.$1673.Metal2 vin.$153.GatPoly 0.0104076f
Cred_2377 VDD.$1673.Metal2 vin.$157.GatPoly 0.0199595f
Cred_2378 VDD.$1673.Metal2 vin.$409.Metal1 0.00196334f
Cred_2379 VDD.$1673.Metal2 vin.$413.Metal1 0.0053756f
Cred_2380 VDD.$1673.Metal2 vin.$419.Metal1 0.00954827f
Cred_2381 VDD.$1673.Metal2 vin.$423.Metal1 0.00220492f
Cred_2382 VDD.$1673.Metal2 vin.$427.Metal1 2.06403e-06f
Cred_2383 VDD.$1673.Metal2 vin.$620.Metal2 0.00930457f
Cred_2384 VDD.$1673.Metal2 vin.$622.Metal2 0.00157433f
Cred_2385 VDD.$1673.Metal2 vin.$625.Metal2 0.0164039f
Cred_2386 VDD.$1673.Metal2 vin.$629.Metal2 0.000254753f
Cred_2387 VDD.$1673.Metal2 vin.P34.GatPoly 0.000813824f
Cred_2388 VDD.$1673.Metal2 vin.P35.GatPoly 0.0655001f
Cred_2389 VDD.$1673.Metal2 vin.P36.GatPoly 0.0682271f
Cred_2390 VDD.$1673.Metal2 vin.P37.GatPoly 0.000813824f
Cred_2391 VDD.$1673.Metal2 vout.$1358.Metal3 0.0480726f
Cred_2392 VDD.$1673.Metal2 vout.$1424.Metal3 0.149062f
Cred_2393 VDD.$1673.Metal2 vout.P14.nSD 0.000757338f
Cred_2394 VDD.$1673.Metal2 vout.P14.pSD 0.0434339f
Cred_2395 VDD.$1673.Metal2 vout.P16.pSD 0.0385935f
Cred_2396 VDD.$1699.Metal2 vin.$423.Metal1 2.77577e-06f
Cred_2397 VDD.$1699.Metal2 vin.$427.Metal1 2.06403e-06f
Cred_2398 VDD.$1699.Metal2 vin.$625.Metal2 0.000254753f
Cred_2399 VDD.$1699.Metal2 vin.$629.Metal2 0.000254753f
Cred_2400 VDD.$1699.Metal2 vin.P36.GatPoly 0.0142617f
Cred_2401 VDD.$1699.Metal2 vin.P37.GatPoly 1.05148e-05f
Cred_2402 VDD.$1699.Metal2 vout.$1424.Metal3 0.00640756f
Cred_2403 VDD.$1699.Metal2 vout.P16.pSD 0.00222625f
Cred_2404 VDD.$1711.Metal2 vin.$173.GatPoly 7.79259e-09f
Cred_2405 VDD.$1711.Metal2 vin.$441.Metal1 4.62915e-06f
Cred_2406 VDD.$1711.Metal2 vin.$449.Metal1 6.53122e-07f
Cred_2407 VDD.$1711.Metal2 vin.$636.Metal2 0.000278681f
Cred_2408 VDD.$1711.Metal2 vin.$640.Metal2 0.000278688f
Cred_2409 VDD.$1711.Metal2 vin.P36.GatPoly 1.52001e-05f
Cred_2410 VDD.$1711.Metal2 vin.P37.GatPoly 0.0133509f
Cred_2411 VDD.$1711.Metal2 vout.$1424.Metal3 0.00713781f
Cred_2412 VDD.$1711.Metal2 vout.P16.pSD 0.00255268f
Cred_2413 VDD.$1738.Metal2 vin.$167.GatPoly 0.0155617f
Cred_2414 VDD.$1738.Metal2 vin.$173.GatPoly 0.00328677f
Cred_2415 VDD.$1738.Metal2 vin.$179.GatPoly 0.0141994f
Cred_2416 VDD.$1738.Metal2 vin.$441.Metal1 0.00122868f
Cred_2417 VDD.$1738.Metal2 vin.$449.Metal1 0.00786533f
Cred_2418 VDD.$1738.Metal2 vin.$453.Metal1 0.00347776f
Cred_2419 VDD.$1738.Metal2 vin.$636.Metal2 0.00028168f
Cred_2420 VDD.$1738.Metal2 vin.$640.Metal2 0.0117902f
Cred_2421 VDD.$1738.Metal2 vin.$642.Metal2 0.00141954f
Cred_2422 VDD.$1738.Metal2 vin.$645.Metal2 0.00915772f
Cred_2423 VDD.$1738.Metal2 vin.P36.GatPoly 0.000670511f
Cred_2424 VDD.$1738.Metal2 vin.P37.GatPoly 0.0576473f
Cred_2425 VDD.$1738.Metal2 vin.P38.GatPoly 0.0530675f
Cred_2426 VDD.$1738.Metal2 vin.P39.GatPoly 0.000739311f
Cred_2427 VDD.$1738.Metal2 vout 0.0814297f
Cred_2428 VDD.$1738.Metal2 vout.$1424.Metal3 0.0865784f
Cred_2429 VDD.$1738.Metal2 vout.P16.pSD 0.0320142f
Cred_2430 VDD.$1738.Metal2 vout.P18.pSD 0.0365299f
Cred_2431 VDD.$1758.Metal2 vin.$167.GatPoly 0.0115885f
Cred_2432 VDD.$1758.Metal2 vin.$173.GatPoly 0.00244759f
Cred_2433 VDD.$1758.Metal2 vin.$179.GatPoly 0.010574f
Cred_2434 VDD.$1758.Metal2 vin.$441.Metal1 0.000911526f
Cred_2435 VDD.$1758.Metal2 vin.$449.Metal1 0.00585667f
Cred_2436 VDD.$1758.Metal2 vin.$453.Metal1 0.00259054f
Cred_2437 VDD.$1758.Metal2 vin.$457.Metal1 4.7359e-06f
Cred_2438 VDD.$1758.Metal2 vin.$636.Metal2 2.23338e-06f
Cred_2439 VDD.$1758.Metal2 vin.$640.Metal2 0.00857241f
Cred_2440 VDD.$1758.Metal2 vin.$642.Metal2 0.00105711f
Cred_2441 VDD.$1758.Metal2 vin.$645.Metal2 0.00710616f
Cred_2442 VDD.$1758.Metal2 vin.$649.Metal2 0.000286576f
Cred_2443 VDD.$1758.Metal2 vin.P36.GatPoly 0.000499317f
Cred_2444 VDD.$1758.Metal2 vin.P37.GatPoly 0.039146f
Cred_2445 VDD.$1758.Metal2 vin.P38.GatPoly 0.0467174f
Cred_2446 VDD.$1758.Metal2 vin.P39.GatPoly 0.000550551f
Cred_2447 VDD.$1758.Metal2 vout 0.0606392f
Cred_2448 VDD.$1758.Metal2 vout.$1424.Metal3 0.0644733f
Cred_2449 VDD.$1758.Metal2 vout.P16.pSD 0.0238403f
Cred_2450 VDD.$1758.Metal2 vout.P18.pSD 0.0272031f
Cred_2451 VDD.$177.Metal1 vin.$15.GatPoly 0.0263169f
Cred_2452 VDD.$177.Metal1 vin.$17.GatPoly 0.00703995f
Cred_2453 VDD.$177.Metal1 vin.$207.Metal1 0.00688167f
Cred_2454 VDD.$177.Metal1 vin.$211.Metal1 0.0154449f
Cred_2455 VDD.$177.Metal1 vin.$219.Metal1 0.00233656f
Cred_2456 VDD.$177.Metal1 vin.$482.Metal2 0.00444434f
Cred_2457 VDD.$177.Metal1 vin.$486.Metal2 0.00256492f
Cred_2458 VDD.$177.Metal1 vin.$489.Metal2 0.015696f
Cred_2459 VDD.$177.Metal1 vin.$493.Metal2 5.72493e-06f
Cred_2460 VDD.$177.Metal1 vin.$9.GatPoly 0.0239497f
Cred_2461 VDD.$177.Metal1 vin.P20.GatPoly 0.00114336f
Cred_2462 VDD.$177.Metal1 vin.P21.GatPoly 0.149723f
Cred_2463 VDD.$177.Metal1 vin.P22.GatPoly 0.139817f
Cred_2464 VDD.$177.Metal1 vin.P23.GatPoly 0.00105302f
Cred_2465 VDD.$177.Metal1 vout.$1226.Metal3 0.143842f
Cred_2466 VDD.$177.Metal1 vout.P0.nSD 0.00317787f
Cred_2467 VDD.$177.Metal1 vout.P0.pSD 0.069098f
Cred_2468 VDD.$177.Metal1 vout.P2.nSD 0.00226609f
Cred_2469 VDD.$177.Metal1 vout.P2.pSD 0.0574723f
Cred_2470 VDD.$1770.Metal2 vin.$453.Metal1 7.22425e-07f
Cred_2471 VDD.$1770.Metal2 vin.$457.Metal1 4.7359e-06f
Cred_2472 VDD.$1770.Metal2 vin.$645.Metal2 0.000286576f
Cred_2473 VDD.$1770.Metal2 vin.$649.Metal2 0.000286576f
Cred_2474 VDD.$1770.Metal2 vin.P38.GatPoly 0.0117641f
Cred_2475 VDD.$1770.Metal2 vout 0.00764785f
Cred_2476 VDD.$1770.Metal2 vout.P18.pSD 0.00319131f
Cred_2477 VDD.$1782.Metal2 vin.$179.GatPoly 3.3467e-07f
Cred_2478 VDD.$1782.Metal2 vin.$457.Metal1 1.77384e-05f
Cred_2479 VDD.$1782.Metal2 vin.$649.Metal2 3.76872e-07f
Cred_2480 VDD.$1782.Metal2 vin.$654.Metal2 0.00109086f
Cred_2481 VDD.$1782.Metal2 vin.P39.GatPoly 0.0101889f
Cred_2482 VDD.$1782.Metal2 vout 0.00497725f
Cred_2483 VDD.$1782.Metal2 vout.P18.pSD 0.00185751f
Cred_2484 VDD.$1788.Metal2 vin.P39.GatPoly 0.0121103f
Cred_2485 VDD.$1788.Metal2 vout 1.64128e-05f
Cred_2486 VDD.$1788.Metal2 vout.P18.pSD 5.57893e-06f
Cred_2487 VDD.$1803.Metal2 vin.$179.GatPoly 0.00118098f
Cred_2488 VDD.$1803.Metal2 vin.$457.Metal1 0.0104043f
Cred_2489 VDD.$1803.Metal2 vin.$649.Metal2 0.000220294f
Cred_2490 VDD.$1803.Metal2 vin.$654.Metal2 0.00109297f
Cred_2491 VDD.$1803.Metal2 vin.P39.GatPoly 0.0145471f
Cred_2492 VDD.$1803.Metal2 vout 0.0801014f
Cred_2493 VDD.$1803.Metal2 vout.P18.pSD 0.0218914f
Cred_2494 VDD.$1803.Metal2 VSS.$1055.Metal2 0.00013048f
Cred_2495 VDD.$1803.Metal2 VSS.$1066.Metal2 0.0259268f
Cred_2496 VDD.$1803.Metal2 VSS.$1307.Metal3 0.00436518f
Cred_2497 VDD.$1803.Metal2 VSS.$18.Metal1 1.07744e-07f
Cred_2498 VDD.$1803.Metal2 VSS.$40.Metal1 4.17722e-08f
Cred_2499 VDD.$1803.Metal2 VSS.$501.Metal1 3.67388e-06f
Cred_2500 VDD.$1803.Metal2 VSS.$509.Metal1 0.00149865f
Cred_2501 VDD.$1803.Metal2 VSS.$520.Metal1 8.26115e-07f
Cred_2502 VDD.$1803.Metal2 VSS.$551.Metal1 0.000719169f
Cred_2503 VDD.$1803.Metal2 VSS.P0.pSD 0.000840004f
Cred_2504 VDD.$1803.Metal2 VSS.P21.nSD 6.32907e-06f
Cred_2505 VDD.$1803.Metal2 VSS.P23.nSD 6.32907e-06f
Cred_2506 VDD.$1806.Metal2 vin.P39.GatPoly 0.0120011f
Cred_2507 VDD.$1806.Metal2 vout 0.0358633f
Cred_2508 VDD.$1806.Metal2 vout.P18.pSD 0.0112851f
Cred_2509 VDD.$1808.Metal2 vin.P39.GatPoly 0.00960931f
Cred_2510 VDD.$1808.Metal2 vout 0.0281209f
Cred_2511 VDD.$1808.Metal2 vout.P18.pSD 0.00943734f
Cred_2512 VDD.$1810.Metal2 vin.P39.GatPoly 0.00720326f
Cred_2513 VDD.$1810.Metal2 vout 0.0209298f
Cred_2514 VDD.$1810.Metal2 vout.P18.pSD 0.00724722f
Cred_2515 VDD.$1811.Metal2 vin.P39.GatPoly 0.00720906f
Cred_2516 VDD.$1811.Metal2 vout 0.0207393f
Cred_2517 VDD.$1811.Metal2 vout.P18.pSD 0.00733897f
Cred_2518 VDD.$1813.Metal2 vin.P39.GatPoly 0.0106879f
Cred_2519 VDD.$1813.Metal2 vout 0.0239104f
Cred_2520 VDD.$1813.Metal2 vout.P18.pSD 0.00866866f
Cred_2521 VDD.$1815.Metal2 vin.P39.GatPoly 0.000974323f
Cred_2522 VDD.$1822.Metal2 vin.P39.GatPoly 0.000396902f
Cred_2523 VDD.$1884.Metal3 vin.P20.GatPoly 0.00354335f
Cred_2524 VDD.$1896.Metal3 vin.$199.Metal1 1.06684e-07f
Cred_2525 VDD.$1896.Metal3 vin.$478.Metal2 4.30366e-06f
Cred_2526 VDD.$1896.Metal3 vin.$7.GatPoly 1.51513e-09f
Cred_2527 VDD.$1896.Metal3 vin.P20.GatPoly 0.0140377f
Cred_2528 VDD.$1896.Metal3 vout.$1226.Metal3 0.00506622f
Cred_2529 VDD.$1896.Metal3 vout.P0.nSD 0.000150856f
Cred_2530 VDD.$1896.Metal3 vout.P0.pSD 0.00236294f
Cred_2531 VDD.$1896.Metal3 vout.P2.nSD 7.98136e-05f
Cred_2532 VDD.$1896.Metal3 vout.P2.pSD 0.0004362f
Cred_2533 VDD.$1902.Metal3 vin.P21.GatPoly 0.0104237f
Cred_2534 VDD.$1902.Metal3 vin.P22.GatPoly 0.000428926f
Cred_2535 VDD.$1902.Metal3 vout.$1226.Metal3 0.00715121f
Cred_2536 VDD.$1902.Metal3 vout.P0.nSD 0.000212941f
Cred_2537 VDD.$1902.Metal3 vout.P0.pSD 0.00333821f
Cred_2538 VDD.$1902.Metal3 vout.P2.nSD 0.000112661f
Cred_2539 VDD.$1902.Metal3 vout.P2.pSD 0.000615716f
Cred_2540 VDD.$1914.Metal3 vin.$17.GatPoly 6.24793e-11f
Cred_2541 VDD.$1914.Metal3 vin.$211.Metal1 5.23659e-09f
Cred_2542 VDD.$1914.Metal3 vin.$219.Metal1 3.71155e-08f
Cred_2543 VDD.$1914.Metal3 vin.$489.Metal2 2.23446e-06f
Cred_2544 VDD.$1914.Metal3 vin.$493.Metal2 2.2344e-06f
Cred_2545 VDD.$1914.Metal3 vin.P21.GatPoly 0.00411181f
Cred_2546 VDD.$1914.Metal3 vin.P22.GatPoly 0.0135848f
Cred_2547 VDD.$1914.Metal3 vin.P23.GatPoly 0.000949761f
Cred_2548 VDD.$1914.Metal3 vout.$1226.Metal3 0.00691211f
Cred_2549 VDD.$1914.Metal3 vout.P0.nSD 0.000100098f
Cred_2550 VDD.$1914.Metal3 vout.P0.pSD 0.000531905f
Cred_2551 VDD.$1914.Metal3 vout.P2.nSD 0.000108894f
Cred_2552 VDD.$1914.Metal3 vout.P2.pSD 0.00221982f
Cred_2553 VDD.$1926.Metal3 vin.$233.Metal1 1.65489e-08f
Cred_2554 VDD.$1926.Metal3 vin.$237.Metal1 2.22555e-08f
Cred_2555 VDD.$1926.Metal3 vin.$500.Metal2 2.04255e-06f
Cred_2556 VDD.$1926.Metal3 vin.$504.Metal2 2.04255e-06f
Cred_2557 VDD.$1926.Metal3 vin.P22.GatPoly 0.000657002f
Cred_2558 VDD.$1926.Metal3 vin.P23.GatPoly 0.0131684f
Cred_2559 VDD.$1926.Metal3 vin.P24.GatPoly 0.00148432f
Cred_2560 VDD.$1926.Metal3 vout.$1226.Metal3 0.00657177f
Cred_2561 VDD.$1926.Metal3 vout.P0.nSD 9.51694e-05f
Cred_2562 VDD.$1926.Metal3 vout.P0.pSD 0.000505715f
Cred_2563 VDD.$1926.Metal3 vout.P2.nSD 0.000103532f
Cred_2564 VDD.$1926.Metal3 vout.P2.pSD 0.00211052f
Cred_2565 VDD.$1935.Metal3 vin.$247.Metal1 3.53695e-08f
Cred_2566 VDD.$1935.Metal3 vin.$251.Metal1 8.36007e-09f
Cred_2567 VDD.$1935.Metal3 vin.$509.Metal2 2.29772e-06f
Cred_2568 VDD.$1935.Metal3 vin.$513.Metal2 2.29772e-06f
Cred_2569 VDD.$1935.Metal3 vin.P24.GatPoly 0.0128015f
Cred_2570 VDD.$1935.Metal3 vin.P25.GatPoly 0.00158839f
Cred_2571 VDD.$1935.Metal3 vout.$1226.Metal3 0.00891078f
Cred_2572 VDD.$1935.Metal3 vout.P4.pSD 0.00175797f
Cred_2573 VDD.$1947.Metal3 vin.P25.GatPoly 0.0128419f
Cred_2574 VDD.$1947.Metal3 vin.P26.GatPoly 0.00532815f
Cred_2575 VDD.$1947.Metal3 vout.$1226.Metal3 0.00712737f
Cred_2576 VDD.$1947.Metal3 vout.$1292.Metal3 0.000247216f
Cred_2577 VDD.$1947.Metal3 vout.P4.pSD 0.00135798f
Cred_2578 VDD.$1947.Metal3 vout.P6.nSD 3.89465e-06f
Cred_2579 VDD.$1947.Metal3 vout.P6.pSD 0.000123637f
Cred_2580 VDD.$1959.Metal3 vin.P26.GatPoly 0.00891174f
Cred_2581 VDD.$1959.Metal3 vout.$1226.Metal3 0.00552626f
Cred_2582 VDD.$1959.Metal3 vout.$1292.Metal3 0.00552626f
Cred_2583 VDD.$1959.Metal3 vout.P6.nSD 8.70611e-05f
Cred_2584 VDD.$1959.Metal3 vout.P6.pSD 0.0027692f
Cred_2585 VDD.$1965.Metal3 vin.$291.Metal1 3.27761e-08f
Cred_2586 VDD.$1965.Metal3 vin.$295.Metal1 1.09254e-08f
Cred_2587 VDD.$1965.Metal3 vin.$538.Metal2 2.29774e-06f
Cred_2588 VDD.$1965.Metal3 vin.$542.Metal2 2.29774e-06f
Cred_2589 VDD.$1965.Metal3 vin.P27.GatPoly 0.0125898f
Cred_2590 VDD.$1965.Metal3 vout.$1226.Metal3 0.00158442f
Cred_2591 VDD.$1965.Metal3 vout.$1292.Metal3 0.00158442f
Cred_2592 VDD.$1965.Metal3 vout.P6.nSD 2.4961e-05f
Cred_2593 VDD.$1965.Metal3 vout.P6.pSD 0.000792395f
Cred_2594 VDD.$1974.Metal3 vin.P27.GatPoly 0.00173171f
Cred_2595 VDD.$1974.Metal3 vin.P28.GatPoly 0.0134465f
Cred_2596 VDD.$1974.Metal3 vin.P29.GatPoly 0.000473177f
Cred_2597 VDD.$1974.Metal3 vout.$1292.Metal3 0.00759833f
Cred_2598 VDD.$1974.Metal3 vout.P8.pSD 0.0014967f
Cred_2599 VDD.$1986.Metal3 vin.$321.Metal1 1.34892e-08f
Cred_2600 VDD.$1986.Metal3 vin.$325.Metal1 3.01902e-08f
Cred_2601 VDD.$1986.Metal3 vin.$558.Metal2 2.29775e-06f
Cred_2602 VDD.$1986.Metal3 vin.$562.Metal2 2.29775e-06f
Cred_2603 VDD.$1986.Metal3 vin.P28.GatPoly 0.00112337f
Cred_2604 VDD.$1986.Metal3 vin.P29.GatPoly 0.0125857f
Cred_2605 VDD.$1986.Metal3 vout.$1292.Metal3 0.0084918f
Cred_2606 VDD.$1986.Metal3 vout.P8.pSD 0.00167269f
Cred_2607 VDD.$2001.Metal3 vin.$335.Metal1 1.26502e-08f
Cred_2608 VDD.$2001.Metal3 vin.$339.Metal1 5.65224e-09f
Cred_2609 VDD.$2001.Metal3 vin.$567.Metal2 9.62799e-07f
Cred_2610 VDD.$2001.Metal3 vin.$571.Metal2 9.62799e-07f
Cred_2611 VDD.$2001.Metal3 vin.P30.GatPoly 0.00601435f
Cred_2612 VDD.$2001.Metal3 vin.P31.GatPoly 0.00228285f
Cred_2613 VDD.$2001.Metal3 vout.$1292.Metal3 0.00657052f
Cred_2614 VDD.$2001.Metal3 vout.$1358.Metal3 0.00657052f
Cred_2615 VDD.$2001.Metal3 vout.P10.nSD 0.000103512f
Cred_2616 VDD.$2001.Metal3 vout.P10.pSD 0.00342719f
Cred_2617 VDD.$2007.Metal3 vin.P31.GatPoly 0.0123232f
Cred_2618 VDD.$2007.Metal3 vin.P32.GatPoly 0.00480679f
Cred_2619 VDD.$2007.Metal3 vout.$1292.Metal3 0.000919926f
Cred_2620 VDD.$2007.Metal3 vout.$1358.Metal3 0.000919926f
Cred_2621 VDD.$2007.Metal3 vout.P10.nSD 1.44926e-05f
Cred_2622 VDD.$2007.Metal3 vout.P10.pSD 0.000479036f
Cred_2623 VDD.$2019.Metal3 vin.P32.GatPoly 0.00934092f
Cred_2624 VDD.$2019.Metal3 vout.$1358.Metal3 0.0122791f
Cred_2625 VDD.$2019.Metal3 vout.P12.pSD 0.00254808f
Cred_2626 VDD.$2025.Metal3 vin.$379.Metal1 3.63673e-08f
Cred_2627 VDD.$2025.Metal3 vin.$383.Metal1 3.30647e-08f
Cred_2628 VDD.$2025.Metal3 vin.$387.Metal1 1.60315e-08f
Cred_2629 VDD.$2025.Metal3 vin.$596.Metal2 3.0265e-06f
Cred_2630 VDD.$2025.Metal3 vin.$603.Metal2 1.52721e-06f
Cred_2631 VDD.$2025.Metal3 vin.P33.GatPoly 0.0120253f
Cred_2632 VDD.$2025.Metal3 vout.$1358.Metal3 0.00541014f
Cred_2633 VDD.$2025.Metal3 vout.P12.pSD 0.00112088f
Cred_2634 VDD.$2034.Metal3 vin.P33.GatPoly 0.0023914f
Cred_2635 VDD.$2034.Metal3 vin.P34.GatPoly 0.0128419f
Cred_2636 VDD.$2034.Metal3 vout.$1358.Metal3 0.00367769f
Cred_2637 VDD.$2034.Metal3 vout.$1424.Metal3 0.00367769f
Cred_2638 VDD.$2034.Metal3 vout.P14.nSD 5.79385e-05f
Cred_2639 VDD.$2034.Metal3 vout.P14.pSD 0.00191782f
Cred_2640 VDD.$2046.Metal3 vin.$409.Metal1 8.36007e-09f
Cred_2641 VDD.$2046.Metal3 vin.$413.Metal1 3.53695e-08f
Cred_2642 VDD.$2046.Metal3 vin.$616.Metal2 2.29772e-06f
Cred_2643 VDD.$2046.Metal3 vin.$620.Metal2 2.29772e-06f
Cred_2644 VDD.$2046.Metal3 vin.P34.GatPoly 0.00158839f
Cred_2645 VDD.$2046.Metal3 vin.P35.GatPoly 0.0128015f
Cred_2646 VDD.$2046.Metal3 vout.$1358.Metal3 0.00463594f
Cred_2647 VDD.$2046.Metal3 vout.$1424.Metal3 0.00463594f
Cred_2648 VDD.$2046.Metal3 vout.P14.nSD 7.30349e-05f
Cred_2649 VDD.$2046.Metal3 vout.P14.pSD 0.00241682f
Cred_2650 VDD.$2055.Metal3 vin.$423.Metal1 2.22555e-08f
Cred_2651 VDD.$2055.Metal3 vin.$427.Metal1 1.65489e-08f
Cred_2652 VDD.$2055.Metal3 vin.$625.Metal2 2.04255e-06f
Cred_2653 VDD.$2055.Metal3 vin.$629.Metal2 2.04255e-06f
Cred_2654 VDD.$2055.Metal3 vin.P35.GatPoly 0.00148432f
Cred_2655 VDD.$2055.Metal3 vin.P36.GatPoly 0.0131684f
Cred_2656 VDD.$2055.Metal3 vin.P37.GatPoly 0.000657023f
Cred_2657 VDD.$2055.Metal3 vout.$1424.Metal3 0.0085334f
Cred_2658 VDD.$2055.Metal3 vout.P16.pSD 0.00177119f
Cred_2659 VDD.$2067.Metal3 vin.$173.GatPoly 6.24793e-11f
Cred_2660 VDD.$2067.Metal3 vin.$441.Metal1 3.71155e-08f
Cred_2661 VDD.$2067.Metal3 vin.$449.Metal1 5.23659e-09f
Cred_2662 VDD.$2067.Metal3 vin.$636.Metal2 2.2344e-06f
Cred_2663 VDD.$2067.Metal3 vin.$640.Metal2 2.23446e-06f
Cred_2664 VDD.$2067.Metal3 vin.P36.GatPoly 0.000949791f
Cred_2665 VDD.$2067.Metal3 vin.P37.GatPoly 0.0134433f
Cred_2666 VDD.$2067.Metal3 vin.P38.GatPoly 0.00107201f
Cred_2667 VDD.$2067.Metal3 vout.$1424.Metal3 0.00893607f
Cred_2668 VDD.$2067.Metal3 vout.P16.pSD 0.00185463f
Cred_2669 VDD.$2076.Metal3 vin.$453.Metal1 5.79224e-09f
Cred_2670 VDD.$2076.Metal3 vin.$457.Metal1 3.79714e-08f
Cred_2671 VDD.$2076.Metal3 vin.$645.Metal2 2.2977e-06f
Cred_2672 VDD.$2076.Metal3 vin.$649.Metal2 2.2977e-06f
Cred_2673 VDD.$2076.Metal3 vin.P37.GatPoly 0.000577237f
Cred_2674 VDD.$2076.Metal3 vin.P38.GatPoly 0.0130339f
Cred_2675 VDD.$2076.Metal3 vout 0.00295747f
Cred_2676 VDD.$2076.Metal3 vout.P18.pSD 0.000737052f
Cred_2677 VDD.$2082.Metal3 vin.P38.GatPoly 0.000588003f
Cred_2678 VDD.$2082.Metal3 vin.P39.GatPoly 0.00692341f
Cred_2679 VDD.$2082.Metal3 vout 0.0123737f
Cred_2680 VDD.$2082.Metal3 vout.P18.pSD 0.00308944f
Cred_2681 VDD.$2091.Metal3 vin.P39.GatPoly 0.0106482f
Cred_2682 VDD.$2091.Metal3 vout 0.00108237f
Cred_2683 VDD.$2091.Metal3 vout.P18.pSD 0.000269745f
Cred_2684 VDD.$230.Metal1 vin.$17.GatPoly 6.24793e-11f
Cred_2685 VDD.$230.Metal1 vin.$211.Metal1 5.23659e-09f
Cred_2686 VDD.$230.Metal1 vin.$219.Metal1 3.71155e-08f
Cred_2687 VDD.$230.Metal1 vin.$489.Metal2 2.23446e-06f
Cred_2688 VDD.$230.Metal1 vin.$493.Metal2 2.2344e-06f
Cred_2689 VDD.$230.Metal1 vin.P22.GatPoly 0.0150929f
Cred_2690 VDD.$230.Metal1 vout.$1226.Metal3 0.000147902f
Cred_2691 VDD.$230.Metal1 vout.P0.nSD 2.14184e-06f
Cred_2692 VDD.$230.Metal1 vout.P0.pSD 1.13814e-05f
Cred_2693 VDD.$230.Metal1 vout.P2.nSD 2.33005e-06f
Cred_2694 VDD.$230.Metal1 vout.P2.pSD 7.64178e-05f
Cred_2695 VDD.$237.Metal1 vin.P22.GatPoly 0.0116661f
Cred_2696 VDD.$237.Metal1 vin.P23.GatPoly 0.00481307f
Cred_2697 VDD.$237.Metal1 vout.$1226.Metal3 0.00854362f
Cred_2698 VDD.$237.Metal1 vout.P0.nSD 0.000123725f
Cred_2699 VDD.$237.Metal1 vout.P0.pSD 0.000657454f
Cred_2700 VDD.$237.Metal1 vout.P2.nSD 0.000134597f
Cred_2701 VDD.$237.Metal1 vout.P2.pSD 0.00646411f
Cred_2702 VDD.$252.Metal1 vin.$233.Metal1 1.65489e-08f
Cred_2703 VDD.$252.Metal1 vin.$237.Metal1 2.22555e-08f
Cred_2704 VDD.$252.Metal1 vin.$500.Metal2 2.04255e-06f
Cred_2705 VDD.$252.Metal1 vin.$504.Metal2 2.04255e-06f
Cred_2706 VDD.$252.Metal1 vin.P23.GatPoly 0.0225336f
Cred_2707 VDD.$252.Metal1 vout.$1226.Metal3 0.00389718f
Cred_2708 VDD.$252.Metal1 vout.P0.nSD 5.64372e-05f
Cred_2709 VDD.$252.Metal1 vout.P0.pSD 0.000299898f
Cred_2710 VDD.$252.Metal1 vout.P2.nSD 6.13964e-05f
Cred_2711 VDD.$252.Metal1 vout.P2.pSD 0.00305091f
Cred_2712 VDD.$257.Metal1 vin.$237.Metal1 0.00359453f
Cred_2713 VDD.$257.Metal1 vin.$241.Metal1 0.0153629f
Cred_2714 VDD.$257.Metal1 vin.$247.Metal1 0.00781892f
Cred_2715 VDD.$257.Metal1 vin.$25.GatPoly 0.0282708f
Cred_2716 VDD.$257.Metal1 vin.$251.Metal1 0.00273151f
Cred_2717 VDD.$257.Metal1 vin.$37.GatPoly 0.0161598f
Cred_2718 VDD.$257.Metal1 vin.$43.GatPoly 0.00516462f
Cred_2719 VDD.$257.Metal1 vin.$504.Metal2 0.0137f
Cred_2720 VDD.$257.Metal1 vin.$506.Metal2 0.00133475f
Cred_2721 VDD.$257.Metal1 vin.$509.Metal2 0.0079159f
Cred_2722 VDD.$257.Metal1 vin.P22.GatPoly 0.00105234f
Cred_2723 VDD.$257.Metal1 vin.P23.GatPoly 0.139314f
Cred_2724 VDD.$257.Metal1 vin.P24.GatPoly 0.146168f
Cred_2725 VDD.$257.Metal1 vin.P25.GatPoly 0.00105234f
Cred_2726 VDD.$257.Metal1 vout.$1226.Metal3 0.165399f
Cred_2727 VDD.$257.Metal1 vout.P0.nSD 0.00108727f
Cred_2728 VDD.$257.Metal1 vout.P0.pSD 0.00577759f
Cred_2729 VDD.$257.Metal1 vout.P2.nSD 0.00118281f
Cred_2730 VDD.$257.Metal1 vout.P2.pSD 0.0520725f
Cred_2731 VDD.$257.Metal1 vout.P4.pSD 0.0462192f
Cred_2732 VDD.$315.Metal1 vin.$247.Metal1 3.53695e-08f
Cred_2733 VDD.$315.Metal1 vin.$251.Metal1 8.36007e-09f
Cred_2734 VDD.$315.Metal1 vin.$509.Metal2 2.29772e-06f
Cred_2735 VDD.$315.Metal1 vin.$513.Metal2 2.29772e-06f
Cred_2736 VDD.$315.Metal1 vin.P24.GatPoly 0.0217412f
Cred_2737 VDD.$315.Metal1 vout.$1226.Metal3 0.00353504f
Cred_2738 VDD.$315.Metal1 vout.P4.pSD 0.00167612f
Cred_2739 VDD.$325.Metal1 vin.P24.GatPoly 0.00376795f
Cred_2740 VDD.$325.Metal1 vin.P25.GatPoly 0.0105446f
Cred_2741 VDD.$325.Metal1 vout.$1226.Metal3 0.0111426f
Cred_2742 VDD.$325.Metal1 vout.P4.pSD 0.00657889f
Cred_2743 VDD.$337.Metal1 vin.P25.GatPoly 0.0201568f
Cred_2744 VDD.$337.Metal1 vin.P26.GatPoly 0.000377142f
Cred_2745 VDD.$337.Metal1 vout.$1226.Metal3 0.0012546f
Cred_2746 VDD.$337.Metal1 vout.P4.pSD 0.000477856f
Cred_2747 VDD.$376.Metal1 vin.$265.Metal1 0.00895697f
Cred_2748 VDD.$376.Metal1 vin.$273.Metal1 0.017099f
Cred_2749 VDD.$376.Metal1 vin.$277.Metal1 0.000312019f
Cred_2750 VDD.$376.Metal1 vin.$281.Metal1 1.94904e-05f
Cred_2751 VDD.$376.Metal1 vin.$47.GatPoly 0.0326854f
Cred_2752 VDD.$376.Metal1 vin.$515.Metal2 0.000531069f
Cred_2753 VDD.$376.Metal1 vin.$520.Metal2 0.00229955f
Cred_2754 VDD.$376.Metal1 vin.$523.Metal2 0.000239362f
Cred_2755 VDD.$376.Metal1 vin.$527.Metal2 0.0227296f
Cred_2756 VDD.$376.Metal1 vin.$528.Metal2 9.0897e-06f
Cred_2757 VDD.$376.Metal1 vin.$53.GatPoly 0.00974692f
Cred_2758 VDD.$376.Metal1 vin.$533.Metal2 0.001622f
Cred_2759 VDD.$376.Metal1 vin.$535.Metal2 0.000531069f
Cred_2760 VDD.$376.Metal1 vin.$57.GatPoly 0.0337709f
Cred_2761 VDD.$376.Metal1 vin.P24.GatPoly 0.00129442f
Cred_2762 VDD.$376.Metal1 vin.P25.GatPoly 0.168053f
Cred_2763 VDD.$376.Metal1 vin.P26.GatPoly 0.168261f
Cred_2764 VDD.$376.Metal1 vin.P27.GatPoly 0.00129442f
Cred_2765 VDD.$376.Metal1 vout.$1226.Metal3 0.161946f
Cred_2766 VDD.$376.Metal1 vout.$1292.Metal3 0.0516131f
Cred_2767 VDD.$376.Metal1 vout.P4.pSD 0.0583f
Cred_2768 VDD.$376.Metal1 vout.P6.nSD 0.000813117f
Cred_2769 VDD.$376.Metal1 vout.P6.pSD 0.0590842f
Cred_2770 VDD.$393.Metal1 vin.P26.GatPoly 0.0193195f
Cred_2771 VDD.$393.Metal1 vout.$1226.Metal3 0.000369988f
Cred_2772 VDD.$393.Metal1 vout.$1292.Metal3 0.000369988f
Cred_2773 VDD.$393.Metal1 vout.P6.nSD 5.82881e-06f
Cred_2774 VDD.$393.Metal1 vout.P6.pSD 0.000150405f
Cred_2775 VDD.$403.Metal1 vin.P26.GatPoly 0.0106676f
Cred_2776 VDD.$403.Metal1 vin.P27.GatPoly 0.00366944f
Cred_2777 VDD.$403.Metal1 vout.$1226.Metal3 0.00527672f
Cred_2778 VDD.$403.Metal1 vout.$1292.Metal3 0.00527672f
Cred_2779 VDD.$403.Metal1 vout.P6.nSD 8.31298e-05f
Cred_2780 VDD.$403.Metal1 vout.P6.pSD 0.00737183f
Cred_2781 VDD.$415.Metal1 vin.$291.Metal1 3.27761e-08f
Cred_2782 VDD.$415.Metal1 vin.$295.Metal1 1.09254e-08f
Cred_2783 VDD.$415.Metal1 vin.$538.Metal2 2.29774e-06f
Cred_2784 VDD.$415.Metal1 vin.$542.Metal2 2.29774e-06f
Cred_2785 VDD.$415.Metal1 vin.P27.GatPoly 0.0219976f
Cred_2786 VDD.$415.Metal1 vout.$1226.Metal3 0.00187034f
Cred_2787 VDD.$415.Metal1 vout.$1292.Metal3 0.00187034f
Cred_2788 VDD.$415.Metal1 vout.P6.nSD 2.94654e-05f
Cred_2789 VDD.$415.Metal1 vout.P6.pSD 0.00217037f
Cred_2790 VDD.$423.Metal1 vin.$291.Metal1 0.00425071f
Cred_2791 VDD.$423.Metal1 vin.$295.Metal1 0.00965228f
Cred_2792 VDD.$423.Metal1 vin.$303.Metal1 0.0146255f
Cred_2793 VDD.$423.Metal1 vin.$307.Metal1 0.000305593f
Cred_2794 VDD.$423.Metal1 vin.$542.Metal2 0.00675532f
Cred_2795 VDD.$423.Metal1 vin.$544.Metal2 0.00127335f
Cred_2796 VDD.$423.Metal1 vin.$547.Metal2 0.0143436f
Cred_2797 VDD.$423.Metal1 vin.$551.Metal2 0.000161352f
Cred_2798 VDD.$423.Metal1 vin.$65.GatPoly 0.00803706f
Cred_2799 VDD.$423.Metal1 vin.$73.GatPoly 0.01444f
Cred_2800 VDD.$423.Metal1 vin.$77.GatPoly 0.027376f
Cred_2801 VDD.$423.Metal1 vin.P26.GatPoly 0.00105163f
Cred_2802 VDD.$423.Metal1 vin.P27.GatPoly 0.146069f
Cred_2803 VDD.$423.Metal1 vin.P28.GatPoly 0.138102f
Cred_2804 VDD.$423.Metal1 vin.P29.GatPoly 0.00105163f
Cred_2805 VDD.$423.Metal1 vout.$1226.Metal3 0.0427388f
Cred_2806 VDD.$423.Metal1 vout.$1292.Metal3 0.130841f
Cred_2807 VDD.$423.Metal1 vout.P6.nSD 0.00067331f
Cred_2808 VDD.$423.Metal1 vout.P6.pSD 0.0510671f
Cred_2809 VDD.$423.Metal1 vout.P8.pSD 0.0443791f
Cred_2810 VDD.$476.Metal1 vin.P28.GatPoly 0.0146185f
Cred_2811 VDD.$476.Metal1 vout.$1292.Metal3 0.000243178f
Cred_2812 VDD.$476.Metal1 vout.P8.pSD 3.7071e-05f
Cred_2813 VDD.$483.Metal1 vin.P28.GatPoly 0.0130839f
Cred_2814 VDD.$483.Metal1 vin.P29.GatPoly 0.00315872f
Cred_2815 VDD.$483.Metal1 vout.$1292.Metal3 0.00943806f
Cred_2816 VDD.$483.Metal1 vout.P8.pSD 0.00559485f
Cred_2817 VDD.$498.Metal1 vin.$321.Metal1 1.34892e-08f
Cred_2818 VDD.$498.Metal1 vin.$325.Metal1 3.01902e-08f
Cred_2819 VDD.$498.Metal1 vin.$558.Metal2 2.29775e-06f
Cred_2820 VDD.$498.Metal1 vin.$562.Metal2 2.29775e-06f
Cred_2821 VDD.$498.Metal1 vin.P28.GatPoly 0.000413897f
Cred_2822 VDD.$498.Metal1 vin.P29.GatPoly 0.0207239f
Cred_2823 VDD.$498.Metal1 vout.$1292.Metal3 0.00601319f
Cred_2824 VDD.$498.Metal1 vout.P8.pSD 0.0033477f
Cred_2825 VDD.$518.Metal1 vin.$325.Metal1 0.00249587f
Cred_2826 VDD.$518.Metal1 vin.$331.Metal1 0.00763577f
Cred_2827 VDD.$518.Metal1 vin.$335.Metal1 0.000392262f
Cred_2828 VDD.$518.Metal1 vin.$562.Metal2 0.00548653f
Cred_2829 VDD.$518.Metal1 vin.$564.Metal2 0.000735589f
Cred_2830 VDD.$518.Metal1 vin.$567.Metal2 0.00506333f
Cred_2831 VDD.$518.Metal1 vin.$87.GatPoly 0.0130081f
Cred_2832 VDD.$518.Metal1 vin.$93.GatPoly 0.00409559f
Cred_2833 VDD.$518.Metal1 vin.$97.GatPoly 0.0136988f
Cred_2834 VDD.$518.Metal1 vin.P28.GatPoly 0.000522501f
Cred_2835 VDD.$518.Metal1 vin.P29.GatPoly 0.0741851f
Cred_2836 VDD.$518.Metal1 vin.P30.GatPoly 0.0676029f
Cred_2837 VDD.$518.Metal1 vin.P31.GatPoly 0.000522501f
Cred_2838 VDD.$518.Metal1 vout.$1292.Metal3 0.0653448f
Cred_2839 VDD.$518.Metal1 vout.$1358.Metal3 0.020761f
Cred_2840 VDD.$518.Metal1 vout.P10.nSD 0.000327069f
Cred_2841 VDD.$518.Metal1 vout.P10.pSD 0.0242459f
Cred_2842 VDD.$518.Metal1 vout.P8.pSD 0.0235173f
Cred_2843 VDD.$554.Metal1 vin.$325.Metal1 0.00249587f
Cred_2844 VDD.$554.Metal1 vin.$331.Metal1 0.00763577f
Cred_2845 VDD.$554.Metal1 vin.$335.Metal1 0.000392262f
Cred_2846 VDD.$554.Metal1 vin.$562.Metal2 0.00548653f
Cred_2847 VDD.$554.Metal1 vin.$564.Metal2 0.000735589f
Cred_2848 VDD.$554.Metal1 vin.$567.Metal2 0.00506333f
Cred_2849 VDD.$554.Metal1 vin.$87.GatPoly 0.0130081f
Cred_2850 VDD.$554.Metal1 vin.$93.GatPoly 0.00409559f
Cred_2851 VDD.$554.Metal1 vin.$97.GatPoly 0.0136988f
Cred_2852 VDD.$554.Metal1 vin.P28.GatPoly 0.000522501f
Cred_2853 VDD.$554.Metal1 vin.P29.GatPoly 0.0676029f
Cred_2854 VDD.$554.Metal1 vin.P30.GatPoly 0.0741851f
Cred_2855 VDD.$554.Metal1 vin.P31.GatPoly 0.000522501f
Cred_2856 VDD.$554.Metal1 vout.$1292.Metal3 0.0653448f
Cred_2857 VDD.$554.Metal1 vout.$1358.Metal3 0.020761f
Cred_2858 VDD.$554.Metal1 vout.P10.nSD 0.000327069f
Cred_2859 VDD.$554.Metal1 vout.P10.pSD 0.0242459f
Cred_2860 VDD.$554.Metal1 vout.P8.pSD 0.0235173f
Cred_2861 VDD.$561.Metal1 vin.$335.Metal1 3.0191e-08f
Cred_2862 VDD.$561.Metal1 vin.$339.Metal1 1.34896e-08f
Cred_2863 VDD.$561.Metal1 vin.$567.Metal2 2.29781e-06f
Cred_2864 VDD.$561.Metal1 vin.$571.Metal2 2.29781e-06f
Cred_2865 VDD.$561.Metal1 vin.P30.GatPoly 0.0191528f
Cred_2866 VDD.$561.Metal1 vout.$1292.Metal3 0.00135036f
Cred_2867 VDD.$561.Metal1 vout.$1358.Metal3 0.00135036f
Cred_2868 VDD.$561.Metal1 vout.P10.nSD 2.12736e-05f
Cred_2869 VDD.$561.Metal1 vout.P10.pSD 0.00138643f
Cred_2870 VDD.$571.Metal1 vin.P30.GatPoly 0.00477781f
Cred_2871 VDD.$571.Metal1 vin.P31.GatPoly 0.00735331f
Cred_2872 VDD.$571.Metal1 vout.$1292.Metal3 0.00515062f
Cred_2873 VDD.$571.Metal1 vout.$1358.Metal3 0.00515062f
Cred_2874 VDD.$571.Metal1 vout.P10.nSD 8.11433e-05f
Cred_2875 VDD.$571.Metal1 vout.P10.pSD 0.00720286f
Cred_2876 VDD.$581.Metal1 vin.P31.GatPoly 0.020714f
Cred_2877 VDD.$581.Metal1 vout.$1292.Metal3 0.000872768f
Cred_2878 VDD.$581.Metal1 vout.$1358.Metal3 0.000872768f
Cred_2879 VDD.$581.Metal1 vout.P10.nSD 1.37496e-05f
Cred_2880 VDD.$581.Metal1 vout.P10.pSD 0.000874896f
Cred_2881 VDD.$586.Metal1 vin.$107.GatPoly 0.027376f
Cred_2882 VDD.$586.Metal1 vin.$115.GatPoly 0.01444f
Cred_2883 VDD.$586.Metal1 vin.$123.GatPoly 0.00803706f
Cred_2884 VDD.$586.Metal1 vin.$353.Metal1 0.000305593f
Cred_2885 VDD.$586.Metal1 vin.$357.Metal1 0.0146255f
Cred_2886 VDD.$586.Metal1 vin.$365.Metal1 0.00965228f
Cred_2887 VDD.$586.Metal1 vin.$369.Metal1 0.00425071f
Cred_2888 VDD.$586.Metal1 vin.$578.Metal2 0.000161352f
Cred_2889 VDD.$586.Metal1 vin.$582.Metal2 0.0143436f
Cred_2890 VDD.$586.Metal1 vin.$584.Metal2 0.00127335f
Cred_2891 VDD.$586.Metal1 vin.$587.Metal2 0.00675532f
Cred_2892 VDD.$586.Metal1 vin.P30.GatPoly 0.00105163f
Cred_2893 VDD.$586.Metal1 vin.P31.GatPoly 0.138102f
Cred_2894 VDD.$586.Metal1 vin.P32.GatPoly 0.152687f
Cred_2895 VDD.$586.Metal1 vin.P33.GatPoly 0.00105163f
Cred_2896 VDD.$586.Metal1 vout.$1292.Metal3 0.0420692f
Cred_2897 VDD.$586.Metal1 vout.$1358.Metal3 0.1305f
Cred_2898 VDD.$586.Metal1 vout.P10.nSD 0.000662761f
Cred_2899 VDD.$586.Metal1 vout.P10.pSD 0.050993f
Cred_2900 VDD.$586.Metal1 vout.P12.pSD 0.0453259f
Cred_2901 VDD.$649.Metal1 vin.P32.GatPoly 0.018764f
Cred_2902 VDD.$649.Metal1 vin.P33.GatPoly 0.0017603f
Cred_2903 VDD.$649.Metal1 vout.$1358.Metal3 0.00999762f
Cred_2904 VDD.$649.Metal1 vout.P12.pSD 0.00617027f
Cred_2905 VDD.$661.Metal1 vin.$379.Metal1 3.63673e-08f
Cred_2906 VDD.$661.Metal1 vin.$383.Metal1 3.30647e-08f
Cred_2907 VDD.$661.Metal1 vin.$387.Metal1 1.60315e-08f
Cred_2908 VDD.$661.Metal1 vin.$596.Metal2 3.0265e-06f
Cred_2909 VDD.$661.Metal1 vin.$603.Metal2 1.52721e-06f
Cred_2910 VDD.$661.Metal1 vin.P32.GatPoly 0.000125212f
Cred_2911 VDD.$661.Metal1 vin.P33.GatPoly 0.0219982f
Cred_2912 VDD.$661.Metal1 vout.$1358.Metal3 0.00511681f
Cred_2913 VDD.$661.Metal1 vout.P12.pSD 0.00259748f
Cred_2914 VDD.$702.Metal1 vin.$127.GatPoly 0.0337709f
Cred_2915 VDD.$702.Metal1 vin.$135.GatPoly 0.00974692f
Cred_2916 VDD.$702.Metal1 vin.$137.GatPoly 0.0326854f
Cred_2917 VDD.$702.Metal1 vin.$379.Metal1 1.94904e-05f
Cred_2918 VDD.$702.Metal1 vin.$383.Metal1 0.000312019f
Cred_2919 VDD.$702.Metal1 vin.$387.Metal1 0.017099f
Cred_2920 VDD.$702.Metal1 vin.$393.Metal1 0.00895697f
Cred_2921 VDD.$702.Metal1 vin.$593.Metal2 0.000531069f
Cred_2922 VDD.$702.Metal1 vin.$596.Metal2 0.001622f
Cred_2923 VDD.$702.Metal1 vin.$599.Metal2 9.0897e-06f
Cred_2924 VDD.$702.Metal1 vin.$603.Metal2 0.0227296f
Cred_2925 VDD.$702.Metal1 vin.$604.Metal2 0.000239362f
Cred_2926 VDD.$702.Metal1 vin.$609.Metal2 0.00229955f
Cred_2927 VDD.$702.Metal1 vin.$613.Metal2 0.000531069f
Cred_2928 VDD.$702.Metal1 vin.P32.GatPoly 0.00129442f
Cred_2929 VDD.$702.Metal1 vin.P33.GatPoly 0.168237f
Cred_2930 VDD.$702.Metal1 vin.P34.GatPoly 0.168053f
Cred_2931 VDD.$702.Metal1 vin.P35.GatPoly 0.00129442f
Cred_2932 VDD.$702.Metal1 vout.$1358.Metal3 0.16027f
Cred_2933 VDD.$702.Metal1 vout.$1424.Metal3 0.05162f
Cred_2934 VDD.$702.Metal1 vout.P12.pSD 0.0583354f
Cred_2935 VDD.$702.Metal1 vout.P14.nSD 0.000813225f
Cred_2936 VDD.$702.Metal1 vout.P14.pSD 0.0603887f
Cred_2937 VDD.$703.Metal1 vin.P33.GatPoly 0.00666275f
Cred_2938 VDD.$722.Metal1 vin.P34.GatPoly 0.0201568f
Cred_2939 VDD.$722.Metal1 vout.$1358.Metal3 0.000594093f
Cred_2940 VDD.$722.Metal1 vout.$1424.Metal3 0.000594093f
Cred_2941 VDD.$722.Metal1 vout.P14.nSD 9.35937e-06f
Cred_2942 VDD.$722.Metal1 vout.P14.pSD 0.000534916f
Cred_2943 VDD.$734.Metal1 vin.P34.GatPoly 0.0105446f
Cred_2944 VDD.$734.Metal1 vin.P35.GatPoly 0.00376795f
Cred_2945 VDD.$734.Metal1 vout.$1358.Metal3 0.00508697f
Cred_2946 VDD.$734.Metal1 vout.$1424.Metal3 0.00508697f
Cred_2947 VDD.$734.Metal1 vout.P14.nSD 8.01405e-05f
Cred_2948 VDD.$734.Metal1 vout.P14.pSD 0.0066465f
Cred_2949 VDD.$744.Metal1 vin.$409.Metal1 8.36007e-09f
Cred_2950 VDD.$744.Metal1 vin.$413.Metal1 3.53695e-08f
Cred_2951 VDD.$744.Metal1 vin.$616.Metal2 2.29772e-06f
Cred_2952 VDD.$744.Metal1 vin.$620.Metal2 2.29772e-06f
Cred_2953 VDD.$744.Metal1 vin.P35.GatPoly 0.0217412f
Cred_2954 VDD.$744.Metal1 vout.$1358.Metal3 0.00158853f
Cred_2955 VDD.$744.Metal1 vout.$1424.Metal3 0.00158853f
Cred_2956 VDD.$744.Metal1 vout.P14.nSD 2.50259e-05f
Cred_2957 VDD.$744.Metal1 vout.P14.pSD 0.00166026f
Cred_2958 VDD.$754.Metal1 vin.$145.GatPoly 0.00516462f
Cred_2959 VDD.$754.Metal1 vin.$153.GatPoly 0.0161598f
Cred_2960 VDD.$754.Metal1 vin.$157.GatPoly 0.0282708f
Cred_2961 VDD.$754.Metal1 vin.$409.Metal1 0.00273151f
Cred_2962 VDD.$754.Metal1 vin.$413.Metal1 0.00781892f
Cred_2963 VDD.$754.Metal1 vin.$419.Metal1 0.0153629f
Cred_2964 VDD.$754.Metal1 vin.$423.Metal1 0.00359453f
Cred_2965 VDD.$754.Metal1 vin.$620.Metal2 0.0079159f
Cred_2966 VDD.$754.Metal1 vin.$622.Metal2 0.00133475f
Cred_2967 VDD.$754.Metal1 vin.$625.Metal2 0.0137f
Cred_2968 VDD.$754.Metal1 vin.P34.GatPoly 0.00105234f
Cred_2969 VDD.$754.Metal1 vin.P35.GatPoly 0.146168f
Cred_2970 VDD.$754.Metal1 vin.P36.GatPoly 0.139314f
Cred_2971 VDD.$754.Metal1 vin.P37.GatPoly 0.00105234f
Cred_2972 VDD.$754.Metal1 vout.$1358.Metal3 0.0421109f
Cred_2973 VDD.$754.Metal1 vout.$1424.Metal3 0.128831f
Cred_2974 VDD.$754.Metal1 vout.P14.nSD 0.000663418f
Cred_2975 VDD.$754.Metal1 vout.P14.pSD 0.0510307f
Cred_2976 VDD.$754.Metal1 vout.P16.pSD 0.0453222f
Cred_2977 VDD.$807.Metal1 vin.$423.Metal1 2.22555e-08f
Cred_2978 VDD.$807.Metal1 vin.$427.Metal1 1.65489e-08f
Cred_2979 VDD.$807.Metal1 vin.$625.Metal2 2.04255e-06f
Cred_2980 VDD.$807.Metal1 vin.$629.Metal2 2.04255e-06f
Cred_2981 VDD.$807.Metal1 vin.P36.GatPoly 0.0201394f
Cred_2982 VDD.$807.Metal1 vout.$1424.Metal3 0.00168232f
Cred_2983 VDD.$807.Metal1 vout.P16.pSD 0.000884946f
Cred_2984 VDD.$817.Metal1 vin.P36.GatPoly 0.00728002f
Cred_2985 VDD.$817.Metal1 vin.P37.GatPoly 0.00580327f
Cred_2986 VDD.$817.Metal1 vout.$1424.Metal3 0.0108832f
Cred_2987 VDD.$817.Metal1 vout.P16.pSD 0.00641077f
Cred_2988 VDD.$829.Metal1 vin.$173.GatPoly 6.24793e-11f
Cred_2989 VDD.$829.Metal1 vin.$441.Metal1 3.71155e-08f
Cred_2990 VDD.$829.Metal1 vin.$449.Metal1 5.23659e-09f
Cred_2991 VDD.$829.Metal1 vin.$636.Metal2 2.2344e-06f
Cred_2992 VDD.$829.Metal1 vin.$640.Metal2 2.23446e-06f
Cred_2993 VDD.$829.Metal1 vin.P37.GatPoly 0.0208963f
Cred_2994 VDD.$829.Metal1 vout.$1424.Metal3 0.00224562f
Cred_2995 VDD.$829.Metal1 vout.P16.pSD 0.00105798f
Cred_2996 VDD.$834.Metal1 vin.$167.GatPoly 0.0263169f
Cred_2997 VDD.$834.Metal1 vin.$173.GatPoly 0.00703995f
Cred_2998 VDD.$834.Metal1 vin.$179.GatPoly 0.0239497f
Cred_2999 VDD.$834.Metal1 vin.$441.Metal1 0.00233656f
Cred_3000 VDD.$834.Metal1 vin.$449.Metal1 0.0154163f
Cred_3001 VDD.$834.Metal1 vin.$453.Metal1 0.00682577f
Cred_3002 VDD.$834.Metal1 vin.$636.Metal2 5.72493e-06f
Cred_3003 VDD.$834.Metal1 vin.$640.Metal2 0.0118837f
Cred_3004 VDD.$834.Metal1 vin.$642.Metal2 0.0014622f
Cred_3005 VDD.$834.Metal1 vin.$645.Metal2 0.00944382f
Cred_3006 VDD.$834.Metal1 vin.P36.GatPoly 0.00105302f
Cred_3007 VDD.$834.Metal1 vin.P37.GatPoly 0.139411f
Cred_3008 VDD.$834.Metal1 vin.P38.GatPoly 0.143853f
Cred_3009 VDD.$834.Metal1 vin.P39.GatPoly 0.00114336f
Cred_3010 VDD.$834.Metal1 vout 0.0867491f
Cred_3011 VDD.$834.Metal1 vout.$1424.Metal3 0.0901216f
Cred_3012 VDD.$834.Metal1 vout.P16.pSD 0.0463072f
Cred_3013 VDD.$834.Metal1 vout.P18.pSD 0.051952f
Cred_3014 VDD.$890.Metal1 vin.$453.Metal1 5.79224e-09f
Cred_3015 VDD.$890.Metal1 vin.$457.Metal1 3.79714e-08f
Cred_3016 VDD.$890.Metal1 vin.$645.Metal2 2.2977e-06f
Cred_3017 VDD.$890.Metal1 vin.$649.Metal2 2.2977e-06f
Cred_3018 VDD.$890.Metal1 vin.P38.GatPoly 0.0212924f
Cred_3019 VDD.$890.Metal1 vout 0.00262104f
Cred_3020 VDD.$890.Metal1 vout.P18.pSD 0.00146084f
Cred_3021 VDD.$902.Metal1 vin.P38.GatPoly 0.00511441f
Cred_3022 VDD.$902.Metal1 vin.P39.GatPoly 0.0148894f
Cred_3023 VDD.$902.Metal1 vout 0.0111676f
Cred_3024 VDD.$902.Metal1 vout.P18.pSD 0.00685644f
Cred_3025 VDD.$917.Metal1 vin.P39.GatPoly 0.0161441f
Cred_3026 VDD.$917.Metal1 vout 0.000925091f
Cred_3027 VDD.$917.Metal1 vout.P18.pSD 0.000408589f
Cred_3028 VDD.$940.Metal1 vin.$179.GatPoly 0.00291445f
Cred_3029 VDD.$940.Metal1 vin.$457.Metal1 0.0256759f
Cred_3030 VDD.$940.Metal1 vin.$649.Metal2 0.000543644f
Cred_3031 VDD.$940.Metal1 vin.$654.Metal2 0.00269725f
Cred_3032 VDD.$940.Metal1 vin.P39.GatPoly 0.0377673f
Cred_3033 VDD.$940.Metal1 vout 0.0164308f
Cred_3034 VDD.$940.Metal1 vout.P18.pSD 0.0152249f
Cred_3035 VDD.$940.Metal1 VSS.$1066.Metal2 0.000646875f
Cred_3036 VDD.$940.Metal1 VSS.$18.Metal1 4.40719e-07f
Cred_3037 VDD.$940.Metal1 VSS.$40.Metal1 1.70865e-07f
Cred_3038 VDD.$940.Metal1 VSS.$509.Metal1 3.79702e-05f
Cred_3039 VDD.$940.Metal1 VSS.$551.Metal1 0.000995951f
Cred_3040 VDD.$940.Metal1 VSS.P0.pSD 0.0025104f
Cred_3041 VDD.$940.Metal1 VSS.P21.nSD 1.60356e-07f
Cred_3042 VDD.$940.Metal1 VSS.P23.nSD 1.60356e-07f
Cred_3043 VDD.$941.Metal1 vin.P39.GatPoly 0.0123085f
Cred_3044 VDD.$941.Metal1 vout 0.00270739f
Cred_3045 VDD.$941.Metal1 vout.P18.pSD 0.00256646f
Cred_3046 VDD.$942.Metal1 vin.P39.GatPoly 0.0123822f
Cred_3047 VDD.$942.Metal1 vout 0.0025373f
Cred_3048 VDD.$942.Metal1 vout.P18.pSD 0.00242224f
Cred_3049 VDD.$943.Metal1 vin.P39.GatPoly 0.0123812f
Cred_3050 VDD.$943.Metal1 vout 0.00268352f
Cred_3051 VDD.$943.Metal1 vout.P18.pSD 0.0025623f
Cred_3052 VDD.$954.Metal1 vin.P36.GatPoly 0.000830976f
Cred_3053 VDD.$954.Metal1 vin.P37.GatPoly 0.00119887f
Cred_3054 VDD.$954.Metal1 vin.P38.GatPoly 0.00215135f
Cred_3055 VDD.$954.Metal1 vin.P39.GatPoly 0.0220904f
Cred_3056 VDD.P0.GatPoly vin.$199.Metal1 0.0150425f
Cred_3057 VDD.P0.GatPoly vin.$478.Metal2 0.000974578f
Cred_3058 VDD.P0.GatPoly vin.$7.GatPoly 0.00580204f
Cred_3059 VDD.P0.GatPoly vin.P20.GatPoly 0.0721942f
Cred_3060 VDD.P0.GatPoly vin.P21.GatPoly 0.00596583f
Cred_3061 VDD.P0.GatPoly vin.P22.GatPoly 0.00328573f
Cred_3062 VDD.P0.GatPoly vin.P23.GatPoly 0.00227743f
Cred_3063 VDD.P0.GatPoly vin.P24.GatPoly 0.00160627f
Cred_3064 VDD.P0.GatPoly vin.P25.GatPoly 0.00130082f
Cred_3065 VDD.P0.GatPoly vout.$1226.Metal3 0.000869187f
Cred_3066 VDD.P0.GatPoly vout.P0.nSD 2.58816e-05f
Cred_3067 VDD.P0.GatPoly vout.P0.pSD 0.000241362f
Cred_3068 VDD.P0.GatPoly vout.P2.nSD 1.36932e-05f
Cred_3069 VDD.P0.GatPoly vout.P2.pSD 7.48366e-05f
Cred_3070 VDD.P0.GatPoly VSS.P0.GatPoly 0.00261825f
Cred_3071 VDD.P0.nSD vin 0.0215681f
Cred_3072 VDD.P0.nSD vin.$105.GatPoly 0.00419837f
Cred_3073 VDD.P0.nSD vin.$107.GatPoly 0.00334997f
Cred_3074 VDD.P0.nSD vin.$115.GatPoly 0.00488727f
Cred_3075 VDD.P0.nSD vin.$123.GatPoly 0.0049785f
Cred_3076 VDD.P0.nSD vin.$127.GatPoly 0.00401393f
Cred_3077 VDD.P0.nSD vin.$135.GatPoly 0.00424536f
Cred_3078 VDD.P0.nSD vin.$137.GatPoly 0.00342686f
Cred_3079 VDD.P0.nSD vin.$145.GatPoly 0.00473251f
Cred_3080 VDD.P0.nSD vin.$15.GatPoly 0.00347542f
Cred_3081 VDD.P0.nSD vin.$153.GatPoly 0.00493305f
Cred_3082 VDD.P0.nSD vin.$157.GatPoly 0.0033355f
Cred_3083 VDD.P0.nSD vin.$163.GatPoly 0.00390585f
Cred_3084 VDD.P0.nSD vin.$167.GatPoly 0.00347542f
Cred_3085 VDD.P0.nSD vin.$17.GatPoly 0.00373846f
Cred_3086 VDD.P0.nSD vin.$173.GatPoly 0.00373846f
Cred_3087 VDD.P0.nSD vin.$179.GatPoly 0.00676155f
Cred_3088 VDD.P0.nSD vin.$199.Metal1 0.0964292f
Cred_3089 VDD.P0.nSD vin.$207.Metal1 0.0342482f
Cred_3090 VDD.P0.nSD vin.$211.Metal1 0.0336559f
Cred_3091 VDD.P0.nSD vin.$219.Metal1 0.0473931f
Cred_3092 VDD.P0.nSD vin.$227.Metal1 0.0454944f
Cred_3093 VDD.P0.nSD vin.$233.Metal1 0.0321514f
Cred_3094 VDD.P0.nSD vin.$237.Metal1 0.0235929f
Cred_3095 VDD.P0.nSD vin.$241.Metal1 0.0339493f
Cred_3096 VDD.P0.nSD vin.$247.Metal1 0.0346365f
Cred_3097 VDD.P0.nSD vin.$25.GatPoly 0.0033355f
Cred_3098 VDD.P0.nSD vin.$251.Metal1 0.0346279f
Cred_3099 VDD.P0.nSD vin.$259.Metal1 0.035049f
Cred_3100 VDD.P0.nSD vin.$263.Metal1 0.0236335f
Cred_3101 VDD.P0.nSD vin.$265.Metal1 0.0351501f
Cred_3102 VDD.P0.nSD vin.$27.GatPoly 0.00390585f
Cred_3103 VDD.P0.nSD vin.$273.Metal1 0.0346048f
Cred_3104 VDD.P0.nSD vin.$277.Metal1 0.023707f
Cred_3105 VDD.P0.nSD vin.$281.Metal1 0.0246221f
Cred_3106 VDD.P0.nSD vin.$285.Metal1 0.034488f
Cred_3107 VDD.P0.nSD vin.$291.Metal1 0.0369454f
Cred_3108 VDD.P0.nSD vin.$295.Metal1 0.0351171f
Cred_3109 VDD.P0.nSD vin.$303.Metal1 0.0350773f
Cred_3110 VDD.P0.nSD vin.$307.Metal1 0.0363796f
Cred_3111 VDD.P0.nSD vin.$313.Metal1 0.0352869f
Cred_3112 VDD.P0.nSD vin.$317.Metal1 0.0234363f
Cred_3113 VDD.P0.nSD vin.$321.Metal1 0.0244293f
Cred_3114 VDD.P0.nSD vin.$325.Metal1 0.034571f
Cred_3115 VDD.P0.nSD vin.$331.Metal1 0.0348954f
Cred_3116 VDD.P0.nSD vin.$335.Metal1 0.023532f
Cred_3117 VDD.P0.nSD vin.$339.Metal1 0.0244293f
Cred_3118 VDD.P0.nSD vin.$343.Metal1 0.0234363f
Cred_3119 VDD.P0.nSD vin.$347.Metal1 0.0352869f
Cred_3120 VDD.P0.nSD vin.$353.Metal1 0.0363796f
Cred_3121 VDD.P0.nSD vin.$357.Metal1 0.0350773f
Cred_3122 VDD.P0.nSD vin.$365.Metal1 0.0351171f
Cred_3123 VDD.P0.nSD vin.$369.Metal1 0.0369454f
Cred_3124 VDD.P0.nSD vin.$37.GatPoly 0.00493305f
Cred_3125 VDD.P0.nSD vin.$375.Metal1 0.034488f
Cred_3126 VDD.P0.nSD vin.$379.Metal1 0.0246221f
Cred_3127 VDD.P0.nSD vin.$383.Metal1 0.023707f
Cred_3128 VDD.P0.nSD vin.$387.Metal1 0.0346048f
Cred_3129 VDD.P0.nSD vin.$393.Metal1 0.0351501f
Cred_3130 VDD.P0.nSD vin.$397.Metal1 0.0236335f
Cred_3131 VDD.P0.nSD vin.$401.Metal1 0.035049f
Cred_3132 VDD.P0.nSD vin.$409.Metal1 0.0346279f
Cred_3133 VDD.P0.nSD vin.$413.Metal1 0.0346365f
Cred_3134 VDD.P0.nSD vin.$419.Metal1 0.0339493f
Cred_3135 VDD.P0.nSD vin.$423.Metal1 0.0235929f
Cred_3136 VDD.P0.nSD vin.$427.Metal1 0.0321514f
Cred_3137 VDD.P0.nSD vin.$43.GatPoly 0.00473251f
Cred_3138 VDD.P0.nSD vin.$433.Metal1 0.0454944f
Cred_3139 VDD.P0.nSD vin.$441.Metal1 0.0473931f
Cred_3140 VDD.P0.nSD vin.$449.Metal1 0.0336237f
Cred_3141 VDD.P0.nSD vin.$453.Metal1 0.0223857f
Cred_3142 VDD.P0.nSD vin.$457.Metal1 0.10467f
Cred_3143 VDD.P0.nSD vin.$47.GatPoly 0.00342686f
Cred_3144 VDD.P0.nSD vin.$476.Metal2 0.000114087f
Cred_3145 VDD.P0.nSD vin.$478.Metal2 0.0355109f
Cred_3146 VDD.P0.nSD vin.$482.Metal2 0.0132996f
Cred_3147 VDD.P0.nSD vin.$486.Metal2 0.0381169f
Cred_3148 VDD.P0.nSD vin.$489.Metal2 0.0217323f
Cred_3149 VDD.P0.nSD vin.$493.Metal2 0.0175904f
Cred_3150 VDD.P0.nSD vin.$495.Metal2 0.0413444f
Cred_3151 VDD.P0.nSD vin.$500.Metal2 0.0181424f
Cred_3152 VDD.P0.nSD vin.$504.Metal2 0.0196769f
Cred_3153 VDD.P0.nSD vin.$506.Metal2 0.0384598f
Cred_3154 VDD.P0.nSD vin.$509.Metal2 0.0131876f
Cred_3155 VDD.P0.nSD vin.$513.Metal2 0.014287f
Cred_3156 VDD.P0.nSD vin.$515.Metal2 0.0510441f
Cred_3157 VDD.P0.nSD vin.$518.Metal2 0.0166623f
Cred_3158 VDD.P0.nSD vin.$520.Metal2 0.00876238f
Cred_3159 VDD.P0.nSD vin.$523.Metal2 0.00548833f
Cred_3160 VDD.P0.nSD vin.$527.Metal2 0.0402275f
Cred_3161 VDD.P0.nSD vin.$528.Metal2 0.000208418f
Cred_3162 VDD.P0.nSD vin.$53.GatPoly 0.00424536f
Cred_3163 VDD.P0.nSD vin.$533.Metal2 0.0213046f
Cred_3164 VDD.P0.nSD vin.$535.Metal2 0.0516091f
Cred_3165 VDD.P0.nSD vin.$538.Metal2 0.01489f
Cred_3166 VDD.P0.nSD vin.$542.Metal2 0.0127954f
Cred_3167 VDD.P0.nSD vin.$544.Metal2 0.0370578f
Cred_3168 VDD.P0.nSD vin.$547.Metal2 0.0218847f
Cred_3169 VDD.P0.nSD vin.$551.Metal2 0.0179844f
Cred_3170 VDD.P0.nSD vin.$555.Metal2 0.0428261f
Cred_3171 VDD.P0.nSD vin.$558.Metal2 0.0191933f
Cred_3172 VDD.P0.nSD vin.$562.Metal2 0.0172049f
Cred_3173 VDD.P0.nSD vin.$564.Metal2 0.0396901f
Cred_3174 VDD.P0.nSD vin.$567.Metal2 0.017005f
Cred_3175 VDD.P0.nSD vin.$57.GatPoly 0.00401393f
Cred_3176 VDD.P0.nSD vin.$571.Metal2 0.0191933f
Cred_3177 VDD.P0.nSD vin.$573.Metal2 0.0428261f
Cred_3178 VDD.P0.nSD vin.$578.Metal2 0.0179844f
Cred_3179 VDD.P0.nSD vin.$582.Metal2 0.0218847f
Cred_3180 VDD.P0.nSD vin.$584.Metal2 0.0370578f
Cred_3181 VDD.P0.nSD vin.$587.Metal2 0.0127954f
Cred_3182 VDD.P0.nSD vin.$591.Metal2 0.01489f
Cred_3183 VDD.P0.nSD vin.$593.Metal2 0.0516091f
Cred_3184 VDD.P0.nSD vin.$596.Metal2 0.0213046f
Cred_3185 VDD.P0.nSD vin.$599.Metal2 0.000208418f
Cred_3186 VDD.P0.nSD vin.$603.Metal2 0.0402275f
Cred_3187 VDD.P0.nSD vin.$604.Metal2 0.00548833f
Cred_3188 VDD.P0.nSD vin.$609.Metal2 0.00876238f
Cred_3189 VDD.P0.nSD vin.$611.Metal2 0.0166623f
Cred_3190 VDD.P0.nSD vin.$613.Metal2 0.0510441f
Cred_3191 VDD.P0.nSD vin.$616.Metal2 0.014287f
Cred_3192 VDD.P0.nSD vin.$620.Metal2 0.0131876f
Cred_3193 VDD.P0.nSD vin.$622.Metal2 0.0384598f
Cred_3194 VDD.P0.nSD vin.$625.Metal2 0.0196769f
Cred_3195 VDD.P0.nSD vin.$629.Metal2 0.0181424f
Cred_3196 VDD.P0.nSD vin.$633.Metal2 0.0413444f
Cred_3197 VDD.P0.nSD vin.$636.Metal2 0.0175904f
Cred_3198 VDD.P0.nSD vin.$640.Metal2 0.0174296f
Cred_3199 VDD.P0.nSD vin.$642.Metal2 0.0511903f
Cred_3200 VDD.P0.nSD vin.$645.Metal2 0.0144721f
Cred_3201 VDD.P0.nSD vin.$648.Metal2 0.000900649f
Cred_3202 VDD.P0.nSD vin.$649.Metal2 0.0141269f
Cred_3203 VDD.P0.nSD vin.$65.GatPoly 0.0049785f
Cred_3204 VDD.P0.nSD vin.$653.Metal2 0.00344366f
Cred_3205 VDD.P0.nSD vin.$654.Metal2 0.0336555f
Cred_3206 VDD.P0.nSD vin.$7.GatPoly 0.00488953f
Cred_3207 VDD.P0.nSD vin.$73.GatPoly 0.00488727f
Cred_3208 VDD.P0.nSD vin.$77.GatPoly 0.00334997f
Cred_3209 VDD.P0.nSD vin.$83.GatPoly 0.00419837f
Cred_3210 VDD.P0.nSD vin.$87.GatPoly 0.00324148f
Cred_3211 VDD.P0.nSD vin.$9.GatPoly 0.0035918f
Cred_3212 VDD.P0.nSD vin.$93.GatPoly 0.00470757f
Cred_3213 VDD.P0.nSD vin.$97.GatPoly 0.00402253f
Cred_3214 VDD.P0.nSD vin.P20.GatPoly 0.0150794f
Cred_3215 VDD.P0.nSD vin.P21.GatPoly 2.98627e-05f
Cred_3216 VDD.P0.nSD vin.P22.GatPoly 5.07671e-06f
Cred_3217 VDD.P0.nSD vin.P23.GatPoly 3.05551e-05f
Cred_3218 VDD.P0.nSD vin.P24.GatPoly 0.00044545f
Cred_3219 VDD.P0.nSD vin.P25.GatPoly 1.59337e-05f
Cred_3220 VDD.P0.nSD vin.P26.GatPoly 1.88789e-05f
Cred_3221 VDD.P0.nSD vin.P27.GatPoly 0.000447371f
Cred_3222 VDD.P0.nSD vin.P28.GatPoly 5.2574e-06f
Cred_3223 VDD.P0.nSD vin.P29.GatPoly 2.11606e-05f
Cred_3224 VDD.P0.nSD vin.P30.GatPoly 1.29989e-05f
Cred_3225 VDD.P0.nSD vin.P31.GatPoly 1.37348e-05f
Cred_3226 VDD.P0.nSD vin.P32.GatPoly 0.000469781f
Cred_3227 VDD.P0.nSD vin.P33.GatPoly 1.94746e-05f
Cred_3228 VDD.P0.nSD vin.P34.GatPoly 1.59337e-05f
Cred_3229 VDD.P0.nSD vin.P35.GatPoly 0.00044545f
Cred_3230 VDD.P0.nSD vin.P36.GatPoly 1.81192e-05f
Cred_3231 VDD.P0.nSD vin.P37.GatPoly 1.60303e-05f
Cred_3232 VDD.P0.nSD vin.P38.GatPoly 1.76658e-05f
Cred_3233 VDD.P0.nSD vin.P39.GatPoly 0.0156082f
Cred_3234 VDD.P0.nSD vout 0.0221576f
Cred_3235 VDD.P0.nSD vout.$1226.Metal3 0.0494824f
Cred_3236 VDD.P0.nSD vout.$1292.Metal3 0.0323364f
Cred_3237 VDD.P0.nSD vout.$1358.Metal3 0.0341206f
Cred_3238 VDD.P0.nSD vout.$1424.Metal3 0.0243294f
Cred_3239 VDD.P0.nSD vout.P0.nSD 0.00059685f
Cred_3240 VDD.P0.nSD vout.P0.pSD 0.00354356f
Cred_3241 VDD.P0.nSD vout.P10.nSD 0.000131761f
Cred_3242 VDD.P0.nSD vout.P10.pSD 0.000719995f
Cred_3243 VDD.P0.nSD vout.P12.pSD 5.89477e-06f
Cred_3244 VDD.P0.nSD vout.P14.nSD 0.000130002f
Cred_3245 VDD.P0.nSD vout.P14.pSD 0.000709939f
Cred_3246 VDD.P0.nSD vout.P16.pSD 5.69196e-06f
Cred_3247 VDD.P0.nSD vout.P18.pSD 6.65702e-06f
Cred_3248 VDD.P0.nSD vout.P2.nSD 0.000405507f
Cred_3249 VDD.P0.nSD vout.P2.pSD 0.00222958f
Cred_3250 VDD.P0.nSD vout.P4.pSD 6.28727e-06f
Cred_3251 VDD.P0.nSD vout.P6.nSD 0.000121359f
Cred_3252 VDD.P0.nSD vout.P6.pSD 0.000667876f
Cred_3253 VDD.P0.nSD vout.P8.pSD 1.575e-05f
Cred_3254 VDD.P0.nSD VSS.$1066.Metal2 0.000857066f
Cred_3255 VDD.P0.nSD VSS.$18.Metal1 0.0217427f
Cred_3256 VDD.P0.nSD VSS.$40.Metal1 0.0113529f
Cred_3257 VDD.P0.nSD VSS.$509.Metal1 0.00292339f
Cred_3258 VDD.P0.nSD VSS.$551.Metal1 0.0322786f
Cred_3259 VDD.P0.nSD VSS.$564.Metal2 0.000857066f
Cred_3260 VDD.P0.nSD VSS.P0.nSD 1.94865e-05f
Cred_3261 VDD.P0.nSD VSS.P0.pSD 0.503705f
Cred_3262 VDD.P0.nSD VSS.P1.nSD 1.94865e-05f
Cred_3263 VDD.P0.nSD VSS.P21.nSD 1.94865e-05f
Cred_3264 VDD.P0.nSD VSS.P23.nSD 1.94865e-05f
Cred_3265 VDD.P0.pSD vin.$199.Metal1 0.000306195f
Cred_3266 VDD.P0.pSD vin.$478.Metal2 1.98378e-05f
Cred_3267 VDD.P0.pSD vin.$7.GatPoly 6.49177e-05f
Cred_3268 VDD.P0.pSD vin.P20.GatPoly 0.000209139f
Cred_3269 VDD.P0.pSD vout.$1226.Metal3 0.00011323f
Cred_3270 VDD.P0.pSD vout.P0.nSD 3.37164e-06f
Cred_3271 VDD.P0.pSD vout.P0.pSD 0.000146497f
Cred_3272 VDD.P0.pSD vout.P2.nSD 1.78384e-06f
Cred_3273 VDD.P0.pSD vout.P2.pSD 9.74907e-06f
Cred_3274 VDD.P0.pSD VSS.$18.Metal1 9.84253e-06f
Cred_3275 VDD.P0.pSD VSS.$40.Metal1 4.27108e-06f
Cred_3276 VDD.P0.pSD VSS.$551.Metal1 9.72867e-09f
Cred_3277 VDD.P0.pSD VSS.$564.Metal2 7.75423e-06f
Cred_3278 VDD.P0.pSD VSS.P0.nSD 1.92222e-09f
Cred_3279 VDD.P0.pSD VSS.P0.pSD 3.78342e-05f
Cred_3280 VDD.P0.pSD VSS.P1.nSD 1.92222e-09f
Cred_3281 VDD.P1.GatPoly vin.$179.GatPoly 0.0030499f
Cred_3282 VDD.P1.GatPoly vin.$457.Metal1 0.0165391f
Cred_3283 VDD.P1.GatPoly vin.$649.Metal2 0.000349285f
Cred_3284 VDD.P1.GatPoly vin.$654.Metal2 0.00168599f
Cred_3285 VDD.P1.GatPoly vin.P34.GatPoly 0.00130082f
Cred_3286 VDD.P1.GatPoly vin.P35.GatPoly 0.00160627f
Cred_3287 VDD.P1.GatPoly vin.P36.GatPoly 0.00227743f
Cred_3288 VDD.P1.GatPoly vin.P37.GatPoly 0.00328573f
Cred_3289 VDD.P1.GatPoly vin.P38.GatPoly 0.00596583f
Cred_3290 VDD.P1.GatPoly vin.P39.GatPoly 0.0723891f
Cred_3291 VDD.P1.GatPoly vout 0.0011116f
Cred_3292 VDD.P1.GatPoly vout.P18.pSD 0.000113358f
Cred_3293 VDD.P1.GatPoly VSS.P1.GatPoly 0.00261825f
Cred_3294 VDD.P1.pSD vin.$199.Metal1 0.000306195f
Cred_3295 VDD.P1.pSD vin.$478.Metal2 1.98378e-05f
Cred_3296 VDD.P1.pSD vin.$7.GatPoly 6.49177e-05f
Cred_3297 VDD.P1.pSD vin.P20.GatPoly 0.000209139f
Cred_3298 VDD.P1.pSD vout.$1226.Metal3 0.00011323f
Cred_3299 VDD.P1.pSD vout.P0.nSD 3.37164e-06f
Cred_3300 VDD.P1.pSD vout.P0.pSD 0.000146497f
Cred_3301 VDD.P1.pSD vout.P2.nSD 1.78384e-06f
Cred_3302 VDD.P1.pSD vout.P2.pSD 9.74907e-06f
Cred_3303 VDD.P1.pSD VSS.$18.Metal1 9.84253e-06f
Cred_3304 VDD.P1.pSD VSS.$40.Metal1 4.27108e-06f
Cred_3305 VDD.P1.pSD VSS.$551.Metal1 9.72867e-09f
Cred_3306 VDD.P1.pSD VSS.$564.Metal2 7.75423e-06f
Cred_3307 VDD.P1.pSD VSS.P0.nSD 1.92222e-09f
Cred_3308 VDD.P1.pSD VSS.P0.pSD 3.78342e-05f
Cred_3309 VDD.P1.pSD VSS.P1.nSD 1.92222e-09f
Cred_3310 VDD.P10.pSD vin.$291.Metal1 0.00310316f
Cred_3311 VDD.P10.pSD vin.$295.Metal1 0.00741339f
Cred_3312 VDD.P10.pSD vin.$303.Metal1 0.0114048f
Cred_3313 VDD.P10.pSD vin.$307.Metal1 0.000210914f
Cred_3314 VDD.P10.pSD vin.$542.Metal2 0.00390274f
Cred_3315 VDD.P10.pSD vin.$544.Metal2 0.000733358f
Cred_3316 VDD.P10.pSD vin.$547.Metal2 0.0082728f
Cred_3317 VDD.P10.pSD vin.$551.Metal2 9.29272e-05f
Cred_3318 VDD.P10.pSD vin.$65.GatPoly 0.00586731f
Cred_3319 VDD.P10.pSD vin.$73.GatPoly 0.00979204f
Cred_3320 VDD.P10.pSD vin.$77.GatPoly 0.0199198f
Cred_3321 VDD.P10.pSD vin.P26.GatPoly 0.000152972f
Cred_3322 VDD.P10.pSD vin.P27.GatPoly 0.0523764f
Cred_3323 VDD.P10.pSD vin.P28.GatPoly 0.0491365f
Cred_3324 VDD.P10.pSD vin.P29.GatPoly 0.000152972f
Cred_3325 VDD.P10.pSD vout.$1226.Metal3 0.0204453f
Cred_3326 VDD.P10.pSD vout.$1292.Metal3 0.0627819f
Cred_3327 VDD.P10.pSD vout.P6.nSD 0.000322096f
Cred_3328 VDD.P10.pSD vout.P6.pSD 0.0234871f
Cred_3329 VDD.P10.pSD vout.P8.pSD 0.0204163f
Cred_3330 VDD.P11.pSD vin.$325.Metal1 0.00397588f
Cred_3331 VDD.P11.pSD vin.$331.Metal1 0.0119672f
Cred_3332 VDD.P11.pSD vin.$335.Metal1 0.000567385f
Cred_3333 VDD.P11.pSD vin.$562.Metal2 0.00641755f
Cred_3334 VDD.P11.pSD vin.$564.Metal2 0.000857879f
Cred_3335 VDD.P11.pSD vin.$567.Metal2 0.00590659f
Cred_3336 VDD.P11.pSD vin.$87.GatPoly 0.0192088f
Cred_3337 VDD.P11.pSD vin.$93.GatPoly 0.00532203f
Cred_3338 VDD.P11.pSD vin.$97.GatPoly 0.020104f
Cred_3339 VDD.P11.pSD vin.P28.GatPoly 0.000156829f
Cred_3340 VDD.P11.pSD vin.P29.GatPoly 0.0495892f
Cred_3341 VDD.P11.pSD vin.P30.GatPoly 0.0495892f
Cred_3342 VDD.P11.pSD vin.P31.GatPoly 0.000156829f
Cred_3343 VDD.P11.pSD vout.$1292.Metal3 0.0634271f
Cred_3344 VDD.P11.pSD vout.$1358.Metal3 0.0201775f
Cred_3345 VDD.P11.pSD vout.P10.nSD 0.000317877f
Cred_3346 VDD.P11.pSD vout.P10.pSD 0.022727f
Cred_3347 VDD.P11.pSD vout.P8.pSD 0.0218661f
Cred_3348 VDD.P13.pSD vin.$107.GatPoly 0.0199198f
Cred_3349 VDD.P13.pSD vin.$115.GatPoly 0.00979204f
Cred_3350 VDD.P13.pSD vin.$123.GatPoly 0.00586731f
Cred_3351 VDD.P13.pSD vin.$353.Metal1 0.000210914f
Cred_3352 VDD.P13.pSD vin.$357.Metal1 0.0114048f
Cred_3353 VDD.P13.pSD vin.$365.Metal1 0.00741339f
Cred_3354 VDD.P13.pSD vin.$369.Metal1 0.00310316f
Cred_3355 VDD.P13.pSD vin.$578.Metal2 9.29272e-05f
Cred_3356 VDD.P13.pSD vin.$582.Metal2 0.0082728f
Cred_3357 VDD.P13.pSD vin.$584.Metal2 0.000733358f
Cred_3358 VDD.P13.pSD vin.$587.Metal2 0.00390274f
Cred_3359 VDD.P13.pSD vin.P30.GatPoly 0.000152972f
Cred_3360 VDD.P13.pSD vin.P31.GatPoly 0.0491365f
Cred_3361 VDD.P13.pSD vin.P32.GatPoly 0.0523764f
Cred_3362 VDD.P13.pSD vin.P33.GatPoly 0.000152972f
Cred_3363 VDD.P13.pSD vout.$1292.Metal3 0.0201171f
Cred_3364 VDD.P13.pSD vout.$1358.Metal3 0.0623414f
Cred_3365 VDD.P13.pSD vout.P10.nSD 0.000316927f
Cred_3366 VDD.P13.pSD vout.P10.pSD 0.0235272f
Cred_3367 VDD.P13.pSD vout.P12.pSD 0.0208567f
Cred_3368 VDD.P15.pSD vin.$127.GatPoly 0.0173403f
Cred_3369 VDD.P15.pSD vin.$135.GatPoly 0.00409503f
Cred_3370 VDD.P15.pSD vin.$137.GatPoly 0.0168685f
Cred_3371 VDD.P15.pSD vin.$379.Metal1 7.61469e-06f
Cred_3372 VDD.P15.pSD vin.$383.Metal1 0.000146691f
Cred_3373 VDD.P15.pSD vin.$387.Metal1 0.009498f
Cred_3374 VDD.P15.pSD vin.$393.Metal1 0.00502835f
Cred_3375 VDD.P15.pSD vin.$593.Metal2 0.000207483f
Cred_3376 VDD.P15.pSD vin.$596.Metal2 0.000633697f
Cred_3377 VDD.P15.pSD vin.$599.Metal2 3.55125e-06f
Cred_3378 VDD.P15.pSD vin.$603.Metal2 0.00890149f
Cred_3379 VDD.P15.pSD vin.$604.Metal2 9.35164e-05f
Cred_3380 VDD.P15.pSD vin.$609.Metal2 0.000898795f
Cred_3381 VDD.P15.pSD vin.$613.Metal2 0.000207483f
Cred_3382 VDD.P15.pSD vin.P32.GatPoly 5.27099e-05f
Cred_3383 VDD.P15.pSD vin.P33.GatPoly 0.0361905f
Cred_3384 VDD.P15.pSD vin.P34.GatPoly 0.0361878f
Cred_3385 VDD.P15.pSD vin.P35.GatPoly 5.27099e-05f
Cred_3386 VDD.P15.pSD vout.$1358.Metal3 0.0498765f
Cred_3387 VDD.P15.pSD vout.$1424.Metal3 0.0160697f
Cred_3388 VDD.P15.pSD vout.P12.pSD 0.0172885f
Cred_3389 VDD.P15.pSD vout.P14.nSD 0.000253163f
Cred_3390 VDD.P15.pSD vout.P14.pSD 0.01791f
Cred_3391 VDD.P17.pSD vin.$145.GatPoly 0.00376764f
Cred_3392 VDD.P17.pSD vin.$153.GatPoly 0.0112577f
Cred_3393 VDD.P17.pSD vin.$157.GatPoly 0.0204789f
Cred_3394 VDD.P17.pSD vin.$409.Metal1 0.00199266f
Cred_3395 VDD.P17.pSD vin.$413.Metal1 0.0058755f
Cred_3396 VDD.P17.pSD vin.$419.Metal1 0.0117675f
Cred_3397 VDD.P17.pSD vin.$423.Metal1 0.00270588f
Cred_3398 VDD.P17.pSD vin.$620.Metal2 0.00456992f
Cred_3399 VDD.P17.pSD vin.$622.Metal2 0.000768448f
Cred_3400 VDD.P17.pSD vin.$625.Metal2 0.00789129f
Cred_3401 VDD.P17.pSD vin.P34.GatPoly 0.000153238f
Cred_3402 VDD.P17.pSD vin.P35.GatPoly 0.0521932f
Cred_3403 VDD.P17.pSD vin.P36.GatPoly 0.0490963f
Cred_3404 VDD.P17.pSD vin.P37.GatPoly 0.000153238f
Cred_3405 VDD.P17.pSD vout.$1358.Metal3 0.0201329f
Cred_3406 VDD.P17.pSD vout.$1424.Metal3 0.0617163f
Cred_3407 VDD.P17.pSD vout.P14.nSD 0.000317174f
Cred_3408 VDD.P17.pSD vout.P14.pSD 0.0235414f
Cred_3409 VDD.P17.pSD vout.P16.pSD 0.0208793f
Cred_3410 VDD.P19.pSD vin.$167.GatPoly 0.019203f
Cred_3411 VDD.P19.pSD vin.$173.GatPoly 0.0048081f
Cred_3412 VDD.P19.pSD vin.$179.GatPoly 0.0172566f
Cred_3413 VDD.P19.pSD vin.$441.Metal1 0.00183947f
Cred_3414 VDD.P19.pSD vin.$449.Metal1 0.0117538f
Cred_3415 VDD.P19.pSD vin.$453.Metal1 0.00518118f
Cred_3416 VDD.P19.pSD vin.$636.Metal2 4.50698e-06f
Cred_3417 VDD.P19.pSD vin.$640.Metal2 0.00685152f
Cred_3418 VDD.P19.pSD vin.$642.Metal2 0.000841537f
Cred_3419 VDD.P19.pSD vin.$645.Metal2 0.00544022f
Cred_3420 VDD.P19.pSD vin.P36.GatPoly 0.000153495f
Cred_3421 VDD.P19.pSD vin.P37.GatPoly 0.0490457f
Cred_3422 VDD.P19.pSD vin.P38.GatPoly 0.0501212f
Cred_3423 VDD.P19.pSD vin.P39.GatPoly 0.000167698f
Cred_3424 VDD.P19.pSD vout 0.0415546f
Cred_3425 VDD.P19.pSD vout.$1424.Metal3 0.0430963f
Cred_3426 VDD.P19.pSD vout.P16.pSD 0.0213054f
Cred_3427 VDD.P19.pSD vout.P18.pSD 0.0240562f
Cred_3428 VDD.P21.pSD vin.$179.GatPoly 3.55377e-05f
Cred_3429 VDD.P21.pSD vin.$457.Metal1 0.000313082f
Cred_3430 VDD.P21.pSD vin.$649.Metal2 6.62899e-06f
Cred_3431 VDD.P21.pSD vin.$654.Metal2 3.28892e-05f
Cred_3432 VDD.P21.pSD vin.P39.GatPoly 0.000211951f
Cred_3433 VDD.P21.pSD vout 0.000144612f
Cred_3434 VDD.P21.pSD vout.P18.pSD 0.000132277f
Cred_3435 VDD.P21.pSD VSS.$1066.Metal2 8.18247e-06f
Cred_3436 VDD.P21.pSD VSS.$18.Metal1 6.47689e-09f
Cred_3437 VDD.P21.pSD VSS.$40.Metal1 2.51107e-09f
Cred_3438 VDD.P21.pSD VSS.$509.Metal1 4.80294e-07f
Cred_3439 VDD.P21.pSD VSS.$551.Metal1 1.46118e-05f
Cred_3440 VDD.P21.pSD VSS.P0.pSD 3.68815e-05f
Cred_3441 VDD.P21.pSD VSS.P21.nSD 2.02837e-09f
Cred_3442 VDD.P21.pSD VSS.P23.nSD 2.02837e-09f
Cred_3443 VDD.P23.pSD vin.$179.GatPoly 3.55377e-05f
Cred_3444 VDD.P23.pSD vin.$457.Metal1 0.000313082f
Cred_3445 VDD.P23.pSD vin.$649.Metal2 6.62899e-06f
Cred_3446 VDD.P23.pSD vin.$654.Metal2 3.28892e-05f
Cred_3447 VDD.P23.pSD vin.P39.GatPoly 0.000211951f
Cred_3448 VDD.P23.pSD vout 0.000144612f
Cred_3449 VDD.P23.pSD vout.P18.pSD 0.000132277f
Cred_3450 VDD.P23.pSD VSS.$1066.Metal2 8.18247e-06f
Cred_3451 VDD.P23.pSD VSS.$18.Metal1 6.47689e-09f
Cred_3452 VDD.P23.pSD VSS.$40.Metal1 2.51107e-09f
Cred_3453 VDD.P23.pSD VSS.$509.Metal1 4.80294e-07f
Cred_3454 VDD.P23.pSD VSS.$551.Metal1 1.46118e-05f
Cred_3455 VDD.P23.pSD VSS.P0.pSD 3.68815e-05f
Cred_3456 VDD.P23.pSD VSS.P21.nSD 2.02837e-09f
Cred_3457 VDD.P23.pSD VSS.P23.nSD 2.02837e-09f
Cred_3458 VDD.P3.pSD vin.$15.GatPoly 0.019203f
Cred_3459 VDD.P3.pSD vin.$17.GatPoly 0.0048081f
Cred_3460 VDD.P3.pSD vin.$207.Metal1 0.00521338f
Cred_3461 VDD.P3.pSD vin.$211.Metal1 0.0117703f
Cred_3462 VDD.P3.pSD vin.$219.Metal1 0.00183947f
Cred_3463 VDD.P3.pSD vin.$482.Metal2 0.00256021f
Cred_3464 VDD.P3.pSD vin.$486.Metal2 0.00147677f
Cred_3465 VDD.P3.pSD vin.$489.Metal2 0.00904763f
Cred_3466 VDD.P3.pSD vin.$493.Metal2 4.50698e-06f
Cred_3467 VDD.P3.pSD vin.$9.GatPoly 0.0172566f
Cred_3468 VDD.P3.pSD vin.P20.GatPoly 0.000167698f
Cred_3469 VDD.P3.pSD vin.P21.GatPoly 0.0499728f
Cred_3470 VDD.P3.pSD vin.P22.GatPoly 0.0491942f
Cred_3471 VDD.P3.pSD vin.P23.GatPoly 0.000153495f
Cred_3472 VDD.P3.pSD vout.$1226.Metal3 0.0689562f
Cred_3473 VDD.P3.pSD vout.P0.nSD 0.00152455f
Cred_3474 VDD.P3.pSD vout.P0.pSD 0.0322882f
Cred_3475 VDD.P3.pSD vout.P2.nSD 0.00108634f
Cred_3476 VDD.P3.pSD vout.P2.pSD 0.026516f
Cred_3477 VDD.P5.pSD vin.$237.Metal1 0.00270588f
Cred_3478 VDD.P5.pSD vin.$241.Metal1 0.0117675f
Cred_3479 VDD.P5.pSD vin.$247.Metal1 0.0058755f
Cred_3480 VDD.P5.pSD vin.$25.GatPoly 0.0204789f
Cred_3481 VDD.P5.pSD vin.$251.Metal1 0.00199266f
Cred_3482 VDD.P5.pSD vin.$37.GatPoly 0.0112577f
Cred_3483 VDD.P5.pSD vin.$43.GatPoly 0.00376764f
Cred_3484 VDD.P5.pSD vin.$504.Metal2 0.00789129f
Cred_3485 VDD.P5.pSD vin.$506.Metal2 0.000768448f
Cred_3486 VDD.P5.pSD vin.$509.Metal2 0.00456992f
Cred_3487 VDD.P5.pSD vin.P22.GatPoly 0.000153238f
Cred_3488 VDD.P5.pSD vin.P23.GatPoly 0.0490963f
Cred_3489 VDD.P5.pSD vin.P24.GatPoly 0.0521932f
Cred_3490 VDD.P5.pSD vin.P25.GatPoly 0.000153238f
Cred_3491 VDD.P5.pSD vout.$1226.Metal3 0.0793409f
Cred_3492 VDD.P5.pSD vout.P0.nSD 0.00051706f
Cred_3493 VDD.P5.pSD vout.P0.pSD 0.00274757f
Cred_3494 VDD.P5.pSD vout.P2.nSD 0.000562494f
Cred_3495 VDD.P5.pSD vout.P2.pSD 0.023732f
Cred_3496 VDD.P5.pSD vout.P4.pSD 0.0215095f
Cred_3497 VDD.P7.pSD vin.$265.Metal1 0.00502835f
Cred_3498 VDD.P7.pSD vin.$273.Metal1 0.009498f
Cred_3499 VDD.P7.pSD vin.$277.Metal1 0.000146691f
Cred_3500 VDD.P7.pSD vin.$281.Metal1 7.61469e-06f
Cred_3501 VDD.P7.pSD vin.$47.GatPoly 0.0168685f
Cred_3502 VDD.P7.pSD vin.$515.Metal2 0.000207483f
Cred_3503 VDD.P7.pSD vin.$520.Metal2 0.000898795f
Cred_3504 VDD.P7.pSD vin.$523.Metal2 9.35164e-05f
Cred_3505 VDD.P7.pSD vin.$527.Metal2 0.00890149f
Cred_3506 VDD.P7.pSD vin.$528.Metal2 3.55125e-06f
Cred_3507 VDD.P7.pSD vin.$53.GatPoly 0.00409503f
Cred_3508 VDD.P7.pSD vin.$533.Metal2 0.000633697f
Cred_3509 VDD.P7.pSD vin.$535.Metal2 0.000207483f
Cred_3510 VDD.P7.pSD vin.$57.GatPoly 0.0173403f
Cred_3511 VDD.P7.pSD vin.P24.GatPoly 5.27099e-05f
Cred_3512 VDD.P7.pSD vin.P25.GatPoly 0.0361878f
Cred_3513 VDD.P7.pSD vin.P26.GatPoly 0.0361905f
Cred_3514 VDD.P7.pSD vin.P27.GatPoly 5.27099e-05f
Cred_3515 VDD.P7.pSD vout.$1226.Metal3 0.0505156f
Cred_3516 VDD.P7.pSD vout.$1292.Metal3 0.0161613f
Cred_3517 VDD.P7.pSD vout.P4.pSD 0.0172026f
Cred_3518 VDD.P7.pSD vout.P6.nSD 0.000254606f
Cred_3519 VDD.P7.pSD vout.P6.pSD 0.0175836f
Cred_3520 vin vout.$1226.Metal3 0.0706959f
Cred_3521 vin vout.P0.nSD 0.00268836f
Cred_3522 vin vout.P0.pSD 0.0118361f
Cred_3523 vin vout.P2.nSD 0.00111375f
Cred_3524 vin vout.P2.pSD 0.00608689f
Cred_3525 vin VSS.$18.Metal1 0.00510124f
Cred_3526 vin VSS.$40.Metal1 0.00197774f
Cred_3527 vin VSS.$551.Metal1 1.30809e-05f
Cred_3528 vin VSS.P0.pSD 0.0342828f
Cred_3529 vin.$10.GatPoly vout.$1226.Metal3 0.000720663f
Cred_3530 vin.$10.GatPoly vout.P0.nSD 0.000271066f
Cred_3531 vin.$10.GatPoly vout.P0.pSD 9.49386e-05f
Cred_3532 vin.$10.GatPoly vout.P2.nSD 1.39817e-05f
Cred_3533 vin.$10.GatPoly vout.P2.pSD 6.20487e-05f
Cred_3534 vin.$10.GatPoly VSS.$18.Metal1 0.000255718f
Cred_3535 vin.$10.GatPoly VSS.$40.Metal1 9.9141e-05f
Cred_3536 vin.$10.GatPoly VSS.$551.Metal1 1.21854e-06f
Cred_3537 vin.$10.GatPoly VSS.$636.Metal2 0.000233705f
Cred_3538 vin.$10.GatPoly VSS.$644.Metal2 0.000313817f
Cred_3539 vin.$10.GatPoly VSS.$92.Metal1 3.65192e-06f
Cred_3540 vin.$10.GatPoly VSS.$97.Metal1 0.00875726f
Cred_3541 vin.$10.GatPoly VSS.P0.pSD 0.00254523f
Cred_3542 vin.$10.GatPoly VSS.P3.nSD 0.000232966f
Cred_3543 vin.$102.GatPoly vout.$1292.Metal3 0.00434755f
Cred_3544 vin.$102.GatPoly vout.$1358.Metal3 0.00410225f
Cred_3545 vin.$102.GatPoly vout.P10.nSD 0.00585196f
Cred_3546 vin.$102.GatPoly vout.P10.pSD 0.000350025f
Cred_3547 vin.$102.GatPoly vout.P8.nSD 2.30011e-06f
Cred_3548 vin.$102.GatPoly VSS.$18.Metal1 1.39557e-05f
Cred_3549 vin.$102.GatPoly VSS.$275.Metal1 0.000353867f
Cred_3550 vin.$102.GatPoly VSS.$285.Metal1 0.000353867f
Cred_3551 vin.$102.GatPoly VSS.$40.Metal1 5.41058e-06f
Cred_3552 vin.$102.GatPoly VSS.$551.Metal1 3.80862e-05f
Cred_3553 vin.$102.GatPoly VSS.$818.Metal2 0.000150349f
Cred_3554 vin.$102.GatPoly VSS.$826.Metal2 0.000150349f
Cred_3555 vin.$102.GatPoly VSS.P0.pSD 0.00369553f
Cred_3556 vin.$102.GatPoly VSS.P11.nSD 2.72757e-05f
Cred_3557 vin.$105.GatPoly vout.$1292.Metal3 0.00513649f
Cred_3558 vin.$105.GatPoly vout.$1358.Metal3 0.00513649f
Cred_3559 vin.$105.GatPoly vout.P10.nSD 8.09205e-05f
Cred_3560 vin.$105.GatPoly vout.P10.pSD 0.00990689f
Cred_3561 vin.$107.GatPoly vout.$1292.Metal3 0.0244564f
Cred_3562 vin.$107.GatPoly vout.$1358.Metal3 0.0304463f
Cred_3563 vin.$107.GatPoly vout.P10.nSD 0.000385287f
Cred_3564 vin.$107.GatPoly vout.P10.pSD 0.0348187f
Cred_3565 vin.$107.GatPoly vout.P12.pSD 0.000455774f
Cred_3566 vin.$108.GatPoly vout.$1292.Metal3 0.00168266f
Cred_3567 vin.$108.GatPoly vout.$1358.Metal3 0.00210155f
Cred_3568 vin.$108.GatPoly vout.P10.nSD 0.002228f
Cred_3569 vin.$108.GatPoly vout.P10.pSD 0.000143573f
Cred_3570 vin.$108.GatPoly vout.P12.nSD 3.92785e-06f
Cred_3571 vin.$108.GatPoly VSS.$18.Metal1 8.34883e-06f
Cred_3572 vin.$108.GatPoly VSS.$304.Metal1 4.53682e-07f
Cred_3573 vin.$108.GatPoly VSS.$314.Metal1 1.48102e-06f
Cred_3574 vin.$108.GatPoly VSS.$319.Metal1 0.0011929f
Cred_3575 vin.$108.GatPoly VSS.$40.Metal1 3.23682e-06f
Cred_3576 vin.$108.GatPoly VSS.$551.Metal1 3.04743e-05f
Cred_3577 vin.$108.GatPoly VSS.$852.Metal2 3.79032e-09f
Cred_3578 vin.$108.GatPoly VSS.$867.Metal2 0.000392707f
Cred_3579 vin.$108.GatPoly VSS.$875.Metal2 0.000118436f
Cred_3580 vin.$108.GatPoly VSS.P0.pSD 0.00255973f
Cred_3581 vin.$108.GatPoly VSS.P13.nSD 4.4642e-05f
Cred_3582 vin.$110.GatPoly vout.$1292.Metal3 0.00115252f
Cred_3583 vin.$110.GatPoly vout.$1358.Metal3 0.00175093f
Cred_3584 vin.$110.GatPoly vout.P10.nSD 0.00102547f
Cred_3585 vin.$110.GatPoly vout.P10.pSD 9.83392e-05f
Cred_3586 vin.$110.GatPoly vout.P12.nSD 5.61121e-06f
Cred_3587 vin.$110.GatPoly VSS.$18.Metal1 8.08864e-06f
Cred_3588 vin.$110.GatPoly VSS.$304.Metal1 2.98183e-07f
Cred_3589 vin.$110.GatPoly VSS.$314.Metal1 1.29111e-05f
Cred_3590 vin.$110.GatPoly VSS.$319.Metal1 0.00732535f
Cred_3591 vin.$110.GatPoly VSS.$40.Metal1 3.13594e-06f
Cred_3592 vin.$110.GatPoly VSS.$551.Metal1 4.02708e-05f
Cred_3593 vin.$110.GatPoly VSS.$852.Metal2 2.49119e-09f
Cred_3594 vin.$110.GatPoly VSS.$867.Metal2 0.000809477f
Cred_3595 vin.$110.GatPoly VSS.$875.Metal2 0.000244128f
Cred_3596 vin.$110.GatPoly VSS.P0.pSD 0.00289138f
Cred_3597 vin.$110.GatPoly VSS.P13.nSD 0.000202016f
Cred_3598 vin.$115.GatPoly vout.$1292.Metal3 0.000678878f
Cred_3599 vin.$115.GatPoly vout.$1358.Metal3 0.0128531f
Cred_3600 vin.$115.GatPoly vout.P10.nSD 1.06951e-05f
Cred_3601 vin.$115.GatPoly vout.P10.pSD 0.000166405f
Cred_3602 vin.$115.GatPoly vout.P12.pSD 0.0077353f
Cred_3603 vin.$118.GatPoly vout.$1292.Metal3 0.000253425f
Cred_3604 vin.$118.GatPoly vout.$1358.Metal3 0.00238925f
Cred_3605 vin.$118.GatPoly vout.P10.nSD 8.98535e-06f
Cred_3606 vin.$118.GatPoly vout.P10.pSD 2.16235e-05f
Cred_3607 vin.$118.GatPoly vout.P12.nSD 0.000861929f
Cred_3608 vin.$118.GatPoly VSS.$18.Metal1 7.74814e-06f
Cred_3609 vin.$118.GatPoly VSS.$319.Metal1 0.00823109f
Cred_3610 vin.$118.GatPoly VSS.$344.Metal1 3.74658e-06f
Cred_3611 vin.$118.GatPoly VSS.$40.Metal1 3.00393e-06f
Cred_3612 vin.$118.GatPoly VSS.$551.Metal1 5.61816e-05f
Cred_3613 vin.$118.GatPoly VSS.$867.Metal2 0.000786752f
Cred_3614 vin.$118.GatPoly VSS.$875.Metal2 0.000237304f
Cred_3615 vin.$118.GatPoly VSS.$881.Metal2 9.81705e-08f
Cred_3616 vin.$118.GatPoly VSS.P0.pSD 0.00333466f
Cred_3617 vin.$118.GatPoly VSS.P13.nSD 0.000219362f
Cred_3618 vin.$122.GatPoly vout.$1292.Metal3 0.000106508f
Cred_3619 vin.$122.GatPoly vout.$1358.Metal3 0.0090962f
Cred_3620 vin.$122.GatPoly vout.$1424.Metal3 2.65924e-05f
Cred_3621 vin.$122.GatPoly vout.P10.nSD 3.77632e-06f
Cred_3622 vin.$122.GatPoly vout.P10.pSD 9.08784e-06f
Cred_3623 vin.$122.GatPoly vout.P12.nSD 0.00591517f
Cred_3624 vin.$122.GatPoly vout.P14.nSD 9.42849e-07f
Cred_3625 vin.$122.GatPoly vout.P14.pSD 2.269e-06f
Cred_3626 vin.$122.GatPoly VSS.$18.Metal1 6.76849e-06f
Cred_3627 vin.$122.GatPoly VSS.$319.Metal1 0.000635031f
Cred_3628 vin.$122.GatPoly VSS.$372.Metal1 0.000169257f
Cred_3629 vin.$122.GatPoly VSS.$40.Metal1 2.62412e-06f
Cred_3630 vin.$122.GatPoly VSS.$551.Metal1 7.64869e-05f
Cred_3631 vin.$122.GatPoly VSS.$867.Metal2 0.000207253f
Cred_3632 vin.$122.GatPoly VSS.$875.Metal2 6.25048e-05f
Cred_3633 vin.$122.GatPoly VSS.$905.Metal2 2.08531e-06f
Cred_3634 vin.$122.GatPoly VSS.$914.Metal2 5.4913e-05f
Cred_3635 vin.$122.GatPoly VSS.P0.pSD 0.00362484f
Cred_3636 vin.$122.GatPoly VSS.P13.nSD 2.37653e-05f
Cred_3637 vin.$122.GatPoly VSS.P15.nSD 1.40717e-06f
Cred_3638 vin.$123.GatPoly vout.$1292.Metal3 0.000877157f
Cred_3639 vin.$123.GatPoly vout.$1358.Metal3 0.0274113f
Cred_3640 vin.$123.GatPoly vout.P10.nSD 1.38188e-05f
Cred_3641 vin.$123.GatPoly vout.P10.pSD 0.000215008f
Cred_3642 vin.$123.GatPoly vout.P12.pSD 0.0188942f
Cred_3643 vin.$127.GatPoly vout.$1358.Metal3 0.0563073f
Cred_3644 vin.$127.GatPoly vout.$1424.Metal3 0.00286031f
Cred_3645 vin.$127.GatPoly vout.P12.pSD 0.0346375f
Cred_3646 vin.$127.GatPoly vout.P14.nSD 4.50615e-05f
Cred_3647 vin.$127.GatPoly vout.P14.pSD 0.000701114f
Cred_3648 vin.$130.GatPoly vout.$1358.Metal3 0.00469248f
Cred_3649 vin.$130.GatPoly vout.$1424.Metal3 0.000411585f
Cred_3650 vin.$130.GatPoly vout.P12.nSD 0.00211167f
Cred_3651 vin.$130.GatPoly vout.P14.nSD 1.4593e-05f
Cred_3652 vin.$130.GatPoly vout.P14.pSD 3.51185e-05f
Cred_3653 vin.$130.GatPoly VSS.$1241.Metal3 3.73213e-10f
Cred_3654 vin.$130.GatPoly VSS.$18.Metal1 4.90605e-06f
Cred_3655 vin.$130.GatPoly VSS.$344.Metal1 2.28603e-07f
Cred_3656 vin.$130.GatPoly VSS.$356.Metal1 2.16492e-05f
Cred_3657 vin.$130.GatPoly VSS.$369.Metal1 0.000751257f
Cred_3658 vin.$130.GatPoly VSS.$372.Metal1 0.00513046f
Cred_3659 vin.$130.GatPoly VSS.$40.Metal1 1.90206e-06f
Cred_3660 vin.$130.GatPoly VSS.$551.Metal1 8.60755e-05f
Cred_3661 vin.$130.GatPoly VSS.$893.Metal2 4.84579e-08f
Cred_3662 vin.$130.GatPoly VSS.$905.Metal2 3.45181e-05f
Cred_3663 vin.$130.GatPoly VSS.$914.Metal2 0.000904124f
Cred_3664 vin.$130.GatPoly VSS.P0.pSD 0.00325937f
Cred_3665 vin.$130.GatPoly VSS.P15.nSD 4.46155e-05f
Cred_3666 vin.$134.GatPoly VSS.$18.Metal1 3.77821e-06f
Cred_3667 vin.$134.GatPoly VSS.$356.Metal1 0.000101628f
Cred_3668 vin.$134.GatPoly VSS.$369.Metal1 0.00548286f
Cred_3669 vin.$134.GatPoly VSS.$372.Metal1 0.00687275f
Cred_3670 vin.$134.GatPoly VSS.$379.Metal1 7.03154e-08f
Cred_3671 vin.$134.GatPoly VSS.$396.Metal1 2.63576e-09f
Cred_3672 vin.$134.GatPoly VSS.$40.Metal1 1.4648e-06f
Cred_3673 vin.$134.GatPoly VSS.$551.Metal1 9.52108e-05f
Cred_3674 vin.$134.GatPoly VSS.$905.Metal2 6.46772e-06f
Cred_3675 vin.$134.GatPoly VSS.$914.Metal2 0.000147958f
Cred_3676 vin.$134.GatPoly VSS.$928.Metal2 4.42625e-11f
Cred_3677 vin.$134.GatPoly VSS.$934.Metal2 2.20213e-11f
Cred_3678 vin.$134.GatPoly VSS.P0.pSD 0.00299781f
Cred_3679 vin.$134.GatPoly VSS.P15.nSD 6.41932e-05f
Cred_3680 vin.$135.GatPoly vout.$1358.Metal3 3.10023e-08f
Cred_3681 vin.$135.GatPoly vout.$1424.Metal3 1.31326e-08f
Cred_3682 vin.$135.GatPoly vout.P12.pSD 1.16045e-09f
Cred_3683 vin.$135.GatPoly vout.P14.nSD 2.06892e-10f
Cred_3684 vin.$135.GatPoly vout.P14.pSD 2.28099e-09f
Cred_3685 vin.$136.GatPoly vout.$1358.Metal3 0.00499834f
Cred_3686 vin.$136.GatPoly vout.$1424.Metal3 0.00354951f
Cred_3687 vin.$136.GatPoly vout.P12.nSD 1.35855e-05f
Cred_3688 vin.$136.GatPoly vout.P14.nSD 0.00342762f
Cred_3689 vin.$136.GatPoly vout.P14.pSD 0.000302862f
Cred_3690 vin.$136.GatPoly VSS.$18.Metal1 2.8526e-06f
Cred_3691 vin.$136.GatPoly VSS.$372.Metal1 0.0053483f
Cred_3692 vin.$136.GatPoly VSS.$379.Metal1 9.19509e-08f
Cred_3693 vin.$136.GatPoly VSS.$396.Metal1 3.44676e-09f
Cred_3694 vin.$136.GatPoly VSS.$40.Metal1 1.10595e-06f
Cred_3695 vin.$136.GatPoly VSS.$551.Metal1 0.000100497f
Cred_3696 vin.$136.GatPoly VSS.$905.Metal2 5.48618e-05f
Cred_3697 vin.$136.GatPoly VSS.$914.Metal2 0.00144469f
Cred_3698 vin.$136.GatPoly VSS.$928.Metal2 5.78817e-11f
Cred_3699 vin.$136.GatPoly VSS.$934.Metal2 2.87971e-11f
Cred_3700 vin.$136.GatPoly VSS.P0.pSD 0.00266099f
Cred_3701 vin.$136.GatPoly VSS.P15.nSD 4.45362e-05f
Cred_3702 vin.$137.GatPoly vout.$1358.Metal3 0.031535f
Cred_3703 vin.$137.GatPoly vout.$1424.Metal3 0.0255253f
Cred_3704 vin.$137.GatPoly vout.P12.pSD 0.000457058f
Cred_3705 vin.$137.GatPoly vout.P14.nSD 0.000402127f
Cred_3706 vin.$137.GatPoly vout.P14.pSD 0.0365848f
Cred_3707 vin.$144.GatPoly vout.$1358.Metal3 0.00355408f
Cred_3708 vin.$144.GatPoly vout.$1424.Metal3 0.00373487f
Cred_3709 vin.$144.GatPoly vout.P14.nSD 0.00542225f
Cred_3710 vin.$144.GatPoly vout.P14.pSD 0.000303252f
Cred_3711 vin.$144.GatPoly vout.P16.nSD 1.69521e-06f
Cred_3712 vin.$144.GatPoly VSS.$18.Metal1 3.45623e-06f
Cred_3713 vin.$144.GatPoly VSS.$40.Metal1 1.33997e-06f
Cred_3714 vin.$144.GatPoly VSS.$409.Metal1 0.00049805f
Cred_3715 vin.$144.GatPoly VSS.$551.Metal1 0.000173618f
Cred_3716 vin.$144.GatPoly VSS.$952.Metal2 6.60099e-05f
Cred_3717 vin.$144.GatPoly VSS.$961.Metal2 0.000150503f
Cred_3718 vin.$144.GatPoly VSS.P0.pSD 0.00382104f
Cred_3719 vin.$144.GatPoly VSS.P17.nSD 1.86375e-05f
Cred_3720 vin.$145.GatPoly vout.$1358.Metal3 0.00988551f
Cred_3721 vin.$145.GatPoly vout.$1424.Metal3 0.0110746f
Cred_3722 vin.$145.GatPoly vout.P14.nSD 0.000155737f
Cred_3723 vin.$145.GatPoly vout.P14.pSD 0.0161545f
Cred_3724 vin.$145.GatPoly vout.P16.pSD 9.04344e-05f
Cred_3725 vin.$15.GatPoly vout.$1226.Metal3 0.0508176f
Cred_3726 vin.$15.GatPoly vout.P0.nSD 0.000803016f
Cred_3727 vin.$15.GatPoly vout.P0.pSD 0.00487722f
Cred_3728 vin.$15.GatPoly vout.P2.nSD 0.000800583f
Cred_3729 vin.$15.GatPoly vout.P2.pSD 0.0392747f
Cred_3730 vin.$152.GatPoly vout.$1358.Metal3 0.000662949f
Cred_3731 vin.$152.GatPoly vout.$1424.Metal3 0.000984583f
Cred_3732 vin.$152.GatPoly vout.P14.nSD 0.000634338f
Cred_3733 vin.$152.GatPoly vout.P14.pSD 5.65662e-05f
Cred_3734 vin.$152.GatPoly vout.P16.nSD 3.01592e-06f
Cred_3735 vin.$152.GatPoly VSS.$18.Metal1 2.3925e-06f
Cred_3736 vin.$152.GatPoly VSS.$40.Metal1 9.27566e-07f
Cred_3737 vin.$152.GatPoly VSS.$409.Metal1 0.0121868f
Cred_3738 vin.$152.GatPoly VSS.$551.Metal1 0.000206086f
Cred_3739 vin.$152.GatPoly VSS.$952.Metal2 0.000322837f
Cred_3740 vin.$152.GatPoly VSS.$961.Metal2 0.000736069f
Cred_3741 vin.$152.GatPoly VSS.P0.pSD 0.00341579f
Cred_3742 vin.$152.GatPoly VSS.P17.nSD 0.000321264f
Cred_3743 vin.$153.GatPoly vout.$1358.Metal3 0.00887412f
Cred_3744 vin.$153.GatPoly vout.$1424.Metal3 0.0109896f
Cred_3745 vin.$153.GatPoly vout.P14.nSD 0.000139803f
Cred_3746 vin.$153.GatPoly vout.P14.pSD 0.0126694f
Cred_3747 vin.$153.GatPoly vout.P16.pSD 0.00016089f
Cred_3748 vin.$156.GatPoly vout.$1358.Metal3 0.000689567f
Cred_3749 vin.$156.GatPoly vout.$1424.Metal3 0.00808297f
Cred_3750 vin.$156.GatPoly vout.P14.nSD 2.4449e-05f
Cred_3751 vin.$156.GatPoly vout.P14.pSD 5.88374e-05f
Cred_3752 vin.$156.GatPoly vout.P16.nSD 0.00329172f
Cred_3753 vin.$156.GatPoly VSS.$18.Metal1 1.79686e-06f
Cred_3754 vin.$156.GatPoly VSS.$40.Metal1 6.96638e-07f
Cred_3755 vin.$156.GatPoly VSS.$409.Metal1 0.0068704f
Cred_3756 vin.$156.GatPoly VSS.$551.Metal1 0.000241551f
Cred_3757 vin.$156.GatPoly VSS.$952.Metal2 0.000577984f
Cred_3758 vin.$156.GatPoly VSS.$961.Metal2 0.0013178f
Cred_3759 vin.$156.GatPoly VSS.P0.pSD 0.00316125f
Cred_3760 vin.$156.GatPoly VSS.P17.nSD 0.000217338f
Cred_3761 vin.$157.GatPoly vout.$1358.Metal3 0.00286031f
Cred_3762 vin.$157.GatPoly vout.$1424.Metal3 0.0543541f
Cred_3763 vin.$157.GatPoly vout.P14.nSD 4.50615e-05f
Cred_3764 vin.$157.GatPoly vout.P14.pSD 0.000701114f
Cred_3765 vin.$157.GatPoly vout.P16.pSD 0.032808f
Cred_3766 vin.$16.GatPoly vout.$1226.Metal3 0.00169532f
Cred_3767 vin.$16.GatPoly vout.P0.nSD 3.44551e-05f
Cred_3768 vin.$16.GatPoly vout.P0.pSD 0.000152976f
Cred_3769 vin.$16.GatPoly vout.P2.nSD 0.000738215f
Cred_3770 vin.$16.GatPoly vout.P2.pSD 0.000145967f
Cred_3771 vin.$16.GatPoly VSS.$1130.Metal3 2.66708e-10f
Cred_3772 vin.$16.GatPoly VSS.$115.Metal1 1.61848e-06f
Cred_3773 vin.$16.GatPoly VSS.$127.Metal1 9.35005e-08f
Cred_3774 vin.$16.GatPoly VSS.$18.Metal1 0.000235521f
Cred_3775 vin.$16.GatPoly VSS.$40.Metal1 9.13108e-05f
Cred_3776 vin.$16.GatPoly VSS.$551.Metal1 1.57413e-06f
Cred_3777 vin.$16.GatPoly VSS.$636.Metal2 0.000418582f
Cred_3778 vin.$16.GatPoly VSS.$644.Metal2 0.000562129f
Cred_3779 vin.$16.GatPoly VSS.$658.Metal2 3.40456e-08f
Cred_3780 vin.$16.GatPoly VSS.$97.Metal1 0.00977471f
Cred_3781 vin.$16.GatPoly VSS.P0.pSD 0.00282807f
Cred_3782 vin.$16.GatPoly VSS.P3.nSD 0.00027123f
Cred_3783 vin.$163.GatPoly vout.$1424.Metal3 0.00960736f
Cred_3784 vin.$163.GatPoly vout.P16.pSD 0.00750068f
Cred_3785 vin.$164.GatPoly vout 0.000159688f
Cred_3786 vin.$164.GatPoly vout.$1424.Metal3 0.00796989f
Cred_3787 vin.$164.GatPoly vout.P16.nSD 0.00541443f
Cred_3788 vin.$164.GatPoly vout.P18.nSD 2.53242e-06f
Cred_3789 vin.$164.GatPoly VSS.$1002.Metal2 0.000110826f
Cred_3790 vin.$164.GatPoly VSS.$1010.Metal2 8.25299e-05f
Cred_3791 vin.$164.GatPoly VSS.$18.Metal1 1.82767e-06f
Cred_3792 vin.$164.GatPoly VSS.$40.Metal1 7.08583e-07f
Cred_3793 vin.$164.GatPoly VSS.$453.Metal1 0.000453293f
Cred_3794 vin.$164.GatPoly VSS.$551.Metal1 0.000365835f
Cred_3795 vin.$164.GatPoly VSS.P0.pSD 0.00386548f
Cred_3796 vin.$164.GatPoly VSS.P19.nSD 1.69634e-05f
Cred_3797 vin.$167.GatPoly vout 0.00580774f
Cred_3798 vin.$167.GatPoly vout.$1424.Metal3 0.0547899f
Cred_3799 vin.$167.GatPoly vout.P16.pSD 0.0353919f
Cred_3800 vin.$167.GatPoly vout.P18.pSD 0.000659047f
Cred_3801 vin.$17.GatPoly vout.$1226.Metal3 9.75242e-08f
Cred_3802 vin.$17.GatPoly vout.P0.nSD 1.4123e-09f
Cred_3803 vin.$17.GatPoly vout.P0.pSD 7.50474e-09f
Cred_3804 vin.$17.GatPoly vout.P2.nSD 1.5364e-09f
Cred_3805 vin.$17.GatPoly vout.P2.pSD 8.39679e-09f
Cred_3806 vin.$172.GatPoly vout 0.000357335f
Cred_3807 vin.$172.GatPoly vout.$1424.Metal3 0.00169243f
Cred_3808 vin.$172.GatPoly vout.P16.nSD 0.000711506f
Cred_3809 vin.$172.GatPoly vout.P18.nSD 5.66682e-06f
Cred_3810 vin.$172.GatPoly VSS.$1002.Metal2 0.000562129f
Cred_3811 vin.$172.GatPoly VSS.$1010.Metal2 0.000418582f
Cred_3812 vin.$172.GatPoly VSS.$1283.Metal3 2.66708e-10f
Cred_3813 vin.$172.GatPoly VSS.$18.Metal1 1.05851e-06f
Cred_3814 vin.$172.GatPoly VSS.$40.Metal1 4.10381e-07f
Cred_3815 vin.$172.GatPoly VSS.$436.Metal1 9.35005e-08f
Cred_3816 vin.$172.GatPoly VSS.$448.Metal1 1.61848e-06f
Cred_3817 vin.$172.GatPoly VSS.$453.Metal1 0.00977471f
Cred_3818 vin.$172.GatPoly VSS.$551.Metal1 0.000349646f
Cred_3819 vin.$172.GatPoly VSS.$987.Metal2 3.40456e-08f
Cred_3820 vin.$172.GatPoly VSS.P0.pSD 0.00280536f
Cred_3821 vin.$172.GatPoly VSS.P19.nSD 0.00027123f
Cred_3822 vin.$173.GatPoly vout.$1424.Metal3 1.16374e-07f
Cred_3823 vin.$176.GatPoly vout 0.000657408f
Cred_3824 vin.$176.GatPoly vout.$1424.Metal3 0.000280295f
Cred_3825 vin.$176.GatPoly vout.P16.nSD 2.62829e-06f
Cred_3826 vin.$176.GatPoly vout.P18.nSD 0.000253687f
Cred_3827 vin.$176.GatPoly VSS.$1002.Metal2 0.000313817f
Cred_3828 vin.$176.GatPoly VSS.$1010.Metal2 0.000233724f
Cred_3829 vin.$176.GatPoly VSS.$1022.Metal2 1.82757e-08f
Cred_3830 vin.$176.GatPoly VSS.$1292.Metal3 1.46531e-10f
Cred_3831 vin.$176.GatPoly VSS.$18.Metal1 8.1883e-07f
Cred_3832 vin.$176.GatPoly VSS.$40.Metal1 3.17458e-07f
Cred_3833 vin.$176.GatPoly VSS.$453.Metal1 0.00875726f
Cred_3834 vin.$176.GatPoly VSS.$471.Metal1 3.65208e-06f
Cred_3835 vin.$176.GatPoly VSS.$551.Metal1 0.000379633f
Cred_3836 vin.$176.GatPoly VSS.P0.pSD 0.00252057f
Cred_3837 vin.$176.GatPoly VSS.P19.nSD 0.000232966f
Cred_3838 vin.$179.GatPoly vout 0.050768f
Cred_3839 vin.$179.GatPoly vout.$1424.Metal3 0.00503908f
Cred_3840 vin.$179.GatPoly vout.P16.pSD 0.000356917f
Cred_3841 vin.$179.GatPoly vout.P18.pSD 0.0366128f
Cred_3842 vin.$179.GatPoly VSS.$1034.Metal2 9.5385e-07f
Cred_3843 vin.$179.GatPoly VSS.$1040.Metal2 8.87412e-05f
Cred_3844 vin.$179.GatPoly VSS.$1298.Metal3 0.000118967f
Cred_3845 vin.$179.GatPoly VSS.$1307.Metal3 0.000167025f
Cred_3846 vin.$180.GatPoly vout 0.00957138f
Cred_3847 vin.$180.GatPoly vout.$1424.Metal3 0.000280295f
Cred_3848 vin.$180.GatPoly vout.P16.nSD 2.62829e-06f
Cred_3849 vin.$180.GatPoly vout.P18.nSD 0.00562703f
Cred_3850 vin.$180.GatPoly VSS.$1002.Metal2 2.72725e-05f
Cred_3851 vin.$180.GatPoly VSS.$1010.Metal2 2.03093e-05f
Cred_3852 vin.$180.GatPoly VSS.$1034.Metal2 2.03611e-06f
Cred_3853 vin.$180.GatPoly VSS.$1040.Metal2 1.9141e-07f
Cred_3854 vin.$180.GatPoly VSS.$1066.Metal2 5.20838e-06f
Cred_3855 vin.$180.GatPoly VSS.$18.Metal1 1.18244e-06f
Cred_3856 vin.$180.GatPoly VSS.$40.Metal1 4.58427e-07f
Cred_3857 vin.$180.GatPoly VSS.$453.Metal1 0.00053061f
Cred_3858 vin.$180.GatPoly VSS.$483.Metal1 2.21677e-05f
Cred_3859 vin.$180.GatPoly VSS.$498.Metal1 2.28935e-05f
Cred_3860 vin.$180.GatPoly VSS.$509.Metal1 0.000218138f
Cred_3861 vin.$180.GatPoly VSS.$551.Metal1 0.000937115f
Cred_3862 vin.$180.GatPoly VSS.P0.pSD 0.00452419f
Cred_3863 vin.$180.GatPoly VSS.P1.GatPoly 0.000406711f
Cred_3864 vin.$180.GatPoly VSS.P19.nSD 1.99003e-05f
Cred_3865 vin.$180.GatPoly VSS.P21.nSD 1.46261e-06f
Cred_3866 vin.$180.GatPoly VSS.P23.nSD 1.46261e-06f
Cred_3867 vin.$199.Metal1 vout.$1226.Metal3 0.0537761f
Cred_3868 vin.$199.Metal1 vout.P0.nSD 0.00160128f
Cred_3869 vin.$199.Metal1 vout.P0.pSD 0.0601226f
Cred_3870 vin.$199.Metal1 vout.P2.nSD 0.000847191f
Cred_3871 vin.$199.Metal1 vout.P2.pSD 0.00463009f
Cred_3872 vin.$199.Metal1 VSS.$1106.Metal3 0.0014391f
Cred_3873 vin.$199.Metal1 VSS.$1115.Metal3 0.00102503f
Cred_3874 vin.$199.Metal1 VSS.$605.Metal2 0.0007646f
Cred_3875 vin.$199.Metal1 VSS.$611.Metal2 8.21843e-06f
Cred_3876 vin.$202.Metal1 vout.$1226.Metal3 0.0291067f
Cred_3877 vin.$202.Metal1 vout.P0.nSD 0.0279189f
Cred_3878 vin.$202.Metal1 vout.P0.pSD 0.00459543f
Cred_3879 vin.$202.Metal1 vout.P2.nSD 0.000459938f
Cred_3880 vin.$202.Metal1 vout.P2.pSD 0.00250607f
Cred_3881 vin.$202.Metal1 VSS.$18.Metal1 0.00795724f
Cred_3882 vin.$202.Metal1 VSS.$40.Metal1 0.00394819f
Cred_3883 vin.$202.Metal1 VSS.$551.Metal1 2.28259e-05f
Cred_3884 vin.$202.Metal1 VSS.$564.Metal2 2.06102e-05f
Cred_3885 vin.$202.Metal1 VSS.$605.Metal2 5.27614e-06f
Cred_3886 vin.$202.Metal1 VSS.$611.Metal2 7.83396e-05f
Cred_3887 vin.$202.Metal1 VSS.$623.Metal2 1.32163e-05f
Cred_3888 vin.$202.Metal1 VSS.$636.Metal2 0.000254557f
Cred_3889 vin.$202.Metal1 VSS.$644.Metal2 0.000340546f
Cred_3890 vin.$202.Metal1 VSS.$65.Metal1 0.000631049f
Cred_3891 vin.$202.Metal1 VSS.$80.Metal1 0.000749603f
Cred_3892 vin.$202.Metal1 VSS.$92.Metal1 0.00151047f
Cred_3893 vin.$202.Metal1 VSS.$97.Metal1 0.00682585f
Cred_3894 vin.$202.Metal1 VSS.P0.GatPoly 0.00160941f
Cred_3895 vin.$202.Metal1 VSS.P0.nSD 5.78774e-06f
Cred_3896 vin.$202.Metal1 VSS.P0.pSD 0.0580128f
Cred_3897 vin.$202.Metal1 VSS.P1.nSD 5.78774e-06f
Cred_3898 vin.$202.Metal1 VSS.P3.nSD 0.000253606f
Cred_3899 vin.$207.Metal1 vout.$1226.Metal3 0.000152555f
Cred_3900 vin.$207.Metal1 vout.P0.nSD 4.00463e-06f
Cred_3901 vin.$207.Metal1 vout.P0.pSD 3.80138e-05f
Cred_3902 vin.$207.Metal1 vout.P2.nSD 2.40336e-06f
Cred_3903 vin.$207.Metal1 vout.P2.pSD 1.4703e-05f
Cred_3904 vin.$210.Metal1 vout.$1226.Metal3 8.17381e-06f
Cred_3905 vin.$210.Metal1 vout.P0.nSD 1.1837e-07f
Cred_3906 vin.$210.Metal1 vout.P0.pSD 6.28996e-07f
Cred_3907 vin.$210.Metal1 vout.P2.nSD 1.28771e-07f
Cred_3908 vin.$210.Metal1 vout.P2.pSD 7.03761e-07f
Cred_3909 vin.$210.Metal1 VSS.$1130.Metal3 2.23536e-08f
Cred_3910 vin.$210.Metal1 VSS.$115.Metal1 0.00013565f
Cred_3911 vin.$210.Metal1 VSS.$127.Metal1 7.83657e-06f
Cred_3912 vin.$210.Metal1 VSS.$18.Metal1 0.00200093f
Cred_3913 vin.$210.Metal1 VSS.$40.Metal1 0.000775754f
Cred_3914 vin.$210.Metal1 VSS.$551.Metal1 1.13457e-05f
Cred_3915 vin.$210.Metal1 VSS.$636.Metal2 0.00154661f
Cred_3916 vin.$210.Metal1 VSS.$644.Metal2 0.00207838f
Cred_3917 vin.$210.Metal1 VSS.$658.Metal2 2.85347e-06f
Cred_3918 vin.$210.Metal1 VSS.$92.Metal1 0.000306226f
Cred_3919 vin.$210.Metal1 VSS.$97.Metal1 0.0419833f
Cred_3920 vin.$210.Metal1 VSS.P0.pSD 0.0219257f
Cred_3921 vin.$210.Metal1 VSS.P3.nSD 0.00156422f
Cred_3922 vin.$211.Metal1 vout.$1226.Metal3 5.52503e-05f
Cred_3923 vin.$211.Metal1 vout.P0.nSD 1.2452e-06f
Cred_3924 vin.$211.Metal1 vout.P0.pSD 7.48276e-06f
Cred_3925 vin.$211.Metal1 vout.P2.nSD 8.70417e-07f
Cred_3926 vin.$211.Metal1 vout.P2.pSD 5.55851e-06f
Cred_3927 vin.$218.Metal1 vout.$1226.Metal3 0.00095452f
Cred_3928 vin.$218.Metal1 vout.P0.nSD 1.90611e-05f
Cred_3929 vin.$218.Metal1 vout.P0.pSD 8.53615e-05f
Cred_3930 vin.$218.Metal1 vout.P2.nSD 0.000391345f
Cred_3931 vin.$218.Metal1 vout.P2.pSD 8.21837e-05f
Cred_3932 vin.$218.Metal1 VSS.$1130.Metal3 1.58436e-07f
Cred_3933 vin.$218.Metal1 VSS.$115.Metal1 0.00212675f
Cred_3934 vin.$218.Metal1 VSS.$127.Metal1 0.000145714f
Cred_3935 vin.$218.Metal1 VSS.$18.Metal1 0.00132067f
Cred_3936 vin.$218.Metal1 VSS.$40.Metal1 0.000512019f
Cred_3937 vin.$218.Metal1 VSS.$551.Metal1 1.00104e-05f
Cred_3938 vin.$218.Metal1 VSS.$636.Metal2 0.000371147f
Cred_3939 vin.$218.Metal1 VSS.$644.Metal2 0.000518159f
Cred_3940 vin.$218.Metal1 VSS.$658.Metal2 2.09779e-05f
Cred_3941 vin.$218.Metal1 VSS.$97.Metal1 0.00768135f
Cred_3942 vin.$218.Metal1 VSS.P0.pSD 0.0170127f
Cred_3943 vin.$218.Metal1 VSS.P3.nSD 0.000293242f
Cred_3944 vin.$219.Metal1 vout.$1226.Metal3 0.00483512f
Cred_3945 vin.$219.Metal1 vout.P0.nSD 7.00202e-05f
Cred_3946 vin.$219.Metal1 vout.P0.pSD 0.000372076f
Cred_3947 vin.$219.Metal1 vout.P2.nSD 7.61729e-05f
Cred_3948 vin.$219.Metal1 vout.P2.pSD 0.00423958f
Cred_3949 vin.$22.GatPoly vout.$1226.Metal3 0.00680273f
Cred_3950 vin.$22.GatPoly vout.P0.nSD 0.00010294f
Cred_3951 vin.$22.GatPoly vout.P0.pSD 0.00053355f
Cred_3952 vin.$22.GatPoly vout.P2.nSD 0.0055216f
Cred_3953 vin.$22.GatPoly vout.P2.pSD 0.000585712f
Cred_3954 vin.$22.GatPoly VSS.$18.Metal1 0.000246427f
Cred_3955 vin.$22.GatPoly VSS.$40.Metal1 9.55388e-05f
Cred_3956 vin.$22.GatPoly VSS.$551.Metal1 2.71613e-06f
Cred_3957 vin.$22.GatPoly VSS.$636.Metal2 8.25299e-05f
Cred_3958 vin.$22.GatPoly VSS.$644.Metal2 0.000110826f
Cred_3959 vin.$22.GatPoly VSS.$97.Metal1 0.000453293f
Cred_3960 vin.$22.GatPoly VSS.P0.pSD 0.00388917f
Cred_3961 vin.$22.GatPoly VSS.P3.nSD 1.69634e-05f
Cred_3962 vin.$222.Metal1 vout.$1226.Metal3 0.0137326f
Cred_3963 vin.$222.Metal1 vout.P0.nSD 0.00020121f
Cred_3964 vin.$222.Metal1 vout.P0.pSD 0.00106208f
Cred_3965 vin.$222.Metal1 vout.P2.nSD 0.0131392f
Cred_3966 vin.$222.Metal1 vout.P2.pSD 0.00118237f
Cred_3967 vin.$222.Metal1 VSS.$115.Metal1 0.000598552f
Cred_3968 vin.$222.Metal1 VSS.$127.Metal1 0.000529433f
Cred_3969 vin.$222.Metal1 VSS.$18.Metal1 0.00115465f
Cred_3970 vin.$222.Metal1 VSS.$40.Metal1 0.000447652f
Cred_3971 vin.$222.Metal1 VSS.$551.Metal1 1.16535e-05f
Cred_3972 vin.$222.Metal1 VSS.$636.Metal2 4.36492e-05f
Cred_3973 vin.$222.Metal1 VSS.$644.Metal2 5.86146e-05f
Cred_3974 vin.$222.Metal1 VSS.$658.Metal2 4.42291e-06f
Cred_3975 vin.$222.Metal1 VSS.$97.Metal1 0.000239742f
Cred_3976 vin.$222.Metal1 VSS.P0.pSD 0.0173911f
Cred_3977 vin.$222.Metal1 VSS.P3.nSD 8.97176e-06f
Cred_3978 vin.$227.Metal1 vout.$1226.Metal3 0.0232307f
Cred_3979 vin.$227.Metal1 vout.P0.nSD 0.000336417f
Cred_3980 vin.$227.Metal1 vout.P0.pSD 0.00178766f
Cred_3981 vin.$227.Metal1 vout.P2.nSD 0.000365978f
Cred_3982 vin.$227.Metal1 vout.P2.pSD 0.0242275f
Cred_3983 vin.$228.Metal1 vout.$1226.Metal3 0.0162804f
Cred_3984 vin.$228.Metal1 vout.P0.nSD 0.000235765f
Cred_3985 vin.$228.Metal1 vout.P0.pSD 0.00125282f
Cred_3986 vin.$228.Metal1 vout.P2.nSD 0.0156675f
Cred_3987 vin.$228.Metal1 vout.P2.pSD 0.00140173f
Cred_3988 vin.$228.Metal1 VSS.$1142.Metal3 7.35435e-08f
Cred_3989 vin.$228.Metal1 VSS.$137.Metal1 7.35435e-08f
Cred_3990 vin.$228.Metal1 VSS.$142.Metal1 6.60482e-07f
Cred_3991 vin.$228.Metal1 VSS.$18.Metal1 0.00103526f
Cred_3992 vin.$228.Metal1 VSS.$40.Metal1 0.000401368f
Cred_3993 vin.$228.Metal1 VSS.$551.Metal1 1.33068e-05f
Cred_3994 vin.$228.Metal1 VSS.$670.Metal2 3.39178e-05f
Cred_3995 vin.$228.Metal1 VSS.$685.Metal2 1.44928e-05f
Cred_3996 vin.$228.Metal1 VSS.$693.Metal2 2.33344e-06f
Cred_3997 vin.$228.Metal1 VSS.P0.pSD 0.0177633f
Cred_3998 vin.$228.Metal1 VSS.P5.nSD 2.29316e-08f
Cred_3999 vin.$232.Metal1 vout.$1226.Metal3 0.00029252f
Cred_4000 vin.$232.Metal1 vout.P0.nSD 4.23614e-06f
Cred_4001 vin.$232.Metal1 vout.P0.pSD 2.25102e-05f
Cred_4002 vin.$232.Metal1 vout.P2.nSD 8.68854e-05f
Cred_4003 vin.$232.Metal1 vout.P2.pSD 2.51858e-05f
Cred_4004 vin.$232.Metal1 VSS.$1142.Metal3 1.42875e-07f
Cred_4005 vin.$232.Metal1 VSS.$127.Metal1 0.000407947f
Cred_4006 vin.$232.Metal1 VSS.$137.Metal1 0.00101873f
Cred_4007 vin.$232.Metal1 VSS.$142.Metal1 1.28313e-06f
Cred_4008 vin.$232.Metal1 VSS.$18.Metal1 0.000632647f
Cred_4009 vin.$232.Metal1 VSS.$40.Metal1 0.000245275f
Cred_4010 vin.$232.Metal1 VSS.$551.Metal1 1.01359e-05f
Cred_4011 vin.$232.Metal1 VSS.$670.Metal2 4.38787e-05f
Cred_4012 vin.$232.Metal1 VSS.$685.Metal2 2.81555e-05f
Cred_4013 vin.$232.Metal1 VSS.$693.Metal2 4.53323e-06f
Cred_4014 vin.$232.Metal1 VSS.P0.pSD 0.0122229f
Cred_4015 vin.$232.Metal1 VSS.P5.nSD 4.45497e-08f
Cred_4016 vin.$233.Metal1 vout.$1226.Metal3 0.00390011f
Cred_4017 vin.$233.Metal1 vout.P0.nSD 5.64797e-05f
Cred_4018 vin.$233.Metal1 vout.P0.pSD 0.000300124f
Cred_4019 vin.$233.Metal1 vout.P2.nSD 6.14426e-05f
Cred_4020 vin.$233.Metal1 vout.P2.pSD 0.00325896f
Cred_4021 vin.$236.Metal1 vout.$1226.Metal3 0.000124248f
Cred_4022 vin.$236.Metal1 vout.P0.nSD 1.79931e-06f
Cred_4023 vin.$236.Metal1 vout.P0.pSD 9.56121e-06f
Cred_4024 vin.$236.Metal1 vout.P2.nSD 1.26286e-05f
Cred_4025 vin.$236.Metal1 vout.P2.pSD 1.06977e-05f
Cred_4026 vin.$236.Metal1 VSS.$1142.Metal3 1.3464e-07f
Cred_4027 vin.$236.Metal1 VSS.$137.Metal1 1.3464e-07f
Cred_4028 vin.$236.Metal1 VSS.$142.Metal1 0.0117113f
Cred_4029 vin.$236.Metal1 VSS.$18.Metal1 0.000598671f
Cred_4030 vin.$236.Metal1 VSS.$40.Metal1 0.000232103f
Cred_4031 vin.$236.Metal1 VSS.$551.Metal1 1.12561e-05f
Cred_4032 vin.$236.Metal1 VSS.$670.Metal2 2.79061e-05f
Cred_4033 vin.$236.Metal1 VSS.$685.Metal2 0.000725046f
Cred_4034 vin.$236.Metal1 VSS.$693.Metal2 0.000310638f
Cred_4035 vin.$236.Metal1 VSS.P0.pSD 0.012598f
Cred_4036 vin.$236.Metal1 VSS.P5.nSD 0.000424836f
Cred_4037 vin.$237.Metal1 vout.$1226.Metal3 3.55807e-05f
Cred_4038 vin.$237.Metal1 vout.P0.nSD 5.15264e-07f
Cred_4039 vin.$237.Metal1 vout.P0.pSD 2.73803e-06f
Cred_4040 vin.$237.Metal1 vout.P2.nSD 5.60541e-07f
Cred_4041 vin.$237.Metal1 vout.P2.pSD 3.06348e-06f
Cred_4042 vin.$24.GatPoly vout.$1226.Metal3 0.00764466f
Cred_4043 vin.$24.GatPoly vout.P0.nSD 8.97252e-05f
Cred_4044 vin.$24.GatPoly vout.P0.pSD 0.000476785f
Cred_4045 vin.$24.GatPoly vout.P2.nSD 0.00338933f
Cred_4046 vin.$24.GatPoly vout.P2.pSD 0.000533457f
Cred_4047 vin.$24.GatPoly vout.P4.nSD 1.35855e-05f
Cred_4048 vin.$24.GatPoly VSS.$142.Metal1 0.0068704f
Cred_4049 vin.$24.GatPoly VSS.$18.Metal1 0.000162709f
Cred_4050 vin.$24.GatPoly VSS.$40.Metal1 6.30816e-05f
Cred_4051 vin.$24.GatPoly VSS.$551.Metal1 2.66943e-06f
Cred_4052 vin.$24.GatPoly VSS.$685.Metal2 0.0013178f
Cred_4053 vin.$24.GatPoly VSS.$693.Metal2 0.000577984f
Cred_4054 vin.$24.GatPoly VSS.P0.pSD 0.00317683f
Cred_4055 vin.$24.GatPoly VSS.P5.nSD 0.000217338f
Cred_4056 vin.$240.Metal1 VSS.$142.Metal1 0.0375483f
Cred_4057 vin.$240.Metal1 VSS.$18.Metal1 0.000748872f
Cred_4058 vin.$240.Metal1 VSS.$40.Metal1 0.000290335f
Cred_4059 vin.$240.Metal1 VSS.$551.Metal1 1.77979e-05f
Cred_4060 vin.$240.Metal1 VSS.$685.Metal2 0.00225701f
Cred_4061 vin.$240.Metal1 VSS.$693.Metal2 0.000989916f
Cred_4062 vin.$240.Metal1 VSS.P0.pSD 0.0178259f
Cred_4063 vin.$240.Metal1 VSS.P5.nSD 0.00140626f
Cred_4064 vin.$246.Metal1 vout.$1226.Metal3 0.000947268f
Cred_4065 vin.$246.Metal1 vout.P0.nSD 2.06442e-06f
Cred_4066 vin.$246.Metal1 vout.P0.pSD 1.097e-05f
Cred_4067 vin.$246.Metal1 vout.P2.nSD 3.84091e-06f
Cred_4068 vin.$246.Metal1 vout.P2.pSD 1.22739e-05f
Cred_4069 vin.$246.Metal1 vout.P4.nSD 0.00032997f
Cred_4070 vin.$246.Metal1 VSS.$142.Metal1 0.0100393f
Cred_4071 vin.$246.Metal1 VSS.$167.Metal1 0.00074865f
Cred_4072 vin.$246.Metal1 VSS.$18.Metal1 0.000658154f
Cred_4073 vin.$246.Metal1 VSS.$40.Metal1 0.000255164f
Cred_4074 vin.$246.Metal1 VSS.$551.Metal1 1.99146e-05f
Cred_4075 vin.$246.Metal1 VSS.$685.Metal2 0.000697698f
Cred_4076 vin.$246.Metal1 VSS.$693.Metal2 0.000309797f
Cred_4077 vin.$246.Metal1 VSS.$699.Metal2 4.46721e-05f
Cred_4078 vin.$246.Metal1 VSS.P0.pSD 0.0177866f
Cred_4079 vin.$246.Metal1 VSS.P5.nSD 0.000359912f
Cred_4080 vin.$247.Metal1 vout.$1226.Metal3 0.010864f
Cred_4081 vin.$247.Metal1 vout.P0.nSD 1.32332e-05f
Cred_4082 vin.$247.Metal1 vout.P0.pSD 7.0319e-05f
Cred_4083 vin.$247.Metal1 vout.P2.nSD 1.4396e-05f
Cred_4084 vin.$247.Metal1 vout.P2.pSD 0.000155297f
Cred_4085 vin.$247.Metal1 vout.P4.pSD 0.00613201f
Cred_4086 vin.$25.GatPoly vout.$1226.Metal3 0.0493491f
Cred_4087 vin.$25.GatPoly vout.P0.nSD 0.000629834f
Cred_4088 vin.$25.GatPoly vout.P0.pSD 0.00334683f
Cred_4089 vin.$25.GatPoly vout.P2.nSD 0.000685178f
Cred_4090 vin.$25.GatPoly vout.P2.pSD 0.0359824f
Cred_4091 vin.$25.GatPoly vout.P4.pSD 0.000411545f
Cred_4092 vin.$250.Metal1 vout.$1226.Metal3 0.0147902f
Cred_4093 vin.$250.Metal1 vout.P0.nSD 1.16038e-06f
Cred_4094 vin.$250.Metal1 vout.P0.pSD 6.16608e-06f
Cred_4095 vin.$250.Metal1 vout.P2.nSD 2.15893e-06f
Cred_4096 vin.$250.Metal1 vout.P2.pSD 6.89901e-06f
Cred_4097 vin.$250.Metal1 vout.P4.nSD 0.0108783f
Cred_4098 vin.$250.Metal1 VSS.$142.Metal1 0.000479229f
Cred_4099 vin.$250.Metal1 VSS.$167.Metal1 0.00115729f
Cred_4100 vin.$250.Metal1 VSS.$18.Metal1 0.000570214f
Cred_4101 vin.$250.Metal1 VSS.$40.Metal1 0.00022107f
Cred_4102 vin.$250.Metal1 VSS.$551.Metal1 2.26838e-05f
Cred_4103 vin.$250.Metal1 VSS.$685.Metal2 7.95992e-05f
Cred_4104 vin.$250.Metal1 VSS.$693.Metal2 3.6165e-05f
Cred_4105 vin.$250.Metal1 VSS.$699.Metal2 1.2149e-05f
Cred_4106 vin.$250.Metal1 VSS.P0.pSD 0.0177723f
Cred_4107 vin.$250.Metal1 VSS.P5.nSD 9.85719e-06f
Cred_4108 vin.$251.Metal1 vout.$1226.Metal3 0.0205824f
Cred_4109 vin.$251.Metal1 vout.P0.nSD 7.43821e-06f
Cred_4110 vin.$251.Metal1 vout.P0.pSD 3.95254e-05f
Cred_4111 vin.$251.Metal1 vout.P2.nSD 8.09181e-06f
Cred_4112 vin.$251.Metal1 vout.P2.pSD 8.72905e-05f
Cred_4113 vin.$251.Metal1 vout.P4.pSD 0.0144287f
Cred_4114 vin.$258.Metal1 vout.$1226.Metal3 0.0211493f
Cred_4115 vin.$258.Metal1 vout.P4.nSD 0.0169439f
Cred_4116 vin.$258.Metal1 VSS.$1163.Metal3 1.31152e-08f
Cred_4117 vin.$258.Metal1 VSS.$167.Metal1 6.98466e-05f
Cred_4118 vin.$258.Metal1 VSS.$18.Metal1 0.000495962f
Cred_4119 vin.$258.Metal1 VSS.$184.Metal1 0.000154212f
Cred_4120 vin.$258.Metal1 VSS.$195.Metal1 1.48819e-06f
Cred_4121 vin.$258.Metal1 VSS.$40.Metal1 0.000192283f
Cred_4122 vin.$258.Metal1 VSS.$551.Metal1 2.486e-05f
Cred_4123 vin.$258.Metal1 VSS.$711.Metal2 5.83555e-07f
Cred_4124 vin.$258.Metal1 VSS.$717.Metal2 1.35373e-05f
Cred_4125 vin.$258.Metal1 VSS.$732.Metal2 1.70451e-05f
Cred_4126 vin.$258.Metal1 VSS.$740.Metal2 5.85163e-07f
Cred_4127 vin.$258.Metal1 VSS.P0.pSD 0.017434f
Cred_4128 vin.$258.Metal1 VSS.P7.nSD 8.70293e-09f
Cred_4129 vin.$259.Metal1 vout.$1226.Metal3 0.0209774f
Cred_4130 vin.$259.Metal1 vout.P4.pSD 0.0170573f
Cred_4131 vin.$262.Metal1 vout.$1226.Metal3 0.000396588f
Cred_4132 vin.$262.Metal1 vout.P4.nSD 0.000133051f
Cred_4133 vin.$262.Metal1 VSS.$1163.Metal3 5.54875e-08f
Cred_4134 vin.$262.Metal1 VSS.$167.Metal1 0.000646423f
Cred_4135 vin.$262.Metal1 VSS.$18.Metal1 0.000314882f
Cred_4136 vin.$262.Metal1 VSS.$184.Metal1 0.00144256f
Cred_4137 vin.$262.Metal1 VSS.$195.Metal1 1.18852e-05f
Cred_4138 vin.$262.Metal1 VSS.$40.Metal1 0.000122079f
Cred_4139 vin.$262.Metal1 VSS.$551.Metal1 1.98456e-05f
Cred_4140 vin.$262.Metal1 VSS.$711.Metal2 5.40074e-06f
Cred_4141 vin.$262.Metal1 VSS.$717.Metal2 6.31661e-05f
Cred_4142 vin.$262.Metal1 VSS.$732.Metal2 7.22346e-05f
Cred_4143 vin.$262.Metal1 VSS.$740.Metal2 2.48028e-06f
Cred_4144 vin.$262.Metal1 VSS.P0.pSD 0.0124755f
Cred_4145 vin.$262.Metal1 VSS.P7.nSD 8.37022e-08f
Cred_4146 vin.$263.Metal1 vout.$1226.Metal3 0.00135071f
Cred_4147 vin.$263.Metal1 vout.P4.pSD 0.000374822f
Cred_4148 vin.$264.Metal1 vout.$1226.Metal3 0.000176163f
Cred_4149 vin.$264.Metal1 vout.P4.nSD 1.87265e-06f
Cred_4150 vin.$264.Metal1 VSS.$1163.Metal3 1.38935e-07f
Cred_4151 vin.$264.Metal1 VSS.$167.Metal1 4.28272e-05f
Cred_4152 vin.$264.Metal1 VSS.$18.Metal1 0.00040627f
Cred_4153 vin.$264.Metal1 VSS.$184.Metal1 0.00114249f
Cred_4154 vin.$264.Metal1 VSS.$195.Metal1 0.022397f
Cred_4155 vin.$264.Metal1 VSS.$40.Metal1 0.00015751f
Cred_4156 vin.$264.Metal1 VSS.$551.Metal1 3.22577e-05f
Cred_4157 vin.$264.Metal1 VSS.$711.Metal2 3.57813e-07f
Cred_4158 vin.$264.Metal1 VSS.$717.Metal2 4.59267e-05f
Cred_4159 vin.$264.Metal1 VSS.$732.Metal2 0.000664556f
Cred_4160 vin.$264.Metal1 VSS.$740.Metal2 2.45783e-05f
Cred_4161 vin.$264.Metal1 VSS.P0.pSD 0.0181068f
Cred_4162 vin.$264.Metal1 VSS.P7.nSD 0.000207174f
Cred_4163 vin.$265.Metal1 vout.$1226.Metal3 6.69587e-05f
Cred_4164 vin.$265.Metal1 vout.$1292.Metal3 1.67231e-06f
Cred_4165 vin.$265.Metal1 vout.P4.pSD 1.95318e-07f
Cred_4166 vin.$265.Metal1 vout.P6.nSD 2.63457e-08f
Cred_4167 vin.$265.Metal1 vout.P6.pSD 3.39303e-07f
Cred_4168 vin.$27.GatPoly vout.$1226.Metal3 0.00841927f
Cred_4169 vin.$27.GatPoly vout.P0.nSD 0.000121924f
Cred_4170 vin.$27.GatPoly vout.P0.pSD 0.000647885f
Cred_4171 vin.$27.GatPoly vout.P2.nSD 0.000132638f
Cred_4172 vin.$27.GatPoly vout.P2.pSD 0.00828964f
Cred_4173 vin.$272.Metal1 vout.$1226.Metal3 1.13457e-05f
Cred_4174 vin.$272.Metal1 vout.$1292.Metal3 1.13457e-05f
Cred_4175 vin.$272.Metal1 vout.P6.nSD 2.6058e-07f
Cred_4176 vin.$272.Metal1 vout.P6.pSD 9.76862e-07f
Cred_4177 vin.$272.Metal1 VSS.$1172.Metal3 3.12823e-08f
Cred_4178 vin.$272.Metal1 VSS.$18.Metal1 0.000464688f
Cred_4179 vin.$272.Metal1 VSS.$192.Metal1 0.000613059f
Cred_4180 vin.$272.Metal1 VSS.$195.Metal1 0.0369406f
Cred_4181 vin.$272.Metal1 VSS.$207.Metal1 0.0006588f
Cred_4182 vin.$272.Metal1 VSS.$219.Metal1 1.91613e-05f
Cred_4183 vin.$272.Metal1 VSS.$40.Metal1 0.000180158f
Cred_4184 vin.$272.Metal1 VSS.$551.Metal1 4.91377e-05f
Cred_4185 vin.$272.Metal1 VSS.$732.Metal2 0.000798763f
Cred_4186 vin.$272.Metal1 VSS.$740.Metal2 3.61193e-05f
Cred_4187 vin.$272.Metal1 VSS.$752.Metal2 4.06169e-06f
Cred_4188 vin.$272.Metal1 VSS.P0.pSD 0.0239629f
Cred_4189 vin.$272.Metal1 VSS.P7.nSD 0.000350366f
Cred_4190 vin.$273.Metal1 vout.$1226.Metal3 4.83458e-05f
Cred_4191 vin.$273.Metal1 vout.$1292.Metal3 4.46677e-05f
Cred_4192 vin.$273.Metal1 vout.P4.pSD 1.32775e-07f
Cred_4193 vin.$273.Metal1 vout.P6.nSD 7.03698e-07f
Cred_4194 vin.$273.Metal1 vout.P6.pSD 6.4668e-06f
Cred_4195 vin.$277.Metal1 vout.$1226.Metal3 7.03749e-05f
Cred_4196 vin.$277.Metal1 vout.$1292.Metal3 7.03749e-05f
Cred_4197 vin.$277.Metal1 vout.P6.nSD 1.10869e-06f
Cred_4198 vin.$277.Metal1 vout.P6.pSD 1.1191e-05f
Cred_4199 vin.$280.Metal1 vout.$1226.Metal3 0.00270877f
Cred_4200 vin.$280.Metal1 vout.$1292.Metal3 0.00263404f
Cred_4201 vin.$280.Metal1 vout.P4.nSD 7.00732e-07f
Cred_4202 vin.$280.Metal1 vout.P6.nSD 0.00337504f
Cred_4203 vin.$280.Metal1 vout.P6.pSD 0.000226789f
Cred_4204 vin.$280.Metal1 VSS.$1172.Metal3 1.40401e-07f
Cred_4205 vin.$280.Metal1 VSS.$18.Metal1 0.000294978f
Cred_4206 vin.$280.Metal1 VSS.$192.Metal1 0.000217158f
Cred_4207 vin.$280.Metal1 VSS.$195.Metal1 0.000705229f
Cred_4208 vin.$280.Metal1 VSS.$207.Metal1 0.0022483f
Cred_4209 vin.$280.Metal1 VSS.$219.Metal1 0.000202968f
Cred_4210 vin.$280.Metal1 VSS.$40.Metal1 0.000114362f
Cred_4211 vin.$280.Metal1 VSS.$551.Metal1 4.12212e-05f
Cred_4212 vin.$280.Metal1 VSS.$732.Metal2 8.3775e-05f
Cred_4213 vin.$280.Metal1 VSS.$740.Metal2 2.25167e-05f
Cred_4214 vin.$280.Metal1 VSS.$752.Metal2 1.92068e-05f
Cred_4215 vin.$280.Metal1 VSS.P0.pSD 0.0175595f
Cred_4216 vin.$280.Metal1 VSS.P7.nSD 5.88858e-06f
Cred_4217 vin.$281.Metal1 vout.$1226.Metal3 0.00224909f
Cred_4218 vin.$281.Metal1 vout.$1292.Metal3 0.00224909f
Cred_4219 vin.$281.Metal1 vout.P6.nSD 3.54323e-05f
Cred_4220 vin.$281.Metal1 vout.P6.pSD 0.00227072f
Cred_4221 vin.$284.Metal1 vout.$1226.Metal3 0.0115648f
Cred_4222 vin.$284.Metal1 vout.$1292.Metal3 0.0115353f
Cred_4223 vin.$284.Metal1 vout.P4.nSD 2.77091e-07f
Cred_4224 vin.$284.Metal1 vout.P6.nSD 0.0198603f
Cred_4225 vin.$284.Metal1 vout.P6.pSD 0.000993182f
Cred_4226 vin.$284.Metal1 VSS.$18.Metal1 0.000270584f
Cred_4227 vin.$284.Metal1 VSS.$195.Metal1 8.95181e-05f
Cred_4228 vin.$284.Metal1 VSS.$40.Metal1 0.000104905f
Cred_4229 vin.$284.Metal1 VSS.$551.Metal1 5.02669e-05f
Cred_4230 vin.$284.Metal1 VSS.$732.Metal2 2.90429e-05f
Cred_4231 vin.$284.Metal1 VSS.$740.Metal2 1.10289e-06f
Cred_4232 vin.$284.Metal1 VSS.P0.pSD 0.0186178f
Cred_4233 vin.$284.Metal1 VSS.P7.nSD 7.44237e-07f
Cred_4234 vin.$285.Metal1 vout.$1226.Metal3 0.0116135f
Cred_4235 vin.$285.Metal1 vout.$1292.Metal3 0.0116135f
Cred_4236 vin.$285.Metal1 vout.P6.nSD 0.00018296f
Cred_4237 vin.$285.Metal1 vout.P6.pSD 0.0220364f
Cred_4238 vin.$290.Metal1 vout.$1226.Metal3 0.00355904f
Cred_4239 vin.$290.Metal1 vout.$1292.Metal3 0.00367739f
Cred_4240 vin.$290.Metal1 vout.P6.nSD 0.00587158f
Cred_4241 vin.$290.Metal1 vout.P6.pSD 0.000306431f
Cred_4242 vin.$290.Metal1 vout.P8.nSD 1.10981e-06f
Cred_4243 vin.$290.Metal1 VSS.$18.Metal1 0.000303742f
Cred_4244 vin.$290.Metal1 VSS.$219.Metal1 0.00138105f
Cred_4245 vin.$290.Metal1 VSS.$232.Metal1 0.00373045f
Cred_4246 vin.$290.Metal1 VSS.$40.Metal1 0.00011776f
Cred_4247 vin.$290.Metal1 VSS.$551.Metal1 7.56664e-05f
Cred_4248 vin.$290.Metal1 VSS.$764.Metal2 4.76175e-05f
Cred_4249 vin.$290.Metal1 VSS.$770.Metal2 9.29939e-05f
Cred_4250 vin.$290.Metal1 VSS.$779.Metal2 0.000292588f
Cred_4251 vin.$290.Metal1 VSS.P0.pSD 0.0242265f
Cred_4252 vin.$290.Metal1 VSS.P10.nSD 0.000113253f
Cred_4253 vin.$291.Metal1 vout.$1226.Metal3 0.00774494f
Cred_4254 vin.$291.Metal1 vout.$1292.Metal3 0.00869489f
Cred_4255 vin.$291.Metal1 vout.P6.nSD 0.000122014f
Cred_4256 vin.$291.Metal1 vout.P6.pSD 0.0112744f
Cred_4257 vin.$291.Metal1 vout.P8.pSD 6.67492e-05f
Cred_4258 vin.$295.Metal1 vout.$1226.Metal3 0.0030992f
Cred_4259 vin.$295.Metal1 vout.$1292.Metal3 0.00383442f
Cred_4260 vin.$295.Metal1 vout.P6.nSD 4.8825e-05f
Cred_4261 vin.$295.Metal1 vout.P6.pSD 0.00428749f
Cred_4262 vin.$295.Metal1 vout.P8.pSD 5.16607e-05f
Cred_4263 vin.$298.Metal1 vout.$1226.Metal3 2.6058e-05f
Cred_4264 vin.$298.Metal1 vout.$1292.Metal3 7.35828e-05f
Cred_4265 vin.$298.Metal1 vout.P6.nSD 6.43208e-07f
Cred_4266 vin.$298.Metal1 vout.P6.pSD 2.24358e-06f
Cred_4267 vin.$298.Metal1 vout.P8.nSD 2.11277e-07f
Cred_4268 vin.$298.Metal1 VSS.$18.Metal1 0.000199738f
Cred_4269 vin.$298.Metal1 VSS.$219.Metal1 0.000314013f
Cred_4270 vin.$298.Metal1 VSS.$232.Metal1 0.0306613f
Cred_4271 vin.$298.Metal1 VSS.$40.Metal1 7.74379e-05f
Cred_4272 vin.$298.Metal1 VSS.$551.Metal1 6.57938e-05f
Cred_4273 vin.$298.Metal1 VSS.$764.Metal2 8.22798e-06f
Cred_4274 vin.$298.Metal1 VSS.$770.Metal2 0.000632215f
Cred_4275 vin.$298.Metal1 VSS.$779.Metal2 0.0020881f
Cred_4276 vin.$298.Metal1 VSS.P0.pSD 0.0183607f
Cred_4277 vin.$298.Metal1 VSS.P10.nSD 0.00112176f
Cred_4278 vin.$302.Metal1 vout.$1226.Metal3 3.90959e-05f
Cred_4279 vin.$302.Metal1 vout.$1292.Metal3 0.000132079f
Cred_4280 vin.$302.Metal1 vout.P6.nSD 1.02929e-06f
Cred_4281 vin.$302.Metal1 vout.P6.pSD 3.36614e-06f
Cred_4282 vin.$302.Metal1 vout.P8.nSD 4.13368e-07f
Cred_4283 vin.$302.Metal1 VSS.$18.Metal1 0.000171088f
Cred_4284 vin.$302.Metal1 VSS.$232.Metal1 0.0268674f
Cred_4285 vin.$302.Metal1 VSS.$247.Metal1 0.00124072f
Cred_4286 vin.$302.Metal1 VSS.$259.Metal1 2.6008e-05f
Cred_4287 vin.$302.Metal1 VSS.$40.Metal1 6.63301e-05f
Cred_4288 vin.$302.Metal1 VSS.$551.Metal1 7.48984e-05f
Cred_4289 vin.$302.Metal1 VSS.$770.Metal2 0.000589775f
Cred_4290 vin.$302.Metal1 VSS.$779.Metal2 0.00195557f
Cred_4291 vin.$302.Metal1 VSS.$793.Metal2 2.17285e-07f
Cred_4292 vin.$302.Metal1 VSS.P0.pSD 0.0181523f
Cred_4293 vin.$302.Metal1 VSS.P10.nSD 0.000994954f
Cred_4294 vin.$303.Metal1 vout.$1292.Metal3 9.34686e-06f
Cred_4295 vin.$307.Metal1 vout.$1292.Metal3 0.00115034f
Cred_4296 vin.$307.Metal1 vout.P8.pSD 0.000166022f
Cred_4297 vin.$310.Metal1 vout.$1292.Metal3 0.00222534f
Cred_4298 vin.$310.Metal1 vout.P8.nSD 0.00164979f
Cred_4299 vin.$310.Metal1 VSS.$18.Metal1 0.000152837f
Cred_4300 vin.$310.Metal1 VSS.$247.Metal1 0.00169644f
Cred_4301 vin.$310.Metal1 VSS.$259.Metal1 0.000519672f
Cred_4302 vin.$310.Metal1 VSS.$40.Metal1 5.92543e-05f
Cred_4303 vin.$310.Metal1 VSS.$551.Metal1 8.45826e-05f
Cred_4304 vin.$310.Metal1 VSS.$793.Metal2 3.66904e-05f
Cred_4305 vin.$310.Metal1 VSS.P0.pSD 0.0182447f
Cred_4306 vin.$312.Metal1 vout.$1292.Metal3 0.0235303f
Cred_4307 vin.$312.Metal1 vout.P8.nSD 0.0191443f
Cred_4308 vin.$312.Metal1 VSS.$18.Metal1 0.000130905f
Cred_4309 vin.$312.Metal1 VSS.$40.Metal1 5.07516e-05f
Cred_4310 vin.$312.Metal1 VSS.$551.Metal1 9.63951e-05f
Cred_4311 vin.$312.Metal1 VSS.P0.pSD 0.0180266f
Cred_4312 vin.$313.Metal1 vout.$1292.Metal3 0.0174116f
Cred_4313 vin.$313.Metal1 vout.P8.pSD 0.0141845f
Cred_4314 vin.$317.Metal1 vout.$1292.Metal3 0.0156846f
Cred_4315 vin.$317.Metal1 vout.P8.pSD 0.0128219f
Cred_4316 vin.$320.Metal1 vout.$1292.Metal3 0.0091509f
Cred_4317 vin.$320.Metal1 vout.$1358.Metal3 4.72442e-05f
Cred_4318 vin.$320.Metal1 vout.P10.nSD 1.67507e-06f
Cred_4319 vin.$320.Metal1 vout.P10.pSD 4.03112e-06f
Cred_4320 vin.$320.Metal1 vout.P8.nSD 0.00719773f
Cred_4321 vin.$320.Metal1 VSS 6.61531e-08f
Cred_4322 vin.$320.Metal1 VSS.$1196.Metal3 4.95488e-08f
Cred_4323 vin.$320.Metal1 VSS.$18.Metal1 0.000151179f
Cred_4324 vin.$320.Metal1 VSS.$259.Metal1 0.00047739f
Cred_4325 vin.$320.Metal1 VSS.$269.Metal1 0.00207483f
Cred_4326 vin.$320.Metal1 VSS.$275.Metal1 0.000667405f
Cred_4327 vin.$320.Metal1 VSS.$285.Metal1 0.000455223f
Cred_4328 vin.$320.Metal1 VSS.$40.Metal1 5.86117e-05f
Cred_4329 vin.$320.Metal1 VSS.$551.Metal1 0.000145454f
Cred_4330 vin.$320.Metal1 VSS.$805.Metal2 1.86017e-05f
Cred_4331 vin.$320.Metal1 VSS.$818.Metal2 0.000104238f
Cred_4332 vin.$320.Metal1 VSS.$826.Metal2 8.9625e-05f
Cred_4333 vin.$320.Metal1 VSS.P0.pSD 0.0237685f
Cred_4334 vin.$320.Metal1 VSS.P11.nSD 3.55581e-05f
Cred_4335 vin.$321.Metal1 vout.$1292.Metal3 0.00227998f
Cred_4336 vin.$321.Metal1 vout.P8.pSD 0.00126704f
Cred_4337 vin.$325.Metal1 vout.$1292.Metal3 5.64036e-05f
Cred_4338 vin.$328.Metal1 vout.$1292.Metal3 2.78522e-05f
Cred_4339 vin.$328.Metal1 VSS 3.47719e-08f
Cred_4340 vin.$328.Metal1 VSS.$1196.Metal3 2.60442e-08f
Cred_4341 vin.$328.Metal1 VSS.$18.Metal1 0.000128568f
Cred_4342 vin.$328.Metal1 VSS.$269.Metal1 0.000843771f
Cred_4343 vin.$328.Metal1 VSS.$275.Metal1 0.0202203f
Cred_4344 vin.$328.Metal1 VSS.$285.Metal1 0.0200613f
Cred_4345 vin.$328.Metal1 VSS.$40.Metal1 4.98454e-05f
Cred_4346 vin.$328.Metal1 VSS.$551.Metal1 0.000174492f
Cred_4347 vin.$328.Metal1 VSS.$805.Metal2 7.6811e-06f
Cred_4348 vin.$328.Metal1 VSS.$818.Metal2 0.00182688f
Cred_4349 vin.$328.Metal1 VSS.$826.Metal2 0.0018192f
Cred_4350 vin.$328.Metal1 VSS.P0.pSD 0.0239891f
Cred_4351 vin.$328.Metal1 VSS.P11.nSD 0.00156783f
Cred_4352 vin.$334.Metal1 vout.$1292.Metal3 0.000387573f
Cred_4353 vin.$334.Metal1 vout.$1358.Metal3 0.000264287f
Cred_4354 vin.$334.Metal1 vout.P10.nSD 0.000208731f
Cred_4355 vin.$334.Metal1 vout.P10.pSD 2.25503e-05f
Cred_4356 vin.$334.Metal1 vout.P8.nSD 1.15604e-06f
Cred_4357 vin.$334.Metal1 VSS 7.04167e-08f
Cred_4358 vin.$334.Metal1 VSS.$1217.Metal3 5.27422e-08f
Cred_4359 vin.$334.Metal1 VSS.$18.Metal1 8.09876e-05f
Cred_4360 vin.$334.Metal1 VSS.$275.Metal1 0.00701343f
Cred_4361 vin.$334.Metal1 VSS.$285.Metal1 0.00733533f
Cred_4362 vin.$334.Metal1 VSS.$294.Metal1 0.00170872f
Cred_4363 vin.$334.Metal1 VSS.$40.Metal1 3.13986e-05f
Cred_4364 vin.$334.Metal1 VSS.$551.Metal1 0.000148628f
Cred_4365 vin.$334.Metal1 VSS.$818.Metal2 0.00070613f
Cred_4366 vin.$334.Metal1 VSS.$826.Metal2 0.000721685f
Cred_4367 vin.$334.Metal1 VSS.$840.Metal2 1.5555e-05f
Cred_4368 vin.$334.Metal1 VSS.P0.pSD 0.0175972f
Cred_4369 vin.$334.Metal1 VSS.P11.nSD 0.000556764f
Cred_4370 vin.$335.Metal1 vout.$1292.Metal3 2.6845e-05f
Cred_4371 vin.$335.Metal1 vout.$1358.Metal3 2.6845e-05f
Cred_4372 vin.$335.Metal1 vout.P10.nSD 4.22919e-07f
Cred_4373 vin.$335.Metal1 vout.P10.pSD 2.29056e-06f
Cred_4374 vin.$338.Metal1 vout.$1292.Metal3 0.00450804f
Cred_4375 vin.$338.Metal1 vout.$1358.Metal3 0.00437831f
Cred_4376 vin.$338.Metal1 vout.P10.nSD 0.00731727f
Cred_4377 vin.$338.Metal1 vout.P10.pSD 0.000373579f
Cred_4378 vin.$338.Metal1 vout.P8.nSD 1.2165e-06f
Cred_4379 vin.$338.Metal1 VSS 3.14628e-08f
Cred_4380 vin.$338.Metal1 VSS.$1217.Metal3 2.35657e-08f
Cred_4381 vin.$338.Metal1 VSS.$18.Metal1 7.37098e-05f
Cred_4382 vin.$338.Metal1 VSS.$275.Metal1 0.000187156f
Cred_4383 vin.$338.Metal1 VSS.$285.Metal1 0.000240754f
Cred_4384 vin.$338.Metal1 VSS.$294.Metal1 0.00123303f
Cred_4385 vin.$338.Metal1 VSS.$304.Metal1 0.00047739f
Cred_4386 vin.$338.Metal1 VSS.$40.Metal1 2.85771e-05f
Cred_4387 vin.$338.Metal1 VSS.$551.Metal1 0.000177508f
Cred_4388 vin.$338.Metal1 VSS.$818.Metal2 7.95179e-05f
Cred_4389 vin.$338.Metal1 VSS.$826.Metal2 8.64679e-05f
Cred_4390 vin.$338.Metal1 VSS.$840.Metal2 1.09387e-05f
Cred_4391 vin.$338.Metal1 VSS.P0.pSD 0.0183459f
Cred_4392 vin.$338.Metal1 VSS.P11.nSD 1.44258e-05f
Cred_4393 vin.$339.Metal1 vout.$1292.Metal3 0.00106876f
Cred_4394 vin.$339.Metal1 vout.$1358.Metal3 0.00106876f
Cred_4395 vin.$339.Metal1 vout.P10.nSD 1.68373e-05f
Cred_4396 vin.$339.Metal1 vout.P10.pSD 0.00139346f
Cred_4397 vin.$343.Metal1 vout.$1292.Metal3 0.00729627f
Cred_4398 vin.$343.Metal1 vout.$1358.Metal3 0.00729627f
Cred_4399 vin.$343.Metal1 vout.P10.nSD 0.000114946f
Cred_4400 vin.$343.Metal1 vout.P10.pSD 0.0137322f
Cred_4401 vin.$346.Metal1 vout.$1292.Metal3 0.0111991f
Cred_4402 vin.$346.Metal1 vout.$1358.Metal3 0.0111991f
Cred_4403 vin.$346.Metal1 vout.P10.nSD 0.0193208f
Cred_4404 vin.$346.Metal1 vout.P10.pSD 0.000955568f
Cred_4405 vin.$346.Metal1 VSS.$18.Metal1 6.49307e-05f
Cred_4406 vin.$346.Metal1 VSS.$40.Metal1 2.51734e-05f
Cred_4407 vin.$346.Metal1 VSS.$551.Metal1 0.000194338f
Cred_4408 vin.$346.Metal1 VSS.P0.pSD 0.0180202f
Cred_4409 vin.$347.Metal1 vout.$1292.Metal3 0.00779742f
Cred_4410 vin.$347.Metal1 vout.$1358.Metal3 0.00779742f
Cred_4411 vin.$347.Metal1 vout.P10.nSD 0.000122841f
Cred_4412 vin.$347.Metal1 vout.P10.pSD 0.0145913f
Cred_4413 vin.$348.Metal1 vout.$1292.Metal3 0.00105914f
Cred_4414 vin.$348.Metal1 vout.$1358.Metal3 0.00105914f
Cred_4415 vin.$348.Metal1 vout.P10.nSD 0.00166647f
Cred_4416 vin.$348.Metal1 vout.P10.pSD 9.03714e-05f
Cred_4417 vin.$348.Metal1 VSS.$18.Metal1 5.69736e-05f
Cred_4418 vin.$348.Metal1 VSS.$304.Metal1 0.000519672f
Cred_4419 vin.$348.Metal1 VSS.$314.Metal1 0.00169644f
Cred_4420 vin.$348.Metal1 VSS.$40.Metal1 2.20885e-05f
Cred_4421 vin.$348.Metal1 VSS.$551.Metal1 0.000226896f
Cred_4422 vin.$348.Metal1 VSS.$852.Metal2 3.66904e-05f
Cred_4423 vin.$348.Metal1 VSS.P0.pSD 0.0182354f
Cred_4424 vin.$353.Metal1 vout.$1292.Metal3 0.00054301f
Cred_4425 vin.$353.Metal1 vout.$1358.Metal3 0.00054301f
Cred_4426 vin.$353.Metal1 vout.P10.nSD 8.55462e-06f
Cred_4427 vin.$353.Metal1 vout.P10.pSD 0.000221788f
Cred_4428 vin.$356.Metal1 vout.$1292.Metal3 4.4255e-05f
Cred_4429 vin.$356.Metal1 vout.$1358.Metal3 0.000126429f
Cred_4430 vin.$356.Metal1 vout.P10.nSD 1.11056e-06f
Cred_4431 vin.$356.Metal1 vout.P10.pSD 3.77606e-06f
Cred_4432 vin.$356.Metal1 vout.P12.nSD 4.13368e-07f
Cred_4433 vin.$356.Metal1 VSS.$18.Metal1 5.04517e-05f
Cred_4434 vin.$356.Metal1 VSS.$304.Metal1 2.6008e-05f
Cred_4435 vin.$356.Metal1 VSS.$314.Metal1 0.00124072f
Cred_4436 vin.$356.Metal1 VSS.$319.Metal1 0.0268674f
Cred_4437 vin.$356.Metal1 VSS.$40.Metal1 1.956e-05f
Cred_4438 vin.$356.Metal1 VSS.$551.Metal1 0.000253982f
Cred_4439 vin.$356.Metal1 VSS.$852.Metal2 2.17285e-07f
Cred_4440 vin.$356.Metal1 VSS.$867.Metal2 0.00195557f
Cred_4441 vin.$356.Metal1 VSS.$875.Metal2 0.000589775f
Cred_4442 vin.$356.Metal1 VSS.P0.pSD 0.0181406f
Cred_4443 vin.$356.Metal1 VSS.P13.nSD 0.000994954f
Cred_4444 vin.$357.Metal1 vout.$1292.Metal3 4.4486e-06f
Cred_4445 vin.$357.Metal1 vout.$1358.Metal3 4.4486e-06f
Cred_4446 vin.$357.Metal1 vout.P10.nSD 7.00835e-08f
Cred_4447 vin.$357.Metal1 vout.P10.pSD 3.79577e-07f
Cred_4448 vin.$36.GatPoly vout.$1226.Metal3 0.00166244f
Cred_4449 vin.$36.GatPoly vout.P0.nSD 3.90331e-06f
Cred_4450 vin.$36.GatPoly vout.P0.pSD 2.07415e-05f
Cred_4451 vin.$36.GatPoly vout.P2.nSD 7.26222e-06f
Cred_4452 vin.$36.GatPoly vout.P2.pSD 2.3207e-05f
Cred_4453 vin.$36.GatPoly vout.P4.nSD 0.000623893f
Cred_4454 vin.$36.GatPoly VSS.$142.Metal1 0.0121868f
Cred_4455 vin.$36.GatPoly VSS.$18.Metal1 0.00013882f
Cred_4456 vin.$36.GatPoly VSS.$40.Metal1 5.38199e-05f
Cred_4457 vin.$36.GatPoly VSS.$551.Metal1 3.55342e-06f
Cred_4458 vin.$36.GatPoly VSS.$685.Metal2 0.000736069f
Cred_4459 vin.$36.GatPoly VSS.$693.Metal2 0.000322837f
Cred_4460 vin.$36.GatPoly VSS.P0.pSD 0.003429f
Cred_4461 vin.$36.GatPoly VSS.P5.nSD 0.000321264f
Cred_4462 vin.$360.Metal1 vout.$1292.Metal3 2.26192e-05f
Cred_4463 vin.$360.Metal1 vout.$1358.Metal3 7.73893e-05f
Cred_4464 vin.$360.Metal1 vout.P10.nSD 5.67622e-07f
Cred_4465 vin.$360.Metal1 vout.P10.pSD 1.92999e-06f
Cred_4466 vin.$360.Metal1 vout.P12.nSD 2.32689e-07f
Cred_4467 vin.$360.Metal1 VSS.$18.Metal1 4.43179e-05f
Cred_4468 vin.$360.Metal1 VSS.$319.Metal1 0.0306613f
Cred_4469 vin.$360.Metal1 VSS.$344.Metal1 0.000314013f
Cred_4470 vin.$360.Metal1 VSS.$40.Metal1 1.71819e-05f
Cred_4471 vin.$360.Metal1 VSS.$551.Metal1 0.00029652f
Cred_4472 vin.$360.Metal1 VSS.$867.Metal2 0.0020881f
Cred_4473 vin.$360.Metal1 VSS.$875.Metal2 0.000632215f
Cred_4474 vin.$360.Metal1 VSS.$881.Metal2 8.22798e-06f
Cred_4475 vin.$360.Metal1 VSS.P0.pSD 0.0183456f
Cred_4476 vin.$360.Metal1 VSS.P13.nSD 0.00112176f
Cred_4477 vin.$365.Metal1 vout.$1292.Metal3 0.000359051f
Cred_4478 vin.$365.Metal1 vout.$1358.Metal3 0.00682448f
Cred_4479 vin.$365.Metal1 vout.P10.nSD 5.65651e-06f
Cred_4480 vin.$365.Metal1 vout.P10.pSD 8.801e-05f
Cred_4481 vin.$365.Metal1 vout.P12.pSD 0.00409171f
Cred_4482 vin.$368.Metal1 vout.$1292.Metal3 5.63311e-05f
Cred_4483 vin.$368.Metal1 vout.$1358.Metal3 0.0075369f
Cred_4484 vin.$368.Metal1 vout.P10.nSD 1.99725e-06f
Cred_4485 vin.$368.Metal1 vout.P10.pSD 4.80646e-06f
Cred_4486 vin.$368.Metal1 vout.P12.nSD 0.00581551f
Cred_4487 vin.$368.Metal1 VSS.$18.Metal1 5.09665e-05f
Cred_4488 vin.$368.Metal1 VSS.$319.Metal1 0.00373045f
Cred_4489 vin.$368.Metal1 VSS.$344.Metal1 0.00138105f
Cred_4490 vin.$368.Metal1 VSS.$40.Metal1 1.97595e-05f
Cred_4491 vin.$368.Metal1 VSS.$551.Metal1 0.000450924f
Cred_4492 vin.$368.Metal1 VSS.$867.Metal2 0.000292588f
Cred_4493 vin.$368.Metal1 VSS.$875.Metal2 9.29939e-05f
Cred_4494 vin.$368.Metal1 VSS.$881.Metal2 4.76175e-05f
Cred_4495 vin.$368.Metal1 VSS.P0.pSD 0.024202f
Cred_4496 vin.$368.Metal1 VSS.P13.nSD 0.000113253f
Cred_4497 vin.$369.Metal1 vout.$1292.Metal3 0.000463919f
Cred_4498 vin.$369.Metal1 vout.$1358.Metal3 0.0164812f
Cred_4499 vin.$369.Metal1 vout.P10.nSD 7.30861e-06f
Cred_4500 vin.$369.Metal1 vout.P10.pSD 0.000113715f
Cred_4501 vin.$369.Metal1 vout.P12.pSD 0.0107913f
Cred_4502 vin.$37.GatPoly vout.$1226.Metal3 0.0204022f
Cred_4503 vin.$37.GatPoly vout.P0.nSD 2.50207e-05f
Cred_4504 vin.$37.GatPoly vout.P0.pSD 0.000132956f
Cred_4505 vin.$37.GatPoly vout.P2.nSD 2.72193e-05f
Cred_4506 vin.$37.GatPoly vout.P2.pSD 0.000293629f
Cred_4507 vin.$37.GatPoly vout.P4.pSD 0.0115941f
Cred_4508 vin.$374.Metal1 vout.$1358.Metal3 0.0242595f
Cred_4509 vin.$374.Metal1 vout.$1424.Metal3 1.40644e-05f
Cred_4510 vin.$374.Metal1 vout.P12.nSD 0.0196785f
Cred_4511 vin.$374.Metal1 vout.P14.nSD 4.98662e-07f
Cred_4512 vin.$374.Metal1 vout.P14.pSD 1.20005e-06f
Cred_4513 vin.$374.Metal1 VSS.$18.Metal1 3.38576e-05f
Cred_4514 vin.$374.Metal1 VSS.$372.Metal1 8.95181e-05f
Cred_4515 vin.$374.Metal1 VSS.$40.Metal1 1.31265e-05f
Cred_4516 vin.$374.Metal1 VSS.$551.Metal1 0.000401699f
Cred_4517 vin.$374.Metal1 VSS.$905.Metal2 1.10289e-06f
Cred_4518 vin.$374.Metal1 VSS.$914.Metal2 2.90429e-05f
Cred_4519 vin.$374.Metal1 VSS.P0.pSD 0.0185949f
Cred_4520 vin.$374.Metal1 VSS.P15.nSD 7.44237e-07f
Cred_4521 vin.$375.Metal1 vout.$1358.Metal3 0.023578f
Cred_4522 vin.$375.Metal1 vout.P12.pSD 0.021265f
Cred_4523 vin.$378.Metal1 vout.$1358.Metal3 0.00557193f
Cred_4524 vin.$378.Metal1 vout.$1424.Metal3 3.55673e-05f
Cred_4525 vin.$378.Metal1 vout.P12.nSD 0.00333354f
Cred_4526 vin.$378.Metal1 vout.P14.nSD 1.26106e-06f
Cred_4527 vin.$378.Metal1 vout.P14.pSD 3.03479e-06f
Cred_4528 vin.$378.Metal1 VSS.$1241.Metal3 1.40401e-07f
Cred_4529 vin.$378.Metal1 VSS.$18.Metal1 2.77643e-05f
Cred_4530 vin.$378.Metal1 VSS.$344.Metal1 0.000202968f
Cred_4531 vin.$378.Metal1 VSS.$356.Metal1 0.0022483f
Cred_4532 vin.$378.Metal1 VSS.$369.Metal1 0.000217158f
Cred_4533 vin.$378.Metal1 VSS.$372.Metal1 0.000705229f
Cred_4534 vin.$378.Metal1 VSS.$40.Metal1 1.07641e-05f
Cred_4535 vin.$378.Metal1 VSS.$551.Metal1 0.000437913f
Cred_4536 vin.$378.Metal1 VSS.$893.Metal2 1.92068e-05f
Cred_4537 vin.$378.Metal1 VSS.$905.Metal2 2.25167e-05f
Cred_4538 vin.$378.Metal1 VSS.$914.Metal2 8.3775e-05f
Cred_4539 vin.$378.Metal1 VSS.P0.pSD 0.0175336f
Cred_4540 vin.$378.Metal1 VSS.P15.nSD 5.88858e-06f
Cred_4541 vin.$379.Metal1 vout.$1358.Metal3 0.00460492f
Cred_4542 vin.$379.Metal1 vout.P12.pSD 0.00208398f
Cred_4543 vin.$383.Metal1 vout.$1358.Metal3 0.000147556f
Cred_4544 vin.$383.Metal1 vout.P12.pSD 5.4933e-06f
Cred_4545 vin.$386.Metal1 vout.$1358.Metal3 2.3847e-05f
Cred_4546 vin.$386.Metal1 vout.P12.nSD 8.18389e-08f
Cred_4547 vin.$386.Metal1 VSS.$1241.Metal3 3.12823e-08f
Cred_4548 vin.$386.Metal1 VSS.$18.Metal1 3.30955e-05f
Cred_4549 vin.$386.Metal1 VSS.$344.Metal1 1.91613e-05f
Cred_4550 vin.$386.Metal1 VSS.$356.Metal1 0.0006588f
Cred_4551 vin.$386.Metal1 VSS.$369.Metal1 0.000613059f
Cred_4552 vin.$386.Metal1 VSS.$372.Metal1 0.0369406f
Cred_4553 vin.$386.Metal1 VSS.$40.Metal1 1.2831e-05f
Cred_4554 vin.$386.Metal1 VSS.$551.Metal1 0.000689859f
Cred_4555 vin.$386.Metal1 VSS.$893.Metal2 4.06169e-06f
Cred_4556 vin.$386.Metal1 VSS.$905.Metal2 3.61193e-05f
Cred_4557 vin.$386.Metal1 VSS.$914.Metal2 0.000798763f
Cred_4558 vin.$386.Metal1 VSS.P0.pSD 0.0239211f
Cred_4559 vin.$386.Metal1 VSS.P15.nSD 0.000350366f
Cred_4560 vin.$387.Metal1 vout.$1358.Metal3 9.54292e-05f
Cred_4561 vin.$387.Metal1 vout.$1424.Metal3 1.74057e-06f
Cred_4562 vin.$387.Metal1 vout.P12.pSD 2.81725e-06f
Cred_4563 vin.$387.Metal1 vout.P14.nSD 2.7421e-08f
Cred_4564 vin.$387.Metal1 vout.P14.pSD 3.02317e-07f
Cred_4565 vin.$392.Metal1 vout.$1358.Metal3 8.38441e-05f
Cred_4566 vin.$392.Metal1 vout.$1424.Metal3 8.38441e-05f
Cred_4567 vin.$392.Metal1 vout.P14.nSD 3.19353e-06f
Cred_4568 vin.$392.Metal1 vout.P14.pSD 7.154e-06f
Cred_4569 vin.$392.Metal1 VSS.$1250.Metal3 1.38935e-07f
Cred_4570 vin.$392.Metal1 VSS.$18.Metal1 2.17256e-05f
Cred_4571 vin.$392.Metal1 VSS.$372.Metal1 0.022397f
Cred_4572 vin.$392.Metal1 VSS.$379.Metal1 0.00114249f
Cred_4573 vin.$392.Metal1 VSS.$396.Metal1 4.28272e-05f
Cred_4574 vin.$392.Metal1 VSS.$40.Metal1 8.42296e-06f
Cred_4575 vin.$392.Metal1 VSS.$551.Metal1 0.000603133f
Cred_4576 vin.$392.Metal1 VSS.$905.Metal2 2.45783e-05f
Cred_4577 vin.$392.Metal1 VSS.$914.Metal2 0.000664556f
Cred_4578 vin.$392.Metal1 VSS.$928.Metal2 4.59267e-05f
Cred_4579 vin.$392.Metal1 VSS.$934.Metal2 3.57813e-07f
Cred_4580 vin.$392.Metal1 VSS.P0.pSD 0.0180695f
Cred_4581 vin.$392.Metal1 VSS.P15.nSD 0.000207174f
Cred_4582 vin.$393.Metal1 vout.$1358.Metal3 3.45421e-05f
Cred_4583 vin.$393.Metal1 vout.$1424.Metal3 3.10581e-05f
Cred_4584 vin.$393.Metal1 vout.P12.pSD 2.26251e-07f
Cred_4585 vin.$393.Metal1 vout.P14.nSD 4.89291e-07f
Cred_4586 vin.$393.Metal1 vout.P14.pSD 2.87628e-06f
Cred_4587 vin.$396.Metal1 vout.$1358.Metal3 0.000188754f
Cred_4588 vin.$396.Metal1 vout.$1424.Metal3 0.000188754f
Cred_4589 vin.$396.Metal1 vout.P14.nSD 0.000136024f
Cred_4590 vin.$396.Metal1 vout.P14.pSD 1.61055e-05f
Cred_4591 vin.$396.Metal1 VSS.$1250.Metal3 5.54875e-08f
Cred_4592 vin.$396.Metal1 VSS.$18.Metal1 1.33655e-05f
Cred_4593 vin.$396.Metal1 VSS.$372.Metal1 1.18852e-05f
Cred_4594 vin.$396.Metal1 VSS.$379.Metal1 0.00144256f
Cred_4595 vin.$396.Metal1 VSS.$396.Metal1 0.000646423f
Cred_4596 vin.$396.Metal1 VSS.$40.Metal1 5.18177e-06f
Cred_4597 vin.$396.Metal1 VSS.$551.Metal1 0.000467462f
Cred_4598 vin.$396.Metal1 VSS.$905.Metal2 2.48028e-06f
Cred_4599 vin.$396.Metal1 VSS.$914.Metal2 7.22346e-05f
Cred_4600 vin.$396.Metal1 VSS.$928.Metal2 6.31661e-05f
Cred_4601 vin.$396.Metal1 VSS.$934.Metal2 5.40074e-06f
Cred_4602 vin.$396.Metal1 VSS.P0.pSD 0.0124463f
Cred_4603 vin.$396.Metal1 VSS.P15.nSD 8.37022e-08f
Cred_4604 vin.$397.Metal1 vout.$1358.Metal3 0.00063605f
Cred_4605 vin.$397.Metal1 vout.$1424.Metal3 0.00063605f
Cred_4606 vin.$397.Metal1 vout.P14.nSD 1.00204e-05f
Cred_4607 vin.$397.Metal1 vout.P14.pSD 0.000443449f
Cred_4608 vin.$400.Metal1 vout.$1358.Metal3 0.0100659f
Cred_4609 vin.$400.Metal1 vout.$1424.Metal3 0.0100659f
Cred_4610 vin.$400.Metal1 vout.P14.nSD 0.0171025f
Cred_4611 vin.$400.Metal1 vout.P14.pSD 0.000858876f
Cred_4612 vin.$400.Metal1 VSS.$1250.Metal3 1.31152e-08f
Cred_4613 vin.$400.Metal1 VSS.$18.Metal1 1.67418e-05f
Cred_4614 vin.$400.Metal1 VSS.$372.Metal1 1.48819e-06f
Cred_4615 vin.$400.Metal1 VSS.$379.Metal1 0.000154212f
Cred_4616 vin.$400.Metal1 VSS.$396.Metal1 6.98466e-05f
Cred_4617 vin.$400.Metal1 VSS.$40.Metal1 6.49075e-06f
Cred_4618 vin.$400.Metal1 VSS.$551.Metal1 0.000736286f
Cred_4619 vin.$400.Metal1 VSS.$905.Metal2 5.85163e-07f
Cred_4620 vin.$400.Metal1 VSS.$914.Metal2 1.70451e-05f
Cred_4621 vin.$400.Metal1 VSS.$928.Metal2 1.35373e-05f
Cred_4622 vin.$400.Metal1 VSS.$934.Metal2 5.83555e-07f
Cred_4623 vin.$400.Metal1 VSS.P0.pSD 0.0173875f
Cred_4624 vin.$400.Metal1 VSS.P15.nSD 8.70293e-09f
Cred_4625 vin.$401.Metal1 vout.$1358.Metal3 0.00954509f
Cred_4626 vin.$401.Metal1 vout.$1424.Metal3 0.00954509f
Cred_4627 vin.$401.Metal1 vout.P14.nSD 0.000150374f
Cred_4628 vin.$401.Metal1 vout.P14.pSD 0.0178495f
Cred_4629 vin.$408.Metal1 vout.$1358.Metal3 0.00700118f
Cred_4630 vin.$408.Metal1 vout.$1424.Metal3 0.00709679f
Cred_4631 vin.$408.Metal1 vout.P14.nSD 0.0109886f
Cred_4632 vin.$408.Metal1 vout.P14.pSD 0.000597376f
Cred_4633 vin.$408.Metal1 vout.P16.nSD 8.9658e-07f
Cred_4634 vin.$408.Metal1 VSS.$18.Metal1 1.52754e-05f
Cred_4635 vin.$408.Metal1 VSS.$396.Metal1 0.00115729f
Cred_4636 vin.$408.Metal1 VSS.$40.Metal1 5.92222e-06f
Cred_4637 vin.$408.Metal1 VSS.$409.Metal1 0.000479229f
Cred_4638 vin.$408.Metal1 VSS.$551.Metal1 0.000846518f
Cred_4639 vin.$408.Metal1 VSS.$946.Metal2 1.2149e-05f
Cred_4640 vin.$408.Metal1 VSS.$952.Metal2 3.6165e-05f
Cred_4641 vin.$408.Metal1 VSS.$961.Metal2 7.95992e-05f
Cred_4642 vin.$408.Metal1 VSS.P0.pSD 0.0177186f
Cred_4643 vin.$408.Metal1 VSS.P17.nSD 9.85719e-06f
Cred_4644 vin.$409.Metal1 vout.$1358.Metal3 0.00923975f
Cred_4645 vin.$409.Metal1 vout.$1424.Metal3 0.00986865f
Cred_4646 vin.$409.Metal1 vout.P14.nSD 0.000145564f
Cred_4647 vin.$409.Metal1 vout.P14.pSD 0.0152637f
Cred_4648 vin.$409.Metal1 vout.P16.pSD 4.78297e-05f
Cred_4649 vin.$412.Metal1 vout.$1358.Metal3 0.000383f
Cred_4650 vin.$412.Metal1 vout.$1424.Metal3 0.000553109f
Cred_4651 vin.$412.Metal1 vout.P14.nSD 0.000336004f
Cred_4652 vin.$412.Metal1 vout.P14.pSD 3.26795e-05f
Cred_4653 vin.$412.Metal1 vout.P16.nSD 1.59509e-06f
Cred_4654 vin.$412.Metal1 VSS.$18.Metal1 1.34093e-05f
Cred_4655 vin.$412.Metal1 VSS.$396.Metal1 0.00074865f
Cred_4656 vin.$412.Metal1 VSS.$40.Metal1 5.19876e-06f
Cred_4657 vin.$412.Metal1 VSS.$409.Metal1 0.0100393f
Cred_4658 vin.$412.Metal1 VSS.$551.Metal1 0.00097707f
Cred_4659 vin.$412.Metal1 VSS.$946.Metal2 4.46721e-05f
Cred_4660 vin.$412.Metal1 VSS.$952.Metal2 0.000309797f
Cred_4661 vin.$412.Metal1 VSS.$961.Metal2 0.000697698f
Cred_4662 vin.$412.Metal1 VSS.P0.pSD 0.0177241f
Cred_4663 vin.$412.Metal1 VSS.P17.nSD 0.000359912f
Cred_4664 vin.$413.Metal1 vout.$1358.Metal3 0.00472945f
Cred_4665 vin.$413.Metal1 vout.$1424.Metal3 0.00584832f
Cred_4666 vin.$413.Metal1 vout.P14.nSD 7.45081e-05f
Cred_4667 vin.$413.Metal1 vout.P14.pSD 0.0067038f
Cred_4668 vin.$413.Metal1 vout.P16.pSD 8.5093e-05f
Cred_4669 vin.$418.Metal1 VSS.$18.Metal1 1.19828e-05f
Cred_4670 vin.$418.Metal1 VSS.$40.Metal1 4.64571e-06f
Cred_4671 vin.$418.Metal1 VSS.$409.Metal1 0.0375483f
Cred_4672 vin.$418.Metal1 VSS.$551.Metal1 0.00111175f
Cred_4673 vin.$418.Metal1 VSS.$952.Metal2 0.000989916f
Cred_4674 vin.$418.Metal1 VSS.$961.Metal2 0.00225701f
Cred_4675 vin.$418.Metal1 VSS.P0.pSD 0.0177546f
Cred_4676 vin.$418.Metal1 VSS.P17.nSD 0.00140626f
Cred_4677 vin.$42.GatPoly vout.$1226.Metal3 0.00761891f
Cred_4678 vin.$42.GatPoly vout.P0.nSD 2.194e-06f
Cred_4679 vin.$42.GatPoly vout.P0.pSD 1.16586e-05f
Cred_4680 vin.$42.GatPoly vout.P2.nSD 4.082e-06f
Cred_4681 vin.$42.GatPoly vout.P2.pSD 1.30444e-05f
Cred_4682 vin.$42.GatPoly vout.P4.nSD 0.00536626f
Cred_4683 vin.$42.GatPoly VSS.$142.Metal1 0.00049805f
Cred_4684 vin.$42.GatPoly VSS.$18.Metal1 0.000116949f
Cred_4685 vin.$42.GatPoly VSS.$40.Metal1 4.53406e-05f
Cred_4686 vin.$42.GatPoly VSS.$551.Metal1 5.13234e-06f
Cred_4687 vin.$42.GatPoly VSS.$685.Metal2 0.000150503f
Cred_4688 vin.$42.GatPoly VSS.$693.Metal2 6.60099e-05f
Cred_4689 vin.$42.GatPoly VSS.P0.pSD 0.00383203f
Cred_4690 vin.$42.GatPoly VSS.P5.nSD 1.86375e-05f
Cred_4691 vin.$422.Metal1 vout.$1424.Metal3 0.000148264f
Cred_4692 vin.$422.Metal1 vout.P16.nSD 1.06712e-05f
Cred_4693 vin.$422.Metal1 VSS.$1271.Metal3 1.3464e-07f
Cred_4694 vin.$422.Metal1 VSS.$18.Metal1 7.57743e-06f
Cred_4695 vin.$422.Metal1 VSS.$40.Metal1 2.93775e-06f
Cred_4696 vin.$422.Metal1 VSS.$409.Metal1 0.0117113f
Cred_4697 vin.$422.Metal1 VSS.$426.Metal1 1.3464e-07f
Cred_4698 vin.$422.Metal1 VSS.$551.Metal1 0.000888765f
Cred_4699 vin.$422.Metal1 VSS.$952.Metal2 0.000310638f
Cred_4700 vin.$422.Metal1 VSS.$961.Metal2 0.000725046f
Cred_4701 vin.$422.Metal1 VSS.$975.Metal2 2.79061e-05f
Cred_4702 vin.$422.Metal1 VSS.P0.pSD 0.0125407f
Cred_4703 vin.$422.Metal1 VSS.P17.nSD 0.000424836f
Cred_4704 vin.$423.Metal1 vout.$1424.Metal3 4.2458e-05f
Cred_4705 vin.$426.Metal1 vout.$1424.Metal3 0.00034906f
Cred_4706 vin.$426.Metal1 vout.P16.nSD 8.2277e-05f
Cred_4707 vin.$426.Metal1 VSS.$1271.Metal3 1.42875e-07f
Cred_4708 vin.$426.Metal1 VSS.$18.Metal1 6.8226e-06f
Cred_4709 vin.$426.Metal1 VSS.$40.Metal1 2.6451e-06f
Cred_4710 vin.$426.Metal1 VSS.$409.Metal1 1.28313e-06f
Cred_4711 vin.$426.Metal1 VSS.$426.Metal1 0.00101873f
Cred_4712 vin.$426.Metal1 VSS.$436.Metal1 0.000407947f
Cred_4713 vin.$426.Metal1 VSS.$551.Metal1 0.000939203f
Cred_4714 vin.$426.Metal1 VSS.$952.Metal2 4.53323e-06f
Cred_4715 vin.$426.Metal1 VSS.$961.Metal2 2.81555e-05f
Cred_4716 vin.$426.Metal1 VSS.$975.Metal2 4.38787e-05f
Cred_4717 vin.$426.Metal1 VSS.P0.pSD 0.0121623f
Cred_4718 vin.$426.Metal1 VSS.P17.nSD 4.45497e-08f
Cred_4719 vin.$427.Metal1 vout.$1424.Metal3 0.00449306f
Cred_4720 vin.$427.Metal1 vout.P16.pSD 0.00292921f
Cred_4721 vin.$43.GatPoly vout.$1226.Metal3 0.0222699f
Cred_4722 vin.$43.GatPoly vout.P0.nSD 1.40638e-05f
Cred_4723 vin.$43.GatPoly vout.P0.pSD 7.4733e-05f
Cred_4724 vin.$43.GatPoly vout.P2.nSD 1.52996e-05f
Cred_4725 vin.$43.GatPoly vout.P2.pSD 0.000165045f
Cred_4726 vin.$43.GatPoly vout.P4.pSD 0.0152604f
Cred_4727 vin.$430.Metal1 vout.$1424.Metal3 0.0194272f
Cred_4728 vin.$430.Metal1 vout.P16.nSD 0.015411f
Cred_4729 vin.$430.Metal1 VSS.$1271.Metal3 7.35435e-08f
Cred_4730 vin.$430.Metal1 VSS.$18.Metal1 8.95545e-06f
Cred_4731 vin.$430.Metal1 VSS.$40.Metal1 3.472e-06f
Cred_4732 vin.$430.Metal1 VSS.$409.Metal1 6.60482e-07f
Cred_4733 vin.$430.Metal1 VSS.$426.Metal1 7.35435e-08f
Cred_4734 vin.$430.Metal1 VSS.$551.Metal1 0.00153691f
Cred_4735 vin.$430.Metal1 VSS.$952.Metal2 2.33344e-06f
Cred_4736 vin.$430.Metal1 VSS.$961.Metal2 1.44928e-05f
Cred_4737 vin.$430.Metal1 VSS.$975.Metal2 3.39178e-05f
Cred_4738 vin.$430.Metal1 VSS.P0.pSD 0.0176639f
Cred_4739 vin.$430.Metal1 VSS.P17.nSD 2.29316e-08f
Cred_4740 vin.$433.Metal1 vout.$1424.Metal3 0.0266176f
Cred_4741 vin.$433.Metal1 vout.P16.pSD 0.0222725f
Cred_4742 vin.$437.Metal1 vout 8.44572e-05f
Cred_4743 vin.$437.Metal1 vout.$1424.Metal3 0.0163088f
Cred_4744 vin.$437.Metal1 vout.P16.nSD 0.0129229f
Cred_4745 vin.$437.Metal1 vout.P18.nSD 1.33937e-06f
Cred_4746 vin.$437.Metal1 VSS.$1002.Metal2 5.86146e-05f
Cred_4747 vin.$437.Metal1 VSS.$1010.Metal2 4.36492e-05f
Cred_4748 vin.$437.Metal1 VSS.$18.Metal1 7.8408e-06f
Cred_4749 vin.$437.Metal1 VSS.$40.Metal1 3.03986e-06f
Cred_4750 vin.$437.Metal1 VSS.$436.Metal1 0.000529433f
Cred_4751 vin.$437.Metal1 VSS.$448.Metal1 0.000598552f
Cred_4752 vin.$437.Metal1 VSS.$453.Metal1 0.000239742f
Cred_4753 vin.$437.Metal1 VSS.$551.Metal1 0.00171414f
Cred_4754 vin.$437.Metal1 VSS.$987.Metal2 4.42291e-06f
Cred_4755 vin.$437.Metal1 VSS.P0.pSD 0.01728f
Cred_4756 vin.$437.Metal1 VSS.P19.nSD 8.97176e-06f
Cred_4757 vin.$44.GatPoly vout.$1226.Metal3 0.00814711f
Cred_4758 vin.$44.GatPoly vout.$1292.Metal3 0.000689313f
Cred_4759 vin.$44.GatPoly vout.P4.nSD 0.0033717f
Cred_4760 vin.$44.GatPoly vout.P6.nSD 2.4445e-05f
Cred_4761 vin.$44.GatPoly vout.P6.pSD 5.93495e-05f
Cred_4762 vin.$44.GatPoly VSS.$167.Metal1 3.44676e-09f
Cred_4763 vin.$44.GatPoly VSS.$18.Metal1 6.76945e-05f
Cred_4764 vin.$44.GatPoly VSS.$184.Metal1 9.19509e-08f
Cred_4765 vin.$44.GatPoly VSS.$195.Metal1 0.0053483f
Cred_4766 vin.$44.GatPoly VSS.$40.Metal1 2.6245e-05f
Cred_4767 vin.$44.GatPoly VSS.$551.Metal1 4.23565e-06f
Cred_4768 vin.$44.GatPoly VSS.$711.Metal2 2.87971e-11f
Cred_4769 vin.$44.GatPoly VSS.$717.Metal2 5.78817e-11f
Cred_4770 vin.$44.GatPoly VSS.$732.Metal2 0.00144469f
Cred_4771 vin.$44.GatPoly VSS.$740.Metal2 5.48618e-05f
Cred_4772 vin.$44.GatPoly VSS.P0.pSD 0.00266727f
Cred_4773 vin.$44.GatPoly VSS.P7.nSD 4.45362e-05f
Cred_4774 vin.$440.Metal1 vout 0.00018899f
Cred_4775 vin.$440.Metal1 vout.$1424.Metal3 0.000964176f
Cred_4776 vin.$440.Metal1 vout.P16.nSD 0.000376308f
Cred_4777 vin.$440.Metal1 vout.P18.nSD 2.99712e-06f
Cred_4778 vin.$440.Metal1 VSS.$1002.Metal2 0.000518159f
Cred_4779 vin.$440.Metal1 VSS.$1010.Metal2 0.000371147f
Cred_4780 vin.$440.Metal1 VSS.$1283.Metal3 1.58436e-07f
Cred_4781 vin.$440.Metal1 VSS.$18.Metal1 6.73276e-06f
Cred_4782 vin.$440.Metal1 VSS.$40.Metal1 2.61027e-06f
Cred_4783 vin.$440.Metal1 VSS.$436.Metal1 0.000145714f
Cred_4784 vin.$440.Metal1 VSS.$448.Metal1 0.00212675f
Cred_4785 vin.$440.Metal1 VSS.$453.Metal1 0.00768135f
Cred_4786 vin.$440.Metal1 VSS.$551.Metal1 0.00196061f
Cred_4787 vin.$440.Metal1 VSS.$987.Metal2 2.09779e-05f
Cred_4788 vin.$440.Metal1 VSS.P0.pSD 0.0168855f
Cred_4789 vin.$440.Metal1 VSS.P19.nSD 0.000293242f
Cred_4790 vin.$441.Metal1 vout.$1424.Metal3 0.00561461f
Cred_4791 vin.$441.Metal1 vout.P16.pSD 0.00387364f
Cred_4792 vin.$448.Metal1 vout 5.39419e-06f
Cred_4793 vin.$448.Metal1 vout.$1424.Metal3 9.75371e-06f
Cred_4794 vin.$448.Metal1 vout.P18.nSD 2.49121e-08f
Cred_4795 vin.$448.Metal1 VSS.$1002.Metal2 0.00207838f
Cred_4796 vin.$448.Metal1 VSS.$1010.Metal2 0.00154814f
Cred_4797 vin.$448.Metal1 VSS.$1022.Metal2 1.53248e-06f
Cred_4798 vin.$448.Metal1 VSS.$1283.Metal3 2.23536e-08f
Cred_4799 vin.$448.Metal1 VSS.$1292.Metal3 1.22871e-08f
Cred_4800 vin.$448.Metal1 VSS.$18.Metal1 7.62758e-06f
Cred_4801 vin.$448.Metal1 VSS.$40.Metal1 2.95719e-06f
Cred_4802 vin.$448.Metal1 VSS.$436.Metal1 7.83657e-06f
Cred_4803 vin.$448.Metal1 VSS.$448.Metal1 0.00013565f
Cred_4804 vin.$448.Metal1 VSS.$453.Metal1 0.0419833f
Cred_4805 vin.$448.Metal1 VSS.$471.Metal1 0.000306238f
Cred_4806 vin.$448.Metal1 VSS.$551.Metal1 0.00297087f
Cred_4807 vin.$448.Metal1 VSS.$987.Metal2 2.85347e-06f
Cred_4808 vin.$448.Metal1 VSS.P0.pSD 0.0217348f
Cred_4809 vin.$448.Metal1 VSS.P19.nSD 0.00156422f
Cred_4810 vin.$449.Metal1 vout.$1424.Metal3 9.75371e-06f
Cred_4811 vin.$453.Metal1 vout 1.09997e-05f
Cred_4812 vin.$456.Metal1 vout 0.0360273f
Cred_4813 vin.$456.Metal1 vout.$1424.Metal3 0.000148245f
Cred_4814 vin.$456.Metal1 vout.P16.nSD 1.39007e-06f
Cred_4815 vin.$456.Metal1 vout.P18.nSD 0.0268524f
Cred_4816 vin.$456.Metal1 VSS.$1002.Metal2 0.000340553f
Cred_4817 vin.$456.Metal1 VSS.$1010.Metal2 0.00027649f
Cred_4818 vin.$456.Metal1 VSS.$1022.Metal2 2.30851e-05f
Cred_4819 vin.$456.Metal1 VSS.$1034.Metal2 5.68117e-05f
Cred_4820 vin.$456.Metal1 VSS.$1040.Metal2 5.27123e-06f
Cred_4821 vin.$456.Metal1 VSS.$1066.Metal2 2.05919e-05f
Cred_4822 vin.$456.Metal1 VSS.$1292.Metal3 1.75811e-07f
Cred_4823 vin.$456.Metal1 VSS.$18.Metal1 1.50387e-05f
Cred_4824 vin.$456.Metal1 VSS.$40.Metal1 5.83047e-06f
Cred_4825 vin.$456.Metal1 VSS.$453.Metal1 0.006826f
Cred_4826 vin.$456.Metal1 VSS.$471.Metal1 0.00151066f
Cred_4827 vin.$456.Metal1 VSS.$483.Metal1 0.000749035f
Cred_4828 vin.$456.Metal1 VSS.$498.Metal1 0.000630463f
Cred_4829 vin.$456.Metal1 VSS.$509.Metal1 0.000862432f
Cred_4830 vin.$456.Metal1 VSS.$551.Metal1 0.0115897f
Cred_4831 vin.$456.Metal1 VSS.P0.pSD 0.0561693f
Cred_4832 vin.$456.Metal1 VSS.P1.GatPoly 0.00160798f
Cred_4833 vin.$456.Metal1 VSS.P19.nSD 0.000253611f
Cred_4834 vin.$456.Metal1 VSS.P21.nSD 5.78261e-06f
Cred_4835 vin.$456.Metal1 VSS.P23.nSD 5.78261e-06f
Cred_4836 vin.$457.Metal1 vout 0.0750388f
Cred_4837 vin.$457.Metal1 vout.P18.pSD 0.0582307f
Cred_4838 vin.$457.Metal1 VSS.$1034.Metal2 8.40328e-06f
Cred_4839 vin.$457.Metal1 VSS.$1040.Metal2 0.000781797f
Cred_4840 vin.$457.Metal1 VSS.$1298.Metal3 0.00104808f
Cred_4841 vin.$457.Metal1 VSS.$1307.Metal3 0.00147146f
Cred_4842 vin.$47.GatPoly vout.$1226.Metal3 0.05686f
Cred_4843 vin.$47.GatPoly vout.$1292.Metal3 0.00278657f
Cred_4844 vin.$47.GatPoly vout.P4.pSD 0.0337983f
Cred_4845 vin.$47.GatPoly vout.P6.nSD 4.38997e-05f
Cred_4846 vin.$47.GatPoly vout.P6.pSD 0.000651467f
Cred_4847 vin.$476.Metal2 vout.$1226.Metal3 0.0953877f
Cred_4848 vin.$476.Metal2 vout.P0.nSD 0.0215725f
Cred_4849 vin.$476.Metal2 vout.P0.pSD 0.0150931f
Cred_4850 vin.$476.Metal2 vout.P2.nSD 0.00150274f
Cred_4851 vin.$476.Metal2 vout.P2.pSD 0.00821284f
Cred_4852 vin.$476.Metal2 VSS.$18.Metal1 0.00296519f
Cred_4853 vin.$476.Metal2 VSS.$40.Metal1 0.00125397f
Cred_4854 vin.$476.Metal2 VSS.$551.Metal1 6.23592e-06f
Cred_4855 vin.$476.Metal2 VSS.$564.Metal2 2.49213e-06f
Cred_4856 vin.$476.Metal2 VSS.$605.Metal2 6.73269e-07f
Cred_4857 vin.$476.Metal2 VSS.$611.Metal2 0.00325244f
Cred_4858 vin.$476.Metal2 VSS.$623.Metal2 0.00086971f
Cred_4859 vin.$476.Metal2 VSS.$65.Metal1 8.0526e-05f
Cred_4860 vin.$476.Metal2 VSS.$80.Metal1 7.79729e-05f
Cred_4861 vin.$476.Metal2 VSS.P0.GatPoly 0.000194605f
Cred_4862 vin.$476.Metal2 VSS.P0.nSD 6.99838e-07f
Cred_4863 vin.$476.Metal2 VSS.P0.pSD 0.0177693f
Cred_4864 vin.$476.Metal2 VSS.P1.nSD 6.99838e-07f
Cred_4865 vin.$478.Metal2 vout.$1226.Metal3 0.0875633f
Cred_4866 vin.$478.Metal2 vout.P0.nSD 0.00260736f
Cred_4867 vin.$478.Metal2 vout.P0.pSD 0.0392364f
Cred_4868 vin.$478.Metal2 vout.P2.nSD 0.00137948f
Cred_4869 vin.$478.Metal2 vout.P2.pSD 0.00753916f
Cred_4870 vin.$478.Metal2 VSS.$1106.Metal3 9.32363e-05f
Cred_4871 vin.$478.Metal2 VSS.$1115.Metal3 6.64095e-05f
Cred_4872 vin.$478.Metal2 VSS.$18.Metal1 6.05931e-05f
Cred_4873 vin.$478.Metal2 VSS.$40.Metal1 2.34917e-05f
Cred_4874 vin.$478.Metal2 VSS.$551.Metal1 8.41816e-08f
Cred_4875 vin.$478.Metal2 VSS.$605.Metal2 4.9537e-05f
Cred_4876 vin.$478.Metal2 VSS.$611.Metal2 5.32457e-07f
Cred_4877 vin.$478.Metal2 VSS.P0.pSD 0.000282108f
Cred_4878 vin.$481.Metal2 vout.$1226.Metal3 0.018203f
Cred_4879 vin.$481.Metal2 vout.P0.nSD 0.00338311f
Cred_4880 vin.$481.Metal2 vout.P0.pSD 0.00288025f
Cred_4881 vin.$481.Metal2 vout.P2.nSD 0.000286772f
Cred_4882 vin.$481.Metal2 vout.P2.pSD 0.00156727f
Cred_4883 vin.$481.Metal2 VSS.$1121.Metal3 1.9043e-05f
Cred_4884 vin.$481.Metal2 VSS.$18.Metal1 0.00043109f
Cred_4885 vin.$481.Metal2 VSS.$40.Metal1 0.000175179f
Cred_4886 vin.$481.Metal2 VSS.$551.Metal1 1.57574e-06f
Cred_4887 vin.$481.Metal2 VSS.$564.Metal2 1.92134e-07f
Cred_4888 vin.$481.Metal2 VSS.$605.Metal2 4.91856e-08f
Cred_4889 vin.$481.Metal2 VSS.$611.Metal2 7.30304e-07f
Cred_4890 vin.$481.Metal2 VSS.$623.Metal2 0.00306413f
Cred_4891 vin.$481.Metal2 VSS.$636.Metal2 0.00237573f
Cred_4892 vin.$481.Metal2 VSS.$644.Metal2 8.54128e-07f
Cred_4893 vin.$481.Metal2 VSS.$65.Metal1 5.88282e-06f
Cred_4894 vin.$481.Metal2 VSS.$80.Metal1 5.6963e-06f
Cred_4895 vin.$481.Metal2 VSS.$92.Metal1 1.98467e-05f
Cred_4896 vin.$481.Metal2 VSS.$97.Metal1 1.71422e-05f
Cred_4897 vin.$481.Metal2 VSS.P0.GatPoly 1.50033e-05f
Cred_4898 vin.$481.Metal2 VSS.P0.nSD 5.39549e-08f
Cred_4899 vin.$481.Metal2 VSS.P0.pSD 0.00367826f
Cred_4900 vin.$481.Metal2 VSS.P1.nSD 5.39549e-08f
Cred_4901 vin.$481.Metal2 VSS.P3.nSD 6.3664e-07f
Cred_4902 vin.$482.Metal2 vout.$1226.Metal3 0.0240431f
Cred_4903 vin.$482.Metal2 vout.P0.nSD 0.000673155f
Cred_4904 vin.$482.Metal2 vout.P0.pSD 0.00720868f
Cred_4905 vin.$482.Metal2 vout.P2.nSD 0.000378776f
Cred_4906 vin.$482.Metal2 vout.P2.pSD 0.00219478f
Cred_4907 vin.$483.Metal2 vout.$1226.Metal3 0.0164961f
Cred_4908 vin.$483.Metal2 vout.P0.nSD 0.000442502f
Cred_4909 vin.$483.Metal2 vout.P0.pSD 0.00206587f
Cred_4910 vin.$483.Metal2 vout.P2.nSD 0.000313664f
Cred_4911 vin.$483.Metal2 vout.P2.pSD 0.00142031f
Cred_4912 vin.$483.Metal2 VSS.$18.Metal1 0.00032803f
Cred_4913 vin.$483.Metal2 VSS.$40.Metal1 0.000127176f
Cred_4914 vin.$483.Metal2 VSS.$551.Metal1 1.82136e-06f
Cred_4915 vin.$483.Metal2 VSS.$636.Metal2 0.0142381f
Cred_4916 vin.$483.Metal2 VSS.$644.Metal2 0.0191198f
Cred_4917 vin.$483.Metal2 VSS.$92.Metal1 4.0101e-06f
Cred_4918 vin.$483.Metal2 VSS.$97.Metal1 0.00303034f
Cred_4919 vin.$483.Metal2 VSS.P0.pSD 0.00352677f
Cred_4920 vin.$483.Metal2 VSS.P3.nSD 0.000105642f
Cred_4921 vin.$486.Metal2 vout.$1226.Metal3 0.100793f
Cred_4922 vin.$486.Metal2 vout.P0.nSD 0.00248323f
Cred_4923 vin.$486.Metal2 vout.P0.pSD 0.0132292f
Cred_4924 vin.$486.Metal2 vout.P2.nSD 0.0016088f
Cred_4925 vin.$486.Metal2 vout.P2.pSD 0.0088121f
Cred_4926 vin.$486.Metal2 VSS.$18.Metal1 0.00422416f
Cred_4927 vin.$486.Metal2 VSS.$40.Metal1 0.00163769f
Cred_4928 vin.$486.Metal2 VSS.$551.Metal1 2.43767e-05f
Cred_4929 vin.$486.Metal2 VSS.$636.Metal2 0.00221267f
Cred_4930 vin.$486.Metal2 VSS.$644.Metal2 0.0029713f
Cred_4931 vin.$486.Metal2 VSS.$97.Metal1 0.000448976f
Cred_4932 vin.$486.Metal2 VSS.P0.pSD 0.0465825f
Cred_4933 vin.$486.Metal2 VSS.P3.nSD 1.55876e-05f
Cred_4934 vin.$488.Metal2 vout.$1226.Metal3 0.0241692f
Cred_4935 vin.$488.Metal2 vout.P0.nSD 0.000579645f
Cred_4936 vin.$488.Metal2 vout.P0.pSD 0.00269673f
Cred_4937 vin.$488.Metal2 vout.P2.nSD 0.000452987f
Cred_4938 vin.$488.Metal2 vout.P2.pSD 0.00208096f
Cred_4939 vin.$488.Metal2 VSS.$1130.Metal3 9.53831e-06f
Cred_4940 vin.$488.Metal2 VSS.$115.Metal1 1.33539e-05f
Cred_4941 vin.$488.Metal2 VSS.$127.Metal1 2.20468e-07f
Cred_4942 vin.$488.Metal2 VSS.$18.Metal1 0.000668607f
Cred_4943 vin.$488.Metal2 VSS.$40.Metal1 0.000259217f
Cred_4944 vin.$488.Metal2 VSS.$551.Metal1 4.15899e-06f
Cred_4945 vin.$488.Metal2 VSS.$636.Metal2 0.0174818f
Cred_4946 vin.$488.Metal2 VSS.$644.Metal2 0.0246652f
Cred_4947 vin.$488.Metal2 VSS.$658.Metal2 0.00118965f
Cred_4948 vin.$488.Metal2 VSS.$97.Metal1 0.00370329f
Cred_4949 vin.$488.Metal2 VSS.P0.pSD 0.00766414f
Cred_4950 vin.$488.Metal2 VSS.P3.nSD 0.000129173f
Cred_4951 vin.$489.Metal2 vout.$1226.Metal3 0.0291954f
Cred_4952 vin.$489.Metal2 vout.P0.nSD 0.000635967f
Cred_4953 vin.$489.Metal2 vout.P0.pSD 0.00387936f
Cred_4954 vin.$489.Metal2 vout.P2.nSD 0.000459945f
Cred_4955 vin.$489.Metal2 vout.P2.pSD 0.00297641f
Cred_4956 vin.$492.Metal2 vout.$1226.Metal3 0.0303152f
Cred_4957 vin.$492.Metal2 vout.P0.nSD 0.000439011f
Cred_4958 vin.$492.Metal2 vout.P0.pSD 0.00233283f
Cred_4959 vin.$492.Metal2 vout.P2.nSD 0.00472695f
Cred_4960 vin.$492.Metal2 vout.P2.pSD 0.00261012f
Cred_4961 vin.$492.Metal2 VSS.$1130.Metal3 9.53807e-06f
Cred_4962 vin.$492.Metal2 VSS.$115.Metal1 1.24159e-05f
Cred_4963 vin.$492.Metal2 VSS.$127.Metal1 5.98294e-07f
Cred_4964 vin.$492.Metal2 VSS.$18.Metal1 0.000305807f
Cred_4965 vin.$492.Metal2 VSS.$40.Metal1 0.00011856f
Cred_4966 vin.$492.Metal2 VSS.$551.Metal1 2.70668e-06f
Cred_4967 vin.$492.Metal2 VSS.$636.Metal2 6.70053e-07f
Cred_4968 vin.$492.Metal2 VSS.$644.Metal2 0.00119052f
Cred_4969 vin.$492.Metal2 VSS.$658.Metal2 0.00353881f
Cred_4970 vin.$492.Metal2 VSS.$97.Metal1 1.75061e-05f
Cred_4971 vin.$492.Metal2 VSS.P0.pSD 0.00428035f
Cred_4972 vin.$492.Metal2 VSS.P3.nSD 6.69298e-07f
Cred_4973 vin.$493.Metal2 vout.$1226.Metal3 0.0495575f
Cred_4974 vin.$493.Metal2 vout.P0.nSD 0.00071767f
Cred_4975 vin.$493.Metal2 vout.P0.pSD 0.00381358f
Cred_4976 vin.$493.Metal2 vout.P2.nSD 0.000780732f
Cred_4977 vin.$493.Metal2 vout.P2.pSD 0.014777f
Cred_4978 vin.$495.Metal2 vout.$1226.Metal3 0.130126f
Cred_4979 vin.$495.Metal2 vout.P0.nSD 0.00188443f
Cred_4980 vin.$495.Metal2 vout.P0.pSD 0.0100136f
Cred_4981 vin.$495.Metal2 vout.P2.nSD 0.00319518f
Cred_4982 vin.$495.Metal2 vout.P2.pSD 0.015747f
Cred_4983 vin.$495.Metal2 VSS.$18.Metal1 0.00302092f
Cred_4984 vin.$495.Metal2 VSS.$40.Metal1 0.0011712f
Cred_4985 vin.$495.Metal2 VSS.$551.Metal1 3.49847e-05f
Cred_4986 vin.$495.Metal2 VSS.P0.pSD 0.0487888f
Cred_4987 vin.$497.Metal2 vout.$1226.Metal3 0.0769369f
Cred_4988 vin.$497.Metal2 vout.P0.nSD 0.00111417f
Cred_4989 vin.$497.Metal2 vout.P0.pSD 0.0059205f
Cred_4990 vin.$497.Metal2 vout.P2.nSD 0.0141958f
Cred_4991 vin.$497.Metal2 vout.P2.pSD 0.00662423f
Cred_4992 vin.$497.Metal2 VSS.$1142.Metal3 6.12031e-06f
Cred_4993 vin.$497.Metal2 VSS.$137.Metal1 6.12031e-06f
Cred_4994 vin.$497.Metal2 VSS.$142.Metal1 5.49654e-05f
Cred_4995 vin.$497.Metal2 VSS.$18.Metal1 0.000700462f
Cred_4996 vin.$497.Metal2 VSS.$40.Metal1 0.000271567f
Cred_4997 vin.$497.Metal2 VSS.$551.Metal1 8.4506e-06f
Cred_4998 vin.$497.Metal2 VSS.$670.Metal2 0.00282265f
Cred_4999 vin.$497.Metal2 VSS.$685.Metal2 0.00120609f
Cred_5000 vin.$497.Metal2 VSS.$693.Metal2 0.00019419f
Cred_5001 vin.$497.Metal2 VSS.P0.pSD 0.0115068f
Cred_5002 vin.$497.Metal2 VSS.P5.nSD 1.90837e-06f
Cred_5003 vin.$500.Metal2 vout.$1226.Metal3 0.0453728f
Cred_5004 vin.$500.Metal2 vout.P0.nSD 0.000657069f
Cred_5005 vin.$500.Metal2 vout.P0.pSD 0.00349156f
Cred_5006 vin.$500.Metal2 vout.P2.nSD 0.000714806f
Cred_5007 vin.$500.Metal2 vout.P2.pSD 0.0129722f
Cred_5008 vin.$503.Metal2 vout.$1226.Metal3 0.0387021f
Cred_5009 vin.$503.Metal2 vout.P0.nSD 0.00036249f
Cred_5010 vin.$503.Metal2 vout.P0.pSD 0.00192621f
Cred_5011 vin.$503.Metal2 vout.P2.nSD 0.00144319f
Cred_5012 vin.$503.Metal2 vout.P2.pSD 0.00215517f
Cred_5013 vin.$503.Metal2 vout.P4.nSD 6.94739e-05f
Cred_5014 vin.$503.Metal2 VSS.$1142.Metal3 1.23569e-05f
Cred_5015 vin.$503.Metal2 VSS.$137.Metal1 1.23569e-05f
Cred_5016 vin.$503.Metal2 VSS.$142.Metal1 0.00393458f
Cred_5017 vin.$503.Metal2 VSS.$18.Metal1 0.000420316f
Cred_5018 vin.$503.Metal2 VSS.$40.Metal1 0.000162955f
Cred_5019 vin.$503.Metal2 VSS.$551.Metal1 8.4319e-06f
Cred_5020 vin.$503.Metal2 VSS.$670.Metal2 0.00256115f
Cred_5021 vin.$503.Metal2 VSS.$685.Metal2 0.0328856f
Cred_5022 vin.$503.Metal2 VSS.$693.Metal2 0.0137476f
Cred_5023 vin.$503.Metal2 VSS.P0.pSD 0.0090772f
Cred_5024 vin.$503.Metal2 VSS.P5.nSD 0.000136794f
Cred_5025 vin.$504.Metal2 vout.$1226.Metal3 0.0299793f
Cred_5026 vin.$504.Metal2 vout.P0.nSD 0.00024078f
Cred_5027 vin.$504.Metal2 vout.P0.pSD 0.00127947f
Cred_5028 vin.$504.Metal2 vout.P2.nSD 0.000261938f
Cred_5029 vin.$504.Metal2 vout.P2.pSD 0.00181934f
Cred_5030 vin.$504.Metal2 vout.P4.pSD 0.000387787f
Cred_5031 vin.$506.Metal2 vout.$1226.Metal3 0.109705f
Cred_5032 vin.$506.Metal2 vout.P0.nSD 0.000720669f
Cred_5033 vin.$506.Metal2 vout.P0.pSD 0.00382952f
Cred_5034 vin.$506.Metal2 vout.P2.nSD 0.000792089f
Cred_5035 vin.$506.Metal2 vout.P2.pSD 0.00432936f
Cred_5036 vin.$506.Metal2 vout.P4.nSD 8.09507e-06f
Cred_5037 vin.$506.Metal2 vout.P4.pSD 4.46531e-05f
Cred_5038 vin.$506.Metal2 VSS.$142.Metal1 0.000410524f
Cred_5039 vin.$506.Metal2 VSS.$18.Metal1 0.00213055f
Cred_5040 vin.$506.Metal2 VSS.$40.Metal1 0.000826007f
Cred_5041 vin.$506.Metal2 VSS.$551.Metal1 4.93958e-05f
Cred_5042 vin.$506.Metal2 VSS.$685.Metal2 0.00330681f
Cred_5043 vin.$506.Metal2 VSS.$693.Metal2 0.00145036f
Cred_5044 vin.$506.Metal2 VSS.P0.pSD 0.0498246f
Cred_5045 vin.$506.Metal2 VSS.P5.nSD 1.42532e-05f
Cred_5046 vin.$508.Metal2 vout.$1226.Metal3 0.0171927f
Cred_5047 vin.$508.Metal2 vout.P0.nSD 5.41085e-05f
Cred_5048 vin.$508.Metal2 vout.P0.pSD 0.000287524f
Cred_5049 vin.$508.Metal2 vout.P2.nSD 7.60473e-05f
Cred_5050 vin.$508.Metal2 vout.P2.pSD 0.0003217f
Cred_5051 vin.$508.Metal2 vout.P4.nSD 1.71843e-05f
Cred_5052 vin.$508.Metal2 VSS.$142.Metal1 0.00250348f
Cred_5053 vin.$508.Metal2 VSS.$18.Metal1 0.000245697f
Cred_5054 vin.$508.Metal2 VSS.$40.Metal1 9.52561e-05f
Cred_5055 vin.$508.Metal2 VSS.$551.Metal1 6.51547e-06f
Cred_5056 vin.$508.Metal2 VSS.$685.Metal2 0.0187469f
Cred_5057 vin.$508.Metal2 VSS.$693.Metal2 0.00942665f
Cred_5058 vin.$508.Metal2 VSS.$699.Metal2 0.00249571f
Cred_5059 vin.$508.Metal2 VSS.P0.pSD 0.00615126f
Cred_5060 vin.$508.Metal2 VSS.P5.nSD 8.75729e-05f
Cred_5061 vin.$509.Metal2 vout.$1226.Metal3 0.0174091f
Cred_5062 vin.$509.Metal2 vout.P0.nSD 5.31665e-05f
Cred_5063 vin.$509.Metal2 vout.P0.pSD 0.000282518f
Cred_5064 vin.$509.Metal2 vout.P2.nSD 5.78383e-05f
Cred_5065 vin.$509.Metal2 vout.P2.pSD 0.000410889f
Cred_5066 vin.$509.Metal2 vout.P4.pSD 9.47899e-05f
Cred_5067 vin.$512.Metal2 vout.$1226.Metal3 0.0580995f
Cred_5068 vin.$512.Metal2 vout.P4.nSD 0.00708686f
Cred_5069 vin.$512.Metal2 VSS.$1154.Metal3 4.44744e-06f
Cred_5070 vin.$512.Metal2 VSS.$167.Metal1 4.44744e-06f
Cred_5071 vin.$512.Metal2 VSS.$18.Metal1 0.000168459f
Cred_5072 vin.$512.Metal2 VSS.$40.Metal1 6.53111e-05f
Cred_5073 vin.$512.Metal2 VSS.$551.Metal1 6.45281e-06f
Cred_5074 vin.$512.Metal2 VSS.$699.Metal2 0.00305041f
Cred_5075 vin.$512.Metal2 VSS.$711.Metal2 0.000554698f
Cred_5076 vin.$512.Metal2 VSS.P0.pSD 0.00511231f
Cred_5077 vin.$513.Metal2 vout.$1226.Metal3 0.0496893f
Cred_5078 vin.$513.Metal2 vout.P4.pSD 0.00878399f
Cred_5079 vin.$515.Metal2 vout.$1226.Metal3 0.174793f
Cred_5080 vin.$515.Metal2 vout.$1292.Metal3 0.00903794f
Cred_5081 vin.$515.Metal2 vout.P4.nSD 0.00122542f
Cred_5082 vin.$515.Metal2 vout.P4.pSD 0.00137652f
Cred_5083 vin.$515.Metal2 vout.P6.nSD 0.000142683f
Cred_5084 vin.$515.Metal2 vout.P6.pSD 0.000778162f
Cred_5085 vin.$515.Metal2 VSS.$18.Metal1 0.00195062f
Cred_5086 vin.$515.Metal2 VSS.$195.Metal1 0.000143935f
Cred_5087 vin.$515.Metal2 VSS.$40.Metal1 0.000756248f
Cred_5088 vin.$515.Metal2 VSS.$551.Metal1 0.000106845f
Cred_5089 vin.$515.Metal2 VSS.$732.Metal2 0.00149036f
Cred_5090 vin.$515.Metal2 VSS.$740.Metal2 5.65961e-05f
Cred_5091 vin.$515.Metal2 VSS.P0.pSD 0.0706557f
Cred_5092 vin.$515.Metal2 VSS.P7.nSD 8.41734e-07f
Cred_5093 vin.$517.Metal2 vout.$1226.Metal3 0.0773344f
Cred_5094 vin.$517.Metal2 vout.P4.nSD 0.0112674f
Cred_5095 vin.$517.Metal2 VSS.$1163.Metal3 3.60466e-06f
Cred_5096 vin.$517.Metal2 VSS.$167.Metal1 7.33628e-07f
Cred_5097 vin.$517.Metal2 VSS.$18.Metal1 0.000277925f
Cred_5098 vin.$517.Metal2 VSS.$184.Metal1 5.22427e-06f
Cred_5099 vin.$517.Metal2 VSS.$195.Metal1 0.000409021f
Cred_5100 vin.$517.Metal2 VSS.$40.Metal1 0.000107751f
Cred_5101 vin.$517.Metal2 VSS.$551.Metal1 1.40666e-05f
Cred_5102 vin.$517.Metal2 VSS.$711.Metal2 6.12933e-09f
Cred_5103 vin.$517.Metal2 VSS.$717.Metal2 0.00339829f
Cred_5104 vin.$517.Metal2 VSS.$732.Metal2 0.00468475f
Cred_5105 vin.$517.Metal2 VSS.$740.Metal2 0.000160829f
Cred_5106 vin.$517.Metal2 VSS.P0.pSD 0.00973453f
Cred_5107 vin.$517.Metal2 VSS.P7.nSD 2.39196e-06f
Cred_5108 vin.$518.Metal2 vout.$1226.Metal3 0.0607039f
Cred_5109 vin.$518.Metal2 vout.P4.pSD 0.0130944f
Cred_5110 vin.$52.GatPoly VSS.$167.Metal1 2.63576e-09f
Cred_5111 vin.$52.GatPoly VSS.$18.Metal1 6.41339e-05f
Cred_5112 vin.$52.GatPoly VSS.$184.Metal1 7.03154e-08f
Cred_5113 vin.$52.GatPoly VSS.$192.Metal1 0.00548286f
Cred_5114 vin.$52.GatPoly VSS.$195.Metal1 0.00687275f
Cred_5115 vin.$52.GatPoly VSS.$207.Metal1 0.000101628f
Cred_5116 vin.$52.GatPoly VSS.$40.Metal1 2.48645e-05f
Cred_5117 vin.$52.GatPoly VSS.$551.Metal1 5.60973e-06f
Cred_5118 vin.$52.GatPoly VSS.$711.Metal2 2.20213e-11f
Cred_5119 vin.$52.GatPoly VSS.$717.Metal2 4.42625e-11f
Cred_5120 vin.$52.GatPoly VSS.$732.Metal2 0.000147958f
Cred_5121 vin.$52.GatPoly VSS.$740.Metal2 6.46772e-06f
Cred_5122 vin.$52.GatPoly VSS.P0.pSD 0.00300365f
Cred_5123 vin.$52.GatPoly VSS.P7.nSD 6.41932e-05f
Cred_5124 vin.$520.Metal2 vout.$1226.Metal3 0.0191896f
Cred_5125 vin.$520.Metal2 vout.$1292.Metal3 4.91937e-05f
Cred_5126 vin.$520.Metal2 vout.P4.pSD 0.000892535f
Cred_5127 vin.$520.Metal2 vout.P6.nSD 7.75001e-07f
Cred_5128 vin.$520.Metal2 vout.P6.pSD 9.98113e-06f
Cred_5129 vin.$523.Metal2 vout.$1226.Metal3 0.0510252f
Cred_5130 vin.$523.Metal2 vout.$1292.Metal3 0.0134562f
Cred_5131 vin.$523.Metal2 vout.P4.nSD 0.000190756f
Cred_5132 vin.$523.Metal2 vout.P6.nSD 0.000304649f
Cred_5133 vin.$523.Metal2 vout.P6.pSD 0.00115857f
Cred_5134 vin.$523.Metal2 VSS.$1163.Metal3 7.27792e-06f
Cred_5135 vin.$523.Metal2 VSS.$167.Metal1 3.63346e-07f
Cred_5136 vin.$523.Metal2 VSS.$18.Metal1 0.000459594f
Cred_5137 vin.$523.Metal2 VSS.$184.Metal1 8.08006e-06f
Cred_5138 vin.$523.Metal2 VSS.$195.Metal1 0.00526f
Cred_5139 vin.$523.Metal2 VSS.$40.Metal1 0.000178183f
Cred_5140 vin.$523.Metal2 VSS.$551.Metal1 3.99804e-05f
Cred_5141 vin.$523.Metal2 VSS.$711.Metal2 3.03569e-09f
Cred_5142 vin.$523.Metal2 VSS.$717.Metal2 0.00236814f
Cred_5143 vin.$523.Metal2 VSS.$732.Metal2 0.0526877f
Cred_5144 vin.$523.Metal2 VSS.$740.Metal2 0.00196633f
Cred_5145 vin.$523.Metal2 VSS.P0.pSD 0.0213215f
Cred_5146 vin.$523.Metal2 VSS.P7.nSD 3.17793e-05f
Cred_5147 vin.$527.Metal2 vout.$1226.Metal3 0.0502821f
Cred_5148 vin.$527.Metal2 vout.$1292.Metal3 0.0180083f
Cred_5149 vin.$527.Metal2 vout.P4.nSD 1.43057e-07f
Cred_5150 vin.$527.Metal2 vout.P4.pSD 0.000521155f
Cred_5151 vin.$527.Metal2 vout.P6.nSD 0.000283847f
Cred_5152 vin.$527.Metal2 vout.P6.pSD 0.00230869f
Cred_5153 vin.$527.Metal2 VSS.$18.Metal1 0.000170568f
Cred_5154 vin.$527.Metal2 VSS.$195.Metal1 6.89462e-05f
Cred_5155 vin.$527.Metal2 VSS.$40.Metal1 6.61287e-05f
Cred_5156 vin.$527.Metal2 VSS.$551.Metal1 1.58849e-05f
Cred_5157 vin.$527.Metal2 VSS.$732.Metal2 0.000713896f
Cred_5158 vin.$527.Metal2 VSS.$740.Metal2 2.711e-05f
Cred_5159 vin.$527.Metal2 VSS.P0.pSD 0.00821501f
Cred_5160 vin.$527.Metal2 VSS.P7.nSD 4.03198e-07f
Cred_5161 vin.$528.Metal2 vout.$1226.Metal3 0.00731763f
Cred_5162 vin.$528.Metal2 vout.$1292.Metal3 0.00647235f
Cred_5163 vin.$528.Metal2 vout.P4.nSD 1.35309e-06f
Cred_5164 vin.$528.Metal2 vout.P6.nSD 0.000127075f
Cred_5165 vin.$528.Metal2 vout.P6.pSD 0.000557266f
Cred_5166 vin.$528.Metal2 VSS.$1172.Metal3 9.08056e-06f
Cred_5167 vin.$528.Metal2 VSS.$18.Metal1 8.19153e-05f
Cred_5168 vin.$528.Metal2 VSS.$192.Metal1 2.61458e-06f
Cred_5169 vin.$528.Metal2 VSS.$195.Metal1 0.0015806f
Cred_5170 vin.$528.Metal2 VSS.$207.Metal1 1.90177e-05f
Cred_5171 vin.$528.Metal2 VSS.$219.Metal1 4.71576e-07f
Cred_5172 vin.$528.Metal2 VSS.$40.Metal1 3.17583e-05f
Cred_5173 vin.$528.Metal2 VSS.$551.Metal1 1.00524e-05f
Cred_5174 vin.$528.Metal2 VSS.$732.Metal2 0.016193f
Cred_5175 vin.$528.Metal2 VSS.$740.Metal2 0.00415717f
Cred_5176 vin.$528.Metal2 VSS.$752.Metal2 0.00113256f
Cred_5177 vin.$528.Metal2 VSS.P0.pSD 0.00455013f
Cred_5178 vin.$528.Metal2 VSS.P7.nSD 9.28578e-06f
Cred_5179 vin.$53.GatPoly vout.$1226.Metal3 3.63287e-08f
Cred_5180 vin.$53.GatPoly vout.$1292.Metal3 8.57734e-09f
Cred_5181 vin.$53.GatPoly vout.P4.pSD 1.00179e-09f
Cred_5182 vin.$53.GatPoly vout.P6.nSD 1.35128e-10f
Cred_5183 vin.$53.GatPoly vout.P6.pSD 1.7403e-09f
Cred_5184 vin.$532.Metal2 vout.$1226.Metal3 0.0341047f
Cred_5185 vin.$532.Metal2 vout.$1292.Metal3 0.0341047f
Cred_5186 vin.$532.Metal2 vout.P6.nSD 0.0110654f
Cred_5187 vin.$532.Metal2 vout.P6.pSD 0.0029364f
Cred_5188 vin.$532.Metal2 VSS.$1172.Metal3 9.08029e-06f
Cred_5189 vin.$532.Metal2 VSS.$18.Metal1 0.000117793f
Cred_5190 vin.$532.Metal2 VSS.$192.Metal1 7.82459e-07f
Cred_5191 vin.$532.Metal2 VSS.$195.Metal1 1.72537e-06f
Cred_5192 vin.$532.Metal2 VSS.$207.Metal1 1.35199e-05f
Cred_5193 vin.$532.Metal2 VSS.$219.Metal1 3.09872e-07f
Cred_5194 vin.$532.Metal2 VSS.$40.Metal1 4.56679e-05f
Cred_5195 vin.$532.Metal2 VSS.$551.Metal1 1.93215e-05f
Cred_5196 vin.$532.Metal2 VSS.$732.Metal2 3.72161e-08f
Cred_5197 vin.$532.Metal2 VSS.$740.Metal2 0.00113253f
Cred_5198 vin.$532.Metal2 VSS.$752.Metal2 0.00113252f
Cred_5199 vin.$532.Metal2 VSS.P0.pSD 0.00754899f
Cred_5200 vin.$532.Metal2 VSS.P7.nSD 1.44361e-08f
Cred_5201 vin.$533.Metal2 vout.$1226.Metal3 0.0331409f
Cred_5202 vin.$533.Metal2 vout.$1292.Metal3 0.0331409f
Cred_5203 vin.$533.Metal2 vout.P6.nSD 0.000522104f
Cred_5204 vin.$533.Metal2 vout.P6.pSD 0.0155504f
Cred_5205 vin.$535.Metal2 vout.$1226.Metal3 0.0985516f
Cred_5206 vin.$535.Metal2 vout.$1292.Metal3 0.0796002f
Cred_5207 vin.$535.Metal2 vout.P4.nSD 2.98653e-07f
Cred_5208 vin.$535.Metal2 vout.P6.nSD 0.0025442f
Cred_5209 vin.$535.Metal2 vout.P6.pSD 0.00832419f
Cred_5210 vin.$535.Metal2 VSS.$18.Metal1 0.00114121f
Cred_5211 vin.$535.Metal2 VSS.$195.Metal1 0.000143935f
Cred_5212 vin.$535.Metal2 VSS.$40.Metal1 0.000442445f
Cred_5213 vin.$535.Metal2 VSS.$551.Metal1 0.000179339f
Cred_5214 vin.$535.Metal2 VSS.$732.Metal2 0.00149036f
Cred_5215 vin.$535.Metal2 VSS.$740.Metal2 5.65961e-05f
Cred_5216 vin.$535.Metal2 VSS.P0.pSD 0.0710028f
Cred_5217 vin.$535.Metal2 VSS.P7.nSD 8.41734e-07f
Cred_5218 vin.$537.Metal2 vout.$1226.Metal3 0.0274843f
Cred_5219 vin.$537.Metal2 vout.$1292.Metal3 0.0274843f
Cred_5220 vin.$537.Metal2 vout.P6.nSD 0.00821533f
Cred_5221 vin.$537.Metal2 vout.P6.pSD 0.00236638f
Cred_5222 vin.$537.Metal2 VSS.$18.Metal1 8.51079e-05f
Cred_5223 vin.$537.Metal2 VSS.$219.Metal1 7.70326e-07f
Cred_5224 vin.$537.Metal2 VSS.$232.Metal1 7.44747e-06f
Cred_5225 vin.$537.Metal2 VSS.$40.Metal1 3.29961e-05f
Cred_5226 vin.$537.Metal2 VSS.$551.Metal1 1.76475e-05f
Cred_5227 vin.$537.Metal2 VSS.$764.Metal2 0.00239142f
Cred_5228 vin.$537.Metal2 VSS.$770.Metal2 1.41269e-07f
Cred_5229 vin.$537.Metal2 VSS.$779.Metal2 4.48317e-07f
Cred_5230 vin.$537.Metal2 VSS.P0.pSD 0.00613455f
Cred_5231 vin.$537.Metal2 VSS.P10.nSD 2.46691e-07f
Cred_5232 vin.$538.Metal2 vout.$1226.Metal3 0.0255876f
Cred_5233 vin.$538.Metal2 vout.$1292.Metal3 0.0255876f
Cred_5234 vin.$538.Metal2 vout.P6.nSD 0.000403108f
Cred_5235 vin.$538.Metal2 vout.P6.pSD 0.0119442f
Cred_5236 vin.$541.Metal2 vout.$1226.Metal3 0.00916639f
Cred_5237 vin.$541.Metal2 vout.$1292.Metal3 0.0189675f
Cred_5238 vin.$541.Metal2 vout.P6.nSD 0.000193831f
Cred_5239 vin.$541.Metal2 vout.P6.pSD 0.000789222f
Cred_5240 vin.$541.Metal2 vout.P8.nSD 4.02867e-05f
Cred_5241 vin.$541.Metal2 VSS.$18.Metal1 8.36153e-05f
Cred_5242 vin.$541.Metal2 VSS.$219.Metal1 4.15136e-06f
Cred_5243 vin.$541.Metal2 VSS.$232.Metal1 0.0036981f
Cred_5244 vin.$541.Metal2 VSS.$40.Metal1 3.24174e-05f
Cred_5245 vin.$541.Metal2 VSS.$551.Metal1 2.74386e-05f
Cred_5246 vin.$541.Metal2 VSS.$764.Metal2 0.00239151f
Cred_5247 vin.$541.Metal2 VSS.$770.Metal2 0.0111327f
Cred_5248 vin.$541.Metal2 VSS.$779.Metal2 0.0320645f
Cred_5249 vin.$541.Metal2 VSS.P0.pSD 0.00758116f
Cred_5250 vin.$541.Metal2 VSS.P10.nSD 0.000128589f
Cred_5251 vin.$542.Metal2 vout.$1226.Metal3 0.00627618f
Cred_5252 vin.$542.Metal2 vout.$1292.Metal3 0.00943108f
Cred_5253 vin.$542.Metal2 vout.P6.nSD 9.88754e-05f
Cred_5254 vin.$542.Metal2 vout.P6.pSD 0.000719226f
Cred_5255 vin.$542.Metal2 vout.P8.pSD 6.00928e-05f
Cred_5256 vin.$544.Metal2 vout.$1226.Metal3 0.0296503f
Cred_5257 vin.$544.Metal2 vout.$1292.Metal3 0.0916487f
Cred_5258 vin.$544.Metal2 vout.P6.nSD 0.000488088f
Cred_5259 vin.$544.Metal2 vout.P6.pSD 0.00258416f
Cred_5260 vin.$544.Metal2 vout.P8.nSD 2.09757e-05f
Cred_5261 vin.$544.Metal2 vout.P8.pSD 3.1288e-05f
Cred_5262 vin.$544.Metal2 VSS.$18.Metal1 0.000548442f
Cred_5263 vin.$544.Metal2 VSS.$232.Metal1 0.00114188f
Cred_5264 vin.$544.Metal2 VSS.$40.Metal1 0.000212629f
Cred_5265 vin.$544.Metal2 VSS.$551.Metal1 0.000204253f
Cred_5266 vin.$544.Metal2 VSS.$770.Metal2 0.00304655f
Cred_5267 vin.$544.Metal2 VSS.$779.Metal2 0.0101017f
Cred_5268 vin.$544.Metal2 VSS.P0.pSD 0.0533779f
Cred_5269 vin.$544.Metal2 VSS.P10.nSD 3.96969e-05f
Cred_5270 vin.$547.Metal2 vout.$1226.Metal3 0.00721531f
Cred_5271 vin.$547.Metal2 vout.$1292.Metal3 0.0281306f
Cred_5272 vin.$547.Metal2 vout.P6.nSD 0.00011367f
Cred_5273 vin.$547.Metal2 vout.P6.pSD 0.00105708f
Cred_5274 vin.$547.Metal2 vout.P8.pSD 0.000435848f
Cred_5275 vin.$548.Metal2 vout.$1226.Metal3 0.00310844f
Cred_5276 vin.$548.Metal2 vout.$1292.Metal3 0.0294593f
Cred_5277 vin.$548.Metal2 vout.P6.nSD 8.18366e-05f
Cred_5278 vin.$548.Metal2 vout.P6.pSD 0.000267635f
Cred_5279 vin.$548.Metal2 vout.P8.nSD 0.00115887f
Cred_5280 vin.$548.Metal2 VSS.$1190.Metal3 1.43603e-05f
Cred_5281 vin.$548.Metal2 VSS.$18.Metal1 7.30058e-05f
Cred_5282 vin.$548.Metal2 VSS.$232.Metal1 0.0021025f
Cred_5283 vin.$548.Metal2 VSS.$247.Metal1 3.56627e-05f
Cred_5284 vin.$548.Metal2 VSS.$259.Metal1 4.46539e-07f
Cred_5285 vin.$548.Metal2 VSS.$40.Metal1 2.83041e-05f
Cred_5286 vin.$548.Metal2 VSS.$551.Metal1 3.23959e-05f
Cred_5287 vin.$548.Metal2 VSS.$770.Metal2 0.00559985f
Cred_5288 vin.$548.Metal2 VSS.$779.Metal2 0.020359f
Cred_5289 vin.$548.Metal2 VSS.$793.Metal2 0.0034856f
Cred_5290 vin.$548.Metal2 VSS.P0.pSD 0.0077337f
Cred_5291 vin.$548.Metal2 VSS.P10.nSD 7.31077e-05f
Cred_5292 vin.$551.Metal2 vout.$1292.Metal3 0.0527566f
Cred_5293 vin.$551.Metal2 vout.P8.pSD 0.00853468f
Cred_5294 vin.$552.Metal2 vout.$1292.Metal3 0.0807481f
Cred_5295 vin.$552.Metal2 vout.P8.nSD 0.0119341f
Cred_5296 vin.$552.Metal2 VSS.$18.Metal1 7.27629e-05f
Cred_5297 vin.$552.Metal2 VSS.$40.Metal1 2.82099e-05f
Cred_5298 vin.$552.Metal2 VSS.$551.Metal1 5.45333e-05f
Cred_5299 vin.$552.Metal2 VSS.$793.Metal2 0.00169455f
Cred_5300 vin.$552.Metal2 VSS.P0.pSD 0.0100258f
Cred_5301 vin.$555.Metal2 vout.$1292.Metal3 0.155889f
Cred_5302 vin.$555.Metal2 vout.P8.nSD 0.00114827f
Cred_5303 vin.$555.Metal2 vout.P8.pSD 0.00434025f
Cred_5304 vin.$555.Metal2 VSS.$18.Metal1 0.000386769f
Cred_5305 vin.$555.Metal2 VSS.$40.Metal1 0.000149949f
Cred_5306 vin.$555.Metal2 VSS.$551.Metal1 0.000288988f
Cred_5307 vin.$555.Metal2 VSS.P0.pSD 0.0534364f
Cred_5308 vin.$557.Metal2 vout.$1292.Metal3 0.0406837f
Cred_5309 vin.$557.Metal2 vout.P8.nSD 0.00506498f
Cred_5310 vin.$557.Metal2 VSS 5.35959e-06f
Cred_5311 vin.$557.Metal2 VSS.$1196.Metal3 4.01434e-06f
Cred_5312 vin.$557.Metal2 VSS.$18.Metal1 3.23577e-05f
Cred_5313 vin.$557.Metal2 VSS.$269.Metal1 1.71212e-05f
Cred_5314 vin.$557.Metal2 VSS.$275.Metal1 3.55095e-06f
Cred_5315 vin.$557.Metal2 VSS.$285.Metal1 2.11364e-06f
Cred_5316 vin.$557.Metal2 VSS.$40.Metal1 1.2545e-05f
Cred_5317 vin.$557.Metal2 VSS.$551.Metal1 3.09311e-05f
Cred_5318 vin.$557.Metal2 VSS.$805.Metal2 0.00311483f
Cred_5319 vin.$557.Metal2 VSS.$818.Metal2 0.00118411f
Cred_5320 vin.$557.Metal2 VSS.$826.Metal2 1.94978e-07f
Cred_5321 vin.$557.Metal2 VSS.P0.pSD 0.00505648f
Cred_5322 vin.$557.Metal2 VSS.P11.nSD 1.66101e-07f
Cred_5323 vin.$558.Metal2 vout.$1292.Metal3 0.0625715f
Cred_5324 vin.$558.Metal2 vout.P8.pSD 0.0114927f
Cred_5325 vin.$561.Metal2 vout.$1292.Metal3 0.0249549f
Cred_5326 vin.$561.Metal2 vout.$1358.Metal3 0.00545257f
Cred_5327 vin.$561.Metal2 vout.P10.nSD 0.000153291f
Cred_5328 vin.$561.Metal2 vout.P10.pSD 0.000465241f
Cred_5329 vin.$561.Metal2 vout.P8.nSD 6.73912e-05f
Cred_5330 vin.$561.Metal2 VSS 5.35966e-06f
Cred_5331 vin.$561.Metal2 VSS.$1196.Metal3 4.01439e-06f
Cred_5332 vin.$561.Metal2 VSS.$18.Metal1 4.35021e-05f
Cred_5333 vin.$561.Metal2 VSS.$269.Metal1 1.884e-05f
Cred_5334 vin.$561.Metal2 VSS.$275.Metal1 0.00164256f
Cred_5335 vin.$561.Metal2 VSS.$285.Metal1 0.0016408f
Cred_5336 vin.$561.Metal2 VSS.$40.Metal1 1.68656e-05f
Cred_5337 vin.$561.Metal2 VSS.$551.Metal1 5.77613e-05f
Cred_5338 vin.$561.Metal2 VSS.$805.Metal2 0.00118395f
Cred_5339 vin.$561.Metal2 VSS.$818.Metal2 0.0200228f
Cred_5340 vin.$561.Metal2 VSS.$826.Metal2 0.0188389f
Cred_5341 vin.$561.Metal2 VSS.P0.pSD 0.00799735f
Cred_5342 vin.$561.Metal2 VSS.P11.nSD 0.00011766f
Cred_5343 vin.$562.Metal2 vout.$1292.Metal3 0.0233645f
Cred_5344 vin.$562.Metal2 vout.$1358.Metal3 0.0048384f
Cred_5345 vin.$562.Metal2 vout.P10.nSD 7.62245e-05f
Cred_5346 vin.$562.Metal2 vout.P10.pSD 0.000766399f
Cred_5347 vin.$562.Metal2 vout.P8.pSD 0.000340744f
Cred_5348 vin.$564.Metal2 vout.$1292.Metal3 0.0925799f
Cred_5349 vin.$564.Metal2 vout.$1358.Metal3 0.0298197f
Cred_5350 vin.$564.Metal2 vout.P10.nSD 0.000492617f
Cred_5351 vin.$564.Metal2 vout.P10.pSD 0.00266417f
Cred_5352 vin.$564.Metal2 vout.P8.nSD 2.2835e-05f
Cred_5353 vin.$564.Metal2 vout.P8.pSD 0.000115459f
Cred_5354 vin.$564.Metal2 VSS.$18.Metal1 0.000272967f
Cred_5355 vin.$564.Metal2 VSS.$275.Metal1 0.000226532f
Cred_5356 vin.$564.Metal2 VSS.$285.Metal1 0.000226532f
Cred_5357 vin.$564.Metal2 VSS.$40.Metal1 0.000105828f
Cred_5358 vin.$564.Metal2 VSS.$551.Metal1 0.000404415f
Cred_5359 vin.$564.Metal2 VSS.$818.Metal2 0.00262312f
Cred_5360 vin.$564.Metal2 VSS.$826.Metal2 0.00262312f
Cred_5361 vin.$564.Metal2 VSS.P0.pSD 0.0530716f
Cred_5362 vin.$564.Metal2 VSS.P11.nSD 1.62309e-05f
Cred_5363 vin.$566.Metal2 vout.$1292.Metal3 0.0207382f
Cred_5364 vin.$566.Metal2 vout.$1358.Metal3 0.00928194f
Cred_5365 vin.$566.Metal2 vout.P10.nSD 0.00021362f
Cred_5366 vin.$566.Metal2 vout.P10.pSD 0.000791983f
Cred_5367 vin.$566.Metal2 vout.P8.nSD 6.73912e-05f
Cred_5368 vin.$566.Metal2 VSS 5.35935e-06f
Cred_5369 vin.$566.Metal2 VSS.$1217.Metal3 4.01416e-06f
Cred_5370 vin.$566.Metal2 VSS.$18.Metal1 3.92021e-05f
Cred_5371 vin.$566.Metal2 VSS.$275.Metal1 0.0016256f
Cred_5372 vin.$566.Metal2 VSS.$285.Metal1 0.00162596f
Cred_5373 vin.$566.Metal2 VSS.$294.Metal1 1.14189e-05f
Cred_5374 vin.$566.Metal2 VSS.$40.Metal1 1.51985e-05f
Cred_5375 vin.$566.Metal2 VSS.$551.Metal1 6.50049e-05f
Cred_5376 vin.$566.Metal2 VSS.$818.Metal2 0.0174298f
Cred_5377 vin.$566.Metal2 VSS.$826.Metal2 0.0186136f
Cred_5378 vin.$566.Metal2 VSS.$840.Metal2 0.00118388f
Cred_5379 vin.$566.Metal2 VSS.P0.pSD 0.00805381f
Cred_5380 vin.$566.Metal2 VSS.P11.nSD 0.00011742f
Cred_5381 vin.$567.Metal2 vout.$1292.Metal3 0.019148f
Cred_5382 vin.$567.Metal2 vout.$1358.Metal3 0.00866777f
Cred_5383 vin.$567.Metal2 vout.P10.nSD 0.000136553f
Cred_5384 vin.$567.Metal2 vout.P10.pSD 0.00109314f
Cred_5385 vin.$567.Metal2 vout.P8.pSD 0.000340744f
Cred_5386 vin.$57.GatPoly vout.$1226.Metal3 0.0315155f
Cred_5387 vin.$57.GatPoly vout.$1292.Metal3 0.0256585f
Cred_5388 vin.$57.GatPoly vout.P4.pSD 0.000411545f
Cred_5389 vin.$57.GatPoly vout.P6.nSD 0.000404226f
Cred_5390 vin.$57.GatPoly vout.P6.pSD 0.0362783f
Cred_5391 vin.$570.Metal2 vout.$1292.Metal3 0.0193631f
Cred_5392 vin.$570.Metal2 vout.$1358.Metal3 0.0193631f
Cred_5393 vin.$570.Metal2 vout.P10.nSD 0.00537002f
Cred_5394 vin.$570.Metal2 vout.P10.pSD 0.00165216f
Cred_5395 vin.$570.Metal2 VSS 5.35935e-06f
Cred_5396 vin.$570.Metal2 VSS.$1217.Metal3 4.01416e-06f
Cred_5397 vin.$570.Metal2 VSS.$18.Metal1 2.06673e-05f
Cred_5398 vin.$570.Metal2 VSS.$285.Metal1 3.63071e-07f
Cred_5399 vin.$570.Metal2 VSS.$294.Metal1 1.14189e-05f
Cred_5400 vin.$570.Metal2 VSS.$40.Metal1 8.01266e-06f
Cred_5401 vin.$570.Metal2 VSS.$551.Metal1 4.77129e-05f
Cred_5402 vin.$570.Metal2 VSS.$826.Metal2 0.00118387f
Cred_5403 vin.$570.Metal2 VSS.$840.Metal2 0.00311478f
Cred_5404 vin.$570.Metal2 VSS.P0.pSD 0.00501794f
Cred_5405 vin.$571.Metal2 vout.$1292.Metal3 0.0300458f
Cred_5406 vin.$571.Metal2 vout.$1358.Metal3 0.0300458f
Cred_5407 vin.$571.Metal2 vout.P10.nSD 0.000473344f
Cred_5408 vin.$571.Metal2 vout.P10.pSD 0.0144261f
Cred_5409 vin.$573.Metal2 vout.$1292.Metal3 0.0747144f
Cred_5410 vin.$573.Metal2 vout.$1358.Metal3 0.0747144f
Cred_5411 vin.$573.Metal2 vout.P10.nSD 0.00232532f
Cred_5412 vin.$573.Metal2 vout.P10.pSD 0.0107242f
Cred_5413 vin.$573.Metal2 VSS.$18.Metal1 0.000194659f
Cred_5414 vin.$573.Metal2 VSS.$40.Metal1 7.54687e-05f
Cred_5415 vin.$573.Metal2 VSS.$551.Metal1 0.000574185f
Cred_5416 vin.$573.Metal2 VSS.P0.pSD 0.0534178f
Cred_5417 vin.$575.Metal2 vout.$1292.Metal3 0.0388124f
Cred_5418 vin.$575.Metal2 vout.$1358.Metal3 0.0388124f
Cred_5419 vin.$575.Metal2 vout.P10.nSD 0.0127832f
Cred_5420 vin.$575.Metal2 vout.P10.pSD 0.00331167f
Cred_5421 vin.$575.Metal2 VSS.$18.Metal1 3.6733e-05f
Cred_5422 vin.$575.Metal2 VSS.$40.Metal1 1.42413e-05f
Cred_5423 vin.$575.Metal2 VSS.$551.Metal1 0.000108021f
Cred_5424 vin.$575.Metal2 VSS.$852.Metal2 0.00169455f
Cred_5425 vin.$575.Metal2 VSS.P0.pSD 0.0100223f
Cred_5426 vin.$578.Metal2 vout.$1292.Metal3 0.024319f
Cred_5427 vin.$578.Metal2 vout.$1358.Metal3 0.024319f
Cred_5428 vin.$578.Metal2 vout.P10.nSD 0.000383123f
Cred_5429 vin.$578.Metal2 vout.P10.pSD 0.0105403f
Cred_5430 vin.$579.Metal2 vout.$1292.Metal3 0.0125416f
Cred_5431 vin.$579.Metal2 vout.$1358.Metal3 0.0190751f
Cred_5432 vin.$579.Metal2 vout.P10.nSD 0.00135645f
Cred_5433 vin.$579.Metal2 vout.P10.pSD 0.00107011f
Cred_5434 vin.$579.Metal2 vout.P12.nSD 3.28661e-05f
Cred_5435 vin.$579.Metal2 VSS.$1223.Metal3 1.43603e-05f
Cred_5436 vin.$579.Metal2 VSS.$18.Metal1 2.19408e-05f
Cred_5437 vin.$579.Metal2 VSS.$304.Metal1 4.46539e-07f
Cred_5438 vin.$579.Metal2 VSS.$314.Metal1 3.56627e-05f
Cred_5439 vin.$579.Metal2 VSS.$319.Metal1 0.0021025f
Cred_5440 vin.$579.Metal2 VSS.$40.Metal1 8.50637e-06f
Cred_5441 vin.$579.Metal2 VSS.$551.Metal1 0.000107679f
Cred_5442 vin.$579.Metal2 VSS.$852.Metal2 0.0034856f
Cred_5443 vin.$579.Metal2 VSS.$867.Metal2 0.020359f
Cred_5444 vin.$579.Metal2 VSS.$875.Metal2 0.00559985f
Cred_5445 vin.$579.Metal2 VSS.P0.pSD 0.00772928f
Cred_5446 vin.$579.Metal2 VSS.P13.nSD 7.31077e-05f
Cred_5447 vin.$58.GatPoly vout.$1226.Metal3 0.0029015f
Cred_5448 vin.$58.GatPoly vout.$1292.Metal3 0.00203672f
Cred_5449 vin.$58.GatPoly vout.P4.nSD 8.10886e-06f
Cred_5450 vin.$58.GatPoly vout.P6.nSD 0.00214376f
Cred_5451 vin.$58.GatPoly vout.P6.pSD 0.000175361f
Cred_5452 vin.$58.GatPoly VSS.$1172.Metal3 3.73213e-10f
Cred_5453 vin.$58.GatPoly VSS.$18.Metal1 5.79804e-05f
Cred_5454 vin.$58.GatPoly VSS.$192.Metal1 0.000751257f
Cred_5455 vin.$58.GatPoly VSS.$195.Metal1 0.00513046f
Cred_5456 vin.$58.GatPoly VSS.$207.Metal1 2.16492e-05f
Cred_5457 vin.$58.GatPoly VSS.$219.Metal1 2.28603e-07f
Cred_5458 vin.$58.GatPoly VSS.$40.Metal1 2.24788e-05f
Cred_5459 vin.$58.GatPoly VSS.$551.Metal1 7.284e-06f
Cred_5460 vin.$58.GatPoly VSS.$732.Metal2 0.000904124f
Cred_5461 vin.$58.GatPoly VSS.$740.Metal2 3.45181e-05f
Cred_5462 vin.$58.GatPoly VSS.$752.Metal2 4.84579e-08f
Cred_5463 vin.$58.GatPoly VSS.P0.pSD 0.00326451f
Cred_5464 vin.$58.GatPoly VSS.P7.nSD 4.46155e-05f
Cred_5465 vin.$582.Metal2 vout.$1292.Metal3 0.00993907f
Cred_5466 vin.$582.Metal2 vout.$1358.Metal3 0.0250721f
Cred_5467 vin.$582.Metal2 vout.P10.nSD 0.000156581f
Cred_5468 vin.$582.Metal2 vout.P10.pSD 0.00131644f
Cred_5469 vin.$582.Metal2 vout.P12.pSD 0.000468386f
Cred_5470 vin.$584.Metal2 vout.$1292.Metal3 0.0295083f
Cred_5471 vin.$584.Metal2 vout.$1358.Metal3 0.0918296f
Cred_5472 vin.$584.Metal2 vout.P10.nSD 0.000485851f
Cred_5473 vin.$584.Metal2 vout.P10.pSD 0.00254831f
Cred_5474 vin.$584.Metal2 vout.P12.nSD 2.09757e-05f
Cred_5475 vin.$584.Metal2 vout.P12.pSD 3.05134e-05f
Cred_5476 vin.$584.Metal2 VSS.$18.Metal1 0.000137916f
Cred_5477 vin.$584.Metal2 VSS.$319.Metal1 0.00114188f
Cred_5478 vin.$584.Metal2 VSS.$40.Metal1 5.34697e-05f
Cred_5479 vin.$584.Metal2 VSS.$551.Metal1 0.000812218f
Cred_5480 vin.$584.Metal2 VSS.$867.Metal2 0.0101017f
Cred_5481 vin.$584.Metal2 VSS.$875.Metal2 0.00304655f
Cred_5482 vin.$584.Metal2 VSS.P0.pSD 0.0533395f
Cred_5483 vin.$584.Metal2 VSS.P13.nSD 3.96969e-05f
Cred_5484 vin.$586.Metal2 vout.$1292.Metal3 0.00466478f
Cred_5485 vin.$586.Metal2 vout.$1358.Metal3 0.0239312f
Cred_5486 vin.$586.Metal2 vout.P10.nSD 0.000113776f
Cred_5487 vin.$586.Metal2 vout.P10.pSD 0.000398023f
Cred_5488 vin.$586.Metal2 vout.P12.nSD 4.94234e-05f
Cred_5489 vin.$586.Metal2 VSS.$18.Metal1 1.86742e-05f
Cred_5490 vin.$586.Metal2 VSS.$319.Metal1 0.0036981f
Cred_5491 vin.$586.Metal2 VSS.$344.Metal1 4.15136e-06f
Cred_5492 vin.$586.Metal2 VSS.$40.Metal1 7.23991e-06f
Cred_5493 vin.$586.Metal2 VSS.$551.Metal1 0.000123002f
Cred_5494 vin.$586.Metal2 VSS.$867.Metal2 0.0320645f
Cred_5495 vin.$586.Metal2 VSS.$875.Metal2 0.0111327f
Cred_5496 vin.$586.Metal2 VSS.$881.Metal2 0.00239151f
Cred_5497 vin.$586.Metal2 VSS.P0.pSD 0.00757572f
Cred_5498 vin.$586.Metal2 VSS.P13.nSD 0.000128589f
Cred_5499 vin.$587.Metal2 vout.$1292.Metal3 0.00150227f
Cred_5500 vin.$587.Metal2 vout.$1358.Metal3 0.0150382f
Cred_5501 vin.$587.Metal2 vout.P10.nSD 2.36668e-05f
Cred_5502 vin.$587.Metal2 vout.P10.pSD 0.000186786f
Cred_5503 vin.$587.Metal2 vout.P12.pSD 0.00018411f
Cred_5504 vin.$590.Metal2 vout.$1358.Metal3 0.0577679f
Cred_5505 vin.$590.Metal2 vout.P12.nSD 0.00778234f
Cred_5506 vin.$590.Metal2 VSS.$18.Metal1 1.18867e-05f
Cred_5507 vin.$590.Metal2 VSS.$319.Metal1 7.44747e-06f
Cred_5508 vin.$590.Metal2 VSS.$344.Metal1 7.70326e-07f
Cred_5509 vin.$590.Metal2 VSS.$40.Metal1 4.60843e-06f
Cred_5510 vin.$590.Metal2 VSS.$551.Metal1 0.000126348f
Cred_5511 vin.$590.Metal2 VSS.$867.Metal2 4.48317e-07f
Cred_5512 vin.$590.Metal2 VSS.$875.Metal2 1.41269e-07f
Cred_5513 vin.$590.Metal2 VSS.$881.Metal2 0.00239142f
Cred_5514 vin.$590.Metal2 VSS.P0.pSD 0.00612746f
Cred_5515 vin.$590.Metal2 VSS.P13.nSD 2.46691e-07f
Cred_5516 vin.$591.Metal2 vout.$1358.Metal3 0.0519778f
Cred_5517 vin.$591.Metal2 vout.P12.pSD 0.00988711f
Cred_5518 vin.$593.Metal2 vout.$1358.Metal3 0.176873f
Cred_5519 vin.$593.Metal2 vout.$1424.Metal3 0.00901986f
Cred_5520 vin.$593.Metal2 vout.P12.nSD 0.00129017f
Cred_5521 vin.$593.Metal2 vout.P12.pSD 0.00144016f
Cred_5522 vin.$593.Metal2 vout.P14.nSD 0.000142398f
Cred_5523 vin.$593.Metal2 vout.P14.pSD 0.00076962f
Cred_5524 vin.$593.Metal2 VSS.$18.Metal1 0.000120795f
Cred_5525 vin.$593.Metal2 VSS.$372.Metal1 0.000143935f
Cred_5526 vin.$593.Metal2 VSS.$40.Metal1 4.68318e-05f
Cred_5527 vin.$593.Metal2 VSS.$551.Metal1 0.00169417f
Cred_5528 vin.$593.Metal2 VSS.$905.Metal2 5.65961e-05f
Cred_5529 vin.$593.Metal2 VSS.$914.Metal2 0.00149036f
Cred_5530 vin.$593.Metal2 VSS.P0.pSD 0.0709039f
Cred_5531 vin.$593.Metal2 VSS.P15.nSD 8.41734e-07f
Cred_5532 vin.$595.Metal2 vout.$1358.Metal3 0.071683f
Cred_5533 vin.$595.Metal2 vout.P12.nSD 0.0105281f
Cred_5534 vin.$595.Metal2 VSS.$1241.Metal3 9.08029e-06f
Cred_5535 vin.$595.Metal2 VSS.$18.Metal1 1.30141e-05f
Cred_5536 vin.$595.Metal2 VSS.$344.Metal1 3.09872e-07f
Cred_5537 vin.$595.Metal2 VSS.$356.Metal1 1.35199e-05f
Cred_5538 vin.$595.Metal2 VSS.$369.Metal1 7.82459e-07f
Cred_5539 vin.$595.Metal2 VSS.$372.Metal1 1.72537e-06f
Cred_5540 vin.$595.Metal2 VSS.$40.Metal1 5.04551e-06f
Cred_5541 vin.$595.Metal2 VSS.$551.Metal1 0.000174871f
Cred_5542 vin.$595.Metal2 VSS.$893.Metal2 0.00113252f
Cred_5543 vin.$595.Metal2 VSS.$905.Metal2 0.00113253f
Cred_5544 vin.$595.Metal2 VSS.$914.Metal2 3.72161e-08f
Cred_5545 vin.$595.Metal2 VSS.P0.pSD 0.00753884f
Cred_5546 vin.$595.Metal2 VSS.P15.nSD 1.44361e-08f
Cred_5547 vin.$596.Metal2 vout.$1358.Metal3 0.0705949f
Cred_5548 vin.$596.Metal2 vout.P12.pSD 0.0131059f
Cred_5549 vin.$599.Metal2 vout.$1358.Metal3 0.0140062f
Cred_5550 vin.$599.Metal2 vout.$1424.Metal3 0.000402309f
Cred_5551 vin.$599.Metal2 vout.P12.nSD 2.51091e-05f
Cred_5552 vin.$599.Metal2 vout.P14.nSD 7.69108e-06f
Cred_5553 vin.$599.Metal2 vout.P14.pSD 3.4327e-05f
Cred_5554 vin.$599.Metal2 VSS.$1241.Metal3 9.08056e-06f
Cred_5555 vin.$599.Metal2 VSS.$18.Metal1 6.77639e-06f
Cred_5556 vin.$599.Metal2 VSS.$344.Metal1 4.71576e-07f
Cred_5557 vin.$599.Metal2 VSS.$356.Metal1 1.90177e-05f
Cred_5558 vin.$599.Metal2 VSS.$369.Metal1 2.61458e-06f
Cred_5559 vin.$599.Metal2 VSS.$372.Metal1 0.0015806f
Cred_5560 vin.$599.Metal2 VSS.$40.Metal1 2.62719e-06f
Cred_5561 vin.$599.Metal2 VSS.$551.Metal1 0.000121464f
Cred_5562 vin.$599.Metal2 VSS.$893.Metal2 0.00113256f
Cred_5563 vin.$599.Metal2 VSS.$905.Metal2 0.00415717f
Cred_5564 vin.$599.Metal2 VSS.$914.Metal2 0.016193f
Cred_5565 vin.$599.Metal2 VSS.P0.pSD 0.00454299f
Cred_5566 vin.$599.Metal2 VSS.P15.nSD 9.28578e-06f
Cred_5567 vin.$6.GatPoly vout.$1226.Metal3 0.00759213f
Cred_5568 vin.$6.GatPoly vout.P0.nSD 0.00585373f
Cred_5569 vin.$6.GatPoly vout.P0.pSD 0.00118221f
Cred_5570 vin.$6.GatPoly vout.P2.nSD 0.000122235f
Cred_5571 vin.$6.GatPoly vout.P2.pSD 0.000653679f
Cred_5572 vin.$6.GatPoly VSS.$18.Metal1 0.00063602f
Cred_5573 vin.$6.GatPoly VSS.$40.Metal1 0.000464745f
Cred_5574 vin.$6.GatPoly VSS.$551.Metal1 1.77582e-06f
Cred_5575 vin.$6.GatPoly VSS.$564.Metal2 5.20896e-06f
Cred_5576 vin.$6.GatPoly VSS.$605.Metal2 1.91566e-07f
Cred_5577 vin.$6.GatPoly VSS.$611.Metal2 2.76689e-06f
Cred_5578 vin.$6.GatPoly VSS.$623.Metal2 2.59404e-07f
Cred_5579 vin.$6.GatPoly VSS.$636.Metal2 2.03093e-05f
Cred_5580 vin.$6.GatPoly VSS.$644.Metal2 2.72725e-05f
Cred_5581 vin.$6.GatPoly VSS.$65.Metal1 2.29122e-05f
Cred_5582 vin.$6.GatPoly VSS.$80.Metal1 2.21857e-05f
Cred_5583 vin.$6.GatPoly VSS.$97.Metal1 0.00053061f
Cred_5584 vin.$6.GatPoly VSS.P0.GatPoly 0.000406757f
Cred_5585 vin.$6.GatPoly VSS.P0.nSD 1.46278e-06f
Cred_5586 vin.$6.GatPoly VSS.P0.pSD 0.00461999f
Cred_5587 vin.$6.GatPoly VSS.P1.nSD 1.46278e-06f
Cred_5588 vin.$6.GatPoly VSS.P3.nSD 1.99003e-05f
Cred_5589 vin.$603.Metal2 vout.$1358.Metal3 0.0531514f
Cred_5590 vin.$603.Metal2 vout.$1424.Metal3 0.0153467f
Cred_5591 vin.$603.Metal2 vout.P12.nSD 1.43057e-07f
Cred_5592 vin.$603.Metal2 vout.P12.pSD 0.000804195f
Cred_5593 vin.$603.Metal2 vout.P14.nSD 0.000241915f
Cred_5594 vin.$603.Metal2 vout.P14.pSD 0.00185992f
Cred_5595 vin.$603.Metal2 VSS.$18.Metal1 1.06993e-05f
Cred_5596 vin.$603.Metal2 VSS.$372.Metal1 6.89462e-05f
Cred_5597 vin.$603.Metal2 VSS.$40.Metal1 4.1481e-06f
Cred_5598 vin.$603.Metal2 VSS.$551.Metal1 0.000253204f
Cred_5599 vin.$603.Metal2 VSS.$905.Metal2 2.711e-05f
Cred_5600 vin.$603.Metal2 VSS.$914.Metal2 0.000713896f
Cred_5601 vin.$603.Metal2 VSS.P0.pSD 0.00819954f
Cred_5602 vin.$603.Metal2 VSS.P15.nSD 4.03198e-07f
Cred_5603 vin.$604.Metal2 vout.$1358.Metal3 0.0461637f
Cred_5604 vin.$604.Metal2 vout.$1424.Metal3 0.0178808f
Cred_5605 vin.$604.Metal2 vout.P12.nSD 9.26598e-05f
Cred_5606 vin.$604.Metal2 vout.P14.nSD 0.000472451f
Cred_5607 vin.$604.Metal2 vout.P14.pSD 0.00152568f
Cred_5608 vin.$604.Metal2 VSS.$1250.Metal3 7.27792e-06f
Cred_5609 vin.$604.Metal2 VSS.$18.Metal1 2.7078e-05f
Cred_5610 vin.$604.Metal2 VSS.$372.Metal1 0.00513633f
Cred_5611 vin.$604.Metal2 VSS.$379.Metal1 8.08006e-06f
Cred_5612 vin.$604.Metal2 VSS.$396.Metal1 3.63346e-07f
Cred_5613 vin.$604.Metal2 VSS.$40.Metal1 1.0498e-05f
Cred_5614 vin.$604.Metal2 VSS.$551.Metal1 0.000678489f
Cred_5615 vin.$604.Metal2 VSS.$905.Metal2 0.0019177f
Cred_5616 vin.$604.Metal2 VSS.$914.Metal2 0.0514072f
Cred_5617 vin.$604.Metal2 VSS.$928.Metal2 0.00236814f
Cred_5618 vin.$604.Metal2 VSS.$934.Metal2 3.03569e-09f
Cred_5619 vin.$604.Metal2 VSS.P0.pSD 0.0212832f
Cred_5620 vin.$604.Metal2 VSS.P15.nSD 3.10561e-05f
Cred_5621 vin.$609.Metal2 vout.$1358.Metal3 0.00918213f
Cred_5622 vin.$609.Metal2 vout.$1424.Metal3 0.00907964f
Cred_5623 vin.$609.Metal2 vout.P12.pSD 6.65553e-06f
Cred_5624 vin.$609.Metal2 vout.P14.nSD 0.000143041f
Cred_5625 vin.$609.Metal2 vout.P14.pSD 0.00173063f
Cred_5626 vin.$610.Metal2 vout.$1358.Metal3 0.036807f
Cred_5627 vin.$610.Metal2 vout.$1424.Metal3 0.036807f
Cred_5628 vin.$610.Metal2 vout.P14.nSD 0.0118473f
Cred_5629 vin.$610.Metal2 vout.P14.pSD 0.00314056f
Cred_5630 vin.$610.Metal2 VSS.$1250.Metal3 3.60466e-06f
Cred_5631 vin.$610.Metal2 VSS.$18.Metal1 9.47307e-06f
Cred_5632 vin.$610.Metal2 VSS.$372.Metal1 0.000409021f
Cred_5633 vin.$610.Metal2 VSS.$379.Metal1 5.22427e-06f
Cred_5634 vin.$610.Metal2 VSS.$396.Metal1 7.33628e-07f
Cred_5635 vin.$610.Metal2 VSS.$40.Metal1 3.67268e-06f
Cred_5636 vin.$610.Metal2 VSS.$551.Metal1 0.000412597f
Cred_5637 vin.$610.Metal2 VSS.$905.Metal2 0.000160829f
Cred_5638 vin.$610.Metal2 VSS.$914.Metal2 0.00468475f
Cred_5639 vin.$610.Metal2 VSS.$928.Metal2 0.00339829f
Cred_5640 vin.$610.Metal2 VSS.$934.Metal2 6.12933e-09f
Cred_5641 vin.$610.Metal2 VSS.P0.pSD 0.00970853f
Cred_5642 vin.$610.Metal2 VSS.P15.nSD 2.39196e-06f
Cred_5643 vin.$611.Metal2 vout.$1358.Metal3 0.0291332f
Cred_5644 vin.$611.Metal2 vout.$1424.Metal3 0.0291332f
Cred_5645 vin.$611.Metal2 vout.P14.nSD 0.000458966f
Cred_5646 vin.$611.Metal2 vout.P14.pSD 0.0159242f
Cred_5647 vin.$613.Metal2 vout.$1358.Metal3 0.0982929f
Cred_5648 vin.$613.Metal2 vout.$1424.Metal3 0.0792964f
Cred_5649 vin.$613.Metal2 vout.P12.nSD 2.98653e-07f
Cred_5650 vin.$613.Metal2 vout.P14.nSD 0.00247466f
Cred_5651 vin.$613.Metal2 vout.P14.pSD 0.00812867f
Cred_5652 vin.$613.Metal2 VSS.$18.Metal1 7.19567e-05f
Cred_5653 vin.$613.Metal2 VSS.$372.Metal1 0.000143935f
Cred_5654 vin.$613.Metal2 VSS.$40.Metal1 2.78974e-05f
Cred_5655 vin.$613.Metal2 VSS.$551.Metal1 0.00289578f
Cred_5656 vin.$613.Metal2 VSS.$905.Metal2 5.65961e-05f
Cred_5657 vin.$613.Metal2 VSS.$914.Metal2 0.00149036f
Cred_5658 vin.$613.Metal2 VSS.P0.pSD 0.0704738f
Cred_5659 vin.$613.Metal2 VSS.P15.nSD 8.41734e-07f
Cred_5660 vin.$615.Metal2 vout.$1358.Metal3 0.0276522f
Cred_5661 vin.$615.Metal2 vout.$1424.Metal3 0.0276522f
Cred_5662 vin.$615.Metal2 vout.P14.nSD 0.00752249f
Cred_5663 vin.$615.Metal2 vout.P14.pSD 0.00235943f
Cred_5664 vin.$615.Metal2 VSS.$1259.Metal3 4.44744e-06f
Cred_5665 vin.$615.Metal2 VSS.$18.Metal1 4.3453e-06f
Cred_5666 vin.$615.Metal2 VSS.$396.Metal1 4.44744e-06f
Cred_5667 vin.$615.Metal2 VSS.$40.Metal1 1.68466e-06f
Cred_5668 vin.$615.Metal2 VSS.$551.Metal1 0.000250088f
Cred_5669 vin.$615.Metal2 VSS.$934.Metal2 0.000554698f
Cred_5670 vin.$615.Metal2 VSS.$946.Metal2 0.00305041f
Cred_5671 vin.$615.Metal2 VSS.P0.pSD 0.00509642f
Cred_5672 vin.$616.Metal2 vout.$1358.Metal3 0.0231172f
Cred_5673 vin.$616.Metal2 vout.$1424.Metal3 0.0231172f
Cred_5674 vin.$616.Metal2 vout.P14.nSD 0.00036419f
Cred_5675 vin.$616.Metal2 vout.P14.pSD 0.010938f
Cred_5676 vin.$619.Metal2 vout.$1358.Metal3 0.00640448f
Cred_5677 vin.$619.Metal2 vout.$1424.Metal3 0.010863f
Cred_5678 vin.$619.Metal2 vout.P14.nSD 0.000118081f
Cred_5679 vin.$619.Metal2 vout.P14.pSD 0.000546463f
Cred_5680 vin.$619.Metal2 vout.P16.nSD 1.71843e-05f
Cred_5681 vin.$619.Metal2 VSS.$18.Metal1 4.38691e-06f
Cred_5682 vin.$619.Metal2 VSS.$40.Metal1 1.70079e-06f
Cred_5683 vin.$619.Metal2 VSS.$409.Metal1 0.00250348f
Cred_5684 vin.$619.Metal2 VSS.$551.Metal1 0.000364753f
Cred_5685 vin.$619.Metal2 VSS.$946.Metal2 0.00249571f
Cred_5686 vin.$619.Metal2 VSS.$952.Metal2 0.00942665f
Cred_5687 vin.$619.Metal2 VSS.$961.Metal2 0.0187469f
Cred_5688 vin.$619.Metal2 VSS.P0.pSD 0.00612789f
Cred_5689 vin.$619.Metal2 VSS.P17.nSD 8.75729e-05f
Cred_5690 vin.$620.Metal2 vout.$1358.Metal3 0.00660463f
Cred_5691 vin.$620.Metal2 vout.$1424.Metal3 0.0109848f
Cred_5692 vin.$620.Metal2 vout.P14.nSD 0.00010405f
Cred_5693 vin.$620.Metal2 vout.P14.pSD 0.000659154f
Cred_5694 vin.$620.Metal2 vout.P16.pSD 9.56129e-05f
Cred_5695 vin.$622.Metal2 vout.$1358.Metal3 0.028528f
Cred_5696 vin.$622.Metal2 vout.$1424.Metal3 0.0879111f
Cred_5697 vin.$622.Metal2 vout.P14.nSD 0.000457527f
Cred_5698 vin.$622.Metal2 vout.P14.pSD 0.0024792f
Cred_5699 vin.$622.Metal2 vout.P16.nSD 8.09507e-06f
Cred_5700 vin.$622.Metal2 vout.P16.pSD 4.50408e-05f
Cred_5701 vin.$622.Metal2 VSS.$18.Metal1 3.32564e-05f
Cred_5702 vin.$622.Metal2 VSS.$40.Metal1 1.28934e-05f
Cred_5703 vin.$622.Metal2 VSS.$409.Metal1 0.000410524f
Cred_5704 vin.$622.Metal2 VSS.$551.Metal1 0.00316293f
Cred_5705 vin.$622.Metal2 VSS.$952.Metal2 0.00145036f
Cred_5706 vin.$622.Metal2 VSS.$961.Metal2 0.00330681f
Cred_5707 vin.$622.Metal2 VSS.P0.pSD 0.0496214f
Cred_5708 vin.$622.Metal2 VSS.P17.nSD 1.42532e-05f
Cred_5709 vin.$624.Metal2 vout.$1358.Metal3 0.00650663f
Cred_5710 vin.$624.Metal2 vout.$1424.Metal3 0.036376f
Cred_5711 vin.$624.Metal2 vout.P14.nSD 0.00017198f
Cred_5712 vin.$624.Metal2 vout.P14.pSD 0.000555179f
Cred_5713 vin.$624.Metal2 vout.P16.nSD 0.00104885f
Cred_5714 vin.$624.Metal2 VSS.$1271.Metal3 1.23569e-05f
Cred_5715 vin.$624.Metal2 VSS.$18.Metal1 5.67646e-06f
Cred_5716 vin.$624.Metal2 VSS.$40.Metal1 2.20075e-06f
Cred_5717 vin.$624.Metal2 VSS.$409.Metal1 0.00393458f
Cred_5718 vin.$624.Metal2 VSS.$426.Metal1 1.23569e-05f
Cred_5719 vin.$624.Metal2 VSS.$551.Metal1 0.000623986f
Cred_5720 vin.$624.Metal2 VSS.$952.Metal2 0.0137476f
Cred_5721 vin.$624.Metal2 VSS.$961.Metal2 0.0328856f
Cred_5722 vin.$624.Metal2 VSS.$975.Metal2 0.00256115f
Cred_5723 vin.$624.Metal2 VSS.P0.pSD 0.00903704f
Cred_5724 vin.$624.Metal2 VSS.P17.nSD 0.000136794f
Cred_5725 vin.$625.Metal2 vout.$1358.Metal3 0.00634131f
Cred_5726 vin.$625.Metal2 vout.$1424.Metal3 0.0261527f
Cred_5727 vin.$625.Metal2 vout.P14.nSD 9.99013e-05f
Cred_5728 vin.$625.Metal2 vout.P14.pSD 0.000957923f
Cred_5729 vin.$625.Metal2 vout.P16.pSD 0.000416851f
Cred_5730 vin.$629.Metal2 vout.$1424.Metal3 0.0538987f
Cred_5731 vin.$629.Metal2 vout.P16.pSD 0.00930781f
Cred_5732 vin.$630.Metal2 vout.$1424.Metal3 0.0918079f
Cred_5733 vin.$630.Metal2 vout.P16.nSD 0.0129837f
Cred_5734 vin.$630.Metal2 VSS.$1271.Metal3 6.12031e-06f
Cred_5735 vin.$630.Metal2 VSS.$18.Metal1 5.68689e-06f
Cred_5736 vin.$630.Metal2 VSS.$40.Metal1 2.20479e-06f
Cred_5737 vin.$630.Metal2 VSS.$409.Metal1 5.49654e-05f
Cred_5738 vin.$630.Metal2 VSS.$426.Metal1 6.12031e-06f
Cred_5739 vin.$630.Metal2 VSS.$551.Metal1 0.00103988f
Cred_5740 vin.$630.Metal2 VSS.$952.Metal2 0.00019419f
Cred_5741 vin.$630.Metal2 VSS.$961.Metal2 0.00120609f
Cred_5742 vin.$630.Metal2 VSS.$975.Metal2 0.00282265f
Cred_5743 vin.$630.Metal2 VSS.P0.pSD 0.0114396f
Cred_5744 vin.$630.Metal2 VSS.P17.nSD 1.90837e-06f
Cred_5745 vin.$633.Metal2 vout.$1424.Metal3 0.156935f
Cred_5746 vin.$633.Metal2 vout.P16.nSD 0.00114517f
Cred_5747 vin.$633.Metal2 vout.P16.pSD 0.0046241f
Cred_5748 vin.$633.Metal2 VSS.$18.Metal1 2.35423e-05f
Cred_5749 vin.$633.Metal2 VSS.$40.Metal1 9.12726e-06f
Cred_5750 vin.$633.Metal2 VSS.$551.Metal1 0.00448474f
Cred_5751 vin.$633.Metal2 VSS.P0.pSD 0.0484985f
Cred_5752 vin.$635.Metal2 vout.$1424.Metal3 0.0361747f
Cred_5753 vin.$635.Metal2 vout.P16.nSD 0.00424937f
Cred_5754 vin.$635.Metal2 VSS.$1002.Metal2 0.00119052f
Cred_5755 vin.$635.Metal2 VSS.$1010.Metal2 6.70053e-07f
Cred_5756 vin.$635.Metal2 VSS.$1283.Metal3 9.53807e-06f
Cred_5757 vin.$635.Metal2 VSS.$18.Metal1 1.82085e-06f
Cred_5758 vin.$635.Metal2 VSS.$40.Metal1 7.05937e-07f
Cred_5759 vin.$635.Metal2 VSS.$436.Metal1 5.98294e-07f
Cred_5760 vin.$635.Metal2 VSS.$448.Metal1 1.24159e-05f
Cred_5761 vin.$635.Metal2 VSS.$453.Metal1 1.75061e-05f
Cred_5762 vin.$635.Metal2 VSS.$551.Metal1 0.000453989f
Cred_5763 vin.$635.Metal2 VSS.$987.Metal2 0.00353881f
Cred_5764 vin.$635.Metal2 VSS.P0.pSD 0.00425091f
Cred_5765 vin.$635.Metal2 VSS.P19.nSD 6.69298e-07f
Cred_5766 vin.$636.Metal2 vout.$1424.Metal3 0.0588585f
Cred_5767 vin.$636.Metal2 vout.P16.pSD 0.010786f
Cred_5768 vin.$639.Metal2 vout 0.0111068f
Cred_5769 vin.$639.Metal2 vout.$1424.Metal3 0.020883f
Cred_5770 vin.$639.Metal2 vout.P16.nSD 7.2224e-05f
Cred_5771 vin.$639.Metal2 vout.P18.nSD 0.000141183f
Cred_5772 vin.$639.Metal2 VSS.$1002.Metal2 0.0246652f
Cred_5773 vin.$639.Metal2 VSS.$1010.Metal2 0.0174818f
Cred_5774 vin.$639.Metal2 VSS.$1283.Metal3 9.53831e-06f
Cred_5775 vin.$639.Metal2 VSS.$18.Metal1 2.79631e-06f
Cred_5776 vin.$639.Metal2 VSS.$40.Metal1 1.08412e-06f
Cred_5777 vin.$639.Metal2 VSS.$436.Metal1 2.20468e-07f
Cred_5778 vin.$639.Metal2 VSS.$448.Metal1 1.33539e-05f
Cred_5779 vin.$639.Metal2 VSS.$453.Metal1 0.00370329f
Cred_5780 vin.$639.Metal2 VSS.$551.Metal1 0.000992589f
Cred_5781 vin.$639.Metal2 VSS.$987.Metal2 0.00118965f
Cred_5782 vin.$639.Metal2 VSS.P0.pSD 0.00759965f
Cred_5783 vin.$639.Metal2 VSS.P19.nSD 0.000129173f
Cred_5784 vin.$64.GatPoly vout.$1226.Metal3 0.00432025f
Cred_5785 vin.$64.GatPoly vout.$1292.Metal3 0.00448816f
Cred_5786 vin.$64.GatPoly vout.P4.nSD 5.23911e-07f
Cred_5787 vin.$64.GatPoly vout.P6.nSD 0.00598235f
Cred_5788 vin.$64.GatPoly vout.P6.pSD 0.000367161f
Cred_5789 vin.$64.GatPoly vout.P8.nSD 2.09838e-06f
Cred_5790 vin.$64.GatPoly VSS.$18.Metal1 5.15215e-05f
Cred_5791 vin.$64.GatPoly VSS.$195.Metal1 0.000169257f
Cred_5792 vin.$64.GatPoly VSS.$232.Metal1 0.000635031f
Cred_5793 vin.$64.GatPoly VSS.$40.Metal1 1.99747e-05f
Cred_5794 vin.$64.GatPoly VSS.$551.Metal1 1.00488e-05f
Cred_5795 vin.$64.GatPoly VSS.$732.Metal2 5.4913e-05f
Cred_5796 vin.$64.GatPoly VSS.$740.Metal2 2.08531e-06f
Cred_5797 vin.$64.GatPoly VSS.$770.Metal2 6.25048e-05f
Cred_5798 vin.$64.GatPoly VSS.$779.Metal2 0.000207253f
Cred_5799 vin.$64.GatPoly VSS.P0.pSD 0.00362918f
Cred_5800 vin.$64.GatPoly VSS.P10.nSD 2.37653e-05f
Cred_5801 vin.$64.GatPoly VSS.P7.nSD 1.40717e-06f
Cred_5802 vin.$640.Metal2 vout 0.00854223f
Cred_5803 vin.$640.Metal2 vout.$1424.Metal3 0.0204479f
Cred_5804 vin.$640.Metal2 vout.P16.pSD 0.000359875f
Cred_5805 vin.$640.Metal2 vout.P18.pSD 0.000544331f
Cred_5806 vin.$642.Metal2 vout 0.110146f
Cred_5807 vin.$642.Metal2 vout.$1424.Metal3 0.0740289f
Cred_5808 vin.$642.Metal2 vout.P16.nSD 2.08912e-05f
Cred_5809 vin.$642.Metal2 vout.P16.pSD 0.000104096f
Cred_5810 vin.$642.Metal2 vout.P18.nSD 0.000469585f
Cred_5811 vin.$642.Metal2 vout.P18.pSD 0.000595411f
Cred_5812 vin.$642.Metal2 VSS.$1002.Metal2 0.0029713f
Cred_5813 vin.$642.Metal2 VSS.$1010.Metal2 0.00221267f
Cred_5814 vin.$642.Metal2 VSS.$18.Metal1 2.21719e-05f
Cred_5815 vin.$642.Metal2 VSS.$40.Metal1 8.59599e-06f
Cred_5816 vin.$642.Metal2 VSS.$453.Metal1 0.000448976f
Cred_5817 vin.$642.Metal2 VSS.$551.Metal1 0.0113627f
Cred_5818 vin.$642.Metal2 VSS.P0.pSD 0.0686247f
Cred_5819 vin.$642.Metal2 VSS.P19.nSD 1.55876e-05f
Cred_5820 vin.$644.Metal2 vout 0.0161788f
Cred_5821 vin.$644.Metal2 vout.$1424.Metal3 0.00989669f
Cred_5822 vin.$644.Metal2 vout.P16.nSD 5.37838e-05f
Cred_5823 vin.$644.Metal2 vout.P18.nSD 0.000181721f
Cred_5824 vin.$644.Metal2 VSS.$1002.Metal2 0.0191202f
Cred_5825 vin.$644.Metal2 VSS.$1010.Metal2 0.0154724f
Cred_5826 vin.$644.Metal2 VSS.$1022.Metal2 0.00123396f
Cred_5827 vin.$644.Metal2 VSS.$1292.Metal3 9.89362e-06f
Cred_5828 vin.$644.Metal2 VSS.$18.Metal1 1.74984e-06f
Cred_5829 vin.$644.Metal2 VSS.$40.Metal1 6.78409e-07f
Cred_5830 vin.$644.Metal2 VSS.$453.Metal1 0.00303883f
Cred_5831 vin.$644.Metal2 VSS.$471.Metal1 1.43018e-05f
Cred_5832 vin.$644.Metal2 VSS.$551.Metal1 0.000781602f
Cred_5833 vin.$644.Metal2 VSS.P0.pSD 0.00525328f
Cred_5834 vin.$644.Metal2 VSS.P19.nSD 0.000105958f
Cred_5835 vin.$645.Metal2 vout 0.0145033f
Cred_5836 vin.$645.Metal2 vout.$1424.Metal3 0.00957272f
Cred_5837 vin.$645.Metal2 vout.P16.pSD 0.000267992f
Cred_5838 vin.$645.Metal2 vout.P18.pSD 0.000498191f
Cred_5839 vin.$648.Metal2 vout 0.0492252f
Cred_5840 vin.$648.Metal2 vout.P18.nSD 0.00659042f
Cred_5841 vin.$648.Metal2 vout.P18.pSD 2.91178e-05f
Cred_5842 vin.$648.Metal2 VSS.$1002.Metal2 4.23036e-07f
Cred_5843 vin.$648.Metal2 VSS.$1010.Metal2 0.00123426f
Cred_5844 vin.$648.Metal2 VSS.$1022.Metal2 0.00280512f
Cred_5845 vin.$648.Metal2 VSS.$1034.Metal2 1.20785e-06f
Cred_5846 vin.$648.Metal2 VSS.$1040.Metal2 1.1207e-07f
Cred_5847 vin.$648.Metal2 VSS.$1066.Metal2 4.37798e-07f
Cred_5848 vin.$648.Metal2 VSS.$1292.Metal3 9.89346e-06f
Cred_5849 vin.$648.Metal2 VSS.$18.Metal1 1.85263e-06f
Cred_5850 vin.$648.Metal2 VSS.$40.Metal1 7.18258e-07f
Cred_5851 vin.$648.Metal2 VSS.$453.Metal1 8.49027e-06f
Cred_5852 vin.$648.Metal2 VSS.$471.Metal1 1.02915e-05f
Cred_5853 vin.$648.Metal2 VSS.$483.Metal1 1.29791e-05f
Cred_5854 vin.$648.Metal2 VSS.$498.Metal1 1.34041e-05f
Cred_5855 vin.$648.Metal2 VSS.$509.Metal1 1.83359e-05f
Cred_5856 vin.$648.Metal2 VSS.$551.Metal1 0.00150213f
Cred_5857 vin.$648.Metal2 VSS.P0.pSD 0.00698773f
Cred_5858 vin.$648.Metal2 VSS.P1.GatPoly 3.41867e-05f
Cred_5859 vin.$648.Metal2 VSS.P19.nSD 3.15318e-07f
Cred_5860 vin.$648.Metal2 VSS.P21.nSD 1.22942e-07f
Cred_5861 vin.$648.Metal2 VSS.P23.nSD 1.22942e-07f
Cred_5862 vin.$649.Metal2 vout 0.0456462f
Cred_5863 vin.$649.Metal2 vout.P18.nSD 2.21245e-05f
Cred_5864 vin.$649.Metal2 vout.P18.pSD 0.00956286f
Cred_5865 vin.$649.Metal2 VSS.$1034.Metal2 1.77925e-07f
Cred_5866 vin.$649.Metal2 VSS.$1040.Metal2 1.65532e-05f
Cred_5867 vin.$649.Metal2 VSS.$1298.Metal3 2.21913e-05f
Cred_5868 vin.$649.Metal2 VSS.$1307.Metal3 3.11558e-05f
Cred_5869 vin.$649.Metal2 VSS.$18.Metal1 3.07557e-07f
Cred_5870 vin.$649.Metal2 VSS.$40.Metal1 1.19239e-07f
Cred_5871 vin.$649.Metal2 VSS.$551.Metal1 0.000275635f
Cred_5872 vin.$649.Metal2 VSS.P0.pSD 0.00120185f
Cred_5873 vin.$65.GatPoly vout.$1226.Metal3 0.012872f
Cred_5874 vin.$65.GatPoly vout.$1292.Metal3 0.0146682f
Cred_5875 vin.$65.GatPoly vout.P6.nSD 0.000202787f
Cred_5876 vin.$65.GatPoly vout.P6.pSD 0.0198092f
Cred_5877 vin.$65.GatPoly vout.P8.pSD 0.000126207f
Cred_5878 vin.$653.Metal2 vout 0.109315f
Cred_5879 vin.$653.Metal2 vout.P18.nSD 0.0155754f
Cred_5880 vin.$653.Metal2 vout.P18.pSD 0.000111333f
Cred_5881 vin.$653.Metal2 VSS.$1034.Metal2 0.00327481f
Cred_5882 vin.$653.Metal2 VSS.$1040.Metal2 6.15563e-07f
Cred_5883 vin.$653.Metal2 VSS.$1066.Metal2 2.26572e-06f
Cred_5884 vin.$653.Metal2 VSS.$18.Metal1 4.65111e-06f
Cred_5885 vin.$653.Metal2 VSS.$40.Metal1 1.80322e-06f
Cred_5886 vin.$653.Metal2 VSS.$483.Metal1 7.12898e-05f
Cred_5887 vin.$653.Metal2 VSS.$498.Metal1 7.36241e-05f
Cred_5888 vin.$653.Metal2 VSS.$509.Metal1 9.48932e-05f
Cred_5889 vin.$653.Metal2 VSS.$551.Metal1 0.00468484f
Cred_5890 vin.$653.Metal2 VSS.P0.pSD 0.0191221f
Cred_5891 vin.$653.Metal2 VSS.P1.GatPoly 0.000176926f
Cred_5892 vin.$653.Metal2 VSS.P21.nSD 6.36259e-07f
Cred_5893 vin.$653.Metal2 VSS.P23.nSD 6.36259e-07f
Cred_5894 vin.$654.Metal2 vout 0.101095f
Cred_5895 vin.$654.Metal2 vout.P18.nSD 8.45938e-05f
Cred_5896 vin.$654.Metal2 vout.P18.pSD 0.0229608f
Cred_5897 vin.$654.Metal2 VSS.$1034.Metal2 8.82763e-07f
Cred_5898 vin.$654.Metal2 VSS.$1040.Metal2 8.21276e-05f
Cred_5899 vin.$654.Metal2 VSS.$1298.Metal3 0.000110101f
Cred_5900 vin.$654.Metal2 VSS.$1307.Metal3 0.000154577f
Cred_5901 vin.$654.Metal2 VSS.$18.Metal1 1.17595e-06f
Cred_5902 vin.$654.Metal2 VSS.$40.Metal1 4.55913e-07f
Cred_5903 vin.$654.Metal2 VSS.$551.Metal1 0.0010539f
Cred_5904 vin.$654.Metal2 VSS.P0.pSD 0.00459532f
Cred_5905 vin.$7.GatPoly vout.$1226.Metal3 0.0231395f
Cred_5906 vin.$7.GatPoly vout.P0.nSD 0.00068902f
Cred_5907 vin.$7.GatPoly vout.P0.pSD 0.025241f
Cred_5908 vin.$7.GatPoly vout.P2.nSD 0.00036454f
Cred_5909 vin.$7.GatPoly vout.P2.pSD 0.0019923f
Cred_5910 vin.$7.GatPoly VSS.$1106.Metal3 0.000305108f
Cred_5911 vin.$7.GatPoly VSS.$1115.Metal3 0.00021732f
Cred_5912 vin.$7.GatPoly VSS.$605.Metal2 0.000162106f
Cred_5913 vin.$7.GatPoly VSS.$611.Metal2 1.74242e-06f
Cred_5914 vin.$70.GatPoly vout.$1226.Metal3 0.00101616f
Cred_5915 vin.$70.GatPoly vout.$1292.Metal3 0.00154863f
Cred_5916 vin.$70.GatPoly vout.P6.nSD 0.000877937f
Cred_5917 vin.$70.GatPoly vout.P6.pSD 8.74912e-05f
Cred_5918 vin.$70.GatPoly vout.P8.nSD 4.99287e-06f
Cred_5919 vin.$70.GatPoly VSS.$18.Metal1 3.78438e-05f
Cred_5920 vin.$70.GatPoly VSS.$219.Metal1 3.74658e-06f
Cred_5921 vin.$70.GatPoly VSS.$232.Metal1 0.00823109f
Cred_5922 vin.$70.GatPoly VSS.$40.Metal1 1.46719e-05f
Cred_5923 vin.$70.GatPoly VSS.$551.Metal1 1.1503e-05f
Cred_5924 vin.$70.GatPoly VSS.$764.Metal2 9.81705e-08f
Cred_5925 vin.$70.GatPoly VSS.$770.Metal2 0.000237304f
Cred_5926 vin.$70.GatPoly VSS.$779.Metal2 0.000786752f
Cred_5927 vin.$70.GatPoly VSS.P0.pSD 0.00333757f
Cred_5928 vin.$70.GatPoly VSS.P10.nSD 0.000219362f
Cred_5929 vin.$73.GatPoly vout.$1226.Metal3 0.00583736f
Cred_5930 vin.$73.GatPoly vout.$1292.Metal3 0.00722747f
Cred_5931 vin.$73.GatPoly vout.P6.nSD 9.19621e-05f
Cred_5932 vin.$73.GatPoly vout.P6.pSD 0.00810359f
Cred_5933 vin.$73.GatPoly vout.P8.pSD 9.76778e-05f
Cred_5934 vin.$77.GatPoly vout.$1226.Metal3 0.00277707f
Cred_5935 vin.$77.GatPoly vout.$1292.Metal3 0.0545756f
Cred_5936 vin.$77.GatPoly vout.P6.nSD 4.37501e-05f
Cred_5937 vin.$77.GatPoly vout.P6.pSD 0.00064954f
Cred_5938 vin.$77.GatPoly vout.P8.pSD 0.0321726f
Cred_5939 vin.$78.GatPoly vout.$1226.Metal3 0.000284706f
Cred_5940 vin.$78.GatPoly vout.$1292.Metal3 0.00270625f
Cred_5941 vin.$78.GatPoly vout.P6.nSD 1.00965e-05f
Cred_5942 vin.$78.GatPoly vout.P6.pSD 2.4513e-05f
Cred_5943 vin.$78.GatPoly vout.P8.nSD 0.00100732f
Cred_5944 vin.$78.GatPoly VSS.$18.Metal1 2.71264e-05f
Cred_5945 vin.$78.GatPoly VSS.$232.Metal1 0.00732535f
Cred_5946 vin.$78.GatPoly VSS.$247.Metal1 1.29111e-05f
Cred_5947 vin.$78.GatPoly VSS.$259.Metal1 2.98183e-07f
Cred_5948 vin.$78.GatPoly VSS.$40.Metal1 1.05168e-05f
Cred_5949 vin.$78.GatPoly VSS.$551.Metal1 1.20084e-05f
Cred_5950 vin.$78.GatPoly VSS.$770.Metal2 0.000244128f
Cred_5951 vin.$78.GatPoly VSS.$779.Metal2 0.000809477f
Cred_5952 vin.$78.GatPoly VSS.$793.Metal2 2.49119e-09f
Cred_5953 vin.$78.GatPoly VSS.P0.pSD 0.00289322f
Cred_5954 vin.$78.GatPoly VSS.P10.nSD 0.000202016f
Cred_5955 vin.$80.GatPoly vout.$1226.Metal3 0.000199294f
Cred_5956 vin.$80.GatPoly vout.$1292.Metal3 0.00373469f
Cred_5957 vin.$80.GatPoly vout.P6.nSD 7.06754e-06f
Cred_5958 vin.$80.GatPoly vout.P6.pSD 1.71591e-05f
Cred_5959 vin.$80.GatPoly vout.P8.nSD 0.00220149f
Cred_5960 vin.$80.GatPoly VSS.$18.Metal1 2.05274e-05f
Cred_5961 vin.$80.GatPoly VSS.$232.Metal1 0.0011929f
Cred_5962 vin.$80.GatPoly VSS.$247.Metal1 1.48102e-06f
Cred_5963 vin.$80.GatPoly VSS.$259.Metal1 4.53682e-07f
Cred_5964 vin.$80.GatPoly VSS.$40.Metal1 7.95841e-06f
Cred_5965 vin.$80.GatPoly VSS.$551.Metal1 1.23946e-05f
Cred_5966 vin.$80.GatPoly VSS.$770.Metal2 0.000118436f
Cred_5967 vin.$80.GatPoly VSS.$779.Metal2 0.000392707f
Cred_5968 vin.$80.GatPoly VSS.$793.Metal2 3.79032e-09f
Cred_5969 vin.$80.GatPoly VSS.P0.pSD 0.00256091f
Cred_5970 vin.$80.GatPoly VSS.P10.nSD 4.4642e-05f
Cred_5971 vin.$83.GatPoly vout.$1292.Metal3 0.0109782f
Cred_5972 vin.$83.GatPoly vout.P8.pSD 0.0092696f
Cred_5973 vin.$84.GatPoly vout.$1292.Metal3 0.00847535f
Cred_5974 vin.$84.GatPoly vout.$1358.Metal3 8.93274e-05f
Cred_5975 vin.$84.GatPoly vout.P10.nSD 3.16716e-06f
Cred_5976 vin.$84.GatPoly vout.P10.pSD 7.62187e-06f
Cred_5977 vin.$84.GatPoly vout.P8.nSD 0.00569174f
Cred_5978 vin.$84.GatPoly VSS.$18.Metal1 2.44453e-05f
Cred_5979 vin.$84.GatPoly VSS.$275.Metal1 0.000270754f
Cred_5980 vin.$84.GatPoly VSS.$285.Metal1 0.000270754f
Cred_5981 vin.$84.GatPoly VSS.$40.Metal1 9.47738e-06f
Cred_5982 vin.$84.GatPoly VSS.$551.Metal1 1.93992e-05f
Cred_5983 vin.$84.GatPoly VSS.$818.Metal2 0.000115037f
Cred_5984 vin.$84.GatPoly VSS.$826.Metal2 0.000115037f
Cred_5985 vin.$84.GatPoly VSS.P0.pSD 0.00349392f
Cred_5986 vin.$84.GatPoly VSS.P11.nSD 2.08695e-05f
Cred_5987 vin.$87.GatPoly vout.$1292.Metal3 0.0565322f
Cred_5988 vin.$87.GatPoly vout.$1358.Metal3 0.00285379f
Cred_5989 vin.$87.GatPoly vout.P10.nSD 4.49588e-05f
Cred_5990 vin.$87.GatPoly vout.P10.pSD 0.000699669f
Cred_5991 vin.$87.GatPoly vout.P8.pSD 0.0335743f
Cred_5992 vin.$9.GatPoly vout.$1226.Metal3 0.0326489f
Cred_5993 vin.$9.GatPoly vout.P0.nSD 0.00089827f
Cred_5994 vin.$9.GatPoly vout.P0.pSD 0.0284069f
Cred_5995 vin.$9.GatPoly vout.P2.nSD 0.000514353f
Cred_5996 vin.$9.GatPoly vout.P2.pSD 0.00321412f
Cred_5997 vin.$90.GatPoly vout.$1292.Metal3 0.00275715f
Cred_5998 vin.$90.GatPoly vout.$1358.Metal3 0.000290126f
Cred_5999 vin.$90.GatPoly vout.P10.nSD 1.02866e-05f
Cred_6000 vin.$90.GatPoly vout.P10.pSD 2.47551e-05f
Cred_6001 vin.$90.GatPoly vout.P8.nSD 0.00101147f
Cred_6002 vin.$90.GatPoly VSS 4.13602e-10f
Cred_6003 vin.$90.GatPoly VSS.$1196.Metal3 3.09789e-10f
Cred_6004 vin.$90.GatPoly VSS.$18.Metal1 1.73024e-05f
Cred_6005 vin.$90.GatPoly VSS.$269.Metal1 1.00364e-05f
Cred_6006 vin.$90.GatPoly VSS.$275.Metal1 0.00265364f
Cred_6007 vin.$90.GatPoly VSS.$285.Metal1 0.00265175f
Cred_6008 vin.$90.GatPoly VSS.$40.Metal1 6.70808e-06f
Cred_6009 vin.$90.GatPoly VSS.$551.Metal1 1.9906e-05f
Cred_6010 vin.$90.GatPoly VSS.$805.Metal2 9.13645e-08f
Cred_6011 vin.$90.GatPoly VSS.$818.Metal2 0.000477826f
Cred_6012 vin.$90.GatPoly VSS.$826.Metal2 0.000477735f
Cred_6013 vin.$90.GatPoly VSS.P0.pSD 0.00297574f
Cred_6014 vin.$90.GatPoly VSS.P11.nSD 0.000156907f
Cred_6015 vin.$94.GatPoly vout.$1292.Metal3 0.000682049f
Cred_6016 vin.$94.GatPoly vout.$1358.Metal3 0.000448945f
Cred_6017 vin.$94.GatPoly vout.P10.nSD 0.00039386f
Cred_6018 vin.$94.GatPoly vout.P10.pSD 3.83063e-05f
Cred_6019 vin.$94.GatPoly vout.P8.nSD 2.18579e-06f
Cred_6020 vin.$94.GatPoly VSS.$18.Metal1 1.74466e-05f
Cred_6021 vin.$94.GatPoly VSS.$275.Metal1 0.00665142f
Cred_6022 vin.$94.GatPoly VSS.$285.Metal1 0.00665142f
Cred_6023 vin.$94.GatPoly VSS.$40.Metal1 6.764e-06f
Cred_6024 vin.$94.GatPoly VSS.$551.Metal1 2.88143e-05f
Cred_6025 vin.$94.GatPoly VSS.$818.Metal2 0.000515852f
Cred_6026 vin.$94.GatPoly VSS.$826.Metal2 0.000515852f
Cred_6027 vin.$94.GatPoly VSS.P0.pSD 0.00358963f
Cred_6028 vin.$94.GatPoly VSS.P11.nSD 0.000345267f
Cred_6029 vin.$97.GatPoly vout.$1292.Metal3 0.0312837f
Cred_6030 vin.$97.GatPoly vout.$1358.Metal3 0.0254406f
Cred_6031 vin.$97.GatPoly vout.P10.nSD 0.000400792f
Cred_6032 vin.$97.GatPoly vout.P10.pSD 0.0365361f
Cred_6033 vin.$97.GatPoly vout.P8.pSD 0.000410777f
Cred_6034 vin.P0.GatPoly vout.$1226.Metal3 0.0351432f
Cred_6035 vin.P0.GatPoly vout.P0.nSD 0.0265002f
Cred_6036 vin.P0.GatPoly vout.P0.pSD 0.00556068f
Cred_6037 vin.P0.GatPoly vout.P2.nSD 0.000553649f
Cred_6038 vin.P0.GatPoly vout.P2.pSD 0.00302582f
Cred_6039 vin.P0.GatPoly VSS.$1106.Metal3 0.0035273f
Cred_6040 vin.P0.GatPoly VSS.$1115.Metal3 0.00278945f
Cred_6041 vin.P0.GatPoly VSS.$18.Metal1 0.00182465f
Cred_6042 vin.P0.GatPoly VSS.$40.Metal1 0.0466552f
Cred_6043 vin.P0.GatPoly VSS.$551.Metal1 3.25845e-06f
Cred_6044 vin.P0.GatPoly VSS.$564.Metal2 0.0129829f
Cred_6045 vin.P0.GatPoly VSS.$590.Metal2 0.000492212f
Cred_6046 vin.P0.GatPoly VSS.$605.Metal2 0.00693351f
Cred_6047 vin.P0.GatPoly VSS.$611.Metal2 0.00497052f
Cred_6048 vin.P0.GatPoly VSS.$623.Metal2 1.14844e-07f
Cred_6049 vin.P0.GatPoly VSS.$636.Metal2 0.000585659f
Cred_6050 vin.P0.GatPoly VSS.$644.Metal2 0.000786456f
Cred_6051 vin.P0.GatPoly VSS.$65.Metal1 0.0104793f
Cred_6052 vin.P0.GatPoly VSS.$80.Metal1 0.00956148f
Cred_6053 vin.P0.GatPoly VSS.$97.Metal1 0.000103919f
Cred_6054 vin.P0.GatPoly VSS.P0.GatPoly 0.0190579f
Cred_6055 vin.P0.GatPoly VSS.P0.nSD 0.000210815f
Cred_6056 vin.P0.GatPoly VSS.P0.pSD 0.0102718f
Cred_6057 vin.P0.GatPoly VSS.P1.nSD 0.000210815f
Cred_6058 vin.P0.GatPoly VSS.P3.nSD 3.56597e-06f
Cred_6059 vin.P1.GatPoly vout.$1226.Metal3 0.0367128f
Cred_6060 vin.P1.GatPoly vout.P0.nSD 0.0231313f
Cred_6061 vin.P1.GatPoly vout.P0.pSD 0.00555071f
Cred_6062 vin.P1.GatPoly vout.P2.nSD 0.000617178f
Cred_6063 vin.P1.GatPoly vout.P2.pSD 0.00316095f
Cred_6064 vin.P1.GatPoly VSS.$1121.Metal3 0.00390769f
Cred_6065 vin.P1.GatPoly VSS.$18.Metal1 6.65059e-05f
Cred_6066 vin.P1.GatPoly VSS.$40.Metal1 2.57841e-05f
Cred_6067 vin.P1.GatPoly VSS.$551.Metal1 2.61957e-07f
Cred_6068 vin.P1.GatPoly VSS.$623.Metal2 0.00556066f
Cred_6069 vin.P1.GatPoly VSS.$636.Metal2 0.0088377f
Cred_6070 vin.P1.GatPoly VSS.$644.Metal2 0.00807083f
Cred_6071 vin.P1.GatPoly VSS.$80.Metal1 0.00333774f
Cred_6072 vin.P1.GatPoly VSS.$92.Metal1 0.0144838f
Cred_6073 vin.P1.GatPoly VSS.$97.Metal1 0.0581484f
Cred_6074 vin.P1.GatPoly VSS.P0.pSD 0.00060685f
Cred_6075 vin.P1.GatPoly VSS.P3.nSD 0.00178219f
Cred_6076 vin.P10.GatPoly vout.$1292.Metal3 0.0242843f
Cred_6077 vin.P10.GatPoly vout.$1358.Metal3 0.0205287f
Cred_6078 vin.P10.GatPoly vout.P10.nSD 0.0217703f
Cred_6079 vin.P10.GatPoly vout.P10.pSD 0.00175161f
Cred_6080 vin.P10.GatPoly vout.P8.nSD 3.84552e-05f
Cred_6081 vin.P10.GatPoly VSS 0.00220645f
Cred_6082 vin.P10.GatPoly VSS.$1217.Metal3 0.00165264f
Cred_6083 vin.P10.GatPoly VSS.$18.Metal1 4.08059e-06f
Cred_6084 vin.P10.GatPoly VSS.$275.Metal1 0.0255808f
Cred_6085 vin.P10.GatPoly VSS.$285.Metal1 0.0301743f
Cred_6086 vin.P10.GatPoly VSS.$294.Metal1 0.0127732f
Cred_6087 vin.P10.GatPoly VSS.$304.Metal1 0.00331295f
Cred_6088 vin.P10.GatPoly VSS.$319.Metal1 8.99087e-05f
Cred_6089 vin.P10.GatPoly VSS.$40.Metal1 1.58203e-06f
Cred_6090 vin.P10.GatPoly VSS.$551.Metal1 8.69779e-06f
Cred_6091 vin.P10.GatPoly VSS.$818.Metal2 0.00699331f
Cred_6092 vin.P10.GatPoly VSS.$826.Metal2 0.00982507f
Cred_6093 vin.P10.GatPoly VSS.$840.Metal2 0.00600219f
Cred_6094 vin.P10.GatPoly VSS.$867.Metal2 0.00091972f
Cred_6095 vin.P10.GatPoly VSS.$875.Metal2 0.000277376f
Cred_6096 vin.P10.GatPoly VSS.P0.pSD 0.00096449f
Cred_6097 vin.P10.GatPoly VSS.P11.nSD 0.0017333f
Cred_6098 vin.P10.GatPoly VSS.P13.nSD 3.08522e-06f
Cred_6099 vin.P11.GatPoly vout.$1292.Metal3 0.0201189f
Cred_6100 vin.P11.GatPoly vout.$1358.Metal3 0.0235822f
Cred_6101 vin.P11.GatPoly vout.P10.nSD 0.0215498f
Cred_6102 vin.P11.GatPoly vout.P10.pSD 0.00171665f
Cred_6103 vin.P11.GatPoly vout.P12.nSD 3.57144e-05f
Cred_6104 vin.P11.GatPoly VSS.$1217.Metal3 0.00093661f
Cred_6105 vin.P11.GatPoly VSS.$1223.Metal3 0.00435988f
Cred_6106 vin.P11.GatPoly VSS.$275.Metal1 4.51842e-05f
Cred_6107 vin.P11.GatPoly VSS.$285.Metal1 4.51842e-05f
Cred_6108 vin.P11.GatPoly VSS.$304.Metal1 0.00413995f
Cred_6109 vin.P11.GatPoly VSS.$314.Metal1 0.0140247f
Cred_6110 vin.P11.GatPoly VSS.$319.Metal1 0.0500404f
Cred_6111 vin.P11.GatPoly VSS.$818.Metal2 0.00059826f
Cred_6112 vin.P11.GatPoly VSS.$826.Metal2 0.00059826f
Cred_6113 vin.P11.GatPoly VSS.$852.Metal2 0.0069128f
Cred_6114 vin.P11.GatPoly VSS.$867.Metal2 0.0126099f
Cred_6115 vin.P11.GatPoly VSS.$875.Metal2 0.00309293f
Cred_6116 vin.P11.GatPoly VSS.P0.pSD 9.05855e-06f
Cred_6117 vin.P11.GatPoly VSS.P11.nSD 3.2009e-06f
Cred_6118 vin.P11.GatPoly VSS.P13.nSD 0.00157765f
Cred_6119 vin.P12.GatPoly vout.$1292.Metal3 0.00172617f
Cred_6120 vin.P12.GatPoly vout.$1358.Metal3 0.0443094f
Cred_6121 vin.P12.GatPoly vout.P10.nSD 6.44422e-05f
Cred_6122 vin.P12.GatPoly vout.P10.pSD 0.000147285f
Cred_6123 vin.P12.GatPoly vout.P12.nSD 0.0212036f
Cred_6124 vin.P12.GatPoly VSS.$1223.Metal3 0.00162593f
Cred_6125 vin.P12.GatPoly VSS.$1235.Metal3 0.00336824f
Cred_6126 vin.P12.GatPoly VSS.$18.Metal1 9.05516e-07f
Cred_6127 vin.P12.GatPoly VSS.$319.Metal1 0.0571382f
Cred_6128 vin.P12.GatPoly VSS.$344.Metal1 0.0126797f
Cred_6129 vin.P12.GatPoly VSS.$372.Metal1 9.66851e-05f
Cred_6130 vin.P12.GatPoly VSS.$40.Metal1 3.51066e-07f
Cred_6131 vin.P12.GatPoly VSS.$551.Metal1 8.21204e-06f
Cred_6132 vin.P12.GatPoly VSS.$867.Metal2 0.0103861f
Cred_6133 vin.P12.GatPoly VSS.$875.Metal2 0.00556097f
Cred_6134 vin.P12.GatPoly VSS.$881.Metal2 0.00699176f
Cred_6135 vin.P12.GatPoly VSS.$893.Metal2 0.00122955f
Cred_6136 vin.P12.GatPoly VSS.$905.Metal2 4.36418e-05f
Cred_6137 vin.P12.GatPoly VSS.$914.Metal2 0.00114923f
Cred_6138 vin.P12.GatPoly VSS.P0.pSD 0.00046576f
Cred_6139 vin.P12.GatPoly VSS.P13.nSD 0.0015791f
Cred_6140 vin.P12.GatPoly VSS.P15.nSD 5.29002e-07f
Cred_6141 vin.P13.GatPoly vout.$1358.Metal3 0.0441012f
Cred_6142 vin.P13.GatPoly vout.$1424.Metal3 0.00165462f
Cred_6143 vin.P13.GatPoly vout.P12.nSD 0.0213646f
Cred_6144 vin.P13.GatPoly vout.P14.nSD 6.19055e-05f
Cred_6145 vin.P13.GatPoly vout.P14.pSD 0.000141181f
Cred_6146 vin.P13.GatPoly VSS.$1241.Metal3 0.00440933f
Cred_6147 vin.P13.GatPoly VSS.$1250.Metal3 0.000775961f
Cred_6148 vin.P13.GatPoly VSS.$18.Metal1 6.85898e-07f
Cred_6149 vin.P13.GatPoly VSS.$319.Metal1 8.99087e-05f
Cred_6150 vin.P13.GatPoly VSS.$344.Metal1 0.00118965f
Cred_6151 vin.P13.GatPoly VSS.$356.Metal1 0.0148789f
Cred_6152 vin.P13.GatPoly VSS.$369.Metal1 0.00436754f
Cred_6153 vin.P13.GatPoly VSS.$372.Metal1 0.0526177f
Cred_6154 vin.P13.GatPoly VSS.$40.Metal1 2.6592e-07f
Cred_6155 vin.P13.GatPoly VSS.$551.Metal1 9.81099e-06f
Cred_6156 vin.P13.GatPoly VSS.$867.Metal2 0.00091972f
Cred_6157 vin.P13.GatPoly VSS.$875.Metal2 0.000277376f
Cred_6158 vin.P13.GatPoly VSS.$893.Metal2 0.00281966f
Cred_6159 vin.P13.GatPoly VSS.$905.Metal2 0.00668692f
Cred_6160 vin.P13.GatPoly VSS.$914.Metal2 0.00985657f
Cred_6161 vin.P13.GatPoly VSS.P0.pSD 0.000426206f
Cred_6162 vin.P13.GatPoly VSS.P13.nSD 3.08522e-06f
Cred_6163 vin.P13.GatPoly VSS.P15.nSD 0.00021155f
Cred_6164 vin.P14.GatPoly vout.$1358.Metal3 0.0222288f
Cred_6165 vin.P14.GatPoly vout.$1424.Metal3 0.0191762f
Cred_6166 vin.P14.GatPoly vout.P12.nSD 3.18635e-05f
Cred_6167 vin.P14.GatPoly vout.P14.nSD 0.0205849f
Cred_6168 vin.P14.GatPoly vout.P14.pSD 0.00163622f
Cred_6169 vin.P14.GatPoly VSS.$1250.Metal3 0.00443521f
Cred_6170 vin.P14.GatPoly VSS.$1259.Metal3 0.000848036f
Cred_6171 vin.P14.GatPoly VSS.$372.Metal1 0.0521114f
Cred_6172 vin.P14.GatPoly VSS.$379.Metal1 0.0154523f
Cred_6173 vin.P14.GatPoly VSS.$396.Metal1 0.00433478f
Cred_6174 vin.P14.GatPoly VSS.$409.Metal1 9.02649e-05f
Cred_6175 vin.P14.GatPoly VSS.$905.Metal2 0.000358966f
Cred_6176 vin.P14.GatPoly VSS.$914.Metal2 0.0113716f
Cred_6177 vin.P14.GatPoly VSS.$928.Metal2 0.00751382f
Cred_6178 vin.P14.GatPoly VSS.$934.Metal2 4.30156e-05f
Cred_6179 vin.P14.GatPoly VSS.$952.Metal2 0.000364856f
Cred_6180 vin.P14.GatPoly VSS.$961.Metal2 0.000831872f
Cred_6181 vin.P14.GatPoly VSS.P0.pSD 2.14021e-05f
Cred_6182 vin.P14.GatPoly VSS.P15.nSD 0.000208376f
Cred_6183 vin.P14.GatPoly VSS.P17.nSD 3.09744e-06f
Cred_6184 vin.P15.GatPoly vout.$1358.Metal3 0.0209365f
Cred_6185 vin.P15.GatPoly vout.$1424.Metal3 0.0246698f
Cred_6186 vin.P15.GatPoly vout.P14.nSD 0.0225422f
Cred_6187 vin.P15.GatPoly vout.P14.pSD 0.00178641f
Cred_6188 vin.P15.GatPoly vout.P16.nSD 3.82463e-05f
Cred_6189 vin.P15.GatPoly VSS.$1259.Metal3 0.00341116f
Cred_6190 vin.P15.GatPoly VSS.$1271.Metal3 0.00154919f
Cred_6191 vin.P15.GatPoly VSS.$18.Metal1 7.51637e-07f
Cred_6192 vin.P15.GatPoly VSS.$372.Metal1 9.66851e-05f
Cred_6193 vin.P15.GatPoly VSS.$396.Metal1 0.0129289f
Cred_6194 vin.P15.GatPoly VSS.$40.Metal1 2.91407e-07f
Cred_6195 vin.P15.GatPoly VSS.$409.Metal1 0.0570885f
Cred_6196 vin.P15.GatPoly VSS.$551.Metal1 5.00449e-05f
Cred_6197 vin.P15.GatPoly VSS.$905.Metal2 4.36418e-05f
Cred_6198 vin.P15.GatPoly VSS.$914.Metal2 0.00114923f
Cred_6199 vin.P15.GatPoly VSS.$934.Metal2 0.00100845f
Cred_6200 vin.P15.GatPoly VSS.$946.Metal2 0.00676466f
Cred_6201 vin.P15.GatPoly VSS.$952.Metal2 0.00616224f
Cred_6202 vin.P15.GatPoly VSS.$961.Metal2 0.00948282f
Cred_6203 vin.P15.GatPoly VSS.P0.pSD 0.000978963f
Cred_6204 vin.P15.GatPoly VSS.P15.nSD 5.29002e-07f
Cred_6205 vin.P15.GatPoly VSS.P17.nSD 0.00158988f
Cred_6206 vin.P16.GatPoly vout.$1358.Metal3 0.00145287f
Cred_6207 vin.P16.GatPoly vout.$1424.Metal3 0.0417745f
Cred_6208 vin.P16.GatPoly vout.P14.nSD 5.47521e-05f
Cred_6209 vin.P16.GatPoly vout.P14.pSD 0.000123966f
Cred_6210 vin.P16.GatPoly vout.P16.nSD 0.0203078f
Cred_6211 vin.P16.GatPoly VSS.$1002.Metal2 0.000685726f
Cred_6212 vin.P16.GatPoly VSS.$1010.Metal2 0.000510647f
Cred_6213 vin.P16.GatPoly VSS.$1271.Metal3 0.00490799f
Cred_6214 vin.P16.GatPoly VSS.$1283.Metal3 0.000393237f
Cred_6215 vin.P16.GatPoly VSS.$409.Metal1 0.0500973f
Cred_6216 vin.P16.GatPoly VSS.$426.Metal1 0.01338f
Cred_6217 vin.P16.GatPoly VSS.$436.Metal1 0.00459092f
Cred_6218 vin.P16.GatPoly VSS.$453.Metal1 9.06084e-05f
Cred_6219 vin.P16.GatPoly VSS.$952.Metal2 0.00392052f
Cred_6220 vin.P16.GatPoly VSS.$961.Metal2 0.0114439f
Cred_6221 vin.P16.GatPoly VSS.$975.Metal2 0.00670696f
Cred_6222 vin.P16.GatPoly VSS.$987.Metal2 6.29324e-06f
Cred_6223 vin.P16.GatPoly VSS.P0.pSD 1.17745e-05f
Cred_6224 vin.P16.GatPoly VSS.P17.nSD 0.00154074f
Cred_6225 vin.P16.GatPoly VSS.P19.nSD 3.10923e-06f
Cred_6226 vin.P17.GatPoly vout 0.00368223f
Cred_6227 vin.P17.GatPoly vout.$1424.Metal3 0.0435155f
Cred_6228 vin.P17.GatPoly vout.P16.nSD 0.0216974f
Cred_6229 vin.P17.GatPoly vout.P18.nSD 6.16347e-05f
Cred_6230 vin.P17.GatPoly VSS.$1002.Metal2 0.0105677f
Cred_6231 vin.P17.GatPoly VSS.$1010.Metal2 0.00582623f
Cred_6232 vin.P17.GatPoly VSS.$1271.Metal3 0.000293177f
Cred_6233 vin.P17.GatPoly VSS.$1283.Metal3 0.004796f
Cred_6234 vin.P17.GatPoly VSS.$18.Metal1 3.89701e-07f
Cred_6235 vin.P17.GatPoly VSS.$40.Metal1 1.51086e-07f
Cred_6236 vin.P17.GatPoly VSS.$409.Metal1 9.02649e-05f
Cred_6237 vin.P17.GatPoly VSS.$436.Metal1 0.0036862f
Cred_6238 vin.P17.GatPoly VSS.$448.Metal1 0.0136645f
Cred_6239 vin.P17.GatPoly VSS.$453.Metal1 0.0524707f
Cred_6240 vin.P17.GatPoly VSS.$551.Metal1 0.000103607f
Cred_6241 vin.P17.GatPoly VSS.$952.Metal2 0.000364856f
Cred_6242 vin.P17.GatPoly VSS.$961.Metal2 0.000831872f
Cred_6243 vin.P17.GatPoly VSS.$975.Metal2 4.69191e-06f
Cred_6244 vin.P17.GatPoly VSS.$987.Metal2 0.00632534f
Cred_6245 vin.P17.GatPoly VSS.P0.pSD 0.000948928f
Cred_6246 vin.P17.GatPoly VSS.P17.nSD 3.09744e-06f
Cred_6247 vin.P17.GatPoly VSS.P19.nSD 0.00161326f
Cred_6248 vin.P18.GatPoly vout 0.0426116f
Cred_6249 vin.P18.GatPoly vout.$1424.Metal3 0.00379259f
Cred_6250 vin.P18.GatPoly vout.P16.nSD 3.88024e-05f
Cred_6251 vin.P18.GatPoly vout.P18.nSD 0.0221618f
Cred_6252 vin.P18.GatPoly VSS.$1002.Metal2 0.00800795f
Cred_6253 vin.P18.GatPoly VSS.$1010.Metal2 0.00879088f
Cred_6254 vin.P18.GatPoly VSS.$1022.Metal2 0.00556066f
Cred_6255 vin.P18.GatPoly VSS.$1292.Metal3 0.00390769f
Cred_6256 vin.P18.GatPoly VSS.$18.Metal1 1.75938e-07f
Cred_6257 vin.P18.GatPoly VSS.$40.Metal1 6.82106e-08f
Cred_6258 vin.P18.GatPoly VSS.$453.Metal1 0.0566901f
Cred_6259 vin.P18.GatPoly VSS.$471.Metal1 0.0144838f
Cred_6260 vin.P18.GatPoly VSS.$483.Metal1 0.00333774f
Cred_6261 vin.P18.GatPoly VSS.$551.Metal1 9.87321e-05f
Cred_6262 vin.P18.GatPoly VSS.P0.pSD 0.000600426f
Cred_6263 vin.P18.GatPoly VSS.P19.nSD 0.00173666f
Cred_6264 vin.P19.GatPoly vout 0.0452586f
Cred_6265 vin.P19.GatPoly vout.P18.nSD 0.0254486f
Cred_6266 vin.P19.GatPoly VSS.$1002.Metal2 0.000786456f
Cred_6267 vin.P19.GatPoly VSS.$1010.Metal2 0.000585659f
Cred_6268 vin.P19.GatPoly VSS.$1034.Metal2 0.00496993f
Cred_6269 vin.P19.GatPoly VSS.$1040.Metal2 0.00693351f
Cred_6270 vin.P19.GatPoly VSS.$1055.Metal2 0.000492212f
Cred_6271 vin.P19.GatPoly VSS.$1066.Metal2 0.0129829f
Cred_6272 vin.P19.GatPoly VSS.$1298.Metal3 0.00278945f
Cred_6273 vin.P19.GatPoly VSS.$1307.Metal3 0.0035273f
Cred_6274 vin.P19.GatPoly VSS.$18.Metal1 2.17531e-06f
Cred_6275 vin.P19.GatPoly VSS.$40.Metal1 8.43359e-07f
Cred_6276 vin.P19.GatPoly VSS.$453.Metal1 0.000103919f
Cred_6277 vin.P19.GatPoly VSS.$483.Metal1 0.00956147f
Cred_6278 vin.P19.GatPoly VSS.$498.Metal1 0.0104793f
Cred_6279 vin.P19.GatPoly VSS.$509.Metal1 0.0459478f
Cred_6280 vin.P19.GatPoly VSS.$551.Metal1 0.00270442f
Cred_6281 vin.P19.GatPoly VSS.P0.pSD 0.0100741f
Cred_6282 vin.P19.GatPoly VSS.P1.GatPoly 0.0190579f
Cred_6283 vin.P19.GatPoly VSS.P19.nSD 3.56597e-06f
Cred_6284 vin.P19.GatPoly VSS.P21.nSD 0.000210815f
Cred_6285 vin.P19.GatPoly VSS.P23.nSD 0.000210815f
Cred_6286 vin.P2.GatPoly vout.$1226.Metal3 0.0393216f
Cred_6287 vin.P2.GatPoly vout.P0.nSD 0.000674738f
Cred_6288 vin.P2.GatPoly vout.P0.pSD 0.00325793f
Cred_6289 vin.P2.GatPoly vout.P2.nSD 0.0223169f
Cred_6290 vin.P2.GatPoly vout.P2.pSD 0.00338557f
Cred_6291 vin.P2.GatPoly VSS.$1130.Metal3 0.004796f
Cred_6292 vin.P2.GatPoly VSS.$1142.Metal3 0.000293177f
Cred_6293 vin.P2.GatPoly VSS.$115.Metal1 0.0136645f
Cred_6294 vin.P2.GatPoly VSS.$127.Metal1 0.0036862f
Cred_6295 vin.P2.GatPoly VSS.$142.Metal1 9.02649e-05f
Cred_6296 vin.P2.GatPoly VSS.$18.Metal1 6.97896e-05f
Cred_6297 vin.P2.GatPoly VSS.$40.Metal1 2.70572e-05f
Cred_6298 vin.P2.GatPoly VSS.$551.Metal1 5.79339e-07f
Cred_6299 vin.P2.GatPoly VSS.$636.Metal2 0.00582372f
Cred_6300 vin.P2.GatPoly VSS.$644.Metal2 0.0105643f
Cred_6301 vin.P2.GatPoly VSS.$658.Metal2 0.00632534f
Cred_6302 vin.P2.GatPoly VSS.$670.Metal2 4.69191e-06f
Cred_6303 vin.P2.GatPoly VSS.$685.Metal2 0.000831872f
Cred_6304 vin.P2.GatPoly VSS.$693.Metal2 0.000364856f
Cred_6305 vin.P2.GatPoly VSS.$97.Metal1 0.0523928f
Cred_6306 vin.P2.GatPoly VSS.P0.pSD 0.00095565f
Cred_6307 vin.P2.GatPoly VSS.P3.nSD 0.00161083f
Cred_6308 vin.P2.GatPoly VSS.P5.nSD 3.09744e-06f
Cred_6309 vin.P20.GatPoly vout.$1226.Metal3 0.156318f
Cred_6310 vin.P20.GatPoly vout.P0.nSD 0.00465464f
Cred_6311 vin.P20.GatPoly vout.P0.pSD 0.169754f
Cred_6312 vin.P20.GatPoly vout.P2.nSD 0.00246264f
Cred_6313 vin.P20.GatPoly vout.P2.pSD 0.0134589f
Cred_6314 vin.P20.GatPoly VSS.$1106.Metal3 0.00064194f
Cred_6315 vin.P20.GatPoly VSS.$1115.Metal3 0.000457235f
Cred_6316 vin.P20.GatPoly VSS.$605.Metal2 0.000341067f
Cred_6317 vin.P20.GatPoly VSS.$611.Metal2 3.66601e-06f
Cred_6318 vin.P21.GatPoly vout.$1226.Metal3 0.160661f
Cred_6319 vin.P21.GatPoly vout.P0.nSD 0.00458159f
Cred_6320 vin.P21.GatPoly vout.P0.pSD 0.152776f
Cred_6321 vin.P21.GatPoly vout.P2.nSD 0.00253106f
Cred_6322 vin.P21.GatPoly vout.P2.pSD 0.0164452f
Cred_6323 vin.P22.GatPoly vout.$1226.Metal3 0.174054f
Cred_6324 vin.P22.GatPoly vout.P0.nSD 0.0026994f
Cred_6325 vin.P22.GatPoly vout.P0.pSD 0.0174661f
Cred_6326 vin.P22.GatPoly vout.P2.nSD 0.00274205f
Cred_6327 vin.P22.GatPoly vout.P2.pSD 0.135457f
Cred_6328 vin.P23.GatPoly vout.$1226.Metal3 0.177972f
Cred_6329 vin.P23.GatPoly vout.P0.nSD 0.00235124f
Cred_6330 vin.P23.GatPoly vout.P0.pSD 0.0124941f
Cred_6331 vin.P23.GatPoly vout.P2.nSD 0.00255785f
Cred_6332 vin.P23.GatPoly vout.P2.pSD 0.13445f
Cred_6333 vin.P23.GatPoly vout.P4.pSD 0.00259263f
Cred_6334 vin.P24.GatPoly vout.$1226.Metal3 0.216059f
Cred_6335 vin.P24.GatPoly vout.P0.nSD 0.000200773f
Cred_6336 vin.P24.GatPoly vout.P0.pSD 0.00106687f
Cred_6337 vin.P24.GatPoly vout.P2.nSD 0.000218415f
Cred_6338 vin.P24.GatPoly vout.P2.pSD 0.00385188f
Cred_6339 vin.P24.GatPoly vout.P4.pSD 0.125718f
Cred_6340 vin.P25.GatPoly vout.$1226.Metal3 0.201171f
Cred_6341 vin.P25.GatPoly vout.$1292.Metal3 0.00742713f
Cred_6342 vin.P25.GatPoly vout.P4.pSD 0.120471f
Cred_6343 vin.P25.GatPoly vout.P6.nSD 0.000117007f
Cred_6344 vin.P25.GatPoly vout.P6.pSD 0.0032321f
Cred_6345 vin.P26.GatPoly vout.$1226.Metal3 0.107788f
Cred_6346 vin.P26.GatPoly vout.$1292.Metal3 0.0921775f
Cred_6347 vin.P26.GatPoly vout.P4.pSD 0.00259263f
Cred_6348 vin.P26.GatPoly vout.P6.nSD 0.00145217f
Cred_6349 vin.P26.GatPoly vout.P6.pSD 0.128408f
Cred_6350 vin.P27.GatPoly vout.$1226.Metal3 0.096316f
Cred_6351 vin.P27.GatPoly vout.$1292.Metal3 0.112912f
Cred_6352 vin.P27.GatPoly vout.P6.nSD 0.00151737f
Cred_6353 vin.P27.GatPoly vout.P6.pSD 0.134153f
Cred_6354 vin.P27.GatPoly vout.P8.pSD 0.00266188f
Cred_6355 vin.P28.GatPoly vout.$1226.Metal3 0.00742713f
Cred_6356 vin.P28.GatPoly vout.$1292.Metal3 0.201171f
Cred_6357 vin.P28.GatPoly vout.P6.nSD 0.000117007f
Cred_6358 vin.P28.GatPoly vout.P6.pSD 0.0032321f
Cred_6359 vin.P28.GatPoly vout.P8.pSD 0.120471f
Cred_6360 vin.P29.GatPoly vout.$1292.Metal3 0.20119f
Cred_6361 vin.P29.GatPoly vout.$1358.Metal3 0.00715313f
Cred_6362 vin.P29.GatPoly vout.P10.nSD 0.000112691f
Cred_6363 vin.P29.GatPoly vout.P10.pSD 0.00322922f
Cred_6364 vin.P29.GatPoly vout.P8.pSD 0.120733f
Cred_6365 vin.P3.GatPoly vout.$1226.Metal3 0.0368429f
Cred_6366 vin.P3.GatPoly vout.P0.nSD 0.000489337f
Cred_6367 vin.P3.GatPoly vout.P0.pSD 0.00260026f
Cred_6368 vin.P3.GatPoly vout.P2.nSD 0.0208402f
Cred_6369 vin.P3.GatPoly vout.P2.pSD 0.00290933f
Cred_6370 vin.P3.GatPoly vout.P4.nSD 3.18635e-05f
Cred_6371 vin.P3.GatPoly VSS.$1130.Metal3 0.000393237f
Cred_6372 vin.P3.GatPoly VSS.$1142.Metal3 0.00490799f
Cred_6373 vin.P3.GatPoly VSS.$127.Metal1 0.00459092f
Cred_6374 vin.P3.GatPoly VSS.$137.Metal1 0.01338f
Cred_6375 vin.P3.GatPoly VSS.$142.Metal1 0.0500973f
Cred_6376 vin.P3.GatPoly VSS.$636.Metal2 0.000510647f
Cred_6377 vin.P3.GatPoly VSS.$644.Metal2 0.000685726f
Cred_6378 vin.P3.GatPoly VSS.$658.Metal2 6.29324e-06f
Cred_6379 vin.P3.GatPoly VSS.$670.Metal2 0.00670696f
Cred_6380 vin.P3.GatPoly VSS.$685.Metal2 0.0114439f
Cred_6381 vin.P3.GatPoly VSS.$693.Metal2 0.00392052f
Cred_6382 vin.P3.GatPoly VSS.$97.Metal1 9.06084e-05f
Cred_6383 vin.P3.GatPoly VSS.P0.pSD 1.17745e-05f
Cred_6384 vin.P3.GatPoly VSS.P3.nSD 3.10923e-06f
Cred_6385 vin.P3.GatPoly VSS.P5.nSD 0.00154074f
Cred_6386 vin.P30.GatPoly vout.$1292.Metal3 0.107309f
Cred_6387 vin.P30.GatPoly vout.$1358.Metal3 0.0916983f
Cred_6388 vin.P30.GatPoly vout.P10.nSD 0.00144462f
Cred_6389 vin.P30.GatPoly vout.P10.pSD 0.129374f
Cred_6390 vin.P30.GatPoly vout.P8.pSD 0.00259263f
Cred_6391 vin.P31.GatPoly vout.$1292.Metal3 0.0918378f
Cred_6392 vin.P31.GatPoly vout.$1358.Metal3 0.106867f
Cred_6393 vin.P31.GatPoly vout.P10.nSD 0.00144682f
Cred_6394 vin.P31.GatPoly vout.P10.pSD 0.129648f
Cred_6395 vin.P31.GatPoly vout.P12.pSD 0.00261888f
Cred_6396 vin.P32.GatPoly vout.$1292.Metal3 0.00763443f
Cred_6397 vin.P32.GatPoly vout.$1358.Metal3 0.209225f
Cred_6398 vin.P32.GatPoly vout.P10.nSD 0.000120273f
Cred_6399 vin.P32.GatPoly vout.P10.pSD 0.00334719f
Cred_6400 vin.P32.GatPoly vout.P12.pSD 0.127294f
Cred_6401 vin.P33.GatPoly vout.$1358.Metal3 0.200112f
Cred_6402 vin.P33.GatPoly vout.$1424.Metal3 0.00715313f
Cred_6403 vin.P33.GatPoly vout.P12.pSD 0.121811f
Cred_6404 vin.P33.GatPoly vout.P14.nSD 0.000112691f
Cred_6405 vin.P33.GatPoly vout.P14.pSD 0.00322922f
Cred_6406 vin.P34.GatPoly vout.$1358.Metal3 0.106868f
Cred_6407 vin.P34.GatPoly vout.$1424.Metal3 0.0918383f
Cred_6408 vin.P34.GatPoly vout.P12.pSD 0.00261888f
Cred_6409 vin.P34.GatPoly vout.P14.nSD 0.00144683f
Cred_6410 vin.P34.GatPoly vout.P14.pSD 0.129647f
Cred_6411 vin.P35.GatPoly vout.$1358.Metal3 0.0958538f
Cred_6412 vin.P35.GatPoly vout.$1424.Metal3 0.11184f
Cred_6413 vin.P35.GatPoly vout.P14.nSD 0.00151009f
Cred_6414 vin.P35.GatPoly vout.P14.pSD 0.135381f
Cred_6415 vin.P35.GatPoly vout.P16.pSD 0.00269169f
Cred_6416 vin.P36.GatPoly vout.$1358.Metal3 0.00715313f
Cred_6417 vin.P36.GatPoly vout.$1424.Metal3 0.200603f
Cred_6418 vin.P36.GatPoly vout.P14.nSD 0.000112691f
Cred_6419 vin.P36.GatPoly vout.P14.pSD 0.00322922f
Cred_6420 vin.P36.GatPoly vout.P16.pSD 0.122248f
Cred_6421 vin.P37.GatPoly vout 0.0145241f
Cred_6422 vin.P37.GatPoly vout.$1424.Metal3 0.192958f
Cred_6423 vin.P37.GatPoly vout.P16.pSD 0.121811f
Cred_6424 vin.P37.GatPoly vout.P18.pSD 0.00312402f
Cred_6425 vin.P38.GatPoly vout 0.189642f
Cred_6426 vin.P38.GatPoly vout.$1424.Metal3 0.0150293f
Cred_6427 vin.P38.GatPoly vout.P16.pSD 0.00261888f
Cred_6428 vin.P38.GatPoly vout.P18.pSD 0.129705f
Cred_6429 vin.P39.GatPoly vout 0.201776f
Cred_6430 vin.P39.GatPoly vout.P18.pSD 0.147273f
Cred_6431 vin.P39.GatPoly VSS.$1034.Metal2 3.74151e-06f
Cred_6432 vin.P39.GatPoly VSS.$1040.Metal2 0.00034809f
Cred_6433 vin.P39.GatPoly VSS.$1298.Metal3 0.000466651f
Cred_6434 vin.P39.GatPoly VSS.$1307.Metal3 0.00065516f
Cred_6435 vin.P4.GatPoly vout.$1226.Metal3 0.0471178f
Cred_6436 vin.P4.GatPoly vout.P0.nSD 4.53065e-05f
Cred_6437 vin.P4.GatPoly vout.P0.pSD 0.000240751f
Cred_6438 vin.P4.GatPoly vout.P2.nSD 8.75338e-05f
Cred_6439 vin.P4.GatPoly vout.P2.pSD 0.000269368f
Cred_6440 vin.P4.GatPoly vout.P4.nSD 0.0222123f
Cred_6441 vin.P4.GatPoly VSS.$1142.Metal3 0.00154919f
Cred_6442 vin.P4.GatPoly VSS.$1154.Metal3 0.00341116f
Cred_6443 vin.P4.GatPoly VSS.$142.Metal1 0.0570885f
Cred_6444 vin.P4.GatPoly VSS.$167.Metal1 0.0129289f
Cred_6445 vin.P4.GatPoly VSS.$18.Metal1 3.37102e-05f
Cred_6446 vin.P4.GatPoly VSS.$195.Metal1 9.66851e-05f
Cred_6447 vin.P4.GatPoly VSS.$40.Metal1 1.30694e-05f
Cred_6448 vin.P4.GatPoly VSS.$551.Metal1 1.11624e-06f
Cred_6449 vin.P4.GatPoly VSS.$685.Metal2 0.00948282f
Cred_6450 vin.P4.GatPoly VSS.$693.Metal2 0.00616224f
Cred_6451 vin.P4.GatPoly VSS.$699.Metal2 0.00676466f
Cred_6452 vin.P4.GatPoly VSS.$711.Metal2 0.00100845f
Cred_6453 vin.P4.GatPoly VSS.$732.Metal2 0.00114923f
Cred_6454 vin.P4.GatPoly VSS.$740.Metal2 4.36418e-05f
Cred_6455 vin.P4.GatPoly VSS.P0.pSD 0.000982155f
Cred_6456 vin.P4.GatPoly VSS.P5.nSD 0.00158988f
Cred_6457 vin.P4.GatPoly VSS.P7.nSD 5.29002e-07f
Cred_6458 vin.P5.GatPoly vout.$1226.Metal3 0.0417431f
Cred_6459 vin.P5.GatPoly vout.$1292.Metal3 0.00145233f
Cred_6460 vin.P5.GatPoly vout.P4.nSD 0.0202828f
Cred_6461 vin.P5.GatPoly vout.P6.nSD 5.47436e-05f
Cred_6462 vin.P5.GatPoly vout.P6.pSD 0.000125045f
Cred_6463 vin.P5.GatPoly VSS.$1154.Metal3 0.000848036f
Cred_6464 vin.P5.GatPoly VSS.$1163.Metal3 0.00443521f
Cred_6465 vin.P5.GatPoly VSS.$142.Metal1 9.02649e-05f
Cred_6466 vin.P5.GatPoly VSS.$167.Metal1 0.00433478f
Cred_6467 vin.P5.GatPoly VSS.$184.Metal1 0.0154523f
Cred_6468 vin.P5.GatPoly VSS.$195.Metal1 0.0521114f
Cred_6469 vin.P5.GatPoly VSS.$685.Metal2 0.000831872f
Cred_6470 vin.P5.GatPoly VSS.$693.Metal2 0.000364856f
Cred_6471 vin.P5.GatPoly VSS.$711.Metal2 4.30156e-05f
Cred_6472 vin.P5.GatPoly VSS.$717.Metal2 0.00751382f
Cred_6473 vin.P5.GatPoly VSS.$732.Metal2 0.0113716f
Cred_6474 vin.P5.GatPoly VSS.$740.Metal2 0.000358966f
Cred_6475 vin.P5.GatPoly VSS.P0.pSD 2.14021e-05f
Cred_6476 vin.P5.GatPoly VSS.P5.nSD 3.09744e-06f
Cred_6477 vin.P5.GatPoly VSS.P7.nSD 0.000208376f
Cred_6478 vin.P6.GatPoly vout.$1226.Metal3 0.0236713f
Cred_6479 vin.P6.GatPoly vout.$1292.Metal3 0.0201949f
Cred_6480 vin.P6.GatPoly vout.P4.nSD 3.58385e-05f
Cred_6481 vin.P6.GatPoly vout.P6.nSD 0.0216827f
Cred_6482 vin.P6.GatPoly vout.P6.pSD 0.00173877f
Cred_6483 vin.P6.GatPoly VSS.$1163.Metal3 0.000775961f
Cred_6484 vin.P6.GatPoly VSS.$1172.Metal3 0.00440933f
Cred_6485 vin.P6.GatPoly VSS.$18.Metal1 6.60868e-06f
Cred_6486 vin.P6.GatPoly VSS.$192.Metal1 0.00436754f
Cred_6487 vin.P6.GatPoly VSS.$195.Metal1 0.0526177f
Cred_6488 vin.P6.GatPoly VSS.$207.Metal1 0.0148789f
Cred_6489 vin.P6.GatPoly VSS.$219.Metal1 0.00118965f
Cred_6490 vin.P6.GatPoly VSS.$232.Metal1 8.99087e-05f
Cred_6491 vin.P6.GatPoly VSS.$40.Metal1 2.56216e-06f
Cred_6492 vin.P6.GatPoly VSS.$551.Metal1 1.01833e-06f
Cred_6493 vin.P6.GatPoly VSS.$732.Metal2 0.00985657f
Cred_6494 vin.P6.GatPoly VSS.$740.Metal2 0.00668692f
Cred_6495 vin.P6.GatPoly VSS.$752.Metal2 0.00281966f
Cred_6496 vin.P6.GatPoly VSS.$770.Metal2 0.000277376f
Cred_6497 vin.P6.GatPoly VSS.$779.Metal2 0.00091972f
Cred_6498 vin.P6.GatPoly VSS.P0.pSD 0.00042678f
Cred_6499 vin.P6.GatPoly VSS.P10.nSD 3.08522e-06f
Cred_6500 vin.P6.GatPoly VSS.P7.nSD 0.00021155f
Cred_6501 vin.P7.GatPoly vout.$1226.Metal3 0.0202598f
Cred_6502 vin.P7.GatPoly vout.$1292.Metal3 0.0238867f
Cred_6503 vin.P7.GatPoly vout.P6.nSD 0.0215228f
Cred_6504 vin.P7.GatPoly vout.P6.pSD 0.00174436f
Cred_6505 vin.P7.GatPoly vout.P8.nSD 3.7248e-05f
Cred_6506 vin.P7.GatPoly VSS.$1178.Metal3 0.00336824f
Cred_6507 vin.P7.GatPoly VSS.$1190.Metal3 0.00162593f
Cred_6508 vin.P7.GatPoly VSS.$18.Metal1 5.53162e-06f
Cred_6509 vin.P7.GatPoly VSS.$195.Metal1 9.66851e-05f
Cred_6510 vin.P7.GatPoly VSS.$219.Metal1 0.0126797f
Cred_6511 vin.P7.GatPoly VSS.$232.Metal1 0.0571382f
Cred_6512 vin.P7.GatPoly VSS.$40.Metal1 2.14459e-06f
Cred_6513 vin.P7.GatPoly VSS.$551.Metal1 1.34436e-06f
Cred_6514 vin.P7.GatPoly VSS.$732.Metal2 0.00114923f
Cred_6515 vin.P7.GatPoly VSS.$740.Metal2 4.36418e-05f
Cred_6516 vin.P7.GatPoly VSS.$752.Metal2 0.00122955f
Cred_6517 vin.P7.GatPoly VSS.$764.Metal2 0.00699176f
Cred_6518 vin.P7.GatPoly VSS.$770.Metal2 0.00556097f
Cred_6519 vin.P7.GatPoly VSS.$779.Metal2 0.0103861f
Cred_6520 vin.P7.GatPoly VSS.P0.pSD 0.000466208f
Cred_6521 vin.P7.GatPoly VSS.P10.nSD 0.0015791f
Cred_6522 vin.P7.GatPoly VSS.P7.nSD 5.29002e-07f
Cred_6523 vin.P8.GatPoly vout.$1226.Metal3 0.00164772f
Cred_6524 vin.P8.GatPoly vout.$1292.Metal3 0.0439192f
Cred_6525 vin.P8.GatPoly vout.P6.nSD 6.16726e-05f
Cred_6526 vin.P8.GatPoly vout.P6.pSD 0.000141868f
Cred_6527 vin.P8.GatPoly vout.P8.nSD 0.0212328f
Cred_6528 vin.P8.GatPoly VSS.$1190.Metal3 0.00435988f
Cred_6529 vin.P8.GatPoly VSS.$1196.Metal3 0.00093661f
Cred_6530 vin.P8.GatPoly VSS.$232.Metal1 0.0500404f
Cred_6531 vin.P8.GatPoly VSS.$247.Metal1 0.0140247f
Cred_6532 vin.P8.GatPoly VSS.$259.Metal1 0.00413995f
Cred_6533 vin.P8.GatPoly VSS.$275.Metal1 4.51842e-05f
Cred_6534 vin.P8.GatPoly VSS.$285.Metal1 4.51842e-05f
Cred_6535 vin.P8.GatPoly VSS.$770.Metal2 0.00309293f
Cred_6536 vin.P8.GatPoly VSS.$779.Metal2 0.0126099f
Cred_6537 vin.P8.GatPoly VSS.$793.Metal2 0.0069128f
Cred_6538 vin.P8.GatPoly VSS.$818.Metal2 0.00059826f
Cred_6539 vin.P8.GatPoly VSS.$826.Metal2 0.00059826f
Cred_6540 vin.P8.GatPoly VSS.P0.pSD 9.05855e-06f
Cred_6541 vin.P8.GatPoly VSS.P10.nSD 0.00157765f
Cred_6542 vin.P8.GatPoly VSS.P11.nSD 3.2009e-06f
Cred_6543 vin.P9.GatPoly vout.$1292.Metal3 0.0441732f
Cred_6544 vin.P9.GatPoly vout.$1358.Metal3 0.00170886f
Cred_6545 vin.P9.GatPoly vout.P10.nSD 6.38285e-05f
Cred_6546 vin.P9.GatPoly vout.P10.pSD 0.000145809f
Cred_6547 vin.P9.GatPoly vout.P8.nSD 0.0211729f
Cred_6548 vin.P9.GatPoly VSS 0.00220645f
Cred_6549 vin.P9.GatPoly VSS.$1196.Metal3 0.00165264f
Cred_6550 vin.P9.GatPoly VSS.$18.Metal1 2.39287e-06f
Cred_6551 vin.P9.GatPoly VSS.$232.Metal1 8.99087e-05f
Cred_6552 vin.P9.GatPoly VSS.$259.Metal1 0.00331295f
Cred_6553 vin.P9.GatPoly VSS.$269.Metal1 0.0127732f
Cred_6554 vin.P9.GatPoly VSS.$275.Metal1 0.0291131f
Cred_6555 vin.P9.GatPoly VSS.$285.Metal1 0.0245196f
Cred_6556 vin.P9.GatPoly VSS.$40.Metal1 9.2771e-07f
Cred_6557 vin.P9.GatPoly VSS.$551.Metal1 2.27744e-06f
Cred_6558 vin.P9.GatPoly VSS.$770.Metal2 0.000277376f
Cred_6559 vin.P9.GatPoly VSS.$779.Metal2 0.00091972f
Cred_6560 vin.P9.GatPoly VSS.$805.Metal2 0.00600219f
Cred_6561 vin.P9.GatPoly VSS.$818.Metal2 0.00965792f
Cred_6562 vin.P9.GatPoly VSS.$826.Metal2 0.00682616f
Cred_6563 vin.P9.GatPoly VSS.P0.pSD 0.000383661f
Cred_6564 vin.P9.GatPoly VSS.P10.nSD 3.08522e-06f
Cred_6565 vin.P9.GatPoly VSS.P11.nSD 0.00166005f
Cred_6566 vout VSS.$1002.Metal2 0.0261243f
Cred_6567 vout VSS.$1010.Metal2 0.0194629f
Cred_6568 vout VSS.$1022.Metal2 0.00591882f
Cred_6569 vout VSS.$1034.Metal2 0.0035963f
Cred_6570 vout VSS.$1040.Metal2 1.16876e-05f
Cred_6571 vout VSS.$1066.Metal2 0.0448765f
Cred_6572 vout VSS.$1283.Metal3 0.000854403f
Cred_6573 vout VSS.$1292.Metal3 0.00716928f
Cred_6574 vout VSS.$1298.Metal3 0.0119594f
Cred_6575 vout VSS.$1307.Metal3 0.00111978f
Cred_6576 vout VSS.$18.Metal1 3.28309e-06f
Cred_6577 vout VSS.$40.Metal1 1.27284e-06f
Cred_6578 vout VSS.$453.Metal1 0.0156327f
Cred_6579 vout VSS.$471.Metal1 0.0018275f
Cred_6580 vout VSS.$483.Metal1 0.00778784f
Cred_6581 vout VSS.$498.Metal1 0.000324063f
Cred_6582 vout VSS.$509.Metal1 0.0113421f
Cred_6583 vout VSS.$551.Metal1 0.00436911f
Cred_6584 vout VSS.P0.pSD 0.0148708f
Cred_6585 vout VSS.P1.GatPoly 0.00120584f
Cred_6586 vout VSS.P19.nSD 0.000537315f
Cred_6587 vout VSS.P21.nSD 5.81234e-05f
Cred_6588 vout VSS.P23.nSD 5.81234e-05f
Cred_6589 vout.$1226.Metal3 VSS.$1106.Metal3 0.000868144f
Cred_6590 vout.$1226.Metal3 VSS.$1115.Metal3 0.00927183f
Cred_6591 vout.$1226.Metal3 VSS.$1121.Metal3 0.00622321f
Cred_6592 vout.$1226.Metal3 VSS.$1130.Metal3 0.0107065f
Cred_6593 vout.$1226.Metal3 VSS.$1142.Metal3 0.0119988f
Cred_6594 vout.$1226.Metal3 VSS.$115.Metal1 0.000930393f
Cred_6595 vout.$1226.Metal3 VSS.$1154.Metal3 0.0160831f
Cred_6596 vout.$1226.Metal3 VSS.$1163.Metal3 0.00935134f
Cred_6597 vout.$1226.Metal3 VSS.$1172.Metal3 0.00492856f
Cred_6598 vout.$1226.Metal3 VSS.$1178.Metal3 0.00619596f
Cred_6599 vout.$1226.Metal3 VSS.$1190.Metal3 0.000885582f
Cred_6600 vout.$1226.Metal3 VSS.$127.Metal1 0.00711959f
Cred_6601 vout.$1226.Metal3 VSS.$137.Metal1 0.00108062f
Cred_6602 vout.$1226.Metal3 VSS.$142.Metal1 0.0294106f
Cred_6603 vout.$1226.Metal3 VSS.$167.Metal1 0.00800819f
Cred_6604 vout.$1226.Metal3 VSS.$18.Metal1 0.00284851f
Cred_6605 vout.$1226.Metal3 VSS.$184.Metal1 0.0026768f
Cred_6606 vout.$1226.Metal3 VSS.$195.Metal1 0.0253105f
Cred_6607 vout.$1226.Metal3 VSS.$207.Metal1 0.00142814f
Cred_6608 vout.$1226.Metal3 VSS.$219.Metal1 0.00374972f
Cred_6609 vout.$1226.Metal3 VSS.$232.Metal1 0.00747146f
Cred_6610 vout.$1226.Metal3 VSS.$40.Metal1 0.0098574f
Cred_6611 vout.$1226.Metal3 VSS.$551.Metal1 3.2992e-05f
Cred_6612 vout.$1226.Metal3 VSS.$564.Metal2 0.0341062f
Cred_6613 vout.$1226.Metal3 VSS.$605.Metal2 9.06117e-06f
Cred_6614 vout.$1226.Metal3 VSS.$611.Metal2 0.00278813f
Cred_6615 vout.$1226.Metal3 VSS.$623.Metal2 0.00458873f
Cred_6616 vout.$1226.Metal3 VSS.$636.Metal2 0.033311f
Cred_6617 vout.$1226.Metal3 VSS.$644.Metal2 0.0447252f
Cred_6618 vout.$1226.Metal3 VSS.$65.Metal1 0.000251239f
Cred_6619 vout.$1226.Metal3 VSS.$658.Metal2 0.00437245f
Cred_6620 vout.$1226.Metal3 VSS.$670.Metal2 0.00379928f
Cred_6621 vout.$1226.Metal3 VSS.$685.Metal2 0.0651013f
Cred_6622 vout.$1226.Metal3 VSS.$693.Metal2 0.0285802f
Cred_6623 vout.$1226.Metal3 VSS.$699.Metal2 0.00192648f
Cred_6624 vout.$1226.Metal3 VSS.$711.Metal2 0.00757602f
Cred_6625 vout.$1226.Metal3 VSS.$717.Metal2 6.23475e-05f
Cred_6626 vout.$1226.Metal3 VSS.$732.Metal2 0.0657654f
Cred_6627 vout.$1226.Metal3 VSS.$740.Metal2 0.00250881f
Cred_6628 vout.$1226.Metal3 VSS.$752.Metal2 0.00355674f
Cred_6629 vout.$1226.Metal3 VSS.$764.Metal2 0.00101031f
Cred_6630 vout.$1226.Metal3 VSS.$770.Metal2 0.00490519f
Cred_6631 vout.$1226.Metal3 VSS.$779.Metal2 0.0162244f
Cred_6632 vout.$1226.Metal3 VSS.$80.Metal1 0.00603775f
Cred_6633 vout.$1226.Metal3 VSS.$92.Metal1 0.00141682f
Cred_6634 vout.$1226.Metal3 VSS.$97.Metal1 0.0256946f
Cred_6635 vout.$1226.Metal3 VSS.P0.GatPoly 0.000934859f
Cred_6636 vout.$1226.Metal3 VSS.P0.nSD 4.48919e-05f
Cred_6637 vout.$1226.Metal3 VSS.P0.pSD 0.031406f
Cred_6638 vout.$1226.Metal3 VSS.P1.nSD 4.48919e-05f
Cred_6639 vout.$1226.Metal3 VSS.P10.nSD 0.0002568f
Cred_6640 vout.$1226.Metal3 VSS.P3.nSD 0.000883225f
Cred_6641 vout.$1226.Metal3 VSS.P5.nSD 0.00100682f
Cred_6642 vout.$1226.Metal3 VSS.P7.nSD 0.000139443f
Cred_6643 vout.$1292.Metal3 VSS 0.00786872f
Cred_6644 vout.$1292.Metal3 VSS.$1163.Metal3 0.000797211f
Cred_6645 vout.$1292.Metal3 VSS.$1172.Metal3 0.00446283f
Cred_6646 vout.$1292.Metal3 VSS.$1178.Metal3 0.00666787f
Cred_6647 vout.$1292.Metal3 VSS.$1190.Metal3 0.00743652f
Cred_6648 vout.$1292.Metal3 VSS.$1196.Metal3 0.0147009f
Cred_6649 vout.$1292.Metal3 VSS.$1217.Metal3 0.00699683f
Cred_6650 vout.$1292.Metal3 VSS.$1223.Metal3 0.00311789f
Cred_6651 vout.$1292.Metal3 VSS.$1235.Metal3 0.000224605f
Cred_6652 vout.$1292.Metal3 VSS.$18.Metal1 0.000140669f
Cred_6653 vout.$1292.Metal3 VSS.$195.Metal1 0.00819691f
Cred_6654 vout.$1292.Metal3 VSS.$207.Metal1 0.00142814f
Cred_6655 vout.$1292.Metal3 VSS.$219.Metal1 0.00374972f
Cred_6656 vout.$1292.Metal3 VSS.$232.Metal1 0.0232126f
Cred_6657 vout.$1292.Metal3 VSS.$247.Metal1 0.000881713f
Cred_6658 vout.$1292.Metal3 VSS.$259.Metal1 0.00864126f
Cred_6659 vout.$1292.Metal3 VSS.$269.Metal1 0.00137136f
Cred_6660 vout.$1292.Metal3 VSS.$275.Metal1 0.0115818f
Cred_6661 vout.$1292.Metal3 VSS.$285.Metal1 0.0115818f
Cred_6662 vout.$1292.Metal3 VSS.$294.Metal1 0.000652696f
Cred_6663 vout.$1292.Metal3 VSS.$304.Metal1 0.00411277f
Cred_6664 vout.$1292.Metal3 VSS.$314.Metal1 0.000419648f
Cred_6665 vout.$1292.Metal3 VSS.$319.Metal1 0.00747422f
Cred_6666 vout.$1292.Metal3 VSS.$40.Metal1 5.45368e-05f
Cred_6667 vout.$1292.Metal3 VSS.$551.Metal1 0.000104736f
Cred_6668 vout.$1292.Metal3 VSS.$732.Metal2 0.0239438f
Cred_6669 vout.$1292.Metal3 VSS.$740.Metal2 0.000917199f
Cred_6670 vout.$1292.Metal3 VSS.$752.Metal2 0.00355674f
Cred_6671 vout.$1292.Metal3 VSS.$764.Metal2 0.0010141f
Cred_6672 vout.$1292.Metal3 VSS.$770.Metal2 0.0169918f
Cred_6673 vout.$1292.Metal3 VSS.$779.Metal2 0.0562874f
Cred_6674 vout.$1292.Metal3 VSS.$793.Metal2 0.00403267f
Cred_6675 vout.$1292.Metal3 VSS.$805.Metal2 0.00558431f
Cred_6676 vout.$1292.Metal3 VSS.$818.Metal2 0.0346355f
Cred_6677 vout.$1292.Metal3 VSS.$826.Metal2 0.0346131f
Cred_6678 vout.$1292.Metal3 VSS.$840.Metal2 0.00265783f
Cred_6679 vout.$1292.Metal3 VSS.$852.Metal2 0.00191933f
Cred_6680 vout.$1292.Metal3 VSS.$867.Metal2 0.0162287f
Cred_6681 vout.$1292.Metal3 VSS.$875.Metal2 0.00489635f
Cred_6682 vout.$1292.Metal3 VSS.$881.Metal2 1.80083e-06f
Cred_6683 vout.$1292.Metal3 VSS.P0.pSD 0.0172048f
Cred_6684 vout.$1292.Metal3 VSS.P10.nSD 0.000797136f
Cred_6685 vout.$1292.Metal3 VSS.P11.nSD 0.000821428f
Cred_6686 vout.$1292.Metal3 VSS.P13.nSD 0.000256895f
Cred_6687 vout.$1292.Metal3 VSS.P7.nSD 4.4933e-05f
Cred_6688 vout.$1358.Metal3 VSS 0.00253742f
Cred_6689 vout.$1358.Metal3 VSS.$1217.Metal3 0.00699683f
Cred_6690 vout.$1358.Metal3 VSS.$1223.Metal3 0.00497925f
Cred_6691 vout.$1358.Metal3 VSS.$1235.Metal3 0.0132476f
Cred_6692 vout.$1358.Metal3 VSS.$1241.Metal3 0.00960187f
Cred_6693 vout.$1358.Metal3 VSS.$1250.Metal3 0.00574692f
Cred_6694 vout.$1358.Metal3 VSS.$1259.Metal3 0.00744765f
Cred_6695 vout.$1358.Metal3 VSS.$1271.Metal3 0.000908368f
Cred_6696 vout.$1358.Metal3 VSS.$18.Metal1 3.56741e-05f
Cred_6697 vout.$1358.Metal3 VSS.$275.Metal1 0.00374154f
Cred_6698 vout.$1358.Metal3 VSS.$285.Metal1 0.00374154f
Cred_6699 vout.$1358.Metal3 VSS.$294.Metal1 0.000652696f
Cred_6700 vout.$1358.Metal3 VSS.$304.Metal1 0.00411277f
Cred_6701 vout.$1358.Metal3 VSS.$314.Metal1 0.000419648f
Cred_6702 vout.$1358.Metal3 VSS.$319.Metal1 0.0232945f
Cred_6703 vout.$1358.Metal3 VSS.$344.Metal1 0.00788136f
Cred_6704 vout.$1358.Metal3 VSS.$356.Metal1 0.00300175f
Cred_6705 vout.$1358.Metal3 VSS.$372.Metal1 0.0252153f
Cred_6706 vout.$1358.Metal3 VSS.$379.Metal1 0.00127401f
Cred_6707 vout.$1358.Metal3 VSS.$396.Metal1 0.00381146f
Cred_6708 vout.$1358.Metal3 VSS.$40.Metal1 1.38307e-05f
Cred_6709 vout.$1358.Metal3 VSS.$409.Metal1 0.00753015f
Cred_6710 vout.$1358.Metal3 VSS.$551.Metal1 0.000444026f
Cred_6711 vout.$1358.Metal3 VSS.$818.Metal2 0.0124061f
Cred_6712 vout.$1358.Metal3 VSS.$826.Metal2 0.0124265f
Cred_6713 vout.$1358.Metal3 VSS.$840.Metal2 0.00265783f
Cred_6714 vout.$1358.Metal3 VSS.$852.Metal2 0.00191933f
Cred_6715 vout.$1358.Metal3 VSS.$867.Metal2 0.0571041f
Cred_6716 vout.$1358.Metal3 VSS.$875.Metal2 0.0172493f
Cred_6717 vout.$1358.Metal3 VSS.$881.Metal2 0.00212533f
Cred_6718 vout.$1358.Metal3 VSS.$893.Metal2 0.00747574f
Cred_6719 vout.$1358.Metal3 VSS.$905.Metal2 0.00249183f
Cred_6720 vout.$1358.Metal3 VSS.$914.Metal2 0.0651354f
Cred_6721 vout.$1358.Metal3 VSS.$928.Metal2 2.9674e-05f
Cred_6722 vout.$1358.Metal3 VSS.$934.Metal2 0.00360577f
Cred_6723 vout.$1358.Metal3 VSS.$946.Metal2 0.00091524f
Cred_6724 vout.$1358.Metal3 VSS.$952.Metal2 0.00645074f
Cred_6725 vout.$1358.Metal3 VSS.$961.Metal2 0.014681f
Cred_6726 vout.$1358.Metal3 VSS.P0.pSD 0.0175453f
Cred_6727 vout.$1358.Metal3 VSS.P11.nSD 0.000265139f
Cred_6728 vout.$1358.Metal3 VSS.P13.nSD 0.000799944f
Cred_6729 vout.$1358.Metal3 VSS.P15.nSD 0.000139048f
Cred_6730 vout.$1358.Metal3 VSS.P17.nSD 0.00025711f
Cred_6731 vout.$1424.Metal3 VSS.$1002.Metal2 0.0307202f
Cred_6732 vout.$1424.Metal3 VSS.$1010.Metal2 0.0228734f
Cred_6733 vout.$1424.Metal3 VSS.$1241.Metal3 0.000221663f
Cred_6734 vout.$1424.Metal3 VSS.$1250.Metal3 0.0040713f
Cred_6735 vout.$1424.Metal3 VSS.$1259.Metal3 0.00796675f
Cred_6736 vout.$1424.Metal3 VSS.$1271.Metal3 0.012949f
Cred_6737 vout.$1424.Metal3 VSS.$1283.Metal3 0.0125628f
Cred_6738 vout.$1424.Metal3 VSS.$1292.Metal3 0.000842123f
Cred_6739 vout.$1424.Metal3 VSS.$18.Metal1 8.33519e-06f
Cred_6740 vout.$1424.Metal3 VSS.$372.Metal1 0.00810174f
Cred_6741 vout.$1424.Metal3 VSS.$379.Metal1 0.00127401f
Cred_6742 vout.$1424.Metal3 VSS.$396.Metal1 0.00381146f
Cred_6743 vout.$1424.Metal3 VSS.$40.Metal1 3.23153e-06f
Cred_6744 vout.$1424.Metal3 VSS.$409.Metal1 0.0224032f
Cred_6745 vout.$1424.Metal3 VSS.$426.Metal1 0.00128949f
Cred_6746 vout.$1424.Metal3 VSS.$436.Metal1 0.00849572f
Cred_6747 vout.$1424.Metal3 VSS.$448.Metal1 0.00111023f
Cred_6748 vout.$1424.Metal3 VSS.$453.Metal1 0.0164666f
Cred_6749 vout.$1424.Metal3 VSS.$551.Metal1 0.00101708f
Cred_6750 vout.$1424.Metal3 VSS.$905.Metal2 0.000886752f
Cred_6751 vout.$1424.Metal3 VSS.$914.Metal2 0.0233079f
Cred_6752 vout.$1424.Metal3 VSS.$928.Metal2 2.9674e-05f
Cred_6753 vout.$1424.Metal3 VSS.$934.Metal2 0.00360577f
Cred_6754 vout.$1424.Metal3 VSS.$946.Metal2 0.000919402f
Cred_6755 vout.$1424.Metal3 VSS.$952.Metal2 0.0199601f
Cred_6756 vout.$1424.Metal3 VSS.$961.Metal2 0.0454758f
Cred_6757 vout.$1424.Metal3 VSS.$975.Metal2 0.00453363f
Cred_6758 vout.$1424.Metal3 VSS.$987.Metal2 0.00521759f
Cred_6759 vout.$1424.Metal3 VSS.P0.pSD 0.0130993f
Cred_6760 vout.$1424.Metal3 VSS.P15.nSD 4.45375e-05f
Cred_6761 vout.$1424.Metal3 VSS.P17.nSD 0.00076834f
Cred_6762 vout.$1424.Metal3 VSS.P19.nSD 0.000566046f
Cred_6763 vout.P0.nSD VSS.$1106.Metal3 4.56197e-05f
Cred_6764 vout.P0.nSD VSS.$1115.Metal3 0.000493588f
Cred_6765 vout.P0.nSD VSS.$1121.Metal3 0.000239325f
Cred_6766 vout.P0.nSD VSS.$1130.Metal3 0.000179453f
Cred_6767 vout.P0.nSD VSS.$1142.Metal3 0.000146123f
Cred_6768 vout.P0.nSD VSS.$115.Metal1 1.34735e-05f
Cred_6769 vout.P0.nSD VSS.$1154.Metal3 6.29978e-06f
Cred_6770 vout.P0.nSD VSS.$127.Metal1 0.000103103f
Cred_6771 vout.P0.nSD VSS.$137.Metal1 1.56491e-05f
Cred_6772 vout.P0.nSD VSS.$142.Metal1 0.00018561f
Cred_6773 vout.P0.nSD VSS.$18.Metal1 6.84293e-05f
Cred_6774 vout.P0.nSD VSS.$40.Metal1 0.00785082f
Cred_6775 vout.P0.nSD VSS.$551.Metal1 1.79487e-07f
Cred_6776 vout.P0.nSD VSS.$564.Metal2 0.00669665f
Cred_6777 vout.P0.nSD VSS.$605.Metal2 2.66139e-06f
Cred_6778 vout.P0.nSD VSS.$611.Metal2 0.00117928f
Cred_6779 vout.P0.nSD VSS.$623.Metal2 0.00194136f
Cred_6780 vout.P0.nSD VSS.$636.Metal2 0.00438621f
Cred_6781 vout.P0.nSD VSS.$644.Metal2 0.00588985f
Cred_6782 vout.P0.nSD VSS.$65.Metal1 0.000274567f
Cred_6783 vout.P0.nSD VSS.$658.Metal2 6.33199e-05f
Cred_6784 vout.P0.nSD VSS.$670.Metal2 5.50195e-05f
Cred_6785 vout.P0.nSD VSS.$685.Metal2 0.000420836f
Cred_6786 vout.P0.nSD VSS.$693.Metal2 0.000184612f
Cred_6787 vout.P0.nSD VSS.$699.Metal2 5.05102e-08f
Cred_6788 vout.P0.nSD VSS.$80.Metal1 0.00476631f
Cred_6789 vout.P0.nSD VSS.$92.Metal1 0.0010383f
Cred_6790 vout.P0.nSD VSS.$97.Metal1 0.0118024f
Cred_6791 vout.P0.nSD VSS.P0.GatPoly 4.696e-05f
Cred_6792 vout.P0.nSD VSS.P0.nSD 4.18236e-05f
Cred_6793 vout.P0.nSD VSS.P0.pSD 0.000432006f
Cred_6794 vout.P0.nSD VSS.P1.nSD 4.18236e-05f
Cred_6795 vout.P0.nSD VSS.P3.nSD 0.000405349f
Cred_6796 vout.P0.nSD VSS.P5.nSD 6.37964e-06f
Cred_6797 vout.P0.pSD VSS.$1106.Metal3 0.000137366f
Cred_6798 vout.P0.pSD VSS.$1115.Metal3 0.00146707f
Cred_6799 vout.P0.pSD VSS.$1121.Metal3 0.000984693f
Cred_6800 vout.P0.pSD VSS.$1130.Metal3 0.000953582f
Cred_6801 vout.P0.pSD VSS.$1142.Metal3 0.000776474f
Cred_6802 vout.P0.pSD VSS.$115.Metal1 7.15962e-05f
Cred_6803 vout.P0.pSD VSS.$1154.Metal3 3.3476e-05f
Cred_6804 vout.P0.pSD VSS.$127.Metal1 0.000547871f
Cred_6805 vout.P0.pSD VSS.$137.Metal1 8.31566e-05f
Cred_6806 vout.P0.pSD VSS.$142.Metal1 0.000986299f
Cred_6807 vout.P0.pSD VSS.$18.Metal1 0.000363622f
Cred_6808 vout.P0.pSD VSS.$40.Metal1 0.00152596f
Cred_6809 vout.P0.pSD VSS.$551.Metal1 9.53763e-07f
Cred_6810 vout.P0.pSD VSS.$564.Metal2 0.0053966f
Cred_6811 vout.P0.pSD VSS.$605.Metal2 1.43374e-06f
Cred_6812 vout.P0.pSD VSS.$611.Metal2 0.000441164f
Cred_6813 vout.P0.pSD VSS.$623.Metal2 0.000726072f
Cred_6814 vout.P0.pSD VSS.$636.Metal2 0.00396137f
Cred_6815 vout.P0.pSD VSS.$644.Metal2 0.00531849f
Cred_6816 vout.P0.pSD VSS.$65.Metal1 3.97533e-05f
Cred_6817 vout.P0.pSD VSS.$658.Metal2 0.000336472f
Cred_6818 vout.P0.pSD VSS.$670.Metal2 0.000292364f
Cred_6819 vout.P0.pSD VSS.$685.Metal2 0.00223626f
Cred_6820 vout.P0.pSD VSS.$693.Metal2 0.000980996f
Cred_6821 vout.P0.pSD VSS.$699.Metal2 2.68403e-07f
Cred_6822 vout.P0.pSD VSS.$80.Metal1 0.000955347f
Cred_6823 vout.P0.pSD VSS.$92.Metal1 0.000224183f
Cred_6824 vout.P0.pSD VSS.$97.Metal1 0.00304522f
Cred_6825 vout.P0.pSD VSS.P0.GatPoly 0.000147922f
Cred_6826 vout.P0.pSD VSS.P0.nSD 7.1032e-06f
Cred_6827 vout.P0.pSD VSS.P0.pSD 0.00227271f
Cred_6828 vout.P0.pSD VSS.P1.nSD 7.1032e-06f
Cred_6829 vout.P0.pSD VSS.P3.nSD 0.00010467f
Cred_6830 vout.P0.pSD VSS.P5.nSD 3.39003e-05f
Cred_6831 vout.P10.nSD VSS 5.78489e-05f
Cred_6832 vout.P10.nSD VSS.$1217.Metal3 0.000258057f
Cred_6833 vout.P10.nSD VSS.$1223.Metal3 7.08263e-05f
Cred_6834 vout.P10.nSD VSS.$1235.Metal3 3.53844e-06f
Cred_6835 vout.P10.nSD VSS.$18.Metal1 2.40691e-07f
Cred_6836 vout.P10.nSD VSS.$275.Metal1 0.00505407f
Cred_6837 vout.P10.nSD VSS.$285.Metal1 0.00505407f
Cred_6838 vout.P10.nSD VSS.$294.Metal1 0.000756691f
Cred_6839 vout.P10.nSD VSS.$304.Metal1 0.0047486f
Cred_6840 vout.P10.nSD VSS.$314.Metal1 0.000483714f
Cred_6841 vout.P10.nSD VSS.$319.Metal1 0.0106057f
Cred_6842 vout.P10.nSD VSS.$40.Metal1 9.33152e-08f
Cred_6843 vout.P10.nSD VSS.$551.Metal1 7.1927e-07f
Cred_6844 vout.P10.nSD VSS.$818.Metal2 0.00405608f
Cred_6845 vout.P10.nSD VSS.$826.Metal2 0.00405658f
Cred_6846 vout.P10.nSD VSS.$840.Metal2 0.00168508f
Cred_6847 vout.P10.nSD VSS.$852.Metal2 0.00122462f
Cred_6848 vout.P10.nSD VSS.$867.Metal2 0.0061508f
Cred_6849 vout.P10.nSD VSS.$875.Metal2 0.00185504f
Cred_6850 vout.P10.nSD VSS.$881.Metal2 2.83704e-08f
Cred_6851 vout.P10.nSD VSS.P0.pSD 7.03707e-05f
Cred_6852 vout.P10.nSD VSS.P11.nSD 0.000357674f
Cred_6853 vout.P10.nSD VSS.P13.nSD 0.000364238f
Cred_6854 vout.P10.pSD VSS 0.000216505f
Cred_6855 vout.P10.pSD VSS.$1217.Metal3 0.000597005f
Cred_6856 vout.P10.pSD VSS.$1223.Metal3 0.000266034f
Cred_6857 vout.P10.pSD VSS.$1235.Metal3 1.91644e-05f
Cred_6858 vout.P10.pSD VSS.$18.Metal1 1.3036e-06f
Cred_6859 vout.P10.pSD VSS.$275.Metal1 0.000319247f
Cred_6860 vout.P10.pSD VSS.$285.Metal1 0.000319247f
Cred_6861 vout.P10.pSD VSS.$294.Metal1 5.56913e-05f
Cred_6862 vout.P10.pSD VSS.$304.Metal1 0.000350923f
Cred_6863 vout.P10.pSD VSS.$314.Metal1 3.58065e-05f
Cred_6864 vout.P10.pSD VSS.$319.Metal1 0.000637738f
Cred_6865 vout.P10.pSD VSS.$40.Metal1 5.05402e-07f
Cred_6866 vout.P10.pSD VSS.$551.Metal1 3.89561e-06f
Cred_6867 vout.P10.pSD VSS.$818.Metal2 0.00105855f
Cred_6868 vout.P10.pSD VSS.$826.Metal2 0.00106029f
Cred_6869 vout.P10.pSD VSS.$840.Metal2 0.00022678f
Cred_6870 vout.P10.pSD VSS.$852.Metal2 0.000163767f
Cred_6871 vout.P10.pSD VSS.$867.Metal2 0.00138472f
Cred_6872 vout.P10.pSD VSS.$875.Metal2 0.000417781f
Cred_6873 vout.P10.pSD VSS.$881.Metal2 1.53656e-07f
Cred_6874 vout.P10.pSD VSS.P0.pSD 0.00035853f
Cred_6875 vout.P10.pSD VSS.P11.nSD 2.2623e-05f
Cred_6876 vout.P10.pSD VSS.P13.nSD 2.19196e-05f
Cred_6877 vout.P12.nSD VSS.$1235.Metal3 0.000116547f
Cred_6878 vout.P12.nSD VSS.$1241.Metal3 6.06927e-05f
Cred_6879 vout.P12.nSD VSS.$319.Metal1 0.0100188f
Cred_6880 vout.P12.nSD VSS.$344.Metal1 0.00426979f
Cred_6881 vout.P12.nSD VSS.$356.Metal1 0.00163283f
Cred_6882 vout.P12.nSD VSS.$372.Metal1 0.0114595f
Cred_6883 vout.P12.nSD VSS.$867.Metal2 0.005925f
Cred_6884 vout.P12.nSD VSS.$875.Metal2 0.0017869f
Cred_6885 vout.P12.nSD VSS.$881.Metal2 0.000623845f
Cred_6886 vout.P12.nSD VSS.$893.Metal2 0.00222004f
Cred_6887 vout.P12.nSD VSS.$905.Metal2 0.000256048f
Cred_6888 vout.P12.nSD VSS.$914.Metal2 0.00674259f
Cred_6889 vout.P12.nSD VSS.P0.pSD 3.83807e-06f
Cred_6890 vout.P12.nSD VSS.P13.nSD 0.000343431f
Cred_6891 vout.P12.nSD VSS.P15.nSD 6.29961e-05f
Cred_6892 vout.P14.nSD VSS.$1241.Metal3 3.49209e-06f
Cred_6893 vout.P14.nSD VSS.$1250.Metal3 0.000107941f
Cred_6894 vout.P14.nSD VSS.$1259.Metal3 0.000255207f
Cred_6895 vout.P14.nSD VSS.$1271.Metal3 1.43105e-05f
Cred_6896 vout.P14.nSD VSS.$18.Metal1 6.65292e-08f
Cred_6897 vout.P14.nSD VSS.$372.Metal1 0.0110044f
Cred_6898 vout.P14.nSD VSS.$379.Metal1 0.00143608f
Cred_6899 vout.P14.nSD VSS.$396.Metal1 0.00447194f
Cred_6900 vout.P14.nSD VSS.$40.Metal1 2.57932e-08f
Cred_6901 vout.P14.nSD VSS.$409.Metal1 0.0106935f
Cred_6902 vout.P14.nSD VSS.$551.Metal1 3.2884e-06f
Cred_6903 vout.P14.nSD VSS.$905.Metal2 0.000275155f
Cred_6904 vout.P14.nSD VSS.$914.Metal2 0.00724505f
Cred_6905 vout.P14.nSD VSS.$928.Metal2 1.26477e-05f
Cred_6906 vout.P14.nSD VSS.$934.Metal2 0.00230297f
Cred_6907 vout.P14.nSD VSS.$946.Metal2 0.000579095f
Cred_6908 vout.P14.nSD VSS.$952.Metal2 0.00244074f
Cred_6909 vout.P14.nSD VSS.$961.Metal2 0.00556334f
Cred_6910 vout.P14.nSD VSS.P0.pSD 8.10463e-05f
Cred_6911 vout.P14.nSD VSS.P15.nSD 6.00629e-05f
Cred_6912 vout.P14.nSD VSS.P17.nSD 0.00036432f
Cred_6913 vout.P14.pSD VSS.$1241.Metal3 1.89134e-05f
Cred_6914 vout.P14.pSD VSS.$1250.Metal3 0.000347384f
Cred_6915 vout.P14.pSD VSS.$1259.Metal3 0.000635471f
Cred_6916 vout.P14.pSD VSS.$1271.Metal3 7.75066e-05f
Cred_6917 vout.P14.pSD VSS.$18.Metal1 3.60327e-07f
Cred_6918 vout.P14.pSD VSS.$372.Metal1 0.000691282f
Cred_6919 vout.P14.pSD VSS.$379.Metal1 0.000108705f
Cred_6920 vout.P14.pSD VSS.$396.Metal1 0.000325213f
Cred_6921 vout.P14.pSD VSS.$40.Metal1 1.39698e-07f
Cred_6922 vout.P14.pSD VSS.$409.Metal1 0.000642511f
Cred_6923 vout.P14.pSD VSS.$551.Metal1 1.78102e-05f
Cred_6924 vout.P14.pSD VSS.$905.Metal2 7.56622e-05f
Cred_6925 vout.P14.pSD VSS.$914.Metal2 0.00198875f
Cred_6926 vout.P14.pSD VSS.$928.Metal2 2.53194e-06f
Cred_6927 vout.P14.pSD VSS.$934.Metal2 0.000307663f
Cred_6928 vout.P14.pSD VSS.$946.Metal2 7.8093e-05f
Cred_6929 vout.P14.pSD VSS.$952.Metal2 0.00055041f
Cred_6930 vout.P14.pSD VSS.$961.Metal2 0.00125265f
Cred_6931 vout.P14.pSD VSS.P0.pSD 0.000391385f
Cred_6932 vout.P14.pSD VSS.P15.nSD 3.80016e-06f
Cred_6933 vout.P14.pSD VSS.P17.nSD 2.1938e-05f
Cred_6934 vout.P16.nSD VSS.$1002.Metal2 0.00448151f
Cred_6935 vout.P16.nSD VSS.$1010.Metal2 0.00333729f
Cred_6936 vout.P16.nSD VSS.$1271.Metal3 9.05797e-05f
Cred_6937 vout.P16.nSD VSS.$1283.Metal3 9.5102e-05f
Cred_6938 vout.P16.nSD VSS.$409.Metal1 0.00980522f
Cred_6939 vout.P16.nSD VSS.$426.Metal1 0.000656678f
Cred_6940 vout.P16.nSD VSS.$436.Metal1 0.00466558f
Cred_6941 vout.P16.nSD VSS.$448.Metal1 0.000731436f
Cred_6942 vout.P16.nSD VSS.$453.Metal1 0.0105042f
Cred_6943 vout.P16.nSD VSS.$952.Metal2 0.00232141f
Cred_6944 vout.P16.nSD VSS.$961.Metal2 0.00529281f
Cred_6945 vout.P16.nSD VSS.$975.Metal2 0.00131867f
Cred_6946 vout.P16.nSD VSS.$987.Metal2 0.00152183f
Cred_6947 vout.P16.nSD VSS.P0.pSD 4.10999e-06f
Cred_6948 vout.P16.nSD VSS.P17.nSD 0.000336751f
Cred_6949 vout.P16.nSD VSS.P19.nSD 0.000360749f
Cred_6950 vout.P18.nSD VSS.$1002.Metal2 0.00490365f
Cred_6951 vout.P18.nSD VSS.$1010.Metal2 0.00365179f
Cred_6952 vout.P18.nSD VSS.$1022.Metal2 0.00180472f
Cred_6953 vout.P18.nSD VSS.$1034.Metal2 0.00109626f
Cred_6954 vout.P18.nSD VSS.$1040.Metal2 2.39158e-06f
Cred_6955 vout.P18.nSD VSS.$1066.Metal2 0.0056951f
Cred_6956 vout.P18.nSD VSS.$1283.Metal3 1.35496e-05f
Cred_6957 vout.P18.nSD VSS.$1292.Metal3 0.000119189f
Cred_6958 vout.P18.nSD VSS.$1298.Metal3 0.000217502f
Cred_6959 vout.P18.nSD VSS.$1307.Metal3 1.97691e-05f
Cred_6960 vout.P18.nSD VSS.$453.Metal1 0.0105451f
Cred_6961 vout.P18.nSD VSS.$471.Metal1 0.000996114f
Cred_6962 vout.P18.nSD VSS.$483.Metal1 0.00458653f
Cred_6963 vout.P18.nSD VSS.$498.Metal1 0.000267086f
Cred_6964 vout.P18.nSD VSS.$509.Metal1 0.00756447f
Cred_6965 vout.P18.nSD VSS.P0.pSD 4.30889e-06f
Cred_6966 vout.P18.nSD VSS.P1.GatPoly 1.91229e-05f
Cred_6967 vout.P18.nSD VSS.P19.nSD 0.000362161f
Cred_6968 vout.P18.nSD VSS.P21.nSD 4.04904e-05f
Cred_6969 vout.P18.nSD VSS.P23.nSD 4.04904e-05f
Cred_6970 vout.P2.nSD VSS.$1106.Metal3 1.36768e-05f
Cred_6971 vout.P2.nSD VSS.$1115.Metal3 0.000146069f
Cred_6972 vout.P2.nSD VSS.$1121.Metal3 9.80408e-05f
Cred_6973 vout.P2.nSD VSS.$1130.Metal3 0.000263772f
Cred_6974 vout.P2.nSD VSS.$1142.Metal3 0.000249543f
Cred_6975 vout.P2.nSD VSS.$115.Metal1 0.000746093f
Cred_6976 vout.P2.nSD VSS.$1154.Metal3 6.85334e-06f
Cred_6977 vout.P2.nSD VSS.$127.Metal1 0.00477774f
Cred_6978 vout.P2.nSD VSS.$137.Metal1 0.000673702f
Cred_6979 vout.P2.nSD VSS.$142.Metal1 0.0100071f
Cred_6980 vout.P2.nSD VSS.$18.Metal1 3.92642e-05f
Cred_6981 vout.P2.nSD VSS.$40.Metal1 0.000153118f
Cred_6982 vout.P2.nSD VSS.$551.Metal1 1.32216e-07f
Cred_6983 vout.P2.nSD VSS.$564.Metal2 0.000537311f
Cred_6984 vout.P2.nSD VSS.$605.Metal2 1.4275e-07f
Cred_6985 vout.P2.nSD VSS.$611.Metal2 4.39244e-05f
Cred_6986 vout.P2.nSD VSS.$623.Metal2 7.22912e-05f
Cred_6987 vout.P2.nSD VSS.$636.Metal2 0.00383799f
Cred_6988 vout.P2.nSD VSS.$644.Metal2 0.00515376f
Cred_6989 vout.P2.nSD VSS.$65.Metal1 3.95803e-06f
Cred_6990 vout.P2.nSD VSS.$658.Metal2 0.00159072f
Cred_6991 vout.P2.nSD VSS.$670.Metal2 0.00137853f
Cred_6992 vout.P2.nSD VSS.$685.Metal2 0.00575062f
Cred_6993 vout.P2.nSD VSS.$693.Metal2 0.00252224f
Cred_6994 vout.P2.nSD VSS.$699.Metal2 5.49486e-08f
Cred_6995 vout.P2.nSD VSS.$80.Metal1 9.5119e-05f
Cred_6996 vout.P2.nSD VSS.$92.Metal1 2.23207e-05f
Cred_6997 vout.P2.nSD VSS.$97.Metal1 0.0102239f
Cred_6998 vout.P2.nSD VSS.P0.GatPoly 1.47278e-05f
Cred_6999 vout.P2.nSD VSS.P0.nSD 7.07229e-07f
Cred_7000 vout.P2.nSD VSS.P0.pSD 0.000280901f
Cred_7001 vout.P2.nSD VSS.P1.nSD 7.07229e-07f
Cred_7002 vout.P2.nSD VSS.P3.nSD 0.000351144f
Cred_7003 vout.P2.nSD VSS.P5.nSD 0.000343691f
Cred_7004 vout.P2.pSD VSS.$1106.Metal3 7.47468e-05f
Cred_7005 vout.P2.pSD VSS.$1115.Metal3 0.000798301f
Cred_7006 vout.P2.pSD VSS.$1121.Metal3 0.000535816f
Cred_7007 vout.P2.pSD VSS.$1130.Metal3 0.000921822f
Cred_7008 vout.P2.pSD VSS.$1142.Metal3 0.000868769f
Cred_7009 vout.P2.pSD VSS.$115.Metal1 8.01064e-05f
Cred_7010 vout.P2.pSD VSS.$1154.Metal3 3.74551e-05f
Cred_7011 vout.P2.pSD VSS.$127.Metal1 0.000612994f
Cred_7012 vout.P2.pSD VSS.$137.Metal1 9.3041e-05f
Cred_7013 vout.P2.pSD VSS.$142.Metal1 0.00110353f
Cred_7014 vout.P2.pSD VSS.$18.Metal1 0.000214588f
Cred_7015 vout.P2.pSD VSS.$40.Metal1 0.000836828f
Cred_7016 vout.P2.pSD VSS.$551.Metal1 7.22589e-07f
Cred_7017 vout.P2.pSD VSS.$564.Metal2 0.00293653f
Cred_7018 vout.P2.pSD VSS.$605.Metal2 7.80163e-07f
Cred_7019 vout.P2.pSD VSS.$611.Metal2 0.000240057f
Cred_7020 vout.P2.pSD VSS.$623.Metal2 0.000395088f
Cred_7021 vout.P2.pSD VSS.$636.Metal2 0.00286806f
Cred_7022 vout.P2.pSD VSS.$644.Metal2 0.00385082f
Cred_7023 vout.P2.pSD VSS.$65.Metal1 2.16316e-05f
Cred_7024 vout.P2.pSD VSS.$658.Metal2 0.000376466f
Cred_7025 vout.P2.pSD VSS.$670.Metal2 0.000327116f
Cred_7026 vout.P2.pSD VSS.$685.Metal2 0.00250207f
Cred_7027 vout.P2.pSD VSS.$693.Metal2 0.0010976f
Cred_7028 vout.P2.pSD VSS.$699.Metal2 3.00306e-07f
Cred_7029 vout.P2.pSD VSS.$80.Metal1 0.000519847f
Cred_7030 vout.P2.pSD VSS.$92.Metal1 0.000121988f
Cred_7031 vout.P2.pSD VSS.$97.Metal1 0.00221229f
Cred_7032 vout.P2.pSD VSS.P0.GatPoly 8.0491e-05f
Cred_7033 vout.P2.pSD VSS.P0.nSD 3.86517e-06f
Cred_7034 vout.P2.pSD VSS.P0.pSD 0.00151273f
Cred_7035 vout.P2.pSD VSS.P1.nSD 3.86517e-06f
Cred_7036 vout.P2.pSD VSS.P3.nSD 7.60453e-05f
Cred_7037 vout.P2.pSD VSS.P5.nSD 3.79299e-05f
Cred_7038 vout.P4.nSD VSS.$1154.Metal3 0.000137876f
Cred_7039 vout.P4.nSD VSS.$1163.Metal3 4.38017e-05f
Cred_7040 vout.P4.nSD VSS.$142.Metal1 0.0107272f
Cred_7041 vout.P4.nSD VSS.$167.Metal1 0.0044119f
Cred_7042 vout.P4.nSD VSS.$184.Metal1 0.00141601f
Cred_7043 vout.P4.nSD VSS.$195.Metal1 0.0114595f
Cred_7044 vout.P4.nSD VSS.$685.Metal2 0.00544458f
Cred_7045 vout.P4.nSD VSS.$693.Metal2 0.00238847f
Cred_7046 vout.P4.nSD VSS.$699.Metal2 0.000564676f
Cred_7047 vout.P4.nSD VSS.$711.Metal2 0.00224617f
Cred_7048 vout.P4.nSD VSS.$717.Metal2 1.21802e-05f
Cred_7049 vout.P4.nSD VSS.$732.Metal2 0.00674259f
Cred_7050 vout.P4.nSD VSS.$740.Metal2 0.000256048f
Cred_7051 vout.P4.nSD VSS.P0.pSD 8.78263e-06f
Cred_7052 vout.P4.nSD VSS.P5.nSD 0.000365061f
Cred_7053 vout.P4.nSD VSS.P7.nSD 6.29961e-05f
Cred_7054 vout.P6.nSD VSS.$1163.Metal3 1.25593e-05f
Cred_7055 vout.P6.nSD VSS.$1172.Metal3 0.000131f
Cred_7056 vout.P6.nSD VSS.$1178.Metal3 0.000214159f
Cred_7057 vout.P6.nSD VSS.$1190.Metal3 1.39515e-05f
Cred_7058 vout.P6.nSD VSS.$18.Metal1 9.57444e-07f
Cred_7059 vout.P6.nSD VSS.$195.Metal1 0.0110755f
Cred_7060 vout.P6.nSD VSS.$207.Metal1 0.00165533f
Cred_7061 vout.P6.nSD VSS.$219.Metal1 0.00432886f
Cred_7062 vout.P6.nSD VSS.$232.Metal1 0.0106057f
Cred_7063 vout.P6.nSD VSS.$40.Metal1 3.71198e-07f
Cred_7064 vout.P6.nSD VSS.$551.Metal1 1.79973e-07f
Cred_7065 vout.P6.nSD VSS.$732.Metal2 0.00718682f
Cred_7066 vout.P6.nSD VSS.$740.Metal2 0.000273042f
Cred_7067 vout.P6.nSD VSS.$752.Metal2 0.00227607f
Cred_7068 vout.P6.nSD VSS.$764.Metal2 0.000639761f
Cred_7069 vout.P6.nSD VSS.$770.Metal2 0.00185517f
Cred_7070 vout.P6.nSD VSS.$779.Metal2 0.00615073f
Cred_7071 vout.P6.nSD VSS.P0.pSD 6.95506e-05f
Cred_7072 vout.P6.nSD VSS.P10.nSD 0.000364237f
Cred_7073 vout.P6.nSD VSS.P7.nSD 6.02365e-05f
Cred_7074 vout.P6.pSD VSS.$1163.Metal3 6.86395e-05f
Cred_7075 vout.P6.pSD VSS.$1172.Metal3 0.000384247f
Cred_7076 vout.P6.pSD VSS.$1178.Metal3 0.000533469f
Cred_7077 vout.P6.pSD VSS.$1190.Metal3 7.62482e-05f
Cred_7078 vout.P6.pSD VSS.$18.Metal1 5.23265e-06f
Cred_7079 vout.P6.pSD VSS.$195.Metal1 0.00070575f
Cred_7080 vout.P6.pSD VSS.$207.Metal1 0.000122962f
Cred_7081 vout.P6.pSD VSS.$219.Metal1 0.000322849f
Cred_7082 vout.P6.pSD VSS.$232.Metal1 0.00064329f
Cred_7083 vout.P6.pSD VSS.$40.Metal1 2.02868e-06f
Cred_7084 vout.P6.pSD VSS.$551.Metal1 9.83591e-07f
Cred_7085 vout.P6.pSD VSS.$732.Metal2 0.00206155f
Cred_7086 vout.P6.pSD VSS.$740.Metal2 7.89704e-05f
Cred_7087 vout.P6.pSD VSS.$752.Metal2 0.000306234f
Cred_7088 vout.P6.pSD VSS.$764.Metal2 8.69874e-05f
Cred_7089 vout.P6.pSD VSS.$770.Metal2 0.000422334f
Cred_7090 vout.P6.pSD VSS.$779.Metal2 0.00139691f
Cred_7091 vout.P6.pSD VSS.P0.pSD 0.000359134f
Cred_7092 vout.P6.pSD VSS.P10.nSD 2.21104e-05f
Cred_7093 vout.P6.pSD VSS.P7.nSD 3.86871e-06f
Cred_7094 vout.P8.nSD VSS 1.78743e-05f
Cred_7095 vout.P8.nSD VSS.$1190.Metal3 2.17069e-05f
Cred_7096 vout.P8.nSD VSS.$1196.Metal3 0.000147829f
Cred_7097 vout.P8.nSD VSS.$232.Metal1 0.0100181f
Cred_7098 vout.P8.nSD VSS.$247.Metal1 0.000477103f
Cred_7099 vout.P8.nSD VSS.$259.Metal1 0.00468381f
Cred_7100 vout.P8.nSD VSS.$269.Metal1 0.000746409f
Cred_7101 vout.P8.nSD VSS.$275.Metal1 0.00522926f
Cred_7102 vout.P8.nSD VSS.$285.Metal1 0.00522926f
Cred_7103 vout.P8.nSD VSS.$770.Metal2 0.00178495f
Cred_7104 vout.P8.nSD VSS.$779.Metal2 0.00591852f
Cred_7105 vout.P8.nSD VSS.$793.Metal2 0.00119438f
Cred_7106 vout.P8.nSD VSS.$805.Metal2 0.0016432f
Cred_7107 vout.P8.nSD VSS.$818.Metal2 0.00384614f
Cred_7108 vout.P8.nSD VSS.$826.Metal2 0.00384596f
Cred_7109 vout.P8.nSD VSS.P0.pSD 4.17331e-06f
Cred_7110 vout.P8.nSD VSS.P10.nSD 0.000343409f
Cred_7111 vout.P8.nSD VSS.P11.nSD 0.000370743f
Rred_1 VDD VDD.$1460.Metal2 4.58578406504
Rred_2 VDD VDD.$1480.Metal2 2.62954381678
Rred_3 VDD VDD.$1492.Metal2 5.30657744993
Rred_4 VDD VDD.$1986.Metal3 0.0367677975703
Rred_5 VDD VDD.$2001.Metal3 0.0849247081608
Rred_6 VDD VDD.$561.Metal1 1326.34549516
Rred_7 VDD.$100.Metal1 VDD.$1056.Metal2 4.54656835116
Rred_8 VDD.$100.Metal1 VDD.$1075.Metal2 4.89436627892
Rred_9 VDD.$100.Metal1 VDD.$141.Metal1 0.020632954956
Rred_10 VDD.$100.Metal1 VDD.$7.Metal1 0.0701908834403
Rred_11 VDD.$100.Metal1 VDD.P0.GatPoly 28.31
Rred_12 VDD.$100.Metal1 VDD.P0.nSD 2.73195937241
Rred_13 VDD.$1000.Metal1 VDD.$1001.Metal1 0.0158290758923
Rred_14 VDD.$1000.Metal1 VDD.$1806.Metal2 10.41608585
Rred_15 VDD.$1000.Metal1 VDD.$1808.Metal2 5.4068653571
Rred_16 VDD.$1000.Metal1 VDD.$943.Metal1 0.0159137912113
Rred_17 VDD.$1000.Metal1 VDD.P21.pSD 17
Rred_18 VDD.$1000.Metal1 VDD.P23.pSD 17
Rred_19 VDD.$1001.Metal1 VDD.$1002.Metal1 0.0157412444284
Rred_20 VDD.$1001.Metal1 VDD.$1808.Metal2 3.80618631613
Rred_21 VDD.$1001.Metal1 VDD.$1810.Metal2 53.5184929349
Rred_22 VDD.$1001.Metal1 VDD.P21.pSD 17
Rred_23 VDD.$1001.Metal1 VDD.P23.pSD 17
Rred_24 VDD.$1002.Metal1 VDD.$1003.Metal1 0.0159085107792
Rred_25 VDD.$1002.Metal1 VDD.$136.Metal1 263709.937499
Rred_26 VDD.$1002.Metal1 VDD.$137.Metal1 235351.598981
Rred_27 VDD.$1002.Metal1 VDD.$1808.Metal2 6.77889319703
Rred_28 VDD.$1002.Metal1 VDD.$1810.Metal2 6.77889319703
Rred_29 VDD.$1002.Metal1 VDD.P0.nSD 3.86907391766
Rred_30 VDD.$1002.Metal1 VDD.P21.pSD 17
Rred_31 VDD.$1002.Metal1 VDD.P23.pSD 17
Rred_32 VDD.$1003.Metal1 VDD.$1004.Metal1 0.0155789539273
Rred_33 VDD.$1003.Metal1 VDD.$136.Metal1 235351.598981
Rred_34 VDD.$1003.Metal1 VDD.$137.Metal1 210042.805622
Rred_35 VDD.$1003.Metal1 VDD.$1810.Metal2 3.08767233209
Rred_36 VDD.$1003.Metal1 VDD.P0.nSD 2.94741596689
Rred_37 VDD.$1003.Metal1 VDD.P21.pSD 17
Rred_38 VDD.$1003.Metal1 VDD.P23.pSD 17
Rred_39 VDD.$1004.Metal1 VDD.$1005.Metal1 0.0155109179578
Rred_40 VDD.$1004.Metal1 VDD.$1810.Metal2 106.269817812
Rred_41 VDD.$1004.Metal1 VDD.$1811.Metal2 3.67726508026
Rred_42 VDD.$1004.Metal1 VDD.P0.nSD 16.3172794515
Rred_43 VDD.$1004.Metal1 VDD.P21.pSD 17
Rred_44 VDD.$1004.Metal1 VDD.P23.pSD 17
Rred_45 VDD.$1005.Metal1 VDD.$1006.Metal1 0.0154395488782
Rred_46 VDD.$1005.Metal1 VDD.$1811.Metal2 5.84932063523
Rred_47 VDD.$1005.Metal1 VDD.$1813.Metal2 9.10301865078
Rred_48 VDD.$1005.Metal1 VDD.P0.nSD 16.3143246567
Rred_49 VDD.$1005.Metal1 VDD.P21.pSD 17
Rred_50 VDD.$1005.Metal1 VDD.P23.pSD 17
Rred_51 VDD.$1006.Metal1 VDD.$1007.Metal1 0.0155816060967
Rred_52 VDD.$1006.Metal1 VDD.$1811.Metal2 17.7818416624
Rred_53 VDD.$1006.Metal1 VDD.$1813.Metal2 4.40334562796
Rred_54 VDD.$1006.Metal1 VDD.P0.nSD 15.883911465
Rred_55 VDD.$1006.Metal1 VDD.P21.pSD 17
Rred_56 VDD.$1006.Metal1 VDD.P23.pSD 17
Rred_57 VDD.$1007.Metal1 VDD.$1813.Metal2 6.17167416666
Rred_58 VDD.$1007.Metal1 VDD.$954.Metal1 0.020632954956
Rred_59 VDD.$1007.Metal1 VDD.P0.nSD 12.9598007829
Rred_60 VDD.$1007.Metal1 VDD.P21.pSD 17
Rred_61 VDD.$1007.Metal1 VDD.P23.pSD 17
Rred_62 VDD.$1056.Metal2 VDD.$1075.Metal2 0.0578379960744
Rred_63 VDD.$1056.Metal2 VDD.$1110.Metal2 0.103798884402
Rred_64 VDD.$1056.Metal2 VDD.$1884.Metal3 1.02173185202
Rred_65 VDD.$1056.Metal2 VDD.$7.Metal1 1.40821085669
Rred_66 VDD.$1056.Metal2 VDD.$95.Metal1 4.99307079321
Rred_67 VDD.$1056.Metal2 VDD.P0.nSD 1091.26144766
Rred_68 VDD.$1065.Metal2 VDD.$1068.Metal2 0.0411706648738
Rred_69 VDD.$1065.Metal2 VDD.$130.Metal1 0.700228681675
Rred_70 VDD.$1065.Metal2 VDD.$131.Metal1 9.31990773858
Rred_71 VDD.$1065.Metal2 VDD.$132.Metal1 32.1191993917
Rred_72 VDD.$1065.Metal2 VDD.P0.pSD 81.5609832592
Rred_73 VDD.$1065.Metal2 VDD.P1.pSD 81.5609832592
Rred_74 VDD.$1068.Metal2 VDD.$1070.Metal2 0.0273436075727
Rred_75 VDD.$1068.Metal2 VDD.$130.Metal1 10.3785482619
Rred_76 VDD.$1068.Metal2 VDD.$131.Metal1 5.78843856548
Rred_77 VDD.$1068.Metal2 VDD.$132.Metal1 3.97201546971
Rred_78 VDD.$1068.Metal2 VDD.$133.Metal1 4.68143389538
Rred_79 VDD.$1068.Metal2 VDD.$134.Metal1 10.41608585
Rred_80 VDD.$1070.Metal2 VDD.$1072.Metal2 0.0273436551723
Rred_81 VDD.$1070.Metal2 VDD.$133.Metal1 14.2716146512
Rred_82 VDD.$1070.Metal2 VDD.$134.Metal1 5.4068653571
Rred_83 VDD.$1070.Metal2 VDD.$135.Metal1 3.80618631613
Rred_84 VDD.$1070.Metal2 VDD.$136.Metal1 6.77889319703
Rred_85 VDD.$1072.Metal2 VDD.$1074.Metal2 0.0273436396529
Rred_86 VDD.$1072.Metal2 VDD.$135.Metal1 53.5184929349
Rred_87 VDD.$1072.Metal2 VDD.$136.Metal1 6.77889319703
Rred_88 VDD.$1072.Metal2 VDD.$137.Metal1 3.08767233209
Rred_89 VDD.$1072.Metal2 VDD.$138.Metal1 6.89310803174
Rred_90 VDD.$1072.Metal2 VDD.$139.Metal1 32.8041725716
Rred_91 VDD.$1072.Metal2 VDD.P0.nSD 47062.5487072
Rred_92 VDD.$1074.Metal2 VDD.$1075.Metal2 0.013640831758
Rred_93 VDD.$1074.Metal2 VDD.$138.Metal1 7.37123754963
Rred_94 VDD.$1074.Metal2 VDD.$139.Metal1 3.98898736996
Rred_95 VDD.$1074.Metal2 VDD.$140.Metal1 8.8707765581
Rred_96 VDD.$1074.Metal2 VDD.P0.nSD 35631.5035777
Rred_97 VDD.$1075.Metal2 VDD.$140.Metal1 5.85264550961
Rred_98 VDD.$1075.Metal2 VDD.$141.Metal1 6.17167416666
Rred_99 VDD.$1075.Metal2 VDD.P0.nSD 118137.610072
Rred_100 VDD.$1110.Metal2 VDD.$1137.Metal2 0.0510644296849
Rred_101 VDD.$1110.Metal2 VDD.$142.Metal1 2.95436589276
Rred_102 VDD.$1110.Metal2 VDD.$1884.Metal3 1.6088056551
Rred_103 VDD.$1110.Metal2 VDD.$1896.Metal3 6.28908610428
Rred_104 VDD.$1110.Metal2 VDD.$7.Metal1 6.95262064139
Rred_105 VDD.$1110.Metal2 VDD.$95.Metal1 3.25361662596
Rred_106 VDD.$1110.Metal2 VDD.P0.nSD 19850.6262899
Rred_107 VDD.$1137.Metal2 VDD.$1149.Metal2 0.0484923752296
Rred_108 VDD.$1137.Metal2 VDD.$142.Metal1 2.94790913599
Rred_109 VDD.$1137.Metal2 VDD.$152.Metal1 3.01904338824
Rred_110 VDD.$1137.Metal2 VDD.$1884.Metal3 5.9864931645
Rred_111 VDD.$1137.Metal2 VDD.$1896.Metal3 2.00648138157
Rred_112 VDD.$1137.Metal2 VDD.P0.nSD 3492.71336707
Rred_113 VDD.$1149.Metal2 VDD.$1161.Metal2 0.0484923752296
Rred_114 VDD.$1149.Metal2 VDD.$152.Metal1 3.01968780352
Rred_115 VDD.$1149.Metal2 VDD.$164.Metal1 3.01955296281
Rred_116 VDD.$1149.Metal2 VDD.$1896.Metal3 3.01802801866
Rred_117 VDD.$1149.Metal2 VDD.$1902.Metal3 3.01802801866
Rred_118 VDD.$1149.Metal2 VDD.P0.nSD 3388.78527683
Rred_119 VDD.$1161.Metal2 VDD.$1167.Metal2 0.0240522173681
Rred_120 VDD.$1161.Metal2 VDD.$1188.Metal2 1526.81857051
Rred_121 VDD.$1161.Metal2 VDD.$164.Metal1 2.71938063724
Rred_122 VDD.$1161.Metal2 VDD.$177.Metal1 7.80034714992
Rred_123 VDD.$1161.Metal2 VDD.$1902.Metal3 2.42113023107
Rred_124 VDD.$1161.Metal2 VDD.$1914.Metal3 12.2416920053
Rred_125 VDD.$1161.Metal2 VDD.P0.nSD 2274.81996338
Rred_126 VDD.$1167.Metal2 VDD.$1188.Metal2 0.0241973575823
Rred_127 VDD.$1167.Metal2 VDD.$164.Metal1 13.6104867163
Rred_128 VDD.$1167.Metal2 VDD.$177.Metal1 1.74523594052
Rred_129 VDD.$1167.Metal2 VDD.$1902.Metal3 6.09640618761
Rred_130 VDD.$1167.Metal2 VDD.$1914.Metal3 6.09640618761
Rred_131 VDD.$1167.Metal2 VDD.P0.nSD 3241.87394578
Rred_132 VDD.$1167.Metal2 VDD.P3.pSD 8.42198716888
Rred_133 VDD.$1188.Metal2 VDD.$1214.Metal2 0.0484923752296
Rred_134 VDD.$1188.Metal2 VDD.$177.Metal1 1.52354430552
Rred_135 VDD.$1188.Metal2 VDD.$1902.Metal3 12.2416920053
Rred_136 VDD.$1188.Metal2 VDD.$1914.Metal3 2.42113023107
Rred_137 VDD.$1188.Metal2 VDD.$230.Metal1 3.7770714324
Rred_138 VDD.$1188.Metal2 VDD.P0.nSD 9485.44026575
Rred_139 VDD.$1188.Metal2 VDD.P3.pSD 6.27169257258
Rred_140 VDD.$1214.Metal2 VDD.$1220.Metal2 0.024052572452
Rred_141 VDD.$1214.Metal2 VDD.$1226.Metal2 1526.81857051
Rred_142 VDD.$1214.Metal2 VDD.$1914.Metal3 2.42113023107
Rred_143 VDD.$1214.Metal2 VDD.$1926.Metal3 12.2416920053
Rred_144 VDD.$1214.Metal2 VDD.$230.Metal1 6.04810666667
Rred_145 VDD.$1214.Metal2 VDD.$237.Metal1 3
Rred_146 VDD.$1220.Metal2 VDD.$1226.Metal2 0.0240520425809
Rred_147 VDD.$1220.Metal2 VDD.$1914.Metal3 6.09640618761
Rred_148 VDD.$1220.Metal2 VDD.$1926.Metal3 6.09640618761
Rred_149 VDD.$1220.Metal2 VDD.$237.Metal1 4.53761745544
Rred_150 VDD.$1220.Metal2 VDD.$252.Metal1 9.12184303317
Rred_151 VDD.$1220.Metal2 VDD.P0.nSD 1756.19669454
Rred_152 VDD.$1226.Metal2 VDD.$1253.Metal2 0.0484923752296
Rred_153 VDD.$1226.Metal2 VDD.$1914.Metal3 12.2416920053
Rred_154 VDD.$1226.Metal2 VDD.$1926.Metal3 2.42113023107
Rred_155 VDD.$1226.Metal2 VDD.$237.Metal1 9.12094760358
Rred_156 VDD.$1226.Metal2 VDD.$252.Metal1 2.59262065558
Rred_157 VDD.$1226.Metal2 VDD.P0.nSD 1756.1767188
Rred_158 VDD.$1253.Metal2 VDD.$1273.Metal2 0.0241782477821
Rred_159 VDD.$1253.Metal2 VDD.$1926.Metal3 2.59007321156
Rred_160 VDD.$1253.Metal2 VDD.$1935.Metal3 9.09640618761
Rred_161 VDD.$1253.Metal2 VDD.$252.Metal1 4.11465861119
Rred_162 VDD.$1253.Metal2 VDD.$257.Metal1 1.3008069774
Rred_163 VDD.$1253.Metal2 VDD.P0.nSD 8945.64126452
Rred_164 VDD.$1253.Metal2 VDD.P5.pSD 5.16725721254
Rred_165 VDD.$1273.Metal2 VDD.$1285.Metal2 0.0484923752296
Rred_166 VDD.$1273.Metal2 VDD.$1926.Metal3 9.09640618761
Rred_167 VDD.$1273.Metal2 VDD.$1935.Metal3 2.59007321156
Rred_168 VDD.$1273.Metal2 VDD.$257.Metal1 2.37397431591
Rred_169 VDD.$1273.Metal2 VDD.$315.Metal1 3.31720723679
Rred_170 VDD.$1273.Metal2 VDD.P0.nSD 4397.77171266
Rred_171 VDD.$1273.Metal2 VDD.P5.pSD 11.7813464446
Rred_172 VDD.$1285.Metal2 VDD.$1297.Metal2 0.048486239739
Rred_173 VDD.$1285.Metal2 VDD.$1935.Metal3 2.02265962076
Rred_174 VDD.$1285.Metal2 VDD.$1947.Metal3 6.13284832082
Rred_175 VDD.$1285.Metal2 VDD.$315.Metal1 3.01958494445
Rred_176 VDD.$1285.Metal2 VDD.$325.Metal1 3.01948047742
Rred_177 VDD.$1285.Metal2 VDD.P0.nSD 3494.79852872
Rred_178 VDD.$1297.Metal2 VDD.$1324.Metal2 0.0484923752296
Rred_179 VDD.$1297.Metal2 VDD.$1935.Metal3 6.13284832082
Rred_180 VDD.$1297.Metal2 VDD.$1947.Metal3 2.02265962076
Rred_181 VDD.$1297.Metal2 VDD.$325.Metal1 3.019631914
Rred_182 VDD.$1297.Metal2 VDD.$337.Metal1 3.01967577385
Rred_183 VDD.$1297.Metal2 VDD.P0.nSD 3195.13122738
Rred_184 VDD.$130.Metal1 VDD.$131.Metal1 0.0161506228679
Rred_185 VDD.$130.Metal1 VDD.$132.Metal1 8096.80052639
Rred_186 VDD.$130.Metal1 VDD.P0.pSD 2.98631324733
Rred_187 VDD.$130.Metal1 VDD.P1.pSD 2.98631324733
Rred_188 VDD.$131.Metal1 VDD.$132.Metal1 0.0160753900045
Rred_189 VDD.$131.Metal1 VDD.P0.pSD 17
Rred_190 VDD.$131.Metal1 VDD.P1.pSD 17
Rred_191 VDD.$132.Metal1 VDD.$133.Metal1 0.0162217048716
Rred_192 VDD.$132.Metal1 VDD.P0.pSD 17
Rred_193 VDD.$132.Metal1 VDD.P1.pSD 17
Rred_194 VDD.$1324.Metal2 VDD.$1344.Metal2 0.0240755530593
Rred_195 VDD.$1324.Metal2 VDD.$1350.Metal2 1526.81857051
Rred_196 VDD.$1324.Metal2 VDD.$1947.Metal3 2.42113023107
Rred_197 VDD.$1324.Metal2 VDD.$1959.Metal3 12.2416920053
Rred_198 VDD.$1324.Metal2 VDD.$337.Metal1 3.12941777057
Rred_199 VDD.$1324.Metal2 VDD.$376.Metal1 1.10227134052
Rred_200 VDD.$1324.Metal2 VDD.$393.Metal1 6.52275239628
Rred_201 VDD.$1324.Metal2 VDD.P0.nSD 3766.67576338
Rred_202 VDD.$1324.Metal2 VDD.P7.pSD 4.95634054678
Rred_203 VDD.$133.Metal1 VDD.$134.Metal1 0.0159137912113
Rred_204 VDD.$133.Metal1 VDD.P0.pSD 17
Rred_205 VDD.$133.Metal1 VDD.P1.pSD 17
Rred_206 VDD.$134.Metal1 VDD.$135.Metal1 0.0158290758923
Rred_207 VDD.$134.Metal1 VDD.P0.pSD 17
Rred_208 VDD.$134.Metal1 VDD.P1.pSD 17
Rred_209 VDD.$1344.Metal2 VDD.$1350.Metal2 0.024052572452
Rred_210 VDD.$1344.Metal2 VDD.$1947.Metal3 6.09640618761
Rred_211 VDD.$1344.Metal2 VDD.$1959.Metal3 6.09640618761
Rred_212 VDD.$1344.Metal2 VDD.$376.Metal1 29.8240991355
Rred_213 VDD.$1344.Metal2 VDD.$393.Metal1 3
Rred_214 VDD.$1344.Metal2 VDD.P7.pSD 130.516967732
Rred_215 VDD.$135.Metal1 VDD.$136.Metal1 0.0157412444284
Rred_216 VDD.$135.Metal1 VDD.P0.pSD 17
Rred_217 VDD.$135.Metal1 VDD.P1.pSD 17
Rred_218 VDD.$1350.Metal2 VDD.$1362.Metal2 0.0484923752296
Rred_219 VDD.$1350.Metal2 VDD.$1947.Metal3 12.2416920053
Rred_220 VDD.$1350.Metal2 VDD.$1959.Metal3 2.42113023107
Rred_221 VDD.$1350.Metal2 VDD.$393.Metal1 6.03055400695
Rred_222 VDD.$1350.Metal2 VDD.$403.Metal1 3.01950107943
Rred_223 VDD.$1350.Metal2 VDD.P0.nSD 3494.73334028
Rred_224 VDD.$136.Metal1 VDD.$137.Metal1 0.0159085107792
Rred_225 VDD.$136.Metal1 VDD.P0.nSD 3.86907391766
Rred_226 VDD.$136.Metal1 VDD.P0.pSD 17
Rred_227 VDD.$136.Metal1 VDD.P1.pSD 17
Rred_228 VDD.$1362.Metal2 VDD.$1374.Metal2 0.0484923752296
Rred_229 VDD.$1362.Metal2 VDD.$1959.Metal3 3.01802801866
Rred_230 VDD.$1362.Metal2 VDD.$1965.Metal3 3.01802801866
Rred_231 VDD.$1362.Metal2 VDD.$403.Metal1 3.01955296281
Rred_232 VDD.$1362.Metal2 VDD.$415.Metal1 3.01968780352
Rred_233 VDD.$1362.Metal2 VDD.P0.nSD 3388.78527683
Rred_234 VDD.$137.Metal1 VDD.$138.Metal1 0.0155789539273
Rred_235 VDD.$137.Metal1 VDD.P0.nSD 2.94741596689
Rred_236 VDD.$137.Metal1 VDD.P0.pSD 17
Rred_237 VDD.$137.Metal1 VDD.P1.pSD 17
Rred_238 VDD.$1374.Metal2 VDD.$1395.Metal2 0.0241581798806
Rred_239 VDD.$1374.Metal2 VDD.$1965.Metal3 2.59007321156
Rred_240 VDD.$1374.Metal2 VDD.$1974.Metal3 9.09640618761
Rred_241 VDD.$1374.Metal2 VDD.$415.Metal1 3.23060192662
Rred_242 VDD.$1374.Metal2 VDD.$423.Metal1 2.78445224755
Rred_243 VDD.$1374.Metal2 VDD.P0.nSD 4421.73574461
Rred_244 VDD.$1374.Metal2 VDD.P10.pSD 15.4889049215
Rred_245 VDD.$138.Metal1 VDD.$139.Metal1 0.0155108907521
Rred_246 VDD.$138.Metal1 VDD.P0.nSD 16.3172656581
Rred_247 VDD.$138.Metal1 VDD.P0.pSD 17
Rred_248 VDD.$138.Metal1 VDD.P1.pSD 17
Rred_249 VDD.$139.Metal1 VDD.$140.Metal1 0.0154395891466
Rred_250 VDD.$139.Metal1 VDD.P0.nSD 16.3143271817
Rred_251 VDD.$139.Metal1 VDD.P0.pSD 17
Rred_252 VDD.$139.Metal1 VDD.P1.pSD 17
Rred_253 VDD.$1395.Metal2 VDD.$1421.Metal2 0.0484923752296
Rred_254 VDD.$1395.Metal2 VDD.$1965.Metal3 9.09640618761
Rred_255 VDD.$1395.Metal2 VDD.$1974.Metal3 2.59007321156
Rred_256 VDD.$1395.Metal2 VDD.$423.Metal1 1.19247785605
Rred_257 VDD.$1395.Metal2 VDD.$476.Metal1 4.38743601401
Rred_258 VDD.$1395.Metal2 VDD.P0.nSD 13268.7698479
Rred_259 VDD.$1395.Metal2 VDD.P10.pSD 4.67125703981
Rred_260 VDD.$140.Metal1 VDD.$141.Metal1 0.0155816060967
Rred_261 VDD.$140.Metal1 VDD.P0.nSD 15.8839141938
Rred_262 VDD.$140.Metal1 VDD.P0.pSD 17
Rred_263 VDD.$140.Metal1 VDD.P1.pSD 17
Rred_264 VDD.$141.Metal1 VDD.P0.nSD 12.9598007829
Rred_265 VDD.$141.Metal1 VDD.P0.pSD 17
Rred_266 VDD.$141.Metal1 VDD.P1.pSD 17
Rred_267 VDD.$142.Metal1 VDD.$152.Metal1 0.0504002983711
Rred_268 VDD.$142.Metal1 VDD.$1884.Metal3 1460.18884818
Rred_269 VDD.$142.Metal1 VDD.$1896.Metal3 1460.18884818
Rred_270 VDD.$142.Metal1 VDD.$95.Metal1 0.0614259096926
Rred_271 VDD.$142.Metal1 VDD.P0.nSD 9.15239107815
Rred_272 VDD.$1421.Metal2 VDD.$1427.Metal2 0.024052572452
Rred_273 VDD.$1421.Metal2 VDD.$1433.Metal2 1526.81857051
Rred_274 VDD.$1421.Metal2 VDD.$1974.Metal3 2.42113023107
Rred_275 VDD.$1421.Metal2 VDD.$1986.Metal3 12.2416920053
Rred_276 VDD.$1421.Metal2 VDD.$476.Metal1 6.04810666667
Rred_277 VDD.$1421.Metal2 VDD.$483.Metal1 3
Rred_278 VDD.$1427.Metal2 VDD.$1433.Metal2 0.0240520425735
Rred_279 VDD.$1427.Metal2 VDD.$1974.Metal3 6.09640618761
Rred_280 VDD.$1427.Metal2 VDD.$1986.Metal3 6.09640618761
Rred_281 VDD.$1427.Metal2 VDD.$483.Metal1 4.53772966289
Rred_282 VDD.$1427.Metal2 VDD.$498.Metal1 9.12139662265
Rred_283 VDD.$1427.Metal2 VDD.P0.nSD 1756.19407983
Rred_284 VDD.$1433.Metal2 VDD.$1460.Metal2 0.0484923752296
Rred_285 VDD.$1433.Metal2 VDD.$1974.Metal3 12.2416920053
Rred_286 VDD.$1433.Metal2 VDD.$1986.Metal3 2.42113023107
Rred_287 VDD.$1433.Metal2 VDD.$483.Metal1 9.12139662265
Rred_288 VDD.$1433.Metal2 VDD.$498.Metal1 2.59258429578
Rred_289 VDD.$1433.Metal2 VDD.P0.nSD 1756.19407983
Rred_290 VDD.$1460.Metal2 VDD.$1480.Metal2 0.0242007999596
Rred_291 VDD.$1460.Metal2 VDD.$1986.Metal3 3.57535799304
Rred_292 VDD.$1460.Metal2 VDD.$498.Metal1 6.04810666667
Rred_293 VDD.$1460.Metal2 VDD.$518.Metal1 1.93591900068
Rred_294 VDD.$1460.Metal2 VDD.$554.Metal1 5.45800273264
Rred_295 VDD.$1460.Metal2 VDD.P11.pSD 7.131239507
Rred_296 VDD.$1480.Metal2 VDD.$1492.Metal2 0.0484880785653
Rred_297 VDD.$1480.Metal2 VDD.$2001.Metal3 8.75783120169
Rred_298 VDD.$1480.Metal2 VDD.$518.Metal1 5.45800273264
Rred_299 VDD.$1480.Metal2 VDD.$554.Metal1 1.93591900068
Rred_300 VDD.$1480.Metal2 VDD.$561.Metal1 6.04783924259
Rred_301 VDD.$1480.Metal2 VDD.P11.pSD 7.131239507
Rred_302 VDD.$1492.Metal2 VDD.$1504.Metal2 0.0484923752296
Rred_303 VDD.$1492.Metal2 VDD.$2001.Metal3 2.12684133089
Rred_304 VDD.$1492.Metal2 VDD.$561.Metal1 3.01946672466
Rred_305 VDD.$1492.Metal2 VDD.$571.Metal1 3.01961271281
Rred_306 VDD.$1492.Metal2 VDD.P0.nSD 3494.78766436
Rred_307 VDD.$1504.Metal2 VDD.$1531.Metal2 0.0484923752296
Rred_308 VDD.$1504.Metal2 VDD.$2001.Metal3 3.01802801866
Rred_309 VDD.$1504.Metal2 VDD.$2007.Metal3 3.01802801866
Rred_310 VDD.$1504.Metal2 VDD.$571.Metal1 3.01967731838
Rred_311 VDD.$1504.Metal2 VDD.$581.Metal1 3.01950933626
Rred_312 VDD.$1504.Metal2 VDD.P0.nSD 3458.67092853
Rred_313 VDD.$152.Metal1 VDD.$164.Metal1 0.0503784994019
Rred_314 VDD.$152.Metal1 VDD.$1896.Metal3 754.337028826
Rred_315 VDD.$152.Metal1 VDD.P0.nSD 7.22369241746
Rred_316 VDD.$1531.Metal2 VDD.$1551.Metal2 0.0241579267437
Rred_317 VDD.$1531.Metal2 VDD.$1557.Metal2 1526.81857051
Rred_318 VDD.$1531.Metal2 VDD.$2007.Metal3 2.42113023107
Rred_319 VDD.$1531.Metal2 VDD.$2019.Metal3 12.2416920053
Rred_320 VDD.$1531.Metal2 VDD.$581.Metal1 4.38743601401
Rred_321 VDD.$1531.Metal2 VDD.$586.Metal1 1.19247785605
Rred_322 VDD.$1531.Metal2 VDD.P0.nSD 13268.7698479
Rred_323 VDD.$1531.Metal2 VDD.P13.pSD 4.67125703981
Rred_324 VDD.$1551.Metal2 VDD.$1557.Metal2 0.0240521306384
Rred_325 VDD.$1551.Metal2 VDD.$2007.Metal3 6.09640618761
Rred_326 VDD.$1551.Metal2 VDD.$2019.Metal3 6.09640618761
Rred_327 VDD.$1551.Metal2 VDD.$586.Metal1 2.43540349047
Rred_328 VDD.$1551.Metal2 VDD.$649.Metal1 10.9394227231
Rred_329 VDD.$1551.Metal2 VDD.P0.nSD 2242.65392533
Rred_330 VDD.$1551.Metal2 VDD.P13.pSD 15.4889049215
Rred_331 VDD.$1557.Metal2 VDD.$1569.Metal2 0.0484923752296
Rred_332 VDD.$1557.Metal2 VDD.$2007.Metal3 12.2416920053
Rred_333 VDD.$1557.Metal2 VDD.$2019.Metal3 2.42113023107
Rred_334 VDD.$1557.Metal2 VDD.$586.Metal1 8.40441758816
Rred_335 VDD.$1557.Metal2 VDD.$649.Metal1 2.65496903055
Rred_336 VDD.$1557.Metal2 VDD.P0.nSD 1968.63194526
Rred_337 VDD.$1569.Metal2 VDD.$1581.Metal2 0.0484923752296
Rred_338 VDD.$1569.Metal2 VDD.$2019.Metal3 3.01802801866
Rred_339 VDD.$1569.Metal2 VDD.$2025.Metal3 3.01802801866
Rred_340 VDD.$1569.Metal2 VDD.$649.Metal1 3.01971402219
Rred_341 VDD.$1569.Metal2 VDD.$661.Metal1 3.01974283614
Rred_342 VDD.$1569.Metal2 VDD.P0.nSD 3135.41320954
Rred_343 VDD.$1581.Metal2 VDD.$1602.Metal2 0.0240758044728
Rred_344 VDD.$1581.Metal2 VDD.$2025.Metal3 2.59007321156
Rred_345 VDD.$1581.Metal2 VDD.$2034.Metal3 9.09640618761
Rred_346 VDD.$1581.Metal2 VDD.$661.Metal1 3.01973069398
Rred_347 VDD.$1581.Metal2 VDD.$702.Metal1 28.9684182142
Rred_348 VDD.$1581.Metal2 VDD.$703.Metal1 6.06585827909
Rred_349 VDD.$1581.Metal2 VDD.P0.nSD 3495.47081898
Rred_350 VDD.$1581.Metal2 VDD.P15.pSD 130.516967732
Rred_351 VDD.$1602.Metal2 VDD.$1628.Metal2 0.0484923752296
Rred_352 VDD.$1602.Metal2 VDD.$2025.Metal3 9.09640618761
Rred_353 VDD.$1602.Metal2 VDD.$2034.Metal3 2.59007321156
Rred_354 VDD.$1602.Metal2 VDD.$702.Metal1 1.13256072667
Rred_355 VDD.$1602.Metal2 VDD.$703.Metal1 3
Rred_356 VDD.$1602.Metal2 VDD.$722.Metal1 6.04810666667
Rred_357 VDD.$1602.Metal2 VDD.P15.pSD 4.95634054678
Rred_358 VDD.$1628.Metal2 VDD.$1640.Metal2 0.048486239739
Rred_359 VDD.$1628.Metal2 VDD.$2034.Metal3 2.02265962076
Rred_360 VDD.$1628.Metal2 VDD.$2046.Metal3 6.13284832082
Rred_361 VDD.$1628.Metal2 VDD.$722.Metal1 3.01967577385
Rred_362 VDD.$1628.Metal2 VDD.$734.Metal1 3.019631914
Rred_363 VDD.$1628.Metal2 VDD.P0.nSD 3195.13122738
Rred_364 VDD.$164.Metal1 VDD.$177.Metal1 0.0651631230407
Rred_365 VDD.$164.Metal1 VDD.$1902.Metal3 754.337028826
Rred_366 VDD.$164.Metal1 VDD.P0.nSD 6.07179088948
Rred_367 VDD.$1640.Metal2 VDD.$1652.Metal2 0.0484923752296
Rred_368 VDD.$1640.Metal2 VDD.$2034.Metal3 6.13284832082
Rred_369 VDD.$1640.Metal2 VDD.$2046.Metal3 2.02265962076
Rred_370 VDD.$1640.Metal2 VDD.$734.Metal1 3.01948047742
Rred_371 VDD.$1640.Metal2 VDD.$744.Metal1 3.01958494445
Rred_372 VDD.$1640.Metal2 VDD.P0.nSD 3494.79852872
Rred_373 VDD.$1652.Metal2 VDD.$1673.Metal2 0.0241782477821
Rred_374 VDD.$1652.Metal2 VDD.$2046.Metal3 2.59007321156
Rred_375 VDD.$1652.Metal2 VDD.$2055.Metal3 9.09640618761
Rred_376 VDD.$1652.Metal2 VDD.$744.Metal1 3.31720723679
Rred_377 VDD.$1652.Metal2 VDD.$754.Metal1 2.37397431591
Rred_378 VDD.$1652.Metal2 VDD.P0.nSD 4397.77171266
Rred_379 VDD.$1652.Metal2 VDD.P17.pSD 11.7813464446
Rred_380 VDD.$1673.Metal2 VDD.$1699.Metal2 0.0484923752296
Rred_381 VDD.$1673.Metal2 VDD.$2046.Metal3 9.09640618761
Rred_382 VDD.$1673.Metal2 VDD.$2055.Metal3 2.59007321156
Rred_383 VDD.$1673.Metal2 VDD.$754.Metal1 1.3008069774
Rred_384 VDD.$1673.Metal2 VDD.$807.Metal1 4.11465861119
Rred_385 VDD.$1673.Metal2 VDD.P0.nSD 8945.64126452
Rred_386 VDD.$1673.Metal2 VDD.P17.pSD 5.16725721254
Rred_387 VDD.$1699.Metal2 VDD.$1711.Metal2 0.048486239739
Rred_388 VDD.$1699.Metal2 VDD.$2055.Metal3 2.02265962076
Rred_389 VDD.$1699.Metal2 VDD.$2067.Metal3 6.13284832082
Rred_390 VDD.$1699.Metal2 VDD.$807.Metal1 3.01958494445
Rred_391 VDD.$1699.Metal2 VDD.$817.Metal1 3.01948047742
Rred_392 VDD.$1699.Metal2 VDD.P0.nSD 3494.79852872
Rred_393 VDD.$1711.Metal2 VDD.$1738.Metal2 0.0484923752296
Rred_394 VDD.$1711.Metal2 VDD.$2055.Metal3 6.13284832082
Rred_395 VDD.$1711.Metal2 VDD.$2067.Metal3 2.02265962076
Rred_396 VDD.$1711.Metal2 VDD.$817.Metal1 3.019631914
Rred_397 VDD.$1711.Metal2 VDD.$829.Metal1 3.01967577385
Rred_398 VDD.$1711.Metal2 VDD.P0.nSD 3195.13122738
Rred_399 VDD.$1738.Metal2 VDD.$1758.Metal2 0.0241976115462
Rred_400 VDD.$1738.Metal2 VDD.$2067.Metal3 2.59007321156
Rred_401 VDD.$1738.Metal2 VDD.$2076.Metal3 9.09640618761
Rred_402 VDD.$1738.Metal2 VDD.$829.Metal1 3.7770714324
Rred_403 VDD.$1738.Metal2 VDD.$834.Metal1 1.52354430552
Rred_404 VDD.$1738.Metal2 VDD.P0.nSD 9485.44026575
Rred_405 VDD.$1738.Metal2 VDD.P19.pSD 6.27169257258
Rred_406 VDD.$1758.Metal2 VDD.$1770.Metal2 0.0484923752296
Rred_407 VDD.$1758.Metal2 VDD.$2067.Metal3 9.09640618761
Rred_408 VDD.$1758.Metal2 VDD.$2076.Metal3 2.59007321156
Rred_409 VDD.$1758.Metal2 VDD.$834.Metal1 1.89952029576
Rred_410 VDD.$1758.Metal2 VDD.$890.Metal1 3.49223384788
Rred_411 VDD.$1758.Metal2 VDD.P0.nSD 6716.86096755
Rred_412 VDD.$1758.Metal2 VDD.P19.pSD 8.42198716888
Rred_413 VDD.$177.Metal1 VDD.$230.Metal1 0.0358581386467
Rred_414 VDD.$177.Metal1 VDD.P0.nSD 7.12742262762
Rred_415 VDD.$177.Metal1 VDD.P3.pSD 1.98810169492
Rred_416 VDD.$1770.Metal2 VDD.$1782.Metal2 0.0484923752296
Rred_417 VDD.$1770.Metal2 VDD.$2076.Metal3 3.01802801866
Rred_418 VDD.$1770.Metal2 VDD.$2082.Metal3 3.01802801866
Rred_419 VDD.$1770.Metal2 VDD.$890.Metal1 3.01974283614
Rred_420 VDD.$1770.Metal2 VDD.$902.Metal1 3.01971402219
Rred_421 VDD.$1770.Metal2 VDD.P0.nSD 3135.41320954
Rred_422 VDD.$1782.Metal2 VDD.$1788.Metal2 0.0240522932358
Rred_423 VDD.$1782.Metal2 VDD.$2082.Metal3 2.59007321156
Rred_424 VDD.$1782.Metal2 VDD.$2091.Metal3 9.09640618761
Rred_425 VDD.$1782.Metal2 VDD.$902.Metal1 2.59239467043
Rred_426 VDD.$1782.Metal2 VDD.$917.Metal1 9.1238147974
Rred_427 VDD.$1782.Metal2 VDD.P0.nSD 1755.63484102
Rred_428 VDD.$1788.Metal2 VDD.$1815.Metal2 0.051071228228
Rred_429 VDD.$1788.Metal2 VDD.$2082.Metal3 9.09640618761
Rred_430 VDD.$1788.Metal2 VDD.$2091.Metal3 2.53685126265
Rred_431 VDD.$1788.Metal2 VDD.$902.Metal1 9.11679557973
Rred_432 VDD.$1788.Metal2 VDD.$917.Metal1 2.53962814341
Rred_433 VDD.$1788.Metal2 VDD.P0.nSD 1755.06325379
Rred_434 VDD.$1803.Metal2 VDD.$1806.Metal2 0.0411706648738
Rred_435 VDD.$1803.Metal2 VDD.$940.Metal1 0.700228681675
Rred_436 VDD.$1803.Metal2 VDD.$941.Metal1 9.31990773858
Rred_437 VDD.$1803.Metal2 VDD.$942.Metal1 32.1191993917
Rred_438 VDD.$1803.Metal2 VDD.P21.pSD 81.5609832592
Rred_439 VDD.$1803.Metal2 VDD.P23.pSD 81.5609832592
Rred_440 VDD.$1806.Metal2 VDD.$1808.Metal2 0.0273436075727
Rred_441 VDD.$1806.Metal2 VDD.$940.Metal1 10.3785482619
Rred_442 VDD.$1806.Metal2 VDD.$941.Metal1 5.78843856548
Rred_443 VDD.$1806.Metal2 VDD.$942.Metal1 3.97201546971
Rred_444 VDD.$1806.Metal2 VDD.$943.Metal1 4.68143389538
Rred_445 VDD.$1808.Metal2 VDD.$1810.Metal2 0.0273436551723
Rred_446 VDD.$1808.Metal2 VDD.$943.Metal1 14.2716146512
Rred_447 VDD.$1810.Metal2 VDD.$1811.Metal2 0.013640831758
Rred_448 VDD.$1810.Metal2 VDD.P0.nSD 137312.430939
Rred_449 VDD.$1811.Metal2 VDD.$1813.Metal2 0.0273436162973
Rred_450 VDD.$1811.Metal2 VDD.P0.nSD 28548.1906899
Rred_451 VDD.$1813.Metal2 VDD.$1822.Metal2 0.0578379960744
Rred_452 VDD.$1813.Metal2 VDD.$954.Metal1 4.89436627892
Rred_453 VDD.$1813.Metal2 VDD.P0.nSD 64522.6638625
Rred_454 VDD.$1815.Metal2 VDD.$1822.Metal2 0.103454691708
Rred_455 VDD.$1815.Metal2 VDD.$2091.Metal3 1.32412392349
Rred_456 VDD.$1815.Metal2 VDD.$917.Metal1 2.95445918098
Rred_457 VDD.$1815.Metal2 VDD.$920.Metal1 6.93995614192
Rred_458 VDD.$1815.Metal2 VDD.$965.Metal1 3.25556270379
Rred_459 VDD.$1815.Metal2 VDD.P0.nSD 19850.6262899
Rred_460 VDD.$1822.Metal2 VDD.$2091.Metal3 1.09323611361
Rred_461 VDD.$1822.Metal2 VDD.$920.Metal1 1.40667812102
Rred_462 VDD.$1822.Metal2 VDD.$954.Metal1 4.54656835116
Rred_463 VDD.$1822.Metal2 VDD.$965.Metal1 4.99622054031
Rred_464 VDD.$1822.Metal2 VDD.P0.nSD 1091.26144766
Rred_465 VDD.$1884.Metal3 VDD.$1896.Metal3 0.0981479196261
Rred_466 VDD.$1884.Metal3 VDD.$7.Metal1 115.265153614
Rred_467 VDD.$1884.Metal3 VDD.$95.Metal1 402.66920167
Rred_468 VDD.$1896.Metal3 VDD.$1902.Metal3 0.0482995209481
Rred_469 VDD.$1902.Metal3 VDD.$1914.Metal3 0.0981511661222
Rred_470 VDD.$1914.Metal3 VDD.$1926.Metal3 0.0981511661222
Rred_471 VDD.$1914.Metal3 VDD.$230.Metal1 754.337028826
Rred_472 VDD.$1926.Metal3 VDD.$1935.Metal3 0.0729329633886
Rred_473 VDD.$1926.Metal3 VDD.$252.Metal1 754.337028826
Rred_474 VDD.$1935.Metal3 VDD.$1947.Metal3 0.0981480735474
Rred_475 VDD.$1935.Metal3 VDD.$315.Metal1 754.337028826
Rred_476 VDD.$1935.Metal3 VDD.$325.Metal1 1532.86667717
Rred_477 VDD.$1947.Metal3 VDD.$1959.Metal3 0.0981511661222
Rred_478 VDD.$1947.Metal3 VDD.$325.Metal1 1532.86667717
Rred_479 VDD.$1947.Metal3 VDD.$337.Metal1 754.337028826
Rred_480 VDD.$1959.Metal3 VDD.$1965.Metal3 0.0482995209481
Rred_481 VDD.$1959.Metal3 VDD.$403.Metal1 754.337028826
Rred_482 VDD.$1965.Metal3 VDD.$1974.Metal3 0.0729329633886
Rred_483 VDD.$1965.Metal3 VDD.$415.Metal1 754.337028826
Rred_484 VDD.$1974.Metal3 VDD.$1986.Metal3 0.0981511661222
Rred_485 VDD.$1974.Metal3 VDD.$476.Metal1 754.337028826
Rred_486 VDD.$1986.Metal3 VDD.$498.Metal1 754.337028826
Rred_487 VDD.$2001.Metal3 VDD.$2007.Metal3 0.0482995209481
Rred_488 VDD.$2001.Metal3 VDD.$561.Metal1 1800.24588827
Rred_489 VDD.$2001.Metal3 VDD.$571.Metal1 754.337028826
Rred_490 VDD.$2007.Metal3 VDD.$2019.Metal3 0.0981511661222
Rred_491 VDD.$2007.Metal3 VDD.$581.Metal1 754.337028826
Rred_492 VDD.$2019.Metal3 VDD.$2025.Metal3 0.0482995209481
Rred_493 VDD.$2019.Metal3 VDD.$649.Metal1 754.337028826
Rred_494 VDD.$2025.Metal3 VDD.$2034.Metal3 0.0729329633886
Rred_495 VDD.$2025.Metal3 VDD.$661.Metal1 754.337028826
Rred_496 VDD.$2034.Metal3 VDD.$2046.Metal3 0.0981480735474
Rred_497 VDD.$2034.Metal3 VDD.$722.Metal1 754.337028826
Rred_498 VDD.$2034.Metal3 VDD.$734.Metal1 1532.86667717
Rred_499 VDD.$2046.Metal3 VDD.$2055.Metal3 0.0729329633886
Rred_500 VDD.$2046.Metal3 VDD.$734.Metal1 1532.86667717
Rred_501 VDD.$2046.Metal3 VDD.$744.Metal1 754.337028826
Rred_502 VDD.$2055.Metal3 VDD.$2067.Metal3 0.0981480735474
Rred_503 VDD.$2055.Metal3 VDD.$807.Metal1 754.337028826
Rred_504 VDD.$2055.Metal3 VDD.$817.Metal1 1532.86667717
Rred_505 VDD.$2067.Metal3 VDD.$2076.Metal3 0.0729329633886
Rred_506 VDD.$2067.Metal3 VDD.$817.Metal1 1532.86667717
Rred_507 VDD.$2067.Metal3 VDD.$829.Metal1 754.337028826
Rred_508 VDD.$2076.Metal3 VDD.$2082.Metal3 0.0482995209481
Rred_509 VDD.$2076.Metal3 VDD.$890.Metal1 754.337028826
Rred_510 VDD.$2082.Metal3 VDD.$2091.Metal3 0.0729329633886
Rred_511 VDD.$2082.Metal3 VDD.$902.Metal1 754.337028826
Rred_512 VDD.$2091.Metal3 VDD.$917.Metal1 718.572763736
Rred_513 VDD.$2091.Metal3 VDD.$920.Metal1 123.255348348
Rred_514 VDD.$2091.Metal3 VDD.$965.Metal1 432.239412419
Rred_515 VDD.$230.Metal1 VDD.$237.Metal1 0.0250612785337
Rred_516 VDD.$230.Metal1 VDD.P0.nSD 11.7565131047
Rred_517 VDD.$237.Metal1 VDD.$252.Metal1 0.0762042704388
Rred_518 VDD.$237.Metal1 VDD.P0.nSD 6.96994651771
Rred_519 VDD.$252.Metal1 VDD.$257.Metal1 0.0327769863206
Rred_520 VDD.$252.Metal1 VDD.P0.nSD 6.64980889266
Rred_521 VDD.$257.Metal1 VDD.$315.Metal1 0.0426557962487
Rred_522 VDD.$257.Metal1 VDD.P0.nSD 9.36743965424
Rred_523 VDD.$257.Metal1 VDD.P5.pSD 1.98874159732
Rred_524 VDD.$315.Metal1 VDD.$325.Metal1 0.0503816845649
Rred_525 VDD.$315.Metal1 VDD.P0.nSD 7.67389633993
Rred_526 VDD.$325.Metal1 VDD.$337.Metal1 0.0503800743211
Rred_527 VDD.$325.Metal1 VDD.P0.nSD 7.11445842696
Rred_528 VDD.$337.Metal1 VDD.$376.Metal1 0.344327320702
Rred_529 VDD.$337.Metal1 VDD.$393.Metal1 0.0544932656316
Rred_530 VDD.$337.Metal1 VDD.P0.nSD 7.0579789329
Rred_531 VDD.$376.Metal1 VDD.$393.Metal1 0.319936894383
Rred_532 VDD.$376.Metal1 VDD.P0.nSD 193.857361467
Rred_533 VDD.$376.Metal1 VDD.P7.pSD 1.61395011284
Rred_534 VDD.$393.Metal1 VDD.$403.Metal1 0.0503784928037
Rred_535 VDD.$393.Metal1 VDD.P0.nSD 7.42506595209
Rred_536 VDD.$403.Metal1 VDD.$415.Metal1 0.0503784994019
Rred_537 VDD.$403.Metal1 VDD.P0.nSD 6.83399526978
Rred_538 VDD.$415.Metal1 VDD.$423.Metal1 0.0445112576733
Rred_539 VDD.$415.Metal1 VDD.P0.nSD 7.62000951606
Rred_540 VDD.$423.Metal1 VDD.$476.Metal1 0.0309221197347
Rred_541 VDD.$423.Metal1 VDD.P0.nSD 9.87658715042
Rred_542 VDD.$423.Metal1 VDD.P10.pSD 1.98940628725
Rred_543 VDD.$476.Metal1 VDD.$483.Metal1 0.0250609268302
Rred_544 VDD.$476.Metal1 VDD.P0.nSD 11.4667619152
Rred_545 VDD.$483.Metal1 VDD.$498.Metal1 0.0762053502085
Rred_546 VDD.$483.Metal1 VDD.P0.nSD 7.26091818225
Rred_547 VDD.$498.Metal1 VDD.$518.Metal1 0.0250609268302
Rred_548 VDD.$498.Metal1 VDD.P0.nSD 7.26091818225
Rred_549 VDD.$518.Metal1 VDD.$554.Metal1 0.0252504167418
Rred_550 VDD.$518.Metal1 VDD.P0.nSD 14.8304595603
Rred_551 VDD.$518.Metal1 VDD.P11.pSD 4.00691620324
Rred_552 VDD.$554.Metal1 VDD.$561.Metal1 0.0250609268302
Rred_553 VDD.$554.Metal1 VDD.P0.nSD 14.8304595603
Rred_554 VDD.$554.Metal1 VDD.P11.pSD 4.00691620324
Rred_555 VDD.$561.Metal1 VDD.$571.Metal1 0.0503811526048
Rred_556 VDD.$561.Metal1 VDD.P0.nSD 9.6323051046
Rred_557 VDD.$571.Metal1 VDD.$581.Metal1 0.0503777081793
Rred_558 VDD.$571.Metal1 VDD.P0.nSD 7.26225858493
Rred_559 VDD.$581.Metal1 VDD.$586.Metal1 0.0309221197347
Rred_560 VDD.$581.Metal1 VDD.P0.nSD 8.20885719669
Rred_561 VDD.$586.Metal1 VDD.$649.Metal1 0.0702143752481
Rred_562 VDD.$586.Metal1 VDD.P0.nSD 7.38084443077
Rred_563 VDD.$586.Metal1 VDD.P13.pSD 1.98940628725
Rred_564 VDD.$649.Metal1 VDD.$661.Metal1 0.0503803330447
Rred_565 VDD.$649.Metal1 VDD.P0.nSD 5.88287853378
Rred_566 VDD.$661.Metal1 VDD.$702.Metal1 8.43555236267
Rred_567 VDD.$661.Metal1 VDD.$703.Metal1 0.0506787060549
Rred_568 VDD.$661.Metal1 VDD.P0.nSD 7.07873954542
Rred_569 VDD.$7.Metal1 VDD.$95.Metal1 0.0485921561394
Rred_570 VDD.$7.Metal1 VDD.P0.nSD 7.08029400794
Rred_571 VDD.$702.Metal1 VDD.$703.Metal1 0.156357770183
Rred_572 VDD.$702.Metal1 VDD.P0.nSD 2754.70704801
Rred_573 VDD.$702.Metal1 VDD.P15.pSD 1.61395011284
Rred_574 VDD.$703.Metal1 VDD.$722.Metal1 0.0250630082153
Rred_575 VDD.$703.Metal1 VDD.P0.nSD 9.7336773516
Rred_576 VDD.$722.Metal1 VDD.$734.Metal1 0.0503800743211
Rred_577 VDD.$722.Metal1 VDD.P0.nSD 9.09873559648
Rred_578 VDD.$734.Metal1 VDD.$744.Metal1 0.0503816845649
Rred_579 VDD.$734.Metal1 VDD.P0.nSD 7.11445842696
Rred_580 VDD.$744.Metal1 VDD.$754.Metal1 0.0426557962487
Rred_581 VDD.$744.Metal1 VDD.P0.nSD 7.67389633993
Rred_582 VDD.$754.Metal1 VDD.$807.Metal1 0.0327769863206
Rred_583 VDD.$754.Metal1 VDD.P0.nSD 9.36743965424
Rred_584 VDD.$754.Metal1 VDD.P17.pSD 1.98874159732
Rred_585 VDD.$807.Metal1 VDD.$817.Metal1 0.0503816845649
Rred_586 VDD.$807.Metal1 VDD.P0.nSD 8.58558123775
Rred_587 VDD.$817.Metal1 VDD.$829.Metal1 0.0503800743211
Rred_588 VDD.$817.Metal1 VDD.P0.nSD 7.11445842696
Rred_589 VDD.$829.Metal1 VDD.$834.Metal1 0.0358581386467
Rred_590 VDD.$829.Metal1 VDD.P0.nSD 8.1616300373
Rred_591 VDD.$834.Metal1 VDD.$890.Metal1 0.0395650532209
Rred_592 VDD.$834.Metal1 VDD.P0.nSD 9.3483204091
Rred_593 VDD.$834.Metal1 VDD.P19.pSD 1.98810169492
Rred_594 VDD.$890.Metal1 VDD.$902.Metal1 0.0503803330447
Rred_595 VDD.$890.Metal1 VDD.P0.nSD 8.00989158551
Rred_596 VDD.$902.Metal1 VDD.$917.Metal1 0.0762245508578
Rred_597 VDD.$902.Metal1 VDD.P0.nSD 5.6382048292
Rred_598 VDD.$917.Metal1 VDD.$965.Metal1 0.0614259096926
Rred_599 VDD.$917.Metal1 VDD.P0.nSD 6.98493275728
Rred_600 VDD.$920.Metal1 VDD.$954.Metal1 0.0701908834403
Rred_601 VDD.$920.Metal1 VDD.$965.Metal1 0.0484688121494
Rred_602 VDD.$920.Metal1 VDD.P0.nSD 7.08029400794
Rred_603 VDD.$940.Metal1 VDD.$941.Metal1 0.0161506228679
Rred_604 VDD.$940.Metal1 VDD.$942.Metal1 8096.80052639
Rred_605 VDD.$940.Metal1 VDD.P21.pSD 2.98631324733
Rred_606 VDD.$940.Metal1 VDD.P23.pSD 2.98631324733
Rred_607 VDD.$941.Metal1 VDD.$942.Metal1 0.0160753900045
Rred_608 VDD.$941.Metal1 VDD.P21.pSD 17
Rred_609 VDD.$941.Metal1 VDD.P23.pSD 17
Rred_610 VDD.$942.Metal1 VDD.$943.Metal1 0.0162217048716
Rred_611 VDD.$942.Metal1 VDD.P21.pSD 17
Rred_612 VDD.$942.Metal1 VDD.P23.pSD 17
Rred_613 VDD.$943.Metal1 VDD.P21.pSD 17
Rred_614 VDD.$943.Metal1 VDD.P23.pSD 17
Rred_615 VDD.$95.Metal1 VDD.P0.nSD 221.142882408
Rred_616 VDD.$954.Metal1 VDD.P0.nSD 2.73195937241
Rred_617 VDD.$954.Metal1 VDD.P1.GatPoly 28.31
Rred_618 VDD.$965.Metal1 VDD.P0.nSD 221.142882408
Rred_619 VDD.P0.pSD VDD.P1.pSD 343.680487506
Rred_620 VDD.P21.pSD VDD.P23.pSD 343.680487506
Rred_621 vin vin.$476.Metal2 0.383359862282
Rred_622 vin vin.$478.Metal2 0.462198005117
Rred_623 vin vin.$486.Metal2 0.113101642234
Rred_624 vin.$10.GatPoly vin.$16.GatPoly 20.0625185185
Rred_625 vin.$10.GatPoly vin.$202.Metal1 20.4899101814
Rred_626 vin.$10.GatPoly vin.$210.Metal1 16.8901693557
Rred_627 vin.$10.GatPoly vin.$481.Metal2 11600.2404591
Rred_628 vin.$10.GatPoly vin.$483.Metal2 2325.0407717
Rred_629 vin.$10.GatPoly vin.$6.GatPoly 33.2847407407
Rred_630 vin.$10.GatPoly vin.P1.GatPoly 19.9708444444
Rred_631 vin.$102.GatPoly vin.$108.GatPoly 20.0625185185
Rred_632 vin.$102.GatPoly vin.$334.Metal1 158.710238626
Rred_633 vin.$102.GatPoly vin.$338.Metal1 17.3193062589
Rred_634 vin.$102.GatPoly vin.$346.Metal1 16.8757273465
Rred_635 vin.$102.GatPoly vin.$570.Metal2 2987.58348254
Rred_636 vin.$102.GatPoly vin.$575.Metal2 5498.19357361
Rred_637 vin.$102.GatPoly vin.$94.GatPoly 83.9400817622
Rred_638 vin.$102.GatPoly vin.P10.GatPoly 27.8344874504
Rred_639 vin.$105.GatPoly vin.$107.GatPoly 15.0537042157
Rred_640 vin.$105.GatPoly vin.$339.Metal1 123.604185185
Rred_641 vin.$105.GatPoly vin.$343.Metal1 33.8281181896
Rred_642 vin.$105.GatPoly vin.$347.Metal1 13.0141464528
Rred_643 vin.$105.GatPoly vin.$353.Metal1 98.1690707437
Rred_644 vin.$105.GatPoly vin.$578.Metal2 5361.89490005
Rred_645 vin.$105.GatPoly vin.$97.GatPoly 30.7637083127
Rred_646 vin.$107.GatPoly vin.$115.GatPoly 29.4260595885
Rred_647 vin.$107.GatPoly vin.$347.Metal1 57.8243567653
Rred_648 vin.$107.GatPoly vin.$353.Metal1 15.9311738026
Rred_649 vin.$107.GatPoly vin.$357.Metal1 55.6375076253
Rred_650 vin.$107.GatPoly vin.$578.Metal2 3154.05582356
Rred_651 vin.$107.GatPoly vin.P31.GatPoly 22.26
Rred_652 vin.$108.GatPoly vin.$110.GatPoly 11.1325184116
Rred_653 vin.$108.GatPoly vin.$346.Metal1 37.9333333333
Rred_654 vin.$108.GatPoly vin.$348.Metal1 15.5718406742
Rred_655 vin.$108.GatPoly vin.$356.Metal1 430.191522254
Rred_656 vin.$108.GatPoly vin.$579.Metal2 25055.8390465
Rred_657 vin.$108.GatPoly vin.P11.GatPoly 16.2266666667
Rred_658 vin.$110.GatPoly vin.$118.GatPoly 42.8025468312
Rred_659 vin.$110.GatPoly vin.$348.Metal1 31.5600123225
Rred_660 vin.$110.GatPoly vin.$356.Metal1 15.334097558
Rred_661 vin.$110.GatPoly vin.$360.Metal1 80.9291851852
Rred_662 vin.$110.GatPoly vin.$579.Metal2 1714.75888267
Rred_663 vin.$110.GatPoly vin.P11.GatPoly 11.3586666667
Rred_664 vin.$115.GatPoly vin.$123.GatPoly 51.4620406015
Rred_665 vin.$115.GatPoly vin.$353.Metal1 135.119661376
Rred_666 vin.$115.GatPoly vin.$357.Metal1 16.0835537092
Rred_667 vin.$115.GatPoly vin.$365.Metal1 15.9974348707
Rred_668 vin.$115.GatPoly vin.$369.Metal1 97.3021776078
Rred_669 vin.$115.GatPoly vin.$582.Metal2 4543.078818
Rred_670 vin.$115.GatPoly vin.$587.Metal2 3372.27982918
Rred_671 vin.$115.GatPoly vin.P32.GatPoly 93.7877994151
Rred_672 vin.$118.GatPoly vin.$122.GatPoly 33.2347189542
Rred_673 vin.$118.GatPoly vin.$356.Metal1 80.9291851852
Rred_674 vin.$118.GatPoly vin.$360.Metal1 15.5987328054
Rred_675 vin.$118.GatPoly vin.$368.Metal1 20.4860406756
Rred_676 vin.$118.GatPoly vin.$586.Metal2 2301.94136839
Rred_677 vin.$118.GatPoly vin.$590.Metal2 12405.3841055
Rred_678 vin.$118.GatPoly vin.P12.GatPoly 12.9518899643
Rred_679 vin.$122.GatPoly vin.$130.GatPoly 60.50563664
Rred_680 vin.$122.GatPoly vin.$368.Metal1 18.2531011901
Rred_681 vin.$122.GatPoly vin.$374.Metal1 15.6601627124
Rred_682 vin.$122.GatPoly vin.$378.Metal1 84.9923100066
Rred_683 vin.$122.GatPoly vin.$590.Metal2 1611.09899248
Rred_684 vin.$122.GatPoly vin.P12.GatPoly 30.8176484848
Rred_685 vin.$122.GatPoly vin.P13.GatPoly 123.431498746
Rred_686 vin.$123.GatPoly vin.$127.GatPoly 36.1143032099
Rred_687 vin.$123.GatPoly vin.$365.Metal1 97.3021776078
Rred_688 vin.$123.GatPoly vin.$369.Metal1 16.2930131079
Rred_689 vin.$123.GatPoly vin.$375.Metal1 15.7999014456
Rred_690 vin.$123.GatPoly vin.$379.Metal1 96.7347407407
Rred_691 vin.$123.GatPoly vin.$591.Metal2 1611.09899248
Rred_692 vin.$123.GatPoly vin.P32.GatPoly 72.5872454666
Rred_693 vin.$127.GatPoly vin.$135.GatPoly 26.7507621399
Rred_694 vin.$127.GatPoly vin.$375.Metal1 68.2833464052
Rred_695 vin.$127.GatPoly vin.$379.Metal1 27.001323271
Rred_696 vin.$127.GatPoly vin.$383.Metal1 20.0005513629
Rred_697 vin.$127.GatPoly vin.$387.Metal1 50.5791721133
Rred_698 vin.$127.GatPoly vin.P33.GatPoly 22.26
Rred_699 vin.$130.GatPoly vin.$134.GatPoly 20.0625185185
Rred_700 vin.$130.GatPoly vin.$374.Metal1 114.401413815
Rred_701 vin.$130.GatPoly vin.$378.Metal1 18.1851091752
Rred_702 vin.$130.GatPoly vin.$386.Metal1 16.8812213797
Rred_703 vin.$130.GatPoly vin.$595.Metal2 8439.59448869
Rred_704 vin.$130.GatPoly vin.$599.Metal2 2525.70222612
Rred_705 vin.$130.GatPoly vin.P13.GatPoly 7.97486881396
Rred_706 vin.$134.GatPoly vin.$136.GatPoly 17.2080405764
Rred_707 vin.$134.GatPoly vin.$386.Metal1 16.9633899809
Rred_708 vin.$134.GatPoly vin.$392.Metal1 17.7474958524
Rred_709 vin.$134.GatPoly vin.$396.Metal1 2936.27252746
Rred_710 vin.$134.GatPoly vin.$604.Metal2 1989.57191416
Rred_711 vin.$135.GatPoly vin.$137.GatPoly 17.2080405764
Rred_712 vin.$135.GatPoly vin.$383.Metal1 171.969185185
Rred_713 vin.$135.GatPoly vin.$387.Metal1 16.3265000824
Rred_714 vin.$135.GatPoly vin.$393.Metal1 17.7474001705
Rred_715 vin.$135.GatPoly vin.$397.Metal1 2936.27252746
Rred_716 vin.$135.GatPoly vin.$603.Metal2 2027.68731673
Rred_717 vin.$135.GatPoly vin.$609.Metal2 111904.93744
Rred_718 vin.$136.GatPoly vin.$144.GatPoly 25.4131134156
Rred_719 vin.$136.GatPoly vin.$392.Metal1 33.0203657934
Rred_720 vin.$136.GatPoly vin.$396.Metal1 18.8410085241
Rred_721 vin.$136.GatPoly vin.$400.Metal1 48.0500043573
Rred_722 vin.$136.GatPoly vin.P14.GatPoly 4.76
Rred_723 vin.$137.GatPoly vin.$145.GatPoly 25.4131134156
Rred_724 vin.$137.GatPoly vin.$393.Metal1 33.0203657934
Rred_725 vin.$137.GatPoly vin.$397.Metal1 18.8410085241
Rred_726 vin.$137.GatPoly vin.$401.Metal1 48.0500043573
Rred_727 vin.$137.GatPoly vin.P34.GatPoly 22.26
Rred_728 vin.$144.GatPoly vin.$152.GatPoly 80.7317467344
Rred_729 vin.$144.GatPoly vin.$396.Metal1 204.212518518
Rred_730 vin.$144.GatPoly vin.$400.Metal1 16.3459334659
Rred_731 vin.$144.GatPoly vin.$408.Metal1 16.4300806005
Rred_732 vin.$144.GatPoly vin.$412.Metal1 152.644058952
Rred_733 vin.$144.GatPoly vin.$610.Metal2 3870.9558658
Rred_734 vin.$144.GatPoly vin.$615.Metal2 3870.9558658
Rred_735 vin.$144.GatPoly vin.P15.GatPoly 38.1468722988
Rred_736 vin.$145.GatPoly vin.$153.GatPoly 50.9131933514
Rred_737 vin.$145.GatPoly vin.$397.Metal1 204.212518518
Rred_738 vin.$145.GatPoly vin.$401.Metal1 16.3459334659
Rred_739 vin.$145.GatPoly vin.$409.Metal1 15.8678203345
Rred_740 vin.$145.GatPoly vin.$413.Metal1 96.2644412107
Rred_741 vin.$145.GatPoly vin.$611.Metal2 3870.9558658
Rred_742 vin.$145.GatPoly vin.$616.Metal2 3870.9558658
Rred_743 vin.$145.GatPoly vin.P35.GatPoly 112.502748125
Rred_744 vin.$15.GatPoly vin.$17.GatPoly 8.64681481481
Rred_745 vin.$15.GatPoly vin.$219.Metal1 12.6296021429
Rred_746 vin.$15.GatPoly vin.$227.Metal1 37.7619085138
Rred_747 vin.$15.GatPoly vin.$27.GatPoly 41.3580961617
Rred_748 vin.$15.GatPoly vin.$493.Metal2 2934.89262124
Rred_749 vin.$15.GatPoly vin.P22.GatPoly 22.26
Rred_750 vin.$152.GatPoly vin.$156.GatPoly 40.1272493827
Rred_751 vin.$152.GatPoly vin.$408.Metal1 152.644058952
Rred_752 vin.$152.GatPoly vin.$412.Metal1 18.6069469566
Rred_753 vin.$152.GatPoly vin.$418.Metal1 15.6802121879
Rred_754 vin.$152.GatPoly vin.$422.Metal1 85.9869629629
Rred_755 vin.$152.GatPoly vin.$619.Metal2 1563.02782058
Rred_756 vin.$152.GatPoly vin.P15.GatPoly 21.4418885263
Rred_757 vin.$153.GatPoly vin.$157.GatPoly 40.1272493827
Rred_758 vin.$153.GatPoly vin.$409.Metal1 96.2644412107
Rred_759 vin.$153.GatPoly vin.$413.Metal1 16.5099701104
Rred_760 vin.$153.GatPoly vin.$419.Metal1 15.6802121879
Rred_761 vin.$153.GatPoly vin.$423.Metal1 85.9869629629
Rred_762 vin.$153.GatPoly vin.$620.Metal2 1563.02782058
Rred_763 vin.$153.GatPoly vin.P35.GatPoly 63.2364133369
Rred_764 vin.$156.GatPoly vin.$164.GatPoly 22.7378159671
Rred_765 vin.$156.GatPoly vin.$418.Metal1 75.8708496732
Rred_766 vin.$156.GatPoly vin.$422.Metal1 30.0016540887
Rred_767 vin.$156.GatPoly vin.$426.Metal1 17.0002205452
Rred_768 vin.$156.GatPoly vin.$430.Metal1 42.9916688453
Rred_769 vin.$156.GatPoly vin.P16.GatPoly 4.76
Rred_770 vin.$157.GatPoly vin.$163.GatPoly 9.36029629629
Rred_771 vin.$157.GatPoly vin.$419.Metal1 75.8708496732
Rred_772 vin.$157.GatPoly vin.$423.Metal1 30.0016540887
Rred_773 vin.$157.GatPoly vin.$427.Metal1 17.6980392157
Rred_774 vin.$157.GatPoly vin.P36.GatPoly 22.26
Rred_775 vin.$16.GatPoly vin.$210.Metal1 16.8857192322
Rred_776 vin.$16.GatPoly vin.$218.Metal1 19.3496497775
Rred_777 vin.$16.GatPoly vin.$22.GatPoly 77.9511897103
Rred_778 vin.$16.GatPoly vin.$222.Metal1 147.386703234
Rred_779 vin.$16.GatPoly vin.$488.Metal2 2301.94136839
Rred_780 vin.$16.GatPoly vin.$492.Metal2 12405.3841055
Rred_781 vin.$16.GatPoly vin.P2.GatPoly 19.176544151
Rred_782 vin.$163.GatPoly vin.$167.GatPoly 41.3580961617
Rred_783 vin.$163.GatPoly vin.$427.Metal1 27.2939474766
Rred_784 vin.$163.GatPoly vin.$433.Metal1 14.2581745852
Rred_785 vin.$163.GatPoly vin.$441.Metal1 115.651204718
Rred_786 vin.$163.GatPoly vin.$629.Metal2 2664.67413314
Rred_787 vin.$163.GatPoly vin.$636.Metal2 6114.14760608
Rred_788 vin.$164.GatPoly vin.$172.GatPoly 77.9511897103
Rred_789 vin.$164.GatPoly vin.$426.Metal1 365.429185185
Rred_790 vin.$164.GatPoly vin.$430.Metal1 16.5931436324
Rred_791 vin.$164.GatPoly vin.$437.Metal1 16.2158441731
Rred_792 vin.$164.GatPoly vin.$440.Metal1 147.386703234
Rred_793 vin.$164.GatPoly vin.$630.Metal2 1836.80456241
Rred_794 vin.$164.GatPoly vin.P17.GatPoly 42.9114848609
Rred_795 vin.$167.GatPoly vin.$173.GatPoly 8.64681481481
Rred_796 vin.$167.GatPoly vin.$433.Metal1 37.7619085138
Rred_797 vin.$167.GatPoly vin.$441.Metal1 12.6296021429
Rred_798 vin.$167.GatPoly vin.$636.Metal2 2934.89262124
Rred_799 vin.$167.GatPoly vin.P37.GatPoly 22.26
Rred_800 vin.$17.GatPoly vin.$207.Metal1 80.9291851852
Rred_801 vin.$17.GatPoly vin.$211.Metal1 15.5987328054
Rred_802 vin.$17.GatPoly vin.$219.Metal1 27.3987871831
Rred_803 vin.$17.GatPoly vin.$489.Metal2 2301.94136839
Rred_804 vin.$17.GatPoly vin.$493.Metal2 12405.3841055
Rred_805 vin.$17.GatPoly vin.$9.GatPoly 42.8025468312
Rred_806 vin.$172.GatPoly vin.$176.GatPoly 20.0625185185
Rred_807 vin.$172.GatPoly vin.$437.Metal1 147.386703234
Rred_808 vin.$172.GatPoly vin.$440.Metal1 19.3496497775
Rred_809 vin.$172.GatPoly vin.$448.Metal1 16.8857192322
Rred_810 vin.$172.GatPoly vin.$635.Metal2 12405.3841055
Rred_811 vin.$172.GatPoly vin.$639.Metal2 2301.94136839
Rred_812 vin.$172.GatPoly vin.P17.GatPoly 19.176544151
Rred_813 vin.$173.GatPoly vin.$179.GatPoly 42.8025468312
Rred_814 vin.$173.GatPoly vin.$441.Metal1 27.3987871831
Rred_815 vin.$173.GatPoly vin.$449.Metal1 15.5987328054
Rred_816 vin.$173.GatPoly vin.$453.Metal1 80.9291851852
Rred_817 vin.$173.GatPoly vin.$636.Metal2 12405.3841055
Rred_818 vin.$173.GatPoly vin.$640.Metal2 2301.94136839
Rred_819 vin.$176.GatPoly vin.$180.GatPoly 33.2847407407
Rred_820 vin.$176.GatPoly vin.$448.Metal1 16.8901542286
Rred_821 vin.$176.GatPoly vin.$456.Metal1 20.489591646
Rred_822 vin.$176.GatPoly vin.$644.Metal2 2115.07400678
Rred_823 vin.$176.GatPoly vin.$648.Metal2 23421.3890021
Rred_824 vin.$176.GatPoly vin.P18.GatPoly 19.9708444444
Rred_825 vin.$179.GatPoly vin.$449.Metal1 80.9291851852
Rred_826 vin.$179.GatPoly vin.$453.Metal1 32.0018746339
Rred_827 vin.$179.GatPoly vin.$457.Metal1 8.16033769425
Rred_828 vin.$179.GatPoly vin.$649.Metal2 877.519802179
Rred_829 vin.$179.GatPoly vin.$654.Metal2 295.150090209
Rred_830 vin.$179.GatPoly vin.P38.GatPoly 22.26
Rred_831 vin.$179.GatPoly vin.P39.GatPoly 365.628758224
Rred_832 vin.$180.GatPoly vin.$456.Metal1 8.0987663346
Rred_833 vin.$180.GatPoly vin.$648.Metal2 456.549538848
Rred_834 vin.$180.GatPoly vin.$653.Metal2 158.542646647
Rred_835 vin.$180.GatPoly vin.P18.GatPoly 19.9708444444
Rred_836 vin.$180.GatPoly vin.P19.GatPoly 86.7094752085
Rred_837 vin.$199.Metal1 vin.$207.Metal1 0.375564027363
Rred_838 vin.$199.Metal1 vin.$478.Metal2 3.78805926628
Rred_839 vin.$199.Metal1 vin.$482.Metal2 10.5892283293
Rred_840 vin.$199.Metal1 vin.$7.GatPoly 8.40742338009
Rred_841 vin.$199.Metal1 vin.$9.GatPoly 31.5600123225
Rred_842 vin.$199.Metal1 vin.P20.GatPoly 42.4356900032
Rred_843 vin.$202.Metal1 vin.$210.Metal1 0.362318738522
Rred_844 vin.$202.Metal1 vin.$476.Metal2 4.15223424267
Rred_845 vin.$202.Metal1 vin.$481.Metal2 6.75208772039
Rred_846 vin.$202.Metal1 vin.$483.Metal2 27.6679763963
Rred_847 vin.$202.Metal1 vin.$6.GatPoly 8.09494705917
Rred_848 vin.$202.Metal1 vin.P0.GatPoly 21.9122811939
Rred_849 vin.$202.Metal1 vin.P1.GatPoly 37.76
Rred_850 vin.$207.Metal1 vin.$211.Metal1 0.178668121137
Rred_851 vin.$207.Metal1 vin.$482.Metal2 10.1906073209
Rred_852 vin.$207.Metal1 vin.$486.Metal2 116.98703911
Rred_853 vin.$207.Metal1 vin.$489.Metal2 33.8392261889
Rred_854 vin.$207.Metal1 vin.$7.GatPoly 430.191522254
Rred_855 vin.$207.Metal1 vin.$9.GatPoly 15.334097558
Rred_856 vin.$210.Metal1 vin.$218.Metal1 0.362653569415
Rred_857 vin.$210.Metal1 vin.$481.Metal2 138.339881981
Rred_858 vin.$210.Metal1 vin.$483.Metal2 13.6089175956
Rred_859 vin.$210.Metal1 vin.$488.Metal2 11.5186194376
Rred_860 vin.$210.Metal1 vin.$492.Metal2 148.012303013
Rred_861 vin.$211.Metal1 vin.$219.Metal1 0.362653569415
Rred_862 vin.$211.Metal1 vin.$482.Metal2 56.7915325123
Rred_863 vin.$211.Metal1 vin.$486.Metal2 228.887685216
Rred_864 vin.$211.Metal1 vin.$489.Metal2 9.81161105877
Rred_865 vin.$211.Metal1 vin.$493.Metal2 148.012303013
Rred_866 vin.$211.Metal1 vin.$9.GatPoly 80.9291851852
Rred_867 vin.$218.Metal1 vin.$22.GatPoly 147.386703234
Rred_868 vin.$218.Metal1 vin.$222.Metal1 0.178129923539
Rred_869 vin.$218.Metal1 vin.$488.Metal2 12.8905653645
Rred_870 vin.$218.Metal1 vin.$492.Metal2 18.9451496641
Rred_871 vin.$218.Metal1 vin.P2.GatPoly 36.2581717142
Rred_872 vin.$219.Metal1 vin.$227.Metal1 0.39094415179
Rred_873 vin.$219.Metal1 vin.$27.GatPoly 115.651204718
Rred_874 vin.$219.Metal1 vin.$489.Metal2 12.8905653645
Rred_875 vin.$219.Metal1 vin.$493.Metal2 9.17818171348
Rred_876 vin.$22.GatPoly vin.$222.Metal1 16.2158441731
Rred_877 vin.$22.GatPoly vin.$228.Metal1 16.5931436324
Rred_878 vin.$22.GatPoly vin.$232.Metal1 365.429185185
Rred_879 vin.$22.GatPoly vin.$24.GatPoly 22.7378159671
Rred_880 vin.$22.GatPoly vin.$497.Metal2 1836.80456241
Rred_881 vin.$22.GatPoly vin.P2.GatPoly 42.9114848609
Rred_882 vin.$222.Metal1 vin.$228.Metal1 0.36174266925
Rred_883 vin.$222.Metal1 vin.$492.Metal2 9.42324175824
Rred_884 vin.$222.Metal1 vin.$497.Metal2 21.8084097251
Rred_885 vin.$222.Metal1 vin.P2.GatPoly 81.1351604514
Rred_886 vin.$227.Metal1 vin.$233.Metal1 0.331848942782
Rred_887 vin.$227.Metal1 vin.$27.GatPoly 14.2581745852
Rred_888 vin.$227.Metal1 vin.$493.Metal2 11.1591689028
Rred_889 vin.$227.Metal1 vin.$495.Metal2 38.1149573586
Rred_890 vin.$227.Metal1 vin.$500.Metal2 12.4168010073
Rred_891 vin.$228.Metal1 vin.$232.Metal1 0.178852088262
Rred_892 vin.$228.Metal1 vin.$236.Metal1 4036.92165822
Rred_893 vin.$228.Metal1 vin.$24.GatPoly 42.9916688453
Rred_894 vin.$228.Metal1 vin.$497.Metal2 9.12759240183
Rred_895 vin.$228.Metal1 vin.$503.Metal2 43.9859302507
Rred_896 vin.$232.Metal1 vin.$236.Metal1 0.17894182666
Rred_897 vin.$232.Metal1 vin.$24.GatPoly 17.0002205452
Rred_898 vin.$232.Metal1 vin.$497.Metal2 23.8007022261
Rred_899 vin.$232.Metal1 vin.$503.Metal2 22.6413748687
Rred_900 vin.$233.Metal1 vin.$237.Metal1 0.178949087371
Rred_901 vin.$233.Metal1 vin.$25.GatPoly 17.6980392157
Rred_902 vin.$233.Metal1 vin.$27.GatPoly 27.2939474766
Rred_903 vin.$233.Metal1 vin.$500.Metal2 10.4731205828
Rred_904 vin.$233.Metal1 vin.$504.Metal2 42.814045977
Rred_905 vin.$236.Metal1 vin.$24.GatPoly 30.0016540887
Rred_906 vin.$236.Metal1 vin.$240.Metal1 0.178504947966
Rred_907 vin.$236.Metal1 vin.$36.GatPoly 85.9869629629
Rred_908 vin.$236.Metal1 vin.$497.Metal2 48.5088769371
Rred_909 vin.$236.Metal1 vin.$503.Metal2 15.140503946
Rred_910 vin.$237.Metal1 vin.$241.Metal1 0.178504947966
Rred_911 vin.$237.Metal1 vin.$25.GatPoly 30.0016540887
Rred_912 vin.$237.Metal1 vin.$37.GatPoly 85.9869629629
Rred_913 vin.$237.Metal1 vin.$500.Metal2 31.8360854701
Rred_914 vin.$237.Metal1 vin.$504.Metal2 17.9090803107
Rred_915 vin.$24.GatPoly vin.$240.Metal1 75.8708496732
Rred_916 vin.$24.GatPoly vin.$36.GatPoly 40.1272493827
Rred_917 vin.$24.GatPoly vin.P3.GatPoly 4.76
Rred_918 vin.$240.Metal1 vin.$246.Metal1 0.36182906056
Rred_919 vin.$240.Metal1 vin.$36.GatPoly 15.6802121879
Rred_920 vin.$240.Metal1 vin.$503.Metal2 11.5864555256
Rred_921 vin.$240.Metal1 vin.$508.Metal2 18.0168451015
Rred_922 vin.$241.Metal1 vin.$247.Metal1 0.36182906056
Rred_923 vin.$241.Metal1 vin.$25.GatPoly 75.8708496732
Rred_924 vin.$241.Metal1 vin.$37.GatPoly 15.6802121879
Rred_925 vin.$241.Metal1 vin.$504.Metal2 11.5864555256
Rred_926 vin.$241.Metal1 vin.$509.Metal2 18.0168451015
Rred_927 vin.$246.Metal1 vin.$250.Metal1 0.17852453123
Rred_928 vin.$246.Metal1 vin.$36.GatPoly 18.6069469566
Rred_929 vin.$246.Metal1 vin.$42.GatPoly 152.644058952
Rred_930 vin.$246.Metal1 vin.$508.Metal2 10.1769943283
Rred_931 vin.$246.Metal1 vin.$512.Metal2 22.5350597402
Rred_932 vin.$246.Metal1 vin.P4.GatPoly 40.541385869
Rred_933 vin.$247.Metal1 vin.$251.Metal1 0.178459879632
Rred_934 vin.$247.Metal1 vin.$37.GatPoly 16.5099701104
Rred_935 vin.$247.Metal1 vin.$43.GatPoly 96.2644412107
Rred_936 vin.$247.Metal1 vin.$509.Metal2 10.1769943283
Rred_937 vin.$247.Metal1 vin.$513.Metal2 22.5350597402
Rred_938 vin.$247.Metal1 vin.P24.GatPoly 119.564647066
Rred_939 vin.$25.GatPoly vin.$27.GatPoly 9.36029629629
Rred_940 vin.$25.GatPoly vin.$37.GatPoly 40.1272493827
Rred_941 vin.$25.GatPoly vin.P23.GatPoly 22.26
Rred_942 vin.$250.Metal1 vin.$258.Metal1 0.362824398622
Rred_943 vin.$250.Metal1 vin.$36.GatPoly 152.644058952
Rred_944 vin.$250.Metal1 vin.$42.GatPoly 16.4300806005
Rred_945 vin.$250.Metal1 vin.$508.Metal2 95.3406373629
Rred_946 vin.$250.Metal1 vin.$512.Metal2 10.1192256903
Rred_947 vin.$250.Metal1 vin.$517.Metal2 46.1776507338
Rred_948 vin.$250.Metal1 vin.P4.GatPoly 72.1264392205
Rred_949 vin.$251.Metal1 vin.$259.Metal1 0.362824398622
Rred_950 vin.$251.Metal1 vin.$37.GatPoly 96.2644412107
Rred_951 vin.$251.Metal1 vin.$43.GatPoly 15.8678203345
Rred_952 vin.$251.Metal1 vin.$509.Metal2 95.3406373629
Rred_953 vin.$251.Metal1 vin.$513.Metal2 10.1192256903
Rred_954 vin.$251.Metal1 vin.$518.Metal2 46.1776507338
Rred_955 vin.$251.Metal1 vin.P24.GatPoly 212.715280069
Rred_956 vin.$258.Metal1 vin.$262.Metal1 0.178550748274
Rred_957 vin.$258.Metal1 vin.$264.Metal1 7610.30667437
Rred_958 vin.$258.Metal1 vin.$42.GatPoly 16.3459334659
Rred_959 vin.$258.Metal1 vin.$44.GatPoly 48.0500043573
Rred_960 vin.$258.Metal1 vin.$512.Metal2 46.1776507338
Rred_961 vin.$258.Metal1 vin.$517.Metal2 9.7817715397
Rred_962 vin.$258.Metal1 vin.$523.Metal2 145.280351752
Rred_963 vin.$259.Metal1 vin.$263.Metal1 0.178557568839
Rred_964 vin.$259.Metal1 vin.$43.GatPoly 16.3459334659
Rred_965 vin.$259.Metal1 vin.$47.GatPoly 48.0500043573
Rred_966 vin.$259.Metal1 vin.$513.Metal2 46.1776507338
Rred_967 vin.$259.Metal1 vin.$518.Metal2 11.3207867366
Rred_968 vin.$259.Metal1 vin.$520.Metal2 47.2209706961
Rred_969 vin.$262.Metal1 vin.$264.Metal1 0.180721425263
Rred_970 vin.$262.Metal1 vin.$42.GatPoly 204.212518518
Rred_971 vin.$262.Metal1 vin.$44.GatPoly 18.8410085241
Rred_972 vin.$262.Metal1 vin.$517.Metal2 17.0071631934
Rred_973 vin.$262.Metal1 vin.$52.GatPoly 2936.27252746
Rred_974 vin.$262.Metal1 vin.$523.Metal2 34.3389922323
Rred_975 vin.$263.Metal1 vin.$265.Metal1 0.180739583769
Rred_976 vin.$263.Metal1 vin.$43.GatPoly 204.212518518
Rred_977 vin.$263.Metal1 vin.$47.GatPoly 18.8410085241
Rred_978 vin.$263.Metal1 vin.$520.Metal2 11.1613203463
Rred_979 vin.$263.Metal1 vin.$53.GatPoly 2936.27252746
Rred_980 vin.$264.Metal1 vin.$272.Metal1 0.358974281487
Rred_981 vin.$264.Metal1 vin.$44.GatPoly 33.0203657934
Rred_982 vin.$264.Metal1 vin.$517.Metal2 27.6894597146
Rred_983 vin.$264.Metal1 vin.$52.GatPoly 17.7474958524
Rred_984 vin.$264.Metal1 vin.$523.Metal2 8.62947986197
Rred_985 vin.$265.Metal1 vin.$273.Metal1 0.358969093271
Rred_986 vin.$265.Metal1 vin.$47.GatPoly 33.0203657934
Rred_987 vin.$265.Metal1 vin.$520.Metal2 17.6141428574
Rred_988 vin.$265.Metal1 vin.$527.Metal2 10.4000814367
Rred_989 vin.$265.Metal1 vin.$53.GatPoly 17.7474001705
Rred_990 vin.$27.GatPoly vin.$493.Metal2 6114.14760608
Rred_991 vin.$27.GatPoly vin.$500.Metal2 2664.67413314
Rred_992 vin.$272.Metal1 vin.$280.Metal1 0.362797942164
Rred_993 vin.$272.Metal1 vin.$52.GatPoly 16.9633899809
Rred_994 vin.$272.Metal1 vin.$523.Metal2 15.0113662187
Rred_995 vin.$272.Metal1 vin.$528.Metal2 10.3514401745
Rred_996 vin.$272.Metal1 vin.$532.Metal2 100.688434264
Rred_997 vin.$272.Metal1 vin.$58.GatPoly 16.8812213797
Rred_998 vin.$273.Metal1 vin.$277.Metal1 0.178843777497
Rred_999 vin.$273.Metal1 vin.$281.Metal1 4137.53229591
Rred_1000 vin.$273.Metal1 vin.$520.Metal2 844.325347394
Rred_1001 vin.$273.Metal1 vin.$527.Metal2 9.30100123455
Rred_1002 vin.$273.Metal1 vin.$53.GatPoly 16.3265000824
Rred_1003 vin.$273.Metal1 vin.$533.Metal2 49.717844922
Rred_1004 vin.$273.Metal1 vin.$57.GatPoly 50.5791721133
Rred_1005 vin.$277.Metal1 vin.$281.Metal1 0.178898601437
Rred_1006 vin.$277.Metal1 vin.$527.Metal2 22.3566696457
Rred_1007 vin.$277.Metal1 vin.$53.GatPoly 171.969185185
Rred_1008 vin.$277.Metal1 vin.$533.Metal2 24.1058961615
Rred_1009 vin.$277.Metal1 vin.$57.GatPoly 20.0005513629
Rred_1010 vin.$280.Metal1 vin.$284.Metal1 0.178374896227
Rred_1011 vin.$280.Metal1 vin.$528.Metal2 14.7413390447
Rred_1012 vin.$280.Metal1 vin.$532.Metal2 15.9997708552
Rred_1013 vin.$280.Metal1 vin.$58.GatPoly 18.1851091752
Rred_1014 vin.$280.Metal1 vin.$64.GatPoly 84.9923100066
Rred_1015 vin.$280.Metal1 vin.P6.GatPoly 92.2851475241
Rred_1016 vin.$281.Metal1 vin.$285.Metal1 0.178398933563
Rred_1017 vin.$281.Metal1 vin.$527.Metal2 43.4328267333
Rred_1018 vin.$281.Metal1 vin.$533.Metal2 15.7349129944
Rred_1019 vin.$281.Metal1 vin.$57.GatPoly 27.001323271
Rred_1020 vin.$281.Metal1 vin.$65.GatPoly 96.7347407407
Rred_1021 vin.$284.Metal1 vin.$290.Metal1 0.361824121591
Rred_1022 vin.$284.Metal1 vin.$532.Metal2 10.7656516291
Rred_1023 vin.$284.Metal1 vin.$537.Metal2 19.1286039107
Rred_1024 vin.$284.Metal1 vin.$58.GatPoly 114.401413815
Rred_1025 vin.$284.Metal1 vin.$64.GatPoly 15.6601627124
Rred_1026 vin.$284.Metal1 vin.P6.GatPoly 233.378884183
Rred_1027 vin.$285.Metal1 vin.$291.Metal1 0.361824121591
Rred_1028 vin.$285.Metal1 vin.$533.Metal2 10.7656516291
Rred_1029 vin.$285.Metal1 vin.$538.Metal2 19.1286039107
Rred_1030 vin.$285.Metal1 vin.$57.GatPoly 68.2833464052
Rred_1031 vin.$285.Metal1 vin.$65.GatPoly 15.7999014456
Rred_1032 vin.$290.Metal1 vin.$298.Metal1 0.362653569415
Rred_1033 vin.$290.Metal1 vin.$537.Metal2 9.52216809103
Rred_1034 vin.$290.Metal1 vin.$541.Metal2 12.8905653645
Rred_1035 vin.$290.Metal1 vin.$64.GatPoly 18.2531011901
Rred_1036 vin.$290.Metal1 vin.$70.GatPoly 20.4860406756
Rred_1037 vin.$290.Metal1 vin.P7.GatPoly 58.2686631016
Rred_1038 vin.$291.Metal1 vin.$295.Metal1 0.17857627571
Rred_1039 vin.$291.Metal1 vin.$538.Metal2 10.1777438502
Rred_1040 vin.$291.Metal1 vin.$542.Metal2 24.3181269841
Rred_1041 vin.$291.Metal1 vin.$65.GatPoly 16.2930131079
Rred_1042 vin.$291.Metal1 vin.$73.GatPoly 97.3021776078
Rred_1043 vin.$291.Metal1 vin.P27.GatPoly 137.244791849
Rred_1044 vin.$295.Metal1 vin.$303.Metal1 0.362799427562
Rred_1045 vin.$295.Metal1 vin.$538.Metal2 72.9543809522
Rred_1046 vin.$295.Metal1 vin.$542.Metal2 10.1293546422
Rred_1047 vin.$295.Metal1 vin.$547.Metal2 54.2048156595
Rred_1048 vin.$295.Metal1 vin.$65.GatPoly 97.3021776078
Rred_1049 vin.$295.Metal1 vin.$73.GatPoly 15.9974348707
Rred_1050 vin.$295.Metal1 vin.P27.GatPoly 177.329872844
Rred_1051 vin.$298.Metal1 vin.$302.Metal1 0.178668868145
Rred_1052 vin.$298.Metal1 vin.$537.Metal2 148.012303013
Rred_1053 vin.$298.Metal1 vin.$541.Metal2 9.91391002973
Rred_1054 vin.$298.Metal1 vin.$544.Metal2 136.676492583
Rred_1055 vin.$298.Metal1 vin.$548.Metal2 63.5012825511
Rred_1056 vin.$298.Metal1 vin.$70.GatPoly 15.5987328054
Rred_1057 vin.$298.Metal1 vin.$78.GatPoly 80.9291851852
Rred_1058 vin.$302.Metal1 vin.$310.Metal1 0.375564027363
Rred_1059 vin.$302.Metal1 vin.$541.Metal2 36.3717608362
Rred_1060 vin.$302.Metal1 vin.$544.Metal2 69.856873987
Rred_1061 vin.$302.Metal1 vin.$548.Metal2 10.5831998195
Rred_1062 vin.$302.Metal1 vin.$70.GatPoly 80.9291851852
Rred_1063 vin.$302.Metal1 vin.$78.GatPoly 15.334097558
Rred_1064 vin.$302.Metal1 vin.$80.GatPoly 430.191522254
Rred_1065 vin.$303.Metal1 vin.$307.Metal1 0.178371493384
Rred_1066 vin.$303.Metal1 vin.$542.Metal2 40.2164761345
Rred_1067 vin.$303.Metal1 vin.$547.Metal2 10.1082003498
Rred_1068 vin.$303.Metal1 vin.$551.Metal2 137.607164021
Rred_1069 vin.$303.Metal1 vin.$73.GatPoly 16.0835537092
Rred_1070 vin.$303.Metal1 vin.$77.GatPoly 55.6375076253
Rred_1071 vin.$307.Metal1 vin.$313.Metal1 0.36146618849
Rred_1072 vin.$307.Metal1 vin.$547.Metal2 20.9909233253
Rred_1073 vin.$307.Metal1 vin.$551.Metal2 10.1668380754
Rred_1074 vin.$307.Metal1 vin.$73.GatPoly 135.119661376
Rred_1075 vin.$307.Metal1 vin.$77.GatPoly 15.9311738026
Rred_1076 vin.$307.Metal1 vin.$83.GatPoly 98.1690707437
Rred_1077 vin.$310.Metal1 vin.$312.Metal1 0.165
Rred_1078 vin.$310.Metal1 vin.$548.Metal2 9.92591643291
Rred_1079 vin.$310.Metal1 vin.$552.Metal2 18.1718095238
Rred_1080 vin.$310.Metal1 vin.$78.GatPoly 31.5600123225
Rred_1081 vin.$310.Metal1 vin.$80.GatPoly 15.5718406742
Rred_1082 vin.$312.Metal1 vin.$320.Metal1 0.362724514501
Rred_1083 vin.$312.Metal1 vin.$552.Metal2 10.5257138212
Rred_1084 vin.$312.Metal1 vin.$557.Metal2 35.6129523328
Rred_1085 vin.$312.Metal1 vin.$80.GatPoly 37.9333333333
Rred_1086 vin.$312.Metal1 vin.$84.GatPoly 16.8757273465
Rred_1087 vin.$313.Metal1 vin.$317.Metal1 0.178799366164
Rred_1088 vin.$313.Metal1 vin.$551.Metal2 11.008714331
Rred_1089 vin.$313.Metal1 vin.$555.Metal2 57.4004804448
Rred_1090 vin.$313.Metal1 vin.$558.Metal2 33.6812736494
Rred_1091 vin.$313.Metal1 vin.$77.GatPoly 57.8243567653
Rred_1092 vin.$313.Metal1 vin.$83.GatPoly 13.0141464528
Rred_1093 vin.$317.Metal1 vin.$321.Metal1 0.178838571508
Rred_1094 vin.$317.Metal1 vin.$551.Metal2 80.5238780093
Rred_1095 vin.$317.Metal1 vin.$555.Metal2 148.032817989
Rred_1096 vin.$317.Metal1 vin.$558.Metal2 14.6154515868
Rred_1097 vin.$317.Metal1 vin.$83.GatPoly 33.8281181896
Rred_1098 vin.$317.Metal1 vin.$87.GatPoly 58.1666753812
Rred_1099 vin.$320.Metal1 vin.$328.Metal1 0.362169844265
Rred_1100 vin.$320.Metal1 vin.$552.Metal2 65.6028069289
Rred_1101 vin.$320.Metal1 vin.$557.Metal2 8.52565576862
Rred_1102 vin.$320.Metal1 vin.$561.Metal2 24.2669420704
Rred_1103 vin.$320.Metal1 vin.$84.GatPoly 17.7993670334
Rred_1104 vin.$320.Metal1 vin.$90.GatPoly 20.2758380631
Rred_1105 vin.$320.Metal1 vin.P9.GatPoly 68.7832679738
Rred_1106 vin.$321.Metal1 vin.$325.Metal1 0.178840374465
Rred_1107 vin.$321.Metal1 vin.$558.Metal2 14.1682801538
Rred_1108 vin.$321.Metal1 vin.$562.Metal2 59.0882403627
Rred_1109 vin.$321.Metal1 vin.$83.GatPoly 123.604185185
Rred_1110 vin.$321.Metal1 vin.$87.GatPoly 23.0008821806
Rred_1111 vin.$325.Metal1 vin.$331.Metal1 0.361795734713
Rred_1112 vin.$325.Metal1 vin.$558.Metal2 26.4011286728
Rred_1113 vin.$325.Metal1 vin.$562.Metal2 10.1761275149
Rred_1114 vin.$325.Metal1 vin.$87.GatPoly 27.1411764706
Rred_1115 vin.$325.Metal1 vin.$93.GatPoly 19.1121432091
Rred_1116 vin.$328.Metal1 vin.$334.Metal1 0.361795734713
Rred_1117 vin.$328.Metal1 vin.$557.Metal2 53.4649554857
Rred_1118 vin.$328.Metal1 vin.$561.Metal2 8.0753915984
Rred_1119 vin.$328.Metal1 vin.$566.Metal2 20.3813394518
Rred_1120 vin.$328.Metal1 vin.$90.GatPoly 16.8684682797
Rred_1121 vin.$328.Metal1 vin.$94.GatPoly 16.8807966702
Rred_1122 vin.$331.Metal1 vin.$335.Metal1 0.178273944544
Rred_1123 vin.$331.Metal1 vin.$562.Metal2 20.3813394518
Rred_1124 vin.$331.Metal1 vin.$567.Metal2 10.0511202186
Rred_1125 vin.$331.Metal1 vin.$93.GatPoly 15.9520155185
Rred_1126 vin.$331.Metal1 vin.$97.GatPoly 60.6958431373
Rred_1127 vin.$334.Metal1 vin.$338.Metal1 0.178733854286
Rred_1128 vin.$334.Metal1 vin.$566.Metal2 10.1761275149
Rred_1129 vin.$334.Metal1 vin.$570.Metal2 26.4011286728
Rred_1130 vin.$334.Metal1 vin.$94.GatPoly 17.1496072721
Rred_1131 vin.$334.Metal1 vin.P10.GatPoly 55.3808723806
Rred_1132 vin.$335.Metal1 vin.$339.Metal1 0.178840374465
Rred_1133 vin.$335.Metal1 vin.$567.Metal2 20.2863564567
Rred_1134 vin.$335.Metal1 vin.$571.Metal2 26.4011286728
Rred_1135 vin.$335.Metal1 vin.$93.GatPoly 114.647703704
Rred_1136 vin.$335.Metal1 vin.$97.GatPoly 24.0009924532
Rred_1137 vin.$338.Metal1 vin.$346.Metal1 0.362724514501
Rred_1138 vin.$338.Metal1 vin.$566.Metal2 59.0882403627
Rred_1139 vin.$338.Metal1 vin.$570.Metal2 10.1385860384
Rred_1140 vin.$338.Metal1 vin.$575.Metal2 65.6028069289
Rred_1141 vin.$338.Metal1 vin.$94.GatPoly 158.710238626
Rred_1142 vin.$338.Metal1 vin.P10.GatPoly 52.6282325743
Rred_1143 vin.$339.Metal1 vin.$343.Metal1 0.178838571508
Rred_1144 vin.$339.Metal1 vin.$567.Metal2 59.0882403627
Rred_1145 vin.$339.Metal1 vin.$571.Metal2 14.1682801538
Rred_1146 vin.$339.Metal1 vin.$97.GatPoly 23.0008821806
Rred_1147 vin.$343.Metal1 vin.$347.Metal1 0.178799366164
Rred_1148 vin.$343.Metal1 vin.$571.Metal2 14.6154515868
Rred_1149 vin.$343.Metal1 vin.$573.Metal2 148.032817989
Rred_1150 vin.$343.Metal1 vin.$578.Metal2 80.5238780093
Rred_1151 vin.$343.Metal1 vin.$97.GatPoly 58.1666753812
Rred_1152 vin.$346.Metal1 vin.$348.Metal1 0.165
Rred_1153 vin.$346.Metal1 vin.$570.Metal2 35.6129523328
Rred_1154 vin.$346.Metal1 vin.$575.Metal2 10.5257138212
Rred_1155 vin.$347.Metal1 vin.$353.Metal1 0.36146618849
Rred_1156 vin.$347.Metal1 vin.$571.Metal2 33.6812736494
Rred_1157 vin.$347.Metal1 vin.$573.Metal2 57.4004804448
Rred_1158 vin.$347.Metal1 vin.$578.Metal2 11.008714331
Rred_1159 vin.$348.Metal1 vin.$356.Metal1 0.375564027363
Rred_1160 vin.$348.Metal1 vin.$575.Metal2 18.1718095238
Rred_1161 vin.$348.Metal1 vin.$579.Metal2 9.92591643291
Rred_1162 vin.$353.Metal1 vin.$357.Metal1 0.178371493384
Rred_1163 vin.$353.Metal1 vin.$578.Metal2 10.1668380754
Rred_1164 vin.$353.Metal1 vin.$582.Metal2 20.9909233253
Rred_1165 vin.$356.Metal1 vin.$360.Metal1 0.178668868145
Rred_1166 vin.$356.Metal1 vin.$579.Metal2 10.5831998195
Rred_1167 vin.$356.Metal1 vin.$584.Metal2 69.856873987
Rred_1168 vin.$356.Metal1 vin.$586.Metal2 36.3717608362
Rred_1169 vin.$357.Metal1 vin.$365.Metal1 0.362799427562
Rred_1170 vin.$357.Metal1 vin.$578.Metal2 137.607164021
Rred_1171 vin.$357.Metal1 vin.$582.Metal2 10.1082003498
Rred_1172 vin.$357.Metal1 vin.$587.Metal2 40.2164761345
Rred_1173 vin.$36.GatPoly vin.$42.GatPoly 80.7317467344
Rred_1174 vin.$36.GatPoly vin.$508.Metal2 1563.02782058
Rred_1175 vin.$36.GatPoly vin.P4.GatPoly 21.4418885263
Rred_1176 vin.$360.Metal1 vin.$368.Metal1 0.362653569415
Rred_1177 vin.$360.Metal1 vin.$579.Metal2 63.5012825511
Rred_1178 vin.$360.Metal1 vin.$584.Metal2 136.676492583
Rred_1179 vin.$360.Metal1 vin.$586.Metal2 9.91391002973
Rred_1180 vin.$360.Metal1 vin.$590.Metal2 148.012303013
Rred_1181 vin.$365.Metal1 vin.$369.Metal1 0.17857627571
Rred_1182 vin.$365.Metal1 vin.$582.Metal2 54.2048156595
Rred_1183 vin.$365.Metal1 vin.$587.Metal2 10.1293546422
Rred_1184 vin.$365.Metal1 vin.$591.Metal2 72.9543809522
Rred_1185 vin.$365.Metal1 vin.P32.GatPoly 177.329872844
Rred_1186 vin.$368.Metal1 vin.$374.Metal1 0.361824121591
Rred_1187 vin.$368.Metal1 vin.$586.Metal2 12.8905653645
Rred_1188 vin.$368.Metal1 vin.$590.Metal2 9.52216809103
Rred_1189 vin.$368.Metal1 vin.P12.GatPoly 58.2686631016
Rred_1190 vin.$369.Metal1 vin.$375.Metal1 0.361824121591
Rred_1191 vin.$369.Metal1 vin.$587.Metal2 24.3181269841
Rred_1192 vin.$369.Metal1 vin.$591.Metal2 10.1777438502
Rred_1193 vin.$369.Metal1 vin.P32.GatPoly 137.244791849
Rred_1194 vin.$37.GatPoly vin.$43.GatPoly 50.9131933514
Rred_1195 vin.$37.GatPoly vin.$509.Metal2 1563.02782058
Rred_1196 vin.$37.GatPoly vin.P24.GatPoly 63.2364133369
Rred_1197 vin.$374.Metal1 vin.$378.Metal1 0.178374896227
Rred_1198 vin.$374.Metal1 vin.$590.Metal2 19.1286039107
Rred_1199 vin.$374.Metal1 vin.$595.Metal2 10.7656516291
Rred_1200 vin.$374.Metal1 vin.P13.GatPoly 233.378884183
Rred_1201 vin.$375.Metal1 vin.$379.Metal1 0.178398933563
Rred_1202 vin.$375.Metal1 vin.$591.Metal2 19.1286039107
Rred_1203 vin.$375.Metal1 vin.$596.Metal2 10.7656516291
Rred_1204 vin.$378.Metal1 vin.$386.Metal1 0.362797942164
Rred_1205 vin.$378.Metal1 vin.$595.Metal2 15.9997708552
Rred_1206 vin.$378.Metal1 vin.$599.Metal2 14.7413390447
Rred_1207 vin.$378.Metal1 vin.P13.GatPoly 92.2851475241
Rred_1208 vin.$379.Metal1 vin.$383.Metal1 0.178898601437
Rred_1209 vin.$379.Metal1 vin.$387.Metal1 4137.53229591
Rred_1210 vin.$379.Metal1 vin.$596.Metal2 15.7349129944
Rred_1211 vin.$379.Metal1 vin.$603.Metal2 43.4328267333
Rred_1212 vin.$383.Metal1 vin.$387.Metal1 0.178843777497
Rred_1213 vin.$383.Metal1 vin.$596.Metal2 24.1058961615
Rred_1214 vin.$383.Metal1 vin.$603.Metal2 22.3566696457
Rred_1215 vin.$386.Metal1 vin.$392.Metal1 0.358974281487
Rred_1216 vin.$386.Metal1 vin.$595.Metal2 100.688434264
Rred_1217 vin.$386.Metal1 vin.$599.Metal2 10.3514401745
Rred_1218 vin.$386.Metal1 vin.$604.Metal2 15.0113662187
Rred_1219 vin.$387.Metal1 vin.$393.Metal1 0.358969093271
Rred_1220 vin.$387.Metal1 vin.$596.Metal2 49.717844922
Rred_1221 vin.$387.Metal1 vin.$603.Metal2 9.30100123455
Rred_1222 vin.$387.Metal1 vin.$609.Metal2 844.325347394
Rred_1223 vin.$392.Metal1 vin.$396.Metal1 0.180721425263
Rred_1224 vin.$392.Metal1 vin.$400.Metal1 7610.30667437
Rred_1225 vin.$392.Metal1 vin.$604.Metal2 8.62947986197
Rred_1226 vin.$392.Metal1 vin.$610.Metal2 27.6894597146
Rred_1227 vin.$393.Metal1 vin.$397.Metal1 0.180739583769
Rred_1228 vin.$393.Metal1 vin.$603.Metal2 10.4000814367
Rred_1229 vin.$393.Metal1 vin.$609.Metal2 17.6141428574
Rred_1230 vin.$396.Metal1 vin.$400.Metal1 0.178550748274
Rred_1231 vin.$396.Metal1 vin.$604.Metal2 34.3389922323
Rred_1232 vin.$396.Metal1 vin.$610.Metal2 17.0071631934
Rred_1233 vin.$397.Metal1 vin.$401.Metal1 0.178557568839
Rred_1234 vin.$397.Metal1 vin.$609.Metal2 11.1613203463
Rred_1235 vin.$400.Metal1 vin.$408.Metal1 0.362824398622
Rred_1236 vin.$400.Metal1 vin.$604.Metal2 145.280351752
Rred_1237 vin.$400.Metal1 vin.$610.Metal2 9.7817715397
Rred_1238 vin.$400.Metal1 vin.$615.Metal2 46.1776507338
Rred_1239 vin.$401.Metal1 vin.$409.Metal1 0.362824398622
Rred_1240 vin.$401.Metal1 vin.$609.Metal2 47.2209706961
Rred_1241 vin.$401.Metal1 vin.$611.Metal2 11.3207867366
Rred_1242 vin.$401.Metal1 vin.$616.Metal2 46.1776507338
Rred_1243 vin.$408.Metal1 vin.$412.Metal1 0.17852453123
Rred_1244 vin.$408.Metal1 vin.$610.Metal2 46.1776507338
Rred_1245 vin.$408.Metal1 vin.$615.Metal2 10.1192256903
Rred_1246 vin.$408.Metal1 vin.$619.Metal2 95.3406373629
Rred_1247 vin.$408.Metal1 vin.P15.GatPoly 72.1264392205
Rred_1248 vin.$409.Metal1 vin.$413.Metal1 0.178459879632
Rred_1249 vin.$409.Metal1 vin.$611.Metal2 46.1776507338
Rred_1250 vin.$409.Metal1 vin.$616.Metal2 10.1192256903
Rred_1251 vin.$409.Metal1 vin.$620.Metal2 95.3406373629
Rred_1252 vin.$409.Metal1 vin.P35.GatPoly 212.715280069
Rred_1253 vin.$412.Metal1 vin.$418.Metal1 0.36182906056
Rred_1254 vin.$412.Metal1 vin.$615.Metal2 22.5350597402
Rred_1255 vin.$412.Metal1 vin.$619.Metal2 10.1769943283
Rred_1256 vin.$412.Metal1 vin.P15.GatPoly 40.541385869
Rred_1257 vin.$413.Metal1 vin.$419.Metal1 0.36182906056
Rred_1258 vin.$413.Metal1 vin.$616.Metal2 22.5350597402
Rred_1259 vin.$413.Metal1 vin.$620.Metal2 10.1769943283
Rred_1260 vin.$413.Metal1 vin.P35.GatPoly 119.564647066
Rred_1261 vin.$418.Metal1 vin.$422.Metal1 0.178504947966
Rred_1262 vin.$418.Metal1 vin.$619.Metal2 18.0168451015
Rred_1263 vin.$418.Metal1 vin.$624.Metal2 11.5864555256
Rred_1264 vin.$419.Metal1 vin.$423.Metal1 0.178504947966
Rred_1265 vin.$419.Metal1 vin.$620.Metal2 18.0168451015
Rred_1266 vin.$419.Metal1 vin.$625.Metal2 11.5864555256
Rred_1267 vin.$42.GatPoly vin.$44.GatPoly 25.4131134156
Rred_1268 vin.$42.GatPoly vin.$512.Metal2 3870.9558658
Rred_1269 vin.$42.GatPoly vin.$517.Metal2 3870.9558658
Rred_1270 vin.$42.GatPoly vin.P4.GatPoly 38.1468722988
Rred_1271 vin.$422.Metal1 vin.$426.Metal1 0.17894182666
Rred_1272 vin.$422.Metal1 vin.$430.Metal1 4036.92165822
Rred_1273 vin.$422.Metal1 vin.$624.Metal2 15.140503946
Rred_1274 vin.$422.Metal1 vin.$630.Metal2 48.5088769371
Rred_1275 vin.$423.Metal1 vin.$427.Metal1 0.178949087371
Rred_1276 vin.$423.Metal1 vin.$625.Metal2 17.9090803107
Rred_1277 vin.$423.Metal1 vin.$629.Metal2 31.8360854701
Rred_1278 vin.$426.Metal1 vin.$430.Metal1 0.178852088262
Rred_1279 vin.$426.Metal1 vin.$624.Metal2 22.6413748687
Rred_1280 vin.$426.Metal1 vin.$630.Metal2 23.8007022261
Rred_1281 vin.$427.Metal1 vin.$433.Metal1 0.331848942782
Rred_1282 vin.$427.Metal1 vin.$625.Metal2 42.814045977
Rred_1283 vin.$427.Metal1 vin.$629.Metal2 10.4731205828
Rred_1284 vin.$43.GatPoly vin.$47.GatPoly 25.4131134156
Rred_1285 vin.$43.GatPoly vin.$513.Metal2 3870.9558658
Rred_1286 vin.$43.GatPoly vin.$518.Metal2 3870.9558658
Rred_1287 vin.$43.GatPoly vin.P24.GatPoly 112.502748125
Rred_1288 vin.$430.Metal1 vin.$437.Metal1 0.36174266925
Rred_1289 vin.$430.Metal1 vin.$624.Metal2 43.9859302507
Rred_1290 vin.$430.Metal1 vin.$630.Metal2 9.12759240183
Rred_1291 vin.$433.Metal1 vin.$441.Metal1 0.39094415179
Rred_1292 vin.$433.Metal1 vin.$629.Metal2 12.4168010073
Rred_1293 vin.$433.Metal1 vin.$633.Metal2 38.1149573586
Rred_1294 vin.$433.Metal1 vin.$636.Metal2 11.1591689028
Rred_1295 vin.$437.Metal1 vin.$440.Metal1 0.178129923539
Rred_1296 vin.$437.Metal1 vin.$630.Metal2 21.8084097251
Rred_1297 vin.$437.Metal1 vin.$635.Metal2 9.42324175824
Rred_1298 vin.$437.Metal1 vin.P17.GatPoly 81.1351604514
Rred_1299 vin.$44.GatPoly vin.$52.GatPoly 17.2080405764
Rred_1300 vin.$44.GatPoly vin.P5.GatPoly 4.76
Rred_1301 vin.$440.Metal1 vin.$448.Metal1 0.362653569415
Rred_1302 vin.$440.Metal1 vin.$635.Metal2 18.9451496641
Rred_1303 vin.$440.Metal1 vin.$639.Metal2 12.8905653645
Rred_1304 vin.$440.Metal1 vin.P17.GatPoly 36.2581717142
Rred_1305 vin.$441.Metal1 vin.$449.Metal1 0.362653569415
Rred_1306 vin.$441.Metal1 vin.$636.Metal2 9.17818171348
Rred_1307 vin.$441.Metal1 vin.$640.Metal2 12.8905653645
Rred_1308 vin.$448.Metal1 vin.$456.Metal1 0.362310386809
Rred_1309 vin.$448.Metal1 vin.$635.Metal2 148.012303013
Rred_1310 vin.$448.Metal1 vin.$639.Metal2 11.5186194376
Rred_1311 vin.$448.Metal1 vin.$644.Metal2 12.9766510302
Rred_1312 vin.$448.Metal1 vin.$648.Metal2 279.314226443
Rred_1313 vin.$449.Metal1 vin.$453.Metal1 0.178675191093
Rred_1314 vin.$449.Metal1 vin.$636.Metal2 148.012303013
Rred_1315 vin.$449.Metal1 vin.$640.Metal2 11.5186194376
Rred_1316 vin.$449.Metal1 vin.$645.Metal2 26.726552795
Rred_1317 vin.$453.Metal1 vin.$457.Metal1 0.178496116933
Rred_1318 vin.$453.Metal1 vin.$645.Metal2 12.426647102
Rred_1319 vin.$453.Metal1 vin.$649.Metal2 137.607164021
Rred_1320 vin.$456.Metal1 vin.$644.Metal2 11.4454036843
Rred_1321 vin.$456.Metal1 vin.$648.Metal2 6.53320320366
Rred_1322 vin.$456.Metal1 vin.$653.Metal2 5.38299903212
Rred_1323 vin.$456.Metal1 vin.P18.GatPoly 37.76
Rred_1324 vin.$456.Metal1 vin.P19.GatPoly 21.9316993903
Rred_1325 vin.$457.Metal1 vin.$645.Metal2 20.9909233253
Rred_1326 vin.$457.Metal1 vin.$649.Metal2 6.62883717454
Rred_1327 vin.$457.Metal1 vin.$654.Metal2 5.24434565257
Rred_1328 vin.$457.Metal1 vin.P39.GatPoly 41.5022353547
Rred_1329 vin.$47.GatPoly vin.$53.GatPoly 17.2080405764
Rred_1330 vin.$47.GatPoly vin.P25.GatPoly 22.26
Rred_1331 vin.$476.Metal2 vin.$478.Metal2 14.0345533852
Rred_1332 vin.$476.Metal2 vin.$481.Metal2 0.310383427653
Rred_1333 vin.$476.Metal2 vin.$6.GatPoly 133.769710264
Rred_1334 vin.$476.Metal2 vin.P0.GatPoly 181.216908754
Rred_1335 vin.$478.Metal2 vin.$482.Metal2 0.310599868985
Rred_1336 vin.$478.Metal2 vin.$7.GatPoly 388.085789519
Rred_1337 vin.$478.Metal2 vin.P20.GatPoly 654.991948339
Rred_1338 vin.$481.Metal2 vin.$483.Metal2 0.171806729636
Rred_1339 vin.$481.Metal2 vin.$6.GatPoly 1040.63139805
Rred_1340 vin.$481.Metal2 vin.P0.GatPoly 2350.52753623
Rred_1341 vin.$482.Metal2 vin.$486.Metal2 1.47138632148
Rred_1342 vin.$482.Metal2 vin.$489.Metal2 0.42560761365
Rred_1343 vin.$482.Metal2 vin.$7.GatPoly 25055.8390465
Rred_1344 vin.$482.Metal2 vin.$9.GatPoly 1714.75888267
Rred_1345 vin.$483.Metal2 vin.$486.Metal2 0.692446258504
Rred_1346 vin.$483.Metal2 vin.$488.Metal2 0.200294372294
Rred_1347 vin.$486.Metal2 vin.$488.Metal2 0.515651469098
Rred_1348 vin.$486.Metal2 vin.$489.Metal2 0.3964679684
Rred_1349 vin.$486.Metal2 vin.$495.Metal2 0.12144
Rred_1350 vin.$488.Metal2 vin.$492.Metal2 0.346876010592
Rred_1351 vin.$489.Metal2 vin.$493.Metal2 0.346876010592
Rred_1352 vin.$492.Metal2 vin.$495.Metal2 4.31912380951
Rred_1353 vin.$492.Metal2 vin.$497.Metal2 0.178476190476
Rred_1354 vin.$493.Metal2 vin.$495.Metal2 0.643273146381
Rred_1355 vin.$493.Metal2 vin.$500.Metal2 0.463026148652
Rred_1356 vin.$495.Metal2 vin.$497.Metal2 0.280462585034
Rred_1357 vin.$495.Metal2 vin.$500.Metal2 0.727612519313
Rred_1358 vin.$495.Metal2 vin.$506.Metal2 0.12144
Rred_1359 vin.$497.Metal2 vin.$503.Metal2 0.528548299458
Rred_1360 vin.$500.Metal2 vin.$504.Metal2 0.346883084067
Rred_1361 vin.$503.Metal2 vin.$506.Metal2 0.417099415205
Rred_1362 vin.$503.Metal2 vin.$508.Metal2 0.196484848485
Rred_1363 vin.$504.Metal2 vin.$506.Metal2 0.417099415205
Rred_1364 vin.$504.Metal2 vin.$509.Metal2 0.196484848485
Rred_1365 vin.$506.Metal2 vin.$508.Metal2 0.950986666669
Rred_1366 vin.$506.Metal2 vin.$509.Metal2 0.950986666669
Rred_1367 vin.$506.Metal2 vin.$515.Metal2 0.12144
Rred_1368 vin.$508.Metal2 vin.$512.Metal2 0.3468888772
Rred_1369 vin.$509.Metal2 vin.$513.Metal2 0.3468888772
Rred_1370 vin.$512.Metal2 vin.$515.Metal2 0.885199294533
Rred_1371 vin.$512.Metal2 vin.$517.Metal2 0.19751717122
Rred_1372 vin.$513.Metal2 vin.$515.Metal2 0.885199294533
Rred_1373 vin.$513.Metal2 vin.$518.Metal2 0.19751717122
Rred_1374 vin.$515.Metal2 vin.$517.Metal2 0.434552380953
Rred_1375 vin.$515.Metal2 vin.$518.Metal2 0.434552380953
Rred_1376 vin.$515.Metal2 vin.$523.Metal2 0.793988220725
Rred_1377 vin.$515.Metal2 vin.$527.Metal2 0.747094537052
Rred_1378 vin.$515.Metal2 vin.$528.Metal2 20.9083564791
Rred_1379 vin.$515.Metal2 vin.$535.Metal2 0.357864457583
Rred_1380 vin.$517.Metal2 vin.$523.Metal2 0.528590320902
Rred_1381 vin.$518.Metal2 vin.$520.Metal2 0.17180952381
Rred_1382 vin.$52.GatPoly vin.$523.Metal2 1989.57191416
Rred_1383 vin.$52.GatPoly vin.$58.GatPoly 20.0625185185
Rred_1384 vin.$520.Metal2 vin.$527.Metal2 0.353544628822
Rred_1385 vin.$520.Metal2 vin.$53.GatPoly 111904.93744
Rred_1386 vin.$523.Metal2 vin.$527.Metal2 1.65756685141
Rred_1387 vin.$523.Metal2 vin.$528.Metal2 0.17524885292
Rred_1388 vin.$523.Metal2 vin.$535.Metal2 0.793988220725
Rred_1389 vin.$527.Metal2 vin.$528.Metal2 43.6492604206
Rred_1390 vin.$527.Metal2 vin.$53.GatPoly 2027.68731673
Rred_1391 vin.$527.Metal2 vin.$533.Metal2 0.521902039577
Rred_1392 vin.$527.Metal2 vin.$535.Metal2 0.747094537052
Rred_1393 vin.$528.Metal2 vin.$532.Metal2 0.346869470833
Rred_1394 vin.$528.Metal2 vin.$535.Metal2 20.9083564791
Rred_1395 vin.$528.Metal2 vin.$58.GatPoly 2525.70222612
Rred_1396 vin.$53.GatPoly vin.$57.GatPoly 26.7507621399
Rred_1397 vin.$532.Metal2 vin.$535.Metal2 0.493407191448
Rred_1398 vin.$532.Metal2 vin.$537.Metal2 0.19980952381
Rred_1399 vin.$532.Metal2 vin.$58.GatPoly 8439.59448869
Rred_1400 vin.$533.Metal2 vin.$535.Metal2 0.493407191448
Rred_1401 vin.$533.Metal2 vin.$538.Metal2 0.19980952381
Rred_1402 vin.$535.Metal2 vin.$537.Metal2 0.732634920637
Rred_1403 vin.$535.Metal2 vin.$538.Metal2 0.732634920637
Rred_1404 vin.$535.Metal2 vin.$544.Metal2 0.12144
Rred_1405 vin.$537.Metal2 vin.$541.Metal2 0.346876010592
Rred_1406 vin.$537.Metal2 vin.$64.GatPoly 1611.09899248
Rred_1407 vin.$537.Metal2 vin.$70.GatPoly 12405.3841055
Rred_1408 vin.$538.Metal2 vin.$542.Metal2 0.346886758096
Rred_1409 vin.$538.Metal2 vin.$65.GatPoly 1611.09899248
Rred_1410 vin.$541.Metal2 vin.$544.Metal2 0.546093875877
Rred_1411 vin.$541.Metal2 vin.$548.Metal2 0.457460174986
Rred_1412 vin.$541.Metal2 vin.$70.GatPoly 2301.94136839
Rred_1413 vin.$542.Metal2 vin.$544.Metal2 1.22615538847
Rred_1414 vin.$542.Metal2 vin.$547.Metal2 0.192530627203
Rred_1415 vin.$542.Metal2 vin.$73.GatPoly 3372.27982918
Rred_1416 vin.$544.Metal2 vin.$547.Metal2 0.369792894936
Rred_1417 vin.$544.Metal2 vin.$548.Metal2 0.878613986878
Rred_1418 vin.$544.Metal2 vin.$555.Metal2 0.12144
Rred_1419 vin.$547.Metal2 vin.$551.Metal2 0.346891446111
Rred_1420 vin.$547.Metal2 vin.$73.GatPoly 4543.078818
Rred_1421 vin.$548.Metal2 vin.$552.Metal2 0.346898882339
Rred_1422 vin.$548.Metal2 vin.$78.GatPoly 1714.75888267
Rred_1423 vin.$548.Metal2 vin.$80.GatPoly 25055.8390465
Rred_1424 vin.$551.Metal2 vin.$555.Metal2 0.786467062936
Rred_1425 vin.$551.Metal2 vin.$558.Metal2 0.461480673293
Rred_1426 vin.$551.Metal2 vin.$77.GatPoly 3154.05582356
Rred_1427 vin.$551.Metal2 vin.$83.GatPoly 5361.89490005
Rred_1428 vin.$552.Metal2 vin.$555.Metal2 0.315849765258
Rred_1429 vin.$552.Metal2 vin.$557.Metal2 0.185328000708
Rred_1430 vin.$552.Metal2 vin.$84.GatPoly 5498.19357361
Rred_1431 vin.$555.Metal2 vin.$557.Metal2 2.03866666667
Rred_1432 vin.$555.Metal2 vin.$558.Metal2 0.599073779942
Rred_1433 vin.$555.Metal2 vin.$564.Metal2 0.12144
Rred_1434 vin.$557.Metal2 vin.$561.Metal2 0.346865293749
Rred_1435 vin.$557.Metal2 vin.$84.GatPoly 2987.58348254
Rred_1436 vin.$557.Metal2 vin.$90.GatPoly 4494.85080275
Rred_1437 vin.$558.Metal2 vin.$562.Metal2 0.346885087058
Rred_1438 vin.$561.Metal2 vin.$564.Metal2 0.592952380953
Rred_1439 vin.$561.Metal2 vin.$566.Metal2 0.200917748918
Rred_1440 vin.$561.Metal2 vin.$90.GatPoly 3453.79724991
Rred_1441 vin.$562.Metal2 vin.$564.Metal2 0.592952380953
Rred_1442 vin.$562.Metal2 vin.$567.Metal2 0.200917748918
Rred_1443 vin.$562.Metal2 vin.$93.GatPoly 1716.610141
Rred_1444 vin.$564.Metal2 vin.$566.Metal2 0.592952380953
Rred_1445 vin.$564.Metal2 vin.$567.Metal2 0.592952380953
Rred_1446 vin.$564.Metal2 vin.$573.Metal2 0.12144
Rred_1447 vin.$566.Metal2 vin.$570.Metal2 0.346885087058
Rred_1448 vin.$566.Metal2 vin.$94.GatPoly 1716.610141
Rred_1449 vin.$567.Metal2 vin.$571.Metal2 0.346885087058
Rred_1450 vin.$57.GatPoly vin.$65.GatPoly 36.1143032099
Rred_1451 vin.$57.GatPoly vin.P26.GatPoly 22.26
Rred_1452 vin.$570.Metal2 vin.$573.Metal2 2.03866666667
Rred_1453 vin.$570.Metal2 vin.$575.Metal2 0.185328000708
Rred_1454 vin.$571.Metal2 vin.$573.Metal2 0.599073779942
Rred_1455 vin.$571.Metal2 vin.$578.Metal2 0.461480673293
Rred_1456 vin.$573.Metal2 vin.$575.Metal2 0.315849765258
Rred_1457 vin.$573.Metal2 vin.$578.Metal2 0.786467062936
Rred_1458 vin.$573.Metal2 vin.$584.Metal2 0.12144
Rred_1459 vin.$575.Metal2 vin.$579.Metal2 0.346898882339
Rred_1460 vin.$578.Metal2 vin.$582.Metal2 0.346891446111
Rred_1461 vin.$579.Metal2 vin.$584.Metal2 0.878613986878
Rred_1462 vin.$579.Metal2 vin.$586.Metal2 0.457460174986
Rred_1463 vin.$58.GatPoly vin.$64.GatPoly 60.50563664
Rred_1464 vin.$58.GatPoly vin.P6.GatPoly 7.97486881396
Rred_1465 vin.$582.Metal2 vin.$584.Metal2 0.369792894936
Rred_1466 vin.$582.Metal2 vin.$587.Metal2 0.192530627203
Rred_1467 vin.$584.Metal2 vin.$586.Metal2 0.546093875877
Rred_1468 vin.$584.Metal2 vin.$587.Metal2 1.22615538847
Rred_1469 vin.$584.Metal2 vin.$593.Metal2 0.12144
Rred_1470 vin.$586.Metal2 vin.$590.Metal2 0.346876010592
Rred_1471 vin.$587.Metal2 vin.$591.Metal2 0.346886758096
Rred_1472 vin.$590.Metal2 vin.$593.Metal2 0.732634920637
Rred_1473 vin.$590.Metal2 vin.$595.Metal2 0.19980952381
Rred_1474 vin.$591.Metal2 vin.$593.Metal2 0.732634920637
Rred_1475 vin.$591.Metal2 vin.$596.Metal2 0.19980952381
Rred_1476 vin.$593.Metal2 vin.$595.Metal2 0.493407191448
Rred_1477 vin.$593.Metal2 vin.$596.Metal2 0.493407191448
Rred_1478 vin.$593.Metal2 vin.$599.Metal2 20.9083564791
Rred_1479 vin.$593.Metal2 vin.$603.Metal2 0.747094537052
Rred_1480 vin.$593.Metal2 vin.$604.Metal2 0.793988220725
Rred_1481 vin.$593.Metal2 vin.$613.Metal2 0.357864457583
Rred_1482 vin.$595.Metal2 vin.$599.Metal2 0.346869470833
Rred_1483 vin.$596.Metal2 vin.$603.Metal2 0.521902039577
Rred_1484 vin.$599.Metal2 vin.$603.Metal2 43.6492604206
Rred_1485 vin.$599.Metal2 vin.$604.Metal2 0.17524885292
Rred_1486 vin.$599.Metal2 vin.$613.Metal2 20.9083564791
Rred_1487 vin.$6.GatPoly vin.P0.GatPoly 86.6998579537
Rred_1488 vin.$6.GatPoly vin.P1.GatPoly 19.9708444444
Rred_1489 vin.$603.Metal2 vin.$604.Metal2 1.65756685141
Rred_1490 vin.$603.Metal2 vin.$609.Metal2 0.353544628822
Rred_1491 vin.$603.Metal2 vin.$613.Metal2 0.747094537052
Rred_1492 vin.$604.Metal2 vin.$610.Metal2 0.528590320902
Rred_1493 vin.$604.Metal2 vin.$613.Metal2 0.793988220725
Rred_1494 vin.$609.Metal2 vin.$611.Metal2 0.17180952381
Rred_1495 vin.$610.Metal2 vin.$613.Metal2 0.434552380953
Rred_1496 vin.$610.Metal2 vin.$615.Metal2 0.19751717122
Rred_1497 vin.$611.Metal2 vin.$613.Metal2 0.434552380953
Rred_1498 vin.$611.Metal2 vin.$616.Metal2 0.19751717122
Rred_1499 vin.$613.Metal2 vin.$615.Metal2 0.885199294533
Rred_1500 vin.$613.Metal2 vin.$616.Metal2 0.885199294533
Rred_1501 vin.$613.Metal2 vin.$622.Metal2 0.12144
Rred_1502 vin.$615.Metal2 vin.$619.Metal2 0.3468888772
Rred_1503 vin.$616.Metal2 vin.$620.Metal2 0.3468888772
Rred_1504 vin.$619.Metal2 vin.$622.Metal2 0.950986666669
Rred_1505 vin.$619.Metal2 vin.$624.Metal2 0.196484848485
Rred_1506 vin.$620.Metal2 vin.$622.Metal2 0.950986666669
Rred_1507 vin.$620.Metal2 vin.$625.Metal2 0.196484848485
Rred_1508 vin.$622.Metal2 vin.$624.Metal2 0.417099415205
Rred_1509 vin.$622.Metal2 vin.$625.Metal2 0.417099415205
Rred_1510 vin.$622.Metal2 vin.$633.Metal2 0.12144
Rred_1511 vin.$624.Metal2 vin.$630.Metal2 0.528548299458
Rred_1512 vin.$625.Metal2 vin.$629.Metal2 0.346883084067
Rred_1513 vin.$629.Metal2 vin.$633.Metal2 0.727612519313
Rred_1514 vin.$629.Metal2 vin.$636.Metal2 0.463026148652
Rred_1515 vin.$630.Metal2 vin.$633.Metal2 0.280462585034
Rred_1516 vin.$630.Metal2 vin.$635.Metal2 0.178476190476
Rred_1517 vin.$633.Metal2 vin.$635.Metal2 4.31912380951
Rred_1518 vin.$633.Metal2 vin.$636.Metal2 0.643273146381
Rred_1519 vin.$633.Metal2 vin.$642.Metal2 0.12144
Rred_1520 vin.$635.Metal2 vin.$639.Metal2 0.346876010592
Rred_1521 vin.$636.Metal2 vin.$640.Metal2 0.346876010592
Rred_1522 vin.$639.Metal2 vin.$642.Metal2 0.515651469098
Rred_1523 vin.$639.Metal2 vin.$644.Metal2 0.200294372294
Rred_1524 vin.$64.GatPoly vin.$70.GatPoly 33.2347189542
Rred_1525 vin.$64.GatPoly vin.P6.GatPoly 123.431498746
Rred_1526 vin.$64.GatPoly vin.P7.GatPoly 30.8176484848
Rred_1527 vin.$640.Metal2 vin.$642.Metal2 0.515651469098
Rred_1528 vin.$640.Metal2 vin.$645.Metal2 0.200294372294
Rred_1529 vin.$642.Metal2 vin.$644.Metal2 0.692446258504
Rred_1530 vin.$642.Metal2 vin.$645.Metal2 0.692446258504
Rred_1531 vin.$642.Metal2 vin.$648.Metal2 2.98963708333
Rred_1532 vin.$642.Metal2 vin.$649.Metal2 3.5599249307
Rred_1533 vin.$642.Metal2 vin.$653.Metal2 0.781905083333
Rred_1534 vin.$642.Metal2 vin.$654.Metal2 0.931057289569
Rred_1535 vin.$644.Metal2 vin.$648.Metal2 0.346885244507
Rred_1536 vin.$645.Metal2 vin.$649.Metal2 0.346891446111
Rred_1537 vin.$648.Metal2 vin.$649.Metal2 53.5446887191
Rred_1538 vin.$648.Metal2 vin.$653.Metal2 0.182222484268
Rred_1539 vin.$648.Metal2 vin.$654.Metal2 14.0039955112
Rred_1540 vin.$648.Metal2 vin.P19.GatPoly 1031.5624039
Rred_1541 vin.$649.Metal2 vin.$653.Metal2 14.0039955112
Rred_1542 vin.$649.Metal2 vin.$654.Metal2 0.180819600935
Rred_1543 vin.$649.Metal2 vin.P39.GatPoly 1960.12022876
Rred_1544 vin.$65.GatPoly vin.$73.GatPoly 51.4620406015
Rred_1545 vin.$65.GatPoly vin.P27.GatPoly 72.5872454666
Rred_1546 vin.$653.Metal2 vin.$654.Metal2 3.66258344139
Rred_1547 vin.$653.Metal2 vin.P19.GatPoly 199.325141092
Rred_1548 vin.$654.Metal2 vin.P39.GatPoly 395.072001344
Rred_1549 vin.$7.GatPoly vin.$9.GatPoly 7.93159272489
Rred_1550 vin.$7.GatPoly vin.P20.GatPoly 200.155301199
Rred_1551 vin.$70.GatPoly vin.$78.GatPoly 42.8025468312
Rred_1552 vin.$70.GatPoly vin.P7.GatPoly 12.9518899643
Rred_1553 vin.$73.GatPoly vin.$77.GatPoly 29.4260595885
Rred_1554 vin.$73.GatPoly vin.P27.GatPoly 93.7877994151
Rred_1555 vin.$77.GatPoly vin.$83.GatPoly 15.0537042157
Rred_1556 vin.$77.GatPoly vin.P28.GatPoly 22.26
Rred_1557 vin.$78.GatPoly vin.$80.GatPoly 11.1325184116
Rred_1558 vin.$78.GatPoly vin.P8.GatPoly 11.3586666667
Rred_1559 vin.$80.GatPoly vin.$84.GatPoly 20.0625185185
Rred_1560 vin.$80.GatPoly vin.P8.GatPoly 16.2266666667
Rred_1561 vin.$83.GatPoly vin.$87.GatPoly 30.7637083127
Rred_1562 vin.$84.GatPoly vin.$90.GatPoly 32.0988583878
Rred_1563 vin.$84.GatPoly vin.P9.GatPoly 36.3787061728
Rred_1564 vin.$87.GatPoly vin.$93.GatPoly 14.3546666667
Rred_1565 vin.$87.GatPoly vin.P29.GatPoly 22.26
Rred_1566 vin.$9.GatPoly vin.P21.GatPoly 22.26
Rred_1567 vin.$90.GatPoly vin.$94.GatPoly 20.0625185185
Rred_1568 vin.$90.GatPoly vin.P9.GatPoly 11.2006811616
Rred_1569 vin.$93.GatPoly vin.$97.GatPoly 32.101357037
Rred_1570 vin.$94.GatPoly vin.P10.GatPoly 29.2903280591
Rred_1571 vin.$97.GatPoly vin.P30.GatPoly 22.26
Rred_1572 vout vout.$1424.Metal3 0.132586666667
Rred_1573 vout vout.P18.nSD 10.3439838345
Rred_1574 vout vout.P18.pSD 1.96368321577
Rred_1575 vout.$1226.Metal3 vout.$1292.Metal3 0.340332136788
Rred_1576 vout.$1226.Metal3 vout.P0.nSD 13.3422870835
Rred_1577 vout.$1226.Metal3 vout.P0.pSD 2.51085853912
Rred_1578 vout.$1226.Metal3 vout.P2.nSD 12.2645927271
Rred_1579 vout.$1226.Metal3 vout.P2.pSD 2.24411350379
Rred_1580 vout.$1226.Metal3 vout.P4.nSD 10.2779838345
Rred_1581 vout.$1226.Metal3 vout.P4.pSD 1.88061379842
Rred_1582 vout.$1226.Metal3 vout.P6.nSD 21.6028174423
Rred_1583 vout.$1226.Metal3 vout.P6.pSD 3.95277490422
Rred_1584 vout.$1292.Metal3 vout.$1358.Metal3 0.34020673713
Rred_1585 vout.$1292.Metal3 vout.P10.nSD 21.5948576124
Rred_1586 vout.$1292.Metal3 vout.P10.pSD 3.98718265158
Rred_1587 vout.$1292.Metal3 vout.P6.nSD 21.6028174423
Rred_1588 vout.$1292.Metal3 vout.P6.pSD 3.95277490422
Rred_1589 vout.$1292.Metal3 vout.P8.nSD 10.2779838345
Rred_1590 vout.$1292.Metal3 vout.P8.pSD 1.88061379842
Rred_1591 vout.$1358.Metal3 vout.$1424.Metal3 0.34020673713
Rred_1592 vout.$1358.Metal3 vout.P10.nSD 21.5948576124
Rred_1593 vout.$1358.Metal3 vout.P10.pSD 3.98718265158
Rred_1594 vout.$1358.Metal3 vout.P12.nSD 10.2779838345
Rred_1595 vout.$1358.Metal3 vout.P12.pSD 1.89768321577
Rred_1596 vout.$1358.Metal3 vout.P14.nSD 21.5948576124
Rred_1597 vout.$1358.Metal3 vout.P14.pSD 3.98718265158
Rred_1598 vout.$1424.Metal3 vout.P14.nSD 21.5948576124
Rred_1599 vout.$1424.Metal3 vout.P14.pSD 3.98718265158
Rred_1600 vout.$1424.Metal3 vout.P16.nSD 10.2779838345
Rred_1601 vout.$1424.Metal3 vout.P16.pSD 1.89768321577
Rred_1602 vout.P0.nSD vout.P0.pSD 84.3225466509
Rred_1603 vout.P0.nSD vout.P2.nSD 846.910887838
Rred_1604 vout.P0.nSD vout.P2.pSD 154.963495502
Rred_1605 vout.P0.pSD vout.P2.nSD 159.378479963
Rred_1606 vout.P0.pSD vout.P2.pSD 29.1622728172
Rred_1607 vout.P10.nSD vout.P10.pSD 253.089172665
Rred_1608 vout.P14.nSD vout.P14.pSD 253.089172665
Rred_1609 vout.P2.nSD vout.P2.pSD 142.446654611
Rred_1610 vout.P6.nSD vout.P6.pSD 250.905117137
Rred_1611 VSS VSS.$1196.Metal3 0.0855397484114
Rred_1612 VSS VSS.$1217.Metal3 0.0855397484114
Rred_1613 VSS VSS.$269.Metal1 1335.95113153
Rred_1614 VSS VSS.$294.Metal1 1335.95113153
Rred_1615 VSS VSS.$805.Metal2 5.34500865323
Rred_1616 VSS VSS.$818.Metal2 2.64858745346
Rred_1617 VSS VSS.$826.Metal2 2.64858745346
Rred_1618 VSS VSS.$840.Metal2 5.34500865323
Rred_1619 VSS.$1002.Metal2 VSS.$1010.Metal2 0.0241063349611
Rred_1620 VSS.$1002.Metal2 VSS.$1283.Metal3 2.59007321156
Rred_1621 VSS.$1002.Metal2 VSS.$1292.Metal3 9.09640618761
Rred_1622 VSS.$1002.Metal2 VSS.$448.Metal1 3.7770714324
Rred_1623 VSS.$1002.Metal2 VSS.$453.Metal1 2.26229116801
Rred_1624 VSS.$1002.Metal2 VSS.$987.Metal2 0.0484923752296
Rred_1625 VSS.$1002.Metal2 VSS.P0.pSD 9485.44026575
Rred_1626 VSS.$1002.Metal2 VSS.P19.nSD 139.403003311
Rred_1627 VSS.$1010.Metal2 VSS.$1022.Metal2 0.0484923752296
Rred_1628 VSS.$1010.Metal2 VSS.$1283.Metal3 9.09640618761
Rred_1629 VSS.$1010.Metal2 VSS.$1292.Metal3 2.59007321156
Rred_1630 VSS.$1010.Metal2 VSS.$453.Metal1 2.72599957429
Rred_1631 VSS.$1010.Metal2 VSS.$471.Metal1 3.49223384788
Rred_1632 VSS.$1010.Metal2 VSS.P0.pSD 6716.86096755
Rred_1633 VSS.$1010.Metal2 VSS.P19.nSD 187.198318732
Rred_1634 VSS.$1022.Metal2 VSS.$1034.Metal2 0.0484923752296
Rred_1635 VSS.$1022.Metal2 VSS.$1292.Metal3 3.01802801866
Rred_1636 VSS.$1022.Metal2 VSS.$1298.Metal3 3.01802801866
Rred_1637 VSS.$1022.Metal2 VSS.$471.Metal1 3.01974283614
Rred_1638 VSS.$1022.Metal2 VSS.$483.Metal1 3.01971402219
Rred_1639 VSS.$1022.Metal2 VSS.P0.pSD 3135.41320954
Rred_1640 VSS.$1034.Metal2 VSS.$1040.Metal2 0.0240522932358
Rred_1641 VSS.$1034.Metal2 VSS.$1298.Metal3 2.59007321156
Rred_1642 VSS.$1034.Metal2 VSS.$1307.Metal3 9.09640618761
Rred_1643 VSS.$1034.Metal2 VSS.$483.Metal1 2.59239467043
Rred_1644 VSS.$1034.Metal2 VSS.$498.Metal1 9.1238147974
Rred_1645 VSS.$1034.Metal2 VSS.P0.pSD 1755.63484102
Rred_1646 VSS.$1040.Metal2 VSS.$1055.Metal2 0.051071228228
Rred_1647 VSS.$1040.Metal2 VSS.$1298.Metal3 9.09640618761
Rred_1648 VSS.$1040.Metal2 VSS.$1307.Metal3 2.53685126265
Rred_1649 VSS.$1040.Metal2 VSS.$483.Metal1 9.11679557973
Rred_1650 VSS.$1040.Metal2 VSS.$498.Metal1 2.53962814341
Rred_1651 VSS.$1040.Metal2 VSS.P0.pSD 1755.06325379
Rred_1652 VSS.$1055.Metal2 VSS.$1066.Metal2 0.103454652464
Rred_1653 VSS.$1055.Metal2 VSS.$1307.Metal3 1.32412383031
Rred_1654 VSS.$1055.Metal2 VSS.$498.Metal1 2.95445918098
Rred_1655 VSS.$1055.Metal2 VSS.$501.Metal1 6.94018416518
Rred_1656 VSS.$1055.Metal2 VSS.$520.Metal1 3.25556260562
Rred_1657 VSS.$1055.Metal2 VSS.P0.pSD 19850.6262899
Rred_1658 VSS.$1066.Metal2 VSS.$1307.Metal3 1.0932358819
Rred_1659 VSS.$1066.Metal2 VSS.$501.Metal1 1.39748077477
Rred_1660 VSS.$1066.Metal2 VSS.$509.Metal1 0.997337569251
Rred_1661 VSS.$1066.Metal2 VSS.$520.Metal1 4.99621969686
Rred_1662 VSS.$1066.Metal2 VSS.$551.Metal1 62.4616340464
Rred_1663 VSS.$1066.Metal2 VSS.P0.pSD 1005.08870278
Rred_1664 VSS.$1066.Metal2 VSS.P21.nSD 301.318005877
Rred_1665 VSS.$1066.Metal2 VSS.P23.nSD 301.318005877
Rred_1666 VSS.$1106.Metal3 VSS.$1115.Metal3 0.0729329633886
Rred_1667 VSS.$1106.Metal3 VSS.$18.Metal1 250.623499579
Rred_1668 VSS.$1106.Metal3 VSS.$44.Metal1 159.234944846
Rred_1669 VSS.$1106.Metal3 VSS.$564.Metal2 1.09325648866
Rred_1670 VSS.$1106.Metal3 VSS.$590.Metal2 1.32382337512
Rred_1671 VSS.$1106.Metal3 VSS.$605.Metal2 2.53685126265
Rred_1672 VSS.$1106.Metal3 VSS.$611.Metal2 9.09640618761
Rred_1673 VSS.$1106.Metal3 VSS.$65.Metal1 718.572763736
Rred_1674 VSS.$1115.Metal3 VSS.$1121.Metal3 0.0482995209481
Rred_1675 VSS.$1115.Metal3 VSS.$605.Metal2 9.09640618761
Rred_1676 VSS.$1115.Metal3 VSS.$611.Metal2 2.59007321156
Rred_1677 VSS.$1115.Metal3 VSS.$623.Metal2 3.01802801866
Rred_1678 VSS.$1115.Metal3 VSS.$80.Metal1 754.337028826
Rred_1679 VSS.$1121.Metal3 VSS.$1130.Metal3 0.0729329633886
Rred_1680 VSS.$1121.Metal3 VSS.$623.Metal2 3.01802801866
Rred_1681 VSS.$1121.Metal3 VSS.$636.Metal2 2.59007321156
Rred_1682 VSS.$1121.Metal3 VSS.$644.Metal2 9.09640618761
Rred_1683 VSS.$1121.Metal3 VSS.$92.Metal1 754.337028826
Rred_1684 VSS.$1130.Metal3 VSS.$1142.Metal3 0.0981480735474
Rred_1685 VSS.$1130.Metal3 VSS.$115.Metal1 754.337028826
Rred_1686 VSS.$1130.Metal3 VSS.$127.Metal1 1532.86667717
Rred_1687 VSS.$1130.Metal3 VSS.$636.Metal2 9.09640618761
Rred_1688 VSS.$1130.Metal3 VSS.$644.Metal2 2.59007321156
Rred_1689 VSS.$1130.Metal3 VSS.$658.Metal2 2.02265962076
Rred_1690 VSS.$1130.Metal3 VSS.$670.Metal2 6.13284832082
Rred_1691 VSS.$1142.Metal3 VSS.$1154.Metal3 0.0981511661222
Rred_1692 VSS.$1142.Metal3 VSS.$127.Metal1 1532.86667717
Rred_1693 VSS.$1142.Metal3 VSS.$137.Metal1 754.337028826
Rred_1694 VSS.$1142.Metal3 VSS.$658.Metal2 6.13284832082
Rred_1695 VSS.$1142.Metal3 VSS.$670.Metal2 2.02265962076
Rred_1696 VSS.$1142.Metal3 VSS.$685.Metal2 2.42113023107
Rred_1697 VSS.$1142.Metal3 VSS.$693.Metal2 6.09640618761
Rred_1698 VSS.$1142.Metal3 VSS.$699.Metal2 12.2416920053
Rred_1699 VSS.$115.Metal1 VSS.$127.Metal1 0.0503800743211
Rred_1700 VSS.$115.Metal1 VSS.$644.Metal2 3.7770714324
Rred_1701 VSS.$115.Metal1 VSS.$658.Metal2 3.01967577385
Rred_1702 VSS.$115.Metal1 VSS.$97.Metal1 0.0358581386467
Rred_1703 VSS.$115.Metal1 VSS.P0.pSD 8.1616300373
Rred_1704 VSS.$1154.Metal3 VSS.$1163.Metal3 0.0729329633886
Rred_1705 VSS.$1154.Metal3 VSS.$167.Metal1 754.337028826
Rred_1706 VSS.$1154.Metal3 VSS.$685.Metal2 12.2416920053
Rred_1707 VSS.$1154.Metal3 VSS.$693.Metal2 6.09640618761
Rred_1708 VSS.$1154.Metal3 VSS.$699.Metal2 2.42113023107
Rred_1709 VSS.$1154.Metal3 VSS.$711.Metal2 2.59007321156
Rred_1710 VSS.$1154.Metal3 VSS.$717.Metal2 9.09640618761
Rred_1711 VSS.$1163.Metal3 VSS.$1172.Metal3 0.0729329633886
Rred_1712 VSS.$1163.Metal3 VSS.$184.Metal1 754.337028826
Rred_1713 VSS.$1163.Metal3 VSS.$711.Metal2 9.09640618761
Rred_1714 VSS.$1163.Metal3 VSS.$717.Metal2 2.59007321156
Rred_1715 VSS.$1163.Metal3 VSS.$732.Metal2 2.59007321156
Rred_1716 VSS.$1163.Metal3 VSS.$740.Metal2 9.09640618761
Rred_1717 VSS.$1172.Metal3 VSS.$1178.Metal3 0.0482995209481
Rred_1718 VSS.$1172.Metal3 VSS.$207.Metal1 754.337028826
Rred_1719 VSS.$1172.Metal3 VSS.$732.Metal2 9.09640618761
Rred_1720 VSS.$1172.Metal3 VSS.$740.Metal2 2.59007321156
Rred_1721 VSS.$1172.Metal3 VSS.$752.Metal2 3.01802801866
Rred_1722 VSS.$1178.Metal3 VSS.$1190.Metal3 0.0981511661222
Rred_1723 VSS.$1178.Metal3 VSS.$219.Metal1 754.337028826
Rred_1724 VSS.$1178.Metal3 VSS.$752.Metal2 3.01802801866
Rred_1725 VSS.$1178.Metal3 VSS.$764.Metal2 2.42113023107
Rred_1726 VSS.$1178.Metal3 VSS.$770.Metal2 6.09640618761
Rred_1727 VSS.$1178.Metal3 VSS.$779.Metal2 12.2416920053
Rred_1728 VSS.$1190.Metal3 VSS.$1196.Metal3 0.0482995209481
Rred_1729 VSS.$1190.Metal3 VSS.$247.Metal1 754.337028826
Rred_1730 VSS.$1190.Metal3 VSS.$764.Metal2 12.2416920053
Rred_1731 VSS.$1190.Metal3 VSS.$770.Metal2 6.09640618761
Rred_1732 VSS.$1190.Metal3 VSS.$779.Metal2 2.42113023107
Rred_1733 VSS.$1190.Metal3 VSS.$793.Metal2 3.01802801866
Rred_1734 VSS.$1196.Metal3 VSS.$259.Metal1 754.337028826
Rred_1735 VSS.$1196.Metal3 VSS.$269.Metal1 1783.64213282
Rred_1736 VSS.$1196.Metal3 VSS.$793.Metal2 3.01802801866
Rred_1737 VSS.$1196.Metal3 VSS.$805.Metal2 2.12101108372
Rred_1738 VSS.$1196.Metal3 VSS.$818.Metal2 8.56224982524
Rred_1739 VSS.$1217.Metal3 VSS.$1223.Metal3 0.0482995209481
Rred_1740 VSS.$1217.Metal3 VSS.$294.Metal1 1783.64213282
Rred_1741 VSS.$1217.Metal3 VSS.$304.Metal1 754.337028826
Rred_1742 VSS.$1217.Metal3 VSS.$826.Metal2 8.56224982524
Rred_1743 VSS.$1217.Metal3 VSS.$840.Metal2 2.12101108372
Rred_1744 VSS.$1217.Metal3 VSS.$852.Metal2 3.01802801866
Rred_1745 VSS.$1223.Metal3 VSS.$1235.Metal3 0.0981511661222
Rred_1746 VSS.$1223.Metal3 VSS.$314.Metal1 754.337028826
Rred_1747 VSS.$1223.Metal3 VSS.$852.Metal2 3.01802801866
Rred_1748 VSS.$1223.Metal3 VSS.$867.Metal2 2.42113023107
Rred_1749 VSS.$1223.Metal3 VSS.$875.Metal2 6.09640618761
Rred_1750 VSS.$1223.Metal3 VSS.$881.Metal2 12.2416920053
Rred_1751 VSS.$1235.Metal3 VSS.$1241.Metal3 0.0482995209481
Rred_1752 VSS.$1235.Metal3 VSS.$344.Metal1 754.337028826
Rred_1753 VSS.$1235.Metal3 VSS.$867.Metal2 12.2416920053
Rred_1754 VSS.$1235.Metal3 VSS.$875.Metal2 6.09640618761
Rred_1755 VSS.$1235.Metal3 VSS.$881.Metal2 2.42113023107
Rred_1756 VSS.$1235.Metal3 VSS.$893.Metal2 3.01802801866
Rred_1757 VSS.$1241.Metal3 VSS.$1250.Metal3 0.0729329633886
Rred_1758 VSS.$1241.Metal3 VSS.$356.Metal1 754.337028826
Rred_1759 VSS.$1241.Metal3 VSS.$893.Metal2 3.01802801866
Rred_1760 VSS.$1241.Metal3 VSS.$905.Metal2 2.59007321156
Rred_1761 VSS.$1241.Metal3 VSS.$914.Metal2 9.09640618761
Rred_1762 VSS.$1250.Metal3 VSS.$1259.Metal3 0.0729329633886
Rred_1763 VSS.$1250.Metal3 VSS.$379.Metal1 754.337028826
Rred_1764 VSS.$1250.Metal3 VSS.$905.Metal2 9.09640618761
Rred_1765 VSS.$1250.Metal3 VSS.$914.Metal2 2.59007321156
Rred_1766 VSS.$1250.Metal3 VSS.$928.Metal2 2.59007321156
Rred_1767 VSS.$1250.Metal3 VSS.$934.Metal2 9.09640618761
Rred_1768 VSS.$1259.Metal3 VSS.$1271.Metal3 0.0981511661222
Rred_1769 VSS.$1259.Metal3 VSS.$396.Metal1 754.337028826
Rred_1770 VSS.$1259.Metal3 VSS.$928.Metal2 9.09640618761
Rred_1771 VSS.$1259.Metal3 VSS.$934.Metal2 2.59007321156
Rred_1772 VSS.$1259.Metal3 VSS.$946.Metal2 2.42113023107
Rred_1773 VSS.$1259.Metal3 VSS.$952.Metal2 6.09640618761
Rred_1774 VSS.$1259.Metal3 VSS.$961.Metal2 12.2416920053
Rred_1775 VSS.$127.Metal1 VSS.$137.Metal1 0.0503816845649
Rred_1776 VSS.$127.Metal1 VSS.$658.Metal2 3.019631914
Rred_1777 VSS.$127.Metal1 VSS.$670.Metal2 3.01948047742
Rred_1778 VSS.$127.Metal1 VSS.P0.pSD 7.11445842696
Rred_1779 VSS.$1271.Metal3 VSS.$1283.Metal3 0.0981480735474
Rred_1780 VSS.$1271.Metal3 VSS.$426.Metal1 754.337028826
Rred_1781 VSS.$1271.Metal3 VSS.$436.Metal1 1532.86667717
Rred_1782 VSS.$1271.Metal3 VSS.$946.Metal2 12.2416920053
Rred_1783 VSS.$1271.Metal3 VSS.$952.Metal2 6.09640618761
Rred_1784 VSS.$1271.Metal3 VSS.$961.Metal2 2.42113023107
Rred_1785 VSS.$1271.Metal3 VSS.$975.Metal2 2.02265962076
Rred_1786 VSS.$1271.Metal3 VSS.$987.Metal2 6.13284832082
Rred_1787 VSS.$1283.Metal3 VSS.$1292.Metal3 0.0729329633886
Rred_1788 VSS.$1283.Metal3 VSS.$436.Metal1 1532.86667717
Rred_1789 VSS.$1283.Metal3 VSS.$448.Metal1 754.337028826
Rred_1790 VSS.$1283.Metal3 VSS.$975.Metal2 6.13284832082
Rred_1791 VSS.$1283.Metal3 VSS.$987.Metal2 2.02265962076
Rred_1792 VSS.$1292.Metal3 VSS.$1298.Metal3 0.0482995209481
Rred_1793 VSS.$1292.Metal3 VSS.$471.Metal1 754.337028826
Rred_1794 VSS.$1298.Metal3 VSS.$1307.Metal3 0.0729329633886
Rred_1795 VSS.$1298.Metal3 VSS.$483.Metal1 754.337028826
Rred_1796 VSS.$1307.Metal3 VSS.$498.Metal1 718.572763736
Rred_1797 VSS.$1307.Metal3 VSS.$501.Metal1 123.25915125
Rred_1798 VSS.$1307.Metal3 VSS.$520.Metal1 432.239320916
Rred_1799 VSS.$137.Metal1 VSS.$142.Metal1 0.0327769863206
Rred_1800 VSS.$137.Metal1 VSS.$670.Metal2 3.01958494445
Rred_1801 VSS.$137.Metal1 VSS.$685.Metal2 4.11465861119
Rred_1802 VSS.$137.Metal1 VSS.P0.pSD 8.58558123775
Rred_1803 VSS.$142.Metal1 VSS.$167.Metal1 0.0683250058824
Rred_1804 VSS.$142.Metal1 VSS.$685.Metal2 1.9666454863
Rred_1805 VSS.$142.Metal1 VSS.$693.Metal2 2.8010161252
Rred_1806 VSS.$142.Metal1 VSS.$699.Metal2 8.17787238273
Rred_1807 VSS.$142.Metal1 VSS.P0.pSD 7.04259645641
Rred_1808 VSS.$142.Metal1 VSS.P5.nSD 6.30788530775
Rred_1809 VSS.$167.Metal1 VSS.$184.Metal1 0.0762090520027
Rred_1810 VSS.$167.Metal1 VSS.$693.Metal2 11.7676017942
Rred_1811 VSS.$167.Metal1 VSS.$699.Metal2 2.67778185654
Rred_1812 VSS.$167.Metal1 VSS.$711.Metal2 2.59268795112
Rred_1813 VSS.$167.Metal1 VSS.$717.Metal2 9.12272515148
Rred_1814 VSS.$167.Metal1 VSS.P0.pSD 5.02273893954
Rred_1815 VSS.$18.Metal1 VSS.$40.Metal1 0.0318980239163
Rred_1816 VSS.$18.Metal1 VSS.$44.Metal1 0.0987257678086
Rred_1817 VSS.$18.Metal1 VSS.$551.Metal1 19457.8182619
Rred_1818 VSS.$18.Metal1 VSS.$564.Metal2 2.14424645913
Rred_1819 VSS.$18.Metal1 VSS.$590.Metal2 14.108492174
Rred_1820 VSS.$18.Metal1 VSS.P0.pSD 1.1847833052
Rred_1821 VSS.$184.Metal1 VSS.$192.Metal1 0.0250630082153
Rred_1822 VSS.$184.Metal1 VSS.$711.Metal2 9.12157587534
Rred_1823 VSS.$184.Metal1 VSS.$717.Metal2 2.59271359665
Rred_1824 VSS.$184.Metal1 VSS.$732.Metal2 6.04810666667
Rred_1825 VSS.$184.Metal1 VSS.P0.pSD 6.90274731842
Rred_1826 VSS.$192.Metal1 VSS.$195.Metal1 0.167409064586
Rred_1827 VSS.$192.Metal1 VSS.$207.Metal1 0.0506589847236
Rred_1828 VSS.$192.Metal1 VSS.$732.Metal2 3
Rred_1829 VSS.$192.Metal1 VSS.$740.Metal2 6.06349778471
Rred_1830 VSS.$192.Metal1 VSS.P0.pSD 9.73144918941
Rred_1831 VSS.$195.Metal1 VSS.$207.Metal1 9.03177327646
Rred_1832 VSS.$195.Metal1 VSS.$732.Metal2 2.59732263903
Rred_1833 VSS.$195.Metal1 VSS.$740.Metal2 64.3262932227
Rred_1834 VSS.$195.Metal1 VSS.P0.pSD 2949.4084597
Rred_1835 VSS.$195.Metal1 VSS.P7.nSD 5.76848282367
Rred_1836 VSS.$207.Metal1 VSS.$219.Metal1 0.0503803330447
Rred_1837 VSS.$207.Metal1 VSS.$740.Metal2 3.01971984652
Rred_1838 VSS.$207.Metal1 VSS.$752.Metal2 3.01974283614
Rred_1839 VSS.$207.Metal1 VSS.P0.pSD 7.07871769757
Rred_1840 VSS.$219.Metal1 VSS.$232.Metal1 0.0702143752481
Rred_1841 VSS.$219.Metal1 VSS.$752.Metal2 3.01971402219
Rred_1842 VSS.$219.Metal1 VSS.$764.Metal2 2.65496903055
Rred_1843 VSS.$219.Metal1 VSS.$770.Metal2 10.9394227231
Rred_1844 VSS.$219.Metal1 VSS.P0.pSD 5.88287853378
Rred_1845 VSS.$232.Metal1 VSS.$247.Metal1 0.0309221197347
Rred_1846 VSS.$232.Metal1 VSS.$764.Metal2 8.40441758816
Rred_1847 VSS.$232.Metal1 VSS.$770.Metal2 3.08894169111
Rred_1848 VSS.$232.Metal1 VSS.$779.Metal2 1.81641905763
Rred_1849 VSS.$232.Metal1 VSS.P0.pSD 7.38084443077
Rred_1850 VSS.$232.Metal1 VSS.P10.nSD 6.30803357837
Rred_1851 VSS.$247.Metal1 VSS.$259.Metal1 0.0503777081793
Rred_1852 VSS.$247.Metal1 VSS.$779.Metal2 4.38743601401
Rred_1853 VSS.$247.Metal1 VSS.$793.Metal2 3.01950933626
Rred_1854 VSS.$247.Metal1 VSS.P0.pSD 8.20885719669
Rred_1855 VSS.$259.Metal1 VSS.$269.Metal1 0.0503811526048
Rred_1856 VSS.$259.Metal1 VSS.$793.Metal2 3.01967731838
Rred_1857 VSS.$259.Metal1 VSS.$805.Metal2 3.01961271281
Rred_1858 VSS.$259.Metal1 VSS.P0.pSD 7.26225858493
Rred_1859 VSS.$269.Metal1 VSS.$275.Metal1 0.0250609268302
Rred_1860 VSS.$269.Metal1 VSS.$805.Metal2 3.01946597019
Rred_1861 VSS.$269.Metal1 VSS.$818.Metal2 6.04783313429
Rred_1862 VSS.$269.Metal1 VSS.P0.pSD 9.6323051046
Rred_1863 VSS.$275.Metal1 VSS.$285.Metal1 0.025137675271
Rred_1864 VSS.$275.Metal1 VSS.$818.Metal2 2.35731732677
Rred_1865 VSS.$275.Metal1 VSS.$826.Metal2 11.0038005922
Rred_1866 VSS.$275.Metal1 VSS.P0.pSD 14.8304595603
Rred_1867 VSS.$275.Metal1 VSS.P11.nSD 12.6567850552
Rred_1868 VSS.$285.Metal1 VSS.$294.Metal1 0.0250609268302
Rred_1869 VSS.$285.Metal1 VSS.$818.Metal2 11.0038005922
Rred_1870 VSS.$285.Metal1 VSS.$826.Metal2 2.35731732677
Rred_1871 VSS.$285.Metal1 VSS.P0.pSD 14.8304595603
Rred_1872 VSS.$285.Metal1 VSS.P11.nSD 12.6567850552
Rred_1873 VSS.$294.Metal1 VSS.$304.Metal1 0.0503811526048
Rred_1874 VSS.$294.Metal1 VSS.$826.Metal2 6.04783313429
Rred_1875 VSS.$294.Metal1 VSS.$840.Metal2 3.01946597019
Rred_1876 VSS.$294.Metal1 VSS.P0.pSD 9.6323051046
Rred_1877 VSS.$304.Metal1 VSS.$314.Metal1 0.0503777081793
Rred_1878 VSS.$304.Metal1 VSS.$840.Metal2 3.01961271281
Rred_1879 VSS.$304.Metal1 VSS.$852.Metal2 3.01967731838
Rred_1880 VSS.$304.Metal1 VSS.P0.pSD 7.26225858493
Rred_1881 VSS.$314.Metal1 VSS.$319.Metal1 0.0309221197347
Rred_1882 VSS.$314.Metal1 VSS.$852.Metal2 3.01950933626
Rred_1883 VSS.$314.Metal1 VSS.$867.Metal2 4.38743601401
Rred_1884 VSS.$314.Metal1 VSS.P0.pSD 8.20885719669
Rred_1885 VSS.$319.Metal1 VSS.$344.Metal1 0.0702143752481
Rred_1886 VSS.$319.Metal1 VSS.$867.Metal2 1.81641905763
Rred_1887 VSS.$319.Metal1 VSS.$875.Metal2 3.08894169111
Rred_1888 VSS.$319.Metal1 VSS.$881.Metal2 8.40441758816
Rred_1889 VSS.$319.Metal1 VSS.P0.pSD 7.38084443077
Rred_1890 VSS.$319.Metal1 VSS.P13.nSD 6.30803357837
Rred_1891 VSS.$344.Metal1 VSS.$356.Metal1 0.0503803330447
Rred_1892 VSS.$344.Metal1 VSS.$875.Metal2 10.9394227231
Rred_1893 VSS.$344.Metal1 VSS.$881.Metal2 2.65496903055
Rred_1894 VSS.$344.Metal1 VSS.$893.Metal2 3.01971402219
Rred_1895 VSS.$344.Metal1 VSS.P0.pSD 5.88287853378
Rred_1896 VSS.$356.Metal1 VSS.$369.Metal1 0.0506589847236
Rred_1897 VSS.$356.Metal1 VSS.$372.Metal1 9.03177327646
Rred_1898 VSS.$356.Metal1 VSS.$893.Metal2 3.01974283614
Rred_1899 VSS.$356.Metal1 VSS.$905.Metal2 3.01971984652
Rred_1900 VSS.$356.Metal1 VSS.P0.pSD 7.07871769757
Rred_1901 VSS.$369.Metal1 VSS.$372.Metal1 0.167409064586
Rred_1902 VSS.$369.Metal1 VSS.$379.Metal1 0.0250630082153
Rred_1903 VSS.$369.Metal1 VSS.$905.Metal2 6.06349778471
Rred_1904 VSS.$369.Metal1 VSS.$914.Metal2 3
Rred_1905 VSS.$369.Metal1 VSS.P0.pSD 9.73144918941
Rred_1906 VSS.$372.Metal1 VSS.$905.Metal2 64.3262932227
Rred_1907 VSS.$372.Metal1 VSS.$914.Metal2 2.59732263903
Rred_1908 VSS.$372.Metal1 VSS.P0.pSD 2949.4084597
Rred_1909 VSS.$372.Metal1 VSS.P15.nSD 5.76848282367
Rred_1910 VSS.$379.Metal1 VSS.$396.Metal1 0.0762090520027
Rred_1911 VSS.$379.Metal1 VSS.$914.Metal2 6.04810666667
Rred_1912 VSS.$379.Metal1 VSS.$928.Metal2 2.59271359665
Rred_1913 VSS.$379.Metal1 VSS.$934.Metal2 9.12157587534
Rred_1914 VSS.$379.Metal1 VSS.P0.pSD 6.90274731842
Rred_1915 VSS.$396.Metal1 VSS.$409.Metal1 0.0683250058824
Rred_1916 VSS.$396.Metal1 VSS.$928.Metal2 9.12272515148
Rred_1917 VSS.$396.Metal1 VSS.$934.Metal2 2.59268795112
Rred_1918 VSS.$396.Metal1 VSS.$946.Metal2 2.67778185654
Rred_1919 VSS.$396.Metal1 VSS.$952.Metal2 11.7676017942
Rred_1920 VSS.$396.Metal1 VSS.P0.pSD 5.02273893954
Rred_1921 VSS.$40.Metal1 VSS.$551.Metal1 50188.2285435
Rred_1922 VSS.$40.Metal1 VSS.$564.Metal2 1.07399788472
Rred_1923 VSS.$40.Metal1 VSS.P0.GatPoly 10.81
Rred_1924 VSS.$40.Metal1 VSS.P0.nSD 5.83762681657
Rred_1925 VSS.$40.Metal1 VSS.P0.pSD 5.96693251408
Rred_1926 VSS.$40.Metal1 VSS.P1.nSD 5.83762681657
Rred_1927 VSS.$409.Metal1 VSS.$426.Metal1 0.0327769863206
Rred_1928 VSS.$409.Metal1 VSS.$946.Metal2 8.17787238273
Rred_1929 VSS.$409.Metal1 VSS.$952.Metal2 2.8010161252
Rred_1930 VSS.$409.Metal1 VSS.$961.Metal2 1.9666454863
Rred_1931 VSS.$409.Metal1 VSS.P0.pSD 7.04259645641
Rred_1932 VSS.$409.Metal1 VSS.P17.nSD 6.30788530775
Rred_1933 VSS.$426.Metal1 VSS.$436.Metal1 0.0503816845649
Rred_1934 VSS.$426.Metal1 VSS.$961.Metal2 4.11465861119
Rred_1935 VSS.$426.Metal1 VSS.$975.Metal2 3.01958494445
Rred_1936 VSS.$426.Metal1 VSS.P0.pSD 8.58558123775
Rred_1937 VSS.$436.Metal1 VSS.$448.Metal1 0.0503800743211
Rred_1938 VSS.$436.Metal1 VSS.$975.Metal2 3.01948047742
Rred_1939 VSS.$436.Metal1 VSS.$987.Metal2 3.019631914
Rred_1940 VSS.$436.Metal1 VSS.P0.pSD 7.11445842696
Rred_1941 VSS.$44.Metal1 VSS.$564.Metal2 1.90397533486
Rred_1942 VSS.$44.Metal1 VSS.$590.Metal2 2.64734467394
Rred_1943 VSS.$44.Metal1 VSS.$65.Metal1 0.0614259096926
Rred_1944 VSS.$44.Metal1 VSS.P0.pSD 221.142882408
Rred_1945 VSS.$448.Metal1 VSS.$453.Metal1 0.0358581386467
Rred_1946 VSS.$448.Metal1 VSS.$987.Metal2 3.01967577385
Rred_1947 VSS.$448.Metal1 VSS.P0.pSD 8.1616300373
Rred_1948 VSS.$453.Metal1 VSS.$471.Metal1 0.0395650532209
Rred_1949 VSS.$453.Metal1 VSS.P0.pSD 9.3483204091
Rred_1950 VSS.$453.Metal1 VSS.P19.nSD 6.30774233271
Rred_1951 VSS.$471.Metal1 VSS.$483.Metal1 0.0503803330447
Rred_1952 VSS.$471.Metal1 VSS.P0.pSD 8.00989158551
Rred_1953 VSS.$483.Metal1 VSS.$498.Metal1 0.0762245508578
Rred_1954 VSS.$483.Metal1 VSS.P0.pSD 5.6382048292
Rred_1955 VSS.$498.Metal1 VSS.$520.Metal1 0.0614259096926
Rred_1956 VSS.$498.Metal1 VSS.P0.pSD 6.98493275728
Rred_1957 VSS.$501.Metal1 VSS.$509.Metal1 0.0936634849612
Rred_1958 VSS.$501.Metal1 VSS.$520.Metal1 0.0484688122519
Rred_1959 VSS.$501.Metal1 VSS.$551.Metal1 0.41870548608
Rred_1960 VSS.$501.Metal1 VSS.P0.pSD 6.73751432021
Rred_1961 VSS.$509.Metal1 VSS.$551.Metal1 0.167228127478
Rred_1962 VSS.$509.Metal1 VSS.P0.pSD 4.71741315312
Rred_1963 VSS.$509.Metal1 VSS.P1.GatPoly 10.81
Rred_1964 VSS.$509.Metal1 VSS.P21.nSD 5.83762681657
Rred_1965 VSS.$509.Metal1 VSS.P23.nSD 5.83762681657
Rred_1966 VSS.$520.Metal1 VSS.P0.pSD 221.142882408
Rred_1967 VSS.$551.Metal1 VSS.P0.pSD 1.45104546928
Rred_1968 VSS.$564.Metal2 VSS.$590.Metal2 0.10355477652
Rred_1969 VSS.$564.Metal2 VSS.P0.nSD 301.318005877
Rred_1970 VSS.$564.Metal2 VSS.P1.nSD 301.318005877
Rred_1971 VSS.$590.Metal2 VSS.$605.Metal2 0.051071228228
Rred_1972 VSS.$590.Metal2 VSS.$65.Metal1 2.95445918098
Rred_1973 VSS.$590.Metal2 VSS.P0.pSD 19850.6262899
Rred_1974 VSS.$605.Metal2 VSS.$611.Metal2 0.0240522932358
Rred_1975 VSS.$605.Metal2 VSS.$65.Metal1 2.53962814341
Rred_1976 VSS.$605.Metal2 VSS.$80.Metal1 9.11679557973
Rred_1977 VSS.$605.Metal2 VSS.P0.pSD 1755.06325379
Rred_1978 VSS.$611.Metal2 VSS.$623.Metal2 0.0484923752296
Rred_1979 VSS.$611.Metal2 VSS.$65.Metal1 9.1238147974
Rred_1980 VSS.$611.Metal2 VSS.$80.Metal1 2.59239467043
Rred_1981 VSS.$611.Metal2 VSS.P0.pSD 1755.63484102
Rred_1982 VSS.$623.Metal2 VSS.$636.Metal2 0.0484923752296
Rred_1983 VSS.$623.Metal2 VSS.$80.Metal1 3.01971402219
Rred_1984 VSS.$623.Metal2 VSS.$92.Metal1 3.01974283614
Rred_1985 VSS.$623.Metal2 VSS.P0.pSD 3135.41320954
Rred_1986 VSS.$636.Metal2 VSS.$644.Metal2 0.0241063349611
Rred_1987 VSS.$636.Metal2 VSS.$92.Metal1 3.49223384788
Rred_1988 VSS.$636.Metal2 VSS.$97.Metal1 2.72599957429
Rred_1989 VSS.$636.Metal2 VSS.P0.pSD 6716.86096755
Rred_1990 VSS.$636.Metal2 VSS.P3.nSD 187.198318732
Rred_1991 VSS.$644.Metal2 VSS.$658.Metal2 0.0484923752296
Rred_1992 VSS.$644.Metal2 VSS.$97.Metal1 2.26229116801
Rred_1993 VSS.$644.Metal2 VSS.P0.pSD 9485.44026575
Rred_1994 VSS.$644.Metal2 VSS.P3.nSD 139.403003311
Rred_1995 VSS.$65.Metal1 VSS.$80.Metal1 0.0762245508578
Rred_1996 VSS.$65.Metal1 VSS.P0.pSD 6.98493275728
Rred_1997 VSS.$658.Metal2 VSS.$670.Metal2 0.048486239739
Rred_1998 VSS.$658.Metal2 VSS.P0.pSD 3195.13122738
Rred_1999 VSS.$670.Metal2 VSS.$685.Metal2 0.0484923752296
Rred_2000 VSS.$670.Metal2 VSS.P0.pSD 3494.79852872
Rred_2001 VSS.$685.Metal2 VSS.$693.Metal2 0.0240989264962
Rred_2002 VSS.$685.Metal2 VSS.$699.Metal2 1526.81857051
Rred_2003 VSS.$685.Metal2 VSS.P0.pSD 8945.64126452
Rred_2004 VSS.$685.Metal2 VSS.P5.nSD 114.91221067
Rred_2005 VSS.$693.Metal2 VSS.$699.Metal2 0.024052161712
Rred_2006 VSS.$693.Metal2 VSS.P0.pSD 2314.81399662
Rred_2007 VSS.$693.Metal2 VSS.P5.nSD 261.999840327
Rred_2008 VSS.$699.Metal2 VSS.$711.Metal2 0.0484923752296
Rred_2009 VSS.$699.Metal2 VSS.P0.pSD 1995.73669521
Rred_2010 VSS.$711.Metal2 VSS.$717.Metal2 0.0240522935581
Rred_2011 VSS.$711.Metal2 VSS.P0.pSD 1703.0815892
Rred_2012 VSS.$717.Metal2 VSS.$732.Metal2 0.0484923752296
Rred_2013 VSS.$717.Metal2 VSS.P0.pSD 1652.72593386
Rred_2014 VSS.$732.Metal2 VSS.$740.Metal2 0.0240610199399
Rred_2015 VSS.$732.Metal2 VSS.P7.nSD 474.710255865
Rred_2016 VSS.$740.Metal2 VSS.$752.Metal2 0.0484923752296
Rred_2017 VSS.$740.Metal2 VSS.P0.pSD 3495.42631106
Rred_2018 VSS.$740.Metal2 VSS.P7.nSD 12500.7034044
Rred_2019 VSS.$752.Metal2 VSS.$764.Metal2 0.0484923752296
Rred_2020 VSS.$752.Metal2 VSS.P0.pSD 3135.41320954
Rred_2021 VSS.$764.Metal2 VSS.$770.Metal2 0.0240521306384
Rred_2022 VSS.$764.Metal2 VSS.$779.Metal2 1526.81857051
Rred_2023 VSS.$764.Metal2 VSS.P0.pSD 1968.63194526
Rred_2024 VSS.$770.Metal2 VSS.$779.Metal2 0.0240915098495
Rred_2025 VSS.$770.Metal2 VSS.P0.pSD 2242.65392533
Rred_2026 VSS.$770.Metal2 VSS.P10.nSD 344.630533059
Rred_2027 VSS.$779.Metal2 VSS.$793.Metal2 0.0484923752296
Rred_2028 VSS.$779.Metal2 VSS.P0.pSD 13268.7698479
Rred_2029 VSS.$779.Metal2 VSS.P10.nSD 103.93619251
Rred_2030 VSS.$793.Metal2 VSS.$805.Metal2 0.0484923752296
Rred_2031 VSS.$793.Metal2 VSS.P0.pSD 3458.67092853
Rred_2032 VSS.$80.Metal1 VSS.$92.Metal1 0.0503803330447
Rred_2033 VSS.$80.Metal1 VSS.P0.pSD 5.6382048292
Rred_2034 VSS.$805.Metal2 VSS.$818.Metal2 0.0484879804286
Rred_2035 VSS.$805.Metal2 VSS.P0.pSD 3494.78766436
Rred_2036 VSS.$818.Metal2 VSS.$826.Metal2 0.0241078976447
Rred_2037 VSS.$818.Metal2 VSS.P11.nSD 155.330735642
Rred_2038 VSS.$826.Metal2 VSS.$840.Metal2 0.0484879804286
Rred_2039 VSS.$826.Metal2 VSS.P11.nSD 155.330735642
Rred_2040 VSS.$840.Metal2 VSS.$852.Metal2 0.0484923752296
Rred_2041 VSS.$840.Metal2 VSS.P0.pSD 3494.78766436
Rred_2042 VSS.$852.Metal2 VSS.$867.Metal2 0.0484923752296
Rred_2043 VSS.$852.Metal2 VSS.P0.pSD 3458.67092853
Rred_2044 VSS.$867.Metal2 VSS.$875.Metal2 0.0240915098495
Rred_2045 VSS.$867.Metal2 VSS.$881.Metal2 1526.81857051
Rred_2046 VSS.$867.Metal2 VSS.P0.pSD 13268.7698479
Rred_2047 VSS.$867.Metal2 VSS.P13.nSD 103.93619251
Rred_2048 VSS.$875.Metal2 VSS.$881.Metal2 0.0240521306384
Rred_2049 VSS.$875.Metal2 VSS.P0.pSD 2242.65392533
Rred_2050 VSS.$875.Metal2 VSS.P13.nSD 344.630533059
Rred_2051 VSS.$881.Metal2 VSS.$893.Metal2 0.0484923752296
Rred_2052 VSS.$881.Metal2 VSS.P0.pSD 1968.63194526
Rred_2053 VSS.$893.Metal2 VSS.$905.Metal2 0.0484923752296
Rred_2054 VSS.$893.Metal2 VSS.P0.pSD 3135.41320954
Rred_2055 VSS.$905.Metal2 VSS.$914.Metal2 0.0240610199399
Rred_2056 VSS.$905.Metal2 VSS.P0.pSD 3495.42631106
Rred_2057 VSS.$905.Metal2 VSS.P15.nSD 12500.7034044
Rred_2058 VSS.$914.Metal2 VSS.$928.Metal2 0.0484923752296
Rred_2059 VSS.$914.Metal2 VSS.P15.nSD 474.710255865
Rred_2060 VSS.$92.Metal1 VSS.$97.Metal1 0.0395650532209
Rred_2061 VSS.$92.Metal1 VSS.P0.pSD 8.00989158551
Rred_2062 VSS.$928.Metal2 VSS.$934.Metal2 0.0240522935581
Rred_2063 VSS.$928.Metal2 VSS.P0.pSD 1652.72593386
Rred_2064 VSS.$934.Metal2 VSS.$946.Metal2 0.0484923752296
Rred_2065 VSS.$934.Metal2 VSS.P0.pSD 1703.0815892
Rred_2066 VSS.$946.Metal2 VSS.$952.Metal2 0.024052161712
Rred_2067 VSS.$946.Metal2 VSS.$961.Metal2 1526.81857051
Rred_2068 VSS.$946.Metal2 VSS.P0.pSD 1995.73669521
Rred_2069 VSS.$952.Metal2 VSS.$961.Metal2 0.0240989264962
Rred_2070 VSS.$952.Metal2 VSS.P0.pSD 2314.81399662
Rred_2071 VSS.$952.Metal2 VSS.P17.nSD 261.999840327
Rred_2072 VSS.$961.Metal2 VSS.$975.Metal2 0.0484923752296
Rred_2073 VSS.$961.Metal2 VSS.P0.pSD 8945.64126452
Rred_2074 VSS.$961.Metal2 VSS.P17.nSD 114.91221067
Rred_2075 VSS.$97.Metal1 VSS.P0.pSD 9.3483204091
Rred_2076 VSS.$97.Metal1 VSS.P3.nSD 6.30774233271
Rred_2077 VSS.$975.Metal2 VSS.$987.Metal2 0.048486239739
Rred_2078 VSS.$975.Metal2 VSS.P0.pSD 3494.79852872
Rred_2079 VSS.$987.Metal2 VSS.P0.pSD 3195.13122738
Rred_2080 VSS.P0.nSD VSS.P1.nSD 1081.46283191
Rred_2081 VSS.P21.nSD VSS.P23.nSD 1081.46283191
.ENDS inverter_pex

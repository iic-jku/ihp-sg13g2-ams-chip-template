* NGSPICE file created from inverter_pex.ext - technology: ihp-sg13g2

.subckt inverter_pex VDD vin vout VSS
X0 VSS.t18 vin vout VSS.t17 sg13_lv_nmos ad=0.19p pd=1.38u as=0.19p ps=1.38u w=1u l=1u
X1 VSS.t36 VSS.t34 VSS.t30 VSS.t35 sg13_lv_nmos ad=0.19p pd=1.38u as=0 ps=0 w=1u l=1u
X2 vout vin VDD VDD sg13_lv_pmos ad=1.14p pd=6.38u as=1.14p ps=6.38u w=6u l=1u
X3 VDD vin vout VDD sg13_lv_pmos ad=1.14p pd=6.38u as=1.14p ps=6.38u w=6u l=1u
X4 vout vin VDD VDD sg13_lv_pmos ad=1.14p pd=6.38u as=1.14p ps=6.38u w=6u l=1u
X5 vout vin VSS.t15 VSS.t16 sg13_lv_nmos ad=0.19p pd=1.38u as=0.19p ps=1.38u w=1u l=1u
X6 vout vin VSS.t1 VSS.t0 sg13_lv_nmos ad=0.19p pd=1.38u as=0.19p ps=1.38u w=1u l=1u
X7 vout vin VDD VDD sg13_lv_pmos ad=1.14p pd=6.38u as=1.14p ps=6.38u w=6u l=1u
X8 VSS.t1 VSS.t31 VSS.t33 VSS.t32 sg13_lv_nmos ad=0.34p pd=2.68u as=0 ps=0 w=1u l=1u
X9 VSS.t24 vin vout VSS.t23 sg13_lv_nmos ad=0.19p pd=1.38u as=0.19p ps=1.38u w=1u l=1u
X10 vout vin VSS.t21 VSS.t22 sg13_lv_nmos ad=0.19p pd=1.38u as=0.19p ps=1.38u w=1u l=1u
X11 VDD vin vout VDD sg13_lv_pmos ad=1.14p pd=6.38u as=1.14p ps=6.38u w=6u l=1u
X12 vout vin VDD VDD sg13_lv_pmos ad=1.14p pd=6.38u as=1.14p ps=6.38u w=6u l=1u
X13 VSS.t9 vin vout VSS.t8 sg13_lv_nmos ad=0.19p pd=1.38u as=0.19p ps=1.38u w=1u l=1u
X14 VSS.t30 vin vout VSS.t29 sg13_lv_nmos ad=0.19p pd=1.38u as=0.19p ps=1.38u w=1u l=1u
X15 VDD vin vout VDD sg13_lv_pmos ad=1.14p pd=6.38u as=1.14p ps=6.38u w=6u l=1u
X16 vout vin VDD VDD sg13_lv_pmos ad=1.14p pd=6.38u as=1.14p ps=6.38u w=6u l=1u
X17 VDD vin vout VDD sg13_lv_pmos ad=1.14p pd=6.38u as=1.14p ps=6.38u w=6u l=1u
X18 vout vin VDD VDD sg13_lv_pmos ad=1.14p pd=6.38u as=1.14p ps=6.38u w=6u l=1u
X19 VSS.t15 vin vout VSS.t14 sg13_lv_nmos ad=0.19p pd=1.38u as=0.19p ps=1.38u w=1u l=1u
X20 vout vin VSS.t27 VSS.t28 sg13_lv_nmos ad=0.19p pd=1.38u as=0.19p ps=1.38u w=1u l=1u
X21 VDD vin vout VDD sg13_lv_pmos ad=1.14p pd=6.38u as=1.14p ps=6.38u w=6u l=1u
X22 vout vin VDD VDD sg13_lv_pmos ad=1.14p pd=6.38u as=1.14p ps=6.38u w=6u l=1u
X23 VDD VDD VDD VDD sg13_lv_pmos ad=2.04p pd=12.68u as=0.14199n ps=0.28418m w=6u l=1u
X24 vout vin VSS.t6 VSS.t7 sg13_lv_nmos ad=0.19p pd=1.38u as=0.19p ps=1.38u w=1u l=1u
X25 VSS.t21 vin vout VSS.t20 sg13_lv_nmos ad=0.19p pd=1.38u as=0.19p ps=1.38u w=1u l=1u
X26 VDD vin vout VDD sg13_lv_pmos ad=1.14p pd=6.38u as=1.14p ps=6.38u w=6u l=1u
X27 VDD vin vout VDD sg13_lv_pmos ad=1.14p pd=6.38u as=1.14p ps=6.38u w=6u l=1u
X28 VSS.t6 vin vout VSS.t5 sg13_lv_nmos ad=0.19p pd=1.38u as=0.19p ps=1.38u w=1u l=1u
X29 vout vin VDD VDD sg13_lv_pmos ad=1.14p pd=6.38u as=1.14p ps=6.38u w=6u l=1u
X30 VSS.t27 vin vout VSS.t26 sg13_lv_nmos ad=0.19p pd=1.38u as=0.19p ps=1.38u w=1u l=1u
X31 VSS.t3 vin vout VSS.t2 sg13_lv_nmos ad=0.19p pd=1.38u as=0.19p ps=1.38u w=1u l=1u
X32 vout vin VSS.t12 VSS.t13 sg13_lv_nmos ad=0.19p pd=1.38u as=0.19p ps=1.38u w=1u l=1u
X33 vout vin VSS.t3 VSS.t4 sg13_lv_nmos ad=0.19p pd=1.38u as=0.19p ps=1.38u w=1u l=1u
X34 vout vin VSS.t24 VSS.t25 sg13_lv_nmos ad=0.19p pd=1.38u as=0.19p ps=1.38u w=1u l=1u
X35 VDD vin vout VDD sg13_lv_pmos ad=1.14p pd=6.38u as=1.14p ps=6.38u w=6u l=1u
X36 vout vin VDD VDD sg13_lv_pmos ad=1.14p pd=6.38u as=1.14p ps=6.38u w=6u l=1u
X37 VSS.t12 vin vout VSS.t11 sg13_lv_nmos ad=0.19p pd=1.38u as=0.19p ps=1.38u w=1u l=1u
X38 VDD vin vout VDD sg13_lv_pmos ad=1.14p pd=6.38u as=1.14p ps=6.38u w=6u l=1u
X39 VDD VDD VDD VDD sg13_lv_pmos ad=1.14p pd=6.38u as=0 ps=0 w=6u l=1u
X40 vout vin VDD VDD sg13_lv_pmos ad=1.14p pd=6.38u as=1.14p ps=6.38u w=6u l=1u
X41 VDD vin vout VDD sg13_lv_pmos ad=1.14p pd=6.38u as=1.14p ps=6.38u w=6u l=1u
X42 vout vin VSS.t9 VSS.t10 sg13_lv_nmos ad=0.19p pd=1.38u as=0.19p ps=1.38u w=1u l=1u
X43 vout vin VSS.t18 VSS.t19 sg13_lv_nmos ad=0.19p pd=1.38u as=0.19p ps=1.38u w=1u l=1u
C0 vin VDD 28.614f
C1 vout VDD 15.0304f
C2 vin vout 18.1624f
R0 VSS.n1 VSS.t28 25.8419
R1 VSS.n1 VSS.t26 33.0469
R2 VSS.n1 VSS.t23 43.855
R3 VSS.n1 VSS.t14 49.8602
R4 VSS.t25 VSS.n1 39.0515
R5 VSS.n1 VSS.t5 39.0512
R6 VSS.n1 VSS.t22 47.4577
R7 VSS.t19 VSS.n1 51.0614
R8 VSS.n1 VSS.t16 49.8592
R9 VSS.n1 VSS.t7 43.8554
R10 VSS.n1 VSS.t4 33.0467
R11 VSS.n1 VSS.t2 25.8412
R12 VSS.n5 VSS.n3 0.0308526
R13 VSS.n3 VSS.t30 5.6685
R14 VSS.t36 VSS.n5 5.66454
R15 VSS.n4 VSS.n8 0.0201203
R16 VSS.t1 VSS.n8 5.66454
R17 VSS.n4 VSS.t33 5.66678
R18 VSS.t35 VSS.n1 7.82627
R19 VSS.t10 VSS.n1 49.8595
R20 VSS.n1 VSS.t13 51.0609
R21 VSS.t20 VSS.n1 49.8599
R22 VSS.n1 VSS.t29 17.4347
R23 VSS.n1 VSS.t0 17.4339
R24 VSS.n3 VSS.n1 1.14366
R25 VSS.n6 VSS.t34 0.0144953
R26 VSS.n7 VSS.t31 0.0144953
R27 VSS.n29 VSS.t3 2.4821
R28 VSS.n30 VSS.t6 2.4821
R29 VSS.n31 VSS.t9 2.4821
R30 VSS.n12 VSS.t12 2.4821
R31 VSS.t18 VSS.n11 2.4821
R32 VSS.n24 VSS.t21 2.4821
R33 VSS.n25 VSS.t24 2.4821
R34 VSS.t27 VSS.n26 2.4821
R35 VSS.n1 VSS.n28 2.09947
R36 VSS.n1 VSS.n21 2.09947
R37 VSS.n1 VSS.n20 2.09947
R38 VSS.n1 VSS.n18 2.09947
R39 VSS.n1 VSS.n9 2.09947
R40 VSS.n1 VSS.n16 2.09947
R41 VSS.n1 VSS.n14 2.09947
R42 VSS.n1 VSS.n2 0.131749
R43 VSS.n2 VSS.t3 0.208063
R44 VSS.n29 VSS.n7 1.21797
R45 VSS.n26 VSS.n6 1.21797
R46 VSS.n1 VSS.t32 7.82744
R47 VSS.n1 VSS.t8 47.4577
R48 VSS.n1 VSS.t11 51.0606
R49 VSS.n1 VSS.t17 51.0607
R50 VSS.n1 VSS.n0 0.909702
R51 VSS.n13 VSS.t6 0.201663
R52 VSS.n15 VSS.t9 0.201663
R53 VSS.n17 VSS.t12 0.201663
R54 VSS.n19 VSS.t18 0.201663
R55 VSS.t21 VSS.n23 0.201663
R56 VSS.t24 VSS.n22 0.201663
R57 VSS.n27 VSS.t27 0.201663
R58 VSS.n30 VSS.n29 0.16242
R59 VSS.n31 VSS.n30 0.16242
R60 VSS.n12 VSS.n31 0.16242
R61 VSS.n10 VSS.n12 0.16242
R62 VSS.n10 VSS.n11 0.16242
R63 VSS.n24 VSS.n11 0.16242
R64 VSS.n25 VSS.n24 0.16242
R65 VSS.n26 VSS.n25 0.16242
R66 VSS.n27 VSS.n0 0.147021
R67 VSS.n13 VSS.n2 0.165827
R68 VSS.n14 VSS.n13 0.0927738
R69 VSS.n28 VSS.n27 0.0925656
R70 VSS.n16 VSS.n15 0.0903294
R71 VSS.n18 VSS.t15 0.0903294
R72 VSS.n22 VSS.n21 0.0901212
R73 VSS.n9 VSS.n17 0.0878849
R74 VSS.n20 VSS.n19 0.0878849
R75 VSS.t15 VSS.n9 0.0876767
R76 VSS.n23 VSS.n20 0.0876767
R77 VSS.n23 VSS.n21 0.0854405
R78 VSS.n17 VSS.n16 0.0852323
R79 VSS.n19 VSS.n18 0.0852323
R80 VSS.n28 VSS.n22 0.082996
R81 VSS.n15 VSS.n14 0.0827878
R82 VSS.t34 VSS.n0 0.0818624
R83 VSS VSS.n10 0.0682949
R84 VSS.t15 VSS.n10 0.0394179
R85 VSS.n8 VSS.n7 0.00787189
R86 VSS.n6 VSS.n5 0.00787189
R87 VSS.n4 VSS.n1 1.11508
R88 VSS.t31 VSS.n1 1.02178
C3 vout VSS 4.52502f
C4 vin VSS 14.9682f
C5 VDD VSS 3.5945f
.ends

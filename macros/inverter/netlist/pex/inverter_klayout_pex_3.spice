* NGSPICE file created from inverter_pex.ext - technology: ihp-sg13g2

.subckt inverter_pex VDD vin vout VSS
X0 VSS.t14 vin vout VSS.t13 sg13_lv_nmos ad=0.19p pd=1.38u as=0.19p ps=1.38u w=1u l=1u
X1 VSS.t31 VSS.t29 VSS.t26 VSS.t30 sg13_lv_nmos ad=0.19p pd=1.38u as=0 ps=0 w=1u l=1u
X2 vout vin VDD VDD sg13_lv_pmos ad=1.14p pd=6.38u as=1.14p ps=6.38u w=6u l=1u
X3 VDD vin vout VDD sg13_lv_pmos ad=1.14p pd=6.38u as=1.14p ps=6.38u w=6u l=1u
X4 vout vin VDD VDD sg13_lv_pmos ad=1.14p pd=6.38u as=1.14p ps=6.38u w=6u l=1u
X5 vout vin VSS VSS.t12 sg13_lv_nmos ad=0.19p pd=1.38u as=0.19p ps=1.38u w=1u l=1u
X6 vout vin VSS.t1 VSS.t0 sg13_lv_nmos ad=0.19p pd=1.38u as=0.19p ps=1.38u w=1u l=1u
X7 vout vin VDD VDD sg13_lv_pmos ad=1.14p pd=6.38u as=1.14p ps=6.38u w=6u l=1u
X8 VSS.t1 VSS VSS.t28 VSS.t27 sg13_lv_nmos ad=0.34p pd=2.68u as=0 ps=0 w=1u l=1u
X9 VSS.t20 vin vout VSS.t19 sg13_lv_nmos ad=0.19p pd=1.38u as=0.19p ps=1.38u w=1u l=1u
X10 vout vin VSS.t17 VSS.t18 sg13_lv_nmos ad=0.19p pd=1.38u as=0.19p ps=1.38u w=1u l=1u
X11 VDD vin vout VDD sg13_lv_pmos ad=1.14p pd=6.38u as=1.14p ps=6.38u w=6u l=1u
X12 vout vin VDD VDD sg13_lv_pmos ad=1.14p pd=6.38u as=1.14p ps=6.38u w=6u l=1u
X13 VSS vin vout VSS.t6 sg13_lv_nmos ad=0.19p pd=1.38u as=0.19p ps=1.38u w=1u l=1u
X14 VSS.t26 vin vout VSS.t25 sg13_lv_nmos ad=0.19p pd=1.38u as=0.19p ps=1.38u w=1u l=1u
X15 VDD vin vout VDD sg13_lv_pmos ad=1.14p pd=6.38u as=1.14p ps=6.38u w=6u l=1u
X16 vout vin VDD VDD sg13_lv_pmos ad=1.14p pd=6.38u as=1.14p ps=6.38u w=6u l=1u
X17 VDD vin vout VDD sg13_lv_pmos ad=1.14p pd=6.38u as=1.14p ps=6.38u w=6u l=1u
X18 vout vin VDD VDD sg13_lv_pmos ad=1.14p pd=6.38u as=1.14p ps=6.38u w=6u l=1u
X19 VSS vin vout VSS.t11 sg13_lv_nmos ad=0.19p pd=1.38u as=0.19p ps=1.38u w=1u l=1u
X20 vout vin VSS.t23 VSS.t24 sg13_lv_nmos ad=0.19p pd=1.38u as=0.19p ps=1.38u w=1u l=1u
X21 VDD vin vout VDD sg13_lv_pmos ad=1.14p pd=6.38u as=1.14p ps=6.38u w=6u l=1u
X22 vout vin VDD VDD sg13_lv_pmos ad=1.14p pd=6.38u as=1.14p ps=6.38u w=6u l=1u
X23 VDD VDD VDD VDD sg13_lv_pmos ad=2.04p pd=12.68u as=0.14199n ps=0.28418m w=6u l=1u
X24 vout vin VSS VSS.t5 sg13_lv_nmos ad=0.19p pd=1.38u as=0.19p ps=1.38u w=1u l=1u
X25 VSS.t17 vin vout VSS.t16 sg13_lv_nmos ad=0.19p pd=1.38u as=0.19p ps=1.38u w=1u l=1u
X26 VDD vin vout VDD sg13_lv_pmos ad=1.14p pd=6.38u as=1.14p ps=6.38u w=6u l=1u
X27 VDD vin vout VDD sg13_lv_pmos ad=1.14p pd=6.38u as=1.14p ps=6.38u w=6u l=1u
X28 VSS vin vout VSS.t4 sg13_lv_nmos ad=0.19p pd=1.38u as=0.19p ps=1.38u w=1u l=1u
X29 vout vin VDD VDD sg13_lv_pmos ad=1.14p pd=6.38u as=1.14p ps=6.38u w=6u l=1u
X30 VSS.t23 vin vout VSS.t22 sg13_lv_nmos ad=0.19p pd=1.38u as=0.19p ps=1.38u w=1u l=1u
X31 VSS vin vout VSS.t2 sg13_lv_nmos ad=0.19p pd=1.38u as=0.19p ps=1.38u w=1u l=1u
X32 vout vin VSS.t9 VSS.t10 sg13_lv_nmos ad=0.19p pd=1.38u as=0.19p ps=1.38u w=1u l=1u
X33 vout vin VSS VSS.t3 sg13_lv_nmos ad=0.19p pd=1.38u as=0.19p ps=1.38u w=1u l=1u
X34 vout vin VSS.t20 VSS.t21 sg13_lv_nmos ad=0.19p pd=1.38u as=0.19p ps=1.38u w=1u l=1u
X35 VDD vin vout VDD sg13_lv_pmos ad=1.14p pd=6.38u as=1.14p ps=6.38u w=6u l=1u
X36 vout vin VDD VDD sg13_lv_pmos ad=1.14p pd=6.38u as=1.14p ps=6.38u w=6u l=1u
X37 VSS.t9 vin vout VSS.t8 sg13_lv_nmos ad=0.19p pd=1.38u as=0.19p ps=1.38u w=1u l=1u
X38 VDD vin vout VDD sg13_lv_pmos ad=1.14p pd=6.38u as=1.14p ps=6.38u w=6u l=1u
X39 VDD VDD VDD VDD sg13_lv_pmos ad=1.14p pd=6.38u as=0 ps=0 w=6u l=1u
X40 vout vin VDD VDD sg13_lv_pmos ad=1.14p pd=6.38u as=1.14p ps=6.38u w=6u l=1u
X41 VDD vin vout VDD sg13_lv_pmos ad=1.14p pd=6.38u as=1.14p ps=6.38u w=6u l=1u
X42 vout vin VSS VSS.t7 sg13_lv_nmos ad=0.19p pd=1.38u as=0.19p ps=1.38u w=1u l=1u
X43 vout vin VSS.t14 VSS.t15 sg13_lv_nmos ad=0.19p pd=1.38u as=0.19p ps=1.38u w=1u l=1u
C0 vout VDD 8.86472f
C1 vout vin 15.6916f
C2 VDD vin 25.795f
R0 VSS.n50 VSS.t27 188.541
R1 VSS.t0 VSS.n49 177.45
R2 VSS.n113 VSS.t25 177.45
R3 VSS.t2 VSS.n46 166.359
R4 VSS.n108 VSS.t24 166.359
R5 VSS.t3 VSS.n45 155.268
R6 VSS.n106 VSS.t22 155.268
R7 VSS.t4 VSS.n44 144.178
R8 VSS.n104 VSS.t21 144.178
R9 VSS.t5 VSS.n43 133.088
R10 VSS.n102 VSS.t19 133.088
R11 VSS.t6 VSS.n42 121.996
R12 VSS.n98 VSS.t18 121.996
R13 VSS.t7 VSS.n39 110.906
R14 VSS.n84 VSS.t11 110.906
R15 VSS.t12 VSS.n33 110.906
R16 VSS.n96 VSS.t16 110.906
R17 VSS.t8 VSS.n38 99.8157
R18 VSS.n82 VSS.t10 99.8157
R19 VSS.t13 VSS.n30 99.8157
R20 VSS.n92 VSS.t15 99.8157
R21 VSS.n78 VSS.t8 88.7251
R22 VSS.t10 VSS.n37 88.7251
R23 VSS.n90 VSS.t13 88.7251
R24 VSS.t15 VSS.n27 88.7251
R25 VSS.n74 VSS.t7 77.6345
R26 VSS.t11 VSS.n34 77.6345
R27 VSS.n88 VSS.t12 77.6345
R28 VSS.t16 VSS.n26 77.6345
R29 VSS.n72 VSS.t6 66.5439
R30 VSS.t18 VSS.n23 66.5439
R31 VSS.n68 VSS.t5 55.4534
R32 VSS.t19 VSS.n22 55.4534
R33 VSS.n64 VSS.t4 44.3628
R34 VSS.t21 VSS.n19 44.3628
R35 VSS.n60 VSS.t3 33.2722
R36 VSS.t22 VSS.n16 33.2722
R37 VSS.n86 VSS.n85 29.2386
R38 VSS.n87 VSS.n86 29.2386
R39 VSS.n15 VSS.n14 28.8069
R40 VSS.n18 VSS.n17 28.8069
R41 VSS.n21 VSS.n20 28.8069
R42 VSS.n25 VSS.n24 28.8069
R43 VSS.n29 VSS.n28 28.8069
R44 VSS.n32 VSS.n31 28.8069
R45 VSS.n36 VSS.n35 28.8069
R46 VSS.n41 VSS.n40 28.8069
R47 VSS.n48 VSS.n47 28.8069
R48 VSS.n11 VSS.n1 3.3736
R49 VSS.n52 VSS.n51 28.8069
R50 VSS.n53 VSS.n52 28.8069
R51 VSS.n55 VSS.n47 28.8069
R52 VSS.n58 VSS.n57 28.8069
R53 VSS.n59 VSS.n58 28.8069
R54 VSS.n62 VSS.n61 28.8069
R55 VSS.n63 VSS.n62 28.8069
R56 VSS.n66 VSS.n65 28.8069
R57 VSS.n67 VSS.n66 28.8069
R58 VSS.n70 VSS.n69 28.8069
R59 VSS.n71 VSS.n70 28.8069
R60 VSS.n73 VSS.n40 28.8069
R61 VSS.n76 VSS.n75 28.8069
R62 VSS.n77 VSS.n76 28.8069
R63 VSS.n80 VSS.n79 28.8069
R64 VSS.n81 VSS.n80 28.8069
R65 VSS.n83 VSS.n35 28.8069
R66 VSS.n89 VSS.n31 28.8069
R67 VSS.n91 VSS.n28 28.8069
R68 VSS.n94 VSS.n93 28.8069
R69 VSS.n95 VSS.n94 28.8069
R70 VSS.n97 VSS.n24 28.8069
R71 VSS.n100 VSS.n99 28.8069
R72 VSS.n101 VSS.n100 28.8069
R73 VSS.n103 VSS.n20 28.8069
R74 VSS.n105 VSS.n17 28.8069
R75 VSS.n107 VSS.n14 28.8069
R76 VSS.n110 VSS.n109 28.8069
R77 VSS.n112 VSS.n110 28.8069
R78 VSS.n114 VSS.n12 28.8069
R79 VSS.n116 VSS.n114 28.8069
R80 VSS.n116 VSS.n115 28.8069
R81 VSS.n56 VSS.t2 22.1816
R82 VSS.t24 VSS.n13 22.1816
R83 VSS.n1 VSS.n113 17.0005
R84 VSS.n1 VSS.n13 17.0005
R85 VSS.n1 VSS.n108 17.0005
R86 VSS.n1 VSS.n16 17.0005
R87 VSS.n1 VSS.n106 17.0005
R88 VSS.n1 VSS.n19 17.0005
R89 VSS.n1 VSS.n104 17.0005
R90 VSS.n1 VSS.n22 17.0005
R91 VSS.n1 VSS.n102 17.0005
R92 VSS.n1 VSS.n23 17.0005
R93 VSS.n1 VSS.n98 17.0005
R94 VSS.n1 VSS.n26 17.0005
R95 VSS.n1 VSS.n96 17.0005
R96 VSS.n1 VSS.n27 17.0005
R97 VSS.n1 VSS.n92 17.0005
R98 VSS.n1 VSS.n30 17.0005
R99 VSS.n1 VSS.n90 17.0005
R100 VSS.n1 VSS.n33 17.0005
R101 VSS.n1 VSS.n88 17.0005
R102 VSS.n1 VSS.n34 17.0005
R103 VSS.n1 VSS.n84 17.0005
R104 VSS.n1 VSS.n37 17.0005
R105 VSS.n1 VSS.n82 17.0005
R106 VSS.n1 VSS.n38 17.0005
R107 VSS.n1 VSS.n78 17.0005
R108 VSS.n1 VSS.n39 17.0005
R109 VSS.n1 VSS.n74 17.0005
R110 VSS.n1 VSS.n42 17.0005
R111 VSS.n1 VSS.n72 17.0005
R112 VSS.n1 VSS.n43 17.0005
R113 VSS.n1 VSS.n68 17.0005
R114 VSS.n1 VSS.n44 17.0005
R115 VSS.n1 VSS.n64 17.0005
R116 VSS.n1 VSS.n45 17.0005
R117 VSS.n1 VSS.n60 17.0005
R118 VSS.n1 VSS.n46 17.0005
R119 VSS.n1 VSS.n56 17.0005
R120 VSS.n1 VSS.n49 17.0005
R121 VSS.n1 VSS.n54 17.0005
R122 VSS.t29 VSS.n7 0.0108323
R123 VSS.n1 VSS.n7 0.814638
R124 VSS.n1 VSS.n3 8.49761
R125 VSS.n6 VSS.t31 5.66109
R126 VSS.n5 VSS.n4 0.00359016
R127 VSS.t26 VSS.n4 5.66455
R128 VSS.n4 VSS.n3 0.0134653
R129 VSS.n6 VSS.n5 0.00876575
R130 VSS.n11 VSS.n8 3.37275
R131 VSS.n111 VSS.n8 17.0005
R132 VSS.n50 VSS.n1 17.0005
R133 VSS.n8 VSS.n2 0.00771884
R134 VSS.t1 VSS 5.66266
R135 VSS VSS.t28 5.66533
R136 VSS.n2 VSS 1.27941
R137 VSS.n54 VSS.n53 14.4037
R138 VSS.n56 VSS.n55 14.4037
R139 VSS.n60 VSS.n59 14.4037
R140 VSS.n64 VSS.n63 14.4037
R141 VSS.n68 VSS.n67 14.4037
R142 VSS.n72 VSS.n71 14.4037
R143 VSS.n74 VSS.n73 14.4037
R144 VSS.n78 VSS.n77 14.4037
R145 VSS.n82 VSS.n81 14.4037
R146 VSS.n84 VSS.n83 14.4037
R147 VSS.n88 VSS.n87 14.4037
R148 VSS.n90 VSS.n89 14.4037
R149 VSS.n92 VSS.n91 14.4037
R150 VSS.n96 VSS.n95 14.4037
R151 VSS.n98 VSS.n97 14.4037
R152 VSS.n102 VSS.n101 14.4037
R153 VSS.n104 VSS.n103 14.4037
R154 VSS.n106 VSS.n105 14.4037
R155 VSS.n108 VSS.n107 14.4037
R156 VSS.n113 VSS.n112 14.4037
R157 VSS.n115 VSS.t30 14.4037
R158 VSS.t27 VSS.n11 6.46332
R159 VSS.n51 VSS.n50 14.4037
R160 VSS.n49 VSS.n48 14.4037
R161 VSS.n57 VSS.n46 14.4037
R162 VSS.n61 VSS.n45 14.4037
R163 VSS.n65 VSS.n44 14.4037
R164 VSS.n69 VSS.n43 14.4037
R165 VSS.n42 VSS.n41 14.4037
R166 VSS.n75 VSS.n39 14.4037
R167 VSS.n79 VSS.n38 14.4037
R168 VSS.n37 VSS.n36 14.4037
R169 VSS.n85 VSS.n34 14.4037
R170 VSS.n33 VSS.n32 14.4037
R171 VSS.n30 VSS.n29 14.4037
R172 VSS.n93 VSS.n27 14.4037
R173 VSS.n26 VSS.n25 14.4037
R174 VSS.n99 VSS.n23 14.4037
R175 VSS.n22 VSS.n21 14.4037
R176 VSS.n19 VSS.n18 14.4037
R177 VSS.n16 VSS.n15 14.4037
R178 VSS.n109 VSS.n13 14.4037
R179 VSS.n111 VSS.n12 14.4037
R180 VSS.t30 VSS.n9 15.6502
R181 VSS.n54 VSS.t0 11.0911
R182 VSS.t25 VSS.n111 11.0911
R183 VSS.n9 VSS.n8 0.00558213
R184 VSS.n0 VSS.t29 3.0005
R185 VSS VSS.t9 0.186677
R186 VSS.t14 VSS 2.4821
R187 VSS.t17 VSS 2.4821
R188 VSS VSS.t20 2.4821
R189 VSS VSS.t23 2.4821
R190 VSS.n119 VSS.n1 2.09947
R191 VSS.n117 VSS.n1 2.09947
R192 VSS VSS.n1 2.09947
R193 VSS VSS.n1 0.206015
R194 VSS.n0 VSS.n5 1.52811
R195 VSS.n1 VSS.n12 1.29964
R196 VSS.n1 VSS.n110 1.29964
R197 VSS.n1 VSS.n14 1.29964
R198 VSS.n1 VSS.n17 1.29964
R199 VSS.n1 VSS.n20 1.29964
R200 VSS.n1 VSS.n100 1.29964
R201 VSS.n1 VSS.n24 1.29964
R202 VSS.n1 VSS.n94 1.29964
R203 VSS.n1 VSS.n28 1.29964
R204 VSS.n1 VSS.n31 1.29964
R205 VSS.n1 VSS.n35 1.29964
R206 VSS.n1 VSS.n80 1.29964
R207 VSS.n1 VSS.n76 1.29964
R208 VSS.n1 VSS.n40 1.29964
R209 VSS.n1 VSS.n70 1.29964
R210 VSS.n1 VSS.n66 1.29964
R211 VSS.n1 VSS.n62 1.29964
R212 VSS.n1 VSS.n58 1.29964
R213 VSS.n1 VSS.n47 1.29964
R214 VSS.n1 VSS.n9 0.00132198
R215 VSS.n1 VSS.n116 1.29964
R216 VSS.n51 VSS.n8 1.29964
R217 VSS.n53 VSS.n8 1.29964
R218 VSS.n48 VSS.n8 1.29964
R219 VSS.n55 VSS.n8 1.29964
R220 VSS.n57 VSS.n8 1.29964
R221 VSS.n59 VSS.n8 1.29964
R222 VSS.n61 VSS.n8 1.29964
R223 VSS.n63 VSS.n8 1.29964
R224 VSS.n65 VSS.n8 1.29964
R225 VSS.n67 VSS.n8 1.29964
R226 VSS.n69 VSS.n8 1.29964
R227 VSS.n71 VSS.n8 1.29964
R228 VSS.n41 VSS.n8 1.29964
R229 VSS.n73 VSS.n8 1.29964
R230 VSS.n75 VSS.n8 1.29964
R231 VSS.n77 VSS.n8 1.29964
R232 VSS.n79 VSS.n8 1.29964
R233 VSS.n81 VSS.n8 1.29964
R234 VSS.n36 VSS.n8 1.29964
R235 VSS.n83 VSS.n8 1.29964
R236 VSS.n85 VSS.n8 1.29964
R237 VSS.n87 VSS.n8 1.29964
R238 VSS.n32 VSS.n8 1.29964
R239 VSS.n89 VSS.n8 1.29964
R240 VSS.n29 VSS.n8 1.29964
R241 VSS.n91 VSS.n8 1.29964
R242 VSS.n93 VSS.n8 1.29964
R243 VSS.n95 VSS.n8 1.29964
R244 VSS.n25 VSS.n8 1.29964
R245 VSS.n97 VSS.n8 1.29964
R246 VSS.n99 VSS.n8 1.29964
R247 VSS.n101 VSS.n8 1.29964
R248 VSS.n21 VSS.n8 1.29964
R249 VSS.n103 VSS.n8 1.29964
R250 VSS.n18 VSS.n8 1.29964
R251 VSS.n105 VSS.n8 1.29964
R252 VSS.n15 VSS.n8 1.29964
R253 VSS.n107 VSS.n8 1.29964
R254 VSS.n109 VSS.n8 1.29964
R255 VSS.n112 VSS.n8 1.29964
R256 VSS.n114 VSS.n8 1.29964
R257 VSS.n115 VSS.n8 1.29964
R258 VSS.n1 VSS.n52 1.29964
R259 VSS.n1 VSS.n86 1.08379
R260 VSS VSS.n0 0.209825
R261 VSS VSS.t14 0.201663
R262 VSS VSS.t17 0.201663
R263 VSS.n118 VSS.t20 0.201663
R264 VSS.n10 VSS.t23 0.201663
R265 VSS.t29 VSS.n10 0.147554
R266 VSS.n10 VSS.n119 0.0925656
R267 VSS.n118 VSS.n117 0.0901212
R268 VSS.n119 VSS.n118 0.082996
R269 VSS.n6 VSS.n7 0.107988
R270 VSS.n3 VSS.n2 1.5616
R271 VSS.n117 VSS 1.07064
C3 vout VSS 2.95976f
C4 vin VSS 12.6327f
C5 VDD VSS 2.98893f
.ends

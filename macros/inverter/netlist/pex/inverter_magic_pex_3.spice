* PEX produced on Fri Jul 31 01:45:34 PM CEST 2026 using /foss/tools/sak/sak-pex.sh with m=3 and s=1 (extresist threshold=10000 mOhm, minres=1000 mOhm, mindelay=1 ps)
* NGSPICE file created from inverter_pex.ext - technology: ihp-sg13g2

.subckt inverter_pex VDD vin vout VSS
X0 VSS.t18 vin vout VSS.t17 sg13_lv_nmos ad=0.19p pd=1.38u as=0.19p ps=1.38u w=1u l=1u
X1 VSS.t36 VSS.t34 VSS.t30 VSS.t35 sg13_lv_nmos ad=0.19p pd=1.38u as=0 ps=0 w=1u l=1u
X2 vout vin VDD VDD sg13_lv_pmos ad=1.14p pd=6.38u as=1.14p ps=6.38u w=6u l=1u
X3 VDD vin vout VDD sg13_lv_pmos ad=1.14p pd=6.38u as=1.14p ps=6.38u w=6u l=1u
X4 vout vin VDD VDD sg13_lv_pmos ad=1.14p pd=6.38u as=1.14p ps=6.38u w=6u l=1u
X5 vout vin VSS.t15 VSS.t16 sg13_lv_nmos ad=0.19p pd=1.38u as=0.19p ps=1.38u w=1u l=1u
X6 vout vin VSS.t1 VSS.t0 sg13_lv_nmos ad=0.19p pd=1.38u as=0.19p ps=1.38u w=1u l=1u
X7 vout vin VDD VDD sg13_lv_pmos ad=1.14p pd=6.38u as=1.14p ps=6.38u w=6u l=1u
X8 VSS.t1 VSS.t31 VSS.t33 VSS.t32 sg13_lv_nmos ad=0.34p pd=2.68u as=0 ps=0 w=1u l=1u
X9 VSS.t24 vin vout VSS.t23 sg13_lv_nmos ad=0.19p pd=1.38u as=0.19p ps=1.38u w=1u l=1u
X10 vout vin VSS.t21 VSS.t22 sg13_lv_nmos ad=0.19p pd=1.38u as=0.19p ps=1.38u w=1u l=1u
X11 VDD vin vout VDD sg13_lv_pmos ad=1.14p pd=6.38u as=1.14p ps=6.38u w=6u l=1u
X12 vout vin VDD VDD sg13_lv_pmos ad=1.14p pd=6.38u as=1.14p ps=6.38u w=6u l=1u
X13 VSS.t9 vin vout VSS.t8 sg13_lv_nmos ad=0.19p pd=1.38u as=0.19p ps=1.38u w=1u l=1u
X14 VSS.t30 vin vout VSS.t29 sg13_lv_nmos ad=0.19p pd=1.38u as=0.19p ps=1.38u w=1u l=1u
X15 VDD vin vout VDD sg13_lv_pmos ad=1.14p pd=6.38u as=1.14p ps=6.38u w=6u l=1u
X16 vout vin VDD VDD sg13_lv_pmos ad=1.14p pd=6.38u as=1.14p ps=6.38u w=6u l=1u
X17 VDD vin vout VDD sg13_lv_pmos ad=1.14p pd=6.38u as=1.14p ps=6.38u w=6u l=1u
X18 vout vin VDD VDD sg13_lv_pmos ad=1.14p pd=6.38u as=1.14p ps=6.38u w=6u l=1u
X19 VSS.t15 vin vout VSS.t14 sg13_lv_nmos ad=0.19p pd=1.38u as=0.19p ps=1.38u w=1u l=1u
X20 vout vin VSS.t27 VSS.t28 sg13_lv_nmos ad=0.19p pd=1.38u as=0.19p ps=1.38u w=1u l=1u
X21 VDD vin vout VDD sg13_lv_pmos ad=1.14p pd=6.38u as=1.14p ps=6.38u w=6u l=1u
X22 vout vin VDD VDD sg13_lv_pmos ad=1.14p pd=6.38u as=1.14p ps=6.38u w=6u l=1u
X23 VDD VDD VDD VDD sg13_lv_pmos ad=2.04p pd=12.68u as=0.14199n ps=0.28418m w=6u l=1u
X24 vout vin VSS.t6 VSS.t7 sg13_lv_nmos ad=0.19p pd=1.38u as=0.19p ps=1.38u w=1u l=1u
X25 VSS.t21 vin vout VSS.t20 sg13_lv_nmos ad=0.19p pd=1.38u as=0.19p ps=1.38u w=1u l=1u
X26 VDD vin vout VDD sg13_lv_pmos ad=1.14p pd=6.38u as=1.14p ps=6.38u w=6u l=1u
X27 VDD vin vout VDD sg13_lv_pmos ad=1.14p pd=6.38u as=1.14p ps=6.38u w=6u l=1u
X28 VSS.t6 vin vout VSS.t5 sg13_lv_nmos ad=0.19p pd=1.38u as=0.19p ps=1.38u w=1u l=1u
X29 vout vin VDD VDD sg13_lv_pmos ad=1.14p pd=6.38u as=1.14p ps=6.38u w=6u l=1u
X30 VSS.t27 vin vout VSS.t26 sg13_lv_nmos ad=0.19p pd=1.38u as=0.19p ps=1.38u w=1u l=1u
X31 VSS.t3 vin vout VSS.t2 sg13_lv_nmos ad=0.19p pd=1.38u as=0.19p ps=1.38u w=1u l=1u
X32 vout vin VSS.t12 VSS.t13 sg13_lv_nmos ad=0.19p pd=1.38u as=0.19p ps=1.38u w=1u l=1u
X33 vout vin VSS.t3 VSS.t4 sg13_lv_nmos ad=0.19p pd=1.38u as=0.19p ps=1.38u w=1u l=1u
X34 vout vin VSS.t24 VSS.t25 sg13_lv_nmos ad=0.19p pd=1.38u as=0.19p ps=1.38u w=1u l=1u
X35 VDD vin vout VDD sg13_lv_pmos ad=1.14p pd=6.38u as=1.14p ps=6.38u w=6u l=1u
X36 vout vin VDD VDD sg13_lv_pmos ad=1.14p pd=6.38u as=1.14p ps=6.38u w=6u l=1u
X37 VSS.t12 vin vout VSS.t11 sg13_lv_nmos ad=0.19p pd=1.38u as=0.19p ps=1.38u w=1u l=1u
X38 VDD vin vout VDD sg13_lv_pmos ad=1.14p pd=6.38u as=1.14p ps=6.38u w=6u l=1u
X39 VDD VDD VDD VDD sg13_lv_pmos ad=1.14p pd=6.38u as=0 ps=0 w=6u l=1u
X40 vout vin VDD VDD sg13_lv_pmos ad=1.14p pd=6.38u as=1.14p ps=6.38u w=6u l=1u
X41 VDD vin vout VDD sg13_lv_pmos ad=1.14p pd=6.38u as=1.14p ps=6.38u w=6u l=1u
X42 vout vin VSS.t9 VSS.t10 sg13_lv_nmos ad=0.19p pd=1.38u as=0.19p ps=1.38u w=1u l=1u
X43 vout vin VSS.t18 VSS.t19 sg13_lv_nmos ad=0.19p pd=1.38u as=0.19p ps=1.38u w=1u l=1u
R0 VSS.t29 VSS.n8 185.599
R1 VSS.n25 VSS.t28 174.508
R2 VSS.n23 VSS.t26 163.418
R3 VSS.n16 VSS.t25 152.327
R4 VSS.n26 VSS.t23 141.237
R5 VSS.n24 VSS.t22 130.145
R6 VSS.n22 VSS.t14 119.055
R7 VSS.n11 VSS.t20 119.055
R8 VSS.n18 VSS.t13 107.965
R9 VSS.n15 VSS.t19 107.966
R10 VSS.n20 VSS.t11 96.8748
R11 VSS.n7 VSS.t17 96.8734
R12 VSS.n10 VSS.t16 85.7837
R13 VSS.n14 VSS.t8 74.6929
R14 VSS.n19 VSS.t7 63.6024
R15 VSS.n21 VSS.t4 41.4212
R16 VSS.n12 VSS.t10 85.7845
R17 VSS.t10 VSS.n20 119.055
R18 VSS.t17 VSS.n15 107.963
R19 VSS.t25 VSS.n23 52.5111
R20 VSS.n13 VSS.t2 30.3307
R21 VSS.n6 VSS.n8 0.00162059
R22 VSS.n8 VSS.t28 30.3309
R23 VSS.n6 VSS.n25 0.00162059
R24 VSS.n25 VSS.t26 41.4215
R25 VSS.n6 VSS.n23 0.00187013
R26 VSS.n16 VSS.t23 63.6031
R27 VSS.n26 VSS.t22 74.6932
R28 VSS.n6 VSS.n15 0.00187013
R29 VSS.n7 VSS.t16 119.055
R30 VSS.n6 VSS.n22 0.00162059
R31 VSS.n22 VSS.t13 96.8744
R32 VSS.n18 VSS.t11 107.965
R33 VSS.n6 VSS.n20 0.00187013
R34 VSS.n6 VSS.n12 0.00161544
R35 VSS.n6 VSS.n14 0.00162059
R36 VSS.n14 VSS.t7 141.237
R37 VSS.n27 VSS.t4 163.417
R38 VSS.n6 VSS.n21 0.00161544
R39 VSS.n13 VSS.t0 185.599
R40 VSS.n6 VSS.n9 0.00103508
R41 VSS.n28 VSS.t34 0.013442
R42 VSS.n28 VSS.n6 5.66307
R43 VSS.n28 VSS.n4 0.0164358
R44 VSS.n2 VSS.n3 0.00876575
R45 VSS.t30 VSS.n3 5.66109
R46 VSS.n4 VSS.t36 5.66455
R47 VSS.n2 VSS.n4 0.00359016
R48 VSS.n6 VSS.n1 0.00576523
R49 VSS.t1 VSS.t31 5.66266
R50 VSS.t31 VSS.t33 5.66533
R51 VSS.n17 VSS.t29 19.2417
R52 VSS.n27 VSS.t5 52.5118
R53 VSS.n17 VSS.t35 7.82647
R54 VSS.n9 VSS.t32 7.82752
R55 VSS.n21 VSS.t2 174.51
R56 VSS.n19 VSS.t5 152.327
R57 VSS.n12 VSS.t8 130.145
R58 VSS.n10 VSS.t14 85.7847
R59 VSS.n11 VSS.t19 96.8751
R60 VSS.n24 VSS.t20 85.7845
R61 VSS.n9 VSS.t0 19.2407
R62 VSS.t34 VSS.n42 3.0005
R63 VSS.n0 VSS.t31 0.0442343
R64 VSS.n37 VSS.n0 0.696271
R65 VSS.n38 VSS.t18 2.4821
R66 VSS.n39 VSS.t21 2.4821
R67 VSS.n40 VSS.t24 2.4821
R68 VSS.n41 VSS.t27 2.4821
R69 VSS.n6 VSS.n32 2.09947
R70 VSS.n6 VSS.n31 2.09947
R71 VSS.n6 VSS.n30 2.09947
R72 VSS.n6 VSS.n29 2.09947
R73 VSS.n43 VSS.n6 2.09947
R74 VSS.n1 VSS.t31 0.289532
R75 VSS.n42 VSS.n2 1.52811
R76 VSS.n6 VSS.n16 0.00187013
R77 VSS.n6 VSS.n7 0.00187013
R78 VSS.n6 VSS.n17 0.00103465
R79 VSS.n6 VSS.n13 0.00162059
R80 VSS.n6 VSS.n27 0.00162059
R81 VSS.n6 VSS.n19 0.00161544
R82 VSS.n6 VSS.n18 0.00162059
R83 VSS.n6 VSS.n10 0.00150776
R84 VSS.n6 VSS.n11 0.00161544
R85 VSS.n6 VSS.n24 0.00161544
R86 VSS.n6 VSS.n26 0.00162059
R87 VSS.n6 VSS.n5 0.965651
R88 VSS.n42 VSS.n41 0.209825
R89 VSS.t3 VSS.t31 0.129174
R90 VSS.t6 VSS.t31 0.139
R91 VSS.t9 VSS.t31 0.144188
R92 VSS.t12 VSS.n0 0.147087
R93 VSS.t18 VSS.n36 0.201663
R94 VSS.t21 VSS.n35 0.201663
R95 VSS.t24 VSS.n34 0.201663
R96 VSS.t27 VSS.n33 0.201663
R97 VSS.n38 VSS.n37 0.16242
R98 VSS.n39 VSS.n38 0.16242
R99 VSS.n40 VSS.n39 0.16242
R100 VSS.n41 VSS.n40 0.16242
R101 VSS.n33 VSS.n5 0.142565
R102 VSS.n33 VSS.n32 0.0925656
R103 VSS.n29 VSS.t15 0.0903294
R104 VSS.n34 VSS.n31 0.0901212
R105 VSS.n36 VSS.n30 0.0878849
R106 VSS.n35 VSS.n30 0.0876767
R107 VSS.n43 VSS.t15 0.0876767
R108 VSS.n35 VSS.n31 0.0854405
R109 VSS.n36 VSS.n29 0.0852323
R110 VSS.t34 VSS.n5 0.0844554
R111 VSS.n34 VSS.n32 0.082996
R112 VSS.n37 VSS.t15 0.0394179
R113 VSS.n1 VSS.n3 1.35669
R114 VSS.n43 VSS.t31 1.05289
C0 vout vin 18.1624f
C1 VDD vout 15.0304f
C2 VDD vin 28.614f
C3 vout 0 12.00912f
C4 VSS.t18 0 7.4841f
.ends

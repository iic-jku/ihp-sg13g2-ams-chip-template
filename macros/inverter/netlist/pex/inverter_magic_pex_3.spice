* PEX produced on Mon May 18 09:43:02 PM CEST 2026 using /foss/tools/sak/sak-pex.sh with m=3 and s=1
* NGSPICE file created from inverter_pex.ext - technology: ihp-sg13g2

.subckt inverter_pex vin VSS VDD vout
X0 VSS.t24 vin.t0 vout.t6 VSS.t23 sg13_lv_nmos ad=0.19p pd=1.38u as=0.19p ps=1.38u w=1u l=1u
X1 VSS.t6 VSS.t4 VSS.t6 VSS.t5 sg13_lv_nmos ad=0.19p pd=1.38u as=0 ps=0 w=1u l=1u
X2 vout.t15 vin.t2 VDD.t17 VDD.t1 sg13_lv_pmos ad=1.14p pd=6.38u as=1.14p ps=6.38u w=6u l=1u
X3 VDD.t21 vin.t2 vout.t16 VDD.t1 sg13_lv_pmos ad=1.14p pd=6.38u as=1.14p ps=6.38u w=6u l=1u
X4 vout.t10 vin.t2 VDD.t23 VDD.t1 sg13_lv_pmos ad=1.14p pd=6.38u as=1.14p ps=6.38u w=6u l=1u
X5 vout.t6 vin.t0 VSS.t21 VSS.t22 sg13_lv_nmos ad=0.19p pd=1.38u as=0.19p ps=1.38u w=1u l=1u
X6 vout.t8 vin.t0 VSS.t2 VSS.t7 sg13_lv_nmos ad=0.19p pd=1.38u as=0.19p ps=1.38u w=1u l=1u
X7 vout.t11 vin.t2 VDD.t2 VDD.t1 sg13_lv_pmos ad=1.14p pd=6.38u as=1.14p ps=6.38u w=6u l=1u
X8 VSS.t3 VSS.t0 VSS.t2 VSS.t1 sg13_lv_nmos ad=0.34p pd=2.68u as=0 ps=0 w=1u l=1u
X9 VSS.t30 vin.t0 vout.t2 VSS.t29 sg13_lv_nmos ad=0.19p pd=1.38u as=0.19p ps=1.38u w=1u l=1u
X10 vout.t2 vin.t0 VSS.t27 VSS.t28 sg13_lv_nmos ad=0.19p pd=1.38u as=0.19p ps=1.38u w=1u l=1u
X11 VDD.t19 vin.t2 vout.t15 VDD.t1 sg13_lv_pmos ad=1.14p pd=6.38u as=1.14p ps=6.38u w=6u l=1u
X12 vout.t19 vin.t2 VDD.t21 VDD.t1 sg13_lv_pmos ad=1.14p pd=6.38u as=1.14p ps=6.38u w=6u l=1u
X13 VSS.t15 vin.t0 vout.t5 VSS.t14 sg13_lv_nmos ad=0.19p pd=1.38u as=0.19p ps=1.38u w=1u l=1u
X14 VSS.t6 vin.t0 vout.t4 VSS.t35 sg13_lv_nmos ad=0.19p pd=1.38u as=0.19p ps=1.38u w=1u l=1u
X15 VDD.t7 vin.t2 vout.t11 VDD.t1 sg13_lv_pmos ad=1.14p pd=6.38u as=1.14p ps=6.38u w=6u l=1u
X16 vout.t14 vin.t2 VDD.t13 VDD.t1 sg13_lv_pmos ad=1.14p pd=6.38u as=1.14p ps=6.38u w=6u l=1u
X17 VDD.t17 vin.t2 vout.t17 VDD.t1 sg13_lv_pmos ad=1.14p pd=6.38u as=1.14p ps=6.38u w=6u l=1u
X18 vout.t16 vin.t2 VDD.t19 VDD.t1 sg13_lv_pmos ad=1.14p pd=6.38u as=1.14p ps=6.38u w=6u l=1u
X19 VSS.t21 vin.t0 vout.t1 VSS.t20 sg13_lv_nmos ad=0.19p pd=1.38u as=0.19p ps=1.38u w=1u l=1u
X20 vout.t4 vin.t0 VSS.t33 VSS.t34 sg13_lv_nmos ad=0.19p pd=1.38u as=0.19p ps=1.38u w=1u l=1u
X21 VDD.t13 vin.t2 vout.t13 VDD.t1 sg13_lv_pmos ad=1.14p pd=6.38u as=1.14p ps=6.38u w=6u l=1u
X22 vout.t17 vin.t2 VDD.t15 VDD.t1 sg13_lv_pmos ad=1.14p pd=6.38u as=1.14p ps=6.38u w=6u l=1u
X23 VDD.t3 VDD.t0 VDD.t2 VDD.t1 sg13_lv_pmos ad=2.04p pd=12.68u as=0 ps=0 w=6u l=1u
X24 vout.t5 vin.t0 VSS.t12 VSS.t13 sg13_lv_nmos ad=0.19p pd=1.38u as=0.19p ps=1.38u w=1u l=1u
X25 VSS.t27 vin.t0 vout.t7 VSS.t26 sg13_lv_nmos ad=0.19p pd=1.38u as=0.19p ps=1.38u w=1u l=1u
X26 VDD.t11 vin.t2 vout.t18 VDD.t1 sg13_lv_pmos ad=1.14p pd=6.38u as=1.14p ps=6.38u w=6u l=1u
X27 VDD.t15 vin.t2 vout.t14 VDD.t1 sg13_lv_pmos ad=1.14p pd=6.38u as=1.14p ps=6.38u w=6u l=1u
X28 VSS.t12 vin.t0 vout.t9 VSS.t11 sg13_lv_nmos ad=0.19p pd=1.38u as=0.19p ps=1.38u w=1u l=1u
X29 vout.t18 vin.t2 VDD.t9 VDD.t1 sg13_lv_pmos ad=1.14p pd=6.38u as=1.14p ps=6.38u w=6u l=1u
X30 VSS.t33 vin.t0 vout.t3 VSS.t32 sg13_lv_nmos ad=0.19p pd=1.38u as=0.19p ps=1.38u w=1u l=1u
X31 VSS.t9 vin.t0 vout.t8 VSS.t8 sg13_lv_nmos ad=0.19p pd=1.38u as=0.19p ps=1.38u w=1u l=1u
X32 vout.t1 vin.t0 VSS.t18 VSS.t19 sg13_lv_nmos ad=0.19p pd=1.38u as=0.19p ps=1.38u w=1u l=1u
X33 vout.t9 vin.t0 VSS.t9 VSS.t10 sg13_lv_nmos ad=0.19p pd=1.38u as=0.19p ps=1.38u w=1u l=1u
X34 vout.t3 vin.t0 VSS.t30 VSS.t31 sg13_lv_nmos ad=0.19p pd=1.38u as=0.19p ps=1.38u w=1u l=1u
X35 VDD.t9 vin.t2 vout.t12 VDD.t1 sg13_lv_pmos ad=1.14p pd=6.38u as=1.14p ps=6.38u w=6u l=1u
X36 vout.t13 vin.t2 VDD.t11 VDD.t1 sg13_lv_pmos ad=1.14p pd=6.38u as=1.14p ps=6.38u w=6u l=1u
X37 VSS.t18 vin.t0 vout.t0 VSS.t17 sg13_lv_nmos ad=0.19p pd=1.38u as=0.19p ps=1.38u w=1u l=1u
X38 VDD.t23 vin.t2 vout.t19 VDD.t1 sg13_lv_pmos ad=1.14p pd=6.38u as=1.14p ps=6.38u w=6u l=1u
X39 VDD.t5 VDD.t4 VDD.t5 VDD.t1 sg13_lv_pmos ad=1.14p pd=6.38u as=0 ps=0 w=6u l=1u
X40 vout.t12 vin.t2 VDD.t7 VDD.t1 sg13_lv_pmos ad=1.14p pd=6.38u as=1.14p ps=6.38u w=6u l=1u
X41 VDD.t5 vin.t1 vout.t10 VDD.t1 sg13_lv_pmos ad=1.14p pd=6.38u as=1.14p ps=6.38u w=6u l=1u
X42 vout.t0 vin.t0 VSS.t15 VSS.t16 sg13_lv_nmos ad=0.19p pd=1.38u as=0.19p ps=1.38u w=1u l=1u
X43 vout.t7 vin.t0 VSS.t24 VSS.t25 sg13_lv_nmos ad=0.19p pd=1.38u as=0.19p ps=1.38u w=1u l=1u
R0 vout.n9 vout.t4 10.2939
R1 vout.n8 vout.t3 10.2939
R2 vout.n7 vout.t2 10.2939
R3 vout.n6 vout.t7 10.2939
R4 vout.n5 vout.t6 10.2939
R5 vout.n4 vout.t1 10.2939
R6 vout.n3 vout.t0 10.2939
R7 vout.n2 vout.t5 10.2939
R8 vout.n1 vout.t9 10.2939
R9 vout.n0 vout.t8 10.2939
R10 vout.n9 vout.t10 2.0884
R11 vout.n8 vout.t19 2.0884
R12 vout.n7 vout.t16 2.0884
R13 vout.n6 vout.t15 2.0884
R14 vout.n5 vout.t17 2.0884
R15 vout.n4 vout.t14 2.0693
R16 vout.n3 vout.t13 2.0693
R17 vout.n2 vout.t18 2.0693
R18 vout.n1 vout.t12 2.0693
R19 vout.n0 vout.t11 2.06738
R20 vout.n9 vout.n8 0.16242
R21 vout.n8 vout.n7 0.16242
R22 vout.n7 vout.n6 0.16242
R23 vout.n6 vout.n5 0.16242
R24 vout.n5 vout.n4 0.16242
R25 vout.n4 vout.n3 0.16242
R26 vout.n3 vout.n2 0.16242
R27 vout.n2 vout.n1 0.16242
R28 vout.n1 vout.n0 0.16242
R29 vout vout.n9 0.0151667
R30 vin.n19 vin.t0 0.994013
R31 vin.n17 vin.n16 0.965665
R32 vin.n28 vin.n27 0.83231
R33 vin.n9 vin.n0 0.754036
R34 vin.n20 vin.n19 0.578786
R35 vin.n21 vin.n20 0.578786
R36 vin.n22 vin.n21 0.578786
R37 vin.n23 vin.n22 0.578786
R38 vin.n24 vin.n23 0.578786
R39 vin.n25 vin.n24 0.578786
R40 vin.n26 vin.n25 0.578786
R41 vin.n27 vin.n26 0.578786
R42 vin.n17 vin.n15 0.578786
R43 vin.n15 vin.n14 0.578786
R44 vin.n14 vin.n13 0.578786
R45 vin.n13 vin.n12 0.578786
R46 vin.n12 vin.n11 0.578786
R47 vin.n11 vin.n10 0.578786
R48 vin.n10 vin.n9 0.578786
R49 vin.n20 vin.n8 0.254024
R50 vin.n21 vin.n7 0.254024
R51 vin.n22 vin.n6 0.254024
R52 vin.n23 vin.n5 0.254024
R53 vin.n24 vin.n4 0.254024
R54 vin.n25 vin.n3 0.254024
R55 vin.n26 vin.n2 0.254024
R56 vin.n27 vin.n1 0.254024
R57 vin.n9 vin.n2 0.254024
R58 vin.n10 vin.n3 0.254024
R59 vin.n11 vin.n4 0.254024
R60 vin.n12 vin.n5 0.254024
R61 vin.n13 vin.n6 0.254024
R62 vin.n14 vin.n7 0.254024
R63 vin.n15 vin.n8 0.254024
R64 vin.n19 vin.n18 0.192615
R65 vin.n18 vin.n17 0.191641
R66 vin.n18 vin.n8 0.128842
R67 vin.n8 vin.n7 0.12194
R68 vin.n7 vin.n6 0.12194
R69 vin.n6 vin.n5 0.12194
R70 vin.n5 vin.n4 0.12194
R71 vin.n4 vin.n3 0.12194
R72 vin.n3 vin.n2 0.12194
R73 vin.n2 vin.n1 0.12194
R74 vin.n28 vin.n0 0.0847067
R75 vin.n1 vin.n0 0.0265126
R76 vin vin.n28 0.00974
R77 vin.n16 vin.t1 0.00374593
R78 vin.n16 vin.t2 0.00125388
R79 VDD.n44 VDD.t3 17.0005
R80 VDD.t2 VDD.n106 17.0005
R81 VDD.t2 VDD.n105 17.0005
R82 VDD.t2 VDD.n104 17.0005
R83 VDD.t2 VDD.n103 17.0005
R84 VDD.t2 VDD.n102 17.0005
R85 VDD.t2 VDD.n101 17.0005
R86 VDD.t2 VDD.n100 17.0005
R87 VDD.t2 VDD.n99 17.0005
R88 VDD.t2 VDD.n50 17.0005
R89 VDD.t2 VDD.n49 17.0005
R90 VDD.t2 VDD.n48 17.0005
R91 VDD.t2 VDD.n47 17.0005
R92 VDD.t2 VDD.n46 17.0005
R93 VDD.t2 VDD.n45 17.0005
R94 VDD.n107 VDD.t3 17.0005
R95 VDD.n45 VDD.t3 17.0005
R96 VDD.n46 VDD.t3 17.0005
R97 VDD.n47 VDD.t3 17.0005
R98 VDD.n48 VDD.t3 17.0005
R99 VDD.n49 VDD.t3 17.0005
R100 VDD.n100 VDD.t3 17.0005
R101 VDD.n101 VDD.t3 17.0005
R102 VDD.n102 VDD.t3 17.0005
R103 VDD.n103 VDD.t3 17.0005
R104 VDD.n104 VDD.t3 17.0005
R105 VDD.n105 VDD.t3 17.0005
R106 VDD.n106 VDD.t3 17.0005
R107 VDD.t3 VDD.n43 17.0005
R108 VDD.n107 VDD.t2 17.0005
R109 VDD.t2 VDD.n43 17.0005
R110 VDD.t2 VDD.n44 17.0005
R111 VDD.n109 VDD.n42 17.0005
R112 VDD.n109 VDD.n41 17.0005
R113 VDD.n109 VDD.n40 17.0005
R114 VDD.n109 VDD.n39 17.0005
R115 VDD.n109 VDD.n38 17.0005
R116 VDD.n109 VDD.n37 17.0005
R117 VDD.n109 VDD.n36 17.0005
R118 VDD.n109 VDD.n35 17.0005
R119 VDD.n109 VDD.n34 17.0005
R120 VDD.n109 VDD.n33 17.0005
R121 VDD.n109 VDD.n32 17.0005
R122 VDD.n109 VDD.n31 17.0005
R123 VDD.n109 VDD.n30 17.0005
R124 VDD.n109 VDD.n28 17.0005
R125 VDD.n109 VDD.n11 17.0005
R126 VDD.n109 VDD.n13 17.0005
R127 VDD.n109 VDD.n14 17.0005
R128 VDD.n109 VDD.n15 17.0005
R129 VDD.n109 VDD.n16 17.0005
R130 VDD.n109 VDD.n17 17.0005
R131 VDD.n109 VDD.n18 17.0005
R132 VDD.n109 VDD.n19 17.0005
R133 VDD.n109 VDD.n20 17.0005
R134 VDD.n109 VDD.n21 17.0005
R135 VDD.n109 VDD.n22 17.0005
R136 VDD.n109 VDD.n23 17.0005
R137 VDD.n109 VDD.n24 17.0005
R138 VDD.n109 VDD.n25 17.0005
R139 VDD.n79 VDD.n78 8.50175
R140 VDD.n79 VDD.n77 8.501
R141 VDD.t5 VDD.n76 8.5005
R142 VDD.t5 VDD.n75 8.5005
R143 VDD.t5 VDD.n74 8.5005
R144 VDD.t5 VDD.n73 8.5005
R145 VDD.t5 VDD.n72 8.5005
R146 VDD.t5 VDD.n71 8.5005
R147 VDD.t5 VDD.n70 8.5005
R148 VDD.t5 VDD.n69 8.5005
R149 VDD.t5 VDD.n68 8.5005
R150 VDD.t5 VDD.n67 8.5005
R151 VDD.t5 VDD.n66 8.5005
R152 VDD.t5 VDD.n65 8.5005
R153 VDD.t5 VDD.n80 8.5005
R154 VDD.n109 VDD.n108 8.49747
R155 VDD.n109 VDD.n29 8.49747
R156 VDD.n109 VDD.n12 8.49747
R157 VDD.n109 VDD.n26 8.49747
R158 VDD.n51 VDD.t3 8.49726
R159 VDD.n97 VDD.t0 5.0005
R160 VDD.n83 VDD.t4 5.0005
R161 VDD.n81 VDD.t5 4.24739
R162 VDD.n98 VDD.n97 3.0005
R163 VDD.n84 VDD.n83 3.0005
R164 VDD.n109 VDD.n9 2.09868
R165 VDD.n109 VDD.n8 2.09868
R166 VDD.n109 VDD.n7 2.09868
R167 VDD.n109 VDD.n6 2.09868
R168 VDD.n110 VDD.n109 2.09868
R169 VDD.n109 VDD.n5 2.09868
R170 VDD.n109 VDD.n4 2.09868
R171 VDD.n109 VDD.n3 2.09868
R172 VDD.n43 VDD.n27 1.47319
R173 VDD.n77 VDD.n27 1.43136
R174 VDD.n91 VDD.t15 1.2889
R175 VDD.n96 VDD.n53 1.02406
R176 VDD.n95 VDD.n55 1.02406
R177 VDD.n94 VDD.n57 1.02406
R178 VDD.n93 VDD.n58 1.02406
R179 VDD.n90 VDD.n60 1.02406
R180 VDD.n89 VDD.n62 1.02406
R181 VDD.n88 VDD.n64 1.02406
R182 VDD.n87 VDD.n86 1.02406
R183 VDD.n109 VDD.n2 0.966128
R184 VDD.n109 VDD.n10 0.965928
R185 VDD.n53 VDD.t7 0.958035
R186 VDD.n55 VDD.t9 0.958035
R187 VDD.n57 VDD.t11 0.958035
R188 VDD.n58 VDD.t13 0.958035
R189 VDD.n60 VDD.t17 0.958035
R190 VDD.n62 VDD.t19 0.958035
R191 VDD.n64 VDD.t21 0.958035
R192 VDD.n86 VDD.t23 0.958035
R193 VDD.n53 VDD.n52 0.506645
R194 VDD.n55 VDD.n54 0.506645
R195 VDD.n57 VDD.n56 0.506645
R196 VDD.n58 VDD.n1 0.506645
R197 VDD.n60 VDD.n59 0.506645
R198 VDD.n62 VDD.n61 0.506645
R199 VDD.n64 VDD.n63 0.506645
R200 VDD.n86 VDD.n85 0.506645
R201 VDD.n99 VDD.n98 0.325576
R202 VDD.n84 VDD.n82 0.325576
R203 VDD.n98 VDD.n96 0.203837
R204 VDD.n87 VDD.n84 0.203837
R205 VDD.n88 VDD.n87 0.16242
R206 VDD.n89 VDD.n88 0.16242
R207 VDD.n90 VDD.n89 0.16242
R208 VDD.n92 VDD.n90 0.16242
R209 VDD.n93 VDD.n92 0.16242
R210 VDD.n94 VDD.n93 0.16242
R211 VDD.n95 VDD.n94 0.16242
R212 VDD.n96 VDD.n95 0.16242
R213 VDD.n85 VDD.n10 0.141406
R214 VDD.n52 VDD.n2 0.141011
R215 VDD.n85 VDD.n9 0.0942639
R216 VDD.n52 VDD.n3 0.0935007
R217 VDD.n63 VDD.n8 0.0918194
R218 VDD.n54 VDD.n4 0.0910563
R219 VDD.n61 VDD.n7 0.089375
R220 VDD.n6 VDD.n0 0.0886118
R221 VDD.n56 VDD.n5 0.0886118
R222 VDD.n59 VDD.n6 0.0869305
R223 VDD.n5 VDD.n1 0.0869305
R224 VDD.n59 VDD.n7 0.0861674
R225 VDD.n110 VDD.n1 0.0861674
R226 VDD.n56 VDD.n4 0.0844861
R227 VDD.n61 VDD.n8 0.083723
R228 VDD.n54 VDD.n3 0.0820417
R229 VDD VDD.n110 0.0817361
R230 VDD.n63 VDD.n9 0.0812785
R231 VDD.n97 VDD.n2 0.0807049
R232 VDD.n83 VDD.n10 0.0802907
R233 VDD.n109 VDD.t1 0.0731496
R234 VDD.n92 VDD.n91 0.0261043
R235 VDD.n107 VDD.n42 0.0144319
R236 VDD.n78 VDD.n25 0.0144319
R237 VDD.n44 VDD.n28 0.014224
R238 VDD.n106 VDD.n30 0.014224
R239 VDD.n80 VDD.n11 0.014224
R240 VDD.n76 VDD.n13 0.014224
R241 VDD.n45 VDD.n41 0.0138081
R242 VDD.n65 VDD.n24 0.0138081
R243 VDD.n81 VDD.n20 0.0137626
R244 VDD.n105 VDD.n31 0.0136002
R245 VDD.n75 VDD.n14 0.0136002
R246 VDD.n91 VDD.n0 0.0134139
R247 VDD.n46 VDD.n40 0.0131843
R248 VDD.n66 VDD.n23 0.0131843
R249 VDD.n104 VDD.n32 0.0129764
R250 VDD.n74 VDD.n15 0.0129764
R251 VDD.n103 VDD.n33 0.0123526
R252 VDD.n47 VDD.n39 0.0123526
R253 VDD.n73 VDD.n16 0.0123526
R254 VDD.n67 VDD.n22 0.0123526
R255 VDD.n48 VDD.n38 0.0117287
R256 VDD.n68 VDD.n21 0.0117287
R257 VDD.n102 VDD.n34 0.0115208
R258 VDD.n72 VDD.n17 0.0115208
R259 VDD.n49 VDD.n37 0.0111049
R260 VDD.n69 VDD.n20 0.0111049
R261 VDD.n101 VDD.n35 0.010897
R262 VDD.n71 VDD.n18 0.010897
R263 VDD.n100 VDD.n36 0.0102732
R264 VDD.n70 VDD.n19 0.0102732
R265 VDD.n82 VDD.n81 0.00935329
R266 VDD.n44 VDD.n29 0.00848288
R267 VDD.n106 VDD.n29 0.00848288
R268 VDD.n108 VDD.n43 0.00848288
R269 VDD.n80 VDD.n12 0.00848288
R270 VDD.n76 VDD.n12 0.00848288
R271 VDD.n77 VDD.n26 0.00848288
R272 VDD.n51 VDD.n50 0.00848253
R273 VDD.n99 VDD.n51 0.00848253
R274 VDD.n108 VDD.n107 0.00827494
R275 VDD.n78 VDD.n26 0.00827494
R276 VDD VDD.n0 0.00813889
R277 VDD.n97 VDD.n28 0.00673819
R278 VDD.n83 VDD.n11 0.00673819
R279 VDD.n99 VDD.n36 0.00549055
R280 VDD.n82 VDD.n19 0.00549055
R281 VDD.n100 VDD.n35 0.00486673
R282 VDD.n70 VDD.n18 0.00486673
R283 VDD.n50 VDD.n37 0.00465879
R284 VDD.n101 VDD.n34 0.00424291
R285 VDD.n71 VDD.n17 0.00424291
R286 VDD.n49 VDD.n38 0.00403497
R287 VDD.n69 VDD.n21 0.00403497
R288 VDD.n109 VDD.n27 0.00379737
R289 VDD.n102 VDD.n33 0.00361909
R290 VDD.n72 VDD.n16 0.00361909
R291 VDD.n48 VDD.n39 0.00341115
R292 VDD.n68 VDD.n22 0.00341115
R293 VDD.n103 VDD.n32 0.00278733
R294 VDD.n47 VDD.n40 0.00278733
R295 VDD.n73 VDD.n15 0.00278733
R296 VDD.n67 VDD.n23 0.00278733
R297 VDD.n104 VDD.n31 0.00216352
R298 VDD.n74 VDD.n14 0.00216352
R299 VDD.n46 VDD.n41 0.00195558
R300 VDD.n66 VDD.n24 0.00195558
R301 VDD.n105 VDD.n30 0.0015397
R302 VDD.n75 VDD.n13 0.0015397
R303 VDD.n45 VDD.n42 0.00133176
R304 VDD.n65 VDD.n25 0.00133176
R305 VDD.t5 VDD.n79 0.00124999
R306 VSS.n169 VSS.n79 188.541
R307 VSS.t35 VSS.n71 177.45
R308 VSS.t7 VSS.n41 177.45
R309 VSS.n70 VSS.t34 166.359
R310 VSS.t8 VSS.n39 166.359
R311 VSS.n68 VSS.t32 155.268
R312 VSS.t10 VSS.n37 155.268
R313 VSS.n67 VSS.t31 144.178
R314 VSS.t11 VSS.n35 144.178
R315 VSS.n65 VSS.t29 133.088
R316 VSS.t13 VSS.n33 133.088
R317 VSS.n64 VSS.t28 121.996
R318 VSS.t14 VSS.n31 121.996
R319 VSS.n62 VSS.t26 110.906
R320 VSS.t22 VSS.n21 110.906
R321 VSS.n57 VSS.t20 110.906
R322 VSS.t16 VSS.n29 110.906
R323 VSS.n61 VSS.t25 99.8157
R324 VSS.t23 VSS.n19 99.8157
R325 VSS.n56 VSS.t19 99.8157
R326 VSS.t17 VSS.n27 99.8157
R327 VSS.t25 VSS.n17 88.7251
R328 VSS.n59 VSS.t23 88.7251
R329 VSS.t19 VSS.n25 88.7251
R330 VSS.n54 VSS.t17 88.7251
R331 VSS.t26 VSS.n15 77.6345
R332 VSS.n58 VSS.t22 77.6345
R333 VSS.t20 VSS.n23 77.6345
R334 VSS.n53 VSS.t16 77.6345
R335 VSS.t28 VSS.n13 66.5439
R336 VSS.n51 VSS.t14 66.5439
R337 VSS.t29 VSS.n11 55.4534
R338 VSS.n50 VSS.t13 55.4534
R339 VSS.t31 VSS.n9 44.3628
R340 VSS.n48 VSS.t11 44.3628
R341 VSS.t32 VSS.n7 33.2722
R342 VSS.n47 VSS.t10 33.2722
R343 VSS.n103 VSS.n22 29.2386
R344 VSS.n102 VSS.n22 29.2386
R345 VSS.n124 VSS.n72 28.8069
R346 VSS.n124 VSS.n74 28.8069
R347 VSS.n123 VSS.n75 28.8069
R348 VSS.n196 VSS.n76 28.8069
R349 VSS.n195 VSS.n2 28.8069
R350 VSS.n121 VSS.n4 28.8069
R351 VSS.n119 VSS.n6 28.8069
R352 VSS.n117 VSS.n8 28.8069
R353 VSS.n115 VSS.n10 28.8069
R354 VSS.n113 VSS.n12 28.8069
R355 VSS.n111 VSS.n14 28.8069
R356 VSS.n109 VSS.n16 28.8069
R357 VSS.n107 VSS.n18 28.8069
R358 VSS.n105 VSS.n20 28.8069
R359 VSS.n101 VSS.n24 28.8069
R360 VSS.n99 VSS.n26 28.8069
R361 VSS.n97 VSS.n28 28.8069
R362 VSS.n95 VSS.n30 28.8069
R363 VSS.n93 VSS.n32 28.8069
R364 VSS.n91 VSS.n34 28.8069
R365 VSS.n89 VSS.n36 28.8069
R366 VSS.n87 VSS.n38 28.8069
R367 VSS.n85 VSS.n40 28.8069
R368 VSS.n83 VSS.n43 28.8069
R369 VSS.n82 VSS.n43 28.8069
R370 VSS.n153 VSS.n82 28.8069
R371 VSS.n152 VSS.n81 28.8069
R372 VSS.n152 VSS.n80 28.8069
R373 VSS.n151 VSS.n80 28.8069
R374 VSS.n196 VSS.n195 28.8069
R375 VSS.n123 VSS.n74 28.8069
R376 VSS.n84 VSS.n40 28.8069
R377 VSS.n86 VSS.n38 28.8069
R378 VSS.n88 VSS.n36 28.8069
R379 VSS.n90 VSS.n34 28.8069
R380 VSS.n92 VSS.n32 28.8069
R381 VSS.n94 VSS.n30 28.8069
R382 VSS.n96 VSS.n28 28.8069
R383 VSS.n98 VSS.n26 28.8069
R384 VSS.n100 VSS.n24 28.8069
R385 VSS.n104 VSS.n20 28.8069
R386 VSS.n106 VSS.n18 28.8069
R387 VSS.n108 VSS.n16 28.8069
R388 VSS.n110 VSS.n14 28.8069
R389 VSS.n112 VSS.n12 28.8069
R390 VSS.n114 VSS.n10 28.8069
R391 VSS.n116 VSS.n8 28.8069
R392 VSS.n118 VSS.n6 28.8069
R393 VSS.n120 VSS.n4 28.8069
R394 VSS.t34 VSS.n5 22.1816
R395 VSS.n45 VSS.t8 22.1816
R396 VSS.n165 VSS.t3 17.0005
R397 VSS.t3 VSS.n148 17.0005
R398 VSS.n164 VSS.t3 17.0005
R399 VSS.t2 VSS.n148 17.0005
R400 VSS.t2 VSS.n164 17.0005
R401 VSS.n165 VSS.t2 17.0005
R402 VSS.n161 VSS.n149 17.0005
R403 VSS.n163 VSS.n161 17.0005
R404 VSS.n167 VSS.n166 17.0005
R405 VSS.n194 VSS.n122 17.0005
R406 VSS.n194 VSS.n79 17.0005
R407 VSS.n129 VSS.n127 17.0005
R408 VSS.n133 VSS.n127 17.0005
R409 VSS.n190 VSS.n128 17.0005
R410 VSS.n190 VSS.n189 17.0005
R411 VSS.n197 VSS.n44 17.0005
R412 VSS.n197 VSS.n41 17.0005
R413 VSS.n197 VSS.n45 17.0005
R414 VSS.n197 VSS.n39 17.0005
R415 VSS.n197 VSS.n47 17.0005
R416 VSS.n197 VSS.n37 17.0005
R417 VSS.n197 VSS.n48 17.0005
R418 VSS.n197 VSS.n35 17.0005
R419 VSS.n197 VSS.n50 17.0005
R420 VSS.n197 VSS.n33 17.0005
R421 VSS.n197 VSS.n51 17.0005
R422 VSS.n197 VSS.n31 17.0005
R423 VSS.n197 VSS.n53 17.0005
R424 VSS.n197 VSS.n29 17.0005
R425 VSS.n197 VSS.n54 17.0005
R426 VSS.n197 VSS.n27 17.0005
R427 VSS.n197 VSS.n56 17.0005
R428 VSS.n197 VSS.n25 17.0005
R429 VSS.n197 VSS.n57 17.0005
R430 VSS.n197 VSS.n23 17.0005
R431 VSS.n197 VSS.n58 17.0005
R432 VSS.n197 VSS.n21 17.0005
R433 VSS.n197 VSS.n59 17.0005
R434 VSS.n197 VSS.n19 17.0005
R435 VSS.n197 VSS.n61 17.0005
R436 VSS.n197 VSS.n17 17.0005
R437 VSS.n197 VSS.n62 17.0005
R438 VSS.n197 VSS.n15 17.0005
R439 VSS.n197 VSS.n64 17.0005
R440 VSS.n197 VSS.n13 17.0005
R441 VSS.n197 VSS.n65 17.0005
R442 VSS.n197 VSS.n11 17.0005
R443 VSS.n197 VSS.n67 17.0005
R444 VSS.n197 VSS.n9 17.0005
R445 VSS.n197 VSS.n68 17.0005
R446 VSS.n197 VSS.n7 17.0005
R447 VSS.n197 VSS.n70 17.0005
R448 VSS.n197 VSS.n5 17.0005
R449 VSS.n197 VSS.n71 17.0005
R450 VSS.n122 VSS.n2 14.4037
R451 VSS.n120 VSS.n5 14.4037
R452 VSS.n118 VSS.n7 14.4037
R453 VSS.n116 VSS.n9 14.4037
R454 VSS.n114 VSS.n11 14.4037
R455 VSS.n112 VSS.n13 14.4037
R456 VSS.n110 VSS.n15 14.4037
R457 VSS.n108 VSS.n17 14.4037
R458 VSS.n106 VSS.n19 14.4037
R459 VSS.n104 VSS.n21 14.4037
R460 VSS.n102 VSS.n23 14.4037
R461 VSS.n100 VSS.n25 14.4037
R462 VSS.n98 VSS.n27 14.4037
R463 VSS.n96 VSS.n29 14.4037
R464 VSS.n94 VSS.n31 14.4037
R465 VSS.n92 VSS.n33 14.4037
R466 VSS.n90 VSS.n35 14.4037
R467 VSS.n88 VSS.n37 14.4037
R468 VSS.n86 VSS.n39 14.4037
R469 VSS.n84 VSS.n41 14.4037
R470 VSS.n153 VSS.t1 14.4037
R471 VSS.n151 VSS.n79 14.4037
R472 VSS.n76 VSS.t5 14.4037
R473 VSS.n121 VSS.n71 14.4037
R474 VSS.n119 VSS.n70 14.4037
R475 VSS.n117 VSS.n68 14.4037
R476 VSS.n115 VSS.n67 14.4037
R477 VSS.n113 VSS.n65 14.4037
R478 VSS.n111 VSS.n64 14.4037
R479 VSS.n109 VSS.n62 14.4037
R480 VSS.n107 VSS.n61 14.4037
R481 VSS.n105 VSS.n59 14.4037
R482 VSS.n103 VSS.n58 14.4037
R483 VSS.n101 VSS.n57 14.4037
R484 VSS.n99 VSS.n56 14.4037
R485 VSS.n97 VSS.n54 14.4037
R486 VSS.n95 VSS.n53 14.4037
R487 VSS.n93 VSS.n51 14.4037
R488 VSS.n91 VSS.n50 14.4037
R489 VSS.n89 VSS.n48 14.4037
R490 VSS.n87 VSS.n47 14.4037
R491 VSS.n85 VSS.n45 14.4037
R492 VSS.n83 VSS.n44 14.4037
R493 VSS.t1 VSS.n81 14.4037
R494 VSS.t5 VSS.n75 14.4037
R495 VSS.n192 VSS.n72 14.4037
R496 VSS.n122 VSS.t35 11.0911
R497 VSS.n44 VSS.t7 11.0911
R498 VSS.n169 VSS.n160 8.501
R499 VSS.n170 VSS.n169 8.501
R500 VSS.n169 VSS.n168 8.501
R501 VSS.n159 VSS.n150 8.501
R502 VSS.n157 VSS.n150 8.501
R503 VSS.n155 VSS.n150 8.501
R504 VSS.n150 VSS.n42 8.501
R505 VSS.n192 VSS.n126 8.501
R506 VSS.n192 VSS.n191 8.501
R507 VSS.n192 VSS.n73 8.501
R508 VSS.n134 VSS.t6 8.5005
R509 VSS.t6 VSS.n131 8.5005
R510 VSS.n132 VSS.t6 8.5005
R511 VSS.n172 VSS.n171 8.49747
R512 VSS.n130 VSS.n125 8.46995
R513 VSS.n181 VSS.t21 5.84562
R514 VSS.n193 VSS.n192 5.66767
R515 VSS.n176 VSS.t9 5.66167
R516 VSS.n136 VSS.t33 5.66167
R517 VSS.n138 VSS.t30 5.66167
R518 VSS.n140 VSS.t27 5.66167
R519 VSS.n142 VSS.t24 5.66167
R520 VSS.n143 VSS.t18 5.66167
R521 VSS.n145 VSS.t15 5.66167
R522 VSS.n147 VSS.t12 5.66167
R523 VSS.n167 VSS.n162 5.61281
R524 VSS.n173 VSS.t0 5.0005
R525 VSS.n188 VSS.t4 5.0005
R526 VSS.n169 VSS.n78 4.251
R527 VSS.n174 VSS.n173 3.0005
R528 VSS.n188 VSS.n187 3.0005
R529 VSS.n186 VSS.n136 2.4821
R530 VSS.n185 VSS.n138 2.4821
R531 VSS.n184 VSS.n140 2.4821
R532 VSS.n183 VSS.n142 2.4821
R533 VSS.n180 VSS.n143 2.4821
R534 VSS.n179 VSS.n145 2.4821
R535 VSS.n178 VSS.n147 2.4821
R536 VSS.n177 VSS.n176 2.4821
R537 VSS.n197 VSS.n46 2.09947
R538 VSS.n197 VSS.n49 2.09947
R539 VSS.n197 VSS.n52 2.09947
R540 VSS.n197 VSS.n55 2.09947
R541 VSS.n198 VSS.n197 2.09947
R542 VSS.n197 VSS.n60 2.09947
R543 VSS.n197 VSS.n63 2.09947
R544 VSS.n197 VSS.n66 2.09947
R545 VSS.n197 VSS.n69 2.09947
R546 VSS.n130 VSS.n77 1.61933
R547 VSS.n162 VSS.n77 1.58913
R548 VSS.n174 VSS.n148 1.52811
R549 VSS.n187 VSS.n134 1.52811
R550 VSS.n158 VSS.n151 1.29964
R551 VSS.n156 VSS.n152 1.29964
R552 VSS.n154 VSS.n153 1.29964
R553 VSS.n197 VSS.n43 1.29964
R554 VSS.n194 VSS.n124 1.29964
R555 VSS.n194 VSS.n123 1.29964
R556 VSS.n194 VSS.n76 1.29964
R557 VSS.n195 VSS.n194 1.29964
R558 VSS.n194 VSS.n121 1.29964
R559 VSS.n194 VSS.n120 1.29964
R560 VSS.n194 VSS.n119 1.29964
R561 VSS.n194 VSS.n118 1.29964
R562 VSS.n194 VSS.n117 1.29964
R563 VSS.n194 VSS.n116 1.29964
R564 VSS.n194 VSS.n115 1.29964
R565 VSS.n194 VSS.n114 1.29964
R566 VSS.n194 VSS.n113 1.29964
R567 VSS.n194 VSS.n112 1.29964
R568 VSS.n194 VSS.n111 1.29964
R569 VSS.n194 VSS.n110 1.29964
R570 VSS.n194 VSS.n109 1.29964
R571 VSS.n194 VSS.n108 1.29964
R572 VSS.n194 VSS.n107 1.29964
R573 VSS.n194 VSS.n106 1.29964
R574 VSS.n194 VSS.n105 1.29964
R575 VSS.n194 VSS.n104 1.29964
R576 VSS.n194 VSS.n103 1.29964
R577 VSS.n194 VSS.n102 1.29964
R578 VSS.n194 VSS.n101 1.29964
R579 VSS.n194 VSS.n100 1.29964
R580 VSS.n194 VSS.n99 1.29964
R581 VSS.n194 VSS.n98 1.29964
R582 VSS.n194 VSS.n97 1.29964
R583 VSS.n194 VSS.n96 1.29964
R584 VSS.n194 VSS.n95 1.29964
R585 VSS.n194 VSS.n94 1.29964
R586 VSS.n194 VSS.n93 1.29964
R587 VSS.n194 VSS.n92 1.29964
R588 VSS.n194 VSS.n91 1.29964
R589 VSS.n194 VSS.n90 1.29964
R590 VSS.n194 VSS.n89 1.29964
R591 VSS.n194 VSS.n88 1.29964
R592 VSS.n194 VSS.n87 1.29964
R593 VSS.n194 VSS.n86 1.29964
R594 VSS.n194 VSS.n85 1.29964
R595 VSS.n194 VSS.n84 1.29964
R596 VSS.n194 VSS.n83 1.29964
R597 VSS.n194 VSS.n82 1.29964
R598 VSS.n194 VSS.n81 1.29964
R599 VSS.n194 VSS.n80 1.29964
R600 VSS.n197 VSS.n196 1.29964
R601 VSS.n197 VSS.n75 1.29964
R602 VSS.n197 VSS.n74 1.29964
R603 VSS.n197 VSS.n72 1.29964
R604 VSS.n197 VSS.n40 1.29964
R605 VSS.n197 VSS.n38 1.29964
R606 VSS.n197 VSS.n36 1.29964
R607 VSS.n197 VSS.n34 1.29964
R608 VSS.n197 VSS.n32 1.29964
R609 VSS.n197 VSS.n30 1.29964
R610 VSS.n197 VSS.n28 1.29964
R611 VSS.n197 VSS.n26 1.29964
R612 VSS.n197 VSS.n24 1.29964
R613 VSS.n197 VSS.n20 1.29964
R614 VSS.n197 VSS.n18 1.29964
R615 VSS.n197 VSS.n16 1.29964
R616 VSS.n197 VSS.n14 1.29964
R617 VSS.n197 VSS.n12 1.29964
R618 VSS.n197 VSS.n10 1.29964
R619 VSS.n197 VSS.n8 1.29964
R620 VSS.n197 VSS.n6 1.29964
R621 VSS.n197 VSS.n4 1.29964
R622 VSS.n197 VSS.n2 1.29964
R623 VSS.n197 VSS.n22 1.08379
R624 VSS.n197 VSS.n3 0.965651
R625 VSS.n177 VSS.n174 0.209825
R626 VSS.n187 VSS.n186 0.209825
R627 VSS.n136 VSS.n135 0.201663
R628 VSS.n138 VSS.n137 0.201663
R629 VSS.n140 VSS.n139 0.201663
R630 VSS.n142 VSS.n141 0.201663
R631 VSS.n143 VSS.n1 0.201663
R632 VSS.n145 VSS.n144 0.201663
R633 VSS.n147 VSS.n146 0.201663
R634 VSS.n176 VSS.n175 0.201663
R635 VSS.n186 VSS.n185 0.16242
R636 VSS.n185 VSS.n184 0.16242
R637 VSS.n184 VSS.n183 0.16242
R638 VSS.n183 VSS.n182 0.16242
R639 VSS.n182 VSS.n180 0.16242
R640 VSS.n180 VSS.n179 0.16242
R641 VSS.n179 VSS.n178 0.16242
R642 VSS.n178 VSS.n177 0.16242
R643 VSS.n135 VSS.n3 0.142565
R644 VSS.n165 VSS.n162 0.138997
R645 VSS.n150 VSS.n46 0.122437
R646 VSS.n175 VSS.n49 0.0952183
R647 VSS.n146 VSS.n52 0.0927738
R648 VSS.n135 VSS.n69 0.0925656
R649 VSS.n60 VSS.n0 0.0903294
R650 VSS.n144 VSS.n55 0.0903294
R651 VSS.n137 VSS.n66 0.0901212
R652 VSS.n141 VSS.n63 0.0878849
R653 VSS.n198 VSS.n1 0.0878849
R654 VSS.n139 VSS.n63 0.0876767
R655 VSS.n139 VSS.n66 0.0854405
R656 VSS.n141 VSS.n60 0.0852323
R657 VSS.n55 VSS.n1 0.0852323
R658 VSS.n189 VSS.n3 0.0844554
R659 VSS.n137 VSS.n69 0.082996
R660 VSS.n144 VSS.n52 0.0827878
R661 VSS.n146 VSS.n49 0.0803434
R662 VSS VSS.n198 0.0800378
R663 VSS.n175 VSS.n46 0.077899
R664 VSS.n131 VSS.n130 0.0766771
R665 VSS.n182 VSS.n181 0.0360747
R666 VSS.n172 VSS.n150 0.0222069
R667 VSS.n173 VSS.n149 0.0133922
R668 VSS.n188 VSS.n128 0.0133922
R669 VSS.n173 VSS.n172 0.00931464
R670 VSS VSS.n0 0.00813889
R671 VSS.n166 VSS.n148 0.00798582
R672 VSS.n163 VSS.n148 0.00798582
R673 VSS.n134 VSS.n129 0.00798582
R674 VSS.n134 VSS.n133 0.00798582
R675 VSS.n166 VSS.n165 0.00756994
R676 VSS.n164 VSS.n163 0.00756994
R677 VSS.n164 VSS.n149 0.00756994
R678 VSS.n131 VSS.n129 0.00756994
R679 VSS.n133 VSS.n132 0.00756994
R680 VSS.n132 VSS.n128 0.00756994
R681 VSS.n194 VSS.n77 0.00726189
R682 VSS.n181 VSS.n0 0.00384321
R683 VSS.n194 VSS.n78 0.00175
R684 VSS.n189 VSS.n188 0.00174764
R685 VSS.n160 VSS.n159 0.0015
R686 VSS.n167 VSS.n78 0.00124998
R687 VSS.n168 VSS.n167 0.001
R688 VSS.n170 VSS.n161 0.001
R689 VSS.n171 VSS.n160 0.001
R690 VSS.n171 VSS.n170 0.001
R691 VSS.n168 VSS.n161 0.001
R692 VSS.n197 VSS.n42 0.001
R693 VSS.n155 VSS.n154 0.001
R694 VSS.n157 VSS.n156 0.001
R695 VSS.n159 VSS.n158 0.001
R696 VSS.n158 VSS.n157 0.001
R697 VSS.n156 VSS.n155 0.001
R698 VSS.n154 VSS.n42 0.001
R699 VSS.n193 VSS.n125 0.001
R700 VSS.n126 VSS.n125 0.001
R701 VSS.n191 VSS.n127 0.001
R702 VSS.n190 VSS.n73 0.001
R703 VSS.n194 VSS.n193 0.001
R704 VSS.n127 VSS.n126 0.001
R705 VSS.n191 VSS.n190 0.001
R706 VSS.n197 VSS.n73 0.001
C0 vin VDD 28.614f
C1 vout vin 18.1624f
C2 vout VDD 15.0304f
C3 vout VSS 4.60296f
C4 vin VSS 14.97998f
C5 VDD VSS 3.72261f
C6 VDD.n0 VSS 0.21001f
C7 VDD.n1 VSS 0.32318f
C8 VDD.n2 VSS 0.23287f
C9 VDD.n3 VSS 0.12709f
C10 VDD.n4 VSS 0.12722f
C11 VDD.n5 VSS 0.12726f
C12 VDD.n6 VSS 0.12726f
C13 VDD.n7 VSS 0.12721f
C14 VDD.n8 VSS 0.12708f
C15 VDD.n9 VSS 0.12686f
C16 VDD.n10 VSS 0.23387f
C17 VDD.n11 VSS 0.04818f
C18 VDD.n13 VSS 0.03563f
C19 VDD.n14 VSS 0.03563f
C20 VDD.n15 VSS 0.03563f
C21 VDD.n16 VSS 0.03613f
C22 VDD.n17 VSS 0.03563f
C23 VDD.n18 VSS 0.03563f
C24 VDD.n19 VSS 0.03563f
C25 VDD.n20 VSS 0.06732f
C26 VDD.n21 VSS 0.03563f
C27 VDD.n22 VSS 0.03563f
C28 VDD.n23 VSS 0.03613f
C29 VDD.n24 VSS 0.03563f
C30 VDD.n25 VSS 0.03563f
C31 VDD.n27 VSS 0.58526f
C32 VDD.n28 VSS 0.04818f
C33 VDD.n30 VSS 0.03563f
C34 VDD.n31 VSS 0.03563f
C35 VDD.n32 VSS 0.03563f
C36 VDD.n33 VSS 0.03613f
C37 VDD.n34 VSS 0.03563f
C38 VDD.n35 VSS 0.03563f
C39 VDD.n36 VSS 0.03563f
C40 VDD.n37 VSS 0.03563f
C41 VDD.n38 VSS 0.03563f
C42 VDD.n39 VSS 0.03563f
C43 VDD.n40 VSS 0.03613f
C44 VDD.n41 VSS 0.03563f
C45 VDD.n42 VSS 0.03563f
C46 VDD.n43 VSS 0.16363f
C47 VDD.t3 VSS 0.15482f
C48 VDD.n44 VSS 0.06742f
C49 VDD.n45 VSS 0.03413f
C50 VDD.n46 VSS 0.03412f
C51 VDD.n47 VSS 0.03412f
C52 VDD.n48 VSS 0.03413f
C53 VDD.n49 VSS 0.03412f
C54 VDD.n50 VSS 0.04617f
C55 VDD.n52 VSS 0.42627f
C56 VDD.t7 VSS 0.18448f
C57 VDD.n53 VSS 0.33692f
C58 VDD.n54 VSS 0.32326f
C59 VDD.t9 VSS 0.18448f
C60 VDD.n55 VSS 0.33692f
C61 VDD.n56 VSS 0.32317f
C62 VDD.t11 VSS 0.18448f
C63 VDD.n57 VSS 0.33692f
C64 VDD.t13 VSS 0.18448f
C65 VDD.n58 VSS 0.33692f
C66 VDD.n59 VSS 0.32318f
C67 VDD.t17 VSS 0.18448f
C68 VDD.n60 VSS 0.33692f
C69 VDD.n61 VSS 0.32327f
C70 VDD.t19 VSS 0.18448f
C71 VDD.n62 VSS 0.33692f
C72 VDD.n63 VSS 0.32345f
C73 VDD.t21 VSS 0.18448f
C74 VDD.n64 VSS 0.33692f
C75 VDD.n65 VSS 0.03413f
C76 VDD.n66 VSS 0.03412f
C77 VDD.n67 VSS 0.03412f
C78 VDD.n68 VSS 0.03413f
C79 VDD.n69 VSS 0.03412f
C80 VDD.n70 VSS 0.03412f
C81 VDD.n71 VSS 0.03413f
C82 VDD.n72 VSS 0.03412f
C83 VDD.n73 VSS 0.03412f
C84 VDD.n74 VSS 0.03413f
C85 VDD.n75 VSS 0.03412f
C86 VDD.n76 VSS 0.06742f
C87 VDD.n77 VSS 0.15631f
C88 VDD.n78 VSS 0.06782f
C89 VDD.n79 VSS 0.01761f
C90 VDD.n80 VSS 0.06742f
C91 VDD.t5 VSS 0.31024f
C92 VDD.n81 VSS 0.01448f
C93 VDD.n82 VSS 0.36732f
C94 VDD.t4 VSS 0.47812f
C95 VDD.n83 VSS 0.36108f
C96 VDD.n84 VSS 1.43606f
C97 VDD.n85 VSS 0.42547f
C98 VDD.t23 VSS 0.18448f
C99 VDD.n86 VSS 0.33692f
C100 VDD.n87 VSS 0.63425f
C101 VDD.n88 VSS 0.53606f
C102 VDD.n89 VSS 0.53606f
C103 VDD.n90 VSS 0.53606f
C104 VDD.t15 VSS 0.271f
C105 VDD.n91 VSS 0.25039f
C106 VDD.n92 VSS -3.18418f
C107 VDD.n93 VSS 0.53606f
C108 VDD.n94 VSS 0.53606f
C109 VDD.n95 VSS 0.53606f
C110 VDD.n96 VSS 0.63425f
C111 VDD.t0 VSS 0.47812f
C112 VDD.n97 VSS 0.36169f
C113 VDD.n98 VSS 1.43606f
C114 VDD.n99 VSS 0.36732f
C115 VDD.n100 VSS 0.03412f
C116 VDD.n101 VSS 0.03413f
C117 VDD.n102 VSS 0.03412f
C118 VDD.n103 VSS 0.03412f
C119 VDD.n104 VSS 0.03413f
C120 VDD.n105 VSS 0.03412f
C121 VDD.n106 VSS 0.06742f
C122 VDD.t2 VSS 0.17303f
C123 VDD.n107 VSS 0.06782f
C124 VDD.t1 VSS 22.0902f
C125 VDD.n109 VSS 1.82597f
C126 VDD.n110 VSS 0.1162f
C127 vin.n0 VSS 0.08062f
C128 vin.n1 VSS 0.33823f
C129 vin.n2 VSS 0.33823f
C130 vin.n3 VSS 0.33823f
C131 vin.n4 VSS 0.33823f
C132 vin.n5 VSS 0.33823f
C133 vin.n6 VSS 0.33823f
C134 vin.n7 VSS 0.33823f
C135 vin.n8 VSS 0.35746f
C136 vin.n9 VSS 0.10373f
C137 vin.n10 VSS 0.0793f
C138 vin.n11 VSS 0.0793f
C139 vin.n12 VSS 0.0793f
C140 vin.n13 VSS 0.0793f
C141 vin.n14 VSS 0.0793f
C142 vin.n15 VSS 0.0793f
C143 vin.t1 VSS 1.51288f
C144 vin.t2 VSS 27.8602f
C145 vin.n16 VSS 0.38573f
C146 vin.n17 VSS 0.88003f
C147 vin.n18 VSS 3.55802f
C148 vin.t0 VSS 7.31059f
C149 vin.n19 VSS 0.89916f
C150 vin.n20 VSS 0.0793f
C151 vin.n21 VSS 0.0793f
C152 vin.n22 VSS 0.0793f
C153 vin.n23 VSS 0.0793f
C154 vin.n24 VSS 0.0793f
C155 vin.n25 VSS 0.0793f
C156 vin.n26 VSS 0.0793f
C157 vin.n27 VSS 0.10505f
C158 vin.n28 VSS 0.31262f
C159 vout.t10 VSS 0.86086f
C160 vout.t4 VSS 0.12026f
C161 vout.t19 VSS 0.86086f
C162 vout.t3 VSS 0.12026f
C163 vout.t16 VSS 0.86086f
C164 vout.t2 VSS 0.12026f
C165 vout.t15 VSS 0.86086f
C166 vout.t7 VSS 0.12026f
C167 vout.t17 VSS 0.86086f
C168 vout.t6 VSS 0.12026f
C169 vout.t14 VSS 0.8539f
C170 vout.t1 VSS 0.12026f
C171 vout.t13 VSS 0.8539f
C172 vout.t0 VSS 0.12026f
C173 vout.t18 VSS 0.8539f
C174 vout.t5 VSS 0.12026f
C175 vout.t12 VSS 0.8539f
C176 vout.t9 VSS 0.12026f
C177 vout.t11 VSS 0.85424f
C178 vout.t8 VSS 0.12026f
C179 vout.n0 VSS 2.19847f
C180 vout.n1 VSS 2.38171f
C181 vout.n2 VSS 2.38171f
C182 vout.n3 VSS 2.38171f
C183 vout.n4 VSS 2.38171f
C184 vout.n5 VSS 2.37474f
C185 vout.n6 VSS 2.37474f
C186 vout.n7 VSS 2.37474f
C187 vout.n8 VSS 2.37474f
C188 vout.n9 VSS 2.1139f
.ends

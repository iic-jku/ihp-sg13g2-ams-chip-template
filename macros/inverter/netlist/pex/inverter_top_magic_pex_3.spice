* PEX produced on Mon Jul 27 09:28:30 AM CEST 2026 using /foss/tools/sak/sak-pex.sh with m=3 and s=1 (extresist threshold=10000 mOhm, minres=1000 mOhm, mindelay=1 ps)
* NGSPICE file created from inverter_top_pex.ext - technology: ihp-sg13g2

.subckt inverter_top_pex VDD vin4 vout4 VSS vin3 vout3 vin2 vout2 vout1 vin1
X0 vout3 vin3 VSS.t105 VSS.t86 sg13_lv_nmos ad=0.19p pd=1.38u as=0.19p ps=1.38u w=1u l=1u
X1 VDD VDD VDD VDD sg13_lv_pmos ad=1.14p pd=6.38u as=0.56797n ps=1.006m w=6u l=1u
X2 VSS.t1 VSS.t53 VSS.t55 VSS.t54 sg13_lv_nmos ad=0.34p pd=2.68u as=0 ps=0 w=1u l=1u
X3 VDD VDD VDD VDD sg13_lv_pmos ad=1.14p pd=6.38u as=0 ps=0 w=6u l=1u
X4 VDD vin4 vout4 VDD sg13_lv_pmos ad=1.14p pd=6.38u as=1.14p ps=6.38u w=6u l=1u
X5 vout2 vin2 VSS.t76 VSS.t77 sg13_lv_nmos ad=0.19p pd=1.38u as=0.19p ps=1.38u w=1u l=1u
X6 vout3 vin3 VDD VDD sg13_lv_pmos ad=1.14p pd=6.38u as=1.14p ps=6.38u w=6u l=1u
X7 vout4 vin4 VSS.t110 VSS.t111 sg13_lv_nmos ad=0.19p pd=1.38u as=0.19p ps=1.38u w=1u l=1u
X8 vout3 vin3 VSS.t42 VSS.t59 sg13_lv_nmos ad=0.19p pd=1.38u as=0.19p ps=1.38u w=1u l=1u
X9 vout2 vin2 VSS.t70 VSS.t71 sg13_lv_nmos ad=0.19p pd=1.38u as=0.19p ps=1.38u w=1u l=1u
X10 vout4 vin4 VDD VDD sg13_lv_pmos ad=1.14p pd=6.38u as=1.14p ps=6.38u w=6u l=1u
X11 VDD vin2 vout2 VDD sg13_lv_pmos ad=1.14p pd=6.38u as=1.14p ps=6.38u w=6u l=1u
X12 VSS.t76 vin2 vout2 VSS.t75 sg13_lv_nmos ad=0.19p pd=1.38u as=0.19p ps=1.38u w=1u l=1u
X13 vout2 vin2 VSS.t79 VSS.t80 sg13_lv_nmos ad=0.19p pd=1.38u as=0.19p ps=1.38u w=1u l=1u
X14 vout2 vin2 VDD VDD sg13_lv_pmos ad=1.14p pd=6.38u as=1.14p ps=6.38u w=6u l=1u
X15 VSS.t116 vin4 vout4 VSS.t115 sg13_lv_nmos ad=0.19p pd=1.38u as=0.19p ps=1.38u w=1u l=1u
X16 vout1 vin1 VSS.t24 VSS.t25 sg13_lv_nmos ad=0.19p pd=1.38u as=0.19p ps=1.38u w=1u l=1u
X17 VDD vin2 vout2 VDD sg13_lv_pmos ad=1.14p pd=6.38u as=1.14p ps=6.38u w=6u l=1u
X18 vout4 vin4 VSS.t34 VSS.t108 sg13_lv_nmos ad=0.19p pd=1.38u as=0.19p ps=1.38u w=1u l=1u
X19 VDD vin2 vout2 VDD sg13_lv_pmos ad=1.14p pd=6.38u as=1.14p ps=6.38u w=6u l=1u
X20 VSS.t105 vin3 vout3 VSS.t84 sg13_lv_nmos ad=0.19p pd=1.38u as=0.19p ps=1.38u w=1u l=1u
X21 vout4 vin4 VSS.t125 VSS.t126 sg13_lv_nmos ad=0.19p pd=1.38u as=0.19p ps=1.38u w=1u l=1u
X22 VSS.t119 vin4 vout4 VSS.t118 sg13_lv_nmos ad=0.19p pd=1.38u as=0.19p ps=1.38u w=1u l=1u
X23 VDD vin3 vout3 VDD sg13_lv_pmos ad=1.14p pd=6.38u as=1.14p ps=6.38u w=6u l=1u
X24 VDD vin2 vout2 VDD sg13_lv_pmos ad=1.14p pd=6.38u as=1.14p ps=6.38u w=6u l=1u
X25 vout3 vin3 VDD VDD sg13_lv_pmos ad=1.14p pd=6.38u as=1.14p ps=6.38u w=6u l=1u
X26 VSS.t70 vin2 vout2 VSS.t69 sg13_lv_nmos ad=0.19p pd=1.38u as=0.19p ps=1.38u w=1u l=1u
X27 VDD vin3 vout3 VDD sg13_lv_pmos ad=1.14p pd=6.38u as=1.14p ps=6.38u w=6u l=1u
X28 VSS.t42 VSS.t39 VSS.t41 VSS.t40 sg13_lv_nmos ad=0.34p pd=2.68u as=0 ps=0 w=1u l=1u
X29 vout2 vin2 VDD VDD sg13_lv_pmos ad=1.14p pd=6.38u as=1.14p ps=6.38u w=6u l=1u
X30 vout2 vin2 VSS.t73 VSS.t74 sg13_lv_nmos ad=0.19p pd=1.38u as=0.19p ps=1.38u w=1u l=1u
X31 vout1 vin1 VSS.t18 VSS.t19 sg13_lv_nmos ad=0.19p pd=1.38u as=0.19p ps=1.38u w=1u l=1u
X32 VSS.t79 vin2 vout2 VSS.t78 sg13_lv_nmos ad=0.19p pd=1.38u as=0.19p ps=1.38u w=1u l=1u
X33 vout4 vin4 VSS.t122 VSS.t123 sg13_lv_nmos ad=0.19p pd=1.38u as=0.19p ps=1.38u w=1u l=1u
X34 vout1 vin1 VDD VDD sg13_lv_pmos ad=1.14p pd=6.38u as=1.14p ps=6.38u w=6u l=1u
X35 vout1 vin1 VSS.t12 VSS.t13 sg13_lv_nmos ad=0.19p pd=1.38u as=0.19p ps=1.38u w=1u l=1u
X36 VSS.t128 vin4 vout4 VSS.t127 sg13_lv_nmos ad=0.19p pd=1.38u as=0.19p ps=1.38u w=1u l=1u
X37 VDD VDD VDD VDD sg13_lv_pmos ad=1.14p pd=6.38u as=0 ps=0 w=6u l=1u
X38 VSS.t18 vin1 vout1 VSS.t17 sg13_lv_nmos ad=0.19p pd=1.38u as=0.19p ps=1.38u w=1u l=1u
X39 vout2 vin2 VDD VDD sg13_lv_pmos ad=1.14p pd=6.38u as=1.14p ps=6.38u w=6u l=1u
X40 VDD vin4 vout4 VDD sg13_lv_pmos ad=1.14p pd=6.38u as=1.14p ps=6.38u w=6u l=1u
X41 vout1 vin1 VSS.t21 VSS.t22 sg13_lv_nmos ad=0.19p pd=1.38u as=0.19p ps=1.38u w=1u l=1u
X42 vout3 vin3 VSS.t103 VSS.t83 sg13_lv_nmos ad=0.19p pd=1.38u as=0.19p ps=1.38u w=1u l=1u
X43 VDD vin3 vout3 VDD sg13_lv_pmos ad=1.14p pd=6.38u as=1.14p ps=6.38u w=6u l=1u
X44 vout4 vin4 VDD VDD sg13_lv_pmos ad=1.14p pd=6.38u as=1.14p ps=6.38u w=6u l=1u
X45 VDD vin4 vout4 VDD sg13_lv_pmos ad=1.14p pd=6.38u as=1.14p ps=6.38u w=6u l=1u
X46 vout3 vin3 VDD VDD sg13_lv_pmos ad=1.14p pd=6.38u as=1.14p ps=6.38u w=6u l=1u
X47 VDD vin3 vout3 VDD sg13_lv_pmos ad=1.14p pd=6.38u as=1.14p ps=6.38u w=6u l=1u
X48 VSS.t38 VSS.t35 VSS.t37 VSS.t36 sg13_lv_nmos ad=0.19p pd=1.38u as=0 ps=0 w=1u l=1u
X49 VDD vin4 vout4 VDD sg13_lv_pmos ad=1.14p pd=6.38u as=1.14p ps=6.38u w=6u l=1u
X50 VDD vin2 vout2 VDD sg13_lv_pmos ad=1.14p pd=6.38u as=1.14p ps=6.38u w=6u l=1u
X51 VSS.t131 vin4 vout4 VSS.t130 sg13_lv_nmos ad=0.19p pd=1.38u as=0.19p ps=1.38u w=1u l=1u
X52 VDD vin3 vout3 VDD sg13_lv_pmos ad=1.14p pd=6.38u as=1.14p ps=6.38u w=6u l=1u
X53 VSS.t12 vin1 vout1 VSS.t11 sg13_lv_nmos ad=0.19p pd=1.38u as=0.19p ps=1.38u w=1u l=1u
X54 VDD vin1 vout1 VDD sg13_lv_pmos ad=1.14p pd=6.38u as=1.14p ps=6.38u w=6u l=1u
X55 vout4 vin4 VSS.t134 VSS.t135 sg13_lv_nmos ad=0.19p pd=1.38u as=0.19p ps=1.38u w=1u l=1u
X56 vout1 vin1 VDD VDD sg13_lv_pmos ad=1.14p pd=6.38u as=1.14p ps=6.38u w=6u l=1u
X57 vout4 vin4 VDD VDD sg13_lv_pmos ad=1.14p pd=6.38u as=1.14p ps=6.38u w=6u l=1u
X58 vout1 vin1 VSS.t15 VSS.t16 sg13_lv_nmos ad=0.19p pd=1.38u as=0.19p ps=1.38u w=1u l=1u
X59 VDD vin1 vout1 VDD sg13_lv_pmos ad=1.14p pd=6.38u as=1.14p ps=6.38u w=6u l=1u
X60 vout3 vin3 VSS.t99 VSS.t77 sg13_lv_nmos ad=0.19p pd=1.38u as=0.19p ps=1.38u w=1u l=1u
X61 VSS.t21 vin1 vout1 VSS.t20 sg13_lv_nmos ad=0.19p pd=1.38u as=0.19p ps=1.38u w=1u l=1u
X62 VDD VDD VDD VDD sg13_lv_pmos ad=2.04p pd=12.68u as=0 ps=0 w=6u l=1u
X63 vout4 vin4 VDD VDD sg13_lv_pmos ad=1.14p pd=6.38u as=1.14p ps=6.38u w=6u l=1u
X64 VDD vin3 vout3 VDD sg13_lv_pmos ad=1.14p pd=6.38u as=1.14p ps=6.38u w=6u l=1u
X65 VDD vin4 vout4 VDD sg13_lv_pmos ad=1.14p pd=6.38u as=1.14p ps=6.38u w=6u l=1u
X66 vout3 vin3 VDD VDD sg13_lv_pmos ad=1.14p pd=6.38u as=1.14p ps=6.38u w=6u l=1u
X67 vout3 vin3 VSS.t95 VSS.t71 sg13_lv_nmos ad=0.19p pd=1.38u as=0.19p ps=1.38u w=1u l=1u
X68 VSS.t99 vin3 vout3 VSS.t75 sg13_lv_nmos ad=0.19p pd=1.38u as=0.19p ps=1.38u w=1u l=1u
X69 VDD VDD VDD VDD sg13_lv_pmos ad=1.14p pd=6.38u as=0 ps=0 w=6u l=1u
X70 vout3 vin3 VSS.t101 VSS.t80 sg13_lv_nmos ad=0.19p pd=1.38u as=0.19p ps=1.38u w=1u l=1u
X71 vout4 vin4 VDD VDD sg13_lv_pmos ad=1.14p pd=6.38u as=1.14p ps=6.38u w=6u l=1u
X72 vout3 vin3 VDD VDD sg13_lv_pmos ad=1.14p pd=6.38u as=1.14p ps=6.38u w=6u l=1u
X73 VDD vin1 vout1 VDD sg13_lv_pmos ad=1.14p pd=6.38u as=1.14p ps=6.38u w=6u l=1u
X74 vout2 vin2 VDD VDD sg13_lv_pmos ad=1.14p pd=6.38u as=1.14p ps=6.38u w=6u l=1u
X75 vout1 vin1 VDD VDD sg13_lv_pmos ad=1.14p pd=6.38u as=1.14p ps=6.38u w=6u l=1u
X76 vout2 vin2 VSS.t64 VSS.t65 sg13_lv_nmos ad=0.19p pd=1.38u as=0.19p ps=1.38u w=1u l=1u
X77 VDD vin1 vout1 VDD sg13_lv_pmos ad=1.14p pd=6.38u as=1.14p ps=6.38u w=6u l=1u
X78 VDD vin1 vout1 VDD sg13_lv_pmos ad=1.14p pd=6.38u as=1.14p ps=6.38u w=6u l=1u
X79 VDD vin3 vout3 VDD sg13_lv_pmos ad=1.14p pd=6.38u as=1.14p ps=6.38u w=6u l=1u
X80 VSS.t95 vin3 vout3 VSS.t69 sg13_lv_nmos ad=0.19p pd=1.38u as=0.19p ps=1.38u w=1u l=1u
X81 vout3 vin3 VSS.t97 VSS.t74 sg13_lv_nmos ad=0.19p pd=1.38u as=0.19p ps=1.38u w=1u l=1u
X82 VSS.t113 vin4 vout4 VSS.t112 sg13_lv_nmos ad=0.19p pd=1.38u as=0.19p ps=1.38u w=1u l=1u
X83 VDD vin4 vout4 VDD sg13_lv_pmos ad=1.14p pd=6.38u as=1.14p ps=6.38u w=6u l=1u
X84 VSS.t101 vin3 vout3 VSS.t78 sg13_lv_nmos ad=0.19p pd=1.38u as=0.19p ps=1.38u w=1u l=1u
X85 vout4 vin4 VSS.t116 VSS.t117 sg13_lv_nmos ad=0.19p pd=1.38u as=0.19p ps=1.38u w=1u l=1u
X86 VDD vin1 vout1 VDD sg13_lv_pmos ad=1.14p pd=6.38u as=1.14p ps=6.38u w=6u l=1u
X87 vout2 vin2 VDD VDD sg13_lv_pmos ad=1.14p pd=6.38u as=1.14p ps=6.38u w=6u l=1u
X88 vout1 vin1 VDD VDD sg13_lv_pmos ad=1.14p pd=6.38u as=1.14p ps=6.38u w=6u l=1u
X89 VSS.t110 vin4 vout4 VSS.t109 sg13_lv_nmos ad=0.19p pd=1.38u as=0.19p ps=1.38u w=1u l=1u
X90 VDD VDD VDD VDD sg13_lv_pmos ad=2.04p pd=12.68u as=0 ps=0 w=6u l=1u
X91 vout2 vin2 VDD VDD sg13_lv_pmos ad=1.14p pd=6.38u as=1.14p ps=6.38u w=6u l=1u
X92 VDD vin2 vout2 VDD sg13_lv_pmos ad=1.14p pd=6.38u as=1.14p ps=6.38u w=6u l=1u
X93 VSS.t64 vin2 vout2 VSS.t63 sg13_lv_nmos ad=0.19p pd=1.38u as=0.19p ps=1.38u w=1u l=1u
X94 VSS.t122 vin4 vout4 VSS.t121 sg13_lv_nmos ad=0.19p pd=1.38u as=0.19p ps=1.38u w=1u l=1u
X95 vout2 vin2 VDD VDD sg13_lv_pmos ad=1.14p pd=6.38u as=1.14p ps=6.38u w=6u l=1u
X96 VDD VDD VDD VDD sg13_lv_pmos ad=2.04p pd=12.68u as=0 ps=0 w=6u l=1u
X97 vout2 vin2 VSS.t67 VSS.t68 sg13_lv_nmos ad=0.19p pd=1.38u as=0.19p ps=1.38u w=1u l=1u
X98 VSS.t73 vin2 vout2 VSS.t72 sg13_lv_nmos ad=0.19p pd=1.38u as=0.19p ps=1.38u w=1u l=1u
X99 vout1 vin1 VDD VDD sg13_lv_pmos ad=1.14p pd=6.38u as=1.14p ps=6.38u w=6u l=1u
X100 vout1 vin1 VSS.t6 VSS.t7 sg13_lv_nmos ad=0.19p pd=1.38u as=0.19p ps=1.38u w=1u l=1u
X101 vout4 vin4 VSS.t119 VSS.t120 sg13_lv_nmos ad=0.19p pd=1.38u as=0.19p ps=1.38u w=1u l=1u
X102 vout3 vin3 VDD VDD sg13_lv_pmos ad=1.14p pd=6.38u as=1.14p ps=6.38u w=6u l=1u
X103 vout4 vin4 VSS.t131 VSS.t132 sg13_lv_nmos ad=0.19p pd=1.38u as=0.19p ps=1.38u w=1u l=1u
X104 VSS.t52 VSS.t50 VSS.t51 VSS.t44 sg13_lv_nmos ad=0.19p pd=1.38u as=0 ps=0 w=1u l=1u
X105 VSS.t125 vin4 vout4 VSS.t124 sg13_lv_nmos ad=0.19p pd=1.38u as=0.19p ps=1.38u w=1u l=1u
X106 VDD vin1 vout1 VDD sg13_lv_pmos ad=1.14p pd=6.38u as=1.14p ps=6.38u w=6u l=1u
X107 VSS.t51 vin2 vout2 VSS.t87 sg13_lv_nmos ad=0.19p pd=1.38u as=0.19p ps=1.38u w=1u l=1u
X108 VDD vin2 vout2 VDD sg13_lv_pmos ad=1.14p pd=6.38u as=1.14p ps=6.38u w=6u l=1u
X109 vout4 vin4 VSS.t128 VSS.t129 sg13_lv_nmos ad=0.19p pd=1.38u as=0.19p ps=1.38u w=1u l=1u
X110 vout4 vin4 VDD VDD sg13_lv_pmos ad=1.14p pd=6.38u as=1.14p ps=6.38u w=6u l=1u
X111 vout2 vin2 VDD VDD sg13_lv_pmos ad=1.14p pd=6.38u as=1.14p ps=6.38u w=6u l=1u
X112 vout2 vin2 VSS.t61 VSS.t62 sg13_lv_nmos ad=0.19p pd=1.38u as=0.19p ps=1.38u w=1u l=1u
X113 VDD vin2 vout2 VDD sg13_lv_pmos ad=1.14p pd=6.38u as=1.14p ps=6.38u w=6u l=1u
X114 VSS.t67 vin2 vout2 VSS.t66 sg13_lv_nmos ad=0.19p pd=1.38u as=0.19p ps=1.38u w=1u l=1u
X115 VDD vin4 vout4 VDD sg13_lv_pmos ad=1.14p pd=6.38u as=1.14p ps=6.38u w=6u l=1u
X116 VDD VDD VDD VDD sg13_lv_pmos ad=2.04p pd=12.68u as=0 ps=0 w=6u l=1u
X117 VSS.t61 vin2 vout2 VSS.t60 sg13_lv_nmos ad=0.19p pd=1.38u as=0.19p ps=1.38u w=1u l=1u
X118 VSS.t6 vin1 vout1 VSS.t5 sg13_lv_nmos ad=0.19p pd=1.38u as=0.19p ps=1.38u w=1u l=1u
X119 vout3 vin3 VDD VDD sg13_lv_pmos ad=1.14p pd=6.38u as=1.14p ps=6.38u w=6u l=1u
X120 vout1 vin1 VSS.t9 VSS.t10 sg13_lv_nmos ad=0.19p pd=1.38u as=0.19p ps=1.38u w=1u l=1u
X121 VSS.t15 vin1 vout1 VSS.t14 sg13_lv_nmos ad=0.19p pd=1.38u as=0.19p ps=1.38u w=1u l=1u
X122 vout3 vin3 VDD VDD sg13_lv_pmos ad=1.14p pd=6.38u as=1.14p ps=6.38u w=6u l=1u
X123 VDD vin3 vout3 VDD sg13_lv_pmos ad=1.14p pd=6.38u as=1.14p ps=6.38u w=6u l=1u
X124 vout3 vin3 VDD VDD sg13_lv_pmos ad=1.14p pd=6.38u as=1.14p ps=6.38u w=6u l=1u
X125 vout3 vin3 VSS.t91 VSS.t65 sg13_lv_nmos ad=0.19p pd=1.38u as=0.19p ps=1.38u w=1u l=1u
X126 VSS.t82 vin2 vout2 VSS.t81 sg13_lv_nmos ad=0.19p pd=1.38u as=0.19p ps=1.38u w=1u l=1u
X127 vout1 vin1 VDD VDD sg13_lv_pmos ad=1.14p pd=6.38u as=1.14p ps=6.38u w=6u l=1u
X128 vout2 vin2 VSS.t85 VSS.t86 sg13_lv_nmos ad=0.19p pd=1.38u as=0.19p ps=1.38u w=1u l=1u
X129 VSS.t37 vin4 vout4 VSS.t136 sg13_lv_nmos ad=0.19p pd=1.38u as=0.19p ps=1.38u w=1u l=1u
X130 VSS.t58 VSS.t56 VSS.t30 VSS.t57 sg13_lv_nmos ad=0.19p pd=1.38u as=0 ps=0 w=1u l=1u
X131 VSS.t30 vin1 vout1 VSS.t29 sg13_lv_nmos ad=0.19p pd=1.38u as=0.19p ps=1.38u w=1u l=1u
X132 vout2 vin2 VSS.t49 VSS.t59 sg13_lv_nmos ad=0.19p pd=1.38u as=0.19p ps=1.38u w=1u l=1u
X133 VSS.t34 VSS.t31 VSS.t33 VSS.t32 sg13_lv_nmos ad=0.34p pd=2.68u as=0 ps=0 w=1u l=1u
X134 vout1 vin1 VSS.t3 VSS.t4 sg13_lv_nmos ad=0.19p pd=1.38u as=0.19p ps=1.38u w=1u l=1u
X135 VSS.t9 vin1 vout1 VSS.t8 sg13_lv_nmos ad=0.19p pd=1.38u as=0.19p ps=1.38u w=1u l=1u
X136 VDD vin3 vout3 VDD sg13_lv_pmos ad=1.14p pd=6.38u as=1.14p ps=6.38u w=6u l=1u
X137 VSS.t3 vin1 vout1 VSS.t2 sg13_lv_nmos ad=0.19p pd=1.38u as=0.19p ps=1.38u w=1u l=1u
X138 vout4 vin4 VDD VDD sg13_lv_pmos ad=1.14p pd=6.38u as=1.14p ps=6.38u w=6u l=1u
X139 vout3 vin3 VDD VDD sg13_lv_pmos ad=1.14p pd=6.38u as=1.14p ps=6.38u w=6u l=1u
X140 VDD vin3 vout3 VDD sg13_lv_pmos ad=1.14p pd=6.38u as=1.14p ps=6.38u w=6u l=1u
X141 VSS.t91 vin3 vout3 VSS.t63 sg13_lv_nmos ad=0.19p pd=1.38u as=0.19p ps=1.38u w=1u l=1u
X142 vout3 vin3 VSS.t93 VSS.t68 sg13_lv_nmos ad=0.19p pd=1.38u as=0.19p ps=1.38u w=1u l=1u
X143 vout1 vin1 VDD VDD sg13_lv_pmos ad=1.14p pd=6.38u as=1.14p ps=6.38u w=6u l=1u
X144 VSS.t85 vin2 vout2 VSS.t84 sg13_lv_nmos ad=0.19p pd=1.38u as=0.19p ps=1.38u w=1u l=1u
X145 VSS.t97 vin3 vout3 VSS.t72 sg13_lv_nmos ad=0.19p pd=1.38u as=0.19p ps=1.38u w=1u l=1u
X146 VDD vin4 vout4 VDD sg13_lv_pmos ad=1.14p pd=6.38u as=1.14p ps=6.38u w=6u l=1u
X147 vout1 vin1 VDD VDD sg13_lv_pmos ad=1.14p pd=6.38u as=1.14p ps=6.38u w=6u l=1u
X148 VDD vin1 vout1 VDD sg13_lv_pmos ad=1.14p pd=6.38u as=1.14p ps=6.38u w=6u l=1u
X149 vout4 vin4 VDD VDD sg13_lv_pmos ad=1.14p pd=6.38u as=1.14p ps=6.38u w=6u l=1u
X150 VSS.t24 vin1 vout1 VSS.t23 sg13_lv_nmos ad=0.19p pd=1.38u as=0.19p ps=1.38u w=1u l=1u
X151 vout1 vin1 VSS.t27 VSS.t28 sg13_lv_nmos ad=0.19p pd=1.38u as=0.19p ps=1.38u w=1u l=1u
X152 vout1 vin1 VDD VDD sg13_lv_pmos ad=1.14p pd=6.38u as=1.14p ps=6.38u w=6u l=1u
X153 vout2 vin2 VDD VDD sg13_lv_pmos ad=1.14p pd=6.38u as=1.14p ps=6.38u w=6u l=1u
X154 vout4 vin4 VSS.t113 VSS.t114 sg13_lv_nmos ad=0.19p pd=1.38u as=0.19p ps=1.38u w=1u l=1u
X155 VSS.t49 VSS.t47 VSS.t48 VSS.t40 sg13_lv_nmos ad=0.34p pd=2.68u as=0 ps=0 w=1u l=1u
X156 VSS.t46 VSS.t43 VSS.t45 VSS.t44 sg13_lv_nmos ad=0.19p pd=1.38u as=0 ps=0 w=1u l=1u
X157 vout4 vin4 VDD VDD sg13_lv_pmos ad=1.14p pd=6.38u as=1.14p ps=6.38u w=6u l=1u
X158 VSS.t45 vin3 vout3 VSS.t87 sg13_lv_nmos ad=0.19p pd=1.38u as=0.19p ps=1.38u w=1u l=1u
X159 VSS.t134 vin4 vout4 VSS.t133 sg13_lv_nmos ad=0.19p pd=1.38u as=0.19p ps=1.38u w=1u l=1u
X160 VDD vin4 vout4 VDD sg13_lv_pmos ad=1.14p pd=6.38u as=1.14p ps=6.38u w=6u l=1u
X161 vout1 vin1 VSS.t1 VSS.t0 sg13_lv_nmos ad=0.19p pd=1.38u as=0.19p ps=1.38u w=1u l=1u
X162 vout3 vin3 VSS.t89 VSS.t62 sg13_lv_nmos ad=0.19p pd=1.38u as=0.19p ps=1.38u w=1u l=1u
X163 VSS.t93 vin3 vout3 VSS.t66 sg13_lv_nmos ad=0.19p pd=1.38u as=0.19p ps=1.38u w=1u l=1u
X164 vout4 vin4 VDD VDD sg13_lv_pmos ad=1.14p pd=6.38u as=1.14p ps=6.38u w=6u l=1u
X165 vout2 vin2 VSS.t82 VSS.t83 sg13_lv_nmos ad=0.19p pd=1.38u as=0.19p ps=1.38u w=1u l=1u
X166 VSS.t89 vin3 vout3 VSS.t60 sg13_lv_nmos ad=0.19p pd=1.38u as=0.19p ps=1.38u w=1u l=1u
X167 VDD vin1 vout1 VDD sg13_lv_pmos ad=1.14p pd=6.38u as=1.14p ps=6.38u w=6u l=1u
X168 vout1 vin1 VDD VDD sg13_lv_pmos ad=1.14p pd=6.38u as=1.14p ps=6.38u w=6u l=1u
X169 VDD vin1 vout1 VDD sg13_lv_pmos ad=1.14p pd=6.38u as=1.14p ps=6.38u w=6u l=1u
X170 VDD vin4 vout4 VDD sg13_lv_pmos ad=1.14p pd=6.38u as=1.14p ps=6.38u w=6u l=1u
X171 VSS.t27 vin1 vout1 VSS.t26 sg13_lv_nmos ad=0.19p pd=1.38u as=0.19p ps=1.38u w=1u l=1u
X172 VDD vin2 vout2 VDD sg13_lv_pmos ad=1.14p pd=6.38u as=1.14p ps=6.38u w=6u l=1u
X173 vout2 vin2 VDD VDD sg13_lv_pmos ad=1.14p pd=6.38u as=1.14p ps=6.38u w=6u l=1u
X174 VDD vin2 vout2 VDD sg13_lv_pmos ad=1.14p pd=6.38u as=1.14p ps=6.38u w=6u l=1u
X175 VSS.t103 vin3 vout3 VSS.t81 sg13_lv_nmos ad=0.19p pd=1.38u as=0.19p ps=1.38u w=1u l=1u
R0 VSS.n29 VSS.n142 6777.49
R1 VSS.n355 VSS.n29 6777.49
R2 VSS.n32 VSS.n142 6777.49
R3 VSS.n355 VSS.n354 1580.41
R4 VSS.n351 VSS.n142 1580.41
R5 VSS.t59 VSS.n161 88.7251
R6 VSS.n144 VSS.t87 88.7251
R7 VSS.t60 VSS.n162 83.1798
R8 VSS.n145 VSS.t86 83.1798
R9 VSS.t62 VSS.n163 77.6345
R10 VSS.n97 VSS.t84 77.6345
R11 VSS.t36 VSS.n29 6.87897
R12 VSS.n128 VSS.t63 72.0892
R13 VSS.t83 VSS.n146 72.0892
R14 VSS.n29 VSS.t135 12.2976
R15 VSS.t65 VSS.n164 66.5439
R16 VSS.n147 VSS.t81 66.5439
R17 VSS.n27 VSS.t133 14.4648
R18 VSS.t66 VSS.n165 60.9987
R19 VSS.n148 VSS.t80 60.9987
R20 VSS.n27 VSS.t132 22.7839
R21 VSS.n29 VSS.t111 14.4672
R22 VSS.t132 VSS.n26 56.9354
R23 VSS.n32 VSS.t28 12.2984
R24 VSS.t68 VSS.n166 55.4534
R25 VSS.n152 VSS.t72 55.4534
R26 VSS.n112 VSS.t74 55.4534
R27 VSS.n149 VSS.t78 55.4534
R28 VSS.t130 VSS.n25 53.1403
R29 VSS.n15 VSS.t114 53.1357
R30 VSS.n119 VSS.t69 49.9081
R31 VSS.n117 VSS.t71 49.9081
R32 VSS.t75 VSS.n169 49.9081
R33 VSS.n150 VSS.t77 49.9081
R34 VSS.t129 VSS.n24 49.3453
R35 VSS.n16 VSS.t115 49.3407
R36 VSS.n87 VSS.t25 56.932
R37 VSS.t127 VSS.n23 45.5502
R38 VSS.t121 VSS.n19 45.5502
R39 VSS.n21 VSS.t123 45.5456
R40 VSS.n17 VSS.t117 45.5456
R41 VSS.n82 VSS.t23 53.1369
R42 VSS.t69 VSS.n153 44.3628
R43 VSS.t71 VSS.n167 44.3628
R44 VSS.n110 VSS.t75 44.3628
R45 VSS.t77 VSS.n170 44.3628
R46 VSS.t126 VSS.n22 41.7551
R47 VSS.t120 VSS.n18 41.7551
R48 VSS.n22 VSS.t124 41.7505
R49 VSS.n18 VSS.t118 41.7505
R50 VSS.n80 VSS.t22 49.3419
R51 VSS.n154 VSS.t68 38.8175
R52 VSS.t72 VSS.n168 38.8175
R53 VSS.t74 VSS.n151 38.8175
R54 VSS.t78 VSS.n171 38.8175
R55 VSS.t124 VSS.n21 37.9601
R56 VSS.t118 VSS.n17 37.9601
R57 VSS.n23 VSS.t126 37.9555
R58 VSS.n19 VSS.t120 37.9555
R59 VSS.n39 VSS.t14 19.5199
R60 VSS.n85 VSS.t20 45.5468
R61 VSS.t123 VSS.n20 34.1682
R62 VSS.t117 VSS.n16 34.165
R63 VSS.n20 VSS.t121 34.1635
R64 VSS.n24 VSS.t127 34.1604
R65 VSS.n81 VSS.t13 41.7518
R66 VSS.n86 VSS.t19 41.7518
R67 VSS.n155 VSS.t66 33.2722
R68 VSS.t80 VSS.n172 33.2722
R69 VSS.t115 VSS.n15 30.3699
R70 VSS.n25 VSS.t129 30.3653
R71 VSS.n126 VSS.t65 27.7269
R72 VSS.t81 VSS.n173 27.7269
R73 VSS.t114 VSS.n14 26.583
R74 VSS.n26 VSS.t130 26.5703
R75 VSS.n83 VSS.t10 34.161
R76 VSS.t112 VSS.n14 16.2727
R77 VSS.n88 VSS.t8 30.3666
R78 VSS.n84 VSS.t11 37.9577
R79 VSS.t54 VSS.n32 6.8802
R80 VSS.t4 VSS.n32 14.4657
R81 VSS.t63 VSS.n156 22.1816
R82 VSS.n99 VSS.t83 22.1816
R83 VSS.t26 VSS.n37 14.465
R84 VSS.t25 VSS.n37 22.7852
R85 VSS.n87 VSS.n32 0.0109013
R86 VSS.t23 VSS.n87 26.5718
R87 VSS.n82 VSS.n32 0.0109013
R88 VSS.t22 VSS.n82 30.3669
R89 VSS.n80 VSS.n32 0.0109013
R90 VSS.t20 VSS.n80 34.162
R91 VSS.t19 VSS.n85 37.957
R92 VSS.n86 VSS.n32 0.0109013
R93 VSS.t17 VSS.n86 41.7521
R94 VSS.n39 VSS.n32 0.00545203
R95 VSS.n81 VSS.n32 0.0109013
R96 VSS.t11 VSS.n81 41.7521
R97 VSS.n84 VSS.n32 0.0108886
R98 VSS.n88 VSS.n32 0.0109013
R99 VSS.t7 VSS.n88 53.1373
R100 VSS.n33 VSS.n32 0.00397259
R101 VSS.t5 VSS.n33 16.2715
R102 VSS.t0 VSS.n32 9.77002
R103 VSS.n7 VSS.t56 0.092763
R104 VSS.n6 VSS.t58 5.66432
R105 VSS.n51 VSS.t30 17.0005
R106 VSS.n6 VSS.n51 0.012029
R107 VSS.t56 VSS.t30 8.49913
R108 VSS.n0 VSS.n32 1.14073
R109 VSS.n1 VSS.t1 5.668
R110 VSS.n0 VSS.n1 0.0107214
R111 VSS.n1 VSS.t55 5.66889
R112 VSS.n49 VSS.n213 17.0005
R113 VSS.n49 VSS.n275 17.0005
R114 VSS.n49 VSS.n214 17.0005
R115 VSS.n49 VSS.n274 17.0005
R116 VSS.n49 VSS.n58 3.40414
R117 VSS.n49 VSS.t44 17.0005
R118 VSS.n49 VSS.n273 17.0005
R119 VSS.n49 VSS.n215 17.0005
R120 VSS.n49 VSS.n272 17.0005
R121 VSS.n49 VSS.n176 17.0005
R122 VSS.n49 VSS.n78 5.66421
R123 VSS.n49 VSS.n216 17.0005
R124 VSS.n49 VSS.n271 17.0005
R125 VSS.n49 VSS.n77 5.66421
R126 VSS.n49 VSS.n175 8.50007
R127 VSS.n49 VSS.n217 17.0005
R128 VSS.n49 VSS.n55 4.2472
R129 VSS.n49 VSS.n270 17.0005
R130 VSS.n49 VSS.n174 17.0005
R131 VSS.n49 VSS.n97 17.0005
R132 VSS.n49 VSS.n218 17.0005
R133 VSS.n49 VSS.n269 17.0005
R134 VSS.n49 VSS.n99 17.0005
R135 VSS.n49 VSS.n220 17.0005
R136 VSS.n49 VSS.n62 4.24728
R137 VSS.n49 VSS.n268 17.0005
R138 VSS.n49 VSS.n221 17.0005
R139 VSS.n49 VSS.n267 17.0005
R140 VSS.n49 VSS.n223 17.0005
R141 VSS.n49 VSS.n8 2.82803
R142 VSS.n49 VSS.n266 17.0005
R143 VSS.n49 VSS.n171 8.49996
R144 VSS.n49 VSS.n224 17.0005
R145 VSS.n49 VSS.n265 17.0005
R146 VSS.n49 VSS.n170 17.0005
R147 VSS.n49 VSS.n226 17.0005
R148 VSS.n49 VSS.n74 5.66421
R149 VSS.n49 VSS.n264 17.0005
R150 VSS.n49 VSS.n169 17.0005
R151 VSS.n49 VSS.n110 17.0005
R152 VSS.n49 VSS.n227 17.0005
R153 VSS.n49 VSS.n261 17.0005
R154 VSS.n49 VSS.n112 17.0005
R155 VSS.n49 VSS.n228 17.0005
R156 VSS.n49 VSS.n259 17.0005
R157 VSS.n49 VSS.n168 17.0005
R158 VSS.n49 VSS.n152 8.49796
R159 VSS.n49 VSS.n229 17.0005
R160 VSS.n49 VSS.n258 17.0005
R161 VSS.n49 VSS.n167 17.0005
R162 VSS.n49 VSS.n117 17.0005
R163 VSS.n49 VSS.n231 17.0005
R164 VSS.n49 VSS.n257 17.0005
R165 VSS.n49 VSS.n63 3.39245
R166 VSS.n49 VSS.n119 17.0005
R167 VSS.n49 VSS.n232 17.0005
R168 VSS.n49 VSS.n256 17.0005
R169 VSS.n49 VSS.n166 17.0005
R170 VSS.n49 VSS.n233 17.0005
R171 VSS.n49 VSS.n255 17.0005
R172 VSS.n50 VSS.n65 0.0237776
R173 VSS.n49 VSS.n165 17.0005
R174 VSS.n49 VSS.n234 17.0005
R175 VSS.n49 VSS.n254 17.0005
R176 VSS.n49 VSS.n164 17.0005
R177 VSS.n49 VSS.n126 17.0005
R178 VSS.n49 VSS.n235 17.0005
R179 VSS.n49 VSS.n252 17.0005
R180 VSS.n48 VSS.n66 0.0231694
R181 VSS.n49 VSS.n128 17.0005
R182 VSS.n49 VSS.n236 17.0005
R183 VSS.n49 VSS.n251 17.0005
R184 VSS.n49 VSS.n163 17.0005
R185 VSS.n49 VSS.n237 17.0005
R186 VSS.n49 VSS.n248 17.0005
R187 VSS.n49 VSS.n60 3.39487
R188 VSS.n49 VSS.n162 17.0005
R189 VSS.n60 VSS.n59 0.0176991
R190 VSS.n49 VSS.n238 17.0005
R191 VSS.n49 VSS.n247 17.0005
R192 VSS.n60 VSS.n71 0.021711
R193 VSS.n49 VSS.n161 17.0005
R194 VSS.n49 VSS.n31 0.0113189
R195 VSS.n49 VSS.n240 17.0005
R196 VSS.n49 VSS.n246 17.0005
R197 VSS.n49 VSS.n242 17.0005
R198 VSS.n49 VSS.t40 17.0005
R199 VSS.n49 VSS.n243 17.0005
R200 VSS.n49 VSS.n69 5.66421
R201 VSS.n49 VSS.n245 17.0005
R202 VSS.n49 VSS.n160 17.0005
R203 VSS.n352 VSS.n49 17.0005
R204 VSS.n49 VSS.n244 4.25044
R205 VSS.n30 VSS.n176 17.0005
R206 VSS.n30 VSS.n144 8.49882
R207 VSS.n30 VSS.n145 8.49857
R208 VSS.n30 VSS.n174 17.0005
R209 VSS.n30 VSS.n146 8.49832
R210 VSS.n49 VSS.n173 8.4991
R211 VSS.n30 VSS.n147 8.49807
R212 VSS.n30 VSS.n172 8.49806
R213 VSS.n30 VSS.n148 8.49782
R214 VSS.n30 VSS.n149 8.49757
R215 VSS.n30 VSS.n170 17.0005
R216 VSS.n30 VSS.n150 8.49733
R217 VSS.n30 VSS.n169 17.0005
R218 VSS.n30 VSS.n151 8.49907
R219 VSS.n30 VSS.n168 17.0005
R220 VSS.n30 VSS.n167 17.0005
R221 VSS.n30 VSS.n153 8.49708
R222 VSS.n30 VSS.n166 17.0005
R223 VSS.n30 VSS.n154 8.49683
R224 VSS.n30 VSS.n165 17.0005
R225 VSS.n30 VSS.n155 8.49658
R226 VSS.n30 VSS.n164 17.0005
R227 VSS.n30 VSS.n156 8.49634
R228 VSS.n30 VSS.n163 17.0005
R229 VSS.n30 VSS.n157 8.49609
R230 VSS.n30 VSS.n162 17.0005
R231 VSS.n30 VSS.n158 8.49821
R232 VSS.n30 VSS.n161 17.0005
R233 VSS.n31 VSS.n159 8.49584
R234 VSS.n141 VSS.n79 5.66316
R235 VSS.n141 VSS.n34 5.66316
R236 VSS.n141 VSS.n76 5.66316
R237 VSS.t97 VSS.n46 0.0111761
R238 VSS.n141 VSS.n12 5.66421
R239 VSS.n141 VSS.n54 5.66421
R240 VSS.n141 VSS.n61 5.66316
R241 VSS.n141 VSS.n71 4.24552
R242 VSS.n5 VSS.n4 0.0153102
R243 VSS.n29 VSS.n41 1.10835
R244 VSS.n42 VSS.t38 8.49687
R245 VSS.t38 VSS.n52 17.0005
R246 VSS.n42 VSS.n41 0.00926173
R247 VSS.n41 VSS.n40 0.0123024
R248 VSS.n40 VSS.t37 8.49535
R249 VSS.n42 VSS.t37 17.0093
R250 VSS.n53 VSS.t34 17.0005
R251 VSS.t34 VSS.n4 8.49711
R252 VSS.n4 VSS.n3 0.0123024
R253 VSS.n3 VSS.t33 8.49535
R254 VSS.n157 VSS.t62 16.6364
R255 VSS.t84 VSS.n174 16.6364
R256 VSS.t109 VSS.n29 12.3005
R257 VSS.t47 VSS.n68 15.0005
R258 VSS.n334 VSS.t39 15.0005
R259 VSS.n347 VSS.t43 15.0005
R260 VSS.t50 VSS.n312 15.0005
R261 VSS.n228 VSS.n198 13.1592
R262 VSS.n259 VSS.n198 13.1592
R263 VSS.n213 VSS.n183 12.4949
R264 VSS.n214 VSS.n184 12.4949
R265 VSS.t44 VSS.n185 12.4949
R266 VSS.n215 VSS.n186 12.4949
R267 VSS.n216 VSS.n187 12.4949
R268 VSS.n217 VSS.n188 12.4949
R269 VSS.n97 VSS.n189 12.4949
R270 VSS.n99 VSS.n190 12.4949
R271 VSS.n220 VSS.n191 12.4949
R272 VSS.n221 VSS.n192 12.4949
R273 VSS.n223 VSS.n193 12.4949
R274 VSS.n224 VSS.n194 12.4949
R275 VSS.n226 VSS.n195 12.4949
R276 VSS.n110 VSS.n196 12.4949
R277 VSS.n112 VSS.n197 12.4949
R278 VSS.n229 VSS.n199 12.4949
R279 VSS.n117 VSS.n200 12.4949
R280 VSS.n119 VSS.n201 12.4949
R281 VSS.n232 VSS.n202 12.4949
R282 VSS.n233 VSS.n203 12.4949
R283 VSS.n234 VSS.n204 12.4949
R284 VSS.n235 VSS.n205 12.4949
R285 VSS.n128 VSS.n206 12.4949
R286 VSS.n236 VSS.n207 12.4949
R287 VSS.n237 VSS.n208 12.4949
R288 VSS.n238 VSS.n209 12.4949
R289 VSS.n240 VSS.n210 12.4949
R290 VSS.n242 VSS.n211 12.4949
R291 VSS.n243 VSS.n212 12.4949
R292 VSS.n353 VSS.n160 12.4949
R293 VSS.n353 VSS.n352 12.4949
R294 VSS.n245 VSS.n212 12.4949
R295 VSS.t40 VSS.n211 12.4949
R296 VSS.n246 VSS.n210 12.4949
R297 VSS.n247 VSS.n209 12.4949
R298 VSS.n248 VSS.n208 12.4949
R299 VSS.n251 VSS.n207 12.4949
R300 VSS.n252 VSS.n206 12.4949
R301 VSS.n126 VSS.n205 12.4949
R302 VSS.n254 VSS.n204 12.4949
R303 VSS.n255 VSS.n203 12.4949
R304 VSS.n256 VSS.n202 12.4949
R305 VSS.n257 VSS.n201 12.4949
R306 VSS.n231 VSS.n200 12.4949
R307 VSS.n258 VSS.n199 12.4949
R308 VSS.n261 VSS.n197 12.4949
R309 VSS.n227 VSS.n196 12.4949
R310 VSS.n264 VSS.n195 12.4949
R311 VSS.n265 VSS.n194 12.4949
R312 VSS.n266 VSS.n193 12.4949
R313 VSS.n267 VSS.n192 12.4949
R314 VSS.n268 VSS.n191 12.4949
R315 VSS.n269 VSS.n190 12.4949
R316 VSS.n218 VSS.n189 12.4949
R317 VSS.n270 VSS.n188 12.4949
R318 VSS.n271 VSS.n187 12.4949
R319 VSS.n272 VSS.n186 12.4949
R320 VSS.n273 VSS.n185 12.4949
R321 VSS.n274 VSS.n184 12.4949
R322 VSS.n275 VSS.n183 12.4949
R323 VSS.t108 VSS.n29 9.77299
R324 VSS.n33 VSS.t7 26.5798
R325 VSS.t8 VSS.n83 49.3426
R326 VSS.t10 VSS.n84 45.5468
R327 VSS.t13 VSS.n39 37.9641
R328 VSS.t16 VSS.n38 19.52
R329 VSS.t29 VSS.n32 9.77049
R330 VSS.n32 VSS.t57 6.87996
R331 VSS.n158 VSS.t60 11.0911
R332 VSS.t86 VSS.n175 11.0911
R333 VSS.n355 VSS.n32 6777.49
R334 VSS.n49 VSS.n351 1.69997
R335 VSS.n141 VSS.n97 8.5005
R336 VSS.n141 VSS.n99 8.5005
R337 VSS.n141 VSS.n110 8.5005
R338 VSS.n141 VSS.n112 8.5005
R339 VSS.n141 VSS.n117 8.5005
R340 VSS.n141 VSS.n119 8.5005
R341 VSS.n141 VSS.n126 8.5005
R342 VSS.n141 VSS.n128 8.5005
R343 VSS.n49 VSS.n56 8.4984
R344 VSS.n78 VSS.n315 0.0161786
R345 VSS.n77 VSS.n79 0.0217011
R346 VSS.n49 VSS.n36 8.4984
R347 VSS.n49 VSS.n219 8.4984
R348 VSS.n49 VSS.n43 8.4984
R349 VSS.n49 VSS.n222 8.4984
R350 VSS.n8 VSS.n319 0.0263987
R351 VSS.n49 VSS.n225 8.4984
R352 VSS.n74 VSS.n320 0.0161786
R353 VSS.n49 VSS.n263 8.4984
R354 VSS.n49 VSS.n262 8.4984
R355 VSS.n49 VSS.n260 8.4984
R356 VSS.n49 VSS.n45 3.39452
R357 VSS.n49 VSS.n230 8.4984
R358 VSS.n49 VSS.n72 8.4984
R359 VSS.n63 VSS.n64 0.021151
R360 VSS.n49 VSS.n11 8.4984
R361 VSS.n49 VSS.n50 2.82658
R362 VSS.n49 VSS.n253 8.4984
R363 VSS.n49 VSS.n48 2.82689
R364 VSS.n49 VSS.n250 8.4984
R365 VSS.n49 VSS.n249 8.4984
R366 VSS.n49 VSS.n239 8.4984
R367 VSS.n49 VSS.n241 8.4984
R368 VSS.n69 VSS.n340 0.0161786
R369 VSS.n58 VSS.n57 0.00970937
R370 VSS.n141 VSS.n315 8.4984
R371 VSS.n79 VSS.n78 0.014444
R372 VSS.n34 VSS.n77 0.014444
R373 VSS.n141 VSS.n35 4.24607
R374 VSS.n35 VSS.n55 0.0149579
R375 VSS.n141 VSS.n316 8.4984
R376 VSS.n141 VSS.n317 8.4984
R377 VSS.n141 VSS.n44 4.24637
R378 VSS.n141 VSS.n318 8.4984
R379 VSS.n141 VSS.n319 8.4984
R380 VSS.n10 VSS.n9 0.0135778
R381 VSS.n141 VSS.n10 2.82401
R382 VSS.n141 VSS.n320 8.4984
R383 VSS.n76 VSS.n75 0.00635632
R384 VSS.n141 VSS.n321 8.4984
R385 VSS.n141 VSS.n322 8.4984
R386 VSS.n141 VSS.n46 3.39343
R387 VSS.n141 VSS.n323 8.4984
R388 VSS.n141 VSS.n324 8.4984
R389 VSS.n141 VSS.n73 8.4984
R390 VSS.n141 VSS.n64 3.39626
R391 VSS.n141 VSS.n65 3.39626
R392 VSS.n141 VSS.n66 3.39626
R393 VSS.n141 VSS.n325 8.4984
R394 VSS.n61 VSS.n59 0.00635632
R395 VSS.n141 VSS.n339 8.4984
R396 VSS.n141 VSS.n340 8.4984
R397 VSS.n141 VSS.n67 2.83158
R398 VSS.n51 VSS.n32 1.2743
R399 VSS.n378 VSS.n177 8.22525
R400 VSS.n306 VSS.n305 8.22525
R401 VSS.n305 VSS.n278 8.22525
R402 VSS.n379 VSS.n378 8.22525
R403 VSS.n140 VSS.n213 7.6711
R404 VSS.n352 VSS.n139 7.6711
R405 VSS.n29 VSS.t32 6.87896
R406 VSS.n332 VSS.t47 7.49606
R407 VSS.t39 VSS.n330 7.49606
R408 VSS.t43 VSS.n346 7.49606
R409 VSS.n313 VSS.t50 7.49606
R410 VSS.n89 VSS.n214 7.20236
R411 VSS.n90 VSS.t44 7.20236
R412 VSS.n91 VSS.n273 7.20236
R413 VSS.n92 VSS.n272 7.20236
R414 VSS.n93 VSS.n216 7.20236
R415 VSS.n94 VSS.n271 7.20236
R416 VSS.n95 VSS.n217 7.20236
R417 VSS.n96 VSS.n270 7.20236
R418 VSS.n98 VSS.n218 7.20236
R419 VSS.n100 VSS.n146 7.20236
R420 VSS.n101 VSS.n268 7.20236
R421 VSS.n102 VSS.n221 7.20236
R422 VSS.n103 VSS.n267 7.20236
R423 VSS.n104 VSS.n148 7.20236
R424 VSS.n105 VSS.n266 7.20236
R425 VSS.n106 VSS.n149 7.20236
R426 VSS.n107 VSS.n265 7.20236
R427 VSS.n108 VSS.n150 7.20236
R428 VSS.n109 VSS.n169 7.20236
R429 VSS.n111 VSS.n227 7.20236
R430 VSS.n113 VSS.n228 7.20236
R431 VSS.n114 VSS.n259 7.20236
R432 VSS.n115 VSS.n229 7.20236
R433 VSS.n116 VSS.n167 7.20236
R434 VSS.n118 VSS.n231 7.20236
R435 VSS.n120 VSS.n153 7.20236
R436 VSS.n121 VSS.n166 7.20236
R437 VSS.n122 VSS.n154 7.20236
R438 VSS.n123 VSS.n165 7.20236
R439 VSS.n124 VSS.n155 7.20236
R440 VSS.n125 VSS.n164 7.20236
R441 VSS.n127 VSS.n235 7.20236
R442 VSS.n129 VSS.n156 7.20236
R443 VSS.n130 VSS.n163 7.20236
R444 VSS.n131 VSS.n157 7.20236
R445 VSS.n132 VSS.n162 7.20236
R446 VSS.n133 VSS.n238 7.20236
R447 VSS.n134 VSS.n161 7.20236
R448 VSS.n135 VSS.n159 7.20236
R449 VSS.n136 VSS.n246 7.20236
R450 VSS.n137 VSS.t40 7.20236
R451 VSS.n138 VSS.n245 7.20236
R452 VSS.n138 VSS.n160 7.20236
R453 VSS.n137 VSS.n243 7.20236
R454 VSS.n136 VSS.n242 7.20236
R455 VSS.n135 VSS.n240 7.20236
R456 VSS.n134 VSS.n247 7.20236
R457 VSS.n133 VSS.n158 7.20236
R458 VSS.n132 VSS.n248 7.20236
R459 VSS.n131 VSS.n237 7.20236
R460 VSS.n130 VSS.n251 7.20236
R461 VSS.n129 VSS.n236 7.20236
R462 VSS.n127 VSS.n252 7.20236
R463 VSS.n125 VSS.n254 7.20236
R464 VSS.n124 VSS.n234 7.20236
R465 VSS.n123 VSS.n255 7.20236
R466 VSS.n122 VSS.n233 7.20236
R467 VSS.n121 VSS.n256 7.20236
R468 VSS.n120 VSS.n232 7.20236
R469 VSS.n118 VSS.n257 7.20236
R470 VSS.n116 VSS.n258 7.20236
R471 VSS.n115 VSS.n152 7.20236
R472 VSS.n114 VSS.n168 7.20236
R473 VSS.n113 VSS.n151 7.20236
R474 VSS.n111 VSS.n261 7.20236
R475 VSS.n109 VSS.n264 7.20236
R476 VSS.n108 VSS.n226 7.20236
R477 VSS.n107 VSS.n170 7.20236
R478 VSS.n106 VSS.n224 7.20236
R479 VSS.n105 VSS.n171 7.20236
R480 VSS.n104 VSS.n223 7.20236
R481 VSS.n103 VSS.n172 7.20236
R482 VSS.n102 VSS.n147 7.20236
R483 VSS.n101 VSS.n173 7.20236
R484 VSS.n100 VSS.n220 7.20236
R485 VSS.n98 VSS.n269 7.20236
R486 VSS.n96 VSS.n174 7.20236
R487 VSS.n95 VSS.n145 7.20236
R488 VSS.n94 VSS.n175 7.20236
R489 VSS.n93 VSS.n144 7.20236
R490 VSS.n92 VSS.n176 7.20236
R491 VSS.n91 VSS.n215 7.20236
R492 VSS.n90 VSS.n274 7.20236
R493 VSS.n89 VSS.n275 7.20236
R494 VSS.n159 VSS.t59 5.54579
R495 VSS.t87 VSS.n176 5.54579
R496 VSS.n333 VSS.t49 4.5005
R497 VSS.t42 VSS.n329 4.5005
R498 VSS.n314 VSS.t51 4.5005
R499 VSS.n350 VSS.t45 4.5005
R500 VSS.n67 VSS.n49 4.25732
R501 VSS.n141 VSS.n58 2.83351
R502 VSS.n354 VSS.n30 1.69985
R503 VSS.n308 VSS.n307 4.11287
R504 VSS.n308 VSS.n178 4.11287
R505 VSS.n2 VSS.t53 0.0141842
R506 VSS.n296 VSS.t35 3.0005
R507 VSS.n303 VSS.t31 3.0005
R508 VSS.n331 VSS.n328 3.0005
R509 VSS.n336 VSS.n335 3.0005
R510 VSS.n311 VSS.n276 3.0005
R511 VSS.n349 VSS.n348 3.0005
R512 VSS.n83 VSS.n32 0.0111485
R513 VSS.n85 VSS.n32 0.0109013
R514 VSS.t17 VSS.n38 37.9631
R515 VSS.t2 VSS.n32 12.2982
R516 VSS.n278 VSS.n277 2.71193
R517 VSS.n381 VSS.n380 2.6297
R518 VSS.n375 VSS.t3 2.4821
R519 VSS.n376 VSS.t6 2.4821
R520 VSS.n377 VSS.t9 2.4821
R521 VSS.n182 VSS.t12 2.4821
R522 VSS.t18 VSS.n181 2.4821
R523 VSS.n356 VSS.t21 2.4821
R524 VSS.n357 VSS.t24 2.4821
R525 VSS.n358 VSS.t27 2.4821
R526 VSS.n295 VSS.t134 2.4821
R527 VSS.n293 VSS.t131 2.4821
R528 VSS.n292 VSS.t128 2.4821
R529 VSS.t125 VSS.n279 2.4821
R530 VSS.t119 VSS.n280 2.4821
R531 VSS.n300 VSS.t116 2.4821
R532 VSS.n301 VSS.t113 2.4821
R533 VSS.n302 VSS.t110 2.4821
R534 VSS.t89 VSS.n338 2.4821
R535 VSS.n338 VSS.t61 2.4821
R536 VSS.n327 VSS.t91 2.4821
R537 VSS.n327 VSS.t64 2.4821
R538 VSS.n326 VSS.t93 2.4821
R539 VSS.n326 VSS.t67 2.4821
R540 VSS.n309 VSS.t95 2.4821
R541 VSS.n309 VSS.t70 2.4821
R542 VSS.n341 VSS.t99 2.4821
R543 VSS.n341 VSS.t76 2.4821
R544 VSS.n342 VSS.t101 2.4821
R545 VSS.n342 VSS.t79 2.4821
R546 VSS.n343 VSS.t103 2.4821
R547 VSS.n343 VSS.t82 2.4821
R548 VSS.n344 VSS.t105 2.4821
R549 VSS.n344 VSS.t85 2.4821
R550 VSS.n30 VSS.n183 2.25406
R551 VSS.n30 VSS.n184 2.25406
R552 VSS.n30 VSS.n185 2.25406
R553 VSS.n30 VSS.n186 2.25406
R554 VSS.n30 VSS.n187 2.25406
R555 VSS.n30 VSS.n188 2.25406
R556 VSS.n30 VSS.n189 2.25406
R557 VSS.n30 VSS.n190 2.25406
R558 VSS.n30 VSS.n191 2.25406
R559 VSS.n30 VSS.n192 2.25406
R560 VSS.n30 VSS.n193 2.25406
R561 VSS.n30 VSS.n194 2.25406
R562 VSS.n30 VSS.n195 2.25406
R563 VSS.n30 VSS.n196 2.25406
R564 VSS.n30 VSS.n197 2.25406
R565 VSS.n30 VSS.n199 2.25406
R566 VSS.n30 VSS.n200 2.25406
R567 VSS.n30 VSS.n201 2.25406
R568 VSS.n30 VSS.n202 2.25406
R569 VSS.n30 VSS.n203 2.25406
R570 VSS.n30 VSS.n204 2.25406
R571 VSS.n30 VSS.n205 2.25406
R572 VSS.n30 VSS.n206 2.25406
R573 VSS.n30 VSS.n207 2.25406
R574 VSS.n30 VSS.n208 2.25406
R575 VSS.n30 VSS.n209 2.25406
R576 VSS.n30 VSS.n210 2.25406
R577 VSS.n30 VSS.n211 2.25406
R578 VSS.n30 VSS.n212 2.25406
R579 VSS.n30 VSS.n353 2.25406
R580 VSS.t48 VSS.n333 2.2505
R581 VSS.t41 VSS.n329 2.2505
R582 VSS.t52 VSS.n314 2.2505
R583 VSS.t46 VSS.n350 2.2505
R584 VSS.n360 VSS.n32 2.09947
R585 VSS.n362 VSS.n32 2.09947
R586 VSS.n364 VSS.n32 2.09947
R587 VSS.n179 VSS.n32 2.09947
R588 VSS.n366 VSS.n32 2.09947
R589 VSS.n368 VSS.n32 2.09947
R590 VSS.n370 VSS.n32 2.09947
R591 VSS.n372 VSS.n32 2.09947
R592 VSS.n29 VSS.n284 2.09862
R593 VSS.n304 VSS.n29 2.09862
R594 VSS.n29 VSS.n287 2.0986
R595 VSS.n29 VSS.n285 2.09857
R596 VSS.n29 VSS.n283 2.09849
R597 VSS.n29 VSS.n143 2.09849
R598 VSS.n29 VSS.n288 2.09849
R599 VSS.n29 VSS.n289 2.09849
R600 VSS.n30 VSS.n198 1.92189
R601 VSS.t46 VSS.n30 1.03764
R602 VSS.n354 VSS.n139 1.53502
R603 VSS.n351 VSS.n140 1.53502
R604 VSS.n375 VSS.n2 1.21808
R605 VSS.n41 VSS.n296 1.52811
R606 VSS.n4 VSS.n303 1.52811
R607 VSS.t56 VSS.n358 1.21797
R608 VSS.n5 VSS.n29 1.13482
R609 VSS.t48 VSS.n141 1.08267
R610 VSS.n141 VSS.t52 1.03735
R611 VSS.n7 VSS.n32 0.813723
R612 VSS.n374 VSS.n32 0.91152
R613 VSS.n29 VSS.n13 0.910334
R614 VSS.n29 VSS.n28 0.909407
R615 VSS.n141 VSS.n89 0.650322
R616 VSS.n141 VSS.n90 0.650322
R617 VSS.n141 VSS.n91 0.650322
R618 VSS.n141 VSS.n92 0.650322
R619 VSS.n141 VSS.n93 0.650322
R620 VSS.n141 VSS.n94 0.650322
R621 VSS.n141 VSS.n95 0.650322
R622 VSS.n141 VSS.n96 0.650322
R623 VSS.n141 VSS.n98 0.650322
R624 VSS.n141 VSS.n100 0.650322
R625 VSS.n141 VSS.n101 0.650322
R626 VSS.n141 VSS.n102 0.650322
R627 VSS.n141 VSS.n103 0.650322
R628 VSS.n141 VSS.n104 0.650322
R629 VSS.n141 VSS.n105 0.650322
R630 VSS.n141 VSS.n106 0.650322
R631 VSS.n141 VSS.n107 0.650322
R632 VSS.n141 VSS.n108 0.650322
R633 VSS.n141 VSS.n109 0.650322
R634 VSS.n141 VSS.n111 0.650322
R635 VSS.n141 VSS.n113 0.650322
R636 VSS.n141 VSS.n114 0.650322
R637 VSS.n141 VSS.n115 0.650322
R638 VSS.n141 VSS.n116 0.650322
R639 VSS.n141 VSS.n118 0.650322
R640 VSS.n141 VSS.n120 0.650322
R641 VSS.n141 VSS.n121 0.650322
R642 VSS.n141 VSS.n122 0.650322
R643 VSS.n141 VSS.n123 0.650322
R644 VSS.n141 VSS.n124 0.650322
R645 VSS.n141 VSS.n125 0.650322
R646 VSS.n141 VSS.n127 0.650322
R647 VSS.n141 VSS.n129 0.650322
R648 VSS.n141 VSS.n130 0.650322
R649 VSS.n141 VSS.n131 0.650322
R650 VSS.n141 VSS.n132 0.650322
R651 VSS.n141 VSS.n133 0.650322
R652 VSS.n141 VSS.n134 0.650322
R653 VSS.n141 VSS.n135 0.650322
R654 VSS.n141 VSS.n136 0.650322
R655 VSS.n141 VSS.n137 0.650322
R656 VSS.n141 VSS.n138 0.650322
R657 VSS.n306 VSS.n277 0.632727
R658 VSS.n382 VSS.n381 0.5505
R659 VSS.n307 VSS.n177 0.2444
R660 VSS.n307 VSS.n306 0.2444
R661 VSS.n379 VSS.n178 0.2444
R662 VSS.n278 VSS.n178 0.2444
R663 VSS.n296 VSS.n295 0.209825
R664 VSS.n303 VSS.n302 0.209825
R665 VSS.n373 VSS.t3 0.201663
R666 VSS.n371 VSS.t6 0.201663
R667 VSS.n369 VSS.t9 0.201663
R668 VSS.n367 VSS.t12 0.201663
R669 VSS.n365 VSS.t18 0.201663
R670 VSS.n363 VSS.t21 0.201663
R671 VSS.n361 VSS.t24 0.201663
R672 VSS.n359 VSS.t27 0.201663
R673 VSS.t134 VSS.n294 0.201663
R674 VSS.t131 VSS.n290 0.201663
R675 VSS.t128 VSS.n291 0.201663
R676 VSS.n286 VSS.t125 0.201663
R677 VSS.n282 VSS.t119 0.201663
R678 VSS.t116 VSS.n299 0.201663
R679 VSS.t113 VSS.n298 0.201663
R680 VSS.t110 VSS.n297 0.201663
R681 VSS.n59 VSS.t89 0.201663
R682 VSS.n59 VSS.t61 0.201663
R683 VSS.n47 VSS.t91 0.201663
R684 VSS.t64 VSS.n47 0.201663
R685 VSS.n12 VSS.t93 0.201663
R686 VSS.t67 VSS.n12 0.201663
R687 VSS.n73 VSS.t95 0.201663
R688 VSS.t70 VSS.n73 0.201663
R689 VSS.n75 VSS.t99 0.201663
R690 VSS.n75 VSS.t76 0.201663
R691 VSS.n9 VSS.t101 0.201663
R692 VSS.t79 VSS.n9 0.201663
R693 VSS.n44 VSS.t103 0.201663
R694 VSS.t82 VSS.n44 0.201663
R695 VSS.n36 VSS.t105 0.201663
R696 VSS.t85 VSS.n36 0.201663
R697 VSS.t73 VSS.t97 0.185696
R698 VSS.n376 VSS.n375 0.16242
R699 VSS.n377 VSS.n376 0.16242
R700 VSS.n182 VSS.n377 0.16242
R701 VSS.n180 VSS.n182 0.16242
R702 VSS.n180 VSS.n181 0.16242
R703 VSS.n356 VSS.n181 0.16242
R704 VSS.n357 VSS.n356 0.16242
R705 VSS.n358 VSS.n357 0.16242
R706 VSS.n302 VSS.n301 0.16242
R707 VSS.n301 VSS.n300 0.16242
R708 VSS.n300 VSS.n280 0.16242
R709 VSS.n281 VSS.n280 0.16242
R710 VSS.n281 VSS.n279 0.16242
R711 VSS.n292 VSS.n279 0.16242
R712 VSS.n293 VSS.n292 0.16242
R713 VSS.n295 VSS.n293 0.16242
R714 VSS.n294 VSS.n28 0.14706
R715 VSS.n297 VSS.n13 0.145358
R716 VSS.n374 VSS.n373 0.144129
R717 VSS.n141 VSS.n140 0.139317
R718 VSS.n338 VSS.n337 0.117247
R719 VSS.n345 VSS.n344 0.1171
R720 VSS.n373 VSS.n372 0.0952183
R721 VSS.n294 VSS.n289 0.093817
R722 VSS.n297 VSS.n283 0.0936887
R723 VSS.n371 VSS.n370 0.0927738
R724 VSS.n360 VSS.n359 0.0925656
R725 VSS.n298 VSS.n284 0.0915644
R726 VSS.n290 VSS.n288 0.0913725
R727 VSS.n369 VSS.n368 0.0903294
R728 VSS.t15 VSS.n179 0.0903294
R729 VSS.n362 VSS.n361 0.0901212
R730 VSS.t122 VSS.n304 0.08912
R731 VSS.n299 VSS.n285 0.0890584
R732 VSS.t122 VSS.n143 0.0890531
R733 VSS.n291 VSS.n287 0.0888607
R734 VSS.n367 VSS.n366 0.0878849
R735 VSS.n365 VSS.n364 0.0878849
R736 VSS.n366 VSS.t15 0.0876767
R737 VSS.n364 VSS.n363 0.0876767
R738 VSS.n287 VSS.n286 0.0866766
R739 VSS.n286 VSS.n143 0.0864836
R740 VSS.n285 VSS.n282 0.0864834
R741 VSS.n304 VSS.n282 0.0864173
R742 VSS.n363 VSS.n362 0.0854405
R743 VSS.n368 VSS.n367 0.0852323
R744 VSS.n179 VSS.n365 0.0852323
R745 VSS.t53 VSS.n374 0.0847768
R746 VSS.n291 VSS.n288 0.0841643
R747 VSS.n299 VSS.n284 0.0839729
R748 VSS.t31 VSS.n13 0.0834709
R749 VSS.n361 VSS.n360 0.082996
R750 VSS.n370 VSS.n369 0.0827878
R751 VSS.n382 VSS.n177 0.0827273
R752 VSS.n380 VSS.n379 0.0827273
R753 VSS.t35 VSS.n28 0.0827016
R754 VSS.n298 VSS.n283 0.0818468
R755 VSS.n290 VSS.n289 0.0817198
R756 VSS.n338 VSS.n327 0.08146
R757 VSS.n327 VSS.n326 0.08146
R758 VSS.n326 VSS.n309 0.08146
R759 VSS.n310 VSS.n309 0.08146
R760 VSS.n341 VSS.n310 0.08146
R761 VSS.n342 VSS.n341 0.08146
R762 VSS.n343 VSS.n342 0.08146
R763 VSS.n344 VSS.n343 0.08146
R764 VSS.n372 VSS.n371 0.0803434
R765 VSS.t41 VSS.n244 0.0592831
R766 VSS.n244 VSS.n30 1.2978
R767 VSS.n381 VSS 0.0445
R768 VSS.n277 VSS 0.0445
R769 VSS.n281 VSS.t122 0.0394179
R770 VSS.t15 VSS.n180 0.0394179
R771 VSS.n378 VSS.n180 0.0389615
R772 VSS.n305 VSS.n281 0.0389615
R773 VSS.t49 VSS.n332 0.031258
R774 VSS.n330 VSS.t42 0.031258
R775 VSS.t51 VSS.n313 0.031258
R776 VSS.n337 VSS.n336 0.0291125
R777 VSS.n345 VSS.n276 0.0291125
R778 VSS.n349 VSS.n345 0.0291125
R779 VSS.n337 VSS.n328 0.0291125
R780 VSS.n336 VSS.n329 0.0281144
R781 VSS.n314 VSS.n276 0.0281144
R782 VSS.n350 VSS.n349 0.0281144
R783 VSS.n333 VSS.n328 0.0281144
R784 VSS.n346 VSS.n57 0.0216549
R785 VSS.n347 VSS.t45 0.0208704
R786 VSS.n331 VSS.n68 0.0202884
R787 VSS.n335 VSS.n334 0.0202884
R788 VSS.n348 VSS.n347 0.0202884
R789 VSS.n312 VSS.n311 0.0202884
R790 VSS.n310 VSS.n308 0.0197308
R791 VSS.n310 VSS.t97 0.019449
R792 VSS.n70 VSS.n67 0.0111909
R793 VSS.n2 VSS.n0 0.00771345
R794 VSS.t35 VSS.n52 0.0133922
R795 VSS.n53 VSS.t31 0.0133922
R796 VSS.n57 VSS.n56 0.0118857
R797 VSS.n315 VSS.n56 0.0118857
R798 VSS.n316 VSS.n55 0.0180746
R799 VSS.n317 VSS.n219 0.0118857
R800 VSS.n318 VSS.n62 0.0180745
R801 VSS.n319 VSS.n222 0.0118857
R802 VSS.n75 VSS.n74 0.00858771
R803 VSS.n321 VSS.n263 0.0118857
R804 VSS.n322 VSS.n262 0.0118857
R805 VSS.n323 VSS.n230 0.0118857
R806 VSS.n324 VSS.n230 0.0118857
R807 VSS.n73 VSS.n72 0.0118857
R808 VSS.n12 VSS.n11 0.0161786
R809 VSS.n325 VSS.n250 0.0118857
R810 VSS.n339 VSS.n239 0.0118857
R811 VSS.n340 VSS.n241 0.0118857
R812 VSS.n339 VSS.n241 0.0118857
R813 VSS.n325 VSS.n249 0.0118857
R814 VSS.n66 VSS.n250 0.0222498
R815 VSS.n54 VSS.n253 0.0161786
R816 VSS.n65 VSS.n253 0.0222498
R817 VSS.n64 VSS.n11 0.0222498
R818 VSS.n324 VSS.n72 0.0118857
R819 VSS.n323 VSS.n45 0.0251412
R820 VSS.n46 VSS.n260 0.0276545
R821 VSS.n322 VSS.n260 0.0118857
R822 VSS.n321 VSS.n262 0.0118857
R823 VSS.n320 VSS.n225 0.0118857
R824 VSS.n318 VSS.n222 0.0118857
R825 VSS.n317 VSS.n43 0.0118857
R826 VSS.n316 VSS.n219 0.0118857
R827 VSS.n70 VSS.n68 0.0115582
R828 VSS.n334 VSS.n70 0.0115582
R829 VSS.n312 VSS.n57 0.0112672
R830 VSS.n29 VSS.n14 0.00406306
R831 VSS.n29 VSS.n15 0.0112168
R832 VSS.n29 VSS.n16 0.0112168
R833 VSS.n29 VSS.n17 0.0112168
R834 VSS.n29 VSS.n18 0.0112168
R835 VSS.n29 VSS.n19 0.0112168
R836 VSS.n29 VSS.n21 0.0112168
R837 VSS.n29 VSS.n22 0.0112168
R838 VSS.n29 VSS.n23 0.0112168
R839 VSS.n29 VSS.n24 0.0112168
R840 VSS.n29 VSS.n25 0.0112168
R841 VSS.n29 VSS.n26 0.0112168
R842 VSS.n29 VSS.t136 9.76925
R843 VSS.n141 VSS.n139 0.141883
R844 VSS.n7 VSS.n359 0.158372
R845 VSS.n332 VSS.n331 0.0108877
R846 VSS.n335 VSS.n330 0.0108877
R847 VSS.n348 VSS.n346 0.0108877
R848 VSS.n313 VSS.n311 0.0108877
R849 VSS.t52 VSS.n57 0.0101032
R850 VSS.n70 VSS.t48 0.00981217
R851 VSS.n70 VSS.t41 0.00981217
R852 VSS.n29 VSS.n20 0.00963963
R853 VSS VSS.n382 0.0095
R854 VSS.n380 VSS 0.0095
R855 VSS.n225 VSS.n10 0.0375578
R856 VSS.n50 VSS.n12 0.0347883
R857 VSS.n73 VSS.n63 0.0293313
R858 VSS.n36 VSS.n35 0.0273751
R859 VSS.n29 VSS.n27 0.0237281
R860 VSS.n37 VSS.n32 0.0229768
R861 VSS.n32 VSS.n38 0.0227665
R862 VSS.t56 VSS.n6 0.0225654
R863 VSS.n44 VSS.n62 0.0220072
R864 VSS.n3 VSS.n53 0.0123024
R865 VSS.n40 VSS.n52 0.0123024
R866 VSS.n48 VSS.n47 0.0139826
R867 VSS.n239 VSS.n71 0.0219621
R868 VSS.n54 VSS.n47 0.0219195
R869 VSS.t97 VSS.n45 0.0136973
R870 VSS.n9 VSS.n8 0.00800306
R871 VSS.t46 VSS.n57 0.0214488
R872 VSS.n31 VSS.n30 0.0113189
R873 VSS.n44 VSS.n43 0.0203286
R874 VSS.n70 VSS.n69 0.0200861
R875 VSS.n36 VSS.n34 0.0174081
R876 VSS.n263 VSS.n76 0.0174081
R877 VSS.n249 VSS.n61 0.0174081
R878 VSS.n5 VSS.t33 17.0032
C0 vin1 vin2 0.05053f
C1 VDD vin4 29.2329f
C2 vin3 vin4 0.05053f
C3 VDD vout4 15.3949f
C4 VDD vout1 15.3949f
C5 VDD vout2 15.3834f
C6 VDD vin3 29.202f
C7 VDD vout3 15.3834f
C8 vout3 vin3 18.2968f
C9 vout1 vin1 18.2968f
C10 VDD vin1 29.2329f
C11 vout2 vin2 18.2968f
C12 VDD vin2 29.202f
C13 vin3 vin2 0.05785f
C14 vin4 vout4 18.2968f
C15 vout1 VSS 13.57609f
C16 vout2 VSS 13.55759f
C17 vout3 VSS 13.55759f
C18 vout4 VSS 13.57609f
C19 VSS.t105 VSS 8.00945f
C20 VSS.t76 VSS 8.00945f
C21 VSS.t24 VSS 8.0271f
.ends

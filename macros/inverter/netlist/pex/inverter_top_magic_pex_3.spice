* PEX produced on Tue May  5 11:31:56 PM CEST 2026 using /foss/tools/sak/sak-pex.sh with m=3 and s=1
* NGSPICE file created from inverter_top_pex.ext - technology: ihp-sg13g2

.subckt inverter_top_pex VDD vin4 vout4 VSS vin3 vout3 vin2 vout2 vout1 vin1
X0 VDD.t16 vin4.t0 vout4.t5 VDD.t0 sg13_lv_pmos ad=1.14p pd=6.38u as=1.14p ps=6.38u w=6u l=1u
X1 VDD.t41 VDD.t95 VDD.t41 VDD.t21 sg13_lv_pmos ad=1.14p pd=6.38u as=0 ps=0 w=6u l=1u
X2 vout2.t11 vin2.t2 VSS.t72 VSS.t73 sg13_lv_nmos ad=0.19p pd=1.38u as=0.19p ps=1.38u w=1u l=1u
X3 vout3.t15 vin3.t2 VDD.t65 VDD.t0 sg13_lv_pmos ad=1.14p pd=6.38u as=1.14p ps=6.38u w=6u l=1u
X4 vout3.t2 vin3.t0 VSS.t38 VSS.t55 sg13_lv_nmos ad=0.19p pd=1.38u as=0.19p ps=1.38u w=1u l=1u
X5 vout2.t14 vin2.t2 VSS.t66 VSS.t67 sg13_lv_nmos ad=0.19p pd=1.38u as=0.19p ps=1.38u w=1u l=1u
X6 vout4.t18 vin4.t2 VSS.t3 VSS.t4 sg13_lv_nmos ad=0.19p pd=1.38u as=0.19p ps=1.38u w=1u l=1u
X7 VDD.t41 vin2.t0 vout2.t3 VDD.t21 sg13_lv_pmos ad=1.14p pd=6.38u as=1.14p ps=6.38u w=6u l=1u
X8 vout4.t8 vin4.t0 VDD.t18 VDD.t0 sg13_lv_pmos ad=1.14p pd=6.38u as=1.14p ps=6.38u w=6u l=1u
X9 VSS.t72 vin2.t2 vout2.t19 VSS.t71 sg13_lv_nmos ad=0.19p pd=1.38u as=0.19p ps=1.38u w=1u l=1u
X10 vout2.t12 vin2.t2 VSS.t75 VSS.t76 sg13_lv_nmos ad=0.19p pd=1.38u as=0.19p ps=1.38u w=1u l=1u
X11 VSS.t9 vin4.t2 vout4.t10 VSS.t8 sg13_lv_nmos ad=0.19p pd=1.38u as=0.19p ps=1.38u w=1u l=1u
X12 vout1.t15 vin1.t0 VSS.t107 VSS.t108 sg13_lv_nmos ad=0.19p pd=1.38u as=0.19p ps=1.38u w=1u l=1u
X13 vout2.t4 vin2.t0 VDD.t23 VDD.t21 sg13_lv_pmos ad=1.14p pd=6.38u as=1.14p ps=6.38u w=6u l=1u
X14 VDD.t27 vin2.t0 vout2.t5 VDD.t21 sg13_lv_pmos ad=1.14p pd=6.38u as=1.14p ps=6.38u w=6u l=1u
X15 vout4.t12 vin4.t2 VSS.t1 VSS.t0 sg13_lv_nmos ad=0.19p pd=1.38u as=0.19p ps=1.38u w=1u l=1u
X16 VDD.t23 vin2.t0 vout2.t9 VDD.t21 sg13_lv_pmos ad=1.14p pd=6.38u as=1.14p ps=6.38u w=6u l=1u
X17 VSS.t130 vin3.t0 vout3.t6 VSS.t80 sg13_lv_nmos ad=0.19p pd=1.38u as=0.19p ps=1.38u w=1u l=1u
X18 vout4.t13 vin4.t2 VSS.t18 VSS.t19 sg13_lv_nmos ad=0.19p pd=1.38u as=0.19p ps=1.38u w=1u l=1u
X19 VSS.t12 vin4.t2 vout4.t11 VSS.t11 sg13_lv_nmos ad=0.19p pd=1.38u as=0.19p ps=1.38u w=1u l=1u
X20 VDD.t65 vin3.t2 vout3.t14 VDD.t0 sg13_lv_pmos ad=1.14p pd=6.38u as=1.14p ps=6.38u w=6u l=1u
X21 vout3.t18 vin3.t2 VDD.t67 VDD.t0 sg13_lv_pmos ad=1.14p pd=6.38u as=1.14p ps=6.38u w=6u l=1u
X22 VDD.t37 vin2.t0 vout2.t1 VDD.t21 sg13_lv_pmos ad=1.14p pd=6.38u as=1.14p ps=6.38u w=6u l=1u
X23 VSS.t66 vin2.t2 vout2.t13 VSS.t65 sg13_lv_nmos ad=0.19p pd=1.38u as=0.19p ps=1.38u w=1u l=1u
X24 VDD.t71 vin3.t2 vout3.t19 VDD.t0 sg13_lv_pmos ad=1.14p pd=6.38u as=1.14p ps=6.38u w=6u l=1u
X25 VSS.t39 VSS.t36 VSS.t38 VSS.t37 sg13_lv_nmos ad=0.34p pd=2.68u as=0 ps=0 w=1u l=1u
X26 vout2.t3 vin2.t0 VDD.t39 VDD.t21 sg13_lv_pmos ad=1.14p pd=6.38u as=1.14p ps=6.38u w=6u l=1u
X27 vout2.t19 vin2.t2 VSS.t69 VSS.t70 sg13_lv_nmos ad=0.19p pd=1.38u as=0.19p ps=1.38u w=1u l=1u
X28 VSS.t75 vin2.t2 vout2.t11 VSS.t74 sg13_lv_nmos ad=0.19p pd=1.38u as=0.19p ps=1.38u w=1u l=1u
X29 vout4.t19 vin4.t2 VSS.t15 VSS.t16 sg13_lv_nmos ad=0.19p pd=1.38u as=0.19p ps=1.38u w=1u l=1u
X30 vout1.t13 vin1.t0 VSS.t101 VSS.t102 sg13_lv_nmos ad=0.19p pd=1.38u as=0.19p ps=1.38u w=1u l=1u
X31 vout1.t6 vin1.t2 VDD.t45 VDD.t21 sg13_lv_pmos ad=1.14p pd=6.38u as=1.14p ps=6.38u w=6u l=1u
X32 vout1.t11 vin1.t0 VSS.t95 VSS.t96 sg13_lv_nmos ad=0.19p pd=1.38u as=0.19p ps=1.38u w=1u l=1u
X33 VSS.t101 vin1.t0 vout1.t12 VSS.t100 sg13_lv_nmos ad=0.19p pd=1.38u as=0.19p ps=1.38u w=1u l=1u
X34 VSS.t21 vin4.t2 vout4.t13 VSS.t20 sg13_lv_nmos ad=0.19p pd=1.38u as=0.19p ps=1.38u w=1u l=1u
X35 VDD.t4 vin4.t0 vout4.t6 VDD.t0 sg13_lv_pmos ad=1.14p pd=6.38u as=1.14p ps=6.38u w=6u l=1u
X36 VDD.t81 VDD.t90 VDD.t81 VDD.t0 sg13_lv_pmos ad=1.14p pd=6.38u as=0 ps=0 w=6u l=1u
X37 vout1.t14 vin1.t0 VSS.t104 VSS.t105 sg13_lv_nmos ad=0.19p pd=1.38u as=0.19p ps=1.38u w=1u l=1u
X38 vout2.t9 vin2.t0 VDD.t22 VDD.t21 sg13_lv_pmos ad=1.14p pd=6.38u as=1.14p ps=6.38u w=6u l=1u
X39 vout3.t6 vin3.t0 VSS.t128 VSS.t79 sg13_lv_nmos ad=0.19p pd=1.38u as=0.19p ps=1.38u w=1u l=1u
X40 VDD.t81 vin3.t1 vout3.t10 VDD.t0 sg13_lv_pmos ad=1.14p pd=6.38u as=1.14p ps=6.38u w=6u l=1u
X41 vout4.t2 vin4.t0 VDD.t6 VDD.t0 sg13_lv_pmos ad=1.14p pd=6.38u as=1.14p ps=6.38u w=6u l=1u
X42 VDD.t2 vin4.t0 vout4.t7 VDD.t0 sg13_lv_pmos ad=1.14p pd=6.38u as=1.14p ps=6.38u w=6u l=1u
X43 vout3.t14 vin3.t2 VDD.t63 VDD.t0 sg13_lv_pmos ad=1.14p pd=6.38u as=1.14p ps=6.38u w=6u l=1u
X44 VSS.t30 VSS.t34 VSS.t30 VSS.t35 sg13_lv_nmos ad=0.19p pd=1.38u as=0 ps=0 w=1u l=1u
X45 VDD.t67 vin3.t2 vout3.t15 VDD.t0 sg13_lv_pmos ad=1.14p pd=6.38u as=1.14p ps=6.38u w=6u l=1u
X46 VDD.t10 vin4.t0 vout4.t3 VDD.t0 sg13_lv_pmos ad=1.14p pd=6.38u as=1.14p ps=6.38u w=6u l=1u
X47 VDD.t39 vin2.t0 vout2.t2 VDD.t21 sg13_lv_pmos ad=1.14p pd=6.38u as=1.14p ps=6.38u w=6u l=1u
X48 VSS.t24 vin4.t2 vout4.t14 VSS.t23 sg13_lv_nmos ad=0.19p pd=1.38u as=0.19p ps=1.38u w=1u l=1u
X49 VDD.t63 vin3.t2 vout3.t11 VDD.t0 sg13_lv_pmos ad=1.14p pd=6.38u as=1.14p ps=6.38u w=6u l=1u
X50 VDD.t45 vin1.t2 vout1.t5 VDD.t21 sg13_lv_pmos ad=1.14p pd=6.38u as=1.14p ps=6.38u w=6u l=1u
X51 VSS.t95 vin1.t0 vout1.t10 VSS.t94 sg13_lv_nmos ad=0.19p pd=1.38u as=0.19p ps=1.38u w=1u l=1u
X52 vout1.t1 vin1.t2 VDD.t47 VDD.t21 sg13_lv_pmos ad=1.14p pd=6.38u as=1.14p ps=6.38u w=6u l=1u
X53 vout4.t16 vin4.t2 VSS.t27 VSS.t28 sg13_lv_nmos ad=0.19p pd=1.38u as=0.19p ps=1.38u w=1u l=1u
X54 vout4.t3 vin4.t0 VDD.t8 VDD.t0 sg13_lv_pmos ad=1.14p pd=6.38u as=1.14p ps=6.38u w=6u l=1u
X55 vout1.t12 vin1.t0 VSS.t98 VSS.t99 sg13_lv_nmos ad=0.19p pd=1.38u as=0.19p ps=1.38u w=1u l=1u
X56 VDD.t51 vin1.t2 vout1.t2 VDD.t21 sg13_lv_pmos ad=1.14p pd=6.38u as=1.14p ps=6.38u w=6u l=1u
X57 VSS.t104 vin1.t0 vout1.t13 VSS.t103 sg13_lv_nmos ad=0.19p pd=1.38u as=0.19p ps=1.38u w=1u l=1u
X58 vout4.t9 vin4.t0 VDD.t16 VDD.t0 sg13_lv_pmos ad=1.14p pd=6.38u as=1.14p ps=6.38u w=6u l=1u
X59 vout3.t5 vin3.t0 VSS.t124 VSS.t73 sg13_lv_nmos ad=0.19p pd=1.38u as=0.19p ps=1.38u w=1u l=1u
X60 VDD.t94 VDD.t92 VDD.t22 VDD.t21 sg13_lv_pmos ad=2.04p pd=12.68u as=0 ps=0 w=6u l=1u
X61 VDD.t77 vin3.t2 vout3.t12 VDD.t0 sg13_lv_pmos ad=1.14p pd=6.38u as=1.14p ps=6.38u w=6u l=1u
X62 VDD.t12 vin4.t0 vout4.t0 VDD.t0 sg13_lv_pmos ad=1.14p pd=6.38u as=1.14p ps=6.38u w=6u l=1u
X63 vout3.t10 vin3.t2 VDD.t79 VDD.t0 sg13_lv_pmos ad=1.14p pd=6.38u as=1.14p ps=6.38u w=6u l=1u
X64 vout3.t9 vin3.t0 VSS.t120 VSS.t67 sg13_lv_nmos ad=0.19p pd=1.38u as=0.19p ps=1.38u w=1u l=1u
X65 VSS.t124 vin3.t0 vout3.t4 VSS.t71 sg13_lv_nmos ad=0.19p pd=1.38u as=0.19p ps=1.38u w=1u l=1u
X66 VDD.t61 VDD.t100 VDD.t61 VDD.t21 sg13_lv_pmos ad=1.14p pd=6.38u as=0 ps=0 w=6u l=1u
X67 vout3.t8 vin3.t0 VSS.t126 VSS.t76 sg13_lv_nmos ad=0.19p pd=1.38u as=0.19p ps=1.38u w=1u l=1u
X68 vout4.t5 vin4.t0 VDD.t14 VDD.t0 sg13_lv_pmos ad=1.14p pd=6.38u as=1.14p ps=6.38u w=6u l=1u
X69 vout3.t11 vin3.t2 VDD.t62 VDD.t0 sg13_lv_pmos ad=1.14p pd=6.38u as=1.14p ps=6.38u w=6u l=1u
X70 VDD.t61 vin1.t1 vout1.t0 VDD.t21 sg13_lv_pmos ad=1.14p pd=6.38u as=1.14p ps=6.38u w=6u l=1u
X71 vout2.t2 vin2.t0 VDD.t37 VDD.t21 sg13_lv_pmos ad=1.14p pd=6.38u as=1.14p ps=6.38u w=6u l=1u
X72 vout1.t5 vin1.t2 VDD.t43 VDD.t21 sg13_lv_pmos ad=1.14p pd=6.38u as=1.14p ps=6.38u w=6u l=1u
X73 vout2.t18 vin2.t2 VSS.t60 VSS.t61 sg13_lv_nmos ad=0.19p pd=1.38u as=0.19p ps=1.38u w=1u l=1u
X74 VDD.t47 vin1.t2 vout1.t6 VDD.t21 sg13_lv_pmos ad=1.14p pd=6.38u as=1.14p ps=6.38u w=6u l=1u
X75 VDD.t43 vin1.t2 vout1.t9 VDD.t21 sg13_lv_pmos ad=1.14p pd=6.38u as=1.14p ps=6.38u w=6u l=1u
X76 VDD.t79 vin3.t2 vout3.t13 VDD.t0 sg13_lv_pmos ad=1.14p pd=6.38u as=1.14p ps=6.38u w=6u l=1u
X77 VSS.t120 vin3.t0 vout3.t1 VSS.t65 sg13_lv_nmos ad=0.19p pd=1.38u as=0.19p ps=1.38u w=1u l=1u
X78 VSS.t6 vin4.t2 vout4.t18 VSS.t5 sg13_lv_nmos ad=0.19p pd=1.38u as=0.19p ps=1.38u w=1u l=1u
X79 vout3.t4 vin3.t0 VSS.t122 VSS.t70 sg13_lv_nmos ad=0.19p pd=1.38u as=0.19p ps=1.38u w=1u l=1u
X80 VDD.t20 vin4.t0 vout4.t8 VDD.t0 sg13_lv_pmos ad=1.14p pd=6.38u as=1.14p ps=6.38u w=6u l=1u
X81 VSS.t126 vin3.t0 vout3.t5 VSS.t74 sg13_lv_nmos ad=0.19p pd=1.38u as=0.19p ps=1.38u w=1u l=1u
X82 VDD.t57 vin1.t2 vout1.t3 VDD.t21 sg13_lv_pmos ad=1.14p pd=6.38u as=1.14p ps=6.38u w=6u l=1u
X83 vout2.t0 vin2.t0 VDD.t33 VDD.t21 sg13_lv_pmos ad=1.14p pd=6.38u as=1.14p ps=6.38u w=6u l=1u
X84 vout4.t11 vin4.t2 VSS.t9 VSS.t10 sg13_lv_nmos ad=0.19p pd=1.38u as=0.19p ps=1.38u w=1u l=1u
X85 vout1.t0 vin1.t2 VDD.t59 VDD.t21 sg13_lv_pmos ad=1.14p pd=6.38u as=1.14p ps=6.38u w=6u l=1u
X86 VSS.t3 vin4.t2 vout4.t12 VSS.t2 sg13_lv_nmos ad=0.19p pd=1.38u as=0.19p ps=1.38u w=1u l=1u
X87 vout2.t6 vin2.t0 VDD.t29 VDD.t21 sg13_lv_pmos ad=1.14p pd=6.38u as=1.14p ps=6.38u w=6u l=1u
X88 VDD.t89 VDD.t87 VDD.t62 VDD.t0 sg13_lv_pmos ad=2.04p pd=12.68u as=0 ps=0 w=6u l=1u
X89 VSS.t15 vin4.t2 vout4.t17 VSS.t14 sg13_lv_nmos ad=0.19p pd=1.38u as=0.19p ps=1.38u w=1u l=1u
X90 VDD.t33 vin2.t0 vout2.t7 VDD.t21 sg13_lv_pmos ad=1.14p pd=6.38u as=1.14p ps=6.38u w=6u l=1u
X91 VSS.t60 vin2.t2 vout2.t17 VSS.t59 sg13_lv_nmos ad=0.19p pd=1.38u as=0.19p ps=1.38u w=1u l=1u
X92 VDD.t84 VDD.t82 VDD.t1 VDD.t0 sg13_lv_pmos ad=2.04p pd=12.68u as=0 ps=0 w=6u l=1u
X93 vout2.t1 vin2.t0 VDD.t35 VDD.t21 sg13_lv_pmos ad=1.14p pd=6.38u as=1.14p ps=6.38u w=6u l=1u
X94 vout2.t13 vin2.t2 VSS.t63 VSS.t64 sg13_lv_nmos ad=0.19p pd=1.38u as=0.19p ps=1.38u w=1u l=1u
X95 VSS.t69 vin2.t2 vout2.t14 VSS.t68 sg13_lv_nmos ad=0.19p pd=1.38u as=0.19p ps=1.38u w=1u l=1u
X96 vout1.t9 vin1.t2 VDD.t42 VDD.t21 sg13_lv_pmos ad=1.14p pd=6.38u as=1.14p ps=6.38u w=6u l=1u
X97 vout1.t17 vin1.t0 VSS.t89 VSS.t90 sg13_lv_nmos ad=0.19p pd=1.38u as=0.19p ps=1.38u w=1u l=1u
X98 vout4.t17 vin4.t2 VSS.t12 VSS.t13 sg13_lv_nmos ad=0.19p pd=1.38u as=0.19p ps=1.38u w=1u l=1u
X99 vout3.t13 vin3.t2 VDD.t77 VDD.t0 sg13_lv_pmos ad=1.14p pd=6.38u as=1.14p ps=6.38u w=6u l=1u
X100 vout4.t15 vin4.t2 VSS.t24 VSS.t25 sg13_lv_nmos ad=0.19p pd=1.38u as=0.19p ps=1.38u w=1u l=1u
X101 VSS.t47 VSS.t46 VSS.t47 VSS.t41 sg13_lv_nmos ad=0.19p pd=1.38u as=0 ps=0 w=1u l=1u
X102 VSS.t18 vin4.t2 vout4.t19 VSS.t17 sg13_lv_nmos ad=0.19p pd=1.38u as=0.19p ps=1.38u w=1u l=1u
X103 VDD.t59 vin1.t2 vout1.t4 VDD.t21 sg13_lv_pmos ad=1.14p pd=6.38u as=1.14p ps=6.38u w=6u l=1u
X104 VSS.t47 vin2.t1 vout2.t10 VSS.t83 sg13_lv_nmos ad=0.19p pd=1.38u as=0.19p ps=1.38u w=1u l=1u
X105 VDD.t29 vin2.t0 vout2.t8 VDD.t21 sg13_lv_pmos ad=1.14p pd=6.38u as=1.14p ps=6.38u w=6u l=1u
X106 vout4.t14 vin4.t2 VSS.t21 VSS.t22 sg13_lv_nmos ad=0.19p pd=1.38u as=0.19p ps=1.38u w=1u l=1u
X107 vout2.t7 vin2.t0 VDD.t31 VDD.t21 sg13_lv_pmos ad=1.14p pd=6.38u as=1.14p ps=6.38u w=6u l=1u
X108 vout4.t4 vin4.t0 VDD.t4 VDD.t0 sg13_lv_pmos ad=1.14p pd=6.38u as=1.14p ps=6.38u w=6u l=1u
X109 VDD.t35 vin2.t0 vout2.t0 VDD.t21 sg13_lv_pmos ad=1.14p pd=6.38u as=1.14p ps=6.38u w=6u l=1u
X110 vout2.t17 vin2.t2 VSS.t57 VSS.t58 sg13_lv_nmos ad=0.19p pd=1.38u as=0.19p ps=1.38u w=1u l=1u
X111 VSS.t63 vin2.t2 vout2.t18 VSS.t62 sg13_lv_nmos ad=0.19p pd=1.38u as=0.19p ps=1.38u w=1u l=1u
X112 VDD.t18 vin4.t0 vout4.t9 VDD.t0 sg13_lv_pmos ad=1.14p pd=6.38u as=1.14p ps=6.38u w=6u l=1u
X113 VSS.t57 vin2.t2 vout2.t16 VSS.t56 sg13_lv_nmos ad=0.19p pd=1.38u as=0.19p ps=1.38u w=1u l=1u
X114 VDD.t99 VDD.t97 VDD.t42 VDD.t21 sg13_lv_pmos ad=2.04p pd=12.68u as=0 ps=0 w=6u l=1u
X115 vout3.t17 vin3.t2 VDD.t73 VDD.t0 sg13_lv_pmos ad=1.14p pd=6.38u as=1.14p ps=6.38u w=6u l=1u
X116 VSS.t89 vin1.t0 vout1.t16 VSS.t88 sg13_lv_nmos ad=0.19p pd=1.38u as=0.19p ps=1.38u w=1u l=1u
X117 vout1.t10 vin1.t0 VSS.t92 VSS.t93 sg13_lv_nmos ad=0.19p pd=1.38u as=0.19p ps=1.38u w=1u l=1u
X118 VSS.t98 vin1.t0 vout1.t11 VSS.t97 sg13_lv_nmos ad=0.19p pd=1.38u as=0.19p ps=1.38u w=1u l=1u
X119 vout3.t19 vin3.t2 VDD.t69 VDD.t0 sg13_lv_pmos ad=1.14p pd=6.38u as=1.14p ps=6.38u w=6u l=1u
X120 VDD.t73 vin3.t2 vout3.t16 VDD.t0 sg13_lv_pmos ad=1.14p pd=6.38u as=1.14p ps=6.38u w=6u l=1u
X121 vout3.t12 vin3.t2 VDD.t75 VDD.t0 sg13_lv_pmos ad=1.14p pd=6.38u as=1.14p ps=6.38u w=6u l=1u
X122 vout3.t0 vin3.t0 VSS.t116 VSS.t61 sg13_lv_nmos ad=0.19p pd=1.38u as=0.19p ps=1.38u w=1u l=1u
X123 VSS.t78 vin2.t2 vout2.t12 VSS.t77 sg13_lv_nmos ad=0.19p pd=1.38u as=0.19p ps=1.38u w=1u l=1u
X124 vout2.t10 vin2.t2 VSS.t81 VSS.t82 sg13_lv_nmos ad=0.19p pd=1.38u as=0.19p ps=1.38u w=1u l=1u
X125 VSS.t30 vin4.t1 vout4.t16 VSS.t29 sg13_lv_nmos ad=0.19p pd=1.38u as=0.19p ps=1.38u w=1u l=1u
X126 VSS.t54 VSS.t52 VSS.t54 VSS.t53 sg13_lv_nmos ad=0.19p pd=1.38u as=0 ps=0 w=1u l=1u
X127 vout1.t4 vin1.t2 VDD.t57 VDD.t21 sg13_lv_pmos ad=1.14p pd=6.38u as=1.14p ps=6.38u w=6u l=1u
X128 VSS.t54 vin1.t0 vout1.t18 VSS.t112 sg13_lv_nmos ad=0.19p pd=1.38u as=0.19p ps=1.38u w=1u l=1u
X129 vout2.t16 vin2.t2 VSS.t44 VSS.t55 sg13_lv_nmos ad=0.19p pd=1.38u as=0.19p ps=1.38u w=1u l=1u
X130 vout1.t16 vin1.t0 VSS.t86 VSS.t87 sg13_lv_nmos ad=0.19p pd=1.38u as=0.19p ps=1.38u w=1u l=1u
X131 VSS.t33 VSS.t31 VSS.t1 VSS.t32 sg13_lv_nmos ad=0.34p pd=2.68u as=0 ps=0 w=1u l=1u
X132 VSS.t92 vin1.t0 vout1.t17 VSS.t91 sg13_lv_nmos ad=0.19p pd=1.38u as=0.19p ps=1.38u w=1u l=1u
X133 VDD.t69 vin3.t2 vout3.t18 VDD.t0 sg13_lv_pmos ad=1.14p pd=6.38u as=1.14p ps=6.38u w=6u l=1u
X134 vout3.t16 vin3.t2 VDD.t71 VDD.t0 sg13_lv_pmos ad=1.14p pd=6.38u as=1.14p ps=6.38u w=6u l=1u
X135 VSS.t86 vin1.t0 vout1.t19 VSS.t85 sg13_lv_nmos ad=0.19p pd=1.38u as=0.19p ps=1.38u w=1u l=1u
X136 vout4.t6 vin4.t0 VDD.t2 VDD.t0 sg13_lv_pmos ad=1.14p pd=6.38u as=1.14p ps=6.38u w=6u l=1u
X137 VSS.t116 vin3.t0 vout3.t3 VSS.t59 sg13_lv_nmos ad=0.19p pd=1.38u as=0.19p ps=1.38u w=1u l=1u
X138 VDD.t75 vin3.t2 vout3.t17 VDD.t0 sg13_lv_pmos ad=1.14p pd=6.38u as=1.14p ps=6.38u w=6u l=1u
X139 vout1.t8 vin1.t2 VDD.t53 VDD.t21 sg13_lv_pmos ad=1.14p pd=6.38u as=1.14p ps=6.38u w=6u l=1u
X140 vout3.t1 vin3.t0 VSS.t118 VSS.t64 sg13_lv_nmos ad=0.19p pd=1.38u as=0.19p ps=1.38u w=1u l=1u
X141 VSS.t81 vin2.t2 vout2.t15 VSS.t80 sg13_lv_nmos ad=0.19p pd=1.38u as=0.19p ps=1.38u w=1u l=1u
X142 VSS.t122 vin3.t0 vout3.t9 VSS.t68 sg13_lv_nmos ad=0.19p pd=1.38u as=0.19p ps=1.38u w=1u l=1u
X143 VDD.t6 vin4.t0 vout4.t4 VDD.t0 sg13_lv_pmos ad=1.14p pd=6.38u as=1.14p ps=6.38u w=6u l=1u
X144 vout1.t2 vin1.t2 VDD.t49 VDD.t21 sg13_lv_pmos ad=1.14p pd=6.38u as=1.14p ps=6.38u w=6u l=1u
X145 vout4.t7 vin4.t0 VDD.t1 VDD.t0 sg13_lv_pmos ad=1.14p pd=6.38u as=1.14p ps=6.38u w=6u l=1u
X146 VDD.t53 vin1.t2 vout1.t7 VDD.t21 sg13_lv_pmos ad=1.14p pd=6.38u as=1.14p ps=6.38u w=6u l=1u
X147 VSS.t107 vin1.t0 vout1.t14 VSS.t106 sg13_lv_nmos ad=0.19p pd=1.38u as=0.19p ps=1.38u w=1u l=1u
X148 vout1.t3 vin1.t2 VDD.t55 VDD.t21 sg13_lv_pmos ad=1.14p pd=6.38u as=1.14p ps=6.38u w=6u l=1u
X149 vout1.t18 vin1.t0 VSS.t110 VSS.t111 sg13_lv_nmos ad=0.19p pd=1.38u as=0.19p ps=1.38u w=1u l=1u
X150 vout2.t5 vin2.t0 VDD.t25 VDD.t21 sg13_lv_pmos ad=1.14p pd=6.38u as=1.14p ps=6.38u w=6u l=1u
X151 VSS.t42 VSS.t40 VSS.t42 VSS.t41 sg13_lv_nmos ad=0.19p pd=1.38u as=0 ps=0 w=1u l=1u
X152 vout4.t10 vin4.t2 VSS.t6 VSS.t7 sg13_lv_nmos ad=0.19p pd=1.38u as=0.19p ps=1.38u w=1u l=1u
X153 VSS.t45 VSS.t43 VSS.t44 VSS.t37 sg13_lv_nmos ad=0.34p pd=2.68u as=0 ps=0 w=1u l=1u
X154 vout4.t1 vin4.t0 VDD.t12 VDD.t0 sg13_lv_pmos ad=1.14p pd=6.38u as=1.14p ps=6.38u w=6u l=1u
X155 VSS.t27 vin4.t2 vout4.t15 VSS.t26 sg13_lv_nmos ad=0.19p pd=1.38u as=0.19p ps=1.38u w=1u l=1u
X156 VSS.t42 vin3.t0 vout3.t7 VSS.t83 sg13_lv_nmos ad=0.19p pd=1.38u as=0.19p ps=1.38u w=1u l=1u
X157 VDD.t8 vin4.t0 vout4.t2 VDD.t0 sg13_lv_pmos ad=1.14p pd=6.38u as=1.14p ps=6.38u w=6u l=1u
X158 vout1.t19 vin1.t0 VSS.t50 VSS.t84 sg13_lv_nmos ad=0.19p pd=1.38u as=0.19p ps=1.38u w=1u l=1u
X159 vout3.t3 vin3.t0 VSS.t114 VSS.t58 sg13_lv_nmos ad=0.19p pd=1.38u as=0.19p ps=1.38u w=1u l=1u
X160 VSS.t118 vin3.t0 vout3.t0 VSS.t62 sg13_lv_nmos ad=0.19p pd=1.38u as=0.19p ps=1.38u w=1u l=1u
X161 vout4.t0 vin4.t0 VDD.t10 VDD.t0 sg13_lv_pmos ad=1.14p pd=6.38u as=1.14p ps=6.38u w=6u l=1u
X162 vout2.t15 vin2.t2 VSS.t78 VSS.t79 sg13_lv_nmos ad=0.19p pd=1.38u as=0.19p ps=1.38u w=1u l=1u
X163 VDD.t49 vin1.t2 vout1.t1 VDD.t21 sg13_lv_pmos ad=1.14p pd=6.38u as=1.14p ps=6.38u w=6u l=1u
X164 VSS.t114 vin3.t0 vout3.t2 VSS.t56 sg13_lv_nmos ad=0.19p pd=1.38u as=0.19p ps=1.38u w=1u l=1u
X165 vout1.t7 vin1.t2 VDD.t51 VDD.t21 sg13_lv_pmos ad=1.14p pd=6.38u as=1.14p ps=6.38u w=6u l=1u
X166 VDD.t14 vin4.t0 vout4.t1 VDD.t0 sg13_lv_pmos ad=1.14p pd=6.38u as=1.14p ps=6.38u w=6u l=1u
X167 VSS.t110 vin1.t0 vout1.t15 VSS.t109 sg13_lv_nmos ad=0.19p pd=1.38u as=0.19p ps=1.38u w=1u l=1u
X168 VDD.t55 vin1.t2 vout1.t8 VDD.t21 sg13_lv_pmos ad=1.14p pd=6.38u as=1.14p ps=6.38u w=6u l=1u
X169 VDD.t25 vin2.t0 vout2.t4 VDD.t21 sg13_lv_pmos ad=1.14p pd=6.38u as=1.14p ps=6.38u w=6u l=1u
X170 vout2.t8 vin2.t0 VDD.t27 VDD.t21 sg13_lv_pmos ad=1.14p pd=6.38u as=1.14p ps=6.38u w=6u l=1u
X171 VDD.t31 vin2.t0 vout2.t6 VDD.t21 sg13_lv_pmos ad=1.14p pd=6.38u as=1.14p ps=6.38u w=6u l=1u
X172 VSS.t128 vin3.t0 vout3.t8 VSS.t77 sg13_lv_nmos ad=0.19p pd=1.38u as=0.19p ps=1.38u w=1u l=1u
X173 vout3.t7 vin3.t0 VSS.t130 VSS.t82 sg13_lv_nmos ad=0.19p pd=1.38u as=0.19p ps=1.38u w=1u l=1u
X174 VDD.t20 VDD.t85 VDD.t20 VDD.t0 sg13_lv_pmos ad=1.14p pd=6.38u as=0 ps=0 w=6u l=1u
X175 VSS.t51 VSS.t48 VSS.t50 VSS.t49 sg13_lv_nmos ad=0.34p pd=2.68u as=0 ps=0 w=1u l=1u
R0 vout1.n9 vout1.t18 10.2939
R1 vout1.n8 vout1.t15 10.2939
R2 vout1.n7 vout1.t14 10.2939
R3 vout1.n6 vout1.t13 10.2939
R4 vout1.n5 vout1.t12 10.2939
R5 vout1.n4 vout1.t11 10.2939
R6 vout1.n3 vout1.t10 10.2939
R7 vout1.n2 vout1.t17 10.2939
R8 vout1.n1 vout1.t16 10.2939
R9 vout1.n0 vout1.t19 10.2939
R10 vout1.n9 vout1.t0 2.0884
R11 vout1.n8 vout1.t4 2.0884
R12 vout1.n7 vout1.t3 2.0884
R13 vout1.n6 vout1.t8 2.0884
R14 vout1.n5 vout1.t7 2.0884
R15 vout1.n4 vout1.t2 2.0693
R16 vout1.n3 vout1.t1 2.0693
R17 vout1.n2 vout1.t6 2.0693
R18 vout1.n1 vout1.t5 2.0693
R19 vout1.n0 vout1.t9 2.06738
R20 vout1.n9 vout1.n8 0.16242
R21 vout1.n8 vout1.n7 0.16242
R22 vout1.n7 vout1.n6 0.16242
R23 vout1.n6 vout1.n5 0.16242
R24 vout1.n5 vout1.n4 0.16242
R25 vout1.n4 vout1.n3 0.16242
R26 vout1.n3 vout1.n2 0.16242
R27 vout1.n2 vout1.n1 0.16242
R28 vout1.n1 vout1.n0 0.16242
R29 vout1 vout1.n9 0.0151667
R30 vin1.n19 vin1.t0 0.994013
R31 vin1.n17 vin1.n16 0.965665
R32 vin1.n28 vin1.n27 0.83231
R33 vin1.n9 vin1.n0 0.754036
R34 vin1.n20 vin1.n19 0.578786
R35 vin1.n21 vin1.n20 0.578786
R36 vin1.n22 vin1.n21 0.578786
R37 vin1.n23 vin1.n22 0.578786
R38 vin1.n24 vin1.n23 0.578786
R39 vin1.n25 vin1.n24 0.578786
R40 vin1.n26 vin1.n25 0.578786
R41 vin1.n27 vin1.n26 0.578786
R42 vin1.n17 vin1.n15 0.578786
R43 vin1.n15 vin1.n14 0.578786
R44 vin1.n14 vin1.n13 0.578786
R45 vin1.n13 vin1.n12 0.578786
R46 vin1.n12 vin1.n11 0.578786
R47 vin1.n11 vin1.n10 0.578786
R48 vin1.n10 vin1.n9 0.578786
R49 vin1.n20 vin1.n8 0.254024
R50 vin1.n21 vin1.n7 0.254024
R51 vin1.n22 vin1.n6 0.254024
R52 vin1.n23 vin1.n5 0.254024
R53 vin1.n24 vin1.n4 0.254024
R54 vin1.n25 vin1.n3 0.254024
R55 vin1.n26 vin1.n2 0.254024
R56 vin1.n27 vin1.n1 0.254024
R57 vin1.n9 vin1.n2 0.254024
R58 vin1.n10 vin1.n3 0.254024
R59 vin1.n11 vin1.n4 0.254024
R60 vin1.n12 vin1.n5 0.254024
R61 vin1.n13 vin1.n6 0.254024
R62 vin1.n14 vin1.n7 0.254024
R63 vin1.n15 vin1.n8 0.254024
R64 vin1.n19 vin1.n18 0.192615
R65 vin1.n18 vin1.n17 0.191641
R66 vin1.n18 vin1.n8 0.128842
R67 vin1.n8 vin1.n7 0.12194
R68 vin1.n7 vin1.n6 0.12194
R69 vin1.n6 vin1.n5 0.12194
R70 vin1.n5 vin1.n4 0.12194
R71 vin1.n4 vin1.n3 0.12194
R72 vin1.n3 vin1.n2 0.12194
R73 vin1.n2 vin1.n1 0.12194
R74 vin1.n28 vin1.n0 0.0847067
R75 vin1.n1 vin1.n0 0.0265126
R76 vin1 vin1.n28 0.00974
R77 vin1.n16 vin1.t1 0.00374593
R78 vin1.n16 vin1.t2 0.00125388
R79 vout2.n9 vout2.t10 10.2939
R80 vout2.n8 vout2.t15 10.2939
R81 vout2.n7 vout2.t12 10.2939
R82 vout2.n6 vout2.t11 10.2939
R83 vout2.n5 vout2.t19 10.2939
R84 vout2.n4 vout2.t14 10.2939
R85 vout2.n3 vout2.t13 10.2939
R86 vout2.n2 vout2.t18 10.2939
R87 vout2.n1 vout2.t17 10.2939
R88 vout2.n0 vout2.t16 10.2933
R89 vout2.n9 vout2.t3 2.08789
R90 vout2.n8 vout2.t2 2.08789
R91 vout2.n7 vout2.t1 2.08789
R92 vout2.n6 vout2.t0 2.08789
R93 vout2.n5 vout2.t7 2.08789
R94 vout2.n4 vout2.t6 2.0693
R95 vout2.n3 vout2.t8 2.0693
R96 vout2.n2 vout2.t5 2.0693
R97 vout2.n1 vout2.t4 2.0693
R98 vout2.n0 vout2.t9 2.0693
R99 vout2.n9 vout2.n8 0.16242
R100 vout2.n8 vout2.n7 0.16242
R101 vout2.n7 vout2.n6 0.16242
R102 vout2.n6 vout2.n5 0.16242
R103 vout2.n5 vout2.n4 0.16242
R104 vout2.n4 vout2.n3 0.16242
R105 vout2.n3 vout2.n2 0.16242
R106 vout2.n2 vout2.n1 0.16242
R107 vout2.n1 vout2.n0 0.16242
R108 vout2 vout2.n9 0.0151667
R109 vin2.n19 vin2.t0 0.994013
R110 vin2.n17 vin2.n16 0.965665
R111 vin2.n28 vin2.n27 0.83231
R112 vin2.n9 vin2.n0 0.754036
R113 vin2.n20 vin2.n19 0.578786
R114 vin2.n21 vin2.n20 0.578786
R115 vin2.n22 vin2.n21 0.578786
R116 vin2.n23 vin2.n22 0.578786
R117 vin2.n24 vin2.n23 0.578786
R118 vin2.n25 vin2.n24 0.578786
R119 vin2.n26 vin2.n25 0.578786
R120 vin2.n27 vin2.n26 0.578786
R121 vin2.n17 vin2.n15 0.578786
R122 vin2.n15 vin2.n14 0.578786
R123 vin2.n14 vin2.n13 0.578786
R124 vin2.n13 vin2.n12 0.578786
R125 vin2.n12 vin2.n11 0.578786
R126 vin2.n11 vin2.n10 0.578786
R127 vin2.n10 vin2.n9 0.578786
R128 vin2.n20 vin2.n8 0.254024
R129 vin2.n21 vin2.n7 0.254024
R130 vin2.n22 vin2.n6 0.254024
R131 vin2.n23 vin2.n5 0.254024
R132 vin2.n24 vin2.n4 0.254024
R133 vin2.n25 vin2.n3 0.254024
R134 vin2.n26 vin2.n2 0.254024
R135 vin2.n27 vin2.n1 0.254024
R136 vin2.n9 vin2.n2 0.254024
R137 vin2.n10 vin2.n3 0.254024
R138 vin2.n11 vin2.n4 0.254024
R139 vin2.n12 vin2.n5 0.254024
R140 vin2.n13 vin2.n6 0.254024
R141 vin2.n14 vin2.n7 0.254024
R142 vin2.n15 vin2.n8 0.254024
R143 vin2.n19 vin2.n18 0.192615
R144 vin2.n18 vin2.n17 0.191641
R145 vin2.n18 vin2.n8 0.128842
R146 vin2.n8 vin2.n7 0.12194
R147 vin2.n7 vin2.n6 0.12194
R148 vin2.n6 vin2.n5 0.12194
R149 vin2.n5 vin2.n4 0.12194
R150 vin2.n4 vin2.n3 0.12194
R151 vin2.n3 vin2.n2 0.12194
R152 vin2.n2 vin2.n1 0.12194
R153 vin2.n28 vin2.n0 0.0847067
R154 vin2.n1 vin2.n0 0.0265126
R155 vin2 vin2.n28 0.00974
R156 vin2.n16 vin2.t1 0.00374593
R157 vin2.n16 vin2.t2 0.00125388
R158 vout3.n9 vout3.t7 10.2939
R159 vout3.n8 vout3.t6 10.2939
R160 vout3.n7 vout3.t8 10.2939
R161 vout3.n6 vout3.t5 10.2939
R162 vout3.n5 vout3.t4 10.2939
R163 vout3.n4 vout3.t9 10.2939
R164 vout3.n3 vout3.t1 10.2939
R165 vout3.n2 vout3.t0 10.2939
R166 vout3.n1 vout3.t3 10.2939
R167 vout3.n0 vout3.t2 10.2939
R168 vout3.n9 vout3.t10 2.0884
R169 vout3.n8 vout3.t13 2.0884
R170 vout3.n7 vout3.t12 2.0884
R171 vout3.n6 vout3.t17 2.0884
R172 vout3.n5 vout3.t16 2.0884
R173 vout3.n4 vout3.t19 2.0693
R174 vout3.n3 vout3.t18 2.0693
R175 vout3.n2 vout3.t15 2.0693
R176 vout3.n1 vout3.t14 2.0693
R177 vout3.n0 vout3.t11 2.06738
R178 vout3.n9 vout3.n8 0.16242
R179 vout3.n8 vout3.n7 0.16242
R180 vout3.n7 vout3.n6 0.16242
R181 vout3.n6 vout3.n5 0.16242
R182 vout3.n5 vout3.n4 0.16242
R183 vout3.n4 vout3.n3 0.16242
R184 vout3.n3 vout3.n2 0.16242
R185 vout3.n2 vout3.n1 0.16242
R186 vout3.n1 vout3.n0 0.16242
R187 vout3 vout3.n9 0.0151667
R188 vin3.n19 vin3.t0 0.994013
R189 vin3.n17 vin3.n16 0.965665
R190 vin3.n28 vin3.n27 0.83231
R191 vin3.n9 vin3.n0 0.754036
R192 vin3.n20 vin3.n19 0.578786
R193 vin3.n21 vin3.n20 0.578786
R194 vin3.n22 vin3.n21 0.578786
R195 vin3.n23 vin3.n22 0.578786
R196 vin3.n24 vin3.n23 0.578786
R197 vin3.n25 vin3.n24 0.578786
R198 vin3.n26 vin3.n25 0.578786
R199 vin3.n27 vin3.n26 0.578786
R200 vin3.n17 vin3.n15 0.578786
R201 vin3.n15 vin3.n14 0.578786
R202 vin3.n14 vin3.n13 0.578786
R203 vin3.n13 vin3.n12 0.578786
R204 vin3.n12 vin3.n11 0.578786
R205 vin3.n11 vin3.n10 0.578786
R206 vin3.n10 vin3.n9 0.578786
R207 vin3.n20 vin3.n8 0.254024
R208 vin3.n21 vin3.n7 0.254024
R209 vin3.n22 vin3.n6 0.254024
R210 vin3.n23 vin3.n5 0.254024
R211 vin3.n24 vin3.n4 0.254024
R212 vin3.n25 vin3.n3 0.254024
R213 vin3.n26 vin3.n2 0.254024
R214 vin3.n27 vin3.n1 0.254024
R215 vin3.n9 vin3.n2 0.254024
R216 vin3.n10 vin3.n3 0.254024
R217 vin3.n11 vin3.n4 0.254024
R218 vin3.n12 vin3.n5 0.254024
R219 vin3.n13 vin3.n6 0.254024
R220 vin3.n14 vin3.n7 0.254024
R221 vin3.n15 vin3.n8 0.254024
R222 vin3.n19 vin3.n18 0.192615
R223 vin3.n18 vin3.n17 0.191641
R224 vin3.n18 vin3.n8 0.128842
R225 vin3.n8 vin3.n7 0.12194
R226 vin3.n7 vin3.n6 0.12194
R227 vin3.n6 vin3.n5 0.12194
R228 vin3.n5 vin3.n4 0.12194
R229 vin3.n4 vin3.n3 0.12194
R230 vin3.n3 vin3.n2 0.12194
R231 vin3.n2 vin3.n1 0.12194
R232 vin3.n28 vin3.n0 0.0847067
R233 vin3.n1 vin3.n0 0.0265126
R234 vin3 vin3.n28 0.00974
R235 vin3.n16 vin3.t1 0.00374593
R236 vin3.n16 vin3.t2 0.00125388
R237 vout4.n9 vout4.t16 10.2939
R238 vout4.n8 vout4.t15 10.2939
R239 vout4.n7 vout4.t14 10.2939
R240 vout4.n6 vout4.t13 10.2939
R241 vout4.n5 vout4.t19 10.2939
R242 vout4.n4 vout4.t17 10.2939
R243 vout4.n3 vout4.t11 10.2939
R244 vout4.n2 vout4.t10 10.2939
R245 vout4.n1 vout4.t18 10.2939
R246 vout4.n0 vout4.t12 10.2933
R247 vout4.n9 vout4.t8 2.08789
R248 vout4.n8 vout4.t9 2.08789
R249 vout4.n7 vout4.t5 2.08789
R250 vout4.n6 vout4.t1 2.08789
R251 vout4.n5 vout4.t0 2.08789
R252 vout4.n4 vout4.t3 2.0693
R253 vout4.n3 vout4.t2 2.0693
R254 vout4.n2 vout4.t4 2.0693
R255 vout4.n1 vout4.t6 2.0693
R256 vout4.n0 vout4.t7 2.0693
R257 vout4.n9 vout4.n8 0.16242
R258 vout4.n8 vout4.n7 0.16242
R259 vout4.n7 vout4.n6 0.16242
R260 vout4.n6 vout4.n5 0.16242
R261 vout4.n5 vout4.n4 0.16242
R262 vout4.n4 vout4.n3 0.16242
R263 vout4.n3 vout4.n2 0.16242
R264 vout4.n2 vout4.n1 0.16242
R265 vout4.n1 vout4.n0 0.16242
R266 vout4 vout4.n9 0.0151667
R267 vin4.n19 vin4.t0 0.994013
R268 vin4.n17 vin4.n16 0.965665
R269 vin4.n28 vin4.n27 0.83231
R270 vin4.n9 vin4.n0 0.754036
R271 vin4.n20 vin4.n19 0.578786
R272 vin4.n21 vin4.n20 0.578786
R273 vin4.n22 vin4.n21 0.578786
R274 vin4.n23 vin4.n22 0.578786
R275 vin4.n24 vin4.n23 0.578786
R276 vin4.n25 vin4.n24 0.578786
R277 vin4.n26 vin4.n25 0.578786
R278 vin4.n27 vin4.n26 0.578786
R279 vin4.n17 vin4.n15 0.578786
R280 vin4.n15 vin4.n14 0.578786
R281 vin4.n14 vin4.n13 0.578786
R282 vin4.n13 vin4.n12 0.578786
R283 vin4.n12 vin4.n11 0.578786
R284 vin4.n11 vin4.n10 0.578786
R285 vin4.n10 vin4.n9 0.578786
R286 vin4.n20 vin4.n8 0.254024
R287 vin4.n21 vin4.n7 0.254024
R288 vin4.n22 vin4.n6 0.254024
R289 vin4.n23 vin4.n5 0.254024
R290 vin4.n24 vin4.n4 0.254024
R291 vin4.n25 vin4.n3 0.254024
R292 vin4.n26 vin4.n2 0.254024
R293 vin4.n27 vin4.n1 0.254024
R294 vin4.n9 vin4.n2 0.254024
R295 vin4.n10 vin4.n3 0.254024
R296 vin4.n11 vin4.n4 0.254024
R297 vin4.n12 vin4.n5 0.254024
R298 vin4.n13 vin4.n6 0.254024
R299 vin4.n14 vin4.n7 0.254024
R300 vin4.n15 vin4.n8 0.254024
R301 vin4.n19 vin4.n18 0.192615
R302 vin4.n18 vin4.n17 0.191641
R303 vin4.n18 vin4.n8 0.128842
R304 vin4.n8 vin4.n7 0.12194
R305 vin4.n7 vin4.n6 0.12194
R306 vin4.n6 vin4.n5 0.12194
R307 vin4.n5 vin4.n4 0.12194
R308 vin4.n4 vin4.n3 0.12194
R309 vin4.n3 vin4.n2 0.12194
R310 vin4.n2 vin4.n1 0.12194
R311 vin4.n28 vin4.n0 0.0847067
R312 vin4.n1 vin4.n0 0.0265126
R313 vin4 vin4.n28 0.00974
R314 vin4.n16 vin4.t1 0.00374593
R315 vin4.n16 vin4.t2 0.00125388
R316 VDD.n516 VDD.t89 17.0005
R317 VDD.t89 VDD.n483 17.0005
R318 VDD.t62 VDD.n515 17.0005
R319 VDD.t62 VDD.n514 17.0005
R320 VDD.t62 VDD.n513 17.0005
R321 VDD.t62 VDD.n512 17.0005
R322 VDD.t62 VDD.n511 17.0005
R323 VDD.t62 VDD.n510 17.0005
R324 VDD.t62 VDD.n509 17.0005
R325 VDD.t62 VDD.n481 17.0005
R326 VDD.t62 VDD.n508 17.0005
R327 VDD.t62 VDD.n506 17.0005
R328 VDD.t62 VDD.n505 17.0005
R329 VDD.t62 VDD.n504 17.0005
R330 VDD.t62 VDD.n503 17.0005
R331 VDD.t62 VDD.n502 17.0005
R332 VDD.n515 VDD.t89 17.0005
R333 VDD.n514 VDD.t89 17.0005
R334 VDD.n513 VDD.t89 17.0005
R335 VDD.n512 VDD.t89 17.0005
R336 VDD.n511 VDD.t89 17.0005
R337 VDD.n510 VDD.t89 17.0005
R338 VDD.n509 VDD.t89 17.0005
R339 VDD.n506 VDD.t89 17.0005
R340 VDD.n505 VDD.t89 17.0005
R341 VDD.n504 VDD.t89 17.0005
R342 VDD.n503 VDD.t89 17.0005
R343 VDD.n502 VDD.t89 17.0005
R344 VDD.n501 VDD.t89 17.0005
R345 VDD.t62 VDD.n501 17.0005
R346 VDD.t62 VDD.n483 17.0005
R347 VDD.n516 VDD.t62 17.0005
R348 VDD.n1041 VDD.n499 17.0005
R349 VDD.n1041 VDD.n498 17.0005
R350 VDD.n1041 VDD.n497 17.0005
R351 VDD.n1041 VDD.n496 17.0005
R352 VDD.n1041 VDD.n495 17.0005
R353 VDD.n1041 VDD.n494 17.0005
R354 VDD.n1041 VDD.n493 17.0005
R355 VDD.n1041 VDD.n492 17.0005
R356 VDD.n1041 VDD.n491 17.0005
R357 VDD.n1041 VDD.n490 17.0005
R358 VDD.n1041 VDD.n489 17.0005
R359 VDD.n1041 VDD.n488 17.0005
R360 VDD.n1041 VDD.n487 17.0005
R361 VDD.n1042 VDD.n1041 17.0005
R362 VDD.n1041 VDD.n482 17.0005
R363 VDD.n1025 VDD.n1024 17.0005
R364 VDD.n1024 VDD.n1023 17.0005
R365 VDD.n1021 VDD.n1020 17.0005
R366 VDD.n1020 VDD.n1019 17.0005
R367 VDD.n1017 VDD.n1016 17.0005
R368 VDD.n1016 VDD.n1015 17.0005
R369 VDD.n691 VDD.n684 17.0005
R370 VDD.n692 VDD.n691 17.0005
R371 VDD.n695 VDD.n694 17.0005
R372 VDD.n696 VDD.n695 17.0005
R373 VDD.n699 VDD.n698 17.0005
R374 VDD.n700 VDD.n699 17.0005
R375 VDD.n703 VDD.n702 17.0005
R376 VDD.n704 VDD.n703 17.0005
R377 VDD.n706 VDD.n705 17.0005
R378 VDD.n707 VDD.n706 17.0005
R379 VDD.n1010 VDD.n1009 17.0005
R380 VDD.n1007 VDD.n1006 17.0005
R381 VDD.n1004 VDD.n1003 17.0005
R382 VDD.n1003 VDD.n1002 17.0005
R383 VDD.n1001 VDD.n1000 17.0005
R384 VDD.n1000 VDD.n999 17.0005
R385 VDD.n965 VDD.n962 17.0005
R386 VDD.n966 VDD.n965 17.0005
R387 VDD.n970 VDD.n969 17.0005
R388 VDD.n971 VDD.n970 17.0005
R389 VDD.n975 VDD.n974 17.0005
R390 VDD.n976 VDD.n975 17.0005
R391 VDD.n981 VDD.n980 17.0005
R392 VDD.n982 VDD.n981 17.0005
R393 VDD.n986 VDD.n985 17.0005
R394 VDD.n987 VDD.n986 17.0005
R395 VDD.n995 VDD.n989 17.0005
R396 VDD.n996 VDD.n995 17.0005
R397 VDD.n809 VDD.n808 17.0005
R398 VDD.n810 VDD.n809 17.0005
R399 VDD.n813 VDD.n812 17.0005
R400 VDD.n814 VDD.n813 17.0005
R401 VDD.n816 VDD.n815 17.0005
R402 VDD.n817 VDD.n816 17.0005
R403 VDD.n819 VDD.n818 17.0005
R404 VDD.n820 VDD.n819 17.0005
R405 VDD.n822 VDD.n821 17.0005
R406 VDD.n823 VDD.n822 17.0005
R407 VDD.n825 VDD.n824 17.0005
R408 VDD.n826 VDD.n825 17.0005
R409 VDD.n828 VDD.n827 17.0005
R410 VDD.n829 VDD.n828 17.0005
R411 VDD.n832 VDD.n831 17.0005
R412 VDD.n833 VDD.n832 17.0005
R413 VDD.n835 VDD.n834 17.0005
R414 VDD.n836 VDD.n835 17.0005
R415 VDD.n838 VDD.n837 17.0005
R416 VDD.n839 VDD.n838 17.0005
R417 VDD.n841 VDD.n840 17.0005
R418 VDD.n842 VDD.n841 17.0005
R419 VDD.n845 VDD.n844 17.0005
R420 VDD.n846 VDD.n845 17.0005
R421 VDD.n848 VDD.n847 17.0005
R422 VDD.n849 VDD.n848 17.0005
R423 VDD.n851 VDD.n850 17.0005
R424 VDD.n852 VDD.n851 17.0005
R425 VDD.n854 VDD.n853 17.0005
R426 VDD.n855 VDD.n854 17.0005
R427 VDD.n858 VDD.n857 17.0005
R428 VDD.n859 VDD.n858 17.0005
R429 VDD.n861 VDD.n860 17.0005
R430 VDD.n862 VDD.n861 17.0005
R431 VDD.n864 VDD.n863 17.0005
R432 VDD.n865 VDD.n864 17.0005
R433 VDD.n867 VDD.n866 17.0005
R434 VDD.n868 VDD.n867 17.0005
R435 VDD.n871 VDD.n870 17.0005
R436 VDD.n872 VDD.n871 17.0005
R437 VDD.n874 VDD.n873 17.0005
R438 VDD.n875 VDD.n874 17.0005
R439 VDD.n877 VDD.n876 17.0005
R440 VDD.n878 VDD.n877 17.0005
R441 VDD.n880 VDD.n879 17.0005
R442 VDD.n881 VDD.n880 17.0005
R443 VDD.n884 VDD.n883 17.0005
R444 VDD.n885 VDD.n884 17.0005
R445 VDD.n887 VDD.n886 17.0005
R446 VDD.n888 VDD.n887 17.0005
R447 VDD.n890 VDD.n889 17.0005
R448 VDD.n891 VDD.n890 17.0005
R449 VDD.n893 VDD.n892 17.0005
R450 VDD.n894 VDD.n893 17.0005
R451 VDD.n897 VDD.n896 17.0005
R452 VDD.n898 VDD.n897 17.0005
R453 VDD.n900 VDD.n899 17.0005
R454 VDD.n901 VDD.n900 17.0005
R455 VDD.n903 VDD.n902 17.0005
R456 VDD.n904 VDD.n903 17.0005
R457 VDD.n906 VDD.n905 17.0005
R458 VDD.n907 VDD.n906 17.0005
R459 VDD.n910 VDD.n909 17.0005
R460 VDD.n911 VDD.n910 17.0005
R461 VDD.n913 VDD.n912 17.0005
R462 VDD.n914 VDD.n913 17.0005
R463 VDD.n916 VDD.n915 17.0005
R464 VDD.n917 VDD.n916 17.0005
R465 VDD.n919 VDD.n918 17.0005
R466 VDD.n920 VDD.n919 17.0005
R467 VDD.n923 VDD.n922 17.0005
R468 VDD.n924 VDD.n923 17.0005
R469 VDD.n926 VDD.n925 17.0005
R470 VDD.n927 VDD.n926 17.0005
R471 VDD.n929 VDD.n928 17.0005
R472 VDD.n930 VDD.n929 17.0005
R473 VDD.n932 VDD.n931 17.0005
R474 VDD.n933 VDD.n932 17.0005
R475 VDD.n936 VDD.n935 17.0005
R476 VDD.n937 VDD.n936 17.0005
R477 VDD.n939 VDD.n938 17.0005
R478 VDD.n940 VDD.n939 17.0005
R479 VDD.n942 VDD.n941 17.0005
R480 VDD.n943 VDD.n942 17.0005
R481 VDD.n945 VDD.n944 17.0005
R482 VDD.n946 VDD.n945 17.0005
R483 VDD.n948 VDD.n947 17.0005
R484 VDD.n949 VDD.n948 17.0005
R485 VDD.n951 VDD.n950 17.0005
R486 VDD.n952 VDD.n951 17.0005
R487 VDD.n957 VDD.n956 17.0005
R488 VDD.n958 VDD.n957 17.0005
R489 VDD.n643 VDD.t84 17.0005
R490 VDD.t1 VDD.n1033 17.0005
R491 VDD.t1 VDD.n676 17.0005
R492 VDD.t1 VDD.n672 17.0005
R493 VDD.t1 VDD.n671 17.0005
R494 VDD.t1 VDD.n667 17.0005
R495 VDD.t1 VDD.n666 17.0005
R496 VDD.t1 VDD.n662 17.0005
R497 VDD.t1 VDD.n660 17.0005
R498 VDD.t1 VDD.n659 17.0005
R499 VDD.t1 VDD.n655 17.0005
R500 VDD.t1 VDD.n654 17.0005
R501 VDD.t1 VDD.n650 17.0005
R502 VDD.t1 VDD.n649 17.0005
R503 VDD.t1 VDD.n645 17.0005
R504 VDD.n644 VDD.t84 17.0005
R505 VDD.n645 VDD.t84 17.0005
R506 VDD.n649 VDD.t84 17.0005
R507 VDD.n650 VDD.t84 17.0005
R508 VDD.n654 VDD.t84 17.0005
R509 VDD.n655 VDD.t84 17.0005
R510 VDD.n659 VDD.t84 17.0005
R511 VDD.n666 VDD.t84 17.0005
R512 VDD.n667 VDD.t84 17.0005
R513 VDD.n671 VDD.t84 17.0005
R514 VDD.n672 VDD.t84 17.0005
R515 VDD.n676 VDD.t84 17.0005
R516 VDD.n1033 VDD.t84 17.0005
R517 VDD.n1034 VDD.t84 17.0005
R518 VDD.t1 VDD.n644 17.0005
R519 VDD.n1034 VDD.t1 17.0005
R520 VDD.t1 VDD.n643 17.0005
R521 VDD.n1037 VDD.n640 17.0005
R522 VDD.n1037 VDD.n1036 17.0005
R523 VDD.n647 VDD.n646 17.0005
R524 VDD.n648 VDD.n647 17.0005
R525 VDD.n652 VDD.n651 17.0005
R526 VDD.n653 VDD.n652 17.0005
R527 VDD.n657 VDD.n656 17.0005
R528 VDD.n658 VDD.n657 17.0005
R529 VDD.n664 VDD.n663 17.0005
R530 VDD.n665 VDD.n664 17.0005
R531 VDD.n669 VDD.n668 17.0005
R532 VDD.n670 VDD.n669 17.0005
R533 VDD.n674 VDD.n673 17.0005
R534 VDD.n675 VDD.n674 17.0005
R535 VDD.n1032 VDD.n1031 17.0005
R536 VDD.t99 VDD.n458 17.0005
R537 VDD.t99 VDD.n444 17.0005
R538 VDD.n445 VDD.t42 17.0005
R539 VDD.n446 VDD.t42 17.0005
R540 VDD.n447 VDD.t42 17.0005
R541 VDD.n448 VDD.t42 17.0005
R542 VDD.n449 VDD.t42 17.0005
R543 VDD.n450 VDD.t42 17.0005
R544 VDD.n451 VDD.t42 17.0005
R545 VDD.n460 VDD.t42 17.0005
R546 VDD.n443 VDD.t42 17.0005
R547 VDD.n452 VDD.t42 17.0005
R548 VDD.n453 VDD.t42 17.0005
R549 VDD.n454 VDD.t42 17.0005
R550 VDD.n455 VDD.t42 17.0005
R551 VDD.n456 VDD.t42 17.0005
R552 VDD.t99 VDD.n445 17.0005
R553 VDD.t99 VDD.n446 17.0005
R554 VDD.t99 VDD.n447 17.0005
R555 VDD.t99 VDD.n448 17.0005
R556 VDD.t99 VDD.n449 17.0005
R557 VDD.t99 VDD.n450 17.0005
R558 VDD.t99 VDD.n451 17.0005
R559 VDD.t99 VDD.n452 17.0005
R560 VDD.t99 VDD.n453 17.0005
R561 VDD.t99 VDD.n454 17.0005
R562 VDD.t99 VDD.n455 17.0005
R563 VDD.t99 VDD.n456 17.0005
R564 VDD.t99 VDD.n457 17.0005
R565 VDD.n457 VDD.t42 17.0005
R566 VDD.n444 VDD.t42 17.0005
R567 VDD.n458 VDD.t42 17.0005
R568 VDD.n1161 VDD.n143 17.0005
R569 VDD.n1161 VDD.n142 17.0005
R570 VDD.n1161 VDD.n141 17.0005
R571 VDD.n1161 VDD.n140 17.0005
R572 VDD.n1161 VDD.n139 17.0005
R573 VDD.n1161 VDD.n138 17.0005
R574 VDD.n1161 VDD.n137 17.0005
R575 VDD.n1161 VDD.n136 17.0005
R576 VDD.n1161 VDD.n135 17.0005
R577 VDD.n1161 VDD.n134 17.0005
R578 VDD.n1161 VDD.n133 17.0005
R579 VDD.n1161 VDD.n132 17.0005
R580 VDD.n1161 VDD.n131 17.0005
R581 VDD.n1161 VDD.n129 17.0005
R582 VDD.n1161 VDD.n128 17.0005
R583 VDD.n266 VDD.n265 17.0005
R584 VDD.n307 VDD.n267 17.0005
R585 VDD.n308 VDD.n307 17.0005
R586 VDD.n305 VDD.n304 17.0005
R587 VDD.n304 VDD.n303 17.0005
R588 VDD.n301 VDD.n300 17.0005
R589 VDD.n300 VDD.n299 17.0005
R590 VDD.n297 VDD.n296 17.0005
R591 VDD.n296 VDD.n295 17.0005
R592 VDD.n293 VDD.n292 17.0005
R593 VDD.n292 VDD.n291 17.0005
R594 VDD.n289 VDD.n288 17.0005
R595 VDD.n288 VDD.n287 17.0005
R596 VDD.n285 VDD.n284 17.0005
R597 VDD.n284 VDD.n283 17.0005
R598 VDD.n279 VDD.n278 17.0005
R599 VDD.n278 VDD.n174 17.0005
R600 VDD.n1139 VDD.n152 17.0005
R601 VDD.n1140 VDD.n1139 17.0005
R602 VDD.n167 VDD.n166 17.0005
R603 VDD.n166 VDD.n165 17.0005
R604 VDD.n163 VDD.n162 17.0005
R605 VDD.n162 VDD.n161 17.0005
R606 VDD.n159 VDD.n158 17.0005
R607 VDD.n158 VDD.n157 17.0005
R608 VDD.n1145 VDD.n1144 17.0005
R609 VDD.n1146 VDD.n1145 17.0005
R610 VDD.n1149 VDD.n1148 17.0005
R611 VDD.n1150 VDD.n1149 17.0005
R612 VDD.n1153 VDD.n1152 17.0005
R613 VDD.n1154 VDD.n1153 17.0005
R614 VDD.n1156 VDD.n126 17.0005
R615 VDD.n146 VDD.n126 17.0005
R616 VDD.n1161 VDD.n1160 17.0005
R617 VDD.n436 VDD.n435 17.0005
R618 VDD.n437 VDD.n436 17.0005
R619 VDD.n432 VDD.n431 17.0005
R620 VDD.n431 VDD.n430 17.0005
R621 VDD.n429 VDD.n428 17.0005
R622 VDD.n428 VDD.n427 17.0005
R623 VDD.n426 VDD.n425 17.0005
R624 VDD.n425 VDD.n424 17.0005
R625 VDD.n423 VDD.n422 17.0005
R626 VDD.n422 VDD.n421 17.0005
R627 VDD.n420 VDD.n419 17.0005
R628 VDD.n419 VDD.n418 17.0005
R629 VDD.n417 VDD.n416 17.0005
R630 VDD.n416 VDD.n415 17.0005
R631 VDD.n413 VDD.n412 17.0005
R632 VDD.n412 VDD.n411 17.0005
R633 VDD.n410 VDD.n409 17.0005
R634 VDD.n409 VDD.n408 17.0005
R635 VDD.n407 VDD.n406 17.0005
R636 VDD.n406 VDD.n405 17.0005
R637 VDD.n404 VDD.n403 17.0005
R638 VDD.n403 VDD.n402 17.0005
R639 VDD.n400 VDD.n399 17.0005
R640 VDD.n399 VDD.n398 17.0005
R641 VDD.n397 VDD.n396 17.0005
R642 VDD.n396 VDD.n395 17.0005
R643 VDD.n394 VDD.n393 17.0005
R644 VDD.n393 VDD.n392 17.0005
R645 VDD.n391 VDD.n390 17.0005
R646 VDD.n390 VDD.n389 17.0005
R647 VDD.n387 VDD.n386 17.0005
R648 VDD.n386 VDD.n385 17.0005
R649 VDD.n384 VDD.n383 17.0005
R650 VDD.n383 VDD.n382 17.0005
R651 VDD.n381 VDD.n380 17.0005
R652 VDD.n380 VDD.n379 17.0005
R653 VDD.n378 VDD.n377 17.0005
R654 VDD.n377 VDD.n376 17.0005
R655 VDD.n374 VDD.n373 17.0005
R656 VDD.n373 VDD.n372 17.0005
R657 VDD.n371 VDD.n370 17.0005
R658 VDD.n370 VDD.n369 17.0005
R659 VDD.n368 VDD.n367 17.0005
R660 VDD.n367 VDD.n366 17.0005
R661 VDD.n1164 VDD.n2 17.0005
R662 VDD.n1165 VDD.n1164 17.0005
R663 VDD.n1063 VDD.n4 17.0005
R664 VDD.n1066 VDD.n4 17.0005
R665 VDD.n1068 VDD.n1067 17.0005
R666 VDD.n1069 VDD.n1068 17.0005
R667 VDD.n1071 VDD.n1070 17.0005
R668 VDD.n1072 VDD.n1071 17.0005
R669 VDD.n1074 VDD.n1073 17.0005
R670 VDD.n1075 VDD.n1074 17.0005
R671 VDD.n1078 VDD.n1077 17.0005
R672 VDD.n1079 VDD.n1078 17.0005
R673 VDD.n1081 VDD.n1080 17.0005
R674 VDD.n1082 VDD.n1081 17.0005
R675 VDD.n1084 VDD.n1083 17.0005
R676 VDD.n1085 VDD.n1084 17.0005
R677 VDD.n1087 VDD.n1086 17.0005
R678 VDD.n1088 VDD.n1087 17.0005
R679 VDD.n1091 VDD.n1090 17.0005
R680 VDD.n1092 VDD.n1091 17.0005
R681 VDD.n1094 VDD.n1093 17.0005
R682 VDD.n1095 VDD.n1094 17.0005
R683 VDD.n1097 VDD.n1096 17.0005
R684 VDD.n1098 VDD.n1097 17.0005
R685 VDD.n1100 VDD.n1099 17.0005
R686 VDD.n1101 VDD.n1100 17.0005
R687 VDD.n1104 VDD.n1103 17.0005
R688 VDD.n1105 VDD.n1104 17.0005
R689 VDD.n1107 VDD.n1106 17.0005
R690 VDD.n1108 VDD.n1107 17.0005
R691 VDD.n1110 VDD.n1109 17.0005
R692 VDD.n1111 VDD.n1110 17.0005
R693 VDD.n1113 VDD.n1112 17.0005
R694 VDD.n1114 VDD.n1113 17.0005
R695 VDD.n1117 VDD.n1116 17.0005
R696 VDD.n1118 VDD.n1117 17.0005
R697 VDD.n1120 VDD.n1119 17.0005
R698 VDD.n1121 VDD.n1120 17.0005
R699 VDD.n1123 VDD.n1122 17.0005
R700 VDD.n1124 VDD.n1123 17.0005
R701 VDD.n1126 VDD.n1125 17.0005
R702 VDD.n1127 VDD.n1126 17.0005
R703 VDD.n1129 VDD.n1128 17.0005
R704 VDD.n1130 VDD.n1129 17.0005
R705 VDD.n1132 VDD.n1131 17.0005
R706 VDD.n1133 VDD.n1132 17.0005
R707 VDD.n1136 VDD.n1135 17.0005
R708 VDD.n1137 VDD.n1136 17.0005
R709 VDD.t94 VDD.n316 17.0005
R710 VDD.n235 VDD.t22 17.0005
R711 VDD.n264 VDD.t22 17.0005
R712 VDD.n236 VDD.t22 17.0005
R713 VDD.n260 VDD.t22 17.0005
R714 VDD.n237 VDD.t22 17.0005
R715 VDD.n256 VDD.t22 17.0005
R716 VDD.n253 VDD.t22 17.0005
R717 VDD.t22 VDD.n231 17.0005
R718 VDD.n239 VDD.t22 17.0005
R719 VDD.n251 VDD.t22 17.0005
R720 VDD.n240 VDD.t22 17.0005
R721 VDD.n244 VDD.t22 17.0005
R722 VDD.n241 VDD.t22 17.0005
R723 VDD.n317 VDD.t22 17.0005
R724 VDD.t94 VDD.n233 17.0005
R725 VDD.n317 VDD.t94 17.0005
R726 VDD.t94 VDD.n241 17.0005
R727 VDD.t94 VDD.n244 17.0005
R728 VDD.t94 VDD.n240 17.0005
R729 VDD.t94 VDD.n251 17.0005
R730 VDD.t94 VDD.n239 17.0005
R731 VDD.t94 VDD.n256 17.0005
R732 VDD.t94 VDD.n237 17.0005
R733 VDD.t94 VDD.n260 17.0005
R734 VDD.t94 VDD.n236 17.0005
R735 VDD.t94 VDD.n264 17.0005
R736 VDD.t94 VDD.n235 17.0005
R737 VDD.t94 VDD.n232 17.0005
R738 VDD.t22 VDD.n233 17.0005
R739 VDD.t22 VDD.n232 17.0005
R740 VDD.n316 VDD.t22 17.0005
R741 VDD.n440 VDD.n439 17.0005
R742 VDD.n323 VDD.n322 17.0005
R743 VDD.n322 VDD.n321 17.0005
R744 VDD.n320 VDD.n319 17.0005
R745 VDD.n319 VDD.n318 17.0005
R746 VDD.n242 VDD.n234 17.0005
R747 VDD.n243 VDD.n242 17.0005
R748 VDD.n249 VDD.n248 17.0005
R749 VDD.n250 VDD.n249 17.0005
R750 VDD.n247 VDD.n246 17.0005
R751 VDD.n246 VDD.n245 17.0005
R752 VDD.n255 VDD.n254 17.0005
R753 VDD.n254 VDD.n252 17.0005
R754 VDD.n259 VDD.n258 17.0005
R755 VDD.n258 VDD.n257 17.0005
R756 VDD.n263 VDD.n262 17.0005
R757 VDD.n262 VDD.n261 17.0005
R758 VDD.n994 VDD.n963 8.50175
R759 VDD.n1027 VDD.n1026 8.50175
R760 VDD.n1008 VDD.n1007 8.50175
R761 VDD.n1041 VDD.n484 8.50175
R762 VDD.n1158 VDD.n1157 8.50175
R763 VDD.n310 VDD.n309 8.50175
R764 VDD.n1139 VDD.n1138 8.50175
R765 VDD.n1161 VDD.n127 8.50175
R766 VDD.t0 VDD.n612 8.501
R767 VDD.n1028 VDD.n1027 8.501
R768 VDD.t0 VDD.n613 8.501
R769 VDD.t0 VDD.n614 8.501
R770 VDD.t0 VDD.n615 8.501
R771 VDD.t0 VDD.n616 8.501
R772 VDD.t0 VDD.n617 8.501
R773 VDD.t0 VDD.n618 8.501
R774 VDD.t0 VDD.n619 8.501
R775 VDD.t0 VDD.n620 8.501
R776 VDD.t0 VDD.n621 8.501
R777 VDD.n992 VDD.n963 8.501
R778 VDD.t0 VDD.n622 8.501
R779 VDD.t0 VDD.n623 8.501
R780 VDD.t0 VDD.n624 8.501
R781 VDD.t0 VDD.n625 8.501
R782 VDD.t0 VDD.n626 8.501
R783 VDD.t0 VDD.n627 8.501
R784 VDD.t0 VDD.n628 8.501
R785 VDD.t0 VDD.n629 8.501
R786 VDD.t0 VDD.n630 8.501
R787 VDD.n1040 VDD.t0 8.501
R788 VDD.t0 VDD.n520 8.501
R789 VDD.t0 VDD.n523 8.501
R790 VDD.t0 VDD.n524 8.501
R791 VDD.t0 VDD.n526 8.501
R792 VDD.t0 VDD.n528 8.501
R793 VDD.t0 VDD.n530 8.501
R794 VDD.t0 VDD.n532 8.501
R795 VDD.t0 VDD.n534 8.501
R796 VDD.t0 VDD.n536 8.501
R797 VDD.t0 VDD.n538 8.501
R798 VDD.t0 VDD.n540 8.501
R799 VDD.t0 VDD.n542 8.501
R800 VDD.t0 VDD.n544 8.501
R801 VDD.t0 VDD.n546 8.501
R802 VDD.t0 VDD.n548 8.501
R803 VDD.t0 VDD.n550 8.501
R804 VDD.t0 VDD.n552 8.501
R805 VDD.t0 VDD.n554 8.501
R806 VDD.t0 VDD.n556 8.501
R807 VDD.t0 VDD.n558 8.501
R808 VDD.t0 VDD.n560 8.501
R809 VDD.t0 VDD.n562 8.501
R810 VDD.t0 VDD.n564 8.501
R811 VDD.t0 VDD.n566 8.501
R812 VDD.t0 VDD.n568 8.501
R813 VDD.t0 VDD.n570 8.501
R814 VDD.t0 VDD.n572 8.501
R815 VDD.t0 VDD.n574 8.501
R816 VDD.t0 VDD.n576 8.501
R817 VDD.t0 VDD.n578 8.501
R818 VDD.t0 VDD.n580 8.501
R819 VDD.t0 VDD.n582 8.501
R820 VDD.t0 VDD.n584 8.501
R821 VDD.t0 VDD.n586 8.501
R822 VDD.t0 VDD.n588 8.501
R823 VDD.t0 VDD.n590 8.501
R824 VDD.t0 VDD.n592 8.501
R825 VDD.t0 VDD.n594 8.501
R826 VDD.t0 VDD.n596 8.501
R827 VDD.t0 VDD.n598 8.501
R828 VDD.t0 VDD.n600 8.501
R829 VDD.t0 VDD.n602 8.501
R830 VDD.t0 VDD.n604 8.501
R831 VDD.t0 VDD.n606 8.501
R832 VDD.t0 VDD.n608 8.501
R833 VDD.n1038 VDD.n484 8.501
R834 VDD.t0 VDD.n519 8.501
R835 VDD.t0 VDD.n521 8.501
R836 VDD.t0 VDD.n522 8.501
R837 VDD.t0 VDD.n525 8.501
R838 VDD.t0 VDD.n527 8.501
R839 VDD.t0 VDD.n529 8.501
R840 VDD.t0 VDD.n531 8.501
R841 VDD.t0 VDD.n533 8.501
R842 VDD.t0 VDD.n535 8.501
R843 VDD.t0 VDD.n537 8.501
R844 VDD.t0 VDD.n539 8.501
R845 VDD.t0 VDD.n541 8.501
R846 VDD.t0 VDD.n543 8.501
R847 VDD.t0 VDD.n545 8.501
R848 VDD.t0 VDD.n547 8.501
R849 VDD.t0 VDD.n549 8.501
R850 VDD.t0 VDD.n551 8.501
R851 VDD.t0 VDD.n553 8.501
R852 VDD.t0 VDD.n555 8.501
R853 VDD.t0 VDD.n557 8.501
R854 VDD.t0 VDD.n559 8.501
R855 VDD.t0 VDD.n561 8.501
R856 VDD.t0 VDD.n563 8.501
R857 VDD.t0 VDD.n565 8.501
R858 VDD.t0 VDD.n567 8.501
R859 VDD.t0 VDD.n569 8.501
R860 VDD.t0 VDD.n571 8.501
R861 VDD.t0 VDD.n573 8.501
R862 VDD.t0 VDD.n575 8.501
R863 VDD.t0 VDD.n577 8.501
R864 VDD.t0 VDD.n579 8.501
R865 VDD.t0 VDD.n581 8.501
R866 VDD.t0 VDD.n583 8.501
R867 VDD.t0 VDD.n585 8.501
R868 VDD.t0 VDD.n587 8.501
R869 VDD.t0 VDD.n589 8.501
R870 VDD.t0 VDD.n591 8.501
R871 VDD.t0 VDD.n593 8.501
R872 VDD.t0 VDD.n595 8.501
R873 VDD.t0 VDD.n597 8.501
R874 VDD.t0 VDD.n599 8.501
R875 VDD.t0 VDD.n601 8.501
R876 VDD.t0 VDD.n603 8.501
R877 VDD.t0 VDD.n605 8.501
R878 VDD.t0 VDD.n607 8.501
R879 VDD.t0 VDD.n609 8.501
R880 VDD.n1009 VDD.n1008 8.501
R881 VDD.t0 VDD.n1039 8.501
R882 VDD.t0 VDD.n639 8.501
R883 VDD.t0 VDD.n638 8.501
R884 VDD.t0 VDD.n637 8.501
R885 VDD.t0 VDD.n636 8.501
R886 VDD.t0 VDD.n635 8.501
R887 VDD.t0 VDD.n634 8.501
R888 VDD.t0 VDD.n633 8.501
R889 VDD.n311 VDD.n310 8.501
R890 VDD.t21 VDD.n108 8.501
R891 VDD.t21 VDD.n109 8.501
R892 VDD.t21 VDD.n110 8.501
R893 VDD.t21 VDD.n111 8.501
R894 VDD.t21 VDD.n112 8.501
R895 VDD.t21 VDD.n113 8.501
R896 VDD.t21 VDD.n114 8.501
R897 VDD.t21 VDD.n115 8.501
R898 VDD.t21 VDD.n116 8.501
R899 VDD.t21 VDD.n117 8.501
R900 VDD.n1159 VDD.n1158 8.501
R901 VDD.t21 VDD.n118 8.501
R902 VDD.t21 VDD.n119 8.501
R903 VDD.t21 VDD.n120 8.501
R904 VDD.t21 VDD.n121 8.501
R905 VDD.t21 VDD.n122 8.501
R906 VDD.t21 VDD.n123 8.501
R907 VDD.t21 VDD.n124 8.501
R908 VDD.t21 VDD.n125 8.501
R909 VDD.t21 VDD.n95 8.501
R910 VDD.t21 VDD.n93 8.501
R911 VDD.t21 VDD.n91 8.501
R912 VDD.t21 VDD.n89 8.501
R913 VDD.t21 VDD.n87 8.501
R914 VDD.t21 VDD.n85 8.501
R915 VDD.t21 VDD.n83 8.501
R916 VDD.t21 VDD.n81 8.501
R917 VDD.t21 VDD.n79 8.501
R918 VDD.t21 VDD.n77 8.501
R919 VDD.t21 VDD.n75 8.501
R920 VDD.t21 VDD.n73 8.501
R921 VDD.t21 VDD.n71 8.501
R922 VDD.t21 VDD.n69 8.501
R923 VDD.t21 VDD.n67 8.501
R924 VDD.t21 VDD.n65 8.501
R925 VDD.t21 VDD.n63 8.501
R926 VDD.t21 VDD.n61 8.501
R927 VDD.t21 VDD.n59 8.501
R928 VDD.t21 VDD.n57 8.501
R929 VDD.t21 VDD.n55 8.501
R930 VDD.t21 VDD.n53 8.501
R931 VDD.t21 VDD.n52 8.501
R932 VDD.t21 VDD.n50 8.501
R933 VDD.t21 VDD.n48 8.501
R934 VDD.t21 VDD.n46 8.501
R935 VDD.t21 VDD.n44 8.501
R936 VDD.t21 VDD.n42 8.501
R937 VDD.t21 VDD.n40 8.501
R938 VDD.t21 VDD.n38 8.501
R939 VDD.t21 VDD.n36 8.501
R940 VDD.t21 VDD.n34 8.501
R941 VDD.t21 VDD.n32 8.501
R942 VDD.t21 VDD.n30 8.501
R943 VDD.t21 VDD.n28 8.501
R944 VDD.t21 VDD.n26 8.501
R945 VDD.t21 VDD.n24 8.501
R946 VDD.t21 VDD.n22 8.501
R947 VDD.t21 VDD.n20 8.501
R948 VDD.t21 VDD.n18 8.501
R949 VDD.t21 VDD.n16 8.501
R950 VDD.t21 VDD.n14 8.501
R951 VDD.t21 VDD.n12 8.501
R952 VDD.t21 VDD.n10 8.501
R953 VDD.t21 VDD.n9 8.501
R954 VDD.t21 VDD.n6 8.501
R955 VDD.n439 VDD.n127 8.501
R956 VDD.t21 VDD.n94 8.501
R957 VDD.t21 VDD.n92 8.501
R958 VDD.t21 VDD.n90 8.501
R959 VDD.t21 VDD.n88 8.501
R960 VDD.t21 VDD.n86 8.501
R961 VDD.t21 VDD.n84 8.501
R962 VDD.t21 VDD.n82 8.501
R963 VDD.t21 VDD.n80 8.501
R964 VDD.t21 VDD.n78 8.501
R965 VDD.t21 VDD.n76 8.501
R966 VDD.t21 VDD.n74 8.501
R967 VDD.t21 VDD.n72 8.501
R968 VDD.t21 VDD.n70 8.501
R969 VDD.t21 VDD.n68 8.501
R970 VDD.t21 VDD.n66 8.501
R971 VDD.t21 VDD.n64 8.501
R972 VDD.t21 VDD.n62 8.501
R973 VDD.t21 VDD.n60 8.501
R974 VDD.t21 VDD.n58 8.501
R975 VDD.t21 VDD.n56 8.501
R976 VDD.t21 VDD.n54 8.501
R977 VDD.t21 VDD.n3 8.501
R978 VDD.n1163 VDD.t21 8.501
R979 VDD.t21 VDD.n49 8.501
R980 VDD.t21 VDD.n47 8.501
R981 VDD.t21 VDD.n45 8.501
R982 VDD.t21 VDD.n43 8.501
R983 VDD.t21 VDD.n41 8.501
R984 VDD.t21 VDD.n39 8.501
R985 VDD.t21 VDD.n37 8.501
R986 VDD.t21 VDD.n35 8.501
R987 VDD.t21 VDD.n33 8.501
R988 VDD.t21 VDD.n31 8.501
R989 VDD.t21 VDD.n29 8.501
R990 VDD.t21 VDD.n27 8.501
R991 VDD.t21 VDD.n25 8.501
R992 VDD.t21 VDD.n23 8.501
R993 VDD.t21 VDD.n21 8.501
R994 VDD.t21 VDD.n19 8.501
R995 VDD.t21 VDD.n17 8.501
R996 VDD.t21 VDD.n15 8.501
R997 VDD.t21 VDD.n13 8.501
R998 VDD.t21 VDD.n11 8.501
R999 VDD.t21 VDD.n8 8.501
R1000 VDD.t21 VDD.n7 8.501
R1001 VDD.n1138 VDD.n171 8.501
R1002 VDD.t21 VDD.n5 8.501
R1003 VDD.t21 VDD.n105 8.501
R1004 VDD.t21 VDD.n104 8.501
R1005 VDD.t21 VDD.n103 8.501
R1006 VDD.t21 VDD.n102 8.501
R1007 VDD.t21 VDD.n101 8.501
R1008 VDD.t21 VDD.n100 8.501
R1009 VDD.t21 VDD.n99 8.501
R1010 VDD.t21 VDD.n98 8.501
R1011 VDD.t21 VDD.n97 8.501
R1012 VDD.n681 VDD.t20 8.5005
R1013 VDD.n1022 VDD.t20 8.5005
R1014 VDD.n682 VDD.t20 8.5005
R1015 VDD.n1018 VDD.t20 8.5005
R1016 VDD.n683 VDD.t20 8.5005
R1017 VDD.n690 VDD.t20 8.5005
R1018 VDD.n693 VDD.t20 8.5005
R1019 VDD.n689 VDD.t20 8.5005
R1020 VDD.n697 VDD.t20 8.5005
R1021 VDD.n688 VDD.t20 8.5005
R1022 VDD.n701 VDD.t20 8.5005
R1023 VDD.n687 VDD.t20 8.5005
R1024 VDD.n686 VDD.t20 8.5005
R1025 VDD.t81 VDD.n997 8.5005
R1026 VDD.t81 VDD.n988 8.5005
R1027 VDD.t81 VDD.n984 8.5005
R1028 VDD.t81 VDD.n983 8.5005
R1029 VDD.t81 VDD.n979 8.5005
R1030 VDD.t81 VDD.n973 8.5005
R1031 VDD.t81 VDD.n972 8.5005
R1032 VDD.t81 VDD.n968 8.5005
R1033 VDD.t81 VDD.n967 8.5005
R1034 VDD.t81 VDD.n964 8.5005
R1035 VDD.n998 VDD.t81 8.5005
R1036 VDD.t81 VDD.n961 8.5005
R1037 VDD.t81 VDD.n960 8.5005
R1038 VDD.n306 VDD.t41 8.5005
R1039 VDD.n268 VDD.t41 8.5005
R1040 VDD.n302 VDD.t41 8.5005
R1041 VDD.n269 VDD.t41 8.5005
R1042 VDD.n298 VDD.t41 8.5005
R1043 VDD.n294 VDD.t41 8.5005
R1044 VDD.n272 VDD.t41 8.5005
R1045 VDD.n290 VDD.t41 8.5005
R1046 VDD.n273 VDD.t41 8.5005
R1047 VDD.n286 VDD.t41 8.5005
R1048 VDD.n274 VDD.t41 8.5005
R1049 VDD.n282 VDD.t41 8.5005
R1050 VDD.n280 VDD.t41 8.5005
R1051 VDD.n1155 VDD.t61 8.5005
R1052 VDD.n147 VDD.t61 8.5005
R1053 VDD.n1151 VDD.t61 8.5005
R1054 VDD.n148 VDD.t61 8.5005
R1055 VDD.n1147 VDD.t61 8.5005
R1056 VDD.n150 VDD.t61 8.5005
R1057 VDD.n156 VDD.t61 8.5005
R1058 VDD.n160 VDD.t61 8.5005
R1059 VDD.n155 VDD.t61 8.5005
R1060 VDD.n164 VDD.t61 8.5005
R1061 VDD.n154 VDD.t61 8.5005
R1062 VDD.n168 VDD.t61 8.5005
R1063 VDD.n170 VDD.t61 8.5005
R1064 VDD.n807 VDD.n518 8.4984
R1065 VDD.n806 VDD.n805 8.4984
R1066 VDD.n804 VDD.n803 8.4984
R1067 VDD.n802 VDD.n801 8.4984
R1068 VDD.n800 VDD.n799 8.4984
R1069 VDD.n798 VDD.n797 8.4984
R1070 VDD.n796 VDD.n795 8.4984
R1071 VDD.n794 VDD.n793 8.4984
R1072 VDD.n792 VDD.n791 8.4984
R1073 VDD.n790 VDD.n789 8.4984
R1074 VDD.n788 VDD.n787 8.4984
R1075 VDD.n786 VDD.n785 8.4984
R1076 VDD.n784 VDD.n783 8.4984
R1077 VDD.n782 VDD.n781 8.4984
R1078 VDD.n780 VDD.n779 8.4984
R1079 VDD.n778 VDD.n777 8.4984
R1080 VDD.n776 VDD.n775 8.4984
R1081 VDD.n774 VDD.n773 8.4984
R1082 VDD.n772 VDD.n771 8.4984
R1083 VDD.n770 VDD.n769 8.4984
R1084 VDD.n768 VDD.n767 8.4984
R1085 VDD.n766 VDD.n765 8.4984
R1086 VDD.n764 VDD.n763 8.4984
R1087 VDD.n762 VDD.n761 8.4984
R1088 VDD.n760 VDD.n759 8.4984
R1089 VDD.n758 VDD.n757 8.4984
R1090 VDD.n756 VDD.n755 8.4984
R1091 VDD.n752 VDD.n751 8.4984
R1092 VDD.n750 VDD.n749 8.4984
R1093 VDD.n748 VDD.n747 8.4984
R1094 VDD.n746 VDD.n745 8.4984
R1095 VDD.n739 VDD.n738 8.4984
R1096 VDD.n737 VDD.n736 8.4984
R1097 VDD.n735 VDD.n734 8.4984
R1098 VDD.n733 VDD.n732 8.4984
R1099 VDD.n729 VDD.n728 8.4984
R1100 VDD.n727 VDD.n726 8.4984
R1101 VDD.n725 VDD.n724 8.4984
R1102 VDD.n723 VDD.n722 8.4984
R1103 VDD.n719 VDD.n718 8.4984
R1104 VDD.n717 VDD.n716 8.4984
R1105 VDD.n715 VDD.n714 8.4984
R1106 VDD.n713 VDD.n712 8.4984
R1107 VDD.n711 VDD.n710 8.4984
R1108 VDD.n709 VDD.n708 8.4984
R1109 VDD.n955 VDD.n954 8.4984
R1110 VDD.n434 VDD.n433 8.4984
R1111 VDD.n325 VDD.n324 8.4984
R1112 VDD.n327 VDD.n326 8.4984
R1113 VDD.n329 VDD.n328 8.4984
R1114 VDD.n331 VDD.n330 8.4984
R1115 VDD.n333 VDD.n332 8.4984
R1116 VDD.n335 VDD.n334 8.4984
R1117 VDD.n337 VDD.n336 8.4984
R1118 VDD.n339 VDD.n338 8.4984
R1119 VDD.n341 VDD.n340 8.4984
R1120 VDD.n343 VDD.n342 8.4984
R1121 VDD.n345 VDD.n344 8.4984
R1122 VDD.n347 VDD.n346 8.4984
R1123 VDD.n349 VDD.n348 8.4984
R1124 VDD.n351 VDD.n350 8.4984
R1125 VDD.n353 VDD.n352 8.4984
R1126 VDD.n355 VDD.n354 8.4984
R1127 VDD.n357 VDD.n356 8.4984
R1128 VDD.n359 VDD.n358 8.4984
R1129 VDD.n361 VDD.n360 8.4984
R1130 VDD.n363 VDD.n362 8.4984
R1131 VDD.n365 VDD.n364 8.4984
R1132 VDD.n51 VDD.n1 8.4984
R1133 VDD.n1065 VDD.n1064 8.4984
R1134 VDD.n1062 VDD.n1061 8.4984
R1135 VDD.n1060 VDD.n1059 8.4984
R1136 VDD.n1058 VDD.n1057 8.4984
R1137 VDD.n216 VDD.n215 8.4984
R1138 VDD.n214 VDD.n213 8.4984
R1139 VDD.n212 VDD.n211 8.4984
R1140 VDD.n210 VDD.n209 8.4984
R1141 VDD.n206 VDD.n205 8.4984
R1142 VDD.n204 VDD.n203 8.4984
R1143 VDD.n202 VDD.n201 8.4984
R1144 VDD.n200 VDD.n199 8.4984
R1145 VDD.n196 VDD.n195 8.4984
R1146 VDD.n194 VDD.n193 8.4984
R1147 VDD.n192 VDD.n191 8.4984
R1148 VDD.n190 VDD.n189 8.4984
R1149 VDD.n186 VDD.n185 8.4984
R1150 VDD.n184 VDD.n183 8.4984
R1151 VDD.n182 VDD.n181 8.4984
R1152 VDD.n180 VDD.n179 8.4984
R1153 VDD.n178 VDD.n177 8.4984
R1154 VDD.n176 VDD.n175 8.4984
R1155 VDD.n173 VDD.n172 8.4984
R1156 VDD.n1041 VDD.n500 8.49747
R1157 VDD.n1041 VDD.n486 8.49747
R1158 VDD.n680 VDD.n679 8.49747
R1159 VDD.n993 VDD.n990 8.49747
R1160 VDD.n642 VDD.n641 8.49747
R1161 VDD.n1031 VDD.n677 8.49747
R1162 VDD.n1161 VDD.n144 8.49747
R1163 VDD.n1161 VDD.n130 8.49747
R1164 VDD.n281 VDD.n275 8.49747
R1165 VDD.n169 VDD.n153 8.49747
R1166 VDD.n315 VDD.n314 8.49747
R1167 VDD.n507 VDD.t89 8.49726
R1168 VDD.n661 VDD.t84 8.49726
R1169 VDD.n459 VDD.t99 8.49726
R1170 VDD.t94 VDD.n238 8.49726
R1171 VDD.n991 VDD.n990 8.46995
R1172 VDD.t0 VDD.n632 5.66778
R1173 VDD.t0 VDD.n610 5.66767
R1174 VDD.t0 VDD.n611 5.66767
R1175 VDD.t21 VDD.n96 5.66767
R1176 VDD.n1031 VDD.n1030 5.62487
R1177 VDD.n1043 VDD.t87 5.0005
R1178 VDD.n1011 VDD.t85 5.0005
R1179 VDD.n1005 VDD.t90 5.0005
R1180 VDD.n1035 VDD.t82 5.0005
R1181 VDD.n461 VDD.t97 5.0005
R1182 VDD.n277 VDD.t95 5.0005
R1183 VDD.n1141 VDD.t100 5.0005
R1184 VDD.n441 VDD.t92 5.0005
R1185 VDD.t21 VDD.n106 4.25119
R1186 VDD.n1014 VDD.t20 4.24739
R1187 VDD.t81 VDD.n978 4.24739
R1188 VDD.n270 VDD.t41 4.24739
R1189 VDD.n149 VDD.t61 4.24739
R1190 VDD.n312 VDD.n265 4.18774
R1191 VDD.n1051 VDD.n468 3.98967
R1192 VDD.n1052 VDD.n1051 3.98967
R1193 VDD.n1012 VDD.n1011 3.0005
R1194 VDD.n1005 VDD.n959 3.0005
R1195 VDD.n1035 VDD.n480 3.0005
R1196 VDD.n1044 VDD.n1043 3.0005
R1197 VDD.n277 VDD.n276 3.0005
R1198 VDD.n1142 VDD.n1141 3.0005
R1199 VDD.n442 VDD.n441 3.0005
R1200 VDD.n462 VDD.n461 3.0005
R1201 VDD.n313 VDD.n312 1.6823
R1202 VDD VDD.n468 1.62885
R1203 VDD.n1030 VDD.n1029 1.60889
R1204 VDD.n1052 VDD 1.54885
R1205 VDD.n991 VDD.n517 1.53109
R1206 VDD.n1029 VDD.n1028 1.49754
R1207 VDD.n458 VDD.n145 1.47286
R1208 VDD.n517 VDD.n516 1.47187
R1209 VDD.n316 VDD.n313 1.47157
R1210 VDD.n1054 VDD.n1053 1.44681
R1211 VDD.n1159 VDD.n145 1.43175
R1212 VDD.n1053 VDD.n468 1.38706
R1213 VDD.n1053 VDD.n1052 1.38706
R1214 VDD.n471 VDD.t10 1.293
R1215 VDD.n222 VDD.t31 1.293
R1216 VDD.n1050 VDD.n469 1.02406
R1217 VDD.n741 VDD.n720 1.02406
R1218 VDD.n741 VDD.n721 1.02406
R1219 VDD.n742 VDD.n730 1.02406
R1220 VDD.n742 VDD.n731 1.02406
R1221 VDD.n743 VDD.n740 1.02406
R1222 VDD.n744 VDD.n743 1.02406
R1223 VDD.n753 VDD.n470 1.02406
R1224 VDD.n754 VDD.n470 1.02406
R1225 VDD.n1049 VDD.n473 1.02406
R1226 VDD.n1049 VDD.n472 1.02406
R1227 VDD.n1048 VDD.n475 1.02406
R1228 VDD.n1048 VDD.n474 1.02406
R1229 VDD.n1047 VDD.n477 1.02406
R1230 VDD.n1047 VDD.n476 1.02406
R1231 VDD.n1046 VDD.n479 1.02406
R1232 VDD.n1046 VDD.n478 1.02406
R1233 VDD.n1054 VDD.n221 1.02406
R1234 VDD.n218 VDD.n187 1.02406
R1235 VDD.n218 VDD.n188 1.02406
R1236 VDD.n219 VDD.n197 1.02406
R1237 VDD.n219 VDD.n198 1.02406
R1238 VDD.n220 VDD.n207 1.02406
R1239 VDD.n220 VDD.n208 1.02406
R1240 VDD.n1055 VDD.n217 1.02406
R1241 VDD.n1056 VDD.n1055 1.02406
R1242 VDD.n467 VDD.n224 1.02406
R1243 VDD.n467 VDD.n223 1.02406
R1244 VDD.n466 VDD.n226 1.02406
R1245 VDD.n466 VDD.n225 1.02406
R1246 VDD.n465 VDD.n228 1.02406
R1247 VDD.n465 VDD.n227 1.02406
R1248 VDD.n464 VDD.n230 1.02406
R1249 VDD.n464 VDD.n229 1.02406
R1250 VDD.n469 VDD.t71 0.958035
R1251 VDD.n720 VDD.t18 0.958035
R1252 VDD.n721 VDD.t79 0.958035
R1253 VDD.n730 VDD.t16 0.958035
R1254 VDD.n731 VDD.t77 0.958035
R1255 VDD.n740 VDD.t14 0.958035
R1256 VDD.n744 VDD.t75 0.958035
R1257 VDD.n753 VDD.t12 0.958035
R1258 VDD.n754 VDD.t73 0.958035
R1259 VDD.n473 VDD.t8 0.958035
R1260 VDD.n472 VDD.t69 0.958035
R1261 VDD.n475 VDD.t6 0.958035
R1262 VDD.n474 VDD.t67 0.958035
R1263 VDD.n477 VDD.t4 0.958035
R1264 VDD.n476 VDD.t65 0.958035
R1265 VDD.n479 VDD.t2 0.958035
R1266 VDD.n478 VDD.t63 0.958035
R1267 VDD.n221 VDD.t51 0.958035
R1268 VDD.n187 VDD.t39 0.958035
R1269 VDD.n188 VDD.t59 0.958035
R1270 VDD.n197 VDD.t37 0.958035
R1271 VDD.n198 VDD.t57 0.958035
R1272 VDD.n207 VDD.t35 0.958035
R1273 VDD.n208 VDD.t55 0.958035
R1274 VDD.n217 VDD.t33 0.958035
R1275 VDD.n1056 VDD.t53 0.958035
R1276 VDD.n224 VDD.t29 0.958035
R1277 VDD.n223 VDD.t49 0.958035
R1278 VDD.n226 VDD.t27 0.958035
R1279 VDD.n225 VDD.t47 0.958035
R1280 VDD.n228 VDD.t25 0.958035
R1281 VDD.n227 VDD.t45 0.958035
R1282 VDD.n230 VDD.t23 0.958035
R1283 VDD.n229 VDD.t43 0.958035
R1284 VDD.n882 VDD.n469 0.506645
R1285 VDD.n934 VDD.n720 0.506645
R1286 VDD.n934 VDD.n721 0.506645
R1287 VDD.n921 VDD.n730 0.506645
R1288 VDD.n921 VDD.n731 0.506645
R1289 VDD.n908 VDD.n740 0.506645
R1290 VDD.n908 VDD.n744 0.506645
R1291 VDD.n895 VDD.n753 0.506645
R1292 VDD.n895 VDD.n754 0.506645
R1293 VDD.n869 VDD.n473 0.506645
R1294 VDD.n869 VDD.n472 0.506645
R1295 VDD.n856 VDD.n475 0.506645
R1296 VDD.n856 VDD.n474 0.506645
R1297 VDD.n843 VDD.n477 0.506645
R1298 VDD.n843 VDD.n476 0.506645
R1299 VDD.n830 VDD.n479 0.506645
R1300 VDD.n830 VDD.n478 0.506645
R1301 VDD.n221 VDD.n0 0.506645
R1302 VDD.n1115 VDD.n187 0.506645
R1303 VDD.n1115 VDD.n188 0.506645
R1304 VDD.n1102 VDD.n197 0.506645
R1305 VDD.n1102 VDD.n198 0.506645
R1306 VDD.n1089 VDD.n207 0.506645
R1307 VDD.n1089 VDD.n208 0.506645
R1308 VDD.n1076 VDD.n217 0.506645
R1309 VDD.n1076 VDD.n1056 0.506645
R1310 VDD.n375 VDD.n224 0.506645
R1311 VDD.n375 VDD.n223 0.506645
R1312 VDD.n388 VDD.n226 0.506645
R1313 VDD.n388 VDD.n225 0.506645
R1314 VDD.n401 VDD.n228 0.506645
R1315 VDD.n401 VDD.n227 0.506645
R1316 VDD.n414 VDD.n230 0.506645
R1317 VDD.n414 VDD.n229 0.506645
R1318 VDD.n977 VDD.n959 0.325576
R1319 VDD.n1013 VDD.n1012 0.325576
R1320 VDD.n660 VDD.n480 0.325576
R1321 VDD.n1044 VDD.n481 0.325576
R1322 VDD.n1143 VDD.n1142 0.325576
R1323 VDD.n276 VDD.n271 0.325576
R1324 VDD.n442 VDD.n231 0.325576
R1325 VDD.n462 VDD.n460 0.325576
R1326 VDD.n312 VDD.n311 0.231793
R1327 VDD.n1030 VDD.n643 0.179602
R1328 VDD.t0 VDD.n631 0.171
R1329 VDD.t21 VDD.n107 0.169802
R1330 VDD.t0 VDD.n485 0.141496
R1331 VDD.t21 VDD.n1162 0.140329
R1332 VDD.n992 VDD.n991 0.135344
R1333 VDD.n1046 VDD.n1045 0.117247
R1334 VDD.n464 VDD.n463 0.117247
R1335 VDD.n741 VDD.n685 0.1171
R1336 VDD.n218 VDD.n151 0.1171
R1337 VDD.n742 VDD.n741 0.08146
R1338 VDD.n743 VDD.n742 0.08146
R1339 VDD.n743 VDD.n470 0.08146
R1340 VDD.n1050 VDD.n470 0.08146
R1341 VDD.n1050 VDD.n1049 0.08146
R1342 VDD.n1049 VDD.n1048 0.08146
R1343 VDD.n1048 VDD.n1047 0.08146
R1344 VDD.n1047 VDD.n1046 0.08146
R1345 VDD.n219 VDD.n218 0.08146
R1346 VDD.n220 VDD.n219 0.08146
R1347 VDD.n1055 VDD.n220 0.08146
R1348 VDD.n1055 VDD.n1054 0.08146
R1349 VDD.n1054 VDD.n467 0.08146
R1350 VDD.n467 VDD.n466 0.08146
R1351 VDD.n466 VDD.n465 0.08146
R1352 VDD.n465 VDD.n464 0.08146
R1353 VDD.n959 VDD.n685 0.0231238
R1354 VDD.n1012 VDD.n685 0.0231238
R1355 VDD.n1045 VDD.n480 0.0231238
R1356 VDD.n1045 VDD.n1044 0.0231238
R1357 VDD.n1142 VDD.n151 0.0231238
R1358 VDD.n276 VDD.n151 0.0231238
R1359 VDD.n463 VDD.n442 0.0231238
R1360 VDD.n463 VDD.n462 0.0231238
R1361 VDD.n1051 VDD.n1050 0.0197308
R1362 VDD.n705 VDD.n704 0.0146399
R1363 VDD.n1002 VDD.n1001 0.0146399
R1364 VDD.n267 VDD.n266 0.0146399
R1365 VDD.n1160 VDD.n146 0.0146399
R1366 VDD.n321 VDD.n320 0.0146399
R1367 VDD.n501 VDD.n499 0.0144319
R1368 VDD.n1026 VDD.n1025 0.0144319
R1369 VDD.n996 VDD.n994 0.0144319
R1370 VDD.n1033 VDD.n1032 0.0144319
R1371 VDD.n457 VDD.n143 0.0144319
R1372 VDD.n309 VDD.n308 0.0144319
R1373 VDD.n1157 VDD.n1156 0.0144319
R1374 VDD.n261 VDD.n235 0.0144319
R1375 VDD.n808 VDD.n484 0.0142344
R1376 VDD.n1008 VDD.n958 0.0142344
R1377 VDD.n435 VDD.n127 0.0142344
R1378 VDD.n1138 VDD.n1137 0.0142344
R1379 VDD.n1042 VDD.n483 0.014224
R1380 VDD.n515 VDD.n487 0.014224
R1381 VDD.n702 VDD.n687 0.014224
R1382 VDD.n707 VDD.n686 0.014224
R1383 VDD.n1004 VDD.n960 0.014224
R1384 VDD.n999 VDD.n961 0.014224
R1385 VDD.n646 VDD.n644 0.014224
R1386 VDD.n1036 VDD.n1034 0.014224
R1387 VDD.n444 VDD.n129 0.014224
R1388 VDD.n445 VDD.n131 0.014224
R1389 VDD.n283 VDD.n282 0.014224
R1390 VDD.n280 VDD.n279 0.014224
R1391 VDD.n1140 VDD.n170 0.014224
R1392 VDD.n168 VDD.n167 0.014224
R1393 VDD.n318 VDD.n233 0.014224
R1394 VDD.n323 VDD.n232 0.014224
R1395 VDD.n502 VDD.n498 0.0138081
R1396 VDD.n1023 VDD.n681 0.0138081
R1397 VDD.n997 VDD.n989 0.0138081
R1398 VDD.n676 VDD.n675 0.0138081
R1399 VDD.n456 VDD.n142 0.0138081
R1400 VDD.n306 VDD.n305 0.0138081
R1401 VDD.n1155 VDD.n1154 0.0138081
R1402 VDD.n264 VDD.n263 0.0138081
R1403 VDD.n1015 VDD.n1014 0.0137626
R1404 VDD.n980 VDD.n978 0.0137626
R1405 VDD.n297 VDD.n270 0.0137626
R1406 VDD.n1146 VDD.n149 0.0137626
R1407 VDD.n1050 VDD.n471 0.013708
R1408 VDD.n1054 VDD.n222 0.013708
R1409 VDD.n514 VDD.n488 0.0136002
R1410 VDD.n701 VDD.n700 0.0136002
R1411 VDD.n998 VDD.n962 0.0136002
R1412 VDD.n648 VDD.n645 0.0136002
R1413 VDD.n446 VDD.n132 0.0136002
R1414 VDD.n285 VDD.n274 0.0136002
R1415 VDD.n165 VDD.n154 0.0136002
R1416 VDD.n317 VDD.n234 0.0136002
R1417 VDD.n503 VDD.n497 0.0131843
R1418 VDD.n1022 VDD.n1021 0.0131843
R1419 VDD.n988 VDD.n987 0.0131843
R1420 VDD.n673 VDD.n672 0.0131843
R1421 VDD.n455 VDD.n141 0.0131843
R1422 VDD.n303 VDD.n268 0.0131843
R1423 VDD.n1152 VDD.n147 0.0131843
R1424 VDD.n257 VDD.n236 0.0131843
R1425 VDD.n513 VDD.n489 0.0129764
R1426 VDD.n698 VDD.n688 0.0129764
R1427 VDD.n966 VDD.n964 0.0129764
R1428 VDD.n651 VDD.n649 0.0129764
R1429 VDD.n447 VDD.n133 0.0129764
R1430 VDD.n287 VDD.n286 0.0129764
R1431 VDD.n164 VDD.n163 0.0129764
R1432 VDD.n243 VDD.n241 0.0129764
R1433 VDD.n512 VDD.n490 0.0123526
R1434 VDD.n504 VDD.n496 0.0123526
R1435 VDD.n1019 VDD.n682 0.0123526
R1436 VDD.n697 VDD.n696 0.0123526
R1437 VDD.n969 VDD.n967 0.0123526
R1438 VDD.n985 VDD.n984 0.0123526
R1439 VDD.n671 VDD.n670 0.0123526
R1440 VDD.n653 VDD.n650 0.0123526
R1441 VDD.n448 VDD.n134 0.0123526
R1442 VDD.n454 VDD.n140 0.0123526
R1443 VDD.n302 VDD.n301 0.0123526
R1444 VDD.n289 VDD.n273 0.0123526
R1445 VDD.n161 VDD.n155 0.0123526
R1446 VDD.n1151 VDD.n1150 0.0123526
R1447 VDD.n260 VDD.n259 0.0123526
R1448 VDD.n248 VDD.n244 0.0123526
R1449 VDD.n505 VDD.n495 0.0117287
R1450 VDD.n1018 VDD.n1017 0.0117287
R1451 VDD.n983 VDD.n982 0.0117287
R1452 VDD.n668 VDD.n667 0.0117287
R1453 VDD.n453 VDD.n139 0.0117287
R1454 VDD.n299 VDD.n269 0.0117287
R1455 VDD.n1148 VDD.n148 0.0117287
R1456 VDD.n252 VDD.n237 0.0117287
R1457 VDD.n511 VDD.n491 0.0115208
R1458 VDD.n694 VDD.n689 0.0115208
R1459 VDD.n971 VDD.n968 0.0115208
R1460 VDD.n656 VDD.n654 0.0115208
R1461 VDD.n449 VDD.n135 0.0115208
R1462 VDD.n291 VDD.n290 0.0115208
R1463 VDD.n160 VDD.n159 0.0115208
R1464 VDD.n250 VDD.n240 0.0115208
R1465 VDD.n506 VDD.n494 0.0111049
R1466 VDD.n1015 VDD.n683 0.0111049
R1467 VDD.n980 VDD.n979 0.0111049
R1468 VDD.n666 VDD.n665 0.0111049
R1469 VDD.n452 VDD.n138 0.0111049
R1470 VDD.n298 VDD.n297 0.0111049
R1471 VDD.n1147 VDD.n1146 0.0111049
R1472 VDD.n256 VDD.n255 0.0111049
R1473 VDD.n510 VDD.n492 0.010897
R1474 VDD.n693 VDD.n692 0.010897
R1475 VDD.n974 VDD.n972 0.010897
R1476 VDD.n658 VDD.n655 0.010897
R1477 VDD.n450 VDD.n136 0.010897
R1478 VDD.n293 VDD.n272 0.010897
R1479 VDD.n157 VDD.n156 0.010897
R1480 VDD.n251 VDD.n247 0.010897
R1481 VDD.n950 VDD.n949 0.0108889
R1482 VDD.n947 VDD.n946 0.0108889
R1483 VDD.n944 VDD.n943 0.0108889
R1484 VDD.n941 VDD.n940 0.0108889
R1485 VDD.n938 VDD.n937 0.0108889
R1486 VDD.n931 VDD.n930 0.0108889
R1487 VDD.n928 VDD.n927 0.0108889
R1488 VDD.n925 VDD.n924 0.0108889
R1489 VDD.n918 VDD.n917 0.0108889
R1490 VDD.n915 VDD.n914 0.0108889
R1491 VDD.n912 VDD.n911 0.0108889
R1492 VDD.n905 VDD.n904 0.0108889
R1493 VDD.n902 VDD.n901 0.0108889
R1494 VDD.n899 VDD.n898 0.0108889
R1495 VDD.n892 VDD.n891 0.0108889
R1496 VDD.n889 VDD.n888 0.0108889
R1497 VDD.n886 VDD.n885 0.0108889
R1498 VDD.n879 VDD.n878 0.0108889
R1499 VDD.n876 VDD.n875 0.0108889
R1500 VDD.n873 VDD.n872 0.0108889
R1501 VDD.n866 VDD.n865 0.0108889
R1502 VDD.n863 VDD.n862 0.0108889
R1503 VDD.n860 VDD.n859 0.0108889
R1504 VDD.n853 VDD.n852 0.0108889
R1505 VDD.n850 VDD.n849 0.0108889
R1506 VDD.n847 VDD.n846 0.0108889
R1507 VDD.n840 VDD.n839 0.0108889
R1508 VDD.n837 VDD.n836 0.0108889
R1509 VDD.n834 VDD.n833 0.0108889
R1510 VDD.n827 VDD.n826 0.0108889
R1511 VDD.n824 VDD.n823 0.0108889
R1512 VDD.n821 VDD.n820 0.0108889
R1513 VDD.n818 VDD.n817 0.0108889
R1514 VDD.n815 VDD.n814 0.0108889
R1515 VDD.n1131 VDD.n1130 0.0108889
R1516 VDD.n1128 VDD.n1127 0.0108889
R1517 VDD.n1125 VDD.n1124 0.0108889
R1518 VDD.n1122 VDD.n1121 0.0108889
R1519 VDD.n1119 VDD.n1118 0.0108889
R1520 VDD.n1112 VDD.n1111 0.0108889
R1521 VDD.n1109 VDD.n1108 0.0108889
R1522 VDD.n1106 VDD.n1105 0.0108889
R1523 VDD.n1099 VDD.n1098 0.0108889
R1524 VDD.n1096 VDD.n1095 0.0108889
R1525 VDD.n1093 VDD.n1092 0.0108889
R1526 VDD.n1086 VDD.n1085 0.0108889
R1527 VDD.n1083 VDD.n1082 0.0108889
R1528 VDD.n1080 VDD.n1079 0.0108889
R1529 VDD.n1073 VDD.n1072 0.0108889
R1530 VDD.n1070 VDD.n1069 0.0108889
R1531 VDD.n1067 VDD.n1066 0.0108889
R1532 VDD.n366 VDD.n2 0.0108889
R1533 VDD.n369 VDD.n368 0.0108889
R1534 VDD.n372 VDD.n371 0.0108889
R1535 VDD.n379 VDD.n378 0.0108889
R1536 VDD.n382 VDD.n381 0.0108889
R1537 VDD.n385 VDD.n384 0.0108889
R1538 VDD.n392 VDD.n391 0.0108889
R1539 VDD.n395 VDD.n394 0.0108889
R1540 VDD.n398 VDD.n397 0.0108889
R1541 VDD.n405 VDD.n404 0.0108889
R1542 VDD.n408 VDD.n407 0.0108889
R1543 VDD.n411 VDD.n410 0.0108889
R1544 VDD.n418 VDD.n417 0.0108889
R1545 VDD.n421 VDD.n420 0.0108889
R1546 VDD.n424 VDD.n423 0.0108889
R1547 VDD.n427 VDD.n426 0.0108889
R1548 VDD.n430 VDD.n429 0.0108889
R1549 VDD.n509 VDD.n493 0.0102732
R1550 VDD.n690 VDD.n684 0.0102732
R1551 VDD.n976 VDD.n973 0.0102732
R1552 VDD.n663 VDD.n659 0.0102732
R1553 VDD.n451 VDD.n137 0.0102732
R1554 VDD.n295 VDD.n294 0.0102732
R1555 VDD.n1144 VDD.n150 0.0102732
R1556 VDD.n245 VDD.n239 0.0102732
R1557 VDD.n934 VDD.n933 0.00936111
R1558 VDD.n831 VDD.n830 0.00936111
R1559 VDD.n1115 VDD.n1114 0.00936111
R1560 VDD.n414 VDD.n413 0.00936111
R1561 VDD.n1014 VDD.n1013 0.00935329
R1562 VDD.n978 VDD.n977 0.00935329
R1563 VDD.n271 VDD.n270 0.00935329
R1564 VDD.n1143 VDD.n149 0.00935329
R1565 VDD.n486 VDD.n483 0.00848288
R1566 VDD.n515 VDD.n486 0.00848288
R1567 VDD.n516 VDD.n500 0.00848288
R1568 VDD.n1028 VDD.n680 0.00848288
R1569 VDD.n993 VDD.n992 0.00848288
R1570 VDD.n677 VDD.n643 0.00848288
R1571 VDD.n644 VDD.n642 0.00848288
R1572 VDD.n1034 VDD.n642 0.00848288
R1573 VDD.n444 VDD.n130 0.00848288
R1574 VDD.n445 VDD.n130 0.00848288
R1575 VDD.n458 VDD.n144 0.00848288
R1576 VDD.n282 VDD.n281 0.00848288
R1577 VDD.n281 VDD.n280 0.00848288
R1578 VDD.n170 VDD.n169 0.00848288
R1579 VDD.n169 VDD.n168 0.00848288
R1580 VDD.n316 VDD.n315 0.00848288
R1581 VDD.n507 VDD.n481 0.00848253
R1582 VDD.n508 VDD.n507 0.00848253
R1583 VDD.n662 VDD.n661 0.00848253
R1584 VDD.n661 VDD.n660 0.00848253
R1585 VDD.n460 VDD.n459 0.00848253
R1586 VDD.n459 VDD.n443 0.00848253
R1587 VDD.n253 VDD.n238 0.00848253
R1588 VDD.n238 VDD.n231 0.00848253
R1589 VDD.n811 VDD.n482 0.0084017
R1590 VDD.n1043 VDD.n482 0.0084017
R1591 VDD.n1011 VDD.n1010 0.0084017
R1592 VDD.n1010 VDD.n953 0.0084017
R1593 VDD.n1006 VDD.n953 0.0084017
R1594 VDD.n1006 VDD.n1005 0.0084017
R1595 VDD.n1035 VDD.n640 0.0084017
R1596 VDD.n811 VDD.n640 0.0084017
R1597 VDD.n438 VDD.n128 0.0084017
R1598 VDD.n461 VDD.n128 0.0084017
R1599 VDD.n277 VDD.n174 0.0084017
R1600 VDD.n1134 VDD.n174 0.0084017
R1601 VDD.n1134 VDD.n152 0.0084017
R1602 VDD.n1141 VDD.n152 0.0084017
R1603 VDD.n441 VDD.n440 0.0084017
R1604 VDD.n440 VDD.n438 0.0084017
R1605 VDD.n501 VDD.n500 0.00827494
R1606 VDD.n1026 VDD.n680 0.00827494
R1607 VDD.n994 VDD.n993 0.00827494
R1608 VDD.n1033 VDD.n677 0.00827494
R1609 VDD.n457 VDD.n144 0.00827494
R1610 VDD.n315 VDD.n235 0.00827494
R1611 VDD.n921 VDD.n920 0.00813889
R1612 VDD.n844 VDD.n843 0.00813889
R1613 VDD.n1102 VDD.n1101 0.00813889
R1614 VDD.n401 VDD.n400 0.00813889
R1615 VDD.n882 VDD.n471 0.00728403
R1616 VDD.n222 VDD.n0 0.00728403
R1617 VDD.n1029 VDD.n678 0.00724968
R1618 VDD.n908 VDD.n907 0.00691667
R1619 VDD.n883 VDD.n882 0.00691667
R1620 VDD.n857 VDD.n856 0.00691667
R1621 VDD.n1089 VDD.n1088 0.00691667
R1622 VDD.n1063 VDD.n0 0.00691667
R1623 VDD.n388 VDD.n387 0.00691667
R1624 VDD.n1043 VDD.n1042 0.00673819
R1625 VDD.n1011 VDD.n707 0.00673819
R1626 VDD.n1005 VDD.n1004 0.00673819
R1627 VDD.n1036 VDD.n1035 0.00673819
R1628 VDD.n461 VDD.n129 0.00673819
R1629 VDD.n279 VDD.n277 0.00673819
R1630 VDD.n1141 VDD.n1140 0.00673819
R1631 VDD.n441 VDD.n323 0.00673819
R1632 VDD.n812 VDD.n811 0.00630556
R1633 VDD.n438 VDD.n432 0.00630556
R1634 VDD.n956 VDD.n955 0.00619286
R1635 VDD.n950 VDD.n709 0.00619286
R1636 VDD.n947 VDD.n711 0.00619286
R1637 VDD.n944 VDD.n713 0.00619286
R1638 VDD.n941 VDD.n715 0.00619286
R1639 VDD.n938 VDD.n717 0.00619286
R1640 VDD.n935 VDD.n719 0.00619286
R1641 VDD.n931 VDD.n723 0.00619286
R1642 VDD.n928 VDD.n725 0.00619286
R1643 VDD.n925 VDD.n727 0.00619286
R1644 VDD.n922 VDD.n729 0.00619286
R1645 VDD.n918 VDD.n733 0.00619286
R1646 VDD.n915 VDD.n735 0.00619286
R1647 VDD.n912 VDD.n737 0.00619286
R1648 VDD.n909 VDD.n739 0.00619286
R1649 VDD.n905 VDD.n746 0.00619286
R1650 VDD.n902 VDD.n748 0.00619286
R1651 VDD.n899 VDD.n750 0.00619286
R1652 VDD.n896 VDD.n752 0.00619286
R1653 VDD.n892 VDD.n756 0.00619286
R1654 VDD.n889 VDD.n758 0.00619286
R1655 VDD.n886 VDD.n760 0.00619286
R1656 VDD.n883 VDD.n762 0.00619286
R1657 VDD.n879 VDD.n764 0.00619286
R1658 VDD.n876 VDD.n766 0.00619286
R1659 VDD.n873 VDD.n768 0.00619286
R1660 VDD.n870 VDD.n770 0.00619286
R1661 VDD.n866 VDD.n772 0.00619286
R1662 VDD.n863 VDD.n774 0.00619286
R1663 VDD.n860 VDD.n776 0.00619286
R1664 VDD.n857 VDD.n778 0.00619286
R1665 VDD.n853 VDD.n780 0.00619286
R1666 VDD.n850 VDD.n782 0.00619286
R1667 VDD.n847 VDD.n784 0.00619286
R1668 VDD.n844 VDD.n786 0.00619286
R1669 VDD.n840 VDD.n788 0.00619286
R1670 VDD.n837 VDD.n790 0.00619286
R1671 VDD.n834 VDD.n792 0.00619286
R1672 VDD.n831 VDD.n794 0.00619286
R1673 VDD.n827 VDD.n796 0.00619286
R1674 VDD.n824 VDD.n798 0.00619286
R1675 VDD.n821 VDD.n800 0.00619286
R1676 VDD.n818 VDD.n802 0.00619286
R1677 VDD.n815 VDD.n804 0.00619286
R1678 VDD.n812 VDD.n806 0.00619286
R1679 VDD.n808 VDD.n807 0.00619286
R1680 VDD.n810 VDD.n807 0.00619286
R1681 VDD.n814 VDD.n806 0.00619286
R1682 VDD.n817 VDD.n804 0.00619286
R1683 VDD.n820 VDD.n802 0.00619286
R1684 VDD.n823 VDD.n800 0.00619286
R1685 VDD.n826 VDD.n798 0.00619286
R1686 VDD.n829 VDD.n796 0.00619286
R1687 VDD.n833 VDD.n794 0.00619286
R1688 VDD.n836 VDD.n792 0.00619286
R1689 VDD.n839 VDD.n790 0.00619286
R1690 VDD.n842 VDD.n788 0.00619286
R1691 VDD.n846 VDD.n786 0.00619286
R1692 VDD.n849 VDD.n784 0.00619286
R1693 VDD.n852 VDD.n782 0.00619286
R1694 VDD.n855 VDD.n780 0.00619286
R1695 VDD.n859 VDD.n778 0.00619286
R1696 VDD.n862 VDD.n776 0.00619286
R1697 VDD.n865 VDD.n774 0.00619286
R1698 VDD.n868 VDD.n772 0.00619286
R1699 VDD.n872 VDD.n770 0.00619286
R1700 VDD.n875 VDD.n768 0.00619286
R1701 VDD.n878 VDD.n766 0.00619286
R1702 VDD.n881 VDD.n764 0.00619286
R1703 VDD.n885 VDD.n762 0.00619286
R1704 VDD.n888 VDD.n760 0.00619286
R1705 VDD.n891 VDD.n758 0.00619286
R1706 VDD.n894 VDD.n756 0.00619286
R1707 VDD.n898 VDD.n752 0.00619286
R1708 VDD.n901 VDD.n750 0.00619286
R1709 VDD.n904 VDD.n748 0.00619286
R1710 VDD.n907 VDD.n746 0.00619286
R1711 VDD.n911 VDD.n739 0.00619286
R1712 VDD.n914 VDD.n737 0.00619286
R1713 VDD.n917 VDD.n735 0.00619286
R1714 VDD.n920 VDD.n733 0.00619286
R1715 VDD.n924 VDD.n729 0.00619286
R1716 VDD.n927 VDD.n727 0.00619286
R1717 VDD.n930 VDD.n725 0.00619286
R1718 VDD.n933 VDD.n723 0.00619286
R1719 VDD.n937 VDD.n719 0.00619286
R1720 VDD.n940 VDD.n717 0.00619286
R1721 VDD.n943 VDD.n715 0.00619286
R1722 VDD.n946 VDD.n713 0.00619286
R1723 VDD.n949 VDD.n711 0.00619286
R1724 VDD.n952 VDD.n709 0.00619286
R1725 VDD.n958 VDD.n955 0.00619286
R1726 VDD.n1135 VDD.n173 0.00619286
R1727 VDD.n1131 VDD.n176 0.00619286
R1728 VDD.n1128 VDD.n178 0.00619286
R1729 VDD.n1125 VDD.n180 0.00619286
R1730 VDD.n1122 VDD.n182 0.00619286
R1731 VDD.n1119 VDD.n184 0.00619286
R1732 VDD.n1116 VDD.n186 0.00619286
R1733 VDD.n1112 VDD.n190 0.00619286
R1734 VDD.n1109 VDD.n192 0.00619286
R1735 VDD.n1106 VDD.n194 0.00619286
R1736 VDD.n1103 VDD.n196 0.00619286
R1737 VDD.n1099 VDD.n200 0.00619286
R1738 VDD.n1096 VDD.n202 0.00619286
R1739 VDD.n1093 VDD.n204 0.00619286
R1740 VDD.n1090 VDD.n206 0.00619286
R1741 VDD.n1086 VDD.n210 0.00619286
R1742 VDD.n1083 VDD.n212 0.00619286
R1743 VDD.n1080 VDD.n214 0.00619286
R1744 VDD.n1077 VDD.n216 0.00619286
R1745 VDD.n1073 VDD.n1058 0.00619286
R1746 VDD.n1070 VDD.n1060 0.00619286
R1747 VDD.n1067 VDD.n1062 0.00619286
R1748 VDD.n1065 VDD.n1063 0.00619286
R1749 VDD.n2 VDD.n1 0.00619286
R1750 VDD.n368 VDD.n365 0.00619286
R1751 VDD.n371 VDD.n363 0.00619286
R1752 VDD.n374 VDD.n361 0.00619286
R1753 VDD.n378 VDD.n359 0.00619286
R1754 VDD.n381 VDD.n357 0.00619286
R1755 VDD.n384 VDD.n355 0.00619286
R1756 VDD.n387 VDD.n353 0.00619286
R1757 VDD.n391 VDD.n351 0.00619286
R1758 VDD.n394 VDD.n349 0.00619286
R1759 VDD.n397 VDD.n347 0.00619286
R1760 VDD.n400 VDD.n345 0.00619286
R1761 VDD.n404 VDD.n343 0.00619286
R1762 VDD.n407 VDD.n341 0.00619286
R1763 VDD.n410 VDD.n339 0.00619286
R1764 VDD.n413 VDD.n337 0.00619286
R1765 VDD.n417 VDD.n335 0.00619286
R1766 VDD.n420 VDD.n333 0.00619286
R1767 VDD.n423 VDD.n331 0.00619286
R1768 VDD.n426 VDD.n329 0.00619286
R1769 VDD.n429 VDD.n327 0.00619286
R1770 VDD.n432 VDD.n325 0.00619286
R1771 VDD.n435 VDD.n434 0.00619286
R1772 VDD.n437 VDD.n434 0.00619286
R1773 VDD.n430 VDD.n325 0.00619286
R1774 VDD.n427 VDD.n327 0.00619286
R1775 VDD.n424 VDD.n329 0.00619286
R1776 VDD.n421 VDD.n331 0.00619286
R1777 VDD.n418 VDD.n333 0.00619286
R1778 VDD.n415 VDD.n335 0.00619286
R1779 VDD.n411 VDD.n337 0.00619286
R1780 VDD.n408 VDD.n339 0.00619286
R1781 VDD.n405 VDD.n341 0.00619286
R1782 VDD.n402 VDD.n343 0.00619286
R1783 VDD.n398 VDD.n345 0.00619286
R1784 VDD.n395 VDD.n347 0.00619286
R1785 VDD.n392 VDD.n349 0.00619286
R1786 VDD.n389 VDD.n351 0.00619286
R1787 VDD.n385 VDD.n353 0.00619286
R1788 VDD.n382 VDD.n355 0.00619286
R1789 VDD.n379 VDD.n357 0.00619286
R1790 VDD.n376 VDD.n359 0.00619286
R1791 VDD.n372 VDD.n361 0.00619286
R1792 VDD.n369 VDD.n363 0.00619286
R1793 VDD.n366 VDD.n365 0.00619286
R1794 VDD.n1165 VDD.n1 0.00619286
R1795 VDD.n1066 VDD.n1065 0.00619286
R1796 VDD.n1069 VDD.n1062 0.00619286
R1797 VDD.n1072 VDD.n1060 0.00619286
R1798 VDD.n1075 VDD.n1058 0.00619286
R1799 VDD.n1079 VDD.n216 0.00619286
R1800 VDD.n1082 VDD.n214 0.00619286
R1801 VDD.n1085 VDD.n212 0.00619286
R1802 VDD.n1088 VDD.n210 0.00619286
R1803 VDD.n1092 VDD.n206 0.00619286
R1804 VDD.n1095 VDD.n204 0.00619286
R1805 VDD.n1098 VDD.n202 0.00619286
R1806 VDD.n1101 VDD.n200 0.00619286
R1807 VDD.n1105 VDD.n196 0.00619286
R1808 VDD.n1108 VDD.n194 0.00619286
R1809 VDD.n1111 VDD.n192 0.00619286
R1810 VDD.n1114 VDD.n190 0.00619286
R1811 VDD.n1118 VDD.n186 0.00619286
R1812 VDD.n1121 VDD.n184 0.00619286
R1813 VDD.n1124 VDD.n182 0.00619286
R1814 VDD.n1127 VDD.n180 0.00619286
R1815 VDD.n1130 VDD.n178 0.00619286
R1816 VDD.n1133 VDD.n176 0.00619286
R1817 VDD.n1137 VDD.n173 0.00619286
R1818 VDD.n953 VDD.n952 0.00615278
R1819 VDD.n1134 VDD.n1133 0.00615278
R1820 VDD.n896 VDD.n895 0.00569444
R1821 VDD.n895 VDD.n894 0.00569444
R1822 VDD.n870 VDD.n869 0.00569444
R1823 VDD.n869 VDD.n868 0.00569444
R1824 VDD.n1077 VDD.n1076 0.00569444
R1825 VDD.n1076 VDD.n1075 0.00569444
R1826 VDD.n375 VDD.n374 0.00569444
R1827 VDD.n376 VDD.n375 0.00569444
R1828 VDD.n493 VDD.n481 0.00549055
R1829 VDD.n1013 VDD.n684 0.00549055
R1830 VDD.n977 VDD.n976 0.00549055
R1831 VDD.n663 VDD.n660 0.00549055
R1832 VDD.n460 VDD.n137 0.00549055
R1833 VDD.n295 VDD.n271 0.00549055
R1834 VDD.n1144 VDD.n1143 0.00549055
R1835 VDD.n245 VDD.n231 0.00549055
R1836 VDD.n956 VDD.n953 0.00523611
R1837 VDD.n1135 VDD.n1134 0.00523611
R1838 VDD.n811 VDD.n810 0.00508333
R1839 VDD.n438 VDD.n437 0.00508333
R1840 VDD.n509 VDD.n492 0.00486673
R1841 VDD.n692 VDD.n690 0.00486673
R1842 VDD.n974 VDD.n973 0.00486673
R1843 VDD.n659 VDD.n658 0.00486673
R1844 VDD.n451 VDD.n136 0.00486673
R1845 VDD.n294 VDD.n293 0.00486673
R1846 VDD.n157 VDD.n150 0.00486673
R1847 VDD.n247 VDD.n239 0.00486673
R1848 VDD.n508 VDD.n494 0.00465879
R1849 VDD.n665 VDD.n662 0.00465879
R1850 VDD.n443 VDD.n138 0.00465879
R1851 VDD.n255 VDD.n253 0.00465879
R1852 VDD.n909 VDD.n908 0.00447222
R1853 VDD.n856 VDD.n855 0.00447222
R1854 VDD.n1090 VDD.n1089 0.00447222
R1855 VDD.n389 VDD.n388 0.00447222
R1856 VDD.n314 VDD.n313 0.00442354
R1857 VDD.n882 VDD 0.00431944
R1858 VDD VDD.n0 0.00431944
R1859 VDD.n510 VDD.n491 0.00424291
R1860 VDD.n694 VDD.n693 0.00424291
R1861 VDD.n972 VDD.n971 0.00424291
R1862 VDD.n656 VDD.n655 0.00424291
R1863 VDD.n450 VDD.n135 0.00424291
R1864 VDD.n291 VDD.n272 0.00424291
R1865 VDD.n159 VDD.n156 0.00424291
R1866 VDD.n251 VDD.n250 0.00424291
R1867 VDD.n506 VDD.n495 0.00403497
R1868 VDD.n1017 VDD.n683 0.00403497
R1869 VDD.n982 VDD.n979 0.00403497
R1870 VDD.n668 VDD.n666 0.00403497
R1871 VDD.n452 VDD.n139 0.00403497
R1872 VDD.n299 VDD.n298 0.00403497
R1873 VDD.n1148 VDD.n1147 0.00403497
R1874 VDD.n256 VDD.n252 0.00403497
R1875 VDD.n1161 VDD.n145 0.00370796
R1876 VDD.n1041 VDD.n517 0.00369836
R1877 VDD.n511 VDD.n490 0.00361909
R1878 VDD.n696 VDD.n689 0.00361909
R1879 VDD.n969 VDD.n968 0.00361909
R1880 VDD.n654 VDD.n653 0.00361909
R1881 VDD.n449 VDD.n134 0.00361909
R1882 VDD.n290 VDD.n289 0.00361909
R1883 VDD.n161 VDD.n160 0.00361909
R1884 VDD.n248 VDD.n240 0.00361909
R1885 VDD.n505 VDD.n496 0.00341115
R1886 VDD.n1019 VDD.n1018 0.00341115
R1887 VDD.n985 VDD.n983 0.00341115
R1888 VDD.n670 VDD.n667 0.00341115
R1889 VDD.n453 VDD.n140 0.00341115
R1890 VDD.n301 VDD.n269 0.00341115
R1891 VDD.n1150 VDD.n148 0.00341115
R1892 VDD.n259 VDD.n237 0.00341115
R1893 VDD.n922 VDD.n921 0.00325
R1894 VDD.n843 VDD.n842 0.00325
R1895 VDD.n1103 VDD.n1102 0.00325
R1896 VDD.n402 VDD.n401 0.00325
R1897 VDD VDD.n881 0.00309722
R1898 VDD VDD.n1165 0.00309722
R1899 VDD.n512 VDD.n489 0.00278733
R1900 VDD.n504 VDD.n497 0.00278733
R1901 VDD.n1021 VDD.n682 0.00278733
R1902 VDD.n698 VDD.n697 0.00278733
R1903 VDD.n967 VDD.n966 0.00278733
R1904 VDD.n987 VDD.n984 0.00278733
R1905 VDD.n673 VDD.n671 0.00278733
R1906 VDD.n651 VDD.n650 0.00278733
R1907 VDD.n448 VDD.n133 0.00278733
R1908 VDD.n454 VDD.n141 0.00278733
R1909 VDD.n303 VDD.n302 0.00278733
R1910 VDD.n287 VDD.n273 0.00278733
R1911 VDD.n163 VDD.n155 0.00278733
R1912 VDD.n1152 VDD.n1151 0.00278733
R1913 VDD.n260 VDD.n257 0.00278733
R1914 VDD.n244 VDD.n243 0.00278733
R1915 VDD.n513 VDD.n488 0.00216352
R1916 VDD.n700 VDD.n688 0.00216352
R1917 VDD.n964 VDD.n962 0.00216352
R1918 VDD.n649 VDD.n648 0.00216352
R1919 VDD.n447 VDD.n132 0.00216352
R1920 VDD.n286 VDD.n285 0.00216352
R1921 VDD.n165 VDD.n164 0.00216352
R1922 VDD.n241 VDD.n234 0.00216352
R1923 VDD.n935 VDD.n934 0.00202778
R1924 VDD.n830 VDD.n829 0.00202778
R1925 VDD.n1116 VDD.n1115 0.00202778
R1926 VDD.n415 VDD.n414 0.00202778
R1927 VDD.n1162 VDD.n126 0.00198355
R1928 VDD.n503 VDD.n498 0.00195558
R1929 VDD.n1023 VDD.n1022 0.00195558
R1930 VDD.n989 VDD.n988 0.00195558
R1931 VDD.n675 VDD.n672 0.00195558
R1932 VDD.n455 VDD.n142 0.00195558
R1933 VDD.n305 VDD.n268 0.00195558
R1934 VDD.n1154 VDD.n147 0.00195558
R1935 VDD.n263 VDD.n236 0.00195558
R1936 VDD.n674 VDD.n632 0.00166667
R1937 VDD.n172 VDD.n106 0.00162501
R1938 VDD.n514 VDD.n487 0.0015397
R1939 VDD.n702 VDD.n701 0.0015397
R1940 VDD.n999 VDD.n998 0.0015397
R1941 VDD.n646 VDD.n645 0.0015397
R1942 VDD.n446 VDD.n131 0.0015397
R1943 VDD.n283 VDD.n274 0.0015397
R1944 VDD.n167 VDD.n154 0.0015397
R1945 VDD.n318 VDD.n317 0.0015397
R1946 VDD.n314 VDD.n107 0.00150496
R1947 VDD.n265 VDD.n107 0.00149502
R1948 VDD.n1139 VDD.n106 0.00137498
R1949 VDD.n1031 VDD.n632 0.00133332
R1950 VDD.n502 VDD.n499 0.00133176
R1951 VDD.n1025 VDD.n681 0.00133176
R1952 VDD.n997 VDD.n996 0.00133176
R1953 VDD.n1032 VDD.n676 0.00133176
R1954 VDD.n456 VDD.n143 0.00133176
R1955 VDD.n308 VDD.n306 0.00133176
R1956 VDD.n1156 VDD.n1155 0.00133176
R1957 VDD.n264 VDD.n261 0.00133176
R1958 VDD.n1027 VDD.t20 0.00124999
R1959 VDD.t81 VDD.n963 0.00124999
R1960 VDD.n310 VDD.t41 0.00124999
R1961 VDD.n1158 VDD.t61 0.00124999
R1962 VDD.n1162 VDD.n1161 0.00101639
R1963 VDD.n674 VDD.n633 0.001
R1964 VDD.n669 VDD.n634 0.001
R1965 VDD.n664 VDD.n635 0.001
R1966 VDD.n657 VDD.n636 0.001
R1967 VDD.n652 VDD.n637 0.001
R1968 VDD.n647 VDD.n638 0.001
R1969 VDD.n641 VDD.n639 0.001
R1970 VDD.n1039 VDD.n1037 0.001
R1971 VDD.n954 VDD.n610 0.001
R1972 VDD.n708 VDD.n608 0.001
R1973 VDD.n710 VDD.n606 0.001
R1974 VDD.n712 VDD.n604 0.001
R1975 VDD.n714 VDD.n602 0.001
R1976 VDD.n716 VDD.n600 0.001
R1977 VDD.n718 VDD.n598 0.001
R1978 VDD.n722 VDD.n596 0.001
R1979 VDD.n724 VDD.n594 0.001
R1980 VDD.n726 VDD.n592 0.001
R1981 VDD.n728 VDD.n590 0.001
R1982 VDD.n732 VDD.n588 0.001
R1983 VDD.n734 VDD.n586 0.001
R1984 VDD.n736 VDD.n584 0.001
R1985 VDD.n738 VDD.n582 0.001
R1986 VDD.n745 VDD.n580 0.001
R1987 VDD.n747 VDD.n578 0.001
R1988 VDD.n749 VDD.n576 0.001
R1989 VDD.n751 VDD.n574 0.001
R1990 VDD.n755 VDD.n572 0.001
R1991 VDD.n757 VDD.n570 0.001
R1992 VDD.n759 VDD.n568 0.001
R1993 VDD.n761 VDD.n566 0.001
R1994 VDD.n763 VDD.n564 0.001
R1995 VDD.n765 VDD.n562 0.001
R1996 VDD.n767 VDD.n560 0.001
R1997 VDD.n769 VDD.n558 0.001
R1998 VDD.n771 VDD.n556 0.001
R1999 VDD.n773 VDD.n554 0.001
R2000 VDD.n775 VDD.n552 0.001
R2001 VDD.n777 VDD.n550 0.001
R2002 VDD.n779 VDD.n548 0.001
R2003 VDD.n781 VDD.n546 0.001
R2004 VDD.n783 VDD.n544 0.001
R2005 VDD.n785 VDD.n542 0.001
R2006 VDD.n787 VDD.n540 0.001
R2007 VDD.n789 VDD.n538 0.001
R2008 VDD.n791 VDD.n536 0.001
R2009 VDD.n793 VDD.n534 0.001
R2010 VDD.n795 VDD.n532 0.001
R2011 VDD.n797 VDD.n530 0.001
R2012 VDD.n799 VDD.n528 0.001
R2013 VDD.n801 VDD.n526 0.001
R2014 VDD.n803 VDD.n524 0.001
R2015 VDD.n805 VDD.n523 0.001
R2016 VDD.n520 VDD.n518 0.001
R2017 VDD.n1041 VDD.n1040 0.001
R2018 VDD.n1007 VDD.n622 0.001
R2019 VDD.n1003 VDD.n623 0.001
R2020 VDD.n1000 VDD.n624 0.001
R2021 VDD.n965 VDD.n625 0.001
R2022 VDD.n970 VDD.n626 0.001
R2023 VDD.n975 VDD.n627 0.001
R2024 VDD.n981 VDD.n628 0.001
R2025 VDD.n986 VDD.n629 0.001
R2026 VDD.n995 VDD.n630 0.001
R2027 VDD.n990 VDD.n485 0.001
R2028 VDD.n1041 VDD.n485 0.001
R2029 VDD.n957 VDD.n611 0.001
R2030 VDD.n951 VDD.n609 0.001
R2031 VDD.n948 VDD.n607 0.001
R2032 VDD.n945 VDD.n605 0.001
R2033 VDD.n942 VDD.n603 0.001
R2034 VDD.n939 VDD.n601 0.001
R2035 VDD.n936 VDD.n599 0.001
R2036 VDD.n932 VDD.n597 0.001
R2037 VDD.n929 VDD.n595 0.001
R2038 VDD.n926 VDD.n593 0.001
R2039 VDD.n923 VDD.n591 0.001
R2040 VDD.n919 VDD.n589 0.001
R2041 VDD.n916 VDD.n587 0.001
R2042 VDD.n913 VDD.n585 0.001
R2043 VDD.n910 VDD.n583 0.001
R2044 VDD.n906 VDD.n581 0.001
R2045 VDD.n903 VDD.n579 0.001
R2046 VDD.n900 VDD.n577 0.001
R2047 VDD.n897 VDD.n575 0.001
R2048 VDD.n893 VDD.n573 0.001
R2049 VDD.n890 VDD.n571 0.001
R2050 VDD.n887 VDD.n569 0.001
R2051 VDD.n884 VDD.n567 0.001
R2052 VDD.n880 VDD.n565 0.001
R2053 VDD.n877 VDD.n563 0.001
R2054 VDD.n874 VDD.n561 0.001
R2055 VDD.n871 VDD.n559 0.001
R2056 VDD.n867 VDD.n557 0.001
R2057 VDD.n864 VDD.n555 0.001
R2058 VDD.n861 VDD.n553 0.001
R2059 VDD.n858 VDD.n551 0.001
R2060 VDD.n854 VDD.n549 0.001
R2061 VDD.n851 VDD.n547 0.001
R2062 VDD.n848 VDD.n545 0.001
R2063 VDD.n845 VDD.n543 0.001
R2064 VDD.n841 VDD.n541 0.001
R2065 VDD.n838 VDD.n539 0.001
R2066 VDD.n835 VDD.n537 0.001
R2067 VDD.n832 VDD.n535 0.001
R2068 VDD.n828 VDD.n533 0.001
R2069 VDD.n825 VDD.n531 0.001
R2070 VDD.n822 VDD.n529 0.001
R2071 VDD.n819 VDD.n527 0.001
R2072 VDD.n816 VDD.n525 0.001
R2073 VDD.n813 VDD.n522 0.001
R2074 VDD.n809 VDD.n521 0.001
R2075 VDD.n1038 VDD.n519 0.001
R2076 VDD.n678 VDD.n612 0.001
R2077 VDD.n679 VDD.n613 0.001
R2078 VDD.n1024 VDD.n614 0.001
R2079 VDD.n1020 VDD.n615 0.001
R2080 VDD.n1016 VDD.n616 0.001
R2081 VDD.n691 VDD.n617 0.001
R2082 VDD.n695 VDD.n618 0.001
R2083 VDD.n699 VDD.n619 0.001
R2084 VDD.n703 VDD.n620 0.001
R2085 VDD.n706 VDD.n621 0.001
R2086 VDD.n678 VDD.n631 0.001
R2087 VDD.n1031 VDD.n631 0.001
R2088 VDD.n679 VDD.n612 0.001
R2089 VDD.n1024 VDD.n613 0.001
R2090 VDD.n1020 VDD.n614 0.001
R2091 VDD.n1016 VDD.n615 0.001
R2092 VDD.n691 VDD.n616 0.001
R2093 VDD.n695 VDD.n617 0.001
R2094 VDD.n699 VDD.n618 0.001
R2095 VDD.n703 VDD.n619 0.001
R2096 VDD.n706 VDD.n620 0.001
R2097 VDD.n1009 VDD.n621 0.001
R2098 VDD.n1003 VDD.n622 0.001
R2099 VDD.n1000 VDD.n623 0.001
R2100 VDD.n965 VDD.n624 0.001
R2101 VDD.n970 VDD.n625 0.001
R2102 VDD.n975 VDD.n626 0.001
R2103 VDD.n981 VDD.n627 0.001
R2104 VDD.n986 VDD.n628 0.001
R2105 VDD.n995 VDD.n629 0.001
R2106 VDD.n990 VDD.n630 0.001
R2107 VDD.n1040 VDD.n518 0.001
R2108 VDD.n805 VDD.n520 0.001
R2109 VDD.n803 VDD.n523 0.001
R2110 VDD.n801 VDD.n524 0.001
R2111 VDD.n799 VDD.n526 0.001
R2112 VDD.n797 VDD.n528 0.001
R2113 VDD.n795 VDD.n530 0.001
R2114 VDD.n793 VDD.n532 0.001
R2115 VDD.n791 VDD.n534 0.001
R2116 VDD.n789 VDD.n536 0.001
R2117 VDD.n787 VDD.n538 0.001
R2118 VDD.n785 VDD.n540 0.001
R2119 VDD.n783 VDD.n542 0.001
R2120 VDD.n781 VDD.n544 0.001
R2121 VDD.n779 VDD.n546 0.001
R2122 VDD.n777 VDD.n548 0.001
R2123 VDD.n775 VDD.n550 0.001
R2124 VDD.n773 VDD.n552 0.001
R2125 VDD.n771 VDD.n554 0.001
R2126 VDD.n769 VDD.n556 0.001
R2127 VDD.n767 VDD.n558 0.001
R2128 VDD.n765 VDD.n560 0.001
R2129 VDD.n763 VDD.n562 0.001
R2130 VDD.n761 VDD.n564 0.001
R2131 VDD.n759 VDD.n566 0.001
R2132 VDD.n757 VDD.n568 0.001
R2133 VDD.n755 VDD.n570 0.001
R2134 VDD.n751 VDD.n572 0.001
R2135 VDD.n749 VDD.n574 0.001
R2136 VDD.n747 VDD.n576 0.001
R2137 VDD.n745 VDD.n578 0.001
R2138 VDD.n738 VDD.n580 0.001
R2139 VDD.n736 VDD.n582 0.001
R2140 VDD.n734 VDD.n584 0.001
R2141 VDD.n732 VDD.n586 0.001
R2142 VDD.n728 VDD.n588 0.001
R2143 VDD.n726 VDD.n590 0.001
R2144 VDD.n724 VDD.n592 0.001
R2145 VDD.n722 VDD.n594 0.001
R2146 VDD.n718 VDD.n596 0.001
R2147 VDD.n716 VDD.n598 0.001
R2148 VDD.n714 VDD.n600 0.001
R2149 VDD.n712 VDD.n602 0.001
R2150 VDD.n710 VDD.n604 0.001
R2151 VDD.n708 VDD.n606 0.001
R2152 VDD.n954 VDD.n608 0.001
R2153 VDD.n1007 VDD.n610 0.001
R2154 VDD.n1039 VDD.n1038 0.001
R2155 VDD.n809 VDD.n519 0.001
R2156 VDD.n813 VDD.n521 0.001
R2157 VDD.n816 VDD.n522 0.001
R2158 VDD.n819 VDD.n525 0.001
R2159 VDD.n822 VDD.n527 0.001
R2160 VDD.n825 VDD.n529 0.001
R2161 VDD.n828 VDD.n531 0.001
R2162 VDD.n832 VDD.n533 0.001
R2163 VDD.n835 VDD.n535 0.001
R2164 VDD.n838 VDD.n537 0.001
R2165 VDD.n841 VDD.n539 0.001
R2166 VDD.n845 VDD.n541 0.001
R2167 VDD.n848 VDD.n543 0.001
R2168 VDD.n851 VDD.n545 0.001
R2169 VDD.n854 VDD.n547 0.001
R2170 VDD.n858 VDD.n549 0.001
R2171 VDD.n861 VDD.n551 0.001
R2172 VDD.n864 VDD.n553 0.001
R2173 VDD.n867 VDD.n555 0.001
R2174 VDD.n871 VDD.n557 0.001
R2175 VDD.n874 VDD.n559 0.001
R2176 VDD.n877 VDD.n561 0.001
R2177 VDD.n880 VDD.n563 0.001
R2178 VDD.n884 VDD.n565 0.001
R2179 VDD.n887 VDD.n567 0.001
R2180 VDD.n890 VDD.n569 0.001
R2181 VDD.n893 VDD.n571 0.001
R2182 VDD.n897 VDD.n573 0.001
R2183 VDD.n900 VDD.n575 0.001
R2184 VDD.n903 VDD.n577 0.001
R2185 VDD.n906 VDD.n579 0.001
R2186 VDD.n910 VDD.n581 0.001
R2187 VDD.n913 VDD.n583 0.001
R2188 VDD.n916 VDD.n585 0.001
R2189 VDD.n919 VDD.n587 0.001
R2190 VDD.n923 VDD.n589 0.001
R2191 VDD.n926 VDD.n591 0.001
R2192 VDD.n929 VDD.n593 0.001
R2193 VDD.n932 VDD.n595 0.001
R2194 VDD.n936 VDD.n597 0.001
R2195 VDD.n939 VDD.n599 0.001
R2196 VDD.n942 VDD.n601 0.001
R2197 VDD.n945 VDD.n603 0.001
R2198 VDD.n948 VDD.n605 0.001
R2199 VDD.n951 VDD.n607 0.001
R2200 VDD.n957 VDD.n609 0.001
R2201 VDD.n1009 VDD.n611 0.001
R2202 VDD.n1037 VDD.n639 0.001
R2203 VDD.n641 VDD.n638 0.001
R2204 VDD.n647 VDD.n637 0.001
R2205 VDD.n652 VDD.n636 0.001
R2206 VDD.n657 VDD.n635 0.001
R2207 VDD.n664 VDD.n634 0.001
R2208 VDD.n669 VDD.n633 0.001
R2209 VDD.n265 VDD.n108 0.001
R2210 VDD.n307 VDD.n109 0.001
R2211 VDD.n304 VDD.n110 0.001
R2212 VDD.n300 VDD.n111 0.001
R2213 VDD.n296 VDD.n112 0.001
R2214 VDD.n292 VDD.n113 0.001
R2215 VDD.n288 VDD.n114 0.001
R2216 VDD.n284 VDD.n115 0.001
R2217 VDD.n275 VDD.n116 0.001
R2218 VDD.n278 VDD.n117 0.001
R2219 VDD.n172 VDD.n6 0.001
R2220 VDD.n175 VDD.n9 0.001
R2221 VDD.n177 VDD.n10 0.001
R2222 VDD.n179 VDD.n12 0.001
R2223 VDD.n181 VDD.n14 0.001
R2224 VDD.n183 VDD.n16 0.001
R2225 VDD.n185 VDD.n18 0.001
R2226 VDD.n189 VDD.n20 0.001
R2227 VDD.n191 VDD.n22 0.001
R2228 VDD.n193 VDD.n24 0.001
R2229 VDD.n195 VDD.n26 0.001
R2230 VDD.n199 VDD.n28 0.001
R2231 VDD.n201 VDD.n30 0.001
R2232 VDD.n203 VDD.n32 0.001
R2233 VDD.n205 VDD.n34 0.001
R2234 VDD.n209 VDD.n36 0.001
R2235 VDD.n211 VDD.n38 0.001
R2236 VDD.n213 VDD.n40 0.001
R2237 VDD.n215 VDD.n42 0.001
R2238 VDD.n1057 VDD.n44 0.001
R2239 VDD.n1059 VDD.n46 0.001
R2240 VDD.n1061 VDD.n48 0.001
R2241 VDD.n1064 VDD.n50 0.001
R2242 VDD.n52 VDD.n51 0.001
R2243 VDD.n364 VDD.n53 0.001
R2244 VDD.n362 VDD.n55 0.001
R2245 VDD.n360 VDD.n57 0.001
R2246 VDD.n358 VDD.n59 0.001
R2247 VDD.n356 VDD.n61 0.001
R2248 VDD.n354 VDD.n63 0.001
R2249 VDD.n352 VDD.n65 0.001
R2250 VDD.n350 VDD.n67 0.001
R2251 VDD.n348 VDD.n69 0.001
R2252 VDD.n346 VDD.n71 0.001
R2253 VDD.n344 VDD.n73 0.001
R2254 VDD.n342 VDD.n75 0.001
R2255 VDD.n340 VDD.n77 0.001
R2256 VDD.n338 VDD.n79 0.001
R2257 VDD.n336 VDD.n81 0.001
R2258 VDD.n334 VDD.n83 0.001
R2259 VDD.n332 VDD.n85 0.001
R2260 VDD.n330 VDD.n87 0.001
R2261 VDD.n328 VDD.n89 0.001
R2262 VDD.n326 VDD.n91 0.001
R2263 VDD.n324 VDD.n93 0.001
R2264 VDD.n433 VDD.n95 0.001
R2265 VDD.n1139 VDD.n118 0.001
R2266 VDD.n153 VDD.n119 0.001
R2267 VDD.n166 VDD.n120 0.001
R2268 VDD.n162 VDD.n121 0.001
R2269 VDD.n158 VDD.n122 0.001
R2270 VDD.n1145 VDD.n123 0.001
R2271 VDD.n1149 VDD.n124 0.001
R2272 VDD.n1153 VDD.n125 0.001
R2273 VDD.n171 VDD.n5 0.001
R2274 VDD.n1136 VDD.n7 0.001
R2275 VDD.n1132 VDD.n8 0.001
R2276 VDD.n1129 VDD.n11 0.001
R2277 VDD.n1126 VDD.n13 0.001
R2278 VDD.n1123 VDD.n15 0.001
R2279 VDD.n1120 VDD.n17 0.001
R2280 VDD.n1117 VDD.n19 0.001
R2281 VDD.n1113 VDD.n21 0.001
R2282 VDD.n1110 VDD.n23 0.001
R2283 VDD.n1107 VDD.n25 0.001
R2284 VDD.n1104 VDD.n27 0.001
R2285 VDD.n1100 VDD.n29 0.001
R2286 VDD.n1097 VDD.n31 0.001
R2287 VDD.n1094 VDD.n33 0.001
R2288 VDD.n1091 VDD.n35 0.001
R2289 VDD.n1087 VDD.n37 0.001
R2290 VDD.n1084 VDD.n39 0.001
R2291 VDD.n1081 VDD.n41 0.001
R2292 VDD.n1078 VDD.n43 0.001
R2293 VDD.n1074 VDD.n45 0.001
R2294 VDD.n1071 VDD.n47 0.001
R2295 VDD.n1068 VDD.n49 0.001
R2296 VDD.n1163 VDD.n4 0.001
R2297 VDD.n1164 VDD.n3 0.001
R2298 VDD.n367 VDD.n54 0.001
R2299 VDD.n370 VDD.n56 0.001
R2300 VDD.n373 VDD.n58 0.001
R2301 VDD.n377 VDD.n60 0.001
R2302 VDD.n380 VDD.n62 0.001
R2303 VDD.n383 VDD.n64 0.001
R2304 VDD.n386 VDD.n66 0.001
R2305 VDD.n390 VDD.n68 0.001
R2306 VDD.n393 VDD.n70 0.001
R2307 VDD.n396 VDD.n72 0.001
R2308 VDD.n399 VDD.n74 0.001
R2309 VDD.n403 VDD.n76 0.001
R2310 VDD.n406 VDD.n78 0.001
R2311 VDD.n409 VDD.n80 0.001
R2312 VDD.n412 VDD.n82 0.001
R2313 VDD.n416 VDD.n84 0.001
R2314 VDD.n419 VDD.n86 0.001
R2315 VDD.n422 VDD.n88 0.001
R2316 VDD.n425 VDD.n90 0.001
R2317 VDD.n428 VDD.n92 0.001
R2318 VDD.n431 VDD.n94 0.001
R2319 VDD.n436 VDD.n96 0.001
R2320 VDD.n314 VDD.n97 0.001
R2321 VDD.n262 VDD.n98 0.001
R2322 VDD.n258 VDD.n99 0.001
R2323 VDD.n254 VDD.n100 0.001
R2324 VDD.n246 VDD.n101 0.001
R2325 VDD.n249 VDD.n102 0.001
R2326 VDD.n242 VDD.n103 0.001
R2327 VDD.n319 VDD.n104 0.001
R2328 VDD.n322 VDD.n105 0.001
R2329 VDD.n307 VDD.n108 0.001
R2330 VDD.n304 VDD.n109 0.001
R2331 VDD.n300 VDD.n110 0.001
R2332 VDD.n296 VDD.n111 0.001
R2333 VDD.n292 VDD.n112 0.001
R2334 VDD.n288 VDD.n113 0.001
R2335 VDD.n284 VDD.n114 0.001
R2336 VDD.n275 VDD.n115 0.001
R2337 VDD.n278 VDD.n116 0.001
R2338 VDD.n153 VDD.n118 0.001
R2339 VDD.n166 VDD.n119 0.001
R2340 VDD.n162 VDD.n120 0.001
R2341 VDD.n158 VDD.n121 0.001
R2342 VDD.n1145 VDD.n122 0.001
R2343 VDD.n1149 VDD.n123 0.001
R2344 VDD.n1153 VDD.n124 0.001
R2345 VDD.n126 VDD.n125 0.001
R2346 VDD.n1161 VDD.n95 0.001
R2347 VDD.n433 VDD.n93 0.001
R2348 VDD.n324 VDD.n91 0.001
R2349 VDD.n326 VDD.n89 0.001
R2350 VDD.n328 VDD.n87 0.001
R2351 VDD.n330 VDD.n85 0.001
R2352 VDD.n332 VDD.n83 0.001
R2353 VDD.n334 VDD.n81 0.001
R2354 VDD.n336 VDD.n79 0.001
R2355 VDD.n338 VDD.n77 0.001
R2356 VDD.n340 VDD.n75 0.001
R2357 VDD.n342 VDD.n73 0.001
R2358 VDD.n344 VDD.n71 0.001
R2359 VDD.n346 VDD.n69 0.001
R2360 VDD.n348 VDD.n67 0.001
R2361 VDD.n350 VDD.n65 0.001
R2362 VDD.n352 VDD.n63 0.001
R2363 VDD.n354 VDD.n61 0.001
R2364 VDD.n356 VDD.n59 0.001
R2365 VDD.n358 VDD.n57 0.001
R2366 VDD.n360 VDD.n55 0.001
R2367 VDD.n362 VDD.n53 0.001
R2368 VDD.n364 VDD.n52 0.001
R2369 VDD.n51 VDD.n50 0.001
R2370 VDD.n1064 VDD.n48 0.001
R2371 VDD.n1061 VDD.n46 0.001
R2372 VDD.n1059 VDD.n44 0.001
R2373 VDD.n1057 VDD.n42 0.001
R2374 VDD.n215 VDD.n40 0.001
R2375 VDD.n213 VDD.n38 0.001
R2376 VDD.n211 VDD.n36 0.001
R2377 VDD.n209 VDD.n34 0.001
R2378 VDD.n205 VDD.n32 0.001
R2379 VDD.n203 VDD.n30 0.001
R2380 VDD.n201 VDD.n28 0.001
R2381 VDD.n199 VDD.n26 0.001
R2382 VDD.n195 VDD.n24 0.001
R2383 VDD.n193 VDD.n22 0.001
R2384 VDD.n191 VDD.n20 0.001
R2385 VDD.n189 VDD.n18 0.001
R2386 VDD.n185 VDD.n16 0.001
R2387 VDD.n183 VDD.n14 0.001
R2388 VDD.n181 VDD.n12 0.001
R2389 VDD.n179 VDD.n10 0.001
R2390 VDD.n177 VDD.n9 0.001
R2391 VDD.n175 VDD.n6 0.001
R2392 VDD.n439 VDD.n96 0.001
R2393 VDD.n436 VDD.n94 0.001
R2394 VDD.n431 VDD.n92 0.001
R2395 VDD.n428 VDD.n90 0.001
R2396 VDD.n425 VDD.n88 0.001
R2397 VDD.n422 VDD.n86 0.001
R2398 VDD.n419 VDD.n84 0.001
R2399 VDD.n416 VDD.n82 0.001
R2400 VDD.n412 VDD.n80 0.001
R2401 VDD.n409 VDD.n78 0.001
R2402 VDD.n406 VDD.n76 0.001
R2403 VDD.n403 VDD.n74 0.001
R2404 VDD.n399 VDD.n72 0.001
R2405 VDD.n396 VDD.n70 0.001
R2406 VDD.n393 VDD.n68 0.001
R2407 VDD.n390 VDD.n66 0.001
R2408 VDD.n386 VDD.n64 0.001
R2409 VDD.n383 VDD.n62 0.001
R2410 VDD.n380 VDD.n60 0.001
R2411 VDD.n377 VDD.n58 0.001
R2412 VDD.n373 VDD.n56 0.001
R2413 VDD.n370 VDD.n54 0.001
R2414 VDD.n367 VDD.n3 0.001
R2415 VDD.n1164 VDD.n1163 0.001
R2416 VDD.n49 VDD.n4 0.001
R2417 VDD.n1068 VDD.n47 0.001
R2418 VDD.n1071 VDD.n45 0.001
R2419 VDD.n1074 VDD.n43 0.001
R2420 VDD.n1078 VDD.n41 0.001
R2421 VDD.n1081 VDD.n39 0.001
R2422 VDD.n1084 VDD.n37 0.001
R2423 VDD.n1087 VDD.n35 0.001
R2424 VDD.n1091 VDD.n33 0.001
R2425 VDD.n1094 VDD.n31 0.001
R2426 VDD.n1097 VDD.n29 0.001
R2427 VDD.n1100 VDD.n27 0.001
R2428 VDD.n1104 VDD.n25 0.001
R2429 VDD.n1107 VDD.n23 0.001
R2430 VDD.n1110 VDD.n21 0.001
R2431 VDD.n1113 VDD.n19 0.001
R2432 VDD.n1117 VDD.n17 0.001
R2433 VDD.n1120 VDD.n15 0.001
R2434 VDD.n1123 VDD.n13 0.001
R2435 VDD.n1126 VDD.n11 0.001
R2436 VDD.n1129 VDD.n8 0.001
R2437 VDD.n1132 VDD.n7 0.001
R2438 VDD.n1136 VDD.n5 0.001
R2439 VDD.n171 VDD.n117 0.001
R2440 VDD.n439 VDD.n105 0.001
R2441 VDD.n322 VDD.n104 0.001
R2442 VDD.n319 VDD.n103 0.001
R2443 VDD.n242 VDD.n102 0.001
R2444 VDD.n249 VDD.n101 0.001
R2445 VDD.n246 VDD.n100 0.001
R2446 VDD.n254 VDD.n99 0.001
R2447 VDD.n258 VDD.n98 0.001
R2448 VDD.n262 VDD.n97 0.001
R2449 VDD.n704 VDD.n687 0.000915879
R2450 VDD.n705 VDD.n686 0.000915879
R2451 VDD.n1002 VDD.n960 0.000915879
R2452 VDD.n1001 VDD.n961 0.000915879
R2453 VDD.n311 VDD.n266 0.000915879
R2454 VDD.n1160 VDD.n1159 0.000915879
R2455 VDD.n320 VDD.n233 0.000915879
R2456 VDD.n321 VDD.n232 0.000915879
R2457 VDD.n309 VDD.n267 0.00070794
R2458 VDD.n1157 VDD.n146 0.00070794
R2459 VSS.n585 VSS.n453 6777.49
R2460 VSS.n627 VSS.n132 6777.49
R2461 VSS.n585 VSS.n584 6775.82
R2462 VSS.n628 VSS.n627 6775.82
R2463 VSS.n589 VSS.n585 1580.41
R2464 VSS.n627 VSS.n626 1580.41
R2465 VSS.t83 VSS.n145 88.7251
R2466 VSS.t55 VSS.n201 88.7251
R2467 VSS.n148 VSS.t82 83.1798
R2468 VSS.t56 VSS.n198 83.1798
R2469 VSS.n151 VSS.t80 77.6345
R2470 VSS.t58 VSS.n195 77.6345
R2471 VSS.t32 VSS.n132 72.1333
R2472 VSS.n528 VSS.t35 72.1157
R2473 VSS.n154 VSS.t79 72.0892
R2474 VSS.t59 VSS.n192 72.0892
R2475 VSS.t29 VSS.n527 68.3206
R2476 VSS.n500 VSS.t0 68.316
R2477 VSS.n157 VSS.t77 66.5439
R2478 VSS.t61 VSS.n189 66.5439
R2479 VSS.t28 VSS.n525 64.5255
R2480 VSS.n501 VSS.t2 64.5209
R2481 VSS.n160 VSS.t76 60.9987
R2482 VSS.t62 VSS.n186 60.9987
R2483 VSS.t26 VSS.n524 60.7305
R2484 VSS.n503 VSS.t4 60.7259
R2485 VSS.n73 VSS.t112 60.7216
R2486 VSS.t84 VSS.n40 60.7216
R2487 VSS.t25 VSS.n522 56.9354
R2488 VSS.n504 VSS.t5 56.9308
R2489 VSS.n72 VSS.t111 56.9265
R2490 VSS.t85 VSS.n38 56.9265
R2491 VSS.n163 VSS.t74 55.4534
R2492 VSS.t70 VSS.n171 55.4534
R2493 VSS.n175 VSS.t68 55.4534
R2494 VSS.t64 VSS.n183 55.4534
R2495 VSS.t23 VSS.n521 53.1403
R2496 VSS.n506 VSS.t7 53.1357
R2497 VSS.n70 VSS.t109 53.1314
R2498 VSS.t87 VSS.n36 53.1314
R2499 VSS.n166 VSS.t73 49.9081
R2500 VSS.t71 VSS.n168 49.9081
R2501 VSS.n178 VSS.t67 49.9081
R2502 VSS.t65 VSS.n180 49.9081
R2503 VSS.t22 VSS.n517 49.3453
R2504 VSS.n507 VSS.t8 49.3407
R2505 VSS.n69 VSS.t108 49.3364
R2506 VSS.t88 VSS.n34 49.3364
R2507 VSS.t14 VSS.n512 45.5502
R2508 VSS.t20 VSS.n516 45.5502
R2509 VSS.n509 VSS.t10 45.5456
R2510 VSS.n514 VSS.t16 45.5456
R2511 VSS.n67 VSS.t106 45.5413
R2512 VSS.t90 VSS.n32 45.5413
R2513 VSS.t73 VSS.n165 44.3628
R2514 VSS.n169 VSS.t71 44.3628
R2515 VSS.t67 VSS.n177 44.3628
R2516 VSS.n181 VSS.t65 44.3628
R2517 VSS.t13 VSS.n510 41.7551
R2518 VSS.t19 VSS.n515 41.7551
R2519 VSS.n510 VSS.t11 41.7505
R2520 VSS.n515 VSS.t17 41.7505
R2521 VSS.n66 VSS.t105 41.7462
R2522 VSS.t91 VSS.n30 41.7462
R2523 VSS.t74 VSS.n162 38.8175
R2524 VSS.n172 VSS.t70 38.8175
R2525 VSS.t68 VSS.n174 38.8175
R2526 VSS.n184 VSS.t64 38.8175
R2527 VSS.t11 VSS.n509 37.9601
R2528 VSS.t17 VSS.n514 37.9601
R2529 VSS.n512 VSS.t13 37.9555
R2530 VSS.n516 VSS.t19 37.9555
R2531 VSS.n64 VSS.t103 37.9512
R2532 VSS.t99 VSS.n20 37.9512
R2533 VSS.n59 VSS.t97 37.9512
R2534 VSS.t93 VSS.n28 37.9512
R2535 VSS.t16 VSS.n513 34.1682
R2536 VSS.t10 VSS.n507 34.165
R2537 VSS.n513 VSS.t14 34.1635
R2538 VSS.n517 VSS.t20 34.1604
R2539 VSS.n63 VSS.t102 34.1561
R2540 VSS.t100 VSS.n18 34.1561
R2541 VSS.n58 VSS.t96 34.1561
R2542 VSS.t94 VSS.n26 34.1561
R2543 VSS.t76 VSS.n159 33.2722
R2544 VSS.n187 VSS.t62 33.2722
R2545 VSS.t8 VSS.n506 30.3699
R2546 VSS.n521 VSS.t22 30.3653
R2547 VSS.t102 VSS.n16 30.361
R2548 VSS.n61 VSS.t100 30.361
R2549 VSS.t96 VSS.n24 30.361
R2550 VSS.n56 VSS.t94 30.361
R2551 VSS.t77 VSS.n156 27.7269
R2552 VSS.n190 VSS.t61 27.7269
R2553 VSS.t7 VSS.n504 26.5749
R2554 VSS.n522 VSS.t23 26.5703
R2555 VSS.t103 VSS.n14 26.566
R2556 VSS.n60 VSS.t99 26.566
R2557 VSS.t97 VSS.n22 26.566
R2558 VSS.n55 VSS.t93 26.566
R2559 VSS.n105 VSS.n21 23.0507
R2560 VSS.n104 VSS.n21 23.0507
R2561 VSS.t5 VSS.n503 22.7798
R2562 VSS.n524 VSS.t25 22.7752
R2563 VSS.t105 VSS.n12 22.7709
R2564 VSS.n53 VSS.t91 22.7709
R2565 VSS.n126 VSS.n76 22.2674
R2566 VSS.n125 VSS.n77 22.2674
R2567 VSS.n635 VSS.n79 22.2674
R2568 VSS.n123 VSS.n3 22.2674
R2569 VSS.n121 VSS.n5 22.2674
R2570 VSS.n119 VSS.n7 22.2674
R2571 VSS.n117 VSS.n9 22.2674
R2572 VSS.n115 VSS.n11 22.2674
R2573 VSS.n113 VSS.n13 22.2674
R2574 VSS.n111 VSS.n15 22.2674
R2575 VSS.n109 VSS.n17 22.2674
R2576 VSS.n107 VSS.n19 22.2674
R2577 VSS.n103 VSS.n23 22.2674
R2578 VSS.n101 VSS.n25 22.2674
R2579 VSS.n99 VSS.n27 22.2674
R2580 VSS.n97 VSS.n29 22.2674
R2581 VSS.n95 VSS.n31 22.2674
R2582 VSS.n93 VSS.n33 22.2674
R2583 VSS.n91 VSS.n35 22.2674
R2584 VSS.n89 VSS.n37 22.2674
R2585 VSS.n87 VSS.n39 22.2674
R2586 VSS.n85 VSS.n45 22.2674
R2587 VSS.n84 VSS.n45 22.2674
R2588 VSS.n84 VSS.n44 22.2674
R2589 VSS.n83 VSS.n43 22.2674
R2590 VSS.n82 VSS.n43 22.2674
R2591 VSS.n82 VSS.n42 22.2674
R2592 VSS.n80 VSS.n42 22.2674
R2593 VSS.n79 VSS.n78 22.2674
R2594 VSS.n124 VSS.n77 22.2674
R2595 VSS.n125 VSS.n76 22.2674
R2596 VSS.n86 VSS.n39 22.2674
R2597 VSS.n88 VSS.n37 22.2674
R2598 VSS.n90 VSS.n35 22.2674
R2599 VSS.n92 VSS.n33 22.2674
R2600 VSS.n94 VSS.n31 22.2674
R2601 VSS.n96 VSS.n29 22.2674
R2602 VSS.n98 VSS.n27 22.2674
R2603 VSS.n100 VSS.n25 22.2674
R2604 VSS.n102 VSS.n23 22.2674
R2605 VSS.n106 VSS.n19 22.2674
R2606 VSS.n108 VSS.n17 22.2674
R2607 VSS.n110 VSS.n15 22.2674
R2608 VSS.n112 VSS.n13 22.2674
R2609 VSS.n114 VSS.n11 22.2674
R2610 VSS.n116 VSS.n9 22.2674
R2611 VSS.n118 VSS.n7 22.2674
R2612 VSS.n120 VSS.n5 22.2674
R2613 VSS.n122 VSS.n3 22.2674
R2614 VSS.n635 VSS.n634 22.2674
R2615 VSS.t79 VSS.n153 22.1816
R2616 VSS.n193 VSS.t59 22.1816
R2617 VSS.t4 VSS.n501 18.9847
R2618 VSS.n525 VSS.t26 18.9801
R2619 VSS.t106 VSS.n10 18.9758
R2620 VSS.n52 VSS.t90 18.9758
R2621 VSS.n563 VSS.t33 17.0005
R2622 VSS.n562 VSS.t33 17.0005
R2623 VSS.n551 VSS.t33 17.0005
R2624 VSS.t1 VSS.n562 17.0005
R2625 VSS.t1 VSS.n551 17.0005
R2626 VSS.n563 VSS.t1 17.0005
R2627 VSS.n565 VSS.n530 17.0005
R2628 VSS.n565 VSS.n531 17.0005
R2629 VSS.n565 VSS.n532 17.0005
R2630 VSS.n565 VSS.n548 17.0005
R2631 VSS.n565 VSS.n549 17.0005
R2632 VSS.n565 VSS.n564 17.0005
R2633 VSS.n624 VSS.n202 17.0005
R2634 VSS.n624 VSS.n201 17.0005
R2635 VSS.n624 VSS.n199 17.0005
R2636 VSS.n624 VSS.n198 17.0005
R2637 VSS.n624 VSS.n196 17.0005
R2638 VSS.n624 VSS.n195 17.0005
R2639 VSS.n624 VSS.n193 17.0005
R2640 VSS.n624 VSS.n192 17.0005
R2641 VSS.n624 VSS.n190 17.0005
R2642 VSS.n624 VSS.n189 17.0005
R2643 VSS.n624 VSS.n187 17.0005
R2644 VSS.n624 VSS.n186 17.0005
R2645 VSS.n624 VSS.n184 17.0005
R2646 VSS.n624 VSS.n183 17.0005
R2647 VSS.n624 VSS.n181 17.0005
R2648 VSS.n624 VSS.n180 17.0005
R2649 VSS.n624 VSS.n178 17.0005
R2650 VSS.n624 VSS.n177 17.0005
R2651 VSS.n624 VSS.n175 17.0005
R2652 VSS.n624 VSS.n174 17.0005
R2653 VSS.n624 VSS.n172 17.0005
R2654 VSS.n624 VSS.n171 17.0005
R2655 VSS.n624 VSS.n169 17.0005
R2656 VSS.n624 VSS.n168 17.0005
R2657 VSS.n624 VSS.n166 17.0005
R2658 VSS.n624 VSS.n165 17.0005
R2659 VSS.n624 VSS.n163 17.0005
R2660 VSS.n624 VSS.n162 17.0005
R2661 VSS.n624 VSS.n160 17.0005
R2662 VSS.n624 VSS.n159 17.0005
R2663 VSS.n624 VSS.n157 17.0005
R2664 VSS.n624 VSS.n156 17.0005
R2665 VSS.n624 VSS.n154 17.0005
R2666 VSS.n624 VSS.n153 17.0005
R2667 VSS.n624 VSS.n151 17.0005
R2668 VSS.n624 VSS.n150 17.0005
R2669 VSS.n624 VSS.n148 17.0005
R2670 VSS.n624 VSS.n147 17.0005
R2671 VSS.n624 VSS.n145 17.0005
R2672 VSS.n624 VSS.n140 17.0005
R2673 VSS.n621 VSS.n620 17.0005
R2674 VSS.n621 VSS.n280 17.0005
R2675 VSS.n622 VSS.n621 17.0005
R2676 VSS.n621 VSS.n206 17.0005
R2677 VSS.n621 VSS.n282 17.0005
R2678 VSS.n621 VSS.n276 17.0005
R2679 VSS.n621 VSS.n275 17.0005
R2680 VSS.n621 VSS.t37 17.0005
R2681 VSS.n621 VSS.n273 17.0005
R2682 VSS.n621 VSS.n283 17.0005
R2683 VSS.n621 VSS.n271 17.0005
R2684 VSS.n621 VSS.n202 17.0005
R2685 VSS.n621 VSS.n201 17.0005
R2686 VSS.n621 VSS.n284 17.0005
R2687 VSS.n621 VSS.n268 17.0005
R2688 VSS.n621 VSS.n199 17.0005
R2689 VSS.n621 VSS.n198 17.0005
R2690 VSS.n621 VSS.n285 17.0005
R2691 VSS.n621 VSS.n286 17.0005
R2692 VSS.n621 VSS.n266 17.0005
R2693 VSS.n621 VSS.n265 17.0005
R2694 VSS.n621 VSS.n196 17.0005
R2695 VSS.n621 VSS.n195 17.0005
R2696 VSS.n621 VSS.n287 17.0005
R2697 VSS.n621 VSS.n262 17.0005
R2698 VSS.n621 VSS.n193 17.0005
R2699 VSS.n621 VSS.n192 17.0005
R2700 VSS.n621 VSS.n288 17.0005
R2701 VSS.n621 VSS.n289 17.0005
R2702 VSS.n621 VSS.n260 17.0005
R2703 VSS.n621 VSS.n259 17.0005
R2704 VSS.n621 VSS.n190 17.0005
R2705 VSS.n621 VSS.n189 17.0005
R2706 VSS.n621 VSS.n290 17.0005
R2707 VSS.n621 VSS.n256 17.0005
R2708 VSS.n621 VSS.n187 17.0005
R2709 VSS.n621 VSS.n186 17.0005
R2710 VSS.n621 VSS.n291 17.0005
R2711 VSS.n621 VSS.n292 17.0005
R2712 VSS.n621 VSS.n254 17.0005
R2713 VSS.n621 VSS.n253 17.0005
R2714 VSS.n621 VSS.n184 17.0005
R2715 VSS.n621 VSS.n183 17.0005
R2716 VSS.n621 VSS.n293 17.0005
R2717 VSS.n621 VSS.n250 17.0005
R2718 VSS.n621 VSS.n181 17.0005
R2719 VSS.n621 VSS.n180 17.0005
R2720 VSS.n621 VSS.n294 17.0005
R2721 VSS.n621 VSS.n295 17.0005
R2722 VSS.n621 VSS.n248 17.0005
R2723 VSS.n621 VSS.n247 17.0005
R2724 VSS.n621 VSS.n178 17.0005
R2725 VSS.n621 VSS.n177 17.0005
R2726 VSS.n621 VSS.n296 17.0005
R2727 VSS.n621 VSS.n244 17.0005
R2728 VSS.n621 VSS.n175 17.0005
R2729 VSS.n621 VSS.n174 17.0005
R2730 VSS.n621 VSS.n297 17.0005
R2731 VSS.n621 VSS.n298 17.0005
R2732 VSS.n621 VSS.n242 17.0005
R2733 VSS.n621 VSS.n241 17.0005
R2734 VSS.n621 VSS.n172 17.0005
R2735 VSS.n621 VSS.n171 17.0005
R2736 VSS.n621 VSS.n299 17.0005
R2737 VSS.n621 VSS.n238 17.0005
R2738 VSS.n621 VSS.n169 17.0005
R2739 VSS.n621 VSS.n168 17.0005
R2740 VSS.n621 VSS.n300 17.0005
R2741 VSS.n621 VSS.n301 17.0005
R2742 VSS.n621 VSS.n236 17.0005
R2743 VSS.n621 VSS.n235 17.0005
R2744 VSS.n621 VSS.n166 17.0005
R2745 VSS.n621 VSS.n165 17.0005
R2746 VSS.n621 VSS.n302 17.0005
R2747 VSS.n621 VSS.n232 17.0005
R2748 VSS.n621 VSS.n163 17.0005
R2749 VSS.n621 VSS.n162 17.0005
R2750 VSS.n621 VSS.n303 17.0005
R2751 VSS.n621 VSS.n304 17.0005
R2752 VSS.n621 VSS.n230 17.0005
R2753 VSS.n621 VSS.n229 17.0005
R2754 VSS.n621 VSS.n160 17.0005
R2755 VSS.n621 VSS.n159 17.0005
R2756 VSS.n621 VSS.n305 17.0005
R2757 VSS.n621 VSS.n226 17.0005
R2758 VSS.n621 VSS.n157 17.0005
R2759 VSS.n621 VSS.n156 17.0005
R2760 VSS.n621 VSS.n306 17.0005
R2761 VSS.n621 VSS.n307 17.0005
R2762 VSS.n621 VSS.n224 17.0005
R2763 VSS.n621 VSS.n223 17.0005
R2764 VSS.n621 VSS.n154 17.0005
R2765 VSS.n621 VSS.n153 17.0005
R2766 VSS.n621 VSS.n308 17.0005
R2767 VSS.n621 VSS.n220 17.0005
R2768 VSS.n621 VSS.n151 17.0005
R2769 VSS.n621 VSS.n150 17.0005
R2770 VSS.n621 VSS.n309 17.0005
R2771 VSS.n621 VSS.n310 17.0005
R2772 VSS.n621 VSS.n218 17.0005
R2773 VSS.n621 VSS.n217 17.0005
R2774 VSS.n621 VSS.n148 17.0005
R2775 VSS.n621 VSS.n147 17.0005
R2776 VSS.n621 VSS.n311 17.0005
R2777 VSS.n621 VSS.n214 17.0005
R2778 VSS.n621 VSS.n145 17.0005
R2779 VSS.n621 VSS.n212 17.0005
R2780 VSS.n621 VSS.n312 17.0005
R2781 VSS.n621 VSS.n210 17.0005
R2782 VSS.n621 VSS.n313 17.0005
R2783 VSS.n621 VSS.t41 17.0005
R2784 VSS.n621 VSS.n314 17.0005
R2785 VSS.n621 VSS.n315 17.0005
R2786 VSS.n621 VSS.n208 17.0005
R2787 VSS.n621 VSS.n317 17.0005
R2788 VSS.t51 VSS.n129 17.0005
R2789 VSS.t51 VSS.n480 17.0005
R2790 VSS.n482 VSS.t51 17.0005
R2791 VSS.t50 VSS.n480 17.0005
R2792 VSS.n482 VSS.t50 17.0005
R2793 VSS.t50 VSS.n129 17.0005
R2794 VSS.n484 VSS.n483 17.0005
R2795 VSS.n481 VSS.n130 17.0005
R2796 VSS.n479 VSS.n130 17.0005
R2797 VSS.n458 VSS.n456 17.0005
R2798 VSS.n459 VSS.n456 17.0005
R2799 VSS.n582 VSS.n457 17.0005
R2800 VSS.n582 VSS.n581 17.0005
R2801 VSS.n636 VSS.n46 17.0005
R2802 VSS.n636 VSS.n40 17.0005
R2803 VSS.n636 VSS.n47 17.0005
R2804 VSS.n636 VSS.n38 17.0005
R2805 VSS.n636 VSS.n49 17.0005
R2806 VSS.n636 VSS.n36 17.0005
R2807 VSS.n636 VSS.n50 17.0005
R2808 VSS.n636 VSS.n34 17.0005
R2809 VSS.n636 VSS.n52 17.0005
R2810 VSS.n636 VSS.n32 17.0005
R2811 VSS.n636 VSS.n53 17.0005
R2812 VSS.n636 VSS.n30 17.0005
R2813 VSS.n636 VSS.n55 17.0005
R2814 VSS.n636 VSS.n28 17.0005
R2815 VSS.n636 VSS.n56 17.0005
R2816 VSS.n636 VSS.n26 17.0005
R2817 VSS.n636 VSS.n58 17.0005
R2818 VSS.n636 VSS.n24 17.0005
R2819 VSS.n636 VSS.n59 17.0005
R2820 VSS.n636 VSS.n22 17.0005
R2821 VSS.n636 VSS.n60 17.0005
R2822 VSS.n636 VSS.n20 17.0005
R2823 VSS.n636 VSS.n61 17.0005
R2824 VSS.n636 VSS.n18 17.0005
R2825 VSS.n636 VSS.n63 17.0005
R2826 VSS.n636 VSS.n16 17.0005
R2827 VSS.n636 VSS.n64 17.0005
R2828 VSS.n636 VSS.n14 17.0005
R2829 VSS.n636 VSS.n66 17.0005
R2830 VSS.n636 VSS.n12 17.0005
R2831 VSS.n636 VSS.n67 17.0005
R2832 VSS.n636 VSS.n10 17.0005
R2833 VSS.n636 VSS.n69 17.0005
R2834 VSS.n636 VSS.n8 17.0005
R2835 VSS.n636 VSS.n70 17.0005
R2836 VSS.n636 VSS.n6 17.0005
R2837 VSS.n636 VSS.n72 17.0005
R2838 VSS.n636 VSS.n4 17.0005
R2839 VSS.n636 VSS.n73 17.0005
R2840 VSS.n636 VSS.n2 17.0005
R2841 VSS.t80 VSS.n150 16.6364
R2842 VSS.n196 VSS.t58 16.6364
R2843 VSS.t2 VSS.n500 15.1897
R2844 VSS.n527 VSS.t28 15.1851
R2845 VSS.t108 VSS.n8 15.1808
R2846 VSS.n50 VSS.t88 15.1808
R2847 VSS.t46 VSS.n358 15.0005
R2848 VSS.n615 VSS.t40 15.0005
R2849 VSS.n598 VSS.t36 15.0005
R2850 VSS.t43 VSS.n356 15.0005
R2851 VSS.n298 VSS.n173 13.1592
R2852 VSS.n241 VSS.n173 13.1592
R2853 VSS.n207 VSS.n140 12.4949
R2854 VSS.n317 VSS.n141 12.4949
R2855 VSS.n315 VSS.n142 12.4949
R2856 VSS.n313 VSS.n143 12.4949
R2857 VSS.n312 VSS.n144 12.4949
R2858 VSS.n311 VSS.n146 12.4949
R2859 VSS.n310 VSS.n149 12.4949
R2860 VSS.n308 VSS.n152 12.4949
R2861 VSS.n307 VSS.n155 12.4949
R2862 VSS.n305 VSS.n158 12.4949
R2863 VSS.n304 VSS.n161 12.4949
R2864 VSS.n302 VSS.n164 12.4949
R2865 VSS.n301 VSS.n167 12.4949
R2866 VSS.n299 VSS.n170 12.4949
R2867 VSS.n296 VSS.n176 12.4949
R2868 VSS.n295 VSS.n179 12.4949
R2869 VSS.n293 VSS.n182 12.4949
R2870 VSS.n292 VSS.n185 12.4949
R2871 VSS.n290 VSS.n188 12.4949
R2872 VSS.n289 VSS.n191 12.4949
R2873 VSS.n287 VSS.n194 12.4949
R2874 VSS.n286 VSS.n197 12.4949
R2875 VSS.n284 VSS.n200 12.4949
R2876 VSS.n283 VSS.n203 12.4949
R2877 VSS.t37 VSS.n204 12.4949
R2878 VSS.n282 VSS.n205 12.4949
R2879 VSS.n623 VSS.n622 12.4949
R2880 VSS.n623 VSS.n206 12.4949
R2881 VSS.n275 VSS.n205 12.4949
R2882 VSS.n273 VSS.n204 12.4949
R2883 VSS.n271 VSS.n203 12.4949
R2884 VSS.n268 VSS.n200 12.4949
R2885 VSS.n265 VSS.n197 12.4949
R2886 VSS.n262 VSS.n194 12.4949
R2887 VSS.n259 VSS.n191 12.4949
R2888 VSS.n256 VSS.n188 12.4949
R2889 VSS.n253 VSS.n185 12.4949
R2890 VSS.n250 VSS.n182 12.4949
R2891 VSS.n247 VSS.n179 12.4949
R2892 VSS.n244 VSS.n176 12.4949
R2893 VSS.n238 VSS.n170 12.4949
R2894 VSS.n235 VSS.n167 12.4949
R2895 VSS.n232 VSS.n164 12.4949
R2896 VSS.n229 VSS.n161 12.4949
R2897 VSS.n226 VSS.n158 12.4949
R2898 VSS.n223 VSS.n155 12.4949
R2899 VSS.n220 VSS.n152 12.4949
R2900 VSS.n217 VSS.n149 12.4949
R2901 VSS.n214 VSS.n146 12.4949
R2902 VSS.n212 VSS.n144 12.4949
R2903 VSS.n210 VSS.n143 12.4949
R2904 VSS.t41 VSS.n142 12.4949
R2905 VSS.n208 VSS.n141 12.4949
R2906 VSS.n589 VSS.n207 12.4949
R2907 VSS.t0 VSS.n499 11.4054
R2908 VSS.n528 VSS.t29 11.39
R2909 VSS.t109 VSS.n6 11.3857
R2910 VSS.n49 VSS.t87 11.3857
R2911 VSS.n124 VSS.t53 11.1339
R2912 VSS.t53 VSS.n78 11.1339
R2913 VSS.n634 VSS.n2 11.1339
R2914 VSS.n122 VSS.n4 11.1339
R2915 VSS.n120 VSS.n6 11.1339
R2916 VSS.n118 VSS.n8 11.1339
R2917 VSS.n116 VSS.n10 11.1339
R2918 VSS.n114 VSS.n12 11.1339
R2919 VSS.n112 VSS.n14 11.1339
R2920 VSS.n110 VSS.n16 11.1339
R2921 VSS.n108 VSS.n18 11.1339
R2922 VSS.n106 VSS.n20 11.1339
R2923 VSS.n104 VSS.n22 11.1339
R2924 VSS.n102 VSS.n24 11.1339
R2925 VSS.n100 VSS.n26 11.1339
R2926 VSS.n98 VSS.n28 11.1339
R2927 VSS.n96 VSS.n30 11.1339
R2928 VSS.n94 VSS.n32 11.1339
R2929 VSS.n92 VSS.n34 11.1339
R2930 VSS.n90 VSS.n36 11.1339
R2931 VSS.n88 VSS.n38 11.1339
R2932 VSS.n86 VSS.n40 11.1339
R2933 VSS.t49 VSS.n44 11.1339
R2934 VSS.n628 VSS.n80 11.1339
R2935 VSS.n83 VSS.t49 11.1339
R2936 VSS.n85 VSS.n46 11.1339
R2937 VSS.n87 VSS.n47 11.1339
R2938 VSS.n89 VSS.n49 11.1339
R2939 VSS.n91 VSS.n50 11.1339
R2940 VSS.n93 VSS.n52 11.1339
R2941 VSS.n95 VSS.n53 11.1339
R2942 VSS.n97 VSS.n55 11.1339
R2943 VSS.n99 VSS.n56 11.1339
R2944 VSS.n101 VSS.n58 11.1339
R2945 VSS.n103 VSS.n59 11.1339
R2946 VSS.n105 VSS.n60 11.1339
R2947 VSS.n107 VSS.n61 11.1339
R2948 VSS.n109 VSS.n63 11.1339
R2949 VSS.n111 VSS.n64 11.1339
R2950 VSS.n113 VSS.n66 11.1339
R2951 VSS.n115 VSS.n67 11.1339
R2952 VSS.n117 VSS.n69 11.1339
R2953 VSS.n119 VSS.n70 11.1339
R2954 VSS.n121 VSS.n72 11.1339
R2955 VSS.n123 VSS.n73 11.1339
R2956 VSS.n584 VSS.n126 11.1339
R2957 VSS.t82 VSS.n147 11.0911
R2958 VSS.n199 VSS.t56 11.0911
R2959 VSS.n589 VSS.n587 8.501
R2960 VSS.n589 VSS.n588 8.501
R2961 VSS.n589 VSS.n318 8.501
R2962 VSS.n626 VSS.n134 8.501
R2963 VSS.n626 VSS.n133 8.501
R2964 VSS.n628 VSS.n131 8.501
R2965 VSS.n629 VSS.n628 8.501
R2966 VSS.n628 VSS.n81 8.501
R2967 VSS.n584 VSS.n127 8.501
R2968 VSS.n584 VSS.n455 8.501
R2969 VSS.n584 VSS.n583 8.501
R2970 VSS.t30 VSS.n545 8.5005
R2971 VSS.t30 VSS.n533 8.5005
R2972 VSS.n546 VSS.t30 8.5005
R2973 VSS.n590 VSS.n212 8.5005
R2974 VSS.n620 VSS.n321 8.5005
R2975 VSS.n620 VSS.n320 8.5005
R2976 VSS.n280 VSS.n278 8.5005
R2977 VSS.n280 VSS.n279 8.5005
R2978 VSS.n462 VSS.t54 8.5005
R2979 VSS.t54 VSS.n460 8.5005
R2980 VSS.t54 VSS.n461 8.5005
R2981 VSS.n590 VSS.n450 8.4984
R2982 VSS.n590 VSS.n448 8.4984
R2983 VSS.n590 VSS.n446 8.4984
R2984 VSS.n590 VSS.n444 8.4984
R2985 VSS.n590 VSS.n442 8.4984
R2986 VSS.n590 VSS.n440 8.4984
R2987 VSS.n590 VSS.n438 8.4984
R2988 VSS.n590 VSS.n436 8.4984
R2989 VSS.n590 VSS.n434 8.4984
R2990 VSS.n590 VSS.n432 8.4984
R2991 VSS.n590 VSS.n430 8.4984
R2992 VSS.n590 VSS.n428 8.4984
R2993 VSS.n590 VSS.n426 8.4984
R2994 VSS.n590 VSS.n424 8.4984
R2995 VSS.n590 VSS.n422 8.4984
R2996 VSS.n590 VSS.n420 8.4984
R2997 VSS.n590 VSS.n418 8.4984
R2998 VSS.n590 VSS.n416 8.4984
R2999 VSS.n590 VSS.n414 8.4984
R3000 VSS.n590 VSS.n412 8.4984
R3001 VSS.n590 VSS.n410 8.4984
R3002 VSS.n590 VSS.n408 8.4984
R3003 VSS.n590 VSS.n406 8.4984
R3004 VSS.n590 VSS.n404 8.4984
R3005 VSS.n590 VSS.n402 8.4984
R3006 VSS.n590 VSS.n400 8.4984
R3007 VSS.n590 VSS.n398 8.4984
R3008 VSS.n590 VSS.n396 8.4984
R3009 VSS.n590 VSS.n394 8.4984
R3010 VSS.n590 VSS.n392 8.4984
R3011 VSS.n590 VSS.n390 8.4984
R3012 VSS.n590 VSS.n388 8.4984
R3013 VSS.n590 VSS.n386 8.4984
R3014 VSS.n590 VSS.n384 8.4984
R3015 VSS.n590 VSS.n382 8.4984
R3016 VSS.n590 VSS.n380 8.4984
R3017 VSS.n590 VSS.n378 8.4984
R3018 VSS.n590 VSS.n376 8.4984
R3019 VSS.n590 VSS.n374 8.4984
R3020 VSS.n590 VSS.n372 8.4984
R3021 VSS.n590 VSS.n370 8.4984
R3022 VSS.n590 VSS.n369 8.4984
R3023 VSS.n590 VSS.n367 8.4984
R3024 VSS.n590 VSS.n365 8.4984
R3025 VSS.n621 VSS.n274 8.4984
R3026 VSS.n621 VSS.n272 8.4984
R3027 VSS.n621 VSS.n270 8.4984
R3028 VSS.n621 VSS.n269 8.4984
R3029 VSS.n621 VSS.n267 8.4984
R3030 VSS.n621 VSS.n264 8.4984
R3031 VSS.n621 VSS.n263 8.4984
R3032 VSS.n621 VSS.n261 8.4984
R3033 VSS.n621 VSS.n258 8.4984
R3034 VSS.n621 VSS.n257 8.4984
R3035 VSS.n621 VSS.n255 8.4984
R3036 VSS.n621 VSS.n252 8.4984
R3037 VSS.n621 VSS.n251 8.4984
R3038 VSS.n621 VSS.n249 8.4984
R3039 VSS.n621 VSS.n246 8.4984
R3040 VSS.n621 VSS.n245 8.4984
R3041 VSS.n621 VSS.n243 8.4984
R3042 VSS.n621 VSS.n240 8.4984
R3043 VSS.n621 VSS.n239 8.4984
R3044 VSS.n621 VSS.n237 8.4984
R3045 VSS.n621 VSS.n234 8.4984
R3046 VSS.n621 VSS.n233 8.4984
R3047 VSS.n621 VSS.n231 8.4984
R3048 VSS.n621 VSS.n228 8.4984
R3049 VSS.n621 VSS.n227 8.4984
R3050 VSS.n621 VSS.n225 8.4984
R3051 VSS.n621 VSS.n222 8.4984
R3052 VSS.n621 VSS.n221 8.4984
R3053 VSS.n621 VSS.n219 8.4984
R3054 VSS.n621 VSS.n216 8.4984
R3055 VSS.n621 VSS.n215 8.4984
R3056 VSS.n621 VSS.n213 8.4984
R3057 VSS.n621 VSS.n211 8.4984
R3058 VSS.n621 VSS.n209 8.4984
R3059 VSS.n485 VSS.n484 8.49747
R3060 VSS.n586 VSS.n319 8.46995
R3061 VSS.n277 VSS.n137 8.46995
R3062 VSS.n631 VSS.n630 8.46995
R3063 VSS.n454 VSS.n128 8.46995
R3064 VSS.n570 VSS.n493 8.22525
R3065 VSS.n571 VSS.n570 8.22525
R3066 VSS.n622 VSS.n136 7.6711
R3067 VSS.t35 VSS.n453 7.60475
R3068 VSS.n499 VSS.t32 7.60373
R3069 VSS.t111 VSS.n4 7.59063
R3070 VSS.n47 VSS.t85 7.59063
R3071 VSS.n359 VSS.t46 7.49606
R3072 VSS.t40 VSS.n614 7.49606
R3073 VSS.t36 VSS.n354 7.49606
R3074 VSS.n593 VSS.t43 7.49606
R3075 VSS.n363 VSS.n140 7.20236
R3076 VSS.n364 VSS.n208 7.20236
R3077 VSS.n366 VSS.t41 7.20236
R3078 VSS.n368 VSS.n210 7.20236
R3079 VSS.n371 VSS.n145 7.20236
R3080 VSS.n373 VSS.n311 7.20236
R3081 VSS.n375 VSS.n148 7.20236
R3082 VSS.n377 VSS.n310 7.20236
R3083 VSS.n379 VSS.n151 7.20236
R3084 VSS.n381 VSS.n308 7.20236
R3085 VSS.n383 VSS.n154 7.20236
R3086 VSS.n385 VSS.n307 7.20236
R3087 VSS.n387 VSS.n157 7.20236
R3088 VSS.n389 VSS.n305 7.20236
R3089 VSS.n391 VSS.n160 7.20236
R3090 VSS.n393 VSS.n304 7.20236
R3091 VSS.n395 VSS.n163 7.20236
R3092 VSS.n397 VSS.n302 7.20236
R3093 VSS.n399 VSS.n166 7.20236
R3094 VSS.n401 VSS.n301 7.20236
R3095 VSS.n403 VSS.n169 7.20236
R3096 VSS.n405 VSS.n299 7.20236
R3097 VSS.n407 VSS.n172 7.20236
R3098 VSS.n409 VSS.n298 7.20236
R3099 VSS.n411 VSS.n175 7.20236
R3100 VSS.n413 VSS.n296 7.20236
R3101 VSS.n415 VSS.n178 7.20236
R3102 VSS.n417 VSS.n295 7.20236
R3103 VSS.n419 VSS.n181 7.20236
R3104 VSS.n421 VSS.n293 7.20236
R3105 VSS.n423 VSS.n184 7.20236
R3106 VSS.n425 VSS.n292 7.20236
R3107 VSS.n427 VSS.n187 7.20236
R3108 VSS.n429 VSS.n290 7.20236
R3109 VSS.n431 VSS.n190 7.20236
R3110 VSS.n433 VSS.n289 7.20236
R3111 VSS.n435 VSS.n193 7.20236
R3112 VSS.n437 VSS.n287 7.20236
R3113 VSS.n439 VSS.n196 7.20236
R3114 VSS.n441 VSS.n286 7.20236
R3115 VSS.n443 VSS.n199 7.20236
R3116 VSS.n445 VSS.n284 7.20236
R3117 VSS.n447 VSS.n202 7.20236
R3118 VSS.n449 VSS.n283 7.20236
R3119 VSS.n451 VSS.t37 7.20236
R3120 VSS.n452 VSS.n282 7.20236
R3121 VSS.n452 VSS.n206 7.20236
R3122 VSS.n451 VSS.n275 7.20236
R3123 VSS.n449 VSS.n273 7.20236
R3124 VSS.n447 VSS.n271 7.20236
R3125 VSS.n445 VSS.n201 7.20236
R3126 VSS.n443 VSS.n268 7.20236
R3127 VSS.n441 VSS.n198 7.20236
R3128 VSS.n439 VSS.n265 7.20236
R3129 VSS.n437 VSS.n195 7.20236
R3130 VSS.n435 VSS.n262 7.20236
R3131 VSS.n433 VSS.n192 7.20236
R3132 VSS.n431 VSS.n259 7.20236
R3133 VSS.n429 VSS.n189 7.20236
R3134 VSS.n427 VSS.n256 7.20236
R3135 VSS.n425 VSS.n186 7.20236
R3136 VSS.n423 VSS.n253 7.20236
R3137 VSS.n421 VSS.n183 7.20236
R3138 VSS.n419 VSS.n250 7.20236
R3139 VSS.n417 VSS.n180 7.20236
R3140 VSS.n415 VSS.n247 7.20236
R3141 VSS.n413 VSS.n177 7.20236
R3142 VSS.n411 VSS.n244 7.20236
R3143 VSS.n409 VSS.n174 7.20236
R3144 VSS.n407 VSS.n241 7.20236
R3145 VSS.n405 VSS.n171 7.20236
R3146 VSS.n403 VSS.n238 7.20236
R3147 VSS.n401 VSS.n168 7.20236
R3148 VSS.n399 VSS.n235 7.20236
R3149 VSS.n397 VSS.n165 7.20236
R3150 VSS.n395 VSS.n232 7.20236
R3151 VSS.n393 VSS.n162 7.20236
R3152 VSS.n391 VSS.n229 7.20236
R3153 VSS.n389 VSS.n159 7.20236
R3154 VSS.n387 VSS.n226 7.20236
R3155 VSS.n385 VSS.n156 7.20236
R3156 VSS.n383 VSS.n223 7.20236
R3157 VSS.n381 VSS.n153 7.20236
R3158 VSS.n379 VSS.n220 7.20236
R3159 VSS.n377 VSS.n150 7.20236
R3160 VSS.n375 VSS.n217 7.20236
R3161 VSS.n373 VSS.n147 7.20236
R3162 VSS.n371 VSS.n214 7.20236
R3163 VSS.n368 VSS.n312 7.20236
R3164 VSS.n366 VSS.n313 7.20236
R3165 VSS.n364 VSS.n315 7.20236
R3166 VSS.n363 VSS.n317 7.20236
R3167 VSS.n607 VSS.t122 5.84693
R3168 VSS.n471 VSS.t98 5.84562
R3169 VSS.n568 VSS.t15 5.84562
R3170 VSS.n626 VSS.n135 5.66778
R3171 VSS.n584 VSS.n74 5.66778
R3172 VSS.n589 VSS.n139 5.66767
R3173 VSS.n626 VSS.n625 5.66767
R3174 VSS.n628 VSS.n41 5.66767
R3175 VSS.n360 VSS.t47 5.66717
R3176 VSS.n362 VSS.t47 5.66717
R3177 VSS.n323 VSS.t42 5.66717
R3178 VSS.n619 VSS.t42 5.66717
R3179 VSS.n355 VSS.t39 5.66717
R3180 VSS.n353 VSS.t38 5.66717
R3181 VSS.n596 VSS.t45 5.66717
R3182 VSS.n594 VSS.t44 5.66717
R3183 VSS.n337 VSS.t69 5.66167
R3184 VSS.n327 VSS.t81 5.66167
R3185 VSS.n330 VSS.t78 5.66167
R3186 VSS.n333 VSS.t75 5.66167
R3187 VSS.n336 VSS.t72 5.66167
R3188 VSS.n341 VSS.t66 5.66167
R3189 VSS.n344 VSS.t63 5.66167
R3190 VSS.n347 VSS.t60 5.66167
R3191 VSS.n350 VSS.t57 5.66167
R3192 VSS.n553 VSS.t3 5.66167
R3193 VSS.n555 VSS.t6 5.66167
R3194 VSS.n557 VSS.t9 5.66167
R3195 VSS.n497 VSS.t12 5.66167
R3196 VSS.n518 VSS.t18 5.66167
R3197 VSS.n537 VSS.t21 5.66167
R3198 VSS.n535 VSS.t24 5.66167
R3199 VSS.n541 VSS.t27 5.66167
R3200 VSS.n464 VSS.t110 5.66167
R3201 VSS.n466 VSS.t107 5.66167
R3202 VSS.n468 VSS.t104 5.66167
R3203 VSS.n470 VSS.t101 5.66167
R3204 VSS.n472 VSS.t95 5.66167
R3205 VSS.n474 VSS.t92 5.66167
R3206 VSS.n476 VSS.t89 5.66167
R3207 VSS.n325 VSS.t130 5.66167
R3208 VSS.n328 VSS.t128 5.66167
R3209 VSS.n331 VSS.t126 5.66167
R3210 VSS.n334 VSS.t124 5.66167
R3211 VSS.n339 VSS.t120 5.66167
R3212 VSS.n342 VSS.t118 5.66167
R3213 VSS.n345 VSS.t116 5.66167
R3214 VSS.n348 VSS.t114 5.66167
R3215 VSS.n478 VSS.t86 5.66167
R3216 VSS.n212 VSS.t83 5.54579
R3217 VSS.n202 VSS.t55 5.54579
R3218 VSS.n550 VSS.t31 5.0005
R3219 VSS.n543 VSS.t34 5.0005
R3220 VSS.n486 VSS.t48 5.0005
R3221 VSS.n580 VSS.t52 5.0005
R3222 VSS.n618 VSS.n323 4.5005
R3223 VSS.n361 VSS.n360 4.5005
R3224 VSS.n353 VSS.n352 4.5005
R3225 VSS.n595 VSS.n594 4.5005
R3226 VSS.n590 VSS.n281 4.25219
R3227 VSS.n621 VSS.n316 4.25206
R3228 VSS.n590 VSS.n316 4.25175
R3229 VSS.n621 VSS.n281 4.25169
R3230 VSS.n492 VSS.n338 4.11287
R3231 VSS.n572 VSS.n338 4.11287
R3232 VSS.t112 VSS.n2 3.79557
R3233 VSS.n46 VSS.t84 3.79557
R3234 VSS.n574 VSS.n573 3.45713
R3235 VSS.n617 VSS.n616 3.0005
R3236 VSS.n357 VSS.n324 3.0005
R3237 VSS.n600 VSS.n599 3.0005
R3238 VSS.n592 VSS.n351 3.0005
R3239 VSS.n561 VSS.n550 3.0005
R3240 VSS.n544 VSS.n543 3.0005
R3241 VSS.n487 VSS.n486 3.0005
R3242 VSS.n580 VSS.n579 3.0005
R3243 VSS.n636 VSS.n42 2.93453
R3244 VSS.n636 VSS.n43 2.93453
R3245 VSS.n636 VSS.n44 2.93453
R3246 VSS.n636 VSS.n45 2.93453
R3247 VSS.n633 VSS.n80 2.93453
R3248 VSS.n633 VSS.n82 2.93453
R3249 VSS.n633 VSS.n83 2.93453
R3250 VSS.n633 VSS.n84 2.93453
R3251 VSS.n633 VSS.n85 2.93453
R3252 VSS.n633 VSS.n86 2.93453
R3253 VSS.n633 VSS.n87 2.93453
R3254 VSS.n633 VSS.n88 2.93453
R3255 VSS.n633 VSS.n89 2.93453
R3256 VSS.n633 VSS.n90 2.93453
R3257 VSS.n633 VSS.n91 2.93453
R3258 VSS.n633 VSS.n92 2.93453
R3259 VSS.n633 VSS.n93 2.93453
R3260 VSS.n633 VSS.n94 2.93453
R3261 VSS.n633 VSS.n95 2.93453
R3262 VSS.n633 VSS.n96 2.93453
R3263 VSS.n633 VSS.n97 2.93453
R3264 VSS.n633 VSS.n98 2.93453
R3265 VSS.n633 VSS.n99 2.93453
R3266 VSS.n633 VSS.n100 2.93453
R3267 VSS.n633 VSS.n101 2.93453
R3268 VSS.n633 VSS.n102 2.93453
R3269 VSS.n633 VSS.n103 2.93453
R3270 VSS.n633 VSS.n104 2.93453
R3271 VSS.n633 VSS.n105 2.93453
R3272 VSS.n633 VSS.n106 2.93453
R3273 VSS.n633 VSS.n107 2.93453
R3274 VSS.n633 VSS.n108 2.93453
R3275 VSS.n633 VSS.n109 2.93453
R3276 VSS.n633 VSS.n110 2.93453
R3277 VSS.n633 VSS.n111 2.93453
R3278 VSS.n633 VSS.n112 2.93453
R3279 VSS.n633 VSS.n113 2.93453
R3280 VSS.n633 VSS.n114 2.93453
R3281 VSS.n633 VSS.n115 2.93453
R3282 VSS.n633 VSS.n116 2.93453
R3283 VSS.n633 VSS.n117 2.93453
R3284 VSS.n633 VSS.n118 2.93453
R3285 VSS.n633 VSS.n119 2.93453
R3286 VSS.n633 VSS.n120 2.93453
R3287 VSS.n633 VSS.n121 2.93453
R3288 VSS.n633 VSS.n122 2.93453
R3289 VSS.n633 VSS.n123 2.93453
R3290 VSS.n634 VSS.n633 2.93453
R3291 VSS.n633 VSS.n79 2.93453
R3292 VSS.n633 VSS.n124 2.93453
R3293 VSS.n633 VSS.n125 2.93453
R3294 VSS.n633 VSS.n126 2.93453
R3295 VSS.n636 VSS.n635 2.93453
R3296 VSS.n636 VSS.n78 2.93453
R3297 VSS.n636 VSS.n77 2.93453
R3298 VSS.n636 VSS.n76 2.93453
R3299 VSS.n636 VSS.n39 2.93453
R3300 VSS.n636 VSS.n37 2.93453
R3301 VSS.n636 VSS.n35 2.93453
R3302 VSS.n636 VSS.n33 2.93453
R3303 VSS.n636 VSS.n31 2.93453
R3304 VSS.n636 VSS.n29 2.93453
R3305 VSS.n636 VSS.n27 2.93453
R3306 VSS.n636 VSS.n25 2.93453
R3307 VSS.n636 VSS.n23 2.93453
R3308 VSS.n636 VSS.n19 2.93453
R3309 VSS.n636 VSS.n17 2.93453
R3310 VSS.n636 VSS.n15 2.93453
R3311 VSS.n636 VSS.n13 2.93453
R3312 VSS.n636 VSS.n11 2.93453
R3313 VSS.n636 VSS.n9 2.93453
R3314 VSS.n636 VSS.n7 2.93453
R3315 VSS.n636 VSS.n5 2.93453
R3316 VSS.n636 VSS.n3 2.93453
R3317 VSS.n636 VSS.n21 2.54286
R3318 VSS.n608 VSS.n337 2.4821
R3319 VSS.n612 VSS.n327 2.4821
R3320 VSS.n612 VSS.n325 2.4821
R3321 VSS.n611 VSS.n330 2.4821
R3322 VSS.n611 VSS.n328 2.4821
R3323 VSS.n610 VSS.n333 2.4821
R3324 VSS.n610 VSS.n331 2.4821
R3325 VSS.n609 VSS.n336 2.4821
R3326 VSS.n609 VSS.n334 2.4821
R3327 VSS.n605 VSS.n341 2.4821
R3328 VSS.n605 VSS.n339 2.4821
R3329 VSS.n604 VSS.n344 2.4821
R3330 VSS.n604 VSS.n342 2.4821
R3331 VSS.n603 VSS.n347 2.4821
R3332 VSS.n603 VSS.n345 2.4821
R3333 VSS.n602 VSS.n350 2.4821
R3334 VSS.n602 VSS.n348 2.4821
R3335 VSS.n560 VSS.n553 2.4821
R3336 VSS.n559 VSS.n555 2.4821
R3337 VSS.n558 VSS.n557 2.4821
R3338 VSS.n497 VSS.n495 2.4821
R3339 VSS.n518 VSS.n494 2.4821
R3340 VSS.n538 VSS.n537 2.4821
R3341 VSS.n539 VSS.n535 2.4821
R3342 VSS.n542 VSS.n541 2.4821
R3343 VSS.n578 VSS.n464 2.4821
R3344 VSS.n577 VSS.n466 2.4821
R3345 VSS.n576 VSS.n468 2.4821
R3346 VSS.n575 VSS.n470 2.4821
R3347 VSS.n491 VSS.n472 2.4821
R3348 VSS.n490 VSS.n474 2.4821
R3349 VSS.n489 VSS.n476 2.4821
R3350 VSS.n488 VSS.n478 2.4821
R3351 VSS.n624 VSS.n623 2.25406
R3352 VSS.n624 VSS.n205 2.25406
R3353 VSS.n624 VSS.n204 2.25406
R3354 VSS.n624 VSS.n203 2.25406
R3355 VSS.n624 VSS.n200 2.25406
R3356 VSS.n624 VSS.n197 2.25406
R3357 VSS.n624 VSS.n194 2.25406
R3358 VSS.n624 VSS.n191 2.25406
R3359 VSS.n624 VSS.n188 2.25406
R3360 VSS.n624 VSS.n185 2.25406
R3361 VSS.n624 VSS.n182 2.25406
R3362 VSS.n624 VSS.n179 2.25406
R3363 VSS.n624 VSS.n176 2.25406
R3364 VSS.n624 VSS.n170 2.25406
R3365 VSS.n624 VSS.n167 2.25406
R3366 VSS.n624 VSS.n164 2.25406
R3367 VSS.n624 VSS.n161 2.25406
R3368 VSS.n624 VSS.n158 2.25406
R3369 VSS.n624 VSS.n155 2.25406
R3370 VSS.n624 VSS.n152 2.25406
R3371 VSS.n624 VSS.n149 2.25406
R3372 VSS.n624 VSS.n146 2.25406
R3373 VSS.n624 VSS.n144 2.25406
R3374 VSS.n624 VSS.n143 2.25406
R3375 VSS.n624 VSS.n142 2.25406
R3376 VSS.n624 VSS.n141 2.25406
R3377 VSS.n621 VSS.n207 2.25406
R3378 VSS.n619 VSS.n618 2.2505
R3379 VSS.n362 VSS.n361 2.2505
R3380 VSS.n355 VSS.n352 2.2505
R3381 VSS.n596 VSS.n595 2.2505
R3382 VSS.n636 VSS.n51 2.09947
R3383 VSS.n636 VSS.n54 2.09947
R3384 VSS.n636 VSS.n57 2.09947
R3385 VSS.n637 VSS.n636 2.09947
R3386 VSS.n636 VSS.n62 2.09947
R3387 VSS.n636 VSS.n65 2.09947
R3388 VSS.n636 VSS.n68 2.09947
R3389 VSS.n636 VSS.n71 2.09947
R3390 VSS.n565 VSS.n526 2.09868
R3391 VSS.n565 VSS.n523 2.09868
R3392 VSS.n565 VSS.n520 2.09868
R3393 VSS.n565 VSS.n496 2.09868
R3394 VSS.n566 VSS.n565 2.09868
R3395 VSS.n565 VSS.n511 2.09868
R3396 VSS.n565 VSS.n508 2.09868
R3397 VSS.n565 VSS.n505 2.09868
R3398 VSS.n624 VSS.n173 1.92189
R3399 VSS.n493 VSS 1.71233
R3400 VSS.n590 VSS.n589 1.7005
R3401 VSS.n573 VSS.n572 1.63431
R3402 VSS.n573 VSS.n492 1.63431
R3403 VSS.n571 VSS 1.63233
R3404 VSS.n632 VSS.n631 1.62037
R3405 VSS.n277 VSS.n138 1.58049
R3406 VSS.n319 VSS.n138 1.53873
R3407 VSS.n632 VSS.n128 1.53574
R3408 VSS.n626 VSS.n136 1.53502
R3409 VSS.n579 VSS.n462 1.52811
R3410 VSS.n562 VSS.n561 1.52811
R3411 VSS.n545 VSS.n544 1.52811
R3412 VSS.n487 VSS.n480 1.52811
R3413 VSS.n551 VSS.n547 1.42159
R3414 VSS.n547 VSS.n546 1.37894
R3415 VSS.n596 VSS.n591 1.08265
R3416 VSS.n591 VSS.n362 1.03719
R3417 VSS.n636 VSS.n48 1.02964
R3418 VSS.n636 VSS.n75 0.96569
R3419 VSS.n565 VSS.n502 0.910334
R3420 VSS.n565 VSS.n529 0.910033
R3421 VSS.n590 VSS.n452 0.650322
R3422 VSS.n590 VSS.n451 0.650322
R3423 VSS.n590 VSS.n449 0.650322
R3424 VSS.n590 VSS.n447 0.650322
R3425 VSS.n590 VSS.n445 0.650322
R3426 VSS.n590 VSS.n443 0.650322
R3427 VSS.n590 VSS.n441 0.650322
R3428 VSS.n590 VSS.n439 0.650322
R3429 VSS.n590 VSS.n437 0.650322
R3430 VSS.n590 VSS.n435 0.650322
R3431 VSS.n590 VSS.n433 0.650322
R3432 VSS.n590 VSS.n431 0.650322
R3433 VSS.n590 VSS.n429 0.650322
R3434 VSS.n590 VSS.n427 0.650322
R3435 VSS.n590 VSS.n425 0.650322
R3436 VSS.n590 VSS.n423 0.650322
R3437 VSS.n590 VSS.n421 0.650322
R3438 VSS.n590 VSS.n419 0.650322
R3439 VSS.n590 VSS.n417 0.650322
R3440 VSS.n590 VSS.n415 0.650322
R3441 VSS.n590 VSS.n413 0.650322
R3442 VSS.n590 VSS.n411 0.650322
R3443 VSS.n590 VSS.n409 0.650322
R3444 VSS.n590 VSS.n407 0.650322
R3445 VSS.n590 VSS.n405 0.650322
R3446 VSS.n590 VSS.n403 0.650322
R3447 VSS.n590 VSS.n401 0.650322
R3448 VSS.n590 VSS.n399 0.650322
R3449 VSS.n590 VSS.n397 0.650322
R3450 VSS.n590 VSS.n395 0.650322
R3451 VSS.n590 VSS.n393 0.650322
R3452 VSS.n590 VSS.n391 0.650322
R3453 VSS.n590 VSS.n389 0.650322
R3454 VSS.n590 VSS.n387 0.650322
R3455 VSS.n590 VSS.n385 0.650322
R3456 VSS.n590 VSS.n383 0.650322
R3457 VSS.n590 VSS.n381 0.650322
R3458 VSS.n590 VSS.n379 0.650322
R3459 VSS.n590 VSS.n377 0.650322
R3460 VSS.n590 VSS.n375 0.650322
R3461 VSS.n590 VSS.n373 0.650322
R3462 VSS.n590 VSS.n371 0.650322
R3463 VSS.n590 VSS.n368 0.650322
R3464 VSS.n590 VSS.n366 0.650322
R3465 VSS.n590 VSS.n364 0.650322
R3466 VSS.n590 VSS.n363 0.650322
R3467 VSS.n493 VSS.n492 0.2444
R3468 VSS.n572 VSS.n571 0.2444
R3469 VSS.n579 VSS.n578 0.209825
R3470 VSS.n561 VSS.n560 0.209825
R3471 VSS.n544 VSS.n542 0.209825
R3472 VSS.n488 VSS.n487 0.209825
R3473 VSS.n606 VSS.n337 0.201663
R3474 VSS.n327 VSS.n326 0.201663
R3475 VSS.n326 VSS.n325 0.201663
R3476 VSS.n330 VSS.n329 0.201663
R3477 VSS.n329 VSS.n328 0.201663
R3478 VSS.n333 VSS.n332 0.201663
R3479 VSS.n332 VSS.n331 0.201663
R3480 VSS.n336 VSS.n335 0.201663
R3481 VSS.n335 VSS.n334 0.201663
R3482 VSS.n341 VSS.n340 0.201663
R3483 VSS.n340 VSS.n339 0.201663
R3484 VSS.n344 VSS.n343 0.201663
R3485 VSS.n343 VSS.n342 0.201663
R3486 VSS.n347 VSS.n346 0.201663
R3487 VSS.n346 VSS.n345 0.201663
R3488 VSS.n350 VSS.n349 0.201663
R3489 VSS.n349 VSS.n348 0.201663
R3490 VSS.n553 VSS.n552 0.201663
R3491 VSS.n555 VSS.n554 0.201663
R3492 VSS.n557 VSS.n556 0.201663
R3493 VSS.n498 VSS.n497 0.201663
R3494 VSS.n519 VSS.n518 0.201663
R3495 VSS.n537 VSS.n536 0.201663
R3496 VSS.n535 VSS.n534 0.201663
R3497 VSS.n541 VSS.n540 0.201663
R3498 VSS.n464 VSS.n463 0.201663
R3499 VSS.n466 VSS.n465 0.201663
R3500 VSS.n468 VSS.n467 0.201663
R3501 VSS.n470 VSS.n469 0.201663
R3502 VSS.n472 VSS.n1 0.201663
R3503 VSS.n474 VSS.n473 0.201663
R3504 VSS.n476 VSS.n475 0.201663
R3505 VSS.n478 VSS.n477 0.201663
R3506 VSS.n542 VSS.n539 0.16242
R3507 VSS.n539 VSS.n538 0.16242
R3508 VSS.n538 VSS.n494 0.16242
R3509 VSS.n569 VSS.n494 0.16242
R3510 VSS.n569 VSS.n495 0.16242
R3511 VSS.n558 VSS.n495 0.16242
R3512 VSS.n559 VSS.n558 0.16242
R3513 VSS.n560 VSS.n559 0.16242
R3514 VSS.n578 VSS.n577 0.16242
R3515 VSS.n577 VSS.n576 0.16242
R3516 VSS.n576 VSS.n575 0.16242
R3517 VSS.n575 VSS.n574 0.16242
R3518 VSS.n574 VSS.n491 0.16242
R3519 VSS.n491 VSS.n490 0.16242
R3520 VSS.n490 VSS.n489 0.16242
R3521 VSS.n489 VSS.n488 0.16242
R3522 VSS.n540 VSS.n529 0.146089
R3523 VSS.n552 VSS.n502 0.145358
R3524 VSS.n463 VSS.n75 0.143085
R3525 VSS.n590 VSS.n136 0.139317
R3526 VSS.n477 VSS.n48 0.135345
R3527 VSS.n602 VSS.n601 0.117247
R3528 VSS.n613 VSS.n612 0.1171
R3529 VSS.n477 VSS.n51 0.0952183
R3530 VSS.n540 VSS.n526 0.0942639
R3531 VSS.n552 VSS.n505 0.0935007
R3532 VSS.n475 VSS.n54 0.0927738
R3533 VSS.n463 VSS.n71 0.0925656
R3534 VSS.n534 VSS.n523 0.0918194
R3535 VSS.n554 VSS.n508 0.0910563
R3536 VSS.n62 VSS.n0 0.0903294
R3537 VSS.n473 VSS.n57 0.0903294
R3538 VSS.n465 VSS.n68 0.0901212
R3539 VSS.n536 VSS.n520 0.089375
R3540 VSS.n567 VSS.n496 0.0886118
R3541 VSS.n556 VSS.n511 0.0886118
R3542 VSS.n469 VSS.n65 0.0878849
R3543 VSS.n637 VSS.n1 0.0878849
R3544 VSS.n467 VSS.n65 0.0876767
R3545 VSS.n519 VSS.n496 0.0869305
R3546 VSS.n511 VSS.n498 0.0869305
R3547 VSS.n520 VSS.n519 0.0861674
R3548 VSS.n566 VSS.n498 0.0861674
R3549 VSS.n467 VSS.n68 0.0854405
R3550 VSS.n469 VSS.n62 0.0852323
R3551 VSS.n57 VSS.n1 0.0852323
R3552 VSS.n581 VSS.n75 0.0849321
R3553 VSS.n556 VSS.n508 0.0844861
R3554 VSS.n485 VSS.n48 0.0844405
R3555 VSS.n536 VSS.n523 0.083723
R3556 VSS.n543 VSS.n529 0.0836785
R3557 VSS.n550 VSS.n502 0.0834709
R3558 VSS.n465 VSS.n71 0.082996
R3559 VSS.n473 VSS.n54 0.0827878
R3560 VSS.n554 VSS.n505 0.0820417
R3561 VSS VSS.n566 0.0817361
R3562 VSS.n612 VSS.n611 0.08146
R3563 VSS.n611 VSS.n610 0.08146
R3564 VSS.n610 VSS.n609 0.08146
R3565 VSS.n609 VSS.n608 0.08146
R3566 VSS.n608 VSS.n605 0.08146
R3567 VSS.n605 VSS.n604 0.08146
R3568 VSS.n604 VSS.n603 0.08146
R3569 VSS.n603 VSS.n602 0.08146
R3570 VSS.n534 VSS.n526 0.0812785
R3571 VSS.n475 VSS.n51 0.0803434
R3572 VSS VSS.n637 0.0800378
R3573 VSS.n631 VSS.n129 0.0766771
R3574 VSS.n460 VSS.n128 0.0766771
R3575 VSS.n620 VSS.n319 0.070439
R3576 VSS.n280 VSS.n277 0.070439
R3577 VSS.n620 VSS.n619 0.0592831
R3578 VSS.n355 VSS.n280 0.0592831
R3579 VSS.n570 VSS.n569 0.0389615
R3580 VSS.n574 VSS.n471 0.0360747
R3581 VSS.n569 VSS.n568 0.0360747
R3582 VSS.n360 VSS.n359 0.031258
R3583 VSS.n354 VSS.n353 0.031258
R3584 VSS.n594 VSS.n593 0.031258
R3585 VSS.n601 VSS.n351 0.0291125
R3586 VSS.n617 VSS.n613 0.0291125
R3587 VSS.n613 VSS.n324 0.0291125
R3588 VSS.n601 VSS.n600 0.0291125
R3589 VSS.n595 VSS.n351 0.0281144
R3590 VSS.n618 VSS.n617 0.0281144
R3591 VSS.n361 VSS.n324 0.0281144
R3592 VSS.n600 VSS.n352 0.0281144
R3593 VSS.n614 VSS.n322 0.0216549
R3594 VSS.n615 VSS.n323 0.0208704
R3595 VSS.n358 VSS.n357 0.0202884
R3596 VSS.n616 VSS.n615 0.0202884
R3597 VSS.n599 VSS.n598 0.0202884
R3598 VSS.n592 VSS.n356 0.0202884
R3599 VSS.n608 VSS.n338 0.0197308
R3600 VSS.n608 VSS.n607 0.0186622
R3601 VSS.n322 VSS.n316 0.0162424
R3602 VSS.n597 VSS.n281 0.0159649
R3603 VSS.n564 VSS.n550 0.0133922
R3604 VSS.n543 VSS.n530 0.0133922
R3605 VSS.n486 VSS.n483 0.0133922
R3606 VSS.n580 VSS.n457 0.0133922
R3607 VSS.n367 VSS.n209 0.0118857
R3608 VSS.n369 VSS.n211 0.0118857
R3609 VSS.n370 VSS.n213 0.0118857
R3610 VSS.n372 VSS.n215 0.0118857
R3611 VSS.n374 VSS.n216 0.0118857
R3612 VSS.n378 VSS.n219 0.0118857
R3613 VSS.n380 VSS.n221 0.0118857
R3614 VSS.n382 VSS.n222 0.0118857
R3615 VSS.n386 VSS.n225 0.0118857
R3616 VSS.n388 VSS.n227 0.0118857
R3617 VSS.n390 VSS.n228 0.0118857
R3618 VSS.n394 VSS.n231 0.0118857
R3619 VSS.n396 VSS.n233 0.0118857
R3620 VSS.n398 VSS.n234 0.0118857
R3621 VSS.n402 VSS.n237 0.0118857
R3622 VSS.n404 VSS.n239 0.0118857
R3623 VSS.n406 VSS.n240 0.0118857
R3624 VSS.n410 VSS.n243 0.0118857
R3625 VSS.n412 VSS.n245 0.0118857
R3626 VSS.n414 VSS.n246 0.0118857
R3627 VSS.n418 VSS.n249 0.0118857
R3628 VSS.n420 VSS.n251 0.0118857
R3629 VSS.n422 VSS.n252 0.0118857
R3630 VSS.n426 VSS.n255 0.0118857
R3631 VSS.n428 VSS.n257 0.0118857
R3632 VSS.n430 VSS.n258 0.0118857
R3633 VSS.n434 VSS.n261 0.0118857
R3634 VSS.n436 VSS.n263 0.0118857
R3635 VSS.n438 VSS.n264 0.0118857
R3636 VSS.n442 VSS.n267 0.0118857
R3637 VSS.n444 VSS.n269 0.0118857
R3638 VSS.n446 VSS.n270 0.0118857
R3639 VSS.n448 VSS.n272 0.0118857
R3640 VSS.n450 VSS.n274 0.0118857
R3641 VSS.n448 VSS.n274 0.0118857
R3642 VSS.n446 VSS.n272 0.0118857
R3643 VSS.n444 VSS.n270 0.0118857
R3644 VSS.n442 VSS.n269 0.0118857
R3645 VSS.n440 VSS.n267 0.0118857
R3646 VSS.n436 VSS.n264 0.0118857
R3647 VSS.n434 VSS.n263 0.0118857
R3648 VSS.n432 VSS.n261 0.0118857
R3649 VSS.n428 VSS.n258 0.0118857
R3650 VSS.n426 VSS.n257 0.0118857
R3651 VSS.n424 VSS.n255 0.0118857
R3652 VSS.n420 VSS.n252 0.0118857
R3653 VSS.n418 VSS.n251 0.0118857
R3654 VSS.n416 VSS.n249 0.0118857
R3655 VSS.n412 VSS.n246 0.0118857
R3656 VSS.n410 VSS.n245 0.0118857
R3657 VSS.n408 VSS.n243 0.0118857
R3658 VSS.n404 VSS.n240 0.0118857
R3659 VSS.n402 VSS.n239 0.0118857
R3660 VSS.n400 VSS.n237 0.0118857
R3661 VSS.n396 VSS.n234 0.0118857
R3662 VSS.n394 VSS.n233 0.0118857
R3663 VSS.n392 VSS.n231 0.0118857
R3664 VSS.n388 VSS.n228 0.0118857
R3665 VSS.n386 VSS.n227 0.0118857
R3666 VSS.n384 VSS.n225 0.0118857
R3667 VSS.n380 VSS.n222 0.0118857
R3668 VSS.n378 VSS.n221 0.0118857
R3669 VSS.n376 VSS.n219 0.0118857
R3670 VSS.n372 VSS.n216 0.0118857
R3671 VSS.n370 VSS.n215 0.0118857
R3672 VSS.n369 VSS.n213 0.0118857
R3673 VSS.n367 VSS.n211 0.0118857
R3674 VSS.n365 VSS.n209 0.0118857
R3675 VSS.n598 VSS.n597 0.0115582
R3676 VSS.n597 VSS.n356 0.0115582
R3677 VSS.n358 VSS.n322 0.0112672
R3678 VSS.n565 VSS.n528 0.0112168
R3679 VSS.n565 VSS.n527 0.0112168
R3680 VSS.n565 VSS.n525 0.0112168
R3681 VSS.n565 VSS.n524 0.0112168
R3682 VSS.n565 VSS.n522 0.0112168
R3683 VSS.n565 VSS.n521 0.0112168
R3684 VSS.n565 VSS.n517 0.0112168
R3685 VSS.n565 VSS.n516 0.0112168
R3686 VSS.n565 VSS.n515 0.0112168
R3687 VSS.n565 VSS.n514 0.0112168
R3688 VSS.n565 VSS.n512 0.0112168
R3689 VSS.n565 VSS.n510 0.0112168
R3690 VSS.n565 VSS.n509 0.0112168
R3691 VSS.n565 VSS.n507 0.0112168
R3692 VSS.n565 VSS.n506 0.0112168
R3693 VSS.n565 VSS.n504 0.0112168
R3694 VSS.n565 VSS.n503 0.0112168
R3695 VSS.n565 VSS.n501 0.0112168
R3696 VSS.n565 VSS.n500 0.0112168
R3697 VSS.n359 VSS.n357 0.0108877
R3698 VSS.n616 VSS.n614 0.0108877
R3699 VSS.n599 VSS.n354 0.0108877
R3700 VSS.n593 VSS.n592 0.0108877
R3701 VSS.n362 VSS.n322 0.0101032
R3702 VSS.n619 VSS.n322 0.0101032
R3703 VSS.n597 VSS.n355 0.00981217
R3704 VSS.n597 VSS.n596 0.00981217
R3705 VSS.n565 VSS.n513 0.00963963
R3706 VSS.n326 VSS.n309 0.00936111
R3707 VSS.n349 VSS.n266 0.00936111
R3708 VSS.n486 VSS.n485 0.00931464
R3709 VSS.n329 VSS.n306 0.00813889
R3710 VSS.n346 VSS.n260 0.00813889
R3711 VSS.n567 VSS 0.00813889
R3712 VSS VSS.n0 0.00813889
R3713 VSS.n562 VSS.n549 0.00798582
R3714 VSS.n562 VSS.n548 0.00798582
R3715 VSS.n545 VSS.n531 0.00798582
R3716 VSS.n545 VSS.n532 0.00798582
R3717 VSS.n480 VSS.n479 0.00798582
R3718 VSS.n481 VSS.n480 0.00798582
R3719 VSS.n462 VSS.n458 0.00798582
R3720 VSS.n462 VSS.n459 0.00798582
R3721 VSS.n564 VSS.n563 0.00756994
R3722 VSS.n563 VSS.n549 0.00756994
R3723 VSS.n551 VSS.n548 0.00756994
R3724 VSS.n533 VSS.n530 0.00756994
R3725 VSS.n533 VSS.n531 0.00756994
R3726 VSS.n546 VSS.n532 0.00756994
R3727 VSS.n479 VSS.n129 0.00756994
R3728 VSS.n482 VSS.n481 0.00756994
R3729 VSS.n483 VSS.n482 0.00756994
R3730 VSS.n460 VSS.n458 0.00756994
R3731 VSS.n461 VSS.n459 0.00756994
R3732 VSS.n461 VSS.n457 0.00756994
R3733 VSS.n633 VSS.n632 0.00722345
R3734 VSS.n332 VSS.n303 0.00691667
R3735 VSS.n606 VSS.n242 0.00691667
R3736 VSS.n343 VSS.n254 0.00691667
R3737 VSS.n597 VSS.n276 0.00630556
R3738 VSS.n365 VSS.n314 0.00619286
R3739 VSS.n376 VSS.n309 0.00619286
R3740 VSS.n384 VSS.n306 0.00619286
R3741 VSS.n392 VSS.n303 0.00619286
R3742 VSS.n400 VSS.n300 0.00619286
R3743 VSS.n408 VSS.n297 0.00619286
R3744 VSS.n416 VSS.n294 0.00619286
R3745 VSS.n424 VSS.n291 0.00619286
R3746 VSS.n432 VSS.n288 0.00619286
R3747 VSS.n440 VSS.n285 0.00619286
R3748 VSS.n450 VSS.n276 0.00619286
R3749 VSS.n438 VSS.n266 0.00619286
R3750 VSS.n430 VSS.n260 0.00619286
R3751 VSS.n422 VSS.n254 0.00619286
R3752 VSS.n414 VSS.n248 0.00619286
R3753 VSS.n406 VSS.n242 0.00619286
R3754 VSS.n398 VSS.n236 0.00619286
R3755 VSS.n390 VSS.n230 0.00619286
R3756 VSS.n382 VSS.n224 0.00619286
R3757 VSS.n374 VSS.n218 0.00619286
R3758 VSS.n322 VSS.n314 0.00615278
R3759 VSS.n335 VSS.n236 0.00569444
R3760 VSS.n335 VSS.n300 0.00569444
R3761 VSS.n340 VSS.n248 0.00569444
R3762 VSS.n340 VSS.n294 0.00569444
R3763 VSS.n332 VSS.n230 0.00447222
R3764 VSS.n343 VSS.n291 0.00447222
R3765 VSS.n606 VSS 0.00431944
R3766 VSS.n624 VSS.n138 0.00431218
R3767 VSS.n568 VSS.n567 0.00384321
R3768 VSS.n471 VSS.n0 0.00384321
R3769 VSS.n565 VSS.n547 0.00378454
R3770 VSS.n565 VSS.n132 0.00354707
R3771 VSS.n329 VSS.n224 0.00325
R3772 VSS.n346 VSS.n288 0.00325
R3773 VSS VSS.n297 0.00309722
R3774 VSS.n591 VSS.n590 0.00308638
R3775 VSS.n607 VSS.n606 0.00243172
R3776 VSS.n565 VSS.n499 0.0024062
R3777 VSS.n326 VSS.n218 0.00202778
R3778 VSS.n349 VSS.n285 0.00202778
R3779 VSS.n581 VSS.n580 0.00174764
R3780 VSS.n582 VSS.n74 0.00166667
R3781 VSS.n278 VSS.n135 0.00166667
R3782 VSS.n565 VSS.n453 0.0013917
R3783 VSS.n621 VSS.n135 0.00133332
R3784 VSS.n636 VSS.n74 0.00133332
R3785 VSS.n633 VSS.n127 0.001
R3786 VSS.n455 VSS.n454 0.001
R3787 VSS.n583 VSS.n456 0.001
R3788 VSS.n586 VSS.n139 0.001
R3789 VSS.n587 VSS.n586 0.001
R3790 VSS.n588 VSS.n321 0.001
R3791 VSS.n320 VSS.n318 0.001
R3792 VSS.n625 VSS.n137 0.001
R3793 VSS.n137 VSS.n133 0.001
R3794 VSS.n279 VSS.n134 0.001
R3795 VSS.n625 VSS.n624 0.001
R3796 VSS.n624 VSS.n139 0.001
R3797 VSS.n587 VSS.n321 0.001
R3798 VSS.n588 VSS.n320 0.001
R3799 VSS.n621 VSS.n318 0.001
R3800 VSS.n278 VSS.n134 0.001
R3801 VSS.n279 VSS.n133 0.001
R3802 VSS.n633 VSS.n81 0.001
R3803 VSS.n630 VSS.n629 0.001
R3804 VSS.n131 VSS.n130 0.001
R3805 VSS.n636 VSS.n41 0.001
R3806 VSS.n484 VSS.n41 0.001
R3807 VSS.n484 VSS.n131 0.001
R3808 VSS.n629 VSS.n130 0.001
R3809 VSS.n630 VSS.n81 0.001
R3810 VSS.n454 VSS.n127 0.001
R3811 VSS.n456 VSS.n455 0.001
R3812 VSS.n583 VSS.n582 0.001
C0 vin4 VDD 29.2329f
C1 vin4 vin3 0.05053f
C2 vin4 vout4 18.2968f
C3 vout1 VDD 15.3949f
C4 vout3 VDD 15.3834f
C5 vin1 VDD 29.2329f
C6 vin3 VDD 29.202f
C7 vout2 VDD 15.3834f
C8 vout4 VDD 15.3949f
C9 vin2 VDD 29.202f
C10 vin1 vout1 18.2968f
C11 vin3 vout3 18.2968f
C12 vin2 vin1 0.05053f
C13 vin3 vin2 0.05785f
C14 vin2 vout2 18.2968f
C15 vout1 VSS 8.36734f
C16 vin1 VSS 19.17327f
C17 vout2 VSS 8.3656f
C18 vin2 VSS 19.13979f
C19 vout3 VSS 8.3656f
C20 vin3 VSS 19.13979f
C21 vout4 VSS 8.36734f
C22 vin4 VSS 19.17327f
C23 VDD VSS 26.03386f
C24 VDD.n0 VSS 0.1336f
C25 VDD.n2 VSS 0.06317f
C26 VDD.n4 VSS 0.01115f
C27 VDD.n51 VSS 0.01115f
C28 VDD.n126 VSS 0.01053f
C29 VDD.n127 VSS 0.1072f
C30 VDD.n128 VSS 0.02594f
C31 VDD.n129 VSS 0.03276f
C32 VDD.n131 VSS 0.02423f
C33 VDD.n132 VSS 0.02423f
C34 VDD.n133 VSS 0.02423f
C35 VDD.n134 VSS 0.02457f
C36 VDD.n135 VSS 0.02423f
C37 VDD.n136 VSS 0.02423f
C38 VDD.n137 VSS 0.02423f
C39 VDD.n138 VSS 0.02423f
C40 VDD.n139 VSS 0.02423f
C41 VDD.n140 VSS 0.02423f
C42 VDD.n141 VSS 0.02457f
C43 VDD.n142 VSS 0.02423f
C44 VDD.n143 VSS 0.02423f
C45 VDD.n145 VSS 0.39814f
C46 VDD.n146 VSS 0.02355f
C47 VDD.t61 VSS 0.21099f
C48 VDD.n147 VSS 0.02321f
C49 VDD.n148 VSS 0.02321f
C50 VDD.n150 VSS 0.02321f
C51 VDD.n151 VSS 0.60573f
C52 VDD.n152 VSS 0.02594f
C53 VDD.n153 VSS 0.01053f
C54 VDD.n154 VSS 0.02321f
C55 VDD.n155 VSS 0.02321f
C56 VDD.n156 VSS 0.02321f
C57 VDD.n157 VSS 0.02423f
C58 VDD.n158 VSS 0.01053f
C59 VDD.n159 VSS 0.02423f
C60 VDD.n160 VSS 0.02321f
C61 VDD.n161 VSS 0.02457f
C62 VDD.n162 VSS 0.01053f
C63 VDD.n163 VSS 0.02423f
C64 VDD.n164 VSS 0.02321f
C65 VDD.n165 VSS 0.02423f
C66 VDD.n166 VSS 0.01053f
C67 VDD.n167 VSS 0.02423f
C68 VDD.n168 VSS 0.04585f
C69 VDD.n170 VSS 0.04585f
C70 VDD.n171 VSS 0.01171f
C71 VDD.n172 VSS 0.01053f
C72 VDD.n174 VSS 0.02594f
C73 VDD.n175 VSS 0.01053f
C74 VDD.n177 VSS 0.01053f
C75 VDD.n179 VSS 0.01053f
C76 VDD.n181 VSS 0.01053f
C77 VDD.n183 VSS 0.01053f
C78 VDD.n185 VSS 0.01053f
C79 VDD.t39 VSS 0.12546f
C80 VDD.n187 VSS 0.22913f
C81 VDD.t59 VSS 0.12546f
C82 VDD.n188 VSS 0.22913f
C83 VDD.n189 VSS 0.01053f
C84 VDD.n191 VSS 0.01053f
C85 VDD.n193 VSS 0.01053f
C86 VDD.n195 VSS 0.01053f
C87 VDD.t37 VSS 0.12546f
C88 VDD.n197 VSS 0.22913f
C89 VDD.t57 VSS 0.12546f
C90 VDD.n198 VSS 0.22913f
C91 VDD.n199 VSS 0.01053f
C92 VDD.n201 VSS 0.01053f
C93 VDD.n203 VSS 0.01053f
C94 VDD.n205 VSS 0.01053f
C95 VDD.t35 VSS 0.12546f
C96 VDD.n207 VSS 0.22913f
C97 VDD.t55 VSS 0.12546f
C98 VDD.n208 VSS 0.22913f
C99 VDD.n209 VSS 0.01053f
C100 VDD.n211 VSS 0.01053f
C101 VDD.n213 VSS 0.01053f
C102 VDD.n215 VSS 0.01053f
C103 VDD.t33 VSS 0.12546f
C104 VDD.n217 VSS 0.22913f
C105 VDD.n218 VSS 0.82319f
C106 VDD.n219 VSS 0.72912f
C107 VDD.n220 VSS 0.72912f
C108 VDD.t51 VSS 0.12546f
C109 VDD.n221 VSS 0.22913f
C110 VDD.t31 VSS 0.18484f
C111 VDD.n222 VSS 0.16975f
C112 VDD.t49 VSS 0.12546f
C113 VDD.n223 VSS 0.22913f
C114 VDD.t29 VSS 0.12546f
C115 VDD.n224 VSS 0.22913f
C116 VDD.t47 VSS 0.12546f
C117 VDD.n225 VSS 0.22913f
C118 VDD.t27 VSS 0.12546f
C119 VDD.n226 VSS 0.22913f
C120 VDD.t45 VSS 0.12546f
C121 VDD.n227 VSS 0.22913f
C122 VDD.t25 VSS 0.12546f
C123 VDD.n228 VSS 0.22913f
C124 VDD.t43 VSS 0.12546f
C125 VDD.n229 VSS 0.22913f
C126 VDD.t23 VSS 0.12546f
C127 VDD.n230 VSS 0.22913f
C128 VDD.n231 VSS 0.24981f
C129 VDD.n232 VSS 0.02321f
C130 VDD.n233 VSS 0.02321f
C131 VDD.n234 VSS 0.02423f
C132 VDD.t22 VSS 0.11768f
C133 VDD.n235 VSS 0.04612f
C134 VDD.n236 VSS 0.02321f
C135 VDD.n237 VSS 0.02321f
C136 VDD.n239 VSS 0.02321f
C137 VDD.n240 VSS 0.02321f
C138 VDD.n241 VSS 0.02321f
C139 VDD.n242 VSS 0.01053f
C140 VDD.n243 VSS 0.02423f
C141 VDD.n244 VSS 0.02321f
C142 VDD.n245 VSS 0.02423f
C143 VDD.n246 VSS 0.01239f
C144 VDD.n247 VSS 0.02423f
C145 VDD.n248 VSS 0.02457f
C146 VDD.n249 VSS 0.01053f
C147 VDD.n250 VSS 0.02423f
C148 VDD.n251 VSS 0.02321f
C149 VDD.n252 VSS 0.02423f
C150 VDD.n253 VSS 0.0314f
C151 VDD.n254 VSS 0.01239f
C152 VDD.n255 VSS 0.02423f
C153 VDD.n256 VSS 0.02321f
C154 VDD.n257 VSS 0.02457f
C155 VDD.n258 VSS 0.01053f
C156 VDD.n259 VSS 0.02423f
C157 VDD.n260 VSS 0.02321f
C158 VDD.n261 VSS 0.02423f
C159 VDD.n262 VSS 0.01053f
C160 VDD.n263 VSS 0.02423f
C161 VDD.n264 VSS 0.02321f
C162 VDD.n265 VSS 0.02632f
C163 VDD.n266 VSS 0.02389f
C164 VDD.t41 VSS 0.21099f
C165 VDD.n267 VSS 0.02355f
C166 VDD.n268 VSS 0.02321f
C167 VDD.n269 VSS 0.02321f
C168 VDD.n271 VSS 0.24981f
C169 VDD.n272 VSS 0.02321f
C170 VDD.n273 VSS 0.02321f
C171 VDD.n274 VSS 0.02321f
C172 VDD.n275 VSS 0.01053f
C173 VDD.n276 VSS 0.69351f
C174 VDD.t95 VSS 0.32516f
C175 VDD.n277 VSS 0.02321f
C176 VDD.n279 VSS 0.03276f
C177 VDD.n280 VSS 0.04585f
C178 VDD.n282 VSS 0.04585f
C179 VDD.n283 VSS 0.02423f
C180 VDD.n284 VSS 0.01053f
C181 VDD.n285 VSS 0.02423f
C182 VDD.n286 VSS 0.02321f
C183 VDD.n287 VSS 0.02423f
C184 VDD.n288 VSS 0.01053f
C185 VDD.n289 VSS 0.02457f
C186 VDD.n290 VSS 0.02321f
C187 VDD.n291 VSS 0.02423f
C188 VDD.n292 VSS 0.01053f
C189 VDD.n293 VSS 0.02423f
C190 VDD.n294 VSS 0.02321f
C191 VDD.n295 VSS 0.02423f
C192 VDD.n296 VSS 0.01425f
C193 VDD.n297 VSS 0.04578f
C194 VDD.n298 VSS 0.02321f
C195 VDD.n299 VSS 0.02423f
C196 VDD.n300 VSS 0.01053f
C197 VDD.n301 VSS 0.02423f
C198 VDD.n302 VSS 0.02321f
C199 VDD.n303 VSS 0.02457f
C200 VDD.n304 VSS 0.01053f
C201 VDD.n305 VSS 0.02423f
C202 VDD.n306 VSS 0.02321f
C203 VDD.n307 VSS 0.01053f
C204 VDD.n308 VSS 0.02423f
C205 VDD.n309 VSS 0.02321f
C206 VDD.n310 VSS 0.01198f
C207 VDD.n311 VSS 0.02705f
C208 VDD.n312 VSS 0.06753f
C209 VDD.n313 VSS 0.38753f
C210 VDD.n314 VSS 0.51716f
C211 VDD.n316 VSS 0.11085f
C212 VDD.t94 VSS 0.10529f
C213 VDD.n317 VSS 0.02321f
C214 VDD.n318 VSS 0.02423f
C215 VDD.n319 VSS 0.01053f
C216 VDD.n320 VSS 0.02389f
C217 VDD.n321 VSS 0.02389f
C218 VDD.n322 VSS 0.01053f
C219 VDD.n323 VSS 0.03276f
C220 VDD.t92 VSS 0.32516f
C221 VDD.n324 VSS 0.01053f
C222 VDD.n326 VSS 0.01053f
C223 VDD.n328 VSS 0.01053f
C224 VDD.n330 VSS 0.01053f
C225 VDD.n332 VSS 0.01053f
C226 VDD.n334 VSS 0.01053f
C227 VDD.n336 VSS 0.01053f
C228 VDD.n338 VSS 0.01053f
C229 VDD.n340 VSS 0.01053f
C230 VDD.n342 VSS 0.01053f
C231 VDD.n344 VSS 0.01053f
C232 VDD.n346 VSS 0.01053f
C233 VDD.n348 VSS 0.01053f
C234 VDD.n350 VSS 0.01053f
C235 VDD.n352 VSS 0.01053f
C236 VDD.n354 VSS 0.01053f
C237 VDD.n356 VSS 0.01053f
C238 VDD.n358 VSS 0.01053f
C239 VDD.n360 VSS 0.01053f
C240 VDD.n362 VSS 0.01053f
C241 VDD.n364 VSS 0.01053f
C242 VDD.n366 VSS 0.06317f
C243 VDD.n367 VSS 0.01053f
C244 VDD.n368 VSS 0.06317f
C245 VDD.n369 VSS 0.06317f
C246 VDD.n370 VSS 0.01053f
C247 VDD.n371 VSS 0.06317f
C248 VDD.n372 VSS 0.06317f
C249 VDD.n373 VSS 0.01053f
C250 VDD.n374 VSS 0.04738f
C251 VDD.n375 VSS 0.13407f
C252 VDD.n376 VSS 0.04738f
C253 VDD.n377 VSS 0.01053f
C254 VDD.n378 VSS 0.06317f
C255 VDD.n379 VSS 0.06317f
C256 VDD.n380 VSS 0.01053f
C257 VDD.n381 VSS 0.06317f
C258 VDD.n382 VSS 0.06317f
C259 VDD.n383 VSS 0.01053f
C260 VDD.n384 VSS 0.06317f
C261 VDD.n385 VSS 0.06317f
C262 VDD.n386 VSS 0.01053f
C263 VDD.n387 VSS 0.0511f
C264 VDD.n388 VSS 0.13407f
C265 VDD.n389 VSS 0.04366f
C266 VDD.n390 VSS 0.01053f
C267 VDD.n391 VSS 0.06317f
C268 VDD.n392 VSS 0.06317f
C269 VDD.n393 VSS 0.01053f
C270 VDD.n394 VSS 0.06317f
C271 VDD.n395 VSS 0.06317f
C272 VDD.n396 VSS 0.01053f
C273 VDD.n397 VSS 0.06317f
C274 VDD.n398 VSS 0.06317f
C275 VDD.n399 VSS 0.01053f
C276 VDD.n400 VSS 0.05481f
C277 VDD.n401 VSS 0.13407f
C278 VDD.n402 VSS 0.03995f
C279 VDD.n403 VSS 0.01053f
C280 VDD.n404 VSS 0.06317f
C281 VDD.n405 VSS 0.06317f
C282 VDD.n406 VSS 0.01053f
C283 VDD.n407 VSS 0.06317f
C284 VDD.n408 VSS 0.06317f
C285 VDD.n409 VSS 0.01053f
C286 VDD.n410 VSS 0.06317f
C287 VDD.n411 VSS 0.06317f
C288 VDD.n412 VSS 0.01053f
C289 VDD.n413 VSS 0.05853f
C290 VDD.n414 VSS 0.13407f
C291 VDD.n415 VSS 0.03623f
C292 VDD.n416 VSS 0.01053f
C293 VDD.n417 VSS 0.06317f
C294 VDD.n418 VSS 0.06317f
C295 VDD.n419 VSS 0.01053f
C296 VDD.n420 VSS 0.06317f
C297 VDD.n421 VSS 0.06317f
C298 VDD.n422 VSS 0.01053f
C299 VDD.n423 VSS 0.06317f
C300 VDD.n424 VSS 0.06317f
C301 VDD.n425 VSS 0.01053f
C302 VDD.n426 VSS 0.06317f
C303 VDD.n427 VSS 0.06317f
C304 VDD.n428 VSS 0.01053f
C305 VDD.n429 VSS 0.06317f
C306 VDD.n430 VSS 0.06317f
C307 VDD.n431 VSS 0.01053f
C308 VDD.n432 VSS 0.04924f
C309 VDD.n433 VSS 0.01053f
C310 VDD.n435 VSS 0.07856f
C311 VDD.n436 VSS 0.01053f
C312 VDD.n437 VSS 0.04552f
C313 VDD.n438 VSS 0.05752f
C314 VDD.n439 VSS 0.01581f
C315 VDD.n440 VSS 0.02594f
C316 VDD.n441 VSS 0.02321f
C317 VDD.n442 VSS 0.69351f
C318 VDD.t42 VSS 0.11768f
C319 VDD.n443 VSS 0.0314f
C320 VDD.n444 VSS 0.04585f
C321 VDD.n445 VSS 0.04585f
C322 VDD.n446 VSS 0.02321f
C323 VDD.n447 VSS 0.02321f
C324 VDD.n448 VSS 0.02321f
C325 VDD.n449 VSS 0.02321f
C326 VDD.n450 VSS 0.02321f
C327 VDD.n451 VSS 0.02321f
C328 VDD.n452 VSS 0.02321f
C329 VDD.n453 VSS 0.02321f
C330 VDD.n454 VSS 0.02321f
C331 VDD.n455 VSS 0.02321f
C332 VDD.n456 VSS 0.02321f
C333 VDD.n457 VSS 0.04612f
C334 VDD.n458 VSS 0.11118f
C335 VDD.t99 VSS 0.10529f
C336 VDD.n460 VSS 0.24981f
C337 VDD.t97 VSS 0.32516f
C338 VDD.n461 VSS 0.02321f
C339 VDD.n462 VSS 0.69351f
C340 VDD.n463 VSS 0.60534f
C341 VDD.n464 VSS 0.82357f
C342 VDD.n465 VSS 0.72912f
C343 VDD.n466 VSS 0.72912f
C344 VDD.n467 VSS 0.72912f
C345 VDD.n468 VSS 11.0329f
C346 VDD.t71 VSS 0.12546f
C347 VDD.n469 VSS 0.22913f
C348 VDD.n470 VSS 0.72912f
C349 VDD.t10 VSS 0.18484f
C350 VDD.n471 VSS 0.16975f
C351 VDD.t69 VSS 0.12546f
C352 VDD.n472 VSS 0.22913f
C353 VDD.t8 VSS 0.12546f
C354 VDD.n473 VSS 0.22913f
C355 VDD.t67 VSS 0.12546f
C356 VDD.n474 VSS 0.22913f
C357 VDD.t6 VSS 0.12546f
C358 VDD.n475 VSS 0.22913f
C359 VDD.t65 VSS 0.12546f
C360 VDD.n476 VSS 0.22913f
C361 VDD.t4 VSS 0.12546f
C362 VDD.n477 VSS 0.22913f
C363 VDD.t63 VSS 0.12546f
C364 VDD.n478 VSS 0.22913f
C365 VDD.t2 VSS 0.12546f
C366 VDD.n479 VSS 0.22913f
C367 VDD.n480 VSS 0.69351f
C368 VDD.n481 VSS 0.24981f
C369 VDD.n482 VSS 0.02594f
C370 VDD.t87 VSS 0.32516f
C371 VDD.n483 VSS 0.04585f
C372 VDD.n484 VSS 0.1072f
C373 VDD.n487 VSS 0.02423f
C374 VDD.n488 VSS 0.02423f
C375 VDD.n489 VSS 0.02423f
C376 VDD.n490 VSS 0.02457f
C377 VDD.n491 VSS 0.02423f
C378 VDD.n492 VSS 0.02423f
C379 VDD.n493 VSS 0.02423f
C380 VDD.n494 VSS 0.02423f
C381 VDD.n495 VSS 0.02423f
C382 VDD.n496 VSS 0.02423f
C383 VDD.n497 VSS 0.02457f
C384 VDD.n498 VSS 0.02423f
C385 VDD.n499 VSS 0.02423f
C386 VDD.t89 VSS 0.10529f
C387 VDD.n501 VSS 0.04612f
C388 VDD.n502 VSS 0.02321f
C389 VDD.n503 VSS 0.02321f
C390 VDD.n504 VSS 0.02321f
C391 VDD.n505 VSS 0.02321f
C392 VDD.n506 VSS 0.02321f
C393 VDD.n508 VSS 0.0314f
C394 VDD.n509 VSS 0.02321f
C395 VDD.n510 VSS 0.02321f
C396 VDD.n511 VSS 0.02321f
C397 VDD.n512 VSS 0.02321f
C398 VDD.n513 VSS 0.02321f
C399 VDD.n514 VSS 0.02321f
C400 VDD.n515 VSS 0.04585f
C401 VDD.t62 VSS 0.11768f
C402 VDD.n516 VSS 0.11091f
C403 VDD.n517 VSS 0.39219f
C404 VDD.n518 VSS 0.01053f
C405 VDD.n640 VSS 0.02594f
C406 VDD.n641 VSS 0.01053f
C407 VDD.t84 VSS 0.10529f
C408 VDD.n643 VSS 0.04773f
C409 VDD.n644 VSS 0.04585f
C410 VDD.n645 VSS 0.02321f
C411 VDD.n646 VSS 0.02423f
C412 VDD.n647 VSS 0.01053f
C413 VDD.n648 VSS 0.02423f
C414 VDD.n649 VSS 0.02321f
C415 VDD.n650 VSS 0.02321f
C416 VDD.n651 VSS 0.02423f
C417 VDD.n652 VSS 0.01053f
C418 VDD.n653 VSS 0.02457f
C419 VDD.n654 VSS 0.02321f
C420 VDD.n655 VSS 0.02321f
C421 VDD.n656 VSS 0.02423f
C422 VDD.n657 VSS 0.01053f
C423 VDD.n658 VSS 0.02423f
C424 VDD.n659 VSS 0.02321f
C425 VDD.n660 VSS 0.24981f
C426 VDD.n662 VSS 0.0314f
C427 VDD.n663 VSS 0.02423f
C428 VDD.n664 VSS 0.01425f
C429 VDD.n665 VSS 0.02423f
C430 VDD.n666 VSS 0.02321f
C431 VDD.n667 VSS 0.02321f
C432 VDD.n668 VSS 0.02423f
C433 VDD.n669 VSS 0.01053f
C434 VDD.n670 VSS 0.02423f
C435 VDD.n671 VSS 0.02321f
C436 VDD.n672 VSS 0.02321f
C437 VDD.n673 VSS 0.02457f
C438 VDD.n674 VSS 0.01053f
C439 VDD.n675 VSS 0.02423f
C440 VDD.n676 VSS 0.02321f
C441 VDD.n678 VSS 0.51189f
C442 VDD.n679 VSS 0.01053f
C443 VDD.t20 VSS 0.21099f
C444 VDD.n681 VSS 0.02321f
C445 VDD.n682 VSS 0.02321f
C446 VDD.n683 VSS 0.02321f
C447 VDD.n684 VSS 0.02423f
C448 VDD.n685 VSS 0.60573f
C449 VDD.n686 VSS 0.02321f
C450 VDD.n687 VSS 0.02321f
C451 VDD.n688 VSS 0.02321f
C452 VDD.n689 VSS 0.02321f
C453 VDD.n690 VSS 0.02321f
C454 VDD.n691 VSS 0.01239f
C455 VDD.n692 VSS 0.02423f
C456 VDD.n693 VSS 0.02321f
C457 VDD.n694 VSS 0.02423f
C458 VDD.n695 VSS 0.01053f
C459 VDD.n696 VSS 0.02457f
C460 VDD.n697 VSS 0.02321f
C461 VDD.n698 VSS 0.02423f
C462 VDD.n699 VSS 0.01053f
C463 VDD.n700 VSS 0.02423f
C464 VDD.n701 VSS 0.02321f
C465 VDD.n702 VSS 0.02423f
C466 VDD.n703 VSS 0.01053f
C467 VDD.n704 VSS 0.02389f
C468 VDD.n705 VSS 0.02389f
C469 VDD.n706 VSS 0.01053f
C470 VDD.n707 VSS 0.03276f
C471 VDD.n708 VSS 0.01053f
C472 VDD.n710 VSS 0.01053f
C473 VDD.n712 VSS 0.01053f
C474 VDD.n714 VSS 0.01053f
C475 VDD.n716 VSS 0.01053f
C476 VDD.n718 VSS 0.01053f
C477 VDD.t18 VSS 0.12546f
C478 VDD.n720 VSS 0.22913f
C479 VDD.t79 VSS 0.12546f
C480 VDD.n721 VSS 0.22913f
C481 VDD.n722 VSS 0.01053f
C482 VDD.n724 VSS 0.01053f
C483 VDD.n726 VSS 0.01053f
C484 VDD.n728 VSS 0.01053f
C485 VDD.t16 VSS 0.12546f
C486 VDD.n730 VSS 0.22913f
C487 VDD.t77 VSS 0.12546f
C488 VDD.n731 VSS 0.22913f
C489 VDD.n732 VSS 0.01053f
C490 VDD.n734 VSS 0.01053f
C491 VDD.n736 VSS 0.01053f
C492 VDD.n738 VSS 0.01053f
C493 VDD.t14 VSS 0.12546f
C494 VDD.n740 VSS 0.22913f
C495 VDD.n741 VSS 0.82319f
C496 VDD.n742 VSS 0.72912f
C497 VDD.n743 VSS 0.72912f
C498 VDD.t75 VSS 0.12546f
C499 VDD.n744 VSS 0.22913f
C500 VDD.n745 VSS 0.01053f
C501 VDD.n747 VSS 0.01053f
C502 VDD.n749 VSS 0.01053f
C503 VDD.n751 VSS 0.01053f
C504 VDD.t12 VSS 0.12546f
C505 VDD.n753 VSS 0.22913f
C506 VDD.t73 VSS 0.12546f
C507 VDD.n754 VSS 0.22913f
C508 VDD.n755 VSS 0.01053f
C509 VDD.n757 VSS 0.01053f
C510 VDD.n759 VSS 0.01053f
C511 VDD.n761 VSS 0.01115f
C512 VDD.n763 VSS 0.01115f
C513 VDD.n765 VSS 0.01053f
C514 VDD.n767 VSS 0.01053f
C515 VDD.n769 VSS 0.01053f
C516 VDD.n771 VSS 0.01053f
C517 VDD.n773 VSS 0.01053f
C518 VDD.n775 VSS 0.01053f
C519 VDD.n777 VSS 0.01053f
C520 VDD.n779 VSS 0.01053f
C521 VDD.n781 VSS 0.01053f
C522 VDD.n783 VSS 0.01053f
C523 VDD.n785 VSS 0.01053f
C524 VDD.n787 VSS 0.01053f
C525 VDD.n789 VSS 0.01053f
C526 VDD.n791 VSS 0.01053f
C527 VDD.n793 VSS 0.01053f
C528 VDD.n795 VSS 0.01053f
C529 VDD.n797 VSS 0.01053f
C530 VDD.n799 VSS 0.01053f
C531 VDD.n801 VSS 0.01053f
C532 VDD.n803 VSS 0.01053f
C533 VDD.n805 VSS 0.01053f
C534 VDD.n808 VSS 0.07856f
C535 VDD.n809 VSS 0.01053f
C536 VDD.n810 VSS 0.04552f
C537 VDD.n811 VSS 0.05752f
C538 VDD.n812 VSS 0.04924f
C539 VDD.n813 VSS 0.01053f
C540 VDD.n814 VSS 0.06317f
C541 VDD.n815 VSS 0.06317f
C542 VDD.n816 VSS 0.01053f
C543 VDD.n817 VSS 0.06317f
C544 VDD.n818 VSS 0.06317f
C545 VDD.n819 VSS 0.01053f
C546 VDD.n820 VSS 0.06317f
C547 VDD.n821 VSS 0.06317f
C548 VDD.n822 VSS 0.01053f
C549 VDD.n823 VSS 0.06317f
C550 VDD.n824 VSS 0.06317f
C551 VDD.n825 VSS 0.01053f
C552 VDD.n826 VSS 0.06317f
C553 VDD.n827 VSS 0.06317f
C554 VDD.n828 VSS 0.01053f
C555 VDD.n829 VSS 0.03623f
C556 VDD.n830 VSS 0.13407f
C557 VDD.n831 VSS 0.05853f
C558 VDD.n832 VSS 0.01053f
C559 VDD.n833 VSS 0.06317f
C560 VDD.n834 VSS 0.06317f
C561 VDD.n835 VSS 0.01053f
C562 VDD.n836 VSS 0.06317f
C563 VDD.n837 VSS 0.06317f
C564 VDD.n838 VSS 0.01053f
C565 VDD.n839 VSS 0.06317f
C566 VDD.n840 VSS 0.06317f
C567 VDD.n841 VSS 0.01053f
C568 VDD.n842 VSS 0.03995f
C569 VDD.n843 VSS 0.13407f
C570 VDD.n844 VSS 0.05481f
C571 VDD.n845 VSS 0.01053f
C572 VDD.n846 VSS 0.06317f
C573 VDD.n847 VSS 0.06317f
C574 VDD.n848 VSS 0.01053f
C575 VDD.n849 VSS 0.06317f
C576 VDD.n850 VSS 0.06317f
C577 VDD.n851 VSS 0.01053f
C578 VDD.n852 VSS 0.06317f
C579 VDD.n853 VSS 0.06317f
C580 VDD.n854 VSS 0.01053f
C581 VDD.n855 VSS 0.04366f
C582 VDD.n856 VSS 0.13407f
C583 VDD.n857 VSS 0.0511f
C584 VDD.n858 VSS 0.01053f
C585 VDD.n859 VSS 0.06317f
C586 VDD.n860 VSS 0.06317f
C587 VDD.n861 VSS 0.01053f
C588 VDD.n862 VSS 0.06317f
C589 VDD.n863 VSS 0.06317f
C590 VDD.n864 VSS 0.01053f
C591 VDD.n865 VSS 0.06317f
C592 VDD.n866 VSS 0.06317f
C593 VDD.n867 VSS 0.01053f
C594 VDD.n868 VSS 0.04738f
C595 VDD.n869 VSS 0.13407f
C596 VDD.n870 VSS 0.04738f
C597 VDD.n871 VSS 0.01053f
C598 VDD.n872 VSS 0.06317f
C599 VDD.n873 VSS 0.06317f
C600 VDD.n874 VSS 0.01053f
C601 VDD.n875 VSS 0.06317f
C602 VDD.n876 VSS 0.06317f
C603 VDD.n877 VSS 0.01053f
C604 VDD.n878 VSS 0.06317f
C605 VDD.n879 VSS 0.06317f
C606 VDD.n880 VSS 0.01115f
C607 VDD.n881 VSS 0.03948f
C608 VDD.n882 VSS 0.1336f
C609 VDD.n883 VSS 0.0511f
C610 VDD.n884 VSS 0.01115f
C611 VDD.n885 VSS 0.06317f
C612 VDD.n886 VSS 0.06317f
C613 VDD.n887 VSS 0.01053f
C614 VDD.n888 VSS 0.06317f
C615 VDD.n889 VSS 0.06317f
C616 VDD.n890 VSS 0.01053f
C617 VDD.n891 VSS 0.06317f
C618 VDD.n892 VSS 0.06317f
C619 VDD.n893 VSS 0.01053f
C620 VDD.n894 VSS 0.04738f
C621 VDD.n895 VSS 0.13407f
C622 VDD.n896 VSS 0.04738f
C623 VDD.n897 VSS 0.01053f
C624 VDD.n898 VSS 0.06317f
C625 VDD.n899 VSS 0.06317f
C626 VDD.n900 VSS 0.01053f
C627 VDD.n901 VSS 0.06317f
C628 VDD.n902 VSS 0.06317f
C629 VDD.n903 VSS 0.01053f
C630 VDD.n904 VSS 0.06317f
C631 VDD.n905 VSS 0.06317f
C632 VDD.n906 VSS 0.01053f
C633 VDD.n907 VSS 0.0511f
C634 VDD.n908 VSS 0.13407f
C635 VDD.n909 VSS 0.04366f
C636 VDD.n910 VSS 0.01053f
C637 VDD.n911 VSS 0.06317f
C638 VDD.n912 VSS 0.06317f
C639 VDD.n913 VSS 0.01053f
C640 VDD.n914 VSS 0.06317f
C641 VDD.n915 VSS 0.06317f
C642 VDD.n916 VSS 0.01053f
C643 VDD.n917 VSS 0.06317f
C644 VDD.n918 VSS 0.06317f
C645 VDD.n919 VSS 0.01053f
C646 VDD.n920 VSS 0.05481f
C647 VDD.n921 VSS 0.13407f
C648 VDD.n922 VSS 0.03995f
C649 VDD.n923 VSS 0.01053f
C650 VDD.n924 VSS 0.06317f
C651 VDD.n925 VSS 0.06317f
C652 VDD.n926 VSS 0.01053f
C653 VDD.n927 VSS 0.06317f
C654 VDD.n928 VSS 0.06317f
C655 VDD.n929 VSS 0.01053f
C656 VDD.n930 VSS 0.06317f
C657 VDD.n931 VSS 0.06317f
C658 VDD.n932 VSS 0.01053f
C659 VDD.n933 VSS 0.05853f
C660 VDD.n934 VSS 0.13407f
C661 VDD.n935 VSS 0.03623f
C662 VDD.n936 VSS 0.01053f
C663 VDD.n937 VSS 0.06317f
C664 VDD.n938 VSS 0.06317f
C665 VDD.n939 VSS 0.01053f
C666 VDD.n940 VSS 0.06317f
C667 VDD.n941 VSS 0.06317f
C668 VDD.n942 VSS 0.01053f
C669 VDD.n943 VSS 0.06317f
C670 VDD.n944 VSS 0.06317f
C671 VDD.n945 VSS 0.01053f
C672 VDD.n946 VSS 0.06317f
C673 VDD.n947 VSS 0.06317f
C674 VDD.n948 VSS 0.01053f
C675 VDD.n949 VSS 0.06317f
C676 VDD.n950 VSS 0.06317f
C677 VDD.n951 VSS 0.01053f
C678 VDD.n952 VSS 0.04877f
C679 VDD.n953 VSS 0.05752f
C680 VDD.n954 VSS 0.01053f
C681 VDD.n956 VSS 0.04599f
C682 VDD.n957 VSS 0.01053f
C683 VDD.n958 VSS 0.07856f
C684 VDD.n959 VSS 0.69351f
C685 VDD.n960 VSS 0.02321f
C686 VDD.n961 VSS 0.02321f
C687 VDD.n962 VSS 0.02423f
C688 VDD.n963 VSS 0.01198f
C689 VDD.n964 VSS 0.02321f
C690 VDD.n965 VSS 0.01053f
C691 VDD.n966 VSS 0.02423f
C692 VDD.n967 VSS 0.02321f
C693 VDD.n968 VSS 0.02321f
C694 VDD.n969 VSS 0.02457f
C695 VDD.n970 VSS 0.01053f
C696 VDD.n971 VSS 0.02423f
C697 VDD.n972 VSS 0.02321f
C698 VDD.n973 VSS 0.02321f
C699 VDD.n974 VSS 0.02423f
C700 VDD.n975 VSS 0.01239f
C701 VDD.n976 VSS 0.02423f
C702 VDD.n977 VSS 0.24981f
C703 VDD.n979 VSS 0.02321f
C704 VDD.n980 VSS 0.04578f
C705 VDD.n981 VSS 0.01239f
C706 VDD.n982 VSS 0.02423f
C707 VDD.n983 VSS 0.02321f
C708 VDD.n984 VSS 0.02321f
C709 VDD.n985 VSS 0.02423f
C710 VDD.n986 VSS 0.01053f
C711 VDD.n987 VSS 0.02457f
C712 VDD.n988 VSS 0.02321f
C713 VDD.n989 VSS 0.02423f
C714 VDD.n990 VSS 0.0199f
C715 VDD.n991 VSS 0.06598f
C716 VDD.n992 VSS 0.04653f
C717 VDD.n994 VSS 0.04613f
C718 VDD.n995 VSS 0.01053f
C719 VDD.n996 VSS 0.02423f
C720 VDD.n997 VSS 0.02321f
C721 VDD.t81 VSS 0.21099f
C722 VDD.n998 VSS 0.02321f
C723 VDD.n999 VSS 0.02423f
C724 VDD.n1000 VSS 0.01053f
C725 VDD.n1001 VSS 0.02389f
C726 VDD.n1002 VSS 0.02389f
C727 VDD.n1003 VSS 0.01053f
C728 VDD.n1004 VSS 0.03276f
C729 VDD.t90 VSS 0.32516f
C730 VDD.n1005 VSS 0.02321f
C731 VDD.n1006 VSS 0.02594f
C732 VDD.n1007 VSS 0.01582f
C733 VDD.n1008 VSS 0.1072f
C734 VDD.n1009 VSS 0.01581f
C735 VDD.n1010 VSS 0.02594f
C736 VDD.t85 VSS 0.32516f
C737 VDD.n1011 VSS 0.02321f
C738 VDD.n1012 VSS 0.69351f
C739 VDD.n1013 VSS 0.24981f
C740 VDD.n1015 VSS 0.04578f
C741 VDD.n1016 VSS 0.01239f
C742 VDD.n1017 VSS 0.02423f
C743 VDD.n1018 VSS 0.02321f
C744 VDD.n1019 VSS 0.02423f
C745 VDD.n1020 VSS 0.01053f
C746 VDD.n1021 VSS 0.02457f
C747 VDD.n1022 VSS 0.02321f
C748 VDD.n1023 VSS 0.02423f
C749 VDD.n1024 VSS 0.01053f
C750 VDD.n1025 VSS 0.02423f
C751 VDD.n1026 VSS 0.04613f
C752 VDD.n1027 VSS 0.01198f
C753 VDD.n1028 VSS 0.11488f
C754 VDD.n1029 VSS 0.3857f
C755 VDD.n1030 VSS 0.0673f
C756 VDD.n1031 VSS 0.03159f
C757 VDD.n1032 VSS 0.02423f
C758 VDD.n1033 VSS 0.04612f
C759 VDD.t1 VSS 0.11768f
C760 VDD.n1034 VSS 0.04585f
C761 VDD.t82 VSS 0.32516f
C762 VDD.n1035 VSS 0.02321f
C763 VDD.n1036 VSS 0.03276f
C764 VDD.n1038 VSS 0.01171f
C765 VDD.t0 VSS 34.0086f
C766 VDD.n1041 VSS 0.63261f
C767 VDD.n1042 VSS 0.03276f
C768 VDD.n1043 VSS 0.02321f
C769 VDD.n1044 VSS 0.69351f
C770 VDD.n1045 VSS 0.60534f
C771 VDD.n1046 VSS 0.82357f
C772 VDD.n1047 VSS 0.72912f
C773 VDD.n1048 VSS 0.72912f
C774 VDD.n1049 VSS 0.72912f
C775 VDD.n1050 VSS 0.72912f
C776 VDD.n1051 VSS 6.57351f
C777 VDD.n1052 VSS 10.9328f
C778 VDD.n1053 VSS 2.65785f
C779 VDD.n1054 VSS 7.21523f
C780 VDD.n1055 VSS 0.72912f
C781 VDD.t53 VSS 0.12546f
C782 VDD.n1056 VSS 0.22913f
C783 VDD.n1057 VSS 0.01053f
C784 VDD.n1059 VSS 0.01053f
C785 VDD.n1061 VSS 0.01053f
C786 VDD.n1063 VSS 0.0511f
C787 VDD.n1064 VSS 0.01115f
C788 VDD.n1066 VSS 0.06317f
C789 VDD.n1067 VSS 0.06317f
C790 VDD.n1068 VSS 0.01053f
C791 VDD.n1069 VSS 0.06317f
C792 VDD.n1070 VSS 0.06317f
C793 VDD.n1071 VSS 0.01053f
C794 VDD.n1072 VSS 0.06317f
C795 VDD.n1073 VSS 0.06317f
C796 VDD.n1074 VSS 0.01053f
C797 VDD.n1075 VSS 0.04738f
C798 VDD.n1076 VSS 0.13407f
C799 VDD.n1077 VSS 0.04738f
C800 VDD.n1078 VSS 0.01053f
C801 VDD.n1079 VSS 0.06317f
C802 VDD.n1080 VSS 0.06317f
C803 VDD.n1081 VSS 0.01053f
C804 VDD.n1082 VSS 0.06317f
C805 VDD.n1083 VSS 0.06317f
C806 VDD.n1084 VSS 0.01053f
C807 VDD.n1085 VSS 0.06317f
C808 VDD.n1086 VSS 0.06317f
C809 VDD.n1087 VSS 0.01053f
C810 VDD.n1088 VSS 0.0511f
C811 VDD.n1089 VSS 0.13407f
C812 VDD.n1090 VSS 0.04366f
C813 VDD.n1091 VSS 0.01053f
C814 VDD.n1092 VSS 0.06317f
C815 VDD.n1093 VSS 0.06317f
C816 VDD.n1094 VSS 0.01053f
C817 VDD.n1095 VSS 0.06317f
C818 VDD.n1096 VSS 0.06317f
C819 VDD.n1097 VSS 0.01053f
C820 VDD.n1098 VSS 0.06317f
C821 VDD.n1099 VSS 0.06317f
C822 VDD.n1100 VSS 0.01053f
C823 VDD.n1101 VSS 0.05481f
C824 VDD.n1102 VSS 0.13407f
C825 VDD.n1103 VSS 0.03995f
C826 VDD.n1104 VSS 0.01053f
C827 VDD.n1105 VSS 0.06317f
C828 VDD.n1106 VSS 0.06317f
C829 VDD.n1107 VSS 0.01053f
C830 VDD.n1108 VSS 0.06317f
C831 VDD.n1109 VSS 0.06317f
C832 VDD.n1110 VSS 0.01053f
C833 VDD.n1111 VSS 0.06317f
C834 VDD.n1112 VSS 0.06317f
C835 VDD.n1113 VSS 0.01053f
C836 VDD.n1114 VSS 0.05853f
C837 VDD.n1115 VSS 0.13407f
C838 VDD.n1116 VSS 0.03623f
C839 VDD.n1117 VSS 0.01053f
C840 VDD.n1118 VSS 0.06317f
C841 VDD.n1119 VSS 0.06317f
C842 VDD.n1120 VSS 0.01053f
C843 VDD.n1121 VSS 0.06317f
C844 VDD.n1122 VSS 0.06317f
C845 VDD.n1123 VSS 0.01053f
C846 VDD.n1124 VSS 0.06317f
C847 VDD.n1125 VSS 0.06317f
C848 VDD.n1126 VSS 0.01053f
C849 VDD.n1127 VSS 0.06317f
C850 VDD.n1128 VSS 0.06317f
C851 VDD.n1129 VSS 0.01053f
C852 VDD.n1130 VSS 0.06317f
C853 VDD.n1131 VSS 0.06317f
C854 VDD.n1132 VSS 0.01053f
C855 VDD.n1133 VSS 0.04877f
C856 VDD.n1134 VSS 0.05752f
C857 VDD.n1135 VSS 0.04599f
C858 VDD.n1136 VSS 0.01053f
C859 VDD.n1137 VSS 0.07856f
C860 VDD.n1138 VSS 0.1072f
C861 VDD.n1139 VSS 0.02108f
C862 VDD.n1140 VSS 0.03276f
C863 VDD.t100 VSS 0.32516f
C864 VDD.n1141 VSS 0.02321f
C865 VDD.n1142 VSS 0.69351f
C866 VDD.n1143 VSS 0.24981f
C867 VDD.n1144 VSS 0.02423f
C868 VDD.n1145 VSS 0.01425f
C869 VDD.n1146 VSS 0.04578f
C870 VDD.n1147 VSS 0.02321f
C871 VDD.n1148 VSS 0.02423f
C872 VDD.n1149 VSS 0.01053f
C873 VDD.n1150 VSS 0.02423f
C874 VDD.n1151 VSS 0.02321f
C875 VDD.n1152 VSS 0.02457f
C876 VDD.n1153 VSS 0.01053f
C877 VDD.n1154 VSS 0.02423f
C878 VDD.n1155 VSS 0.02321f
C879 VDD.n1156 VSS 0.02423f
C880 VDD.n1157 VSS 0.02321f
C881 VDD.n1158 VSS 0.01198f
C882 VDD.n1159 VSS 0.08365f
C883 VDD.n1160 VSS 0.02389f
C884 VDD.n1161 VSS 0.64725f
C885 VDD.t21 VSS 34.0086f
C886 VDD.n1164 VSS 0.01115f
C887 VDD.n1165 VSS 0.03948f
C888 vin4.n0 VSS 0.07665f
C889 vin4.n1 VSS 0.32157f
C890 vin4.n2 VSS 0.32157f
C891 vin4.n3 VSS 0.32157f
C892 vin4.n4 VSS 0.32157f
C893 vin4.n5 VSS 0.32157f
C894 vin4.n6 VSS 0.32157f
C895 vin4.n7 VSS 0.32157f
C896 vin4.n8 VSS 0.33985f
C897 vin4.n9 VSS 0.09862f
C898 vin4.n10 VSS 0.07539f
C899 vin4.n11 VSS 0.07539f
C900 vin4.n12 VSS 0.07539f
C901 vin4.n13 VSS 0.07539f
C902 vin4.n14 VSS 0.07539f
C903 vin4.n15 VSS 0.07539f
C904 vin4.t1 VSS 0.37147f
C905 vin4.t2 VSS 6.21692f
C906 vin4.n16 VSS 0.36673f
C907 vin4.n17 VSS 0.83668f
C908 vin4.n18 VSS 3.38277f
C909 vin4.t0 VSS 28.2884f
C910 vin4.n19 VSS 0.85487f
C911 vin4.n20 VSS 0.07539f
C912 vin4.n21 VSS 0.07539f
C913 vin4.n22 VSS 0.07539f
C914 vin4.n23 VSS 0.07539f
C915 vin4.n24 VSS 0.07539f
C916 vin4.n25 VSS 0.07539f
C917 vin4.n26 VSS 0.07539f
C918 vin4.n27 VSS 0.09987f
C919 vin4.n28 VSS 0.29722f
C920 vout4.t16 VSS 0.11212f
C921 vout4.t8 VSS 0.80266f
C922 vout4.t15 VSS 0.11212f
C923 vout4.t9 VSS 0.80266f
C924 vout4.t14 VSS 0.11212f
C925 vout4.t5 VSS 0.80266f
C926 vout4.t13 VSS 0.11212f
C927 vout4.t1 VSS 0.80266f
C928 vout4.t19 VSS 0.11212f
C929 vout4.t0 VSS 0.80266f
C930 vout4.t17 VSS 0.11212f
C931 vout4.t3 VSS 0.7961f
C932 vout4.t11 VSS 0.11212f
C933 vout4.t2 VSS 0.7961f
C934 vout4.t10 VSS 0.11212f
C935 vout4.t4 VSS 0.7961f
C936 vout4.t18 VSS 0.11212f
C937 vout4.t6 VSS 0.7961f
C938 vout4.t12 VSS 0.11212f
C939 vout4.t7 VSS 0.7961f
C940 vout4.n0 VSS 2.04997f
C941 vout4.n1 VSS 2.22049f
C942 vout4.n2 VSS 2.22049f
C943 vout4.n3 VSS 2.22049f
C944 vout4.n4 VSS 2.22049f
C945 vout4.n5 VSS 2.21393f
C946 vout4.n6 VSS 2.21393f
C947 vout4.n7 VSS 2.21393f
C948 vout4.n8 VSS 2.21393f
C949 vout4.n9 VSS 1.97075f
C950 vin3.n0 VSS 0.07669f
C951 vin3.n1 VSS 0.32176f
C952 vin3.n2 VSS 0.32176f
C953 vin3.n3 VSS 0.32176f
C954 vin3.n4 VSS 0.32176f
C955 vin3.n5 VSS 0.32176f
C956 vin3.n6 VSS 0.32176f
C957 vin3.n7 VSS 0.32176f
C958 vin3.n8 VSS 0.34005f
C959 vin3.n9 VSS 0.09868f
C960 vin3.n10 VSS 0.07544f
C961 vin3.n11 VSS 0.07544f
C962 vin3.n12 VSS 0.07544f
C963 vin3.n13 VSS 0.07544f
C964 vin3.n14 VSS 0.07544f
C965 vin3.n15 VSS 0.07544f
C966 vin3.t1 VSS 1.4392f
C967 vin3.t2 VSS 26.5034f
C968 vin3.n16 VSS 0.36694f
C969 vin3.n17 VSS 0.83717f
C970 vin3.n18 VSS 3.38475f
C971 vin3.t0 VSS 6.95456f
C972 vin3.n19 VSS 0.85537f
C973 vin3.n20 VSS 0.07544f
C974 vin3.n21 VSS 0.07544f
C975 vin3.n22 VSS 0.07544f
C976 vin3.n23 VSS 0.07544f
C977 vin3.n24 VSS 0.07544f
C978 vin3.n25 VSS 0.07544f
C979 vin3.n26 VSS 0.07544f
C980 vin3.n27 VSS 0.09993f
C981 vin3.n28 VSS 0.2974f
C982 vout3.t10 VSS 0.80234f
C983 vout3.t7 VSS 0.11208f
C984 vout3.t13 VSS 0.80234f
C985 vout3.t6 VSS 0.11208f
C986 vout3.t12 VSS 0.80234f
C987 vout3.t8 VSS 0.11208f
C988 vout3.t17 VSS 0.80234f
C989 vout3.t5 VSS 0.11208f
C990 vout3.t16 VSS 0.80234f
C991 vout3.t4 VSS 0.11208f
C992 vout3.t19 VSS 0.79584f
C993 vout3.t9 VSS 0.11208f
C994 vout3.t18 VSS 0.79584f
C995 vout3.t1 VSS 0.11208f
C996 vout3.t15 VSS 0.79584f
C997 vout3.t0 VSS 0.11208f
C998 vout3.t14 VSS 0.79584f
C999 vout3.t3 VSS 0.11208f
C1000 vout3.t11 VSS 0.79616f
C1001 vout3.t2 VSS 0.11208f
C1002 vout3.n0 VSS 2.04901f
C1003 vout3.n1 VSS 2.21979f
C1004 vout3.n2 VSS 2.21979f
C1005 vout3.n3 VSS 2.21979f
C1006 vout3.n4 VSS 2.21979f
C1007 vout3.n5 VSS 2.2133f
C1008 vout3.n6 VSS 2.2133f
C1009 vout3.n7 VSS 2.2133f
C1010 vout3.n8 VSS 2.2133f
C1011 vout3.n9 VSS 1.97019f
C1012 vin2.n0 VSS 0.07669f
C1013 vin2.n1 VSS 0.32176f
C1014 vin2.n2 VSS 0.32176f
C1015 vin2.n3 VSS 0.32176f
C1016 vin2.n4 VSS 0.32176f
C1017 vin2.n5 VSS 0.32176f
C1018 vin2.n6 VSS 0.32176f
C1019 vin2.n7 VSS 0.32176f
C1020 vin2.n8 VSS 0.34005f
C1021 vin2.n9 VSS 0.09868f
C1022 vin2.n10 VSS 0.07544f
C1023 vin2.n11 VSS 0.07544f
C1024 vin2.n12 VSS 0.07544f
C1025 vin2.n13 VSS 0.07544f
C1026 vin2.n14 VSS 0.07544f
C1027 vin2.n15 VSS 0.07544f
C1028 vin2.t1 VSS 0.37168f
C1029 vin2.t2 VSS 6.22055f
C1030 vin2.n16 VSS 0.36694f
C1031 vin2.n17 VSS 0.83717f
C1032 vin2.n18 VSS 3.38475f
C1033 vin2.t0 VSS 28.3049f
C1034 vin2.n19 VSS 0.85537f
C1035 vin2.n20 VSS 0.07544f
C1036 vin2.n21 VSS 0.07544f
C1037 vin2.n22 VSS 0.07544f
C1038 vin2.n23 VSS 0.07544f
C1039 vin2.n24 VSS 0.07544f
C1040 vin2.n25 VSS 0.07544f
C1041 vin2.n26 VSS 0.07544f
C1042 vin2.n27 VSS 0.09993f
C1043 vin2.n28 VSS 0.2974f
C1044 vout2.t10 VSS 0.11208f
C1045 vout2.t3 VSS 0.80241f
C1046 vout2.t15 VSS 0.11208f
C1047 vout2.t2 VSS 0.80241f
C1048 vout2.t12 VSS 0.11208f
C1049 vout2.t1 VSS 0.80241f
C1050 vout2.t11 VSS 0.11208f
C1051 vout2.t0 VSS 0.80241f
C1052 vout2.t19 VSS 0.11208f
C1053 vout2.t7 VSS 0.80241f
C1054 vout2.t14 VSS 0.11208f
C1055 vout2.t6 VSS 0.79584f
C1056 vout2.t13 VSS 0.11208f
C1057 vout2.t8 VSS 0.79584f
C1058 vout2.t18 VSS 0.11208f
C1059 vout2.t5 VSS 0.79584f
C1060 vout2.t17 VSS 0.11208f
C1061 vout2.t4 VSS 0.79584f
C1062 vout2.t16 VSS 0.11208f
C1063 vout2.t9 VSS 0.79584f
C1064 vout2.n0 VSS 2.04933f
C1065 vout2.n1 VSS 2.21979f
C1066 vout2.n2 VSS 2.21979f
C1067 vout2.n3 VSS 2.21979f
C1068 vout2.n4 VSS 2.21979f
C1069 vout2.n5 VSS 2.21323f
C1070 vout2.n6 VSS 2.21323f
C1071 vout2.n7 VSS 2.21323f
C1072 vout2.n8 VSS 2.21323f
C1073 vout2.n9 VSS 1.97013f
C1074 vin1.n0 VSS 0.07665f
C1075 vin1.n1 VSS 0.32157f
C1076 vin1.n2 VSS 0.32157f
C1077 vin1.n3 VSS 0.32157f
C1078 vin1.n4 VSS 0.32157f
C1079 vin1.n5 VSS 0.32157f
C1080 vin1.n6 VSS 0.32157f
C1081 vin1.n7 VSS 0.32157f
C1082 vin1.n8 VSS 0.33985f
C1083 vin1.n9 VSS 0.09862f
C1084 vin1.n10 VSS 0.07539f
C1085 vin1.n11 VSS 0.07539f
C1086 vin1.n12 VSS 0.07539f
C1087 vin1.n13 VSS 0.07539f
C1088 vin1.n14 VSS 0.07539f
C1089 vin1.n15 VSS 0.07539f
C1090 vin1.t1 VSS 1.43836f
C1091 vin1.t2 VSS 26.4879f
C1092 vin1.n16 VSS 0.36673f
C1093 vin1.n17 VSS 0.83668f
C1094 vin1.n18 VSS 3.38277f
C1095 vin1.t0 VSS 6.9505f
C1096 vin1.n19 VSS 0.85487f
C1097 vin1.n20 VSS 0.07539f
C1098 vin1.n21 VSS 0.07539f
C1099 vin1.n22 VSS 0.07539f
C1100 vin1.n23 VSS 0.07539f
C1101 vin1.n24 VSS 0.07539f
C1102 vin1.n25 VSS 0.07539f
C1103 vin1.n26 VSS 0.07539f
C1104 vin1.n27 VSS 0.09987f
C1105 vin1.n28 VSS 0.29722f
C1106 vout1.t0 VSS 0.80259f
C1107 vout1.t18 VSS 0.11212f
C1108 vout1.t4 VSS 0.80259f
C1109 vout1.t15 VSS 0.11212f
C1110 vout1.t3 VSS 0.80259f
C1111 vout1.t14 VSS 0.11212f
C1112 vout1.t8 VSS 0.80259f
C1113 vout1.t13 VSS 0.11212f
C1114 vout1.t7 VSS 0.80259f
C1115 vout1.t12 VSS 0.11212f
C1116 vout1.t2 VSS 0.7961f
C1117 vout1.t11 VSS 0.11212f
C1118 vout1.t1 VSS 0.7961f
C1119 vout1.t10 VSS 0.11212f
C1120 vout1.t6 VSS 0.7961f
C1121 vout1.t17 VSS 0.11212f
C1122 vout1.t5 VSS 0.7961f
C1123 vout1.t16 VSS 0.11212f
C1124 vout1.t9 VSS 0.79641f
C1125 vout1.t19 VSS 0.11212f
C1126 vout1.n0 VSS 2.04966f
C1127 vout1.n1 VSS 2.22049f
C1128 vout1.n2 VSS 2.22049f
C1129 vout1.n3 VSS 2.22049f
C1130 vout1.n4 VSS 2.22049f
C1131 vout1.n5 VSS 2.21399f
C1132 vout1.n6 VSS 2.21399f
C1133 vout1.n7 VSS 2.21399f
C1134 vout1.n8 VSS 2.21399f
C1135 vout1.n9 VSS 1.97082f
.ends

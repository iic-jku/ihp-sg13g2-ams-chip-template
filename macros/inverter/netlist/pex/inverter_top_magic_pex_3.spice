* PEX produced on Fri Jul 31 03:30:36 PM CEST 2026 using /foss/tools/sak/sak-pex.sh with m=3 and s=1 (extresist threshold=10000 mOhm, minres=1000 mOhm, mindelay=1 ps)
* NGSPICE file created from inverter_top_pex.ext - technology: ihp-sg13g2

.subckt inverter_top_pex VDD vin4 vout4 VSS vin3 vout3 vin2 vout2 vout1 vin1
X0 vout3 vin3 VSS.t105 VSS.t86 sg13_lv_nmos ad=0.19p pd=1.38u as=0.19p ps=1.38u w=1u l=1u
X1 VDD VDD VDD VDD sg13_lv_pmos ad=1.14p pd=6.38u as=0.56797n ps=1.006m w=6u l=1u
X2 VSS.t1 VSS.t53 VSS.t55 VSS.t54 sg13_lv_nmos ad=0.34p pd=2.68u as=0 ps=0 w=1u l=1u
X3 VDD VDD VDD VDD sg13_lv_pmos ad=1.14p pd=6.38u as=0 ps=0 w=6u l=1u
X4 VDD vin4 vout4 VDD sg13_lv_pmos ad=1.14p pd=6.38u as=1.14p ps=6.38u w=6u l=1u
X5 vout2 vin2 VSS.t76 VSS.t77 sg13_lv_nmos ad=0.19p pd=1.38u as=0.19p ps=1.38u w=1u l=1u
X6 vout3 vin3 VDD VDD sg13_lv_pmos ad=1.14p pd=6.38u as=1.14p ps=6.38u w=6u l=1u
X7 vout4 vin4 VSS.t110 VSS.t111 sg13_lv_nmos ad=0.19p pd=1.38u as=0.19p ps=1.38u w=1u l=1u
X8 vout3 vin3 VSS.t42 VSS.t59 sg13_lv_nmos ad=0.19p pd=1.38u as=0.19p ps=1.38u w=1u l=1u
X9 vout2 vin2 VSS.t70 VSS.t71 sg13_lv_nmos ad=0.19p pd=1.38u as=0.19p ps=1.38u w=1u l=1u
X10 vout4 vin4 VDD VDD sg13_lv_pmos ad=1.14p pd=6.38u as=1.14p ps=6.38u w=6u l=1u
X11 VDD vin2 vout2 VDD sg13_lv_pmos ad=1.14p pd=6.38u as=1.14p ps=6.38u w=6u l=1u
X12 VSS.t76 vin2 vout2 VSS.t75 sg13_lv_nmos ad=0.19p pd=1.38u as=0.19p ps=1.38u w=1u l=1u
X13 vout2 vin2 VSS.t79 VSS.t80 sg13_lv_nmos ad=0.19p pd=1.38u as=0.19p ps=1.38u w=1u l=1u
X14 vout2 vin2 VDD VDD sg13_lv_pmos ad=1.14p pd=6.38u as=1.14p ps=6.38u w=6u l=1u
X15 VSS.t116 vin4 vout4 VSS.t115 sg13_lv_nmos ad=0.19p pd=1.38u as=0.19p ps=1.38u w=1u l=1u
X16 vout1 vin1 VSS.t24 VSS.t25 sg13_lv_nmos ad=0.19p pd=1.38u as=0.19p ps=1.38u w=1u l=1u
X17 VDD vin2 vout2 VDD sg13_lv_pmos ad=1.14p pd=6.38u as=1.14p ps=6.38u w=6u l=1u
X18 vout4 vin4 VSS.t34 VSS.t108 sg13_lv_nmos ad=0.19p pd=1.38u as=0.19p ps=1.38u w=1u l=1u
X19 VDD vin2 vout2 VDD sg13_lv_pmos ad=1.14p pd=6.38u as=1.14p ps=6.38u w=6u l=1u
X20 VSS.t105 vin3 vout3 VSS.t84 sg13_lv_nmos ad=0.19p pd=1.38u as=0.19p ps=1.38u w=1u l=1u
X21 vout4 vin4 VSS.t125 VSS.t126 sg13_lv_nmos ad=0.19p pd=1.38u as=0.19p ps=1.38u w=1u l=1u
X22 VSS.t119 vin4 vout4 VSS.t118 sg13_lv_nmos ad=0.19p pd=1.38u as=0.19p ps=1.38u w=1u l=1u
X23 VDD vin3 vout3 VDD sg13_lv_pmos ad=1.14p pd=6.38u as=1.14p ps=6.38u w=6u l=1u
X24 VDD vin2 vout2 VDD sg13_lv_pmos ad=1.14p pd=6.38u as=1.14p ps=6.38u w=6u l=1u
X25 vout3 vin3 VDD VDD sg13_lv_pmos ad=1.14p pd=6.38u as=1.14p ps=6.38u w=6u l=1u
X26 VSS.t70 vin2 vout2 VSS.t69 sg13_lv_nmos ad=0.19p pd=1.38u as=0.19p ps=1.38u w=1u l=1u
X27 VDD vin3 vout3 VDD sg13_lv_pmos ad=1.14p pd=6.38u as=1.14p ps=6.38u w=6u l=1u
X28 VSS.t42 VSS.t39 VSS.t41 VSS.t40 sg13_lv_nmos ad=0.34p pd=2.68u as=0 ps=0 w=1u l=1u
X29 vout2 vin2 VDD VDD sg13_lv_pmos ad=1.14p pd=6.38u as=1.14p ps=6.38u w=6u l=1u
X30 vout2 vin2 VSS.t73 VSS.t74 sg13_lv_nmos ad=0.19p pd=1.38u as=0.19p ps=1.38u w=1u l=1u
X31 vout1 vin1 VSS.t18 VSS.t19 sg13_lv_nmos ad=0.19p pd=1.38u as=0.19p ps=1.38u w=1u l=1u
X32 VSS.t79 vin2 vout2 VSS.t78 sg13_lv_nmos ad=0.19p pd=1.38u as=0.19p ps=1.38u w=1u l=1u
X33 vout4 vin4 VSS.t122 VSS.t123 sg13_lv_nmos ad=0.19p pd=1.38u as=0.19p ps=1.38u w=1u l=1u
X34 vout1 vin1 VDD VDD sg13_lv_pmos ad=1.14p pd=6.38u as=1.14p ps=6.38u w=6u l=1u
X35 vout1 vin1 VSS.t12 VSS.t13 sg13_lv_nmos ad=0.19p pd=1.38u as=0.19p ps=1.38u w=1u l=1u
X36 VSS.t128 vin4 vout4 VSS.t127 sg13_lv_nmos ad=0.19p pd=1.38u as=0.19p ps=1.38u w=1u l=1u
X37 VDD VDD VDD VDD sg13_lv_pmos ad=1.14p pd=6.38u as=0 ps=0 w=6u l=1u
X38 VSS.t18 vin1 vout1 VSS.t17 sg13_lv_nmos ad=0.19p pd=1.38u as=0.19p ps=1.38u w=1u l=1u
X39 vout2 vin2 VDD VDD sg13_lv_pmos ad=1.14p pd=6.38u as=1.14p ps=6.38u w=6u l=1u
X40 VDD vin4 vout4 VDD sg13_lv_pmos ad=1.14p pd=6.38u as=1.14p ps=6.38u w=6u l=1u
X41 vout1 vin1 VSS.t21 VSS.t22 sg13_lv_nmos ad=0.19p pd=1.38u as=0.19p ps=1.38u w=1u l=1u
X42 vout3 vin3 VSS.t103 VSS.t83 sg13_lv_nmos ad=0.19p pd=1.38u as=0.19p ps=1.38u w=1u l=1u
X43 VDD vin3 vout3 VDD sg13_lv_pmos ad=1.14p pd=6.38u as=1.14p ps=6.38u w=6u l=1u
X44 vout4 vin4 VDD VDD sg13_lv_pmos ad=1.14p pd=6.38u as=1.14p ps=6.38u w=6u l=1u
X45 VDD vin4 vout4 VDD sg13_lv_pmos ad=1.14p pd=6.38u as=1.14p ps=6.38u w=6u l=1u
X46 vout3 vin3 VDD VDD sg13_lv_pmos ad=1.14p pd=6.38u as=1.14p ps=6.38u w=6u l=1u
X47 VDD vin3 vout3 VDD sg13_lv_pmos ad=1.14p pd=6.38u as=1.14p ps=6.38u w=6u l=1u
X48 VSS.t38 VSS.t35 VSS.t37 VSS.t36 sg13_lv_nmos ad=0.19p pd=1.38u as=0 ps=0 w=1u l=1u
X49 VDD vin4 vout4 VDD sg13_lv_pmos ad=1.14p pd=6.38u as=1.14p ps=6.38u w=6u l=1u
X50 VDD vin2 vout2 VDD sg13_lv_pmos ad=1.14p pd=6.38u as=1.14p ps=6.38u w=6u l=1u
X51 VSS.t131 vin4 vout4 VSS.t130 sg13_lv_nmos ad=0.19p pd=1.38u as=0.19p ps=1.38u w=1u l=1u
X52 VDD vin3 vout3 VDD sg13_lv_pmos ad=1.14p pd=6.38u as=1.14p ps=6.38u w=6u l=1u
X53 VSS.t12 vin1 vout1 VSS.t11 sg13_lv_nmos ad=0.19p pd=1.38u as=0.19p ps=1.38u w=1u l=1u
X54 VDD vin1 vout1 VDD sg13_lv_pmos ad=1.14p pd=6.38u as=1.14p ps=6.38u w=6u l=1u
X55 vout4 vin4 VSS.t134 VSS.t135 sg13_lv_nmos ad=0.19p pd=1.38u as=0.19p ps=1.38u w=1u l=1u
X56 vout1 vin1 VDD VDD sg13_lv_pmos ad=1.14p pd=6.38u as=1.14p ps=6.38u w=6u l=1u
X57 vout4 vin4 VDD VDD sg13_lv_pmos ad=1.14p pd=6.38u as=1.14p ps=6.38u w=6u l=1u
X58 vout1 vin1 VSS.t15 VSS.t16 sg13_lv_nmos ad=0.19p pd=1.38u as=0.19p ps=1.38u w=1u l=1u
X59 VDD vin1 vout1 VDD sg13_lv_pmos ad=1.14p pd=6.38u as=1.14p ps=6.38u w=6u l=1u
X60 vout3 vin3 VSS.t99 VSS.t77 sg13_lv_nmos ad=0.19p pd=1.38u as=0.19p ps=1.38u w=1u l=1u
X61 VSS.t21 vin1 vout1 VSS.t20 sg13_lv_nmos ad=0.19p pd=1.38u as=0.19p ps=1.38u w=1u l=1u
X62 VDD VDD VDD VDD sg13_lv_pmos ad=2.04p pd=12.68u as=0 ps=0 w=6u l=1u
X63 vout4 vin4 VDD VDD sg13_lv_pmos ad=1.14p pd=6.38u as=1.14p ps=6.38u w=6u l=1u
X64 VDD vin3 vout3 VDD sg13_lv_pmos ad=1.14p pd=6.38u as=1.14p ps=6.38u w=6u l=1u
X65 VDD vin4 vout4 VDD sg13_lv_pmos ad=1.14p pd=6.38u as=1.14p ps=6.38u w=6u l=1u
X66 vout3 vin3 VDD VDD sg13_lv_pmos ad=1.14p pd=6.38u as=1.14p ps=6.38u w=6u l=1u
X67 vout3 vin3 VSS.t95 VSS.t71 sg13_lv_nmos ad=0.19p pd=1.38u as=0.19p ps=1.38u w=1u l=1u
X68 VSS.t99 vin3 vout3 VSS.t75 sg13_lv_nmos ad=0.19p pd=1.38u as=0.19p ps=1.38u w=1u l=1u
X69 VDD VDD VDD VDD sg13_lv_pmos ad=1.14p pd=6.38u as=0 ps=0 w=6u l=1u
X70 vout3 vin3 VSS.t101 VSS.t80 sg13_lv_nmos ad=0.19p pd=1.38u as=0.19p ps=1.38u w=1u l=1u
X71 vout4 vin4 VDD VDD sg13_lv_pmos ad=1.14p pd=6.38u as=1.14p ps=6.38u w=6u l=1u
X72 vout3 vin3 VDD VDD sg13_lv_pmos ad=1.14p pd=6.38u as=1.14p ps=6.38u w=6u l=1u
X73 VDD vin1 vout1 VDD sg13_lv_pmos ad=1.14p pd=6.38u as=1.14p ps=6.38u w=6u l=1u
X74 vout2 vin2 VDD VDD sg13_lv_pmos ad=1.14p pd=6.38u as=1.14p ps=6.38u w=6u l=1u
X75 vout1 vin1 VDD VDD sg13_lv_pmos ad=1.14p pd=6.38u as=1.14p ps=6.38u w=6u l=1u
X76 vout2 vin2 VSS.t64 VSS.t65 sg13_lv_nmos ad=0.19p pd=1.38u as=0.19p ps=1.38u w=1u l=1u
X77 VDD vin1 vout1 VDD sg13_lv_pmos ad=1.14p pd=6.38u as=1.14p ps=6.38u w=6u l=1u
X78 VDD vin1 vout1 VDD sg13_lv_pmos ad=1.14p pd=6.38u as=1.14p ps=6.38u w=6u l=1u
X79 VDD vin3 vout3 VDD sg13_lv_pmos ad=1.14p pd=6.38u as=1.14p ps=6.38u w=6u l=1u
X80 VSS.t95 vin3 vout3 VSS.t69 sg13_lv_nmos ad=0.19p pd=1.38u as=0.19p ps=1.38u w=1u l=1u
X81 vout3 vin3 VSS.t97 VSS.t74 sg13_lv_nmos ad=0.19p pd=1.38u as=0.19p ps=1.38u w=1u l=1u
X82 VSS.t113 vin4 vout4 VSS.t112 sg13_lv_nmos ad=0.19p pd=1.38u as=0.19p ps=1.38u w=1u l=1u
X83 VDD vin4 vout4 VDD sg13_lv_pmos ad=1.14p pd=6.38u as=1.14p ps=6.38u w=6u l=1u
X84 VSS.t101 vin3 vout3 VSS.t78 sg13_lv_nmos ad=0.19p pd=1.38u as=0.19p ps=1.38u w=1u l=1u
X85 vout4 vin4 VSS.t116 VSS.t117 sg13_lv_nmos ad=0.19p pd=1.38u as=0.19p ps=1.38u w=1u l=1u
X86 VDD vin1 vout1 VDD sg13_lv_pmos ad=1.14p pd=6.38u as=1.14p ps=6.38u w=6u l=1u
X87 vout2 vin2 VDD VDD sg13_lv_pmos ad=1.14p pd=6.38u as=1.14p ps=6.38u w=6u l=1u
X88 vout1 vin1 VDD VDD sg13_lv_pmos ad=1.14p pd=6.38u as=1.14p ps=6.38u w=6u l=1u
X89 VSS.t110 vin4 vout4 VSS.t109 sg13_lv_nmos ad=0.19p pd=1.38u as=0.19p ps=1.38u w=1u l=1u
X90 VDD VDD VDD VDD sg13_lv_pmos ad=2.04p pd=12.68u as=0 ps=0 w=6u l=1u
X91 vout2 vin2 VDD VDD sg13_lv_pmos ad=1.14p pd=6.38u as=1.14p ps=6.38u w=6u l=1u
X92 VDD vin2 vout2 VDD sg13_lv_pmos ad=1.14p pd=6.38u as=1.14p ps=6.38u w=6u l=1u
X93 VSS.t64 vin2 vout2 VSS.t63 sg13_lv_nmos ad=0.19p pd=1.38u as=0.19p ps=1.38u w=1u l=1u
X94 VSS.t122 vin4 vout4 VSS.t121 sg13_lv_nmos ad=0.19p pd=1.38u as=0.19p ps=1.38u w=1u l=1u
X95 vout2 vin2 VDD VDD sg13_lv_pmos ad=1.14p pd=6.38u as=1.14p ps=6.38u w=6u l=1u
X96 VDD VDD VDD VDD sg13_lv_pmos ad=2.04p pd=12.68u as=0 ps=0 w=6u l=1u
X97 vout2 vin2 VSS.t67 VSS.t68 sg13_lv_nmos ad=0.19p pd=1.38u as=0.19p ps=1.38u w=1u l=1u
X98 VSS.t73 vin2 vout2 VSS.t72 sg13_lv_nmos ad=0.19p pd=1.38u as=0.19p ps=1.38u w=1u l=1u
X99 vout1 vin1 VDD VDD sg13_lv_pmos ad=1.14p pd=6.38u as=1.14p ps=6.38u w=6u l=1u
X100 vout1 vin1 VSS.t6 VSS.t7 sg13_lv_nmos ad=0.19p pd=1.38u as=0.19p ps=1.38u w=1u l=1u
X101 vout4 vin4 VSS.t119 VSS.t120 sg13_lv_nmos ad=0.19p pd=1.38u as=0.19p ps=1.38u w=1u l=1u
X102 vout3 vin3 VDD VDD sg13_lv_pmos ad=1.14p pd=6.38u as=1.14p ps=6.38u w=6u l=1u
X103 vout4 vin4 VSS.t131 VSS.t132 sg13_lv_nmos ad=0.19p pd=1.38u as=0.19p ps=1.38u w=1u l=1u
X104 VSS.t52 VSS.t50 VSS.t51 VSS.t44 sg13_lv_nmos ad=0.19p pd=1.38u as=0 ps=0 w=1u l=1u
X105 VSS.t125 vin4 vout4 VSS.t124 sg13_lv_nmos ad=0.19p pd=1.38u as=0.19p ps=1.38u w=1u l=1u
X106 VDD vin1 vout1 VDD sg13_lv_pmos ad=1.14p pd=6.38u as=1.14p ps=6.38u w=6u l=1u
X107 VSS.t51 vin2 vout2 VSS.t87 sg13_lv_nmos ad=0.19p pd=1.38u as=0.19p ps=1.38u w=1u l=1u
X108 VDD vin2 vout2 VDD sg13_lv_pmos ad=1.14p pd=6.38u as=1.14p ps=6.38u w=6u l=1u
X109 vout4 vin4 VSS.t128 VSS.t129 sg13_lv_nmos ad=0.19p pd=1.38u as=0.19p ps=1.38u w=1u l=1u
X110 vout4 vin4 VDD VDD sg13_lv_pmos ad=1.14p pd=6.38u as=1.14p ps=6.38u w=6u l=1u
X111 vout2 vin2 VDD VDD sg13_lv_pmos ad=1.14p pd=6.38u as=1.14p ps=6.38u w=6u l=1u
X112 vout2 vin2 VSS.t61 VSS.t62 sg13_lv_nmos ad=0.19p pd=1.38u as=0.19p ps=1.38u w=1u l=1u
X113 VDD vin2 vout2 VDD sg13_lv_pmos ad=1.14p pd=6.38u as=1.14p ps=6.38u w=6u l=1u
X114 VSS.t67 vin2 vout2 VSS.t66 sg13_lv_nmos ad=0.19p pd=1.38u as=0.19p ps=1.38u w=1u l=1u
X115 VDD vin4 vout4 VDD sg13_lv_pmos ad=1.14p pd=6.38u as=1.14p ps=6.38u w=6u l=1u
X116 VDD VDD VDD VDD sg13_lv_pmos ad=2.04p pd=12.68u as=0 ps=0 w=6u l=1u
X117 VSS.t61 vin2 vout2 VSS.t60 sg13_lv_nmos ad=0.19p pd=1.38u as=0.19p ps=1.38u w=1u l=1u
X118 VSS.t6 vin1 vout1 VSS.t5 sg13_lv_nmos ad=0.19p pd=1.38u as=0.19p ps=1.38u w=1u l=1u
X119 vout3 vin3 VDD VDD sg13_lv_pmos ad=1.14p pd=6.38u as=1.14p ps=6.38u w=6u l=1u
X120 vout1 vin1 VSS.t9 VSS.t10 sg13_lv_nmos ad=0.19p pd=1.38u as=0.19p ps=1.38u w=1u l=1u
X121 VSS.t15 vin1 vout1 VSS.t14 sg13_lv_nmos ad=0.19p pd=1.38u as=0.19p ps=1.38u w=1u l=1u
X122 vout3 vin3 VDD VDD sg13_lv_pmos ad=1.14p pd=6.38u as=1.14p ps=6.38u w=6u l=1u
X123 VDD vin3 vout3 VDD sg13_lv_pmos ad=1.14p pd=6.38u as=1.14p ps=6.38u w=6u l=1u
X124 vout3 vin3 VDD VDD sg13_lv_pmos ad=1.14p pd=6.38u as=1.14p ps=6.38u w=6u l=1u
X125 vout3 vin3 VSS.t91 VSS.t65 sg13_lv_nmos ad=0.19p pd=1.38u as=0.19p ps=1.38u w=1u l=1u
X126 VSS.t82 vin2 vout2 VSS.t81 sg13_lv_nmos ad=0.19p pd=1.38u as=0.19p ps=1.38u w=1u l=1u
X127 vout1 vin1 VDD VDD sg13_lv_pmos ad=1.14p pd=6.38u as=1.14p ps=6.38u w=6u l=1u
X128 vout2 vin2 VSS.t85 VSS.t86 sg13_lv_nmos ad=0.19p pd=1.38u as=0.19p ps=1.38u w=1u l=1u
X129 VSS.t37 vin4 vout4 VSS.t136 sg13_lv_nmos ad=0.19p pd=1.38u as=0.19p ps=1.38u w=1u l=1u
X130 VSS.t58 VSS.t56 VSS.t30 VSS.t57 sg13_lv_nmos ad=0.19p pd=1.38u as=0 ps=0 w=1u l=1u
X131 VSS.t30 vin1 vout1 VSS.t29 sg13_lv_nmos ad=0.19p pd=1.38u as=0.19p ps=1.38u w=1u l=1u
X132 vout2 vin2 VSS.t49 VSS.t59 sg13_lv_nmos ad=0.19p pd=1.38u as=0.19p ps=1.38u w=1u l=1u
X133 VSS.t34 VSS.t31 VSS.t33 VSS.t32 sg13_lv_nmos ad=0.34p pd=2.68u as=0 ps=0 w=1u l=1u
X134 vout1 vin1 VSS.t3 VSS.t4 sg13_lv_nmos ad=0.19p pd=1.38u as=0.19p ps=1.38u w=1u l=1u
X135 VSS.t9 vin1 vout1 VSS.t8 sg13_lv_nmos ad=0.19p pd=1.38u as=0.19p ps=1.38u w=1u l=1u
X136 VDD vin3 vout3 VDD sg13_lv_pmos ad=1.14p pd=6.38u as=1.14p ps=6.38u w=6u l=1u
X137 VSS.t3 vin1 vout1 VSS.t2 sg13_lv_nmos ad=0.19p pd=1.38u as=0.19p ps=1.38u w=1u l=1u
X138 vout4 vin4 VDD VDD sg13_lv_pmos ad=1.14p pd=6.38u as=1.14p ps=6.38u w=6u l=1u
X139 vout3 vin3 VDD VDD sg13_lv_pmos ad=1.14p pd=6.38u as=1.14p ps=6.38u w=6u l=1u
X140 VDD vin3 vout3 VDD sg13_lv_pmos ad=1.14p pd=6.38u as=1.14p ps=6.38u w=6u l=1u
X141 VSS.t91 vin3 vout3 VSS.t63 sg13_lv_nmos ad=0.19p pd=1.38u as=0.19p ps=1.38u w=1u l=1u
X142 vout3 vin3 VSS.t93 VSS.t68 sg13_lv_nmos ad=0.19p pd=1.38u as=0.19p ps=1.38u w=1u l=1u
X143 vout1 vin1 VDD VDD sg13_lv_pmos ad=1.14p pd=6.38u as=1.14p ps=6.38u w=6u l=1u
X144 VSS.t85 vin2 vout2 VSS.t84 sg13_lv_nmos ad=0.19p pd=1.38u as=0.19p ps=1.38u w=1u l=1u
X145 VSS.t97 vin3 vout3 VSS.t72 sg13_lv_nmos ad=0.19p pd=1.38u as=0.19p ps=1.38u w=1u l=1u
X146 VDD vin4 vout4 VDD sg13_lv_pmos ad=1.14p pd=6.38u as=1.14p ps=6.38u w=6u l=1u
X147 vout1 vin1 VDD VDD sg13_lv_pmos ad=1.14p pd=6.38u as=1.14p ps=6.38u w=6u l=1u
X148 VDD vin1 vout1 VDD sg13_lv_pmos ad=1.14p pd=6.38u as=1.14p ps=6.38u w=6u l=1u
X149 vout4 vin4 VDD VDD sg13_lv_pmos ad=1.14p pd=6.38u as=1.14p ps=6.38u w=6u l=1u
X150 VSS.t24 vin1 vout1 VSS.t23 sg13_lv_nmos ad=0.19p pd=1.38u as=0.19p ps=1.38u w=1u l=1u
X151 vout1 vin1 VSS.t27 VSS.t28 sg13_lv_nmos ad=0.19p pd=1.38u as=0.19p ps=1.38u w=1u l=1u
X152 vout1 vin1 VDD VDD sg13_lv_pmos ad=1.14p pd=6.38u as=1.14p ps=6.38u w=6u l=1u
X153 vout2 vin2 VDD VDD sg13_lv_pmos ad=1.14p pd=6.38u as=1.14p ps=6.38u w=6u l=1u
X154 vout4 vin4 VSS.t113 VSS.t114 sg13_lv_nmos ad=0.19p pd=1.38u as=0.19p ps=1.38u w=1u l=1u
X155 VSS.t49 VSS.t47 VSS.t48 VSS.t40 sg13_lv_nmos ad=0.34p pd=2.68u as=0 ps=0 w=1u l=1u
X156 VSS.t46 VSS.t43 VSS.t45 VSS.t44 sg13_lv_nmos ad=0.19p pd=1.38u as=0 ps=0 w=1u l=1u
X157 vout4 vin4 VDD VDD sg13_lv_pmos ad=1.14p pd=6.38u as=1.14p ps=6.38u w=6u l=1u
X158 VSS.t45 vin3 vout3 VSS.t87 sg13_lv_nmos ad=0.19p pd=1.38u as=0.19p ps=1.38u w=1u l=1u
X159 VSS.t134 vin4 vout4 VSS.t133 sg13_lv_nmos ad=0.19p pd=1.38u as=0.19p ps=1.38u w=1u l=1u
X160 VDD vin4 vout4 VDD sg13_lv_pmos ad=1.14p pd=6.38u as=1.14p ps=6.38u w=6u l=1u
X161 vout1 vin1 VSS.t1 VSS.t0 sg13_lv_nmos ad=0.19p pd=1.38u as=0.19p ps=1.38u w=1u l=1u
X162 vout3 vin3 VSS.t89 VSS.t62 sg13_lv_nmos ad=0.19p pd=1.38u as=0.19p ps=1.38u w=1u l=1u
X163 VSS.t93 vin3 vout3 VSS.t66 sg13_lv_nmos ad=0.19p pd=1.38u as=0.19p ps=1.38u w=1u l=1u
X164 vout4 vin4 VDD VDD sg13_lv_pmos ad=1.14p pd=6.38u as=1.14p ps=6.38u w=6u l=1u
X165 vout2 vin2 VSS.t82 VSS.t83 sg13_lv_nmos ad=0.19p pd=1.38u as=0.19p ps=1.38u w=1u l=1u
X166 VSS.t89 vin3 vout3 VSS.t60 sg13_lv_nmos ad=0.19p pd=1.38u as=0.19p ps=1.38u w=1u l=1u
X167 VDD vin1 vout1 VDD sg13_lv_pmos ad=1.14p pd=6.38u as=1.14p ps=6.38u w=6u l=1u
X168 vout1 vin1 VDD VDD sg13_lv_pmos ad=1.14p pd=6.38u as=1.14p ps=6.38u w=6u l=1u
X169 VDD vin1 vout1 VDD sg13_lv_pmos ad=1.14p pd=6.38u as=1.14p ps=6.38u w=6u l=1u
X170 VDD vin4 vout4 VDD sg13_lv_pmos ad=1.14p pd=6.38u as=1.14p ps=6.38u w=6u l=1u
X171 VSS.t27 vin1 vout1 VSS.t26 sg13_lv_nmos ad=0.19p pd=1.38u as=0.19p ps=1.38u w=1u l=1u
X172 VDD vin2 vout2 VDD sg13_lv_pmos ad=1.14p pd=6.38u as=1.14p ps=6.38u w=6u l=1u
X173 vout2 vin2 VDD VDD sg13_lv_pmos ad=1.14p pd=6.38u as=1.14p ps=6.38u w=6u l=1u
X174 VDD vin2 vout2 VDD sg13_lv_pmos ad=1.14p pd=6.38u as=1.14p ps=6.38u w=6u l=1u
X175 VSS.t103 vin3 vout3 VSS.t81 sg13_lv_nmos ad=0.19p pd=1.38u as=0.19p ps=1.38u w=1u l=1u
R0 VSS.n26 VSS.n94 6777.49
R1 VSS.n285 VSS.n26 6777.49
R2 VSS.n44 VSS.n94 6777.49
R3 VSS.n285 VSS.n284 1580.41
R4 VSS.n283 VSS.n94 1580.41
R5 VSS.t59 VSS.n142 88.7251
R6 VSS.n216 VSS.t87 88.7251
R7 VSS.t60 VSS.n141 83.1798
R8 VSS.n212 VSS.t86 83.1798
R9 VSS.t62 VSS.n140 77.6345
R10 VSS.n209 VSS.t84 77.6345
R11 VSS.n26 VSS.t136 9.76925
R12 VSS.t63 VSS.n139 72.0892
R13 VSS.n206 VSS.t83 72.0892
R14 VSS.t65 VSS.n138 66.5439
R15 VSS.n203 VSS.t81 66.5439
R16 VSS.t135 VSS.n26 12.2976
R17 VSS.n26 VSS.t109 12.3005
R18 VSS.t66 VSS.n137 60.9987
R19 VSS.n201 VSS.t80 60.9987
R20 VSS.n26 VSS.t132 16.2707
R21 VSS.t29 VSS.n44 9.77
R22 VSS.n26 VSS.t112 16.2727
R23 VSS.t28 VSS.n44 12.2979
R24 VSS.t68 VSS.n135 55.4534
R25 VSS.n184 VSS.t72 55.4534
R26 VSS.t74 VSS.n126 55.4534
R27 VSS.n198 VSS.t78 55.4534
R28 VSS.t130 VSS.n26 17.7154
R29 VSS.t69 VSS.n131 49.9081
R30 VSS.n181 VSS.t71 49.9081
R31 VSS.t75 VSS.n125 49.9081
R32 VSS.n194 VSS.t77 49.9081
R33 VSS.n26 VSS.t127 19.5212
R34 VSS.n26 VSS.t126 19.8823
R35 VSS.t121 VSS.n45 19.5591
R36 VSS.t23 VSS.n44 17.716
R37 VSS.n178 VSS.t69 44.3628
R38 VSS.t71 VSS.n129 44.3628
R39 VSS.n191 VSS.t75 44.3628
R40 VSS.t77 VSS.n124 44.3628
R41 VSS.t22 VSS.n44 18.7991
R42 VSS.n175 VSS.t68 38.8175
R43 VSS.t72 VSS.n127 38.8175
R44 VSS.n187 VSS.t74 38.8175
R45 VSS.t78 VSS.n123 38.8175
R46 VSS.t124 VSS.n26 19.882
R47 VSS.t118 VSS.n26 19.8825
R48 VSS.n26 VSS.t120 19.8818
R49 VSS.t123 VSS.n45 19.5044
R50 VSS.t117 VSS.n26 19.5219
R51 VSS.n172 VSS.t66 33.2722
R52 VSS.t80 VSS.n121 33.2722
R53 VSS.t115 VSS.n26 18.8
R54 VSS.n166 VSS.t65 27.7269
R55 VSS.t81 VSS.n120 27.7269
R56 VSS.t114 VSS.n26 17.717
R57 VSS.n44 VSS.t2 12.2981
R58 VSS.n162 VSS.t63 22.1816
R59 VSS.t83 VSS.n119 22.1816
R60 VSS.t111 VSS.n26 14.4672
R61 VSS.t26 VSS.n44 14.465
R62 VSS.t17 VSS.n44 19.8815
R63 VSS.t16 VSS.n44 19.5029
R64 VSS.n44 VSS.t13 19.8815
R65 VSS.t10 VSS.n44 19.5211
R66 VSS.t8 VSS.n44 18.799
R67 VSS.t7 VSS.n44 17.7156
R68 VSS.t56 VSS.n93 0.008067
R69 VSS.n44 VSS.n93 8.49747
R70 VSS.n105 VSS.n44 17.0005
R71 VSS.n44 VSS.n90 1.27462
R72 VSS.t58 VSS.n104 17.0005
R73 VSS.n111 VSS.t58 17.0005
R74 VSS.n110 VSS.t30 17.0005
R75 VSS.n111 VSS.t30 17.0005
R76 VSS.t58 VSS.n110 17.0005
R77 VSS.n104 VSS.t30 17.0005
R78 VSS.t0 VSS.n44 9.76976
R79 VSS.n89 VSS.n44 1.3171
R80 VSS.n44 VSS.n114 17.0005
R81 VSS.n44 VSS.n96 17.0005
R82 VSS.t1 VSS.n112 17.0005
R83 VSS.n113 VSS.t1 17.0005
R84 VSS.t1 VSS.n103 17.0005
R85 VSS.n113 VSS.t55 17.0005
R86 VSS.t55 VSS.n103 17.0005
R87 VSS.n112 VSS.t55 17.0005
R88 VSS.n55 VSS.n43 4.02492
R89 VSS.n55 VSS.n16 3.39928
R90 VSS.n55 VSS.n14 0.9743
R91 VSS.n69 VSS.n222 14.4044
R92 VSS.n82 VSS.n219 14.4044
R93 VSS.n55 VSS.n64 0.650675
R94 VSS.n64 VSS.n213 14.4044
R95 VSS.n55 VSS.n56 0.650675
R96 VSS.n56 VSS.n116 7.20256
R97 VSS.n55 VSS.n212 8.49975
R98 VSS.n55 VSS.n83 0.650675
R99 VSS.n83 VSS.n210 14.4044
R100 VSS.n55 VSS.n53 2.4234
R101 VSS.n55 VSS.n209 8.4995
R102 VSS.n61 VSS.n207 14.4044
R103 VSS.n55 VSS.n119 8.49925
R104 VSS.n55 VSS.n206 8.499
R105 VSS.n79 VSS.n204 14.4044
R106 VSS.n55 VSS.n120 8.49875
R107 VSS.n55 VSS.n66 0.650675
R108 VSS.n49 VSS.n48 0.0146543
R109 VSS.n66 VSS.n202 14.4044
R110 VSS.n55 VSS.n57 0.650675
R111 VSS.n57 VSS.n121 7.20256
R112 VSS.n55 VSS.n201 8.4985
R113 VSS.n67 VSS.n199 14.4044
R114 VSS.n55 VSS.n78 0.650675
R115 VSS.n78 VSS.n197 14.4044
R116 VSS.n55 VSS.n65 0.650675
R117 VSS.n65 VSS.n124 7.20256
R118 VSS.n55 VSS.n194 8.50025
R119 VSS.n55 VSS.n81 0.650675
R120 VSS.n81 VSS.n192 14.4044
R121 VSS.n55 VSS.n31 4.2464
R122 VSS.n55 VSS.n125 8.49825
R123 VSS.n55 VSS.n73 0.650675
R124 VSS.n31 VSS.n40 0.0188594
R125 VSS.n73 VSS.n189 14.4044
R126 VSS.n55 VSS.n126 8.49865
R127 VSS.n55 VSS.n187 8.498
R128 VSS.n63 VSS.n186 14.6203
R129 VSS.n55 VSS.n63 0.542754
R130 VSS.n55 VSS.n184 8.49775
R131 VSS.n55 VSS.n38 3.39223
R132 VSS.n71 VSS.n182 14.4044
R133 VSS.n55 VSS.n181 8.49751
R134 VSS.n55 VSS.n76 0.650675
R135 VSS.n76 VSS.n179 14.4044
R136 VSS.n55 VSS.n10 4.24711
R137 VSS.n55 VSS.n178 8.49726
R138 VSS.n72 VSS.n176 14.4044
R139 VSS.n77 VSS.n174 14.4044
R140 VSS.n55 VSS.n37 5.66421
R141 VSS.n55 VSS.n77 0.650675
R142 VSS.n55 VSS.n137 8.49701
R143 VSS.n55 VSS.n74 0.650675
R144 VSS.n74 VSS.n169 14.4044
R145 VSS.n55 VSS.n60 0.650675
R146 VSS.n60 VSS.n138 7.20256
R147 VSS.n62 VSS.n163 14.4044
R148 VSS.n86 VSS.n92 0.00806492
R149 VSS.n55 VSS.n80 0.650675
R150 VSS.n80 VSS.n160 14.4044
R151 VSS.n55 VSS.n35 3.39294
R152 VSS.n55 VSS.n140 8.49676
R153 VSS.n55 VSS.n159 8.49651
R154 VSS.n75 VSS.n157 14.4044
R155 VSS.n55 VSS.n156 8.49627
R156 VSS.n55 VSS.n70 0.650675
R157 VSS.n55 VSS.n150 8.49602
R158 VSS.n59 VSS.n149 14.4044
R159 VSS.n55 VSS.n59 0.650675
R160 VSS.n55 VSS.n85 1.20771
R161 VSS.n55 VSS.n58 0.650675
R162 VSS.n58 VSS.n143 14.4044
R163 VSS.n115 VSS.n55 8.50049
R164 VSS.n117 VSS.n55 8.5004
R165 VSS.n123 VSS.n55 8.5005
R166 VSS.n191 VSS.n55 8.50069
R167 VSS.n127 VSS.n55 8.4997
R168 VSS.n129 VSS.n55 8.50066
R169 VSS.n131 VSS.n55 8.5022
R170 VSS.n135 VSS.n55 8.50071
R171 VSS.n175 VSS.n55 8.50073
R172 VSS.n166 VSS.n55 8.50022
R173 VSS.n139 VSS.n55 8.50072
R174 VSS.n162 VSS.n55 8.50062
R175 VSS.n141 VSS.n55 8.50006
R176 VSS.n142 VSS.n55 8.50058
R177 VSS.n17 VSS.n6 5.66316
R178 VSS.n51 VSS.n6 2.4234
R179 VSS.n48 VSS.n6 17.0005
R180 VSS.n41 VSS.n42 0.0216799
R181 VSS.n28 VSS.n6 5.66316
R182 VSS.n40 VSS.n6 5.66316
R183 VSS.n88 VSS.n6 4.24736
R184 VSS.n39 VSS.n6 5.66316
R185 VSS.n23 VSS.n6 5.66405
R186 VSS.n164 VSS.n91 0.0117843
R187 VSS.n86 VSS.n6 17.0005
R188 VSS.n36 VSS.n6 5.66316
R189 VSS.n34 VSS.n6 3.39699
R190 VSS.n30 VSS.n6 5.66421
R191 VSS.n5 VSS.n4 0.0153102
R192 VSS.n2 VSS.n1 0.0153621
R193 VSS.t38 VSS.n25 17.0005
R194 VSS.t38 VSS.n1 8.49711
R195 VSS.n1 VSS.n0 0.0123024
R196 VSS.n0 VSS.t37 8.49535
R197 VSS.n27 VSS.t34 17.0005
R198 VSS.t34 VSS.n4 8.49711
R199 VSS.n4 VSS.n3 0.0123024
R200 VSS.n3 VSS.t33 8.49535
R201 VSS.n159 VSS.t62 16.6364
R202 VSS.t84 VSS.n117 16.6364
R203 VSS.t47 VSS.n8 15.0005
R204 VSS.n266 VSS.t39 15.0005
R205 VSS.t43 VSS.n282 15.0005
R206 VSS.t50 VSS.n13 15.0005
R207 VSS.n185 VSS.n63 14.6209
R208 VSS.n69 VSS.t44 7.20324
R209 VSS.n82 VSS.n222 14.4051
R210 VSS.n61 VSS.n208 14.4051
R211 VSS.n79 VSS.n205 14.4051
R212 VSS.n67 VSS.n200 14.4051
R213 VSS.n71 VSS.n183 14.4051
R214 VSS.n72 VSS.n177 14.4051
R215 VSS.n62 VSS.n165 14.4051
R216 VSS.n284 VSS.n68 1.53568
R217 VSS.n84 VSS.t40 13.3823
R218 VSS.n146 VSS.n59 14.4051
R219 VSS.n153 VSS.n70 14.4051
R220 VSS.n172 VSS.n74 7.20324
R221 VSS.n173 VSS.n77 14.4051
R222 VSS.n198 VSS.n78 7.20324
R223 VSS.n203 VSS.n66 7.20324
R224 VSS.n216 VSS.n64 7.20324
R225 VSS.t108 VSS.n26 9.77299
R226 VSS.t57 VSS.n44 6.8802
R227 VSS.n44 VSS.t4 14.4658
R228 VSS.n44 VSS.t5 16.2716
R229 VSS.t11 VSS.n44 19.8818
R230 VSS.n44 VSS.t14 19.5606
R231 VSS.n44 VSS.t19 19.8821
R232 VSS.n44 VSS.t20 19.5213
R233 VSS.n44 VSS.t25 16.271
R234 VSS.n156 VSS.t60 11.0911
R235 VSS.t86 VSS.n116 11.0911
R236 VSS.n285 VSS.n44 6777.49
R237 VSS.n216 VSS.n6 8.5005
R238 VSS.n116 VSS.n6 8.5005
R239 VSS.n203 VSS.n6 8.5005
R240 VSS.n121 VSS.n6 8.5005
R241 VSS.n198 VSS.n6 8.5005
R242 VSS.n124 VSS.n6 8.5005
R243 VSS.n172 VSS.n6 8.5005
R244 VSS.n138 VSS.n6 8.5005
R245 VSS.t40 VSS.n6 8.5005
R246 VSS.n55 VSS.n221 8.4984
R247 VSS.n55 VSS.n218 8.4984
R248 VSS.n55 VSS.n215 8.4984
R249 VSS.n53 VSS.n214 0.0262321
R250 VSS.n55 VSS.n118 8.4984
R251 VSS.n50 VSS.n51 0.00653337
R252 VSS.n48 VSS.n50 0.00867464
R253 VSS.n55 VSS.n49 2.11119
R254 VSS.n55 VSS.n20 8.4984
R255 VSS.n55 VSS.n41 3.39669
R256 VSS.n55 VSS.n196 8.4984
R257 VSS.n55 VSS.n29 8.4984
R258 VSS.n55 VSS.n188 8.4984
R259 VSS.n38 VSS.t97 0.0201659
R260 VSS.n55 VSS.n128 8.4984
R261 VSS.n10 VSS.n130 0.0180748
R262 VSS.n55 VSS.n132 8.4984
R263 VSS.n55 VSS.n134 8.4984
R264 VSS.n37 VSS.n136 0.0161786
R265 VSS.n55 VSS.n24 8.4984
R266 VSS.n55 VSS.n171 8.4984
R267 VSS.n55 VSS.n168 8.4984
R268 VSS.n55 VSS.n164 8.4984
R269 VSS.n35 VSS.n86 0.0180337
R270 VSS.n55 VSS.n32 8.4984
R271 VSS.n55 VSS.n87 3.39233
R272 VSS.n55 VSS.n152 8.4984
R273 VSS.n55 VSS.n148 8.4984
R274 VSS.n55 VSS.n145 8.4984
R275 VSS.n55 VSS.n7 2.83124
R276 VSS.n220 VSS.n6 8.4984
R277 VSS.n217 VSS.n6 8.4984
R278 VSS.n214 VSS.n6 8.4984
R279 VSS.n52 VSS.n54 0.0157515
R280 VSS.n54 VSS.n6 2.41741
R281 VSS.n122 VSS.n6 8.4984
R282 VSS.n19 VSS.n6 4.24668
R283 VSS.n41 VSS.n19 0.0163135
R284 VSS.n42 VSS.n6 5.66294
R285 VSS.n195 VSS.n6 8.4984
R286 VSS.n31 VSS.n28 0.0186087
R287 VSS.n38 VSS.n39 0.0272155
R288 VSS.n130 VSS.n6 8.4984
R289 VSS.n11 VSS.n12 0.0123705
R290 VSS.n12 VSS.n6 4.24427
R291 VSS.n133 VSS.n6 8.4984
R292 VSS.n136 VSS.n6 8.4984
R293 VSS.n37 VSS.n23 0.0131216
R294 VSS.n22 VSS.n6 8.4984
R295 VSS.n170 VSS.n6 8.4984
R296 VSS.n167 VSS.n6 8.4984
R297 VSS.n91 VSS.n6 5.66504
R298 VSS.n35 VSS.n36 0.0257958
R299 VSS.n33 VSS.n34 0.00344721
R300 VSS.n154 VSS.n6 8.4984
R301 VSS.n151 VSS.n6 8.4984
R302 VSS.n147 VSS.n6 8.4984
R303 VSS.n307 VSS.n97 8.22525
R304 VSS.n257 VSS.n256 8.22525
R305 VSS.n256 VSS.n229 8.22525
R306 VSS.n308 VSS.n307 8.22525
R307 VSS.n26 VSS.t36 6.87897
R308 VSS.n26 VSS.t32 6.87896
R309 VSS.n264 VSS.t47 7.49606
R310 VSS.t39 VSS.n262 7.49606
R311 VSS.n15 VSS.t43 7.49606
R312 VSS.n225 VSS.t50 7.49606
R313 VSS.n211 VSS.n83 14.4051
R314 VSS.n193 VSS.n81 14.4051
R315 VSS.n190 VSS.n73 14.4051
R316 VSS.n181 VSS.n180 7.20236
R317 VSS.n161 VSS.n80 14.4051
R318 VSS.n159 VSS.n158 7.20236
R319 VSS.n156 VSS.n155 7.20236
R320 VSS.n84 VSS.n144 13.8932
R321 VSS.n143 VSS.n68 14.8739
R322 VSS.n144 VSS.n58 14.4051
R323 VSS.n146 VSS.n85 13.8932
R324 VSS.n150 VSS.n149 7.20236
R325 VSS.n153 VSS.n142 7.20236
R326 VSS.n155 VSS.n70 14.4044
R327 VSS.n157 VSS.n141 7.20236
R328 VSS.n158 VSS.n75 14.4051
R329 VSS.n160 VSS.n140 7.20236
R330 VSS.n162 VSS.n161 7.20236
R331 VSS.n163 VSS.n139 7.20236
R332 VSS.n166 VSS.n165 7.20236
R333 VSS.n60 VSS.n169 14.4051
R334 VSS.n173 VSS.n137 7.20236
R335 VSS.n175 VSS.n174 7.20236
R336 VSS.n176 VSS.n135 7.20236
R337 VSS.n178 VSS.n177 7.20236
R338 VSS.n179 VSS.n131 7.20236
R339 VSS.n180 VSS.n76 14.4051
R340 VSS.n182 VSS.n129 7.20236
R341 VSS.n184 VSS.n183 7.20236
R342 VSS.n185 VSS.n127 7.20236
R343 VSS.n187 VSS.n186 7.20236
R344 VSS.n189 VSS.n126 7.20236
R345 VSS.n191 VSS.n190 7.20236
R346 VSS.n192 VSS.n125 7.20236
R347 VSS.n194 VSS.n193 7.20236
R348 VSS.n65 VSS.n197 14.4051
R349 VSS.n199 VSS.n123 7.20236
R350 VSS.n201 VSS.n200 7.20236
R351 VSS.n57 VSS.n202 14.4051
R352 VSS.n204 VSS.n120 7.20236
R353 VSS.n206 VSS.n205 7.20236
R354 VSS.n207 VSS.n119 7.20236
R355 VSS.n209 VSS.n208 7.20236
R356 VSS.n210 VSS.n117 7.20236
R357 VSS.n212 VSS.n211 7.20236
R358 VSS.n56 VSS.n213 14.4051
R359 VSS.n219 VSS.n115 7.20236
R360 VSS.n43 VSS.t44 7.66551
R361 VSS.n55 VSS.n283 1.70051
R362 VSS.n150 VSS.t59 5.54579
R363 VSS.t87 VSS.n115 5.54579
R364 VSS.n265 VSS.t49 4.5005
R365 VSS.t42 VSS.n261 4.5005
R366 VSS.t51 VSS.n224 4.5005
R367 VSS.t45 VSS.n281 4.5005
R368 VSS.n7 VSS.n6 4.25807
R369 VSS.n16 VSS.n6 4.25571
R370 VSS.n259 VSS.n258 4.11287
R371 VSS.n259 VSS.n98 4.11287
R372 VSS.n109 VSS.t56 3.0005
R373 VSS.n303 VSS.t53 3.0005
R374 VSS.n247 VSS.t35 3.0005
R375 VSS.n254 VSS.t31 3.0005
R376 VSS.n263 VSS.n260 3.0005
R377 VSS.n268 VSS.n267 3.0005
R378 VSS.n227 VSS.n226 3.0005
R379 VSS.n280 VSS.n223 3.0005
R380 VSS.t54 VSS.n44 6.87945
R381 VSS.n229 VSS.n228 2.71193
R382 VSS.n310 VSS.n309 2.6297
R383 VSS.n304 VSS.t3 2.4821
R384 VSS.n305 VSS.t6 2.4821
R385 VSS.n306 VSS.t9 2.4821
R386 VSS.n102 VSS.t12 2.4821
R387 VSS.t18 VSS.n101 2.4821
R388 VSS.n106 VSS.t21 2.4821
R389 VSS.n107 VSS.t24 2.4821
R390 VSS.n108 VSS.t27 2.4821
R391 VSS.n246 VSS.t134 2.4821
R392 VSS.n244 VSS.t131 2.4821
R393 VSS.n243 VSS.t128 2.4821
R394 VSS.t125 VSS.n230 2.4821
R395 VSS.t119 VSS.n231 2.4821
R396 VSS.n251 VSS.t116 2.4821
R397 VSS.n252 VSS.t113 2.4821
R398 VSS.n253 VSS.t110 2.4821
R399 VSS.n270 VSS.t89 2.4821
R400 VSS.n270 VSS.t61 2.4821
R401 VSS.n271 VSS.t91 2.4821
R402 VSS.n271 VSS.t64 2.4821
R403 VSS.n272 VSS.t93 2.4821
R404 VSS.n272 VSS.t67 2.4821
R405 VSS.n273 VSS.t95 2.4821
R406 VSS.n273 VSS.t70 2.4821
R407 VSS.n275 VSS.t99 2.4821
R408 VSS.n275 VSS.t76 2.4821
R409 VSS.n276 VSS.t101 2.4821
R410 VSS.n276 VSS.t79 2.4821
R411 VSS.n277 VSS.t103 2.4821
R412 VSS.n277 VSS.t82 2.4821
R413 VSS.n278 VSS.t105 2.4821
R414 VSS.n278 VSS.t85 2.4821
R415 VSS.n55 VSS.n84 1.20771
R416 VSS.n69 VSS.n55 0.650675
R417 VSS.n82 VSS.n55 0.650675
R418 VSS.n61 VSS.n55 0.650675
R419 VSS.n79 VSS.n55 0.650675
R420 VSS.n67 VSS.n55 0.650675
R421 VSS.n71 VSS.n55 0.650675
R422 VSS.n72 VSS.n55 0.650675
R423 VSS.n62 VSS.n55 0.650675
R424 VSS.n75 VSS.n55 0.650675
R425 VSS.t40 VSS.n85 13.3823
R426 VSS.t48 VSS.n265 2.2505
R427 VSS.t41 VSS.n261 2.2505
R428 VSS.n224 VSS.t52 2.2505
R429 VSS.n281 VSS.t46 2.2505
R430 VSS.n288 VSS.n44 2.09947
R431 VSS.n290 VSS.n44 2.09947
R432 VSS.n292 VSS.n44 2.09947
R433 VSS.n99 VSS.n44 2.09947
R434 VSS.n294 VSS.n44 2.09947
R435 VSS.n296 VSS.n44 2.09947
R436 VSS.n298 VSS.n44 2.09947
R437 VSS.n300 VSS.n44 2.09947
R438 VSS.n26 VSS.n240 2.09901
R439 VSS.n26 VSS.n236 2.09885
R440 VSS.n26 VSS.n234 2.09868
R441 VSS.n26 VSS.n235 2.09868
R442 VSS.n26 VSS.n95 2.09862
R443 VSS.n26 VSS.n238 2.09862
R444 VSS.n26 VSS.n239 2.09857
R445 VSS.n255 VSS.n26 2.09849
R446 VSS.n284 VSS.n6 1.7005
R447 VSS.n90 VSS.n111 0.00152967
R448 VSS.n283 VSS.n6 1.53502
R449 VSS.n303 VSS.n103 1.52811
R450 VSS.n1 VSS.n247 1.52811
R451 VSS.n4 VSS.n254 1.52811
R452 VSS.n110 VSS.n109 1.52811
R453 VSS.n5 VSS.n26 1.13482
R454 VSS.n26 VSS.n2 1.10812
R455 VSS.t48 VSS.n6 1.08267
R456 VSS.n6 VSS.t52 1.03721
R457 VSS.n286 VSS.n44 0.96569
R458 VSS.n26 VSS.n46 0.910334
R459 VSS.n26 VSS.n47 0.909168
R460 VSS.n43 VSS.n6 0.167883
R461 VSS.n222 VSS.n6 0.650322
R462 VSS.n219 VSS.n6 0.650322
R463 VSS.n213 VSS.n6 0.650322
R464 VSS.n211 VSS.n6 0.650322
R465 VSS.n210 VSS.n6 0.650322
R466 VSS.n208 VSS.n6 0.650322
R467 VSS.n207 VSS.n6 0.650322
R468 VSS.n205 VSS.n6 0.650322
R469 VSS.n204 VSS.n6 0.650322
R470 VSS.n202 VSS.n6 0.650322
R471 VSS.n200 VSS.n6 0.650322
R472 VSS.n199 VSS.n6 0.650322
R473 VSS.n197 VSS.n6 0.650322
R474 VSS.n193 VSS.n6 0.650322
R475 VSS.n192 VSS.n6 0.650322
R476 VSS.n190 VSS.n6 0.650322
R477 VSS.n189 VSS.n6 0.650322
R478 VSS.n186 VSS.n6 0.650322
R479 VSS.n185 VSS.n6 0.650322
R480 VSS.n183 VSS.n6 0.650322
R481 VSS.n182 VSS.n6 0.650322
R482 VSS.n180 VSS.n6 0.650322
R483 VSS.n179 VSS.n6 0.650322
R484 VSS.n177 VSS.n6 0.650322
R485 VSS.n176 VSS.n6 0.650322
R486 VSS.n174 VSS.n6 0.650322
R487 VSS.n173 VSS.n6 0.650322
R488 VSS.n169 VSS.n6 0.650322
R489 VSS.n165 VSS.n6 0.650322
R490 VSS.n163 VSS.n6 0.650322
R491 VSS.n161 VSS.n6 0.650322
R492 VSS.n160 VSS.n6 0.650322
R493 VSS.n158 VSS.n6 0.650322
R494 VSS.n157 VSS.n6 0.650322
R495 VSS.n155 VSS.n6 0.650322
R496 VSS.n153 VSS.n6 0.650322
R497 VSS.n149 VSS.n6 0.650322
R498 VSS.n146 VSS.n6 0.650322
R499 VSS.n144 VSS.n6 0.650322
R500 VSS.n143 VSS.n6 0.650322
R501 VSS.n257 VSS.n228 0.632727
R502 VSS.n311 VSS.n310 0.5505
R503 VSS.n258 VSS.n97 0.2444
R504 VSS.n258 VSS.n257 0.2444
R505 VSS.n308 VSS.n98 0.2444
R506 VSS.n229 VSS.n98 0.2444
R507 VSS.n304 VSS.n303 0.209825
R508 VSS.n247 VSS.n246 0.209825
R509 VSS.n254 VSS.n253 0.209825
R510 VSS.n109 VSS.n108 0.209825
R511 VSS.n301 VSS.t3 0.201663
R512 VSS.n299 VSS.t6 0.201663
R513 VSS.n297 VSS.t9 0.201663
R514 VSS.n295 VSS.t12 0.201663
R515 VSS.n293 VSS.t18 0.201663
R516 VSS.n291 VSS.t21 0.201663
R517 VSS.n289 VSS.t24 0.201663
R518 VSS.n287 VSS.t27 0.201663
R519 VSS.t134 VSS.n245 0.201663
R520 VSS.t131 VSS.n241 0.201663
R521 VSS.t128 VSS.n242 0.201663
R522 VSS.n237 VSS.t125 0.201663
R523 VSS.n233 VSS.t119 0.201663
R524 VSS.t116 VSS.n250 0.201663
R525 VSS.t113 VSS.n249 0.201663
R526 VSS.t110 VSS.n248 0.201663
R527 VSS.n33 VSS.t89 0.201663
R528 VSS.t61 VSS.n33 0.201663
R529 VSS.n92 VSS.t91 0.201663
R530 VSS.t64 VSS.n92 0.201663
R531 VSS.n24 VSS.t93 0.201663
R532 VSS.t67 VSS.n24 0.201663
R533 VSS.n11 VSS.t95 0.201663
R534 VSS.t70 VSS.n11 0.201663
R535 VSS.n29 VSS.t99 0.201663
R536 VSS.t76 VSS.n29 0.201663
R537 VSS.n21 VSS.t101 0.201663
R538 VSS.t79 VSS.n21 0.201663
R539 VSS.n50 VSS.t103 0.201663
R540 VSS.t82 VSS.n50 0.201663
R541 VSS.n52 VSS.t105 0.201663
R542 VSS.t85 VSS.n52 0.201663
R543 VSS.t73 VSS.t97 0.185696
R544 VSS.n305 VSS.n304 0.16242
R545 VSS.n306 VSS.n305 0.16242
R546 VSS.n102 VSS.n306 0.16242
R547 VSS.n100 VSS.n102 0.16242
R548 VSS.n100 VSS.n101 0.16242
R549 VSS.n106 VSS.n101 0.16242
R550 VSS.n107 VSS.n106 0.16242
R551 VSS.n108 VSS.n107 0.16242
R552 VSS.n253 VSS.n252 0.16242
R553 VSS.n252 VSS.n251 0.16242
R554 VSS.n251 VSS.n231 0.16242
R555 VSS.n232 VSS.n231 0.16242
R556 VSS.n232 VSS.n230 0.16242
R557 VSS.n243 VSS.n230 0.16242
R558 VSS.n244 VSS.n243 0.16242
R559 VSS.n246 VSS.n244 0.16242
R560 VSS.n245 VSS.n47 0.147332
R561 VSS.n248 VSS.n46 0.145358
R562 VSS.n302 VSS.n301 0.144129
R563 VSS.n287 VSS.n286 0.143085
R564 VSS.n270 VSS.n269 0.117247
R565 VSS.n279 VSS.n278 0.1171
R566 VSS.n301 VSS.n300 0.0952183
R567 VSS.n248 VSS.n234 0.0942639
R568 VSS.n245 VSS.n240 0.0931256
R569 VSS.n299 VSS.n298 0.0927738
R570 VSS.n288 VSS.n287 0.0925656
R571 VSS.n249 VSS.n235 0.0918194
R572 VSS.n241 VSS.n239 0.0913723
R573 VSS.n297 VSS.n296 0.0903294
R574 VSS.t15 VSS.n99 0.0903294
R575 VSS.n290 VSS.n289 0.0901212
R576 VSS.n250 VSS.n236 0.0894369
R577 VSS.t122 VSS.n255 0.0891801
R578 VSS.t122 VSS.n95 0.0888618
R579 VSS.n242 VSS.n238 0.0888618
R580 VSS.n295 VSS.n294 0.0878849
R581 VSS.n293 VSS.n292 0.0878849
R582 VSS.n294 VSS.t15 0.0876767
R583 VSS.n292 VSS.n291 0.0876767
R584 VSS.n237 VSS.n95 0.0866755
R585 VSS.n238 VSS.n237 0.0866755
R586 VSS.n255 VSS.n233 0.0863554
R587 VSS.n236 VSS.n233 0.0861023
R588 VSS.n291 VSS.n290 0.0854405
R589 VSS.n296 VSS.n295 0.0852323
R590 VSS.n99 VSS.n293 0.0852323
R591 VSS.n286 VSS.t56 0.0849321
R592 VSS.t53 VSS.n302 0.0847768
R593 VSS.n242 VSS.n239 0.0841695
R594 VSS.n250 VSS.n235 0.083723
R595 VSS.t31 VSS.n46 0.0834709
R596 VSS.n289 VSS.n288 0.082996
R597 VSS.n298 VSS.n297 0.0827878
R598 VSS.n311 VSS.n97 0.0827273
R599 VSS.n309 VSS.n308 0.0827273
R600 VSS.n241 VSS.n240 0.0824218
R601 VSS.t35 VSS.n47 0.0823986
R602 VSS.n271 VSS.n270 0.08146
R603 VSS.n272 VSS.n271 0.08146
R604 VSS.n273 VSS.n272 0.08146
R605 VSS.n274 VSS.n273 0.08146
R606 VSS.n275 VSS.n274 0.08146
R607 VSS.n276 VSS.n275 0.08146
R608 VSS.n277 VSS.n276 0.08146
R609 VSS.n278 VSS.n277 0.08146
R610 VSS.n249 VSS.n234 0.0812785
R611 VSS.n300 VSS.n299 0.0803434
R612 VSS.n55 VSS.t41 1.05933
R613 VSS.n14 VSS.t46 0.00154981
R614 VSS.n310 VSS 0.0445
R615 VSS.n228 VSS 0.0445
R616 VSS.n232 VSS.t122 0.0394179
R617 VSS.t15 VSS.n100 0.0394179
R618 VSS.n307 VSS.n100 0.0389615
R619 VSS.n256 VSS.n232 0.0389615
R620 VSS.t49 VSS.n264 0.031258
R621 VSS.n262 VSS.t42 0.031258
R622 VSS.n225 VSS.t51 0.031258
R623 VSS.n269 VSS.n268 0.0291125
R624 VSS.n279 VSS.n227 0.0291125
R625 VSS.n280 VSS.n279 0.0291125
R626 VSS.n269 VSS.n260 0.0291125
R627 VSS.n268 VSS.n261 0.0281144
R628 VSS.n227 VSS.n224 0.0281144
R629 VSS.n281 VSS.n280 0.0281144
R630 VSS.n265 VSS.n260 0.0281144
R631 VSS.n18 VSS.n15 0.0216549
R632 VSS.n282 VSS.t45 0.0208704
R633 VSS.n263 VSS.n8 0.0202884
R634 VSS.n267 VSS.n266 0.0202884
R635 VSS.n282 VSS.n223 0.0202884
R636 VSS.n226 VSS.n13 0.0202884
R637 VSS.n274 VSS.n259 0.0197308
R638 VSS.n274 VSS.t97 0.019449
R639 VSS.n18 VSS.n16 0.0135839
R640 VSS.n9 VSS.n7 0.0111915
R641 VSS.n112 VSS.n89 0.00154734
R642 VSS.t53 VSS.n96 0.0133922
R643 VSS.t35 VSS.n25 0.0133922
R644 VSS.n27 VSS.t31 0.0133922
R645 VSS.n221 VSS.n220 0.0118857
R646 VSS.n218 VSS.n217 0.0118857
R647 VSS.n215 VSS.n214 0.0118857
R648 VSS.n53 VSS.n52 0.00653337
R649 VSS.n51 VSS.n118 0.0262321
R650 VSS.n122 VSS.n49 0.0534527
R651 VSS.n195 VSS.n29 0.0118857
R652 VSS.n188 VSS.n88 0.0180744
R653 VSS.n130 VSS.n128 0.0118857
R654 VSS.n134 VSS.n133 0.0118857
R655 VSS.n136 VSS.n134 0.0118857
R656 VSS.n24 VSS.n22 0.0118857
R657 VSS.n170 VSS.n168 0.0118857
R658 VSS.n168 VSS.n167 0.0118857
R659 VSS.n33 VSS.n32 0.0176935
R660 VSS.n87 VSS.n154 0.0294365
R661 VSS.n152 VSS.n151 0.0118857
R662 VSS.n148 VSS.n147 0.0118857
R663 VSS.n145 VSS.n30 0.0161786
R664 VSS.n147 VSS.n145 0.0118857
R665 VSS.n151 VSS.n148 0.0118857
R666 VSS.n154 VSS.n152 0.0118857
R667 VSS.n167 VSS.n164 0.0118857
R668 VSS.n171 VSS.n170 0.0118857
R669 VSS.n22 VSS.n171 0.0118857
R670 VSS.n133 VSS.n132 0.0118857
R671 VSS.n12 VSS.n132 0.0237562
R672 VSS.n11 VSS.n10 0.00668905
R673 VSS.n88 VSS.t97 0.00668938
R674 VSS.n196 VSS.n195 0.0118857
R675 VSS.n42 VSS.n196 0.0180738
R676 VSS.n20 VSS.n122 0.0118857
R677 VSS.n118 VSS.n54 0.0492861
R678 VSS.n217 VSS.n215 0.0118857
R679 VSS.n220 VSS.n218 0.0118857
R680 VSS.n9 VSS.n8 0.0115582
R681 VSS.n266 VSS.n9 0.0115582
R682 VSS.n18 VSS.n13 0.0112672
R683 VSS.n26 VSS.n45 0.0506578
R684 VSS.n26 VSS.t129 18.799
R685 VSS.n26 VSS.t133 14.4648
R686 VSS.n302 VSS.n44 0.963914
R687 VSS.n68 VSS.n55 0.157361
R688 VSS.n3 VSS.n27 0.0123024
R689 VSS.n0 VSS.n25 0.0123024
R690 VSS.n221 VSS.n17 0.0174081
R691 VSS.n188 VSS.n40 0.0174081
R692 VSS.n39 VSS.n128 0.0174081
R693 VSS.n36 VSS.n32 0.0174081
R694 VSS.n264 VSS.n263 0.0108877
R695 VSS.n267 VSS.n262 0.0108877
R696 VSS.n15 VSS.n223 0.0108877
R697 VSS.n226 VSS.n225 0.0108877
R698 VSS.n18 VSS.n14 0.0100483
R699 VSS.n18 VSS.t52 0.0101032
R700 VSS.n9 VSS.t48 0.00981217
R701 VSS.n9 VSS.t41 0.00981217
R702 VSS VSS.n311 0.0095
R703 VSS.n309 VSS 0.0095
R704 VSS.n92 VSS.n91 0.00354511
R705 VSS.n110 VSS.n105 0.00798582
R706 VSS.n114 VSS.n103 0.00798582
R707 VSS.n104 VSS.n93 0.0151369
R708 VSS.n105 VSS.n104 0.00756994
R709 VSS.n90 VSS.n110 0.0150234
R710 VSS.n113 VSS.n96 0.00756994
R711 VSS.n114 VSS.n113 0.00756994
R712 VSS.n89 VSS.n103 0.0150057
R713 VSS.n21 VSS.n19 0.00754911
R714 VSS.n87 VSS.n34 0.0226578
R715 VSS.n21 VSS.n20 0.0215508
R716 VSS.n30 VSS.n9 0.0200861
R717 VSS.n24 VSS.n23 0.0187349
R718 VSS.n18 VSS.n17 0.017702
R719 VSS.n29 VSS.n28 0.0174081
R720 VSS.n5 VSS.t33 17.0032
R721 VSS.t37 VSS.n2 17.0032
C0 VDD vin1 29.2329f
C1 VDD vout1 15.3949f
C2 vin2 VDD 29.202f
C3 vin3 vin2 0.05785f
C4 vin3 VDD 29.202f
C5 vout3 VDD 15.3834f
C6 vin3 vout3 18.2968f
C7 vout4 VDD 15.3949f
C8 vin4 VDD 29.2329f
C9 vin3 vin4 0.05053f
C10 vout2 vin2 18.2968f
C11 vin1 vout1 18.2968f
C12 vin2 vin1 0.05053f
C13 vin4 vout4 18.2968f
C14 vout2 VDD 15.3834f
C15 vout1 VSS 13.57609f
C16 vout2 VSS 13.55759f
C17 vout3 VSS 13.55759f
C18 vout4 VSS 13.57609f
C19 VSS.t105 VSS 8.00945f
C20 VSS.t24 VSS 8.0271f
C21 VSS.t76 VSS 8.00945f
.ends

* PEX produced on Wed Aug 26 09:49:27 AM CEST 2026 using /foss/tools/sak/sak-pex.sh with m=3 and s=1 (extresist threshold=10000 mOhm, minres=1000 mOhm, mindelay=1 ps)
* NGSPICE file created from inverter_top_pex.ext - technology: ihp-sg13g2

.subckt inverter_top_pex VDD vin4 vout4 VSS vin3 vout3 vin2 vout2 vout1 vin1
X0 vout3 vin3 VSS.t105 VSS.t86 sg13_lv_nmos ad=0.19p pd=1.38u as=0.19p ps=1.38u w=1u l=1u
X1 VDD VDD VDD VDD sg13_lv_pmos ad=1.14p pd=6.38u as=0.56797n ps=1.006m w=6u l=1u
X2 VSS.t1 VSS.t53 VSS.t55 VSS.t54 sg13_lv_nmos ad=0.34p pd=2.68u as=0 ps=0 w=1u l=1u
X3 VDD VDD VDD VDD sg13_lv_pmos ad=1.14p pd=6.38u as=0 ps=0 w=6u l=1u
X4 VDD vin4 vout4 VDD sg13_lv_pmos ad=1.14p pd=6.38u as=1.14p ps=6.38u w=6u l=1u
X5 vout2 vin2 VSS.t76 VSS.t77 sg13_lv_nmos ad=0.19p pd=1.38u as=0.19p ps=1.38u w=1u l=1u
X6 vout3 vin3 VDD VDD sg13_lv_pmos ad=1.14p pd=6.38u as=1.14p ps=6.38u w=6u l=1u
X7 vout4 vin4 VSS.t110 VSS.t111 sg13_lv_nmos ad=0.19p pd=1.38u as=0.19p ps=1.38u w=1u l=1u
X8 vout3 vin3 VSS.t42 VSS.t59 sg13_lv_nmos ad=0.19p pd=1.38u as=0.19p ps=1.38u w=1u l=1u
X9 vout2 vin2 VSS.t70 VSS.t71 sg13_lv_nmos ad=0.19p pd=1.38u as=0.19p ps=1.38u w=1u l=1u
X10 vout4 vin4 VDD VDD sg13_lv_pmos ad=1.14p pd=6.38u as=1.14p ps=6.38u w=6u l=1u
X11 VDD vin2 vout2 VDD sg13_lv_pmos ad=1.14p pd=6.38u as=1.14p ps=6.38u w=6u l=1u
X12 VSS.t76 vin2 vout2 VSS.t75 sg13_lv_nmos ad=0.19p pd=1.38u as=0.19p ps=1.38u w=1u l=1u
X13 vout2 vin2 VSS.t79 VSS.t80 sg13_lv_nmos ad=0.19p pd=1.38u as=0.19p ps=1.38u w=1u l=1u
X14 vout2 vin2 VDD VDD sg13_lv_pmos ad=1.14p pd=6.38u as=1.14p ps=6.38u w=6u l=1u
X15 VSS.t116 vin4 vout4 VSS.t115 sg13_lv_nmos ad=0.19p pd=1.38u as=0.19p ps=1.38u w=1u l=1u
X16 vout1 vin1 VSS.t24 VSS.t25 sg13_lv_nmos ad=0.19p pd=1.38u as=0.19p ps=1.38u w=1u l=1u
X17 VDD vin2 vout2 VDD sg13_lv_pmos ad=1.14p pd=6.38u as=1.14p ps=6.38u w=6u l=1u
X18 vout4 vin4 VSS.t34 VSS.t108 sg13_lv_nmos ad=0.19p pd=1.38u as=0.19p ps=1.38u w=1u l=1u
X19 VDD vin2 vout2 VDD sg13_lv_pmos ad=1.14p pd=6.38u as=1.14p ps=6.38u w=6u l=1u
X20 VSS.t105 vin3 vout3 VSS.t84 sg13_lv_nmos ad=0.19p pd=1.38u as=0.19p ps=1.38u w=1u l=1u
X21 vout4 vin4 VSS.t125 VSS.t126 sg13_lv_nmos ad=0.19p pd=1.38u as=0.19p ps=1.38u w=1u l=1u
X22 VSS.t119 vin4 vout4 VSS.t118 sg13_lv_nmos ad=0.19p pd=1.38u as=0.19p ps=1.38u w=1u l=1u
X23 VDD vin3 vout3 VDD sg13_lv_pmos ad=1.14p pd=6.38u as=1.14p ps=6.38u w=6u l=1u
X24 VDD vin2 vout2 VDD sg13_lv_pmos ad=1.14p pd=6.38u as=1.14p ps=6.38u w=6u l=1u
X25 vout3 vin3 VDD VDD sg13_lv_pmos ad=1.14p pd=6.38u as=1.14p ps=6.38u w=6u l=1u
X26 VSS.t70 vin2 vout2 VSS.t69 sg13_lv_nmos ad=0.19p pd=1.38u as=0.19p ps=1.38u w=1u l=1u
X27 VDD vin3 vout3 VDD sg13_lv_pmos ad=1.14p pd=6.38u as=1.14p ps=6.38u w=6u l=1u
X28 VSS.t42 VSS.t39 VSS.t41 VSS.t40 sg13_lv_nmos ad=0.34p pd=2.68u as=0 ps=0 w=1u l=1u
X29 vout2 vin2 VDD VDD sg13_lv_pmos ad=1.14p pd=6.38u as=1.14p ps=6.38u w=6u l=1u
X30 vout2 vin2 VSS.t73 VSS.t74 sg13_lv_nmos ad=0.19p pd=1.38u as=0.19p ps=1.38u w=1u l=1u
X31 vout1 vin1 VSS.t18 VSS.t19 sg13_lv_nmos ad=0.19p pd=1.38u as=0.19p ps=1.38u w=1u l=1u
X32 VSS.t79 vin2 vout2 VSS.t78 sg13_lv_nmos ad=0.19p pd=1.38u as=0.19p ps=1.38u w=1u l=1u
X33 vout4 vin4 VSS.t122 VSS.t123 sg13_lv_nmos ad=0.19p pd=1.38u as=0.19p ps=1.38u w=1u l=1u
X34 vout1 vin1 VDD VDD sg13_lv_pmos ad=1.14p pd=6.38u as=1.14p ps=6.38u w=6u l=1u
X35 vout1 vin1 VSS.t12 VSS.t13 sg13_lv_nmos ad=0.19p pd=1.38u as=0.19p ps=1.38u w=1u l=1u
X36 VSS.t128 vin4 vout4 VSS.t127 sg13_lv_nmos ad=0.19p pd=1.38u as=0.19p ps=1.38u w=1u l=1u
X37 VDD VDD VDD VDD sg13_lv_pmos ad=1.14p pd=6.38u as=0 ps=0 w=6u l=1u
X38 VSS.t18 vin1 vout1 VSS.t17 sg13_lv_nmos ad=0.19p pd=1.38u as=0.19p ps=1.38u w=1u l=1u
X39 vout2 vin2 VDD VDD sg13_lv_pmos ad=1.14p pd=6.38u as=1.14p ps=6.38u w=6u l=1u
X40 VDD vin4 vout4 VDD sg13_lv_pmos ad=1.14p pd=6.38u as=1.14p ps=6.38u w=6u l=1u
X41 vout1 vin1 VSS.t21 VSS.t22 sg13_lv_nmos ad=0.19p pd=1.38u as=0.19p ps=1.38u w=1u l=1u
X42 vout3 vin3 VSS.t103 VSS.t83 sg13_lv_nmos ad=0.19p pd=1.38u as=0.19p ps=1.38u w=1u l=1u
X43 VDD vin3 vout3 VDD sg13_lv_pmos ad=1.14p pd=6.38u as=1.14p ps=6.38u w=6u l=1u
X44 vout4 vin4 VDD VDD sg13_lv_pmos ad=1.14p pd=6.38u as=1.14p ps=6.38u w=6u l=1u
X45 VDD vin4 vout4 VDD sg13_lv_pmos ad=1.14p pd=6.38u as=1.14p ps=6.38u w=6u l=1u
X46 vout3 vin3 VDD VDD sg13_lv_pmos ad=1.14p pd=6.38u as=1.14p ps=6.38u w=6u l=1u
X47 VDD vin3 vout3 VDD sg13_lv_pmos ad=1.14p pd=6.38u as=1.14p ps=6.38u w=6u l=1u
X48 VSS.t38 VSS.t35 VSS.t37 VSS.t36 sg13_lv_nmos ad=0.19p pd=1.38u as=0 ps=0 w=1u l=1u
X49 VDD vin4 vout4 VDD sg13_lv_pmos ad=1.14p pd=6.38u as=1.14p ps=6.38u w=6u l=1u
X50 VDD vin2 vout2 VDD sg13_lv_pmos ad=1.14p pd=6.38u as=1.14p ps=6.38u w=6u l=1u
X51 VSS.t131 vin4 vout4 VSS.t130 sg13_lv_nmos ad=0.19p pd=1.38u as=0.19p ps=1.38u w=1u l=1u
X52 VDD vin3 vout3 VDD sg13_lv_pmos ad=1.14p pd=6.38u as=1.14p ps=6.38u w=6u l=1u
X53 VSS.t12 vin1 vout1 VSS.t11 sg13_lv_nmos ad=0.19p pd=1.38u as=0.19p ps=1.38u w=1u l=1u
X54 VDD vin1 vout1 VDD sg13_lv_pmos ad=1.14p pd=6.38u as=1.14p ps=6.38u w=6u l=1u
X55 vout4 vin4 VSS.t134 VSS.t135 sg13_lv_nmos ad=0.19p pd=1.38u as=0.19p ps=1.38u w=1u l=1u
X56 vout1 vin1 VDD VDD sg13_lv_pmos ad=1.14p pd=6.38u as=1.14p ps=6.38u w=6u l=1u
X57 vout4 vin4 VDD VDD sg13_lv_pmos ad=1.14p pd=6.38u as=1.14p ps=6.38u w=6u l=1u
X58 vout1 vin1 VSS.t15 VSS.t16 sg13_lv_nmos ad=0.19p pd=1.38u as=0.19p ps=1.38u w=1u l=1u
X59 VDD vin1 vout1 VDD sg13_lv_pmos ad=1.14p pd=6.38u as=1.14p ps=6.38u w=6u l=1u
X60 vout3 vin3 VSS.t99 VSS.t77 sg13_lv_nmos ad=0.19p pd=1.38u as=0.19p ps=1.38u w=1u l=1u
X61 VSS.t21 vin1 vout1 VSS.t20 sg13_lv_nmos ad=0.19p pd=1.38u as=0.19p ps=1.38u w=1u l=1u
X62 VDD VDD VDD VDD sg13_lv_pmos ad=2.04p pd=12.68u as=0 ps=0 w=6u l=1u
X63 vout4 vin4 VDD VDD sg13_lv_pmos ad=1.14p pd=6.38u as=1.14p ps=6.38u w=6u l=1u
X64 VDD vin3 vout3 VDD sg13_lv_pmos ad=1.14p pd=6.38u as=1.14p ps=6.38u w=6u l=1u
X65 VDD vin4 vout4 VDD sg13_lv_pmos ad=1.14p pd=6.38u as=1.14p ps=6.38u w=6u l=1u
X66 vout3 vin3 VDD VDD sg13_lv_pmos ad=1.14p pd=6.38u as=1.14p ps=6.38u w=6u l=1u
X67 vout3 vin3 VSS.t95 VSS.t71 sg13_lv_nmos ad=0.19p pd=1.38u as=0.19p ps=1.38u w=1u l=1u
X68 VSS.t99 vin3 vout3 VSS.t75 sg13_lv_nmos ad=0.19p pd=1.38u as=0.19p ps=1.38u w=1u l=1u
X69 VDD VDD VDD VDD sg13_lv_pmos ad=1.14p pd=6.38u as=0 ps=0 w=6u l=1u
X70 vout3 vin3 VSS.t101 VSS.t80 sg13_lv_nmos ad=0.19p pd=1.38u as=0.19p ps=1.38u w=1u l=1u
X71 vout4 vin4 VDD VDD sg13_lv_pmos ad=1.14p pd=6.38u as=1.14p ps=6.38u w=6u l=1u
X72 vout3 vin3 VDD VDD sg13_lv_pmos ad=1.14p pd=6.38u as=1.14p ps=6.38u w=6u l=1u
X73 VDD vin1 vout1 VDD sg13_lv_pmos ad=1.14p pd=6.38u as=1.14p ps=6.38u w=6u l=1u
X74 vout2 vin2 VDD VDD sg13_lv_pmos ad=1.14p pd=6.38u as=1.14p ps=6.38u w=6u l=1u
X75 vout1 vin1 VDD VDD sg13_lv_pmos ad=1.14p pd=6.38u as=1.14p ps=6.38u w=6u l=1u
X76 vout2 vin2 VSS.t64 VSS.t65 sg13_lv_nmos ad=0.19p pd=1.38u as=0.19p ps=1.38u w=1u l=1u
X77 VDD vin1 vout1 VDD sg13_lv_pmos ad=1.14p pd=6.38u as=1.14p ps=6.38u w=6u l=1u
X78 VDD vin1 vout1 VDD sg13_lv_pmos ad=1.14p pd=6.38u as=1.14p ps=6.38u w=6u l=1u
X79 VDD vin3 vout3 VDD sg13_lv_pmos ad=1.14p pd=6.38u as=1.14p ps=6.38u w=6u l=1u
X80 VSS.t95 vin3 vout3 VSS.t69 sg13_lv_nmos ad=0.19p pd=1.38u as=0.19p ps=1.38u w=1u l=1u
X81 vout3 vin3 VSS.t97 VSS.t74 sg13_lv_nmos ad=0.19p pd=1.38u as=0.19p ps=1.38u w=1u l=1u
X82 VSS.t113 vin4 vout4 VSS.t112 sg13_lv_nmos ad=0.19p pd=1.38u as=0.19p ps=1.38u w=1u l=1u
X83 VDD vin4 vout4 VDD sg13_lv_pmos ad=1.14p pd=6.38u as=1.14p ps=6.38u w=6u l=1u
X84 VSS.t101 vin3 vout3 VSS.t78 sg13_lv_nmos ad=0.19p pd=1.38u as=0.19p ps=1.38u w=1u l=1u
X85 vout4 vin4 VSS.t116 VSS.t117 sg13_lv_nmos ad=0.19p pd=1.38u as=0.19p ps=1.38u w=1u l=1u
X86 VDD vin1 vout1 VDD sg13_lv_pmos ad=1.14p pd=6.38u as=1.14p ps=6.38u w=6u l=1u
X87 vout2 vin2 VDD VDD sg13_lv_pmos ad=1.14p pd=6.38u as=1.14p ps=6.38u w=6u l=1u
X88 vout1 vin1 VDD VDD sg13_lv_pmos ad=1.14p pd=6.38u as=1.14p ps=6.38u w=6u l=1u
X89 VSS.t110 vin4 vout4 VSS.t109 sg13_lv_nmos ad=0.19p pd=1.38u as=0.19p ps=1.38u w=1u l=1u
X90 VDD VDD VDD VDD sg13_lv_pmos ad=2.04p pd=12.68u as=0 ps=0 w=6u l=1u
X91 vout2 vin2 VDD VDD sg13_lv_pmos ad=1.14p pd=6.38u as=1.14p ps=6.38u w=6u l=1u
X92 VDD vin2 vout2 VDD sg13_lv_pmos ad=1.14p pd=6.38u as=1.14p ps=6.38u w=6u l=1u
X93 VSS.t64 vin2 vout2 VSS.t63 sg13_lv_nmos ad=0.19p pd=1.38u as=0.19p ps=1.38u w=1u l=1u
X94 VSS.t122 vin4 vout4 VSS.t121 sg13_lv_nmos ad=0.19p pd=1.38u as=0.19p ps=1.38u w=1u l=1u
X95 vout2 vin2 VDD VDD sg13_lv_pmos ad=1.14p pd=6.38u as=1.14p ps=6.38u w=6u l=1u
X96 VDD VDD VDD VDD sg13_lv_pmos ad=2.04p pd=12.68u as=0 ps=0 w=6u l=1u
X97 vout2 vin2 VSS.t67 VSS.t68 sg13_lv_nmos ad=0.19p pd=1.38u as=0.19p ps=1.38u w=1u l=1u
X98 VSS.t73 vin2 vout2 VSS.t72 sg13_lv_nmos ad=0.19p pd=1.38u as=0.19p ps=1.38u w=1u l=1u
X99 vout1 vin1 VDD VDD sg13_lv_pmos ad=1.14p pd=6.38u as=1.14p ps=6.38u w=6u l=1u
X100 vout1 vin1 VSS.t6 VSS.t7 sg13_lv_nmos ad=0.19p pd=1.38u as=0.19p ps=1.38u w=1u l=1u
X101 vout4 vin4 VSS.t119 VSS.t120 sg13_lv_nmos ad=0.19p pd=1.38u as=0.19p ps=1.38u w=1u l=1u
X102 vout3 vin3 VDD VDD sg13_lv_pmos ad=1.14p pd=6.38u as=1.14p ps=6.38u w=6u l=1u
X103 vout4 vin4 VSS.t131 VSS.t132 sg13_lv_nmos ad=0.19p pd=1.38u as=0.19p ps=1.38u w=1u l=1u
X104 VSS.t52 VSS.t50 VSS.t51 VSS.t44 sg13_lv_nmos ad=0.19p pd=1.38u as=0 ps=0 w=1u l=1u
X105 VSS.t125 vin4 vout4 VSS.t124 sg13_lv_nmos ad=0.19p pd=1.38u as=0.19p ps=1.38u w=1u l=1u
X106 VDD vin1 vout1 VDD sg13_lv_pmos ad=1.14p pd=6.38u as=1.14p ps=6.38u w=6u l=1u
X107 VSS.t51 vin2 vout2 VSS.t87 sg13_lv_nmos ad=0.19p pd=1.38u as=0.19p ps=1.38u w=1u l=1u
X108 VDD vin2 vout2 VDD sg13_lv_pmos ad=1.14p pd=6.38u as=1.14p ps=6.38u w=6u l=1u
X109 vout4 vin4 VSS.t128 VSS.t129 sg13_lv_nmos ad=0.19p pd=1.38u as=0.19p ps=1.38u w=1u l=1u
X110 vout4 vin4 VDD VDD sg13_lv_pmos ad=1.14p pd=6.38u as=1.14p ps=6.38u w=6u l=1u
X111 vout2 vin2 VDD VDD sg13_lv_pmos ad=1.14p pd=6.38u as=1.14p ps=6.38u w=6u l=1u
X112 vout2 vin2 VSS.t61 VSS.t62 sg13_lv_nmos ad=0.19p pd=1.38u as=0.19p ps=1.38u w=1u l=1u
X113 VDD vin2 vout2 VDD sg13_lv_pmos ad=1.14p pd=6.38u as=1.14p ps=6.38u w=6u l=1u
X114 VSS.t67 vin2 vout2 VSS.t66 sg13_lv_nmos ad=0.19p pd=1.38u as=0.19p ps=1.38u w=1u l=1u
X115 VDD vin4 vout4 VDD sg13_lv_pmos ad=1.14p pd=6.38u as=1.14p ps=6.38u w=6u l=1u
X116 VDD VDD VDD VDD sg13_lv_pmos ad=2.04p pd=12.68u as=0 ps=0 w=6u l=1u
X117 VSS.t61 vin2 vout2 VSS.t60 sg13_lv_nmos ad=0.19p pd=1.38u as=0.19p ps=1.38u w=1u l=1u
X118 VSS.t6 vin1 vout1 VSS.t5 sg13_lv_nmos ad=0.19p pd=1.38u as=0.19p ps=1.38u w=1u l=1u
X119 vout3 vin3 VDD VDD sg13_lv_pmos ad=1.14p pd=6.38u as=1.14p ps=6.38u w=6u l=1u
X120 vout1 vin1 VSS.t9 VSS.t10 sg13_lv_nmos ad=0.19p pd=1.38u as=0.19p ps=1.38u w=1u l=1u
X121 VSS.t15 vin1 vout1 VSS.t14 sg13_lv_nmos ad=0.19p pd=1.38u as=0.19p ps=1.38u w=1u l=1u
X122 vout3 vin3 VDD VDD sg13_lv_pmos ad=1.14p pd=6.38u as=1.14p ps=6.38u w=6u l=1u
X123 VDD vin3 vout3 VDD sg13_lv_pmos ad=1.14p pd=6.38u as=1.14p ps=6.38u w=6u l=1u
X124 vout3 vin3 VDD VDD sg13_lv_pmos ad=1.14p pd=6.38u as=1.14p ps=6.38u w=6u l=1u
X125 vout3 vin3 VSS.t91 VSS.t65 sg13_lv_nmos ad=0.19p pd=1.38u as=0.19p ps=1.38u w=1u l=1u
X126 VSS.t82 vin2 vout2 VSS.t81 sg13_lv_nmos ad=0.19p pd=1.38u as=0.19p ps=1.38u w=1u l=1u
X127 vout1 vin1 VDD VDD sg13_lv_pmos ad=1.14p pd=6.38u as=1.14p ps=6.38u w=6u l=1u
X128 vout2 vin2 VSS.t85 VSS.t86 sg13_lv_nmos ad=0.19p pd=1.38u as=0.19p ps=1.38u w=1u l=1u
X129 VSS.t37 vin4 vout4 VSS.t136 sg13_lv_nmos ad=0.19p pd=1.38u as=0.19p ps=1.38u w=1u l=1u
X130 VSS.t58 VSS.t56 VSS.t30 VSS.t57 sg13_lv_nmos ad=0.19p pd=1.38u as=0 ps=0 w=1u l=1u
X131 VSS.t30 vin1 vout1 VSS.t29 sg13_lv_nmos ad=0.19p pd=1.38u as=0.19p ps=1.38u w=1u l=1u
X132 vout2 vin2 VSS.t49 VSS.t59 sg13_lv_nmos ad=0.19p pd=1.38u as=0.19p ps=1.38u w=1u l=1u
X133 VSS.t34 VSS.t31 VSS.t33 VSS.t32 sg13_lv_nmos ad=0.34p pd=2.68u as=0 ps=0 w=1u l=1u
X134 vout1 vin1 VSS.t3 VSS.t4 sg13_lv_nmos ad=0.19p pd=1.38u as=0.19p ps=1.38u w=1u l=1u
X135 VSS.t9 vin1 vout1 VSS.t8 sg13_lv_nmos ad=0.19p pd=1.38u as=0.19p ps=1.38u w=1u l=1u
X136 VDD vin3 vout3 VDD sg13_lv_pmos ad=1.14p pd=6.38u as=1.14p ps=6.38u w=6u l=1u
X137 VSS.t3 vin1 vout1 VSS.t2 sg13_lv_nmos ad=0.19p pd=1.38u as=0.19p ps=1.38u w=1u l=1u
X138 vout4 vin4 VDD VDD sg13_lv_pmos ad=1.14p pd=6.38u as=1.14p ps=6.38u w=6u l=1u
X139 vout3 vin3 VDD VDD sg13_lv_pmos ad=1.14p pd=6.38u as=1.14p ps=6.38u w=6u l=1u
X140 VDD vin3 vout3 VDD sg13_lv_pmos ad=1.14p pd=6.38u as=1.14p ps=6.38u w=6u l=1u
X141 VSS.t91 vin3 vout3 VSS.t63 sg13_lv_nmos ad=0.19p pd=1.38u as=0.19p ps=1.38u w=1u l=1u
X142 vout3 vin3 VSS.t93 VSS.t68 sg13_lv_nmos ad=0.19p pd=1.38u as=0.19p ps=1.38u w=1u l=1u
X143 vout1 vin1 VDD VDD sg13_lv_pmos ad=1.14p pd=6.38u as=1.14p ps=6.38u w=6u l=1u
X144 VSS.t85 vin2 vout2 VSS.t84 sg13_lv_nmos ad=0.19p pd=1.38u as=0.19p ps=1.38u w=1u l=1u
X145 VSS.t97 vin3 vout3 VSS.t72 sg13_lv_nmos ad=0.19p pd=1.38u as=0.19p ps=1.38u w=1u l=1u
X146 VDD vin4 vout4 VDD sg13_lv_pmos ad=1.14p pd=6.38u as=1.14p ps=6.38u w=6u l=1u
X147 vout1 vin1 VDD VDD sg13_lv_pmos ad=1.14p pd=6.38u as=1.14p ps=6.38u w=6u l=1u
X148 VDD vin1 vout1 VDD sg13_lv_pmos ad=1.14p pd=6.38u as=1.14p ps=6.38u w=6u l=1u
X149 vout4 vin4 VDD VDD sg13_lv_pmos ad=1.14p pd=6.38u as=1.14p ps=6.38u w=6u l=1u
X150 VSS.t24 vin1 vout1 VSS.t23 sg13_lv_nmos ad=0.19p pd=1.38u as=0.19p ps=1.38u w=1u l=1u
X151 vout1 vin1 VSS.t27 VSS.t28 sg13_lv_nmos ad=0.19p pd=1.38u as=0.19p ps=1.38u w=1u l=1u
X152 vout1 vin1 VDD VDD sg13_lv_pmos ad=1.14p pd=6.38u as=1.14p ps=6.38u w=6u l=1u
X153 vout2 vin2 VDD VDD sg13_lv_pmos ad=1.14p pd=6.38u as=1.14p ps=6.38u w=6u l=1u
X154 vout4 vin4 VSS.t113 VSS.t114 sg13_lv_nmos ad=0.19p pd=1.38u as=0.19p ps=1.38u w=1u l=1u
X155 VSS.t49 VSS.t47 VSS.t48 VSS.t40 sg13_lv_nmos ad=0.34p pd=2.68u as=0 ps=0 w=1u l=1u
X156 VSS.t46 VSS.t43 VSS.t45 VSS.t44 sg13_lv_nmos ad=0.19p pd=1.38u as=0 ps=0 w=1u l=1u
X157 vout4 vin4 VDD VDD sg13_lv_pmos ad=1.14p pd=6.38u as=1.14p ps=6.38u w=6u l=1u
X158 VSS.t45 vin3 vout3 VSS.t87 sg13_lv_nmos ad=0.19p pd=1.38u as=0.19p ps=1.38u w=1u l=1u
X159 VSS.t134 vin4 vout4 VSS.t133 sg13_lv_nmos ad=0.19p pd=1.38u as=0.19p ps=1.38u w=1u l=1u
X160 VDD vin4 vout4 VDD sg13_lv_pmos ad=1.14p pd=6.38u as=1.14p ps=6.38u w=6u l=1u
X161 vout1 vin1 VSS.t1 VSS.t0 sg13_lv_nmos ad=0.19p pd=1.38u as=0.19p ps=1.38u w=1u l=1u
X162 vout3 vin3 VSS.t89 VSS.t62 sg13_lv_nmos ad=0.19p pd=1.38u as=0.19p ps=1.38u w=1u l=1u
X163 VSS.t93 vin3 vout3 VSS.t66 sg13_lv_nmos ad=0.19p pd=1.38u as=0.19p ps=1.38u w=1u l=1u
X164 vout4 vin4 VDD VDD sg13_lv_pmos ad=1.14p pd=6.38u as=1.14p ps=6.38u w=6u l=1u
X165 vout2 vin2 VSS.t82 VSS.t83 sg13_lv_nmos ad=0.19p pd=1.38u as=0.19p ps=1.38u w=1u l=1u
X166 VSS.t89 vin3 vout3 VSS.t60 sg13_lv_nmos ad=0.19p pd=1.38u as=0.19p ps=1.38u w=1u l=1u
X167 VDD vin1 vout1 VDD sg13_lv_pmos ad=1.14p pd=6.38u as=1.14p ps=6.38u w=6u l=1u
X168 vout1 vin1 VDD VDD sg13_lv_pmos ad=1.14p pd=6.38u as=1.14p ps=6.38u w=6u l=1u
X169 VDD vin1 vout1 VDD sg13_lv_pmos ad=1.14p pd=6.38u as=1.14p ps=6.38u w=6u l=1u
X170 VDD vin4 vout4 VDD sg13_lv_pmos ad=1.14p pd=6.38u as=1.14p ps=6.38u w=6u l=1u
X171 VSS.t27 vin1 vout1 VSS.t26 sg13_lv_nmos ad=0.19p pd=1.38u as=0.19p ps=1.38u w=1u l=1u
X172 VDD vin2 vout2 VDD sg13_lv_pmos ad=1.14p pd=6.38u as=1.14p ps=6.38u w=6u l=1u
X173 vout2 vin2 VDD VDD sg13_lv_pmos ad=1.14p pd=6.38u as=1.14p ps=6.38u w=6u l=1u
X174 VDD vin2 vout2 VDD sg13_lv_pmos ad=1.14p pd=6.38u as=1.14p ps=6.38u w=6u l=1u
X175 VSS.t103 vin3 vout3 VSS.t81 sg13_lv_nmos ad=0.19p pd=1.38u as=0.19p ps=1.38u w=1u l=1u
R0 VSS.n414 VSS.n2 6777.49
R1 VSS.n414 VSS.n28 6777.49
R2 VSS.n43 VSS.n419 1580.41
R3 VSS.n415 VSS.n414 1580.41
R4 VSS.n419 VSS.n93 3.4696
R5 VSS.n45 VSS.n65 14.1877
R6 VSS.t59 VSS.n78 88.7251
R7 VSS.n299 VSS.t87 88.7251
R8 VSS.t60 VSS.n77 83.1798
R9 VSS.t86 VSS.n92 83.1798
R10 VSS.n195 VSS.t62 77.6345
R11 VSS.n91 VSS.t84 77.6345
R12 VSS.t32 VSS.n2 6.87872
R13 VSS.t36 VSS.n2 6.87897
R14 VSS.t63 VSS.n76 72.0892
R15 VSS.n90 VSS.t83 72.0892
R16 VSS.t136 VSS.n2 9.76925
R17 VSS.n191 VSS.t65 66.5439
R18 VSS.n89 VSS.t81 66.5439
R19 VSS.t135 VSS.n2 12.2976
R20 VSS.n2 VSS.t109 12.3005
R21 VSS.t66 VSS.n75 60.9987
R22 VSS.n275 VSS.t80 60.9987
R23 VSS.n2 VSS.t132 16.2707
R24 VSS.n2 VSS.t130 17.7154
R25 VSS.t68 VSS.n74 55.4534
R26 VSS.n86 VSS.t72 55.4534
R27 VSS.n169 VSS.t74 55.4534
R28 VSS.n272 VSS.t78 55.4534
R29 VSS.n2 VSS.t114 17.717
R30 VSS.n18 VSS.t26 60.7271
R31 VSS.n185 VSS.t69 49.9081
R32 VSS.n253 VSS.t71 49.9081
R33 VSS.t75 VSS.n71 49.9081
R34 VSS.t77 VSS.n88 49.9081
R35 VSS.t129 VSS.n2 18.799
R36 VSS.n36 VSS.t25 56.9314
R37 VSS.n2 VSS.t126 19.8823
R38 VSS.n3 VSS.n2 0.0490479
R39 VSS.n25 VSS.t23 53.1364
R40 VSS.t69 VSS.n85 44.3628
R41 VSS.t71 VSS.n73 44.3628
R42 VSS.n261 VSS.t75 44.3628
R43 VSS.n162 VSS.t77 44.3628
R44 VSS.n27 VSS.t22 49.3419
R45 VSS.n84 VSS.t68 38.8175
R46 VSS.t72 VSS.n72 38.8175
R47 VSS.t74 VSS.n87 38.8175
R48 VSS.t78 VSS.n159 38.8175
R49 VSS.t124 VSS.n2 19.882
R50 VSS.t118 VSS.n2 19.8825
R51 VSS.n2 VSS.t120 19.8818
R52 VSS.n21 VSS.t14 45.5468
R53 VSS.n3 VSS.t121 19.5044
R54 VSS.t117 VSS.n2 19.5219
R55 VSS.n31 VSS.t13 41.7518
R56 VSS.n20 VSS.t19 41.7518
R57 VSS.n240 VSS.t66 33.2722
R58 VSS.t80 VSS.n70 33.2722
R59 VSS.t115 VSS.n2 18.8
R60 VSS.n38 VSS.t11 37.9561
R61 VSS.t65 VSS.n83 27.7269
R62 VSS.t81 VSS.n69 27.7269
R63 VSS.n35 VSS.t10 34.1616
R64 VSS.t112 VSS.n2 16.2727
R65 VSS.n23 VSS.t28 64.5232
R66 VSS.t17 VSS.n26 37.9577
R67 VSS.t20 VSS.n39 45.5478
R68 VSS.n230 VSS.t63 22.1816
R69 VSS.t83 VSS.n68 22.1816
R70 VSS.t111 VSS.n2 14.4672
R71 VSS.n19 VSS.t7 26.5715
R72 VSS.n22 VSS.t29 11.4002
R73 VSS.n37 VSS.t28 15.1866
R74 VSS.n18 VSS.t25 22.7768
R75 VSS.n36 VSS.t23 26.5722
R76 VSS.n27 VSS.t20 34.162
R77 VSS.n17 VSS.n39 0.0108886
R78 VSS.n17 VSS.n20 0.0108886
R79 VSS.n34 VSS.t14 34.1651
R80 VSS.n17 VSS.n31 0.0109013
R81 VSS.n31 VSS.t11 41.7521
R82 VSS.n17 VSS.n35 0.0108886
R83 VSS.n17 VSS.n24 0.0109013
R84 VSS.n17 VSS.n19 0.0109013
R85 VSS.n19 VSS.t5 56.9324
R86 VSS.n30 VSS.t4 60.7274
R87 VSS.n17 VSS.n40 0.0109013
R88 VSS.n406 VSS.n17 17.0005
R89 VSS.n17 VSS.n62 17.0005
R90 VSS.n403 VSS.n17 17.0005
R91 VSS.n405 VSS.t58 17.0005
R92 VSS.t58 VSS.n404 17.0005
R93 VSS.t30 VSS.n402 17.0005
R94 VSS.n404 VSS.t30 17.0005
R95 VSS.t58 VSS.n402 17.0005
R96 VSS.n405 VSS.t30 17.0005
R97 VSS.n420 VSS.n17 17.0005
R98 VSS.n17 VSS.n423 17.0005
R99 VSS.n17 VSS.n63 17.0005
R100 VSS.t1 VSS.n421 17.0005
R101 VSS.n422 VSS.t1 17.0005
R102 VSS.t1 VSS.n100 17.0005
R103 VSS.n422 VSS.t55 17.0005
R104 VSS.t55 VSS.n100 17.0005
R105 VSS.n421 VSS.t55 17.0005
R106 VSS.n16 VSS.n65 17.0005
R107 VSS.n16 VSS.n307 17.0005
R108 VSS.n16 VSS.n305 17.0005
R109 VSS.n16 VSS.t44 17.0005
R110 VSS.n16 VSS.n303 17.0005
R111 VSS.n16 VSS.n138 17.0005
R112 VSS.n16 VSS.n301 17.0005
R113 VSS.n16 VSS.n66 17.0005
R114 VSS.n16 VSS.n299 17.0005
R115 VSS.n16 VSS.n143 17.0005
R116 VSS.n16 VSS.n145 17.0005
R117 VSS.n16 VSS.n298 17.0005
R118 VSS.n16 VSS.n146 17.0005
R119 VSS.n16 VSS.n15 0.00191501
R120 VSS.n16 VSS.n148 17.0005
R121 VSS.n16 VSS.n293 17.0005
R122 VSS.n16 VSS.n59 17.0005
R123 VSS.n16 VSS.n67 17.0005
R124 VSS.n16 VSS.n91 17.0005
R125 VSS.n16 VSS.n151 17.0005
R126 VSS.n16 VSS.n153 17.0005
R127 VSS.n16 VSS.n290 17.0005
R128 VSS.n16 VSS.n68 17.0005
R129 VSS.n16 VSS.n90 17.0005
R130 VSS.n16 VSS.n155 17.0005
R131 VSS.n16 VSS.n285 17.0005
R132 VSS.n16 VSS.n69 8.49814
R133 VSS.n16 VSS.n89 17.0005
R134 VSS.n16 VSS.n157 17.0005
R135 VSS.n16 VSS.n279 17.0005
R136 VSS.n16 VSS.n277 17.0005
R137 VSS.n16 VSS.n70 17.0005
R138 VSS.n16 VSS.n275 17.0005
R139 VSS.n16 VSS.n158 17.0005
R140 VSS.n16 VSS.n12 4.24736
R141 VSS.n16 VSS.n274 17.0005
R142 VSS.n16 VSS.n159 17.0005
R143 VSS.n16 VSS.n272 17.0005
R144 VSS.n16 VSS.n160 17.0005
R145 VSS.n16 VSS.n161 17.0005
R146 VSS.n16 VSS.n271 17.0005
R147 VSS.n16 VSS.n162 17.0005
R148 VSS.n16 VSS.n88 17.0005
R149 VSS.n16 VSS.n164 17.0005
R150 VSS.n16 VSS.n265 17.0005
R151 VSS.n16 VSS.n263 17.0005
R152 VSS.n16 VSS.n71 17.0005
R153 VSS.n16 VSS.n261 17.0005
R154 VSS.n16 VSS.n166 17.0005
R155 VSS.n16 VSS.n260 17.0005
R156 VSS.n16 VSS.n169 17.0005
R157 VSS.n16 VSS.n87 17.0005
R158 VSS.n16 VSS.n173 17.0005
R159 VSS.n16 VSS.n54 17.0005
R160 VSS.n16 VSS.n258 17.0005
R161 VSS.n16 VSS.n55 17.0005
R162 VSS.n14 VSS.n72 8.49799
R163 VSS.n16 VSS.n86 17.0005
R164 VSS.n16 VSS.n177 17.0005
R165 VSS.n16 VSS.n255 17.0005
R166 VSS.n16 VSS.n73 17.0005
R167 VSS.n16 VSS.n253 17.0005
R168 VSS.n16 VSS.n182 17.0005
R169 VSS.n16 VSS.n184 17.0005
R170 VSS.n16 VSS.n252 17.0005
R171 VSS.n16 VSS.n185 17.0005
R172 VSS.n16 VSS.n187 17.0005
R173 VSS.n16 VSS.n246 17.0005
R174 VSS.n16 VSS.n244 17.0005
R175 VSS.n16 VSS.n74 17.0005
R176 VSS.n16 VSS.n84 17.0005
R177 VSS.n16 VSS.n189 17.0005
R178 VSS.n16 VSS.n242 17.0005
R179 VSS.n7 VSS.n11 0.00734992
R180 VSS.n16 VSS.n75 17.0005
R181 VSS.n8 VSS.n7 0.0126856
R182 VSS.n16 VSS.n240 17.0005
R183 VSS.n16 VSS.n190 17.0005
R184 VSS.n16 VSS.n238 17.0005
R185 VSS.n16 VSS.n191 17.0005
R186 VSS.n16 VSS.n83 17.0005
R187 VSS.n16 VSS.n193 17.0005
R188 VSS.n16 VSS.n233 17.0005
R189 VSS.n16 VSS.n76 17.0005
R190 VSS.n16 VSS.n230 17.0005
R191 VSS.n16 VSS.n194 17.0005
R192 VSS.n16 VSS.n227 17.0005
R193 VSS.n16 VSS.n195 17.0005
R194 VSS.n16 VSS.n82 17.0005
R195 VSS.n16 VSS.n197 17.0005
R196 VSS.n16 VSS.n222 17.0005
R197 VSS.n16 VSS.n77 17.0005
R198 VSS.n16 VSS.n81 17.0005
R199 VSS.n16 VSS.n199 17.0005
R200 VSS.n16 VSS.n217 17.0005
R201 VSS.n16 VSS.n78 17.0005
R202 VSS.n14 VSS.n80 8.49926
R203 VSS.n16 VSS.n201 17.0005
R204 VSS.n16 VSS.n211 17.0005
R205 VSS.n16 VSS.n209 17.0005
R206 VSS.n16 VSS.n202 17.0005
R207 VSS.n16 VSS.n206 17.0005
R208 VSS.n16 VSS.n79 17.0005
R209 VSS.n417 VSS.n16 17.0005
R210 VSS.n93 VSS.n64 13.8738
R211 VSS.n14 VSS.n45 0.257027
R212 VSS.n14 VSS.n102 17.0005
R213 VSS.n14 VSS.n66 17.0005
R214 VSS.n15 VSS.n92 8.50222
R215 VSS.n14 VSS.n67 17.0005
R216 VSS.n14 VSS.n91 17.0005
R217 VSS.n14 VSS.n68 17.0005
R218 VSS.n14 VSS.n90 17.0005
R219 VSS.n14 VSS.n89 17.0005
R220 VSS.n14 VSS.n70 17.0005
R221 VSS.n14 VSS.n88 17.0005
R222 VSS.n14 VSS.n71 17.0005
R223 VSS.n14 VSS.n87 17.0005
R224 VSS.n14 VSS.n86 17.0005
R225 VSS.n14 VSS.n73 17.0005
R226 VSS.n14 VSS.n85 8.49789
R227 VSS.n14 VSS.n74 17.0005
R228 VSS.n14 VSS.n84 17.0005
R229 VSS.n14 VSS.n75 17.0005
R230 VSS.n14 VSS.n83 17.0005
R231 VSS.n14 VSS.n76 17.0005
R232 VSS.n14 VSS.n82 17.0005
R233 VSS.n14 VSS.n77 17.0005
R234 VSS.n14 VSS.n81 17.0005
R235 VSS.n14 VSS.n78 17.0005
R236 VSS.n14 VSS.n134 17.0005
R237 VSS.n14 VSS.n64 17.0005
R238 VSS.n295 VSS.n4 17.0005
R239 VSS.n61 VSS.n4 17.0005
R240 VSS.n287 VSS.n4 17.0005
R241 VSS.n49 VSS.n4 8.49909
R242 VSS.n283 VSS.n49 0.0105114
R243 VSS.n276 VSS.n4 17.0005
R244 VSS.n268 VSS.n4 17.0005
R245 VSS.n340 VSS.n4 17.0005
R246 VSS.n343 VSS.n4 17.0005
R247 VSS.n243 VSS.n4 17.0005
R248 VSS.n7 VSS.n4 17.0005
R249 VSS.n234 VSS.n46 0.0105114
R250 VSS.n46 VSS.n4 8.49909
R251 VSS.n223 VSS.n56 0.0111223
R252 VSS.n56 VSS.n4 8.49879
R253 VSS.n208 VSS.n4 17.0005
R254 VSS.n2 VSS.n389 17.0005
R255 VSS.n2 VSS.n320 17.0005
R256 VSS.n2 VSS.n52 1.31087
R257 VSS.n2 VSS.n53 1.27652
R258 VSS.n2 VSS.n319 17.0005
R259 VSS.n2 VSS.n318 17.0005
R260 VSS.n330 VSS.t38 17.0005
R261 VSS.n329 VSS.t38 17.0005
R262 VSS.n331 VSS.t38 17.0005
R263 VSS.n331 VSS.t37 17.0005
R264 VSS.t37 VSS.n329 17.0005
R265 VSS.t37 VSS.n330 17.0005
R266 VSS.n388 VSS.t34 17.0005
R267 VSS.t34 VSS.n321 17.0005
R268 VSS.t34 VSS.n387 17.0005
R269 VSS.n321 VSS.t33 17.0005
R270 VSS.n387 VSS.t33 17.0005
R271 VSS.n388 VSS.t33 17.0005
R272 VSS.t62 VSS.n82 16.6364
R273 VSS.t84 VSS.n67 16.6364
R274 VSS.t47 VSS.n348 15.0005
R275 VSS.n368 VSS.t39 15.0005
R276 VSS.n352 VSS.t43 15.0005
R277 VSS.t50 VSS.n361 15.0005
R278 VSS.n173 VSS.n119 13.1592
R279 VSS.n258 VSS.n119 13.1592
R280 VSS.n309 VSS.n308 12.4949
R281 VSS.n204 VSS.t40 12.4949
R282 VSS.n308 VSS.n103 12.4949
R283 VSS.t44 VSS.n104 12.4949
R284 VSS.n138 VSS.n105 12.4949
R285 VSS.n143 VSS.n106 12.4949
R286 VSS.n146 VSS.n107 12.4949
R287 VSS.n148 VSS.n108 12.4949
R288 VSS.n151 VSS.n109 12.4949
R289 VSS.n155 VSS.n110 12.4949
R290 VSS.n157 VSS.n111 12.4949
R291 VSS.n158 VSS.n112 12.4949
R292 VSS.n159 VSS.n113 12.4949
R293 VSS.n160 VSS.n114 12.4949
R294 VSS.n162 VSS.n115 12.4949
R295 VSS.n164 VSS.n116 12.4949
R296 VSS.n261 VSS.n117 12.4949
R297 VSS.n169 VSS.n118 12.4949
R298 VSS.n177 VSS.n120 12.4949
R299 VSS.n253 VSS.n121 12.4949
R300 VSS.n185 VSS.n122 12.4949
R301 VSS.n187 VSS.n123 12.4949
R302 VSS.n189 VSS.n124 12.4949
R303 VSS.n240 VSS.n125 12.4949
R304 VSS.n191 VSS.n126 12.4949
R305 VSS.n193 VSS.n127 12.4949
R306 VSS.n230 VSS.n128 12.4949
R307 VSS.n195 VSS.n129 12.4949
R308 VSS.n197 VSS.n130 12.4949
R309 VSS.n199 VSS.n131 12.4949
R310 VSS.n201 VSS.n132 12.4949
R311 VSS.n202 VSS.n133 12.4949
R312 VSS.n418 VSS.n417 12.4949
R313 VSS.n418 VSS.n79 12.4949
R314 VSS.n204 VSS.n134 12.4949
R315 VSS.t40 VSS.n133 12.4949
R316 VSS.n211 VSS.n132 12.4949
R317 VSS.n217 VSS.n131 12.4949
R318 VSS.n222 VSS.n130 12.4949
R319 VSS.n227 VSS.n129 12.4949
R320 VSS.n194 VSS.n128 12.4949
R321 VSS.n233 VSS.n127 12.4949
R322 VSS.n238 VSS.n126 12.4949
R323 VSS.n190 VSS.n125 12.4949
R324 VSS.n242 VSS.n124 12.4949
R325 VSS.n246 VSS.n123 12.4949
R326 VSS.n252 VSS.n122 12.4949
R327 VSS.n182 VSS.n121 12.4949
R328 VSS.n255 VSS.n120 12.4949
R329 VSS.n260 VSS.n118 12.4949
R330 VSS.n166 VSS.n117 12.4949
R331 VSS.n265 VSS.n116 12.4949
R332 VSS.n271 VSS.n115 12.4949
R333 VSS.n272 VSS.n114 12.4949
R334 VSS.n274 VSS.n113 12.4949
R335 VSS.n275 VSS.n112 12.4949
R336 VSS.n279 VSS.n111 12.4949
R337 VSS.n285 VSS.n110 12.4949
R338 VSS.n290 VSS.n109 12.4949
R339 VSS.n293 VSS.n108 12.4949
R340 VSS.n298 VSS.n107 12.4949
R341 VSS.n299 VSS.n106 12.4949
R342 VSS.n301 VSS.n105 12.4949
R343 VSS.n303 VSS.n104 12.4949
R344 VSS.n307 VSS.n103 12.4949
R345 VSS.n309 VSS.n102 12.4949
R346 VSS.t108 VSS.n2 9.77299
R347 VSS.t29 VSS.n37 68.3172
R348 VSS.t16 VSS.n34 34.1648
R349 VSS.t5 VSS.n30 22.7764
R350 VSS.t54 VSS.n29 13.76
R351 VSS.t0 VSS.n32 68.318
R352 VSS.t2 VSS.n40 64.5222
R353 VSS.t7 VSS.n24 53.1369
R354 VSS.n35 VSS.t8 49.3429
R355 VSS.t10 VSS.n38 45.5476
R356 VSS.t13 VSS.n21 37.9577
R357 VSS.n26 VSS.t16 45.5468
R358 VSS.t17 VSS.n20 41.7528
R359 VSS.n39 VSS.t19 37.9567
R360 VSS.t22 VSS.n25 30.3673
R361 VSS.t26 VSS.n23 18.9814
R362 VSS.n22 VSS.t57 13.7572
R363 VSS.n81 VSS.t60 11.0911
R364 VSS.n146 VSS.t86 11.0911
R365 VSS.n28 VSS.n17 0.00105049
R366 VSS.n93 VSS.n16 0.626505
R367 VSS.n14 VSS.n15 0.00505102
R368 VSS.n308 VSS.n4 8.5005
R369 VSS.n299 VSS.n4 8.5005
R370 VSS.n146 VSS.n4 8.5005
R371 VSS.n275 VSS.n4 8.5005
R372 VSS.n159 VSS.n4 8.5005
R373 VSS.n272 VSS.n4 8.5005
R374 VSS.n162 VSS.n4 8.5005
R375 VSS.n261 VSS.n4 8.5005
R376 VSS.n169 VSS.n4 8.5005
R377 VSS.n253 VSS.n4 8.5005
R378 VSS.n185 VSS.n4 8.5005
R379 VSS.n240 VSS.n4 8.5005
R380 VSS.n191 VSS.n4 8.5005
R381 VSS.n230 VSS.n4 8.5005
R382 VSS.n195 VSS.n4 8.5005
R383 VSS.t40 VSS.n4 8.5005
R384 VSS.n16 VSS.n137 8.4984
R385 VSS.n16 VSS.n140 8.4984
R386 VSS.n16 VSS.n142 8.4984
R387 VSS.n16 VSS.n296 8.4984
R388 VSS.n16 VSS.n60 8.4984
R389 VSS.n16 VSS.n149 8.4984
R390 VSS.n16 VSS.n288 8.4984
R391 VSS.n16 VSS.n50 8.4984
R392 VSS.n16 VSS.n283 8.4984
R393 VSS.n16 VSS.n281 8.4984
R394 VSS.n12 VSS.n276 0.0123816
R395 VSS.n16 VSS.n6 8.4984
R396 VSS.n16 VSS.n269 8.4984
R397 VSS.n16 VSS.n266 8.4984
R398 VSS.n16 VSS.n165 8.4984
R399 VSS.n16 VSS.n168 8.4984
R400 VSS.n16 VSS.n171 8.4984
R401 VSS.n16 VSS.n175 8.4984
R402 VSS.n16 VSS.n179 8.4984
R403 VSS.n16 VSS.n181 8.4984
R404 VSS.n16 VSS.n250 8.4984
R405 VSS.n16 VSS.n248 8.4984
R406 VSS.n16 VSS.n9 8.4984
R407 VSS.n16 VSS.n8 3.39213
R408 VSS.n16 VSS.n236 8.4984
R409 VSS.n16 VSS.n234 8.4984
R410 VSS.n16 VSS.n47 8.4984
R411 VSS.n16 VSS.n229 8.4984
R412 VSS.n16 VSS.n225 8.4984
R413 VSS.n16 VSS.n223 8.4984
R414 VSS.n16 VSS.n57 8.4984
R415 VSS.n16 VSS.n219 8.4984
R416 VSS.n16 VSS.n215 8.4984
R417 VSS.n16 VSS.n213 8.4984
R418 VSS.n16 VSS.n203 8.4984
R419 VSS.n304 VSS.n4 8.4984
R420 VSS.n139 VSS.n4 8.4984
R421 VSS.n141 VSS.n4 8.4984
R422 VSS.n144 VSS.n4 8.4984
R423 VSS.n294 VSS.n4 8.4984
R424 VSS.n291 VSS.n4 8.4984
R425 VSS.n152 VSS.n4 8.4984
R426 VSS.n286 VSS.n4 8.4984
R427 VSS.n282 VSS.n4 8.4984
R428 VSS.n280 VSS.n4 8.4984
R429 VSS.n13 VSS.n6 0.0123715
R430 VSS.n6 VSS.n5 0.0125069
R431 VSS.n5 VSS.n4 2.82365
R432 VSS.n267 VSS.n4 8.4984
R433 VSS.n262 VSS.n4 8.4984
R434 VSS.n167 VSS.n4 8.4984
R435 VSS.n170 VSS.n4 8.4984
R436 VSS.n174 VSS.n4 8.4984
R437 VSS.n256 VSS.n4 8.4984
R438 VSS.n178 VSS.n4 8.4984
R439 VSS.n180 VSS.n4 8.4984
R440 VSS.n183 VSS.n4 8.4984
R441 VSS.n249 VSS.n4 8.4984
R442 VSS.n247 VSS.n4 8.4984
R443 VSS.n10 VSS.n4 4.2476
R444 VSS.n239 VSS.n4 8.4984
R445 VSS.n235 VSS.n4 8.4984
R446 VSS.n231 VSS.n4 8.4984
R447 VSS.n228 VSS.n4 8.4984
R448 VSS.n224 VSS.n4 8.4984
R449 VSS.n220 VSS.n4 8.4984
R450 VSS.n218 VSS.n4 8.4984
R451 VSS.n214 VSS.n4 8.4984
R452 VSS.n212 VSS.n4 8.4984
R453 VSS.n205 VSS.n4 8.4984
R454 VSS.n17 VSS.n41 0.910042
R455 VSS.n44 VSS.n17 0.910943
R456 VSS.n404 VSS.n42 1.37839
R457 VSS.n17 VSS.n42 0.0110668
R458 VSS.n428 VSS.n94 8.22525
R459 VSS.n380 VSS.n379 8.22525
R460 VSS.n380 VSS.n338 8.22525
R461 VSS.n429 VSS.n428 8.22525
R462 VSS.n32 VSS.t2 15.1857
R463 VSS.n365 VSS.t47 7.49606
R464 VSS.t39 VSS.n347 7.49606
R465 VSS.t43 VSS.n351 7.49606
R466 VSS.n362 VSS.t50 7.49606
R467 VSS.n101 VSS.n65 7.20236
R468 VSS.n307 VSS.n306 7.20236
R469 VSS.n303 VSS.n302 7.20236
R470 VSS.n301 VSS.n300 7.20236
R471 VSS.n297 VSS.n143 7.20236
R472 VSS.n147 VSS.n92 7.20236
R473 VSS.n292 VSS.n67 7.20236
R474 VSS.n150 VSS.n91 7.20236
R475 VSS.n290 VSS.n289 7.20236
R476 VSS.n154 VSS.n90 7.20236
R477 VSS.n285 VSS.n284 7.20236
R478 VSS.n157 VSS.n156 7.20236
R479 VSS.n279 VSS.n278 7.20236
R480 VSS.n273 VSS.n158 7.20236
R481 VSS.n270 VSS.n160 7.20236
R482 VSS.n163 VSS.n88 7.20236
R483 VSS.n265 VSS.n264 7.20236
R484 VSS.n259 VSS.n166 7.20236
R485 VSS.n172 VSS.n87 7.20236
R486 VSS.n258 VSS.n257 7.20236
R487 VSS.n176 VSS.n86 7.20236
R488 VSS.n254 VSS.n73 7.20236
R489 VSS.n251 VSS.n182 7.20236
R490 VSS.n187 VSS.n186 7.20236
R491 VSS.n245 VSS.n74 7.20236
R492 VSS.n188 VSS.n84 7.20236
R493 VSS.n242 VSS.n241 7.20236
R494 VSS.n237 VSS.n190 7.20236
R495 VSS.n193 VSS.n192 7.20236
R496 VSS.n232 VSS.n76 7.20236
R497 VSS.n226 VSS.n194 7.20236
R498 VSS.n196 VSS.n82 7.20236
R499 VSS.n222 VSS.n221 7.20236
R500 VSS.n198 VSS.n81 7.20236
R501 VSS.n217 VSS.n216 7.20236
R502 VSS.n201 VSS.n200 7.20236
R503 VSS.n211 VSS.n210 7.20236
R504 VSS.n135 VSS.n134 7.20236
R505 VSS.n416 VSS.n64 7.20236
R506 VSS.n417 VSS.n416 7.20236
R507 VSS.n79 VSS.n135 7.20236
R508 VSS.n210 VSS.n202 7.20236
R509 VSS.n200 VSS.n80 7.20236
R510 VSS.n216 VSS.n78 7.20236
R511 VSS.n199 VSS.n198 7.20236
R512 VSS.n221 VSS.n77 7.20236
R513 VSS.n197 VSS.n196 7.20236
R514 VSS.n227 VSS.n226 7.20236
R515 VSS.n233 VSS.n232 7.20236
R516 VSS.n192 VSS.n83 7.20236
R517 VSS.n238 VSS.n237 7.20236
R518 VSS.n241 VSS.n75 7.20236
R519 VSS.n189 VSS.n188 7.20236
R520 VSS.n246 VSS.n245 7.20236
R521 VSS.n186 VSS.n85 7.20236
R522 VSS.n252 VSS.n251 7.20236
R523 VSS.n255 VSS.n254 7.20236
R524 VSS.n177 VSS.n176 7.20236
R525 VSS.n257 VSS.n72 7.20236
R526 VSS.n173 VSS.n172 7.20236
R527 VSS.n260 VSS.n259 7.20236
R528 VSS.n264 VSS.n71 7.20236
R529 VSS.n164 VSS.n163 7.20236
R530 VSS.n271 VSS.n270 7.20236
R531 VSS.n274 VSS.n273 7.20236
R532 VSS.n278 VSS.n70 7.20236
R533 VSS.n156 VSS.n89 7.20236
R534 VSS.n284 VSS.n69 7.20236
R535 VSS.n155 VSS.n154 7.20236
R536 VSS.n289 VSS.n68 7.20236
R537 VSS.n151 VSS.n150 7.20236
R538 VSS.n293 VSS.n292 7.20236
R539 VSS.n148 VSS.n147 7.20236
R540 VSS.n298 VSS.n297 7.20236
R541 VSS.n300 VSS.n66 7.20236
R542 VSS.n302 VSS.n138 7.20236
R543 VSS.n306 VSS.t44 7.20236
R544 VSS.n102 VSS.n101 7.20236
R545 VSS.n415 VSS.n45 1.41982
R546 VSS.n419 VSS.n14 2.8344
R547 VSS.n14 VSS.t46 1.03678
R548 VSS.n80 VSS.t59 5.54579
R549 VSS.t87 VSS.n66 5.54579
R550 VSS.n366 VSS.t49 4.5005
R551 VSS.t42 VSS.n346 4.5005
R552 VSS.n363 VSS.t51 4.5005
R553 VSS.t45 VSS.n350 4.5005
R554 VSS.n207 VSS.n4 4.25219
R555 VSS.n136 VSS.n4 4.25206
R556 VSS.n16 VSS.n136 4.25175
R557 VSS.n16 VSS.n207 4.25169
R558 VSS.n43 VSS.n29 6777.49
R559 VSS.n378 VSS.n377 4.11287
R560 VSS.n377 VSS.n95 4.11287
R561 VSS.n33 VSS.t0 11.3992
R562 VSS.n407 VSS.t56 3.0005
R563 VSS.n424 VSS.t53 3.0005
R564 VSS.n332 VSS.t35 3.0005
R565 VSS.n386 VSS.t31 3.0005
R566 VSS.n364 VSS.n345 3.0005
R567 VSS.n370 VSS.n369 3.0005
R568 VSS.n360 VSS.n359 3.0005
R569 VSS.n354 VSS.n353 3.0005
R570 VSS.n17 VSS.n36 0.0111485
R571 VSS.n17 VSS.n25 0.0111485
R572 VSS.n17 VSS.n38 0.0111485
R573 VSS.n24 VSS.t8 30.3669
R574 VSS.n40 VSS.t4 18.9817
R575 VSS.n17 VSS.n32 0.0111485
R576 VSS.n17 VSS.n22 0.00293611
R577 VSS.t57 VSS.n28 13.7611
R578 VSS.n37 VSS.n17 0.0109013
R579 VSS.n23 VSS.n17 0.0108886
R580 VSS.n18 VSS.n17 0.0109013
R581 VSS.n27 VSS.n17 0.0109013
R582 VSS.n26 VSS.n17 0.0108886
R583 VSS.n34 VSS.n17 0.0093246
R584 VSS.n21 VSS.n17 0.0108886
R585 VSS.n30 VSS.n17 0.0109013
R586 VSS.n33 VSS.n17 0.00291261
R587 VSS.n33 VSS.t54 13.7592
R588 VSS.n17 VSS.n29 0.00104908
R589 VSS.n339 VSS.n338 2.71193
R590 VSS.n431 VSS.n430 2.6297
R591 VSS.n425 VSS.t3 2.4821
R592 VSS.n426 VSS.t6 2.4821
R593 VSS.n427 VSS.t9 2.4821
R594 VSS.n99 VSS.t12 2.4821
R595 VSS.t18 VSS.n98 2.4821
R596 VSS.n410 VSS.t21 2.4821
R597 VSS.n411 VSS.t24 2.4821
R598 VSS.t27 VSS.n412 2.4821
R599 VSS.n334 VSS.t134 2.4821
R600 VSS.n335 VSS.t131 2.4821
R601 VSS.n336 VSS.t128 2.4821
R602 VSS.n337 VSS.t125 2.4821
R603 VSS.n382 VSS.t119 2.4821
R604 VSS.n383 VSS.t116 2.4821
R605 VSS.n384 VSS.t113 2.4821
R606 VSS.n385 VSS.t110 2.4821
R607 VSS.n372 VSS.t89 2.4821
R608 VSS.n372 VSS.t61 2.4821
R609 VSS.n373 VSS.t91 2.4821
R610 VSS.n373 VSS.t64 2.4821
R611 VSS.n374 VSS.t93 2.4821
R612 VSS.n374 VSS.t67 2.4821
R613 VSS.n375 VSS.t95 2.4821
R614 VSS.n375 VSS.t70 2.4821
R615 VSS.n342 VSS.t99 2.4821
R616 VSS.n342 VSS.t76 2.4821
R617 VSS.n355 VSS.t101 2.4821
R618 VSS.n355 VSS.t79 2.4821
R619 VSS.n356 VSS.t103 2.4821
R620 VSS.n356 VSS.t82 2.4821
R621 VSS.n357 VSS.t105 2.4821
R622 VSS.n357 VSS.t85 2.4821
R623 VSS.n16 VSS.n309 2.25406
R624 VSS.n16 VSS.n204 2.25406
R625 VSS.n14 VSS.n103 2.25406
R626 VSS.n14 VSS.n104 2.25406
R627 VSS.n14 VSS.n105 2.25406
R628 VSS.n14 VSS.n106 2.25406
R629 VSS.n14 VSS.n107 2.25406
R630 VSS.n14 VSS.n108 2.25406
R631 VSS.n14 VSS.n109 2.25406
R632 VSS.n14 VSS.n110 2.25406
R633 VSS.n14 VSS.n111 2.25406
R634 VSS.n14 VSS.n112 2.25406
R635 VSS.n14 VSS.n113 2.25406
R636 VSS.n14 VSS.n114 2.25406
R637 VSS.n14 VSS.n115 2.25406
R638 VSS.n14 VSS.n116 2.25406
R639 VSS.n14 VSS.n117 2.25406
R640 VSS.n14 VSS.n118 2.25406
R641 VSS.n14 VSS.n120 2.25406
R642 VSS.n14 VSS.n121 2.25406
R643 VSS.n14 VSS.n122 2.25406
R644 VSS.n14 VSS.n123 2.25406
R645 VSS.n14 VSS.n124 2.25406
R646 VSS.n14 VSS.n125 2.25406
R647 VSS.n14 VSS.n126 2.25406
R648 VSS.n14 VSS.n127 2.25406
R649 VSS.n14 VSS.n128 2.25406
R650 VSS.n14 VSS.n129 2.25406
R651 VSS.n14 VSS.n130 2.25406
R652 VSS.n14 VSS.n131 2.25406
R653 VSS.n14 VSS.n132 2.25406
R654 VSS.n14 VSS.n133 2.25406
R655 VSS.n14 VSS.n418 2.25406
R656 VSS.t48 VSS.n366 2.2505
R657 VSS.t41 VSS.n346 2.2505
R658 VSS.t52 VSS.n363 2.2505
R659 VSS.n350 VSS.t46 2.2505
R660 VSS.n17 VSS.n401 2.09947
R661 VSS.n17 VSS.n400 2.09947
R662 VSS.n17 VSS.n399 2.09947
R663 VSS.n17 VSS.n397 2.09947
R664 VSS.n17 VSS.n96 2.09947
R665 VSS.n17 VSS.n395 2.09947
R666 VSS.n17 VSS.n393 2.09947
R667 VSS.n17 VSS.n391 2.09947
R668 VSS.n2 VSS.n312 2.0987
R669 VSS.n2 VSS.n311 2.09868
R670 VSS.n2 VSS.n310 2.09862
R671 VSS.n2 VSS.n313 2.09857
R672 VSS.n2 VSS.n314 2.09849
R673 VSS.n2 VSS.n316 2.09849
R674 VSS.n2 VSS.n317 2.09849
R675 VSS.n2 VSS.n315 2.09849
R676 VSS.n14 VSS.n119 1.92189
R677 VSS.n415 VSS.n4 1.7005
R678 VSS.n419 VSS.n4 1.7005
R679 VSS.n424 VSS.n100 1.52811
R680 VSS.n332 VSS.n331 1.52811
R681 VSS.n387 VSS.n386 1.52811
R682 VSS.n407 VSS.n402 1.52811
R683 VSS.n321 VSS.n52 0.00154475
R684 VSS.n330 VSS.n53 0.00153046
R685 VSS.t48 VSS.n4 1.08265
R686 VSS.n4 VSS.t52 1.03719
R687 VSS.n44 VSS.n390 0.144834
R688 VSS.n41 VSS.n413 0.148049
R689 VSS.n2 VSS.n0 0.910334
R690 VSS.n2 VSS.n1 0.909129
R691 VSS.n306 VSS.n4 0.650322
R692 VSS.n302 VSS.n4 0.650322
R693 VSS.n300 VSS.n4 0.650322
R694 VSS.n297 VSS.n4 0.650322
R695 VSS.n147 VSS.n4 0.650322
R696 VSS.n292 VSS.n4 0.650322
R697 VSS.n150 VSS.n4 0.650322
R698 VSS.n289 VSS.n4 0.650322
R699 VSS.n154 VSS.n4 0.650322
R700 VSS.n284 VSS.n4 0.650322
R701 VSS.n156 VSS.n4 0.650322
R702 VSS.n278 VSS.n4 0.650322
R703 VSS.n273 VSS.n4 0.650322
R704 VSS.n270 VSS.n4 0.650322
R705 VSS.n163 VSS.n4 0.650322
R706 VSS.n264 VSS.n4 0.650322
R707 VSS.n259 VSS.n4 0.650322
R708 VSS.n172 VSS.n4 0.650322
R709 VSS.n257 VSS.n4 0.650322
R710 VSS.n176 VSS.n4 0.650322
R711 VSS.n254 VSS.n4 0.650322
R712 VSS.n251 VSS.n4 0.650322
R713 VSS.n186 VSS.n4 0.650322
R714 VSS.n245 VSS.n4 0.650322
R715 VSS.n188 VSS.n4 0.650322
R716 VSS.n241 VSS.n4 0.650322
R717 VSS.n237 VSS.n4 0.650322
R718 VSS.n192 VSS.n4 0.650322
R719 VSS.n232 VSS.n4 0.650322
R720 VSS.n226 VSS.n4 0.650322
R721 VSS.n196 VSS.n4 0.650322
R722 VSS.n221 VSS.n4 0.650322
R723 VSS.n198 VSS.n4 0.650322
R724 VSS.n216 VSS.n4 0.650322
R725 VSS.n200 VSS.n4 0.650322
R726 VSS.n210 VSS.n4 0.650322
R727 VSS.n135 VSS.n4 0.650322
R728 VSS.n416 VSS.n4 0.650322
R729 VSS.n379 VSS.n339 0.632727
R730 VSS.n432 VSS.n431 0.5505
R731 VSS.n378 VSS.n94 0.2444
R732 VSS.n379 VSS.n378 0.2444
R733 VSS.n429 VSS.n95 0.2444
R734 VSS.n338 VSS.n95 0.2444
R735 VSS.n425 VSS.n424 0.209825
R736 VSS.n334 VSS.n332 0.209825
R737 VSS.n386 VSS.n385 0.209825
R738 VSS.n412 VSS.n407 0.209825
R739 VSS.n390 VSS.t3 0.201663
R740 VSS.n392 VSS.t6 0.201663
R741 VSS.n394 VSS.t9 0.201663
R742 VSS.n396 VSS.t12 0.201663
R743 VSS.n398 VSS.t18 0.201663
R744 VSS.t21 VSS.n409 0.201663
R745 VSS.t24 VSS.n408 0.201663
R746 VSS.n413 VSS.t27 0.201663
R747 VSS.t134 VSS.n333 0.201663
R748 VSS.t131 VSS.n328 0.201663
R749 VSS.t128 VSS.n327 0.201663
R750 VSS.t125 VSS.n326 0.201663
R751 VSS.t119 VSS.n325 0.201663
R752 VSS.t116 VSS.n324 0.201663
R753 VSS.t113 VSS.n323 0.201663
R754 VSS.t110 VSS.n322 0.201663
R755 VSS.n58 VSS.t89 0.201663
R756 VSS.t61 VSS.n58 0.201663
R757 VSS.n48 VSS.t91 0.201663
R758 VSS.t64 VSS.n48 0.201663
R759 VSS.n11 VSS.t93 0.201663
R760 VSS.t67 VSS.n11 0.201663
R761 VSS.n344 VSS.t95 0.201663
R762 VSS.t70 VSS.n344 0.201663
R763 VSS.n341 VSS.t99 0.201663
R764 VSS.t76 VSS.n341 0.201663
R765 VSS.n13 VSS.t101 0.201663
R766 VSS.t79 VSS.n13 0.201663
R767 VSS.n51 VSS.t103 0.201663
R768 VSS.t82 VSS.n51 0.201663
R769 VSS.n61 VSS.t105 0.201663
R770 VSS.t85 VSS.n61 0.201663
R771 VSS.t73 VSS.t97 0.185696
R772 VSS.n426 VSS.n425 0.16242
R773 VSS.n427 VSS.n426 0.16242
R774 VSS.n99 VSS.n427 0.16242
R775 VSS.n97 VSS.n99 0.16242
R776 VSS.n97 VSS.n98 0.16242
R777 VSS.n410 VSS.n98 0.16242
R778 VSS.n411 VSS.n410 0.16242
R779 VSS.n412 VSS.n411 0.16242
R780 VSS.n385 VSS.n384 0.16242
R781 VSS.n384 VSS.n383 0.16242
R782 VSS.n383 VSS.n382 0.16242
R783 VSS.n382 VSS.n381 0.16242
R784 VSS.n381 VSS.n337 0.16242
R785 VSS.n337 VSS.n336 0.16242
R786 VSS.n336 VSS.n335 0.16242
R787 VSS.n335 VSS.n334 0.16242
R788 VSS.n333 VSS.n1 0.147861
R789 VSS.n322 VSS.n0 0.145358
R790 VSS.n372 VSS.n371 0.117247
R791 VSS.n358 VSS.n357 0.1171
R792 VSS.n391 VSS.n390 0.0952183
R793 VSS.n333 VSS.n317 0.0938811
R794 VSS.n322 VSS.n310 0.0937507
R795 VSS.n393 VSS.n392 0.0927738
R796 VSS.n413 VSS.n401 0.0925656
R797 VSS.n328 VSS.n316 0.0914366
R798 VSS.n323 VSS.n311 0.0910563
R799 VSS.n395 VSS.n394 0.0903294
R800 VSS.n397 VSS.t15 0.0903294
R801 VSS.n408 VSS.n400 0.0901212
R802 VSS.t122 VSS.n313 0.0893103
R803 VSS.n327 VSS.n315 0.0891801
R804 VSS.n324 VSS.n312 0.0891092
R805 VSS.t122 VSS.n314 0.0889922
R806 VSS.n96 VSS.n396 0.0878849
R807 VSS.n399 VSS.n398 0.0878849
R808 VSS.t15 VSS.n96 0.0876767
R809 VSS.n409 VSS.n399 0.0876767
R810 VSS.n326 VSS.n314 0.0865477
R811 VSS.n325 VSS.n312 0.0864255
R812 VSS.n326 VSS.n315 0.0863554
R813 VSS.n325 VSS.n313 0.0862315
R814 VSS.n409 VSS.n400 0.0854405
R815 VSS.n396 VSS.n395 0.0852323
R816 VSS.n398 VSS.n397 0.0852323
R817 VSS.n324 VSS.n311 0.0844861
R818 VSS.t53 VSS.n44 0.0840328
R819 VSS.n327 VSS.n316 0.0841033
R820 VSS.t31 VSS.n0 0.0834709
R821 VSS.n408 VSS.n401 0.082996
R822 VSS.n394 VSS.n393 0.0827878
R823 VSS.n432 VSS.n94 0.0827273
R824 VSS.n430 VSS.n429 0.0827273
R825 VSS.t35 VSS.n1 0.081888
R826 VSS.n323 VSS.n310 0.0817866
R827 VSS.n328 VSS.n317 0.0816588
R828 VSS.n373 VSS.n372 0.08146
R829 VSS.n374 VSS.n373 0.08146
R830 VSS.n375 VSS.n374 0.08146
R831 VSS.n376 VSS.n375 0.08146
R832 VSS.n376 VSS.n342 0.08146
R833 VSS.n355 VSS.n342 0.08146
R834 VSS.n356 VSS.n355 0.08146
R835 VSS.n357 VSS.n356 0.08146
R836 VSS.n392 VSS.n391 0.0803434
R837 VSS.n421 VSS.n42 1.43643
R838 VSS.t41 VSS.n14 1.05051
R839 VSS.n431 VSS 0.0445
R840 VSS.n339 VSS 0.0445
R841 VSS.n381 VSS.t122 0.0394179
R842 VSS.t15 VSS.n97 0.0394179
R843 VSS.n428 VSS.n97 0.0389615
R844 VSS.n381 VSS.n380 0.0389615
R845 VSS.t49 VSS.n365 0.031258
R846 VSS.n347 VSS.t42 0.031258
R847 VSS.t51 VSS.n362 0.031258
R848 VSS.n371 VSS.n370 0.0291125
R849 VSS.n359 VSS.n358 0.0291125
R850 VSS.n358 VSS.n354 0.0291125
R851 VSS.n371 VSS.n345 0.0291125
R852 VSS.n370 VSS.n346 0.0281144
R853 VSS.n363 VSS.n359 0.0281144
R854 VSS.n354 VSS.n350 0.0281144
R855 VSS.n366 VSS.n345 0.0281144
R856 VSS.n351 VSS.n349 0.0216549
R857 VSS.n352 VSS.t45 0.0208704
R858 VSS.n364 VSS.n348 0.0202884
R859 VSS.n369 VSS.n368 0.0202884
R860 VSS.n353 VSS.n352 0.0202884
R861 VSS.n361 VSS.n360 0.0202884
R862 VSS.n377 VSS.n376 0.0197308
R863 VSS.n376 VSS.t97 0.019449
R864 VSS.n349 VSS.n136 0.0162424
R865 VSS.n367 VSS.n207 0.0159649
R866 VSS.t56 VSS.n406 0.0133922
R867 VSS.t53 VSS.n63 0.0133922
R868 VSS.t35 VSS.n318 0.0133922
R869 VSS.n389 VSS.t31 0.0133922
R870 VSS.n304 VSS.n137 0.0118857
R871 VSS.n139 VSS.n137 0.0118857
R872 VSS.n141 VSS.n140 0.0118857
R873 VSS.n296 VSS.n294 0.0118857
R874 VSS.n152 VSS.n149 0.0118857
R875 VSS.n288 VSS.n286 0.0118857
R876 VSS.n283 VSS.n282 0.0118857
R877 VSS.n281 VSS.n280 0.0118857
R878 VSS.n13 VSS.n12 0.00668938
R879 VSS.n269 VSS.n267 0.0118857
R880 VSS.n167 VSS.n165 0.0118857
R881 VSS.n170 VSS.n168 0.0118857
R882 VSS.n174 VSS.n171 0.0118857
R883 VSS.n178 VSS.n175 0.0118857
R884 VSS.n180 VSS.n179 0.0118857
R885 VSS.n183 VSS.n181 0.0118857
R886 VSS.n250 VSS.n249 0.0118857
R887 VSS.n248 VSS.n247 0.0118857
R888 VSS.n10 VSS.n9 0.0170834
R889 VSS.n8 VSS.n239 0.0299229
R890 VSS.n235 VSS.n234 0.0118857
R891 VSS.n47 VSS.n231 0.0118857
R892 VSS.n229 VSS.n228 0.0118857
R893 VSS.n224 VSS.n223 0.0118857
R894 VSS.n57 VSS.n220 0.0118857
R895 VSS.n219 VSS.n218 0.0118857
R896 VSS.n215 VSS.n214 0.0118857
R897 VSS.n213 VSS.n212 0.0118857
R898 VSS.n205 VSS.n203 0.0118857
R899 VSS.n214 VSS.n213 0.0118857
R900 VSS.n218 VSS.n215 0.0118857
R901 VSS.n220 VSS.n219 0.0118857
R902 VSS.n225 VSS.n224 0.0118857
R903 VSS.n228 VSS.n225 0.0118857
R904 VSS.n231 VSS.n229 0.0118857
R905 VSS.n236 VSS.n235 0.0118857
R906 VSS.n239 VSS.n236 0.0118857
R907 VSS.n249 VSS.n248 0.0118857
R908 VSS.n181 VSS.n180 0.0118857
R909 VSS.n179 VSS.n178 0.0118857
R910 VSS.n256 VSS.n175 0.0118857
R911 VSS.n171 VSS.n170 0.0118857
R912 VSS.n168 VSS.n167 0.0118857
R913 VSS.n262 VSS.n165 0.0118857
R914 VSS.n267 VSS.n266 0.0118857
R915 VSS.n282 VSS.n281 0.0118857
R916 VSS.n286 VSS.n50 0.0118857
R917 VSS.n291 VSS.n149 0.0118857
R918 VSS.n294 VSS.n60 0.0118857
R919 VSS.n144 VSS.n142 0.0118857
R920 VSS.n142 VSS.n141 0.0118857
R921 VSS.n140 VSS.n139 0.0118857
R922 VSS.n367 VSS.n348 0.0115582
R923 VSS.n368 VSS.n367 0.0115582
R924 VSS.n361 VSS.n349 0.0112672
R925 VSS.t123 VSS.n3 19.5585
R926 VSS.t127 VSS.n2 19.5212
R927 VSS.t133 VSS.n2 14.4648
R928 VSS.n209 VSS.n208 0.0108889
R929 VSS.n244 VSS.n243 0.0108889
R930 VSS.n268 VSS.n161 0.0108889
R931 VSS.n277 VSS.n276 0.0108889
R932 VSS.n287 VSS.n153 0.0108889
R933 VSS.n295 VSS.n145 0.0108889
R934 VSS.n365 VSS.n364 0.0108877
R935 VSS.n369 VSS.n347 0.0108877
R936 VSS.n353 VSS.n351 0.0108877
R937 VSS.n362 VSS.n360 0.0108877
R938 VSS.t46 VSS.n349 0.0101032
R939 VSS.t52 VSS.n349 0.0101032
R940 VSS.n367 VSS.t48 0.00981217
R941 VSS.n367 VSS.t41 0.00981217
R942 VSS VSS.n432 0.0095
R943 VSS.n430 VSS 0.0095
R944 VSS.n58 VSS.n56 0.0054294
R945 VSS.n61 VSS.n59 0.00936111
R946 VSS.t56 VSS.n41 0.0818274
R947 VSS.n48 VSS.n46 0.00481859
R948 VSS.n51 VSS.n49 0.00481859
R949 VSS.n62 VSS.n402 0.00798582
R950 VSS.n403 VSS.n402 0.00798582
R951 VSS.n423 VSS.n100 0.00798582
R952 VSS.n420 VSS.n100 0.00798582
R953 VSS.n331 VSS.n53 0.0150226
R954 VSS.n331 VSS.n319 0.00798582
R955 VSS.n387 VSS.n52 0.0150083
R956 VSS.n387 VSS.n320 0.00798582
R957 VSS.n406 VSS.n405 0.00756994
R958 VSS.n405 VSS.n62 0.00756994
R959 VSS.n404 VSS.n403 0.00756994
R960 VSS.n422 VSS.n63 0.00756994
R961 VSS.n423 VSS.n422 0.00756994
R962 VSS.n421 VSS.n420 0.00756994
R963 VSS.n329 VSS.n319 0.00756994
R964 VSS.n329 VSS.n318 0.00756994
R965 VSS.n388 VSS.n320 0.00756994
R966 VSS.n389 VSS.n388 0.00756994
R967 VSS.t97 VSS.n55 0.00691667
R968 VSS.n367 VSS.n206 0.00630556
R969 VSS.n340 VSS.n266 0.00619286
R970 VSS.n145 VSS.n144 0.00619286
R971 VSS.n59 VSS.n291 0.00619286
R972 VSS.n263 VSS.n262 0.00619286
R973 VSS.n55 VSS.n256 0.00619286
R974 VSS.n206 VSS.n205 0.00619286
R975 VSS.n208 VSS.n203 0.00619286
R976 VSS.n212 VSS.n209 0.00619286
R977 VSS.n11 VSS.n10 0.00569769
R978 VSS.n243 VSS.n9 0.00619286
R979 VSS.n247 VSS.n244 0.00619286
R980 VSS.n343 VSS.n250 0.00619286
R981 VSS.n184 VSS.n183 0.00619286
R982 VSS.n54 VSS.n174 0.00619286
R983 VSS.n269 VSS.n268 0.00619286
R984 VSS.n161 VSS.n5 0.0297349
R985 VSS.n280 VSS.n277 0.00619286
R986 VSS.n288 VSS.n287 0.00619286
R987 VSS.n153 VSS.n152 0.00619286
R988 VSS.n296 VSS.n295 0.00619286
R989 VSS.n305 VSS.n304 0.00619286
R990 VSS.n349 VSS.n305 0.00615278
R991 VSS.n344 VSS.n343 0.00569444
R992 VSS.n344 VSS.n184 0.00569444
R993 VSS.n341 VSS.n263 0.00569444
R994 VSS.n341 VSS.n340 0.00569444
R995 VSS.n101 VSS.n4 0.652909
R996 VSS.n51 VSS.n50 0.00894286
R997 VSS.n48 VSS.n47 0.00894286
R998 VSS.t97 VSS.n54 0.00891217
R999 VSS.n61 VSS.n60 0.00772064
R1000 VSS.n58 VSS.n57 0.00772064
R1001 VSS.n2 VSS.n43 6777.49
C0 vout3 vin3 15.8261f
C1 vin1 VDD 26.3603f
C2 vout4 VDD 9.20502f
C3 vin3 VDD 26.3294f
C4 vout2 VDD 9.19358f
C5 vin2 vin1 0.02526f
C6 vin2 VDD 26.3294f
C7 vin3 vin2 0.02893f
C8 vout2 vin2 15.8261f
C9 vout4 vin4 15.8261f
C10 VDD vin4 26.3603f
C11 vin1 vout1 15.8261f
C12 vin3 vin4 0.02526f
C13 vout1 VDD 9.20502f
C14 vout3 VDD 9.19358f
C15 vout1 VSS 10.72398f
C16 vout2 VSS 10.70542f
C17 vout3 VSS 10.70542f
C18 vout4 VSS 10.72398f
C19 VSS.t105 VSS 6.81335f
C20 VSS.t76 VSS 6.81335f
C21 VSS.t24 VSS 6.83105f
.ends

* PEX produced on Tue Jul 21 03:56:40 AM CEST 2026 using /foss/tools/sak/sak-pex.sh with m=3 and s=1 (extresist threshold=10000 mOhm, minres=1000 mOhm, mindelay=1 ps)
* NGSPICE file created from inverter_top_pex.ext - technology: ihp-sg13g2

.subckt inverter_top_pex VDD vin4 vout4 VSS vin3 vout3 vin2 vout2 vout1 vin1
X0 vout3 vin3 VSS.t105 VSS.t86 sg13_lv_nmos ad=0.19p pd=1.38u as=0.19p ps=1.38u w=1u l=1u
X1 VDD VDD VDD VDD sg13_lv_pmos ad=1.14p pd=6.38u as=0.56797n ps=1.006m w=6u l=1u
X2 VSS.t1 VSS.t53 VSS.t55 VSS.t54 sg13_lv_nmos ad=0.34p pd=2.68u as=0 ps=0 w=1u l=1u
X3 VDD VDD VDD VDD sg13_lv_pmos ad=1.14p pd=6.38u as=0 ps=0 w=6u l=1u
X4 VDD vin4 vout4 VDD sg13_lv_pmos ad=1.14p pd=6.38u as=1.14p ps=6.38u w=6u l=1u
X5 vout2 vin2 VSS.t76 VSS.t77 sg13_lv_nmos ad=0.19p pd=1.38u as=0.19p ps=1.38u w=1u l=1u
X6 vout3 vin3 VDD VDD sg13_lv_pmos ad=1.14p pd=6.38u as=1.14p ps=6.38u w=6u l=1u
X7 vout4 vin4 VSS.t110 VSS.t111 sg13_lv_nmos ad=0.19p pd=1.38u as=0.19p ps=1.38u w=1u l=1u
X8 vout3 vin3 VSS.t42 VSS.t59 sg13_lv_nmos ad=0.19p pd=1.38u as=0.19p ps=1.38u w=1u l=1u
X9 vout2 vin2 VSS.t70 VSS.t71 sg13_lv_nmos ad=0.19p pd=1.38u as=0.19p ps=1.38u w=1u l=1u
X10 vout4 vin4 VDD VDD sg13_lv_pmos ad=1.14p pd=6.38u as=1.14p ps=6.38u w=6u l=1u
X11 VDD vin2 vout2 VDD sg13_lv_pmos ad=1.14p pd=6.38u as=1.14p ps=6.38u w=6u l=1u
X12 VSS.t76 vin2 vout2 VSS.t75 sg13_lv_nmos ad=0.19p pd=1.38u as=0.19p ps=1.38u w=1u l=1u
X13 vout2 vin2 VSS.t79 VSS.t80 sg13_lv_nmos ad=0.19p pd=1.38u as=0.19p ps=1.38u w=1u l=1u
X14 vout2 vin2 VDD VDD sg13_lv_pmos ad=1.14p pd=6.38u as=1.14p ps=6.38u w=6u l=1u
X15 VSS.t116 vin4 vout4 VSS.t115 sg13_lv_nmos ad=0.19p pd=1.38u as=0.19p ps=1.38u w=1u l=1u
X16 vout1 vin1 VSS.t24 VSS.t25 sg13_lv_nmos ad=0.19p pd=1.38u as=0.19p ps=1.38u w=1u l=1u
X17 VDD vin2 vout2 VDD sg13_lv_pmos ad=1.14p pd=6.38u as=1.14p ps=6.38u w=6u l=1u
X18 vout4 vin4 VSS.t34 VSS.t108 sg13_lv_nmos ad=0.19p pd=1.38u as=0.19p ps=1.38u w=1u l=1u
X19 VDD vin2 vout2 VDD sg13_lv_pmos ad=1.14p pd=6.38u as=1.14p ps=6.38u w=6u l=1u
X20 VSS.t105 vin3 vout3 VSS.t84 sg13_lv_nmos ad=0.19p pd=1.38u as=0.19p ps=1.38u w=1u l=1u
X21 vout4 vin4 VSS.t125 VSS.t126 sg13_lv_nmos ad=0.19p pd=1.38u as=0.19p ps=1.38u w=1u l=1u
X22 VSS.t119 vin4 vout4 VSS.t118 sg13_lv_nmos ad=0.19p pd=1.38u as=0.19p ps=1.38u w=1u l=1u
X23 VDD vin3 vout3 VDD sg13_lv_pmos ad=1.14p pd=6.38u as=1.14p ps=6.38u w=6u l=1u
X24 VDD vin2 vout2 VDD sg13_lv_pmos ad=1.14p pd=6.38u as=1.14p ps=6.38u w=6u l=1u
X25 vout3 vin3 VDD VDD sg13_lv_pmos ad=1.14p pd=6.38u as=1.14p ps=6.38u w=6u l=1u
X26 VSS.t70 vin2 vout2 VSS.t69 sg13_lv_nmos ad=0.19p pd=1.38u as=0.19p ps=1.38u w=1u l=1u
X27 VDD vin3 vout3 VDD sg13_lv_pmos ad=1.14p pd=6.38u as=1.14p ps=6.38u w=6u l=1u
X28 VSS.t42 VSS.t39 VSS.t41 VSS.t40 sg13_lv_nmos ad=0.34p pd=2.68u as=0 ps=0 w=1u l=1u
X29 vout2 vin2 VDD VDD sg13_lv_pmos ad=1.14p pd=6.38u as=1.14p ps=6.38u w=6u l=1u
X30 vout2 vin2 VSS.t73 VSS.t74 sg13_lv_nmos ad=0.19p pd=1.38u as=0.19p ps=1.38u w=1u l=1u
X31 vout1 vin1 VSS.t18 VSS.t19 sg13_lv_nmos ad=0.19p pd=1.38u as=0.19p ps=1.38u w=1u l=1u
X32 VSS.t79 vin2 vout2 VSS.t78 sg13_lv_nmos ad=0.19p pd=1.38u as=0.19p ps=1.38u w=1u l=1u
X33 vout4 vin4 VSS.t122 VSS.t123 sg13_lv_nmos ad=0.19p pd=1.38u as=0.19p ps=1.38u w=1u l=1u
X34 vout1 vin1 VDD VDD sg13_lv_pmos ad=1.14p pd=6.38u as=1.14p ps=6.38u w=6u l=1u
X35 vout1 vin1 VSS.t12 VSS.t13 sg13_lv_nmos ad=0.19p pd=1.38u as=0.19p ps=1.38u w=1u l=1u
X36 VSS.t128 vin4 vout4 VSS.t127 sg13_lv_nmos ad=0.19p pd=1.38u as=0.19p ps=1.38u w=1u l=1u
X37 VDD VDD VDD VDD sg13_lv_pmos ad=1.14p pd=6.38u as=0 ps=0 w=6u l=1u
X38 VSS.t18 vin1 vout1 VSS.t17 sg13_lv_nmos ad=0.19p pd=1.38u as=0.19p ps=1.38u w=1u l=1u
X39 vout2 vin2 VDD VDD sg13_lv_pmos ad=1.14p pd=6.38u as=1.14p ps=6.38u w=6u l=1u
X40 VDD vin4 vout4 VDD sg13_lv_pmos ad=1.14p pd=6.38u as=1.14p ps=6.38u w=6u l=1u
X41 vout1 vin1 VSS.t21 VSS.t22 sg13_lv_nmos ad=0.19p pd=1.38u as=0.19p ps=1.38u w=1u l=1u
X42 vout3 vin3 VSS.t103 VSS.t83 sg13_lv_nmos ad=0.19p pd=1.38u as=0.19p ps=1.38u w=1u l=1u
X43 VDD vin3 vout3 VDD sg13_lv_pmos ad=1.14p pd=6.38u as=1.14p ps=6.38u w=6u l=1u
X44 vout4 vin4 VDD VDD sg13_lv_pmos ad=1.14p pd=6.38u as=1.14p ps=6.38u w=6u l=1u
X45 VDD vin4 vout4 VDD sg13_lv_pmos ad=1.14p pd=6.38u as=1.14p ps=6.38u w=6u l=1u
X46 vout3 vin3 VDD VDD sg13_lv_pmos ad=1.14p pd=6.38u as=1.14p ps=6.38u w=6u l=1u
X47 VDD vin3 vout3 VDD sg13_lv_pmos ad=1.14p pd=6.38u as=1.14p ps=6.38u w=6u l=1u
X48 VSS.t38 VSS.t35 VSS.t37 VSS.t36 sg13_lv_nmos ad=0.19p pd=1.38u as=0 ps=0 w=1u l=1u
X49 VDD vin4 vout4 VDD sg13_lv_pmos ad=1.14p pd=6.38u as=1.14p ps=6.38u w=6u l=1u
X50 VDD vin2 vout2 VDD sg13_lv_pmos ad=1.14p pd=6.38u as=1.14p ps=6.38u w=6u l=1u
X51 VSS.t131 vin4 vout4 VSS.t130 sg13_lv_nmos ad=0.19p pd=1.38u as=0.19p ps=1.38u w=1u l=1u
X52 VDD vin3 vout3 VDD sg13_lv_pmos ad=1.14p pd=6.38u as=1.14p ps=6.38u w=6u l=1u
X53 VSS.t12 vin1 vout1 VSS.t11 sg13_lv_nmos ad=0.19p pd=1.38u as=0.19p ps=1.38u w=1u l=1u
X54 VDD vin1 vout1 VDD sg13_lv_pmos ad=1.14p pd=6.38u as=1.14p ps=6.38u w=6u l=1u
X55 vout4 vin4 VSS.t134 VSS.t135 sg13_lv_nmos ad=0.19p pd=1.38u as=0.19p ps=1.38u w=1u l=1u
X56 vout1 vin1 VDD VDD sg13_lv_pmos ad=1.14p pd=6.38u as=1.14p ps=6.38u w=6u l=1u
X57 vout4 vin4 VDD VDD sg13_lv_pmos ad=1.14p pd=6.38u as=1.14p ps=6.38u w=6u l=1u
X58 vout1 vin1 VSS.t15 VSS.t16 sg13_lv_nmos ad=0.19p pd=1.38u as=0.19p ps=1.38u w=1u l=1u
X59 VDD vin1 vout1 VDD sg13_lv_pmos ad=1.14p pd=6.38u as=1.14p ps=6.38u w=6u l=1u
X60 vout3 vin3 VSS.t99 VSS.t77 sg13_lv_nmos ad=0.19p pd=1.38u as=0.19p ps=1.38u w=1u l=1u
X61 VSS.t21 vin1 vout1 VSS.t20 sg13_lv_nmos ad=0.19p pd=1.38u as=0.19p ps=1.38u w=1u l=1u
X62 VDD VDD VDD VDD sg13_lv_pmos ad=2.04p pd=12.68u as=0 ps=0 w=6u l=1u
X63 vout4 vin4 VDD VDD sg13_lv_pmos ad=1.14p pd=6.38u as=1.14p ps=6.38u w=6u l=1u
X64 VDD vin3 vout3 VDD sg13_lv_pmos ad=1.14p pd=6.38u as=1.14p ps=6.38u w=6u l=1u
X65 VDD vin4 vout4 VDD sg13_lv_pmos ad=1.14p pd=6.38u as=1.14p ps=6.38u w=6u l=1u
X66 vout3 vin3 VDD VDD sg13_lv_pmos ad=1.14p pd=6.38u as=1.14p ps=6.38u w=6u l=1u
X67 vout3 vin3 VSS.t95 VSS.t71 sg13_lv_nmos ad=0.19p pd=1.38u as=0.19p ps=1.38u w=1u l=1u
X68 VSS.t99 vin3 vout3 VSS.t75 sg13_lv_nmos ad=0.19p pd=1.38u as=0.19p ps=1.38u w=1u l=1u
X69 VDD VDD VDD VDD sg13_lv_pmos ad=1.14p pd=6.38u as=0 ps=0 w=6u l=1u
X70 vout3 vin3 VSS.t101 VSS.t80 sg13_lv_nmos ad=0.19p pd=1.38u as=0.19p ps=1.38u w=1u l=1u
X71 vout4 vin4 VDD VDD sg13_lv_pmos ad=1.14p pd=6.38u as=1.14p ps=6.38u w=6u l=1u
X72 vout3 vin3 VDD VDD sg13_lv_pmos ad=1.14p pd=6.38u as=1.14p ps=6.38u w=6u l=1u
X73 VDD vin1 vout1 VDD sg13_lv_pmos ad=1.14p pd=6.38u as=1.14p ps=6.38u w=6u l=1u
X74 vout2 vin2 VDD VDD sg13_lv_pmos ad=1.14p pd=6.38u as=1.14p ps=6.38u w=6u l=1u
X75 vout1 vin1 VDD VDD sg13_lv_pmos ad=1.14p pd=6.38u as=1.14p ps=6.38u w=6u l=1u
X76 vout2 vin2 VSS.t64 VSS.t65 sg13_lv_nmos ad=0.19p pd=1.38u as=0.19p ps=1.38u w=1u l=1u
X77 VDD vin1 vout1 VDD sg13_lv_pmos ad=1.14p pd=6.38u as=1.14p ps=6.38u w=6u l=1u
X78 VDD vin1 vout1 VDD sg13_lv_pmos ad=1.14p pd=6.38u as=1.14p ps=6.38u w=6u l=1u
X79 VDD vin3 vout3 VDD sg13_lv_pmos ad=1.14p pd=6.38u as=1.14p ps=6.38u w=6u l=1u
X80 VSS.t95 vin3 vout3 VSS.t69 sg13_lv_nmos ad=0.19p pd=1.38u as=0.19p ps=1.38u w=1u l=1u
X81 vout3 vin3 VSS.t97 VSS.t74 sg13_lv_nmos ad=0.19p pd=1.38u as=0.19p ps=1.38u w=1u l=1u
X82 VSS.t113 vin4 vout4 VSS.t112 sg13_lv_nmos ad=0.19p pd=1.38u as=0.19p ps=1.38u w=1u l=1u
X83 VDD vin4 vout4 VDD sg13_lv_pmos ad=1.14p pd=6.38u as=1.14p ps=6.38u w=6u l=1u
X84 VSS.t101 vin3 vout3 VSS.t78 sg13_lv_nmos ad=0.19p pd=1.38u as=0.19p ps=1.38u w=1u l=1u
X85 vout4 vin4 VSS.t116 VSS.t117 sg13_lv_nmos ad=0.19p pd=1.38u as=0.19p ps=1.38u w=1u l=1u
X86 VDD vin1 vout1 VDD sg13_lv_pmos ad=1.14p pd=6.38u as=1.14p ps=6.38u w=6u l=1u
X87 vout2 vin2 VDD VDD sg13_lv_pmos ad=1.14p pd=6.38u as=1.14p ps=6.38u w=6u l=1u
X88 vout1 vin1 VDD VDD sg13_lv_pmos ad=1.14p pd=6.38u as=1.14p ps=6.38u w=6u l=1u
X89 VSS.t110 vin4 vout4 VSS.t109 sg13_lv_nmos ad=0.19p pd=1.38u as=0.19p ps=1.38u w=1u l=1u
X90 VDD VDD VDD VDD sg13_lv_pmos ad=2.04p pd=12.68u as=0 ps=0 w=6u l=1u
X91 vout2 vin2 VDD VDD sg13_lv_pmos ad=1.14p pd=6.38u as=1.14p ps=6.38u w=6u l=1u
X92 VDD vin2 vout2 VDD sg13_lv_pmos ad=1.14p pd=6.38u as=1.14p ps=6.38u w=6u l=1u
X93 VSS.t64 vin2 vout2 VSS.t63 sg13_lv_nmos ad=0.19p pd=1.38u as=0.19p ps=1.38u w=1u l=1u
X94 VSS.t122 vin4 vout4 VSS.t121 sg13_lv_nmos ad=0.19p pd=1.38u as=0.19p ps=1.38u w=1u l=1u
X95 vout2 vin2 VDD VDD sg13_lv_pmos ad=1.14p pd=6.38u as=1.14p ps=6.38u w=6u l=1u
X96 VDD VDD VDD VDD sg13_lv_pmos ad=2.04p pd=12.68u as=0 ps=0 w=6u l=1u
X97 vout2 vin2 VSS.t67 VSS.t68 sg13_lv_nmos ad=0.19p pd=1.38u as=0.19p ps=1.38u w=1u l=1u
X98 VSS.t73 vin2 vout2 VSS.t72 sg13_lv_nmos ad=0.19p pd=1.38u as=0.19p ps=1.38u w=1u l=1u
X99 vout1 vin1 VDD VDD sg13_lv_pmos ad=1.14p pd=6.38u as=1.14p ps=6.38u w=6u l=1u
X100 vout1 vin1 VSS.t6 VSS.t7 sg13_lv_nmos ad=0.19p pd=1.38u as=0.19p ps=1.38u w=1u l=1u
X101 vout4 vin4 VSS.t119 VSS.t120 sg13_lv_nmos ad=0.19p pd=1.38u as=0.19p ps=1.38u w=1u l=1u
X102 vout3 vin3 VDD VDD sg13_lv_pmos ad=1.14p pd=6.38u as=1.14p ps=6.38u w=6u l=1u
X103 vout4 vin4 VSS.t131 VSS.t132 sg13_lv_nmos ad=0.19p pd=1.38u as=0.19p ps=1.38u w=1u l=1u
X104 VSS.t52 VSS.t50 VSS.t51 VSS.t44 sg13_lv_nmos ad=0.19p pd=1.38u as=0 ps=0 w=1u l=1u
X105 VSS.t125 vin4 vout4 VSS.t124 sg13_lv_nmos ad=0.19p pd=1.38u as=0.19p ps=1.38u w=1u l=1u
X106 VDD vin1 vout1 VDD sg13_lv_pmos ad=1.14p pd=6.38u as=1.14p ps=6.38u w=6u l=1u
X107 VSS.t51 vin2 vout2 VSS.t87 sg13_lv_nmos ad=0.19p pd=1.38u as=0.19p ps=1.38u w=1u l=1u
X108 VDD vin2 vout2 VDD sg13_lv_pmos ad=1.14p pd=6.38u as=1.14p ps=6.38u w=6u l=1u
X109 vout4 vin4 VSS.t128 VSS.t129 sg13_lv_nmos ad=0.19p pd=1.38u as=0.19p ps=1.38u w=1u l=1u
X110 vout4 vin4 VDD VDD sg13_lv_pmos ad=1.14p pd=6.38u as=1.14p ps=6.38u w=6u l=1u
X111 vout2 vin2 VDD VDD sg13_lv_pmos ad=1.14p pd=6.38u as=1.14p ps=6.38u w=6u l=1u
X112 vout2 vin2 VSS.t61 VSS.t62 sg13_lv_nmos ad=0.19p pd=1.38u as=0.19p ps=1.38u w=1u l=1u
X113 VDD vin2 vout2 VDD sg13_lv_pmos ad=1.14p pd=6.38u as=1.14p ps=6.38u w=6u l=1u
X114 VSS.t67 vin2 vout2 VSS.t66 sg13_lv_nmos ad=0.19p pd=1.38u as=0.19p ps=1.38u w=1u l=1u
X115 VDD vin4 vout4 VDD sg13_lv_pmos ad=1.14p pd=6.38u as=1.14p ps=6.38u w=6u l=1u
X116 VDD VDD VDD VDD sg13_lv_pmos ad=2.04p pd=12.68u as=0 ps=0 w=6u l=1u
X117 VSS.t61 vin2 vout2 VSS.t60 sg13_lv_nmos ad=0.19p pd=1.38u as=0.19p ps=1.38u w=1u l=1u
X118 VSS.t6 vin1 vout1 VSS.t5 sg13_lv_nmos ad=0.19p pd=1.38u as=0.19p ps=1.38u w=1u l=1u
X119 vout3 vin3 VDD VDD sg13_lv_pmos ad=1.14p pd=6.38u as=1.14p ps=6.38u w=6u l=1u
X120 vout1 vin1 VSS.t9 VSS.t10 sg13_lv_nmos ad=0.19p pd=1.38u as=0.19p ps=1.38u w=1u l=1u
X121 VSS.t15 vin1 vout1 VSS.t14 sg13_lv_nmos ad=0.19p pd=1.38u as=0.19p ps=1.38u w=1u l=1u
X122 vout3 vin3 VDD VDD sg13_lv_pmos ad=1.14p pd=6.38u as=1.14p ps=6.38u w=6u l=1u
X123 VDD vin3 vout3 VDD sg13_lv_pmos ad=1.14p pd=6.38u as=1.14p ps=6.38u w=6u l=1u
X124 vout3 vin3 VDD VDD sg13_lv_pmos ad=1.14p pd=6.38u as=1.14p ps=6.38u w=6u l=1u
X125 vout3 vin3 VSS.t91 VSS.t65 sg13_lv_nmos ad=0.19p pd=1.38u as=0.19p ps=1.38u w=1u l=1u
X126 VSS.t82 vin2 vout2 VSS.t81 sg13_lv_nmos ad=0.19p pd=1.38u as=0.19p ps=1.38u w=1u l=1u
X127 vout1 vin1 VDD VDD sg13_lv_pmos ad=1.14p pd=6.38u as=1.14p ps=6.38u w=6u l=1u
X128 vout2 vin2 VSS.t85 VSS.t86 sg13_lv_nmos ad=0.19p pd=1.38u as=0.19p ps=1.38u w=1u l=1u
X129 VSS.t37 vin4 vout4 VSS.t136 sg13_lv_nmos ad=0.19p pd=1.38u as=0.19p ps=1.38u w=1u l=1u
X130 VSS.t58 VSS.t56 VSS.t30 VSS.t57 sg13_lv_nmos ad=0.19p pd=1.38u as=0 ps=0 w=1u l=1u
X131 VSS.t30 vin1 vout1 VSS.t29 sg13_lv_nmos ad=0.19p pd=1.38u as=0.19p ps=1.38u w=1u l=1u
X132 vout2 vin2 VSS.t49 VSS.t59 sg13_lv_nmos ad=0.19p pd=1.38u as=0.19p ps=1.38u w=1u l=1u
X133 VSS.t34 VSS.t31 VSS.t33 VSS.t32 sg13_lv_nmos ad=0.34p pd=2.68u as=0 ps=0 w=1u l=1u
X134 vout1 vin1 VSS.t3 VSS.t4 sg13_lv_nmos ad=0.19p pd=1.38u as=0.19p ps=1.38u w=1u l=1u
X135 VSS.t9 vin1 vout1 VSS.t8 sg13_lv_nmos ad=0.19p pd=1.38u as=0.19p ps=1.38u w=1u l=1u
X136 VDD vin3 vout3 VDD sg13_lv_pmos ad=1.14p pd=6.38u as=1.14p ps=6.38u w=6u l=1u
X137 VSS.t3 vin1 vout1 VSS.t2 sg13_lv_nmos ad=0.19p pd=1.38u as=0.19p ps=1.38u w=1u l=1u
X138 vout4 vin4 VDD VDD sg13_lv_pmos ad=1.14p pd=6.38u as=1.14p ps=6.38u w=6u l=1u
X139 vout3 vin3 VDD VDD sg13_lv_pmos ad=1.14p pd=6.38u as=1.14p ps=6.38u w=6u l=1u
X140 VDD vin3 vout3 VDD sg13_lv_pmos ad=1.14p pd=6.38u as=1.14p ps=6.38u w=6u l=1u
X141 VSS.t91 vin3 vout3 VSS.t63 sg13_lv_nmos ad=0.19p pd=1.38u as=0.19p ps=1.38u w=1u l=1u
X142 vout3 vin3 VSS.t93 VSS.t68 sg13_lv_nmos ad=0.19p pd=1.38u as=0.19p ps=1.38u w=1u l=1u
X143 vout1 vin1 VDD VDD sg13_lv_pmos ad=1.14p pd=6.38u as=1.14p ps=6.38u w=6u l=1u
X144 VSS.t85 vin2 vout2 VSS.t84 sg13_lv_nmos ad=0.19p pd=1.38u as=0.19p ps=1.38u w=1u l=1u
X145 VSS.t97 vin3 vout3 VSS.t72 sg13_lv_nmos ad=0.19p pd=1.38u as=0.19p ps=1.38u w=1u l=1u
X146 VDD vin4 vout4 VDD sg13_lv_pmos ad=1.14p pd=6.38u as=1.14p ps=6.38u w=6u l=1u
X147 vout1 vin1 VDD VDD sg13_lv_pmos ad=1.14p pd=6.38u as=1.14p ps=6.38u w=6u l=1u
X148 VDD vin1 vout1 VDD sg13_lv_pmos ad=1.14p pd=6.38u as=1.14p ps=6.38u w=6u l=1u
X149 vout4 vin4 VDD VDD sg13_lv_pmos ad=1.14p pd=6.38u as=1.14p ps=6.38u w=6u l=1u
X150 VSS.t24 vin1 vout1 VSS.t23 sg13_lv_nmos ad=0.19p pd=1.38u as=0.19p ps=1.38u w=1u l=1u
X151 vout1 vin1 VSS.t27 VSS.t28 sg13_lv_nmos ad=0.19p pd=1.38u as=0.19p ps=1.38u w=1u l=1u
X152 vout1 vin1 VDD VDD sg13_lv_pmos ad=1.14p pd=6.38u as=1.14p ps=6.38u w=6u l=1u
X153 vout2 vin2 VDD VDD sg13_lv_pmos ad=1.14p pd=6.38u as=1.14p ps=6.38u w=6u l=1u
X154 vout4 vin4 VSS.t113 VSS.t114 sg13_lv_nmos ad=0.19p pd=1.38u as=0.19p ps=1.38u w=1u l=1u
X155 VSS.t49 VSS.t47 VSS.t48 VSS.t40 sg13_lv_nmos ad=0.34p pd=2.68u as=0 ps=0 w=1u l=1u
X156 VSS.t46 VSS.t43 VSS.t45 VSS.t44 sg13_lv_nmos ad=0.19p pd=1.38u as=0 ps=0 w=1u l=1u
X157 vout4 vin4 VDD VDD sg13_lv_pmos ad=1.14p pd=6.38u as=1.14p ps=6.38u w=6u l=1u
X158 VSS.t45 vin3 vout3 VSS.t87 sg13_lv_nmos ad=0.19p pd=1.38u as=0.19p ps=1.38u w=1u l=1u
X159 VSS.t134 vin4 vout4 VSS.t133 sg13_lv_nmos ad=0.19p pd=1.38u as=0.19p ps=1.38u w=1u l=1u
X160 VDD vin4 vout4 VDD sg13_lv_pmos ad=1.14p pd=6.38u as=1.14p ps=6.38u w=6u l=1u
X161 vout1 vin1 VSS.t1 VSS.t0 sg13_lv_nmos ad=0.19p pd=1.38u as=0.19p ps=1.38u w=1u l=1u
X162 vout3 vin3 VSS.t89 VSS.t62 sg13_lv_nmos ad=0.19p pd=1.38u as=0.19p ps=1.38u w=1u l=1u
X163 VSS.t93 vin3 vout3 VSS.t66 sg13_lv_nmos ad=0.19p pd=1.38u as=0.19p ps=1.38u w=1u l=1u
X164 vout4 vin4 VDD VDD sg13_lv_pmos ad=1.14p pd=6.38u as=1.14p ps=6.38u w=6u l=1u
X165 vout2 vin2 VSS.t82 VSS.t83 sg13_lv_nmos ad=0.19p pd=1.38u as=0.19p ps=1.38u w=1u l=1u
X166 VSS.t89 vin3 vout3 VSS.t60 sg13_lv_nmos ad=0.19p pd=1.38u as=0.19p ps=1.38u w=1u l=1u
X167 VDD vin1 vout1 VDD sg13_lv_pmos ad=1.14p pd=6.38u as=1.14p ps=6.38u w=6u l=1u
X168 vout1 vin1 VDD VDD sg13_lv_pmos ad=1.14p pd=6.38u as=1.14p ps=6.38u w=6u l=1u
X169 VDD vin1 vout1 VDD sg13_lv_pmos ad=1.14p pd=6.38u as=1.14p ps=6.38u w=6u l=1u
X170 VDD vin4 vout4 VDD sg13_lv_pmos ad=1.14p pd=6.38u as=1.14p ps=6.38u w=6u l=1u
X171 VSS.t27 vin1 vout1 VSS.t26 sg13_lv_nmos ad=0.19p pd=1.38u as=0.19p ps=1.38u w=1u l=1u
X172 VDD vin2 vout2 VDD sg13_lv_pmos ad=1.14p pd=6.38u as=1.14p ps=6.38u w=6u l=1u
X173 vout2 vin2 VDD VDD sg13_lv_pmos ad=1.14p pd=6.38u as=1.14p ps=6.38u w=6u l=1u
X174 VDD vin2 vout2 VDD sg13_lv_pmos ad=1.14p pd=6.38u as=1.14p ps=6.38u w=6u l=1u
X175 VSS.t103 vin3 vout3 VSS.t81 sg13_lv_nmos ad=0.19p pd=1.38u as=0.19p ps=1.38u w=1u l=1u
R0 VSS.n75 VSS.n77 6777.49
R1 VSS.n6 VSS.n77 6777.49
R2 VSS.n320 VSS.n319 1580.41
R3 VSS.n112 VSS.n77 1580.41
R4 VSS.t59 VSS.n94 88.7251
R5 VSS.t87 VSS.n110 88.7251
R6 VSS.t60 VSS.n93 83.1798
R7 VSS.n228 VSS.t86 83.1798
R8 VSS.t62 VSS.n92 77.6345
R9 VSS.t84 VSS.n109 77.6345
R10 VSS.t32 VSS.n76 6.87896
R11 VSS.t36 VSS.n79 6.87897
R12 VSS.n170 VSS.t63 72.0892
R13 VSS.n108 VSS.t83 72.0892
R14 VSS.t136 VSS.n74 68.3206
R15 VSS.t65 VSS.n91 66.5439
R16 VSS.n107 VSS.t81 66.5439
R17 VSS.t135 VSS.n73 64.5255
R18 VSS.n57 VSS.t109 64.5209
R19 VSS.t66 VSS.n90 60.9987
R20 VSS.n106 VSS.t80 60.9987
R21 VSS.t133 VSS.n72 60.7305
R22 VSS.n58 VSS.t111 60.7259
R23 VSS.t132 VSS.n71 56.9354
R24 VSS.n59 VSS.t112 56.9308
R25 VSS.n6 VSS.t28 12.2984
R26 VSS.n159 VSS.t68 55.4534
R27 VSS.n102 VSS.t72 55.4534
R28 VSS.t74 VSS.n87 55.4534
R29 VSS.n105 VSS.t78 55.4534
R30 VSS.t130 VSS.n70 53.1403
R31 VSS.n60 VSS.t114 53.1357
R32 VSS.t69 VSS.n89 49.9081
R33 VSS.n101 VSS.t71 49.9081
R34 VSS.t75 VSS.n86 49.9081
R35 VSS.n104 VSS.t77 49.9081
R36 VSS.t129 VSS.n69 49.3453
R37 VSS.n61 VSS.t115 49.3407
R38 VSS.t127 VSS.n68 45.5502
R39 VSS.t121 VSS.n64 45.5502
R40 VSS.n66 VSS.t123 45.5456
R41 VSS.n62 VSS.t117 45.5456
R42 VSS.n197 VSS.t69 44.3628
R43 VSS.t71 VSS.n88 44.3628
R44 VSS.n103 VSS.t75 44.3628
R45 VSS.t77 VSS.n85 44.3628
R46 VSS.t126 VSS.n67 41.7551
R47 VSS.t120 VSS.n63 41.7551
R48 VSS.n67 VSS.t124 41.7505
R49 VSS.n63 VSS.t118 41.7505
R50 VSS.n6 VSS.t22 18.7991
R51 VSS.t68 VSS.n100 38.8175
R52 VSS.n3 VSS.t74 40.8367
R53 VSS.t78 VSS.n84 38.8175
R54 VSS.t124 VSS.n66 37.9601
R55 VSS.t118 VSS.n62 37.9601
R56 VSS.n68 VSS.t126 37.9555
R57 VSS.n64 VSS.t120 37.9555
R58 VSS.n6 VSS.t20 19.5211
R59 VSS.t123 VSS.n65 34.1682
R60 VSS.t117 VSS.n61 34.165
R61 VSS.n65 VSS.t121 34.1635
R62 VSS.n69 VSS.t127 34.1604
R63 VSS.n99 VSS.t66 33.2722
R64 VSS.t80 VSS.n83 33.2722
R65 VSS.t115 VSS.n60 30.3699
R66 VSS.n70 VSS.t129 30.3653
R67 VSS.n6 VSS.t17 19.8815
R68 VSS.n191 VSS.t65 27.7269
R69 VSS.t81 VSS.n82 27.7269
R70 VSS.t114 VSS.n59 26.5749
R71 VSS.n71 VSS.t130 26.5703
R72 VSS.t112 VSS.n58 22.7798
R73 VSS.n72 VSS.t132 22.7752
R74 VSS.t54 VSS.n6 6.87994
R75 VSS.n6 VSS.t5 16.2715
R76 VSS.t63 VSS.n98 22.1816
R77 VSS.t83 VSS.n81 22.1816
R78 VSS.t111 VSS.n57 18.9847
R79 VSS.n73 VSS.t133 18.9801
R80 VSS.t26 VSS.n6 14.465
R81 VSS.t25 VSS.n6 16.2712
R82 VSS.t23 VSS.n6 17.7157
R83 VSS.t19 VSS.n6 19.882
R84 VSS.t16 VSS.n7 19.5026
R85 VSS.t14 VSS.n7 19.5609
R86 VSS.n6 VSS.t8 18.7991
R87 VSS.t4 VSS.n6 14.4657
R88 VSS.n6 VSS.n328 17.0005
R89 VSS.n6 VSS.n119 17.0005
R90 VSS.n327 VSS.t58 17.0005
R91 VSS.t58 VSS.n321 17.0005
R92 VSS.n326 VSS.t30 17.0005
R93 VSS.n321 VSS.t30 17.0005
R94 VSS.t58 VSS.n326 17.0005
R95 VSS.n327 VSS.t30 17.0005
R96 VSS.n6 VSS.n122 17.0005
R97 VSS.n6 VSS.n111 17.0005
R98 VSS.t1 VSS.n120 17.0005
R99 VSS.n121 VSS.t1 17.0005
R100 VSS.t1 VSS.n8 17.0005
R101 VSS.n121 VSS.t55 17.0005
R102 VSS.t55 VSS.n8 17.0005
R103 VSS.n120 VSS.t55 17.0005
R104 VSS.n0 VSS.n5 4.02492
R105 VSS.n0 VSS.n232 17.0005
R106 VSS.n38 VSS.t44 6.69134
R107 VSS.n0 VSS.n18 0.650675
R108 VSS.n18 VSS.n128 7.20256
R109 VSS.n0 VSS.n21 0.650675
R110 VSS.n21 VSS.n229 14.4044
R111 VSS.n0 VSS.n33 0.650675
R112 VSS.n33 VSS.n227 14.4044
R113 VSS.n0 VSS.n52 4.2472
R114 VSS.n0 VSS.n19 0.650675
R115 VSS.n19 VSS.n135 7.20256
R116 VSS.n0 VSS.n136 17.0005
R117 VSS.n0 VSS.n23 0.650675
R118 VSS.n23 VSS.n223 14.4044
R119 VSS.n0 VSS.n222 17.0005
R120 VSS.n0 VSS.n81 8.49725
R121 VSS.n0 VSS.n29 0.650675
R122 VSS.n0 VSS.n47 4.24728
R123 VSS.n29 VSS.n220 14.4044
R124 VSS.n0 VSS.n82 8.49965
R125 VSS.n17 VSS.n219 14.4044
R126 VSS.n0 VSS.n15 0.650675
R127 VSS.n0 VSS.n143 17.0005
R128 VSS.n15 VSS.n218 14.4044
R129 VSS.n0 VSS.n84 8.49825
R130 VSS.n0 VSS.n215 17.0005
R131 VSS.n0 VSS.n31 0.650675
R132 VSS.n31 VSS.n213 14.4044
R133 VSS.n0 VSS.n150 17.0005
R134 VSS.n13 VSS.n212 14.4044
R135 VSS.n0 VSS.n211 17.0005
R136 VSS.n0 VSS.n151 17.0005
R137 VSS.n0 VSS.n103 8.49676
R138 VSS.n0 VSS.n16 0.650675
R139 VSS.n16 VSS.n206 14.4044
R140 VSS.n2 VSS.n4 4.12339
R141 VSS.n0 VSS.n11 2.42322
R142 VSS.n0 VSS.n2 4.09889
R143 VSS.n0 VSS.n154 17.0005
R144 VSS.n27 VSS.n205 14.4044
R145 VSS.n0 VSS.n20 0.650675
R146 VSS.n20 VSS.n200 14.4044
R147 VSS.n0 VSS.n199 17.0005
R148 VSS.n32 VSS.n197 7.20256
R149 VSS.n0 VSS.n34 0.650675
R150 VSS.n34 VSS.n159 7.20256
R151 VSS.n0 VSS.n164 17.0005
R152 VSS.n0 VSS.n25 0.650675
R153 VSS.n0 VSS.n194 17.0005
R154 VSS.n0 VSS.n99 8.49874
R155 VSS.n0 VSS.n30 0.650675
R156 VSS.n30 VSS.n192 14.4044
R157 VSS.n0 VSS.n91 8.50152
R158 VSS.n22 VSS.n191 7.20256
R159 VSS.n43 VSS.n46 0.00714631
R160 VSS.n26 VSS.n170 7.20256
R161 VSS.n0 VSS.n28 0.650675
R162 VSS.n28 VSS.n189 14.4044
R163 VSS.n24 VSS.n188 14.4044
R164 VSS.n0 VSS.n49 17.0005
R165 VSS.n0 VSS.n14 0.650675
R166 VSS.n14 VSS.n186 14.4044
R167 VSS.n0 VSS.n95 8.49775
R168 VSS.n36 VSS.n177 13.8932
R169 VSS.n0 VSS.t40 7.668
R170 VSS.n1 VSS.n4 1.35946
R171 VSS.n0 VSS.n184 17.0005
R172 VSS.n0 VSS.n110 8.49187
R173 VSS.n0 VSS.n80 8.49626
R174 VSS.n0 VSS.n109 8.49211
R175 VSS.n0 VSS.n108 8.49235
R176 VSS.n0 VSS.n107 8.49899
R177 VSS.n0 VSS.n83 8.49601
R178 VSS.n0 VSS.n106 8.49259
R179 VSS.n0 VSS.n105 8.49284
R180 VSS.n0 VSS.n85 8.497
R181 VSS.n0 VSS.n104 8.49308
R182 VSS.n0 VSS.n86 8.4975
R183 VSS.n0 VSS.n87 8.49577
R184 VSS.n0 VSS.n3 4.09905
R185 VSS.n0 VSS.n102 8.49332
R186 VSS.n0 VSS.n88 8.49552
R187 VSS.n0 VSS.n101 8.49356
R188 VSS.n0 VSS.n89 8.49528
R189 VSS.n0 VSS.n100 8.49381
R190 VSS.n0 VSS.n90 8.49849
R191 VSS.n0 VSS.n98 8.49405
R192 VSS.n0 VSS.n92 8.49503
R193 VSS.n0 VSS.n97 8.49651
R194 VSS.n0 VSS.n93 8.49478
R195 VSS.n0 VSS.n96 8.4943
R196 VSS.n0 VSS.n94 8.49454
R197 VSS.n225 VSS.n4 17.0005
R198 VSS.n221 VSS.n4 17.0005
R199 VSS.n235 VSS.n4 17.0005
R200 VSS.n214 VSS.n4 17.0005
R201 VSS.n208 VSS.n4 17.0005
R202 VSS.n203 VSS.n4 17.0005
R203 VSS.n285 VSS.n4 17.0005
R204 VSS.n43 VSS.n4 17.0005
R205 VSS.n50 VSS.n4 4.2472
R206 VSS.n187 VSS.n4 17.0005
R207 VSS.n243 VSS.n75 17.0005
R208 VSS.n247 VSS.n75 17.0005
R209 VSS.n248 VSS.n75 17.0005
R210 VSS.n249 VSS.n75 17.0005
R211 VSS.n251 VSS.n75 17.0005
R212 VSS.n263 VSS.n75 17.0005
R213 VSS.n266 VSS.t38 17.0005
R214 VSS.t38 VSS.n250 17.0005
R215 VSS.t38 VSS.n265 17.0005
R216 VSS.n265 VSS.t37 17.0005
R217 VSS.n250 VSS.t37 17.0005
R218 VSS.n266 VSS.t37 17.0005
R219 VSS.n269 VSS.t34 17.0005
R220 VSS.n268 VSS.t34 17.0005
R221 VSS.n270 VSS.t34 17.0005
R222 VSS.t33 VSS.n268 17.0005
R223 VSS.n270 VSS.t33 17.0005
R224 VSS.t33 VSS.n269 17.0005
R225 VSS.n97 VSS.t62 16.6364
R226 VSS.n135 VSS.t84 16.6364
R227 VSS.t109 VSS.n56 15.1993
R228 VSS.n74 VSS.t135 15.1851
R229 VSS.t47 VSS.n291 15.0005
R230 VSS.n300 VSS.t39 15.0005
R231 VSS.n315 VSS.t43 15.0005
R232 VSS.t50 VSS.n293 15.0005
R233 VSS.n4 VSS.n3 4.12345
R234 VSS.n38 VSS.n125 13.3823
R235 VSS.n153 VSS.n27 14.4051
R236 VSS.n36 VSS.n180 13.3823
R237 VSS.n180 VSS.n37 13.3823
R238 VSS.n190 VSS.n22 14.4051
R239 VSS.n195 VSS.n25 14.4051
R240 VSS.n196 VSS.n32 14.4051
R241 VSS.n228 VSS.n33 7.20324
R242 VSS.n125 VSS.n35 13.3823
R243 VSS.t108 VSS.n56 9.77299
R244 VSS.t2 VSS.n6 12.2982
R245 VSS.n6 VSS.t7 17.7161
R246 VSS.n6 VSS.t10 19.521
R247 VSS.n6 VSS.t11 19.8822
R248 VSS.t13 VSS.n6 19.8817
R249 VSS.n7 VSS.n6 0.0531137
R250 VSS.t29 VSS.n6 9.77049
R251 VSS.n6 VSS.t57 6.87996
R252 VSS.n96 VSS.t60 11.0911
R253 VSS.t86 VSS.n80 11.0911
R254 VSS.n319 VSS.n0 1.53537
R255 VSS.n0 VSS.n112 1.69886
R256 VSS.n125 VSS.n4 8.5005
R257 VSS.n128 VSS.n4 8.5005
R258 VSS.n228 VSS.n4 8.5005
R259 VSS.n135 VSS.n4 8.5005
R260 VSS.n197 VSS.n4 8.5005
R261 VSS.n159 VSS.n4 8.5005
R262 VSS.n191 VSS.n4 8.5005
R263 VSS.n170 VSS.n4 8.5005
R264 VSS.n180 VSS.n4 8.5005
R265 VSS.n0 VSS.n124 8.4984
R266 VSS.n0 VSS.n127 8.4984
R267 VSS.n0 VSS.n130 8.4984
R268 VSS.n0 VSS.n133 8.4984
R269 VSS.n52 VSS.n134 0.0180746
R270 VSS.n0 VSS.n226 8.4984
R271 VSS.n47 VSS.n221 0.0123817
R272 VSS.n0 VSS.n40 4.24695
R273 VSS.n0 VSS.n140 8.4984
R274 VSS.n0 VSS.n217 8.4984
R275 VSS.n0 VSS.n145 8.4984
R276 VSS.n0 VSS.n147 8.4984
R277 VSS.n0 VSS.n209 8.4984
R278 VSS.n11 VSS.n207 0.0262325
R279 VSS.n0 VSS.n204 8.4984
R280 VSS.n0 VSS.n201 8.4984
R281 VSS.n0 VSS.n156 8.4984
R282 VSS.n0 VSS.n158 8.4984
R283 VSS.n0 VSS.n161 8.4984
R284 VSS.n0 VSS.n165 8.4984
R285 VSS.n0 VSS.n168 8.4984
R286 VSS.n0 VSS.n44 8.4984
R287 VSS.n41 VSS.n43 0.0288738
R288 VSS.n0 VSS.n41 1.53452
R289 VSS.n42 VSS.n51 0.0362733
R290 VSS.n0 VSS.n174 8.4984
R291 VSS.n0 VSS.n176 8.4984
R292 VSS.n0 VSS.n179 8.4984
R293 VSS.n0 VSS.n182 8.4984
R294 VSS.n231 VSS.n4 8.4984
R295 VSS.n126 VSS.n4 8.4984
R296 VSS.n129 VSS.n4 8.4984
R297 VSS.n132 VSS.n4 8.4984
R298 VSS.n134 VSS.n4 8.4984
R299 VSS.n53 VSS.n54 0.0123709
R300 VSS.n54 VSS.n4 4.24427
R301 VSS.n224 VSS.n4 8.4984
R302 VSS.n48 VSS.n40 0.0188704
R303 VSS.n40 VSS.n39 0.0190014
R304 VSS.n39 VSS.n4 2.11151
R305 VSS.n142 VSS.n4 8.4984
R306 VSS.n216 VSS.n4 8.4984
R307 VSS.n146 VSS.n4 8.4984
R308 VSS.n149 VSS.n4 8.4984
R309 VSS.n210 VSS.n4 8.4984
R310 VSS.n207 VSS.n4 8.4984
R311 VSS.t97 VSS.n12 0.0170062
R312 VSS.n12 VSS.n4 2.41652
R313 VSS.n202 VSS.n4 8.4984
R314 VSS.n198 VSS.n4 8.4984
R315 VSS.n157 VSS.n4 8.4984
R316 VSS.n160 VSS.n4 8.4984
R317 VSS.n163 VSS.n4 8.4984
R318 VSS.n193 VSS.n4 8.4984
R319 VSS.n167 VSS.n4 8.4984
R320 VSS.n169 VSS.n4 8.4984
R321 VSS.n45 VSS.n4 4.24745
R322 VSS.n41 VSS.n42 0.0380956
R323 VSS.n42 VSS.n4 4.23825
R324 VSS.n175 VSS.n4 8.4984
R325 VSS.n178 VSS.n4 8.4984
R326 VSS.n181 VSS.n4 8.4984
R327 VSS.n183 VSS.n4 8.4984
R328 VSS.n10 VSS.n6 1.2743
R329 VSS.n349 VSS.n113 8.22525
R330 VSS.n282 VSS.n281 8.22525
R331 VSS.n281 VSS.n239 8.22525
R332 VSS.n350 VSS.n349 8.22525
R333 VSS.n75 VSS.n76 0.00129054
R334 VSS.n297 VSS.t47 7.49606
R335 VSS.t39 VSS.n290 7.49606
R336 VSS.t43 VSS.n314 7.49606
R337 VSS.n294 VSS.t50 7.49606
R338 VSS.n230 VSS.n35 13.8932
R339 VSS.n131 VSS.n110 7.20236
R340 VSS.n137 VSS.n109 7.20236
R341 VSS.n138 VSS.n108 7.20236
R342 VSS.n139 VSS.n107 7.20236
R343 VSS.n141 VSS.n106 7.20236
R344 VSS.n144 VSS.n105 7.20236
R345 VSS.n148 VSS.n104 7.20236
R346 VSS.n152 VSS.n103 7.20236
R347 VSS.n206 VSS.n87 7.20236
R348 VSS.n205 VSS.n88 7.20236
R349 VSS.n155 VSS.n101 7.20236
R350 VSS.n200 VSS.n89 7.20236
R351 VSS.n162 VSS.n100 7.20236
R352 VSS.n30 VSS.n166 14.4051
R353 VSS.n171 VSS.n98 7.20236
R354 VSS.n172 VSS.n97 7.20236
R355 VSS.n188 VSS.n93 7.20236
R356 VSS.n173 VSS.n96 7.20236
R357 VSS.n185 VSS.n37 13.8932
R358 VSS.t40 VSS.n185 7.20236
R359 VSS.n177 VSS.n95 7.20236
R360 VSS.n186 VSS.n94 7.20236
R361 VSS.n14 VSS.n173 14.4051
R362 VSS.n24 VSS.n172 14.4051
R363 VSS.n189 VSS.n92 7.20236
R364 VSS.n28 VSS.n171 14.4051
R365 VSS.n26 VSS.n190 14.4051
R366 VSS.n192 VSS.n91 7.20236
R367 VSS.n166 VSS.n99 7.20236
R368 VSS.n195 VSS.n90 7.20236
R369 VSS.n25 VSS.n162 14.4044
R370 VSS.n34 VSS.n196 14.4051
R371 VSS.n20 VSS.n155 14.4051
R372 VSS.n153 VSS.n102 7.20236
R373 VSS.n2 VSS.t72 40.8367
R374 VSS.n16 VSS.n152 14.4051
R375 VSS.n212 VSS.n86 7.20236
R376 VSS.n13 VSS.n148 14.4051
R377 VSS.n213 VSS.n85 7.20236
R378 VSS.n31 VSS.n144 14.4051
R379 VSS.n218 VSS.n84 7.20236
R380 VSS.n15 VSS.n141 14.4051
R381 VSS.n219 VSS.n83 7.20236
R382 VSS.n17 VSS.n139 14.4051
R383 VSS.n220 VSS.n82 7.20236
R384 VSS.n29 VSS.n138 14.4051
R385 VSS.n223 VSS.n81 7.20236
R386 VSS.n23 VSS.n137 14.4051
R387 VSS.n19 VSS.n227 14.4051
R388 VSS.n229 VSS.n80 7.20236
R389 VSS.n21 VSS.n131 14.4051
R390 VSS.n18 VSS.n230 14.4051
R391 VSS.n5 VSS.t44 7.66551
R392 VSS.n320 VSS.n6 6777.49
R393 VSS.n95 VSS.t59 5.54579
R394 VSS.n128 VSS.t87 5.54579
R395 VSS.n298 VSS.t49 4.5005
R396 VSS.t42 VSS.n289 4.5005
R397 VSS.n295 VSS.t51 4.5005
R398 VSS.n318 VSS.t45 4.5005
R399 VSS.n299 VSS.n1 1.46299
R400 VSS.n123 VSS.n4 4.25206
R401 VSS.n0 VSS.n123 4.25175
R402 VSS.n0 VSS.n1 1.3593
R403 VSS.n284 VSS.n283 4.11287
R404 VSS.n284 VSS.n114 4.11287
R405 VSS.n325 VSS.t56 3.0005
R406 VSS.n345 VSS.t53 3.0005
R407 VSS.n264 VSS.t35 3.0005
R408 VSS.t31 VSS.n271 3.0005
R409 VSS.n296 VSS.n288 3.0005
R410 VSS.n302 VSS.n301 3.0005
R411 VSS.n292 VSS.n234 3.0005
R412 VSS.n317 VSS.n316 3.0005
R413 VSS.t0 VSS.n6 9.77002
R414 VSS.n239 VSS.n238 2.71193
R415 VSS.n352 VSS.n351 2.6297
R416 VSS.n346 VSS.t3 2.4821
R417 VSS.n347 VSS.t6 2.4821
R418 VSS.n348 VSS.t9 2.4821
R419 VSS.n118 VSS.t12 2.4821
R420 VSS.t18 VSS.n117 2.4821
R421 VSS.n322 VSS.t21 2.4821
R422 VSS.n323 VSS.t24 2.4821
R423 VSS.n324 VSS.t27 2.4821
R424 VSS.t134 VSS.n252 2.4821
R425 VSS.n253 VSS.t131 2.4821
R426 VSS.t128 VSS.n254 2.4821
R427 VSS.t125 VSS.n240 2.4821
R428 VSS.t119 VSS.n241 2.4821
R429 VSS.n244 VSS.t116 2.4821
R430 VSS.n245 VSS.t113 2.4821
R431 VSS.n246 VSS.t110 2.4821
R432 VSS.n304 VSS.t89 2.4821
R433 VSS.n304 VSS.t61 2.4821
R434 VSS.n305 VSS.t91 2.4821
R435 VSS.n305 VSS.t64 2.4821
R436 VSS.n306 VSS.t93 2.4821
R437 VSS.n306 VSS.t67 2.4821
R438 VSS.n307 VSS.t95 2.4821
R439 VSS.n307 VSS.t70 2.4821
R440 VSS.n309 VSS.t99 2.4821
R441 VSS.n309 VSS.t76 2.4821
R442 VSS.n310 VSS.t101 2.4821
R443 VSS.n310 VSS.t79 2.4821
R444 VSS.n311 VSS.t103 2.4821
R445 VSS.n311 VSS.t82 2.4821
R446 VSS.n312 VSS.t105 2.4821
R447 VSS.n312 VSS.t85 2.4821
R448 VSS.n0 VSS.n35 1.20771
R449 VSS.n0 VSS.n37 1.20771
R450 VSS.n0 VSS.n38 1.20771
R451 VSS.n0 VSS.n17 0.650675
R452 VSS.n0 VSS.n13 0.650675
R453 VSS.n0 VSS.n27 0.650675
R454 VSS.n0 VSS.n32 0.650675
R455 VSS.n0 VSS.n22 0.650675
R456 VSS.n0 VSS.n26 0.650675
R457 VSS.n0 VSS.n36 1.20771
R458 VSS.t48 VSS.n298 2.2505
R459 VSS.t41 VSS.n289 2.2505
R460 VSS.t52 VSS.n295 2.2505
R461 VSS.t46 VSS.n318 2.2505
R462 VSS.n330 VSS.n6 2.09947
R463 VSS.n332 VSS.n6 2.09947
R464 VSS.n334 VSS.n6 2.09947
R465 VSS.n115 VSS.n6 2.09947
R466 VSS.n336 VSS.n6 2.09947
R467 VSS.n338 VSS.n6 2.09947
R468 VSS.n340 VSS.n6 2.09947
R469 VSS.n342 VSS.n6 2.09947
R470 VSS.n75 VSS.n78 2.09901
R471 VSS.n256 VSS.n75 2.0988
R472 VSS.n274 VSS.n75 2.09868
R473 VSS.n278 VSS.n75 2.09868
R474 VSS.n276 VSS.n75 2.0986
R475 VSS.n258 VSS.n75 2.09849
R476 VSS.n280 VSS.n75 2.09849
R477 VSS.n260 VSS.n75 2.09849
R478 VSS.n319 VSS.n4 1.7005
R479 VSS.t46 VSS.n0 1.03745
R480 VSS.n112 VSS.n4 1.53502
R481 VSS.n345 VSS.n8 1.52811
R482 VSS.n265 VSS.n264 1.52811
R483 VSS.n271 VSS.n270 1.52811
R484 VSS.n326 VSS.n325 1.52811
R485 VSS.n268 VSS.n267 1.42216
R486 VSS.n267 VSS.n266 1.37855
R487 VSS.t48 VSS.n4 1.08267
R488 VSS.n4 VSS.t52 1.03721
R489 VSS.n55 VSS.n6 0.910042
R490 VSS.n344 VSS.n6 0.91152
R491 VSS.n272 VSS.n75 0.910334
R492 VSS.n262 VSS.n75 0.909239
R493 VSS.n5 VSS.n4 0.167883
R494 VSS.n230 VSS.n4 0.650322
R495 VSS.n131 VSS.n4 0.650322
R496 VSS.n229 VSS.n4 0.650322
R497 VSS.n227 VSS.n4 0.650322
R498 VSS.n137 VSS.n4 0.650322
R499 VSS.n223 VSS.n4 0.650322
R500 VSS.n138 VSS.n4 0.650322
R501 VSS.n220 VSS.n4 0.650322
R502 VSS.n139 VSS.n4 0.650322
R503 VSS.n219 VSS.n4 0.650322
R504 VSS.n141 VSS.n4 0.650322
R505 VSS.n218 VSS.n4 0.650322
R506 VSS.n144 VSS.n4 0.650322
R507 VSS.n213 VSS.n4 0.650322
R508 VSS.n148 VSS.n4 0.650322
R509 VSS.n212 VSS.n4 0.650322
R510 VSS.n152 VSS.n4 0.650322
R511 VSS.n206 VSS.n4 0.650322
R512 VSS.n153 VSS.n4 0.650322
R513 VSS.n205 VSS.n4 0.650322
R514 VSS.n155 VSS.n4 0.650322
R515 VSS.n200 VSS.n4 0.650322
R516 VSS.n196 VSS.n4 0.650322
R517 VSS.n162 VSS.n4 0.650322
R518 VSS.n195 VSS.n4 0.650322
R519 VSS.n166 VSS.n4 0.650322
R520 VSS.n192 VSS.n4 0.650322
R521 VSS.n190 VSS.n4 0.650322
R522 VSS.n171 VSS.n4 0.650322
R523 VSS.n189 VSS.n4 0.650322
R524 VSS.n172 VSS.n4 0.650322
R525 VSS.n188 VSS.n4 0.650322
R526 VSS.n173 VSS.n4 0.650322
R527 VSS.n186 VSS.n4 0.650322
R528 VSS.n177 VSS.n4 0.650322
R529 VSS.n185 VSS.n4 0.650322
R530 VSS.n282 VSS.n238 0.632727
R531 VSS.n353 VSS.n352 0.5505
R532 VSS.n283 VSS.n113 0.2444
R533 VSS.n283 VSS.n282 0.2444
R534 VSS.n350 VSS.n114 0.2444
R535 VSS.n239 VSS.n114 0.2444
R536 VSS.n346 VSS.n345 0.209825
R537 VSS.n264 VSS.n252 0.209825
R538 VSS.n271 VSS.n246 0.209825
R539 VSS.n325 VSS.n324 0.209825
R540 VSS.n343 VSS.t3 0.201663
R541 VSS.n341 VSS.t6 0.201663
R542 VSS.n339 VSS.t9 0.201663
R543 VSS.n337 VSS.t12 0.201663
R544 VSS.n335 VSS.t18 0.201663
R545 VSS.n333 VSS.t21 0.201663
R546 VSS.n331 VSS.t24 0.201663
R547 VSS.n329 VSS.t27 0.201663
R548 VSS.n261 VSS.t134 0.201663
R549 VSS.n259 VSS.t131 0.201663
R550 VSS.n257 VSS.t128 0.201663
R551 VSS.n255 VSS.t125 0.201663
R552 VSS.n279 VSS.t119 0.201663
R553 VSS.n277 VSS.t116 0.201663
R554 VSS.n275 VSS.t113 0.201663
R555 VSS.n273 VSS.t110 0.201663
R556 VSS.n51 VSS.t89 0.201663
R557 VSS.t61 VSS.n51 0.201663
R558 VSS.n46 VSS.t91 0.201663
R559 VSS.t64 VSS.n46 0.201663
R560 VSS.n287 VSS.t93 0.201663
R561 VSS.t67 VSS.n287 0.201663
R562 VSS.n286 VSS.t95 0.201663
R563 VSS.t70 VSS.n286 0.201663
R564 VSS.n237 VSS.t99 0.201663
R565 VSS.t76 VSS.n237 0.201663
R566 VSS.n236 VSS.t101 0.201663
R567 VSS.t79 VSS.n236 0.201663
R568 VSS.n48 VSS.t103 0.201663
R569 VSS.t82 VSS.n48 0.201663
R570 VSS.n53 VSS.t105 0.201663
R571 VSS.t85 VSS.n53 0.201663
R572 VSS.n6 VSS.n9 1.3173
R573 VSS.t73 VSS.t97 0.185696
R574 VSS.n347 VSS.n346 0.16242
R575 VSS.n348 VSS.n347 0.16242
R576 VSS.n118 VSS.n348 0.16242
R577 VSS.n116 VSS.n118 0.16242
R578 VSS.n116 VSS.n117 0.16242
R579 VSS.n322 VSS.n117 0.16242
R580 VSS.n323 VSS.n322 0.16242
R581 VSS.n324 VSS.n323 0.16242
R582 VSS.n246 VSS.n245 0.16242
R583 VSS.n245 VSS.n244 0.16242
R584 VSS.n244 VSS.n241 0.16242
R585 VSS.n242 VSS.n241 0.16242
R586 VSS.n242 VSS.n240 0.16242
R587 VSS.n254 VSS.n240 0.16242
R588 VSS.n254 VSS.n253 0.16242
R589 VSS.n253 VSS.n252 0.16242
R590 VSS.n262 VSS.n261 0.147459
R591 VSS.n273 VSS.n272 0.145358
R592 VSS.n344 VSS.n343 0.144129
R593 VSS.n304 VSS.n303 0.117247
R594 VSS.n313 VSS.n312 0.1171
R595 VSS.n343 VSS.n342 0.0952183
R596 VSS.n274 VSS.n273 0.0942639
R597 VSS.n261 VSS.n260 0.093817
R598 VSS.n341 VSS.n340 0.0927738
R599 VSS.n330 VSS.n329 0.0925656
R600 VSS.n276 VSS.n275 0.0915655
R601 VSS.n259 VSS.n258 0.0912432
R602 VSS.n339 VSS.n338 0.0903294
R603 VSS.t15 VSS.n115 0.0903294
R604 VSS.n332 VSS.n331 0.0901212
R605 VSS.t122 VSS.n78 0.0897551
R606 VSS.n278 VSS.n277 0.089375
R607 VSS.t122 VSS.n280 0.0889922
R608 VSS.n257 VSS.n256 0.0884862
R609 VSS.n337 VSS.n336 0.0878849
R610 VSS.n335 VSS.n334 0.0878849
R611 VSS.n336 VSS.t15 0.0876767
R612 VSS.n334 VSS.n333 0.0876767
R613 VSS.n256 VSS.n255 0.0870574
R614 VSS.n280 VSS.n279 0.0865477
R615 VSS.n279 VSS.n278 0.0861674
R616 VSS.n255 VSS.n78 0.0857922
R617 VSS.n333 VSS.n332 0.0854405
R618 VSS.n338 VSS.n337 0.0852323
R619 VSS.n115 VSS.n335 0.0852323
R620 VSS.t53 VSS.n344 0.0847768
R621 VSS.n258 VSS.n257 0.0842923
R622 VSS.n277 VSS.n276 0.0839718
R623 VSS.n272 VSS.t31 0.0834709
R624 VSS.n331 VSS.n330 0.082996
R625 VSS.n340 VSS.n339 0.0827878
R626 VSS.n353 VSS.n113 0.0827273
R627 VSS.n351 VSS.n350 0.0827273
R628 VSS.t35 VSS.n262 0.082293
R629 VSS.n329 VSS.n55 0.148049
R630 VSS.n260 VSS.n259 0.0817198
R631 VSS.n305 VSS.n304 0.08146
R632 VSS.n306 VSS.n305 0.08146
R633 VSS.n307 VSS.n306 0.08146
R634 VSS.n308 VSS.n307 0.08146
R635 VSS.n309 VSS.n308 0.08146
R636 VSS.n310 VSS.n309 0.08146
R637 VSS.n311 VSS.n310 0.08146
R638 VSS.n312 VSS.n311 0.08146
R639 VSS.n275 VSS.n274 0.0812785
R640 VSS.n342 VSS.n341 0.0803434
R641 VSS.t41 VSS.n0 1.05169
R642 VSS.n352 VSS 0.0445
R643 VSS.n238 VSS 0.0445
R644 VSS.n242 VSS.t122 0.0394179
R645 VSS.t15 VSS.n116 0.0394179
R646 VSS.n349 VSS.n116 0.0389615
R647 VSS.n281 VSS.n242 0.0389615
R648 VSS.t49 VSS.n297 0.031258
R649 VSS.n290 VSS.t42 0.031258
R650 VSS.t51 VSS.n294 0.031258
R651 VSS.n303 VSS.n302 0.0291125
R652 VSS.n313 VSS.n234 0.0291125
R653 VSS.n317 VSS.n313 0.0291125
R654 VSS.n303 VSS.n288 0.0291125
R655 VSS.n302 VSS.n289 0.0281144
R656 VSS.n295 VSS.n234 0.0281144
R657 VSS.n318 VSS.n317 0.0281144
R658 VSS.n298 VSS.n288 0.0281144
R659 VSS.n314 VSS.n233 0.0216549
R660 VSS.n315 VSS.t45 0.0208704
R661 VSS.n296 VSS.n291 0.0202884
R662 VSS.n301 VSS.n300 0.0202884
R663 VSS.n316 VSS.n315 0.0202884
R664 VSS.n293 VSS.n292 0.0202884
R665 VSS.n308 VSS.n284 0.0197308
R666 VSS.n308 VSS.t97 0.019449
R667 VSS.n233 VSS.n123 0.0162424
R668 VSS.n328 VSS.t56 0.0133922
R669 VSS.t53 VSS.n111 0.0133922
R670 VSS.t35 VSS.n263 0.0133922
R671 VSS.t31 VSS.n243 0.0133922
R672 VSS.n231 VSS.n124 0.0118857
R673 VSS.n126 VSS.n124 0.0118857
R674 VSS.n129 VSS.n127 0.0118857
R675 VSS.n132 VSS.n130 0.0118857
R676 VSS.n53 VSS.n52 0.00668917
R677 VSS.n226 VSS.n224 0.0118857
R678 VSS.n48 VSS.n47 0.00668928
R679 VSS.n217 VSS.n216 0.0118857
R680 VSS.n146 VSS.n145 0.0118857
R681 VSS.n209 VSS.n207 0.0118857
R682 VSS.n204 VSS.n202 0.0118857
R683 VSS.n157 VSS.n156 0.0118857
R684 VSS.n161 VSS.n160 0.0118857
R685 VSS.n163 VSS.n161 0.0118857
R686 VSS.n193 VSS.n165 0.0118857
R687 VSS.n167 VSS.n165 0.0118857
R688 VSS.n169 VSS.n168 0.0118857
R689 VSS.n45 VSS.n44 0.0173885
R690 VSS.n51 VSS.n50 0.00668917
R691 VSS.n175 VSS.n174 0.0118857
R692 VSS.n178 VSS.n176 0.0118857
R693 VSS.n181 VSS.n179 0.0118857
R694 VSS.n183 VSS.n182 0.0118857
R695 VSS.n182 VSS.n181 0.0118857
R696 VSS.n179 VSS.n178 0.0118857
R697 VSS.n176 VSS.n175 0.0118857
R698 VSS.n44 VSS.n169 0.0118857
R699 VSS.n168 VSS.n167 0.0118857
R700 VSS.n160 VSS.n158 0.0118857
R701 VSS.n158 VSS.n157 0.0118857
R702 VSS.n198 VSS.n156 0.0118857
R703 VSS.n202 VSS.n201 0.0118857
R704 VSS.n11 VSS.t97 0.00653296
R705 VSS.n149 VSS.n147 0.0118857
R706 VSS.n147 VSS.n146 0.0118857
R707 VSS.n142 VSS.n140 0.0118857
R708 VSS.n140 VSS.n39 0.0470081
R709 VSS.n134 VSS.n133 0.0118857
R710 VSS.n133 VSS.n132 0.0118857
R711 VSS.n130 VSS.n129 0.0118857
R712 VSS.n127 VSS.n126 0.0118857
R713 VSS.n299 VSS.n291 0.0115582
R714 VSS.n300 VSS.n299 0.0115582
R715 VSS.n293 VSS.n233 0.0112672
R716 VSS.n75 VSS.n56 0.00253296
R717 VSS.n75 VSS.n57 0.0112168
R718 VSS.n75 VSS.n58 0.0112168
R719 VSS.n75 VSS.n59 0.0112168
R720 VSS.n75 VSS.n60 0.0112168
R721 VSS.n75 VSS.n61 0.0112168
R722 VSS.n75 VSS.n62 0.0112168
R723 VSS.n75 VSS.n63 0.0112168
R724 VSS.n75 VSS.n64 0.0112168
R725 VSS.n75 VSS.n66 0.0112168
R726 VSS.n75 VSS.n67 0.0112168
R727 VSS.n75 VSS.n68 0.0112168
R728 VSS.n75 VSS.n69 0.0112168
R729 VSS.n75 VSS.n70 0.0112168
R730 VSS.n75 VSS.n71 0.0112168
R731 VSS.n75 VSS.n72 0.0112168
R732 VSS.n75 VSS.n73 0.0112168
R733 VSS.n75 VSS.n74 0.0112168
R734 VSS.n79 VSS.t136 11.4002
R735 VSS.n49 VSS.n187 0.0108889
R736 VSS.n203 VSS.n154 0.0108889
R737 VSS.n208 VSS.n151 0.0108889
R738 VSS.n215 VSS.n214 0.0108889
R739 VSS.n222 VSS.n221 0.0108889
R740 VSS.n225 VSS.n136 0.0108889
R741 VSS.n297 VSS.n296 0.0108877
R742 VSS.n301 VSS.n290 0.0108877
R743 VSS.n316 VSS.n314 0.0108877
R744 VSS.n294 VSS.n292 0.0108877
R745 VSS.t46 VSS.n233 0.0101032
R746 VSS.t52 VSS.n233 0.0101032
R747 VSS.n299 VSS.t48 0.00981217
R748 VSS.n299 VSS.t41 0.00981217
R749 VSS.n75 VSS.n65 0.00963963
R750 VSS VSS.n353 0.0095
R751 VSS.n351 VSS 0.0095
R752 VSS.n55 VSS.t56 0.0818274
R753 VSS.n326 VSS.n119 0.00798582
R754 VSS.n326 VSS.n10 0.0150235
R755 VSS.n122 VSS.n8 0.00798582
R756 VSS.n9 VSS.n8 0.0150056
R757 VSS.n265 VSS.n249 0.00798582
R758 VSS.n265 VSS.n251 0.00798582
R759 VSS.n270 VSS.n248 0.00798582
R760 VSS.n270 VSS.n247 0.00798582
R761 VSS.n328 VSS.n327 0.00756994
R762 VSS.n327 VSS.n119 0.00756994
R763 VSS.n321 VSS.n10 0.00152954
R764 VSS.n121 VSS.n111 0.00756994
R765 VSS.n122 VSS.n121 0.00756994
R766 VSS.n120 VSS.n9 0.00154742
R767 VSS.n266 VSS.n249 0.00756994
R768 VSS.n251 VSS.n250 0.00756994
R769 VSS.n263 VSS.n250 0.00756994
R770 VSS.n268 VSS.n248 0.00756994
R771 VSS.n269 VSS.n247 0.00756994
R772 VSS.n269 VSS.n243 0.00756994
R773 VSS.n287 VSS.n164 0.00691667
R774 VSS.n236 VSS.n235 0.00691667
R775 VSS.n299 VSS.n184 0.00630556
R776 VSS.n285 VSS.n201 0.00619286
R777 VSS.n143 VSS.n142 0.00619286
R778 VSS.n150 VSS.n149 0.00619286
R779 VSS.n210 VSS.n151 0.00619286
R780 VSS.n199 VSS.n198 0.00619286
R781 VSS.n184 VSS.n183 0.00619286
R782 VSS.n187 VSS.n174 0.00619286
R783 VSS.n50 VSS.n49 0.0123818
R784 VSS.n46 VSS.n45 0.00600277
R785 VSS.n194 VSS.n193 0.00619286
R786 VSS.n164 VSS.n163 0.00619286
R787 VSS.n204 VSS.n203 0.00619286
R788 VSS.n154 VSS.n12 0.046732
R789 VSS.n209 VSS.n208 0.00619286
R790 VSS.n211 VSS.n210 0.00619286
R791 VSS.n214 VSS.n145 0.00619286
R792 VSS.n216 VSS.n215 0.00619286
R793 VSS.n235 VSS.n217 0.00619286
R794 VSS.n224 VSS.n222 0.00619286
R795 VSS.n226 VSS.n225 0.00619286
R796 VSS.n54 VSS.n136 0.0180638
R797 VSS.n232 VSS.n231 0.00619286
R798 VSS.n233 VSS.n232 0.00615278
R799 VSS.n286 VSS.n199 0.00569444
R800 VSS.n286 VSS.n285 0.00569444
R801 VSS.n237 VSS.n211 0.00569444
R802 VSS.n237 VSS.n150 0.00569444
R803 VSS.n75 VSS.n79 0.00482001
R804 VSS.n287 VSS.n194 0.00447222
R805 VSS.n236 VSS.n143 0.00447222
R806 VSS.n267 VSS.n75 0.00421062
R807 VSS.n76 VSS.n320 6777.49
R808 VSS.n0 VSS.n24 1.50747
C0 vin4 vin3 0.05053f
C1 vin2 vin3 0.05785f
C2 vout2 VDD 15.3834f
C3 vin1 VDD 29.2329f
C4 vin4 VDD 29.2329f
C5 vout1 VDD 15.3949f
C6 VDD vin2 29.202f
C7 VDD vout4 15.3949f
C8 vin3 vout3 18.2968f
C9 VDD vin3 29.202f
C10 vin1 vout1 18.2968f
C11 vout2 vin2 18.2968f
C12 vin1 vin2 0.05053f
C13 VDD vout3 15.3834f
C14 vin4 vout4 18.2968f
C15 vout1 VSS 13.57609f
C16 vout2 VSS 13.55759f
C17 vout3 VSS 13.55759f
C18 vout4 VSS 13.57609f
C19 VSS.t105 VSS 8.00945f
C20 VSS.t24 VSS 8.0271f
C21 VSS.t76 VSS 8.00945f
.ends

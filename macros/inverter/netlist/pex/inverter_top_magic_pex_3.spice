* PEX produced on Wed Jul 29 01:28:37 AM CEST 2026 using /foss/tools/sak/sak-pex.sh with m=3 and s=1 (extresist threshold=10000 mOhm, minres=1000 mOhm, mindelay=1 ps)
* NGSPICE file created from inverter_top_pex.ext - technology: ihp-sg13g2

.subckt inverter_top_pex VDD vin4 vout4 VSS vin3 vout3 vin2 vout2 vout1 vin1
X0 vout3 vin3 VSS.t99 VSS.t80 sg13_lv_nmos ad=0.19p pd=1.38u as=0.19p ps=1.38u w=1u l=1u
X1 VDD VDD VDD VDD sg13_lv_pmos ad=1.14p pd=6.38u as=0.56797n ps=1.006m w=6u l=1u
X2 VSS.t1 VSS.t47 VSS.t49 VSS.t48 sg13_lv_nmos ad=0.34p pd=2.68u as=0 ps=0 w=1u l=1u
X3 VDD VDD VDD VDD sg13_lv_pmos ad=1.14p pd=6.38u as=0 ps=0 w=6u l=1u
X4 VDD vin4 vout4 VDD sg13_lv_pmos ad=1.14p pd=6.38u as=1.14p ps=6.38u w=6u l=1u
X5 vout2 vin2 VSS.t70 VSS.t71 sg13_lv_nmos ad=0.19p pd=1.38u as=0.19p ps=1.38u w=1u l=1u
X6 vout3 vin3 VDD VDD sg13_lv_pmos ad=1.14p pd=6.38u as=1.14p ps=6.38u w=6u l=1u
X7 vout4 vin4 VSS.t29 VSS.t104 sg13_lv_nmos ad=0.19p pd=1.38u as=0.19p ps=1.38u w=1u l=1u
X8 vout3 vin3 VSS.t38 VSS.t53 sg13_lv_nmos ad=0.19p pd=1.38u as=0.19p ps=1.38u w=1u l=1u
X9 vout2 vin2 VSS.t64 VSS.t65 sg13_lv_nmos ad=0.19p pd=1.38u as=0.19p ps=1.38u w=1u l=1u
X10 vout4 vin4 VDD VDD sg13_lv_pmos ad=1.14p pd=6.38u as=1.14p ps=6.38u w=6u l=1u
X11 VDD vin2 vout2 VDD sg13_lv_pmos ad=1.14p pd=6.38u as=1.14p ps=6.38u w=6u l=1u
X12 VSS.t70 vin2 vout2 VSS.t69 sg13_lv_nmos ad=0.19p pd=1.38u as=0.19p ps=1.38u w=1u l=1u
X13 vout2 vin2 VSS.t73 VSS.t74 sg13_lv_nmos ad=0.19p pd=1.38u as=0.19p ps=1.38u w=1u l=1u
X14 vout2 vin2 VDD VDD sg13_lv_pmos ad=1.14p pd=6.38u as=1.14p ps=6.38u w=6u l=1u
X15 VSS.t29 vin4 vout4 VSS.t107 sg13_lv_nmos ad=0.19p pd=1.38u as=0.19p ps=1.38u w=1u l=1u
X16 vout1 vin1 VSS.t21 VSS.t24 sg13_lv_nmos ad=0.19p pd=1.38u as=0.19p ps=1.38u w=1u l=1u
X17 VDD vin2 vout2 VDD sg13_lv_pmos ad=1.14p pd=6.38u as=1.14p ps=6.38u w=6u l=1u
X18 vout4 vin4 VSS.t32 VSS.t102 sg13_lv_nmos ad=0.19p pd=1.38u as=0.19p ps=1.38u w=1u l=1u
X19 VDD vin2 vout2 VDD sg13_lv_pmos ad=1.14p pd=6.38u as=1.14p ps=6.38u w=6u l=1u
X20 VSS.t99 vin3 vout3 VSS.t78 sg13_lv_nmos ad=0.19p pd=1.38u as=0.19p ps=1.38u w=1u l=1u
X21 vout4 vin4 VSS.t115 VSS.t116 sg13_lv_nmos ad=0.19p pd=1.38u as=0.19p ps=1.38u w=1u l=1u
X22 VSS.t110 vin4 vout4 VSS.t109 sg13_lv_nmos ad=0.19p pd=1.38u as=0.19p ps=1.38u w=1u l=1u
X23 VDD vin3 vout3 VDD sg13_lv_pmos ad=1.14p pd=6.38u as=1.14p ps=6.38u w=6u l=1u
X24 VDD vin2 vout2 VDD sg13_lv_pmos ad=1.14p pd=6.38u as=1.14p ps=6.38u w=6u l=1u
X25 vout3 vin3 VDD VDD sg13_lv_pmos ad=1.14p pd=6.38u as=1.14p ps=6.38u w=6u l=1u
X26 VSS.t64 vin2 vout2 VSS.t63 sg13_lv_nmos ad=0.19p pd=1.38u as=0.19p ps=1.38u w=1u l=1u
X27 VDD vin3 vout3 VDD sg13_lv_pmos ad=1.14p pd=6.38u as=1.14p ps=6.38u w=6u l=1u
X28 VSS.t38 VSS.t36 VSS.t38 VSS.t37 sg13_lv_nmos ad=0.34p pd=2.68u as=0 ps=0 w=1u l=1u
X29 vout2 vin2 VDD VDD sg13_lv_pmos ad=1.14p pd=6.38u as=1.14p ps=6.38u w=6u l=1u
X30 vout2 vin2 VSS.t67 VSS.t68 sg13_lv_nmos ad=0.19p pd=1.38u as=0.19p ps=1.38u w=1u l=1u
X31 vout1 vin1 VSS.t18 VSS.t19 sg13_lv_nmos ad=0.19p pd=1.38u as=0.19p ps=1.38u w=1u l=1u
X32 VSS.t73 vin2 vout2 VSS.t72 sg13_lv_nmos ad=0.19p pd=1.38u as=0.19p ps=1.38u w=1u l=1u
X33 vout4 vin4 VSS.t29 VSS.t113 sg13_lv_nmos ad=0.19p pd=1.38u as=0.19p ps=1.38u w=1u l=1u
X34 vout1 vin1 VDD VDD sg13_lv_pmos ad=1.14p pd=6.38u as=1.14p ps=6.38u w=6u l=1u
X35 vout1 vin1 VSS.t12 VSS.t13 sg13_lv_nmos ad=0.19p pd=1.38u as=0.19p ps=1.38u w=1u l=1u
X36 VSS.t118 vin4 vout4 VSS.t117 sg13_lv_nmos ad=0.19p pd=1.38u as=0.19p ps=1.38u w=1u l=1u
X37 VDD VDD VDD VDD sg13_lv_pmos ad=1.14p pd=6.38u as=0 ps=0 w=6u l=1u
X38 VSS.t18 vin1 vout1 VSS.t17 sg13_lv_nmos ad=0.19p pd=1.38u as=0.19p ps=1.38u w=1u l=1u
X39 vout2 vin2 VDD VDD sg13_lv_pmos ad=1.14p pd=6.38u as=1.14p ps=6.38u w=6u l=1u
X40 VDD vin4 vout4 VDD sg13_lv_pmos ad=1.14p pd=6.38u as=1.14p ps=6.38u w=6u l=1u
X41 vout1 vin1 VSS.t21 VSS.t22 sg13_lv_nmos ad=0.19p pd=1.38u as=0.19p ps=1.38u w=1u l=1u
X42 vout3 vin3 VSS.t97 VSS.t77 sg13_lv_nmos ad=0.19p pd=1.38u as=0.19p ps=1.38u w=1u l=1u
X43 VDD vin3 vout3 VDD sg13_lv_pmos ad=1.14p pd=6.38u as=1.14p ps=6.38u w=6u l=1u
X44 vout4 vin4 VDD VDD sg13_lv_pmos ad=1.14p pd=6.38u as=1.14p ps=6.38u w=6u l=1u
X45 VDD vin4 vout4 VDD sg13_lv_pmos ad=1.14p pd=6.38u as=1.14p ps=6.38u w=6u l=1u
X46 vout3 vin3 VDD VDD sg13_lv_pmos ad=1.14p pd=6.38u as=1.14p ps=6.38u w=6u l=1u
X47 VDD vin3 vout3 VDD sg13_lv_pmos ad=1.14p pd=6.38u as=1.14p ps=6.38u w=6u l=1u
X48 VSS.t35 VSS.t29 VSS.t34 VSS.t33 sg13_lv_nmos ad=0.19p pd=1.38u as=0 ps=0 w=1u l=1u
X49 VDD vin4 vout4 VDD sg13_lv_pmos ad=1.14p pd=6.38u as=1.14p ps=6.38u w=6u l=1u
X50 VDD vin2 vout2 VDD sg13_lv_pmos ad=1.14p pd=6.38u as=1.14p ps=6.38u w=6u l=1u
X51 VSS.t121 vin4 vout4 VSS.t120 sg13_lv_nmos ad=0.19p pd=1.38u as=0.19p ps=1.38u w=1u l=1u
X52 VDD vin3 vout3 VDD sg13_lv_pmos ad=1.14p pd=6.38u as=1.14p ps=6.38u w=6u l=1u
X53 VSS.t12 vin1 vout1 VSS.t11 sg13_lv_nmos ad=0.19p pd=1.38u as=0.19p ps=1.38u w=1u l=1u
X54 VDD vin1 vout1 VDD sg13_lv_pmos ad=1.14p pd=6.38u as=1.14p ps=6.38u w=6u l=1u
X55 vout4 vin4 VSS.t124 VSS.t125 sg13_lv_nmos ad=0.19p pd=1.38u as=0.19p ps=1.38u w=1u l=1u
X56 vout1 vin1 VDD VDD sg13_lv_pmos ad=1.14p pd=6.38u as=1.14p ps=6.38u w=6u l=1u
X57 vout4 vin4 VDD VDD sg13_lv_pmos ad=1.14p pd=6.38u as=1.14p ps=6.38u w=6u l=1u
X58 vout1 vin1 VSS.t15 VSS.t16 sg13_lv_nmos ad=0.19p pd=1.38u as=0.19p ps=1.38u w=1u l=1u
X59 VDD vin1 vout1 VDD sg13_lv_pmos ad=1.14p pd=6.38u as=1.14p ps=6.38u w=6u l=1u
X60 vout3 vin3 VSS.t93 VSS.t71 sg13_lv_nmos ad=0.19p pd=1.38u as=0.19p ps=1.38u w=1u l=1u
X61 VSS.t21 vin1 vout1 VSS.t20 sg13_lv_nmos ad=0.19p pd=1.38u as=0.19p ps=1.38u w=1u l=1u
X62 VDD VDD VDD VDD sg13_lv_pmos ad=2.04p pd=12.68u as=0 ps=0 w=6u l=1u
X63 vout4 vin4 VDD VDD sg13_lv_pmos ad=1.14p pd=6.38u as=1.14p ps=6.38u w=6u l=1u
X64 VDD vin3 vout3 VDD sg13_lv_pmos ad=1.14p pd=6.38u as=1.14p ps=6.38u w=6u l=1u
X65 VDD vin4 vout4 VDD sg13_lv_pmos ad=1.14p pd=6.38u as=1.14p ps=6.38u w=6u l=1u
X66 vout3 vin3 VDD VDD sg13_lv_pmos ad=1.14p pd=6.38u as=1.14p ps=6.38u w=6u l=1u
X67 vout3 vin3 VSS.t89 VSS.t65 sg13_lv_nmos ad=0.19p pd=1.38u as=0.19p ps=1.38u w=1u l=1u
X68 VSS.t93 vin3 vout3 VSS.t69 sg13_lv_nmos ad=0.19p pd=1.38u as=0.19p ps=1.38u w=1u l=1u
X69 VDD VDD VDD VDD sg13_lv_pmos ad=1.14p pd=6.38u as=0 ps=0 w=6u l=1u
X70 vout3 vin3 VSS.t95 VSS.t74 sg13_lv_nmos ad=0.19p pd=1.38u as=0.19p ps=1.38u w=1u l=1u
X71 vout4 vin4 VDD VDD sg13_lv_pmos ad=1.14p pd=6.38u as=1.14p ps=6.38u w=6u l=1u
X72 vout3 vin3 VDD VDD sg13_lv_pmos ad=1.14p pd=6.38u as=1.14p ps=6.38u w=6u l=1u
X73 VDD vin1 vout1 VDD sg13_lv_pmos ad=1.14p pd=6.38u as=1.14p ps=6.38u w=6u l=1u
X74 vout2 vin2 VDD VDD sg13_lv_pmos ad=1.14p pd=6.38u as=1.14p ps=6.38u w=6u l=1u
X75 vout1 vin1 VDD VDD sg13_lv_pmos ad=1.14p pd=6.38u as=1.14p ps=6.38u w=6u l=1u
X76 vout2 vin2 VSS.t58 VSS.t59 sg13_lv_nmos ad=0.19p pd=1.38u as=0.19p ps=1.38u w=1u l=1u
X77 VDD vin1 vout1 VDD sg13_lv_pmos ad=1.14p pd=6.38u as=1.14p ps=6.38u w=6u l=1u
X78 VDD vin1 vout1 VDD sg13_lv_pmos ad=1.14p pd=6.38u as=1.14p ps=6.38u w=6u l=1u
X79 VDD vin3 vout3 VDD sg13_lv_pmos ad=1.14p pd=6.38u as=1.14p ps=6.38u w=6u l=1u
X80 VSS.t89 vin3 vout3 VSS.t63 sg13_lv_nmos ad=0.19p pd=1.38u as=0.19p ps=1.38u w=1u l=1u
X81 vout3 vin3 VSS.t91 VSS.t68 sg13_lv_nmos ad=0.19p pd=1.38u as=0.19p ps=1.38u w=1u l=1u
X82 VSS.t29 vin4 vout4 VSS.t105 sg13_lv_nmos ad=0.19p pd=1.38u as=0.19p ps=1.38u w=1u l=1u
X83 VDD vin4 vout4 VDD sg13_lv_pmos ad=1.14p pd=6.38u as=1.14p ps=6.38u w=6u l=1u
X84 VSS.t95 vin3 vout3 VSS.t72 sg13_lv_nmos ad=0.19p pd=1.38u as=0.19p ps=1.38u w=1u l=1u
X85 vout4 vin4 VSS.t29 VSS.t108 sg13_lv_nmos ad=0.19p pd=1.38u as=0.19p ps=1.38u w=1u l=1u
X86 VDD vin1 vout1 VDD sg13_lv_pmos ad=1.14p pd=6.38u as=1.14p ps=6.38u w=6u l=1u
X87 vout2 vin2 VDD VDD sg13_lv_pmos ad=1.14p pd=6.38u as=1.14p ps=6.38u w=6u l=1u
X88 vout1 vin1 VDD VDD sg13_lv_pmos ad=1.14p pd=6.38u as=1.14p ps=6.38u w=6u l=1u
X89 VSS.t29 vin4 vout4 VSS.t103 sg13_lv_nmos ad=0.19p pd=1.38u as=0.19p ps=1.38u w=1u l=1u
X90 VDD VDD VDD VDD sg13_lv_pmos ad=2.04p pd=12.68u as=0 ps=0 w=6u l=1u
X91 vout2 vin2 VDD VDD sg13_lv_pmos ad=1.14p pd=6.38u as=1.14p ps=6.38u w=6u l=1u
X92 VDD vin2 vout2 VDD sg13_lv_pmos ad=1.14p pd=6.38u as=1.14p ps=6.38u w=6u l=1u
X93 VSS.t58 vin2 vout2 VSS.t57 sg13_lv_nmos ad=0.19p pd=1.38u as=0.19p ps=1.38u w=1u l=1u
X94 VSS.t29 vin4 vout4 VSS.t112 sg13_lv_nmos ad=0.19p pd=1.38u as=0.19p ps=1.38u w=1u l=1u
X95 vout2 vin2 VDD VDD sg13_lv_pmos ad=1.14p pd=6.38u as=1.14p ps=6.38u w=6u l=1u
X96 VDD VDD VDD VDD sg13_lv_pmos ad=2.04p pd=12.68u as=0 ps=0 w=6u l=1u
X97 vout2 vin2 VSS.t61 VSS.t62 sg13_lv_nmos ad=0.19p pd=1.38u as=0.19p ps=1.38u w=1u l=1u
X98 VSS.t67 vin2 vout2 VSS.t66 sg13_lv_nmos ad=0.19p pd=1.38u as=0.19p ps=1.38u w=1u l=1u
X99 vout1 vin1 VDD VDD sg13_lv_pmos ad=1.14p pd=6.38u as=1.14p ps=6.38u w=6u l=1u
X100 vout1 vin1 VSS.t6 VSS.t7 sg13_lv_nmos ad=0.19p pd=1.38u as=0.19p ps=1.38u w=1u l=1u
X101 vout4 vin4 VSS.t110 VSS.t111 sg13_lv_nmos ad=0.19p pd=1.38u as=0.19p ps=1.38u w=1u l=1u
X102 vout3 vin3 VDD VDD sg13_lv_pmos ad=1.14p pd=6.38u as=1.14p ps=6.38u w=6u l=1u
X103 vout4 vin4 VSS.t121 VSS.t122 sg13_lv_nmos ad=0.19p pd=1.38u as=0.19p ps=1.38u w=1u l=1u
X104 VSS.t42 VSS.t45 VSS.t46 VSS.t40 sg13_lv_nmos ad=0.19p pd=1.38u as=0 ps=0 w=1u l=1u
X105 VSS.t115 vin4 vout4 VSS.t114 sg13_lv_nmos ad=0.19p pd=1.38u as=0.19p ps=1.38u w=1u l=1u
X106 VDD vin1 vout1 VDD sg13_lv_pmos ad=1.14p pd=6.38u as=1.14p ps=6.38u w=6u l=1u
X107 VSS.t46 vin2 vout2 VSS.t81 sg13_lv_nmos ad=0.19p pd=1.38u as=0.19p ps=1.38u w=1u l=1u
X108 VDD vin2 vout2 VDD sg13_lv_pmos ad=1.14p pd=6.38u as=1.14p ps=6.38u w=6u l=1u
X109 vout4 vin4 VSS.t118 VSS.t119 sg13_lv_nmos ad=0.19p pd=1.38u as=0.19p ps=1.38u w=1u l=1u
X110 vout4 vin4 VDD VDD sg13_lv_pmos ad=1.14p pd=6.38u as=1.14p ps=6.38u w=6u l=1u
X111 vout2 vin2 VDD VDD sg13_lv_pmos ad=1.14p pd=6.38u as=1.14p ps=6.38u w=6u l=1u
X112 vout2 vin2 VSS.t55 VSS.t56 sg13_lv_nmos ad=0.19p pd=1.38u as=0.19p ps=1.38u w=1u l=1u
X113 VDD vin2 vout2 VDD sg13_lv_pmos ad=1.14p pd=6.38u as=1.14p ps=6.38u w=6u l=1u
X114 VSS.t61 vin2 vout2 VSS.t60 sg13_lv_nmos ad=0.19p pd=1.38u as=0.19p ps=1.38u w=1u l=1u
X115 VDD vin4 vout4 VDD sg13_lv_pmos ad=1.14p pd=6.38u as=1.14p ps=6.38u w=6u l=1u
X116 VDD VDD VDD VDD sg13_lv_pmos ad=2.04p pd=12.68u as=0 ps=0 w=6u l=1u
X117 VSS.t55 vin2 vout2 VSS.t54 sg13_lv_nmos ad=0.19p pd=1.38u as=0.19p ps=1.38u w=1u l=1u
X118 VSS.t6 vin1 vout1 VSS.t5 sg13_lv_nmos ad=0.19p pd=1.38u as=0.19p ps=1.38u w=1u l=1u
X119 vout3 vin3 VDD VDD sg13_lv_pmos ad=1.14p pd=6.38u as=1.14p ps=6.38u w=6u l=1u
X120 vout1 vin1 VSS.t9 VSS.t10 sg13_lv_nmos ad=0.19p pd=1.38u as=0.19p ps=1.38u w=1u l=1u
X121 VSS.t15 vin1 vout1 VSS.t14 sg13_lv_nmos ad=0.19p pd=1.38u as=0.19p ps=1.38u w=1u l=1u
X122 vout3 vin3 VDD VDD sg13_lv_pmos ad=1.14p pd=6.38u as=1.14p ps=6.38u w=6u l=1u
X123 VDD vin3 vout3 VDD sg13_lv_pmos ad=1.14p pd=6.38u as=1.14p ps=6.38u w=6u l=1u
X124 vout3 vin3 VDD VDD sg13_lv_pmos ad=1.14p pd=6.38u as=1.14p ps=6.38u w=6u l=1u
X125 vout3 vin3 VSS.t85 VSS.t59 sg13_lv_nmos ad=0.19p pd=1.38u as=0.19p ps=1.38u w=1u l=1u
X126 VSS.t76 vin2 vout2 VSS.t75 sg13_lv_nmos ad=0.19p pd=1.38u as=0.19p ps=1.38u w=1u l=1u
X127 vout1 vin1 VDD VDD sg13_lv_pmos ad=1.14p pd=6.38u as=1.14p ps=6.38u w=6u l=1u
X128 vout2 vin2 VSS.t79 VSS.t80 sg13_lv_nmos ad=0.19p pd=1.38u as=0.19p ps=1.38u w=1u l=1u
X129 VSS.t34 vin4 vout4 VSS.t126 sg13_lv_nmos ad=0.19p pd=1.38u as=0.19p ps=1.38u w=1u l=1u
X130 VSS.t52 VSS.t21 VSS.t28 VSS.t50 sg13_lv_nmos ad=0.19p pd=1.38u as=0 ps=0 w=1u l=1u
X131 VSS.t28 vin1 vout1 VSS.t27 sg13_lv_nmos ad=0.19p pd=1.38u as=0.19p ps=1.38u w=1u l=1u
X132 vout2 vin2 VSS.t38 VSS.t53 sg13_lv_nmos ad=0.19p pd=1.38u as=0.19p ps=1.38u w=1u l=1u
X133 VSS.t32 VSS.t29 VSS.t31 VSS.t30 sg13_lv_nmos ad=0.34p pd=2.68u as=0 ps=0 w=1u l=1u
X134 vout1 vin1 VSS.t3 VSS.t4 sg13_lv_nmos ad=0.19p pd=1.38u as=0.19p ps=1.38u w=1u l=1u
X135 VSS.t9 vin1 vout1 VSS.t8 sg13_lv_nmos ad=0.19p pd=1.38u as=0.19p ps=1.38u w=1u l=1u
X136 VDD vin3 vout3 VDD sg13_lv_pmos ad=1.14p pd=6.38u as=1.14p ps=6.38u w=6u l=1u
X137 VSS.t3 vin1 vout1 VSS.t2 sg13_lv_nmos ad=0.19p pd=1.38u as=0.19p ps=1.38u w=1u l=1u
X138 vout4 vin4 VDD VDD sg13_lv_pmos ad=1.14p pd=6.38u as=1.14p ps=6.38u w=6u l=1u
X139 vout3 vin3 VDD VDD sg13_lv_pmos ad=1.14p pd=6.38u as=1.14p ps=6.38u w=6u l=1u
X140 VDD vin3 vout3 VDD sg13_lv_pmos ad=1.14p pd=6.38u as=1.14p ps=6.38u w=6u l=1u
X141 VSS.t85 vin3 vout3 VSS.t57 sg13_lv_nmos ad=0.19p pd=1.38u as=0.19p ps=1.38u w=1u l=1u
X142 vout3 vin3 VSS.t87 VSS.t62 sg13_lv_nmos ad=0.19p pd=1.38u as=0.19p ps=1.38u w=1u l=1u
X143 vout1 vin1 VDD VDD sg13_lv_pmos ad=1.14p pd=6.38u as=1.14p ps=6.38u w=6u l=1u
X144 VSS.t79 vin2 vout2 VSS.t78 sg13_lv_nmos ad=0.19p pd=1.38u as=0.19p ps=1.38u w=1u l=1u
X145 VSS.t91 vin3 vout3 VSS.t66 sg13_lv_nmos ad=0.19p pd=1.38u as=0.19p ps=1.38u w=1u l=1u
X146 VDD vin4 vout4 VDD sg13_lv_pmos ad=1.14p pd=6.38u as=1.14p ps=6.38u w=6u l=1u
X147 vout1 vin1 VDD VDD sg13_lv_pmos ad=1.14p pd=6.38u as=1.14p ps=6.38u w=6u l=1u
X148 VDD vin1 vout1 VDD sg13_lv_pmos ad=1.14p pd=6.38u as=1.14p ps=6.38u w=6u l=1u
X149 vout4 vin4 VDD VDD sg13_lv_pmos ad=1.14p pd=6.38u as=1.14p ps=6.38u w=6u l=1u
X150 VSS.t21 vin1 vout1 VSS.t23 sg13_lv_nmos ad=0.19p pd=1.38u as=0.19p ps=1.38u w=1u l=1u
X151 vout1 vin1 VSS.t21 VSS.t26 sg13_lv_nmos ad=0.19p pd=1.38u as=0.19p ps=1.38u w=1u l=1u
X152 vout1 vin1 VDD VDD sg13_lv_pmos ad=1.14p pd=6.38u as=1.14p ps=6.38u w=6u l=1u
X153 vout2 vin2 VDD VDD sg13_lv_pmos ad=1.14p pd=6.38u as=1.14p ps=6.38u w=6u l=1u
X154 vout4 vin4 VSS.t29 VSS.t106 sg13_lv_nmos ad=0.19p pd=1.38u as=0.19p ps=1.38u w=1u l=1u
X155 VSS.t38 VSS.t43 VSS.t38 VSS.t37 sg13_lv_nmos ad=0.34p pd=2.68u as=0 ps=0 w=1u l=1u
X156 VSS.t42 VSS.t39 VSS.t41 VSS.t40 sg13_lv_nmos ad=0.19p pd=1.38u as=0 ps=0 w=1u l=1u
X157 vout4 vin4 VDD VDD sg13_lv_pmos ad=1.14p pd=6.38u as=1.14p ps=6.38u w=6u l=1u
X158 VSS.t41 vin3 vout3 VSS.t81 sg13_lv_nmos ad=0.19p pd=1.38u as=0.19p ps=1.38u w=1u l=1u
X159 VSS.t124 vin4 vout4 VSS.t123 sg13_lv_nmos ad=0.19p pd=1.38u as=0.19p ps=1.38u w=1u l=1u
X160 VDD vin4 vout4 VDD sg13_lv_pmos ad=1.14p pd=6.38u as=1.14p ps=6.38u w=6u l=1u
X161 vout1 vin1 VSS.t1 VSS.t0 sg13_lv_nmos ad=0.19p pd=1.38u as=0.19p ps=1.38u w=1u l=1u
X162 vout3 vin3 VSS.t83 VSS.t56 sg13_lv_nmos ad=0.19p pd=1.38u as=0.19p ps=1.38u w=1u l=1u
X163 VSS.t87 vin3 vout3 VSS.t60 sg13_lv_nmos ad=0.19p pd=1.38u as=0.19p ps=1.38u w=1u l=1u
X164 vout4 vin4 VDD VDD sg13_lv_pmos ad=1.14p pd=6.38u as=1.14p ps=6.38u w=6u l=1u
X165 vout2 vin2 VSS.t76 VSS.t77 sg13_lv_nmos ad=0.19p pd=1.38u as=0.19p ps=1.38u w=1u l=1u
X166 VSS.t83 vin3 vout3 VSS.t54 sg13_lv_nmos ad=0.19p pd=1.38u as=0.19p ps=1.38u w=1u l=1u
X167 VDD vin1 vout1 VDD sg13_lv_pmos ad=1.14p pd=6.38u as=1.14p ps=6.38u w=6u l=1u
X168 vout1 vin1 VDD VDD sg13_lv_pmos ad=1.14p pd=6.38u as=1.14p ps=6.38u w=6u l=1u
X169 VDD vin1 vout1 VDD sg13_lv_pmos ad=1.14p pd=6.38u as=1.14p ps=6.38u w=6u l=1u
X170 VDD vin4 vout4 VDD sg13_lv_pmos ad=1.14p pd=6.38u as=1.14p ps=6.38u w=6u l=1u
X171 VSS.t21 vin1 vout1 VSS.t25 sg13_lv_nmos ad=0.19p pd=1.38u as=0.19p ps=1.38u w=1u l=1u
X172 VDD vin2 vout2 VDD sg13_lv_pmos ad=1.14p pd=6.38u as=1.14p ps=6.38u w=6u l=1u
X173 vout2 vin2 VDD VDD sg13_lv_pmos ad=1.14p pd=6.38u as=1.14p ps=6.38u w=6u l=1u
X174 VDD vin2 vout2 VDD sg13_lv_pmos ad=1.14p pd=6.38u as=1.14p ps=6.38u w=6u l=1u
X175 VSS.t97 vin3 vout3 VSS.t75 sg13_lv_nmos ad=0.19p pd=1.38u as=0.19p ps=1.38u w=1u l=1u
R0 VSS.t29 VSS.n143 6777.49
R1 VSS.n196 VSS.t29 6777.49
R2 VSS.n196 VSS.n195 1580.41
R3 VSS.n194 VSS.n143 1580.41
R4 VSS.n194 VSS.t38 1.5351
R5 VSS.t53 VSS.n157 88.7251
R6 VSS.n94 VSS.t81 88.7251
R7 VSS.t54 VSS.n156 83.1798
R8 VSS.t80 VSS.n171 83.1798
R9 VSS.t56 VSS.n155 77.6345
R10 VSS.n170 VSS.t78 77.6345
R11 VSS.t29 VSS.t126 9.76925
R12 VSS.n131 VSS.t57 72.0892
R13 VSS.n101 VSS.t77 72.0892
R14 VSS.t29 VSS.t102 9.77299
R15 VSS.t59 VSS.n128 66.5439
R16 VSS.t75 VSS.n169 66.5439
R17 VSS.t125 VSS.t29 12.2976
R18 VSS.t29 VSS.t103 12.3005
R19 VSS.t60 VSS.n154 60.9987
R20 VSS.n168 VSS.t74 60.9987
R21 VSS.t29 VSS.t104 14.4672
R22 VSS.t122 VSS.t29 16.2707
R23 VSS.t26 VSS.n70 64.5216
R24 VSS.n123 VSS.t62 55.4534
R25 VSS.n164 VSS.t66 55.4534
R26 VSS.n114 VSS.t68 55.4534
R27 VSS.n167 VSS.t72 55.4534
R28 VSS.t25 VSS.n72 60.7265
R29 VSS.t63 VSS.n153 49.9081
R30 VSS.n163 VSS.t65 49.9081
R31 VSS.t69 VSS.n150 49.9081
R32 VSS.n166 VSS.t71 49.9081
R33 VSS.t119 VSS.t29 18.799
R34 VSS.t29 VSS.t107 18.8
R35 VSS.t24 VSS.n88 56.932
R36 VSS.t117 VSS.t29 19.5212
R37 VSS.t112 VSS.t29 19.5199
R38 VSS.t29 VSS.t113 19.5235
R39 VSS.t23 VSS.n76 53.137
R40 VSS.n121 VSS.t63 44.3628
R41 VSS.t65 VSS.n152 44.3628
R42 VSS.n112 VSS.t69 44.3628
R43 VSS.t71 VSS.n149 44.3628
R44 VSS.t116 VSS.t29 19.8823
R45 VSS.t29 VSS.t109 19.9162
R46 VSS.t22 VSS.n73 49.3419
R47 VSS.t62 VSS.n162 38.8175
R48 VSS.t66 VSS.n151 38.8175
R49 VSS.t68 VSS.n165 38.8175
R50 VSS.t72 VSS.n148 38.8175
R51 VSS.t20 VSS.n83 45.5476
R52 VSS.t108 VSS.t29 19.5219
R53 VSS.t13 VSS.n89 41.7518
R54 VSS.t19 VSS.n91 41.7518
R55 VSS.n126 VSS.t60 33.2722
R56 VSS.t74 VSS.n147 33.2722
R57 VSS.t11 VSS.n82 37.9567
R58 VSS.t17 VSS.n90 37.9567
R59 VSS.n129 VSS.t59 27.7269
R60 VSS.n103 VSS.t75 27.7269
R61 VSS.t106 VSS.t29 17.717
R62 VSS.t10 VSS.n75 34.1616
R63 VSS.t105 VSS.t29 16.2727
R64 VSS.t8 VSS.n79 30.3673
R65 VSS.t48 VSS.n86 13.7582
R66 VSS.n77 VSS.t0 68.3166
R67 VSS.n79 VSS.t7 53.1364
R68 VSS.n83 VSS.t19 37.9561
R69 VSS.t50 VSS.n71 13.7572
R70 VSS.n69 VSS.t50 13.76
R71 VSS.t57 VSS.n161 22.1816
R72 VSS.t77 VSS.n146 22.1816
R73 VSS.t7 VSS.n78 26.5715
R74 VSS.t27 VSS.n71 11.4002
R75 VSS.t26 VSS.n87 15.1866
R76 VSS.n76 VSS.n68 0.0108886
R77 VSS.t20 VSS.n73 34.162
R78 VSS.n83 VSS.n68 0.0111485
R79 VSS.n91 VSS.n68 0.0109013
R80 VSS.t17 VSS.n91 41.7521
R81 VSS.n90 VSS.n68 0.0109013
R82 VSS.t16 VSS.n90 45.5472
R83 VSS.t14 VSS.n80 34.1651
R84 VSS.t13 VSS.n74 37.957
R85 VSS.n89 VSS.n68 0.0109013
R86 VSS.t11 VSS.n89 41.7521
R87 VSS.n82 VSS.n68 0.0109013
R88 VSS.t10 VSS.n82 45.5472
R89 VSS.n79 VSS.n68 0.0111485
R90 VSS.n78 VSS.n68 0.0109013
R91 VSS.t5 VSS.n78 56.9324
R92 VSS.n85 VSS.n68 0.0109013
R93 VSS.t4 VSS.n85 60.7274
R94 VSS.t2 VSS.n84 64.5225
R95 VSS.n77 VSS.n68 0.0111485
R96 VSS.n1 VSS.t21 0.294368
R97 VSS.t52 VSS.t21 5.66266
R98 VSS.t21 VSS.t28 5.66533
R99 VSS.n68 VSS.n1 0.00319301
R100 VSS.t47 VSS.t1 5.66266
R101 VSS.t47 VSS.t49 5.66533
R102 VSS.t38 VSS.n49 0.650675
R103 VSS.n49 VSS.n92 14.4044
R104 VSS.n35 VSS.n93 14.4044
R105 VSS.t38 VSS.n56 0.650675
R106 VSS.n56 VSS.n95 14.4044
R107 VSS.n44 VSS.n96 7.20256
R108 VSS.t38 VSS.n171 8.50052
R109 VSS.n46 VSS.n98 14.4044
R110 VSS.t38 VSS.n145 8.49983
R111 VSS.n43 VSS.n99 14.4044
R112 VSS.t38 VSS.n43 0.650675
R113 VSS.n54 VSS.n101 7.20256
R114 VSS.t38 VSS.n54 0.650675
R115 VSS.t38 VSS.n34 0.650675
R116 VSS.n64 VSS.n63 0.0169945
R117 VSS.n34 VSS.n103 7.20256
R118 VSS.t38 VSS.n29 0.650675
R119 VSS.n29 VSS.n105 14.4044
R120 VSS.t38 VSS.n39 0.650675
R121 VSS.n39 VSS.n107 14.4044
R122 VSS.t38 VSS.n60 3.39221
R123 VSS.n57 VSS.n108 14.4044
R124 VSS.t38 VSS.n57 0.650675
R125 VSS.t38 VSS.n149 8.50017
R126 VSS.n27 VSS.n111 14.4044
R127 VSS.t38 VSS.n14 0.812197
R128 VSS.n55 VSS.n113 14.4044
R129 VSS.t38 VSS.n31 0.650675
R130 VSS.n31 VSS.n114 7.20256
R131 VSS.t38 VSS.n165 8.49984
R132 VSS.n38 VSS.n116 14.6203
R133 VSS.t38 VSS.n40 0.650675
R134 VSS.n40 VSS.n118 14.4044
R135 VSS.t38 VSS.n163 8.50029
R136 VSS.n42 VSS.n120 14.4044
R137 VSS.t91 VSS.n66 0.0441465
R138 VSS.n50 VSS.n122 14.4044
R139 VSS.t38 VSS.n32 0.650675
R140 VSS.n32 VSS.n123 7.20256
R141 VSS.t38 VSS.n36 0.650675
R142 VSS.n36 VSS.n125 14.4044
R143 VSS.n25 VSS.n24 0.0146418
R144 VSS.t38 VSS.n51 0.650675
R145 VSS.n51 VSS.n127 14.4044
R146 VSS.t38 VSS.n45 0.650675
R147 VSS.n45 VSS.n128 7.20256
R148 VSS.n48 VSS.n129 7.20256
R149 VSS.t38 VSS.n30 0.650675
R150 VSS.n30 VSS.n131 7.20256
R151 VSS.n33 VSS.n133 14.4044
R152 VSS.n47 VSS.n135 14.4044
R153 VSS.n28 VSS.n137 14.4044
R154 VSS.t38 VSS.n157 8.50046
R155 VSS.t38 VSS.n53 0.650675
R156 VSS.t38 VSS.n41 0.650675
R157 VSS.n41 VSS.t37 7.20256
R158 VSS.t38 VSS.n37 0.650675
R159 VSS.n37 VSS.n141 14.4044
R160 VSS.t38 VSS.n52 0.650675
R161 VSS.n142 VSS.n52 14.8732
R162 VSS.t38 VSS.n144 8.49451
R163 VSS.t38 VSS.n170 8.49997
R164 VSS.t38 VSS.n146 8.49958
R165 VSS.t38 VSS.n169 8.49897
R166 VSS.t38 VSS.n147 8.49476
R167 VSS.t38 VSS.n168 8.49872
R168 VSS.t38 VSS.n148 8.495
R169 VSS.t38 VSS.n167 8.49847
R170 VSS.t38 VSS.n166 8.49822
R171 VSS.t38 VSS.n150 8.49525
R172 VSS.t38 VSS.n151 8.4955
R173 VSS.t38 VSS.n164 8.49834
R174 VSS.t38 VSS.n152 8.49574
R175 VSS.t38 VSS.n153 8.49599
R176 VSS.t38 VSS.n162 8.49797
R177 VSS.t38 VSS.n154 8.49624
R178 VSS.t38 VSS.n161 8.49772
R179 VSS.t38 VSS.n155 8.50037
R180 VSS.t38 VSS.n160 8.49747
R181 VSS.t38 VSS.n156 8.49648
R182 VSS.t38 VSS.n159 8.49723
R183 VSS.t38 VSS.n158 8.49698
R184 VSS.t42 VSS.n16 0.00584445
R185 VSS.n63 VSS.n65 0.0126585
R186 VSS.n61 VSS.n64 0.0447619
R187 VSS.n61 VSS.n67 2.11567
R188 VSS.t35 VSS.t29 5.6616
R189 VSS.t29 VSS.t34 5.65987
R190 VSS.t32 VSS.t29 5.6616
R191 VSS.t29 VSS.t31 5.65987
R192 VSS.n160 VSS.t56 16.6364
R193 VSS.t78 VSS.n145 16.6364
R194 VSS.t5 VSS.n85 22.7764
R195 VSS.t43 VSS.t38 4.99233
R196 VSS.t38 VSS.t36 4.99233
R197 VSS.t41 VSS.t39 4.99233
R198 VSS.t45 VSS.n20 4.99233
R199 VSS.n115 VSS.n38 14.6209
R200 VSS.t40 VSS.n49 7.20324
R201 VSS.n97 VSS.n46 14.4051
R202 VSS.n119 VSS.n42 14.4051
R203 VSS.n134 VSS.n47 14.4051
R204 VSS.n139 VSS.n53 14.4051
R205 VSS.n130 VSS.n48 14.4051
R206 VSS.n126 VSS.n51 7.20324
R207 VSS.n121 VSS.n50 7.20324
R208 VSS.n112 VSS.n55 7.20324
R209 VSS.n109 VSS.n57 14.4051
R210 VSS.n102 VSS.n54 14.4051
R211 VSS.n100 VSS.n43 14.4051
R212 VSS.n94 VSS.n56 7.20324
R213 VSS.n11 VSS.t38 3.9931
R214 VSS.t27 VSS.n87 68.3172
R215 VSS.t16 VSS.n80 34.1648
R216 VSS.t14 VSS.n74 45.5468
R217 VSS.t4 VSS.n84 18.9814
R218 VSS.n75 VSS.t8 49.3429
R219 VSS.n76 VSS.t22 30.3676
R220 VSS.n88 VSS.t23 26.5725
R221 VSS.n72 VSS.t24 22.7772
R222 VSS.n70 VSS.t25 18.9821
R223 VSS.n159 VSS.t54 11.0911
R224 VSS.n96 VSS.t80 11.0911
R225 VSS.n81 VSS.n68 0.00105051
R226 VSS.n67 VSS.n94 8.5005
R227 VSS.n67 VSS.n96 8.5005
R228 VSS.n67 VSS.n101 8.5005
R229 VSS.n67 VSS.n103 8.5005
R230 VSS.n67 VSS.n112 8.5005
R231 VSS.n67 VSS.n114 8.5005
R232 VSS.n67 VSS.n121 8.5005
R233 VSS.n67 VSS.n123 8.5005
R234 VSS.n67 VSS.n126 8.5005
R235 VSS.n67 VSS.n128 8.5005
R236 VSS.n67 VSS.n129 8.5005
R237 VSS.n67 VSS.n131 8.5005
R238 VSS.t38 VSS.n177 8.4984
R239 VSS.n23 VSS.n178 0.0330498
R240 VSS.t38 VSS.n23 1.69278
R241 VSS.t38 VSS.n176 8.4984
R242 VSS.t38 VSS.n175 8.4984
R243 VSS.t38 VSS.n64 2.11897
R244 VSS.n60 VSS.n59 0.0194757
R245 VSS.t38 VSS.n174 8.4984
R246 VSS.n14 VSS.n181 0.171978
R247 VSS.n14 VSS.t91 0.0389158
R248 VSS.t38 VSS.n58 8.4984
R249 VSS.n24 VSS.n26 0.0274715
R250 VSS.t38 VSS.n25 1.68371
R251 VSS.n62 VSS.n182 0.0218844
R252 VSS.t38 VSS.n62 3.39647
R253 VSS.n67 VSS.n16 0.722021
R254 VSS.n67 VSS.n178 8.4984
R255 VSS.n21 VSS.n23 0.0112884
R256 VSS.n22 VSS.n21 0.0342178
R257 VSS.n67 VSS.n22 1.68134
R258 VSS.n67 VSS.n179 8.4984
R259 VSS.n67 VSS.n65 3.39245
R260 VSS.n67 VSS.n180 8.4984
R261 VSS.n67 VSS.n181 8.4984
R262 VSS.n67 VSS.t91 1.04404
R263 VSS.n58 VSS.n66 0.0123705
R264 VSS.n26 VSS.n58 0.0484019
R265 VSS.n67 VSS.n26 1.19382
R266 VSS.n67 VSS.n182 8.4984
R267 VSS.n8 VSS.n62 0.00881082
R268 VSS.n67 VSS.n9 0.390029
R269 VSS.n7 VSS 1.34016
R270 VSS VSS.t29 8.22525
R271 VSS.t29 VSS 8.22525
R272 VSS.n7 VSS.n173 3.48225
R273 VSS.t29 VSS.t33 6.87897
R274 VSS.t29 VSS.t30 6.87896
R275 VSS.t2 VSS.n77 15.187
R276 VSS.n19 VSS.n20 0.0110412
R277 VSS.n104 VSS.n169 7.20236
R278 VSS.n105 VSS.n147 7.20236
R279 VSS.n106 VSS.n168 7.20236
R280 VSS.n107 VSS.n148 7.20236
R281 VSS.n110 VSS.n166 7.20236
R282 VSS.n111 VSS.n150 7.20236
R283 VSS.n117 VSS.n164 7.20236
R284 VSS.n118 VSS.n152 7.20236
R285 VSS.n120 VSS.n153 7.20236
R286 VSS.n124 VSS.n162 7.20236
R287 VSS.n125 VSS.n154 7.20236
R288 VSS.n132 VSS.n161 7.20236
R289 VSS.n136 VSS.n159 7.20236
R290 VSS.n138 VSS.n158 7.20236
R291 VSS.n140 VSS.t37 7.20236
R292 VSS.n141 VSS.n52 14.4051
R293 VSS.n140 VSS.n37 14.4051
R294 VSS.n139 VSS.n41 14.4051
R295 VSS.n138 VSS.n53 14.4044
R296 VSS.n137 VSS.n157 7.20236
R297 VSS.n136 VSS.n28 14.4051
R298 VSS.n135 VSS.n156 7.20236
R299 VSS.n134 VSS.n160 7.20236
R300 VSS.n133 VSS.n155 7.20236
R301 VSS.n132 VSS.n33 14.4051
R302 VSS.n130 VSS.n30 14.4051
R303 VSS.n127 VSS.n45 14.4051
R304 VSS.n124 VSS.n36 14.4051
R305 VSS.n122 VSS.n32 14.4051
R306 VSS.n119 VSS.n163 7.20236
R307 VSS.n117 VSS.n40 14.4051
R308 VSS.n116 VSS.n151 7.20236
R309 VSS.n115 VSS.n165 7.20236
R310 VSS.n113 VSS.n31 14.4051
R311 VSS.n110 VSS.n27 14.4051
R312 VSS.n109 VSS.n149 7.20236
R313 VSS.n108 VSS.n167 7.20236
R314 VSS.n106 VSS.n39 14.4051
R315 VSS.n104 VSS.n29 14.4051
R316 VSS.n102 VSS.n34 14.4051
R317 VSS.n100 VSS.n146 7.20236
R318 VSS.n99 VSS.n170 7.20236
R319 VSS.n98 VSS.n145 7.20236
R320 VSS.n97 VSS.n171 7.20236
R321 VSS.n95 VSS.n44 14.4051
R322 VSS.n93 VSS.n144 7.20236
R323 VSS.n92 VSS.n35 14.4051
R324 VSS.n11 VSS.t40 7.66687
R325 VSS.n195 VSS.t38 1.70074
R326 VSS.n158 VSS.t53 5.54579
R327 VSS.t81 VSS.n144 5.54579
R328 VSS.n186 VSS.t46 4.5005
R329 VSS.t42 VSS.t38 0.768394
R330 VSS.n196 VSS.n81 6777.49
R331 VSS.t91 VSS 4.11287
R332 VSS.t91 VSS 4.11287
R333 VSS.t0 VSS.n86 11.3996
R334 VSS.n19 VSS.n18 3.0005
R335 VSS.t42 VSS.t41 0.0328544
R336 VSS.n70 VSS.n68 0.0111485
R337 VSS.n72 VSS.n68 0.0111485
R338 VSS.n143 VSS.n69 6777.49
R339 VSS.n69 VSS.n68 0.00105211
R340 VSS.n71 VSS.n68 0.00293611
R341 VSS.n68 VSS.n87 0.0109013
R342 VSS.n68 VSS.n88 0.0108886
R343 VSS.n68 VSS.n73 0.0109013
R344 VSS.n68 VSS.n80 0.0093246
R345 VSS.n68 VSS.n74 0.0109013
R346 VSS.n68 VSS.n75 0.0108886
R347 VSS.n68 VSS.n84 0.0109013
R348 VSS.n68 VSS.n86 0.00289146
R349 VSS.t48 VSS.n81 13.7601
R350 VSS VSS.n6 2.71193
R351 VSS.n3 VSS.t47 0.0442343
R352 VSS.n173 VSS.n3 0.696271
R353 VSS.n0 VSS.n173 0.696271
R354 VSS.n0 VSS.t21 0.0442343
R355 VSS.n4 VSS.t121 2.54786
R356 VSS.t29 VSS.t118 2.4821
R357 VSS.t115 VSS.n5 0.204721
R358 VSS.t110 VSS.t29 0.186677
R359 VSS.n187 VSS.n15 0.467761
R360 VSS.n187 VSS.t55 2.4821
R361 VSS.n188 VSS.t85 2.4821
R362 VSS.n188 VSS.t58 2.4821
R363 VSS.n189 VSS.t87 2.4821
R364 VSS.n189 VSS.t61 2.4821
R365 VSS.n12 VSS.t89 2.4821
R366 VSS.n12 VSS.t64 2.4821
R367 VSS.n190 VSS.n13 0.0736956
R368 VSS.n190 VSS.t70 2.4821
R369 VSS.n191 VSS.t95 2.4821
R370 VSS.n191 VSS.t73 2.4821
R371 VSS.n192 VSS.t97 2.4821
R372 VSS.n192 VSS.t76 2.4821
R373 VSS.n193 VSS.t99 2.4821
R374 VSS.n193 VSS.t79 2.4821
R375 VSS.t38 VSS.n35 0.650675
R376 VSS.t38 VSS.n44 0.650675
R377 VSS.t38 VSS.n46 0.650675
R378 VSS.t38 VSS.n27 0.650675
R379 VSS.t38 VSS.n55 0.650675
R380 VSS.t38 VSS.n42 0.650675
R381 VSS.t38 VSS.n50 0.650675
R382 VSS.t38 VSS.n48 0.650675
R383 VSS.t38 VSS.n33 0.650675
R384 VSS.t38 VSS.n47 0.650675
R385 VSS.t38 VSS.n28 0.650675
R386 VSS.t42 VSS.n186 2.2505
R387 VSS.n172 VSS.n68 2.09947
R388 VSS.n2 VSS.n68 2.09947
R389 VSS.t47 VSS.n1 0.29562
R390 VSS.t29 VSS.n183 2.09901
R391 VSS.t29 VSS.n5 0.593886
R392 VSS.t38 VSS.n38 0.542754
R393 VSS.n194 VSS.n67 1.7005
R394 VSS.n195 VSS.n142 1.53502
R395 VSS.n67 VSS.n11 0.166454
R396 VSS.n67 VSS.n92 0.650322
R397 VSS.n67 VSS.n93 0.650322
R398 VSS.n67 VSS.n95 0.650322
R399 VSS.n67 VSS.n97 0.650322
R400 VSS.n67 VSS.n98 0.650322
R401 VSS.n67 VSS.n99 0.650322
R402 VSS.n67 VSS.n100 0.650322
R403 VSS.n67 VSS.n102 0.650322
R404 VSS.n67 VSS.n104 0.650322
R405 VSS.n67 VSS.n105 0.650322
R406 VSS.n67 VSS.n106 0.650322
R407 VSS.n67 VSS.n107 0.650322
R408 VSS.n67 VSS.n108 0.650322
R409 VSS.n67 VSS.n109 0.650322
R410 VSS.n67 VSS.n110 0.650322
R411 VSS.n67 VSS.n111 0.650322
R412 VSS.n67 VSS.n113 0.650322
R413 VSS.n67 VSS.n115 0.650322
R414 VSS.n67 VSS.n116 0.650322
R415 VSS.n67 VSS.n117 0.650322
R416 VSS.n67 VSS.n118 0.650322
R417 VSS.n67 VSS.n119 0.650322
R418 VSS.n67 VSS.n120 0.650322
R419 VSS.n67 VSS.n122 0.650322
R420 VSS.n67 VSS.n124 0.650322
R421 VSS.n67 VSS.n125 0.650322
R422 VSS.n67 VSS.n127 0.650322
R423 VSS.n67 VSS.n130 0.650322
R424 VSS.n67 VSS.n132 0.650322
R425 VSS.n67 VSS.n133 0.650322
R426 VSS.n67 VSS.n134 0.650322
R427 VSS.n67 VSS.n135 0.650322
R428 VSS.n67 VSS.n136 0.650322
R429 VSS.n67 VSS.n137 0.650322
R430 VSS.n67 VSS.n138 0.650322
R431 VSS.n67 VSS.n139 0.650322
R432 VSS.n67 VSS.n140 0.650322
R433 VSS.n67 VSS.n141 0.650322
R434 VSS.t29 VSS.n4 0.489525
R435 VSS.t47 VSS.t3 0.129174
R436 VSS.t47 VSS.t6 0.139
R437 VSS.t47 VSS.t9 0.144188
R438 VSS.n3 VSS.t12 0.147087
R439 VSS.n0 VSS.t18 0.147087
R440 VSS.t124 VSS.n10 0.210005
R441 VSS.t121 VSS.n184 0.201663
R442 VSS.t118 VSS.n185 0.201663
R443 VSS.n185 VSS.n5 0.156593
R444 VSS.n15 VSS.t83 0.15208
R445 VSS.t55 VSS.t38 0.201663
R446 VSS.n8 VSS.t85 0.201663
R447 VSS.t58 VSS.n8 0.201663
R448 VSS.n24 VSS.t87 0.201663
R449 VSS.t61 VSS.n24 0.201663
R450 VSS.n66 VSS.t89 0.201663
R451 VSS.t64 VSS.n66 0.201663
R452 VSS.n13 VSS.t93 0.181628
R453 VSS.t70 VSS.t91 0.201663
R454 VSS.n59 VSS.t95 0.201663
R455 VSS.t73 VSS.n59 0.201663
R456 VSS.n63 VSS.t97 0.201663
R457 VSS.t76 VSS.n63 0.201663
R458 VSS.n21 VSS.t99 0.201663
R459 VSS.t79 VSS.n21 0.201663
R460 VSS.t67 VSS.t91 0.185696
R461 VSS.t124 VSS.n4 2.56788
R462 VSS.n10 VSS.t29 0.177674
R463 VSS.n67 VSS.n142 0.141883
R464 VSS.n17 VSS.n193 0.1171
R465 VSS.n184 VSS.n183 0.0906811
R466 VSS.t15 VSS.n172 0.0903294
R467 VSS.n2 VSS.t15 0.0876767
R468 VSS.n185 VSS.n183 0.0848662
R469 VSS.n184 VSS.n10 0.16407
R470 VSS.n188 VSS.n187 0.08146
R471 VSS.n189 VSS.n188 0.08146
R472 VSS.n12 VSS.n189 0.08146
R473 VSS.t91 VSS.n12 0.08146
R474 VSS.n13 VSS.t91 0.00689282
R475 VSS.n191 VSS.n190 0.08146
R476 VSS.n192 VSS.n191 0.08146
R477 VSS.n193 VSS.n192 0.08146
R478 VSS.n6 VSS 0.0445
R479 VSS.t15 VSS.n173 0.0394179
R480 VSS.t46 VSS.n19 0.031258
R481 VSS.n17 VSS.n18 0.0291125
R482 VSS.n15 VSS.t38 0.0388364
R483 VSS.n186 VSS.n18 0.0281144
R484 VSS.t42 VSS.n17 1.02432
R485 VSS.n178 VSS.n177 0.0118857
R486 VSS.n179 VSS.n176 0.0118857
R487 VSS.n180 VSS.n174 0.0118857
R488 VSS.n181 VSS.n174 0.0118857
R489 VSS.n182 VSS.n25 0.0671924
R490 VSS.t38 VSS.n9 0.568063
R491 VSS.n9 VSS.n8 0.138832
R492 VSS.n180 VSS.n60 0.0289924
R493 VSS.n61 VSS.n59 0.0187634
R494 VSS.n65 VSS.n175 0.0298796
R495 VSS.n179 VSS.n175 0.0118857
R496 VSS.n22 VSS.n176 0.0558032
R497 VSS.n16 VSS.n177 0.0642889
R498 VSS.n20 VSS.t42 0.0318616
R499 VSS.t29 VSS.t111 19.8705
R500 VSS.t29 VSS.t114 19.8853
R501 VSS.t29 VSS.t120 17.7154
R502 VSS.t29 VSS.t123 14.4648
R503 VSS.n7 VSS 1.34016
R504 VSS VSS.n6 1.12053
R505 VSS.t47 VSS.n2 1.05109
R506 VSS.n172 VSS.t21 1.04946
C0 VDD vout2 15.3834f
C1 vin3 vout3 18.2968f
C2 vin4 vout4 18.2968f
C3 vin1 VDD 29.2329f
C4 vin3 vin4 0.05053f
C5 vin3 vin2 0.05785f
C6 vin1 vout1 18.2968f
C7 vin2 vout2 18.2968f
C8 vout3 VDD 15.3834f
C9 vout4 VDD 15.3949f
C10 VDD vout1 15.3949f
C11 vin1 vin2 0.05053f
C12 vin4 VDD 29.2329f
C13 vin3 VDD 29.202f
C14 VDD vin2 29.202f
C15 vout1 VSS 13.57609f
C16 vout2 VSS 13.55759f
C17 vout3 VSS 13.55759f
C18 vout4 VSS 13.57609f
C19 VSS.t99 VSS 8.00945f
C20 VSS.t28 VSS 4.01355f
C21 VSS.t70 VSS 8.00945f
C22 VSS.t52 VSS 4.01355f
.ends

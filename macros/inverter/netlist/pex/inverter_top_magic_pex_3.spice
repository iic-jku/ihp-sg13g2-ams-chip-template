* PEX produced on Mon Jul 20 08:16:11 PM CEST 2026 using /foss/tools/sak/sak-pex.sh with m=3 and s=1 (extresist threshold=10000 mOhm, minres=1000 mOhm, mindelay=1 ps)
* NGSPICE file created from inverter_top_pex.ext - technology: ihp-sg13g2

.subckt inverter_top_pex VDD vin4 vout4 VSS vin3 vout3 vin2 vout2 vout1 vin1
X0 vout3 vin3 VSS.t105 VSS.t86 sg13_lv_nmos ad=0.19p pd=1.38u as=0.19p ps=1.38u w=1u l=1u
X1 VDD VDD VDD VDD sg13_lv_pmos ad=1.14p pd=6.38u as=0.56797n ps=1.006m w=6u l=1u
X2 VSS.t1 VSS.t53 VSS.t55 VSS.t54 sg13_lv_nmos ad=0.34p pd=2.68u as=0 ps=0 w=1u l=1u
X3 VDD VDD VDD VDD sg13_lv_pmos ad=1.14p pd=6.38u as=0 ps=0 w=6u l=1u
X4 VDD vin4 vout4 VDD sg13_lv_pmos ad=1.14p pd=6.38u as=1.14p ps=6.38u w=6u l=1u
X5 vout2 vin2 VSS.t76 VSS.t77 sg13_lv_nmos ad=0.19p pd=1.38u as=0.19p ps=1.38u w=1u l=1u
X6 vout3 vin3 VDD VDD sg13_lv_pmos ad=1.14p pd=6.38u as=1.14p ps=6.38u w=6u l=1u
X7 vout4 vin4 VSS.t110 VSS.t111 sg13_lv_nmos ad=0.19p pd=1.38u as=0.19p ps=1.38u w=1u l=1u
X8 vout3 vin3 VSS.t42 VSS.t59 sg13_lv_nmos ad=0.19p pd=1.38u as=0.19p ps=1.38u w=1u l=1u
X9 vout2 vin2 VSS.t70 VSS.t71 sg13_lv_nmos ad=0.19p pd=1.38u as=0.19p ps=1.38u w=1u l=1u
X10 vout4 vin4 VDD VDD sg13_lv_pmos ad=1.14p pd=6.38u as=1.14p ps=6.38u w=6u l=1u
X11 VDD vin2 vout2 VDD sg13_lv_pmos ad=1.14p pd=6.38u as=1.14p ps=6.38u w=6u l=1u
X12 VSS.t76 vin2 vout2 VSS.t75 sg13_lv_nmos ad=0.19p pd=1.38u as=0.19p ps=1.38u w=1u l=1u
X13 vout2 vin2 VSS.t79 VSS.t80 sg13_lv_nmos ad=0.19p pd=1.38u as=0.19p ps=1.38u w=1u l=1u
X14 vout2 vin2 VDD VDD sg13_lv_pmos ad=1.14p pd=6.38u as=1.14p ps=6.38u w=6u l=1u
X15 VSS.t116 vin4 vout4 VSS.t115 sg13_lv_nmos ad=0.19p pd=1.38u as=0.19p ps=1.38u w=1u l=1u
X16 vout1 vin1 VSS.t24 VSS.t25 sg13_lv_nmos ad=0.19p pd=1.38u as=0.19p ps=1.38u w=1u l=1u
X17 VDD vin2 vout2 VDD sg13_lv_pmos ad=1.14p pd=6.38u as=1.14p ps=6.38u w=6u l=1u
X18 vout4 vin4 VSS.t34 VSS.t108 sg13_lv_nmos ad=0.19p pd=1.38u as=0.19p ps=1.38u w=1u l=1u
X19 VDD vin2 vout2 VDD sg13_lv_pmos ad=1.14p pd=6.38u as=1.14p ps=6.38u w=6u l=1u
X20 VSS.t105 vin3 vout3 VSS.t84 sg13_lv_nmos ad=0.19p pd=1.38u as=0.19p ps=1.38u w=1u l=1u
X21 vout4 vin4 VSS.t125 VSS.t126 sg13_lv_nmos ad=0.19p pd=1.38u as=0.19p ps=1.38u w=1u l=1u
X22 VSS.t119 vin4 vout4 VSS.t118 sg13_lv_nmos ad=0.19p pd=1.38u as=0.19p ps=1.38u w=1u l=1u
X23 VDD vin3 vout3 VDD sg13_lv_pmos ad=1.14p pd=6.38u as=1.14p ps=6.38u w=6u l=1u
X24 VDD vin2 vout2 VDD sg13_lv_pmos ad=1.14p pd=6.38u as=1.14p ps=6.38u w=6u l=1u
X25 vout3 vin3 VDD VDD sg13_lv_pmos ad=1.14p pd=6.38u as=1.14p ps=6.38u w=6u l=1u
X26 VSS.t70 vin2 vout2 VSS.t69 sg13_lv_nmos ad=0.19p pd=1.38u as=0.19p ps=1.38u w=1u l=1u
X27 VDD vin3 vout3 VDD sg13_lv_pmos ad=1.14p pd=6.38u as=1.14p ps=6.38u w=6u l=1u
X28 VSS.t42 VSS.t39 VSS.t41 VSS.t40 sg13_lv_nmos ad=0.34p pd=2.68u as=0 ps=0 w=1u l=1u
X29 vout2 vin2 VDD VDD sg13_lv_pmos ad=1.14p pd=6.38u as=1.14p ps=6.38u w=6u l=1u
X30 vout2 vin2 VSS.t73 VSS.t74 sg13_lv_nmos ad=0.19p pd=1.38u as=0.19p ps=1.38u w=1u l=1u
X31 vout1 vin1 VSS.t18 VSS.t19 sg13_lv_nmos ad=0.19p pd=1.38u as=0.19p ps=1.38u w=1u l=1u
X32 VSS.t79 vin2 vout2 VSS.t78 sg13_lv_nmos ad=0.19p pd=1.38u as=0.19p ps=1.38u w=1u l=1u
X33 vout4 vin4 VSS.t122 VSS.t123 sg13_lv_nmos ad=0.19p pd=1.38u as=0.19p ps=1.38u w=1u l=1u
X34 vout1 vin1 VDD VDD sg13_lv_pmos ad=1.14p pd=6.38u as=1.14p ps=6.38u w=6u l=1u
X35 vout1 vin1 VSS.t12 VSS.t13 sg13_lv_nmos ad=0.19p pd=1.38u as=0.19p ps=1.38u w=1u l=1u
X36 VSS.t128 vin4 vout4 VSS.t127 sg13_lv_nmos ad=0.19p pd=1.38u as=0.19p ps=1.38u w=1u l=1u
X37 VDD VDD VDD VDD sg13_lv_pmos ad=1.14p pd=6.38u as=0 ps=0 w=6u l=1u
X38 VSS.t18 vin1 vout1 VSS.t17 sg13_lv_nmos ad=0.19p pd=1.38u as=0.19p ps=1.38u w=1u l=1u
X39 vout2 vin2 VDD VDD sg13_lv_pmos ad=1.14p pd=6.38u as=1.14p ps=6.38u w=6u l=1u
X40 VDD vin4 vout4 VDD sg13_lv_pmos ad=1.14p pd=6.38u as=1.14p ps=6.38u w=6u l=1u
X41 vout1 vin1 VSS.t21 VSS.t22 sg13_lv_nmos ad=0.19p pd=1.38u as=0.19p ps=1.38u w=1u l=1u
X42 vout3 vin3 VSS.t103 VSS.t83 sg13_lv_nmos ad=0.19p pd=1.38u as=0.19p ps=1.38u w=1u l=1u
X43 VDD vin3 vout3 VDD sg13_lv_pmos ad=1.14p pd=6.38u as=1.14p ps=6.38u w=6u l=1u
X44 vout4 vin4 VDD VDD sg13_lv_pmos ad=1.14p pd=6.38u as=1.14p ps=6.38u w=6u l=1u
X45 VDD vin4 vout4 VDD sg13_lv_pmos ad=1.14p pd=6.38u as=1.14p ps=6.38u w=6u l=1u
X46 vout3 vin3 VDD VDD sg13_lv_pmos ad=1.14p pd=6.38u as=1.14p ps=6.38u w=6u l=1u
X47 VDD vin3 vout3 VDD sg13_lv_pmos ad=1.14p pd=6.38u as=1.14p ps=6.38u w=6u l=1u
X48 VSS.t38 VSS.t35 VSS.t37 VSS.t36 sg13_lv_nmos ad=0.19p pd=1.38u as=0 ps=0 w=1u l=1u
X49 VDD vin4 vout4 VDD sg13_lv_pmos ad=1.14p pd=6.38u as=1.14p ps=6.38u w=6u l=1u
X50 VDD vin2 vout2 VDD sg13_lv_pmos ad=1.14p pd=6.38u as=1.14p ps=6.38u w=6u l=1u
X51 VSS.t131 vin4 vout4 VSS.t130 sg13_lv_nmos ad=0.19p pd=1.38u as=0.19p ps=1.38u w=1u l=1u
X52 VDD vin3 vout3 VDD sg13_lv_pmos ad=1.14p pd=6.38u as=1.14p ps=6.38u w=6u l=1u
X53 VSS.t12 vin1 vout1 VSS.t11 sg13_lv_nmos ad=0.19p pd=1.38u as=0.19p ps=1.38u w=1u l=1u
X54 VDD vin1 vout1 VDD sg13_lv_pmos ad=1.14p pd=6.38u as=1.14p ps=6.38u w=6u l=1u
X55 vout4 vin4 VSS.t134 VSS.t135 sg13_lv_nmos ad=0.19p pd=1.38u as=0.19p ps=1.38u w=1u l=1u
X56 vout1 vin1 VDD VDD sg13_lv_pmos ad=1.14p pd=6.38u as=1.14p ps=6.38u w=6u l=1u
X57 vout4 vin4 VDD VDD sg13_lv_pmos ad=1.14p pd=6.38u as=1.14p ps=6.38u w=6u l=1u
X58 vout1 vin1 VSS.t15 VSS.t16 sg13_lv_nmos ad=0.19p pd=1.38u as=0.19p ps=1.38u w=1u l=1u
X59 VDD vin1 vout1 VDD sg13_lv_pmos ad=1.14p pd=6.38u as=1.14p ps=6.38u w=6u l=1u
X60 vout3 vin3 VSS.t99 VSS.t77 sg13_lv_nmos ad=0.19p pd=1.38u as=0.19p ps=1.38u w=1u l=1u
X61 VSS.t21 vin1 vout1 VSS.t20 sg13_lv_nmos ad=0.19p pd=1.38u as=0.19p ps=1.38u w=1u l=1u
X62 VDD VDD VDD VDD sg13_lv_pmos ad=2.04p pd=12.68u as=0 ps=0 w=6u l=1u
X63 vout4 vin4 VDD VDD sg13_lv_pmos ad=1.14p pd=6.38u as=1.14p ps=6.38u w=6u l=1u
X64 VDD vin3 vout3 VDD sg13_lv_pmos ad=1.14p pd=6.38u as=1.14p ps=6.38u w=6u l=1u
X65 VDD vin4 vout4 VDD sg13_lv_pmos ad=1.14p pd=6.38u as=1.14p ps=6.38u w=6u l=1u
X66 vout3 vin3 VDD VDD sg13_lv_pmos ad=1.14p pd=6.38u as=1.14p ps=6.38u w=6u l=1u
X67 vout3 vin3 VSS.t95 VSS.t71 sg13_lv_nmos ad=0.19p pd=1.38u as=0.19p ps=1.38u w=1u l=1u
X68 VSS.t99 vin3 vout3 VSS.t75 sg13_lv_nmos ad=0.19p pd=1.38u as=0.19p ps=1.38u w=1u l=1u
X69 VDD VDD VDD VDD sg13_lv_pmos ad=1.14p pd=6.38u as=0 ps=0 w=6u l=1u
X70 vout3 vin3 VSS.t101 VSS.t80 sg13_lv_nmos ad=0.19p pd=1.38u as=0.19p ps=1.38u w=1u l=1u
X71 vout4 vin4 VDD VDD sg13_lv_pmos ad=1.14p pd=6.38u as=1.14p ps=6.38u w=6u l=1u
X72 vout3 vin3 VDD VDD sg13_lv_pmos ad=1.14p pd=6.38u as=1.14p ps=6.38u w=6u l=1u
X73 VDD vin1 vout1 VDD sg13_lv_pmos ad=1.14p pd=6.38u as=1.14p ps=6.38u w=6u l=1u
X74 vout2 vin2 VDD VDD sg13_lv_pmos ad=1.14p pd=6.38u as=1.14p ps=6.38u w=6u l=1u
X75 vout1 vin1 VDD VDD sg13_lv_pmos ad=1.14p pd=6.38u as=1.14p ps=6.38u w=6u l=1u
X76 vout2 vin2 VSS.t64 VSS.t65 sg13_lv_nmos ad=0.19p pd=1.38u as=0.19p ps=1.38u w=1u l=1u
X77 VDD vin1 vout1 VDD sg13_lv_pmos ad=1.14p pd=6.38u as=1.14p ps=6.38u w=6u l=1u
X78 VDD vin1 vout1 VDD sg13_lv_pmos ad=1.14p pd=6.38u as=1.14p ps=6.38u w=6u l=1u
X79 VDD vin3 vout3 VDD sg13_lv_pmos ad=1.14p pd=6.38u as=1.14p ps=6.38u w=6u l=1u
X80 VSS.t95 vin3 vout3 VSS.t69 sg13_lv_nmos ad=0.19p pd=1.38u as=0.19p ps=1.38u w=1u l=1u
X81 vout3 vin3 VSS.t97 VSS.t74 sg13_lv_nmos ad=0.19p pd=1.38u as=0.19p ps=1.38u w=1u l=1u
X82 VSS.t113 vin4 vout4 VSS.t112 sg13_lv_nmos ad=0.19p pd=1.38u as=0.19p ps=1.38u w=1u l=1u
X83 VDD vin4 vout4 VDD sg13_lv_pmos ad=1.14p pd=6.38u as=1.14p ps=6.38u w=6u l=1u
X84 VSS.t101 vin3 vout3 VSS.t78 sg13_lv_nmos ad=0.19p pd=1.38u as=0.19p ps=1.38u w=1u l=1u
X85 vout4 vin4 VSS.t116 VSS.t117 sg13_lv_nmos ad=0.19p pd=1.38u as=0.19p ps=1.38u w=1u l=1u
X86 VDD vin1 vout1 VDD sg13_lv_pmos ad=1.14p pd=6.38u as=1.14p ps=6.38u w=6u l=1u
X87 vout2 vin2 VDD VDD sg13_lv_pmos ad=1.14p pd=6.38u as=1.14p ps=6.38u w=6u l=1u
X88 vout1 vin1 VDD VDD sg13_lv_pmos ad=1.14p pd=6.38u as=1.14p ps=6.38u w=6u l=1u
X89 VSS.t110 vin4 vout4 VSS.t109 sg13_lv_nmos ad=0.19p pd=1.38u as=0.19p ps=1.38u w=1u l=1u
X90 VDD VDD VDD VDD sg13_lv_pmos ad=2.04p pd=12.68u as=0 ps=0 w=6u l=1u
X91 vout2 vin2 VDD VDD sg13_lv_pmos ad=1.14p pd=6.38u as=1.14p ps=6.38u w=6u l=1u
X92 VDD vin2 vout2 VDD sg13_lv_pmos ad=1.14p pd=6.38u as=1.14p ps=6.38u w=6u l=1u
X93 VSS.t64 vin2 vout2 VSS.t63 sg13_lv_nmos ad=0.19p pd=1.38u as=0.19p ps=1.38u w=1u l=1u
X94 VSS.t122 vin4 vout4 VSS.t121 sg13_lv_nmos ad=0.19p pd=1.38u as=0.19p ps=1.38u w=1u l=1u
X95 vout2 vin2 VDD VDD sg13_lv_pmos ad=1.14p pd=6.38u as=1.14p ps=6.38u w=6u l=1u
X96 VDD VDD VDD VDD sg13_lv_pmos ad=2.04p pd=12.68u as=0 ps=0 w=6u l=1u
X97 vout2 vin2 VSS.t67 VSS.t68 sg13_lv_nmos ad=0.19p pd=1.38u as=0.19p ps=1.38u w=1u l=1u
X98 VSS.t73 vin2 vout2 VSS.t72 sg13_lv_nmos ad=0.19p pd=1.38u as=0.19p ps=1.38u w=1u l=1u
X99 vout1 vin1 VDD VDD sg13_lv_pmos ad=1.14p pd=6.38u as=1.14p ps=6.38u w=6u l=1u
X100 vout1 vin1 VSS.t6 VSS.t7 sg13_lv_nmos ad=0.19p pd=1.38u as=0.19p ps=1.38u w=1u l=1u
X101 vout4 vin4 VSS.t119 VSS.t120 sg13_lv_nmos ad=0.19p pd=1.38u as=0.19p ps=1.38u w=1u l=1u
X102 vout3 vin3 VDD VDD sg13_lv_pmos ad=1.14p pd=6.38u as=1.14p ps=6.38u w=6u l=1u
X103 vout4 vin4 VSS.t131 VSS.t132 sg13_lv_nmos ad=0.19p pd=1.38u as=0.19p ps=1.38u w=1u l=1u
X104 VSS.t52 VSS.t50 VSS.t51 VSS.t44 sg13_lv_nmos ad=0.19p pd=1.38u as=0 ps=0 w=1u l=1u
X105 VSS.t125 vin4 vout4 VSS.t124 sg13_lv_nmos ad=0.19p pd=1.38u as=0.19p ps=1.38u w=1u l=1u
X106 VDD vin1 vout1 VDD sg13_lv_pmos ad=1.14p pd=6.38u as=1.14p ps=6.38u w=6u l=1u
X107 VSS.t51 vin2 vout2 VSS.t87 sg13_lv_nmos ad=0.19p pd=1.38u as=0.19p ps=1.38u w=1u l=1u
X108 VDD vin2 vout2 VDD sg13_lv_pmos ad=1.14p pd=6.38u as=1.14p ps=6.38u w=6u l=1u
X109 vout4 vin4 VSS.t128 VSS.t129 sg13_lv_nmos ad=0.19p pd=1.38u as=0.19p ps=1.38u w=1u l=1u
X110 vout4 vin4 VDD VDD sg13_lv_pmos ad=1.14p pd=6.38u as=1.14p ps=6.38u w=6u l=1u
X111 vout2 vin2 VDD VDD sg13_lv_pmos ad=1.14p pd=6.38u as=1.14p ps=6.38u w=6u l=1u
X112 vout2 vin2 VSS.t61 VSS.t62 sg13_lv_nmos ad=0.19p pd=1.38u as=0.19p ps=1.38u w=1u l=1u
X113 VDD vin2 vout2 VDD sg13_lv_pmos ad=1.14p pd=6.38u as=1.14p ps=6.38u w=6u l=1u
X114 VSS.t67 vin2 vout2 VSS.t66 sg13_lv_nmos ad=0.19p pd=1.38u as=0.19p ps=1.38u w=1u l=1u
X115 VDD vin4 vout4 VDD sg13_lv_pmos ad=1.14p pd=6.38u as=1.14p ps=6.38u w=6u l=1u
X116 VDD VDD VDD VDD sg13_lv_pmos ad=2.04p pd=12.68u as=0 ps=0 w=6u l=1u
X117 VSS.t61 vin2 vout2 VSS.t60 sg13_lv_nmos ad=0.19p pd=1.38u as=0.19p ps=1.38u w=1u l=1u
X118 VSS.t6 vin1 vout1 VSS.t5 sg13_lv_nmos ad=0.19p pd=1.38u as=0.19p ps=1.38u w=1u l=1u
X119 vout3 vin3 VDD VDD sg13_lv_pmos ad=1.14p pd=6.38u as=1.14p ps=6.38u w=6u l=1u
X120 vout1 vin1 VSS.t9 VSS.t10 sg13_lv_nmos ad=0.19p pd=1.38u as=0.19p ps=1.38u w=1u l=1u
X121 VSS.t15 vin1 vout1 VSS.t14 sg13_lv_nmos ad=0.19p pd=1.38u as=0.19p ps=1.38u w=1u l=1u
X122 vout3 vin3 VDD VDD sg13_lv_pmos ad=1.14p pd=6.38u as=1.14p ps=6.38u w=6u l=1u
X123 VDD vin3 vout3 VDD sg13_lv_pmos ad=1.14p pd=6.38u as=1.14p ps=6.38u w=6u l=1u
X124 vout3 vin3 VDD VDD sg13_lv_pmos ad=1.14p pd=6.38u as=1.14p ps=6.38u w=6u l=1u
X125 vout3 vin3 VSS.t91 VSS.t65 sg13_lv_nmos ad=0.19p pd=1.38u as=0.19p ps=1.38u w=1u l=1u
X126 VSS.t82 vin2 vout2 VSS.t81 sg13_lv_nmos ad=0.19p pd=1.38u as=0.19p ps=1.38u w=1u l=1u
X127 vout1 vin1 VDD VDD sg13_lv_pmos ad=1.14p pd=6.38u as=1.14p ps=6.38u w=6u l=1u
X128 vout2 vin2 VSS.t85 VSS.t86 sg13_lv_nmos ad=0.19p pd=1.38u as=0.19p ps=1.38u w=1u l=1u
X129 VSS.t37 vin4 vout4 VSS.t136 sg13_lv_nmos ad=0.19p pd=1.38u as=0.19p ps=1.38u w=1u l=1u
X130 VSS.t58 VSS.t56 VSS.t30 VSS.t57 sg13_lv_nmos ad=0.19p pd=1.38u as=0 ps=0 w=1u l=1u
X131 VSS.t30 vin1 vout1 VSS.t29 sg13_lv_nmos ad=0.19p pd=1.38u as=0.19p ps=1.38u w=1u l=1u
X132 vout2 vin2 VSS.t49 VSS.t59 sg13_lv_nmos ad=0.19p pd=1.38u as=0.19p ps=1.38u w=1u l=1u
X133 VSS.t34 VSS.t31 VSS.t33 VSS.t32 sg13_lv_nmos ad=0.34p pd=2.68u as=0 ps=0 w=1u l=1u
X134 vout1 vin1 VSS.t3 VSS.t4 sg13_lv_nmos ad=0.19p pd=1.38u as=0.19p ps=1.38u w=1u l=1u
X135 VSS.t9 vin1 vout1 VSS.t8 sg13_lv_nmos ad=0.19p pd=1.38u as=0.19p ps=1.38u w=1u l=1u
X136 VDD vin3 vout3 VDD sg13_lv_pmos ad=1.14p pd=6.38u as=1.14p ps=6.38u w=6u l=1u
X137 VSS.t3 vin1 vout1 VSS.t2 sg13_lv_nmos ad=0.19p pd=1.38u as=0.19p ps=1.38u w=1u l=1u
X138 vout4 vin4 VDD VDD sg13_lv_pmos ad=1.14p pd=6.38u as=1.14p ps=6.38u w=6u l=1u
X139 vout3 vin3 VDD VDD sg13_lv_pmos ad=1.14p pd=6.38u as=1.14p ps=6.38u w=6u l=1u
X140 VDD vin3 vout3 VDD sg13_lv_pmos ad=1.14p pd=6.38u as=1.14p ps=6.38u w=6u l=1u
X141 VSS.t91 vin3 vout3 VSS.t63 sg13_lv_nmos ad=0.19p pd=1.38u as=0.19p ps=1.38u w=1u l=1u
X142 vout3 vin3 VSS.t93 VSS.t68 sg13_lv_nmos ad=0.19p pd=1.38u as=0.19p ps=1.38u w=1u l=1u
X143 vout1 vin1 VDD VDD sg13_lv_pmos ad=1.14p pd=6.38u as=1.14p ps=6.38u w=6u l=1u
X144 VSS.t85 vin2 vout2 VSS.t84 sg13_lv_nmos ad=0.19p pd=1.38u as=0.19p ps=1.38u w=1u l=1u
X145 VSS.t97 vin3 vout3 VSS.t72 sg13_lv_nmos ad=0.19p pd=1.38u as=0.19p ps=1.38u w=1u l=1u
X146 VDD vin4 vout4 VDD sg13_lv_pmos ad=1.14p pd=6.38u as=1.14p ps=6.38u w=6u l=1u
X147 vout1 vin1 VDD VDD sg13_lv_pmos ad=1.14p pd=6.38u as=1.14p ps=6.38u w=6u l=1u
X148 VDD vin1 vout1 VDD sg13_lv_pmos ad=1.14p pd=6.38u as=1.14p ps=6.38u w=6u l=1u
X149 vout4 vin4 VDD VDD sg13_lv_pmos ad=1.14p pd=6.38u as=1.14p ps=6.38u w=6u l=1u
X150 VSS.t24 vin1 vout1 VSS.t23 sg13_lv_nmos ad=0.19p pd=1.38u as=0.19p ps=1.38u w=1u l=1u
X151 vout1 vin1 VSS.t27 VSS.t28 sg13_lv_nmos ad=0.19p pd=1.38u as=0.19p ps=1.38u w=1u l=1u
X152 vout1 vin1 VDD VDD sg13_lv_pmos ad=1.14p pd=6.38u as=1.14p ps=6.38u w=6u l=1u
X153 vout2 vin2 VDD VDD sg13_lv_pmos ad=1.14p pd=6.38u as=1.14p ps=6.38u w=6u l=1u
X154 vout4 vin4 VSS.t113 VSS.t114 sg13_lv_nmos ad=0.19p pd=1.38u as=0.19p ps=1.38u w=1u l=1u
X155 VSS.t49 VSS.t47 VSS.t48 VSS.t40 sg13_lv_nmos ad=0.34p pd=2.68u as=0 ps=0 w=1u l=1u
X156 VSS.t46 VSS.t43 VSS.t45 VSS.t44 sg13_lv_nmos ad=0.19p pd=1.38u as=0 ps=0 w=1u l=1u
X157 vout4 vin4 VDD VDD sg13_lv_pmos ad=1.14p pd=6.38u as=1.14p ps=6.38u w=6u l=1u
X158 VSS.t45 vin3 vout3 VSS.t87 sg13_lv_nmos ad=0.19p pd=1.38u as=0.19p ps=1.38u w=1u l=1u
X159 VSS.t134 vin4 vout4 VSS.t133 sg13_lv_nmos ad=0.19p pd=1.38u as=0.19p ps=1.38u w=1u l=1u
X160 VDD vin4 vout4 VDD sg13_lv_pmos ad=1.14p pd=6.38u as=1.14p ps=6.38u w=6u l=1u
X161 vout1 vin1 VSS.t1 VSS.t0 sg13_lv_nmos ad=0.19p pd=1.38u as=0.19p ps=1.38u w=1u l=1u
X162 vout3 vin3 VSS.t89 VSS.t62 sg13_lv_nmos ad=0.19p pd=1.38u as=0.19p ps=1.38u w=1u l=1u
X163 VSS.t93 vin3 vout3 VSS.t66 sg13_lv_nmos ad=0.19p pd=1.38u as=0.19p ps=1.38u w=1u l=1u
X164 vout4 vin4 VDD VDD sg13_lv_pmos ad=1.14p pd=6.38u as=1.14p ps=6.38u w=6u l=1u
X165 vout2 vin2 VSS.t82 VSS.t83 sg13_lv_nmos ad=0.19p pd=1.38u as=0.19p ps=1.38u w=1u l=1u
X166 VSS.t89 vin3 vout3 VSS.t60 sg13_lv_nmos ad=0.19p pd=1.38u as=0.19p ps=1.38u w=1u l=1u
X167 VDD vin1 vout1 VDD sg13_lv_pmos ad=1.14p pd=6.38u as=1.14p ps=6.38u w=6u l=1u
X168 vout1 vin1 VDD VDD sg13_lv_pmos ad=1.14p pd=6.38u as=1.14p ps=6.38u w=6u l=1u
X169 VDD vin1 vout1 VDD sg13_lv_pmos ad=1.14p pd=6.38u as=1.14p ps=6.38u w=6u l=1u
X170 VDD vin4 vout4 VDD sg13_lv_pmos ad=1.14p pd=6.38u as=1.14p ps=6.38u w=6u l=1u
X171 VSS.t27 vin1 vout1 VSS.t26 sg13_lv_nmos ad=0.19p pd=1.38u as=0.19p ps=1.38u w=1u l=1u
X172 VDD vin2 vout2 VDD sg13_lv_pmos ad=1.14p pd=6.38u as=1.14p ps=6.38u w=6u l=1u
X173 vout2 vin2 VDD VDD sg13_lv_pmos ad=1.14p pd=6.38u as=1.14p ps=6.38u w=6u l=1u
X174 VDD vin2 vout2 VDD sg13_lv_pmos ad=1.14p pd=6.38u as=1.14p ps=6.38u w=6u l=1u
X175 VSS.t103 vin3 vout3 VSS.t81 sg13_lv_nmos ad=0.19p pd=1.38u as=0.19p ps=1.38u w=1u l=1u
R0 VSS.n54 VSS.n127 6777.49
R1 VSS.n480 VSS.n127 6775.82
R2 VSS.n365 VSS.n364 1580.41
R3 VSS.n162 VSS.n127 1580.41
R4 VSS.t59 VSS.n146 88.7251
R5 VSS.n130 VSS.t87 88.7251
R6 VSS.t60 VSS.n147 83.1798
R7 VSS.n131 VSS.t86 83.1798
R8 VSS.n102 VSS.t62 77.6345
R9 VSS.n132 VSS.t84 77.6345
R10 VSS.t32 VSS.n56 6.87896
R11 VSS.n53 VSS.t136 11.4002
R12 VSS.t63 VSS.n148 72.0892
R13 VSS.n133 VSS.t83 72.0892
R14 VSS.t136 VSS.n52 68.3206
R15 VSS.n55 VSS.t108 9.77299
R16 VSS.n97 VSS.t65 66.5439
R17 VSS.n134 VSS.t81 66.5439
R18 VSS.t135 VSS.n51 64.5255
R19 VSS.n35 VSS.t109 64.5209
R20 VSS.t66 VSS.n149 60.9987
R21 VSS.n75 VSS.t80 60.9987
R22 VSS.t133 VSS.n50 60.7305
R23 VSS.n36 VSS.t111 60.7259
R24 VSS.n375 VSS.t0 60.7216
R25 VSS.t29 VSS.n469 60.7216
R26 VSS.t132 VSS.n49 56.9354
R27 VSS.n37 VSS.t112 56.9308
R28 VSS.n380 VSS.t2 56.9265
R29 VSS.t28 VSS.n464 56.9265
R30 VSS.n92 VSS.t68 55.4534
R31 VSS.n139 VSS.t72 55.4534
R32 VSS.t74 VSS.n153 55.4534
R33 VSS.t78 VSS.n135 55.4534
R34 VSS.t130 VSS.n48 53.1403
R35 VSS.n38 VSS.t114 53.1357
R36 VSS.n385 VSS.t4 53.1314
R37 VSS.t26 VSS.n459 53.1314
R38 VSS.t69 VSS.n150 49.9081
R39 VSS.n140 VSS.t71 49.9081
R40 VSS.t75 VSS.n154 49.9081
R41 VSS.n136 VSS.t77 49.9081
R42 VSS.t129 VSS.n47 49.3453
R43 VSS.n39 VSS.t115 49.3407
R44 VSS.n390 VSS.t5 49.3364
R45 VSS.t25 VSS.n454 49.3364
R46 VSS.t127 VSS.n46 45.5502
R47 VSS.t121 VSS.n42 45.5502
R48 VSS.n44 VSS.t123 45.5456
R49 VSS.n40 VSS.t117 45.5456
R50 VSS.n395 VSS.t7 45.5413
R51 VSS.t23 VSS.n449 45.5413
R52 VSS.n90 VSS.t69 44.3628
R53 VSS.t71 VSS.n151 44.3628
R54 VSS.n137 VSS.t75 44.3628
R55 VSS.t77 VSS.n155 44.3628
R56 VSS.t126 VSS.n45 41.7551
R57 VSS.t120 VSS.n41 41.7551
R58 VSS.n45 VSS.t124 41.7505
R59 VSS.n41 VSS.t118 41.7505
R60 VSS.n400 VSS.t8 41.7462
R61 VSS.t22 VSS.n444 41.7462
R62 VSS.t68 VSS.n141 38.8175
R63 VSS.t72 VSS.n152 38.8175
R64 VSS.n138 VSS.t74 38.8175
R65 VSS.n77 VSS.t78 38.8175
R66 VSS.t124 VSS.n44 37.9601
R67 VSS.t118 VSS.n40 37.9601
R68 VSS.n46 VSS.t126 37.9555
R69 VSS.n42 VSS.t120 37.9555
R70 VSS.n405 VSS.t10 37.9512
R71 VSS.t14 VSS.n419 37.9512
R72 VSS.n425 VSS.t16 37.9512
R73 VSS.t20 VSS.n439 37.9512
R74 VSS.t123 VSS.n43 34.1682
R75 VSS.t117 VSS.n39 34.165
R76 VSS.n43 VSS.t121 34.1635
R77 VSS.n47 VSS.t127 34.1604
R78 VSS.n410 VSS.t11 34.1561
R79 VSS.t13 VSS.n414 34.1561
R80 VSS.n430 VSS.t17 34.1561
R81 VSS.t19 VSS.n434 34.1561
R82 VSS.n95 VSS.t66 33.2722
R83 VSS.t80 VSS.n156 33.2722
R84 VSS.t115 VSS.n38 30.3699
R85 VSS.n48 VSS.t129 30.3653
R86 VSS.t11 VSS.n409 30.361
R87 VSS.n415 VSS.t13 30.361
R88 VSS.t17 VSS.n429 30.361
R89 VSS.n435 VSS.t19 30.361
R90 VSS.t65 VSS.n142 27.7269
R91 VSS.t81 VSS.n157 27.7269
R92 VSS.t114 VSS.n37 26.5749
R93 VSS.n49 VSS.t130 26.5703
R94 VSS.t10 VSS.n404 26.566
R95 VSS.n420 VSS.t14 26.566
R96 VSS.t16 VSS.n424 26.566
R97 VSS.n440 VSS.t20 26.566
R98 VSS.n366 VSS.n119 24.3158
R99 VSS.n422 VSS.n421 23.0507
R100 VSS.n423 VSS.n422 23.0507
R101 VSS.t112 VSS.n36 22.7798
R102 VSS.n50 VSS.t132 22.7752
R103 VSS.t8 VSS.n399 22.7709
R104 VSS.n445 VSS.t22 22.7709
R105 VSS.n462 VSS.n461 22.2674
R106 VSS.n457 VSS.n456 22.2674
R107 VSS.n432 VSS.n431 22.2674
R108 VSS.n427 VSS.n426 22.2674
R109 VSS.n407 VSS.n406 22.2674
R110 VSS.n402 VSS.n401 22.2674
R111 VSS.n392 VSS.n391 22.2674
R112 VSS.n387 VSS.n386 22.2674
R113 VSS.n382 VSS.n381 22.2674
R114 VSS.n478 VSS.n477 22.2674
R115 VSS.n367 VSS.n366 22.2674
R116 VSS.n368 VSS.n367 22.2674
R117 VSS.n369 VSS.n368 22.2674
R118 VSS.n371 VSS.n370 22.2674
R119 VSS.n372 VSS.n371 22.2674
R120 VSS.n373 VSS.n372 22.2674
R121 VSS.n377 VSS.n376 22.2674
R122 VSS.n378 VSS.n377 22.2674
R123 VSS.n383 VSS.n382 22.2674
R124 VSS.n388 VSS.n387 22.2674
R125 VSS.n393 VSS.n392 22.2674
R126 VSS.n397 VSS.n396 22.2674
R127 VSS.n398 VSS.n397 22.2674
R128 VSS.n403 VSS.n402 22.2674
R129 VSS.n408 VSS.n407 22.2674
R130 VSS.n412 VSS.n411 22.2674
R131 VSS.n413 VSS.n412 22.2674
R132 VSS.n417 VSS.n416 22.2674
R133 VSS.n418 VSS.n417 22.2674
R134 VSS.n428 VSS.n427 22.2674
R135 VSS.n433 VSS.n432 22.2674
R136 VSS.n437 VSS.n436 22.2674
R137 VSS.n438 VSS.n437 22.2674
R138 VSS.n442 VSS.n441 22.2674
R139 VSS.n443 VSS.n442 22.2674
R140 VSS.n447 VSS.n446 22.2674
R141 VSS.n448 VSS.n447 22.2674
R142 VSS.n452 VSS.n451 22.2674
R143 VSS.n453 VSS.n452 22.2674
R144 VSS.n458 VSS.n457 22.2674
R145 VSS.n463 VSS.n462 22.2674
R146 VSS.n467 VSS.n466 22.2674
R147 VSS.n468 VSS.n467 22.2674
R148 VSS.n472 VSS.n471 22.2674
R149 VSS.n473 VSS.n472 22.2674
R150 VSS.n474 VSS.n473 22.2674
R151 VSS.n476 VSS.n475 22.2674
R152 VSS.n477 VSS.n476 22.2674
R153 VSS.n479 VSS.n478 22.2674
R154 VSS.n100 VSS.t63 22.1816
R155 VSS.t83 VSS.n158 22.1816
R156 VSS.t111 VSS.n35 18.9847
R157 VSS.n51 VSS.t133 18.9801
R158 VSS.t7 VSS.n394 18.9758
R159 VSS.n450 VSS.t23 18.9758
R160 VSS.n470 VSS.n118 17.0005
R161 VSS.n469 VSS.n118 17.0005
R162 VSS.n465 VSS.n118 17.0005
R163 VSS.n464 VSS.n118 17.0005
R164 VSS.n460 VSS.n118 17.0005
R165 VSS.n459 VSS.n118 17.0005
R166 VSS.n455 VSS.n118 17.0005
R167 VSS.n454 VSS.n118 17.0005
R168 VSS.n450 VSS.n118 17.0005
R169 VSS.n449 VSS.n118 17.0005
R170 VSS.n445 VSS.n118 17.0005
R171 VSS.n444 VSS.n118 17.0005
R172 VSS.n440 VSS.n118 17.0005
R173 VSS.n439 VSS.n118 17.0005
R174 VSS.n435 VSS.n118 17.0005
R175 VSS.n434 VSS.n118 17.0005
R176 VSS.n430 VSS.n118 17.0005
R177 VSS.n429 VSS.n118 17.0005
R178 VSS.n425 VSS.n118 17.0005
R179 VSS.n424 VSS.n118 17.0005
R180 VSS.n420 VSS.n118 17.0005
R181 VSS.n419 VSS.n118 17.0005
R182 VSS.n415 VSS.n118 17.0005
R183 VSS.n414 VSS.n118 17.0005
R184 VSS.n410 VSS.n118 17.0005
R185 VSS.n409 VSS.n118 17.0005
R186 VSS.n405 VSS.n118 17.0005
R187 VSS.n404 VSS.n118 17.0005
R188 VSS.n400 VSS.n118 17.0005
R189 VSS.n399 VSS.n118 17.0005
R190 VSS.n395 VSS.n118 17.0005
R191 VSS.n394 VSS.n118 17.0005
R192 VSS.n390 VSS.n118 17.0005
R193 VSS.n389 VSS.n118 17.0005
R194 VSS.n385 VSS.n118 17.0005
R195 VSS.n384 VSS.n118 17.0005
R196 VSS.n380 VSS.n118 17.0005
R197 VSS.n379 VSS.n118 17.0005
R198 VSS.n375 VSS.n118 17.0005
R199 VSS.n114 VSS.n171 17.0005
R200 VSS.n175 VSS.n114 17.0005
R201 VSS.n114 VSS.n126 17.0005
R202 VSS.t58 VSS.n174 17.0005
R203 VSS.n181 VSS.t58 17.0005
R204 VSS.n180 VSS.t30 17.0005
R205 VSS.n181 VSS.t30 17.0005
R206 VSS.t58 VSS.n180 17.0005
R207 VSS.n174 VSS.t30 17.0005
R208 VSS.n374 VSS.n114 17.0005
R209 VSS.n118 VSS.n185 17.0005
R210 VSS.n118 VSS.n172 17.0005
R211 VSS.n118 VSS.n173 17.0005
R212 VSS.n118 VSS.n163 17.0005
R213 VSS.n184 VSS.t1 17.0005
R214 VSS.t1 VSS.n183 17.0005
R215 VSS.t1 VSS.n170 17.0005
R216 VSS.n183 VSS.t55 17.0005
R217 VSS.t55 VSS.n170 17.0005
R218 VSS.n184 VSS.t55 17.0005
R219 VSS.n0 VSS.n32 1.20771
R220 VSS.n0 VSS.n16 0.650675
R221 VSS.n27 VSS.n64 13.8932
R222 VSS.n0 VSS.n226 17.0005
R223 VSS.n0 VSS.n161 8.49292
R224 VSS.n0 VSS.n130 8.49316
R225 VSS.n18 VSS.n65 14.4044
R226 VSS.n0 VSS.n187 17.0005
R227 VSS.n0 VSS.n18 0.650675
R228 VSS.n0 VSS.n160 8.49341
R229 VSS.n0 VSS.n131 8.49365
R230 VSS.n0 VSS.n19 0.650675
R231 VSS.n19 VSS.n68 14.4044
R232 VSS.n0 VSS.n123 17.0005
R233 VSS.n0 VSS.n159 8.49389
R234 VSS.n0 VSS.n132 8.49414
R235 VSS.n21 VSS.n70 14.4044
R236 VSS.n0 VSS.n158 8.49438
R237 VSS.n0 VSS.n133 8.49463
R238 VSS.n0 VSS.n26 0.650675
R239 VSS.n0 VSS.n59 8.49909
R240 VSS.n26 VSS.n72 14.4044
R241 VSS.n0 VSS.n157 8.49487
R242 VSS.n0 VSS.n134 8.49512
R243 VSS.n0 VSS.n25 0.650675
R244 VSS.n25 VSS.n74 14.4044
R245 VSS.n0 VSS.n156 8.50035
R246 VSS.n0 VSS.n23 0.650675
R247 VSS.n23 VSS.n76 14.4044
R248 VSS.n0 VSS.n194 17.0005
R249 VSS.n0 VSS.n8 0.650675
R250 VSS.n0 VSS.n224 17.0005
R251 VSS.n8 VSS.n77 7.20256
R252 VSS.n0 VSS.n195 17.0005
R253 VSS.n0 VSS.n135 8.49536
R254 VSS.n0 VSS.n4 0.650675
R255 VSS.n4 VSS.n79 14.4044
R256 VSS.n0 VSS.n155 8.49561
R257 VSS.n0 VSS.n136 8.49585
R258 VSS.n0 VSS.n11 0.650675
R259 VSS.n11 VSS.n81 14.4044
R260 VSS.n0 VSS.n220 17.0005
R261 VSS.n0 VSS.n154 8.4961
R262 VSS.n0 VSS.n137 8.49635
R263 VSS.n0 VSS.n17 0.650675
R264 VSS.n17 VSS.n83 14.4044
R265 VSS.n0 VSS.n153 8.4966
R266 VSS.n0 VSS.n138 8.49684
R267 VSS.n0 VSS.n7 0.542754
R268 VSS.n0 VSS.n116 17.0005
R269 VSS.n7 VSS.n85 14.6203
R270 VSS.n0 VSS.n117 17.0005
R271 VSS.n0 VSS.n152 8.49973
R272 VSS.n0 VSS.n139 8.49709
R273 VSS.n0 VSS.n9 0.650675
R274 VSS.n0 VSS.n200 17.0005
R275 VSS.n9 VSS.n87 14.4044
R276 VSS.n0 VSS.n151 8.49734
R277 VSS.n0 VSS.n140 8.49759
R278 VSS.n1 VSS.n89 14.4044
R279 VSS.n0 VSS.n217 17.0005
R280 VSS.n0 VSS.n150 8.49784
R281 VSS.n0 VSS.n201 17.0005
R282 VSS.n0 VSS.n15 0.650675
R283 VSS.n0 VSS.n13 0.650675
R284 VSS.n13 VSS.n92 7.20256
R285 VSS.n0 VSS.n141 8.49803
R286 VSS.n2 VSS.n94 14.4044
R287 VSS.n0 VSS.n213 17.0005
R288 VSS.n0 VSS.n149 8.49809
R289 VSS.n22 VSS.n95 7.20256
R290 VSS.n0 VSS.n12 0.650675
R291 VSS.n12 VSS.n97 7.20256
R292 VSS.n0 VSS.n142 8.49834
R293 VSS.n0 VSS.n5 0.650675
R294 VSS.n5 VSS.n99 14.4044
R295 VSS.n0 VSS.n57 8.49909
R296 VSS.n0 VSS.n148 8.49859
R297 VSS.n0 VSS.n14 0.650675
R298 VSS.n14 VSS.n101 14.4044
R299 VSS.n0 VSS.n3 0.650675
R300 VSS.n3 VSS.n102 7.20256
R301 VSS.n0 VSS.n143 8.49883
R302 VSS.n0 VSS.n24 0.650675
R303 VSS.n0 VSS.n120 17.0005
R304 VSS.n24 VSS.n104 14.4044
R305 VSS.n0 VSS.n147 8.49908
R306 VSS.n0 VSS.n144 8.49933
R307 VSS.n0 VSS.n20 0.650675
R308 VSS.n20 VSS.n106 14.4044
R309 VSS.n0 VSS.n146 8.49958
R310 VSS.n0 VSS.n145 8.50058
R311 VSS.n0 VSS.n10 0.650675
R312 VSS.n0 VSS.n34 1.20771
R313 VSS.n112 VSS.n30 14.3619
R314 VSS.n0 VSS.n29 1.20771
R315 VSS.n0 VSS.n33 1.20771
R316 VSS.n0 VSS.n31 1.20771
R317 VSS.n113 VSS.n230 17.0005
R318 VSS.n113 VSS.n234 17.0005
R319 VSS.n113 VSS.n236 17.0005
R320 VSS.n113 VSS.n125 17.0005
R321 VSS.n113 VSS.n247 17.0005
R322 VSS.n113 VSS.n250 17.0005
R323 VSS.n113 VSS.n257 17.0005
R324 VSS.n113 VSS.n259 17.0005
R325 VSS.n113 VSS.n261 17.0005
R326 VSS.n113 VSS.n264 17.0005
R327 VSS.n113 VSS.n122 17.0005
R328 VSS.n113 VSS.n278 17.0005
R329 VSS.n305 VSS.n54 17.0005
R330 VSS.n309 VSS.n54 17.0005
R331 VSS.n310 VSS.n54 17.0005
R332 VSS.n311 VSS.n54 17.0005
R333 VSS.n313 VSS.n54 17.0005
R334 VSS.n325 VSS.n54 17.0005
R335 VSS.n328 VSS.t38 17.0005
R336 VSS.t38 VSS.n312 17.0005
R337 VSS.t38 VSS.n327 17.0005
R338 VSS.n327 VSS.t37 17.0005
R339 VSS.n312 VSS.t37 17.0005
R340 VSS.n328 VSS.t37 17.0005
R341 VSS.n331 VSS.t34 17.0005
R342 VSS.n330 VSS.t34 17.0005
R343 VSS.n332 VSS.t34 17.0005
R344 VSS.t33 VSS.n330 17.0005
R345 VSS.n332 VSS.t33 17.0005
R346 VSS.t33 VSS.n331 17.0005
R347 VSS.t62 VSS.n143 16.6364
R348 VSS.t84 VSS.n159 16.6364
R349 VSS.t109 VSS.n55 15.1993
R350 VSS.n52 VSS.t135 15.1851
R351 VSS.t5 VSS.n389 15.1808
R352 VSS.n455 VSS.t25 15.1808
R353 VSS.n359 VSS.t47 15.0005
R354 VSS.n354 VSS.t39 15.0005
R355 VSS.t43 VSS.n288 15.0005
R356 VSS.t50 VSS.n291 15.0005
R357 VSS.n29 VSS.n62 13.8932
R358 VSS.n232 VSS.n33 13.3823
R359 VSS.n31 VSS.n111 13.3823
R360 VSS.n232 VSS.n27 13.3823
R361 VSS.n69 VSS.n21 14.4051
R362 VSS.n90 VSS.n15 7.20324
R363 VSS.n93 VSS.n2 14.4051
R364 VSS.n30 VSS.n111 13.3823
R365 VSS.t40 VSS.n28 13.3823
R366 VSS.n108 VSS.n10 14.4051
R367 VSS.n100 VSS.n14 7.20324
R368 VSS.n96 VSS.n22 14.4051
R369 VSS.n91 VSS.n15 14.4044
R370 VSS.n75 VSS.n23 7.20324
R371 VSS.n66 VSS.n18 14.4051
R372 VSS.t44 VSS.n16 7.20256
R373 VSS.n229 VSS.n29 13.3823
R374 VSS.n55 VSS.n54 0.00253296
R375 VSS.t4 VSS.n384 11.3857
R376 VSS.n460 VSS.t26 11.3857
R377 VSS.n374 VSS.n373 11.1339
R378 VSS.t57 VSS.n474 11.1339
R379 VSS.n480 VSS.n479 11.1339
R380 VSS.n469 VSS.n468 11.1339
R381 VSS.n464 VSS.n463 11.1339
R382 VSS.n459 VSS.n458 11.1339
R383 VSS.n454 VSS.n453 11.1339
R384 VSS.n449 VSS.n448 11.1339
R385 VSS.n444 VSS.n443 11.1339
R386 VSS.n439 VSS.n438 11.1339
R387 VSS.n434 VSS.n433 11.1339
R388 VSS.n429 VSS.n428 11.1339
R389 VSS.n424 VSS.n423 11.1339
R390 VSS.n419 VSS.n418 11.1339
R391 VSS.n414 VSS.n413 11.1339
R392 VSS.n409 VSS.n408 11.1339
R393 VSS.n404 VSS.n403 11.1339
R394 VSS.n399 VSS.n398 11.1339
R395 VSS.n394 VSS.n393 11.1339
R396 VSS.n389 VSS.n388 11.1339
R397 VSS.n384 VSS.n383 11.1339
R398 VSS.n379 VSS.n378 11.1339
R399 VSS.t54 VSS.n369 11.1339
R400 VSS.n370 VSS.t54 11.1339
R401 VSS.n376 VSS.n375 11.1339
R402 VSS.n381 VSS.n380 11.1339
R403 VSS.n386 VSS.n385 11.1339
R404 VSS.n391 VSS.n390 11.1339
R405 VSS.n396 VSS.n395 11.1339
R406 VSS.n401 VSS.n400 11.1339
R407 VSS.n406 VSS.n405 11.1339
R408 VSS.n411 VSS.n410 11.1339
R409 VSS.n416 VSS.n415 11.1339
R410 VSS.n421 VSS.n420 11.1339
R411 VSS.n426 VSS.n425 11.1339
R412 VSS.n431 VSS.n430 11.1339
R413 VSS.n436 VSS.n435 11.1339
R414 VSS.n441 VSS.n440 11.1339
R415 VSS.n446 VSS.n445 11.1339
R416 VSS.n451 VSS.n450 11.1339
R417 VSS.n456 VSS.n455 11.1339
R418 VSS.n461 VSS.n460 11.1339
R419 VSS.n466 VSS.n465 11.1339
R420 VSS.n471 VSS.n470 11.1339
R421 VSS.n475 VSS.t57 11.1339
R422 VSS.n144 VSS.t60 11.0911
R423 VSS.t86 VSS.n160 11.0911
R424 VSS.n118 VSS.n480 1.88951
R425 VSS.n119 VSS.n118 0.34847
R426 VSS.n6 VSS.n0 0.0310862
R427 VSS.n113 VSS.n229 8.5005
R428 VSS.n113 VSS.n232 8.5005
R429 VSS.n113 VSS.n75 8.5005
R430 VSS.n113 VSS.n77 8.5005
R431 VSS.n113 VSS.n90 8.5005
R432 VSS.n113 VSS.n92 8.5005
R433 VSS.n113 VSS.n95 8.5005
R434 VSS.n113 VSS.n97 8.5005
R435 VSS.n113 VSS.n100 8.5005
R436 VSS.n113 VSS.n102 8.5005
R437 VSS.n113 VSS.t40 8.5005
R438 VSS.n113 VSS.n111 8.5005
R439 VSS.n0 VSS.n228 8.4984
R440 VSS.n0 VSS.n227 8.4984
R441 VSS.n0 VSS.n186 8.4984
R442 VSS.n0 VSS.n225 8.4984
R443 VSS.n0 VSS.n124 8.4984
R444 VSS.n0 VSS.n188 8.4984
R445 VSS.n0 VSS.n189 8.4984
R446 VSS.n0 VSS.n190 8.4984
R447 VSS.n0 VSS.n191 8.4984
R448 VSS.n0 VSS.n192 8.4984
R449 VSS.n0 VSS.n193 8.4984
R450 VSS.n0 VSS.n223 8.4984
R451 VSS.n0 VSS.n222 8.4984
R452 VSS.n0 VSS.n221 8.4984
R453 VSS.n0 VSS.n196 8.4984
R454 VSS.n0 VSS.n197 8.4984
R455 VSS.n0 VSS.n198 8.4984
R456 VSS.n0 VSS.n199 8.4984
R457 VSS.n0 VSS.n219 8.4984
R458 VSS.n0 VSS.n218 8.4984
R459 VSS.n0 VSS.n216 8.4984
R460 VSS.n0 VSS.n215 8.4984
R461 VSS.n0 VSS.n214 8.4984
R462 VSS.n0 VSS.n202 8.4984
R463 VSS.n0 VSS.n203 8.4984
R464 VSS.n0 VSS.n204 8.4984
R465 VSS.n0 VSS.n205 8.4984
R466 VSS.n0 VSS.n206 8.4984
R467 VSS.n0 VSS.n207 8.4984
R468 VSS.n0 VSS.n121 8.4984
R469 VSS.n0 VSS.n212 8.4984
R470 VSS.n0 VSS.n211 8.4984
R471 VSS.n0 VSS.n210 8.4984
R472 VSS.n0 VSS.n209 8.4984
R473 VSS.n0 VSS.n208 8.4984
R474 VSS.n113 VSS.n231 8.4984
R475 VSS.n113 VSS.n233 8.4984
R476 VSS.n113 VSS.n235 8.4984
R477 VSS.n113 VSS.n237 8.4984
R478 VSS.n113 VSS.n238 8.4984
R479 VSS.n113 VSS.n239 8.4984
R480 VSS.n113 VSS.n240 8.4984
R481 VSS.n113 VSS.n241 8.4984
R482 VSS.n113 VSS.n242 8.4984
R483 VSS.n113 VSS.n243 8.4984
R484 VSS.n113 VSS.n244 8.4984
R485 VSS.n113 VSS.n245 8.4984
R486 VSS.n113 VSS.n246 8.4984
R487 VSS.n113 VSS.n248 8.4984
R488 VSS.n113 VSS.n249 8.4984
R489 VSS.n113 VSS.n251 8.4984
R490 VSS.n113 VSS.n252 8.4984
R491 VSS.n113 VSS.n253 8.4984
R492 VSS.n113 VSS.n254 8.4984
R493 VSS.n113 VSS.n255 8.4984
R494 VSS.n113 VSS.n256 8.4984
R495 VSS.n113 VSS.n258 8.4984
R496 VSS.n113 VSS.n260 8.4984
R497 VSS.n113 VSS.n262 8.4984
R498 VSS.n113 VSS.n263 8.4984
R499 VSS.n113 VSS.n265 8.4984
R500 VSS.n113 VSS.n266 8.4984
R501 VSS.n113 VSS.n267 8.4984
R502 VSS.n113 VSS.n268 8.4984
R503 VSS.n113 VSS.n269 8.4984
R504 VSS.n113 VSS.n270 8.4984
R505 VSS.n113 VSS.n271 8.4984
R506 VSS.n113 VSS.n272 8.4984
R507 VSS.n113 VSS.n273 8.4984
R508 VSS.n113 VSS.n274 8.4984
R509 VSS.n113 VSS.n275 8.4984
R510 VSS.n113 VSS.n276 8.4984
R511 VSS.n113 VSS.n277 8.4984
R512 VSS.n481 VSS.n114 8.49747
R513 VSS.n129 VSS.n114 0.00673459
R514 VSS.n182 VSS.n115 8.47188
R515 VSS.n503 VSS.n164 8.22525
R516 VSS.n344 VSS.n343 8.22525
R517 VSS.n343 VSS.n301 8.22525
R518 VSS.n504 VSS.n503 8.22525
R519 VSS.n363 VSS.n32 14.3619
R520 VSS.n53 VSS.t36 6.87897
R521 VSS.n54 VSS.n56 0.00129054
R522 VSS.t2 VSS.n379 7.59063
R523 VSS.n465 VSS.t28 7.59063
R524 VSS.n361 VSS.t47 7.49606
R525 VSS.t39 VSS.n353 7.49606
R526 VSS.n289 VSS.t43 7.49606
R527 VSS.n292 VSS.t50 7.49606
R528 VSS.n63 VSS.t44 7.20236
R529 VSS.n66 VSS.n160 7.20236
R530 VSS.n67 VSS.n131 7.20236
R531 VSS.n71 VSS.n26 14.4051
R532 VSS.n73 VSS.n25 14.4051
R533 VSS.n78 VSS.n135 7.20236
R534 VSS.n79 VSS.n155 7.20236
R535 VSS.n80 VSS.n136 7.20236
R536 VSS.n82 VSS.n137 7.20236
R537 VSS.n84 VSS.n138 7.20236
R538 VSS.n86 VSS.n139 7.20236
R539 VSS.n88 VSS.n140 7.20236
R540 VSS.n98 VSS.n142 7.20236
R541 VSS.n103 VSS.n143 7.20236
R542 VSS.n105 VSS.n144 7.20236
R543 VSS.n107 VSS.n145 7.20236
R544 VSS.n110 VSS.n28 13.8932
R545 VSS.n110 VSS.n31 13.8932
R546 VSS.n108 VSS.n34 13.8932
R547 VSS.n107 VSS.n10 14.4044
R548 VSS.n106 VSS.n146 7.20236
R549 VSS.n105 VSS.n20 14.4051
R550 VSS.n104 VSS.n147 7.20236
R551 VSS.n103 VSS.n24 14.4051
R552 VSS.n101 VSS.n3 14.4051
R553 VSS.n99 VSS.n148 7.20236
R554 VSS.n98 VSS.n5 14.4051
R555 VSS.n96 VSS.n12 14.4051
R556 VSS.n94 VSS.n149 7.20236
R557 VSS.n93 VSS.n141 7.20236
R558 VSS.n91 VSS.n13 14.4051
R559 VSS.n89 VSS.n150 7.20236
R560 VSS.n88 VSS.n1 14.4051
R561 VSS.n87 VSS.n151 7.20236
R562 VSS.n86 VSS.n9 14.4051
R563 VSS.n85 VSS.n152 7.20236
R564 VSS.n84 VSS.n7 14.6209
R565 VSS.n83 VSS.n153 7.20236
R566 VSS.n82 VSS.n17 14.4051
R567 VSS.n81 VSS.n154 7.20236
R568 VSS.n80 VSS.n11 14.4051
R569 VSS.n78 VSS.n4 14.4051
R570 VSS.n76 VSS.n8 14.4051
R571 VSS.n74 VSS.n156 7.20236
R572 VSS.n73 VSS.n134 7.20236
R573 VSS.n72 VSS.n157 7.20236
R574 VSS.n71 VSS.n133 7.20236
R575 VSS.n70 VSS.n158 7.20236
R576 VSS.n69 VSS.n132 7.20236
R577 VSS.n68 VSS.n159 7.20236
R578 VSS.n67 VSS.n19 14.4051
R579 VSS.n65 VSS.n130 7.20236
R580 VSS.n64 VSS.n161 7.20236
R581 VSS.n63 VSS.n33 13.8932
R582 VSS.n62 VSS.n16 14.4051
R583 VSS.n0 VSS.n162 1.70042
R584 VSS.n364 VSS.n0 1.70084
R585 VSS.n145 VSS.t59 5.54579
R586 VSS.t87 VSS.n161 5.54579
R587 VSS.n362 VSS.t49 4.5005
R588 VSS.t42 VSS.n352 4.5005
R589 VSS.t51 VSS.n285 4.5005
R590 VSS.t45 VSS.n287 4.5005
R591 VSS.n113 VSS.n109 4.25219
R592 VSS.n0 VSS.n61 4.25206
R593 VSS.n113 VSS.n61 4.25175
R594 VSS.n0 VSS.n109 4.25169
R595 VSS.n119 VSS.n365 6777.14
R596 VSS.n346 VSS.n345 4.11287
R597 VSS.n346 VSS.n165 4.11287
R598 VSS.t0 VSS.n374 3.79557
R599 VSS.n470 VSS.t29 3.79557
R600 VSS.n179 VSS.t56 3.0005
R601 VSS.n499 VSS.t53 3.0005
R602 VSS.n326 VSS.t35 3.0005
R603 VSS.t31 VSS.n333 3.0005
R604 VSS.n360 VSS.n358 3.0005
R605 VSS.n356 VSS.n355 3.0005
R606 VSS.n294 VSS.n293 3.0005
R607 VSS.n286 VSS.n284 3.0005
R608 VSS.n472 VSS.n118 2.93453
R609 VSS.n467 VSS.n118 2.93453
R610 VSS.n462 VSS.n118 2.93453
R611 VSS.n457 VSS.n118 2.93453
R612 VSS.n452 VSS.n118 2.93453
R613 VSS.n447 VSS.n118 2.93453
R614 VSS.n442 VSS.n118 2.93453
R615 VSS.n437 VSS.n118 2.93453
R616 VSS.n432 VSS.n118 2.93453
R617 VSS.n427 VSS.n118 2.93453
R618 VSS.n417 VSS.n118 2.93453
R619 VSS.n412 VSS.n118 2.93453
R620 VSS.n407 VSS.n118 2.93453
R621 VSS.n402 VSS.n118 2.93453
R622 VSS.n397 VSS.n118 2.93453
R623 VSS.n392 VSS.n118 2.93453
R624 VSS.n387 VSS.n118 2.93453
R625 VSS.n382 VSS.n118 2.93453
R626 VSS.n377 VSS.n118 2.93453
R627 VSS.n373 VSS.n118 2.93453
R628 VSS.n478 VSS.n118 2.93453
R629 VSS.n476 VSS.n118 2.93453
R630 VSS.n474 VSS.n118 2.93453
R631 VSS.n479 VSS.n114 2.93453
R632 VSS.n477 VSS.n114 2.93453
R633 VSS.n475 VSS.n114 2.93453
R634 VSS.n473 VSS.n114 2.93453
R635 VSS.n471 VSS.n114 2.93453
R636 VSS.n468 VSS.n114 2.93453
R637 VSS.n466 VSS.n114 2.93453
R638 VSS.n463 VSS.n114 2.93453
R639 VSS.n461 VSS.n114 2.93453
R640 VSS.n458 VSS.n114 2.93453
R641 VSS.n456 VSS.n114 2.93453
R642 VSS.n453 VSS.n114 2.93453
R643 VSS.n451 VSS.n114 2.93453
R644 VSS.n448 VSS.n114 2.93453
R645 VSS.n446 VSS.n114 2.93453
R646 VSS.n443 VSS.n114 2.93453
R647 VSS.n441 VSS.n114 2.93453
R648 VSS.n438 VSS.n114 2.93453
R649 VSS.n436 VSS.n114 2.93453
R650 VSS.n433 VSS.n114 2.93453
R651 VSS.n431 VSS.n114 2.93453
R652 VSS.n428 VSS.n114 2.93453
R653 VSS.n426 VSS.n114 2.93453
R654 VSS.n423 VSS.n114 2.93453
R655 VSS.n421 VSS.n114 2.93453
R656 VSS.n418 VSS.n114 2.93453
R657 VSS.n416 VSS.n114 2.93453
R658 VSS.n413 VSS.n114 2.93453
R659 VSS.n411 VSS.n114 2.93453
R660 VSS.n408 VSS.n114 2.93453
R661 VSS.n406 VSS.n114 2.93453
R662 VSS.n403 VSS.n114 2.93453
R663 VSS.n401 VSS.n114 2.93453
R664 VSS.n398 VSS.n114 2.93453
R665 VSS.n396 VSS.n114 2.93453
R666 VSS.n393 VSS.n114 2.93453
R667 VSS.n391 VSS.n114 2.93453
R668 VSS.n388 VSS.n114 2.93453
R669 VSS.n386 VSS.n114 2.93453
R670 VSS.n383 VSS.n114 2.93453
R671 VSS.n381 VSS.n114 2.93453
R672 VSS.n378 VSS.n114 2.93453
R673 VSS.n376 VSS.n114 2.93453
R674 VSS.n372 VSS.n114 2.93453
R675 VSS.n370 VSS.n114 2.93453
R676 VSS.n368 VSS.n114 2.93453
R677 VSS.n366 VSS.n114 2.93453
R678 VSS.n371 VSS.n118 2.93453
R679 VSS.n369 VSS.n118 2.93453
R680 VSS.n367 VSS.n118 2.93453
R681 VSS.n301 VSS.n300 2.71193
R682 VSS.n506 VSS.n505 2.6297
R683 VSS.n422 VSS.n118 2.54286
R684 VSS.n500 VSS.t3 2.4821
R685 VSS.n501 VSS.t6 2.4821
R686 VSS.n502 VSS.t9 2.4821
R687 VSS.n169 VSS.t12 2.4821
R688 VSS.t18 VSS.n168 2.4821
R689 VSS.n176 VSS.t21 2.4821
R690 VSS.n177 VSS.t24 2.4821
R691 VSS.n178 VSS.t27 2.4821
R692 VSS.t134 VSS.n314 2.4821
R693 VSS.n315 VSS.t131 2.4821
R694 VSS.t128 VSS.n316 2.4821
R695 VSS.t125 VSS.n302 2.4821
R696 VSS.t119 VSS.n303 2.4821
R697 VSS.n306 VSS.t116 2.4821
R698 VSS.n307 VSS.t113 2.4821
R699 VSS.n308 VSS.t110 2.4821
R700 VSS.n351 VSS.t89 2.4821
R701 VSS.n351 VSS.t61 2.4821
R702 VSS.n350 VSS.t91 2.4821
R703 VSS.n350 VSS.t64 2.4821
R704 VSS.n349 VSS.t93 2.4821
R705 VSS.n349 VSS.t67 2.4821
R706 VSS.n348 VSS.t95 2.4821
R707 VSS.n348 VSS.t70 2.4821
R708 VSS.n299 VSS.t99 2.4821
R709 VSS.n299 VSS.t76 2.4821
R710 VSS.n298 VSS.t101 2.4821
R711 VSS.n298 VSS.t79 2.4821
R712 VSS.n297 VSS.t103 2.4821
R713 VSS.n297 VSS.t82 2.4821
R714 VSS.n296 VSS.t105 2.4821
R715 VSS.n296 VSS.t85 2.4821
R716 VSS.n0 VSS.n28 1.20771
R717 VSS.n32 VSS.n229 13.3823
R718 VSS.n0 VSS.n27 1.20771
R719 VSS.n0 VSS.n21 0.650675
R720 VSS.n0 VSS.n1 0.650675
R721 VSS.n0 VSS.n2 0.650675
R722 VSS.n0 VSS.n22 0.650675
R723 VSS.n34 VSS.t40 13.3823
R724 VSS.n0 VSS.n30 1.20771
R725 VSS.t48 VSS.n362 2.2505
R726 VSS.n352 VSS.t41 2.2505
R727 VSS.n285 VSS.t52 2.2505
R728 VSS.n287 VSS.t46 2.2505
R729 VSS.n484 VSS.n118 2.09947
R730 VSS.n486 VSS.n118 2.09947
R731 VSS.n488 VSS.n118 2.09947
R732 VSS.n166 VSS.n118 2.09947
R733 VSS.n490 VSS.n118 2.09947
R734 VSS.n492 VSS.n118 2.09947
R735 VSS.n494 VSS.n118 2.09947
R736 VSS.n496 VSS.n118 2.09947
R737 VSS.n340 VSS.n54 2.09868
R738 VSS.n336 VSS.n54 2.09868
R739 VSS.n338 VSS.n54 2.09868
R740 VSS.n320 VSS.n54 2.09866
R741 VSS.n318 VSS.n54 2.09865
R742 VSS.n54 VSS.n128 2.09859
R743 VSS.n342 VSS.n54 2.09857
R744 VSS.n322 VSS.n54 2.09849
R745 VSS.n129 VSS.n181 1.37591
R746 VSS.n364 VSS.n112 1.53502
R747 VSS.n162 VSS.n363 1.53502
R748 VSS.n499 VSS.n170 1.52811
R749 VSS.n327 VSS.n326 1.52811
R750 VSS.n333 VSS.n332 1.52811
R751 VSS.n180 VSS.n179 1.52811
R752 VSS.n330 VSS.n329 1.42147
R753 VSS.n329 VSS.n328 1.37896
R754 VSS.n113 VSS.t48 1.08267
R755 VSS.n113 VSS.t52 1.03721
R756 VSS.n482 VSS.n118 1.0282
R757 VSS.n498 VSS.n118 0.91152
R758 VSS.n334 VSS.n54 0.910334
R759 VSS.n324 VSS.n54 0.909162
R760 VSS.n113 VSS.n62 0.650322
R761 VSS.n113 VSS.n63 0.650322
R762 VSS.n113 VSS.n64 0.650322
R763 VSS.n113 VSS.n65 0.650322
R764 VSS.n113 VSS.n66 0.650322
R765 VSS.n113 VSS.n67 0.650322
R766 VSS.n113 VSS.n68 0.650322
R767 VSS.n113 VSS.n69 0.650322
R768 VSS.n113 VSS.n70 0.650322
R769 VSS.n113 VSS.n71 0.650322
R770 VSS.n113 VSS.n72 0.650322
R771 VSS.n113 VSS.n73 0.650322
R772 VSS.n113 VSS.n74 0.650322
R773 VSS.n113 VSS.n76 0.650322
R774 VSS.n113 VSS.n78 0.650322
R775 VSS.n113 VSS.n79 0.650322
R776 VSS.n113 VSS.n80 0.650322
R777 VSS.n113 VSS.n81 0.650322
R778 VSS.n113 VSS.n82 0.650322
R779 VSS.n113 VSS.n83 0.650322
R780 VSS.n113 VSS.n84 0.650322
R781 VSS.n113 VSS.n85 0.650322
R782 VSS.n113 VSS.n86 0.650322
R783 VSS.n113 VSS.n87 0.650322
R784 VSS.n113 VSS.n88 0.650322
R785 VSS.n113 VSS.n89 0.650322
R786 VSS.n113 VSS.n91 0.650322
R787 VSS.n113 VSS.n93 0.650322
R788 VSS.n113 VSS.n94 0.650322
R789 VSS.n113 VSS.n96 0.650322
R790 VSS.n113 VSS.n98 0.650322
R791 VSS.n113 VSS.n99 0.650322
R792 VSS.n113 VSS.n101 0.650322
R793 VSS.n113 VSS.n103 0.650322
R794 VSS.n113 VSS.n104 0.650322
R795 VSS.n113 VSS.n105 0.650322
R796 VSS.n113 VSS.n106 0.650322
R797 VSS.n113 VSS.n107 0.650322
R798 VSS.n113 VSS.n108 0.650322
R799 VSS.n113 VSS.n110 0.650322
R800 VSS.n344 VSS.n300 0.632727
R801 VSS.n507 VSS.n506 0.5505
R802 VSS.n345 VSS.n164 0.2444
R803 VSS.n345 VSS.n344 0.2444
R804 VSS.n504 VSS.n165 0.2444
R805 VSS.n301 VSS.n165 0.2444
R806 VSS.n500 VSS.n499 0.209825
R807 VSS.n326 VSS.n314 0.209825
R808 VSS.n333 VSS.n308 0.209825
R809 VSS.n179 VSS.n178 0.209825
R810 VSS.n497 VSS.t3 0.201663
R811 VSS.n495 VSS.t6 0.201663
R812 VSS.n493 VSS.t9 0.201663
R813 VSS.n491 VSS.t12 0.201663
R814 VSS.n489 VSS.t18 0.201663
R815 VSS.n487 VSS.t21 0.201663
R816 VSS.n485 VSS.t24 0.201663
R817 VSS.n483 VSS.t27 0.201663
R818 VSS.n323 VSS.t134 0.201663
R819 VSS.n321 VSS.t131 0.201663
R820 VSS.n319 VSS.t128 0.201663
R821 VSS.n317 VSS.t125 0.201663
R822 VSS.n341 VSS.t119 0.201663
R823 VSS.n339 VSS.t116 0.201663
R824 VSS.n337 VSS.t113 0.201663
R825 VSS.n335 VSS.t110 0.201663
R826 VSS.n122 VSS.t89 0.201663
R827 VSS.t61 VSS.n122 0.201663
R828 VSS.n58 VSS.t91 0.201663
R829 VSS.t64 VSS.n58 0.201663
R830 VSS.n280 VSS.t93 0.201663
R831 VSS.t67 VSS.n280 0.201663
R832 VSS.n281 VSS.t95 0.201663
R833 VSS.t70 VSS.n281 0.201663
R834 VSS.n282 VSS.t99 0.201663
R835 VSS.t76 VSS.n282 0.201663
R836 VSS.n283 VSS.t101 0.201663
R837 VSS.t79 VSS.n283 0.201663
R838 VSS.n60 VSS.t103 0.201663
R839 VSS.t82 VSS.n60 0.201663
R840 VSS.n125 VSS.t105 0.201663
R841 VSS.t85 VSS.n125 0.201663
R842 VSS.n185 VSS.n182 0.187772
R843 VSS.t73 VSS.t97 0.185696
R844 VSS.n501 VSS.n500 0.16242
R845 VSS.n502 VSS.n501 0.16242
R846 VSS.n169 VSS.n502 0.16242
R847 VSS.n167 VSS.n169 0.16242
R848 VSS.n167 VSS.n168 0.16242
R849 VSS.n176 VSS.n168 0.16242
R850 VSS.n177 VSS.n176 0.16242
R851 VSS.n178 VSS.n177 0.16242
R852 VSS.n308 VSS.n307 0.16242
R853 VSS.n307 VSS.n306 0.16242
R854 VSS.n306 VSS.n303 0.16242
R855 VSS.n304 VSS.n303 0.16242
R856 VSS.n304 VSS.n302 0.16242
R857 VSS.n316 VSS.n302 0.16242
R858 VSS.n316 VSS.n315 0.16242
R859 VSS.n315 VSS.n314 0.16242
R860 VSS.n324 VSS.n323 0.14713
R861 VSS.n335 VSS.n334 0.145358
R862 VSS.n498 VSS.n497 0.144129
R863 VSS.n363 VSS.n113 0.139317
R864 VSS.n483 VSS.n482 0.138839
R865 VSS.n357 VSS.n351 0.117247
R866 VSS.n296 VSS.n295 0.1171
R867 VSS.n497 VSS.n496 0.0952183
R868 VSS.n336 VSS.n335 0.0942639
R869 VSS.n323 VSS.n322 0.0938811
R870 VSS.n495 VSS.n494 0.0927738
R871 VSS.n484 VSS.n483 0.0925656
R872 VSS.n338 VSS.n337 0.0918194
R873 VSS.n321 VSS.n320 0.091818
R874 VSS.n493 VSS.n492 0.0903294
R875 VSS.t15 VSS.n166 0.0903294
R876 VSS.n486 VSS.n485 0.0901212
R877 VSS.t122 VSS.n342 0.0893103
R878 VSS.t122 VSS.n128 0.0892445
R879 VSS.n340 VSS.n339 0.0889846
R880 VSS.n319 VSS.n318 0.088805
R881 VSS.n491 VSS.n490 0.0878849
R882 VSS.n489 VSS.n488 0.0878849
R883 VSS.n490 VSS.t15 0.0876767
R884 VSS.n488 VSS.n487 0.0876767
R885 VSS.n318 VSS.n317 0.086743
R886 VSS.n341 VSS.n340 0.086549
R887 VSS.n317 VSS.n128 0.0862916
R888 VSS.n342 VSS.n341 0.0862315
R889 VSS.n487 VSS.n486 0.0854405
R890 VSS.n492 VSS.n491 0.0852323
R891 VSS.n166 VSS.n489 0.0852323
R892 VSS.t53 VSS.n498 0.0847768
R893 VSS.n320 VSS.n319 0.0837243
R894 VSS.n339 VSS.n338 0.083723
R895 VSS.n334 VSS.t31 0.0834709
R896 VSS.n485 VSS.n484 0.082996
R897 VSS.n494 VSS.n493 0.0827878
R898 VSS.n507 VSS.n164 0.0827273
R899 VSS.n505 VSS.n504 0.0827273
R900 VSS.t35 VSS.n324 0.0825696
R901 VSS.n482 VSS.n481 0.0819126
R902 VSS.n322 VSS.n321 0.0816588
R903 VSS.n351 VSS.n350 0.08146
R904 VSS.n350 VSS.n349 0.08146
R905 VSS.n349 VSS.n348 0.08146
R906 VSS.n348 VSS.n347 0.08146
R907 VSS.n347 VSS.n299 0.08146
R908 VSS.n299 VSS.n298 0.08146
R909 VSS.n298 VSS.n297 0.08146
R910 VSS.n297 VSS.n296 0.08146
R911 VSS.n337 VSS.n336 0.0812785
R912 VSS.n496 VSS.n495 0.0803434
R913 VSS.t41 VSS.n6 1.05225
R914 VSS.n506 VSS 0.0445
R915 VSS.n300 VSS 0.0445
R916 VSS.n304 VSS.t122 0.0394179
R917 VSS.t15 VSS.n167 0.0394179
R918 VSS.n503 VSS.n167 0.0389615
R919 VSS.n343 VSS.n304 0.0389615
R920 VSS.t49 VSS.n361 0.031258
R921 VSS.n353 VSS.t42 0.031258
R922 VSS.n292 VSS.t51 0.031258
R923 VSS.n357 VSS.n356 0.0291125
R924 VSS.n295 VSS.n294 0.0291125
R925 VSS.n295 VSS.n284 0.0291125
R926 VSS.n358 VSS.n357 0.0291125
R927 VSS.n356 VSS.n352 0.0281144
R928 VSS.n294 VSS.n285 0.0281144
R929 VSS.n287 VSS.n284 0.0281144
R930 VSS.n362 VSS.n358 0.0281144
R931 VSS.n290 VSS.n289 0.0216549
R932 VSS.n288 VSS.t45 0.0208704
R933 VSS.n360 VSS.n359 0.0202884
R934 VSS.n355 VSS.n354 0.0202884
R935 VSS.n288 VSS.n286 0.0202884
R936 VSS.n293 VSS.n291 0.0202884
R937 VSS.n347 VSS.n346 0.0197308
R938 VSS.n347 VSS.t97 0.019449
R939 VSS.n290 VSS.n61 0.0162424
R940 VSS.n279 VSS.n109 0.0159649
R941 VSS.n185 VSS.n184 0.0140715
R942 VSS.n171 VSS.t56 0.0133922
R943 VSS.t53 VSS.n163 0.0133922
R944 VSS.t35 VSS.n325 0.0133922
R945 VSS.t31 VSS.n305 0.0133922
R946 VSS.n231 VSS.n228 0.0118857
R947 VSS.n233 VSS.n227 0.0118857
R948 VSS.n235 VSS.n186 0.0118857
R949 VSS.n237 VSS.n225 0.0118857
R950 VSS.n238 VSS.n188 0.0118857
R951 VSS.n239 VSS.n188 0.0118857
R952 VSS.n240 VSS.n189 0.0118857
R953 VSS.n241 VSS.n190 0.0118857
R954 VSS.n243 VSS.n191 0.0118857
R955 VSS.n244 VSS.n193 0.0118857
R956 VSS.n245 VSS.n193 0.0118857
R957 VSS.n248 VSS.n223 0.0118857
R958 VSS.n249 VSS.n221 0.0118857
R959 VSS.n252 VSS.n196 0.0118857
R960 VSS.n253 VSS.n198 0.0118857
R961 VSS.n254 VSS.n198 0.0118857
R962 VSS.n255 VSS.n199 0.0118857
R963 VSS.n256 VSS.n199 0.0118857
R964 VSS.n258 VSS.n219 0.0118857
R965 VSS.n262 VSS.n216 0.0118857
R966 VSS.n263 VSS.n214 0.0118857
R967 VSS.n265 VSS.n202 0.0118857
R968 VSS.n266 VSS.n202 0.0118857
R969 VSS.n267 VSS.n203 0.0118857
R970 VSS.n268 VSS.n204 0.0118857
R971 VSS.n269 VSS.n205 0.0118857
R972 VSS.n270 VSS.n205 0.0118857
R973 VSS.n271 VSS.n207 0.0118857
R974 VSS.n272 VSS.n207 0.0118857
R975 VSS.n273 VSS.n121 0.0118857
R976 VSS.n274 VSS.n212 0.0118857
R977 VSS.n275 VSS.n211 0.0118857
R978 VSS.n276 VSS.n210 0.0118857
R979 VSS.n277 VSS.n208 0.0118857
R980 VSS.n277 VSS.n209 0.0118857
R981 VSS.n276 VSS.n209 0.0118857
R982 VSS.n275 VSS.n210 0.0118857
R983 VSS.n274 VSS.n211 0.0118857
R984 VSS.n273 VSS.n212 0.0118857
R985 VSS.n271 VSS.n206 0.0118857
R986 VSS.n270 VSS.n206 0.0118857
R987 VSS.n267 VSS.n204 0.0118857
R988 VSS.n266 VSS.n203 0.0118857
R989 VSS.n263 VSS.n215 0.0118857
R990 VSS.n262 VSS.n215 0.0118857
R991 VSS.n258 VSS.n218 0.0118857
R992 VSS.n253 VSS.n197 0.0118857
R993 VSS.n252 VSS.n197 0.0118857
R994 VSS.n251 VSS.n196 0.0118857
R995 VSS.n249 VSS.n222 0.0118857
R996 VSS.n248 VSS.n222 0.0118857
R997 VSS.n244 VSS.n192 0.0118857
R998 VSS.n243 VSS.n192 0.0118857
R999 VSS.n242 VSS.n191 0.0118857
R1000 VSS.n240 VSS.n190 0.0118857
R1001 VSS.n239 VSS.n189 0.0118857
R1002 VSS.n237 VSS.n124 0.0118857
R1003 VSS.n231 VSS.n227 0.0118857
R1004 VSS.n359 VSS.n279 0.0115582
R1005 VSS.n354 VSS.n279 0.0115582
R1006 VSS.n291 VSS.n290 0.0112672
R1007 VSS.n54 VSS.n35 0.0112168
R1008 VSS.n54 VSS.n36 0.0112168
R1009 VSS.n54 VSS.n37 0.0112168
R1010 VSS.n54 VSS.n38 0.0112168
R1011 VSS.n54 VSS.n39 0.0112168
R1012 VSS.n54 VSS.n40 0.0112168
R1013 VSS.n54 VSS.n41 0.0112168
R1014 VSS.n54 VSS.n42 0.0112168
R1015 VSS.n54 VSS.n44 0.0112168
R1016 VSS.n54 VSS.n45 0.0112168
R1017 VSS.n54 VSS.n46 0.0112168
R1018 VSS.n54 VSS.n47 0.0112168
R1019 VSS.n54 VSS.n48 0.0112168
R1020 VSS.n54 VSS.n49 0.0112168
R1021 VSS.n54 VSS.n50 0.0112168
R1022 VSS.n54 VSS.n51 0.0112168
R1023 VSS.n54 VSS.n52 0.0112168
R1024 VSS.n261 VSS.n201 0.0108889
R1025 VSS.n257 VSS.n200 0.0108889
R1026 VSS.n247 VSS.n195 0.0108889
R1027 VSS.n236 VSS.n187 0.0108889
R1028 VSS.n234 VSS.n226 0.0108889
R1029 VSS.n361 VSS.n360 0.0108877
R1030 VSS.n355 VSS.n353 0.0108877
R1031 VSS.n289 VSS.n286 0.0108877
R1032 VSS.n293 VSS.n292 0.0108877
R1033 VSS.n290 VSS.t46 0.0101032
R1034 VSS.n290 VSS.t52 0.0101032
R1035 VSS.t48 VSS.n279 0.00981217
R1036 VSS.t41 VSS.n279 0.00981217
R1037 VSS.n54 VSS.n43 0.00963963
R1038 VSS VSS.n507 0.0095
R1039 VSS.n505 VSS 0.0095
R1040 VSS.n122 VSS.n120 0.00936111
R1041 VSS.n125 VSS.n123 0.00936111
R1042 VSS.n481 VSS.t56 0.00931464
R1043 VSS.n58 VSS.n57 0.00481859
R1044 VSS.n60 VSS.n59 0.00481859
R1045 VSS.n180 VSS.n175 0.00798582
R1046 VSS.n180 VSS.n126 0.00798582
R1047 VSS.n173 VSS.n170 0.00798582
R1048 VSS.n172 VSS.n170 0.00798582
R1049 VSS.n327 VSS.n311 0.00798582
R1050 VSS.n327 VSS.n313 0.00798582
R1051 VSS.n332 VSS.n310 0.00798582
R1052 VSS.n332 VSS.n309 0.00798582
R1053 VSS.n174 VSS.n171 0.00756994
R1054 VSS.n175 VSS.n174 0.00756994
R1055 VSS.n181 VSS.n126 0.00756994
R1056 VSS.n183 VSS.n163 0.00756994
R1057 VSS.n183 VSS.n173 0.00756994
R1058 VSS.n184 VSS.n172 0.00756994
R1059 VSS.n328 VSS.n311 0.00756994
R1060 VSS.n313 VSS.n312 0.00756994
R1061 VSS.n325 VSS.n312 0.00756994
R1062 VSS.n330 VSS.n310 0.00756994
R1063 VSS.n331 VSS.n309 0.00756994
R1064 VSS.n331 VSS.n305 0.00756994
R1065 VSS.n182 VSS.n129 1.61247
R1066 VSS.n113 VSS.n112 0.141883
R1067 VSS.n241 VSS.n60 0.00894286
R1068 VSS.t97 VSS.n116 0.00891217
R1069 VSS.n125 VSS.n124 0.00772064
R1070 VSS.n122 VSS.n121 0.00772064
R1071 VSS.n280 VSS.n264 0.00691667
R1072 VSS.t97 VSS.n117 0.00691667
R1073 VSS.n283 VSS.n224 0.00691667
R1074 VSS.n279 VSS.n278 0.00630556
R1075 VSS.n250 VSS.n221 0.00619286
R1076 VSS.n259 VSS.n218 0.00619286
R1077 VSS.n264 VSS.n214 0.00619286
R1078 VSS.n278 VSS.n208 0.00619286
R1079 VSS.n242 VSS.n59 0.0105114
R1080 VSS.n269 VSS.n58 0.00894286
R1081 VSS.n246 VSS.n224 0.00619286
R1082 VSS.n251 VSS.n220 0.00619286
R1083 VSS.n260 VSS.n201 0.00619286
R1084 VSS.n272 VSS.n120 0.00619286
R1085 VSS.n268 VSS.n57 0.0105114
R1086 VSS.n265 VSS.n213 0.00619286
R1087 VSS.n261 VSS.n216 0.00619286
R1088 VSS.n260 VSS.n217 0.00619286
R1089 VSS.n257 VSS.n219 0.00619286
R1090 VSS.n256 VSS.n200 0.00619286
R1091 VSS.n255 VSS.n117 0.00619286
R1092 VSS.n254 VSS.n116 0.00619286
R1093 VSS.n247 VSS.n223 0.00619286
R1094 VSS.n246 VSS.n195 0.00619286
R1095 VSS.n245 VSS.n194 0.00619286
R1096 VSS.n238 VSS.n123 0.00619286
R1097 VSS.n236 VSS.n225 0.00619286
R1098 VSS.n235 VSS.n187 0.00619286
R1099 VSS.n234 VSS.n186 0.00619286
R1100 VSS.n233 VSS.n226 0.00619286
R1101 VSS.n230 VSS.n228 0.00619286
R1102 VSS.n290 VSS.n230 0.00615278
R1103 VSS.n281 VSS.n217 0.00569444
R1104 VSS.n281 VSS.n259 0.00569444
R1105 VSS.n282 VSS.n220 0.00569444
R1106 VSS.n282 VSS.n250 0.00569444
R1107 VSS.n280 VSS.n213 0.00447222
R1108 VSS.n283 VSS.n194 0.00447222
R1109 VSS.n54 VSS.n53 0.00482001
R1110 VSS.n115 VSS.n114 0.0027855
R1111 VSS.n118 VSS.n115 0.00242831
R1112 VSS.n6 VSS.t46 1.04146
R1113 VSS.n329 VSS.n54 0.00390992
R1114 VSS.n56 VSS.n365 6777.49
C0 vout4 VDD 15.3949f
C1 vin4 VDD 29.2329f
C2 vin2 vin1 0.05053f
C3 vin4 vin3 0.05053f
C4 VDD vout3 15.3834f
C5 vin4 vout4 18.2968f
C6 vin2 vout2 18.2968f
C7 vin3 vout3 18.2968f
C8 vin2 VDD 29.202f
C9 vin1 VDD 29.2329f
C10 vin1 vout1 18.2968f
C11 vin2 vin3 0.05785f
C12 vout2 VDD 15.3834f
C13 vout1 VDD 15.3949f
C14 vin3 VDD 29.202f
C15 vout1 VSS 13.57609f
C16 vout2 VSS 13.55759f
C17 vout3 VSS 13.55759f
C18 vout4 VSS 13.57609f
C19 VSS.t105 VSS 8.00945f
C20 VSS.t24 VSS 8.0271f
C21 VSS.t76 VSS 8.00945f
.ends

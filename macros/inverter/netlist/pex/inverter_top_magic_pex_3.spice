* PEX produced on Mon Aug 24 02:46:23 PM CEST 2026 using /foss/tools/sak/sak-pex.sh with m=3 and s=1 (extresist threshold=10000 mOhm, minres=1000 mOhm, mindelay=1 ps)
* NGSPICE file created from inverter_top_pex.ext - technology: ihp-sg13g2

.subckt inverter_top_pex VDD vin4 vout4 VSS vin3 vout3 vin2 vout2 vout1 vin1
X0 vout3 vin3 VSS.t105 VSS.t86 sg13_lv_nmos ad=0.19p pd=1.38u as=0.19p ps=1.38u w=1u l=1u
X1 VDD VDD VDD VDD sg13_lv_pmos ad=1.14p pd=6.38u as=0.56797n ps=1.006m w=6u l=1u
X2 VSS.t1 VSS.t53 VSS.t55 VSS.t54 sg13_lv_nmos ad=0.34p pd=2.68u as=0 ps=0 w=1u l=1u
X3 VDD VDD VDD VDD sg13_lv_pmos ad=1.14p pd=6.38u as=0 ps=0 w=6u l=1u
X4 VDD vin4 vout4 VDD sg13_lv_pmos ad=1.14p pd=6.38u as=1.14p ps=6.38u w=6u l=1u
X5 vout2 vin2 VSS.t76 VSS.t77 sg13_lv_nmos ad=0.19p pd=1.38u as=0.19p ps=1.38u w=1u l=1u
X6 vout3 vin3 VDD VDD sg13_lv_pmos ad=1.14p pd=6.38u as=1.14p ps=6.38u w=6u l=1u
X7 vout4 vin4 VSS.t110 VSS.t111 sg13_lv_nmos ad=0.19p pd=1.38u as=0.19p ps=1.38u w=1u l=1u
X8 vout3 vin3 VSS.t42 VSS.t59 sg13_lv_nmos ad=0.19p pd=1.38u as=0.19p ps=1.38u w=1u l=1u
X9 vout2 vin2 VSS.t70 VSS.t71 sg13_lv_nmos ad=0.19p pd=1.38u as=0.19p ps=1.38u w=1u l=1u
X10 vout4 vin4 VDD VDD sg13_lv_pmos ad=1.14p pd=6.38u as=1.14p ps=6.38u w=6u l=1u
X11 VDD vin2 vout2 VDD sg13_lv_pmos ad=1.14p pd=6.38u as=1.14p ps=6.38u w=6u l=1u
X12 VSS.t76 vin2 vout2 VSS.t75 sg13_lv_nmos ad=0.19p pd=1.38u as=0.19p ps=1.38u w=1u l=1u
X13 vout2 vin2 VSS.t79 VSS.t80 sg13_lv_nmos ad=0.19p pd=1.38u as=0.19p ps=1.38u w=1u l=1u
X14 vout2 vin2 VDD VDD sg13_lv_pmos ad=1.14p pd=6.38u as=1.14p ps=6.38u w=6u l=1u
X15 VSS.t116 vin4 vout4 VSS.t115 sg13_lv_nmos ad=0.19p pd=1.38u as=0.19p ps=1.38u w=1u l=1u
X16 vout1 vin1 VSS.t24 VSS.t25 sg13_lv_nmos ad=0.19p pd=1.38u as=0.19p ps=1.38u w=1u l=1u
X17 VDD vin2 vout2 VDD sg13_lv_pmos ad=1.14p pd=6.38u as=1.14p ps=6.38u w=6u l=1u
X18 vout4 vin4 VSS.t34 VSS.t108 sg13_lv_nmos ad=0.19p pd=1.38u as=0.19p ps=1.38u w=1u l=1u
X19 VDD vin2 vout2 VDD sg13_lv_pmos ad=1.14p pd=6.38u as=1.14p ps=6.38u w=6u l=1u
X20 VSS.t105 vin3 vout3 VSS.t84 sg13_lv_nmos ad=0.19p pd=1.38u as=0.19p ps=1.38u w=1u l=1u
X21 vout4 vin4 VSS.t125 VSS.t126 sg13_lv_nmos ad=0.19p pd=1.38u as=0.19p ps=1.38u w=1u l=1u
X22 VSS.t119 vin4 vout4 VSS.t118 sg13_lv_nmos ad=0.19p pd=1.38u as=0.19p ps=1.38u w=1u l=1u
X23 VDD vin3 vout3 VDD sg13_lv_pmos ad=1.14p pd=6.38u as=1.14p ps=6.38u w=6u l=1u
X24 VDD vin2 vout2 VDD sg13_lv_pmos ad=1.14p pd=6.38u as=1.14p ps=6.38u w=6u l=1u
X25 vout3 vin3 VDD VDD sg13_lv_pmos ad=1.14p pd=6.38u as=1.14p ps=6.38u w=6u l=1u
X26 VSS.t70 vin2 vout2 VSS.t69 sg13_lv_nmos ad=0.19p pd=1.38u as=0.19p ps=1.38u w=1u l=1u
X27 VDD vin3 vout3 VDD sg13_lv_pmos ad=1.14p pd=6.38u as=1.14p ps=6.38u w=6u l=1u
X28 VSS.t42 VSS.t39 VSS.t41 VSS.t40 sg13_lv_nmos ad=0.34p pd=2.68u as=0 ps=0 w=1u l=1u
X29 vout2 vin2 VDD VDD sg13_lv_pmos ad=1.14p pd=6.38u as=1.14p ps=6.38u w=6u l=1u
X30 vout2 vin2 VSS.t73 VSS.t74 sg13_lv_nmos ad=0.19p pd=1.38u as=0.19p ps=1.38u w=1u l=1u
X31 vout1 vin1 VSS.t18 VSS.t19 sg13_lv_nmos ad=0.19p pd=1.38u as=0.19p ps=1.38u w=1u l=1u
X32 VSS.t79 vin2 vout2 VSS.t78 sg13_lv_nmos ad=0.19p pd=1.38u as=0.19p ps=1.38u w=1u l=1u
X33 vout4 vin4 VSS.t122 VSS.t123 sg13_lv_nmos ad=0.19p pd=1.38u as=0.19p ps=1.38u w=1u l=1u
X34 vout1 vin1 VDD VDD sg13_lv_pmos ad=1.14p pd=6.38u as=1.14p ps=6.38u w=6u l=1u
X35 vout1 vin1 VSS.t12 VSS.t13 sg13_lv_nmos ad=0.19p pd=1.38u as=0.19p ps=1.38u w=1u l=1u
X36 VSS.t128 vin4 vout4 VSS.t127 sg13_lv_nmos ad=0.19p pd=1.38u as=0.19p ps=1.38u w=1u l=1u
X37 VDD VDD VDD VDD sg13_lv_pmos ad=1.14p pd=6.38u as=0 ps=0 w=6u l=1u
X38 VSS.t18 vin1 vout1 VSS.t17 sg13_lv_nmos ad=0.19p pd=1.38u as=0.19p ps=1.38u w=1u l=1u
X39 vout2 vin2 VDD VDD sg13_lv_pmos ad=1.14p pd=6.38u as=1.14p ps=6.38u w=6u l=1u
X40 VDD vin4 vout4 VDD sg13_lv_pmos ad=1.14p pd=6.38u as=1.14p ps=6.38u w=6u l=1u
X41 vout1 vin1 VSS.t21 VSS.t22 sg13_lv_nmos ad=0.19p pd=1.38u as=0.19p ps=1.38u w=1u l=1u
X42 vout3 vin3 VSS.t103 VSS.t83 sg13_lv_nmos ad=0.19p pd=1.38u as=0.19p ps=1.38u w=1u l=1u
X43 VDD vin3 vout3 VDD sg13_lv_pmos ad=1.14p pd=6.38u as=1.14p ps=6.38u w=6u l=1u
X44 vout4 vin4 VDD VDD sg13_lv_pmos ad=1.14p pd=6.38u as=1.14p ps=6.38u w=6u l=1u
X45 VDD vin4 vout4 VDD sg13_lv_pmos ad=1.14p pd=6.38u as=1.14p ps=6.38u w=6u l=1u
X46 vout3 vin3 VDD VDD sg13_lv_pmos ad=1.14p pd=6.38u as=1.14p ps=6.38u w=6u l=1u
X47 VDD vin3 vout3 VDD sg13_lv_pmos ad=1.14p pd=6.38u as=1.14p ps=6.38u w=6u l=1u
X48 VSS.t38 VSS.t35 VSS.t37 VSS.t36 sg13_lv_nmos ad=0.19p pd=1.38u as=0 ps=0 w=1u l=1u
X49 VDD vin4 vout4 VDD sg13_lv_pmos ad=1.14p pd=6.38u as=1.14p ps=6.38u w=6u l=1u
X50 VDD vin2 vout2 VDD sg13_lv_pmos ad=1.14p pd=6.38u as=1.14p ps=6.38u w=6u l=1u
X51 VSS.t131 vin4 vout4 VSS.t130 sg13_lv_nmos ad=0.19p pd=1.38u as=0.19p ps=1.38u w=1u l=1u
X52 VDD vin3 vout3 VDD sg13_lv_pmos ad=1.14p pd=6.38u as=1.14p ps=6.38u w=6u l=1u
X53 VSS.t12 vin1 vout1 VSS.t11 sg13_lv_nmos ad=0.19p pd=1.38u as=0.19p ps=1.38u w=1u l=1u
X54 VDD vin1 vout1 VDD sg13_lv_pmos ad=1.14p pd=6.38u as=1.14p ps=6.38u w=6u l=1u
X55 vout4 vin4 VSS.t134 VSS.t135 sg13_lv_nmos ad=0.19p pd=1.38u as=0.19p ps=1.38u w=1u l=1u
X56 vout1 vin1 VDD VDD sg13_lv_pmos ad=1.14p pd=6.38u as=1.14p ps=6.38u w=6u l=1u
X57 vout4 vin4 VDD VDD sg13_lv_pmos ad=1.14p pd=6.38u as=1.14p ps=6.38u w=6u l=1u
X58 vout1 vin1 VSS.t15 VSS.t16 sg13_lv_nmos ad=0.19p pd=1.38u as=0.19p ps=1.38u w=1u l=1u
X59 VDD vin1 vout1 VDD sg13_lv_pmos ad=1.14p pd=6.38u as=1.14p ps=6.38u w=6u l=1u
X60 vout3 vin3 VSS.t99 VSS.t77 sg13_lv_nmos ad=0.19p pd=1.38u as=0.19p ps=1.38u w=1u l=1u
X61 VSS.t21 vin1 vout1 VSS.t20 sg13_lv_nmos ad=0.19p pd=1.38u as=0.19p ps=1.38u w=1u l=1u
X62 VDD VDD VDD VDD sg13_lv_pmos ad=2.04p pd=12.68u as=0 ps=0 w=6u l=1u
X63 vout4 vin4 VDD VDD sg13_lv_pmos ad=1.14p pd=6.38u as=1.14p ps=6.38u w=6u l=1u
X64 VDD vin3 vout3 VDD sg13_lv_pmos ad=1.14p pd=6.38u as=1.14p ps=6.38u w=6u l=1u
X65 VDD vin4 vout4 VDD sg13_lv_pmos ad=1.14p pd=6.38u as=1.14p ps=6.38u w=6u l=1u
X66 vout3 vin3 VDD VDD sg13_lv_pmos ad=1.14p pd=6.38u as=1.14p ps=6.38u w=6u l=1u
X67 vout3 vin3 VSS.t95 VSS.t71 sg13_lv_nmos ad=0.19p pd=1.38u as=0.19p ps=1.38u w=1u l=1u
X68 VSS.t99 vin3 vout3 VSS.t75 sg13_lv_nmos ad=0.19p pd=1.38u as=0.19p ps=1.38u w=1u l=1u
X69 VDD VDD VDD VDD sg13_lv_pmos ad=1.14p pd=6.38u as=0 ps=0 w=6u l=1u
X70 vout3 vin3 VSS.t101 VSS.t80 sg13_lv_nmos ad=0.19p pd=1.38u as=0.19p ps=1.38u w=1u l=1u
X71 vout4 vin4 VDD VDD sg13_lv_pmos ad=1.14p pd=6.38u as=1.14p ps=6.38u w=6u l=1u
X72 vout3 vin3 VDD VDD sg13_lv_pmos ad=1.14p pd=6.38u as=1.14p ps=6.38u w=6u l=1u
X73 VDD vin1 vout1 VDD sg13_lv_pmos ad=1.14p pd=6.38u as=1.14p ps=6.38u w=6u l=1u
X74 vout2 vin2 VDD VDD sg13_lv_pmos ad=1.14p pd=6.38u as=1.14p ps=6.38u w=6u l=1u
X75 vout1 vin1 VDD VDD sg13_lv_pmos ad=1.14p pd=6.38u as=1.14p ps=6.38u w=6u l=1u
X76 vout2 vin2 VSS.t64 VSS.t65 sg13_lv_nmos ad=0.19p pd=1.38u as=0.19p ps=1.38u w=1u l=1u
X77 VDD vin1 vout1 VDD sg13_lv_pmos ad=1.14p pd=6.38u as=1.14p ps=6.38u w=6u l=1u
X78 VDD vin1 vout1 VDD sg13_lv_pmos ad=1.14p pd=6.38u as=1.14p ps=6.38u w=6u l=1u
X79 VDD vin3 vout3 VDD sg13_lv_pmos ad=1.14p pd=6.38u as=1.14p ps=6.38u w=6u l=1u
X80 VSS.t95 vin3 vout3 VSS.t69 sg13_lv_nmos ad=0.19p pd=1.38u as=0.19p ps=1.38u w=1u l=1u
X81 vout3 vin3 VSS.t97 VSS.t74 sg13_lv_nmos ad=0.19p pd=1.38u as=0.19p ps=1.38u w=1u l=1u
X82 VSS.t113 vin4 vout4 VSS.t112 sg13_lv_nmos ad=0.19p pd=1.38u as=0.19p ps=1.38u w=1u l=1u
X83 VDD vin4 vout4 VDD sg13_lv_pmos ad=1.14p pd=6.38u as=1.14p ps=6.38u w=6u l=1u
X84 VSS.t101 vin3 vout3 VSS.t78 sg13_lv_nmos ad=0.19p pd=1.38u as=0.19p ps=1.38u w=1u l=1u
X85 vout4 vin4 VSS.t116 VSS.t117 sg13_lv_nmos ad=0.19p pd=1.38u as=0.19p ps=1.38u w=1u l=1u
X86 VDD vin1 vout1 VDD sg13_lv_pmos ad=1.14p pd=6.38u as=1.14p ps=6.38u w=6u l=1u
X87 vout2 vin2 VDD VDD sg13_lv_pmos ad=1.14p pd=6.38u as=1.14p ps=6.38u w=6u l=1u
X88 vout1 vin1 VDD VDD sg13_lv_pmos ad=1.14p pd=6.38u as=1.14p ps=6.38u w=6u l=1u
X89 VSS.t110 vin4 vout4 VSS.t109 sg13_lv_nmos ad=0.19p pd=1.38u as=0.19p ps=1.38u w=1u l=1u
X90 VDD VDD VDD VDD sg13_lv_pmos ad=2.04p pd=12.68u as=0 ps=0 w=6u l=1u
X91 vout2 vin2 VDD VDD sg13_lv_pmos ad=1.14p pd=6.38u as=1.14p ps=6.38u w=6u l=1u
X92 VDD vin2 vout2 VDD sg13_lv_pmos ad=1.14p pd=6.38u as=1.14p ps=6.38u w=6u l=1u
X93 VSS.t64 vin2 vout2 VSS.t63 sg13_lv_nmos ad=0.19p pd=1.38u as=0.19p ps=1.38u w=1u l=1u
X94 VSS.t122 vin4 vout4 VSS.t121 sg13_lv_nmos ad=0.19p pd=1.38u as=0.19p ps=1.38u w=1u l=1u
X95 vout2 vin2 VDD VDD sg13_lv_pmos ad=1.14p pd=6.38u as=1.14p ps=6.38u w=6u l=1u
X96 VDD VDD VDD VDD sg13_lv_pmos ad=2.04p pd=12.68u as=0 ps=0 w=6u l=1u
X97 vout2 vin2 VSS.t67 VSS.t68 sg13_lv_nmos ad=0.19p pd=1.38u as=0.19p ps=1.38u w=1u l=1u
X98 VSS.t73 vin2 vout2 VSS.t72 sg13_lv_nmos ad=0.19p pd=1.38u as=0.19p ps=1.38u w=1u l=1u
X99 vout1 vin1 VDD VDD sg13_lv_pmos ad=1.14p pd=6.38u as=1.14p ps=6.38u w=6u l=1u
X100 vout1 vin1 VSS.t6 VSS.t7 sg13_lv_nmos ad=0.19p pd=1.38u as=0.19p ps=1.38u w=1u l=1u
X101 vout4 vin4 VSS.t119 VSS.t120 sg13_lv_nmos ad=0.19p pd=1.38u as=0.19p ps=1.38u w=1u l=1u
X102 vout3 vin3 VDD VDD sg13_lv_pmos ad=1.14p pd=6.38u as=1.14p ps=6.38u w=6u l=1u
X103 vout4 vin4 VSS.t131 VSS.t132 sg13_lv_nmos ad=0.19p pd=1.38u as=0.19p ps=1.38u w=1u l=1u
X104 VSS.t52 VSS.t50 VSS.t51 VSS.t44 sg13_lv_nmos ad=0.19p pd=1.38u as=0 ps=0 w=1u l=1u
X105 VSS.t125 vin4 vout4 VSS.t124 sg13_lv_nmos ad=0.19p pd=1.38u as=0.19p ps=1.38u w=1u l=1u
X106 VDD vin1 vout1 VDD sg13_lv_pmos ad=1.14p pd=6.38u as=1.14p ps=6.38u w=6u l=1u
X107 VSS.t51 vin2 vout2 VSS.t87 sg13_lv_nmos ad=0.19p pd=1.38u as=0.19p ps=1.38u w=1u l=1u
X108 VDD vin2 vout2 VDD sg13_lv_pmos ad=1.14p pd=6.38u as=1.14p ps=6.38u w=6u l=1u
X109 vout4 vin4 VSS.t128 VSS.t129 sg13_lv_nmos ad=0.19p pd=1.38u as=0.19p ps=1.38u w=1u l=1u
X110 vout4 vin4 VDD VDD sg13_lv_pmos ad=1.14p pd=6.38u as=1.14p ps=6.38u w=6u l=1u
X111 vout2 vin2 VDD VDD sg13_lv_pmos ad=1.14p pd=6.38u as=1.14p ps=6.38u w=6u l=1u
X112 vout2 vin2 VSS.t61 VSS.t62 sg13_lv_nmos ad=0.19p pd=1.38u as=0.19p ps=1.38u w=1u l=1u
X113 VDD vin2 vout2 VDD sg13_lv_pmos ad=1.14p pd=6.38u as=1.14p ps=6.38u w=6u l=1u
X114 VSS.t67 vin2 vout2 VSS.t66 sg13_lv_nmos ad=0.19p pd=1.38u as=0.19p ps=1.38u w=1u l=1u
X115 VDD vin4 vout4 VDD sg13_lv_pmos ad=1.14p pd=6.38u as=1.14p ps=6.38u w=6u l=1u
X116 VDD VDD VDD VDD sg13_lv_pmos ad=2.04p pd=12.68u as=0 ps=0 w=6u l=1u
X117 VSS.t61 vin2 vout2 VSS.t60 sg13_lv_nmos ad=0.19p pd=1.38u as=0.19p ps=1.38u w=1u l=1u
X118 VSS.t6 vin1 vout1 VSS.t5 sg13_lv_nmos ad=0.19p pd=1.38u as=0.19p ps=1.38u w=1u l=1u
X119 vout3 vin3 VDD VDD sg13_lv_pmos ad=1.14p pd=6.38u as=1.14p ps=6.38u w=6u l=1u
X120 vout1 vin1 VSS.t9 VSS.t10 sg13_lv_nmos ad=0.19p pd=1.38u as=0.19p ps=1.38u w=1u l=1u
X121 VSS.t15 vin1 vout1 VSS.t14 sg13_lv_nmos ad=0.19p pd=1.38u as=0.19p ps=1.38u w=1u l=1u
X122 vout3 vin3 VDD VDD sg13_lv_pmos ad=1.14p pd=6.38u as=1.14p ps=6.38u w=6u l=1u
X123 VDD vin3 vout3 VDD sg13_lv_pmos ad=1.14p pd=6.38u as=1.14p ps=6.38u w=6u l=1u
X124 vout3 vin3 VDD VDD sg13_lv_pmos ad=1.14p pd=6.38u as=1.14p ps=6.38u w=6u l=1u
X125 vout3 vin3 VSS.t91 VSS.t65 sg13_lv_nmos ad=0.19p pd=1.38u as=0.19p ps=1.38u w=1u l=1u
X126 VSS.t82 vin2 vout2 VSS.t81 sg13_lv_nmos ad=0.19p pd=1.38u as=0.19p ps=1.38u w=1u l=1u
X127 vout1 vin1 VDD VDD sg13_lv_pmos ad=1.14p pd=6.38u as=1.14p ps=6.38u w=6u l=1u
X128 vout2 vin2 VSS.t85 VSS.t86 sg13_lv_nmos ad=0.19p pd=1.38u as=0.19p ps=1.38u w=1u l=1u
X129 VSS.t37 vin4 vout4 VSS.t136 sg13_lv_nmos ad=0.19p pd=1.38u as=0.19p ps=1.38u w=1u l=1u
X130 VSS.t58 VSS.t56 VSS.t30 VSS.t57 sg13_lv_nmos ad=0.19p pd=1.38u as=0 ps=0 w=1u l=1u
X131 VSS.t30 vin1 vout1 VSS.t29 sg13_lv_nmos ad=0.19p pd=1.38u as=0.19p ps=1.38u w=1u l=1u
X132 vout2 vin2 VSS.t49 VSS.t59 sg13_lv_nmos ad=0.19p pd=1.38u as=0.19p ps=1.38u w=1u l=1u
X133 VSS.t34 VSS.t31 VSS.t33 VSS.t32 sg13_lv_nmos ad=0.34p pd=2.68u as=0 ps=0 w=1u l=1u
X134 vout1 vin1 VSS.t3 VSS.t4 sg13_lv_nmos ad=0.19p pd=1.38u as=0.19p ps=1.38u w=1u l=1u
X135 VSS.t9 vin1 vout1 VSS.t8 sg13_lv_nmos ad=0.19p pd=1.38u as=0.19p ps=1.38u w=1u l=1u
X136 VDD vin3 vout3 VDD sg13_lv_pmos ad=1.14p pd=6.38u as=1.14p ps=6.38u w=6u l=1u
X137 VSS.t3 vin1 vout1 VSS.t2 sg13_lv_nmos ad=0.19p pd=1.38u as=0.19p ps=1.38u w=1u l=1u
X138 vout4 vin4 VDD VDD sg13_lv_pmos ad=1.14p pd=6.38u as=1.14p ps=6.38u w=6u l=1u
X139 vout3 vin3 VDD VDD sg13_lv_pmos ad=1.14p pd=6.38u as=1.14p ps=6.38u w=6u l=1u
X140 VDD vin3 vout3 VDD sg13_lv_pmos ad=1.14p pd=6.38u as=1.14p ps=6.38u w=6u l=1u
X141 VSS.t91 vin3 vout3 VSS.t63 sg13_lv_nmos ad=0.19p pd=1.38u as=0.19p ps=1.38u w=1u l=1u
X142 vout3 vin3 VSS.t93 VSS.t68 sg13_lv_nmos ad=0.19p pd=1.38u as=0.19p ps=1.38u w=1u l=1u
X143 vout1 vin1 VDD VDD sg13_lv_pmos ad=1.14p pd=6.38u as=1.14p ps=6.38u w=6u l=1u
X144 VSS.t85 vin2 vout2 VSS.t84 sg13_lv_nmos ad=0.19p pd=1.38u as=0.19p ps=1.38u w=1u l=1u
X145 VSS.t97 vin3 vout3 VSS.t72 sg13_lv_nmos ad=0.19p pd=1.38u as=0.19p ps=1.38u w=1u l=1u
X146 VDD vin4 vout4 VDD sg13_lv_pmos ad=1.14p pd=6.38u as=1.14p ps=6.38u w=6u l=1u
X147 vout1 vin1 VDD VDD sg13_lv_pmos ad=1.14p pd=6.38u as=1.14p ps=6.38u w=6u l=1u
X148 VDD vin1 vout1 VDD sg13_lv_pmos ad=1.14p pd=6.38u as=1.14p ps=6.38u w=6u l=1u
X149 vout4 vin4 VDD VDD sg13_lv_pmos ad=1.14p pd=6.38u as=1.14p ps=6.38u w=6u l=1u
X150 VSS.t24 vin1 vout1 VSS.t23 sg13_lv_nmos ad=0.19p pd=1.38u as=0.19p ps=1.38u w=1u l=1u
X151 vout1 vin1 VSS.t27 VSS.t28 sg13_lv_nmos ad=0.19p pd=1.38u as=0.19p ps=1.38u w=1u l=1u
X152 vout1 vin1 VDD VDD sg13_lv_pmos ad=1.14p pd=6.38u as=1.14p ps=6.38u w=6u l=1u
X153 vout2 vin2 VDD VDD sg13_lv_pmos ad=1.14p pd=6.38u as=1.14p ps=6.38u w=6u l=1u
X154 vout4 vin4 VSS.t113 VSS.t114 sg13_lv_nmos ad=0.19p pd=1.38u as=0.19p ps=1.38u w=1u l=1u
X155 VSS.t49 VSS.t47 VSS.t48 VSS.t40 sg13_lv_nmos ad=0.34p pd=2.68u as=0 ps=0 w=1u l=1u
X156 VSS.t46 VSS.t43 VSS.t45 VSS.t44 sg13_lv_nmos ad=0.19p pd=1.38u as=0 ps=0 w=1u l=1u
X157 vout4 vin4 VDD VDD sg13_lv_pmos ad=1.14p pd=6.38u as=1.14p ps=6.38u w=6u l=1u
X158 VSS.t45 vin3 vout3 VSS.t87 sg13_lv_nmos ad=0.19p pd=1.38u as=0.19p ps=1.38u w=1u l=1u
X159 VSS.t134 vin4 vout4 VSS.t133 sg13_lv_nmos ad=0.19p pd=1.38u as=0.19p ps=1.38u w=1u l=1u
X160 VDD vin4 vout4 VDD sg13_lv_pmos ad=1.14p pd=6.38u as=1.14p ps=6.38u w=6u l=1u
X161 vout1 vin1 VSS.t1 VSS.t0 sg13_lv_nmos ad=0.19p pd=1.38u as=0.19p ps=1.38u w=1u l=1u
X162 vout3 vin3 VSS.t89 VSS.t62 sg13_lv_nmos ad=0.19p pd=1.38u as=0.19p ps=1.38u w=1u l=1u
X163 VSS.t93 vin3 vout3 VSS.t66 sg13_lv_nmos ad=0.19p pd=1.38u as=0.19p ps=1.38u w=1u l=1u
X164 vout4 vin4 VDD VDD sg13_lv_pmos ad=1.14p pd=6.38u as=1.14p ps=6.38u w=6u l=1u
X165 vout2 vin2 VSS.t82 VSS.t83 sg13_lv_nmos ad=0.19p pd=1.38u as=0.19p ps=1.38u w=1u l=1u
X166 VSS.t89 vin3 vout3 VSS.t60 sg13_lv_nmos ad=0.19p pd=1.38u as=0.19p ps=1.38u w=1u l=1u
X167 VDD vin1 vout1 VDD sg13_lv_pmos ad=1.14p pd=6.38u as=1.14p ps=6.38u w=6u l=1u
X168 vout1 vin1 VDD VDD sg13_lv_pmos ad=1.14p pd=6.38u as=1.14p ps=6.38u w=6u l=1u
X169 VDD vin1 vout1 VDD sg13_lv_pmos ad=1.14p pd=6.38u as=1.14p ps=6.38u w=6u l=1u
X170 VDD vin4 vout4 VDD sg13_lv_pmos ad=1.14p pd=6.38u as=1.14p ps=6.38u w=6u l=1u
X171 VSS.t27 vin1 vout1 VSS.t26 sg13_lv_nmos ad=0.19p pd=1.38u as=0.19p ps=1.38u w=1u l=1u
X172 VDD vin2 vout2 VDD sg13_lv_pmos ad=1.14p pd=6.38u as=1.14p ps=6.38u w=6u l=1u
X173 vout2 vin2 VDD VDD sg13_lv_pmos ad=1.14p pd=6.38u as=1.14p ps=6.38u w=6u l=1u
X174 VDD vin2 vout2 VDD sg13_lv_pmos ad=1.14p pd=6.38u as=1.14p ps=6.38u w=6u l=1u
X175 VSS.t103 vin3 vout3 VSS.t81 sg13_lv_nmos ad=0.19p pd=1.38u as=0.19p ps=1.38u w=1u l=1u
R0 VSS.n64 VSS.n185 6777.49
R1 VSS.n318 VSS.n64 6777.49
R2 VSS.n318 VSS.n317 1580.41
R3 VSS.n316 VSS.n185 1580.41
R4 VSS.n316 VSS.n11 1.53566
R5 VSS.t59 VSS.n205 88.7251
R6 VSS.n141 VSS.t87 88.7251
R7 VSS.t60 VSS.n206 83.1798
R8 VSS.t86 VSS.n187 83.1798
R9 VSS.t62 VSS.n207 77.6345
R10 VSS.n188 VSS.t84 77.6345
R11 VSS.t36 VSS.n64 6.87897
R12 VSS.t63 VSS.n208 72.0892
R13 VSS.n189 VSS.t83 72.0892
R14 VSS.n64 VSS.t135 12.2976
R15 VSS.t65 VSS.n209 66.5439
R16 VSS.n190 VSS.t81 66.5439
R17 VSS.n64 VSS.n87 0.00355238
R18 VSS.n64 VSS.t109 12.3005
R19 VSS.t66 VSS.n210 60.9987
R20 VSS.n191 VSS.t80 60.9987
R21 VSS.t133 VSS.n87 14.4648
R22 VSS.n64 VSS.t111 14.4672
R23 VSS.t132 VSS.n86 56.9354
R24 VSS.t28 VSS.n129 64.5222
R25 VSS.t68 VSS.n211 55.4534
R26 VSS.t72 VSS.n195 55.4534
R27 VSS.t74 VSS.n214 55.4534
R28 VSS.n192 VSS.t78 55.4534
R29 VSS.t130 VSS.n85 53.1403
R30 VSS.t69 VSS.n212 49.9081
R31 VSS.n196 VSS.t71 49.9081
R32 VSS.t75 VSS.n215 49.9081
R33 VSS.n193 VSS.t77 49.9081
R34 VSS.t129 VSS.n84 49.3453
R35 VSS.n76 VSS.t115 49.3407
R36 VSS.t25 VSS.n122 56.932
R37 VSS.t127 VSS.n83 45.5502
R38 VSS.t121 VSS.n79 45.5502
R39 VSS.n81 VSS.t123 45.5456
R40 VSS.n77 VSS.t117 45.5456
R41 VSS.t23 VSS.n133 53.1369
R42 VSS.n197 VSS.t69 44.3628
R43 VSS.t71 VSS.n213 44.3628
R44 VSS.n194 VSS.t75 44.3628
R45 VSS.t77 VSS.n216 44.3628
R46 VSS.t126 VSS.n82 41.7551
R47 VSS.t120 VSS.n78 41.7551
R48 VSS.n82 VSS.t124 41.7505
R49 VSS.n78 VSS.t118 41.7505
R50 VSS.t22 VSS.n132 49.3419
R51 VSS.n198 VSS.t68 38.8175
R52 VSS.n162 VSS.t72 38.8175
R53 VSS.n160 VSS.t74 38.8175
R54 VSS.t78 VSS.n217 38.8175
R55 VSS.t124 VSS.n81 37.9601
R56 VSS.t118 VSS.n77 37.9601
R57 VSS.n83 VSS.t126 37.9555
R58 VSS.n79 VSS.t120 37.9555
R59 VSS.t14 VSS.n127 45.5462
R60 VSS.t123 VSS.n80 34.1682
R61 VSS.t117 VSS.n76 34.165
R62 VSS.n80 VSS.t121 34.1635
R63 VSS.n84 VSS.t127 34.1604
R64 VSS.t13 VSS.n120 41.7525
R65 VSS.t19 VSS.n135 41.7518
R66 VSS.n199 VSS.t66 33.2722
R67 VSS.t80 VSS.n218 33.2722
R68 VSS.t115 VSS.n75 30.3776
R69 VSS.n85 VSS.t129 30.3653
R70 VSS.t17 VSS.n125 37.9567
R71 VSS.n200 VSS.t65 27.7269
R72 VSS.t81 VSS.n219 27.7269
R73 VSS.t114 VSS.n75 17.717
R74 VSS.n86 VSS.t130 26.5703
R75 VSS.t10 VSS.n123 34.1616
R76 VSS.n88 VSS.n318 6777.49
R77 VSS.t16 VSS.n130 34.1658
R78 VSS.t112 VSS.n64 16.2727
R79 VSS.t8 VSS.n136 30.3666
R80 VSS.t26 VSS.n126 60.7281
R81 VSS.t20 VSS.n121 45.5478
R82 VSS.n185 VSS.n88 6777.49
R83 VSS.n88 VSS.t54 6.87957
R84 VSS.n120 VSS.t11 41.7512
R85 VSS.n201 VSS.t63 22.1816
R86 VSS.t83 VSS.n220 22.1816
R87 VSS.t7 VSS.n131 26.5715
R88 VSS.t28 VSS.n92 15.1957
R89 VSS.n129 VSS.n88 0.0109013
R90 VSS.t26 VSS.n129 18.9817
R91 VSS.n126 VSS.n88 0.0108886
R92 VSS.n133 VSS.n88 0.0109013
R93 VSS.t22 VSS.n133 30.3669
R94 VSS.n132 VSS.n88 0.0108886
R95 VSS.n135 VSS.n88 0.0109013
R96 VSS.t17 VSS.n135 41.7521
R97 VSS.n125 VSS.n88 0.0109013
R98 VSS.t16 VSS.n125 45.5472
R99 VSS.n130 VSS.n88 0.00931161
R100 VSS.n120 VSS.n88 0.0111485
R101 VSS.n134 VSS.n88 0.0109013
R102 VSS.n123 VSS.n88 0.0109013
R103 VSS.t8 VSS.n123 49.3422
R104 VSS.n136 VSS.n88 0.0109013
R105 VSS.t7 VSS.n136 53.1373
R106 VSS.n89 VSS.n88 0.00248725
R107 VSS.n89 VSS.t2 15.1957
R108 VSS.n56 VSS.t56 0.0213927
R109 VSS.n88 VSS.n56 1.03963
R110 VSS.t58 VSS.n56 17.0005
R111 VSS.n62 VSS.n61 0.00513447
R112 VSS.n61 VSS.t30 8.50175
R113 VSS.t58 VSS.n61 8.501
R114 VSS.n56 VSS.t30 17.0005
R115 VSS.t0 VSS.n89 9.76942
R116 VSS.n88 VSS.n33 1.14067
R117 VSS.t1 VSS.n34 5.668
R118 VSS.n33 VSS.n34 0.0107214
R119 VSS.n34 VSS.t55 5.66889
R120 VSS.n0 VSS.n13 0.650675
R121 VSS.n0 VSS.n2 0.650675
R122 VSS.n0 VSS.n51 3.41835
R123 VSS.n2 VSS.t44 7.20256
R124 VSS.n0 VSS.n118 5.66421
R125 VSS.n28 VSS.n140 13.8932
R126 VSS.n22 VSS.n141 7.20256
R127 VSS.n0 VSS.n22 0.650675
R128 VSS.n0 VSS.n4 0.650675
R129 VSS.n4 VSS.n143 7.20256
R130 VSS.n0 VSS.n7 0.650675
R131 VSS.n7 VSS.n145 14.4044
R132 VSS.n0 VSS.n72 5.66421
R133 VSS.n0 VSS.n188 8.50154
R134 VSS.n15 VSS.n147 14.4044
R135 VSS.n0 VSS.n117 5.66355
R136 VSS.n24 VSS.n149 14.4044
R137 VSS.n0 VSS.n219 8.49951
R138 VSS.n117 VSS.n116 0.0154247
R139 VSS.n0 VSS.n21 0.650675
R140 VSS.n21 VSS.n151 14.4044
R141 VSS.n0 VSS.n191 8.49851
R142 VSS.n23 VSS.n153 14.4044
R143 VSS.n0 VSS.n99 5.66316
R144 VSS.n0 VSS.n192 8.49756
R145 VSS.n5 VSS.n155 14.4044
R146 VSS.n0 VSS.n193 8.49924
R147 VSS.n25 VSS.n157 14.4044
R148 VSS.n0 VSS.n114 5.66421
R149 VSS.n0 VSS.n3 0.650675
R150 VSS.n3 VSS.n159 14.4044
R151 VSS.n0 VSS.n214 8.49852
R152 VSS.n12 VSS.n161 14.6203
R153 VSS.n0 VSS.n9 0.650675
R154 VSS.n0 VSS.n90 5.66218
R155 VSS.n9 VSS.n162 7.20256
R156 VSS.n0 VSS.n112 5.66421
R157 VSS.n1 VSS.n164 14.4044
R158 VSS.n0 VSS.n10 0.650675
R159 VSS.n10 VSS.n166 14.4044
R160 VSS.n0 VSS.n212 8.49952
R161 VSS.n14 VSS.n168 14.4044
R162 VSS.n111 VSS.n261 0.0234783
R163 VSS.n0 VSS.n211 8.49993
R164 VSS.n0 VSS.n19 0.650675
R165 VSS.n0 VSS.n111 3.39604
R166 VSS.n0 VSS.n210 8.49798
R167 VSS.n0 VSS.n20 0.650675
R168 VSS.n0 VSS.n109 5.66421
R169 VSS.n20 VSS.n172 14.4044
R170 VSS.n17 VSS.n173 14.4044
R171 VSS.n0 VSS.n17 0.650675
R172 VSS.n70 VSS.n93 0.00859469
R173 VSS.n93 VSS.n108 0.0120259
R174 VSS.n0 VSS.n18 0.650675
R175 VSS.n18 VSS.n176 14.4044
R176 VSS.n0 VSS.n106 5.66421
R177 VSS.n0 VSS.n16 0.650675
R178 VSS.n16 VSS.n178 14.4044
R179 VSS.n0 VSS.n96 4.2472
R180 VSS.n0 VSS.n6 0.650675
R181 VSS.n0 VSS.n94 5.66421
R182 VSS.n6 VSS.n180 14.4044
R183 VSS.n0 VSS.n205 8.49998
R184 VSS.n0 VSS.n32 1.20771
R185 VSS.n27 VSS.n183 13.8932
R186 VSS.n184 VSS.n8 14.8732
R187 VSS.n0 VSS.n222 8.49777
R188 VSS.n0 VSS.n187 8.49358
R189 VSS.n0 VSS.n221 8.49752
R190 VSS.n0 VSS.n220 8.49728
R191 VSS.n0 VSS.n189 8.49383
R192 VSS.n0 VSS.n190 8.49911
R193 VSS.n0 VSS.n218 8.49703
R194 VSS.n0 VSS.n217 8.49774
R195 VSS.n0 VSS.n216 8.49678
R196 VSS.n0 VSS.n215 8.4973
R197 VSS.n0 VSS.n194 8.49407
R198 VSS.n0 VSS.n195 8.49432
R199 VSS.n0 VSS.n213 8.49921
R200 VSS.n0 VSS.n196 8.49456
R201 VSS.n0 VSS.n197 8.49481
R202 VSS.n0 VSS.n198 8.49505
R203 VSS.n0 VSS.n199 8.4953
R204 VSS.n0 VSS.n209 8.49828
R205 VSS.n0 VSS.n200 8.49826
R206 VSS.n0 VSS.n208 8.49915
R207 VSS.n0 VSS.n201 8.49554
R208 VSS.n0 VSS.n207 8.49653
R209 VSS.n0 VSS.n202 8.49579
R210 VSS.n0 VSS.n206 8.49628
R211 VSS.n0 VSS.n203 8.49604
R212 VSS.n0 VSS.n204 8.49937
R213 VSS.n0 VSS.n30 1.20771
R214 VSS.n105 VSS.n119 5.66316
R215 VSS.n57 VSS.n105 5.6635
R216 VSS.n116 VSS.n244 0.0136165
R217 VSS.n100 VSS.n105 5.66421
R218 VSS.n105 VSS.n115 5.66316
R219 VSS.n91 VSS.n105 5.66421
R220 VSS.n105 VSS.n113 5.66316
R221 VSS.n97 VSS.n105 4.24711
R222 VSS.n105 VSS.n110 5.66316
R223 VSS.n105 VSS.n107 5.66316
R224 VSS.n105 VSS.n95 5.66316
R225 VSS.n71 VSS.n105 5.66421
R226 VSS.n39 VSS.n40 0.0153095
R227 VSS.n37 VSS.n38 0.0153627
R228 VSS.t38 VSS.n65 17.0005
R229 VSS.t38 VSS.n37 8.49711
R230 VSS.n37 VSS.n36 0.0123024
R231 VSS.n36 VSS.t37 8.49535
R232 VSS.n66 VSS.t34 17.0005
R233 VSS.n39 VSS.t34 8.49711
R234 VSS.n39 VSS.n63 0.0123024
R235 VSS.t33 VSS.n63 8.49535
R236 VSS.n202 VSS.t62 16.6364
R237 VSS.t84 VSS.n221 16.6364
R238 VSS.t5 VSS.n124 22.7758
R239 VSS.t47 VSS.n43 4.99233
R240 VSS.n45 VSS.t39 4.99233
R241 VSS.n47 VSS.t43 4.99233
R242 VSS.t50 VSS.n50 4.99233
R243 VSS.n265 VSS.n30 13.3823
R244 VSS.n248 VSS.n28 13.3823
R245 VSS.n146 VSS.n15 14.4051
R246 VSS.n148 VSS.n24 14.4051
R247 VSS.n152 VSS.n23 14.4051
R248 VSS.n154 VSS.n5 14.4051
R249 VSS.n156 VSS.n25 14.4051
R250 VSS.n163 VSS.n1 14.4051
R251 VSS.n167 VSS.n14 14.4051
R252 VSS.n265 VSS.n27 13.3823
R253 VSS.n30 VSS.t40 6.69134
R254 VSS.n264 VSS.n26 13.3823
R255 VSS.n174 VSS.n17 14.4051
R256 VSS.n170 VSS.n19 14.4051
R257 VSS.n160 VSS.n12 7.20324
R258 VSS.n142 VSS.n22 14.4051
R259 VSS.n248 VSS.n29 13.3823
R260 VSS.n138 VSS.n13 14.4044
R261 VSS.t108 VSS.n64 9.77299
R262 VSS.t4 VSS.n128 18.9814
R263 VSS.t57 VSS.n88 6.87972
R264 VSS.n128 VSS.t2 64.5232
R265 VSS.n124 VSS.t4 60.7278
R266 VSS.n131 VSS.t5 56.933
R267 VSS.n134 VSS.t10 45.5468
R268 VSS.n127 VSS.t13 37.9574
R269 VSS.n130 VSS.t14 34.1648
R270 VSS.n121 VSS.t19 37.9567
R271 VSS.n132 VSS.t20 34.1626
R272 VSS.n122 VSS.t23 26.5725
R273 VSS.n126 VSS.t25 22.7764
R274 VSS.n203 VSS.t60 11.0911
R275 VSS.n143 VSS.t86 11.0911
R276 VSS.n0 VSS.n11 0.139615
R277 VSS.n317 VSS.n0 1.70099
R278 VSS.n105 VSS.n248 8.5005
R279 VSS.n105 VSS.n141 8.5005
R280 VSS.n105 VSS.n143 8.5005
R281 VSS.n105 VSS.n160 8.5005
R282 VSS.n105 VSS.n162 8.5005
R283 VSS.n105 VSS.n264 8.5005
R284 VSS.n105 VSS.n265 8.5005
R285 VSS.n118 VSS.t52 0.0161786
R286 VSS.n0 VSS.n247 8.4984
R287 VSS.n0 VSS.n246 8.4984
R288 VSS.n0 VSS.n245 8.4984
R289 VSS.n0 VSS.n58 8.4984
R290 VSS.n0 VSS.n232 8.4984
R291 VSS.n0 VSS.n103 8.4984
R292 VSS.n0 VSS.n244 8.4984
R293 VSS.n0 VSS.n243 8.4984
R294 VSS.n99 VSS.n98 0.00635632
R295 VSS.n0 VSS.n233 8.4984
R296 VSS.n0 VSS.n234 8.4984
R297 VSS.n0 VSS.n73 8.4984
R298 VSS.n0 VSS.n242 8.4984
R299 VSS.n0 VSS.n241 8.4984
R300 VSS.n90 VSS.t97 0.00783394
R301 VSS.n112 VSS.n259 0.0161786
R302 VSS.n0 VSS.n240 8.4984
R303 VSS.n0 VSS.n67 4.24569
R304 VSS.n67 VSS.n97 0.0157198
R305 VSS.n0 VSS.n239 8.4984
R306 VSS.n111 VSS.n101 0.0168109
R307 VSS.n0 VSS.n238 8.4984
R308 VSS.n0 VSS.n70 4.24592
R309 VSS.n106 VSS.n108 0.0179095
R310 VSS.n96 VSS.n107 0.0235971
R311 VSS.n94 VSS.n59 0.0161786
R312 VSS.n0 VSS.n237 8.4984
R313 VSS.n0 VSS.n236 8.4984
R314 VSS.n0 VSS.n235 8.4984
R315 VSS.n0 VSS.n31 0.76462
R316 VSS.n119 VSS.n118 0.014444
R317 VSS.n105 VSS.n249 8.4984
R318 VSS.n105 VSS.n250 8.4984
R319 VSS.n105 VSS.n251 8.4984
R320 VSS.n57 VSS.n72 0.0139355
R321 VSS.n105 VSS.n252 8.4984
R322 VSS.n105 VSS.n253 8.4984
R323 VSS.n105 VSS.n104 8.4984
R324 VSS.n105 VSS.n116 5.66443
R325 VSS.n105 VSS.n254 8.4984
R326 VSS.n105 VSS.n255 8.4984
R327 VSS.n105 VSS.n256 8.4984
R328 VSS.n105 VSS.n257 8.4984
R329 VSS.n105 VSS.n74 8.4984
R330 VSS.n115 VSS.n114 0.014444
R331 VSS.n105 VSS.n258 8.4984
R332 VSS.n105 VSS.n259 8.4984
R333 VSS.n113 VSS.n112 0.014444
R334 VSS.n105 VSS.n260 8.4984
R335 VSS.n105 VSS.n261 8.4984
R336 VSS.n105 VSS.n101 3.39543
R337 VSS.n110 VSS.n109 0.014444
R338 VSS.n105 VSS.n69 5.66294
R339 VSS.n105 VSS.n108 5.66443
R340 VSS.n107 VSS.n106 0.014444
R341 VSS.n105 VSS.n60 4.24427
R342 VSS.n60 VSS.n59 0.0123709
R343 VSS.n95 VSS.n94 0.014444
R344 VSS.n105 VSS.n262 8.4984
R345 VSS.n105 VSS.n263 8.4984
R346 VSS.n339 VSS.n54 8.22525
R347 VSS.n297 VSS.n296 8.22525
R348 VSS.n296 VSS.n267 8.22525
R349 VSS.n55 VSS.n339 8.22525
R350 VSS.n64 VSS.t32 6.87896
R351 VSS.n42 VSS.n43 0.0110412
R352 VSS.n45 VSS.n44 0.0110412
R353 VSS.n47 VSS.n46 0.0110412
R354 VSS.n49 VSS.n50 0.0110412
R355 VSS.n161 VSS.n9 14.6209
R356 VSS.n137 VSS.n11 14.8732
R357 VSS.n139 VSS.n29 13.8932
R358 VSS.n144 VSS.n187 7.20236
R359 VSS.n145 VSS.n221 7.20236
R360 VSS.n150 VSS.n21 14.4051
R361 VSS.n151 VSS.n218 7.20236
R362 VSS.n158 VSS.n194 7.20236
R363 VSS.n165 VSS.n196 7.20236
R364 VSS.n169 VSS.n198 7.20236
R365 VSS.n171 VSS.n199 7.20236
R366 VSS.n175 VSS.n201 7.20236
R367 VSS.n176 VSS.n207 7.20236
R368 VSS.n177 VSS.n202 7.20236
R369 VSS.n178 VSS.n206 7.20236
R370 VSS.n179 VSS.n203 7.20236
R371 VSS.n181 VSS.n204 7.20236
R372 VSS.n182 VSS.n26 13.8932
R373 VSS.n183 VSS.n8 14.4051
R374 VSS.n182 VSS.t40 7.20236
R375 VSS.n181 VSS.n32 13.8932
R376 VSS.n180 VSS.n205 7.20236
R377 VSS.n179 VSS.n6 14.4051
R378 VSS.n177 VSS.n16 14.4051
R379 VSS.n175 VSS.n18 14.4051
R380 VSS.n174 VSS.n208 7.20236
R381 VSS.n173 VSS.n200 7.20236
R382 VSS.n172 VSS.n209 7.20236
R383 VSS.n171 VSS.n20 14.4051
R384 VSS.n170 VSS.n210 7.20236
R385 VSS.n169 VSS.n19 14.4044
R386 VSS.n168 VSS.n211 7.20236
R387 VSS.n167 VSS.n197 7.20236
R388 VSS.n166 VSS.n212 7.20236
R389 VSS.n165 VSS.n10 14.4051
R390 VSS.n164 VSS.n213 7.20236
R391 VSS.n163 VSS.n195 7.20236
R392 VSS.n159 VSS.n214 7.20236
R393 VSS.n158 VSS.n3 14.4051
R394 VSS.n157 VSS.n215 7.20236
R395 VSS.n156 VSS.n193 7.20236
R396 VSS.n155 VSS.n216 7.20236
R397 VSS.n154 VSS.n192 7.20236
R398 VSS.n153 VSS.n217 7.20236
R399 VSS.n152 VSS.n191 7.20236
R400 VSS.n150 VSS.n190 7.20236
R401 VSS.n149 VSS.n219 7.20236
R402 VSS.n148 VSS.n189 7.20236
R403 VSS.n147 VSS.n220 7.20236
R404 VSS.n146 VSS.n188 7.20236
R405 VSS.n144 VSS.n7 14.4051
R406 VSS.n142 VSS.n4 14.4051
R407 VSS.n140 VSS.n222 7.20236
R408 VSS.n139 VSS.t44 7.20236
R409 VSS.n138 VSS.n2 14.4051
R410 VSS.n137 VSS.n13 14.4051
R411 VSS.n204 VSS.t59 5.54579
R412 VSS.t87 VSS.n222 5.54579
R413 VSS.n301 VSS.t49 4.5005
R414 VSS.t42 VSS.n52 4.5005
R415 VSS.n300 VSS.t51 4.5005
R416 VSS.n315 VSS.t45 4.5005
R417 VSS.n105 VSS.n31 4.26635
R418 VSS.n105 VSS.n51 0.756375
R419 VSS.n299 VSS.n298 4.11287
R420 VSS.n299 VSS.n223 4.11287
R421 VSS.n231 VSS.t56 3.0005
R422 VSS.n35 VSS.t53 0.0141842
R423 VSS.n285 VSS.t35 3.0005
R424 VSS.t31 VSS.n286 3.0005
R425 VSS.n42 VSS.n41 3.0005
R426 VSS.n302 VSS.n44 3.0005
R427 VSS.n49 VSS.n48 3.0005
R428 VSS.n314 VSS.n46 3.0005
R429 VSS.t29 VSS.n92 9.77002
R430 VSS.n127 VSS.n88 0.0111485
R431 VSS.t11 VSS.n134 37.957
R432 VSS.n124 VSS.n88 0.0111485
R433 VSS.n122 VSS.n88 0.0108886
R434 VSS.n121 VSS.n88 0.0108886
R435 VSS.n131 VSS.n88 0.0108886
R436 VSS.n128 VSS.n88 0.0108886
R437 VSS.n267 VSS.n266 2.71193
R438 VSS.n53 VSS 2.6297
R439 VSS.n336 VSS.t3 2.4821
R440 VSS.n337 VSS.t6 2.4821
R441 VSS.n338 VSS.t9 2.4821
R442 VSS.n227 VSS.t12 2.4821
R443 VSS.t18 VSS.n226 2.4821
R444 VSS.n228 VSS.t21 2.4821
R445 VSS.n229 VSS.t24 2.4821
R446 VSS.n230 VSS.t27 2.4821
R447 VSS.t134 VSS.n274 2.4821
R448 VSS.n275 VSS.t131 2.4821
R449 VSS.t128 VSS.n276 2.4821
R450 VSS.t125 VSS.n268 2.4821
R451 VSS.t119 VSS.n269 2.4821
R452 VSS.n271 VSS.t116 2.4821
R453 VSS.n272 VSS.t113 2.4821
R454 VSS.n273 VSS.t110 2.4821
R455 VSS.n304 VSS.t89 2.4821
R456 VSS.n304 VSS.t61 2.4821
R457 VSS.n305 VSS.t91 2.4821
R458 VSS.n305 VSS.t64 2.4821
R459 VSS.n306 VSS.t93 2.4821
R460 VSS.n306 VSS.t67 2.4821
R461 VSS.n307 VSS.t95 2.4821
R462 VSS.n307 VSS.t70 2.4821
R463 VSS.n309 VSS.t99 2.4821
R464 VSS.n309 VSS.t76 2.4821
R465 VSS.n310 VSS.t101 2.4821
R466 VSS.n310 VSS.t79 2.4821
R467 VSS.n311 VSS.t103 2.4821
R468 VSS.n311 VSS.t82 2.4821
R469 VSS.n312 VSS.t105 2.4821
R470 VSS.n312 VSS.t85 2.4821
R471 VSS.n0 VSS.n29 1.20771
R472 VSS.n0 VSS.n26 1.20771
R473 VSS.n0 VSS.n28 1.20771
R474 VSS.n0 VSS.n15 0.650675
R475 VSS.n0 VSS.n24 0.650675
R476 VSS.n0 VSS.n23 0.650675
R477 VSS.n0 VSS.n5 0.650675
R478 VSS.n0 VSS.n25 0.650675
R479 VSS.n0 VSS.n12 0.650675
R480 VSS.n0 VSS.n1 0.650675
R481 VSS.n0 VSS.n14 0.650675
R482 VSS.n32 VSS.n264 13.3823
R483 VSS.n0 VSS.n27 1.20771
R484 VSS.n0 VSS.n8 0.650675
R485 VSS.t48 VSS.n301 2.2505
R486 VSS.t41 VSS.n52 2.2505
R487 VSS.t52 VSS.n300 2.2505
R488 VSS.t46 VSS.n315 2.2505
R489 VSS.n321 VSS.n88 2.09947
R490 VSS.n323 VSS.n88 2.09947
R491 VSS.n325 VSS.n88 2.09947
R492 VSS.n224 VSS.n88 2.09947
R493 VSS.n327 VSS.n88 2.09947
R494 VSS.n329 VSS.n88 2.09947
R495 VSS.n331 VSS.n88 2.09947
R496 VSS.n333 VSS.n88 2.09947
R497 VSS.n278 VSS.n64 2.09874
R498 VSS.n293 VSS.n64 2.09868
R499 VSS.n295 VSS.n64 2.09868
R500 VSS.n280 VSS.n64 2.09868
R501 VSS.n282 VSS.n64 2.09865
R502 VSS.n64 VSS.n186 2.09857
R503 VSS.n291 VSS.n64 2.09849
R504 VSS.n289 VSS.n64 2.09849
R505 VSS.n316 VSS.n105 1.7005
R506 VSS.n317 VSS.n184 1.53502
R507 VSS.n336 VSS.n35 1.21808
R508 VSS.n37 VSS.n285 1.52811
R509 VSS.n286 VSS.n39 1.52811
R510 VSS.n62 VSS.n231 1.52811
R511 VSS.n40 VSS.n64 1.13519
R512 VSS.n64 VSS.n38 1.10782
R513 VSS.t48 VSS.n105 1.08267
R514 VSS.n51 VSS.t52 0.00601606
R515 VSS.n319 VSS.n88 0.96569
R516 VSS.n335 VSS.n88 0.91152
R517 VSS.n287 VSS.n64 0.910334
R518 VSS.n284 VSS.n64 0.909368
R519 VSS.n105 VSS.n137 0.650322
R520 VSS.n105 VSS.n138 0.650322
R521 VSS.n105 VSS.n139 0.650322
R522 VSS.n105 VSS.n140 0.650322
R523 VSS.n105 VSS.n142 0.650322
R524 VSS.n105 VSS.n144 0.650322
R525 VSS.n105 VSS.n145 0.650322
R526 VSS.n105 VSS.n146 0.650322
R527 VSS.n105 VSS.n147 0.650322
R528 VSS.n105 VSS.n148 0.650322
R529 VSS.n105 VSS.n149 0.650322
R530 VSS.n105 VSS.n150 0.650322
R531 VSS.n105 VSS.n151 0.650322
R532 VSS.n105 VSS.n152 0.650322
R533 VSS.n105 VSS.n153 0.650322
R534 VSS.n105 VSS.n154 0.650322
R535 VSS.n105 VSS.n155 0.650322
R536 VSS.n105 VSS.n156 0.650322
R537 VSS.n105 VSS.n157 0.650322
R538 VSS.n105 VSS.n158 0.650322
R539 VSS.n105 VSS.n159 0.650322
R540 VSS.n105 VSS.n163 0.650322
R541 VSS.n105 VSS.n164 0.650322
R542 VSS.n105 VSS.n165 0.650322
R543 VSS.n105 VSS.n166 0.650322
R544 VSS.n105 VSS.n167 0.650322
R545 VSS.n105 VSS.n168 0.650322
R546 VSS.n105 VSS.n169 0.650322
R547 VSS.n105 VSS.n170 0.650322
R548 VSS.n105 VSS.n171 0.650322
R549 VSS.n105 VSS.n172 0.650322
R550 VSS.n105 VSS.n173 0.650322
R551 VSS.n105 VSS.n174 0.650322
R552 VSS.n105 VSS.n175 0.650322
R553 VSS.n105 VSS.n176 0.650322
R554 VSS.n105 VSS.n177 0.650322
R555 VSS.n105 VSS.n178 0.650322
R556 VSS.n105 VSS.n179 0.650322
R557 VSS.n105 VSS.n180 0.650322
R558 VSS.n105 VSS.n181 0.650322
R559 VSS.n105 VSS.n182 0.650322
R560 VSS.n105 VSS.n183 0.650322
R561 VSS.n297 VSS.n266 0.632727
R562 VSS.n105 VSS.n161 0.542397
R563 VSS.n298 VSS.n54 0.2444
R564 VSS.n298 VSS.n297 0.2444
R565 VSS.n55 VSS.n223 0.2444
R566 VSS.n267 VSS.n223 0.2444
R567 VSS.n285 VSS.n274 0.209825
R568 VSS.n286 VSS.n273 0.209825
R569 VSS.n231 VSS.n230 0.209825
R570 VSS.n334 VSS.t3 0.201663
R571 VSS.n332 VSS.t6 0.201663
R572 VSS.n330 VSS.t9 0.201663
R573 VSS.n328 VSS.t12 0.201663
R574 VSS.n326 VSS.t18 0.201663
R575 VSS.n324 VSS.t21 0.201663
R576 VSS.n322 VSS.t24 0.201663
R577 VSS.n320 VSS.t27 0.201663
R578 VSS.n283 VSS.t134 0.201663
R579 VSS.n281 VSS.t131 0.201663
R580 VSS.n279 VSS.t128 0.201663
R581 VSS.n277 VSS.t125 0.201663
R582 VSS.n294 VSS.t119 0.201663
R583 VSS.n292 VSS.t116 0.201663
R584 VSS.n290 VSS.t113 0.201663
R585 VSS.n288 VSS.t110 0.201663
R586 VSS.n59 VSS.t89 0.201663
R587 VSS.t61 VSS.n59 0.201663
R588 VSS.n93 VSS.t91 0.201663
R589 VSS.t64 VSS.n93 0.201663
R590 VSS.n102 VSS.t93 0.201663
R591 VSS.t67 VSS.n102 0.201663
R592 VSS.n68 VSS.t95 0.201663
R593 VSS.t70 VSS.n68 0.201663
R594 VSS.n74 VSS.t99 0.201663
R595 VSS.t76 VSS.n74 0.201663
R596 VSS.n98 VSS.t101 0.201663
R597 VSS.t79 VSS.n98 0.201663
R598 VSS.n104 VSS.t103 0.201663
R599 VSS.t82 VSS.n104 0.201663
R600 VSS.n58 VSS.t105 0.201663
R601 VSS.t85 VSS.n58 0.201663
R602 VSS.t73 VSS.t97 0.185696
R603 VSS.n337 VSS.n336 0.16242
R604 VSS.n338 VSS.n337 0.16242
R605 VSS.n227 VSS.n338 0.16242
R606 VSS.n225 VSS.n227 0.16242
R607 VSS.n225 VSS.n226 0.16242
R608 VSS.n228 VSS.n226 0.16242
R609 VSS.n229 VSS.n228 0.16242
R610 VSS.n230 VSS.n229 0.16242
R611 VSS.n273 VSS.n272 0.16242
R612 VSS.n272 VSS.n271 0.16242
R613 VSS.n271 VSS.n269 0.16242
R614 VSS.n270 VSS.n269 0.16242
R615 VSS.n270 VSS.n268 0.16242
R616 VSS.n276 VSS.n268 0.16242
R617 VSS.n276 VSS.n275 0.16242
R618 VSS.n275 VSS.n274 0.16242
R619 VSS.n284 VSS.n283 0.146995
R620 VSS.n288 VSS.n287 0.145358
R621 VSS.n335 VSS.n334 0.144129
R622 VSS.n320 VSS.n319 0.143085
R623 VSS.n304 VSS.n303 0.117247
R624 VSS.n313 VSS.n312 0.1171
R625 VSS.n334 VSS.n333 0.0952183
R626 VSS.n289 VSS.n288 0.093942
R627 VSS.n283 VSS.n282 0.0936939
R628 VSS.n332 VSS.n331 0.0927738
R629 VSS.n321 VSS.n320 0.0925656
R630 VSS.n291 VSS.n290 0.0916257
R631 VSS.n281 VSS.n280 0.0910563
R632 VSS.n330 VSS.n329 0.0903294
R633 VSS.t15 VSS.n224 0.0903294
R634 VSS.n323 VSS.n322 0.0901212
R635 VSS.n293 VSS.n292 0.089375
R636 VSS.t122 VSS.n186 0.0893103
R637 VSS.t122 VSS.n295 0.0886118
R638 VSS.n279 VSS.n278 0.0885493
R639 VSS.n328 VSS.n327 0.0878849
R640 VSS.n326 VSS.n325 0.0878849
R641 VSS.n327 VSS.t15 0.0876767
R642 VSS.n325 VSS.n324 0.0876767
R643 VSS.n278 VSS.n277 0.086995
R644 VSS.n295 VSS.n294 0.0869305
R645 VSS.n277 VSS.n186 0.0862315
R646 VSS.n294 VSS.n293 0.0861674
R647 VSS.n324 VSS.n323 0.0854405
R648 VSS.n329 VSS.n328 0.0852323
R649 VSS.n224 VSS.n326 0.0852323
R650 VSS.n319 VSS.t56 0.0849321
R651 VSS.t53 VSS.n335 0.0847768
R652 VSS.n280 VSS.n279 0.0844861
R653 VSS.n292 VSS.n291 0.0839099
R654 VSS.n287 VSS.t31 0.0834709
R655 VSS.n322 VSS.n321 0.082996
R656 VSS.n331 VSS.n330 0.0827878
R657 VSS.t35 VSS.n284 0.0827574
R658 VSS.n282 VSS.n281 0.0818541
R659 VSS.n290 VSS.n289 0.0815947
R660 VSS.n305 VSS.n304 0.08146
R661 VSS.n306 VSS.n305 0.08146
R662 VSS.n307 VSS.n306 0.08146
R663 VSS.n308 VSS.n307 0.08146
R664 VSS.n309 VSS.n308 0.08146
R665 VSS.n310 VSS.n309 0.08146
R666 VSS.n311 VSS.n310 0.08146
R667 VSS.n312 VSS.n311 0.08146
R668 VSS.n333 VSS.n332 0.0803434
R669 VSS.t41 VSS.n31 0.00388412
R670 VSS.n53 VSS 0.0445
R671 VSS.n266 VSS 0.0445
R672 VSS.n270 VSS.t122 0.0394179
R673 VSS.t15 VSS.n225 0.0394179
R674 VSS.n339 VSS.n225 0.0389615
R675 VSS.n296 VSS.n270 0.0389615
R676 VSS.t49 VSS.n42 0.031258
R677 VSS.n44 VSS.t42 0.031258
R678 VSS.t51 VSS.n49 0.031258
R679 VSS.n303 VSS.n302 0.0291125
R680 VSS.n313 VSS.n48 0.0291125
R681 VSS.n314 VSS.n313 0.0291125
R682 VSS.n303 VSS.n41 0.0291125
R683 VSS.n302 VSS.n52 0.0281144
R684 VSS.n300 VSS.n48 0.0281144
R685 VSS.n315 VSS.n314 0.0281144
R686 VSS.n301 VSS.n41 0.0281144
R687 VSS.n46 VSS.t52 0.0216549
R688 VSS.n308 VSS.n299 0.0197308
R689 VSS.n308 VSS.t97 0.019449
R690 VSS.n35 VSS.n33 0.00771346
R691 VSS.t35 VSS.n65 0.0133922
R692 VSS.t31 VSS.n66 0.0133922
R693 VSS.n249 VSS.n247 0.0118857
R694 VSS.n250 VSS.n246 0.0118857
R695 VSS.n251 VSS.n58 0.0118857
R696 VSS.n252 VSS.n72 0.0161786
R697 VSS.n253 VSS.n232 0.0118857
R698 VSS.n254 VSS.n244 0.0118857
R699 VSS.n100 VSS.n98 0.00858771
R700 VSS.n256 VSS.n234 0.0118857
R701 VSS.n257 VSS.n234 0.0118857
R702 VSS.n258 VSS.n242 0.0118857
R703 VSS.n91 VSS.t97 0.00858771
R704 VSS.n260 VSS.n240 0.0118857
R705 VSS.n60 VSS.n96 0.0185601
R706 VSS.n262 VSS.n237 0.0118857
R707 VSS.n263 VSS.n236 0.0118857
R708 VSS.n71 VSS.n235 0.0161786
R709 VSS.n263 VSS.n235 0.0118857
R710 VSS.n262 VSS.n236 0.0118857
R711 VSS.n261 VSS.n239 0.0118857
R712 VSS.n97 VSS.n239 0.0180748
R713 VSS.n91 VSS.n241 0.0161786
R714 VSS.n258 VSS.n241 0.0118857
R715 VSS.n74 VSS.n73 0.0118857
R716 VSS.n257 VSS.n73 0.0118857
R717 VSS.n256 VSS.n233 0.0118857
R718 VSS.n255 VSS.n233 0.0118857
R719 VSS.n100 VSS.n243 0.0161786
R720 VSS.n254 VSS.n243 0.0118857
R721 VSS.n104 VSS.n103 0.0118857
R722 VSS.n253 VSS.n103 0.0118857
R723 VSS.n252 VSS.n232 0.0118857
R724 VSS.n251 VSS.n245 0.0118857
R725 VSS.n250 VSS.n245 0.0118857
R726 VSS.n249 VSS.n246 0.0118857
R727 VSS.n50 VSS.t52 0.0318616
R728 VSS.n64 VSS.n76 0.0112168
R729 VSS.n64 VSS.n77 0.0112168
R730 VSS.n64 VSS.n78 0.0112168
R731 VSS.n64 VSS.n79 0.0112168
R732 VSS.n64 VSS.n81 0.0112168
R733 VSS.n64 VSS.n82 0.0112168
R734 VSS.n64 VSS.n83 0.0112168
R735 VSS.n64 VSS.n84 0.0112168
R736 VSS.n64 VSS.n85 0.0112168
R737 VSS.n64 VSS.n86 0.0112168
R738 VSS.n87 VSS.t132 22.7839
R739 VSS.n64 VSS.t136 9.76925
R740 VSS.n54 VSS.n53 0.632727
R741 VSS.n105 VSS.n184 0.141883
R742 VSS VSS.n55 0.0827273
R743 VSS.n47 VSS.t45 0.0414647
R744 VSS.n45 VSS.t41 0.0321526
R745 VSS.n43 VSS.t41 0.0321526
R746 VSS.n109 VSS.n102 0.0258437
R747 VSS.n66 VSS.n63 0.0123024
R748 VSS.n65 VSS.n36 0.0123024
R749 VSS.t46 VSS.t52 0.0214488
R750 VSS.n90 VSS.n259 0.0203641
R751 VSS.n64 VSS.n80 0.0193107
R752 VSS.n64 VSS.n75 0.0190637
R753 VSS.n117 VSS.n104 0.0189924
R754 VSS.n68 VSS.n67 0.00953071
R755 VSS.n238 VSS.n69 0.0180738
R756 VSS.n102 VSS.n101 0.0114291
R757 VSS.n247 VSS.n119 0.0174081
R758 VSS.n242 VSS.n115 0.0174081
R759 VSS.n240 VSS.n113 0.0174081
R760 VSS.n238 VSS.n110 0.0174081
R761 VSS.n99 VSS.n255 0.0174081
R762 VSS.n237 VSS.n95 0.0174081
R763 VSS.n92 VSS.n88 0.0169451
R764 VSS.n114 VSS.n74 0.0161786
R765 VSS.n70 VSS.n69 0.0204746
R766 VSS.n71 VSS.t41 0.0200861
R767 VSS.t41 VSS.t48 0.0191243
R768 VSS.n62 VSS.n56 0.0183418
R769 VSS.n58 VSS.n57 0.0179185
R770 VSS.n260 VSS.n68 0.0175786
R771 VSS.t33 VSS.n40 17.0032
R772 VSS.t37 VSS.n38 17.0032
R773 VSS.t46 VSS.n0 1.06298
C0 vin1 vin2 0.02526f
C1 VDD vout4 9.20502f
C2 VDD vin2 26.3294f
C3 vin3 vin2 0.02893f
C4 vin4 vout4 15.8261f
C5 vin1 vout1 15.8261f
C6 vout3 VDD 9.19358f
C7 VDD vout1 9.20502f
C8 vin1 VDD 26.3603f
C9 vout2 vin2 15.8261f
C10 vout3 vin3 15.8261f
C11 VDD vin3 26.3294f
C12 vin4 VDD 26.3603f
C13 vout2 VDD 9.19358f
C14 vin4 vin3 0.02526f
C15 vout1 VSS 10.72398f
C16 vout2 VSS 10.70542f
C17 vout3 VSS 10.70542f
C18 vout4 VSS 10.72398f
C19 VSS.t105 VSS 6.81335f
C20 VSS.t24 VSS 6.83105f
C21 VSS.t76 VSS 6.81335f
.ends

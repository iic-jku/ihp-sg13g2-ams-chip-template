* PEX produced on Mon Aug 24 12:46:38 PM CEST 2026 using /foss/tools/sak/sak-pex.sh with m=3 and s=1 (extresist threshold=10000 mOhm, minres=1000 mOhm, mindelay=1 ps)
* NGSPICE file created from inverter_top_pex.ext - technology: ihp-sg13g2

.subckt inverter_top_pex VDD vin4 vout4 VSS vin3 vout3 vin2 vout2 vout1 vin1
X0 vout3 vin3 VSS.t105 VSS.t86 sg13_lv_nmos ad=0.19p pd=1.38u as=0.19p ps=1.38u w=1u l=1u
X1 VDD VDD VDD VDD sg13_lv_pmos ad=1.14p pd=6.38u as=0.56797n ps=1.006m w=6u l=1u
X2 VSS.t1 VSS.t53 VSS.t55 VSS.t54 sg13_lv_nmos ad=0.34p pd=2.68u as=0 ps=0 w=1u l=1u
X3 VDD VDD VDD VDD sg13_lv_pmos ad=1.14p pd=6.38u as=0 ps=0 w=6u l=1u
X4 VDD vin4 vout4 VDD sg13_lv_pmos ad=1.14p pd=6.38u as=1.14p ps=6.38u w=6u l=1u
X5 vout2 vin2 VSS.t76 VSS.t77 sg13_lv_nmos ad=0.19p pd=1.38u as=0.19p ps=1.38u w=1u l=1u
X6 vout3 vin3 VDD VDD sg13_lv_pmos ad=1.14p pd=6.38u as=1.14p ps=6.38u w=6u l=1u
X7 vout4 vin4 VSS.t110 VSS.t111 sg13_lv_nmos ad=0.19p pd=1.38u as=0.19p ps=1.38u w=1u l=1u
X8 vout3 vin3 VSS.t42 VSS.t59 sg13_lv_nmos ad=0.19p pd=1.38u as=0.19p ps=1.38u w=1u l=1u
X9 vout2 vin2 VSS.t70 VSS.t71 sg13_lv_nmos ad=0.19p pd=1.38u as=0.19p ps=1.38u w=1u l=1u
X10 vout4 vin4 VDD VDD sg13_lv_pmos ad=1.14p pd=6.38u as=1.14p ps=6.38u w=6u l=1u
X11 VDD vin2 vout2 VDD sg13_lv_pmos ad=1.14p pd=6.38u as=1.14p ps=6.38u w=6u l=1u
X12 VSS.t76 vin2 vout2 VSS.t75 sg13_lv_nmos ad=0.19p pd=1.38u as=0.19p ps=1.38u w=1u l=1u
X13 vout2 vin2 VSS.t79 VSS.t80 sg13_lv_nmos ad=0.19p pd=1.38u as=0.19p ps=1.38u w=1u l=1u
X14 vout2 vin2 VDD VDD sg13_lv_pmos ad=1.14p pd=6.38u as=1.14p ps=6.38u w=6u l=1u
X15 VSS.t116 vin4 vout4 VSS.t115 sg13_lv_nmos ad=0.19p pd=1.38u as=0.19p ps=1.38u w=1u l=1u
X16 vout1 vin1 VSS.t24 VSS.t25 sg13_lv_nmos ad=0.19p pd=1.38u as=0.19p ps=1.38u w=1u l=1u
X17 VDD vin2 vout2 VDD sg13_lv_pmos ad=1.14p pd=6.38u as=1.14p ps=6.38u w=6u l=1u
X18 vout4 vin4 VSS.t34 VSS.t108 sg13_lv_nmos ad=0.19p pd=1.38u as=0.19p ps=1.38u w=1u l=1u
X19 VDD vin2 vout2 VDD sg13_lv_pmos ad=1.14p pd=6.38u as=1.14p ps=6.38u w=6u l=1u
X20 VSS.t105 vin3 vout3 VSS.t84 sg13_lv_nmos ad=0.19p pd=1.38u as=0.19p ps=1.38u w=1u l=1u
X21 vout4 vin4 VSS.t125 VSS.t126 sg13_lv_nmos ad=0.19p pd=1.38u as=0.19p ps=1.38u w=1u l=1u
X22 VSS.t119 vin4 vout4 VSS.t118 sg13_lv_nmos ad=0.19p pd=1.38u as=0.19p ps=1.38u w=1u l=1u
X23 VDD vin3 vout3 VDD sg13_lv_pmos ad=1.14p pd=6.38u as=1.14p ps=6.38u w=6u l=1u
X24 VDD vin2 vout2 VDD sg13_lv_pmos ad=1.14p pd=6.38u as=1.14p ps=6.38u w=6u l=1u
X25 vout3 vin3 VDD VDD sg13_lv_pmos ad=1.14p pd=6.38u as=1.14p ps=6.38u w=6u l=1u
X26 VSS.t70 vin2 vout2 VSS.t69 sg13_lv_nmos ad=0.19p pd=1.38u as=0.19p ps=1.38u w=1u l=1u
X27 VDD vin3 vout3 VDD sg13_lv_pmos ad=1.14p pd=6.38u as=1.14p ps=6.38u w=6u l=1u
X28 VSS.t42 VSS.t39 VSS.t41 VSS.t40 sg13_lv_nmos ad=0.34p pd=2.68u as=0 ps=0 w=1u l=1u
X29 vout2 vin2 VDD VDD sg13_lv_pmos ad=1.14p pd=6.38u as=1.14p ps=6.38u w=6u l=1u
X30 vout2 vin2 VSS.t73 VSS.t74 sg13_lv_nmos ad=0.19p pd=1.38u as=0.19p ps=1.38u w=1u l=1u
X31 vout1 vin1 VSS.t18 VSS.t19 sg13_lv_nmos ad=0.19p pd=1.38u as=0.19p ps=1.38u w=1u l=1u
X32 VSS.t79 vin2 vout2 VSS.t78 sg13_lv_nmos ad=0.19p pd=1.38u as=0.19p ps=1.38u w=1u l=1u
X33 vout4 vin4 VSS.t122 VSS.t123 sg13_lv_nmos ad=0.19p pd=1.38u as=0.19p ps=1.38u w=1u l=1u
X34 vout1 vin1 VDD VDD sg13_lv_pmos ad=1.14p pd=6.38u as=1.14p ps=6.38u w=6u l=1u
X35 vout1 vin1 VSS.t12 VSS.t13 sg13_lv_nmos ad=0.19p pd=1.38u as=0.19p ps=1.38u w=1u l=1u
X36 VSS.t128 vin4 vout4 VSS.t127 sg13_lv_nmos ad=0.19p pd=1.38u as=0.19p ps=1.38u w=1u l=1u
X37 VDD VDD VDD VDD sg13_lv_pmos ad=1.14p pd=6.38u as=0 ps=0 w=6u l=1u
X38 VSS.t18 vin1 vout1 VSS.t17 sg13_lv_nmos ad=0.19p pd=1.38u as=0.19p ps=1.38u w=1u l=1u
X39 vout2 vin2 VDD VDD sg13_lv_pmos ad=1.14p pd=6.38u as=1.14p ps=6.38u w=6u l=1u
X40 VDD vin4 vout4 VDD sg13_lv_pmos ad=1.14p pd=6.38u as=1.14p ps=6.38u w=6u l=1u
X41 vout1 vin1 VSS.t21 VSS.t22 sg13_lv_nmos ad=0.19p pd=1.38u as=0.19p ps=1.38u w=1u l=1u
X42 vout3 vin3 VSS.t103 VSS.t83 sg13_lv_nmos ad=0.19p pd=1.38u as=0.19p ps=1.38u w=1u l=1u
X43 VDD vin3 vout3 VDD sg13_lv_pmos ad=1.14p pd=6.38u as=1.14p ps=6.38u w=6u l=1u
X44 vout4 vin4 VDD VDD sg13_lv_pmos ad=1.14p pd=6.38u as=1.14p ps=6.38u w=6u l=1u
X45 VDD vin4 vout4 VDD sg13_lv_pmos ad=1.14p pd=6.38u as=1.14p ps=6.38u w=6u l=1u
X46 vout3 vin3 VDD VDD sg13_lv_pmos ad=1.14p pd=6.38u as=1.14p ps=6.38u w=6u l=1u
X47 VDD vin3 vout3 VDD sg13_lv_pmos ad=1.14p pd=6.38u as=1.14p ps=6.38u w=6u l=1u
X48 VSS.t38 VSS.t35 VSS.t37 VSS.t36 sg13_lv_nmos ad=0.19p pd=1.38u as=0 ps=0 w=1u l=1u
X49 VDD vin4 vout4 VDD sg13_lv_pmos ad=1.14p pd=6.38u as=1.14p ps=6.38u w=6u l=1u
X50 VDD vin2 vout2 VDD sg13_lv_pmos ad=1.14p pd=6.38u as=1.14p ps=6.38u w=6u l=1u
X51 VSS.t131 vin4 vout4 VSS.t130 sg13_lv_nmos ad=0.19p pd=1.38u as=0.19p ps=1.38u w=1u l=1u
X52 VDD vin3 vout3 VDD sg13_lv_pmos ad=1.14p pd=6.38u as=1.14p ps=6.38u w=6u l=1u
X53 VSS.t12 vin1 vout1 VSS.t11 sg13_lv_nmos ad=0.19p pd=1.38u as=0.19p ps=1.38u w=1u l=1u
X54 VDD vin1 vout1 VDD sg13_lv_pmos ad=1.14p pd=6.38u as=1.14p ps=6.38u w=6u l=1u
X55 vout4 vin4 VSS.t134 VSS.t135 sg13_lv_nmos ad=0.19p pd=1.38u as=0.19p ps=1.38u w=1u l=1u
X56 vout1 vin1 VDD VDD sg13_lv_pmos ad=1.14p pd=6.38u as=1.14p ps=6.38u w=6u l=1u
X57 vout4 vin4 VDD VDD sg13_lv_pmos ad=1.14p pd=6.38u as=1.14p ps=6.38u w=6u l=1u
X58 vout1 vin1 VSS.t15 VSS.t16 sg13_lv_nmos ad=0.19p pd=1.38u as=0.19p ps=1.38u w=1u l=1u
X59 VDD vin1 vout1 VDD sg13_lv_pmos ad=1.14p pd=6.38u as=1.14p ps=6.38u w=6u l=1u
X60 vout3 vin3 VSS.t99 VSS.t77 sg13_lv_nmos ad=0.19p pd=1.38u as=0.19p ps=1.38u w=1u l=1u
X61 VSS.t21 vin1 vout1 VSS.t20 sg13_lv_nmos ad=0.19p pd=1.38u as=0.19p ps=1.38u w=1u l=1u
X62 VDD VDD VDD VDD sg13_lv_pmos ad=2.04p pd=12.68u as=0 ps=0 w=6u l=1u
X63 vout4 vin4 VDD VDD sg13_lv_pmos ad=1.14p pd=6.38u as=1.14p ps=6.38u w=6u l=1u
X64 VDD vin3 vout3 VDD sg13_lv_pmos ad=1.14p pd=6.38u as=1.14p ps=6.38u w=6u l=1u
X65 VDD vin4 vout4 VDD sg13_lv_pmos ad=1.14p pd=6.38u as=1.14p ps=6.38u w=6u l=1u
X66 vout3 vin3 VDD VDD sg13_lv_pmos ad=1.14p pd=6.38u as=1.14p ps=6.38u w=6u l=1u
X67 vout3 vin3 VSS.t95 VSS.t71 sg13_lv_nmos ad=0.19p pd=1.38u as=0.19p ps=1.38u w=1u l=1u
X68 VSS.t99 vin3 vout3 VSS.t75 sg13_lv_nmos ad=0.19p pd=1.38u as=0.19p ps=1.38u w=1u l=1u
X69 VDD VDD VDD VDD sg13_lv_pmos ad=1.14p pd=6.38u as=0 ps=0 w=6u l=1u
X70 vout3 vin3 VSS.t101 VSS.t80 sg13_lv_nmos ad=0.19p pd=1.38u as=0.19p ps=1.38u w=1u l=1u
X71 vout4 vin4 VDD VDD sg13_lv_pmos ad=1.14p pd=6.38u as=1.14p ps=6.38u w=6u l=1u
X72 vout3 vin3 VDD VDD sg13_lv_pmos ad=1.14p pd=6.38u as=1.14p ps=6.38u w=6u l=1u
X73 VDD vin1 vout1 VDD sg13_lv_pmos ad=1.14p pd=6.38u as=1.14p ps=6.38u w=6u l=1u
X74 vout2 vin2 VDD VDD sg13_lv_pmos ad=1.14p pd=6.38u as=1.14p ps=6.38u w=6u l=1u
X75 vout1 vin1 VDD VDD sg13_lv_pmos ad=1.14p pd=6.38u as=1.14p ps=6.38u w=6u l=1u
X76 vout2 vin2 VSS.t64 VSS.t65 sg13_lv_nmos ad=0.19p pd=1.38u as=0.19p ps=1.38u w=1u l=1u
X77 VDD vin1 vout1 VDD sg13_lv_pmos ad=1.14p pd=6.38u as=1.14p ps=6.38u w=6u l=1u
X78 VDD vin1 vout1 VDD sg13_lv_pmos ad=1.14p pd=6.38u as=1.14p ps=6.38u w=6u l=1u
X79 VDD vin3 vout3 VDD sg13_lv_pmos ad=1.14p pd=6.38u as=1.14p ps=6.38u w=6u l=1u
X80 VSS.t95 vin3 vout3 VSS.t69 sg13_lv_nmos ad=0.19p pd=1.38u as=0.19p ps=1.38u w=1u l=1u
X81 vout3 vin3 VSS.t97 VSS.t74 sg13_lv_nmos ad=0.19p pd=1.38u as=0.19p ps=1.38u w=1u l=1u
X82 VSS.t113 vin4 vout4 VSS.t112 sg13_lv_nmos ad=0.19p pd=1.38u as=0.19p ps=1.38u w=1u l=1u
X83 VDD vin4 vout4 VDD sg13_lv_pmos ad=1.14p pd=6.38u as=1.14p ps=6.38u w=6u l=1u
X84 VSS.t101 vin3 vout3 VSS.t78 sg13_lv_nmos ad=0.19p pd=1.38u as=0.19p ps=1.38u w=1u l=1u
X85 vout4 vin4 VSS.t116 VSS.t117 sg13_lv_nmos ad=0.19p pd=1.38u as=0.19p ps=1.38u w=1u l=1u
X86 VDD vin1 vout1 VDD sg13_lv_pmos ad=1.14p pd=6.38u as=1.14p ps=6.38u w=6u l=1u
X87 vout2 vin2 VDD VDD sg13_lv_pmos ad=1.14p pd=6.38u as=1.14p ps=6.38u w=6u l=1u
X88 vout1 vin1 VDD VDD sg13_lv_pmos ad=1.14p pd=6.38u as=1.14p ps=6.38u w=6u l=1u
X89 VSS.t110 vin4 vout4 VSS.t109 sg13_lv_nmos ad=0.19p pd=1.38u as=0.19p ps=1.38u w=1u l=1u
X90 VDD VDD VDD VDD sg13_lv_pmos ad=2.04p pd=12.68u as=0 ps=0 w=6u l=1u
X91 vout2 vin2 VDD VDD sg13_lv_pmos ad=1.14p pd=6.38u as=1.14p ps=6.38u w=6u l=1u
X92 VDD vin2 vout2 VDD sg13_lv_pmos ad=1.14p pd=6.38u as=1.14p ps=6.38u w=6u l=1u
X93 VSS.t64 vin2 vout2 VSS.t63 sg13_lv_nmos ad=0.19p pd=1.38u as=0.19p ps=1.38u w=1u l=1u
X94 VSS.t122 vin4 vout4 VSS.t121 sg13_lv_nmos ad=0.19p pd=1.38u as=0.19p ps=1.38u w=1u l=1u
X95 vout2 vin2 VDD VDD sg13_lv_pmos ad=1.14p pd=6.38u as=1.14p ps=6.38u w=6u l=1u
X96 VDD VDD VDD VDD sg13_lv_pmos ad=2.04p pd=12.68u as=0 ps=0 w=6u l=1u
X97 vout2 vin2 VSS.t67 VSS.t68 sg13_lv_nmos ad=0.19p pd=1.38u as=0.19p ps=1.38u w=1u l=1u
X98 VSS.t73 vin2 vout2 VSS.t72 sg13_lv_nmos ad=0.19p pd=1.38u as=0.19p ps=1.38u w=1u l=1u
X99 vout1 vin1 VDD VDD sg13_lv_pmos ad=1.14p pd=6.38u as=1.14p ps=6.38u w=6u l=1u
X100 vout1 vin1 VSS.t6 VSS.t7 sg13_lv_nmos ad=0.19p pd=1.38u as=0.19p ps=1.38u w=1u l=1u
X101 vout4 vin4 VSS.t119 VSS.t120 sg13_lv_nmos ad=0.19p pd=1.38u as=0.19p ps=1.38u w=1u l=1u
X102 vout3 vin3 VDD VDD sg13_lv_pmos ad=1.14p pd=6.38u as=1.14p ps=6.38u w=6u l=1u
X103 vout4 vin4 VSS.t131 VSS.t132 sg13_lv_nmos ad=0.19p pd=1.38u as=0.19p ps=1.38u w=1u l=1u
X104 VSS.t52 VSS.t50 VSS.t51 VSS.t44 sg13_lv_nmos ad=0.19p pd=1.38u as=0 ps=0 w=1u l=1u
X105 VSS.t125 vin4 vout4 VSS.t124 sg13_lv_nmos ad=0.19p pd=1.38u as=0.19p ps=1.38u w=1u l=1u
X106 VDD vin1 vout1 VDD sg13_lv_pmos ad=1.14p pd=6.38u as=1.14p ps=6.38u w=6u l=1u
X107 VSS.t51 vin2 vout2 VSS.t87 sg13_lv_nmos ad=0.19p pd=1.38u as=0.19p ps=1.38u w=1u l=1u
X108 VDD vin2 vout2 VDD sg13_lv_pmos ad=1.14p pd=6.38u as=1.14p ps=6.38u w=6u l=1u
X109 vout4 vin4 VSS.t128 VSS.t129 sg13_lv_nmos ad=0.19p pd=1.38u as=0.19p ps=1.38u w=1u l=1u
X110 vout4 vin4 VDD VDD sg13_lv_pmos ad=1.14p pd=6.38u as=1.14p ps=6.38u w=6u l=1u
X111 vout2 vin2 VDD VDD sg13_lv_pmos ad=1.14p pd=6.38u as=1.14p ps=6.38u w=6u l=1u
X112 vout2 vin2 VSS.t61 VSS.t62 sg13_lv_nmos ad=0.19p pd=1.38u as=0.19p ps=1.38u w=1u l=1u
X113 VDD vin2 vout2 VDD sg13_lv_pmos ad=1.14p pd=6.38u as=1.14p ps=6.38u w=6u l=1u
X114 VSS.t67 vin2 vout2 VSS.t66 sg13_lv_nmos ad=0.19p pd=1.38u as=0.19p ps=1.38u w=1u l=1u
X115 VDD vin4 vout4 VDD sg13_lv_pmos ad=1.14p pd=6.38u as=1.14p ps=6.38u w=6u l=1u
X116 VDD VDD VDD VDD sg13_lv_pmos ad=2.04p pd=12.68u as=0 ps=0 w=6u l=1u
X117 VSS.t61 vin2 vout2 VSS.t60 sg13_lv_nmos ad=0.19p pd=1.38u as=0.19p ps=1.38u w=1u l=1u
X118 VSS.t6 vin1 vout1 VSS.t5 sg13_lv_nmos ad=0.19p pd=1.38u as=0.19p ps=1.38u w=1u l=1u
X119 vout3 vin3 VDD VDD sg13_lv_pmos ad=1.14p pd=6.38u as=1.14p ps=6.38u w=6u l=1u
X120 vout1 vin1 VSS.t9 VSS.t10 sg13_lv_nmos ad=0.19p pd=1.38u as=0.19p ps=1.38u w=1u l=1u
X121 VSS.t15 vin1 vout1 VSS.t14 sg13_lv_nmos ad=0.19p pd=1.38u as=0.19p ps=1.38u w=1u l=1u
X122 vout3 vin3 VDD VDD sg13_lv_pmos ad=1.14p pd=6.38u as=1.14p ps=6.38u w=6u l=1u
X123 VDD vin3 vout3 VDD sg13_lv_pmos ad=1.14p pd=6.38u as=1.14p ps=6.38u w=6u l=1u
X124 vout3 vin3 VDD VDD sg13_lv_pmos ad=1.14p pd=6.38u as=1.14p ps=6.38u w=6u l=1u
X125 vout3 vin3 VSS.t91 VSS.t65 sg13_lv_nmos ad=0.19p pd=1.38u as=0.19p ps=1.38u w=1u l=1u
X126 VSS.t82 vin2 vout2 VSS.t81 sg13_lv_nmos ad=0.19p pd=1.38u as=0.19p ps=1.38u w=1u l=1u
X127 vout1 vin1 VDD VDD sg13_lv_pmos ad=1.14p pd=6.38u as=1.14p ps=6.38u w=6u l=1u
X128 vout2 vin2 VSS.t85 VSS.t86 sg13_lv_nmos ad=0.19p pd=1.38u as=0.19p ps=1.38u w=1u l=1u
X129 VSS.t37 vin4 vout4 VSS.t136 sg13_lv_nmos ad=0.19p pd=1.38u as=0.19p ps=1.38u w=1u l=1u
X130 VSS.t58 VSS.t56 VSS.t30 VSS.t57 sg13_lv_nmos ad=0.19p pd=1.38u as=0 ps=0 w=1u l=1u
X131 VSS.t30 vin1 vout1 VSS.t29 sg13_lv_nmos ad=0.19p pd=1.38u as=0.19p ps=1.38u w=1u l=1u
X132 vout2 vin2 VSS.t49 VSS.t59 sg13_lv_nmos ad=0.19p pd=1.38u as=0.19p ps=1.38u w=1u l=1u
X133 VSS.t34 VSS.t31 VSS.t33 VSS.t32 sg13_lv_nmos ad=0.34p pd=2.68u as=0 ps=0 w=1u l=1u
X134 vout1 vin1 VSS.t3 VSS.t4 sg13_lv_nmos ad=0.19p pd=1.38u as=0.19p ps=1.38u w=1u l=1u
X135 VSS.t9 vin1 vout1 VSS.t8 sg13_lv_nmos ad=0.19p pd=1.38u as=0.19p ps=1.38u w=1u l=1u
X136 VDD vin3 vout3 VDD sg13_lv_pmos ad=1.14p pd=6.38u as=1.14p ps=6.38u w=6u l=1u
X137 VSS.t3 vin1 vout1 VSS.t2 sg13_lv_nmos ad=0.19p pd=1.38u as=0.19p ps=1.38u w=1u l=1u
X138 vout4 vin4 VDD VDD sg13_lv_pmos ad=1.14p pd=6.38u as=1.14p ps=6.38u w=6u l=1u
X139 vout3 vin3 VDD VDD sg13_lv_pmos ad=1.14p pd=6.38u as=1.14p ps=6.38u w=6u l=1u
X140 VDD vin3 vout3 VDD sg13_lv_pmos ad=1.14p pd=6.38u as=1.14p ps=6.38u w=6u l=1u
X141 VSS.t91 vin3 vout3 VSS.t63 sg13_lv_nmos ad=0.19p pd=1.38u as=0.19p ps=1.38u w=1u l=1u
X142 vout3 vin3 VSS.t93 VSS.t68 sg13_lv_nmos ad=0.19p pd=1.38u as=0.19p ps=1.38u w=1u l=1u
X143 vout1 vin1 VDD VDD sg13_lv_pmos ad=1.14p pd=6.38u as=1.14p ps=6.38u w=6u l=1u
X144 VSS.t85 vin2 vout2 VSS.t84 sg13_lv_nmos ad=0.19p pd=1.38u as=0.19p ps=1.38u w=1u l=1u
X145 VSS.t97 vin3 vout3 VSS.t72 sg13_lv_nmos ad=0.19p pd=1.38u as=0.19p ps=1.38u w=1u l=1u
X146 VDD vin4 vout4 VDD sg13_lv_pmos ad=1.14p pd=6.38u as=1.14p ps=6.38u w=6u l=1u
X147 vout1 vin1 VDD VDD sg13_lv_pmos ad=1.14p pd=6.38u as=1.14p ps=6.38u w=6u l=1u
X148 VDD vin1 vout1 VDD sg13_lv_pmos ad=1.14p pd=6.38u as=1.14p ps=6.38u w=6u l=1u
X149 vout4 vin4 VDD VDD sg13_lv_pmos ad=1.14p pd=6.38u as=1.14p ps=6.38u w=6u l=1u
X150 VSS.t24 vin1 vout1 VSS.t23 sg13_lv_nmos ad=0.19p pd=1.38u as=0.19p ps=1.38u w=1u l=1u
X151 vout1 vin1 VSS.t27 VSS.t28 sg13_lv_nmos ad=0.19p pd=1.38u as=0.19p ps=1.38u w=1u l=1u
X152 vout1 vin1 VDD VDD sg13_lv_pmos ad=1.14p pd=6.38u as=1.14p ps=6.38u w=6u l=1u
X153 vout2 vin2 VDD VDD sg13_lv_pmos ad=1.14p pd=6.38u as=1.14p ps=6.38u w=6u l=1u
X154 vout4 vin4 VSS.t113 VSS.t114 sg13_lv_nmos ad=0.19p pd=1.38u as=0.19p ps=1.38u w=1u l=1u
X155 VSS.t49 VSS.t47 VSS.t48 VSS.t40 sg13_lv_nmos ad=0.34p pd=2.68u as=0 ps=0 w=1u l=1u
X156 VSS.t46 VSS.t43 VSS.t45 VSS.t44 sg13_lv_nmos ad=0.19p pd=1.38u as=0 ps=0 w=1u l=1u
X157 vout4 vin4 VDD VDD sg13_lv_pmos ad=1.14p pd=6.38u as=1.14p ps=6.38u w=6u l=1u
X158 VSS.t45 vin3 vout3 VSS.t87 sg13_lv_nmos ad=0.19p pd=1.38u as=0.19p ps=1.38u w=1u l=1u
X159 VSS.t134 vin4 vout4 VSS.t133 sg13_lv_nmos ad=0.19p pd=1.38u as=0.19p ps=1.38u w=1u l=1u
X160 VDD vin4 vout4 VDD sg13_lv_pmos ad=1.14p pd=6.38u as=1.14p ps=6.38u w=6u l=1u
X161 vout1 vin1 VSS.t1 VSS.t0 sg13_lv_nmos ad=0.19p pd=1.38u as=0.19p ps=1.38u w=1u l=1u
X162 vout3 vin3 VSS.t89 VSS.t62 sg13_lv_nmos ad=0.19p pd=1.38u as=0.19p ps=1.38u w=1u l=1u
X163 VSS.t93 vin3 vout3 VSS.t66 sg13_lv_nmos ad=0.19p pd=1.38u as=0.19p ps=1.38u w=1u l=1u
X164 vout4 vin4 VDD VDD sg13_lv_pmos ad=1.14p pd=6.38u as=1.14p ps=6.38u w=6u l=1u
X165 vout2 vin2 VSS.t82 VSS.t83 sg13_lv_nmos ad=0.19p pd=1.38u as=0.19p ps=1.38u w=1u l=1u
X166 VSS.t89 vin3 vout3 VSS.t60 sg13_lv_nmos ad=0.19p pd=1.38u as=0.19p ps=1.38u w=1u l=1u
X167 VDD vin1 vout1 VDD sg13_lv_pmos ad=1.14p pd=6.38u as=1.14p ps=6.38u w=6u l=1u
X168 vout1 vin1 VDD VDD sg13_lv_pmos ad=1.14p pd=6.38u as=1.14p ps=6.38u w=6u l=1u
X169 VDD vin1 vout1 VDD sg13_lv_pmos ad=1.14p pd=6.38u as=1.14p ps=6.38u w=6u l=1u
X170 VDD vin4 vout4 VDD sg13_lv_pmos ad=1.14p pd=6.38u as=1.14p ps=6.38u w=6u l=1u
X171 VSS.t27 vin1 vout1 VSS.t26 sg13_lv_nmos ad=0.19p pd=1.38u as=0.19p ps=1.38u w=1u l=1u
X172 VDD vin2 vout2 VDD sg13_lv_pmos ad=1.14p pd=6.38u as=1.14p ps=6.38u w=6u l=1u
X173 vout2 vin2 VDD VDD sg13_lv_pmos ad=1.14p pd=6.38u as=1.14p ps=6.38u w=6u l=1u
X174 VDD vin2 vout2 VDD sg13_lv_pmos ad=1.14p pd=6.38u as=1.14p ps=6.38u w=6u l=1u
X175 VSS.t103 vin3 vout3 VSS.t81 sg13_lv_nmos ad=0.19p pd=1.38u as=0.19p ps=1.38u w=1u l=1u
R0 VSS.n24 VSS.n154 6777.49
R1 VSS.n384 VSS.n24 6777.49
R2 VSS.n45 VSS.n384 6777.49
R3 VSS.n384 VSS.n383 1580.41
R4 VSS.n380 VSS.n154 1580.41
R5 VSS.t59 VSS.n167 88.7251
R6 VSS.n88 VSS.t87 88.7251
R7 VSS.t60 VSS.n166 83.1798
R8 VSS.t86 VSS.n181 83.1798
R9 VSS.n128 VSS.t62 77.6345
R10 VSS.n93 VSS.t84 77.6345
R11 VSS.t36 VSS.n24 6.87897
R12 VSS.t63 VSS.n165 72.0892
R13 VSS.t83 VSS.n180 72.0892
R14 VSS.t136 VSS.n24 9.76925
R15 VSS.n123 VSS.t65 66.5439
R16 VSS.n179 VSS.t81 66.5439
R17 VSS.t135 VSS.n25 12.2976
R18 VSS.t66 VSS.n164 60.9987
R19 VSS.n178 VSS.t80 60.9987
R20 VSS.t133 VSS.n22 60.7305
R21 VSS.n60 VSS.t111 14.4672
R22 VSS.t132 VSS.n21 56.9354
R23 VSS.n9 VSS.t112 56.9308
R24 VSS.n118 VSS.t68 55.4534
R25 VSS.n175 VSS.t72 55.4534
R26 VSS.n109 VSS.t74 55.4534
R27 VSS.n177 VSS.t78 55.4534
R28 VSS.t130 VSS.n20 53.1403
R29 VSS.n10 VSS.t114 53.1357
R30 VSS.n57 VSS.t26 14.4654
R31 VSS.t69 VSS.n163 49.9081
R32 VSS.n174 VSS.t71 49.9081
R33 VSS.t75 VSS.n106 49.9081
R34 VSS.n104 VSS.t77 49.9081
R35 VSS.t129 VSS.n19 49.3453
R36 VSS.n11 VSS.t115 49.3407
R37 VSS.n148 VSS.t25 56.9328
R38 VSS.t127 VSS.n18 45.5502
R39 VSS.t121 VSS.n14 45.5502
R40 VSS.n16 VSS.t123 45.5456
R41 VSS.n12 VSS.t117 45.5456
R42 VSS.n140 VSS.t23 53.1377
R43 VSS.n116 VSS.t69 44.3628
R44 VSS.t71 VSS.n162 44.3628
R45 VSS.n107 VSS.t75 44.3628
R46 VSS.t77 VSS.n160 44.3628
R47 VSS.t126 VSS.n17 41.7551
R48 VSS.t120 VSS.n13 41.7551
R49 VSS.n17 VSS.t124 41.7505
R50 VSS.n13 VSS.t118 41.7505
R51 VSS.n141 VSS.t22 49.3419
R52 VSS.t68 VSS.n173 38.8175
R53 VSS.t72 VSS.n161 38.8175
R54 VSS.t74 VSS.n176 38.8175
R55 VSS.t78 VSS.n159 38.8175
R56 VSS.t124 VSS.n16 37.9601
R57 VSS.t118 VSS.n12 37.9601
R58 VSS.n18 VSS.t126 37.9555
R59 VSS.n14 VSS.t120 37.9555
R60 VSS.n147 VSS.t20 45.5476
R61 VSS.t123 VSS.n15 34.1682
R62 VSS.t117 VSS.n11 34.165
R63 VSS.n15 VSS.t121 34.1635
R64 VSS.n19 VSS.t127 34.1604
R65 VSS.n149 VSS.t13 41.7518
R66 VSS.n152 VSS.t19 41.7512
R67 VSS.n121 VSS.t66 33.2722
R68 VSS.t80 VSS.n158 33.2722
R69 VSS.t115 VSS.n10 30.3699
R70 VSS.n20 VSS.t129 30.3653
R71 VSS.n146 VSS.t11 37.9567
R72 VSS.n151 VSS.t17 37.9567
R73 VSS.t65 VSS.n172 27.7269
R74 VSS.t81 VSS.n157 27.7269
R75 VSS.t114 VSS.n9 26.5749
R76 VSS.n21 VSS.t130 26.5703
R77 VSS.n143 VSS.t10 34.1616
R78 VSS.t112 VSS.n60 22.7885
R79 VSS.n22 VSS.t132 22.7752
R80 VSS.n150 VSS.t8 30.3673
R81 VSS.n150 VSS.t7 53.1364
R82 VSS.n147 VSS.t19 37.9561
R83 VSS.n140 VSS.t22 30.366
R84 VSS.n148 VSS.t23 26.5709
R85 VSS.t57 VSS.n52 6.87971
R86 VSS.n126 VSS.t63 22.1816
R87 VSS.n95 VSS.t83 22.1816
R88 VSS.n144 VSS.t7 26.5715
R89 VSS.n52 VSS.t28 12.2984
R90 VSS.n57 VSS.t25 22.7844
R91 VSS.n52 VSS.n148 0.0111485
R92 VSS.n52 VSS.n140 0.0111485
R93 VSS.n141 VSS.t20 34.162
R94 VSS.n52 VSS.n147 0.0111485
R95 VSS.n152 VSS.t17 41.7525
R96 VSS.n52 VSS.n151 0.0109013
R97 VSS.n151 VSS.t16 45.5472
R98 VSS.n145 VSS.t14 34.1651
R99 VSS.n142 VSS.t13 37.957
R100 VSS.n52 VSS.n149 0.0109013
R101 VSS.n149 VSS.t11 41.7521
R102 VSS.n52 VSS.n146 0.0109013
R103 VSS.n146 VSS.t10 45.5472
R104 VSS.n52 VSS.n150 0.0111485
R105 VSS.n52 VSS.n144 0.0109013
R106 VSS.n144 VSS.t5 56.9324
R107 VSS.n53 VSS.t5 22.7848
R108 VSS.n53 VSS.t4 14.4652
R109 VSS.n53 VSS.n52 0.00347743
R110 VSS.t2 VSS.n52 12.2982
R111 VSS.n52 VSS.n46 0.815553
R112 VSS.n0 VSS.n1 0.0183293
R113 VSS.t58 VSS.n0 5.66244
R114 VSS.n1 VSS.t30 5.66128
R115 VSS.n52 VSS.n45 0.00234686
R116 VSS.t1 VSS.n43 5.66266
R117 VSS.n43 VSS.t55 5.66533
R118 VSS.n47 VSS.n221 17.0005
R119 VSS.n47 VSS.n283 17.0005
R120 VSS.n47 VSS.n222 17.0005
R121 VSS.n47 VSS.n282 17.0005
R122 VSS.n47 VSS.n80 5.66421
R123 VSS.n47 VSS.n224 17.0005
R124 VSS.n47 VSS.n281 17.0005
R125 VSS.n47 VSS.n87 17.0005
R126 VSS.n47 VSS.n78 5.66421
R127 VSS.n47 VSS.n88 17.0005
R128 VSS.n47 VSS.n225 17.0005
R129 VSS.n47 VSS.n279 17.0005
R130 VSS.n47 VSS.n90 17.0005
R131 VSS.n47 VSS.n181 8.49928
R132 VSS.n47 VSS.n226 17.0005
R133 VSS.n47 VSS.n277 17.0005
R134 VSS.n47 VSS.n156 17.0005
R135 VSS.n47 VSS.n93 17.0005
R136 VSS.n47 VSS.n227 17.0005
R137 VSS.n47 VSS.n276 17.0005
R138 VSS.n47 VSS.n95 17.0005
R139 VSS.n47 VSS.n180 17.0005
R140 VSS.n47 VSS.n229 17.0005
R141 VSS.n47 VSS.n77 5.66377
R142 VSS.n47 VSS.n275 17.0005
R143 VSS.n47 VSS.n157 17.0005
R144 VSS.n47 VSS.n179 17.0005
R145 VSS.n47 VSS.n230 17.0005
R146 VSS.n47 VSS.n273 17.0005
R147 VSS.n47 VSS.n158 17.0005
R148 VSS.n47 VSS.n178 17.0005
R149 VSS.n47 VSS.n231 17.0005
R150 VSS.n47 VSS.n271 17.0005
R151 VSS.n47 VSS.n65 4.2464
R152 VSS.n48 VSS.n159 8.49579
R153 VSS.n47 VSS.n177 8.49603
R154 VSS.n47 VSS.n232 17.0005
R155 VSS.n65 VSS.n75 0.0188594
R156 VSS.n47 VSS.n270 17.0005
R157 VSS.n47 VSS.n160 8.49952
R158 VSS.n47 VSS.n104 17.0005
R159 VSS.n47 VSS.n233 17.0005
R160 VSS.n47 VSS.n268 17.0005
R161 VSS.n61 VSS.n74 0.0194337
R162 VSS.n47 VSS.n106 17.0005
R163 VSS.n47 VSS.n107 17.0005
R164 VSS.n47 VSS.n234 17.0005
R165 VSS.n47 VSS.n266 17.0005
R166 VSS.n47 VSS.n109 17.0005
R167 VSS.n47 VSS.n176 8.49628
R168 VSS.n47 VSS.n235 17.0005
R169 VSS.n47 VSS.n264 17.0005
R170 VSS.n47 VSS.n161 8.49653
R171 VSS.n47 VSS.n175 8.49677
R172 VSS.n47 VSS.n236 17.0005
R173 VSS.n47 VSS.n263 17.0005
R174 VSS.n47 VSS.n162 8.49702
R175 VSS.n47 VSS.n174 8.49727
R176 VSS.n47 VSS.n238 17.0005
R177 VSS.n47 VSS.n262 17.0005
R178 VSS.n47 VSS.n30 4.24711
R179 VSS.n47 VSS.n163 8.49752
R180 VSS.n47 VSS.n116 17.0005
R181 VSS.n47 VSS.n240 17.0005
R182 VSS.n47 VSS.n261 17.0005
R183 VSS.n47 VSS.n118 17.0005
R184 VSS.n47 VSS.n173 8.49777
R185 VSS.n47 VSS.n242 17.0005
R186 VSS.n47 VSS.n66 5.66421
R187 VSS.n47 VSS.n260 17.0005
R188 VSS.n47 VSS.n164 8.49802
R189 VSS.n47 VSS.n121 17.0005
R190 VSS.n47 VSS.n243 17.0005
R191 VSS.n47 VSS.n259 17.0005
R192 VSS.n47 VSS.n72 5.66421
R193 VSS.n47 VSS.n123 17.0005
R194 VSS.n47 VSS.n172 8.49827
R195 VSS.n47 VSS.n244 17.0005
R196 VSS.n47 VSS.n71 5.66421
R197 VSS.n47 VSS.n258 17.0005
R198 VSS.n47 VSS.n165 8.49851
R199 VSS.n47 VSS.n126 17.0005
R200 VSS.n47 VSS.n245 17.0005
R201 VSS.n47 VSS.n256 17.0005
R202 VSS.n70 VSS.n350 0.0213902
R203 VSS.n47 VSS.n128 17.0005
R204 VSS.n47 VSS.n171 8.49876
R205 VSS.n47 VSS.n246 17.0005
R206 VSS.n47 VSS.n70 4.24614
R207 VSS.n47 VSS.n255 17.0005
R208 VSS.n47 VSS.n166 8.49901
R209 VSS.n47 VSS.n170 8.49926
R210 VSS.n47 VSS.n247 17.0005
R211 VSS.n47 VSS.n254 17.0005
R212 VSS.n50 VSS.n69 0.0212075
R213 VSS.n47 VSS.n167 8.49951
R214 VSS.n47 VSS.n169 8.49976
R215 VSS.n47 VSS.n248 17.0005
R216 VSS.n47 VSS.n67 5.66421
R217 VSS.n47 VSS.n253 17.0005
R218 VSS.n47 VSS.n249 17.0005
R219 VSS.n47 VSS.t40 17.0005
R220 VSS.n47 VSS.n250 17.0005
R221 VSS.n47 VSS.n251 17.0005
R222 VSS.n47 VSS.n168 17.0005
R223 VSS.n381 VSS.n47 17.0005
R224 VSS.n42 VSS.t44 17.0005
R225 VSS.n42 VSS.n156 17.0005
R226 VSS.n42 VSS.n180 17.0005
R227 VSS.n42 VSS.n157 17.0005
R228 VSS.n42 VSS.n179 17.0005
R229 VSS.n42 VSS.n158 17.0005
R230 VSS.n42 VSS.n178 17.0005
R231 VSS.n139 VSS.n82 3.39928
R232 VSS.n139 VSS.n81 5.66316
R233 VSS.n139 VSS.n79 5.66316
R234 VSS.n55 VSS.n54 0.0124956
R235 VSS.n139 VSS.n76 5.66421
R236 VSS.n139 VSS.n33 5.66405
R237 VSS.n139 VSS.n75 5.66316
R238 VSS.n63 VSS.n62 0.012379
R239 VSS.n74 VSS.n267 0.0136165
R240 VSS.n27 VSS.n139 3.39428
R241 VSS.n139 VSS.n35 5.66405
R242 VSS.n139 VSS.n73 5.66316
R243 VSS.n139 VSS.n40 5.66377
R244 VSS.n139 VSS.n51 2.82465
R245 VSS.n139 VSS.n69 5.66316
R246 VSS.n139 VSS.n68 5.66316
R247 VSS.n139 VSS.n64 5.66421
R248 VSS.n7 VSS.n6 0.0153095
R249 VSS.n4 VSS.n3 0.0153627
R250 VSS.t38 VSS.n58 17.0005
R251 VSS.t38 VSS.n3 8.49711
R252 VSS.n3 VSS.n2 0.0123024
R253 VSS.n2 VSS.t37 8.49535
R254 VSS.n59 VSS.t34 17.0005
R255 VSS.t34 VSS.n6 8.49711
R256 VSS.n6 VSS.n5 0.0123024
R257 VSS.n5 VSS.t33 8.49535
R258 VSS.t62 VSS.n171 16.6364
R259 VSS.t84 VSS.n156 16.6364
R260 VSS.t109 VSS.n24 12.3005
R261 VSS.n365 VSS.t47 15.0005
R262 VSS.n360 VSS.t39 15.0005
R263 VSS.n375 VSS.t43 15.0005
R264 VSS.t50 VSS.n352 15.0005
R265 VSS.n235 VSS.n205 13.1592
R266 VSS.n264 VSS.n205 13.1592
R267 VSS.n337 VSS.n223 12.4949
R268 VSS.n221 VSS.n188 12.4949
R269 VSS.n222 VSS.n189 12.4949
R270 VSS.n224 VSS.n190 12.4949
R271 VSS.n87 VSS.n191 12.4949
R272 VSS.n225 VSS.n192 12.4949
R273 VSS.n90 VSS.n193 12.4949
R274 VSS.n226 VSS.n194 12.4949
R275 VSS.n227 VSS.n195 12.4949
R276 VSS.n95 VSS.n196 12.4949
R277 VSS.n229 VSS.n197 12.4949
R278 VSS.n230 VSS.n198 12.4949
R279 VSS.n231 VSS.n199 12.4949
R280 VSS.n232 VSS.n200 12.4949
R281 VSS.n233 VSS.n201 12.4949
R282 VSS.n106 VSS.n202 12.4949
R283 VSS.n234 VSS.n203 12.4949
R284 VSS.n109 VSS.n204 12.4949
R285 VSS.n236 VSS.n206 12.4949
R286 VSS.n238 VSS.n207 12.4949
R287 VSS.n116 VSS.n208 12.4949
R288 VSS.n118 VSS.n209 12.4949
R289 VSS.n242 VSS.n210 12.4949
R290 VSS.n243 VSS.n211 12.4949
R291 VSS.n123 VSS.n212 12.4949
R292 VSS.n244 VSS.n213 12.4949
R293 VSS.n245 VSS.n214 12.4949
R294 VSS.n128 VSS.n215 12.4949
R295 VSS.n246 VSS.n216 12.4949
R296 VSS.n247 VSS.n217 12.4949
R297 VSS.n248 VSS.n218 12.4949
R298 VSS.n249 VSS.n219 12.4949
R299 VSS.n250 VSS.n220 12.4949
R300 VSS.n382 VSS.n168 12.4949
R301 VSS.n382 VSS.n381 12.4949
R302 VSS.n251 VSS.n220 12.4949
R303 VSS.t40 VSS.n219 12.4949
R304 VSS.n253 VSS.n218 12.4949
R305 VSS.n254 VSS.n217 12.4949
R306 VSS.n255 VSS.n216 12.4949
R307 VSS.n256 VSS.n215 12.4949
R308 VSS.n126 VSS.n214 12.4949
R309 VSS.n258 VSS.n213 12.4949
R310 VSS.n259 VSS.n212 12.4949
R311 VSS.n121 VSS.n211 12.4949
R312 VSS.n260 VSS.n210 12.4949
R313 VSS.n261 VSS.n209 12.4949
R314 VSS.n240 VSS.n208 12.4949
R315 VSS.n262 VSS.n207 12.4949
R316 VSS.n263 VSS.n206 12.4949
R317 VSS.n266 VSS.n204 12.4949
R318 VSS.n107 VSS.n203 12.4949
R319 VSS.n268 VSS.n202 12.4949
R320 VSS.n104 VSS.n201 12.4949
R321 VSS.n270 VSS.n200 12.4949
R322 VSS.n271 VSS.n199 12.4949
R323 VSS.n273 VSS.n198 12.4949
R324 VSS.n275 VSS.n197 12.4949
R325 VSS.n276 VSS.n196 12.4949
R326 VSS.n93 VSS.n195 12.4949
R327 VSS.n277 VSS.n194 12.4949
R328 VSS.n279 VSS.n193 12.4949
R329 VSS.n88 VSS.n192 12.4949
R330 VSS.n281 VSS.n191 12.4949
R331 VSS.n282 VSS.n190 12.4949
R332 VSS.n223 VSS.t44 12.4949
R333 VSS.n337 VSS.n189 12.4949
R334 VSS.n283 VSS.n188 12.4949
R335 VSS.t108 VSS.n24 9.77299
R336 VSS.t29 VSS.n52 9.77002
R337 VSS.t16 VSS.n145 34.1648
R338 VSS.t14 VSS.n142 45.5468
R339 VSS.t8 VSS.n143 49.3429
R340 VSS.n170 VSS.t60 11.0911
R341 VSS.n90 VSS.t86 11.0911
R342 VSS.n43 VSS.n45 1.16719
R343 VSS.n383 VSS.n47 1.70154
R344 VSS.n139 VSS.n337 8.5005
R345 VSS.n139 VSS.n87 8.5005
R346 VSS.n139 VSS.n88 8.5005
R347 VSS.n139 VSS.n90 8.5005
R348 VSS.n139 VSS.n93 8.5005
R349 VSS.n139 VSS.n95 8.5005
R350 VSS.n139 VSS.n104 8.5005
R351 VSS.n139 VSS.n106 8.5005
R352 VSS.n139 VSS.n107 8.5005
R353 VSS.n139 VSS.n109 8.5005
R354 VSS.n139 VSS.n116 8.5005
R355 VSS.n139 VSS.n118 8.5005
R356 VSS.n139 VSS.n121 8.5005
R357 VSS.n139 VSS.n123 8.5005
R358 VSS.n139 VSS.n126 8.5005
R359 VSS.n139 VSS.n128 8.5005
R360 VSS.n80 VSS.n83 0.0161386
R361 VSS.n78 VSS.n81 0.0217011
R362 VSS.n47 VSS.n280 8.4984
R363 VSS.n47 VSS.n278 8.4984
R364 VSS.n47 VSS.n56 3.39638
R365 VSS.n47 VSS.n228 8.4984
R366 VSS.n47 VSS.n38 8.4984
R367 VSS.n77 VSS.n76 0.0135286
R368 VSS.n47 VSS.n274 8.4984
R369 VSS.n47 VSS.n272 8.4984
R370 VSS.n47 VSS.n34 8.4984
R371 VSS.n47 VSS.n269 8.4984
R372 VSS.n47 VSS.n61 4.24575
R373 VSS.n47 VSS.n267 8.4984
R374 VSS.n47 VSS.n265 8.4984
R375 VSS.n47 VSS.n26 3.39476
R376 VSS.n47 VSS.n237 8.4984
R377 VSS.n30 VSS.n345 0.0180748
R378 VSS.n47 VSS.n239 8.4984
R379 VSS.n47 VSS.n241 8.4984
R380 VSS.n66 VSS.n347 0.0161786
R381 VSS.n47 VSS.n36 8.4984
R382 VSS.n72 VSS.n348 0.0161786
R383 VSS.n71 VSS.n73 0.0217011
R384 VSS.n47 VSS.n41 8.4984
R385 VSS.n47 VSS.n257 8.4984
R386 VSS.n47 VSS.n50 3.39584
R387 VSS.n50 VSS.n49 0.0103978
R388 VSS.n67 VSS.n69 0.0217011
R389 VSS.n47 VSS.n252 8.4984
R390 VSS.n47 VSS.n28 2.83119
R391 VSS.n81 VSS.n80 0.014444
R392 VSS.n79 VSS.n78 0.014444
R393 VSS.n139 VSS.n338 8.4984
R394 VSS.n139 VSS.n55 3.39245
R395 VSS.n54 VSS.n56 0.00905453
R396 VSS.n139 VSS.n339 8.4984
R397 VSS.n139 VSS.n340 8.4984
R398 VSS.n139 VSS.n39 8.4984
R399 VSS.n139 VSS.n341 8.4984
R400 VSS.n139 VSS.n342 8.4984
R401 VSS.n33 VSS.n65 0.0172863
R402 VSS.n139 VSS.n63 5.66294
R403 VSS.n139 VSS.n74 5.66443
R404 VSS.n139 VSS.n343 8.4984
R405 VSS.n27 VSS.t97 0.0142963
R406 VSS.n139 VSS.n344 8.4984
R407 VSS.n139 VSS.n345 8.4984
R408 VSS.n32 VSS.n31 0.0123705
R409 VSS.n139 VSS.n32 4.24427
R410 VSS.n139 VSS.n346 8.4984
R411 VSS.n139 VSS.n347 8.4984
R412 VSS.n35 VSS.n66 0.0131216
R413 VSS.n139 VSS.n348 8.4984
R414 VSS.n73 VSS.n72 0.014444
R415 VSS.n40 VSS.n71 0.0135286
R416 VSS.n139 VSS.n349 8.4984
R417 VSS.n139 VSS.n350 8.4984
R418 VSS.n51 VSS.n49 0.0231031
R419 VSS.n68 VSS.n67 0.014444
R420 VSS.n153 VSS.n52 0.910943
R421 VSS.n388 VSS.n182 8.22525
R422 VSS.n332 VSS.n331 8.22525
R423 VSS.n331 VSS.n304 8.22525
R424 VSS.n389 VSS.n388 8.22525
R425 VSS.n138 VSS.n221 7.6711
R426 VSS.n381 VSS.n137 7.6711
R427 VSS.n24 VSS.t32 6.87896
R428 VSS.n367 VSS.t47 7.49606
R429 VSS.t39 VSS.n359 7.49606
R430 VSS.t43 VSS.n374 7.49606
R431 VSS.n353 VSS.t50 7.49606
R432 VSS.n84 VSS.n283 7.20236
R433 VSS.n85 VSS.t44 7.20236
R434 VSS.n86 VSS.n224 7.20236
R435 VSS.n89 VSS.n225 7.20236
R436 VSS.n91 VSS.n226 7.20236
R437 VSS.n92 VSS.n156 7.20236
R438 VSS.n94 VSS.n227 7.20236
R439 VSS.n96 VSS.n229 7.20236
R440 VSS.n97 VSS.n275 7.20236
R441 VSS.n98 VSS.n230 7.20236
R442 VSS.n99 VSS.n273 7.20236
R443 VSS.n100 VSS.n178 7.20236
R444 VSS.n101 VSS.n159 7.20236
R445 VSS.n102 VSS.n177 7.20236
R446 VSS.n103 VSS.n270 7.20236
R447 VSS.n105 VSS.n233 7.20236
R448 VSS.n108 VSS.n234 7.20236
R449 VSS.n110 VSS.n176 7.20236
R450 VSS.n111 VSS.n264 7.20236
R451 VSS.n112 VSS.n175 7.20236
R452 VSS.n113 VSS.n263 7.20236
R453 VSS.n114 VSS.n174 7.20236
R454 VSS.n115 VSS.n262 7.20236
R455 VSS.n117 VSS.n240 7.20236
R456 VSS.n119 VSS.n173 7.20236
R457 VSS.n120 VSS.n260 7.20236
R458 VSS.n122 VSS.n243 7.20236
R459 VSS.n124 VSS.n172 7.20236
R460 VSS.n125 VSS.n258 7.20236
R461 VSS.n127 VSS.n245 7.20236
R462 VSS.n129 VSS.n171 7.20236
R463 VSS.n130 VSS.n255 7.20236
R464 VSS.n131 VSS.n170 7.20236
R465 VSS.n132 VSS.n254 7.20236
R466 VSS.n133 VSS.n248 7.20236
R467 VSS.n134 VSS.n253 7.20236
R468 VSS.n135 VSS.n250 7.20236
R469 VSS.n136 VSS.n251 7.20236
R470 VSS.n136 VSS.n168 7.20236
R471 VSS.n135 VSS.t40 7.20236
R472 VSS.n134 VSS.n249 7.20236
R473 VSS.n133 VSS.n169 7.20236
R474 VSS.n132 VSS.n167 7.20236
R475 VSS.n131 VSS.n247 7.20236
R476 VSS.n130 VSS.n166 7.20236
R477 VSS.n129 VSS.n246 7.20236
R478 VSS.n127 VSS.n256 7.20236
R479 VSS.n125 VSS.n165 7.20236
R480 VSS.n124 VSS.n244 7.20236
R481 VSS.n122 VSS.n259 7.20236
R482 VSS.n120 VSS.n164 7.20236
R483 VSS.n119 VSS.n242 7.20236
R484 VSS.n117 VSS.n261 7.20236
R485 VSS.n115 VSS.n163 7.20236
R486 VSS.n114 VSS.n238 7.20236
R487 VSS.n113 VSS.n162 7.20236
R488 VSS.n112 VSS.n236 7.20236
R489 VSS.n111 VSS.n161 7.20236
R490 VSS.n110 VSS.n235 7.20236
R491 VSS.n108 VSS.n266 7.20236
R492 VSS.n105 VSS.n268 7.20236
R493 VSS.n103 VSS.n160 7.20236
R494 VSS.n102 VSS.n232 7.20236
R495 VSS.n101 VSS.n271 7.20236
R496 VSS.n100 VSS.n231 7.20236
R497 VSS.n99 VSS.n158 7.20236
R498 VSS.n98 VSS.n179 7.20236
R499 VSS.n97 VSS.n157 7.20236
R500 VSS.n96 VSS.n180 7.20236
R501 VSS.n94 VSS.n276 7.20236
R502 VSS.n92 VSS.n277 7.20236
R503 VSS.n91 VSS.n181 7.20236
R504 VSS.n89 VSS.n279 7.20236
R505 VSS.n86 VSS.n281 7.20236
R506 VSS.n85 VSS.n282 7.20236
R507 VSS.n84 VSS.n222 7.20236
R508 VSS.n380 VSS.n42 1.7006
R509 VSS.n47 VSS.n379 3.40076
R510 VSS.n169 VSS.t59 5.54579
R511 VSS.t87 VSS.n87 5.54579
R512 VSS.n368 VSS.t49 4.5005
R513 VSS.t42 VSS.n358 4.5005
R514 VSS.n354 VSS.t51 4.5005
R515 VSS.n378 VSS.t45 4.5005
R516 VSS.n139 VSS.n28 4.25784
R517 VSS.n82 VSS.n47 4.25571
R518 VSS.n154 VSS.n52 6777.49
R519 VSS.n334 VSS.n333 4.11287
R520 VSS.n334 VSS.n183 4.11287
R521 VSS.n37 VSS.t56 0.019456
R522 VSS.n322 VSS.t35 3.0005
R523 VSS.n329 VSS.t31 3.0005
R524 VSS.n366 VSS.n364 3.0005
R525 VSS.n362 VSS.n361 3.0005
R526 VSS.n351 VSS.n302 3.0005
R527 VSS.n377 VSS.n376 3.0005
R528 VSS.n52 VSS.n152 0.0111485
R529 VSS.n52 VSS.n141 0.0109013
R530 VSS.n52 VSS.n145 0.0093246
R531 VSS.n52 VSS.n142 0.0109013
R532 VSS.n52 VSS.n143 0.0108886
R533 VSS.n52 VSS.t0 9.76976
R534 VSS.n52 VSS.t54 6.87937
R535 VSS.n304 VSS.n303 2.71193
R536 VSS.n391 VSS.n390 2.6297
R537 VSS.n385 VSS.t3 2.4821
R538 VSS.n386 VSS.t6 2.4821
R539 VSS.n387 VSS.t9 2.4821
R540 VSS.n187 VSS.t12 2.4821
R541 VSS.t18 VSS.n186 2.4821
R542 VSS.t21 VSS.n286 2.4821
R543 VSS.n285 VSS.t24 2.4821
R544 VSS.t27 VSS.n284 2.4821
R545 VSS.n321 VSS.t134 2.4821
R546 VSS.n319 VSS.t131 2.4821
R547 VSS.n318 VSS.t128 2.4821
R548 VSS.t125 VSS.n305 2.4821
R549 VSS.t119 VSS.n306 2.4821
R550 VSS.n326 VSS.t116 2.4821
R551 VSS.n327 VSS.t113 2.4821
R552 VSS.n328 VSS.t110 2.4821
R553 VSS.n357 VSS.t89 2.4821
R554 VSS.n357 VSS.t61 2.4821
R555 VSS.n356 VSS.t91 2.4821
R556 VSS.n356 VSS.t64 2.4821
R557 VSS.n355 VSS.t93 2.4821
R558 VSS.n355 VSS.t67 2.4821
R559 VSS.n335 VSS.t95 2.4821
R560 VSS.n335 VSS.t70 2.4821
R561 VSS.n369 VSS.t99 2.4821
R562 VSS.n369 VSS.t76 2.4821
R563 VSS.n370 VSS.t101 2.4821
R564 VSS.n370 VSS.t79 2.4821
R565 VSS.n371 VSS.t103 2.4821
R566 VSS.n371 VSS.t82 2.4821
R567 VSS.n372 VSS.t105 2.4821
R568 VSS.n372 VSS.t85 2.4821
R569 VSS.n47 VSS.n223 2.25406
R570 VSS.n42 VSS.n188 2.25406
R571 VSS.n42 VSS.n189 2.25406
R572 VSS.n42 VSS.n190 2.25406
R573 VSS.n42 VSS.n191 2.25406
R574 VSS.n42 VSS.n192 2.25406
R575 VSS.n42 VSS.n193 2.25406
R576 VSS.n42 VSS.n194 2.25406
R577 VSS.n42 VSS.n195 2.25406
R578 VSS.n42 VSS.n196 2.25406
R579 VSS.n42 VSS.n197 2.25406
R580 VSS.n42 VSS.n198 2.25406
R581 VSS.n42 VSS.n199 2.25406
R582 VSS.n42 VSS.n200 2.25406
R583 VSS.n42 VSS.n201 2.25406
R584 VSS.n42 VSS.n202 2.25406
R585 VSS.n42 VSS.n203 2.25406
R586 VSS.n42 VSS.n204 2.25406
R587 VSS.n42 VSS.n206 2.25406
R588 VSS.n42 VSS.n207 2.25406
R589 VSS.n42 VSS.n208 2.25406
R590 VSS.n42 VSS.n209 2.25406
R591 VSS.n42 VSS.n210 2.25406
R592 VSS.n42 VSS.n211 2.25406
R593 VSS.n42 VSS.n212 2.25406
R594 VSS.n42 VSS.n213 2.25406
R595 VSS.n42 VSS.n214 2.25406
R596 VSS.n42 VSS.n215 2.25406
R597 VSS.n42 VSS.n216 2.25406
R598 VSS.n42 VSS.n217 2.25406
R599 VSS.n42 VSS.n218 2.25406
R600 VSS.n42 VSS.n219 2.25406
R601 VSS.n42 VSS.n220 2.25406
R602 VSS.n42 VSS.n382 2.25406
R603 VSS.t48 VSS.n368 2.2505
R604 VSS.n358 VSS.t41 2.2505
R605 VSS.t52 VSS.n354 2.2505
R606 VSS.t46 VSS.n378 2.2505
R607 VSS.n300 VSS.n52 2.09947
R608 VSS.n298 VSS.n52 2.09947
R609 VSS.n296 VSS.n52 2.09947
R610 VSS.n294 VSS.n52 2.09947
R611 VSS.n184 VSS.n52 2.09947
R612 VSS.n292 VSS.n52 2.09947
R613 VSS.n290 VSS.n52 2.09947
R614 VSS.n288 VSS.n52 2.09947
R615 VSS.n24 VSS.n313 2.0988
R616 VSS.n24 VSS.n309 2.09868
R617 VSS.n24 VSS.n310 2.09868
R618 VSS.n24 VSS.n311 2.09865
R619 VSS.n24 VSS.n314 2.09857
R620 VSS.n24 VSS.n155 2.09849
R621 VSS.n24 VSS.n315 2.09849
R622 VSS.n330 VSS.n24 2.09849
R623 VSS.n42 VSS.n205 1.92189
R624 VSS.n0 VSS.n52 1.27394
R625 VSS.n42 VSS.n379 1.37583
R626 VSS.n383 VSS.n137 1.53502
R627 VSS.n380 VSS.n138 1.53502
R628 VSS.n44 VSS.n43 0.0100665
R629 VSS.n3 VSS.n322 1.52811
R630 VSS.n6 VSS.n329 1.52811
R631 VSS.n37 VSS.n284 1.2163
R632 VSS.n7 VSS.n24 1.13519
R633 VSS.n24 VSS.n4 1.10782
R634 VSS.n139 VSS.t48 1.08341
R635 VSS.n139 VSS.t52 1.03696
R636 VSS.n153 VSS.n287 0.144834
R637 VSS.n301 VSS.n46 0.156346
R638 VSS.n24 VSS.n8 0.910334
R639 VSS.n24 VSS.n23 0.909368
R640 VSS.n139 VSS.n84 0.650322
R641 VSS.n139 VSS.n85 0.650322
R642 VSS.n139 VSS.n86 0.650322
R643 VSS.n139 VSS.n89 0.650322
R644 VSS.n139 VSS.n91 0.650322
R645 VSS.n139 VSS.n92 0.650322
R646 VSS.n139 VSS.n94 0.650322
R647 VSS.n139 VSS.n96 0.650322
R648 VSS.n139 VSS.n97 0.650322
R649 VSS.n139 VSS.n98 0.650322
R650 VSS.n139 VSS.n99 0.650322
R651 VSS.n139 VSS.n100 0.650322
R652 VSS.n139 VSS.n101 0.650322
R653 VSS.n139 VSS.n102 0.650322
R654 VSS.n139 VSS.n103 0.650322
R655 VSS.n139 VSS.n105 0.650322
R656 VSS.n139 VSS.n108 0.650322
R657 VSS.n139 VSS.n110 0.650322
R658 VSS.n139 VSS.n111 0.650322
R659 VSS.n139 VSS.n112 0.650322
R660 VSS.n139 VSS.n113 0.650322
R661 VSS.n139 VSS.n114 0.650322
R662 VSS.n139 VSS.n115 0.650322
R663 VSS.n139 VSS.n117 0.650322
R664 VSS.n139 VSS.n119 0.650322
R665 VSS.n139 VSS.n120 0.650322
R666 VSS.n139 VSS.n122 0.650322
R667 VSS.n139 VSS.n124 0.650322
R668 VSS.n139 VSS.n125 0.650322
R669 VSS.n139 VSS.n127 0.650322
R670 VSS.n139 VSS.n129 0.650322
R671 VSS.n139 VSS.n130 0.650322
R672 VSS.n139 VSS.n131 0.650322
R673 VSS.n139 VSS.n132 0.650322
R674 VSS.n139 VSS.n133 0.650322
R675 VSS.n139 VSS.n134 0.650322
R676 VSS.n139 VSS.n135 0.650322
R677 VSS.n139 VSS.n136 0.650322
R678 VSS.n332 VSS.n303 0.632727
R679 VSS.n392 VSS.n391 0.5505
R680 VSS.n333 VSS.n182 0.2444
R681 VSS.n333 VSS.n332 0.2444
R682 VSS.n389 VSS.n183 0.2444
R683 VSS.n304 VSS.n183 0.2444
R684 VSS.n385 VSS.n44 1.21652
R685 VSS.n322 VSS.n321 0.209825
R686 VSS.n329 VSS.n328 0.209825
R687 VSS.n287 VSS.t3 0.201663
R688 VSS.n289 VSS.t6 0.201663
R689 VSS.n291 VSS.t9 0.201663
R690 VSS.n293 VSS.t12 0.201663
R691 VSS.n295 VSS.t18 0.201663
R692 VSS.n297 VSS.t21 0.201663
R693 VSS.n299 VSS.t24 0.201663
R694 VSS.n301 VSS.t27 0.201663
R695 VSS.t134 VSS.n320 0.201663
R696 VSS.t131 VSS.n316 0.201663
R697 VSS.t128 VSS.n317 0.201663
R698 VSS.n312 VSS.t125 0.201663
R699 VSS.n308 VSS.t119 0.201663
R700 VSS.t116 VSS.n325 0.201663
R701 VSS.t113 VSS.n324 0.201663
R702 VSS.t110 VSS.n323 0.201663
R703 VSS.n49 VSS.t89 0.201663
R704 VSS.t61 VSS.n49 0.201663
R705 VSS.n41 VSS.t91 0.201663
R706 VSS.t64 VSS.n41 0.201663
R707 VSS.n36 VSS.t93 0.201663
R708 VSS.t67 VSS.n36 0.201663
R709 VSS.n31 VSS.t95 0.201663
R710 VSS.t70 VSS.n31 0.201663
R711 VSS.n62 VSS.t99 0.201663
R712 VSS.n62 VSS.t76 0.201663
R713 VSS.n34 VSS.t101 0.201663
R714 VSS.n34 VSS.t79 0.201663
R715 VSS.n39 VSS.t103 0.201663
R716 VSS.n39 VSS.t82 0.201663
R717 VSS.n54 VSS.t105 0.201663
R718 VSS.n54 VSS.t85 0.201663
R719 VSS.t73 VSS.t97 0.185696
R720 VSS.n386 VSS.n385 0.16242
R721 VSS.n387 VSS.n386 0.16242
R722 VSS.n187 VSS.n387 0.16242
R723 VSS.n185 VSS.n187 0.16242
R724 VSS.n185 VSS.n186 0.16242
R725 VSS.n286 VSS.n186 0.16242
R726 VSS.n286 VSS.n285 0.16242
R727 VSS.n285 VSS.n284 0.16242
R728 VSS.n328 VSS.n327 0.16242
R729 VSS.n327 VSS.n326 0.16242
R730 VSS.n326 VSS.n306 0.16242
R731 VSS.n307 VSS.n306 0.16242
R732 VSS.n307 VSS.n305 0.16242
R733 VSS.n318 VSS.n305 0.16242
R734 VSS.n319 VSS.n318 0.16242
R735 VSS.n321 VSS.n319 0.16242
R736 VSS.n320 VSS.n23 0.146995
R737 VSS.n323 VSS.n8 0.145358
R738 VSS.n139 VSS.n138 0.139317
R739 VSS.n363 VSS.n357 0.117247
R740 VSS.n373 VSS.n372 0.1171
R741 VSS.n288 VSS.n287 0.0952183
R742 VSS.n323 VSS.n309 0.0942639
R743 VSS.n320 VSS.n315 0.0938804
R744 VSS.n290 VSS.n289 0.0927738
R745 VSS.n301 VSS.n300 0.0925656
R746 VSS.n324 VSS.n310 0.0918194
R747 VSS.n316 VSS.n314 0.0913723
R748 VSS.n292 VSS.n291 0.0903294
R749 VSS.n294 VSS.t15 0.0903294
R750 VSS.n299 VSS.n298 0.0901212
R751 VSS.n325 VSS.n311 0.0891874
R752 VSS.t122 VSS.n330 0.0889922
R753 VSS.t122 VSS.n155 0.0889841
R754 VSS.n317 VSS.n313 0.0884862
R755 VSS.n184 VSS.n293 0.0878849
R756 VSS.n296 VSS.n295 0.0878849
R757 VSS.t15 VSS.n184 0.0876767
R758 VSS.n297 VSS.n296 0.0876767
R759 VSS.n313 VSS.n312 0.0870574
R760 VSS.n330 VSS.n308 0.0865477
R761 VSS.n312 VSS.n155 0.086547
R762 VSS.n311 VSS.n308 0.0863606
R763 VSS.n298 VSS.n297 0.0854405
R764 VSS.n293 VSS.n292 0.0852323
R765 VSS.n295 VSS.n294 0.0852323
R766 VSS.t53 VSS.n153 0.0840328
R767 VSS.n317 VSS.n314 0.0841695
R768 VSS.n325 VSS.n310 0.083723
R769 VSS.t31 VSS.n8 0.0834709
R770 VSS.n300 VSS.n299 0.082996
R771 VSS.n291 VSS.n290 0.0827878
R772 VSS.t35 VSS.n23 0.0827574
R773 VSS.n392 VSS.n182 0.0827273
R774 VSS.n390 VSS.n389 0.0827273
R775 VSS.n316 VSS.n315 0.0816507
R776 VSS.n357 VSS.n356 0.08146
R777 VSS.n356 VSS.n355 0.08146
R778 VSS.n355 VSS.n335 0.08146
R779 VSS.n336 VSS.n335 0.08146
R780 VSS.n369 VSS.n336 0.08146
R781 VSS.n370 VSS.n369 0.08146
R782 VSS.n371 VSS.n370 0.08146
R783 VSS.n372 VSS.n371 0.08146
R784 VSS.n324 VSS.n309 0.0812785
R785 VSS.n289 VSS.n288 0.0803434
R786 VSS.t41 VSS.n42 1.05113
R787 VSS.n379 VSS.t46 0.0592831
R788 VSS.n391 VSS 0.0445
R789 VSS.n303 VSS 0.0445
R790 VSS.n307 VSS.t122 0.0394179
R791 VSS.t15 VSS.n185 0.0394179
R792 VSS.n388 VSS.n185 0.0389615
R793 VSS.n331 VSS.n307 0.0389615
R794 VSS.t49 VSS.n367 0.031258
R795 VSS.n359 VSS.t42 0.031258
R796 VSS.t51 VSS.n353 0.031258
R797 VSS.n363 VSS.n362 0.0291125
R798 VSS.n373 VSS.n302 0.0291125
R799 VSS.n377 VSS.n373 0.0291125
R800 VSS.n364 VSS.n363 0.0291125
R801 VSS.n362 VSS.n358 0.0281144
R802 VSS.n354 VSS.n302 0.0281144
R803 VSS.n378 VSS.n377 0.0281144
R804 VSS.n368 VSS.n364 0.0281144
R805 VSS.n374 VSS.n83 0.0216549
R806 VSS.n375 VSS.t45 0.0208704
R807 VSS.n366 VSS.n365 0.0202884
R808 VSS.n361 VSS.n360 0.0202884
R809 VSS.n376 VSS.n375 0.0202884
R810 VSS.n352 VSS.n351 0.0202884
R811 VSS.n336 VSS.n334 0.0197308
R812 VSS.n336 VSS.t97 0.019449
R813 VSS.n83 VSS.n82 0.0135839
R814 VSS.n29 VSS.n28 0.0112956
R815 VSS.t35 VSS.n58 0.0133922
R816 VSS.n59 VSS.t31 0.0133922
R817 VSS.n338 VSS.n280 0.0118857
R818 VSS.n339 VSS.n228 0.0118857
R819 VSS.n340 VSS.n228 0.0118857
R820 VSS.n39 VSS.n38 0.0118857
R821 VSS.n341 VSS.n274 0.0118857
R822 VSS.n342 VSS.n272 0.0118857
R823 VSS.n343 VSS.n267 0.0118857
R824 VSS.n27 VSS.n265 0.0255404
R825 VSS.n344 VSS.n26 0.0247447
R826 VSS.n345 VSS.n237 0.0118857
R827 VSS.n31 VSS.n30 0.00668905
R828 VSS.n346 VSS.n241 0.0118857
R829 VSS.n347 VSS.n241 0.0118857
R830 VSS.n348 VSS.n36 0.0118857
R831 VSS.n349 VSS.n41 0.0118857
R832 VSS.n64 VSS.n252 0.0161786
R833 VSS.n350 VSS.n257 0.0118857
R834 VSS.n349 VSS.n257 0.0118857
R835 VSS.n346 VSS.n239 0.0118857
R836 VSS.n344 VSS.n237 0.0118857
R837 VSS.n343 VSS.n265 0.0118857
R838 VSS.n342 VSS.n34 0.0118857
R839 VSS.n341 VSS.n272 0.0118857
R840 VSS.n76 VSS.n274 0.0161786
R841 VSS.n340 VSS.n38 0.0118857
R842 VSS.n339 VSS.n56 0.0220468
R843 VSS.n55 VSS.n278 0.0296359
R844 VSS.n338 VSS.n278 0.0118857
R845 VSS.n365 VSS.n29 0.0115582
R846 VSS.n360 VSS.n29 0.0115582
R847 VSS.n352 VSS.n83 0.0112672
R848 VSS.n24 VSS.n9 0.0112168
R849 VSS.n24 VSS.n10 0.0112168
R850 VSS.n24 VSS.n11 0.0112168
R851 VSS.n24 VSS.n12 0.0112168
R852 VSS.n24 VSS.n13 0.0112168
R853 VSS.n24 VSS.n14 0.0112168
R854 VSS.n24 VSS.n16 0.0112168
R855 VSS.n24 VSS.n17 0.0112168
R856 VSS.n24 VSS.n18 0.0112168
R857 VSS.n24 VSS.n19 0.0112168
R858 VSS.n24 VSS.n20 0.0112168
R859 VSS.n24 VSS.n21 0.0112168
R860 VSS.n24 VSS.n22 0.0112168
R861 VSS.n25 VSS.t133 18.9893
R862 VSS.n24 VSS.n25 0.00304232
R863 VSS.n139 VSS.n137 0.142137
R864 VSS.n367 VSS.n366 0.0108877
R865 VSS.n361 VSS.n359 0.0108877
R866 VSS.n376 VSS.n374 0.0108877
R867 VSS.n353 VSS.n351 0.0108877
R868 VSS.t46 VSS.n83 0.0101032
R869 VSS.t52 VSS.n83 0.0101032
R870 VSS.t48 VSS.n29 0.00981217
R871 VSS.t41 VSS.n29 0.00981217
R872 VSS.n24 VSS.n15 0.00963963
R873 VSS VSS.n392 0.0095
R874 VSS.n390 VSS 0.0095
R875 VSS.t56 VSS.n46 0.0738339
R876 VSS.n1 VSS.n37 0.0195611
R877 VSS.n51 VSS.n70 0.0282015
R878 VSS.n32 VSS.n239 0.0237562
R879 VSS.n5 VSS.n59 0.0123024
R880 VSS.n2 VSS.n58 0.0123024
R881 VSS.t53 VSS.n44 0.0188052
R882 VSS.n52 VSS.n57 0.0219532
R883 VSS.t97 VSS.n26 0.0131024
R884 VSS.n64 VSS.n29 0.0200861
R885 VSS.n36 VSS.n35 0.0187349
R886 VSS.n34 VSS.n33 0.0187349
R887 VSS.n60 VSS.n24 0.0185563
R888 VSS.n41 VSS.n40 0.0183268
R889 VSS.n77 VSS.n39 0.0183268
R890 VSS.n48 VSS.n47 0.0114278
R891 VSS.n269 VSS.n63 0.0180738
R892 VSS.n42 VSS.n48 0.0174599
R893 VSS.n280 VSS.n79 0.0174081
R894 VSS.n269 VSS.n75 0.0174081
R895 VSS.n62 VSS.n61 0.00928196
R896 VSS.n252 VSS.n68 0.0174081
R897 VSS.n7 VSS.t33 17.0032
R898 VSS.t37 VSS.n4 17.0032
C0 vout4 vin4 15.8261f
C1 vin3 vin4 0.02526f
C2 vin2 vout2 15.8261f
C3 vout2 VDD 9.19358f
C4 vout3 VDD 9.19358f
C5 vin3 vout3 15.8261f
C6 vin2 vin1 0.02526f
C7 vin1 VDD 26.3603f
C8 vin2 VDD 26.3294f
C9 vout4 VDD 9.20502f
C10 vout1 vin1 15.8261f
C11 vout1 VDD 9.20502f
C12 vin2 vin3 0.02893f
C13 vin3 VDD 26.3294f
C14 vin4 VDD 26.3603f
C15 vout1 VSS 10.72398f
C16 vout2 VSS 10.70542f
C17 vout3 VSS 10.70542f
C18 vout4 VSS 10.72398f
C19 VSS.t105 VSS 6.81335f
C20 VSS.t76 VSS 6.81335f
C21 VSS.t24 VSS 6.83105f
.ends

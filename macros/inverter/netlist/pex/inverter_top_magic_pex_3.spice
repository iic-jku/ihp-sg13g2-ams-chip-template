* PEX produced on Tue Jul 21 02:39:13 AM CEST 2026 using /foss/tools/sak/sak-pex.sh with m=3 and s=1 (extresist threshold=10000 mOhm, minres=1000 mOhm, mindelay=1 ps)
* NGSPICE file created from inverter_top_pex.ext - technology: ihp-sg13g2

.subckt inverter_top_pex VDD vin4 vout4 VSS vin3 vout3 vin2 vout2 vout1 vin1
X0 vout3 vin3 VSS.t102 VSS.t83 sg13_lv_nmos ad=0.19p pd=1.38u as=0.19p ps=1.38u w=1u l=1u
X1 VDD VDD VDD VDD sg13_lv_pmos ad=1.14p pd=6.38u as=0.56797n ps=1.006m w=6u l=1u
X2 VSS.t1 VSS.t50 VSS.t52 VSS.t51 sg13_lv_nmos ad=0.34p pd=2.68u as=0 ps=0 w=1u l=1u
X3 VDD VDD VDD VDD sg13_lv_pmos ad=1.14p pd=6.38u as=0 ps=0 w=6u l=1u
X4 VDD vin4 vout4 VDD sg13_lv_pmos ad=1.14p pd=6.38u as=1.14p ps=6.38u w=6u l=1u
X5 vout2 vin2 VSS.t73 VSS.t74 sg13_lv_nmos ad=0.19p pd=1.38u as=0.19p ps=1.38u w=1u l=1u
X6 vout3 vin3 VDD VDD sg13_lv_pmos ad=1.14p pd=6.38u as=1.14p ps=6.38u w=6u l=1u
X7 vout4 vin4 VSS.t107 VSS.t108 sg13_lv_nmos ad=0.19p pd=1.38u as=0.19p ps=1.38u w=1u l=1u
X8 vout3 vin3 VSS.t41 VSS.t56 sg13_lv_nmos ad=0.19p pd=1.38u as=0.19p ps=1.38u w=1u l=1u
X9 vout2 vin2 VSS.t67 VSS.t68 sg13_lv_nmos ad=0.19p pd=1.38u as=0.19p ps=1.38u w=1u l=1u
X10 vout4 vin4 VDD VDD sg13_lv_pmos ad=1.14p pd=6.38u as=1.14p ps=6.38u w=6u l=1u
X11 VDD vin2 vout2 VDD sg13_lv_pmos ad=1.14p pd=6.38u as=1.14p ps=6.38u w=6u l=1u
X12 VSS.t73 vin2 vout2 VSS.t72 sg13_lv_nmos ad=0.19p pd=1.38u as=0.19p ps=1.38u w=1u l=1u
X13 vout2 vin2 VSS.t76 VSS.t77 sg13_lv_nmos ad=0.19p pd=1.38u as=0.19p ps=1.38u w=1u l=1u
X14 vout2 vin2 VDD VDD sg13_lv_pmos ad=1.14p pd=6.38u as=1.14p ps=6.38u w=6u l=1u
X15 VSS.t113 vin4 vout4 VSS.t112 sg13_lv_nmos ad=0.19p pd=1.38u as=0.19p ps=1.38u w=1u l=1u
X16 vout1 vin1 VSS.t24 VSS.t25 sg13_lv_nmos ad=0.19p pd=1.38u as=0.19p ps=1.38u w=1u l=1u
X17 VDD vin2 vout2 VDD sg13_lv_pmos ad=1.14p pd=6.38u as=1.14p ps=6.38u w=6u l=1u
X18 vout4 vin4 VSS.t34 VSS.t105 sg13_lv_nmos ad=0.19p pd=1.38u as=0.19p ps=1.38u w=1u l=1u
X19 VDD vin2 vout2 VDD sg13_lv_pmos ad=1.14p pd=6.38u as=1.14p ps=6.38u w=6u l=1u
X20 VSS.t102 vin3 vout3 VSS.t81 sg13_lv_nmos ad=0.19p pd=1.38u as=0.19p ps=1.38u w=1u l=1u
X21 vout4 vin4 VSS.t122 VSS.t123 sg13_lv_nmos ad=0.19p pd=1.38u as=0.19p ps=1.38u w=1u l=1u
X22 VSS.t116 vin4 vout4 VSS.t115 sg13_lv_nmos ad=0.19p pd=1.38u as=0.19p ps=1.38u w=1u l=1u
X23 VDD vin3 vout3 VDD sg13_lv_pmos ad=1.14p pd=6.38u as=1.14p ps=6.38u w=6u l=1u
X24 VDD vin2 vout2 VDD sg13_lv_pmos ad=1.14p pd=6.38u as=1.14p ps=6.38u w=6u l=1u
X25 vout3 vin3 VDD VDD sg13_lv_pmos ad=1.14p pd=6.38u as=1.14p ps=6.38u w=6u l=1u
X26 VSS.t67 vin2 vout2 VSS.t66 sg13_lv_nmos ad=0.19p pd=1.38u as=0.19p ps=1.38u w=1u l=1u
X27 VDD vin3 vout3 VDD sg13_lv_pmos ad=1.14p pd=6.38u as=1.14p ps=6.38u w=6u l=1u
X28 VSS.t41 VSS.t39 VSS.t41 VSS.t40 sg13_lv_nmos ad=0.34p pd=2.68u as=0 ps=0 w=1u l=1u
X29 vout2 vin2 VDD VDD sg13_lv_pmos ad=1.14p pd=6.38u as=1.14p ps=6.38u w=6u l=1u
X30 vout2 vin2 VSS.t70 VSS.t71 sg13_lv_nmos ad=0.19p pd=1.38u as=0.19p ps=1.38u w=1u l=1u
X31 vout1 vin1 VSS.t18 VSS.t19 sg13_lv_nmos ad=0.19p pd=1.38u as=0.19p ps=1.38u w=1u l=1u
X32 VSS.t76 vin2 vout2 VSS.t75 sg13_lv_nmos ad=0.19p pd=1.38u as=0.19p ps=1.38u w=1u l=1u
X33 vout4 vin4 VSS.t119 VSS.t120 sg13_lv_nmos ad=0.19p pd=1.38u as=0.19p ps=1.38u w=1u l=1u
X34 vout1 vin1 VDD VDD sg13_lv_pmos ad=1.14p pd=6.38u as=1.14p ps=6.38u w=6u l=1u
X35 vout1 vin1 VSS.t12 VSS.t13 sg13_lv_nmos ad=0.19p pd=1.38u as=0.19p ps=1.38u w=1u l=1u
X36 VSS.t125 vin4 vout4 VSS.t124 sg13_lv_nmos ad=0.19p pd=1.38u as=0.19p ps=1.38u w=1u l=1u
X37 VDD VDD VDD VDD sg13_lv_pmos ad=1.14p pd=6.38u as=0 ps=0 w=6u l=1u
X38 VSS.t18 vin1 vout1 VSS.t17 sg13_lv_nmos ad=0.19p pd=1.38u as=0.19p ps=1.38u w=1u l=1u
X39 vout2 vin2 VDD VDD sg13_lv_pmos ad=1.14p pd=6.38u as=1.14p ps=6.38u w=6u l=1u
X40 VDD vin4 vout4 VDD sg13_lv_pmos ad=1.14p pd=6.38u as=1.14p ps=6.38u w=6u l=1u
X41 vout1 vin1 VSS.t21 VSS.t22 sg13_lv_nmos ad=0.19p pd=1.38u as=0.19p ps=1.38u w=1u l=1u
X42 vout3 vin3 VSS.t100 VSS.t80 sg13_lv_nmos ad=0.19p pd=1.38u as=0.19p ps=1.38u w=1u l=1u
X43 VDD vin3 vout3 VDD sg13_lv_pmos ad=1.14p pd=6.38u as=1.14p ps=6.38u w=6u l=1u
X44 vout4 vin4 VDD VDD sg13_lv_pmos ad=1.14p pd=6.38u as=1.14p ps=6.38u w=6u l=1u
X45 VDD vin4 vout4 VDD sg13_lv_pmos ad=1.14p pd=6.38u as=1.14p ps=6.38u w=6u l=1u
X46 vout3 vin3 VDD VDD sg13_lv_pmos ad=1.14p pd=6.38u as=1.14p ps=6.38u w=6u l=1u
X47 VDD vin3 vout3 VDD sg13_lv_pmos ad=1.14p pd=6.38u as=1.14p ps=6.38u w=6u l=1u
X48 VSS.t38 VSS.t35 VSS.t37 VSS.t36 sg13_lv_nmos ad=0.19p pd=1.38u as=0 ps=0 w=1u l=1u
X49 VDD vin4 vout4 VDD sg13_lv_pmos ad=1.14p pd=6.38u as=1.14p ps=6.38u w=6u l=1u
X50 VDD vin2 vout2 VDD sg13_lv_pmos ad=1.14p pd=6.38u as=1.14p ps=6.38u w=6u l=1u
X51 VSS.t128 vin4 vout4 VSS.t127 sg13_lv_nmos ad=0.19p pd=1.38u as=0.19p ps=1.38u w=1u l=1u
X52 VDD vin3 vout3 VDD sg13_lv_pmos ad=1.14p pd=6.38u as=1.14p ps=6.38u w=6u l=1u
X53 VSS.t12 vin1 vout1 VSS.t11 sg13_lv_nmos ad=0.19p pd=1.38u as=0.19p ps=1.38u w=1u l=1u
X54 VDD vin1 vout1 VDD sg13_lv_pmos ad=1.14p pd=6.38u as=1.14p ps=6.38u w=6u l=1u
X55 vout4 vin4 VSS.t131 VSS.t132 sg13_lv_nmos ad=0.19p pd=1.38u as=0.19p ps=1.38u w=1u l=1u
X56 vout1 vin1 VDD VDD sg13_lv_pmos ad=1.14p pd=6.38u as=1.14p ps=6.38u w=6u l=1u
X57 vout4 vin4 VDD VDD sg13_lv_pmos ad=1.14p pd=6.38u as=1.14p ps=6.38u w=6u l=1u
X58 vout1 vin1 VSS.t15 VSS.t16 sg13_lv_nmos ad=0.19p pd=1.38u as=0.19p ps=1.38u w=1u l=1u
X59 VDD vin1 vout1 VDD sg13_lv_pmos ad=1.14p pd=6.38u as=1.14p ps=6.38u w=6u l=1u
X60 vout3 vin3 VSS.t96 VSS.t74 sg13_lv_nmos ad=0.19p pd=1.38u as=0.19p ps=1.38u w=1u l=1u
X61 VSS.t21 vin1 vout1 VSS.t20 sg13_lv_nmos ad=0.19p pd=1.38u as=0.19p ps=1.38u w=1u l=1u
X62 VDD VDD VDD VDD sg13_lv_pmos ad=2.04p pd=12.68u as=0 ps=0 w=6u l=1u
X63 vout4 vin4 VDD VDD sg13_lv_pmos ad=1.14p pd=6.38u as=1.14p ps=6.38u w=6u l=1u
X64 VDD vin3 vout3 VDD sg13_lv_pmos ad=1.14p pd=6.38u as=1.14p ps=6.38u w=6u l=1u
X65 VDD vin4 vout4 VDD sg13_lv_pmos ad=1.14p pd=6.38u as=1.14p ps=6.38u w=6u l=1u
X66 vout3 vin3 VDD VDD sg13_lv_pmos ad=1.14p pd=6.38u as=1.14p ps=6.38u w=6u l=1u
X67 vout3 vin3 VSS.t92 VSS.t68 sg13_lv_nmos ad=0.19p pd=1.38u as=0.19p ps=1.38u w=1u l=1u
X68 VSS.t96 vin3 vout3 VSS.t72 sg13_lv_nmos ad=0.19p pd=1.38u as=0.19p ps=1.38u w=1u l=1u
X69 VDD VDD VDD VDD sg13_lv_pmos ad=1.14p pd=6.38u as=0 ps=0 w=6u l=1u
X70 vout3 vin3 VSS.t98 VSS.t77 sg13_lv_nmos ad=0.19p pd=1.38u as=0.19p ps=1.38u w=1u l=1u
X71 vout4 vin4 VDD VDD sg13_lv_pmos ad=1.14p pd=6.38u as=1.14p ps=6.38u w=6u l=1u
X72 vout3 vin3 VDD VDD sg13_lv_pmos ad=1.14p pd=6.38u as=1.14p ps=6.38u w=6u l=1u
X73 VDD vin1 vout1 VDD sg13_lv_pmos ad=1.14p pd=6.38u as=1.14p ps=6.38u w=6u l=1u
X74 vout2 vin2 VDD VDD sg13_lv_pmos ad=1.14p pd=6.38u as=1.14p ps=6.38u w=6u l=1u
X75 vout1 vin1 VDD VDD sg13_lv_pmos ad=1.14p pd=6.38u as=1.14p ps=6.38u w=6u l=1u
X76 vout2 vin2 VSS.t61 VSS.t62 sg13_lv_nmos ad=0.19p pd=1.38u as=0.19p ps=1.38u w=1u l=1u
X77 VDD vin1 vout1 VDD sg13_lv_pmos ad=1.14p pd=6.38u as=1.14p ps=6.38u w=6u l=1u
X78 VDD vin1 vout1 VDD sg13_lv_pmos ad=1.14p pd=6.38u as=1.14p ps=6.38u w=6u l=1u
X79 VDD vin3 vout3 VDD sg13_lv_pmos ad=1.14p pd=6.38u as=1.14p ps=6.38u w=6u l=1u
X80 VSS.t92 vin3 vout3 VSS.t66 sg13_lv_nmos ad=0.19p pd=1.38u as=0.19p ps=1.38u w=1u l=1u
X81 vout3 vin3 VSS.t94 VSS.t71 sg13_lv_nmos ad=0.19p pd=1.38u as=0.19p ps=1.38u w=1u l=1u
X82 VSS.t110 vin4 vout4 VSS.t109 sg13_lv_nmos ad=0.19p pd=1.38u as=0.19p ps=1.38u w=1u l=1u
X83 VDD vin4 vout4 VDD sg13_lv_pmos ad=1.14p pd=6.38u as=1.14p ps=6.38u w=6u l=1u
X84 VSS.t98 vin3 vout3 VSS.t75 sg13_lv_nmos ad=0.19p pd=1.38u as=0.19p ps=1.38u w=1u l=1u
X85 vout4 vin4 VSS.t113 VSS.t114 sg13_lv_nmos ad=0.19p pd=1.38u as=0.19p ps=1.38u w=1u l=1u
X86 VDD vin1 vout1 VDD sg13_lv_pmos ad=1.14p pd=6.38u as=1.14p ps=6.38u w=6u l=1u
X87 vout2 vin2 VDD VDD sg13_lv_pmos ad=1.14p pd=6.38u as=1.14p ps=6.38u w=6u l=1u
X88 vout1 vin1 VDD VDD sg13_lv_pmos ad=1.14p pd=6.38u as=1.14p ps=6.38u w=6u l=1u
X89 VSS.t107 vin4 vout4 VSS.t106 sg13_lv_nmos ad=0.19p pd=1.38u as=0.19p ps=1.38u w=1u l=1u
X90 VDD VDD VDD VDD sg13_lv_pmos ad=2.04p pd=12.68u as=0 ps=0 w=6u l=1u
X91 vout2 vin2 VDD VDD sg13_lv_pmos ad=1.14p pd=6.38u as=1.14p ps=6.38u w=6u l=1u
X92 VDD vin2 vout2 VDD sg13_lv_pmos ad=1.14p pd=6.38u as=1.14p ps=6.38u w=6u l=1u
X93 VSS.t61 vin2 vout2 VSS.t60 sg13_lv_nmos ad=0.19p pd=1.38u as=0.19p ps=1.38u w=1u l=1u
X94 VSS.t119 vin4 vout4 VSS.t118 sg13_lv_nmos ad=0.19p pd=1.38u as=0.19p ps=1.38u w=1u l=1u
X95 vout2 vin2 VDD VDD sg13_lv_pmos ad=1.14p pd=6.38u as=1.14p ps=6.38u w=6u l=1u
X96 VDD VDD VDD VDD sg13_lv_pmos ad=2.04p pd=12.68u as=0 ps=0 w=6u l=1u
X97 vout2 vin2 VSS.t64 VSS.t65 sg13_lv_nmos ad=0.19p pd=1.38u as=0.19p ps=1.38u w=1u l=1u
X98 VSS.t70 vin2 vout2 VSS.t69 sg13_lv_nmos ad=0.19p pd=1.38u as=0.19p ps=1.38u w=1u l=1u
X99 vout1 vin1 VDD VDD sg13_lv_pmos ad=1.14p pd=6.38u as=1.14p ps=6.38u w=6u l=1u
X100 vout1 vin1 VSS.t6 VSS.t7 sg13_lv_nmos ad=0.19p pd=1.38u as=0.19p ps=1.38u w=1u l=1u
X101 vout4 vin4 VSS.t116 VSS.t117 sg13_lv_nmos ad=0.19p pd=1.38u as=0.19p ps=1.38u w=1u l=1u
X102 vout3 vin3 VDD VDD sg13_lv_pmos ad=1.14p pd=6.38u as=1.14p ps=6.38u w=6u l=1u
X103 vout4 vin4 VSS.t128 VSS.t129 sg13_lv_nmos ad=0.19p pd=1.38u as=0.19p ps=1.38u w=1u l=1u
X104 VSS.t45 VSS.t48 VSS.t45 VSS.t43 sg13_lv_nmos ad=0.19p pd=1.38u as=0 ps=0 w=1u l=1u
X105 VSS.t122 vin4 vout4 VSS.t121 sg13_lv_nmos ad=0.19p pd=1.38u as=0.19p ps=1.38u w=1u l=1u
X106 VDD vin1 vout1 VDD sg13_lv_pmos ad=1.14p pd=6.38u as=1.14p ps=6.38u w=6u l=1u
X107 VSS.t45 vin2 vout2 VSS.t84 sg13_lv_nmos ad=0.19p pd=1.38u as=0.19p ps=1.38u w=1u l=1u
X108 VDD vin2 vout2 VDD sg13_lv_pmos ad=1.14p pd=6.38u as=1.14p ps=6.38u w=6u l=1u
X109 vout4 vin4 VSS.t125 VSS.t126 sg13_lv_nmos ad=0.19p pd=1.38u as=0.19p ps=1.38u w=1u l=1u
X110 vout4 vin4 VDD VDD sg13_lv_pmos ad=1.14p pd=6.38u as=1.14p ps=6.38u w=6u l=1u
X111 vout2 vin2 VDD VDD sg13_lv_pmos ad=1.14p pd=6.38u as=1.14p ps=6.38u w=6u l=1u
X112 vout2 vin2 VSS.t58 VSS.t59 sg13_lv_nmos ad=0.19p pd=1.38u as=0.19p ps=1.38u w=1u l=1u
X113 VDD vin2 vout2 VDD sg13_lv_pmos ad=1.14p pd=6.38u as=1.14p ps=6.38u w=6u l=1u
X114 VSS.t64 vin2 vout2 VSS.t63 sg13_lv_nmos ad=0.19p pd=1.38u as=0.19p ps=1.38u w=1u l=1u
X115 VDD vin4 vout4 VDD sg13_lv_pmos ad=1.14p pd=6.38u as=1.14p ps=6.38u w=6u l=1u
X116 VDD VDD VDD VDD sg13_lv_pmos ad=2.04p pd=12.68u as=0 ps=0 w=6u l=1u
X117 VSS.t58 vin2 vout2 VSS.t57 sg13_lv_nmos ad=0.19p pd=1.38u as=0.19p ps=1.38u w=1u l=1u
X118 VSS.t6 vin1 vout1 VSS.t5 sg13_lv_nmos ad=0.19p pd=1.38u as=0.19p ps=1.38u w=1u l=1u
X119 vout3 vin3 VDD VDD sg13_lv_pmos ad=1.14p pd=6.38u as=1.14p ps=6.38u w=6u l=1u
X120 vout1 vin1 VSS.t9 VSS.t10 sg13_lv_nmos ad=0.19p pd=1.38u as=0.19p ps=1.38u w=1u l=1u
X121 VSS.t15 vin1 vout1 VSS.t14 sg13_lv_nmos ad=0.19p pd=1.38u as=0.19p ps=1.38u w=1u l=1u
X122 vout3 vin3 VDD VDD sg13_lv_pmos ad=1.14p pd=6.38u as=1.14p ps=6.38u w=6u l=1u
X123 VDD vin3 vout3 VDD sg13_lv_pmos ad=1.14p pd=6.38u as=1.14p ps=6.38u w=6u l=1u
X124 vout3 vin3 VDD VDD sg13_lv_pmos ad=1.14p pd=6.38u as=1.14p ps=6.38u w=6u l=1u
X125 vout3 vin3 VSS.t88 VSS.t62 sg13_lv_nmos ad=0.19p pd=1.38u as=0.19p ps=1.38u w=1u l=1u
X126 VSS.t79 vin2 vout2 VSS.t78 sg13_lv_nmos ad=0.19p pd=1.38u as=0.19p ps=1.38u w=1u l=1u
X127 vout1 vin1 VDD VDD sg13_lv_pmos ad=1.14p pd=6.38u as=1.14p ps=6.38u w=6u l=1u
X128 vout2 vin2 VSS.t82 VSS.t83 sg13_lv_nmos ad=0.19p pd=1.38u as=0.19p ps=1.38u w=1u l=1u
X129 VSS.t37 vin4 vout4 VSS.t133 sg13_lv_nmos ad=0.19p pd=1.38u as=0.19p ps=1.38u w=1u l=1u
X130 VSS.t55 VSS.t53 VSS.t30 VSS.t54 sg13_lv_nmos ad=0.19p pd=1.38u as=0 ps=0 w=1u l=1u
X131 VSS.t30 vin1 vout1 VSS.t29 sg13_lv_nmos ad=0.19p pd=1.38u as=0.19p ps=1.38u w=1u l=1u
X132 vout2 vin2 VSS.t41 VSS.t56 sg13_lv_nmos ad=0.19p pd=1.38u as=0.19p ps=1.38u w=1u l=1u
X133 VSS.t34 VSS.t31 VSS.t33 VSS.t32 sg13_lv_nmos ad=0.34p pd=2.68u as=0 ps=0 w=1u l=1u
X134 vout1 vin1 VSS.t3 VSS.t4 sg13_lv_nmos ad=0.19p pd=1.38u as=0.19p ps=1.38u w=1u l=1u
X135 VSS.t9 vin1 vout1 VSS.t8 sg13_lv_nmos ad=0.19p pd=1.38u as=0.19p ps=1.38u w=1u l=1u
X136 VDD vin3 vout3 VDD sg13_lv_pmos ad=1.14p pd=6.38u as=1.14p ps=6.38u w=6u l=1u
X137 VSS.t3 vin1 vout1 VSS.t2 sg13_lv_nmos ad=0.19p pd=1.38u as=0.19p ps=1.38u w=1u l=1u
X138 vout4 vin4 VDD VDD sg13_lv_pmos ad=1.14p pd=6.38u as=1.14p ps=6.38u w=6u l=1u
X139 vout3 vin3 VDD VDD sg13_lv_pmos ad=1.14p pd=6.38u as=1.14p ps=6.38u w=6u l=1u
X140 VDD vin3 vout3 VDD sg13_lv_pmos ad=1.14p pd=6.38u as=1.14p ps=6.38u w=6u l=1u
X141 VSS.t88 vin3 vout3 VSS.t60 sg13_lv_nmos ad=0.19p pd=1.38u as=0.19p ps=1.38u w=1u l=1u
X142 vout3 vin3 VSS.t90 VSS.t65 sg13_lv_nmos ad=0.19p pd=1.38u as=0.19p ps=1.38u w=1u l=1u
X143 vout1 vin1 VDD VDD sg13_lv_pmos ad=1.14p pd=6.38u as=1.14p ps=6.38u w=6u l=1u
X144 VSS.t82 vin2 vout2 VSS.t81 sg13_lv_nmos ad=0.19p pd=1.38u as=0.19p ps=1.38u w=1u l=1u
X145 VSS.t94 vin3 vout3 VSS.t69 sg13_lv_nmos ad=0.19p pd=1.38u as=0.19p ps=1.38u w=1u l=1u
X146 VDD vin4 vout4 VDD sg13_lv_pmos ad=1.14p pd=6.38u as=1.14p ps=6.38u w=6u l=1u
X147 vout1 vin1 VDD VDD sg13_lv_pmos ad=1.14p pd=6.38u as=1.14p ps=6.38u w=6u l=1u
X148 VDD vin1 vout1 VDD sg13_lv_pmos ad=1.14p pd=6.38u as=1.14p ps=6.38u w=6u l=1u
X149 vout4 vin4 VDD VDD sg13_lv_pmos ad=1.14p pd=6.38u as=1.14p ps=6.38u w=6u l=1u
X150 VSS.t24 vin1 vout1 VSS.t23 sg13_lv_nmos ad=0.19p pd=1.38u as=0.19p ps=1.38u w=1u l=1u
X151 vout1 vin1 VSS.t27 VSS.t28 sg13_lv_nmos ad=0.19p pd=1.38u as=0.19p ps=1.38u w=1u l=1u
X152 vout1 vin1 VDD VDD sg13_lv_pmos ad=1.14p pd=6.38u as=1.14p ps=6.38u w=6u l=1u
X153 vout2 vin2 VDD VDD sg13_lv_pmos ad=1.14p pd=6.38u as=1.14p ps=6.38u w=6u l=1u
X154 vout4 vin4 VSS.t110 VSS.t111 sg13_lv_nmos ad=0.19p pd=1.38u as=0.19p ps=1.38u w=1u l=1u
X155 VSS.t41 VSS.t46 VSS.t41 VSS.t40 sg13_lv_nmos ad=0.34p pd=2.68u as=0 ps=0 w=1u l=1u
X156 VSS.t45 VSS.t42 VSS.t44 VSS.t43 sg13_lv_nmos ad=0.19p pd=1.38u as=0 ps=0 w=1u l=1u
X157 vout4 vin4 VDD VDD sg13_lv_pmos ad=1.14p pd=6.38u as=1.14p ps=6.38u w=6u l=1u
X158 VSS.t44 vin3 vout3 VSS.t84 sg13_lv_nmos ad=0.19p pd=1.38u as=0.19p ps=1.38u w=1u l=1u
X159 VSS.t131 vin4 vout4 VSS.t130 sg13_lv_nmos ad=0.19p pd=1.38u as=0.19p ps=1.38u w=1u l=1u
X160 VDD vin4 vout4 VDD sg13_lv_pmos ad=1.14p pd=6.38u as=1.14p ps=6.38u w=6u l=1u
X161 vout1 vin1 VSS.t1 VSS.t0 sg13_lv_nmos ad=0.19p pd=1.38u as=0.19p ps=1.38u w=1u l=1u
X162 vout3 vin3 VSS.t86 VSS.t59 sg13_lv_nmos ad=0.19p pd=1.38u as=0.19p ps=1.38u w=1u l=1u
X163 VSS.t90 vin3 vout3 VSS.t63 sg13_lv_nmos ad=0.19p pd=1.38u as=0.19p ps=1.38u w=1u l=1u
X164 vout4 vin4 VDD VDD sg13_lv_pmos ad=1.14p pd=6.38u as=1.14p ps=6.38u w=6u l=1u
X165 vout2 vin2 VSS.t79 VSS.t80 sg13_lv_nmos ad=0.19p pd=1.38u as=0.19p ps=1.38u w=1u l=1u
X166 VSS.t86 vin3 vout3 VSS.t57 sg13_lv_nmos ad=0.19p pd=1.38u as=0.19p ps=1.38u w=1u l=1u
X167 VDD vin1 vout1 VDD sg13_lv_pmos ad=1.14p pd=6.38u as=1.14p ps=6.38u w=6u l=1u
X168 vout1 vin1 VDD VDD sg13_lv_pmos ad=1.14p pd=6.38u as=1.14p ps=6.38u w=6u l=1u
X169 VDD vin1 vout1 VDD sg13_lv_pmos ad=1.14p pd=6.38u as=1.14p ps=6.38u w=6u l=1u
X170 VDD vin4 vout4 VDD sg13_lv_pmos ad=1.14p pd=6.38u as=1.14p ps=6.38u w=6u l=1u
X171 VSS.t27 vin1 vout1 VSS.t26 sg13_lv_nmos ad=0.19p pd=1.38u as=0.19p ps=1.38u w=1u l=1u
X172 VDD vin2 vout2 VDD sg13_lv_pmos ad=1.14p pd=6.38u as=1.14p ps=6.38u w=6u l=1u
X173 vout2 vin2 VDD VDD sg13_lv_pmos ad=1.14p pd=6.38u as=1.14p ps=6.38u w=6u l=1u
X174 VDD vin2 vout2 VDD sg13_lv_pmos ad=1.14p pd=6.38u as=1.14p ps=6.38u w=6u l=1u
X175 VSS.t100 vin3 vout3 VSS.t78 sg13_lv_nmos ad=0.19p pd=1.38u as=0.19p ps=1.38u w=1u l=1u
R0 VSS.n2 VSS.n130 6777.49
R1 VSS.n319 VSS.n2 6777.49
R2 VSS.n63 VSS.n130 6777.49
R3 VSS.n319 VSS.n318 1580.41
R4 VSS.n315 VSS.n130 1580.41
R5 VSS.n18 VSS.n132 13.7057
R6 VSS.t56 VSS.n150 88.7251
R7 VSS.n169 VSS.t84 88.7251
R8 VSS.t57 VSS.n149 83.1798
R9 VSS.n168 VSS.t83 83.1798
R10 VSS.t59 VSS.n148 77.6345
R11 VSS.n167 VSS.t81 77.6345
R12 VSS.n2 VSS.t133 9.76925
R13 VSS.n118 VSS.t60 72.0892
R14 VSS.n166 VSS.t80 72.0892
R15 VSS.n2 VSS.t132 12.2976
R16 VSS.t62 VSS.n147 66.5439
R17 VSS.n165 VSS.t78 66.5439
R18 VSS.n2 VSS.t130 14.4719
R19 VSS.n2 VSS.t106 12.3005
R20 VSS.t63 VSS.n146 60.9987
R21 VSS.n164 VSS.t77 60.9987
R22 VSS.n2 VSS.t129 16.2681
R23 VSS.n2 VSS.t108 14.4672
R24 VSS.n2 VSS.t109 16.2774
R25 VSS.t28 VSS.n75 64.5222
R26 VSS.t65 VSS.n145 55.4534
R27 VSS.n160 VSS.t69 55.4534
R28 VSS.t71 VSS.n141 55.4534
R29 VSS.n163 VSS.t75 55.4534
R30 VSS.n2 VSS.t111 17.7165
R31 VSS.t26 VSS.n68 60.7265
R32 VSS.t66 VSS.n144 49.9081
R33 VSS.n159 VSS.t68 49.9081
R34 VSS.n101 VSS.t72 49.9081
R35 VSS.n99 VSS.t74 49.9081
R36 VSS.t126 VSS.n2 18.8053
R37 VSS.n2 VSS.t112 18.798
R38 VSS.t25 VSS.n71 56.932
R39 VSS.t124 VSS.n2 19.5205
R40 VSS.t118 VSS.n2 19.5199
R41 VSS.n2 VSS.t120 19.5206
R42 VSS.n158 VSS.t66 44.3628
R43 VSS.t68 VSS.n143 44.3628
R44 VSS.t72 VSS.n162 44.3628
R45 VSS.t74 VSS.n140 44.3628
R46 VSS.n2 VSS.t121 19.8915
R47 VSS.n2 VSS.t115 19.882
R48 VSS.t22 VSS.n77 49.3419
R49 VSS.n157 VSS.t65 38.8175
R50 VSS.t69 VSS.n142 38.8175
R51 VSS.n161 VSS.t71 38.8175
R52 VSS.t75 VSS.n139 38.8175
R53 VSS.n2 VSS.t114 19.5268
R54 VSS.n2 VSS.t123 19.8804
R55 VSS.t14 VSS.n67 45.5476
R56 VSS.t20 VSS.n61 45.5468
R57 VSS.t13 VSS.n69 41.7525
R58 VSS.t19 VSS.n79 41.7518
R59 VSS.n156 VSS.t63 33.2722
R60 VSS.t77 VSS.n138 33.2722
R61 VSS.t11 VSS.n62 37.9567
R62 VSS.t17 VSS.n73 37.9567
R63 VSS.n116 VSS.t62 27.7269
R64 VSS.t78 VSS.n137 27.7269
R65 VSS.n2 VSS.t127 17.7118
R66 VSS.t16 VSS.n64 34.1648
R67 VSS.t8 VSS.n80 30.3666
R68 VSS.t10 VSS.n66 34.1626
R69 VSS.n69 VSS.t11 41.7512
R70 VSS.n67 VSS.t13 37.9561
R71 VSS.n76 VSS.t29 11.3986
R72 VSS.t60 VSS.n155 22.1816
R73 VSS.t80 VSS.n136 22.1816
R74 VSS.t7 VSS.n60 26.5715
R75 VSS.n76 VSS.n57 0.00316223
R76 VSS.t28 VSS.n65 15.1866
R77 VSS.n75 VSS.n57 0.0108886
R78 VSS.n59 VSS.n57 0.0109013
R79 VSS.n77 VSS.n57 0.0108886
R80 VSS.n61 VSS.n57 0.0109013
R81 VSS.t19 VSS.n61 37.957
R82 VSS.n79 VSS.n57 0.0109013
R83 VSS.t17 VSS.n79 41.7521
R84 VSS.n73 VSS.n57 0.0109013
R85 VSS.t16 VSS.n73 45.5472
R86 VSS.n67 VSS.n57 0.0111485
R87 VSS.n69 VSS.n57 0.0111485
R88 VSS.n66 VSS.n57 0.0108886
R89 VSS.n80 VSS.n57 0.0109013
R90 VSS.t7 VSS.n80 53.1373
R91 VSS.n60 VSS.n57 0.0109013
R92 VSS.t5 VSS.n60 56.9324
R93 VSS.t0 VSS.n58 68.3176
R94 VSS.n33 VSS.t53 0.013442
R95 VSS.n33 VSS.n57 5.66307
R96 VSS.n57 VSS.n34 0.00844403
R97 VSS.n27 VSS.n33 0.0164358
R98 VSS.n25 VSS.n26 0.00876575
R99 VSS.n26 VSS.t30 5.66109
R100 VSS.t55 VSS.n27 5.66455
R101 VSS.n27 VSS.n25 0.00359016
R102 VSS.n70 VSS.n57 0.00291254
R103 VSS.n57 VSS.n17 0.816497
R104 VSS.n30 VSS.n29 0.00359052
R105 VSS.t1 VSS.n31 5.66266
R106 VSS.n31 VSS.n29 0.00641486
R107 VSS.n30 VSS.t52 5.66533
R108 VSS.n34 VSS.n30 1.32324
R109 VSS.n19 VSS.n18 0.824893
R110 VSS.n19 VSS.n265 17.0005
R111 VSS.n19 VSS.n207 17.0005
R112 VSS.n19 VSS.n263 17.0005
R113 VSS.n19 VSS.n208 17.0005
R114 VSS.n19 VSS.n262 17.0005
R115 VSS.n19 VSS.n133 17.0005
R116 VSS.n19 VSS.n209 17.0005
R117 VSS.n19 VSS.n261 17.0005
R118 VSS.n19 VSS.n134 17.0005
R119 VSS.n19 VSS.n210 17.0005
R120 VSS.n19 VSS.n259 17.0005
R121 VSS.n19 VSS.n56 5.66421
R122 VSS.n19 VSS.n135 17.0005
R123 VSS.n19 VSS.n211 17.0005
R124 VSS.n19 VSS.n258 17.0005
R125 VSS.n19 VSS.n136 8.49986
R126 VSS.n19 VSS.n166 17.0005
R127 VSS.n19 VSS.n213 17.0005
R128 VSS.n19 VSS.n55 5.66355
R129 VSS.n19 VSS.n257 17.0005
R130 VSS.n55 VSS.n54 0.0154247
R131 VSS.n19 VSS.n165 17.0005
R132 VSS.n19 VSS.n214 17.0005
R133 VSS.n19 VSS.n255 17.0005
R134 VSS.n19 VSS.n138 17.0005
R135 VSS.n19 VSS.n164 17.0005
R136 VSS.n19 VSS.n215 17.0005
R137 VSS.n19 VSS.n253 17.0005
R138 VSS.n40 VSS.n53 0.017451
R139 VSS.n19 VSS.n139 8.4998
R140 VSS.n19 VSS.n163 17.0005
R141 VSS.n19 VSS.n216 17.0005
R142 VSS.n19 VSS.n251 17.0005
R143 VSS.n19 VSS.n140 17.0005
R144 VSS.n19 VSS.n99 17.0005
R145 VSS.n19 VSS.n217 17.0005
R146 VSS.n19 VSS.n249 17.0005
R147 VSS.n19 VSS.n52 5.66421
R148 VSS.n19 VSS.n101 17.0005
R149 VSS.n19 VSS.n162 17.0005
R150 VSS.n19 VSS.n218 17.0005
R151 VSS.n19 VSS.n248 17.0005
R152 VSS.n19 VSS.n141 8.49762
R153 VSS.n19 VSS.n161 17.0005
R154 VSS.n19 VSS.n220 17.0005
R155 VSS.n19 VSS.n23 2.82683
R156 VSS.n19 VSS.n247 17.0005
R157 VSS.n19 VSS.n142 17.0005
R158 VSS.n19 VSS.n160 17.0005
R159 VSS.n19 VSS.n221 17.0005
R160 VSS.n19 VSS.n246 17.0005
R161 VSS.n20 VSS.n143 8.49565
R162 VSS.n19 VSS.n159 8.4959
R163 VSS.n19 VSS.n223 17.0005
R164 VSS.n19 VSS.n49 5.66421
R165 VSS.n19 VSS.n245 17.0005
R166 VSS.n19 VSS.n144 8.49614
R167 VSS.n19 VSS.n158 8.49639
R168 VSS.n19 VSS.n224 17.0005
R169 VSS.n19 VSS.n242 17.0005
R170 VSS.n19 VSS.n157 8.49664
R171 VSS.n19 VSS.n225 17.0005
R172 VSS.n19 VSS.n241 17.0005
R173 VSS.n32 VSS.n48 0.017222
R174 VSS.n19 VSS.n146 8.49688
R175 VSS.n19 VSS.n226 17.0005
R176 VSS.n19 VSS.n240 17.0005
R177 VSS.n19 VSS.n46 5.66421
R178 VSS.n19 VSS.n116 17.0005
R179 VSS.n19 VSS.n227 17.0005
R180 VSS.n19 VSS.n239 17.0005
R181 VSS.n19 VSS.n3 4.24728
R182 VSS.n19 VSS.n118 17.0005
R183 VSS.n28 VSS.n155 8.50015
R184 VSS.n19 VSS.n228 17.0005
R185 VSS.n19 VSS.n238 17.0005
R186 VSS.n19 VSS.n148 8.49713
R187 VSS.n19 VSS.n154 8.49861
R188 VSS.n19 VSS.n229 17.0005
R189 VSS.n19 VSS.n237 17.0005
R190 VSS.n19 VSS.t41 0.415922
R191 VSS.n19 VSS.n230 17.0005
R192 VSS.n19 VSS.n236 17.0005
R193 VSS.n19 VSS.n150 8.49753
R194 VSS.n19 VSS.n231 17.0005
R195 VSS.n19 VSS.n235 17.0005
R196 VSS.n19 VSS.n232 17.0005
R197 VSS.n19 VSS.t40 17.0005
R198 VSS.n19 VSS.n233 17.0005
R199 VSS.n19 VSS.n234 17.0005
R200 VSS.n19 VSS.n151 17.0005
R201 VSS.n316 VSS.n19 17.0005
R202 VSS.n28 VSS.n132 17.0005
R203 VSS.n28 VSS.n180 17.0005
R204 VSS.n28 VSS.n133 17.0005
R205 VSS.n28 VSS.n169 8.49842
R206 VSS.n28 VSS.n134 17.0005
R207 VSS.n28 VSS.n168 8.49817
R208 VSS.n28 VSS.n135 17.0005
R209 VSS.n28 VSS.n167 8.49792
R210 VSS.n28 VSS.n166 17.0005
R211 VSS.n28 VSS.n137 8.49787
R212 VSS.n28 VSS.n165 17.0005
R213 VSS.n28 VSS.n138 17.0005
R214 VSS.n28 VSS.n164 17.0005
R215 VSS.n28 VSS.n163 17.0005
R216 VSS.n28 VSS.n140 17.0005
R217 VSS.n28 VSS.n162 17.0005
R218 VSS.n28 VSS.n161 17.0005
R219 VSS.n28 VSS.n142 17.0005
R220 VSS.n28 VSS.n160 17.0005
R221 VSS.n28 VSS.n20 0.0117031
R222 VSS.n28 VSS.n145 8.49886
R223 VSS.n28 VSS.n156 8.49836
R224 VSS.n28 VSS.n147 8.49956
R225 VSS.n28 VSS.n149 8.49914
R226 VSS.n28 VSS.n153 8.49955
R227 VSS.n28 VSS.n152 8.50005
R228 VSS.n6 VSS.n38 5.6635
R229 VSS.n54 VSS.n256 0.0136165
R230 VSS.n53 VSS.n252 0.0136165
R231 VSS.n6 VSS.n41 5.66316
R232 VSS.n6 VSS.n51 5.66316
R233 VSS.n6 VSS.n22 5.66421
R234 VSS.n6 VSS.n47 5.66316
R235 VSS.n15 VSS.n2 8.49747
R236 VSS.n12 VSS.n2 1.10829
R237 VSS.n13 VSS.t38 8.49687
R238 VSS.t38 VSS.n35 17.0005
R239 VSS.n13 VSS.n12 0.00926173
R240 VSS.n12 VSS.n11 0.0123024
R241 VSS.n11 VSS.t37 8.49535
R242 VSS.n13 VSS.t37 17.0093
R243 VSS.n37 VSS.t34 17.0005
R244 VSS.n36 VSS.n14 0.00877297
R245 VSS.n14 VSS.t34 8.49711
R246 VSS.t33 VSS.n36 17.0005
R247 VSS.n15 VSS.n16 0.0123024
R248 VSS.t33 VSS.n16 8.49535
R249 VSS.n154 VSS.t59 16.6364
R250 VSS.t81 VSS.n135 16.6364
R251 VSS.t5 VSS.n78 22.7758
R252 VSS.t46 VSS.t41 4.99233
R253 VSS.t39 VSS.t41 4.99233
R254 VSS.t42 VSS.t44 4.99233
R255 VSS.t48 VSS.t45 4.99233
R256 VSS.n220 VSS.n193 13.1592
R257 VSS.n247 VSS.n193 13.1592
R258 VSS.t43 VSS.n264 12.4949
R259 VSS.n207 VSS.n179 12.4949
R260 VSS.t43 VSS.n181 12.4949
R261 VSS.n208 VSS.n182 12.4949
R262 VSS.n209 VSS.n183 12.4949
R263 VSS.n210 VSS.n184 12.4949
R264 VSS.n211 VSS.n185 12.4949
R265 VSS.n213 VSS.n186 12.4949
R266 VSS.n214 VSS.n187 12.4949
R267 VSS.n215 VSS.n188 12.4949
R268 VSS.n216 VSS.n189 12.4949
R269 VSS.n99 VSS.n190 12.4949
R270 VSS.n101 VSS.n191 12.4949
R271 VSS.n218 VSS.n192 12.4949
R272 VSS.n221 VSS.n194 12.4949
R273 VSS.n223 VSS.n195 12.4949
R274 VSS.n224 VSS.n196 12.4949
R275 VSS.n225 VSS.n197 12.4949
R276 VSS.n226 VSS.n198 12.4949
R277 VSS.n116 VSS.n199 12.4949
R278 VSS.n118 VSS.n200 12.4949
R279 VSS.n228 VSS.n201 12.4949
R280 VSS.n229 VSS.n202 12.4949
R281 VSS.n230 VSS.n203 12.4949
R282 VSS.n231 VSS.n204 12.4949
R283 VSS.n232 VSS.n205 12.4949
R284 VSS.n233 VSS.n206 12.4949
R285 VSS.n317 VSS.n151 12.4949
R286 VSS.n317 VSS.n316 12.4949
R287 VSS.n234 VSS.n206 12.4949
R288 VSS.t40 VSS.n205 12.4949
R289 VSS.n235 VSS.n204 12.4949
R290 VSS.n236 VSS.n203 12.4949
R291 VSS.n237 VSS.n202 12.4949
R292 VSS.n238 VSS.n201 12.4949
R293 VSS.n239 VSS.n200 12.4949
R294 VSS.n227 VSS.n199 12.4949
R295 VSS.n240 VSS.n198 12.4949
R296 VSS.n241 VSS.n197 12.4949
R297 VSS.n242 VSS.n196 12.4949
R298 VSS.n245 VSS.n195 12.4949
R299 VSS.n246 VSS.n194 12.4949
R300 VSS.n248 VSS.n192 12.4949
R301 VSS.n249 VSS.n191 12.4949
R302 VSS.n217 VSS.n190 12.4949
R303 VSS.n251 VSS.n189 12.4949
R304 VSS.n253 VSS.n188 12.4949
R305 VSS.n255 VSS.n187 12.4949
R306 VSS.n257 VSS.n186 12.4949
R307 VSS.n258 VSS.n185 12.4949
R308 VSS.n259 VSS.n184 12.4949
R309 VSS.n261 VSS.n183 12.4949
R310 VSS.n262 VSS.n182 12.4949
R311 VSS.n263 VSS.n181 12.4949
R312 VSS.n264 VSS.n180 12.4949
R313 VSS.n265 VSS.n179 12.4949
R314 VSS.t105 VSS.n2 9.77299
R315 VSS.t4 VSS.n74 18.9814
R316 VSS.t54 VSS.n76 13.7589
R317 VSS.t29 VSS.n65 68.3172
R318 VSS.t51 VSS.n72 13.759
R319 VSS.n74 VSS.t2 64.5232
R320 VSS.n78 VSS.t4 60.7278
R321 VSS.n66 VSS.t8 49.3419
R322 VSS.n62 VSS.t10 45.5478
R323 VSS.n64 VSS.t14 34.1658
R324 VSS.n77 VSS.t20 34.1626
R325 VSS.n59 VSS.t22 30.3666
R326 VSS.n71 VSS.t23 26.5725
R327 VSS.n68 VSS.t25 22.7772
R328 VSS.n75 VSS.t26 18.9824
R329 VSS.n153 VSS.t57 11.0911
R330 VSS.t83 VSS.n134 11.0911
R331 VSS.n63 VSS.n57 0.00104473
R332 VSS.n319 VSS.n72 6777.49
R333 VSS.n6 VSS.t43 8.5005
R334 VSS.n6 VSS.n99 8.5005
R335 VSS.n6 VSS.n101 8.5005
R336 VSS.n6 VSS.n116 8.5005
R337 VSS.n6 VSS.n118 8.5005
R338 VSS.n19 VSS.t45 0.587026
R339 VSS.n19 VSS.n260 8.4984
R340 VSS.n19 VSS.n39 8.4984
R341 VSS.n19 VSS.n212 8.4984
R342 VSS.n19 VSS.n43 8.4984
R343 VSS.n19 VSS.n256 8.4984
R344 VSS.n19 VSS.n254 8.4984
R345 VSS.n19 VSS.n40 4.24674
R346 VSS.n19 VSS.n252 8.4984
R347 VSS.n19 VSS.n250 8.4984
R348 VSS.n19 VSS.n42 8.4984
R349 VSS.n19 VSS.n219 8.4984
R350 VSS.n23 VSS.n273 0.0300047
R351 VSS.n19 VSS.n222 8.4984
R352 VSS.n49 VSS.n274 0.0161786
R353 VSS.n19 VSS.n244 8.4984
R354 VSS.n19 VSS.n243 8.4984
R355 VSS.n19 VSS.n21 8.4984
R356 VSS.n19 VSS.n32 4.2476
R357 VSS.n46 VSS.n48 0.0179095
R358 VSS.n3 VSS.n47 0.023597
R359 VSS.n6 VSS.n7 0.557375
R360 VSS.n6 VSS.n266 8.4984
R361 VSS.n38 VSS.n56 0.0139355
R362 VSS.n6 VSS.n267 8.4984
R363 VSS.n6 VSS.n268 8.4984
R364 VSS.n6 VSS.n44 8.4984
R365 VSS.n6 VSS.n54 5.66443
R366 VSS.n6 VSS.n269 8.4984
R367 VSS.n6 VSS.n45 5.66206
R368 VSS.n6 VSS.n53 5.66443
R369 VSS.n6 VSS.n270 8.4984
R370 VSS.n6 VSS.n271 8.4984
R371 VSS.n41 VSS.n52 0.014444
R372 VSS.n6 VSS.n272 8.4984
R373 VSS.n6 VSS.n273 8.4984
R374 VSS.n24 VSS.t94 0.0132494
R375 VSS.n6 VSS.n24 2.82412
R376 VSS.n6 VSS.n274 8.4984
R377 VSS.n51 VSS.n50 0.00635632
R378 VSS.n6 VSS.n275 8.4984
R379 VSS.n6 VSS.n276 8.4984
R380 VSS.n6 VSS.n48 5.66443
R381 VSS.n47 VSS.n46 0.014444
R382 VSS.n6 VSS.n4 0.362508
R383 VSS.n340 VSS.n9 8.22525
R384 VSS.n308 VSS.n307 8.22525
R385 VSS.n307 VSS.n282 8.22525
R386 VSS.n10 VSS.n340 8.22525
R387 VSS.n316 VSS.n129 7.6711
R388 VSS.n2 VSS.t36 6.87897
R389 VSS.n2 VSS.t32 6.87896
R390 VSS.t2 VSS.n58 15.1863
R391 VSS.n81 VSS.n132 7.20236
R392 VSS.n82 VSS.n207 7.20236
R393 VSS.n83 VSS.n263 7.20236
R394 VSS.n84 VSS.n262 7.20236
R395 VSS.n85 VSS.n169 7.20236
R396 VSS.n86 VSS.n261 7.20236
R397 VSS.n87 VSS.n210 7.20236
R398 VSS.n88 VSS.n259 7.20236
R399 VSS.n89 VSS.n167 7.20236
R400 VSS.n90 VSS.n258 7.20236
R401 VSS.n91 VSS.n166 7.20236
R402 VSS.n92 VSS.n257 7.20236
R403 VSS.n93 VSS.n165 7.20236
R404 VSS.n94 VSS.n255 7.20236
R405 VSS.n95 VSS.n164 7.20236
R406 VSS.n96 VSS.n253 7.20236
R407 VSS.n97 VSS.n163 7.20236
R408 VSS.n98 VSS.n140 7.20236
R409 VSS.n100 VSS.n217 7.20236
R410 VSS.n102 VSS.n218 7.20236
R411 VSS.n103 VSS.n248 7.20236
R412 VSS.n104 VSS.n161 7.20236
R413 VSS.n105 VSS.n247 7.20236
R414 VSS.n106 VSS.n160 7.20236
R415 VSS.n107 VSS.n143 7.20236
R416 VSS.n108 VSS.n159 7.20236
R417 VSS.n109 VSS.n245 7.20236
R418 VSS.n110 VSS.n224 7.20236
R419 VSS.n111 VSS.n242 7.20236
R420 VSS.n112 VSS.n157 7.20236
R421 VSS.n113 VSS.n241 7.20236
R422 VSS.n114 VSS.n156 7.20236
R423 VSS.n115 VSS.n240 7.20236
R424 VSS.n117 VSS.n227 7.20236
R425 VSS.n119 VSS.n228 7.20236
R426 VSS.n120 VSS.n238 7.20236
R427 VSS.n121 VSS.n229 7.20236
R428 VSS.n122 VSS.n237 7.20236
R429 VSS.n123 VSS.n230 7.20236
R430 VSS.n124 VSS.n236 7.20236
R431 VSS.n125 VSS.n231 7.20236
R432 VSS.n126 VSS.n232 7.20236
R433 VSS.n127 VSS.t40 7.20236
R434 VSS.n128 VSS.n234 7.20236
R435 VSS.n128 VSS.n151 7.20236
R436 VSS.n127 VSS.n233 7.20236
R437 VSS.n126 VSS.n235 7.20236
R438 VSS.n125 VSS.n152 7.20236
R439 VSS.n124 VSS.n150 7.20236
R440 VSS.n123 VSS.n153 7.20236
R441 VSS.n122 VSS.n149 7.20236
R442 VSS.n121 VSS.n154 7.20236
R443 VSS.n120 VSS.n148 7.20236
R444 VSS.n119 VSS.n155 7.20236
R445 VSS.n117 VSS.n239 7.20236
R446 VSS.n115 VSS.n147 7.20236
R447 VSS.n114 VSS.n226 7.20236
R448 VSS.n113 VSS.n146 7.20236
R449 VSS.n112 VSS.n225 7.20236
R450 VSS.n111 VSS.n145 7.20236
R451 VSS.n110 VSS.n158 7.20236
R452 VSS.n109 VSS.n144 7.20236
R453 VSS.n108 VSS.n223 7.20236
R454 VSS.n107 VSS.n246 7.20236
R455 VSS.n106 VSS.n221 7.20236
R456 VSS.n105 VSS.n142 7.20236
R457 VSS.n104 VSS.n220 7.20236
R458 VSS.n103 VSS.n141 7.20236
R459 VSS.n102 VSS.n162 7.20236
R460 VSS.n100 VSS.n249 7.20236
R461 VSS.n98 VSS.n251 7.20236
R462 VSS.n97 VSS.n216 7.20236
R463 VSS.n96 VSS.n139 7.20236
R464 VSS.n95 VSS.n215 7.20236
R465 VSS.n94 VSS.n138 7.20236
R466 VSS.n93 VSS.n214 7.20236
R467 VSS.n92 VSS.n137 7.20236
R468 VSS.n91 VSS.n213 7.20236
R469 VSS.n90 VSS.n136 7.20236
R470 VSS.n89 VSS.n211 7.20236
R471 VSS.n88 VSS.n135 7.20236
R472 VSS.n87 VSS.n168 7.20236
R473 VSS.n86 VSS.n134 7.20236
R474 VSS.n85 VSS.n209 7.20236
R475 VSS.n84 VSS.n133 7.20236
R476 VSS.n83 VSS.n208 7.20236
R477 VSS.n82 VSS.n180 7.20236
R478 VSS.n81 VSS.n265 7.20236
R479 VSS.n18 VSS.n315 4.56972
R480 VSS.n318 VSS.n19 1.70082
R481 VSS.n152 VSS.t56 5.54579
R482 VSS.t84 VSS.n133 5.54579
R483 VSS.n315 VSS.n28 2.42922
R484 VSS.n310 VSS.n309 4.11287
R485 VSS.n310 VSS.n170 4.11287
R486 VSS.t0 VSS.n70 11.3992
R487 VSS.n178 VSS.t53 3.0005
R488 VSS.n336 VSS.t50 3.0005
R489 VSS.n296 VSS.t35 3.0005
R490 VSS.t31 VSS.n297 3.0005
R491 VSS.t44 VSS.t45 0.0328544
R492 VSS.n68 VSS.n57 0.0111485
R493 VSS.t23 VSS.n59 53.1373
R494 VSS.n78 VSS.n57 0.0111485
R495 VSS.t54 VSS.n63 13.7601
R496 VSS.n65 VSS.n57 0.0109013
R497 VSS.n71 VSS.n57 0.0108886
R498 VSS.n64 VSS.n57 0.00931161
R499 VSS.n62 VSS.n57 0.0108886
R500 VSS.n74 VSS.n57 0.0108886
R501 VSS.n58 VSS.n57 0.0109013
R502 VSS.t51 VSS.n70 13.7582
R503 VSS.n72 VSS.n57 0.00109675
R504 VSS.n282 VSS.n281 2.71193
R505 VSS.n8 VSS 2.6297
R506 VSS.n337 VSS.t3 2.4821
R507 VSS.n338 VSS.t6 2.4821
R508 VSS.n339 VSS.t9 2.4821
R509 VSS.n174 VSS.t12 2.4821
R510 VSS.t18 VSS.n173 2.4821
R511 VSS.n175 VSS.t21 2.4821
R512 VSS.n176 VSS.t24 2.4821
R513 VSS.n177 VSS.t27 2.4821
R514 VSS.t131 VSS.n289 2.4821
R515 VSS.n290 VSS.t128 2.4821
R516 VSS.t125 VSS.n291 2.4821
R517 VSS.t122 VSS.n283 2.4821
R518 VSS.t116 VSS.n284 2.4821
R519 VSS.n286 VSS.t113 2.4821
R520 VSS.n287 VSS.t110 2.4821
R521 VSS.n288 VSS.t107 2.4821
R522 VSS.n5 VSS.t41 0.0299603
R523 VSS.n314 VSS.n5 0.358263
R524 VSS.n314 VSS.t61 2.4821
R525 VSS.n313 VSS.t90 2.4821
R526 VSS.n313 VSS.t64 2.4821
R527 VSS.n312 VSS.t92 2.4821
R528 VSS.n312 VSS.t67 2.4821
R529 VSS.n280 VSS.t96 2.4821
R530 VSS.n280 VSS.t73 2.4821
R531 VSS.n279 VSS.t98 2.4821
R532 VSS.n279 VSS.t76 2.4821
R533 VSS.n278 VSS.t100 2.4821
R534 VSS.n278 VSS.t79 2.4821
R535 VSS.n277 VSS.t102 2.4821
R536 VSS.n277 VSS.t82 2.4821
R537 VSS.n19 VSS.n264 2.25406
R538 VSS.n28 VSS.n179 2.25406
R539 VSS.n28 VSS.n181 2.25406
R540 VSS.n28 VSS.n182 2.25406
R541 VSS.n28 VSS.n183 2.25406
R542 VSS.n28 VSS.n184 2.25406
R543 VSS.n28 VSS.n185 2.25406
R544 VSS.n28 VSS.n186 2.25406
R545 VSS.n28 VSS.n187 2.25406
R546 VSS.n28 VSS.n188 2.25406
R547 VSS.n28 VSS.n189 2.25406
R548 VSS.n28 VSS.n190 2.25406
R549 VSS.n28 VSS.n191 2.25406
R550 VSS.n28 VSS.n192 2.25406
R551 VSS.n28 VSS.n194 2.25406
R552 VSS.n28 VSS.n195 2.25406
R553 VSS.n28 VSS.n196 2.25406
R554 VSS.n28 VSS.n197 2.25406
R555 VSS.n28 VSS.n198 2.25406
R556 VSS.n28 VSS.n199 2.25406
R557 VSS.n28 VSS.n200 2.25406
R558 VSS.n28 VSS.n201 2.25406
R559 VSS.n28 VSS.n202 2.25406
R560 VSS.n28 VSS.n203 2.25406
R561 VSS.n28 VSS.n204 2.25406
R562 VSS.n28 VSS.n205 2.25406
R563 VSS.n28 VSS.n206 2.25406
R564 VSS.n28 VSS.n317 2.25406
R565 VSS.n322 VSS.n57 2.09947
R566 VSS.n324 VSS.n57 2.09947
R567 VSS.n326 VSS.n57 2.09947
R568 VSS.n171 VSS.n57 2.09947
R569 VSS.n328 VSS.n57 2.09947
R570 VSS.n330 VSS.n57 2.09947
R571 VSS.n332 VSS.n57 2.09947
R572 VSS.n334 VSS.n57 2.09947
R573 VSS.n295 VSS.n2 2.09888
R574 VSS.n304 VSS.n2 2.09887
R575 VSS.n300 VSS.n2 2.09865
R576 VSS.n302 VSS.n2 2.09862
R577 VSS.n2 VSS.n131 2.09857
R578 VSS.n293 VSS.n2 2.09849
R579 VSS.n306 VSS.n2 2.09849
R580 VSS.n28 VSS.n193 1.92189
R581 VSS.n315 VSS.n6 1.7005
R582 VSS.n318 VSS.n129 1.53502
R583 VSS.n336 VSS.n29 1.52811
R584 VSS.n12 VSS.n296 1.52811
R585 VSS.n297 VSS.n15 1.52811
R586 VSS.n25 VSS.n178 1.52811
R587 VSS.n36 VSS.n2 1.31136
R588 VSS.t41 VSS.n4 0.0289531
R589 VSS.n320 VSS.n57 0.96569
R590 VSS.n335 VSS.n17 0.152717
R591 VSS.n298 VSS.n2 0.910334
R592 VSS.n6 VSS.n81 0.650322
R593 VSS.n6 VSS.n82 0.650322
R594 VSS.n6 VSS.n83 0.650322
R595 VSS.n6 VSS.n84 0.650322
R596 VSS.n6 VSS.n85 0.650322
R597 VSS.n6 VSS.n86 0.650322
R598 VSS.n6 VSS.n87 0.650322
R599 VSS.n6 VSS.n88 0.650322
R600 VSS.n6 VSS.n89 0.650322
R601 VSS.n6 VSS.n90 0.650322
R602 VSS.n6 VSS.n91 0.650322
R603 VSS.n6 VSS.n92 0.650322
R604 VSS.n6 VSS.n93 0.650322
R605 VSS.n6 VSS.n94 0.650322
R606 VSS.n6 VSS.n95 0.650322
R607 VSS.n6 VSS.n96 0.650322
R608 VSS.n6 VSS.n97 0.650322
R609 VSS.n6 VSS.n98 0.650322
R610 VSS.n6 VSS.n100 0.650322
R611 VSS.n6 VSS.n102 0.650322
R612 VSS.n6 VSS.n103 0.650322
R613 VSS.n6 VSS.n104 0.650322
R614 VSS.n6 VSS.n105 0.650322
R615 VSS.n6 VSS.n106 0.650322
R616 VSS.n6 VSS.n107 0.650322
R617 VSS.n6 VSS.n108 0.650322
R618 VSS.n6 VSS.n109 0.650322
R619 VSS.n6 VSS.n110 0.650322
R620 VSS.n6 VSS.n111 0.650322
R621 VSS.n6 VSS.n112 0.650322
R622 VSS.n6 VSS.n113 0.650322
R623 VSS.n6 VSS.n114 0.650322
R624 VSS.n6 VSS.n115 0.650322
R625 VSS.n6 VSS.n117 0.650322
R626 VSS.n6 VSS.n119 0.650322
R627 VSS.n6 VSS.n120 0.650322
R628 VSS.n6 VSS.n121 0.650322
R629 VSS.n6 VSS.n122 0.650322
R630 VSS.n6 VSS.n123 0.650322
R631 VSS.n6 VSS.n124 0.650322
R632 VSS.n6 VSS.n125 0.650322
R633 VSS.n6 VSS.n126 0.650322
R634 VSS.n6 VSS.n127 0.650322
R635 VSS.n6 VSS.n128 0.650322
R636 VSS.n308 VSS.n281 0.632727
R637 VSS.n309 VSS.n9 0.2444
R638 VSS.n309 VSS.n308 0.2444
R639 VSS.n10 VSS.n170 0.2444
R640 VSS.n282 VSS.n170 0.2444
R641 VSS.n337 VSS.n336 0.209825
R642 VSS.n296 VSS.n289 0.209825
R643 VSS.n297 VSS.n288 0.209825
R644 VSS.n178 VSS.n177 0.209825
R645 VSS.n335 VSS.t3 0.201663
R646 VSS.n333 VSS.t6 0.201663
R647 VSS.n331 VSS.t9 0.201663
R648 VSS.n329 VSS.t12 0.201663
R649 VSS.n327 VSS.t18 0.201663
R650 VSS.n325 VSS.t21 0.201663
R651 VSS.n323 VSS.t24 0.201663
R652 VSS.n321 VSS.t27 0.201663
R653 VSS.n1 VSS.t131 0.207985
R654 VSS.n0 VSS.t128 0.201663
R655 VSS.n294 VSS.t125 0.201663
R656 VSS.n292 VSS.t122 0.201663
R657 VSS.n305 VSS.t116 0.201663
R658 VSS.n303 VSS.t113 0.201663
R659 VSS.n301 VSS.t110 0.201663
R660 VSS.n299 VSS.t107 0.201663
R661 VSS.t41 VSS.t86 0.159356
R662 VSS.t58 VSS.t41 0.1519
R663 VSS.n5 VSS.t88 0.16029
R664 VSS.t61 VSS.t41 0.201663
R665 VSS.n22 VSS.t90 0.201663
R666 VSS.t64 VSS.n22 0.201663
R667 VSS.n50 VSS.t92 0.201663
R668 VSS.t67 VSS.n50 0.201663
R669 VSS.n42 VSS.t96 0.201663
R670 VSS.t73 VSS.n42 0.201663
R671 VSS.n40 VSS.t98 0.201663
R672 VSS.t76 VSS.n40 0.201663
R673 VSS.n44 VSS.t100 0.201663
R674 VSS.t79 VSS.n44 0.201663
R675 VSS.n39 VSS.t102 0.201663
R676 VSS.t82 VSS.n39 0.201663
R677 VSS.t70 VSS.t94 0.185696
R678 VSS.n338 VSS.n337 0.16242
R679 VSS.n339 VSS.n338 0.16242
R680 VSS.n174 VSS.n339 0.16242
R681 VSS.n172 VSS.n174 0.16242
R682 VSS.n172 VSS.n173 0.16242
R683 VSS.n175 VSS.n173 0.16242
R684 VSS.n176 VSS.n175 0.16242
R685 VSS.n177 VSS.n176 0.16242
R686 VSS.n288 VSS.n287 0.16242
R687 VSS.n287 VSS.n286 0.16242
R688 VSS.n286 VSS.n284 0.16242
R689 VSS.n285 VSS.n284 0.16242
R690 VSS.n285 VSS.n283 0.16242
R691 VSS.n291 VSS.n283 0.16242
R692 VSS.n291 VSS.n290 0.16242
R693 VSS.n290 VSS.n289 0.16242
R694 VSS.n2 VSS.n1 0.1329
R695 VSS.n299 VSS.n298 0.145358
R696 VSS.n321 VSS.n320 0.143085
R697 VSS.n335 VSS.n334 0.0952183
R698 VSS.n300 VSS.n299 0.0940763
R699 VSS.n333 VSS.n332 0.0927738
R700 VSS.n322 VSS.n321 0.0925656
R701 VSS.n302 VSS.n301 0.0915644
R702 VSS.n0 VSS.n295 0.0908079
R703 VSS.n331 VSS.n330 0.0903294
R704 VSS.t15 VSS.n171 0.0903294
R705 VSS.n324 VSS.n323 0.0901212
R706 VSS.n304 VSS.n303 0.0895627
R707 VSS.t119 VSS.n306 0.0891801
R708 VSS.t119 VSS.n131 0.0890584
R709 VSS.n294 VSS.n293 0.0887988
R710 VSS.n329 VSS.n328 0.0878849
R711 VSS.n327 VSS.n326 0.0878849
R712 VSS.n328 VSS.t15 0.0876767
R713 VSS.n326 VSS.n325 0.0876767
R714 VSS.n293 VSS.n292 0.0867368
R715 VSS.n292 VSS.n131 0.0864834
R716 VSS.n306 VSS.n305 0.0863554
R717 VSS.n305 VSS.n304 0.0859778
R718 VSS.n325 VSS.n324 0.0854405
R719 VSS.n330 VSS.n329 0.0852323
R720 VSS.n171 VSS.n327 0.0852323
R721 VSS.n320 VSS.t53 0.0849321
R722 VSS.t50 VSS.n17 0.0764401
R723 VSS.n295 VSS.n294 0.084742
R724 VSS.n303 VSS.n302 0.0839729
R725 VSS.n298 VSS.t31 0.0834709
R726 VSS.n323 VSS.n322 0.082996
R727 VSS.n332 VSS.n331 0.0827878
R728 VSS.n1 VSS.n0 0.166056
R729 VSS.n301 VSS.n300 0.0814717
R730 VSS.n314 VSS.n313 0.08146
R731 VSS.n313 VSS.n312 0.08146
R732 VSS.n312 VSS.n311 0.08146
R733 VSS.n311 VSS.n280 0.08146
R734 VSS.n280 VSS.n279 0.08146
R735 VSS.n279 VSS.n278 0.08146
R736 VSS.n278 VSS.n277 0.08146
R737 VSS.n334 VSS.n333 0.0803434
R738 VSS.n6 VSS.n129 0.14216
R739 VSS.n8 VSS 0.0445
R740 VSS.n281 VSS 0.0445
R741 VSS.n285 VSS.t119 0.0394179
R742 VSS.t15 VSS.n172 0.0394179
R743 VSS.n340 VSS.n172 0.0389615
R744 VSS.n307 VSS.n285 0.0389615
R745 VSS.n277 VSS.t45 0.631464
R746 VSS.t94 VSS.n23 0.00980515
R747 VSS.n34 VSS.n26 1.2923
R748 VSS.n9 VSS.n8 0.632727
R749 VSS VSS.n10 0.0827273
R750 VSS.t50 VSS.n31 0.03986
R751 VSS.n222 VSS.n24 0.036902
R752 VSS.n45 VSS.n40 0.0218227
R753 VSS.n254 VSS.n45 0.0193957
R754 VSS.n311 VSS.n310 0.0197308
R755 VSS.n311 VSS.t94 0.019449
R756 VSS.n55 VSS.n44 0.0189924
R757 VSS.n51 VSS.n244 0.0174081
R758 VSS.t35 VSS.n35 0.0133922
R759 VSS.t31 VSS.n37 0.0133922
R760 VSS.n7 VSS.t45 0.00723727
R761 VSS.n266 VSS.n39 0.0118857
R762 VSS.n267 VSS.n56 0.0161786
R763 VSS.n268 VSS.n43 0.0118857
R764 VSS.n44 VSS.n43 0.0118857
R765 VSS.n269 VSS.n256 0.0118857
R766 VSS.n270 VSS.n252 0.0118857
R767 VSS.n271 VSS.n42 0.0118857
R768 VSS.n272 VSS.n219 0.0118857
R769 VSS.n273 VSS.n219 0.0118857
R770 VSS.n50 VSS.n49 0.00858771
R771 VSS.n275 VSS.n244 0.0118857
R772 VSS.n276 VSS.n243 0.0118857
R773 VSS.n4 VSS.n3 0.297705
R774 VSS.n32 VSS.n22 0.0252833
R775 VSS.n37 VSS.n16 0.0123024
R776 VSS.n35 VSS.n11 0.0123024
R777 VSS.n20 VSS.n19 0.0117031
R778 VSS.n22 VSS.n21 0.0161786
R779 VSS.n276 VSS.n21 0.0118857
R780 VSS.n275 VSS.n243 0.0118857
R781 VSS.n274 VSS.n222 0.0118857
R782 VSS.n39 VSS.n38 0.0179185
R783 VSS.n42 VSS.n41 0.0174081
R784 VSS.n272 VSS.n52 0.0161786
R785 VSS.n15 VSS.n14 0.00877297
R786 VSS.n271 VSS.n250 0.0118857
R787 VSS.n270 VSS.n250 0.0118857
R788 VSS.n269 VSS.n254 0.0118857
R789 VSS.n268 VSS.n212 0.0118857
R790 VSS.n267 VSS.n212 0.0118857
R791 VSS.n266 VSS.n260 0.0118857
R792 VSS.n7 VSS.n260 0.100428
R793 VSS.n2 VSS.t117 19.8823
R794 VSS.t35 VSS.n2 1.05776
C0 vout3 VDD 15.3834f
C1 VDD vin1 29.2329f
C2 vin1 vout1 18.2968f
C3 vin2 vin1 0.05053f
C4 vout4 vin4 18.2968f
C5 vout4 VDD 15.3949f
C6 vin4 vin3 0.05053f
C7 VDD vout2 15.3834f
C8 vin4 VDD 29.2329f
C9 VDD vin3 29.202f
C10 vin2 vout2 18.2968f
C11 VDD vout1 15.3949f
C12 vin3 vin2 0.05785f
C13 VDD vin2 29.202f
C14 vout3 vin3 18.2968f
C15 vout1 VSS 13.57609f
C16 vout2 VSS 13.55759f
C17 vout3 VSS 13.55759f
C18 vout4 VSS 13.57609f
C19 VSS.t102 VSS 8.00945f
C20 VSS.t24 VSS 8.0271f
C21 VSS.t73 VSS 8.00945f
.ends

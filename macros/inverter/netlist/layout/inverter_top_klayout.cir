* Extracted by KLayout with SG13G2 LVS runset on : 18/05/2026 21:42

.SUBCKT inverter_top vin1 vin2 vin3 vin4 vout1 vout2 vout3 vout4 VSS VDD
X$1 \$19 VSS VDD vout1 vin1 \$10 inverter
X$2 \$19 VSS VDD vout2 vin2 \$10 inverter
X$3 \$19 VSS VDD vout3 vin3 \$9 inverter
X$4 \$19 VSS VDD vout4 vin4 \$9 inverter
.ENDS inverter_top

.SUBCKT inverter \$1 VSS VDD vout vin \$I103
M$1 VSS VSS VSS \$1 sg13_lv_nmos L=1u W=2u AS=0.53p AD=0.53p PS=4.06u PD=4.06u
+ rfmode=0
M$2 VSS vin vout \$1 sg13_lv_nmos L=1u W=20u AS=3.8p AD=3.8p PS=27.6u PD=27.6u
+ rfmode=0
R$23 VSS \$1 ptap1 A=21.276p P=141.84u
M$24 VDD VDD VDD \$I103 sg13_lv_pmos L=1u W=12u AS=3.18p AD=3.18p PS=19.06u
+ PD=19.06u rfmode=0
M$25 VDD vin vout \$I103 sg13_lv_pmos L=1u W=120u AS=22.8p AD=22.8p PS=127.6u
+ PD=127.6u rfmode=0
R$46 VDD \$I103 ntap1 A=24.06p P=160.4u
.ENDS inverter

* Extracted by KLayout with SG13G2 LVS runset on : 05/05/2026 22:25

.SUBCKT inverter VSS VDD vout vin
M$1 VSS VSS VSS \$1 sg13_lv_nmos L=1u W=2u AS=0.53p AD=0.53p PS=4.06u PD=4.06u
+ rfmode=0
M$2 VSS vin vout \$1 sg13_lv_nmos L=1u W=20u AS=3.8p AD=3.8p PS=27.6u PD=27.6u
+ rfmode=0
R$23 VSS \$1 ptap1 A=21.276p P=141.84u
M$24 VDD VDD VDD \$I103 sg13_lv_pmos L=1u W=12u AS=3.18p AD=3.18p PS=19.06u
+ PD=19.06u rfmode=0
M$25 VDD vin vout \$I103 sg13_lv_pmos L=1u W=120u AS=22.8p AD=22.8p PS=127.6u
+ PD=127.6u rfmode=0
R$46 VDD \$I103 ntap1 A=24.06p P=160.4u
.ENDS inverter

** sch_path: /foss/designs/ihp-sg13g2-ams-chip-template/macros/inverter/schematic/xschem/inverter_top.sch
.subckt inverter_top VDD vin4 vout4 VSS vin3 vout3 vin2 vout2 vout1 vin1
*.PININFO vin4:I VDD:B VSS:B vout4:B vin3:I vin2:I vin1:I vout3:B vout2:B vout1:B
x1 VDD VSS vin1 vout1 inverter
x2 VDD VSS vin2 vout2 inverter
x3 VDD VSS vin3 vout3 inverter
x4 VDD VSS vin4 vout4 inverter
.ends

* expanding   symbol:  inverter.sym # of pins=6
** sym_path: /foss/designs/ihp-sg13g2-ams-chip-template/macros/inverter/schematic/xschem/inverter.sym
** sch_path: /foss/designs/ihp-sg13g2-ams-chip-template/macros/inverter/schematic/xschem/inverter.sch
.subckt inverter VDD VSS vin vout
*.PININFO vin:I VDD:B VSS:B vout:B VDD:B VSS:B
XMdummy1 VSS VSS VSS VSS sg13_lv_nmos w=2.0u l=1.0u ng=2
XMdummy2 VDD VDD VDD VDD sg13_lv_pmos w=12.0u l=1.0u ng=2
XM1 vout vin VSS VSS sg13_lv_nmos w=20.0u l=1.0u ng=20
XM2 vout vin VDD VDD sg13_lv_pmos w=120.0u l=1.0u ng=20
.ends

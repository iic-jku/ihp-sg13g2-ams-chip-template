** sch_path: /foss/designs/ihp-sg13g2-ams-chip-template/macros/inverter/schematic/xschem/inverter_top.sch
.subckt inverter_top VDD vin4 vout4 VSS vin3 vout3 vin2 vout2 vout1 vin1
*.PININFO vin4:I VDD:B VSS:B vout4:B vin3:I vin2:I vin1:I vout3:B vout2:B vout1:B
x1 VDD vin1 vout1 VSS inverter
x2 VDD vin2 vout2 VSS inverter
x3 VDD vin3 vout3 VSS inverter
x4 VDD vin4 vout4 VSS inverter
.ends

* expanding   symbol:  inverter.sym # of pins=4
** sym_path: /foss/designs/ihp-sg13g2-ams-chip-template/macros/inverter/schematic/xschem/inverter.sym
** sch_path: /foss/designs/ihp-sg13g2-ams-chip-template/macros/inverter/schematic/xschem/inverter.sch
.subckt inverter VDD vin vout VSS
*.PININFO vin:I VDD:B VSS:B vout:B
MMdummy1 VSS VSS VSS VSS sg13_lv_nmos w=2.0u l=1.0u ng=2
MMdummy2 VDD VDD VDD VDD sg13_lv_pmos w=12.0u l=1.0u ng=2
MM1 vout vin VSS VSS sg13_lv_nmos w=20.0u l=1.0u ng=20
MM2 vout vin VDD VDD sg13_lv_pmos w=120.0u l=1.0u ng=20
.ends

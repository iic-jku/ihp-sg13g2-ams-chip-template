** sch_path: /foss/designs/ihp-sg13g2-ams-chip-template/macros/vco/schematic/xschem/vco_top.sch
.subckt vco_top di_en VDD VSS vtune rf_out_p rf_out_n
*.PININFO VDD:B VSS:B di_en:I vtune:I rf_out_p:B rf_out_n:B
xbias di_en VDD VSS vbg_buf vbn_buf en_b vco_bias
xcore vdd_core VSS vtune rf_p rf_n vco_core
xbuf vbn_buf vbg_buf VDD VSS rf_p rf_n rf_out_p rf_out_n vco_buf
xfeed en_b VDD VSS vdd_core vco_feed
.ends

* expanding   symbol:  vco_bias.sym # of pins=6
** sym_path: /foss/designs/ihp-sg13g2-ams-chip-template/macros/vco/schematic/xschem/vco_bias.sym
** sch_path: /foss/designs/ihp-sg13g2-ams-chip-template/macros/vco/schematic/xschem/vco_bias.sch
.subckt vco_bias di_en VDD VSS vbg_buf vbn_buf en_b
*.PININFO VDD:B VSS:B di_en:I en_b:O vbn_buf:B vbg_buf:B
MMPi1 en_b di_en VDD VDD sg13_lv_pmos w=1u l=0.13u ng=1
MMNi1 en_b di_en VSS VSS sg13_lv_nmos w=0.5u l=0.13u ng=1
MMPi2 en en_b VDD VDD sg13_lv_pmos w=1u l=0.13u ng=1
MMNi2 en en_b VSS VSS sg13_lv_nmos w=0.5u l=0.13u ng=1
MMN0 ibias_100u ibias_100u VSS VSS sg13_lv_nmos w=2.5u l=0.5u ng=1
MMNd0 ibias_100u en_b VSS VSS sg13_lv_nmos w=1u l=0.13u ng=1
RRn ibias_100u vbn_buf 94.929k $SUB=VSS $[rhigh] w=0.5e-6 l=32e-6 b=0
MMNd1 vbn_buf en_b VSS VSS sg13_lv_nmos w=1u l=0.13u ng=1
MMN1 vbp_ref ibias_100u VSS VSS sg13_lv_nmos w=2.5u l=0.5u ng=1
MMP1 vbp_ref vbp_ref VDD VDD sg13_lv_pmos w=5u l=0.5u ng=1
MMPd vbp_ref en VDD VDD sg13_lv_pmos w=1u l=0.13u ng=1
MMP2 vbg_int vbp_ref VDD VDD sg13_lv_pmos w=5u l=0.5u ng=1
RRg vbg_int nbg 4.5076k $SUB=VSS $[rppd] w=0.5e-6 l=8.5e-6 b=0
MMN3 nbg nbg VSS VSS sg13_lv_nmos w=2.5u l=0.5u ng=1
MMCn1 VSS vbn_buf VSS VSS sg13_lv_nmos w=40u l=10u ng=5
MMCn2 VSS vbn_buf VSS VSS sg13_lv_nmos w=40u l=10u ng=5
RRf vbg_int vbg_buf 94.929k $SUB=VSS $[rhigh] w=0.5e-6 l=32e-6 b=0
MMCg1 VSS vbg_buf VSS VSS sg13_lv_nmos w=40u l=10u ng=5
MMCg2 VSS vbg_buf VSS VSS sg13_lv_nmos w=40u l=10u ng=5
MMDn1 VSS VSS VSS VSS sg13_lv_nmos w=2.5u l=0.5u ng=1
MMDn2 VSS VSS VSS VSS sg13_lv_nmos w=2.5u l=0.5u ng=1
MMDp1 VDD VDD VDD VDD sg13_lv_pmos w=5u l=0.5u ng=1
MMDp2 VDD VDD VDD VDD sg13_lv_pmos w=5u l=0.5u ng=1
MMPb nrb en_b VDD VDD sg13_lv_pmos w=2u l=0.13u ng=1
MMDp4 VDD VDD VDD VDD sg13_lv_pmos w=1u l=0.13u ng=1
RRb nrb ibias_100u 6.8712k $SUB=VSS $[rppd] w=0.5e-6 l=13.1e-6 b=0
CCg1 vbg_buf VSS cap_cmim w=17.5e-6 l=19.1e-6
CCg2 vbg_buf VSS cap_cmim w=13.6e-6 l=7.28e-6
.ends

* expanding   symbol:  vco_core.sym # of pins=5
** sym_path: /foss/designs/ihp-sg13g2-ams-chip-template/macros/vco/schematic/xschem/vco_core.sym
** sch_path: /foss/designs/ihp-sg13g2-ams-chip-template/macros/vco/schematic/xschem/vco_core.sch
.subckt vco_core vdd_core VSS vtune rf_p rf_n
*.PININFO vdd_core:B VSS:B vtune:I rf_p:B rf_n:B
xind rf_p rf_n vdd_core VSS vco_ind
CCct1 vdd_core VSS cap_cmim w=56e-6 l=39e-6
xvar rf_p rf_n vtune VSS vco_var
MM1 rf_p rf_n VSS VSS sg13_lv_nmos w=20u l=0.13u ng=10
MM2 rf_n rf_p VSS VSS sg13_lv_nmos w=20u l=0.13u ng=10
CCct2 vdd_core VSS cap_cmim w=42e-6 l=25.5e-6
.ends

* expanding   symbol:  vco_buf.sym # of pins=8
** sym_path: /foss/designs/ihp-sg13g2-ams-chip-template/macros/vco/schematic/xschem/vco_buf.sym
** sch_path: /foss/designs/ihp-sg13g2-ams-chip-template/macros/vco/schematic/xschem/vco_buf.sch
.subckt vco_buf vbn_buf vbg_buf VDD VSS rf_p rf_n rf_out_p rf_out_n
*.PININFO VDD:B VSS:B rf_out_n:B rf_out_p:B vbn_buf:I rf_p:B rf_n:B vbg_buf:I
MMB1 rf_out_n gp tail VSS sg13_lv_nmos w=24u l=0.13u ng=12
MMB2 rf_out_p gn tail VSS sg13_lv_nmos w=24u l=0.13u ng=12
RRL1 VDD rf_out_n 49.874 $SUB=VSS $[rppd] w=10e-6 l=1.65e-6 b=0
RRL2 VDD rf_out_p 49.874 $SUB=VSS $[rppd] w=10e-6 l=1.65e-6 b=0
MMBt tail vbn_buf VSS VSS sg13_lv_nmos w=150u l=0.5u ng=30
CCc1 gp rf_p cap_cmim w=10e-6 l=10e-6
CCc2 gn rf_n cap_cmim w=10e-6 l=10e-6
RRb1 vbg_buf gp 23.972k $SUB=VSS $[rhigh] w=0.5e-6 l=8e-6 b=0
RRb2 vbg_buf gn 23.972k $SUB=VSS $[rhigh] w=0.5e-6 l=8e-6 b=0
.ends

* expanding   symbol:  vco_feed.sym # of pins=4
** sym_path: /foss/designs/ihp-sg13g2-ams-chip-template/macros/vco/schematic/xschem/vco_feed.sym
** sch_path: /foss/designs/ihp-sg13g2-ams-chip-template/macros/vco/schematic/xschem/vco_feed.sch
.subckt vco_feed en_b VDD VSS vdd_core
*.PININFO VDD:B VSS:B en_b:I vdd_core:B
MMPs n1 en_b VDD VDD sg13_lv_pmos w=96u l=0.13u ng=32
RRct n1 vdd_core 136.25 $SUB=VSS $[rppd] w=17.3e-6 l=8.8e-6 b=0
.ends

* expanding   symbol:  vco_ind.sym # of pins=4
** sym_path: /foss/designs/ihp-sg13g2-ams-chip-template/macros/vco/schematic/xschem/vco_ind.sym
** sch_path: /foss/designs/ihp-sg13g2-ams-chip-template/macros/vco/schematic/xschem/vco_ind.sch
.subckt vco_ind la lb lc VSS
*.PININFO la:B lc:B lb:B VSS:B
LL1 la lc lb VSS inductor3 w=4e-6 s=4e-6 d=52e-6 nr_r=2
.ends

* expanding   symbol:  vco_var.sym # of pins=4
** sym_path: /foss/designs/ihp-sg13g2-ams-chip-template/macros/vco/schematic/xschem/vco_var.sym
** sch_path: /foss/designs/ihp-sg13g2-ams-chip-template/macros/vco/schematic/xschem/vco_var.sch
.subckt vco_var rf_p rf_n vtune VSS
*.PININFO vtune:I rf_p:B rf_n:B VSS:B
CCvar1 rf_p vtune rf_n VSS sg13_hv_svaricap w=3.74u l=0.3u Nx=7
CCvar2 rf_p vtune rf_n VSS sg13_hv_svaricap w=3.74u l=0.3u Nx=7
CCvar3 rf_p vtune rf_n VSS sg13_hv_svaricap w=3.74u l=0.3u Nx=7
.ends

** sch_path: /foss/designs/ihp-sg13g2-ams-chip-template/macros/vco/schematic/xschem/vco_top.sch
.subckt vco_top ibias_100u di_en VDD VSS vtune rf_out_p rf_out_n
*.PININFO VDD:B VSS:B ibias_100u:I di_en:I vtune:I rf_out_p:B rf_out_n:B
xbias ibias_100u di_en VDD VSS vbg_buf vbn_buf vbp_core vco_bias
xcore vbp_core VDD VSS vtune rf_p rf_n vco_core
xbuf vbn_buf vbg_buf VDD VSS rf_p rf_n rf_out_p rf_out_n vco_buf
.ends

* expanding   symbol:  vco_bias.sym # of pins=7
** sym_path: /foss/designs/ihp-sg13g2-ams-chip-template/macros/vco/schematic/xschem/vco_bias.sym
** sch_path: /foss/designs/ihp-sg13g2-ams-chip-template/macros/vco/schematic/xschem/vco_bias.sch
.subckt vco_bias ibias_100u di_en VDD VSS vbg_buf vbn_buf vbp_core
*.PININFO VDD:B VSS:B di_en:I ibias_100u:I vbn_buf:B vbp_core:B vbg_buf:B
MMPi1 en_b di_en VDD VDD sg13_lv_pmos w=1u l=0.13u ng=1
MMNi1 en_b di_en VSS VSS sg13_lv_nmos w=0.5u l=0.13u ng=1
MMPi2 en en_b VDD VDD sg13_lv_pmos w=1u l=0.13u ng=1
MMNi2 en en_b VSS VSS sg13_lv_nmos w=0.5u l=0.13u ng=1
MMN0 ibias_100u ibias_100u VSS VSS sg13_lv_nmos w=2.5u l=0.5u ng=1
MMNd0 ibias_100u en_b VSS VSS sg13_lv_nmos w=1u l=0.13u ng=1
RRn ibias_100u vbn_buf 47.624k $SUB=VSS $[rhigh] w=0.5e-6 l=16e-6 b=0
CCn vbn_buf VSS cap_cmim w=30e-6 l=30e-6
MMNd1 vbn_buf en_b VSS VSS sg13_lv_nmos w=1u l=0.13u ng=1
MMN1 vbp_ref ibias_100u VSS VSS sg13_lv_nmos w=2.5u l=0.5u ng=1
MMP1 vbp_ref vbp_ref VDD VDD sg13_lv_pmos w=5u l=0.5u ng=1
RRp vbp_ref vbp_core 47.624k $SUB=VSS $[rhigh] w=0.5e-6 l=16e-6 b=0
CCp VDD vbp_core cap_cmim w=30e-6 l=30e-6
MMPd vbp_core en VDD VDD sg13_lv_pmos w=1u l=0.13u ng=1
MMP2 vbg_buf vbp_core VDD VDD sg13_lv_pmos w=5u l=0.5u ng=1
RRg vbg_buf nbg 4.5076k $SUB=VSS $[rppd] w=0.5e-6 l=8.5e-6 b=0
MMN3 nbg nbg VSS VSS sg13_lv_nmos w=2.5u l=0.5u ng=1
CCg vbg_buf VSS cap_cmim w=20e-6 l=20e-6
.ends

* expanding   symbol:  vco_core.sym # of pins=6
** sym_path: /foss/designs/ihp-sg13g2-ams-chip-template/macros/vco/schematic/xschem/vco_core.sym
** sch_path: /foss/designs/ihp-sg13g2-ams-chip-template/macros/vco/schematic/xschem/vco_core.sch
.subckt vco_core vbp_core VDD VSS vtune rf_p rf_n
*.PININFO VDD:B VSS:B vbp_core:I vtune:I rf_p:B rf_n:B
MMtop vct vbp_core VDD VDD sg13_lv_pmos w=150u l=0.5u ng=30
xind rf_p rf_n vct VSS vco_ind
CCct vct VSS cap_cmim w=25e-6 l=25e-6
xvar rf_p rf_n vtune VSS vco_var
MM1 rf_p rf_n VSS VSS sg13_lv_nmos w=20u l=0.13u ng=10
MM2 rf_n rf_p VSS VSS sg13_lv_nmos w=20u l=0.13u ng=10
.ends

* expanding   symbol:  vco_buf.sym # of pins=8
** sym_path: /foss/designs/ihp-sg13g2-ams-chip-template/macros/vco/schematic/xschem/vco_buf.sym
** sch_path: /foss/designs/ihp-sg13g2-ams-chip-template/macros/vco/schematic/xschem/vco_buf.sch
.subckt vco_buf vbn_buf vbg_buf VDD VSS rf_p rf_n rf_out_p rf_out_n
*.PININFO VDD:B VSS:B rf_out_n:B rf_out_p:B vbn_buf:I rf_p:B rf_n:B vbg_buf:I
MMB1 rf_out_n gp tail VSS sg13_lv_nmos w=24u l=0.13u ng=12
MMB2 rf_out_p gn tail VSS sg13_lv_nmos w=24u l=0.13u ng=12
RRL1 VDD rf_out_n 49.874 $SUB=VSS $[rppd] w=10e-6 l=1.65e-6 b=0
RRL2 VDD rf_out_p 49.874 $SUB=VSS $[rppd] w=10e-6 l=1.65e-6 b=0
MMBt tail vbn_buf VSS VSS sg13_lv_nmos w=2.5u l=0.5u ng=1 m=60
CCc1 gp rf_p cap_cmim w=10e-6 l=10e-6
CCc2 gn rf_n cap_cmim w=10e-6 l=10e-6
RRb1 vbg_buf gp 23.972k $SUB=VSS $[rhigh] w=0.5e-6 l=8e-6 b=0
RRb2 vbg_buf gn 23.972k $SUB=VSS $[rhigh] w=0.5e-6 l=8e-6 b=0
.ends

* expanding   symbol:  vco_ind.sym # of pins=4
** sym_path: /foss/designs/ihp-sg13g2-ams-chip-template/macros/vco/schematic/xschem/vco_ind.sym
** sch_path: /foss/designs/ihp-sg13g2-ams-chip-template/macros/vco/schematic/xschem/vco_ind.sch
.subckt vco_ind la lb lc VSS
*.PININFO la:B lc:B lb:B VSS:B
LL1 la lc lb VSS inductor3 w=4e-6 s=4e-6 d=82e-6 nr_r=2
.ends

* expanding   symbol:  vco_var.sym # of pins=4
** sym_path: /foss/designs/ihp-sg13g2-ams-chip-template/macros/vco/schematic/xschem/vco_var.sym
** sch_path: /foss/designs/ihp-sg13g2-ams-chip-template/macros/vco/schematic/xschem/vco_var.sch
.subckt vco_var rf_p rf_n vtune VSS
*.PININFO vtune:I rf_p:B rf_n:B VSS:B
CCvar1 rf_p vtune rf_n VSS sg13_hv_svaricap w=3.74u l=0.3u Nx=8
CCvar2 rf_p vtune rf_n VSS sg13_hv_svaricap w=3.74u l=0.3u Nx=8
CCvar3 rf_p vtune rf_n VSS sg13_hv_svaricap w=3.74u l=0.3u Nx=8
.ends

** sch_path: /foss/designs/ihp-sg13g2-ams-chip-template/macros/vco/schematic/xschem/vco_core.sch
.subckt vco_core vbp_core VDD VSS vtune rf_p rf_n
*.PININFO VDD:B VSS:B vbp_core:I vtune:I rf_p:B rf_n:B
XMtop vct vbp_core VDD VDD sg13_lv_pmos w=150u l=0.5u ng=30 m=1 mm_ok=1
xind rf_p rf_n vct VSS vco_ind
XCct vct VSS cap_cmim w=25e-6 l=25e-6 m=1 mm_ok=1
xvar rf_p rf_n vtune VSS vco_var
XM1 rf_p rf_n VSS VSS sg13_lv_nmos w=20u l=0.13u ng=10 m=1 mm_ok=1
XM2 rf_n rf_p VSS VSS sg13_lv_nmos w=20u l=0.13u ng=10 m=1 mm_ok=1
.ends

* expanding   symbol:  vco_ind.sym # of pins=4
** sym_path: /foss/designs/ihp-sg13g2-ams-chip-template/macros/vco/schematic/xschem/vco_ind.sym
** sch_path: /foss/designs/ihp-sg13g2-ams-chip-template/macros/vco/schematic/xschem/vco_ind.sch
.subckt vco_ind la lb lc VSS
*.PININFO la:B lc:B lb:B VSS:B
XL1 la lc lb VSS inductor3 w=4e-6 s=4e-6 d=82e-6 nr_r=2
.ends

* expanding   symbol:  vco_var.sym # of pins=4
** sym_path: /foss/designs/ihp-sg13g2-ams-chip-template/macros/vco/schematic/xschem/vco_var.sym
** sch_path: /foss/designs/ihp-sg13g2-ams-chip-template/macros/vco/schematic/xschem/vco_var.sch
.subckt vco_var rf_p rf_n vtune VSS
*.PININFO vtune:I rf_p:B rf_n:B VSS:B
XCvar1 rf_p vtune rf_n VSS sg13_hv_svaricap w=3.74u l=0.3u Nx=8 mm_ok=1
XCvar2 rf_p vtune rf_n VSS sg13_hv_svaricap w=3.74u l=0.3u Nx=8 mm_ok=1
XCvar3 rf_p vtune rf_n VSS sg13_hv_svaricap w=3.74u l=0.3u Nx=8 mm_ok=1
.ends

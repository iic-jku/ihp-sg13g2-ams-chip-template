** sch_path: /foss/designs/_wt/ihp-sg13g2-ams-chip-template-rf/macros/vco/schematic/xschem/vco_ind.sch
.subckt vco_ind la lb lc VSS
*.PININFO la:B lc:B lb:B VSS:B
LL1 la lc lb VSS inductor3 w=4e-6 s=4e-6 d=52e-6 nr_r=2
.ends

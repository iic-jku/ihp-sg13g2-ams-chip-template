** sch_path: /foss/designs/_wt/ihp-sg13g2-ams-chip-template-rf/macros/vco/schematic/xschem/vco_core.sch
.subckt vco_core vdd_core VSS vtune rf_p rf_n
*.PININFO vdd_core:B VSS:B vtune:I rf_p:B rf_n:B
xind rf_p rf_n vdd_core VSS vco_ind
CCct1 vdd_core VSS cap_cmim w=56e-6 l=39e-6
xvar rf_p rf_n vtune VSS vco_var
MM1 rf_p rf_n VSS VSS sg13_lv_nmos w=20u l=0.13u ng=10
MM2 rf_n rf_p VSS VSS sg13_lv_nmos w=20u l=0.13u ng=10
CCct2 vdd_core VSS cap_cmim w=42e-6 l=25.5e-6
.ends

* expanding   symbol:  vco_ind.sym # of pins=4
** sym_path: /foss/designs/_wt/ihp-sg13g2-ams-chip-template-rf/macros/vco/schematic/xschem/vco_ind.sym
** sch_path: /foss/designs/_wt/ihp-sg13g2-ams-chip-template-rf/macros/vco/schematic/xschem/vco_ind.sch
.subckt vco_ind la lb lc VSS
*.PININFO la:B lc:B lb:B VSS:B
LL1 la lc lb VSS inductor3 w=4e-6 s=4e-6 d=52e-6 nr_r=2
.ends

* expanding   symbol:  vco_var.sym # of pins=4
** sym_path: /foss/designs/_wt/ihp-sg13g2-ams-chip-template-rf/macros/vco/schematic/xschem/vco_var.sym
** sch_path: /foss/designs/_wt/ihp-sg13g2-ams-chip-template-rf/macros/vco/schematic/xschem/vco_var.sch
.subckt vco_var rf_p rf_n vtune VSS
*.PININFO vtune:I rf_p:B rf_n:B VSS:B
CCvar1 rf_p vtune rf_n VSS sg13_hv_svaricap w=3.74u l=0.3u Nx=8
CCvar2 rf_p vtune rf_n VSS sg13_hv_svaricap w=3.74u l=0.3u Nx=8
CCvar3 rf_p vtune rf_n VSS sg13_hv_svaricap w=3.74u l=0.3u Nx=8
.ends

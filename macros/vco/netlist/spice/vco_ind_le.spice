* vco_ind_le - lumped-element equivalent (Ngspice / SPICE3)
* generated by snp2le 0.1.17
* wideband center-tapped inductor model (center tap p3), fitted 0.01 to 60 GHz, 2 coil segments per half
* element values per segment are the totals divided by 2
* after Volker Muehlhaus' inductor_fit
.SUBCKT vco_ind_le p1 p2 p3
Rs_h1_1 p1 a_h1_1 0.5781392665318184
Ls_h1_1 a_h1_1 b_h1_1 4.134809019497757e-11
Rskin1_h1_1 b_h1_1 d_h1_1 0.5065695111522008
Lskin1_h1_1 b_h1_1 d_h1_1 6.227694136472135e-12
Rskin2_h1_1 d_h1_1 c1 205.98193647360995
Lskin2_h1_1 d_h1_1 c1 3.340723947857587e-11
Rs_h1_2 c1 a_h1_2 0.5781392665318184
Ls_h1_2 a_h1_2 b_h1_2 4.134809019497757e-11
Rskin1_h1_2 b_h1_2 d_h1_2 0.5065695111522008
Lskin1_h1_2 b_h1_2 d_h1_2 6.227694136472135e-12
Rskin2_h1_2 d_h1_2 m 205.98193647360995
Lskin2_h1_2 d_h1_2 m 3.340723947857587e-11
Rs_h2_1 m a_h2_1 0.8620316274923617
Ls_h2_1 a_h2_1 b_h2_1 4.134809019497757e-11
Rskin1_h2_1 b_h2_1 d_h2_1 0.6328556031062355
Lskin1_h2_1 b_h2_1 d_h2_1 6.227694136472135e-12
Rskin2_h2_1 d_h2_1 c3 238.25237008565486
Lskin2_h2_1 d_h2_1 c3 3.340723947857587e-11
Rs_h2_2 c3 a_h2_2 0.8620316274923617
Ls_h2_2 a_h2_2 b_h2_2 4.134809019497757e-11
Rskin1_h2_2 b_h2_2 d_h2_2 0.6328556031062355
Lskin1_h2_2 b_h2_2 d_h2_2 6.227694136472135e-12
Rskin2_h2_2 d_h2_2 p2 238.25237008565486
Lskin2_h2_2 d_h2_2 p2 3.340723947857587e-11
Cs p1 p2 3.727973356466969e-15
Rct m p3 0.12810182240445947
Cox_n0 p1 s0 2.6725544459286455e-15
Rsi_n0 s0 0 623.2755148872832
Csi_n0 s0 0 4.628547487287775e-14
Cox_n1 c1 s1 6.958724982501704e-15
Rsi_n1 s1 0 606.382151729094
Csi_n1 s1 0 4.6638649656840174e-14
Cox_n2 m s2 8.572341073146117e-15
Rsi_n2 s2 0 11186.142874522791
Csi_n2 s2 0 7.063495679248487e-16
Cox_n3 c3 s3 7.259871963074566e-15
Rsi_n3 s3 0 757.4146547149168
Csi_n3 s3 0 4.335082626353886e-14
Cox_n4 p2 s4 2.9737014265015075e-15
Rsi_n4 s4 0 783.9555004443824
Csi_n4 s4 0 4.299765147957644e-14
K1 Ls_h1_1 Ls_h2_1 0.31142515150978356
K2 Ls_h1_1 Ls_h2_2 0.31142515150978356
K3 Ls_h1_2 Ls_h2_1 0.31142515150978356
K4 Ls_h1_2 Ls_h2_2 0.31142515150978356
.ENDS vco_ind_le

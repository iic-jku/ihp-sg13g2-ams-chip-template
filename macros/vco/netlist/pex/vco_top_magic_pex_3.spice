* PEX produced on Sat Nov  7 12:43:12 AM CET 2026 using /foss/tools/sak/sak-pex.sh with m=3 and s=1 (extresist threshold=1000 mOhm, minres=100 mOhm, mindelay=0 ps)
* NGSPICE file created from vco_top_pex.ext - technology: ihp-sg13g2

.subckt vco_top_pex ibias_100u di_en VDD VSS vdd_core vtune rf_out_p rf_out_n
X0 VSS.t83 vdd_core.t5 vdd_core.t9 VSS.t82 sg13_lv_nmos ad=0.68p pd=4.68u as=0.38p ps=2.38u w=2u l=0.13u
X1 VSS.t67 vdd_core.t2 vdd_core.t4 VSS.t66 sg13_lv_nmos ad=0.68p pd=4.68u as=0.38p ps=2.38u w=2u l=0.13u
X2 VSS.t109 VSS.t106 VSS.t108 VSS.t107 sg13_lv_nmos ad=0.85p pd=5.68u as=0 ps=0 w=2.5u l=0.5u
X3 rf_out_n.t2 a_9450_4394# a_11798_1180.t11 VSS.t97 sg13_lv_nmos ad=0.38p pd=2.38u as=0.38p ps=2.38u w=2u l=0.13u
X4 rf_out_n.t3 a_9450_4394# a_11798_1180.t9 VSS.t93 sg13_lv_nmos ad=0.38p pd=2.38u as=0.38p ps=2.38u w=2u l=0.13u
X5 VSS.t149 vco_bias_0.vbn_buf.t2 a_11798_1180.t26 VSS.t148 sg13_lv_nmos ad=0.95p pd=5.38u as=0.95p ps=5.38u w=5u l=0.5u
X6 a_11798_1180.t24 vco_bias_0.vbn_buf.t2 VSS.t140 VSS.t141 sg13_lv_nmos ad=0.95p pd=5.38u as=0.95p ps=5.38u w=5u l=0.5u
X7 a_11798_1180.t14 vco_bias_0.vbn_buf.t2 VSS.t111 VSS.t110 sg13_lv_nmos ad=0.95p pd=5.38u as=1.7p ps=10.68u w=5u l=0.5u
X8 VSS.t4 vco_bias_0.vbn_buf.t3 VSS.t2 VSS.t3 sg13_lv_nmos ad=1.52p pd=8.38u as=0 ps=0 w=8u l=10u
X9 ibias_100u.t1 ibias_100u.t0 VSS.t14 VSS.t13 sg13_lv_nmos ad=0.85p pd=5.68u as=0.85p ps=5.68u w=2.5u l=0.5u
X10 VSS.t8 vco_bias_0.vbn_buf.t3 VSS.t6 VSS.t7 sg13_lv_nmos ad=1.52p pd=8.38u as=0 ps=0 w=8u l=10u
X11 VSS.t124 vco_bias_0.vbn_buf.t2 a_11798_1180.t17 VSS.t123 sg13_lv_nmos ad=0.95p pd=5.38u as=0.95p ps=5.38u w=5u l=0.5u
X12 VSS.t77 vdd_core.t5 vdd_core.t7 VSS.t76 sg13_lv_nmos ad=0.38p pd=2.38u as=0.38p ps=2.38u w=2u l=0.13u
X13 a_11798_1180.t2 a_14668_2644# rf_out_p.t5 VSS.t36 sg13_lv_nmos ad=0.38p pd=2.38u as=0.38p ps=2.38u w=2u l=0.13u
X14 vco_bias_0.vbn_buf.t0 a_5905_4552.t2 VSS.t32 VSS.t31 sg13_lv_nmos ad=0.34p pd=2.68u as=0.34p ps=2.68u w=1u l=0.13u
X15 VSS.t26 vco_bias_0.vbn_buf.t4 VSS.t24 VSS.t5 sg13_lv_nmos ad=1.52p pd=8.38u as=0 ps=0 w=8u l=10u
X16 rf_out_p.t4 a_14668_2644# a_11798_1180.t0 VSS.t33 sg13_lv_nmos ad=0.38p pd=2.38u as=0.68p ps=4.68u w=2u l=0.13u
X17 VSS.t161 vco_bias_0.vbg_buf VSS.t160 VSS.t0 sg13_lv_nmos ad=2.72p pd=16.68u as=0 ps=0 w=8u l=10u
X18 a_5948_4416.t1 a_5905_4552.t5 VDD.t3 VDD.t0 sg13_lv_pmos ad=0.34p pd=2.68u as=0.34p ps=2.68u w=1u l=0.13u
X19 VSS.t177 vco_bias_0.vbg_buf VSS.t175 VSS.t7 sg13_lv_nmos ad=1.52p pd=8.38u as=0 ps=0 w=8u l=10u
X20 ibias_100u.t2 a_5905_4552.t3 VSS.t18 VSS.t17 sg13_lv_nmos ad=0.34p pd=2.68u as=0.34p ps=2.68u w=1u l=0.13u
X21 a_5560_5708.t2 a_5560_3922.t2 VSS.t87 rppd l=8.5u w=0.5u
X22 VSS.t58 vdd_core.t2 vdd_core.t18 VSS.t57 sg13_lv_nmos ad=0.38p pd=2.38u as=0.38p ps=2.38u w=2u l=0.13u
X23 vdd_core.t8 vdd_core.t5 VSS.t77 VSS.t78 sg13_lv_nmos ad=0.38p pd=2.38u as=0.38p ps=2.38u w=2u l=0.13u
X24 vdd_core.t6 vdd_core.t5 VSS.t71 VSS.t72 sg13_lv_nmos ad=0.38p pd=2.38u as=0.38p ps=2.38u w=2u l=0.13u
X25 vco_bias_0.vbg_buf a_5560_5708.t1 VSS.t47 rhigh l=32u w=0.5u
X26 vdd_core.t3 vdd_core.t2 VSS.t61 VSS.t62 sg13_lv_nmos ad=0.38p pd=2.38u as=0.38p ps=2.38u w=2u l=0.13u
X27 a_5905_4552.t0 di_en.t0 VSS.t86 VSS.t85 sg13_lv_nmos ad=0.17p pd=1.68u as=0.17p ps=1.68u w=0.5u l=0.13u
N28 vdd_core.t30 vtune.t3 sg13_hv_svaricap l=0.3u w=26.34u
X29 a_11798_1180.t5 a_14668_2644# rf_out_p.t1 VSS.t42 sg13_lv_nmos ad=0.38p pd=2.38u as=0.38p ps=2.38u w=2u l=0.13u
X30 VSS.t140 vco_bias_0.vbn_buf.t2 a_11798_1180.t23 VSS.t139 sg13_lv_nmos ad=0.95p pd=5.38u as=0.95p ps=5.38u w=5u l=0.5u
X31 VSS.t175 vco_bias_0.vbg_buf VSS.t173 VSS.t5 sg13_lv_nmos ad=1.52p pd=8.38u as=0 ps=0 w=8u l=10u
X32 vco_bias_0.vbg_buf VSS.t156 cap_cmim l=19.1u w=19.5u
X33 VSS.t113 vco_bias_0.vbn_buf.t2 a_11798_1180.t14 VSS.t112 sg13_lv_nmos ad=0.95p pd=5.38u as=0.95p ps=5.38u w=5u l=0.5u
X34 a_11798_1180.t27 vco_bias_0.vbn_buf.t2 VSS.t149 VSS.t150 sg13_lv_nmos ad=0.95p pd=5.38u as=0.95p ps=5.38u w=5u l=0.5u
X35 vco_bias_0.vbn_buf.t1 ibias_100u.t3 VSS.t84 rhigh l=32u w=0.5u
X36 a_11798_1180.t28 vco_bias_0.vbn_buf.t2 VSS.t152 VSS.t153 sg13_lv_nmos ad=0.95p pd=5.38u as=0.95p ps=5.38u w=5u l=0.5u
N37 vdd_core.t29 vtune.t3 sg13_hv_svaricap l=0.3u w=26.34u
X38 VSS.t6 vco_bias_0.vbn_buf.t3 VSS.t4 VSS.t5 sg13_lv_nmos ad=1.52p pd=8.38u as=0 ps=0 w=8u l=10u
X39 a_11798_1180.t12 a_9450_4394# rf_out_n.t2 VSS.t98 sg13_lv_nmos ad=0.38p pd=2.38u as=0.38p ps=2.38u w=2u l=0.13u
X40 a_11798_1180.t18 vco_bias_0.vbn_buf.t2 VSS.t124 VSS.t129 sg13_lv_nmos ad=0.95p pd=5.38u as=0.95p ps=5.38u w=5u l=0.5u
X41 a_11798_1180.t10 a_9450_4394# rf_out_n.t3 VSS.t94 sg13_lv_nmos ad=0.38p pd=2.38u as=0.38p ps=2.38u w=2u l=0.13u
X42 VSS.t163 vco_bias_0.vbg_buf VSS.t161 VSS.t3 sg13_lv_nmos ad=1.52p pd=8.38u as=0 ps=0 w=8u l=10u
X43 VSS.t136 vco_bias_0.vbn_buf.t2 a_11798_1180.t21 VSS.t137 sg13_lv_nmos ad=0.95p pd=5.38u as=0.95p ps=5.38u w=5u l=0.5u
X44 VSS.t179 vco_bias_0.vbg_buf VSS.t177 VSS.t9 sg13_lv_nmos ad=1.52p pd=8.38u as=0 ps=0 w=8u l=10u
X45 VDD.t16 VDD.t14 VDD.t15 VDD.t0 sg13_lv_pmos ad=1.7p pd=10.68u as=0 ps=0 w=5u l=0.5u
X46 VSS.t152 vco_bias_0.vbn_buf.t2 a_11798_1180.t27 VSS.t151 sg13_lv_nmos ad=0.95p pd=5.38u as=0.95p ps=5.38u w=5u l=0.5u
X47 VSS.t80 vdd_core.t5 vdd_core.t8 VSS.t79 sg13_lv_nmos ad=0.38p pd=2.38u as=0.38p ps=2.38u w=2u l=0.13u
X48 VSS.t155 vco_bias_0.vbn_buf.t2 a_11798_1180.t28 VSS.t154 sg13_lv_nmos ad=1.7p pd=10.68u as=0.95p ps=5.38u w=5u l=0.5u
X49 VSS.t22 vco_bias_0.vbn_buf.t4 VSS.t21 VSS.t0 sg13_lv_nmos ad=2.72p pd=16.68u as=0 ps=0 w=8u l=10u
X50 VSS.t64 vdd_core.t2 vdd_core.t3 VSS.t63 sg13_lv_nmos ad=0.38p pd=2.38u as=0.38p ps=2.38u w=2u l=0.13u
X51 VDD.t7 rf_out_p.t6 VSS.t101 rppd l=1.65u w=10u
X52 VDD.t10 VDD.t8 VDD.t9 VDD.t0 sg13_lv_pmos ad=0.34p pd=2.68u as=0 ps=0 w=1u l=0.13u
X53 VDD.t13 VDD.t11 VDD.t12 VDD.t0 sg13_lv_pmos ad=1.7p pd=10.68u as=0 ps=0 w=5u l=0.5u
X54 a_6568_6136.t1 a_5948_4416.t2 VDD.t4 VDD.t0 sg13_lv_pmos ad=0.34p pd=2.68u as=0.34p ps=2.68u w=1u l=0.13u
X55 rf_out_p.t2 a_14668_2644# a_11798_1180.t5 VSS.t43 sg13_lv_nmos ad=0.38p pd=2.38u as=0.38p ps=2.38u w=2u l=0.13u
X56 a_5905_4552.t1 di_en.t1 VDD.t6 VDD.t0 sg13_lv_pmos ad=0.34p pd=2.68u as=0.34p ps=2.68u w=1u l=0.13u
X57 a_11798_1180.t21 vco_bias_0.vbn_buf.t2 VSS.t133 VSS.t134 sg13_lv_nmos ad=0.95p pd=5.38u as=0.95p ps=5.38u w=5u l=0.5u
X58 rf_out_p.t0 a_14668_2644# a_11798_1180.t3 VSS.t39 sg13_lv_nmos ad=0.38p pd=2.38u as=0.38p ps=2.38u w=2u l=0.13u
X59 VSS.t30 vco_bias_0.vbn_buf.t4 VSS.t28 VSS.t9 sg13_lv_nmos ad=1.52p pd=8.38u as=0 ps=0 w=8u l=10u
X60 vdd_core.t10 vdd_core.t2 VSS.t58 VSS.t59 sg13_lv_nmos ad=0.38p pd=2.38u as=0.38p ps=2.38u w=2u l=0.13u
X61 VSS.t143 vco_bias_0.vbn_buf.t2 a_11798_1180.t24 VSS.t142 sg13_lv_nmos ad=0.95p pd=5.38u as=0.95p ps=5.38u w=5u l=0.5u
X62 a_11798_1180.t22 vco_bias_0.vbn_buf.t2 VSS.t136 VSS.t135 sg13_lv_nmos ad=0.95p pd=5.38u as=0.95p ps=5.38u w=5u l=0.5u
X63 vdd_core.t13 vdd_core.t2 VSS.t53 VSS.t52 sg13_lv_nmos ad=0.38p pd=2.38u as=0.68p ps=4.68u w=2u l=0.13u
X64 VSS.t146 vco_bias_0.vbn_buf.t2 a_11798_1180.t25 VSS.t145 sg13_lv_nmos ad=0.95p pd=5.38u as=0.95p ps=5.38u w=5u l=0.5u
X65 VSS.t74 vdd_core.t5 vdd_core.t6 VSS.t73 sg13_lv_nmos ad=0.38p pd=2.38u as=0.38p ps=2.38u w=2u l=0.13u
X66 rf_out_n.t5 a_9450_4394# a_11798_1180.t7 VSS.t89 sg13_lv_nmos ad=0.38p pd=2.38u as=0.68p ps=4.68u w=2u l=0.13u
X67 a_5560_5708.t0 a_6568_6136.t4 VDD.t2 VDD.t0 sg13_lv_pmos ad=1.7p pd=10.68u as=1.7p ps=10.68u w=5u l=0.5u
N68 vdd_core.t27 vtune.t6 sg13_hv_svaricap l=0.3u w=26.34u
X69 VSS.t55 vdd_core.t2 vdd_core.t13 VSS.t54 sg13_lv_nmos ad=0.38p pd=2.38u as=0.38p ps=2.38u w=2u l=0.13u
X70 VSS.t2 vco_bias_0.vbn_buf.t3 VSS.t1 VSS.t0 sg13_lv_nmos ad=2.72p pd=16.68u as=0 ps=0 w=8u l=10u
X71 rf_out_n.t4 a_9450_4394# a_11798_1180.t12 VSS.t99 sg13_lv_nmos ad=0.38p pd=2.38u as=0.38p ps=2.38u w=2u l=0.13u
X72 rf_out_n.t1 a_9450_4394# a_11798_1180.t10 VSS.t95 sg13_lv_nmos ad=0.38p pd=2.38u as=0.38p ps=2.38u w=2u l=0.13u
X73 VSS.t171 vco_bias_0.vbg_buf VSS.t170 VSS.t0 sg13_lv_nmos ad=2.72p pd=16.68u as=0 ps=0 w=8u l=10u
X74 VSS.t116 vco_bias_0.vbn_buf.t2 a_11798_1180.t15 VSS.t115 sg13_lv_nmos ad=0.95p pd=5.38u as=0.95p ps=5.38u w=5u l=0.5u
X75 a_11798_1180.t19 vco_bias_0.vbn_buf.t2 VSS.t126 VSS.t125 sg13_lv_nmos ad=0.95p pd=5.38u as=0.95p ps=5.38u w=5u l=0.5u
N76 vdd_core.t31 vtune.t0 sg13_hv_svaricap l=0.3u w=26.34u
X77 a_11798_1180.t25 vco_bias_0.vbn_buf.t2 VSS.t143 VSS.t144 sg13_lv_nmos ad=0.95p pd=5.38u as=0.95p ps=5.38u w=5u l=0.5u
X78 a_11798_1180.t26 vco_bias_0.vbn_buf.t2 VSS.t146 VSS.t147 sg13_lv_nmos ad=0.95p pd=5.38u as=0.95p ps=5.38u w=5u l=0.5u
X79 a_9450_4394# vdd_core.t24 cap_cmim l=10u w=10u
X80 a_11798_1180.t1 a_14668_2644# rf_out_p.t4 VSS.t34 sg13_lv_nmos ad=0.38p pd=2.38u as=0.38p ps=2.38u w=2u l=0.13u
X81 VSS.t10 vco_bias_0.vbn_buf.t3 VSS.t8 VSS.t9 sg13_lv_nmos ad=1.52p pd=8.38u as=0 ps=0 w=8u l=10u
X82 VSS.t105 VSS.t102 VSS.t104 VSS.t103 sg13_lv_nmos ad=0.85p pd=5.68u as=0 ps=0 w=2.5u l=0.5u
X83 vdd_core.t9 vdd_core.t5 VSS.t80 VSS.t81 sg13_lv_nmos ad=0.38p pd=2.38u as=0.38p ps=2.38u w=2u l=0.13u
X84 vdd_core.t4 vdd_core.t2 VSS.t64 VSS.t65 sg13_lv_nmos ad=0.38p pd=2.38u as=0.38p ps=2.38u w=2u l=0.13u
X85 a_11798_1180.t15 vco_bias_0.vbn_buf.t2 VSS.t113 VSS.t114 sg13_lv_nmos ad=0.95p pd=5.38u as=0.95p ps=5.38u w=5u l=0.5u
X86 VSS.t126 vco_bias_0.vbn_buf.t2 a_11798_1180.t18 VSS.t130 sg13_lv_nmos ad=0.95p pd=5.38u as=0.95p ps=5.38u w=5u l=0.5u
X87 a_11798_1180.t16 vco_bias_0.vbn_buf.t2 VSS.t116 VSS.t117 sg13_lv_nmos ad=0.95p pd=5.38u as=0.95p ps=5.38u w=5u l=0.5u
X88 a_11798_1180.t4 a_14668_2644# rf_out_p.t0 VSS.t40 sg13_lv_nmos ad=0.38p pd=2.38u as=0.38p ps=2.38u w=2u l=0.13u
X89 rf_out_p.t3 a_14668_2644# a_11798_1180.t2 VSS.t37 sg13_lv_nmos ad=0.38p pd=2.38u as=0.38p ps=2.38u w=2u l=0.13u
X90 VDD.t19 VDD.t17 VDD.t18 VDD.t0 sg13_lv_pmos ad=1.7p pd=10.68u as=0 ps=0 w=5u l=0.5u
X91 VSS.t167 vco_bias_0.vbg_buf VSS.t165 VSS.t7 sg13_lv_nmos ad=1.52p pd=8.38u as=0 ps=0 w=8u l=10u
X92 a_14668_2644# vdd_core.t0 cap_cmim l=10u w=10u
X93 VSS.t119 vco_bias_0.vbn_buf.t2 a_11798_1180.t19 VSS.t118 sg13_lv_nmos ad=0.95p pd=5.38u as=0.95p ps=5.38u w=5u l=0.5u
X94 a_11798_1180.t23 vco_bias_0.vbn_buf.t2 VSS.t128 VSS.t127 sg13_lv_nmos ad=0.95p pd=5.38u as=0.95p ps=5.38u w=5u l=0.5u
X95 a_11798_1180.t8 a_9450_4394# rf_out_n.t5 VSS.t90 sg13_lv_nmos ad=0.38p pd=2.38u as=0.38p ps=2.38u w=2u l=0.13u
X96 a_5560_3922.t1 a_5560_3922.t0 VSS.t12 VSS.t11 sg13_lv_nmos ad=0.85p pd=5.68u as=0.85p ps=5.68u w=2.5u l=0.5u
X97 VSS.t173 vco_bias_0.vbg_buf VSS.t171 VSS.t3 sg13_lv_nmos ad=1.52p pd=8.38u as=0 ps=0 w=8u l=10u
X98 VSS.t165 vco_bias_0.vbg_buf VSS.t163 VSS.t5 sg13_lv_nmos ad=1.52p pd=8.38u as=0 ps=0 w=8u l=10u
X99 VSS.t61 vdd_core.t2 vdd_core.t10 VSS.t60 sg13_lv_nmos ad=0.38p pd=2.38u as=0.38p ps=2.38u w=2u l=0.13u
X100 a_6568_6136.t3 a_6568_6136.t2 VDD.t1 VDD.t0 sg13_lv_pmos ad=1.7p pd=10.68u as=1.7p ps=10.68u w=5u l=0.5u
X101 vdd_core.t7 vdd_core.t5 VSS.t74 VSS.t75 sg13_lv_nmos ad=0.38p pd=2.38u as=0.38p ps=2.38u w=2u l=0.13u
X102 a_11798_1180.t13 a_9450_4394# rf_out_n.t4 VSS.t100 sg13_lv_nmos ad=0.68p pd=4.68u as=0.38p ps=2.38u w=2u l=0.13u
X103 vdd_core.t14 vdd_core.t5 VSS.t69 VSS.t68 sg13_lv_nmos ad=0.38p pd=2.38u as=0.68p ps=4.68u w=2u l=0.13u
X104 vdd_core.t26 VSS.t48 cap_cmim l=39u w=56u
X105 a_11798_1180.t11 a_9450_4394# rf_out_n.t1 VSS.t96 sg13_lv_nmos ad=0.38p pd=2.38u as=0.38p ps=2.38u w=2u l=0.13u
X106 a_11798_1180.t9 a_9450_4394# rf_out_n.t6 VSS.t92 sg13_lv_nmos ad=0.38p pd=2.38u as=0.38p ps=2.38u w=2u l=0.13u
X107 VSS.t121 vco_bias_0.vbn_buf.t2 a_11798_1180.t16 VSS.t122 sg13_lv_nmos ad=0.95p pd=5.38u as=0.95p ps=5.38u w=5u l=0.5u
X108 vco_bias_0.vbg_buf a_14668_2644# VSS.t45 rhigh l=8u w=0.5u
N109 vdd_core.t28 vtune.t6 sg13_hv_svaricap l=0.3u w=26.34u
X110 a_6568_6136.t0 ibias_100u.t4 VSS.t16 VSS.t15 sg13_lv_nmos ad=0.85p pd=5.68u as=0.85p ps=5.68u w=2.5u l=0.5u
X111 vdd_core.t18 vdd_core.t2 VSS.t55 VSS.t56 sg13_lv_nmos ad=0.38p pd=2.38u as=0.38p ps=2.38u w=2u l=0.13u
X112 VSS.t128 vco_bias_0.vbn_buf.t2 a_11798_1180.t22 VSS.t138 sg13_lv_nmos ad=0.95p pd=5.38u as=0.95p ps=5.38u w=5u l=0.5u
X113 a_11798_1180.t20 vco_bias_0.vbn_buf.t2 VSS.t119 VSS.t131 sg13_lv_nmos ad=0.95p pd=5.38u as=0.95p ps=5.38u w=5u l=0.5u
X114 VSS.t71 vdd_core.t5 vdd_core.t14 VSS.t70 sg13_lv_nmos ad=0.38p pd=2.38u as=0.38p ps=2.38u w=2u l=0.13u
X115 a_5948_4416.t0 a_5905_4552.t4 VSS.t20 VSS.t19 sg13_lv_nmos ad=0.17p pd=1.68u as=0.17p ps=1.68u w=0.5u l=0.13u
X116 vco_bias_0.vbg_buf VSS.t158 cap_cmim l=7.28u w=13.6u
X117 rf_out_p.t5 a_14668_2644# a_11798_1180.t1 VSS.t35 sg13_lv_nmos ad=0.38p pd=2.38u as=0.38p ps=2.38u w=2u l=0.13u
N118 vdd_core.t32 vtune.t0 sg13_hv_svaricap l=0.3u w=26.34u
X119 VDD.t5 rf_out_n.t0 VSS.t46 rppd l=1.65u w=10u
X120 VSS.t169 vco_bias_0.vbg_buf VSS.t167 VSS.t9 sg13_lv_nmos ad=1.52p pd=8.38u as=0 ps=0 w=8u l=10u
X121 VSS.t24 vco_bias_0.vbn_buf.t4 VSS.t22 VSS.t3 sg13_lv_nmos ad=1.52p pd=8.38u as=0 ps=0 w=8u l=10u
X122 VSS.t28 vco_bias_0.vbn_buf.t4 VSS.t26 VSS.t7 sg13_lv_nmos ad=1.52p pd=8.38u as=0 ps=0 w=8u l=10u
X123 vdd_core.t26 VSS.t50 cap_cmim l=25.5u w=42u
X124 a_11798_1180.t6 a_14668_2644# rf_out_p.t2 VSS.t44 sg13_lv_nmos ad=0.68p pd=4.68u as=0.38p ps=2.38u w=2u l=0.13u
X125 rf_out_p.t1 a_14668_2644# a_11798_1180.t4 VSS.t41 sg13_lv_nmos ad=0.38p pd=2.38u as=0.38p ps=2.38u w=2u l=0.13u
X126 a_11798_1180.t3 a_14668_2644# rf_out_p.t3 VSS.t38 sg13_lv_nmos ad=0.38p pd=2.38u as=0.38p ps=2.38u w=2u l=0.13u
X127 vco_bias_0.vbg_buf a_9450_4394# VSS.t88 rhigh l=8u w=0.5u
X128 a_11798_1180.t17 vco_bias_0.vbn_buf.t2 VSS.t121 VSS.t120 sg13_lv_nmos ad=0.95p pd=5.38u as=0.95p ps=5.38u w=5u l=0.5u
X129 VSS.t133 vco_bias_0.vbn_buf.t2 a_11798_1180.t20 VSS.t132 sg13_lv_nmos ad=0.95p pd=5.38u as=0.95p ps=5.38u w=5u l=0.5u
X130 rf_out_n.t6 a_9450_4394# a_11798_1180.t8 VSS.t91 sg13_lv_nmos ad=0.38p pd=2.38u as=0.38p ps=2.38u w=2u l=0.13u
R0 rf_out_p rf_out_p.n2 6.6125
R1 rf_out_p.n0 rf_out_p.t4 4.77599
R2 rf_out_p.n1 rf_out_p.t2 4.72949
R3 rf_out_p.n1 rf_out_p.t1 4.72949
R4 rf_out_p.n0 rf_out_p.t0 4.72949
R5 rf_out_p.n0 rf_out_p.t3 4.72949
R6 rf_out_p.n0 rf_out_p.t5 4.72949
R7 rf_out_p.n2 rf_out_p.t6 2.40801
R8 rf_out_p.n2 rf_out_p.n1 0.685593
R9 rf_out_p.n1 rf_out_p.n0 0.186531
R10 rf_out_n rf_out_n.n2 6.6125
R11 rf_out_n.n0 rf_out_n.t4 4.77599
R12 rf_out_n.n0 rf_out_n.t2 4.72949
R13 rf_out_n.n0 rf_out_n.t1 4.72949
R14 rf_out_n.n1 rf_out_n.t3 4.72949
R15 rf_out_n.n1 rf_out_n.t6 4.72949
R16 rf_out_n.n1 rf_out_n.t5 4.72949
R17 rf_out_n.n2 rf_out_n.t0 2.40801
R18 rf_out_n.n2 rf_out_n.n1 0.685593
R19 rf_out_n.n1 rf_out_n.n0 0.186531
R20 ibias_100u.n3 ibias_100u.t3 48.8821
R21 ibias_100u.n0 ibias_100u.t4 24.2693
R22 ibias_100u.n1 ibias_100u.t0 24.2693
R23 ibias_100u ibias_100u.n3 19.3314
R24 ibias_100u.n0 ibias_100u.t2 17.3756
R25 ibias_100u.n2 ibias_100u.t1 9.21754
R26 ibias_100u.n3 ibias_100u.n2 4.77917
R27 ibias_100u.n1 ibias_100u.n0 0.543167
R28 ibias_100u.n2 ibias_100u.n1 0.320233
R29 di_en.n0 di_en.t0 21.6583
R30 di_en.n0 di_en.t1 19.605
R31 di_en di_en.n0 14.2582
R32 vdd_core.n44 vdd_core.t0 5.04833
R33 vdd_core.n14 vdd_core.t24 4.89028
R34 vdd_core.n3 vdd_core.t14 4.76919
R35 vdd_core.n1 vdd_core.t4 4.76919
R36 vdd_core.n51 vdd_core.t9 4.74635
R37 vdd_core.n18 vdd_core.t13 4.74635
R38 vdd_core.n50 vdd_core.t8 4.72949
R39 vdd_core.n42 vdd_core.t7 4.72949
R40 vdd_core.n4 vdd_core.t6 4.72949
R41 vdd_core.n2 vdd_core.t3 4.72949
R42 vdd_core.n20 vdd_core.t10 4.72949
R43 vdd_core.n21 vdd_core.t18 4.72949
R44 vdd_core.n23 vdd_core.t5 4.1356
R45 vdd_core.n53 vdd_core.t2 3.9789
R46 vdd_core.n14 vdd_core.t27 3.51966
R47 vdd_core.n15 vdd_core.t29 3.51966
R48 vdd_core.n19 vdd_core.t31 3.51966
R49 vdd_core.n44 vdd_core.t28 3.4996
R50 vdd_core.n48 vdd_core.t30 3.4996
R51 vdd_core.n49 vdd_core.t32 3.4996
R52 vdd_core.n4 vdd_core.n3 0.0338961
R53 vdd_core.n2 vdd_core.n1 0.0338961
R54 vdd_core.n40 vdd_core.n38 1.5005
R55 vdd_core.n29 vdd_core.n28 1.5005
R56 vdd_core.n74 vdd_core.n30 1.48507
R57 vdd_core.n52 vdd_core.n51 1.12056
R58 vdd_core.n0 vdd_core.n18 1.12056
R59 vdd_core.n25 vdd_core.n24 0.778589
R60 vdd_core.n54 vdd_core.n39 0.778576
R61 vdd_core.n41 vdd_core.n38 0.767758
R62 vdd_core.n29 vdd_core.n12 0.767758
R63 vdd_core.n55 vdd_core.n41 0.751792
R64 vdd_core.n17 vdd_core.n12 0.751792
R65 vdd_core.n56 vdd_core.n55 0.741729
R66 vdd_core.n17 vdd_core.n13 0.741729
R67 vdd_core.n52 vdd_core.n43 0.741487
R68 vdd_core.n0 vdd_core.n22 0.741487
R69 vdd_core.n47 vdd_core.n46 0.703434
R70 vdd_core.n26 vdd_core.n16 0.703434
R71 vdd_core.n10 vdd_core.n62 0.928728
R72 vdd_core.n58 vdd_core.n57 0.498121
R73 vdd_core.n30 vdd_core.n11 0.498121
R74 vdd_core.t26 vdd_core.n74 0.485212
R75 vdd_core.n0 vdd_core.n19 0.33314
R76 vdd_core.n73 vdd_core.n31 0.314786
R77 vdd_core.n72 vdd_core.n32 0.314786
R78 vdd_core.n49 vdd_core.n48 0.29442
R79 vdd_core.n15 vdd_core.n14 0.29442
R80 vdd_core.n47 vdd_core.n44 0.284212
R81 vdd_core.n65 vdd_core.n35 0.256643
R82 vdd_core.n67 vdd_core.n66 0.222071
R83 vdd_core.n66 vdd_core.n65 0.184357
R84 vdd_core.n63 vdd_core.n35 0.183571
R85 vdd_core.n52 vdd_core.n49 0.175092
R86 vdd_core.n16 vdd_core.n15 0.14834
R87 vdd_core.n19 vdd_core.n16 0.14658
R88 vdd_core.n23 vdd_core.n0 0.14658
R89 vdd_core.n53 vdd_core.n52 0.12898
R90 vdd_core.n73 vdd_core.n32 0.125429
R91 vdd_core.n6 vdd_core.n31 0.0923444
R92 vdd_core.n54 vdd_core.n53 0.0809928
R93 vdd_core.n57 vdd_core.n56 0.0703453
R94 vdd_core.n13 vdd_core.n11 0.0703453
R95 vdd_core vdd_core.t26 0.0649111
R96 vdd_core.n24 vdd_core.n23 0.0633895
R97 vdd_core.n46 vdd_core.n39 0.0593402
R98 vdd_core.n26 vdd_core.n25 0.0593402
R99 vdd_core.n72 vdd_core.n71 0.0515714
R100 vdd_core.n63 vdd_core.n10 0.0483595
R101 vdd_core.n45 vdd_core.n41 0.0338265
R102 vdd_core.n27 vdd_core.n12 0.0334354
R103 vdd_core.n6 vdd_core.n5 0.0107373
R104 vdd_core.n73 vdd_core.n5 0.00934163
R105 vdd_core.n64 vdd_core.n63 0.0315396
R106 vdd_core.n51 vdd_core.n50 0.0310403
R107 vdd_core.n21 vdd_core.n18 0.0310403
R108 vdd_core.n67 vdd_core.n34 0.0304505
R109 vdd_core.n65 vdd_core.n64 0.0304505
R110 vdd_core.n1 vdd_core.n0 0.59294
R111 vdd_core.n65 vdd_core.n34 0.0267475
R112 vdd_core.n57 vdd_core.n39 0.0267154
R113 vdd_core.n25 vdd_core.n11 0.0267154
R114 vdd_core.n50 vdd_core.n43 0.0260771
R115 vdd_core.n22 vdd_core.n21 0.0257351
R116 vdd_core.n22 vdd_core.n20 0.0233414
R117 vdd_core.n37 vdd_core.n36 0.0230739
R118 vdd_core.n43 vdd_core.n42 0.0229994
R119 vdd_core.n42 vdd_core.n4 0.022386
R120 vdd_core.n20 vdd_core.n2 0.022386
R121 vdd_core.n59 vdd_core.n36 0.0219261
R122 vdd_core.n8 vdd_core.n7 0.0123949
R123 vdd_core.n7 vdd_core.n60 0.00986331
R124 vdd_core.n46 vdd_core.n45 0.020388
R125 vdd_core.n27 vdd_core.n26 0.020388
R126 vdd_core.n56 vdd_core.n40 0.0195413
R127 vdd_core.n28 vdd_core.n13 0.0195413
R128 vdd_core.n68 vdd_core.n31 0.0185637
R129 vdd_core.n60 vdd_core.n59 0.0181308
R130 vdd_core.n52 vdd_core.n3 0.59294
R131 vdd_core.n72 vdd_core.n5 0.0301636
R132 vdd_core.n28 vdd_core.n27 0.0149711
R133 vdd_core.n61 vdd_core.n7 0.0322965
R134 vdd_core.n45 vdd_core.n40 0.01458
R135 vdd_core.n70 vdd_core.n32 0.0134951
R136 vdd_core.n68 vdd_core.n32 0.0125784
R137 vdd_core.n71 vdd_core.n70 0.0125784
R138 vdd_core.n58 vdd_core.n8 0.7269
R139 vdd_core.n48 vdd_core.n47 0.010708
R140 vdd_core.n24 vdd_core.n17 0.0103252
R141 vdd_core.n55 vdd_core.n54 0.0103207
R142 vdd_core.n59 vdd_core.n8 0.016582
R143 vdd_core.n64 vdd_core.n33 0.00841435
R144 vdd_core.n61 vdd_core.n37 0.00737127
R145 vdd_core.n58 vdd_core.n38 0.00722611
R146 vdd_core.n30 vdd_core.n29 0.00722611
R147 vdd_core.n69 vdd_core.n68 0.00718951
R148 vdd_core.n62 vdd_core.n61 0.00703478
R149 vdd_core.n69 vdd_core.n67 0.00681683
R150 vdd_core.n9 vdd_core.n10 0.00452013
R151 vdd_core.n60 vdd_core.n37 0.00651402
R152 vdd_core.n71 vdd_core.n33 0.00637745
R153 vdd_core.n62 vdd_core.n36 0.00601652
R154 vdd_core.n70 vdd_core.n69 0.00476338
R155 vdd_core.n34 vdd_core.n33 0.00476338
R156 vdd_core.n70 vdd_core.n34 0.0040803
R157 vdd_core.n9 vdd_core.n35 0.00151948
R158 vdd_core.n9 vdd_core.n66 0.0111422
R159 vdd_core.n74 vdd_core.n6 0.467907
R160 vtune.n0 vtune.t0 16.1774
R161 vtune vtune.n1 16.1137
R162 vtune.n0 vtune.t3 14.7078
R163 vtune.n1 vtune.t6 14.7078
R164 vtune.n1 vtune.n0 1.4701
R165 VDD VDD.n6 22.5016
R166 VDD VDD.n12 17.6809
R167 VDD.n0 VDD.t17 17.5809
R168 VDD.n2 VDD.t14 17.5809
R169 VDD.n8 VDD.t11 17.5809
R170 VDD.n7 VDD.n8 0.0636783
R171 VDD.n11 VDD.n7 1.85672
R172 VDD.n3 VDD.t18 2.54465
R173 VDD.n10 VDD.t8 15.8062
R174 VDD.n11 VDD.n9 2.10335
R175 VDD.n8 VDD.t9 6.07554
R176 VDD.n8 VDD.t10 6.07554
R177 VDD.n4 VDD.t4 6.07554
R178 VDD.n5 VDD.t6 6.07554
R179 VDD.n6 VDD.t3 6.07554
R180 VDD.n11 VDD.n4 2.40129
R181 VDD.n4 VDD.n5 0.1061
R182 VDD.n12 VDD.t7 4.22454
R183 VDD.n6 VDD.n11 3.37539
R184 VDD.n11 VDD.n3 1.16155
R185 VDD.n2 VDD.t16 2.36422
R186 VDD.n1 VDD.t2 2.36399
R187 VDD.n0 VDD.t1 2.36379
R188 VDD.n2 VDD.t12 2.36379
R189 VDD.n2 VDD.t13 2.36327
R190 VDD.n0 VDD.t19 2.36326
R191 VDD.n1 VDD.t15 2.36322
R192 VDD.n12 VDD.t5 0.517741
R193 VDD.n11 VDD.t0 0.395849
R194 VDD.n1 VDD.n0 0.181347
R195 VDD.n6 VDD.n5 0.152127
R196 VDD.n3 VDD.n0 0.0814646
R197 VDD.n10 VDD.n4 0.144689
R198 VDD.n9 VDD.n1 0.139765
R199 VDD.n9 VDD.n2 0.137132
R200 VDD.n2 VDD.n7 0.120382
R201 VDD.n8 VDD.n10 0.102865
R202 VSS.n330 VSS.n242 18957.8
R203 VSS.n506 VSS.n505 1094.66
R204 VSS.t84 VSS.n421 657.683
R205 VSS.t87 VSS.t47 381.851
R206 VSS.t101 VSS.t45 301.887
R207 VSS.t47 VSS.t84 179.696
R208 VSS.n10 VSS.t87 147.716
R209 VSS.n102 VSS.t101 109.811
R210 VSS.n422 VSS.n7 70.6476
R211 VSS.n8 VSS.t15 11.2345
R212 VSS.t107 VSS.n7 8.96376
R213 VSS.n6 VSS.t85 12.0533
R214 VSS.t103 VSS.n9 15.8457
R215 VSS.t11 VSS.n9 13.3662
R216 VSS.n6 VSS.n8 0.0411729
R217 VSS.n6 VSS.n10 7.68641
R218 VSS.n6 VSS.t17 15.5114
R219 VSS.n449 VSS.n70 25.2835
R220 VSS.n331 VSS.n330 21.7962
R221 VSS.n262 VSS.t0 20.8203
R222 VSS.t31 VSS.n6 13.9985
R223 VSS.t19 VSS.n10 9.25867
R224 VSS.n413 VSS.t20 17.3443
R225 VSS.n415 VSS.t86 17.3443
R226 VSS.n38 VSS.n37 0.0686681
R227 VSS.n474 VSS.n473 17.0005
R228 VSS.n474 VSS.n458 17.0005
R229 VSS.n474 VSS.n472 17.0005
R230 VSS.n474 VSS.n459 17.0005
R231 VSS.n474 VSS.n471 17.0005
R232 VSS.n474 VSS.n460 17.0005
R233 VSS.n474 VSS.n470 17.0005
R234 VSS.n474 VSS.n461 17.0005
R235 VSS.n474 VSS.n469 17.0005
R236 VSS.n474 VSS.n462 17.0005
R237 VSS.n474 VSS.n468 17.0005
R238 VSS.n474 VSS.n463 17.0005
R239 VSS.n474 VSS.n467 17.0005
R240 VSS.n474 VSS.n464 17.0005
R241 VSS.n474 VSS.n466 17.0005
R242 VSS.n474 VSS.n465 17.0005
R243 VSS.n508 VSS.n507 17.0005
R244 VSS.n509 VSS.n508 17.0005
R245 VSS.n508 VSS.n130 17.0005
R246 VSS.n508 VSS.n128 17.0005
R247 VSS.n508 VSS.n129 17.0005
R248 VSS.n58 VSS.n57 0.790948
R249 VSS.n31 VSS.n510 17.0005
R250 VSS.n31 VSS.n61 17.0005
R251 VSS.n31 VSS.n80 17.0005
R252 VSS.n31 VSS.n62 17.0005
R253 VSS.n31 VSS.n79 17.0005
R254 VSS.n31 VSS.n63 17.0005
R255 VSS.n31 VSS.n78 17.0005
R256 VSS.n31 VSS.n64 17.0005
R257 VSS.n31 VSS.n77 17.0005
R258 VSS.n31 VSS.n65 17.0005
R259 VSS.n31 VSS.n76 17.0005
R260 VSS.n31 VSS.n66 17.0005
R261 VSS.n31 VSS.n75 17.0005
R262 VSS.n31 VSS.n67 17.0005
R263 VSS.n31 VSS.n74 17.0005
R264 VSS.n31 VSS.n68 17.0005
R265 VSS.n31 VSS.n73 17.0005
R266 VSS.n31 VSS.n70 17.0005
R267 VSS.n508 VSS.n131 17.0005
R268 VSS.n508 VSS.n481 17.0005
R269 VSS.n508 VSS.n482 17.0005
R270 VSS.n508 VSS.n483 17.0005
R271 VSS.n508 VSS.n484 17.0005
R272 VSS.n508 VSS.n485 17.0005
R273 VSS.n508 VSS.n486 17.0005
R274 VSS.n508 VSS.n487 17.0005
R275 VSS.n508 VSS.n488 17.0005
R276 VSS.n508 VSS.n489 17.0005
R277 VSS.n508 VSS.n490 17.0005
R278 VSS.n508 VSS.n491 17.0005
R279 VSS.n508 VSS.n492 17.0005
R280 VSS.n508 VSS.n493 17.0005
R281 VSS.n508 VSS.n494 17.0005
R282 VSS.n508 VSS.n495 17.0005
R283 VSS.n508 VSS.n496 17.0005
R284 VSS.n508 VSS.n497 17.0005
R285 VSS.n508 VSS.n498 17.0005
R286 VSS.n508 VSS.n499 17.0005
R287 VSS.n508 VSS.n500 17.0005
R288 VSS.n508 VSS.n501 17.0005
R289 VSS.n508 VSS.n502 17.0005
R290 VSS.n508 VSS.n503 17.0005
R291 VSS.n508 VSS.n504 17.0005
R292 VSS.n31 VSS.n81 17.0005
R293 VSS.n31 VSS.n103 17.0005
R294 VSS.n31 VSS.n104 17.0005
R295 VSS.n31 VSS.n105 17.0005
R296 VSS.n31 VSS.n106 17.0005
R297 VSS.n31 VSS.n107 17.0005
R298 VSS.n31 VSS.n108 17.0005
R299 VSS.n31 VSS.n109 17.0005
R300 VSS.n31 VSS.n110 17.0005
R301 VSS.n31 VSS.n111 17.0005
R302 VSS.n31 VSS.n112 17.0005
R303 VSS.n31 VSS.n113 17.0005
R304 VSS.n31 VSS.n114 17.0005
R305 VSS.n31 VSS.n115 17.0005
R306 VSS.n31 VSS.n116 17.0005
R307 VSS.n31 VSS.n117 17.0005
R308 VSS.n31 VSS.n118 17.0005
R309 VSS.n31 VSS.n119 17.0005
R310 VSS.n31 VSS.n120 17.0005
R311 VSS.n31 VSS.n121 17.0005
R312 VSS.n31 VSS.n122 17.0005
R313 VSS.n31 VSS.n123 17.0005
R314 VSS.n31 VSS.n124 17.0005
R315 VSS.n31 VSS.n125 17.0005
R316 VSS.n31 VSS.n126 17.0005
R317 VSS.n31 VSS.n127 17.0005
R318 VSS.n477 VSS.n476 17.0005
R319 VSS.n477 VSS.n137 17.0005
R320 VSS.n477 VSS.n150 17.0005
R321 VSS.n477 VSS.n138 17.0005
R322 VSS.n477 VSS.n149 17.0005
R323 VSS.n477 VSS.n139 17.0005
R324 VSS.n477 VSS.n148 17.0005
R325 VSS.n477 VSS.n140 17.0005
R326 VSS.n477 VSS.n147 17.0005
R327 VSS.n477 VSS.n141 17.0005
R328 VSS.n477 VSS.n146 17.0005
R329 VSS.n477 VSS.n142 17.0005
R330 VSS.n477 VSS.n145 17.0005
R331 VSS.n478 VSS.n477 17.0005
R332 VSS.n477 VSS.n144 17.0005
R333 VSS.n477 VSS.n143 17.0005
R334 VSS.n508 VSS.n480 17.0005
R335 VSS.n508 VSS.n135 17.0005
R336 VSS.n508 VSS.n134 17.0005
R337 VSS.n508 VSS.n133 17.0005
R338 VSS.n508 VSS.n132 17.0005
R339 VSS.n31 VSS.n102 17.0005
R340 VSS.n31 VSS.n98 17.0005
R341 VSS.n31 VSS.n97 17.0005
R342 VSS.n31 VSS.n96 17.0005
R343 VSS.n31 VSS.n95 17.0005
R344 VSS.n31 VSS.n94 17.0005
R345 VSS.n31 VSS.n93 17.0005
R346 VSS.n31 VSS.n92 17.0005
R347 VSS.n31 VSS.n91 17.0005
R348 VSS.n31 VSS.n90 17.0005
R349 VSS.n31 VSS.n89 17.0005
R350 VSS.n31 VSS.n88 17.0005
R351 VSS.n31 VSS.n87 17.0005
R352 VSS.n31 VSS.n86 17.0005
R353 VSS.n31 VSS.n85 17.0005
R354 VSS.n31 VSS.n84 17.0005
R355 VSS.n31 VSS.n83 17.0005
R356 VSS.n31 VSS.n82 17.0005
R357 VSS.n421 VSS.n276 16.9166
R358 VSS.n454 VSS.n160 16.9166
R359 VSS.n455 VSS.n161 16.9166
R360 VSS.n403 VSS.n151 16.9166
R361 VSS.n188 VSS.n159 16.9166
R362 VSS.n404 VSS.n152 16.9166
R363 VSS.n187 VSS.n158 16.9166
R364 VSS.n405 VSS.n153 16.9166
R365 VSS.n406 VSS.n154 16.9166
R366 VSS.n185 VSS.n156 16.9166
R367 VSS.n408 VSS.n155 16.9166
R368 VSS.n4 VSS.t102 16.4809
R369 VSS.n37 VSS.t106 16.4809
R370 VSS.n72 VSS.t114 15.6019
R371 VSS.t151 VSS.n99 15.6019
R372 VSS.n101 VSS.t153 14.4834
R373 VSS.n71 VSS.t112 14.4827
R374 VSS.t112 VSS.n69 12.9739
R375 VSS.t153 VSS.n100 12.9739
R376 VSS.n182 VSS.n181 12.8307
R377 VSS.n175 VSS.n174 12.8307
R378 VSS.n447 VSS.n446 12.8307
R379 VSS.t110 VSS.n70 12.4533
R380 VSS.n102 VSS.t154 12.4533
R381 VSS.n504 VSS.n127 12.3761
R382 VSS.n503 VSS.n126 12.3761
R383 VSS.n503 VSS.n125 12.3761
R384 VSS.n502 VSS.n124 12.3761
R385 VSS.n500 VSS.n123 12.3761
R386 VSS.n500 VSS.n122 12.3761
R387 VSS.n499 VSS.n121 12.3761
R388 VSS.n497 VSS.n120 12.3761
R389 VSS.n497 VSS.n119 12.3761
R390 VSS.n496 VSS.n119 12.3761
R391 VSS.n495 VSS.n118 12.3761
R392 VSS.n495 VSS.n117 12.3761
R393 VSS.n494 VSS.n117 12.3761
R394 VSS.n494 VSS.n116 12.3761
R395 VSS.n493 VSS.n115 12.3761
R396 VSS.n492 VSS.n115 12.3761
R397 VSS.n492 VSS.n114 12.3761
R398 VSS.n491 VSS.n114 12.3761
R399 VSS.n490 VSS.n113 12.3761
R400 VSS.n490 VSS.n112 12.3761
R401 VSS.n489 VSS.n112 12.3761
R402 VSS.n489 VSS.n111 12.3761
R403 VSS.n488 VSS.n110 12.3761
R404 VSS.n487 VSS.n110 12.3761
R405 VSS.n487 VSS.n109 12.3761
R406 VSS.n485 VSS.n108 12.3761
R407 VSS.n484 VSS.n107 12.3761
R408 VSS.n484 VSS.n106 12.3761
R409 VSS.n482 VSS.n105 12.3761
R410 VSS.n481 VSS.n104 12.3761
R411 VSS.n481 VSS.n103 12.3761
R412 VSS.n131 VSS.n81 12.3761
R413 VSS.t9 VSS.n440 12.076
R414 VSS.n322 VSS.t3 11.7116
R415 VSS.n498 VSS.t131 11.6482
R416 VSS.n486 VSS.t138 11.6482
R417 VSS.n457 VSS.n52 11.5239
R418 VSS.t88 VSS.n429 11.3213
R419 VSS.n422 VSS.n410 11.061
R420 VSS.t118 VSS.n124 10.9202
R421 VSS.t127 VSS.n105 10.9202
R422 VSS.t3 VSS.n218 10.4104
R423 VSS.n186 VSS.t7 10.4104
R424 VSS.t97 VSS.n125 9.82821
R425 VSS.n501 VSS.t98 9.82821
R426 VSS.t99 VSS.n122 9.82821
R427 VSS.n498 VSS.t100 9.82821
R428 VSS.n486 VSS.t33 9.82821
R429 VSS.t34 VSS.n107 9.82821
R430 VSS.n483 VSS.t35 9.82821
R431 VSS.t36 VSS.n104 9.82821
R432 VSS.n297 VSS.n59 9.76416
R433 VSS.n412 VSS.t158 9.50586
R434 VSS.t132 VSS.n118 9.46422
R435 VSS.t135 VSS.n111 9.46422
R436 VSS.n51 VSS.n59 9.47095
R437 VSS.n100 VSS.t151 9.19965
R438 VSS.t114 VSS.n69 9.19965
R439 VSS.n465 VSS.n72 9.18684
R440 VSS.n476 VSS.n99 9.18684
R441 VSS.n506 VSS.n127 9.10023
R442 VSS.n505 VSS.n81 9.10023
R443 VSS.n511 VSS.n36 9.0005
R444 VSS.n32 VSS.n56 9.0005
R445 VSS.n504 VSS.t125 8.73624
R446 VSS.n131 VSS.t139 8.73624
R447 VSS.n453 VSS.n449 8.5005
R448 VSS.n453 VSS.n169 8.5005
R449 VSS.n453 VSS.n447 8.5005
R450 VSS.n453 VSS.n175 8.5005
R451 VSS.n453 VSS.n430 8.5005
R452 VSS.n453 VSS.n181 8.5005
R453 VSS.n168 VSS.n162 8.5005
R454 VSS.n440 VSS.n162 8.5005
R455 VSS.n174 VSS.n162 8.5005
R456 VSS.n182 VSS.n162 8.5005
R457 VSS.n446 VSS.n162 8.5005
R458 VSS.n441 VSS.n162 8.5005
R459 VSS.n429 VSS.n162 8.5005
R460 VSS.n423 VSS.n162 8.5005
R461 VSS.n453 VSS.t5 8.5005
R462 VSS.n453 VSS.n410 8.5005
R463 VSS.n453 VSS.n184 8.5005
R464 VSS.n453 VSS.n408 8.5005
R465 VSS.n453 VSS.n185 8.5005
R466 VSS.n453 VSS.n406 8.5005
R467 VSS.n453 VSS.n186 8.5005
R468 VSS.n453 VSS.n405 8.5005
R469 VSS.n453 VSS.n187 8.5005
R470 VSS.n453 VSS.n404 8.5005
R471 VSS.n453 VSS.n188 8.5005
R472 VSS.n453 VSS.n403 8.5005
R473 VSS.n453 VSS.n161 8.5005
R474 VSS.n454 VSS.n453 8.5005
R475 VSS.n453 VSS.n189 8.5005
R476 VSS.n453 VSS.n402 8.5005
R477 VSS.n453 VSS.n190 8.5005
R478 VSS.n453 VSS.n399 8.5005
R479 VSS.n453 VSS.n191 8.5005
R480 VSS.n453 VSS.n396 8.5005
R481 VSS.n453 VSS.n192 8.5005
R482 VSS.n453 VSS.n393 8.5005
R483 VSS.n453 VSS.n195 8.5005
R484 VSS.n453 VSS.n390 8.5005
R485 VSS.n453 VSS.n196 8.5005
R486 VSS.n453 VSS.n387 8.5005
R487 VSS.n453 VSS.n197 8.5005
R488 VSS.n453 VSS.n384 8.5005
R489 VSS.n453 VSS.n198 8.5005
R490 VSS.n453 VSS.n381 8.5005
R491 VSS.n453 VSS.n199 8.5005
R492 VSS.n453 VSS.n378 8.5005
R493 VSS.n453 VSS.n200 8.5005
R494 VSS.n453 VSS.n375 8.5005
R495 VSS.n453 VSS.n201 8.5005
R496 VSS.n453 VSS.n372 8.5005
R497 VSS.n453 VSS.n202 8.5005
R498 VSS.n453 VSS.n203 8.5005
R499 VSS.n453 VSS.n367 8.5005
R500 VSS.n453 VSS.n204 8.5005
R501 VSS.n453 VSS.n364 8.5005
R502 VSS.n453 VSS.n205 8.5005
R503 VSS.n453 VSS.n361 8.5005
R504 VSS.n453 VSS.n206 8.5005
R505 VSS.n453 VSS.n358 8.5005
R506 VSS.n453 VSS.n207 8.5005
R507 VSS.n453 VSS.n355 8.5005
R508 VSS.n453 VSS.n208 8.5005
R509 VSS.n453 VSS.n352 8.5005
R510 VSS.n453 VSS.n209 8.5005
R511 VSS.n453 VSS.n349 8.5005
R512 VSS.n453 VSS.n210 8.5005
R513 VSS.n453 VSS.n343 8.5005
R514 VSS.n453 VSS.n211 8.5005
R515 VSS.n453 VSS.n340 8.5005
R516 VSS.n453 VSS.n212 8.5005
R517 VSS.n453 VSS.n337 8.5005
R518 VSS.n453 VSS.n213 8.5005
R519 VSS.n453 VSS.n334 8.5005
R520 VSS.n453 VSS.n214 8.5005
R521 VSS.n453 VSS.n331 8.5005
R522 VSS.n453 VSS.n215 8.5005
R523 VSS.n453 VSS.n328 8.5005
R524 VSS.n453 VSS.n216 8.5005
R525 VSS.n453 VSS.n325 8.5005
R526 VSS.n453 VSS.n217 8.5005
R527 VSS.n453 VSS.n322 8.5005
R528 VSS.n453 VSS.n218 8.5005
R529 VSS.n453 VSS.n320 8.5005
R530 VSS.n453 VSS.n219 8.5005
R531 VSS.n453 VSS.n317 8.5005
R532 VSS.n453 VSS.n220 8.5005
R533 VSS.n453 VSS.n314 8.5005
R534 VSS.n453 VSS.n221 8.5005
R535 VSS.n453 VSS.n311 8.5005
R536 VSS.n453 VSS.n222 8.5005
R537 VSS.n453 VSS.n308 8.5005
R538 VSS.n453 VSS.n223 8.5005
R539 VSS.n453 VSS.n305 8.5005
R540 VSS.n453 VSS.n224 8.5005
R541 VSS.n453 VSS.n302 8.5005
R542 VSS.n453 VSS.n225 8.5005
R543 VSS.n453 VSS.n285 8.5005
R544 VSS.n453 VSS.n226 8.5005
R545 VSS.n453 VSS.n282 8.5005
R546 VSS.n453 VSS.n227 8.5005
R547 VSS.n453 VSS.n279 8.5005
R548 VSS.n453 VSS.n228 8.5005
R549 VSS.n453 VSS.n276 8.5005
R550 VSS.n453 VSS.n229 8.5005
R551 VSS.n453 VSS.n274 8.5005
R552 VSS.n453 VSS.n230 8.5005
R553 VSS.n453 VSS.n271 8.5005
R554 VSS.n453 VSS.n231 8.5005
R555 VSS.n453 VSS.n268 8.5005
R556 VSS.n453 VSS.n232 8.5005
R557 VSS.n453 VSS.n265 8.5005
R558 VSS.n453 VSS.n233 8.5005
R559 VSS.n453 VSS.n262 8.5005
R560 VSS.n453 VSS.n234 8.5005
R561 VSS.n453 VSS.n260 8.5005
R562 VSS.n453 VSS.n235 8.5005
R563 VSS.n453 VSS.n257 8.5005
R564 VSS.n453 VSS.n236 8.5005
R565 VSS.n453 VSS.n254 8.5005
R566 VSS.n453 VSS.n237 8.5005
R567 VSS.n453 VSS.n251 8.5005
R568 VSS.n453 VSS.n238 8.5005
R569 VSS.n453 VSS.n248 8.5005
R570 VSS.n453 VSS.n239 8.5005
R571 VSS.n453 VSS.n245 8.5005
R572 VSS.n453 VSS.n240 8.5005
R573 VSS.n453 VSS.n242 8.5005
R574 VSS.n185 VSS.n162 8.5005
R575 VSS.n406 VSS.n162 8.5005
R576 VSS.n186 VSS.n162 8.5005
R577 VSS.n405 VSS.n162 8.5005
R578 VSS.n187 VSS.n162 8.5005
R579 VSS.n404 VSS.n162 8.5005
R580 VSS.n188 VSS.n162 8.5005
R581 VSS.n403 VSS.n162 8.5005
R582 VSS.n162 VSS.n161 8.5005
R583 VSS.n454 VSS.n162 8.5005
R584 VSS.n466 VSS.n68 8.30239
R585 VSS.n467 VSS.n67 8.30239
R586 VSS.n463 VSS.n75 8.30239
R587 VSS.n462 VSS.n76 8.30239
R588 VSS.n469 VSS.n65 8.30239
R589 VSS.n460 VSS.n78 8.30239
R590 VSS.n146 VSS.n88 8.30239
R591 VSS.n140 VSS.n91 8.30239
R592 VSS.n148 VSS.n92 8.30239
R593 VSS.n149 VSS.n94 8.30239
R594 VSS.n138 VSS.n95 8.30239
R595 VSS.n137 VSS.n97 8.30239
R596 VSS.n409 VSS.n184 7.89854
R597 VSS.n402 VSS.n400 7.89854
R598 VSS.n328 VSS.n326 7.89854
R599 VSS.n320 VSS.n318 7.89854
R600 VSS.n275 VSS.n229 7.89854
R601 VSS.n261 VSS.n234 7.89854
R602 VSS.n407 VSS.n184 7.89788
R603 VSS.n329 VSS.n214 7.89788
R604 VSS.n321 VSS.n217 7.89788
R605 VSS.n279 VSS.n278 7.89788
R606 VSS.n265 VSS.n264 7.89788
R607 VSS.n241 VSS.n240 7.89788
R608 VSS.n298 VSS.n297 7.76695
R609 VSS.n71 VSS.t110 7.69091
R610 VSS.t154 VSS.n101 7.69022
R611 VSS.t46 VSS.n168 7.54767
R612 VSS.n164 VSS.n163 7.31333
R613 VSS.n166 VSS.n165 7.31333
R614 VSS.n171 VSS.n170 7.31333
R615 VSS.n437 VSS.n176 7.31333
R616 VSS.n434 VSS.n432 7.31333
R617 VSS.n431 VSS.n177 7.31333
R618 VSS.n180 VSS.n179 7.31333
R619 VSS.n427 VSS.n426 7.31333
R620 VSS.n426 VSS.n424 7.31333
R621 VSS.n427 VSS.n425 7.31333
R622 VSS.n425 VSS.n183 7.31333
R623 VSS.n428 VSS.n177 7.31333
R624 VSS.n432 VSS.n431 7.31333
R625 VSS.n435 VSS.n434 7.31333
R626 VSS.n435 VSS.n433 7.31333
R627 VSS.n433 VSS.n176 7.31333
R628 VSS.n438 VSS.n437 7.31333
R629 VSS.n438 VSS.n436 7.31333
R630 VSS.n439 VSS.n173 7.31333
R631 VSS.n442 VSS.n439 7.31333
R632 VSS.n172 VSS.n171 7.31333
R633 VSS.n443 VSS.n170 7.31333
R634 VSS.n444 VSS.n443 7.31333
R635 VSS.n167 VSS.n166 7.31333
R636 VSS.n165 VSS.n164 7.31333
R637 VSS.n448 VSS.n163 7.31333
R638 VSS.n493 VSS.t134 7.28029
R639 VSS.n491 VSS.t137 7.28029
R640 VSS.n470 VSS.t90 6.98163
R641 VSS.n459 VSS.t92 6.98163
R642 VSS.n145 VSS.t41 6.98163
R643 VSS.n141 VSS.t43 6.98163
R644 VSS.n402 VSS.n401 6.70183
R645 VSS.n397 VSS.n190 6.70183
R646 VSS.n399 VSS.n398 6.70183
R647 VSS.n394 VSS.n191 6.70183
R648 VSS.n396 VSS.n395 6.70183
R649 VSS.n391 VSS.n192 6.70183
R650 VSS.n393 VSS.n392 6.70183
R651 VSS.n388 VSS.n195 6.70183
R652 VSS.n390 VSS.n389 6.70183
R653 VSS.n385 VSS.n196 6.70183
R654 VSS.n387 VSS.n386 6.70183
R655 VSS.n382 VSS.n197 6.70183
R656 VSS.n384 VSS.n383 6.70183
R657 VSS.n379 VSS.n198 6.70183
R658 VSS.n381 VSS.n380 6.70183
R659 VSS.n376 VSS.n199 6.70183
R660 VSS.n378 VSS.n377 6.70183
R661 VSS.n373 VSS.n200 6.70183
R662 VSS.n375 VSS.n374 6.70183
R663 VSS.n370 VSS.n201 6.70183
R664 VSS.n372 VSS.n371 6.70183
R665 VSS.n368 VSS.n202 6.70183
R666 VSS.n365 VSS.n203 6.70183
R667 VSS.n367 VSS.n366 6.70183
R668 VSS.n362 VSS.n204 6.70183
R669 VSS.n364 VSS.n363 6.70183
R670 VSS.n359 VSS.n205 6.70183
R671 VSS.n361 VSS.n360 6.70183
R672 VSS.n356 VSS.n206 6.70183
R673 VSS.n358 VSS.n357 6.70183
R674 VSS.n353 VSS.n207 6.70183
R675 VSS.n355 VSS.n354 6.70183
R676 VSS.n350 VSS.n208 6.70183
R677 VSS.n352 VSS.n351 6.70183
R678 VSS.n347 VSS.n209 6.70183
R679 VSS.n349 VSS.n348 6.70183
R680 VSS.n341 VSS.n210 6.70183
R681 VSS.n343 VSS.n342 6.70183
R682 VSS.n338 VSS.n211 6.70183
R683 VSS.n340 VSS.n339 6.70183
R684 VSS.n335 VSS.n212 6.70183
R685 VSS.n337 VSS.n336 6.70183
R686 VSS.n332 VSS.n213 6.70183
R687 VSS.n334 VSS.n333 6.70183
R688 VSS.n328 VSS.n327 6.70183
R689 VSS.n323 VSS.n216 6.70183
R690 VSS.n325 VSS.n324 6.70183
R691 VSS.n320 VSS.n319 6.70183
R692 VSS.n315 VSS.n219 6.70183
R693 VSS.n317 VSS.n316 6.70183
R694 VSS.n312 VSS.n220 6.70183
R695 VSS.n314 VSS.n313 6.70183
R696 VSS.n309 VSS.n221 6.70183
R697 VSS.n311 VSS.n310 6.70183
R698 VSS.n306 VSS.n222 6.70183
R699 VSS.n308 VSS.n307 6.70183
R700 VSS.n303 VSS.n223 6.70183
R701 VSS.n305 VSS.n304 6.70183
R702 VSS.n300 VSS.n224 6.70183
R703 VSS.n302 VSS.n301 6.70183
R704 VSS.n283 VSS.n225 6.70183
R705 VSS.n285 VSS.n284 6.70183
R706 VSS.n280 VSS.n226 6.70183
R707 VSS.n282 VSS.n281 6.70183
R708 VSS.n277 VSS.n227 6.70183
R709 VSS.n272 VSS.n229 6.70183
R710 VSS.n274 VSS.n273 6.70183
R711 VSS.n269 VSS.n230 6.70183
R712 VSS.n271 VSS.n270 6.70183
R713 VSS.n266 VSS.n231 6.70183
R714 VSS.n268 VSS.n267 6.70183
R715 VSS.n263 VSS.n232 6.70183
R716 VSS.n258 VSS.n234 6.70183
R717 VSS.n260 VSS.n259 6.70183
R718 VSS.n255 VSS.n235 6.70183
R719 VSS.n257 VSS.n256 6.70183
R720 VSS.n252 VSS.n236 6.70183
R721 VSS.n254 VSS.n253 6.70183
R722 VSS.n249 VSS.n237 6.70183
R723 VSS.n251 VSS.n250 6.70183
R724 VSS.n246 VSS.n238 6.70183
R725 VSS.n248 VSS.n247 6.70183
R726 VSS.n243 VSS.n239 6.70183
R727 VSS.n245 VSS.n244 6.70183
R728 VSS.t5 VSS.n369 6.70183
R729 VSS.n244 VSS.n240 6.70183
R730 VSS.n245 VSS.n243 6.70183
R731 VSS.n247 VSS.n239 6.70183
R732 VSS.n248 VSS.n246 6.70183
R733 VSS.n250 VSS.n238 6.70183
R734 VSS.n251 VSS.n249 6.70183
R735 VSS.n253 VSS.n237 6.70183
R736 VSS.n254 VSS.n252 6.70183
R737 VSS.n256 VSS.n236 6.70183
R738 VSS.n257 VSS.n255 6.70183
R739 VSS.n259 VSS.n235 6.70183
R740 VSS.n260 VSS.n258 6.70183
R741 VSS.n265 VSS.n263 6.70183
R742 VSS.n267 VSS.n232 6.70183
R743 VSS.n268 VSS.n266 6.70183
R744 VSS.n270 VSS.n231 6.70183
R745 VSS.n271 VSS.n269 6.70183
R746 VSS.n273 VSS.n230 6.70183
R747 VSS.n274 VSS.n272 6.70183
R748 VSS.n279 VSS.n277 6.70183
R749 VSS.n281 VSS.n227 6.70183
R750 VSS.n282 VSS.n280 6.70183
R751 VSS.n284 VSS.n226 6.70183
R752 VSS.n285 VSS.n283 6.70183
R753 VSS.n301 VSS.n225 6.70183
R754 VSS.n302 VSS.n300 6.70183
R755 VSS.n304 VSS.n224 6.70183
R756 VSS.n305 VSS.n303 6.70183
R757 VSS.n307 VSS.n223 6.70183
R758 VSS.n308 VSS.n306 6.70183
R759 VSS.n310 VSS.n222 6.70183
R760 VSS.n311 VSS.n309 6.70183
R761 VSS.n313 VSS.n221 6.70183
R762 VSS.n314 VSS.n312 6.70183
R763 VSS.n316 VSS.n220 6.70183
R764 VSS.n317 VSS.n315 6.70183
R765 VSS.n319 VSS.n219 6.70183
R766 VSS.n324 VSS.n217 6.70183
R767 VSS.n325 VSS.n323 6.70183
R768 VSS.n327 VSS.n216 6.70183
R769 VSS.n333 VSS.n214 6.70183
R770 VSS.n334 VSS.n332 6.70183
R771 VSS.n336 VSS.n213 6.70183
R772 VSS.n337 VSS.n335 6.70183
R773 VSS.n339 VSS.n212 6.70183
R774 VSS.n340 VSS.n338 6.70183
R775 VSS.n342 VSS.n211 6.70183
R776 VSS.n343 VSS.n341 6.70183
R777 VSS.n348 VSS.n210 6.70183
R778 VSS.n349 VSS.n347 6.70183
R779 VSS.n351 VSS.n209 6.70183
R780 VSS.n352 VSS.n350 6.70183
R781 VSS.n354 VSS.n208 6.70183
R782 VSS.n355 VSS.n353 6.70183
R783 VSS.n357 VSS.n207 6.70183
R784 VSS.n358 VSS.n356 6.70183
R785 VSS.n360 VSS.n206 6.70183
R786 VSS.n361 VSS.n359 6.70183
R787 VSS.n363 VSS.n205 6.70183
R788 VSS.n364 VSS.n362 6.70183
R789 VSS.n366 VSS.n204 6.70183
R790 VSS.n367 VSS.n365 6.70183
R791 VSS.n369 VSS.n203 6.70183
R792 VSS.t5 VSS.n368 6.70183
R793 VSS.n371 VSS.n202 6.70183
R794 VSS.n372 VSS.n370 6.70183
R795 VSS.n374 VSS.n201 6.70183
R796 VSS.n375 VSS.n373 6.70183
R797 VSS.n377 VSS.n200 6.70183
R798 VSS.n378 VSS.n376 6.70183
R799 VSS.n380 VSS.n199 6.70183
R800 VSS.n381 VSS.n379 6.70183
R801 VSS.n383 VSS.n198 6.70183
R802 VSS.n384 VSS.n382 6.70183
R803 VSS.n386 VSS.n197 6.70183
R804 VSS.n387 VSS.n385 6.70183
R805 VSS.n389 VSS.n196 6.70183
R806 VSS.n390 VSS.n388 6.70183
R807 VSS.n392 VSS.n195 6.70183
R808 VSS.n393 VSS.n391 6.70183
R809 VSS.n395 VSS.n192 6.70183
R810 VSS.n396 VSS.n394 6.70183
R811 VSS.n398 VSS.n191 6.70183
R812 VSS.n399 VSS.n397 6.70183
R813 VSS.n401 VSS.n190 6.70183
R814 VSS.t7 VSS.n157 6.50668
R815 VSS.n423 VSS.n422 6.41559
R816 VSS.n510 VSS.n509 6.41559
R817 VSS.n133 VSS.n82 6.41559
R818 VSS.n31 VSS.n72 6.17223
R819 VSS.n31 VSS.n99 6.17223
R820 VSS.n416 VSS.t18 6.07511
R821 VSS.n1 VSS.t32 6.07511
R822 VSS.n411 VSS.t156 5.92636
R823 VSS.n456 VSS.n455 5.66717
R824 VSS.n456 VSS.n151 5.66717
R825 VSS.n456 VSS.n159 5.66717
R826 VSS.n456 VSS.n152 5.66717
R827 VSS.n456 VSS.n158 5.66717
R828 VSS.n456 VSS.n153 5.66717
R829 VSS.n456 VSS.n157 5.66717
R830 VSS.n456 VSS.n154 5.66717
R831 VSS.n456 VSS.n156 5.66717
R832 VSS.n456 VSS.n155 5.66717
R833 VSS.n456 VSS.n160 5.66717
R834 VSS.n37 VSS.t109 3.20134
R835 VSS.n5 VSS.n48 0.0750609
R836 VSS.n474 VSS.n43 5.65086
R837 VSS.n53 VSS.n42 0.0974311
R838 VSS.n474 VSS.n42 2.80696
R839 VSS.n11 VSS.n40 0.066765
R840 VSS.n46 VSS.n47 0.0585658
R841 VSS.n477 VSS.n46 2.7974
R842 VSS.n15 VSS.n45 0.066765
R843 VSS.n477 VSS.n39 5.65086
R844 VSS.n169 VSS.t46 5.28352
R845 VSS.n421 VSS.n228 5.20544
R846 VSS.n189 VSS.n160 5.20544
R847 VSS.n455 VSS.n454 5.20544
R848 VSS.n161 VSS.n151 5.20544
R849 VSS.n403 VSS.n159 5.20544
R850 VSS.n188 VSS.n152 5.20544
R851 VSS.n404 VSS.n158 5.20544
R852 VSS.n187 VSS.n153 5.20544
R853 VSS.n405 VSS.n157 5.20544
R854 VSS.n186 VSS.n154 5.20544
R855 VSS.n406 VSS.n156 5.20544
R856 VSS.n185 VSS.n155 5.20544
R857 VSS.n368 VSS.n162 5.15059
R858 VSS.n401 VSS.n162 5.15059
R859 VSS.n397 VSS.n162 5.15059
R860 VSS.n398 VSS.n162 5.15059
R861 VSS.n394 VSS.n162 5.15059
R862 VSS.n395 VSS.n162 5.15059
R863 VSS.n391 VSS.n162 5.15059
R864 VSS.n392 VSS.n162 5.15059
R865 VSS.n388 VSS.n162 5.15059
R866 VSS.n389 VSS.n162 5.15059
R867 VSS.n385 VSS.n162 5.15059
R868 VSS.n386 VSS.n162 5.15059
R869 VSS.n382 VSS.n162 5.15059
R870 VSS.n383 VSS.n162 5.15059
R871 VSS.n379 VSS.n162 5.15059
R872 VSS.n380 VSS.n162 5.15059
R873 VSS.n376 VSS.n162 5.15059
R874 VSS.n377 VSS.n162 5.15059
R875 VSS.n373 VSS.n162 5.15059
R876 VSS.n374 VSS.n162 5.15059
R877 VSS.n370 VSS.n162 5.15059
R878 VSS.n371 VSS.n162 5.15059
R879 VSS.n369 VSS.n162 5.15059
R880 VSS.n365 VSS.n162 5.15059
R881 VSS.n366 VSS.n162 5.15059
R882 VSS.n362 VSS.n162 5.15059
R883 VSS.n363 VSS.n162 5.15059
R884 VSS.n359 VSS.n162 5.15059
R885 VSS.n360 VSS.n162 5.15059
R886 VSS.n356 VSS.n162 5.15059
R887 VSS.n357 VSS.n162 5.15059
R888 VSS.n353 VSS.n162 5.15059
R889 VSS.n354 VSS.n162 5.15059
R890 VSS.n350 VSS.n162 5.15059
R891 VSS.n351 VSS.n162 5.15059
R892 VSS.n347 VSS.n162 5.15059
R893 VSS.n348 VSS.n162 5.15059
R894 VSS.n341 VSS.n162 5.15059
R895 VSS.n342 VSS.n162 5.15059
R896 VSS.n338 VSS.n162 5.15059
R897 VSS.n339 VSS.n162 5.15059
R898 VSS.n335 VSS.n162 5.15059
R899 VSS.n336 VSS.n162 5.15059
R900 VSS.n332 VSS.n162 5.15059
R901 VSS.n333 VSS.n162 5.15059
R902 VSS.n327 VSS.n162 5.15059
R903 VSS.n323 VSS.n162 5.15059
R904 VSS.n324 VSS.n162 5.15059
R905 VSS.n319 VSS.n162 5.15059
R906 VSS.n315 VSS.n162 5.15059
R907 VSS.n316 VSS.n162 5.15059
R908 VSS.n312 VSS.n162 5.15059
R909 VSS.n313 VSS.n162 5.15059
R910 VSS.n309 VSS.n162 5.15059
R911 VSS.n310 VSS.n162 5.15059
R912 VSS.n306 VSS.n162 5.15059
R913 VSS.n307 VSS.n162 5.15059
R914 VSS.n303 VSS.n162 5.15059
R915 VSS.n304 VSS.n162 5.15059
R916 VSS.n300 VSS.n162 5.15059
R917 VSS.n301 VSS.n162 5.15059
R918 VSS.n283 VSS.n162 5.15059
R919 VSS.n284 VSS.n162 5.15059
R920 VSS.n280 VSS.n162 5.15059
R921 VSS.n281 VSS.n162 5.15059
R922 VSS.n277 VSS.n162 5.15059
R923 VSS.n272 VSS.n162 5.15059
R924 VSS.n273 VSS.n162 5.15059
R925 VSS.n269 VSS.n162 5.15059
R926 VSS.n270 VSS.n162 5.15059
R927 VSS.n266 VSS.n162 5.15059
R928 VSS.n267 VSS.n162 5.15059
R929 VSS.n263 VSS.n162 5.15059
R930 VSS.n258 VSS.n162 5.15059
R931 VSS.n259 VSS.n162 5.15059
R932 VSS.n255 VSS.n162 5.15059
R933 VSS.n256 VSS.n162 5.15059
R934 VSS.n252 VSS.n162 5.15059
R935 VSS.n253 VSS.n162 5.15059
R936 VSS.n249 VSS.n162 5.15059
R937 VSS.n250 VSS.n162 5.15059
R938 VSS.n246 VSS.n162 5.15059
R939 VSS.n247 VSS.n162 5.15059
R940 VSS.n243 VSS.n162 5.15059
R941 VSS.n244 VSS.n162 5.15059
R942 VSS.t134 VSS.n116 5.09635
R943 VSS.t137 VSS.n113 5.09635
R944 VSS.t54 VSS.n74 5.09484
R945 VSS.t60 VSS.n77 5.09484
R946 VSS.t63 VSS.n63 5.09484
R947 VSS.t66 VSS.n80 5.09484
R948 VSS.n130 VSS.t94 5.09484
R949 VSS.n510 VSS.t95 5.09484
R950 VSS.t38 VSS.n82 5.09484
R951 VSS.n134 VSS.t39 5.09484
R952 VSS.t68 VSS.n84 5.09484
R953 VSS.t72 VSS.n87 5.09484
R954 VSS.t75 VSS.n90 5.09484
R955 VSS.t81 VSS.n96 5.09484
R956 VSS.n465 VSS.t115 4.90616
R957 VSS.n476 VSS.t150 4.90616
R958 VSS.n47 VSS.n52 4.69693
R959 VSS.n297 VSS.n296 4.67815
R960 VSS.n16 VSS.n20 4.59452
R961 VSS.n464 VSS.n68 4.5288
R962 VSS.n468 VSS.n75 4.5288
R963 VSS.n462 VSS.n66 4.5288
R964 VSS.n461 VSS.n65 4.5288
R965 VSS.n470 VSS.n77 4.5288
R966 VSS.n459 VSS.n63 4.5288
R967 VSS.n458 VSS.n62 4.5288
R968 VSS.n473 VSS.n80 4.5288
R969 VSS.n143 VSS.n84 4.5288
R970 VSS.n144 VSS.n85 4.5288
R971 VSS.n145 VSS.n87 4.5288
R972 VSS.n141 VSS.n90 4.5288
R973 VSS.n147 VSS.n91 4.5288
R974 VSS.n148 VSS.n93 4.5288
R975 VSS.n139 VSS.n94 4.5288
R976 VSS.n150 VSS.n97 4.5288
R977 VSS.n19 VSS.n54 4.5005
R978 VSS.n19 VSS.n475 4.5005
R979 VSS.n18 VSS.n17 2.16985
R980 VSS.n16 VSS.n53 4.5005
R981 VSS.n6 VSS.n38 2.08334
R982 VSS.n6 VSS.n2 1.8585
R983 VSS.n6 VSS.n417 4.23094
R984 VSS.n474 VSS.n11 2.3909
R985 VSS.n477 VSS.n15 2.3909
R986 VSS.t117 VSS.n74 4.15144
R987 VSS.t129 VSS.n62 4.15144
R988 VSS.t142 VSS.n85 4.15144
R989 VSS.t148 VSS.n96 4.15144
R990 VSS.n7 VSS.n6 2.99824
R991 VSS.t57 VSS.t122 3.96276
R992 VSS.t78 VSS.t147 3.96276
R993 VSS.n410 VSS.n409 3.9496
R994 VSS.n400 VSS.n189 3.9496
R995 VSS.n326 VSS.n215 3.9496
R996 VSS.n318 VSS.n218 3.9496
R997 VSS.n276 VSS.n275 3.9496
R998 VSS.n262 VSS.n261 3.9496
R999 VSS.n242 VSS.n241 3.94944
R1000 VSS.n264 VSS.n233 3.94944
R1001 VSS.n278 VSS.n228 3.94944
R1002 VSS.n322 VSS.n321 3.94944
R1003 VSS.n331 VSS.n329 3.94944
R1004 VSS.n408 VSS.n407 3.94944
R1005 VSS.n20 VSS.n456 3.89324
R1006 VSS.n168 VSS.n167 3.65691
R1007 VSS.n446 VSS.n444 3.65691
R1008 VSS.n440 VSS.n172 3.65691
R1009 VSS.n442 VSS.n441 3.65691
R1010 VSS.n174 VSS.n173 3.65691
R1011 VSS.n183 VSS.n182 3.65691
R1012 VSS.n424 VSS.n423 3.65691
R1013 VSS.n447 VSS.n445 3.65691
R1014 VSS.n436 VSS.n175 3.65691
R1015 VSS.n181 VSS.n180 3.65691
R1016 VSS.n429 VSS.n179 3.65691
R1017 VSS.n430 VSS.n428 3.65691
R1018 VSS.n445 VSS.n169 3.65691
R1019 VSS.n449 VSS.n448 3.65691
R1020 VSS.n54 VSS.t71 3.45423
R1021 VSS.n14 VSS.t74 3.45423
R1022 VSS.n45 VSS.t77 3.45423
R1023 VSS.n44 VSS.t80 3.45423
R1024 VSS.n13 VSS.t55 3.45423
R1025 VSS.n40 VSS.t58 3.45423
R1026 VSS.n41 VSS.t61 3.45423
R1027 VSS.n53 VSS.t64 3.45423
R1028 VSS.n39 VSS.t69 3.45313
R1029 VSS.n47 VSS.t83 3.45313
R1030 VSS.n12 VSS.t53 3.45313
R1031 VSS.n43 VSS.t67 3.45313
R1032 VSS.t115 VSS.n73 3.39673
R1033 VSS.n471 VSS.t123 3.39673
R1034 VSS.t130 VSS.n61 3.39673
R1035 VSS.t141 VSS.n83 3.39673
R1036 VSS.n142 VSS.t144 3.39673
R1037 VSS.t150 VSS.n98 3.39673
R1038 VSS.n34 VSS.n31 1.10108
R1039 VSS.n22 VSS.n31 1.67243
R1040 VSS.n30 VSS.n21 0.0776913
R1041 VSS.n25 VSS.n35 0.0463032
R1042 VSS.n35 VSS.n31 0.649869
R1043 VSS.n29 VSS.n28 0.0780044
R1044 VSS.n35 VSS.n36 0.0467982
R1045 VSS.n6 VSS.n5 1.51113
R1046 VSS.n6 VSS.n414 3.37539
R1047 VSS.n466 VSS.t52 3.20805
R1048 VSS.n464 VSS.t54 3.20805
R1049 VSS.n463 VSS.t56 3.20805
R1050 VSS.n468 VSS.t57 3.20805
R1051 VSS.n469 VSS.t59 3.20805
R1052 VSS.n460 VSS.t62 3.20805
R1053 VSS.n472 VSS.t65 3.20805
R1054 VSS.n478 VSS.t70 3.20805
R1055 VSS.n146 VSS.t73 3.20805
R1056 VSS.n140 VSS.t76 3.20805
R1057 VSS.n139 VSS.t78 3.20805
R1058 VSS.n149 VSS.t79 3.20805
R1059 VSS.n150 VSS.t81 3.20805
R1060 VSS.n137 VSS.t82 3.20805
R1061 VSS.n3 VSS.t12 3.14902
R1062 VSS.n4 VSS.t104 3.14902
R1063 VSS.n48 VSS.t105 3.14902
R1064 VSS.n418 VSS.t16 3.14902
R1065 VSS.n420 VSS.t14 3.14902
R1066 VSS.n37 VSS.t108 3.14902
R1067 VSS.n409 VSS.n162 3.03556
R1068 VSS.n400 VSS.n162 3.03556
R1069 VSS.n326 VSS.n162 3.03556
R1070 VSS.n318 VSS.n162 3.03556
R1071 VSS.n275 VSS.n162 3.03556
R1072 VSS.n261 VSS.n162 3.03556
R1073 VSS.n407 VSS.n162 3.03537
R1074 VSS.n329 VSS.n162 3.03537
R1075 VSS.n321 VSS.n162 3.03537
R1076 VSS.n278 VSS.n162 3.03537
R1077 VSS.n264 VSS.n162 3.03537
R1078 VSS.n241 VSS.n162 3.03537
R1079 VSS.n509 VSS.t130 3.01937
R1080 VSS.n133 VSS.t141 3.01937
R1081 VSS.n20 VSS.n457 2.9309
R1082 VSS.n496 VSS.t132 2.91241
R1083 VSS.n488 VSS.t135 2.91241
R1084 VSS.n21 VSS.n31 1.50426
R1085 VSS.n27 VSS.n31 2.81756
R1086 VSS.n31 VSS.n29 1.50387
R1087 VSS.n6 VSS.n419 2.80331
R1088 VSS.n413 VSS.n412 2.69572
R1089 VSS.t91 VSS.t63 2.64201
R1090 VSS.t42 VSS.t72 2.64201
R1091 VSS.n31 VSS.n101 2.58141
R1092 VSS.n31 VSS.n100 2.58141
R1093 VSS.n31 VSS.n69 2.58141
R1094 VSS.n31 VSS.n71 2.58141
R1095 VSS.t96 VSS.n126 2.54843
R1096 VSS.n502 VSS.t97 2.54843
R1097 VSS.t98 VSS.n123 2.54843
R1098 VSS.n499 VSS.t99 2.54843
R1099 VSS.t100 VSS.n120 2.54843
R1100 VSS.t33 VSS.n109 2.54843
R1101 VSS.n485 VSS.t34 2.54843
R1102 VSS.t35 VSS.n106 2.54843
R1103 VSS.n482 VSS.t36 2.54843
R1104 VSS.t37 VSS.n103 2.54843
R1105 VSS.n453 VSS.n163 2.42304
R1106 VSS.n453 VSS.n165 2.42304
R1107 VSS.n453 VSS.n167 2.42304
R1108 VSS.n453 VSS.n444 2.42304
R1109 VSS.n453 VSS.n170 2.42304
R1110 VSS.n453 VSS.n172 2.42304
R1111 VSS.n453 VSS.n442 2.42304
R1112 VSS.n453 VSS.n173 2.42304
R1113 VSS.n453 VSS.n438 2.42304
R1114 VSS.n453 VSS.n176 2.42304
R1115 VSS.n453 VSS.n435 2.42304
R1116 VSS.n453 VSS.n432 2.42304
R1117 VSS.n453 VSS.n177 2.42304
R1118 VSS.n453 VSS.n179 2.42304
R1119 VSS.n453 VSS.n183 2.42304
R1120 VSS.n453 VSS.n427 2.42304
R1121 VSS.n453 VSS.n424 2.42304
R1122 VSS.n448 VSS.n162 2.42304
R1123 VSS.n436 VSS.n162 2.42304
R1124 VSS.n433 VSS.n162 2.42304
R1125 VSS.n428 VSS.n162 2.42304
R1126 VSS.n425 VSS.n162 2.42304
R1127 VSS.n426 VSS.n162 2.42304
R1128 VSS.n164 VSS.n162 2.42304
R1129 VSS.n166 VSS.n162 2.42304
R1130 VSS.n445 VSS.n162 2.42304
R1131 VSS.n443 VSS.n162 2.42304
R1132 VSS.n171 VSS.n162 2.42304
R1133 VSS.n439 VSS.n162 2.42304
R1134 VSS.n437 VSS.n162 2.42304
R1135 VSS.n434 VSS.n162 2.42304
R1136 VSS.n431 VSS.n162 2.42304
R1137 VSS.n180 VSS.n162 2.42304
R1138 VSS.n28 VSS.t155 2.40206
R1139 VSS.n30 VSS.t111 2.40081
R1140 VSS.n30 VSS.t113 2.36054
R1141 VSS.n32 VSS.t124 2.36054
R1142 VSS.n27 VSS.t128 2.3605
R1143 VSS.n23 VSS.t116 2.36048
R1144 VSS.n27 VSS.t136 2.36019
R1145 VSS.n28 VSS.t152 2.36016
R1146 VSS.n26 VSS.t119 2.36001
R1147 VSS.n24 VSS.t149 2.3598
R1148 VSS.n23 VSS.t121 2.35975
R1149 VSS.n36 VSS.t143 2.35968
R1150 VSS.n26 VSS.t133 2.35963
R1151 VSS.n25 VSS.t140 2.35952
R1152 VSS.n33 VSS.t126 2.35951
R1153 VSS.n24 VSS.t146 2.35935
R1154 VSS.n290 VSS.t175 2.21117
R1155 VSS.n294 VSS.t171 2.21093
R1156 VSS.n345 VSS.t4 2.21084
R1157 VSS.n286 VSS.t179 2.21075
R1158 VSS.n344 VSS.t2 2.21072
R1159 VSS.n288 VSS.t177 2.21056
R1160 VSS.n298 VSS.t1 2.21048
R1161 VSS.n292 VSS.t173 2.2104
R1162 VSS.n193 VSS.t6 2.21028
R1163 VSS.n451 VSS.t10 2.21024
R1164 VSS.n296 VSS.t170 2.20952
R1165 VSS.n450 VSS.t8 2.20952
R1166 VSS.n450 VSS.t28 2.20299
R1167 VSS.n292 VSS.t163 2.20297
R1168 VSS.n290 VSS.t165 2.20278
R1169 VSS.n294 VSS.t161 2.20236
R1170 VSS.n344 VSS.t22 2.20233
R1171 VSS.n345 VSS.t24 2.20232
R1172 VSS.n193 VSS.t26 2.20231
R1173 VSS.n288 VSS.t167 2.20192
R1174 VSS.n286 VSS.t169 2.2019
R1175 VSS.n298 VSS.t21 2.20124
R1176 VSS.n451 VSS.t30 2.20119
R1177 VSS.n296 VSS.t160 2.20091
R1178 VSS.n479 VSS.n58 2.18498
R1179 VSS.n136 VSS.t129 2.07597
R1180 VSS.n479 VSS.t142 2.07597
R1181 VSS.n472 VSS.n129 1.88729
R1182 VSS.n473 VSS.n130 1.88729
R1183 VSS.n143 VSS.n134 1.88729
R1184 VSS.n480 VSS.n478 1.88729
R1185 VSS.n507 VSS.n506 1.69861
R1186 VSS.n505 VSS.n132 1.69861
R1187 VSS.n55 VSS.n0 0.766777
R1188 VSS.n0 VSS.n49 0.288546
R1189 VSS VSS.n50 0.189868
R1190 VSS.n51 VSS 0.776964
R1191 VSS.n430 VSS.t88 1.50993
R1192 VSS.n501 VSS.t118 1.45646
R1193 VSS.n483 VSS.t127 1.45646
R1194 VSS.n57 VSS.n136 1.39925
R1195 VSS.t52 VSS.n73 1.32125
R1196 VSS.t56 VSS.n67 1.32125
R1197 VSS.t59 VSS.n76 1.32125
R1198 VSS.t89 VSS.t120 1.32125
R1199 VSS.t120 VSS.t60 1.32125
R1200 VSS.t90 VSS.n64 1.32125
R1201 VSS.t62 VSS.n64 1.32125
R1202 VSS.t92 VSS.n79 1.32125
R1203 VSS.t65 VSS.n79 1.32125
R1204 VSS.t93 VSS.n128 1.32125
R1205 VSS.n128 VSS.t66 1.32125
R1206 VSS.t94 VSS.n61 1.32125
R1207 VSS.n507 VSS.t95 1.32125
R1208 VSS.n132 VSS.t38 1.32125
R1209 VSS.t39 VSS.n83 1.32125
R1210 VSS.n135 VSS.t68 1.32125
R1211 VSS.t40 VSS.n135 1.32125
R1212 VSS.t70 VSS.n86 1.32125
R1213 VSS.t41 VSS.n86 1.32125
R1214 VSS.t73 VSS.n89 1.32125
R1215 VSS.t43 VSS.n89 1.32125
R1216 VSS.t145 VSS.t75 1.32125
R1217 VSS.t44 VSS.t145 1.32125
R1218 VSS.t76 VSS.n92 1.32125
R1219 VSS.t79 VSS.n95 1.32125
R1220 VSS.t82 VSS.n98 1.32125
R1221 VSS.t0 VSS.n233 1.30174
R1222 VSS.t122 VSS.n66 1.13258
R1223 VSS.t123 VSS.n78 1.13258
R1224 VSS.t144 VSS.n88 1.13258
R1225 VSS.t147 VSS.n93 1.13258
R1226 VSS.t125 VSS.t96 1.09247
R1227 VSS.t139 VSS.t37 1.09247
R1228 VSS.n457 VSS.n57 1.04917
R1229 VSS.n411 VSS.n59 0.762586
R1230 VSS.n441 VSS.t9 0.755217
R1231 VSS.t131 VSS.n121 0.728479
R1232 VSS.t138 VSS.n108 0.728479
R1233 VSS.n412 VSS.n411 0.674942
R1234 VSS.n461 VSS.t89 0.566538
R1235 VSS.n471 VSS.t91 0.566538
R1236 VSS.n458 VSS.t93 0.566538
R1237 VSS.n144 VSS.t40 0.566538
R1238 VSS.n142 VSS.t42 0.566538
R1239 VSS.n147 VSS.t44 0.566538
R1240 VSS.n511 VSS.n60 0.551994
R1241 VSS.n467 VSS.t117 0.377858
R1242 VSS.n138 VSS.t148 0.377858
R1243 VSS.n475 VSS.n18 0.50003
R1244 VSS.n330 VSS.n215 0.325809
R1245 VSS.n508 VSS.n58 0.252599
R1246 VSS.t50 VSS.n60 0.264692
R1247 VSS.n51 VSS.n50 0.75765
R1248 VSS.n50 VSS.n49 0.959389
R1249 VSS.t48 VSS.t50 0.252013
R1250 VSS.n294 VSS.n293 0.243424
R1251 VSS.n346 VSS.n344 0.243424
R1252 VSS.n299 VSS.n298 0.242716
R1253 VSS.n296 VSS.n295 0.242681
R1254 VSS.n290 VSS.n289 0.24245
R1255 VSS.n193 VSS.n178 0.24245
R1256 VSS.n18 VSS.n43 0.404622
R1257 VSS.n475 VSS.n39 0.241827
R1258 VSS.n292 VSS.n291 0.240796
R1259 VSS.n345 VSS.n194 0.240796
R1260 VSS.n288 VSS.n287 0.239822
R1261 VSS.n452 VSS.n450 0.239822
R1262 VSS.n289 VSS.n288 0.227974
R1263 VSS.n450 VSS.n178 0.227974
R1264 VSS.n293 VSS.n292 0.227001
R1265 VSS.n346 VSS.n345 0.227001
R1266 VSS.n287 VSS.n286 0.225646
R1267 VSS.n452 VSS.n451 0.225646
R1268 VSS.n291 VSS.n290 0.224672
R1269 VSS.n194 VSS.n193 0.224672
R1270 VSS.n295 VSS.n294 0.223727
R1271 VSS.n344 VSS.n299 0.223715
R1272 VSS.n453 VSS.n178 0.218846
R1273 VSS.n289 VSS.n162 0.218846
R1274 VSS.n453 VSS.n346 0.218846
R1275 VSS.n293 VSS.n162 0.218846
R1276 VSS.n453 VSS.n452 0.208386
R1277 VSS.n287 VSS.n162 0.208386
R1278 VSS.n453 VSS.n194 0.208386
R1279 VSS.n291 VSS.n162 0.208386
R1280 VSS.n453 VSS.n299 0.208371
R1281 VSS.n295 VSS.n162 0.20836
R1282 VSS.n60 VSS.n0 0.197134
R1283 VSS.n136 VSS.n129 0.189179
R1284 VSS.n480 VSS.n479 0.189179
R1285 VSS.n55 VSS.n56 0.299243
R1286 VSS.n52 VSS.n19 0.113321
R1287 VSS.n419 VSS.n418 0.0927224
R1288 VSS.n420 VSS.n419 0.0891245
R1289 VSS.n49 VSS.n56 0.402928
R1290 VSS.n55 VSS.n511 0.211243
R1291 VSS.n2 VSS.n1 0.0455524
R1292 VSS.n417 VSS.n416 0.0794206
R1293 VSS.n42 VSS.n41 0.0394405
R1294 VSS.n415 VSS.n414 0.0776211
R1295 VSS.t13 VSS.n8 16.0214
R1296 VSS VSS.n0 0.210343
R1297 VSS.n3 VSS.n1 0.146661
R1298 VSS.n27 VSS.n26 0.146149
R1299 VSS.n46 VSS.n44 0.0585658
R1300 VSS.n45 VSS.n44 0.116817
R1301 VSS.n15 VSS.n14 0.0501977
R1302 VSS.n41 VSS.n40 0.116817
R1303 VSS.n13 VSS.n11 0.0501977
R1304 VSS.n54 VSS.n39 0.116817
R1305 VSS.n5 VSS.n4 0.0537818
R1306 VSS.n53 VSS.n43 0.097735
R1307 VSS.n418 VSS.n48 0.0951565
R1308 VSS.n34 VSS.n33 0.0593367
R1309 VSS.n32 VSS.n22 0.0873931
R1310 VSS.n52 VSS.t48 0.0894317
R1311 VSS.n38 VSS.n420 0.145414
R1312 VSS.n12 VSS.n20 0.140806
R1313 VSS.n4 VSS.n3 0.139213
R1314 VSS.n9 VSS.n6 0.134756
R1315 VSS.n23 VSS.n21 0.0647961
R1316 VSS.n27 VSS.n25 0.133422
R1317 VSS.n36 VSS.n24 0.133
R1318 VSS.n26 VSS.n34 0.126222
R1319 VSS.n29 VSS.n24 0.11762
R1320 VSS.n54 VSS.n14 0.117555
R1321 VSS.n13 VSS.n12 0.117555
R1322 VSS.n19 VSS.n17 0.113321
R1323 VSS.n17 VSS.n16 0.113321
R1324 VSS.n23 VSS.n22 0.0986904
R1325 VSS.n33 VSS.n32 0.0931265
R1326 VSS.n414 VSS.n413 0.0750054
R1327 VSS.n417 VSS.n415 0.0725235
R1328 VSS.n416 VSS.n2 0.107222
R1329 a_11798_1180.n0 a_11798_1180.n4 9.42143
R1330 a_11798_1180.n1 a_11798_1180.n12 9.42143
R1331 a_11798_1180.n1 a_11798_1180.n5 9.42143
R1332 a_11798_1180.n1 a_11798_1180.n6 9.42143
R1333 a_11798_1180.n2 a_11798_1180.n9 9.42143
R1334 a_11798_1180.n2 a_11798_1180.n7 9.42143
R1335 a_11798_1180.n4 a_11798_1180.t7 3.60374
R1336 a_11798_1180.n5 a_11798_1180.t13 3.60255
R1337 a_11798_1180.n6 a_11798_1180.t0 3.60255
R1338 a_11798_1180.n7 a_11798_1180.t6 3.60255
R1339 a_11798_1180.n4 a_11798_1180.t8 3.45423
R1340 a_11798_1180.n13 a_11798_1180.t9 3.45423
R1341 a_11798_1180.n11 a_11798_1180.t11 3.45423
R1342 a_11798_1180.n5 a_11798_1180.t12 3.45423
R1343 a_11798_1180.n12 a_11798_1180.t10 3.45423
R1344 a_11798_1180.n6 a_11798_1180.t1 3.45423
R1345 a_11798_1180.n10 a_11798_1180.t2 3.45423
R1346 a_11798_1180.n8 a_11798_1180.t4 3.45423
R1347 a_11798_1180.n7 a_11798_1180.t5 3.45423
R1348 a_11798_1180.n9 a_11798_1180.t3 3.45423
R1349 a_11798_1180.t28 a_11798_1180.n3 2.61386
R1350 a_11798_1180.n0 a_11798_1180.t14 2.61074
R1351 a_11798_1180.n2 a_11798_1180.t25 2.56233
R1352 a_11798_1180.n1 a_11798_1180.t18 2.56207
R1353 a_11798_1180.n2 a_11798_1180.t24 2.56173
R1354 a_11798_1180.n1 a_11798_1180.t22 2.56173
R1355 a_11798_1180.n1 a_11798_1180.t21 2.56173
R1356 a_11798_1180.n1 a_11798_1180.t23 2.56161
R1357 a_11798_1180.n0 a_11798_1180.t16 2.56161
R1358 a_11798_1180.n3 a_11798_1180.t26 2.5616
R1359 a_11798_1180.n0 a_11798_1180.t17 2.56155
R1360 a_11798_1180.n1 a_11798_1180.t19 2.56147
R1361 a_11798_1180.n3 a_11798_1180.t27 2.56146
R1362 a_11798_1180.n1 a_11798_1180.t20 2.56146
R1363 a_11798_1180.n0 a_11798_1180.t15 2.56146
R1364 a_11798_1180.n2 a_11798_1180.n1 0.245563
R1365 a_11798_1180.n8 a_11798_1180.n7 0.225083
R1366 a_11798_1180.n6 a_11798_1180.n10 0.225083
R1367 a_11798_1180.n11 a_11798_1180.n5 0.225083
R1368 a_11798_1180.n4 a_11798_1180.n13 0.225083
R1369 a_11798_1180.n1 a_11798_1180.n0 0.196551
R1370 a_11798_1180.n13 a_11798_1180.n12 0.1875
R1371 a_11798_1180.n12 a_11798_1180.n11 0.1875
R1372 a_11798_1180.n10 a_11798_1180.n9 0.1875
R1373 a_11798_1180.n9 a_11798_1180.n8 0.1875
R1374 a_11798_1180.n3 a_11798_1180.n2 0.147538
R1375 a_5560_3922.n0 a_5560_3922.t2 27.72
R1376 a_5560_3922.n0 a_5560_3922.t0 24.1197
R1377 a_5560_3922.t1 a_5560_3922.n0 9.38813
R1378 a_5560_5708.n0 a_5560_5708.t1 55.2712
R1379 a_5560_5708.n0 a_5560_5708.t2 27.8842
R1380 a_5560_5708.t0 a_5560_5708.n0 7.50485
R1381 a_6568_6136.n2 a_6568_6136.t2 19.9393
R1382 a_6568_6136.n0 a_6568_6136.t4 19.6783
R1383 a_6568_6136.n1 a_6568_6136.t1 17.974
R1384 a_6568_6136.n2 a_6568_6136.n1 5.04317
R1385 a_6568_6136.n0 a_6568_6136.t0 4.81727
R1386 a_6568_6136.n1 a_6568_6136.n0 4.76157
R1387 a_6568_6136.t3 a_6568_6136.n2 3.15445
R1388 a_5948_4416.n0 a_5948_4416.t2 30.2902
R1389 a_5948_4416.n0 a_5948_4416.t0 27.2706
R1390 a_5948_4416.t1 a_5948_4416.n0 11.5346
R1391 a_5905_4552.n0 a_5905_4552.t0 27.1774
R1392 a_5905_4552.n2 a_5905_4552.t2 25.4059
R1393 a_5905_4552.n1 a_5905_4552.t5 20.7725
R1394 a_5905_4552.n1 a_5905_4552.t4 20.4909
R1395 a_5905_4552.n0 a_5905_4552.t3 20.4287
R1396 a_5905_4552.t1 a_5905_4552.n0 12.1418
R1397 a_5905_4552.n2 a_5905_4552.n1 5.30277
R1398 a_5905_4552.n0 a_5905_4552.n2 4.5269
R1399 vco_bias_0.vbn_buf.n3 vco_bias_0.vbn_buf.t1 45.045
R1400 vco_bias_0.vbn_buf.n2 vco_bias_0.vbn_buf.t4 34.2391
R1401 vco_bias_0.vbn_buf.n2 vco_bias_0.vbn_buf.t3 28.5544
R1402 vco_bias_0.vbn_buf.n1 vco_bias_0.vbn_buf.n0 22.7415
R1403 vco_bias_0.vbn_buf.n0 vco_bias_0.vbn_buf.t2 21.7736
R1404 vco_bias_0.vbn_buf.n4 vco_bias_0.vbn_buf.t0 17.2373
R1405 vco_bias_0.vbn_buf.n4 vco_bias_0.vbn_buf.n3 13.5293
R1406 vco_bias_0.vbn_buf.n3 vco_bias_0.vbn_buf.n2 6.9349
R1407 vco_bias_0.vbn_buf vco_bias_0.vbn_buf.n4 2.55837
R1408 vco_bias_0.vbn_buf vco_bias_0.vbn_buf.n1 0.2645
R1409 vco_bias_0.vbn_buf.n1 vco_bias_0.vbn_buf 0.1985
R1410 vco_bias_0.vbn_buf.n0 vco_bias_0.vbn_buf 0.1105
C0 a_9450_4394# rf_out_n 0.97363f
C1 a_9450_4394# a_9450_4480# 0.03458f
C2 a_10100_3480# rf_out_n 0.47902f
C3 vco_bias_0.vbn_buf a_9450_4394# 0.03045f
C4 a_10100_3480# vco_bias_0.vbn_buf 0.01657f
C5 vtune rf_out_n 0.03195f
C6 vtune vco_bias_0.vbn_buf 0.09328f
C7 a_16500_3480# a_14668_2644# 0.0615f
C8 vco_bias_0.vbn_buf a_14668_2644# 0.01681f
C9 VDD rf_out_n 0.42538f
C10 VDD a_16500_3480# 0.32168f
C11 VDD vco_bias_0.vbn_buf 1.39392f
C12 a_9450_4480# vco_bias_0.vbg_buf 0.04475f
C13 vco_bias_0.vbn_buf di_en 0.10308f
C14 vco_bias_0.vbn_buf vco_bias_0.vbg_buf 4.95375f
C15 vdd_core rf_out_p 0.01629f
C16 vco_bias_0.vbn_buf ibias_100u 0.18745f
C17 a_19050_4480# a_14668_2644# 0.03458f
C18 a_19050_4480# vco_bias_0.vbg_buf 0.04459f
C19 a_10100_3480# a_9450_4394# 0.0615f
C20 vtune a_9450_4394# 0.18199f
C21 VDD a_1160_1390# 0.03027f
C22 vdd_core rf_out_n 0.01574f
C23 a_9450_4394# a_14668_2644# 0.17478f
C24 a_16500_3480# vdd_core 0.01688f
C25 a_1160_1390# vco_bias_0.vbg_buf 0.0551f
C26 vco_bias_0.vbn_buf vdd_core 0.31748f
C27 rf_out_n rf_out_p 0.01053f
C28 a_1160_1390# ibias_100u 0.0297f
C29 a_16500_3480# rf_out_p 0.47902f
C30 VDD a_9450_4394# 0.55386f
C31 VDD a_10100_3480# 0.35541f
C32 vco_bias_0.vbn_buf rf_out_p 0.17253f
C33 a_9450_4394# vco_bias_0.vbg_buf 0.06224f
C34 vtune a_14668_2644# 0.18199f
C35 vtune VDD 0.31574f
C36 a_19050_4480# vdd_core 0.01117f
C37 vtune vco_bias_0.vbg_buf 0.13019f
C38 VDD a_14668_2644# 0.53384f
C39 a_14668_2644# vco_bias_0.vbg_buf 0.05315f
C40 VDD di_en 0.59704f
C41 VDD vco_bias_0.vbg_buf 2.38433f
C42 di_en vco_bias_0.vbg_buf 1.53374f
C43 VDD ibias_100u 0.50906f
C44 a_1560_1090# a_1160_1390# 0.17942f
C45 di_en ibias_100u 3.44752f
C46 ibias_100u vco_bias_0.vbg_buf 1.5817f
C47 vco_bias_0.vbn_buf rf_out_n 0.19807f
C48 vco_bias_0.vbn_buf a_9450_4480# 0.01693f
C49 VDD a_5560_4008# 0.04042f
C50 a_9450_4394# vdd_core 1.68757f
C51 a_10100_3480# vdd_core 0.01479f
C52 a_5560_4008# vco_bias_0.vbg_buf 0.01338f
C53 vtune vdd_core 11.8836f
C54 a_14668_2644# vdd_core 1.69805f
C55 vtune rf_out_p 0.03195f
C56 a_1560_1090# VDD 0.06439f
C57 a_14668_2644# rf_out_p 0.97363f
C58 VDD vdd_core 0.60885f
C59 a_1560_1090# vco_bias_0.vbg_buf 0.06332f
C60 vdd_core vco_bias_0.vbg_buf 1.49466f
C61 VDD rf_out_p 0.41138f
C62 a_1560_1090# ibias_100u 0.01292f
C63 vco_bias_0.vbn_buf a_1160_1390# 0.029f
C64 rf_out_p VSS 4.02018f
C65 rf_out_n VSS 3.99973f
C66 ibias_100u VSS 6.42417f
C67 di_en VSS 3.76471f
C68 vdd_core VSS 0.10405p
C69 vtune VSS 4.64235f
C70 VDD VSS 38.35958f
C71 vco_bias_0.vbg_buf VSS 0.51558f
C72 vco_bias_0.vbn_buf VSS 0.12662p
C73 vco_bias_0.vbn_buf.n0 VSS 0.12078f
C74 vco_bias_0.vbn_buf.n1 VSS 0.06844f
C75 vco_bias_0.vbn_buf.n2 VSS 0.13082f
C76 vco_bias_0.vbn_buf.t1 VSS 2.22498f
C77 vco_bias_0.vbn_buf.n3 VSS 0.18646f
C78 vco_bias_0.vbn_buf.t0 VSS 0.11958f
C79 vco_bias_0.vbn_buf.n4 VSS 0.12618f
C80 a_5905_4552.n0 VSS 1.13583f
C81 a_5905_4552.n1 VSS 0.90577f
C82 a_5905_4552.n2 VSS 0.72569f
C83 a_5905_4552.t0 VSS 0.1858f
C84 a_5905_4552.t1 VSS 0.26216f
C85 a_5948_4416.t0 VSS 0.15048f
C86 a_5948_4416.n0 VSS 1.93057f
C87 a_5948_4416.t1 VSS 0.27583f
C88 a_6568_6136.t1 VSS 0.52613f
C89 a_6568_6136.t0 VSS 0.53512f
C90 a_6568_6136.n0 VSS 0.61316f
C91 a_6568_6136.n1 VSS 0.91934f
C92 a_6568_6136.n2 VSS 0.61361f
C93 a_6568_6136.t3 VSS 0.98208f
C94 a_5560_5708.t1 VSS 2.51989f
C95 a_5560_5708.t2 VSS 0.76942f
C96 a_5560_5708.n0 VSS 2.85514f
C97 a_5560_5708.t0 VSS 1.09803f
C98 a_5560_3922.t2 VSS 0.72877f
C99 a_5560_3922.n0 VSS 0.74973f
C100 a_5560_3922.t1 VSS 0.38379f
C101 a_11798_1180.n0 VSS 1.87357f
C102 a_11798_1180.n1 VSS 3.22693f
C103 a_11798_1180.n2 VSS 1.31647f
C104 a_11798_1180.n3 VSS 1.24061f
C105 a_11798_1180.n4 VSS 0.13002f
C106 a_11798_1180.n5 VSS 0.13002f
C107 a_11798_1180.n6 VSS 0.13002f
C108 a_11798_1180.n7 VSS 0.13002f
C109 a_11798_1180.t6 VSS 0.06106f
C110 a_11798_1180.t3 VSS 0.06535f
C111 a_11798_1180.t4 VSS 0.06535f
C112 a_11798_1180.t5 VSS 0.06535f
C113 a_11798_1180.n8 VSS 0.07299f
C114 a_11798_1180.n9 VSS 0.07639f
C115 a_11798_1180.t1 VSS 0.33593f
C116 a_11798_1180.t2 VSS 2.95606f
C117 a_11798_1180.n10 VSS 0.07299f
C118 a_11798_1180.t0 VSS 0.06106f
C119 a_11798_1180.t13 VSS 0.06106f
C120 a_11798_1180.t10 VSS 0.06535f
C121 a_11798_1180.t11 VSS 2.94263f
C122 a_11798_1180.t12 VSS 0.06535f
C123 a_11798_1180.n11 VSS 0.07299f
C124 a_11798_1180.n12 VSS 0.07639f
C125 a_11798_1180.t8 VSS 0.32314f
C126 a_11798_1180.t9 VSS 0.06535f
C127 a_11798_1180.n13 VSS 0.07299f
C128 a_11798_1180.t7 VSS 0.06107f
C129 a_11798_1180.t14 VSS 0.19692f
C130 a_11798_1180.t15 VSS 0.19158f
C131 a_11798_1180.t16 VSS 0.19159f
C132 a_11798_1180.t17 VSS 0.19158f
C133 a_11798_1180.t18 VSS 0.19158f
C134 a_11798_1180.t19 VSS 0.19158f
C135 a_11798_1180.t20 VSS 0.19158f
C136 a_11798_1180.t21 VSS 0.19159f
C137 a_11798_1180.t22 VSS 0.19159f
C138 a_11798_1180.t23 VSS 0.19159f
C139 a_11798_1180.t24 VSS 0.19159f
C140 a_11798_1180.t25 VSS 0.19158f
C141 a_11798_1180.t26 VSS 0.89249f
C142 a_11798_1180.t27 VSS 0.19158f
C143 a_11798_1180.t28 VSS 0.19688f
C144 VSS.t48 VSS 9.56407f
C145 VSS.t149 VSS 0.70091f
C146 VSS.t83 VSS 0.01376f
C147 VSS.t67 VSS 0.01999f
C148 VSS.t26 VSS 3.12617f
C149 VSS.t160 VSS 57.674f
C150 VSS.t161 VSS 57.674f
C151 VSS.t173 VSS 1.00654f
C152 VSS.t175 VSS 1.00654f
C153 VSS.t2 VSS 3.12175f
C154 VSS.t24 VSS 3.12617f
C155 VSS.t4 VSS 3.12175f
C156 VSS.t32 VSS 0.10086f
C157 VSS.t20 VSS 0.05366f
C158 VSS.t158 VSS 0.54116f
C159 VSS.t86 VSS 0.12196f
C160 VSS.t18 VSS 0.06182f
C161 VSS.t12 VSS 0.1355f
C162 VSS.t16 VSS 0.23156f
C163 VSS.t14 VSS 0.23156f
C164 VDD.n0 VSS 0.14726f
C165 VDD.n1 VSS 0.07097f
C166 VDD.n2 VSS 0.13248f
C167 VDD.n3 VSS 0.02602f
C168 VDD.n4 VSS 0.0426f
C169 VDD.n5 VSS 0.03457f
C170 VDD.n6 VSS 0.35432f
C171 VDD.n8 VSS 0.09271f
C172 VDD.t3 VSS 0.07306f
C173 VDD.t6 VSS 0.10758f
C174 VDD.t4 VSS 0.241f
C175 VDD.t1 VSS 0.42529f
C176 VDD.t18 VSS 0.0812f
C177 VDD.t19 VSS 0.07932f
C178 VDD.t2 VSS 0.42362f
C179 VDD.t15 VSS 0.07932f
C180 VDD.t16 VSS 0.07932f
C181 VDD.t12 VSS 0.07932f
C182 VDD.t13 VSS 0.07932f
C183 VDD.t9 VSS 0.01108f
C184 VDD.t10 VSS 0.01108f
C185 VDD.n10 VSS 0.03724f
C186 VDD.t0 VSS 2.37059f
C187 VDD.n11 VSS 0.19443f
C188 VDD.t7 VSS 1.38874f
C189 VDD.t5 VSS 0.88941f
C190 VDD.n12 VSS 1.33672f
C191 vtune.t0 VSS 3.74675f
C192 vtune.t3 VSS 3.73279f
C193 vtune.n0 VSS 0.40559f
C194 vtune.t6 VSS 3.73279f
C195 vtune.n1 VSS 1.02501f
C196 vdd_core.n0 VSS 0.03342f
C197 vdd_core.n5 VSS 0.01481f
C198 vdd_core.n6 VSS 0.41603f
C199 vdd_core.n7 VSS 0.01789f
C200 vdd_core.n8 VSS 0.30441f
C201 vdd_core.n10 VSS 0.25096f
C202 vdd_core.t24 VSS 0.24424f
C203 vdd_core.n14 VSS 0.05171f
C204 vdd_core.n15 VSS 0.03182f
C205 vdd_core.n16 VSS 0.13358f
C206 vdd_core.n19 VSS 0.03407f
C207 vdd_core.t4 VSS 0.0216f
C208 vdd_core.n23 VSS 0.0451f
C209 vdd_core.n26 VSS 0.04808f
C210 vdd_core.n30 VSS 0.65663f
C211 vdd_core.t0 VSS 0.24545f
C212 vdd_core.n44 VSS 0.06902f
C213 vdd_core.n46 VSS 0.04808f
C214 vdd_core.n47 VSS 0.13358f
C215 vdd_core.n48 VSS 0.02332f
C216 vdd_core.n49 VSS 0.03333f
C217 vdd_core.t9 VSS 0.01535f
C218 vdd_core.n52 VSS 0.02272f
C219 vdd_core.n53 VSS 0.04025f
C220 vdd_core.n58 VSS 0.25036f
C221 vdd_core.n62 VSS 0.51088f
C222 vdd_core.n66 VSS 0.01376f
C223 vdd_core.n74 VSS 2.21952f
C224 di_en.n0 VSS 3.33136f
C225 ibias_100u.t3 VSS 2.55107f
C226 ibias_100u.t2 VSS 0.30197f
C227 ibias_100u.n0 VSS 0.8652f
C228 ibias_100u.n1 VSS 0.28946f
C229 ibias_100u.t1 VSS 0.65887f
C230 ibias_100u.n2 VSS 0.28295f
C231 ibias_100u.n3 VSS 3.07386f
C232 rf_out_n.n0 VSS 0.67272f
C233 rf_out_n.n1 VSS 0.83323f
C234 rf_out_n.t0 VSS 1.72144f
C235 rf_out_n.t4 VSS 0.10811f
C236 rf_out_n.t2 VSS 2.98379f
C237 rf_out_n.t1 VSS 0.10651f
C238 rf_out_n.t3 VSS 0.10651f
C239 rf_out_n.t6 VSS 0.3643f
C240 rf_out_n.t5 VSS 0.10651f
C241 rf_out_n.n2 VSS 0.74634f
C242 rf_out_p.n0 VSS 0.92003f
C243 rf_out_p.n1 VSS 0.57327f
C244 rf_out_p.t6 VSS 1.71554f
C245 rf_out_p.t4 VSS 0.1072f
C246 rf_out_p.t5 VSS 3.26692f
C247 rf_out_p.t3 VSS 0.10562f
C248 rf_out_p.t0 VSS 0.10562f
C249 rf_out_p.t1 VSS 0.10562f
C250 rf_out_p.t2 VSS 0.10562f
C251 rf_out_p.n2 VSS 0.74006f
.ends

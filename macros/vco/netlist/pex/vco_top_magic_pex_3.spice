* PEX produced on Thu Nov  5 08:20:53 PM CET 2026 using /foss/tools/sak/sak-pex.sh with m=3 and s=1 (extresist threshold=1000 mOhm, minres=100 mOhm, mindelay=0 ps)
* NGSPICE file created from vco_top_pex.ext - technology: ihp-sg13g2

.subckt vco_top_pex ibias_100u di_en VDD VSS vdd_core vtune rf_out_p rf_out_n
X0 VSS.t124 vdd_core.t2 vdd_core.t3 VSS.t123 sg13_lv_nmos ad=0.68p pd=4.68u as=0.38p ps=2.38u w=2u l=0.13u
X1 VSS.t108 vdd_core.t4 vdd_core.t14 VSS.t107 sg13_lv_nmos ad=0.68p pd=4.68u as=0.38p ps=2.38u w=2u l=0.13u
X2 a_1474_1090.t1 a_2654_4840.t4 VDD.t7 VDD.t6 sg13_lv_pmos ad=1.7p pd=10.68u as=1.7p ps=10.68u w=5u l=0.5u
X3 rf_out_n.t5 a_9450_4394# a_11798_1180.t19 VSS.t83 sg13_lv_nmos ad=0.38p pd=2.38u as=0.38p ps=2.38u w=2u l=0.13u
X4 rf_out_n.t1 a_9450_4394# a_11798_1180.t17 VSS.t79 sg13_lv_nmos ad=0.38p pd=2.38u as=0.38p ps=2.38u w=2u l=0.13u
X5 VSS.t39 vco_bias_0.vbn_buf.t2 a_11798_1180.t12 VSS.t40 sg13_lv_nmos ad=0.95p pd=5.38u as=0.95p ps=5.38u w=5u l=0.5u
X6 a_11798_1180.t10 vco_bias_0.vbn_buf.t2 VSS.t32 VSS.t33 sg13_lv_nmos ad=0.95p pd=5.38u as=0.95p ps=5.38u w=5u l=0.5u
X7 a_11798_1180.t0 vco_bias_0.vbn_buf.t2 VSS.t7 VSS.t6 sg13_lv_nmos ad=0.95p pd=5.38u as=1.7p ps=10.68u w=5u l=0.5u
X8 VSS.t62 vco_bias_0.vbn_buf.t3 VSS.t60 VSS.t49 sg13_lv_nmos ad=1.52p pd=8.38u as=0 ps=0 w=8u l=10u
X9 VSS.t1 vco_bias_0.vbn_buf.t2 a_11798_1180.t3 VSS.t17 sg13_lv_nmos ad=0.95p pd=5.38u as=0.95p ps=5.38u w=5u l=0.5u
X10 VSS.t66 vco_bias_0.vbn_buf.t3 VSS.t64 VSS.t53 sg13_lv_nmos ad=1.52p pd=8.38u as=0 ps=0 w=8u l=10u
X11 VSS.t118 vdd_core.t2 vdd_core.t15 VSS.t117 sg13_lv_nmos ad=0.38p pd=2.38u as=0.38p ps=2.38u w=2u l=0.13u
X12 a_11798_1180.t24 a_14668_2644# rf_out_p.t1 VSS.t134 sg13_lv_nmos ad=0.38p pd=2.38u as=0.38p ps=2.38u w=2u l=0.13u
X13 VSS.t52 vco_bias_0.vbn_buf.t4 VSS.t50 VSS.t51 sg13_lv_nmos ad=1.52p pd=8.38u as=0 ps=0 w=8u l=10u
X14 rf_out_p.t0 a_14668_2644# a_11798_1180.t22 VSS.t131 sg13_lv_nmos ad=0.38p pd=2.38u as=0.68p ps=4.68u w=2u l=0.13u
X15 ibias_100u.t0 a_1254_2820.t3 VSS.t73 VSS.t69 sg13_lv_nmos ad=0.34p pd=2.68u as=0.34p ps=2.68u w=1u l=0.13u
X16 VSS.t145 vco_bias_0.vbg_buf VSS.t144 VSS.t46 sg13_lv_nmos ad=2.72p pd=16.68u as=0 ps=0 w=8u l=10u
X17 VSS.t161 vco_bias_0.vbg_buf VSS.t159 VSS.t53 sg13_lv_nmos ad=1.52p pd=8.38u as=0 ps=0 w=8u l=10u
X18 VSS.t99 vdd_core.t4 vdd_core.t6 VSS.t98 sg13_lv_nmos ad=0.38p pd=2.38u as=0.38p ps=2.38u w=2u l=0.13u
X19 vdd_core.t7 vdd_core.t2 VSS.t118 VSS.t119 sg13_lv_nmos ad=0.38p pd=2.38u as=0.38p ps=2.38u w=2u l=0.13u
X20 vdd_core.t12 vdd_core.t2 VSS.t112 VSS.t113 sg13_lv_nmos ad=0.38p pd=2.38u as=0.38p ps=2.38u w=2u l=0.13u
X21 a_1474_1090.t2 vco_bias_0.vbg_buf VSS.t88 rhigh l=32u w=0.5u
X22 a_2654_4840.t0 a_1954_2820.t2 VDD.t3 VDD.t2 sg13_lv_pmos ad=0.34p pd=2.68u as=0.34p ps=2.68u w=1u l=0.13u
X23 vdd_core.t13 vdd_core.t4 VSS.t102 VSS.t103 sg13_lv_nmos ad=0.38p pd=2.38u as=0.38p ps=2.38u w=2u l=0.13u
X24 a_11798_1180.t27 a_14668_2644# rf_out_p.t5 VSS.t140 sg13_lv_nmos ad=0.38p pd=2.38u as=0.38p ps=2.38u w=2u l=0.13u
X25 a_1954_2820.t1 a_1254_2820.t4 VSS.t72 VSS.t71 sg13_lv_nmos ad=0.17p pd=1.68u as=0.17p ps=1.68u w=0.5u l=0.13u
N26 vdd_core.t30 vtune.t3 sg13_hv_svaricap l=0.3u w=26.34u
X27 VSS.t32 vco_bias_0.vbn_buf.t2 a_11798_1180.t9 VSS.t31 sg13_lv_nmos ad=0.95p pd=5.38u as=0.95p ps=5.38u w=5u l=0.5u
X28 VSS.t159 vco_bias_0.vbg_buf VSS.t157 VSS.t51 sg13_lv_nmos ad=1.52p pd=8.38u as=0 ps=0 w=8u l=10u
X29 VSS.t9 vco_bias_0.vbn_buf.t2 a_11798_1180.t0 VSS.t8 sg13_lv_nmos ad=0.95p pd=5.38u as=0.95p ps=5.38u w=5u l=0.5u
X30 a_11798_1180.t13 vco_bias_0.vbn_buf.t2 VSS.t39 VSS.t38 sg13_lv_nmos ad=0.95p pd=5.38u as=0.95p ps=5.38u w=5u l=0.5u
X31 ibias_100u.t1 vco_bias_0.vbn_buf.t1 VSS.t125 rhigh l=32u w=0.5u
X32 a_11798_1180.t14 vco_bias_0.vbn_buf.t2 VSS.t42 VSS.t43 sg13_lv_nmos ad=0.95p pd=5.38u as=0.95p ps=5.38u w=5u l=0.5u
X33 a_1254_2820.t1 di_en.t1 VDD.t10 VDD.t9 sg13_lv_pmos ad=0.34p pd=2.68u as=0.34p ps=2.68u w=1u l=0.13u
N34 vdd_core.t29 vtune.t3 sg13_hv_svaricap l=0.3u w=26.34u
X35 a_5428_2384.t1 a_5428_2384.t0 VSS.t58 VSS.t57 sg13_lv_nmos ad=0.85p pd=5.68u as=0.85p ps=5.68u w=2.5u l=0.5u
X36 a_11798_1180.t20 a_9450_4394# rf_out_n.t5 VSS.t84 sg13_lv_nmos ad=0.38p pd=2.38u as=0.38p ps=2.38u w=2u l=0.13u
X37 VSS.t64 vco_bias_0.vbn_buf.t3 VSS.t62 VSS.t51 sg13_lv_nmos ad=1.52p pd=8.38u as=0 ps=0 w=8u l=10u
X38 a_11798_1180.t4 vco_bias_0.vbn_buf.t2 VSS.t1 VSS.t0 sg13_lv_nmos ad=0.95p pd=5.38u as=0.95p ps=5.38u w=5u l=0.5u
X39 a_11798_1180.t18 a_9450_4394# rf_out_n.t1 VSS.t80 sg13_lv_nmos ad=0.38p pd=2.38u as=0.38p ps=2.38u w=2u l=0.13u
X40 VSS.t28 vco_bias_0.vbn_buf.t2 a_11798_1180.t7 VSS.t27 sg13_lv_nmos ad=0.95p pd=5.38u as=0.95p ps=5.38u w=5u l=0.5u
X41 VSS.t147 vco_bias_0.vbg_buf VSS.t145 VSS.t49 sg13_lv_nmos ad=1.52p pd=8.38u as=0 ps=0 w=8u l=10u
X42 a_2654_4840.t3 ibias_100u.t4 VSS.t129 VSS.t57 sg13_lv_nmos ad=0.85p pd=5.68u as=0.85p ps=5.68u w=2.5u l=0.5u
X43 VSS.t163 vco_bias_0.vbg_buf VSS.t161 VSS.t55 sg13_lv_nmos ad=1.52p pd=8.38u as=0 ps=0 w=8u l=10u
X44 VSS.t42 vco_bias_0.vbn_buf.t2 a_11798_1180.t13 VSS.t41 sg13_lv_nmos ad=0.95p pd=5.38u as=0.95p ps=5.38u w=5u l=0.5u
X45 VSS.t121 vdd_core.t2 vdd_core.t7 VSS.t120 sg13_lv_nmos ad=0.38p pd=2.38u as=0.38p ps=2.38u w=2u l=0.13u
X46 VSS.t45 vco_bias_0.vbn_buf.t2 a_11798_1180.t14 VSS.t44 sg13_lv_nmos ad=1.7p pd=10.68u as=0.95p ps=5.38u w=5u l=0.5u
X47 VSS.t48 vco_bias_0.vbn_buf.t4 VSS.t47 VSS.t46 sg13_lv_nmos ad=2.72p pd=16.68u as=0 ps=0 w=8u l=10u
X48 VSS.t105 vdd_core.t4 vdd_core.t13 VSS.t104 sg13_lv_nmos ad=0.38p pd=2.38u as=0.38p ps=2.38u w=2u l=0.13u
X49 VDD.t11 rf_out_p.t6 VSS.t143 rppd l=1.65u w=10u
X50 rf_out_p.t2 a_14668_2644# a_11798_1180.t27 VSS.t141 sg13_lv_nmos ad=0.38p pd=2.38u as=0.38p ps=2.38u w=2u l=0.13u
X51 a_2654_4840.t2 a_2654_4840.t1 VDD.t5 VDD.t4 sg13_lv_pmos ad=1.7p pd=10.68u as=1.7p ps=10.68u w=5u l=0.5u
X52 a_11798_1180.t7 vco_bias_0.vbn_buf.t2 VSS.t25 VSS.t26 sg13_lv_nmos ad=0.95p pd=5.38u as=0.95p ps=5.38u w=5u l=0.5u
X53 rf_out_p.t4 a_14668_2644# a_11798_1180.t25 VSS.t137 sg13_lv_nmos ad=0.38p pd=2.38u as=0.38p ps=2.38u w=2u l=0.13u
X54 VSS.t56 vco_bias_0.vbn_buf.t4 VSS.t54 VSS.t55 sg13_lv_nmos ad=1.52p pd=8.38u as=0 ps=0 w=8u l=10u
X55 vdd_core.t20 vdd_core.t4 VSS.t99 VSS.t100 sg13_lv_nmos ad=0.38p pd=2.38u as=0.38p ps=2.38u w=2u l=0.13u
X56 VSS.t3 vco_bias_0.vbn_buf.t2 a_11798_1180.t10 VSS.t2 sg13_lv_nmos ad=0.95p pd=5.38u as=0.95p ps=5.38u w=5u l=0.5u
X57 a_11798_1180.t8 vco_bias_0.vbn_buf.t2 VSS.t28 VSS.t29 sg13_lv_nmos ad=0.95p pd=5.38u as=0.95p ps=5.38u w=5u l=0.5u
X58 vdd_core.t5 vdd_core.t4 VSS.t94 VSS.t93 sg13_lv_nmos ad=0.38p pd=2.38u as=0.68p ps=4.68u w=2u l=0.13u
X59 VSS.t36 vco_bias_0.vbn_buf.t2 a_11798_1180.t11 VSS.t35 sg13_lv_nmos ad=0.95p pd=5.38u as=0.95p ps=5.38u w=5u l=0.5u
X60 VSS.t115 vdd_core.t2 vdd_core.t12 VSS.t114 sg13_lv_nmos ad=0.38p pd=2.38u as=0.38p ps=2.38u w=2u l=0.13u
X61 rf_out_n.t4 a_9450_4394# a_11798_1180.t15 VSS.t75 sg13_lv_nmos ad=0.38p pd=2.38u as=0.68p ps=4.68u w=2u l=0.13u
N62 vdd_core.t27 vtune.t6 sg13_hv_svaricap l=0.3u w=26.34u
X63 a_1954_2820.t0 a_1254_2820.t5 VDD.t1 VDD.t0 sg13_lv_pmos ad=0.34p pd=2.68u as=0.34p ps=2.68u w=1u l=0.13u
X64 VSS.t96 vdd_core.t4 vdd_core.t5 VSS.t95 sg13_lv_nmos ad=0.38p pd=2.38u as=0.38p ps=2.38u w=2u l=0.13u
X65 VSS.t60 vco_bias_0.vbn_buf.t3 VSS.t59 VSS.t46 sg13_lv_nmos ad=2.72p pd=16.68u as=0 ps=0 w=8u l=10u
X66 rf_out_n.t2 a_9450_4394# a_11798_1180.t20 VSS.t85 sg13_lv_nmos ad=0.38p pd=2.38u as=0.38p ps=2.38u w=2u l=0.13u
X67 rf_out_n.t3 a_9450_4394# a_11798_1180.t18 VSS.t81 sg13_lv_nmos ad=0.38p pd=2.38u as=0.38p ps=2.38u w=2u l=0.13u
X68 VSS.t155 vco_bias_0.vbg_buf VSS.t154 VSS.t46 sg13_lv_nmos ad=2.72p pd=16.68u as=0 ps=0 w=8u l=10u
X69 VSS.t12 vco_bias_0.vbn_buf.t2 a_11798_1180.t1 VSS.t11 sg13_lv_nmos ad=0.95p pd=5.38u as=0.95p ps=5.38u w=5u l=0.5u
X70 a_11798_1180.t5 vco_bias_0.vbn_buf.t2 VSS.t19 VSS.t20 sg13_lv_nmos ad=0.95p pd=5.38u as=0.95p ps=5.38u w=5u l=0.5u
X71 a_11798_1180.t11 vco_bias_0.vbn_buf.t2 VSS.t3 VSS.t34 sg13_lv_nmos ad=0.95p pd=5.38u as=0.95p ps=5.38u w=5u l=0.5u
N72 vdd_core.t31 vtune.t0 sg13_hv_svaricap l=0.3u w=26.34u
X73 a_11798_1180.t12 vco_bias_0.vbn_buf.t2 VSS.t36 VSS.t37 sg13_lv_nmos ad=0.95p pd=5.38u as=0.95p ps=5.38u w=5u l=0.5u
X74 a_9450_4394# vdd_core.t0 cap_cmim l=10u w=10u
X75 a_11798_1180.t23 a_14668_2644# rf_out_p.t0 VSS.t132 sg13_lv_nmos ad=0.38p pd=2.38u as=0.38p ps=2.38u w=2u l=0.13u
X76 VSS.t68 vco_bias_0.vbn_buf.t3 VSS.t66 VSS.t55 sg13_lv_nmos ad=1.52p pd=8.38u as=0 ps=0 w=8u l=10u
X77 vdd_core.t3 vdd_core.t2 VSS.t121 VSS.t122 sg13_lv_nmos ad=0.38p pd=2.38u as=0.38p ps=2.38u w=2u l=0.13u
X78 vdd_core.t14 vdd_core.t4 VSS.t105 VSS.t106 sg13_lv_nmos ad=0.38p pd=2.38u as=0.38p ps=2.38u w=2u l=0.13u
X79 a_11798_1180.t1 vco_bias_0.vbn_buf.t2 VSS.t9 VSS.t10 sg13_lv_nmos ad=0.95p pd=5.38u as=0.95p ps=5.38u w=5u l=0.5u
X80 ibias_100u.t3 ibias_100u.t2 VSS.t128 VSS.t57 sg13_lv_nmos ad=0.85p pd=5.68u as=0.85p ps=5.68u w=2.5u l=0.5u
X81 VSS.t19 vco_bias_0.vbn_buf.t2 a_11798_1180.t4 VSS.t18 sg13_lv_nmos ad=0.95p pd=5.38u as=0.95p ps=5.38u w=5u l=0.5u
X82 a_11798_1180.t2 vco_bias_0.vbn_buf.t2 VSS.t12 VSS.t13 sg13_lv_nmos ad=0.95p pd=5.38u as=0.95p ps=5.38u w=5u l=0.5u
X83 a_11798_1180.t26 a_14668_2644# rf_out_p.t4 VSS.t138 sg13_lv_nmos ad=0.38p pd=2.38u as=0.38p ps=2.38u w=2u l=0.13u
X84 rf_out_p.t3 a_14668_2644# a_11798_1180.t24 VSS.t135 sg13_lv_nmos ad=0.38p pd=2.38u as=0.38p ps=2.38u w=2u l=0.13u
X85 a_1474_1090.t0 a_5428_2384.t2 VSS.t74 rppd l=8.5u w=0.5u
X86 vco_bias_0.vbn_buf.t0 a_1254_2820.t2 VSS.t70 VSS.t69 sg13_lv_nmos ad=0.34p pd=2.68u as=0.34p ps=2.68u w=1u l=0.13u
X87 VSS.t151 vco_bias_0.vbg_buf VSS.t149 VSS.t53 sg13_lv_nmos ad=1.52p pd=8.38u as=0 ps=0 w=8u l=10u
X88 a_14668_2644# vdd_core.t24 cap_cmim l=10u w=10u
X89 VSS.t22 vco_bias_0.vbn_buf.t2 a_11798_1180.t5 VSS.t21 sg13_lv_nmos ad=0.95p pd=5.38u as=0.95p ps=5.38u w=5u l=0.5u
X90 a_11798_1180.t9 vco_bias_0.vbn_buf.t2 VSS.t5 VSS.t4 sg13_lv_nmos ad=0.95p pd=5.38u as=0.95p ps=5.38u w=5u l=0.5u
X91 a_11798_1180.t16 a_9450_4394# rf_out_n.t4 VSS.t76 sg13_lv_nmos ad=0.38p pd=2.38u as=0.38p ps=2.38u w=2u l=0.13u
X92 VSS.t157 vco_bias_0.vbg_buf VSS.t155 VSS.t49 sg13_lv_nmos ad=1.52p pd=8.38u as=0 ps=0 w=8u l=10u
X93 VSS.t149 vco_bias_0.vbg_buf VSS.t147 VSS.t51 sg13_lv_nmos ad=1.52p pd=8.38u as=0 ps=0 w=8u l=10u
X94 VSS.t102 vdd_core.t4 vdd_core.t20 VSS.t101 sg13_lv_nmos ad=0.38p pd=2.38u as=0.38p ps=2.38u w=2u l=0.13u
X95 vdd_core.t15 vdd_core.t2 VSS.t115 VSS.t116 sg13_lv_nmos ad=0.38p pd=2.38u as=0.38p ps=2.38u w=2u l=0.13u
X96 a_11798_1180.t21 a_9450_4394# rf_out_n.t2 VSS.t86 sg13_lv_nmos ad=0.68p pd=4.68u as=0.38p ps=2.38u w=2u l=0.13u
X97 vdd_core.t9 vdd_core.t2 VSS.t110 VSS.t109 sg13_lv_nmos ad=0.38p pd=2.38u as=0.68p ps=4.68u w=2u l=0.13u
X98 vdd_core.t26 VSS.t89 cap_cmim l=39u w=56u
X99 a_11798_1180.t19 a_9450_4394# rf_out_n.t3 VSS.t82 sg13_lv_nmos ad=0.38p pd=2.38u as=0.38p ps=2.38u w=2u l=0.13u
X100 a_11798_1180.t17 a_9450_4394# rf_out_n.t0 VSS.t78 sg13_lv_nmos ad=0.38p pd=2.38u as=0.38p ps=2.38u w=2u l=0.13u
X101 VSS.t15 vco_bias_0.vbn_buf.t2 a_11798_1180.t2 VSS.t14 sg13_lv_nmos ad=0.95p pd=5.38u as=0.95p ps=5.38u w=5u l=0.5u
X102 vco_bias_0.vbg_buf a_14668_2644# VSS.t130 rhigh l=8u w=0.5u
N103 vdd_core.t28 vtune.t6 sg13_hv_svaricap l=0.3u w=26.34u
X104 vdd_core.t6 vdd_core.t4 VSS.t96 VSS.t97 sg13_lv_nmos ad=0.38p pd=2.38u as=0.38p ps=2.38u w=2u l=0.13u
X105 VSS.t5 vco_bias_0.vbn_buf.t2 a_11798_1180.t8 VSS.t30 sg13_lv_nmos ad=0.95p pd=5.38u as=0.95p ps=5.38u w=5u l=0.5u
X106 a_11798_1180.t6 vco_bias_0.vbn_buf.t2 VSS.t22 VSS.t23 sg13_lv_nmos ad=0.95p pd=5.38u as=0.95p ps=5.38u w=5u l=0.5u
X107 VSS.t112 vdd_core.t2 vdd_core.t9 VSS.t111 sg13_lv_nmos ad=0.38p pd=2.38u as=0.38p ps=2.38u w=2u l=0.13u
X108 rf_out_p.t1 a_14668_2644# a_11798_1180.t23 VSS.t133 sg13_lv_nmos ad=0.38p pd=2.38u as=0.38p ps=2.38u w=2u l=0.13u
X109 a_1254_2820.t0 di_en.t0 VSS.t126 VSS.t71 sg13_lv_nmos ad=0.17p pd=1.68u as=0.17p ps=1.68u w=0.5u l=0.13u
X110 VDD.t8 rf_out_n.t6 VSS.t87 rppd l=1.65u w=10u
N111 vdd_core.t32 vtune.t0 sg13_hv_svaricap l=0.3u w=26.34u
X112 VSS.t153 vco_bias_0.vbg_buf VSS.t151 VSS.t55 sg13_lv_nmos ad=1.52p pd=8.38u as=0 ps=0 w=8u l=10u
X113 VSS.t50 vco_bias_0.vbn_buf.t4 VSS.t48 VSS.t49 sg13_lv_nmos ad=1.52p pd=8.38u as=0 ps=0 w=8u l=10u
X114 VSS.t54 vco_bias_0.vbn_buf.t4 VSS.t52 VSS.t53 sg13_lv_nmos ad=1.52p pd=8.38u as=0 ps=0 w=8u l=10u
X115 vdd_core.t26 VSS.t91 cap_cmim l=25.5u w=42u
X116 a_11798_1180.t28 a_14668_2644# rf_out_p.t2 VSS.t142 sg13_lv_nmos ad=0.68p pd=4.68u as=0.38p ps=2.38u w=2u l=0.13u
X117 rf_out_p.t5 a_14668_2644# a_11798_1180.t26 VSS.t139 sg13_lv_nmos ad=0.38p pd=2.38u as=0.38p ps=2.38u w=2u l=0.13u
X118 a_11798_1180.t25 a_14668_2644# rf_out_p.t3 VSS.t136 sg13_lv_nmos ad=0.38p pd=2.38u as=0.38p ps=2.38u w=2u l=0.13u
X119 vco_bias_0.vbg_buf a_9450_4394# VSS.t127 rhigh l=8u w=0.5u
X120 a_11798_1180.t3 vco_bias_0.vbn_buf.t2 VSS.t15 VSS.t16 sg13_lv_nmos ad=0.95p pd=5.38u as=0.95p ps=5.38u w=5u l=0.5u
X121 VSS.t25 vco_bias_0.vbn_buf.t2 a_11798_1180.t6 VSS.t24 sg13_lv_nmos ad=0.95p pd=5.38u as=0.95p ps=5.38u w=5u l=0.5u
X122 rf_out_n.t0 a_9450_4394# a_11798_1180.t16 VSS.t77 sg13_lv_nmos ad=0.38p pd=2.38u as=0.38p ps=2.38u w=2u l=0.13u
R0 ibias_100u.n3 ibias_100u.t1 54.3738
R1 ibias_100u.n0 ibias_100u.t4 34.6784
R2 ibias_100u.n1 ibias_100u.t2 34.2252
R3 ibias_100u.n2 ibias_100u.t0 20.5585
R4 ibias_100u.n0 ibias_100u.t3 14.6093
R5 ibias_100u.n3 ibias_100u.n2 1.7473
R6 ibias_100u ibias_100u.n3 1.2149
R7 ibias_100u.n2 ibias_100u.n1 0.5351
R8 ibias_100u.n1 ibias_100u.n0 0.3173
R9 rf_out_p rf_out_p.n2 6.6125
R10 rf_out_p.n0 rf_out_p.t0 4.77599
R11 rf_out_p.n1 rf_out_p.t2 4.72949
R12 rf_out_p.n1 rf_out_p.t5 4.72949
R13 rf_out_p.n0 rf_out_p.t4 4.72949
R14 rf_out_p.n0 rf_out_p.t3 4.72949
R15 rf_out_p.n0 rf_out_p.t1 4.72949
R16 rf_out_p.n2 rf_out_p.t6 2.40801
R17 rf_out_p.n2 rf_out_p.n1 0.685593
R18 rf_out_p.n1 rf_out_p.n0 0.186531
R19 rf_out_n rf_out_n.n2 6.6125
R20 rf_out_n.n0 rf_out_n.t2 4.77599
R21 rf_out_n.n0 rf_out_n.t5 4.72949
R22 rf_out_n.n0 rf_out_n.t3 4.72949
R23 rf_out_n.n1 rf_out_n.t1 4.72949
R24 rf_out_n.n1 rf_out_n.t0 4.72949
R25 rf_out_n.n1 rf_out_n.t4 4.72949
R26 rf_out_n.n2 rf_out_n.t6 2.40801
R27 rf_out_n.n2 rf_out_n.n1 0.685593
R28 rf_out_n.n1 rf_out_n.n0 0.186531
R29 di_en.n0 di_en.t1 26.3252
R30 di_en.n0 di_en.t0 24.5065
R31 di_en di_en.n0 10.1632
R32 vdd_core.n44 vdd_core.t24 5.04833
R33 vdd_core.n14 vdd_core.t0 4.89028
R34 vdd_core.n3 vdd_core.t9 4.76919
R35 vdd_core.n1 vdd_core.t14 4.76919
R36 vdd_core.n51 vdd_core.t3 4.74635
R37 vdd_core.n18 vdd_core.t5 4.74635
R38 vdd_core.n50 vdd_core.t7 4.72949
R39 vdd_core.n42 vdd_core.t15 4.72949
R40 vdd_core.n4 vdd_core.t12 4.72949
R41 vdd_core.n2 vdd_core.t13 4.72949
R42 vdd_core.n20 vdd_core.t20 4.72949
R43 vdd_core.n21 vdd_core.t6 4.72949
R44 vdd_core.n23 vdd_core.t2 4.1356
R45 vdd_core.n53 vdd_core.t4 3.9789
R46 vdd_core.n14 vdd_core.t27 3.51966
R47 vdd_core.n15 vdd_core.t29 3.51966
R48 vdd_core.n19 vdd_core.t31 3.51966
R49 vdd_core.n44 vdd_core.t28 3.4996
R50 vdd_core.n48 vdd_core.t30 3.4996
R51 vdd_core.n49 vdd_core.t32 3.4996
R52 vdd_core.n4 vdd_core.n3 0.0338961
R53 vdd_core.n2 vdd_core.n1 0.0338961
R54 vdd_core.n40 vdd_core.n38 1.5005
R55 vdd_core.n29 vdd_core.n28 1.5005
R56 vdd_core.n74 vdd_core.n30 1.48507
R57 vdd_core.n52 vdd_core.n51 1.12056
R58 vdd_core.n0 vdd_core.n18 1.12056
R59 vdd_core.n25 vdd_core.n24 0.778589
R60 vdd_core.n54 vdd_core.n39 0.778576
R61 vdd_core.n41 vdd_core.n38 0.767758
R62 vdd_core.n29 vdd_core.n12 0.767758
R63 vdd_core.n55 vdd_core.n41 0.751792
R64 vdd_core.n17 vdd_core.n12 0.751792
R65 vdd_core.n56 vdd_core.n55 0.741729
R66 vdd_core.n17 vdd_core.n13 0.741729
R67 vdd_core.n52 vdd_core.n43 0.741487
R68 vdd_core.n0 vdd_core.n22 0.741487
R69 vdd_core.n47 vdd_core.n46 0.703434
R70 vdd_core.n26 vdd_core.n16 0.703434
R71 vdd_core.n10 vdd_core.n62 0.928728
R72 vdd_core.n58 vdd_core.n57 0.498121
R73 vdd_core.n30 vdd_core.n11 0.498121
R74 vdd_core.t26 vdd_core.n74 0.485212
R75 vdd_core.n0 vdd_core.n19 0.33314
R76 vdd_core.n73 vdd_core.n31 0.314786
R77 vdd_core.n72 vdd_core.n32 0.314786
R78 vdd_core.n49 vdd_core.n48 0.29442
R79 vdd_core.n15 vdd_core.n14 0.29442
R80 vdd_core.n47 vdd_core.n44 0.284212
R81 vdd_core.n65 vdd_core.n35 0.256643
R82 vdd_core.n67 vdd_core.n66 0.222071
R83 vdd_core.n66 vdd_core.n65 0.184357
R84 vdd_core.n63 vdd_core.n35 0.183571
R85 vdd_core.n52 vdd_core.n49 0.175092
R86 vdd_core.n16 vdd_core.n15 0.14834
R87 vdd_core.n19 vdd_core.n16 0.14658
R88 vdd_core.n23 vdd_core.n0 0.14658
R89 vdd_core.n53 vdd_core.n52 0.12898
R90 vdd_core.n73 vdd_core.n32 0.125429
R91 vdd_core.n6 vdd_core.n31 0.0923444
R92 vdd_core.n54 vdd_core.n53 0.0809928
R93 vdd_core.n57 vdd_core.n56 0.0703453
R94 vdd_core.n13 vdd_core.n11 0.0703453
R95 vdd_core vdd_core.t26 0.0649111
R96 vdd_core.n24 vdd_core.n23 0.0633895
R97 vdd_core.n46 vdd_core.n39 0.0593402
R98 vdd_core.n26 vdd_core.n25 0.0593402
R99 vdd_core.n72 vdd_core.n71 0.0515714
R100 vdd_core.n63 vdd_core.n10 0.0483595
R101 vdd_core.n45 vdd_core.n41 0.0338265
R102 vdd_core.n27 vdd_core.n12 0.0334354
R103 vdd_core.n6 vdd_core.n5 0.0107373
R104 vdd_core.n73 vdd_core.n5 0.00934163
R105 vdd_core.n64 vdd_core.n63 0.0315396
R106 vdd_core.n51 vdd_core.n50 0.0310403
R107 vdd_core.n21 vdd_core.n18 0.0310403
R108 vdd_core.n67 vdd_core.n34 0.0304505
R109 vdd_core.n65 vdd_core.n64 0.0304505
R110 vdd_core.n1 vdd_core.n0 0.59294
R111 vdd_core.n65 vdd_core.n34 0.0267475
R112 vdd_core.n57 vdd_core.n39 0.0267154
R113 vdd_core.n25 vdd_core.n11 0.0267154
R114 vdd_core.n50 vdd_core.n43 0.0260771
R115 vdd_core.n22 vdd_core.n21 0.0257351
R116 vdd_core.n22 vdd_core.n20 0.0233414
R117 vdd_core.n37 vdd_core.n36 0.0230739
R118 vdd_core.n43 vdd_core.n42 0.0229994
R119 vdd_core.n42 vdd_core.n4 0.022386
R120 vdd_core.n20 vdd_core.n2 0.022386
R121 vdd_core.n59 vdd_core.n36 0.0219261
R122 vdd_core.n8 vdd_core.n7 0.0123949
R123 vdd_core.n7 vdd_core.n60 0.00986331
R124 vdd_core.n46 vdd_core.n45 0.020388
R125 vdd_core.n27 vdd_core.n26 0.020388
R126 vdd_core.n56 vdd_core.n40 0.0195413
R127 vdd_core.n28 vdd_core.n13 0.0195413
R128 vdd_core.n68 vdd_core.n31 0.0185637
R129 vdd_core.n60 vdd_core.n59 0.0181308
R130 vdd_core.n52 vdd_core.n3 0.59294
R131 vdd_core.n72 vdd_core.n5 0.0301636
R132 vdd_core.n28 vdd_core.n27 0.0149711
R133 vdd_core.n61 vdd_core.n7 0.0322965
R134 vdd_core.n45 vdd_core.n40 0.01458
R135 vdd_core.n70 vdd_core.n32 0.0134951
R136 vdd_core.n68 vdd_core.n32 0.0125784
R137 vdd_core.n71 vdd_core.n70 0.0125784
R138 vdd_core.n58 vdd_core.n8 0.7269
R139 vdd_core.n48 vdd_core.n47 0.010708
R140 vdd_core.n24 vdd_core.n17 0.0103252
R141 vdd_core.n55 vdd_core.n54 0.0103207
R142 vdd_core.n59 vdd_core.n8 0.016582
R143 vdd_core.n64 vdd_core.n33 0.00841435
R144 vdd_core.n61 vdd_core.n37 0.00737127
R145 vdd_core.n58 vdd_core.n38 0.00722611
R146 vdd_core.n30 vdd_core.n29 0.00722611
R147 vdd_core.n69 vdd_core.n68 0.00718951
R148 vdd_core.n62 vdd_core.n61 0.00703478
R149 vdd_core.n69 vdd_core.n67 0.00681683
R150 vdd_core.n9 vdd_core.n10 0.00452013
R151 vdd_core.n60 vdd_core.n37 0.00651402
R152 vdd_core.n71 vdd_core.n33 0.00637745
R153 vdd_core.n62 vdd_core.n36 0.00601652
R154 vdd_core.n70 vdd_core.n69 0.00476338
R155 vdd_core.n34 vdd_core.n33 0.00476338
R156 vdd_core.n70 vdd_core.n34 0.0040803
R157 vdd_core.n9 vdd_core.n35 0.00151948
R158 vdd_core.n9 vdd_core.n66 0.0111422
R159 vdd_core.n74 vdd_core.n6 0.467907
R160 vtune.n0 vtune.t0 16.1774
R161 vtune vtune.n1 16.1137
R162 vtune.n0 vtune.t3 14.7078
R163 vtune.n1 vtune.t6 14.7078
R164 vtune.n1 vtune.n0 1.4701
R165 VDD VDD.n9 17.6809
R166 VDD.n7 VDD.t9 17.0005
R167 VDD.n5 VDD.t0 17.0005
R168 VDD.n3 VDD.t2 17.0005
R169 VDD VDD.n8 16.7718
R170 VDD.n1 VDD.t4 11.3356
R171 VDD.n0 VDD.t6 11.3356
R172 VDD.n7 VDD.t10 6.19097
R173 VDD.n5 VDD.t1 6.19097
R174 VDD.n3 VDD.t3 6.19097
R175 VDD.n9 VDD.t11 4.22454
R176 VDD.n0 VDD.t7 2.44341
R177 VDD.n1 VDD.t5 2.44322
R178 VDD.n2 VDD.n0 1.42463
R179 VDD.n4 VDD.n2 0.851625
R180 VDD.n8 VDD.n7 0.751488
R181 VDD.n6 VDD.n5 0.751488
R182 VDD.n4 VDD.n3 0.751488
R183 VDD.n9 VDD.t8 0.517741
R184 VDD.n8 VDD.n6 0.370375
R185 VDD.n6 VDD.n4 0.370375
R186 VDD.n2 VDD.n1 0.143127
R187 VSS.n223 VSS.n196 19554.9
R188 VSS.n396 VSS.n393 2420.69
R189 VSS.n396 VSS.n395 1880.72
R190 VSS.n468 VSS.n467 1094.66
R191 VSS.t71 VSS.n396 900.284
R192 VSS.n392 VSS.t125 358.603
R193 VSS.t143 VSS.t130 301.887
R194 VSS.t125 VSS.t88 141.554
R195 VSS.n83 VSS.t143 109.811
R196 VSS.n412 VSS.n392 89.1795
R197 VSS.t57 VSS.t69 70.7775
R198 VSS.n412 VSS.n411 52.3755
R199 VSS.n411 VSS.n397 47.1851
R200 VSS.n397 VSS.t57 33.0298
R201 VSS.n251 VSS.n51 25.2835
R202 VSS.t69 VSS.t71 23.5928
R203 VSS.n200 VSS.n198 20.9925
R204 VSS.n195 VSS.n194 20.9925
R205 VSS.n205 VSS.n203 20.9925
R206 VSS.n209 VSS.n208 20.9925
R207 VSS.n164 VSS.n163 20.9925
R208 VSS.n242 VSS.n240 20.9925
R209 VSS.n150 VSS.n149 20.9925
R210 VSS.n247 VSS.n245 20.9925
R211 VSS.n145 VSS.n144 20.9925
R212 VSS.n224 VSS.n223 20.0664
R213 VSS.n188 VSS.t46 19.7577
R214 VSS.n395 VSS.n192 17.5967
R215 VSS.n399 VSS.t126 17.4597
R216 VSS.n401 VSS.t72 17.4597
R217 VSS.n399 VSS.n397 17.0005
R218 VSS.n401 VSS.n397 17.0005
R219 VSS.n411 VSS.n398 17.0005
R220 VSS.n411 VSS.n410 17.0005
R221 VSS.n436 VSS.n435 17.0005
R222 VSS.n436 VSS.n420 17.0005
R223 VSS.n436 VSS.n434 17.0005
R224 VSS.n436 VSS.n421 17.0005
R225 VSS.n436 VSS.n433 17.0005
R226 VSS.n436 VSS.n422 17.0005
R227 VSS.n436 VSS.n432 17.0005
R228 VSS.n436 VSS.n423 17.0005
R229 VSS.n436 VSS.n431 17.0005
R230 VSS.n436 VSS.n424 17.0005
R231 VSS.n436 VSS.n430 17.0005
R232 VSS.n436 VSS.n425 17.0005
R233 VSS.n436 VSS.n429 17.0005
R234 VSS.n436 VSS.n426 17.0005
R235 VSS.n436 VSS.n428 17.0005
R236 VSS.n436 VSS.n427 17.0005
R237 VSS.n470 VSS.n469 17.0005
R238 VSS.n471 VSS.n470 17.0005
R239 VSS.n470 VSS.n111 17.0005
R240 VSS.n470 VSS.n109 17.0005
R241 VSS.n470 VSS.n110 17.0005
R242 VSS.n39 VSS.n38 0.790948
R243 VSS.n7 VSS.n472 17.0005
R244 VSS.n7 VSS.n42 17.0005
R245 VSS.n7 VSS.n61 17.0005
R246 VSS.n7 VSS.n43 17.0005
R247 VSS.n7 VSS.n60 17.0005
R248 VSS.n7 VSS.n44 17.0005
R249 VSS.n7 VSS.n59 17.0005
R250 VSS.n7 VSS.n45 17.0005
R251 VSS.n7 VSS.n58 17.0005
R252 VSS.n7 VSS.n46 17.0005
R253 VSS.n7 VSS.n57 17.0005
R254 VSS.n7 VSS.n47 17.0005
R255 VSS.n7 VSS.n56 17.0005
R256 VSS.n7 VSS.n48 17.0005
R257 VSS.n7 VSS.n55 17.0005
R258 VSS.n7 VSS.n49 17.0005
R259 VSS.n7 VSS.n54 17.0005
R260 VSS.n7 VSS.n51 17.0005
R261 VSS.n470 VSS.n112 17.0005
R262 VSS.n470 VSS.n443 17.0005
R263 VSS.n470 VSS.n444 17.0005
R264 VSS.n470 VSS.n445 17.0005
R265 VSS.n470 VSS.n446 17.0005
R266 VSS.n470 VSS.n447 17.0005
R267 VSS.n470 VSS.n448 17.0005
R268 VSS.n470 VSS.n449 17.0005
R269 VSS.n470 VSS.n450 17.0005
R270 VSS.n470 VSS.n451 17.0005
R271 VSS.n470 VSS.n452 17.0005
R272 VSS.n470 VSS.n453 17.0005
R273 VSS.n470 VSS.n454 17.0005
R274 VSS.n470 VSS.n455 17.0005
R275 VSS.n470 VSS.n456 17.0005
R276 VSS.n470 VSS.n457 17.0005
R277 VSS.n470 VSS.n458 17.0005
R278 VSS.n470 VSS.n459 17.0005
R279 VSS.n470 VSS.n460 17.0005
R280 VSS.n470 VSS.n461 17.0005
R281 VSS.n470 VSS.n462 17.0005
R282 VSS.n470 VSS.n463 17.0005
R283 VSS.n470 VSS.n464 17.0005
R284 VSS.n470 VSS.n465 17.0005
R285 VSS.n470 VSS.n466 17.0005
R286 VSS.n7 VSS.n62 17.0005
R287 VSS.n7 VSS.n84 17.0005
R288 VSS.n7 VSS.n85 17.0005
R289 VSS.n7 VSS.n86 17.0005
R290 VSS.n7 VSS.n87 17.0005
R291 VSS.n7 VSS.n88 17.0005
R292 VSS.n7 VSS.n89 17.0005
R293 VSS.n7 VSS.n90 17.0005
R294 VSS.n7 VSS.n91 17.0005
R295 VSS.n7 VSS.n92 17.0005
R296 VSS.n7 VSS.n93 17.0005
R297 VSS.n7 VSS.n94 17.0005
R298 VSS.n7 VSS.n95 17.0005
R299 VSS.n7 VSS.n96 17.0005
R300 VSS.n7 VSS.n97 17.0005
R301 VSS.n7 VSS.n98 17.0005
R302 VSS.n7 VSS.n99 17.0005
R303 VSS.n7 VSS.n100 17.0005
R304 VSS.n7 VSS.n101 17.0005
R305 VSS.n7 VSS.n102 17.0005
R306 VSS.n7 VSS.n103 17.0005
R307 VSS.n7 VSS.n104 17.0005
R308 VSS.n7 VSS.n105 17.0005
R309 VSS.n7 VSS.n106 17.0005
R310 VSS.n7 VSS.n107 17.0005
R311 VSS.n7 VSS.n108 17.0005
R312 VSS.n439 VSS.n438 17.0005
R313 VSS.n439 VSS.n118 17.0005
R314 VSS.n439 VSS.n131 17.0005
R315 VSS.n439 VSS.n119 17.0005
R316 VSS.n439 VSS.n130 17.0005
R317 VSS.n439 VSS.n120 17.0005
R318 VSS.n439 VSS.n129 17.0005
R319 VSS.n439 VSS.n121 17.0005
R320 VSS.n439 VSS.n128 17.0005
R321 VSS.n439 VSS.n122 17.0005
R322 VSS.n439 VSS.n127 17.0005
R323 VSS.n439 VSS.n123 17.0005
R324 VSS.n439 VSS.n126 17.0005
R325 VSS.n440 VSS.n439 17.0005
R326 VSS.n439 VSS.n125 17.0005
R327 VSS.n439 VSS.n124 17.0005
R328 VSS.n470 VSS.n442 17.0005
R329 VSS.n470 VSS.n116 17.0005
R330 VSS.n470 VSS.n115 17.0005
R331 VSS.n470 VSS.n114 17.0005
R332 VSS.n470 VSS.n113 17.0005
R333 VSS.n7 VSS.n83 17.0005
R334 VSS.n7 VSS.n79 17.0005
R335 VSS.n7 VSS.n78 17.0005
R336 VSS.n7 VSS.n77 17.0005
R337 VSS.n7 VSS.n76 17.0005
R338 VSS.n7 VSS.n75 17.0005
R339 VSS.n7 VSS.n74 17.0005
R340 VSS.n7 VSS.n73 17.0005
R341 VSS.n7 VSS.n72 17.0005
R342 VSS.n7 VSS.n71 17.0005
R343 VSS.n7 VSS.n70 17.0005
R344 VSS.n7 VSS.n69 17.0005
R345 VSS.n7 VSS.n68 17.0005
R346 VSS.n7 VSS.n67 17.0005
R347 VSS.n7 VSS.n66 17.0005
R348 VSS.n7 VSS.n65 17.0005
R349 VSS.n7 VSS.n64 17.0005
R350 VSS.n7 VSS.n63 17.0005
R351 VSS.n53 VSS.t10 15.6019
R352 VSS.t41 VSS.n80 15.6019
R353 VSS.n82 VSS.t43 14.4834
R354 VSS.n52 VSS.t8 14.4827
R355 VSS.n414 VSS.n412 14.201
R356 VSS.t8 VSS.n50 12.9739
R357 VSS.t43 VSS.n81 12.9739
R358 VSS.t6 VSS.n51 12.4533
R359 VSS.n83 VSS.t44 12.4533
R360 VSS.n466 VSS.n108 12.3761
R361 VSS.n465 VSS.n107 12.3761
R362 VSS.n465 VSS.n106 12.3761
R363 VSS.n464 VSS.n105 12.3761
R364 VSS.n462 VSS.n104 12.3761
R365 VSS.n462 VSS.n103 12.3761
R366 VSS.n461 VSS.n102 12.3761
R367 VSS.n459 VSS.n101 12.3761
R368 VSS.n459 VSS.n100 12.3761
R369 VSS.n458 VSS.n100 12.3761
R370 VSS.n457 VSS.n99 12.3761
R371 VSS.n457 VSS.n98 12.3761
R372 VSS.n456 VSS.n98 12.3761
R373 VSS.n456 VSS.n97 12.3761
R374 VSS.n455 VSS.n96 12.3761
R375 VSS.n454 VSS.n96 12.3761
R376 VSS.n454 VSS.n95 12.3761
R377 VSS.n453 VSS.n95 12.3761
R378 VSS.n452 VSS.n94 12.3761
R379 VSS.n452 VSS.n93 12.3761
R380 VSS.n451 VSS.n93 12.3761
R381 VSS.n451 VSS.n92 12.3761
R382 VSS.n450 VSS.n91 12.3761
R383 VSS.n449 VSS.n91 12.3761
R384 VSS.n449 VSS.n90 12.3761
R385 VSS.n447 VSS.n89 12.3761
R386 VSS.n446 VSS.n88 12.3761
R387 VSS.n446 VSS.n87 12.3761
R388 VSS.n444 VSS.n86 12.3761
R389 VSS.n443 VSS.n85 12.3761
R390 VSS.n443 VSS.n84 12.3761
R391 VSS.n112 VSS.n62 12.3761
R392 VSS.n393 VSS.n238 12.3487
R393 VSS.t55 VSS.n278 12.076
R394 VSS.t74 VSS.n351 11.6986
R395 VSS.n460 VSS.t23 11.6482
R396 VSS.n448 VSS.t30 11.6482
R397 VSS.n419 VSS.t89 11.5239
R398 VSS.n404 VSS.n392 11.3338
R399 VSS.n406 VSS.n392 11.3338
R400 VSS.n408 VSS.n392 11.3338
R401 VSS.n312 VSS.t127 11.3213
R402 VSS.n235 VSS.t49 11.1139
R403 VSS.t21 VSS.n105 10.9202
R404 VSS.t4 VSS.n86 10.9202
R405 VSS.t49 VSS.n234 9.87908
R406 VSS.t83 VSS.n106 9.82821
R407 VSS.n463 VSS.t84 9.82821
R408 VSS.t85 VSS.n103 9.82821
R409 VSS.n460 VSS.t86 9.82821
R410 VSS.n448 VSS.t131 9.82821
R411 VSS.t132 VSS.n88 9.82821
R412 VSS.n445 VSS.t133 9.82821
R413 VSS.t134 VSS.n85 9.82821
R414 VSS.n416 VSS.n141 9.81182
R415 VSS.n417 VSS.n142 9.81182
R416 VSS.n342 VSS.n132 9.81182
R417 VSS.n341 VSS.n140 9.81182
R418 VSS.n340 VSS.n133 9.81182
R419 VSS.n339 VSS.n139 9.81182
R420 VSS.n338 VSS.n134 9.81182
R421 VSS.n336 VSS.n135 9.81182
R422 VSS.n335 VSS.n137 9.81182
R423 VSS.n334 VSS.n136 9.81182
R424 VSS.n179 VSS.n40 9.75612
R425 VSS.t24 VSS.n99 9.46422
R426 VSS.t29 VSS.n92 9.46422
R427 VSS.n34 VSS.n40 9.55191
R428 VSS.n157 VSS.n156 9.39463
R429 VSS.n159 VSS.n158 9.39463
R430 VSS.n161 VSS.n160 9.39463
R431 VSS.n228 VSS.n166 9.39463
R432 VSS.n218 VSS.n217 9.39463
R433 VSS.n214 VSS.n212 9.39463
R434 VSS.n185 VSS.n184 9.39463
R435 VSS.n190 VSS.n189 9.39463
R436 VSS.n206 VSS.n204 9.39463
R437 VSS.n232 VSS.n231 9.39463
R438 VSS.n227 VSS.n226 9.39463
R439 VSS.n222 VSS.n221 9.39463
R440 VSS.n217 VSS.n216 9.39463
R441 VSS.n212 VSS.n211 9.39463
R442 VSS.n201 VSS.n199 9.39463
R443 VSS.n202 VSS.n193 9.39463
R444 VSS.n191 VSS.n190 9.39463
R445 VSS.n186 VSS.n185 9.39463
R446 VSS.n207 VSS.n184 9.39463
R447 VSS.n211 VSS.n210 9.39463
R448 VSS.n215 VSS.n214 9.39463
R449 VSS.n215 VSS.n213 9.39463
R450 VSS.n213 VSS.n183 9.39463
R451 VSS.n216 VSS.n183 9.39463
R452 VSS.n219 VSS.n218 9.39463
R453 VSS.n221 VSS.n219 9.39463
R454 VSS.n222 VSS.n220 9.39463
R455 VSS.n227 VSS.n225 9.39463
R456 VSS.n225 VSS.n166 9.39463
R457 VSS.n229 VSS.n228 9.39463
R458 VSS.n231 VSS.n229 9.39463
R459 VSS.n232 VSS.n230 9.39463
R460 VSS.n230 VSS.n165 9.39463
R461 VSS.n236 VSS.n233 9.39463
R462 VSS.n162 VSS.n161 9.39463
R463 VSS.n160 VSS.n159 9.39463
R464 VSS.n158 VSS.n157 9.39463
R465 VSS.n237 VSS.n156 9.39463
R466 VSS.n154 VSS.n153 9.39463
R467 VSS.n239 VSS.n153 9.39463
R468 VSS.n243 VSS.n241 9.39463
R469 VSS.n241 VSS.n151 9.39463
R470 VSS.n248 VSS.n246 9.39463
R471 VSS.n246 VSS.n148 9.39463
R472 VSS.n148 VSS.n147 9.39463
R473 VSS.n147 VSS.n146 9.39463
R474 VSS.n81 VSS.t41 9.19965
R475 VSS.t10 VSS.n50 9.19965
R476 VSS.n427 VSS.n53 9.18684
R477 VSS.n438 VSS.n80 9.18684
R478 VSS.n468 VSS.n108 9.10023
R479 VSS.n467 VSS.n62 9.10023
R480 VSS.n473 VSS.n2 9.0005
R481 VSS.n1 VSS.n37 9.0005
R482 VSS.n466 VSS.t20 8.73624
R483 VSS.n112 VSS.t31 8.73624
R484 VSS.n393 VSS.n155 8.64425
R485 VSS.n415 VSS.n414 8.5005
R486 VSS.n415 VSS.n144 8.5005
R487 VSS.n415 VSS.n245 8.5005
R488 VSS.n415 VSS.n149 8.5005
R489 VSS.n415 VSS.n240 8.5005
R490 VSS.n415 VSS.n155 8.5005
R491 VSS.n415 VSS.n238 8.5005
R492 VSS.n415 VSS.n164 8.5005
R493 VSS.n415 VSS.n224 8.5005
R494 VSS.n415 VSS.n167 8.5005
R495 VSS.n415 VSS.n208 8.5005
R496 VSS.n415 VSS.n192 8.5005
R497 VSS.n415 VSS.n203 8.5005
R498 VSS.n415 VSS.n195 8.5005
R499 VSS.n415 VSS.n198 8.5005
R500 VSS.n415 VSS.n196 8.5005
R501 VSS.n145 VSS.n143 8.5005
R502 VSS.n150 VSS.n143 8.5005
R503 VSS.n163 VSS.n143 8.5005
R504 VSS.n234 VSS.n143 8.5005
R505 VSS.n187 VSS.n143 8.5005
R506 VSS.n394 VSS.n143 8.5005
R507 VSS.n194 VSS.n143 8.5005
R508 VSS.n247 VSS.n143 8.5005
R509 VSS.n242 VSS.n143 8.5005
R510 VSS.n235 VSS.n143 8.5005
R511 VSS.n209 VSS.n143 8.5005
R512 VSS.n188 VSS.n143 8.5005
R513 VSS.n205 VSS.n143 8.5005
R514 VSS.n200 VSS.n143 8.5005
R515 VSS.n415 VSS.n251 8.5005
R516 VSS.n415 VSS.n253 8.5005
R517 VSS.n415 VSS.n255 8.5005
R518 VSS.n415 VSS.n257 8.5005
R519 VSS.n415 VSS.n259 8.5005
R520 VSS.n415 VSS.n261 8.5005
R521 VSS.n415 VSS.n263 8.5005
R522 VSS.n415 VSS.n264 8.5005
R523 VSS.n415 VSS.n266 8.5005
R524 VSS.n415 VSS.n268 8.5005
R525 VSS.n415 VSS.n270 8.5005
R526 VSS.n415 VSS.n272 8.5005
R527 VSS.n415 VSS.n274 8.5005
R528 VSS.n415 VSS.n276 8.5005
R529 VSS.n415 VSS.n278 8.5005
R530 VSS.n415 VSS.n279 8.5005
R531 VSS.n415 VSS.n281 8.5005
R532 VSS.n415 VSS.n283 8.5005
R533 VSS.n415 VSS.n285 8.5005
R534 VSS.n415 VSS.n287 8.5005
R535 VSS.n415 VSS.n289 8.5005
R536 VSS.n415 VSS.n291 8.5005
R537 VSS.n415 VSS.n293 8.5005
R538 VSS.n415 VSS.n295 8.5005
R539 VSS.n415 VSS.n297 8.5005
R540 VSS.n415 VSS.n299 8.5005
R541 VSS.n415 VSS.n301 8.5005
R542 VSS.n415 VSS.n303 8.5005
R543 VSS.n415 VSS.n305 8.5005
R544 VSS.n415 VSS.n307 8.5005
R545 VSS.n415 VSS.n309 8.5005
R546 VSS.n415 VSS.n312 8.5005
R547 VSS.n415 VSS.n314 8.5005
R548 VSS.n415 VSS.n316 8.5005
R549 VSS.n415 VSS.n318 8.5005
R550 VSS.n415 VSS.n320 8.5005
R551 VSS.n415 VSS.n322 8.5005
R552 VSS.n415 VSS.n324 8.5005
R553 VSS.n415 VSS.n326 8.5005
R554 VSS.n415 VSS.n328 8.5005
R555 VSS.n415 VSS.n330 8.5005
R556 VSS.n415 VSS.n332 8.5005
R557 VSS.n415 VSS.n334 8.5005
R558 VSS.n415 VSS.n335 8.5005
R559 VSS.n415 VSS.n336 8.5005
R560 VSS.n415 VSS.n337 8.5005
R561 VSS.n415 VSS.n338 8.5005
R562 VSS.n415 VSS.n339 8.5005
R563 VSS.n415 VSS.n340 8.5005
R564 VSS.n415 VSS.n341 8.5005
R565 VSS.n415 VSS.n342 8.5005
R566 VSS.n415 VSS.n142 8.5005
R567 VSS.n416 VSS.n415 8.5005
R568 VSS.n415 VSS.n343 8.5005
R569 VSS.n415 VSS.n345 8.5005
R570 VSS.n415 VSS.n347 8.5005
R571 VSS.n415 VSS.n349 8.5005
R572 VSS.n415 VSS.n351 8.5005
R573 VSS.n415 VSS.n352 8.5005
R574 VSS.n415 VSS.n354 8.5005
R575 VSS.n415 VSS.n356 8.5005
R576 VSS.n415 VSS.n361 8.5005
R577 VSS.n415 VSS.n363 8.5005
R578 VSS.n415 VSS.n365 8.5005
R579 VSS.n415 VSS.n367 8.5005
R580 VSS.n415 VSS.n369 8.5005
R581 VSS.n415 VSS.n371 8.5005
R582 VSS.n415 VSS.n373 8.5005
R583 VSS.n415 VSS.n375 8.5005
R584 VSS.n415 VSS.n377 8.5005
R585 VSS.n415 VSS.n379 8.5005
R586 VSS.n415 VSS.n381 8.5005
R587 VSS.n415 VSS.n383 8.5005
R588 VSS.n415 VSS.n385 8.5005
R589 VSS.n415 VSS.n387 8.5005
R590 VSS.n415 VSS.n389 8.5005
R591 VSS.n415 VSS.n391 8.5005
R592 VSS.n335 VSS.n143 8.5005
R593 VSS.n336 VSS.n143 8.5005
R594 VSS.n337 VSS.n143 8.5005
R595 VSS.n338 VSS.n143 8.5005
R596 VSS.n339 VSS.n143 8.5005
R597 VSS.n340 VSS.n143 8.5005
R598 VSS.n341 VSS.n143 8.5005
R599 VSS.n342 VSS.n143 8.5005
R600 VSS.n143 VSS.n142 8.5005
R601 VSS.n416 VSS.n143 8.5005
R602 VSS.n428 VSS.n49 8.30239
R603 VSS.n429 VSS.n48 8.30239
R604 VSS.n425 VSS.n56 8.30239
R605 VSS.n424 VSS.n57 8.30239
R606 VSS.n431 VSS.n46 8.30239
R607 VSS.n422 VSS.n59 8.30239
R608 VSS.n127 VSS.n69 8.30239
R609 VSS.n121 VSS.n72 8.30239
R610 VSS.n129 VSS.n73 8.30239
R611 VSS.n130 VSS.n75 8.30239
R612 VSS.n119 VSS.n76 8.30239
R613 VSS.n118 VSS.n78 8.30239
R614 VSS.n180 VSS.n179 7.76695
R615 VSS.n52 VSS.t6 7.69091
R616 VSS.t44 VSS.n82 7.69022
R617 VSS.t87 VSS.n263 7.54767
R618 VSS.n455 VSS.t26 7.28029
R619 VSS.n453 VSS.t27 7.28029
R620 VSS.n432 VSS.t76 6.98163
R621 VSS.n421 VSS.t78 6.98163
R622 VSS.n126 VSS.t139 6.98163
R623 VSS.n122 VSS.t141 6.98163
R624 VSS.n412 VSS.t51 6.79202
R625 VSS.n472 VSS.n471 6.41559
R626 VSS.n114 VSS.n63 6.41559
R627 VSS.n410 VSS.t70 6.19054
R628 VSS.n398 VSS.t73 6.19054
R629 VSS.n254 VSS.n143 6.17223
R630 VSS.n256 VSS.n143 6.17223
R631 VSS.n258 VSS.n143 6.17223
R632 VSS.n260 VSS.n143 6.17223
R633 VSS.n267 VSS.n143 6.17223
R634 VSS.n269 VSS.n143 6.17223
R635 VSS.n271 VSS.n143 6.17223
R636 VSS.n273 VSS.n143 6.17223
R637 VSS.n275 VSS.n143 6.17223
R638 VSS.n282 VSS.n143 6.17223
R639 VSS.n284 VSS.n143 6.17223
R640 VSS.n286 VSS.n143 6.17223
R641 VSS.n288 VSS.n143 6.17223
R642 VSS.n290 VSS.n143 6.17223
R643 VSS.n292 VSS.n143 6.17223
R644 VSS.n294 VSS.n143 6.17223
R645 VSS.n296 VSS.n143 6.17223
R646 VSS.n298 VSS.n143 6.17223
R647 VSS.n300 VSS.n143 6.17223
R648 VSS.n302 VSS.n143 6.17223
R649 VSS.n304 VSS.n143 6.17223
R650 VSS.n306 VSS.n143 6.17223
R651 VSS.n315 VSS.n143 6.17223
R652 VSS.n317 VSS.n143 6.17223
R653 VSS.n319 VSS.n143 6.17223
R654 VSS.n321 VSS.n143 6.17223
R655 VSS.n323 VSS.n143 6.17223
R656 VSS.n325 VSS.n143 6.17223
R657 VSS.n327 VSS.n143 6.17223
R658 VSS.n329 VSS.n143 6.17223
R659 VSS.n331 VSS.n143 6.17223
R660 VSS.n346 VSS.n143 6.17223
R661 VSS.n348 VSS.n143 6.17223
R662 VSS.n355 VSS.n143 6.17223
R663 VSS.n360 VSS.n143 6.17223
R664 VSS.n362 VSS.n143 6.17223
R665 VSS.n364 VSS.n143 6.17223
R666 VSS.n366 VSS.n143 6.17223
R667 VSS.n368 VSS.n143 6.17223
R668 VSS.n370 VSS.n143 6.17223
R669 VSS.n372 VSS.n143 6.17223
R670 VSS.n374 VSS.n143 6.17223
R671 VSS.n376 VSS.n143 6.17223
R672 VSS.n378 VSS.n143 6.17223
R673 VSS.n380 VSS.n143 6.17223
R674 VSS.n382 VSS.n143 6.17223
R675 VSS.n384 VSS.n143 6.17223
R676 VSS.n386 VSS.n143 6.17223
R677 VSS.n388 VSS.n143 6.17223
R678 VSS.n7 VSS.n53 6.17223
R679 VSS.n7 VSS.n80 6.17223
R680 VSS.n337 VSS.t53 6.03824
R681 VSS.n253 VSS.n252 5.69203
R682 VSS.n266 VSS.n265 5.69203
R683 VSS.n281 VSS.n280 5.69203
R684 VSS.n314 VSS.n313 5.69203
R685 VSS.n345 VSS.n344 5.69203
R686 VSS.n354 VSS.n353 5.69203
R687 VSS.n262 VSS.n261 5.69138
R688 VSS.n277 VSS.n276 5.69138
R689 VSS.n308 VSS.n307 5.69138
R690 VSS.n333 VSS.n332 5.69138
R691 VSS.n350 VSS.n349 5.69138
R692 VSS.n390 VSS.n389 5.69138
R693 VSS.n418 VSS.n141 5.66717
R694 VSS.n418 VSS.n417 5.66717
R695 VSS.n418 VSS.n132 5.66717
R696 VSS.n418 VSS.n140 5.66717
R697 VSS.n418 VSS.n133 5.66717
R698 VSS.n418 VSS.n139 5.66717
R699 VSS.n418 VSS.n134 5.66717
R700 VSS.n418 VSS.n138 5.66717
R701 VSS.n418 VSS.n135 5.66717
R702 VSS.n418 VSS.n137 5.66717
R703 VSS.n418 VSS.n136 5.66717
R704 VSS.n5 VSS.n4 0.15257
R705 VSS.n436 VSS.n5 1.82581
R706 VSS.n13 VSS.n27 0.066765
R707 VSS.n30 VSS.n31 0.0585658
R708 VSS.n439 VSS.n30 2.7974
R709 VSS.n17 VSS.n29 0.066765
R710 VSS.n439 VSS.n26 5.65086
R711 VSS.n264 VSS.t87 5.28352
R712 VSS.t26 VSS.n97 5.09635
R713 VSS.t27 VSS.n94 5.09635
R714 VSS.t95 VSS.n55 5.09484
R715 VSS.t101 VSS.n58 5.09484
R716 VSS.t104 VSS.n44 5.09484
R717 VSS.t107 VSS.n61 5.09484
R718 VSS.n111 VSS.t80 5.09484
R719 VSS.n472 VSS.t81 5.09484
R720 VSS.t136 VSS.n63 5.09484
R721 VSS.n115 VSS.t137 5.09484
R722 VSS.t109 VSS.n65 5.09484
R723 VSS.t113 VSS.n68 5.09484
R724 VSS.t116 VSS.n71 5.09484
R725 VSS.t122 VSS.n77 5.09484
R726 VSS.n427 VSS.t11 4.90616
R727 VSS.n438 VSS.t38 4.90616
R728 VSS.n146 VSS.n145 4.69757
R729 VSS.n248 VSS.n247 4.69757
R730 VSS.n151 VSS.n150 4.69757
R731 VSS.n243 VSS.n242 4.69757
R732 VSS.n163 VSS.n162 4.69757
R733 VSS.n236 VSS.n235 4.69757
R734 VSS.n234 VSS.n165 4.69757
R735 VSS.n210 VSS.n209 4.69757
R736 VSS.n187 VSS.n186 4.69757
R737 VSS.n394 VSS.n191 4.69757
R738 VSS.n206 VSS.n205 4.69757
R739 VSS.n194 VSS.n193 4.69757
R740 VSS.n201 VSS.n200 4.69757
R741 VSS.n414 VSS.n413 4.69757
R742 VSS.n245 VSS.n244 4.69757
R743 VSS.n240 VSS.n239 4.69757
R744 VSS.n238 VSS.n237 4.69757
R745 VSS.n208 VSS.n207 4.69757
R746 VSS.n203 VSS.n202 4.69757
R747 VSS.n198 VSS.n197 4.69757
R748 VSS.n155 VSS.n154 4.69757
R749 VSS.n233 VSS.n164 4.69757
R750 VSS.n220 VSS.n167 4.69757
R751 VSS.n199 VSS.n195 4.69757
R752 VSS.n197 VSS.n196 4.69757
R753 VSS.n204 VSS.n192 4.69757
R754 VSS.n189 VSS.n188 4.69757
R755 VSS.n226 VSS.n224 4.69757
R756 VSS.n244 VSS.n149 4.69757
R757 VSS.n413 VSS.n144 4.69757
R758 VSS.n31 VSS.t89 4.69693
R759 VSS.n179 VSS.n178 4.67815
R760 VSS.n254 VSS.n253 4.65853
R761 VSS.n256 VSS.n255 4.65853
R762 VSS.n258 VSS.n257 4.65853
R763 VSS.n260 VSS.n259 4.65853
R764 VSS.n267 VSS.n266 4.65853
R765 VSS.n269 VSS.n268 4.65853
R766 VSS.n271 VSS.n270 4.65853
R767 VSS.n273 VSS.n272 4.65853
R768 VSS.n275 VSS.n274 4.65853
R769 VSS.n282 VSS.n281 4.65853
R770 VSS.n284 VSS.n283 4.65853
R771 VSS.n286 VSS.n285 4.65853
R772 VSS.n288 VSS.n287 4.65853
R773 VSS.n290 VSS.n289 4.65853
R774 VSS.n292 VSS.n291 4.65853
R775 VSS.n294 VSS.n293 4.65853
R776 VSS.n296 VSS.n295 4.65853
R777 VSS.n298 VSS.n297 4.65853
R778 VSS.n300 VSS.n299 4.65853
R779 VSS.n302 VSS.n301 4.65853
R780 VSS.n304 VSS.n303 4.65853
R781 VSS.n306 VSS.n305 4.65853
R782 VSS.n315 VSS.n314 4.65853
R783 VSS.n317 VSS.n316 4.65853
R784 VSS.n319 VSS.n318 4.65853
R785 VSS.n321 VSS.n320 4.65853
R786 VSS.n323 VSS.n322 4.65853
R787 VSS.n325 VSS.n324 4.65853
R788 VSS.n327 VSS.n326 4.65853
R789 VSS.n329 VSS.n328 4.65853
R790 VSS.n331 VSS.n330 4.65853
R791 VSS.n346 VSS.n345 4.65853
R792 VSS.n348 VSS.n347 4.65853
R793 VSS.n355 VSS.n354 4.65853
R794 VSS.n360 VSS.n356 4.65853
R795 VSS.n362 VSS.n361 4.65853
R796 VSS.n364 VSS.n363 4.65853
R797 VSS.n366 VSS.n365 4.65853
R798 VSS.n368 VSS.n367 4.65853
R799 VSS.n370 VSS.n369 4.65853
R800 VSS.n372 VSS.n371 4.65853
R801 VSS.n374 VSS.n373 4.65853
R802 VSS.n376 VSS.n375 4.65853
R803 VSS.n378 VSS.n377 4.65853
R804 VSS.n380 VSS.n379 4.65853
R805 VSS.n382 VSS.n381 4.65853
R806 VSS.n384 VSS.n383 4.65853
R807 VSS.n386 VSS.n385 4.65853
R808 VSS.n388 VSS.n387 4.65853
R809 VSS.n389 VSS.n388 4.65853
R810 VSS.n387 VSS.n386 4.65853
R811 VSS.n385 VSS.n384 4.65853
R812 VSS.n383 VSS.n382 4.65853
R813 VSS.n381 VSS.n380 4.65853
R814 VSS.n379 VSS.n378 4.65853
R815 VSS.n377 VSS.n376 4.65853
R816 VSS.n375 VSS.n374 4.65853
R817 VSS.n373 VSS.n372 4.65853
R818 VSS.n371 VSS.n370 4.65853
R819 VSS.n369 VSS.n368 4.65853
R820 VSS.n367 VSS.n366 4.65853
R821 VSS.n365 VSS.n364 4.65853
R822 VSS.n363 VSS.n362 4.65853
R823 VSS.n361 VSS.n360 4.65853
R824 VSS.n356 VSS.n355 4.65853
R825 VSS.n349 VSS.n348 4.65853
R826 VSS.n347 VSS.n346 4.65853
R827 VSS.n332 VSS.n331 4.65853
R828 VSS.n330 VSS.n329 4.65853
R829 VSS.n328 VSS.n327 4.65853
R830 VSS.n326 VSS.n325 4.65853
R831 VSS.n324 VSS.n323 4.65853
R832 VSS.n322 VSS.n321 4.65853
R833 VSS.n320 VSS.n319 4.65853
R834 VSS.n318 VSS.n317 4.65853
R835 VSS.n316 VSS.n315 4.65853
R836 VSS.n307 VSS.n306 4.65853
R837 VSS.n305 VSS.n304 4.65853
R838 VSS.n303 VSS.n302 4.65853
R839 VSS.n301 VSS.n300 4.65853
R840 VSS.n299 VSS.n298 4.65853
R841 VSS.n297 VSS.n296 4.65853
R842 VSS.n295 VSS.n294 4.65853
R843 VSS.n293 VSS.n292 4.65853
R844 VSS.n291 VSS.n290 4.65853
R845 VSS.n289 VSS.n288 4.65853
R846 VSS.n287 VSS.n286 4.65853
R847 VSS.n285 VSS.n284 4.65853
R848 VSS.n283 VSS.n282 4.65853
R849 VSS.n276 VSS.n275 4.65853
R850 VSS.n274 VSS.n273 4.65853
R851 VSS.n272 VSS.n271 4.65853
R852 VSS.n270 VSS.n269 4.65853
R853 VSS.n268 VSS.n267 4.65853
R854 VSS.n261 VSS.n260 4.65853
R855 VSS.n259 VSS.n258 4.65853
R856 VSS.n257 VSS.n256 4.65853
R857 VSS.n255 VSS.n254 4.65853
R858 VSS.n18 VSS.n22 4.59452
R859 VSS.n426 VSS.n49 4.5288
R860 VSS.n430 VSS.n56 4.5288
R861 VSS.n424 VSS.n47 4.5288
R862 VSS.n423 VSS.n46 4.5288
R863 VSS.n432 VSS.n58 4.5288
R864 VSS.n421 VSS.n44 4.5288
R865 VSS.n420 VSS.n43 4.5288
R866 VSS.n435 VSS.n61 4.5288
R867 VSS.n124 VSS.n65 4.5288
R868 VSS.n125 VSS.n66 4.5288
R869 VSS.n126 VSS.n68 4.5288
R870 VSS.n122 VSS.n71 4.5288
R871 VSS.n128 VSS.n72 4.5288
R872 VSS.n129 VSS.n74 4.5288
R873 VSS.n120 VSS.n75 4.5288
R874 VSS.n131 VSS.n78 4.5288
R875 VSS.n21 VSS.n35 4.5005
R876 VSS.n21 VSS.n437 4.5005
R877 VSS.n20 VSS.n19 2.16985
R878 VSS.n18 VSS.n4 4.5005
R879 VSS.n436 VSS.n13 2.3909
R880 VSS.n439 VSS.n17 2.3909
R881 VSS.n412 VSS.n391 4.15144
R882 VSS.t13 VSS.n55 4.15144
R883 VSS.t0 VSS.n43 4.15144
R884 VSS.t2 VSS.n66 4.15144
R885 VSS.t40 VSS.n77 4.15144
R886 VSS.t98 VSS.t14 3.96276
R887 VSS.t119 VSS.t37 3.96276
R888 VSS.n22 VSS.n418 3.89324
R889 VSS.t53 VSS.n138 3.77408
R890 VSS.n252 VSS.n143 3.77104
R891 VSS.n265 VSS.n143 3.77104
R892 VSS.n280 VSS.n143 3.77104
R893 VSS.n313 VSS.n143 3.77104
R894 VSS.n344 VSS.n143 3.77104
R895 VSS.n353 VSS.n143 3.77104
R896 VSS.n262 VSS.n143 3.77087
R897 VSS.n277 VSS.n143 3.77087
R898 VSS.n308 VSS.n143 3.77087
R899 VSS.n333 VSS.n143 3.77087
R900 VSS.n350 VSS.n143 3.77087
R901 VSS.n390 VSS.n143 3.77087
R902 VSS.n35 VSS.t112 3.45423
R903 VSS.n16 VSS.t115 3.45423
R904 VSS.n29 VSS.t118 3.45423
R905 VSS.n28 VSS.t121 3.45423
R906 VSS.n15 VSS.t96 3.45423
R907 VSS.n27 VSS.t99 3.45423
R908 VSS.n11 VSS.t102 3.45423
R909 VSS.n4 VSS.t105 3.45423
R910 VSS.n26 VSS.t110 3.45313
R911 VSS.n31 VSS.t124 3.45313
R912 VSS.n14 VSS.t94 3.45313
R913 VSS.n4 VSS.t108 3.45313
R914 VSS.t11 VSS.n54 3.39673
R915 VSS.n433 VSS.t17 3.39673
R916 VSS.t18 VSS.n42 3.39673
R917 VSS.t33 VSS.n64 3.39673
R918 VSS.n123 VSS.t34 3.39673
R919 VSS.t38 VSS.n79 3.39673
R920 VSS.n395 VSS.n394 3.39626
R921 VSS.n8 VSS.n7 0.624323
R922 VSS.n1 VSS.n8 0.102675
R923 VSS.n25 VSS.n0 0.0776913
R924 VSS.n3 VSS.n2 0.0821451
R925 VSS.n23 VSS.n7 0.767758
R926 VSS.n408 VSS.t58 3.22826
R927 VSS.n406 VSS.t129 3.22826
R928 VSS.n404 VSS.t128 3.22826
R929 VSS.n428 VSS.t93 3.20805
R930 VSS.n426 VSS.t95 3.20805
R931 VSS.n425 VSS.t97 3.20805
R932 VSS.n430 VSS.t98 3.20805
R933 VSS.n431 VSS.t100 3.20805
R934 VSS.n422 VSS.t103 3.20805
R935 VSS.n434 VSS.t106 3.20805
R936 VSS.n440 VSS.t111 3.20805
R937 VSS.n127 VSS.t114 3.20805
R938 VSS.n121 VSS.t117 3.20805
R939 VSS.n120 VSS.t119 3.20805
R940 VSS.n130 VSS.t120 3.20805
R941 VSS.n131 VSS.t122 3.20805
R942 VSS.n118 VSS.t123 3.20805
R943 VSS.n343 VSS.n141 3.01937
R944 VSS.n417 VSS.n416 3.01937
R945 VSS.n142 VSS.n132 3.01937
R946 VSS.n342 VSS.n140 3.01937
R947 VSS.n341 VSS.n133 3.01937
R948 VSS.n340 VSS.n139 3.01937
R949 VSS.n339 VSS.n134 3.01937
R950 VSS.n338 VSS.n138 3.01937
R951 VSS.n337 VSS.n135 3.01937
R952 VSS.n336 VSS.n137 3.01937
R953 VSS.n335 VSS.n136 3.01937
R954 VSS.n471 VSS.t18 3.01937
R955 VSS.n114 VSS.t33 3.01937
R956 VSS.n22 VSS.n419 2.9309
R957 VSS.n458 VSS.t24 2.91241
R958 VSS.n450 VSS.t29 2.91241
R959 VSS.n252 VSS.n251 2.84639
R960 VSS.n265 VSS.n264 2.84639
R961 VSS.n280 VSS.n279 2.84639
R962 VSS.n313 VSS.n312 2.84639
R963 VSS.n344 VSS.n343 2.84639
R964 VSS.n353 VSS.n352 2.84639
R965 VSS.n391 VSS.n390 2.84619
R966 VSS.n351 VSS.n350 2.84619
R967 VSS.n334 VSS.n333 2.84619
R968 VSS.n309 VSS.n308 2.84619
R969 VSS.n278 VSS.n277 2.84619
R970 VSS.n263 VSS.n262 2.84619
R971 VSS.n0 VSS.n7 1.50426
R972 VSS.n7 VSS.n3 0.75412
R973 VSS.t77 VSS.t104 2.64201
R974 VSS.t140 VSS.t113 2.64201
R975 VSS.n7 VSS.n82 2.58141
R976 VSS.n7 VSS.n81 2.58141
R977 VSS.n7 VSS.n50 2.58141
R978 VSS.n7 VSS.n52 2.58141
R979 VSS.t82 VSS.n107 2.54843
R980 VSS.n464 VSS.t83 2.54843
R981 VSS.t84 VSS.n104 2.54843
R982 VSS.n461 VSS.t85 2.54843
R983 VSS.t86 VSS.n101 2.54843
R984 VSS.t131 VSS.n90 2.54843
R985 VSS.n447 VSS.t132 2.54843
R986 VSS.t133 VSS.n87 2.54843
R987 VSS.n444 VSS.t134 2.54843
R988 VSS.t135 VSS.n84 2.54843
R989 VSS.n25 VSS.t7 2.40253
R990 VSS.n24 VSS.t45 2.40073
R991 VSS.n6 VSS.t25 2.36054
R992 VSS.n6 VSS.t5 2.36054
R993 VSS.n2 VSS.t3 2.36054
R994 VSS.n1 VSS.t12 2.3605
R995 VSS.n24 VSS.t42 2.36044
R996 VSS.n1 VSS.t1 2.36036
R997 VSS.n2 VSS.t36 2.36035
R998 VSS.n6 VSS.t22 2.36029
R999 VSS.n2 VSS.t39 2.36016
R1000 VSS.n25 VSS.t9 2.36002
R1001 VSS.n9 VSS.t19 2.35954
R1002 VSS.n10 VSS.t32 2.35939
R1003 VSS.n6 VSS.t28 2.35936
R1004 VSS.n1 VSS.t15 2.35929
R1005 VSS.n358 VSS.t62 2.21124
R1006 VSS.n357 VSS.t64 2.2112
R1007 VSS.n170 VSS.t161 2.21097
R1008 VSS.n176 VSS.t155 2.21091
R1009 VSS.n172 VSS.t159 2.21087
R1010 VSS.n178 VSS.t154 2.21084
R1011 VSS.n310 VSS.t66 2.21063
R1012 VSS.n168 VSS.t163 2.21053
R1013 VSS.n181 VSS.t60 2.21018
R1014 VSS.n249 VSS.t68 2.21
R1015 VSS.n174 VSS.t157 2.20994
R1016 VSS.n180 VSS.t59 2.20993
R1017 VSS.n168 VSS.t153 2.20268
R1018 VSS.n181 VSS.t48 2.20233
R1019 VSS.n174 VSS.t147 2.20223
R1020 VSS.n357 VSS.t52 2.20187
R1021 VSS.n358 VSS.t50 2.20163
R1022 VSS.n249 VSS.t56 2.20156
R1023 VSS.n310 VSS.t54 2.20154
R1024 VSS.n170 VSS.t151 2.20154
R1025 VSS.n178 VSS.t144 2.20151
R1026 VSS.n172 VSS.t149 2.20141
R1027 VSS.n176 VSS.t145 2.20127
R1028 VSS.n180 VSS.t47 2.20073
R1029 VSS.n441 VSS.n39 2.17591
R1030 VSS.n117 VSS.t0 2.07597
R1031 VSS.n441 VSS.t2 2.07597
R1032 VSS.n415 VSS.n146 1.90272
R1033 VSS.n415 VSS.n148 1.90272
R1034 VSS.n415 VSS.n248 1.90272
R1035 VSS.n415 VSS.n151 1.90272
R1036 VSS.n415 VSS.n243 1.90272
R1037 VSS.n415 VSS.n153 1.90272
R1038 VSS.n415 VSS.n156 1.90272
R1039 VSS.n415 VSS.n158 1.90272
R1040 VSS.n415 VSS.n160 1.90272
R1041 VSS.n415 VSS.n162 1.90272
R1042 VSS.n415 VSS.n236 1.90272
R1043 VSS.n415 VSS.n165 1.90272
R1044 VSS.n415 VSS.n232 1.90272
R1045 VSS.n415 VSS.n229 1.90272
R1046 VSS.n415 VSS.n166 1.90272
R1047 VSS.n415 VSS.n227 1.90272
R1048 VSS.n415 VSS.n222 1.90272
R1049 VSS.n415 VSS.n219 1.90272
R1050 VSS.n415 VSS.n217 1.90272
R1051 VSS.n415 VSS.n183 1.90272
R1052 VSS.n415 VSS.n215 1.90272
R1053 VSS.n415 VSS.n212 1.90272
R1054 VSS.n415 VSS.n210 1.90272
R1055 VSS.n415 VSS.n184 1.90272
R1056 VSS.n415 VSS.n186 1.90272
R1057 VSS.n415 VSS.n189 1.90272
R1058 VSS.n415 VSS.n191 1.90272
R1059 VSS.n415 VSS.n206 1.90272
R1060 VSS.n415 VSS.n193 1.90272
R1061 VSS.n415 VSS.n201 1.90272
R1062 VSS.n147 VSS.n143 1.90272
R1063 VSS.n246 VSS.n143 1.90272
R1064 VSS.n241 VSS.n143 1.90272
R1065 VSS.n154 VSS.n143 1.90272
R1066 VSS.n233 VSS.n143 1.90272
R1067 VSS.n230 VSS.n143 1.90272
R1068 VSS.n231 VSS.n143 1.90272
R1069 VSS.n225 VSS.n143 1.90272
R1070 VSS.n226 VSS.n143 1.90272
R1071 VSS.n220 VSS.n143 1.90272
R1072 VSS.n221 VSS.n143 1.90272
R1073 VSS.n216 VSS.n143 1.90272
R1074 VSS.n213 VSS.n143 1.90272
R1075 VSS.n211 VSS.n143 1.90272
R1076 VSS.n199 VSS.n143 1.90272
R1077 VSS.n413 VSS.n143 1.90272
R1078 VSS.n244 VSS.n143 1.90272
R1079 VSS.n239 VSS.n143 1.90272
R1080 VSS.n237 VSS.n143 1.90272
R1081 VSS.n157 VSS.n143 1.90272
R1082 VSS.n159 VSS.n143 1.90272
R1083 VSS.n161 VSS.n143 1.90272
R1084 VSS.n228 VSS.n143 1.90272
R1085 VSS.n218 VSS.n143 1.90272
R1086 VSS.n214 VSS.n143 1.90272
R1087 VSS.n207 VSS.n143 1.90272
R1088 VSS.n185 VSS.n143 1.90272
R1089 VSS.n190 VSS.n143 1.90272
R1090 VSS.n204 VSS.n143 1.90272
R1091 VSS.n202 VSS.n143 1.90272
R1092 VSS.n197 VSS.n143 1.90272
R1093 VSS.n434 VSS.n110 1.88729
R1094 VSS.n435 VSS.n111 1.88729
R1095 VSS.n124 VSS.n115 1.88729
R1096 VSS.n442 VSS.n440 1.88729
R1097 VSS.n469 VSS.n468 1.69861
R1098 VSS.n467 VSS.n113 1.69861
R1099 VSS.n36 VSS.n12 0.766777
R1100 VSS.n12 VSS.n32 0.288546
R1101 VSS VSS.n33 0.189868
R1102 VSS.n34 VSS 0.776964
R1103 VSS.t127 VSS.n309 1.50993
R1104 VSS.n463 VSS.t21 1.45646
R1105 VSS.n445 VSS.t4 1.45646
R1106 VSS.n38 VSS.n117 1.39084
R1107 VSS.t93 VSS.n54 1.32125
R1108 VSS.t97 VSS.n48 1.32125
R1109 VSS.t100 VSS.n57 1.32125
R1110 VSS.t75 VSS.t16 1.32125
R1111 VSS.t16 VSS.t101 1.32125
R1112 VSS.t76 VSS.n45 1.32125
R1113 VSS.t103 VSS.n45 1.32125
R1114 VSS.t78 VSS.n60 1.32125
R1115 VSS.t106 VSS.n60 1.32125
R1116 VSS.t79 VSS.n109 1.32125
R1117 VSS.n109 VSS.t107 1.32125
R1118 VSS.t80 VSS.n42 1.32125
R1119 VSS.n469 VSS.t81 1.32125
R1120 VSS.n113 VSS.t136 1.32125
R1121 VSS.t137 VSS.n64 1.32125
R1122 VSS.n116 VSS.t109 1.32125
R1123 VSS.t138 VSS.n116 1.32125
R1124 VSS.t111 VSS.n67 1.32125
R1125 VSS.t139 VSS.n67 1.32125
R1126 VSS.t114 VSS.n70 1.32125
R1127 VSS.t141 VSS.n70 1.32125
R1128 VSS.t35 VSS.t116 1.32125
R1129 VSS.t142 VSS.t35 1.32125
R1130 VSS.t117 VSS.n73 1.32125
R1131 VSS.t120 VSS.n76 1.32125
R1132 VSS.t123 VSS.n79 1.32125
R1133 VSS.t46 VSS.n187 1.23532
R1134 VSS.n352 VSS.t74 1.13258
R1135 VSS.t14 VSS.n47 1.13258
R1136 VSS.t17 VSS.n59 1.13258
R1137 VSS.t34 VSS.n69 1.13258
R1138 VSS.t37 VSS.n74 1.13258
R1139 VSS.t20 VSS.t82 1.09247
R1140 VSS.t31 VSS.t135 1.09247
R1141 VSS.n419 VSS.n38 1.04917
R1142 VSS.n223 VSS.n167 0.926616
R1143 VSS.n279 VSS.t55 0.755217
R1144 VSS.t23 VSS.n102 0.728479
R1145 VSS.t30 VSS.n89 0.728479
R1146 VSS.n423 VSS.t75 0.566538
R1147 VSS.n433 VSS.t77 0.566538
R1148 VSS.n420 VSS.t79 0.566538
R1149 VSS.n125 VSS.t138 0.566538
R1150 VSS.n123 VSS.t140 0.566538
R1151 VSS.n128 VSS.t142 0.566538
R1152 VSS.n473 VSS.n41 0.551994
R1153 VSS.n409 VSS.n408 0.513002
R1154 VSS.n400 VSS.n399 0.479883
R1155 VSS.n402 VSS.n401 0.479883
R1156 VSS.n410 VSS.n409 0.411981
R1157 VSS.n403 VSS.n398 0.411981
R1158 VSS.n429 VSS.t13 0.377858
R1159 VSS.n119 VSS.t40 0.377858
R1160 VSS.n405 VSS.n403 0.370375
R1161 VSS.n403 VSS.n402 0.370375
R1162 VSS.n402 VSS.n400 0.370375
R1163 VSS.n437 VSS.n20 0.50003
R1164 VSS.n409 VSS.n407 0.3195
R1165 VSS.n407 VSS.n405 0.3195
R1166 VSS.n470 VSS.n39 0.252599
R1167 VSS.t91 VSS.n41 0.264692
R1168 VSS.n34 VSS.n33 0.75765
R1169 VSS.n33 VSS.n32 0.959389
R1170 VSS.t89 VSS.t91 0.252013
R1171 VSS.n400 VSS.n40 0.248
R1172 VSS.n176 VSS.n175 0.243424
R1173 VSS.n181 VSS.n152 0.243424
R1174 VSS.n20 VSS.n4 0.404622
R1175 VSS.n437 VSS.n26 0.241827
R1176 VSS.n178 VSS.n177 0.241769
R1177 VSS.n182 VSS.n180 0.241769
R1178 VSS.n172 VSS.n171 0.237318
R1179 VSS.n357 VSS.n311 0.237318
R1180 VSS.n359 VSS.n358 0.234764
R1181 VSS.n174 VSS.n173 0.234752
R1182 VSS.n170 VSS.n169 0.234686
R1183 VSS.n310 VSS.n250 0.234193
R1184 VSS.n171 VSS.n170 0.231239
R1185 VSS.n311 VSS.n310 0.231239
R1186 VSS.n173 VSS.n172 0.229708
R1187 VSS.n359 VSS.n357 0.229696
R1188 VSS.n250 VSS.n249 0.229197
R1189 VSS.n169 VSS.n168 0.228745
R1190 VSS.n175 VSS.n174 0.227001
R1191 VSS.n358 VSS.n152 0.227001
R1192 VSS.n177 VSS.n176 0.223699
R1193 VSS.n182 VSS.n181 0.223699
R1194 VSS.n415 VSS.n152 0.218846
R1195 VSS.n175 VSS.n143 0.218846
R1196 VSS.n415 VSS.n311 0.21564
R1197 VSS.n171 VSS.n143 0.21564
R1198 VSS.n415 VSS.n182 0.208386
R1199 VSS.n177 VSS.n143 0.208386
R1200 VSS.n169 VSS.n143 0.20534
R1201 VSS.n415 VSS.n250 0.204862
R1202 VSS.n173 VSS.n143 0.203693
R1203 VSS.n415 VSS.n359 0.203693
R1204 VSS.n41 VSS.n12 0.197134
R1205 VSS.n117 VSS.n110 0.189179
R1206 VSS.n442 VSS.n441 0.189179
R1207 VSS.n36 VSS.n37 0.299243
R1208 VSS.n407 VSS.n406 0.143127
R1209 VSS.n405 VSS.n404 0.143127
R1210 VSS.n32 VSS.n37 0.402928
R1211 VSS.n5 VSS.n11 0.0762831
R1212 VSS.n36 VSS.n473 0.211243
R1213 VSS VSS.n12 0.210343
R1214 VSS.t89 VSS.n21 0.202252
R1215 VSS.n6 VSS.n9 0.185055
R1216 VSS.n6 VSS.n23 0.182218
R1217 VSS.n2 VSS.n10 0.180762
R1218 VSS.n1 VSS.n0 0.162986
R1219 VSS.n24 VSS.n3 0.151478
R1220 VSS.n9 VSS.n8 0.0679278
R1221 VSS.n14 VSS.n22 0.140806
R1222 VSS.n23 VSS.n10 0.0939139
R1223 VSS.n35 VSS.n16 0.117555
R1224 VSS.n15 VSS.n14 0.117555
R1225 VSS.n30 VSS.n28 0.0585658
R1226 VSS.n29 VSS.n28 0.116817
R1227 VSS.n17 VSS.n16 0.0501977
R1228 VSS.n11 VSS.n27 0.116817
R1229 VSS.n15 VSS.n13 0.0501977
R1230 VSS.n35 VSS.n26 0.116817
R1231 VSS.n21 VSS.n19 0.113321
R1232 VSS.n19 VSS.n18 0.113321
R1233 a_11798_1180.n0 a_11798_1180.n4 9.42143
R1234 a_11798_1180.n1 a_11798_1180.n12 9.42143
R1235 a_11798_1180.n1 a_11798_1180.n5 9.42143
R1236 a_11798_1180.n1 a_11798_1180.n6 9.42143
R1237 a_11798_1180.n2 a_11798_1180.n9 9.42143
R1238 a_11798_1180.n2 a_11798_1180.n7 9.42143
R1239 a_11798_1180.n4 a_11798_1180.t15 3.60374
R1240 a_11798_1180.n5 a_11798_1180.t21 3.60255
R1241 a_11798_1180.n6 a_11798_1180.t22 3.60255
R1242 a_11798_1180.n7 a_11798_1180.t28 3.60255
R1243 a_11798_1180.n4 a_11798_1180.t16 3.45423
R1244 a_11798_1180.n13 a_11798_1180.t17 3.45423
R1245 a_11798_1180.n11 a_11798_1180.t19 3.45423
R1246 a_11798_1180.n5 a_11798_1180.t20 3.45423
R1247 a_11798_1180.n12 a_11798_1180.t18 3.45423
R1248 a_11798_1180.n6 a_11798_1180.t23 3.45423
R1249 a_11798_1180.n10 a_11798_1180.t24 3.45423
R1250 a_11798_1180.n8 a_11798_1180.t26 3.45423
R1251 a_11798_1180.n7 a_11798_1180.t27 3.45423
R1252 a_11798_1180.n9 a_11798_1180.t25 3.45423
R1253 a_11798_1180.t14 a_11798_1180.n3 2.61386
R1254 a_11798_1180.n0 a_11798_1180.t0 2.61135
R1255 a_11798_1180.n1 a_11798_1180.t8 2.56233
R1256 a_11798_1180.n1 a_11798_1180.t6 2.5622
R1257 a_11798_1180.n3 a_11798_1180.t13 2.56174
R1258 a_11798_1180.n1 a_11798_1180.t4 2.56174
R1259 a_11798_1180.n0 a_11798_1180.t3 2.56174
R1260 a_11798_1180.n3 a_11798_1180.t12 2.56173
R1261 a_11798_1180.n2 a_11798_1180.t10 2.56173
R1262 a_11798_1180.n1 a_11798_1180.t5 2.56173
R1263 a_11798_1180.n0 a_11798_1180.t1 2.56173
R1264 a_11798_1180.n2 a_11798_1180.t11 2.56161
R1265 a_11798_1180.n0 a_11798_1180.t2 2.56161
R1266 a_11798_1180.n1 a_11798_1180.t7 2.56153
R1267 a_11798_1180.n1 a_11798_1180.t9 2.5613
R1268 a_11798_1180.n2 a_11798_1180.n1 0.245563
R1269 a_11798_1180.n8 a_11798_1180.n7 0.225083
R1270 a_11798_1180.n6 a_11798_1180.n10 0.225083
R1271 a_11798_1180.n11 a_11798_1180.n5 0.225083
R1272 a_11798_1180.n4 a_11798_1180.n13 0.225083
R1273 a_11798_1180.n1 a_11798_1180.n0 0.196551
R1274 a_11798_1180.n13 a_11798_1180.n12 0.1875
R1275 a_11798_1180.n12 a_11798_1180.n11 0.1875
R1276 a_11798_1180.n10 a_11798_1180.n9 0.1875
R1277 a_11798_1180.n9 a_11798_1180.n8 0.1875
R1278 a_11798_1180.n3 a_11798_1180.n2 0.147538
R1279 a_5428_2384.n0 a_5428_2384.t2 36.3628
R1280 a_5428_2384.n0 a_5428_2384.t0 35.246
R1281 a_5428_2384.t1 a_5428_2384.n0 15.3137
R1282 a_1474_1090.n0 a_1474_1090.t2 60.5214
R1283 a_1474_1090.n0 a_1474_1090.t0 33.8343
R1284 a_1474_1090.n1 a_1474_1090.n0 12.0028
R1285 a_1474_1090.t1 a_1474_1090.n1 2.87353
R1286 a_1474_1090.t1 a_1474_1090.n1 2.86853
R1287 a_1954_2820.n0 a_1954_2820.t2 44.3673
R1288 a_1954_2820.n0 a_1954_2820.t1 27.0418
R1289 a_1954_2820.t0 a_1954_2820.n0 12.2034
R1290 a_1254_2820.n0 a_1254_2820.t2 36.0512
R1291 a_1254_2820.n0 a_1254_2820.t3 33.7412
R1292 a_1254_2820.n3 a_1254_2820.t0 26.8072
R1293 a_1254_2820.n1 a_1254_2820.t5 26.0905
R1294 a_1254_2820.n1 a_1254_2820.t4 24.7412
R1295 a_1254_2820.t1 a_1254_2820.n3 12.4381
R1296 a_1254_2820.n3 a_1254_2820.n2 9.512
R1297 a_1254_2820.n2 a_1254_2820.n1 9.0005
R1298 a_1254_2820.n2 a_1254_2820.n0 0.7705
R1299 a_2654_4840.n1 a_2654_4840.t4 36.3944
R1300 a_2654_4840.n0 a_2654_4840.t1 34.4012
R1301 a_2654_4840.n0 a_2654_4840.t0 22.0391
R1302 a_2654_4840.n2 a_2654_4840.n1 9.0005
R1303 a_2654_4840.n2 a_2654_4840.t3 5.84394
R1304 a_2654_4840.t2 a_2654_4840.n2 4.67685
R1305 a_2654_4840.n1 a_2654_4840.n0 0.3173
R1306 vco_bias_0.vbn_buf.n3 vco_bias_0.vbn_buf.t1 55.3125
R1307 vco_bias_0.vbn_buf.n1 vco_bias_0.vbn_buf.t4 34.2391
R1308 vco_bias_0.vbn_buf.n1 vco_bias_0.vbn_buf.t3 28.5544
R1309 vco_bias_0.vbn_buf.n2 vco_bias_0.vbn_buf.n1 23.0981
R1310 vco_bias_0.vbn_buf.n0 vco_bias_0.vbn_buf.t2 21.7736
R1311 vco_bias_0.vbn_buf.n2 vco_bias_0.vbn_buf.t0 21.4968
R1312 vco_bias_0.vbn_buf vco_bias_0.vbn_buf.n0 20.8275
R1313 vco_bias_0.vbn_buf.n3 vco_bias_0.vbn_buf.n2 3.1069
R1314 vco_bias_0.vbn_buf vco_bias_0.vbn_buf.n3 1.2149
R1315 vco_bias_0.vbn_buf.n0 vco_bias_0.vbn_buf 0.1105
C0 VDD a_16500_3480# 0.32168f
C1 vtune a_9450_4394# 0.18199f
C2 a_14668_2644# rf_out_p 0.97363f
C3 VDD di_en 0.23329f
C4 vdd_core a_9450_4394# 1.68757f
C5 VDD ibias_100u 0.19944f
C6 rf_out_n vtune 0.03195f
C7 VDD rf_out_p 0.41138f
C8 VDD a_1560_1090# 0.0645f
C9 vco_bias_0.vbn_buf a_9450_4394# 0.03328f
C10 VDD a_14668_2644# 0.53384f
C11 rf_out_n vdd_core 0.01574f
C12 vco_bias_0.vbg_buf a_9450_4394# 0.06261f
C13 vco_bias_0.vbg_buf a_9450_4480# 0.05793f
C14 a_10100_3480# a_9450_4394# 0.0615f
C15 vco_bias_0.vbn_buf a_1160_1390# 0.03612f
C16 vtune vdd_core 11.8815f
C17 vco_bias_0.vbn_buf rf_out_n 0.19616f
C18 a_19050_4480# vdd_core 0.01117f
C19 a_10100_3480# rf_out_n 0.47902f
C20 vco_bias_0.vbn_buf vtune 0.09328f
C21 vco_bias_0.vbg_buf vtune 0.13019f
C22 vco_bias_0.vbn_buf vdd_core 0.31748f
C23 vco_bias_0.vbg_buf a_19050_4480# 0.03836f
C24 vco_bias_0.vbg_buf vdd_core 1.49445f
C25 a_10100_3480# vdd_core 0.01479f
C26 a_1160_1390# ibias_100u 0.03363f
C27 a_14668_2644# a_9450_4394# 0.17478f
C28 vco_bias_0.vbn_buf vco_bias_0.vbg_buf 5.04344f
C29 a_16500_3480# vdd_core 0.01688f
C30 a_1160_1390# a_1560_1090# 0.17942f
C31 a_10100_3480# vco_bias_0.vbn_buf 0.01657f
C32 rf_out_n rf_out_p 0.01053f
C33 VDD a_9450_4394# 0.55368f
C34 vtune rf_out_p 0.03195f
C35 vtune a_14668_2644# 0.18199f
C36 VDD a_1160_1390# 0.03044f
C37 vco_bias_0.vbn_buf di_en 0.04963f
C38 VDD rf_out_n 0.42538f
C39 vdd_core rf_out_p 0.01629f
C40 a_19050_4480# a_14668_2644# 0.03458f
C41 vco_bias_0.vbg_buf di_en 0.06388f
C42 vdd_core a_14668_2644# 1.69805f
C43 vco_bias_0.vbn_buf ibias_100u 0.02722f
C44 VDD vtune 0.31574f
C45 vco_bias_0.vbn_buf rf_out_p 0.17253f
C46 vco_bias_0.vbn_buf a_6760_4250# 0.0432f
C47 vco_bias_0.vbn_buf a_14668_2644# 0.01681f
C48 vco_bias_0.vbg_buf a_1560_1090# 0.03586f
C49 vco_bias_0.vbg_buf a_6760_4250# 0.01222f
C50 VDD vdd_core 0.60885f
C51 vco_bias_0.vbg_buf a_14668_2644# 0.05315f
C52 a_9450_4480# a_9450_4394# 0.03458f
C53 a_16500_3480# rf_out_p 0.47902f
C54 VDD vco_bias_0.vbn_buf 0.4152f
C55 a_16500_3480# a_14668_2644# 0.0615f
C56 di_en ibias_100u 0.17714f
C57 VDD vco_bias_0.vbg_buf 0.57293f
C58 a_10100_3480# VDD 0.35541f
C59 rf_out_n a_9450_4394# 0.97363f
C60 ibias_100u VSS 2.9592f
C61 rf_out_p VSS 4.02018f
C62 rf_out_n VSS 4.00358f
C63 di_en VSS 1.37466f
C64 vdd_core VSS 0.10405p
C65 vtune VSS 4.64089f
C66 VDD VSS 38.48719f
C67 vco_bias_0.vbg_buf VSS 0.53116f
C68 vco_bias_0.vbn_buf VSS 0.12538p
C69 vco_bias_0.vbn_buf.n0 VSS 0.0947f
C70 vco_bias_0.vbn_buf.n1 VSS 0.19579f
C71 vco_bias_0.vbn_buf.t0 VSS 0.08715f
C72 vco_bias_0.vbn_buf.n2 VSS 0.18186f
C73 vco_bias_0.vbn_buf.t1 VSS 2.03052f
C74 vco_bias_0.vbn_buf.n3 VSS 0.1012f
C75 a_2654_4840.t3 VSS 0.3313f
C76 a_2654_4840.t0 VSS 0.37376f
C77 a_2654_4840.n0 VSS 0.71784f
C78 a_2654_4840.n1 VSS 0.75734f
C79 a_2654_4840.n2 VSS 0.59076f
C80 a_2654_4840.t2 VSS 0.71388f
C81 a_1254_2820.t0 VSS 0.05773f
C82 a_1254_2820.n0 VSS 0.78003f
C83 a_1254_2820.n1 VSS 0.41938f
C84 a_1254_2820.n2 VSS 0.20691f
C85 a_1254_2820.n3 VSS 0.38183f
C86 a_1254_2820.t1 VSS 0.12237f
C87 a_1954_2820.t1 VSS 0.07448f
C88 a_1954_2820.n0 VSS 0.99877f
C89 a_1954_2820.t0 VSS 0.15689f
C90 a_1474_1090.t0 VSS 0.6288f
C91 a_1474_1090.t2 VSS 2.28251f
C92 a_1474_1090.n0 VSS 2.19033f
C93 a_1474_1090.n1 VSS 0.41883f
C94 a_1474_1090.t1 VSS 0.5654f
C95 a_5428_2384.t2 VSS 0.64067f
C96 a_5428_2384.n0 VSS 1.11945f
C97 a_5428_2384.t1 VSS 0.52452f
C98 a_11798_1180.n0 VSS 1.87358f
C99 a_11798_1180.n1 VSS 3.22693f
C100 a_11798_1180.n2 VSS 1.31647f
C101 a_11798_1180.n3 VSS 1.24061f
C102 a_11798_1180.n4 VSS 0.13002f
C103 a_11798_1180.n5 VSS 0.13002f
C104 a_11798_1180.n6 VSS 0.13002f
C105 a_11798_1180.n7 VSS 0.13002f
C106 a_11798_1180.t28 VSS 0.06106f
C107 a_11798_1180.t25 VSS 0.06535f
C108 a_11798_1180.t26 VSS 0.06535f
C109 a_11798_1180.t27 VSS 0.06535f
C110 a_11798_1180.n8 VSS 0.07299f
C111 a_11798_1180.n9 VSS 0.07639f
C112 a_11798_1180.t23 VSS 0.33593f
C113 a_11798_1180.t24 VSS 2.95606f
C114 a_11798_1180.n10 VSS 0.07299f
C115 a_11798_1180.t22 VSS 0.06106f
C116 a_11798_1180.t21 VSS 0.06106f
C117 a_11798_1180.t18 VSS 0.06535f
C118 a_11798_1180.t19 VSS 2.94588f
C119 a_11798_1180.t20 VSS 0.06535f
C120 a_11798_1180.n11 VSS 0.07299f
C121 a_11798_1180.n12 VSS 0.07639f
C122 a_11798_1180.t16 VSS 0.33093f
C123 a_11798_1180.t17 VSS 0.06535f
C124 a_11798_1180.n13 VSS 0.07299f
C125 a_11798_1180.t15 VSS 0.06107f
C126 a_11798_1180.t0 VSS 0.19691f
C127 a_11798_1180.t1 VSS 0.19158f
C128 a_11798_1180.t2 VSS 0.19159f
C129 a_11798_1180.t3 VSS 0.19159f
C130 a_11798_1180.t4 VSS 0.19159f
C131 a_11798_1180.t5 VSS 0.19159f
C132 a_11798_1180.t6 VSS 0.19158f
C133 a_11798_1180.t7 VSS 0.19158f
C134 a_11798_1180.t8 VSS 0.19158f
C135 a_11798_1180.t9 VSS 0.19158f
C136 a_11798_1180.t10 VSS 0.19159f
C137 a_11798_1180.t11 VSS 0.19159f
C138 a_11798_1180.t12 VSS 0.88858f
C139 a_11798_1180.t13 VSS 0.19159f
C140 a_11798_1180.t14 VSS 0.19688f
C141 VSS.t89 VSS 9.56283f
C142 VSS.t39 VSS 0.697f
C143 VSS.t124 VSS 0.01375f
C144 VSS.t108 VSS 0.01999f
C145 VSS.t144 VSS 55.148f
C146 VSS.t145 VSS 55.148f
C147 VSS.t157 VSS 0.98805f
C148 VSS.t159 VSS 0.98805f
C149 VSS.t151 VSS 0.27058f
C150 VSS.t153 VSS 0.27058f
C151 VSS.t60 VSS 3.10521f
C152 VSS.t52 VSS 3.10949f
C153 VSS.t50 VSS 3.10949f
C154 VSS.t62 VSS 3.10521f
C155 VSS.t73 VSS 0.0535f
C156 VSS.t70 VSS 0.06525f
C157 VSS.t126 VSS 0.03094f
C158 VSS.t72 VSS 0.03148f
C159 VSS.t128 VSS 0.10957f
C160 VSS.t129 VSS 0.11061f
C161 VSS.t58 VSS 0.15914f
C162 VDD.t6 VSS 0.19093f
C163 VDD.t7 VSS 0.31424f
C164 VDD.n0 VSS 0.10687f
C165 VDD.t4 VSS 0.19093f
C166 VDD.t5 VSS 0.30118f
C167 VDD.n1 VSS 0.03938f
C168 VDD.n2 VSS 0.11891f
C169 VDD.t3 VSS 0.17434f
C170 VDD.t2 VSS 0.06705f
C171 VDD.n3 VSS 0.04924f
C172 VDD.n4 VSS 0.08989f
C173 VDD.t1 VSS 0.04626f
C174 VDD.t0 VSS 0.06705f
C175 VDD.n5 VSS 0.04924f
C176 VDD.n6 VSS 0.06931f
C177 VDD.t10 VSS 0.04764f
C178 VDD.t9 VSS 0.06705f
C179 VDD.n7 VSS 0.04924f
C180 VDD.n8 VSS 0.15126f
C181 VDD.t11 VSS 1.19226f
C182 VDD.t8 VSS 0.85801f
C183 VDD.n9 VSS 0.89299f
C184 vtune.t0 VSS 3.74632f
C185 vtune.t3 VSS 3.73239f
C186 vtune.n0 VSS 0.40508f
C187 vtune.t6 VSS 3.73239f
C188 vtune.n1 VSS 1.02468f
C189 vdd_core.n0 VSS 0.03341f
C190 vdd_core.n5 VSS 0.01481f
C191 vdd_core.n6 VSS 0.41598f
C192 vdd_core.n7 VSS 0.01788f
C193 vdd_core.n8 VSS 0.30436f
C194 vdd_core.n10 VSS 0.25093f
C195 vdd_core.t0 VSS 0.24421f
C196 vdd_core.n14 VSS 0.0517f
C197 vdd_core.n15 VSS 0.03181f
C198 vdd_core.n16 VSS 0.13356f
C199 vdd_core.n19 VSS 0.03406f
C200 vdd_core.t14 VSS 0.02159f
C201 vdd_core.n23 VSS 0.0451f
C202 vdd_core.n26 VSS 0.04807f
C203 vdd_core.n30 VSS 0.65655f
C204 vdd_core.t24 VSS 0.24542f
C205 vdd_core.n44 VSS 0.06901f
C206 vdd_core.n46 VSS 0.04807f
C207 vdd_core.n47 VSS 0.13356f
C208 vdd_core.n48 VSS 0.02332f
C209 vdd_core.n49 VSS 0.03333f
C210 vdd_core.t3 VSS 0.01535f
C211 vdd_core.n52 VSS 0.02272f
C212 vdd_core.n53 VSS 0.04025f
C213 vdd_core.n58 VSS 0.25032f
C214 vdd_core.n62 VSS 0.51081f
C215 vdd_core.n66 VSS 0.01375f
C216 vdd_core.n74 VSS 2.21923f
C217 di_en.n0 VSS 0.43437f
C218 rf_out_n.n0 VSS 0.67241f
C219 rf_out_n.n1 VSS 0.83284f
C220 rf_out_n.t6 VSS 1.72101f
C221 rf_out_n.t2 VSS 0.10806f
C222 rf_out_n.t5 VSS 2.987f
C223 rf_out_n.t3 VSS 0.10646f
C224 rf_out_n.t1 VSS 0.10646f
C225 rf_out_n.t0 VSS 0.37204f
C226 rf_out_n.t4 VSS 0.10646f
C227 rf_out_n.n2 VSS 0.74599f
C228 rf_out_p.n0 VSS 0.92003f
C229 rf_out_p.n1 VSS 0.57327f
C230 rf_out_p.t6 VSS 1.71554f
C231 rf_out_p.t0 VSS 0.1072f
C232 rf_out_p.t1 VSS 3.26692f
C233 rf_out_p.t3 VSS 0.10562f
C234 rf_out_p.t4 VSS 0.10562f
C235 rf_out_p.t5 VSS 0.10562f
C236 rf_out_p.t2 VSS 0.10562f
C237 rf_out_p.n2 VSS 0.74006f
C238 ibias_100u.t3 VSS 0.34287f
C239 ibias_100u.n0 VSS 0.28473f
C240 ibias_100u.n1 VSS 0.18135f
C241 ibias_100u.t0 VSS 0.16179f
C242 ibias_100u.n2 VSS 0.26659f
C243 ibias_100u.t1 VSS 2.1098f
C244 ibias_100u.n3 VSS 0.51286f
.ends

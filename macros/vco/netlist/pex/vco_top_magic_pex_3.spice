* PEX produced on Sat Nov  7 09:43:02 PM CET 2026 using /foss/tools/sak/sak-pex.sh with m=3 and s=1 (extresist threshold=1000 mOhm, minres=100 mOhm, mindelay=0 ps)
* NGSPICE file created from vco_top_pex.ext - technology: ihp-sg13g2

.subckt vco_top_pex di_en VDD VSS vtune rf_out_p rf_out_n
X0 VSS.t39 vco_feed_0.vdd_core.t13 vco_feed_0.vdd_core.t22 VSS.t38 sg13_lv_nmos ad=0.68p pd=4.68u as=0.38p ps=2.38u w=2u l=0.13u
X1 VSS.t9 vco_feed_0.vdd_core.t2 vco_feed_0.vdd_core.t11 VSS.t8 sg13_lv_nmos ad=0.68p pd=4.68u as=0.38p ps=2.38u w=2u l=0.13u
X2 a_20954_346.t7 vco_feed_0.en_b.t2 VDD.t21 VDD.t6 sg13_lv_pmos ad=0.57p pd=3.38u as=0.57p ps=3.38u w=3u l=0.13u
X3 VDD.t16 vco_feed_0.en_b.t2 a_20954_346.t4 VDD.t6 sg13_lv_pmos ad=0.57p pd=3.38u as=0.57p ps=3.38u w=3u l=0.13u
X4 VSS.t162 VSS.t159 VSS.t161 VSS.t160 sg13_lv_nmos ad=0.85p pd=5.68u as=0 ps=0 w=2.5u l=0.5u
X5 VDD.t17 vco_feed_0.en_b.t2 a_20954_346.t7 VDD.t6 sg13_lv_pmos ad=0.57p pd=3.38u as=0.57p ps=3.38u w=3u l=0.13u
X6 a_20954_346.t5 vco_feed_0.en_b.t2 VDD.t16 VDD.t6 sg13_lv_pmos ad=0.57p pd=3.38u as=0.57p ps=3.38u w=3u l=0.13u
X7 rf_out_n.t4 a_9450_4394# a_11798_1180.t26 VSS.t174 sg13_lv_nmos ad=0.38p pd=2.38u as=0.38p ps=2.38u w=2u l=0.13u
X8 VDD.t29 vco_feed_0.en_b.t2 a_20954_346.t10 VDD.t6 sg13_lv_pmos ad=0.57p pd=3.38u as=0.57p ps=3.38u w=3u l=0.13u
X9 a_20954_346.t8 vco_feed_0.en_b.t2 VDD.t17 VDD.t6 sg13_lv_pmos ad=0.57p pd=3.38u as=0.57p ps=3.38u w=3u l=0.13u
X10 rf_out_n.t6 a_9450_4394# a_11798_1180.t24 VSS.t170 sg13_lv_nmos ad=0.38p pd=2.38u as=0.38p ps=2.38u w=2u l=0.13u
X11 VSS.t81 vco_bias_0.vbn_buf.t2 a_11798_1180.t12 VSS.t80 sg13_lv_nmos ad=0.95p pd=5.38u as=0.95p ps=5.38u w=5u l=0.5u
X12 a_11798_1180.t10 vco_bias_0.vbn_buf.t2 VSS.t72 VSS.t71 sg13_lv_nmos ad=0.95p pd=5.38u as=0.95p ps=5.38u w=5u l=0.5u
X13 a_11798_1180.t0 vco_bias_0.vbn_buf.t2 VSS.t45 VSS.t44 sg13_lv_nmos ad=0.95p pd=5.38u as=1.7p ps=10.68u w=5u l=0.5u
X14 VSS.t92 vco_bias_0.vbn_buf.t3 VSS.t90 VSS.t91 sg13_lv_nmos ad=1.52p pd=8.38u as=0 ps=0 w=8u l=10u
X15 a_5060_3002.t2 a_5060_3002.t1 VSS.t5 VSS.t4 sg13_lv_nmos ad=0.85p pd=5.68u as=0.85p ps=5.68u w=2.5u l=0.5u
X16 VSS.t96 vco_bias_0.vbn_buf.t3 VSS.t94 VSS.t95 sg13_lv_nmos ad=1.52p pd=8.38u as=0 ps=0 w=8u l=10u
X17 VSS.t54 vco_bias_0.vbn_buf.t2 a_11798_1180.t3 VSS.t53 sg13_lv_nmos ad=0.95p pd=5.38u as=0.95p ps=5.38u w=5u l=0.5u
X18 VSS.t30 vco_feed_0.vdd_core.t13 vco_feed_0.vdd_core.t18 VSS.t34 sg13_lv_nmos ad=0.38p pd=2.38u as=0.38p ps=2.38u w=2u l=0.13u
X19 vco_bias_0.vbn_buf.t1 vco_feed_0.en_b.t3 VSS.t1 VSS.t0 sg13_lv_nmos ad=0.34p pd=2.68u as=0.34p ps=2.68u w=1u l=0.13u
X20 a_11798_1180.t17 a_14668_2644# rf_out_p.t4 VSS.t140 sg13_lv_nmos ad=0.38p pd=2.38u as=0.38p ps=2.38u w=2u l=0.13u
X21 VSS.t108 vco_bias_0.vbn_buf.t4 VSS.t106 VSS.t93 sg13_lv_nmos ad=1.52p pd=8.38u as=0 ps=0 w=8u l=10u
X22 a_20954_346.t11 vco_feed_0.en_b.t2 VDD.t29 VDD.t6 sg13_lv_pmos ad=0.57p pd=3.38u as=0.57p ps=3.38u w=3u l=0.13u
X23 VDD.t24 vco_feed_0.en_b.t2 a_20954_346.t8 VDD.t6 sg13_lv_pmos ad=0.57p pd=3.38u as=0.57p ps=3.38u w=3u l=0.13u
X24 rf_out_p.t3 a_14668_2644# a_11798_1180.t15 VSS.t137 sg13_lv_nmos ad=0.38p pd=2.38u as=0.68p ps=4.68u w=2u l=0.13u
X25 VSS.t118 vco_bias_0.vbg_buf VSS.t117 VSS.t88 sg13_lv_nmos ad=2.72p pd=16.68u as=0 ps=0 w=8u l=10u
X26 a_5948_4416.t0 vco_feed_0.en_b.t7 VDD.t4 VDD.t0 sg13_lv_pmos ad=0.34p pd=2.68u as=0.34p ps=2.68u w=1u l=0.13u
X27 VSS.t134 vco_bias_0.vbg_buf VSS.t132 VSS.t95 sg13_lv_nmos ad=1.52p pd=8.38u as=0 ps=0 w=8u l=10u
X28 a_5560_5708.t1 a_5560_3922.t0 VSS.t149 rppd l=8.5u w=0.5u
X29 a_5060_3002.t0 vco_feed_0.en_b.t4 VSS.t3 VSS.t2 sg13_lv_nmos ad=0.34p pd=2.68u as=0.34p ps=2.68u w=1u l=0.13u
X30 VSS.t18 vco_feed_0.vdd_core.t2 vco_feed_0.vdd_core.t5 VSS.t17 sg13_lv_nmos ad=0.38p pd=2.38u as=0.38p ps=2.38u w=2u l=0.13u
X31 vco_feed_0.vdd_core.t20 vco_feed_0.vdd_core.t13 VSS.t30 VSS.t29 sg13_lv_nmos ad=0.38p pd=2.38u as=0.38p ps=2.38u w=2u l=0.13u
X32 vco_feed_0.vdd_core.t16 vco_feed_0.vdd_core.t13 VSS.t27 VSS.t28 sg13_lv_nmos ad=0.38p pd=2.38u as=0.38p ps=2.38u w=2u l=0.13u
X33 vco_bias_0.vbg_buf a_5560_5708.t2 VSS.t152 rhigh l=32u w=0.5u
X34 vco_feed_0.vdd_core.t9 vco_feed_0.vdd_core.t2 VSS.t11 VSS.t10 sg13_lv_nmos ad=0.38p pd=2.38u as=0.38p ps=2.38u w=2u l=0.13u
X35 vco_feed_0.en_b.t1 di_en.t0 VSS.t41 VSS.t40 sg13_lv_nmos ad=0.17p pd=1.68u as=0.17p ps=1.68u w=0.5u l=0.13u
X36 VDD.t31 vco_feed_0.en_b.t2 a_20954_346.t11 VDD.t6 sg13_lv_pmos ad=0.57p pd=3.38u as=0.57p ps=3.38u w=3u l=0.13u
N37 vco_feed_0.vdd_core.t30 vtune.t0 sg13_hv_svaricap l=0.3u w=26.34u
X38 a_20954_346.t9 vco_feed_0.en_b.t2 VDD.t24 VDD.t6 sg13_lv_pmos ad=0.57p pd=3.38u as=0.57p ps=3.38u w=3u l=0.13u
X39 a_11798_1180.t20 a_14668_2644# rf_out_p.t0 VSS.t146 sg13_lv_nmos ad=0.38p pd=2.38u as=0.38p ps=2.38u w=2u l=0.13u
X40 VSS.t132 vco_bias_0.vbg_buf VSS.t130 VSS.t93 sg13_lv_nmos ad=1.52p pd=8.38u as=0 ps=0 w=8u l=10u
X41 VSS.t72 vco_bias_0.vbn_buf.t2 a_11798_1180.t9 VSS.t75 sg13_lv_nmos ad=0.95p pd=5.38u as=0.95p ps=5.38u w=5u l=0.5u
X42 vco_bias_0.vbg_buf VSS.t113 cap_cmim l=19.1u w=17.5u
X43 VSS.t47 vco_bias_0.vbn_buf.t2 a_11798_1180.t0 VSS.t46 sg13_lv_nmos ad=0.95p pd=5.38u as=0.95p ps=5.38u w=5u l=0.5u
X44 a_11798_1180.t13 vco_bias_0.vbn_buf.t2 VSS.t81 VSS.t82 sg13_lv_nmos ad=0.95p pd=5.38u as=0.95p ps=5.38u w=5u l=0.5u
X45 vco_bias_0.vbn_buf.t0 a_5060_3002.t4 VSS.t154 rhigh l=32u w=0.5u
X46 a_11798_1180.t14 vco_bias_0.vbn_buf.t2 VSS.t84 VSS.t85 sg13_lv_nmos ad=0.95p pd=5.38u as=0.95p ps=5.38u w=5u l=0.5u
X47 a_20954_346.t12 vco_feed_0.en_b.t2 VDD.t31 VDD.t6 sg13_lv_pmos ad=0.57p pd=3.38u as=0.57p ps=3.38u w=3u l=0.13u
X48 VDD.t26 vco_feed_0.en_b.t2 a_20954_346.t9 VDD.t6 sg13_lv_pmos ad=0.57p pd=3.38u as=0.57p ps=3.38u w=3u l=0.13u
N49 vco_feed_0.vdd_core.t29 vtune.t0 sg13_hv_svaricap l=0.3u w=26.34u
X50 VDD.t28 vco_feed_0.en_b.t2 a_20954_346.t12 VDD.t6 sg13_lv_pmos ad=0.57p pd=3.38u as=0.57p ps=3.38u w=3u l=0.13u
X51 a_20954_346.t10 vco_feed_0.en_b.t2 VDD.t26 VDD.t6 sg13_lv_pmos ad=0.57p pd=3.38u as=0.57p ps=3.38u w=3u l=0.13u
X52 VSS.t94 vco_bias_0.vbn_buf.t3 VSS.t92 VSS.t93 sg13_lv_nmos ad=1.52p pd=8.38u as=0 ps=0 w=8u l=10u
X53 a_11798_1180.t27 a_9450_4394# rf_out_n.t4 VSS.t175 sg13_lv_nmos ad=0.38p pd=2.38u as=0.38p ps=2.38u w=2u l=0.13u
X54 VDD.t38 vco_feed_0.en_b.t2 a_20954_346.t15 VDD.t6 sg13_lv_pmos ad=1.02p pd=6.68u as=0.57p ps=3.38u w=3u l=0.13u
X55 a_20954_346.t13 vco_feed_0.en_b.t2 VDD.t28 VDD.t6 sg13_lv_pmos ad=0.57p pd=3.38u as=0.57p ps=3.38u w=3u l=0.13u
X56 a_11798_1180.t4 vco_bias_0.vbn_buf.t2 VSS.t54 VSS.t55 sg13_lv_nmos ad=0.95p pd=5.38u as=0.95p ps=5.38u w=5u l=0.5u
X57 a_11798_1180.t25 a_9450_4394# rf_out_n.t6 VSS.t171 sg13_lv_nmos ad=0.38p pd=2.38u as=0.38p ps=2.38u w=2u l=0.13u
X58 VSS.t120 vco_bias_0.vbg_buf VSS.t118 VSS.t91 sg13_lv_nmos ad=1.52p pd=8.38u as=0 ps=0 w=8u l=10u
X59 VSS.t64 vco_bias_0.vbn_buf.t2 a_11798_1180.t7 VSS.t63 sg13_lv_nmos ad=0.95p pd=5.38u as=0.95p ps=5.38u w=5u l=0.5u
X60 VSS.t136 vco_bias_0.vbg_buf VSS.t134 VSS.t97 sg13_lv_nmos ad=1.52p pd=8.38u as=0 ps=0 w=8u l=10u
X61 VDD.t46 VDD.t44 VDD.t45 VDD.t0 sg13_lv_pmos ad=1.7p pd=10.68u as=0 ps=0 w=5u l=0.5u
X62 VSS.t84 vco_bias_0.vbn_buf.t2 a_11798_1180.t13 VSS.t83 sg13_lv_nmos ad=0.95p pd=5.38u as=0.95p ps=5.38u w=5u l=0.5u
X63 VSS.t36 vco_feed_0.vdd_core.t13 vco_feed_0.vdd_core.t20 VSS.t35 sg13_lv_nmos ad=0.38p pd=2.38u as=0.38p ps=2.38u w=2u l=0.13u
X64 VSS.t87 vco_bias_0.vbn_buf.t2 a_11798_1180.t14 VSS.t86 sg13_lv_nmos ad=1.7p pd=10.68u as=0.95p ps=5.38u w=5u l=0.5u
X65 VSS.t104 vco_bias_0.vbn_buf.t4 VSS.t103 VSS.t88 sg13_lv_nmos ad=2.72p pd=16.68u as=0 ps=0 w=8u l=10u
X66 VSS.t22 vco_feed_0.vdd_core.t2 vco_feed_0.vdd_core.t9 VSS.t21 sg13_lv_nmos ad=0.38p pd=2.38u as=0.38p ps=2.38u w=2u l=0.13u
X67 VDD.t34 vco_feed_0.en_b.t2 a_20954_346.t13 VDD.t6 sg13_lv_pmos ad=0.57p pd=3.38u as=0.57p ps=3.38u w=3u l=0.13u
X68 VDD.t43 VDD.t41 VDD.t42 VDD.t0 sg13_lv_pmos ad=0.34p pd=2.68u as=0 ps=0 w=1u l=0.13u
X69 VDD.t50 rf_out_p.t6 VSS.t178 rppd l=1.65u w=10u
X70 a_6568_6136.t0 a_5948_4416.t2 VDD.t5 VDD.t0 sg13_lv_pmos ad=0.34p pd=2.68u as=0.34p ps=2.68u w=1u l=0.13u
X71 a_20954_346.t14 vco_feed_0.en_b.t2 VDD.t34 VDD.t6 sg13_lv_pmos ad=0.57p pd=3.38u as=0.57p ps=3.38u w=3u l=0.13u
X72 rf_out_p.t1 a_14668_2644# a_11798_1180.t20 VSS.t147 sg13_lv_nmos ad=0.38p pd=2.38u as=0.38p ps=2.38u w=2u l=0.13u
X73 vco_feed_0.en_b.t0 di_en.t1 VDD.t39 VDD.t0 sg13_lv_pmos ad=0.34p pd=2.68u as=0.34p ps=2.68u w=1u l=0.13u
X74 a_11798_1180.t7 vco_bias_0.vbn_buf.t2 VSS.t62 VSS.t61 sg13_lv_nmos ad=0.95p pd=5.38u as=0.95p ps=5.38u w=5u l=0.5u
X75 rf_out_p.t2 a_14668_2644# a_11798_1180.t18 VSS.t143 sg13_lv_nmos ad=0.38p pd=2.38u as=0.38p ps=2.38u w=2u l=0.13u
X76 VSS.t112 vco_bias_0.vbn_buf.t4 VSS.t110 VSS.t97 sg13_lv_nmos ad=1.52p pd=8.38u as=0 ps=0 w=8u l=10u
X77 vco_feed_0.vdd_core.t7 vco_feed_0.vdd_core.t2 VSS.t18 VSS.t19 sg13_lv_nmos ad=0.38p pd=2.38u as=0.38p ps=2.38u w=2u l=0.13u
X78 VSS.t74 vco_bias_0.vbn_buf.t2 a_11798_1180.t10 VSS.t76 sg13_lv_nmos ad=0.95p pd=5.38u as=0.95p ps=5.38u w=5u l=0.5u
X79 a_11798_1180.t8 vco_bias_0.vbn_buf.t2 VSS.t64 VSS.t67 sg13_lv_nmos ad=0.95p pd=5.38u as=0.95p ps=5.38u w=5u l=0.5u
X80 vco_feed_0.vdd_core.t3 vco_feed_0.vdd_core.t2 VSS.t13 VSS.t12 sg13_lv_nmos ad=0.38p pd=2.38u as=0.68p ps=4.68u w=2u l=0.13u
X81 VSS.t78 vco_bias_0.vbn_buf.t2 a_11798_1180.t11 VSS.t77 sg13_lv_nmos ad=0.95p pd=5.38u as=0.95p ps=5.38u w=5u l=0.5u
X82 VSS.t32 vco_feed_0.vdd_core.t13 vco_feed_0.vdd_core.t16 VSS.t33 sg13_lv_nmos ad=0.38p pd=2.38u as=0.38p ps=2.38u w=2u l=0.13u
X83 VDD.t36 vco_feed_0.en_b.t2 a_20954_346.t14 VDD.t6 sg13_lv_pmos ad=0.57p pd=3.38u as=0.57p ps=3.38u w=3u l=0.13u
X84 rf_out_n.t1 a_9450_4394# a_11798_1180.t22 VSS.t166 sg13_lv_nmos ad=0.38p pd=2.38u as=0.68p ps=4.68u w=2u l=0.13u
N85 vco_feed_0.vdd_core.t27 vtune.t4 sg13_hv_svaricap l=0.3u w=26.34u
X86 a_5560_5708.t0 a_6568_6136.t4 VDD.t2 VDD.t0 sg13_lv_pmos ad=1.7p pd=10.68u as=1.7p ps=10.68u w=5u l=0.5u
X87 VSS.t15 vco_feed_0.vdd_core.t2 vco_feed_0.vdd_core.t3 VSS.t14 sg13_lv_nmos ad=0.38p pd=2.38u as=0.38p ps=2.38u w=2u l=0.13u
X88 VSS.t90 vco_bias_0.vbn_buf.t3 VSS.t89 VSS.t88 sg13_lv_nmos ad=2.72p pd=16.68u as=0 ps=0 w=8u l=10u
X89 a_20954_346.t15 vco_feed_0.en_b.t2 VDD.t36 VDD.t6 sg13_lv_pmos ad=0.57p pd=3.38u as=0.57p ps=3.38u w=3u l=0.13u
X90 rf_out_n.t5 a_9450_4394# a_11798_1180.t27 VSS.t176 sg13_lv_nmos ad=0.38p pd=2.38u as=0.38p ps=2.38u w=2u l=0.13u
X91 VSS.t128 vco_bias_0.vbg_buf VSS.t127 VSS.t88 sg13_lv_nmos ad=2.72p pd=16.68u as=0 ps=0 w=8u l=10u
X92 rf_out_n.t3 a_9450_4394# a_11798_1180.t25 VSS.t172 sg13_lv_nmos ad=0.38p pd=2.38u as=0.38p ps=2.38u w=2u l=0.13u
X93 a_5060_5708.t0 vco_feed_0.en_b.t6 VDD.t3 VDD.t0 sg13_lv_pmos ad=0.68p pd=4.68u as=0.68p ps=4.68u w=2u l=0.13u
X94 VSS.t50 vco_bias_0.vbn_buf.t2 a_11798_1180.t1 VSS.t49 sg13_lv_nmos ad=0.95p pd=5.38u as=0.95p ps=5.38u w=5u l=0.5u
X95 VDD.t8 vco_feed_0.en_b.t2 a_20954_346.t0 VDD.t6 sg13_lv_pmos ad=0.57p pd=3.38u as=0.57p ps=3.38u w=3u l=0.13u
X96 a_11798_1180.t5 vco_bias_0.vbn_buf.t2 VSS.t57 VSS.t58 sg13_lv_nmos ad=0.95p pd=5.38u as=0.95p ps=5.38u w=5u l=0.5u
N97 vco_feed_0.vdd_core.t31 vtune.t2 sg13_hv_svaricap l=0.3u w=26.34u
X98 a_11798_1180.t11 vco_bias_0.vbn_buf.t2 VSS.t74 VSS.t73 sg13_lv_nmos ad=0.95p pd=5.38u as=0.95p ps=5.38u w=5u l=0.5u
X99 a_11798_1180.t12 vco_bias_0.vbn_buf.t2 VSS.t78 VSS.t79 sg13_lv_nmos ad=0.95p pd=5.38u as=0.95p ps=5.38u w=5u l=0.5u
X100 a_9450_4394# vco_feed_0.vdd_core.t24 cap_cmim l=10u w=10u
X101 a_20954_346.t1 vco_feed_0.en_b.t2 VDD.t8 VDD.t6 sg13_lv_pmos ad=0.57p pd=3.38u as=0.57p ps=3.38u w=3u l=0.13u
X102 a_11798_1180.t16 a_14668_2644# rf_out_p.t3 VSS.t138 sg13_lv_nmos ad=0.38p pd=2.38u as=0.38p ps=2.38u w=2u l=0.13u
X103 VSS.t98 vco_bias_0.vbn_buf.t3 VSS.t96 VSS.t97 sg13_lv_nmos ad=1.52p pd=8.38u as=0 ps=0 w=8u l=10u
X104 VSS.t158 VSS.t155 VSS.t157 VSS.t156 sg13_lv_nmos ad=0.85p pd=5.68u as=0 ps=0 w=2.5u l=0.5u
X105 vco_feed_0.vdd_core.t22 vco_feed_0.vdd_core.t13 VSS.t36 VSS.t37 sg13_lv_nmos ad=0.38p pd=2.38u as=0.38p ps=2.38u w=2u l=0.13u
X106 vco_feed_0.vdd_core.t11 vco_feed_0.vdd_core.t2 VSS.t22 VSS.t23 sg13_lv_nmos ad=0.38p pd=2.38u as=0.38p ps=2.38u w=2u l=0.13u
X107 a_11798_1180.t1 vco_bias_0.vbn_buf.t2 VSS.t47 VSS.t48 sg13_lv_nmos ad=0.95p pd=5.38u as=0.95p ps=5.38u w=5u l=0.5u
X108 VDD.t10 vco_feed_0.en_b.t2 a_20954_346.t1 VDD.t6 sg13_lv_pmos ad=0.57p pd=3.38u as=0.57p ps=3.38u w=3u l=0.13u
X109 VSS.t57 vco_bias_0.vbn_buf.t2 a_11798_1180.t4 VSS.t56 sg13_lv_nmos ad=0.95p pd=5.38u as=0.95p ps=5.38u w=5u l=0.5u
X110 a_11798_1180.t2 vco_bias_0.vbn_buf.t2 VSS.t50 VSS.t51 sg13_lv_nmos ad=0.95p pd=5.38u as=0.95p ps=5.38u w=5u l=0.5u
X111 a_11798_1180.t19 a_14668_2644# rf_out_p.t2 VSS.t144 sg13_lv_nmos ad=0.38p pd=2.38u as=0.38p ps=2.38u w=2u l=0.13u
X112 rf_out_p.t5 a_14668_2644# a_11798_1180.t17 VSS.t141 sg13_lv_nmos ad=0.38p pd=2.38u as=0.38p ps=2.38u w=2u l=0.13u
X113 VSS.t124 vco_bias_0.vbg_buf VSS.t122 VSS.t95 sg13_lv_nmos ad=1.52p pd=8.38u as=0 ps=0 w=8u l=10u
X114 VDD.t49 VDD.t47 VDD.t48 VDD.t0 sg13_lv_pmos ad=1.7p pd=10.68u as=0 ps=0 w=5u l=0.5u
X115 a_14668_2644# vco_feed_0.vdd_core.t0 cap_cmim l=10u w=10u
X116 VSS.t60 vco_bias_0.vbn_buf.t2 a_11798_1180.t5 VSS.t59 sg13_lv_nmos ad=0.95p pd=5.38u as=0.95p ps=5.38u w=5u l=0.5u
X117 a_11798_1180.t9 vco_bias_0.vbn_buf.t2 VSS.t69 VSS.t70 sg13_lv_nmos ad=0.95p pd=5.38u as=0.95p ps=5.38u w=5u l=0.5u
X118 a_5560_3922.t2 a_5560_3922.t1 VSS.t181 VSS.t180 sg13_lv_nmos ad=0.85p pd=5.68u as=0.85p ps=5.68u w=2.5u l=0.5u
X119 a_11798_1180.t23 a_9450_4394# rf_out_n.t1 VSS.t167 sg13_lv_nmos ad=0.38p pd=2.38u as=0.38p ps=2.38u w=2u l=0.13u
X120 VSS.t130 vco_bias_0.vbg_buf VSS.t128 VSS.t91 sg13_lv_nmos ad=1.52p pd=8.38u as=0 ps=0 w=8u l=10u
X121 a_20954_346.t2 vco_feed_0.en_b.t2 VDD.t10 VDD.t6 sg13_lv_pmos ad=0.57p pd=3.38u as=0.57p ps=3.38u w=3u l=0.13u
X122 VSS.t122 vco_bias_0.vbg_buf VSS.t120 VSS.t93 sg13_lv_nmos ad=1.52p pd=8.38u as=0 ps=0 w=8u l=10u
X123 VSS.t11 vco_feed_0.vdd_core.t2 vco_feed_0.vdd_core.t7 VSS.t20 sg13_lv_nmos ad=0.38p pd=2.38u as=0.38p ps=2.38u w=2u l=0.13u
X124 a_6568_6136.t3 a_6568_6136.t2 VDD.t1 VDD.t0 sg13_lv_pmos ad=1.7p pd=10.68u as=1.7p ps=10.68u w=5u l=0.5u
X125 vco_feed_0.vdd_core.t18 vco_feed_0.vdd_core.t13 VSS.t32 VSS.t31 sg13_lv_nmos ad=0.38p pd=2.38u as=0.38p ps=2.38u w=2u l=0.13u
X126 a_11798_1180.t28 a_9450_4394# rf_out_n.t5 VSS.t177 sg13_lv_nmos ad=0.68p pd=4.68u as=0.38p ps=2.38u w=2u l=0.13u
X127 vco_feed_0.vdd_core.t14 vco_feed_0.vdd_core.t13 VSS.t25 VSS.t24 sg13_lv_nmos ad=0.38p pd=2.38u as=0.68p ps=4.68u w=2u l=0.13u
X128 vco_feed_0.vdd_core VSS.t99 cap_cmim l=39u w=56u
X129 VDD.t12 vco_feed_0.en_b.t2 a_20954_346.t2 VDD.t6 sg13_lv_pmos ad=0.57p pd=3.38u as=0.57p ps=3.38u w=3u l=0.13u
X130 a_11798_1180.t26 a_9450_4394# rf_out_n.t3 VSS.t173 sg13_lv_nmos ad=0.38p pd=2.38u as=0.38p ps=2.38u w=2u l=0.13u
X131 a_20954_346.t0 vco_feed_0.en_b.t2 VDD.t7 VDD.t6 sg13_lv_pmos ad=0.57p pd=3.38u as=1.02p ps=6.68u w=3u l=0.13u
X132 VDD.t19 vco_feed_0.en_b.t2 a_20954_346.t5 VDD.t6 sg13_lv_pmos ad=0.57p pd=3.38u as=0.57p ps=3.38u w=3u l=0.13u
X133 a_11798_1180.t24 a_9450_4394# rf_out_n.t2 VSS.t169 sg13_lv_nmos ad=0.38p pd=2.38u as=0.38p ps=2.38u w=2u l=0.13u
N134 vco_feed_0.vdd_core.t28 vtune.t4 sg13_hv_svaricap l=0.3u w=26.34u
X135 vco_bias_0.vbg_buf a_14668_2644# VSS.t150 rhigh l=8u w=0.5u
X136 a_20954_346.t3 vco_feed_0.en_b.t2 VDD.t12 VDD.t6 sg13_lv_pmos ad=0.57p pd=3.38u as=0.57p ps=3.38u w=3u l=0.13u
X137 VSS.t43 vco_bias_0.vbn_buf.t2 a_11798_1180.t2 VSS.t42 sg13_lv_nmos ad=0.95p pd=5.38u as=0.95p ps=5.38u w=5u l=0.5u
X138 a_6568_6136.t1 a_5060_3002.t5 VSS.t7 VSS.t6 sg13_lv_nmos ad=0.85p pd=5.68u as=0.85p ps=5.68u w=2.5u l=0.5u
X139 vco_feed_0.vdd_core.t5 vco_feed_0.vdd_core.t2 VSS.t15 VSS.t16 sg13_lv_nmos ad=0.38p pd=2.38u as=0.38p ps=2.38u w=2u l=0.13u
X140 VSS.t69 vco_bias_0.vbn_buf.t2 a_11798_1180.t8 VSS.t68 sg13_lv_nmos ad=0.95p pd=5.38u as=0.95p ps=5.38u w=5u l=0.5u
X141 a_11798_1180.t6 vco_bias_0.vbn_buf.t2 VSS.t60 VSS.t65 sg13_lv_nmos ad=0.95p pd=5.38u as=0.95p ps=5.38u w=5u l=0.5u
X142 VSS.t27 vco_feed_0.vdd_core.t13 vco_feed_0.vdd_core.t14 VSS.t26 sg13_lv_nmos ad=0.38p pd=2.38u as=0.38p ps=2.38u w=2u l=0.13u
X143 a_5948_4416.t1 vco_feed_0.en_b.t5 VSS.t165 VSS.t164 sg13_lv_nmos ad=0.17p pd=1.68u as=0.17p ps=1.68u w=0.5u l=0.13u
X144 vco_bias_0.vbg_buf VSS.t115 cap_cmim l=7.28u w=13.6u
X145 a_20954_346.t16 vco_feed_0.vdd_core.t26 VSS.t179 rppd l=8.8u w=17.3u
X146 rf_out_p.t4 a_14668_2644# a_11798_1180.t16 VSS.t139 sg13_lv_nmos ad=0.38p pd=2.38u as=0.38p ps=2.38u w=2u l=0.13u
X147 a_20954_346.t6 vco_feed_0.en_b.t2 VDD.t19 VDD.t6 sg13_lv_pmos ad=0.57p pd=3.38u as=0.57p ps=3.38u w=3u l=0.13u
X148 VDD.t14 vco_feed_0.en_b.t2 a_20954_346.t3 VDD.t6 sg13_lv_pmos ad=0.57p pd=3.38u as=0.57p ps=3.38u w=3u l=0.13u
N149 vco_feed_0.vdd_core.t32 vtune.t2 sg13_hv_svaricap l=0.3u w=26.34u
X150 VDD.t40 rf_out_n.t0 VSS.t151 rppd l=1.65u w=10u
X151 VSS.t126 vco_bias_0.vbg_buf VSS.t124 VSS.t97 sg13_lv_nmos ad=1.52p pd=8.38u as=0 ps=0 w=8u l=10u
X152 VSS.t106 vco_bias_0.vbn_buf.t4 VSS.t104 VSS.t91 sg13_lv_nmos ad=1.52p pd=8.38u as=0 ps=0 w=8u l=10u
X153 VSS.t110 vco_bias_0.vbn_buf.t4 VSS.t108 VSS.t95 sg13_lv_nmos ad=1.52p pd=8.38u as=0 ps=0 w=8u l=10u
X154 vco_feed_0.vdd_core VSS.t101 cap_cmim l=25.5u w=42u
X155 VDD.t21 vco_feed_0.en_b.t2 a_20954_346.t6 VDD.t6 sg13_lv_pmos ad=0.57p pd=3.38u as=0.57p ps=3.38u w=3u l=0.13u
X156 a_20954_346.t4 vco_feed_0.en_b.t2 VDD.t14 VDD.t6 sg13_lv_pmos ad=0.57p pd=3.38u as=0.57p ps=3.38u w=3u l=0.13u
X157 a_11798_1180.t21 a_14668_2644# rf_out_p.t1 VSS.t148 sg13_lv_nmos ad=0.68p pd=4.68u as=0.38p ps=2.38u w=2u l=0.13u
X158 a_5060_5708.t1 a_5060_3002.t3 VSS.t153 rppd l=13.1u w=0.5u
X159 rf_out_p.t0 a_14668_2644# a_11798_1180.t19 VSS.t145 sg13_lv_nmos ad=0.38p pd=2.38u as=0.38p ps=2.38u w=2u l=0.13u
X160 vco_bias_0.vbg_buf a_9450_4394# VSS.t163 rhigh l=8u w=0.5u
X161 a_11798_1180.t18 a_14668_2644# rf_out_p.t5 VSS.t142 sg13_lv_nmos ad=0.38p pd=2.38u as=0.38p ps=2.38u w=2u l=0.13u
X162 a_11798_1180.t3 vco_bias_0.vbn_buf.t2 VSS.t43 VSS.t52 sg13_lv_nmos ad=0.95p pd=5.38u as=0.95p ps=5.38u w=5u l=0.5u
X163 VSS.t62 vco_bias_0.vbn_buf.t2 a_11798_1180.t6 VSS.t66 sg13_lv_nmos ad=0.95p pd=5.38u as=0.95p ps=5.38u w=5u l=0.5u
X164 rf_out_n.t2 a_9450_4394# a_11798_1180.t23 VSS.t168 sg13_lv_nmos ad=0.38p pd=2.38u as=0.38p ps=2.38u w=2u l=0.13u
R0 rf_out_p.n0 rf_out_p.t3 6.56137
R1 rf_out_p.n1 rf_out_p.t1 6.52949
R2 rf_out_p.n1 rf_out_p.t0 6.52949
R3 rf_out_p.n0 rf_out_p.t2 6.52949
R4 rf_out_p.n0 rf_out_p.t5 6.52949
R5 rf_out_p.n0 rf_out_p.t4 6.52949
R6 rf_out_p rf_out_p.n2 1.88238
R7 rf_out_p.n2 rf_out_p.t6 1.62005
R8 rf_out_p.n1 rf_out_p.n0 0.128045
R9 rf_out_p.n2 rf_out_p.n1 0.117417
R10 rf_out_n.n0 rf_out_n.t5 6.56137
R11 rf_out_n.n0 rf_out_n.t4 6.52949
R12 rf_out_n.n0 rf_out_n.t3 6.52949
R13 rf_out_n.n1 rf_out_n.t6 6.52949
R14 rf_out_n.n1 rf_out_n.t2 6.52949
R15 rf_out_n.n1 rf_out_n.t1 6.52949
R16 rf_out_n rf_out_n.n2 1.88238
R17 rf_out_n.n2 rf_out_n.t0 1.62005
R18 rf_out_n.n1 rf_out_n.n0 0.128045
R19 rf_out_n.n2 rf_out_n.n1 0.117417
R20 di_en.n0 di_en.t0 21.6583
R21 di_en.n0 di_en.t1 19.605
R22 di_en di_en.n0 14.2582
R23 vtune.n0 vtune.t2 16.1774
R24 vtune vtune.n1 16.1137
R25 vtune.n0 vtune.t0 14.7078
R26 vtune.n1 vtune.t4 14.7078
R27 vtune.n1 vtune.n0 1.4701
R28 VDD VDD.n24 32.7055
R29 VDD.n17 VDD.t47 17.5809
R30 VDD.n0 VDD.t44 17.5809
R31 VDD.n60 VDD.n1 1.2602
R32 VDD.n18 VDD.t48 2.54465
R33 VDD.n2 VDD.t41 15.8062
R34 VDD.n57 VDD.n56 10.8262
R35 VDD.n59 VDD.n58 10.8262
R36 VDD.n20 VDD.n29 3.37066
R37 VDD.n25 VDD.t42 6.07554
R38 VDD.n2 VDD.t43 6.07554
R39 VDD.n19 VDD.t5 6.07554
R40 VDD.n23 VDD.t39 6.07554
R41 VDD.n24 VDD.t4 6.07554
R42 VDD.n1 VDD.n19 0.0656783
R43 VDD.n54 VDD.n22 0.830556
R44 VDD.n22 VDD.n29 2.80696
R45 VDD.n52 VDD.n51 0.0585658
R46 VDD.n51 VDD.n29 2.7974
R47 VDD.n50 VDD.n48 0.0585658
R48 VDD.n48 VDD.n29 2.7974
R49 VDD.n47 VDD.n30 0.066765
R50 VDD.n21 VDD.n42 0.0585658
R51 VDD.n42 VDD.n29 2.7974
R52 VDD.n41 VDD.n37 0.0585658
R53 VDD.n37 VDD.n29 2.7974
R54 VDD.n28 VDD.n29 2.37707
R55 VDD.n19 VDD.n23 0.1061
R56 VDD.n30 VDD.n29 2.3909
R57 VDD.n27 VDD.n28 0.0743661
R58 VDD.n58 VDD.n57 3.7073
R59 VDD.n25 VDD.t3 3.45404
R60 VDD.n24 VDD.n60 3.37539
R61 VDD.n60 VDD.n0 1.51113
R62 VDD.n60 VDD.n18 1.16155
R63 VDD.n32 VDD.t17 2.57245
R64 VDD.n0 VDD.t45 2.36428
R65 VDD.n17 VDD.t1 2.36394
R66 VDD.n17 VDD.t49 2.36357
R67 VDD.n0 VDD.t46 2.36357
R68 VDD.n33 VDD.t2 2.36299
R69 VDD.n3 VDD.n55 2.10932
R70 VDD.n54 VDD.n16 2.10932
R71 VDD.n55 VDD.t7 2.06537
R72 VDD.n54 VDD.t38 2.06537
R73 VDD.n26 VDD.t8 2.06506
R74 VDD.n35 VDD.t10 2.06506
R75 VDD.n38 VDD.t12 2.06506
R76 VDD.n40 VDD.t14 2.06506
R77 VDD.n43 VDD.t16 2.06506
R78 VDD.n44 VDD.t19 2.06506
R79 VDD.n45 VDD.t21 2.06506
R80 VDD.n53 VDD.t24 2.06506
R81 VDD.n9 VDD.t26 2.06506
R82 VDD.n8 VDD.t29 2.06506
R83 VDD.n12 VDD.t31 2.06506
R84 VDD.n11 VDD.t28 2.06506
R85 VDD.n15 VDD.t34 2.06506
R86 VDD.n14 VDD.t36 2.06506
R87 VDD.n3 VDD.n26 2.01733
R88 VDD.n4 VDD.n35 2.01733
R89 VDD.n4 VDD.n38 2.01733
R90 VDD.n5 VDD.n40 2.01733
R91 VDD.n5 VDD.n43 2.01733
R92 VDD.n6 VDD.n44 2.01733
R93 VDD.n6 VDD.n45 2.01733
R94 VDD.n53 VDD.n7 2.01733
R95 VDD.n10 VDD.n9 2.01733
R96 VDD.n10 VDD.n8 2.01733
R97 VDD.n13 VDD.n12 2.01733
R98 VDD.n13 VDD.n11 2.01733
R99 VDD.n16 VDD.n15 2.01733
R100 VDD.n16 VDD.n14 2.01733
R101 VDD.n56 VDD.n7 0.833598
R102 VDD.n55 VDD.n27 0.811613
R103 VDD.n27 VDD.n26 0.75308
R104 VDD.n36 VDD.n35 0.75308
R105 VDD.n34 VDD.n38 0.75308
R106 VDD.n41 VDD.n40 0.75308
R107 VDD.n39 VDD.n43 0.75308
R108 VDD.n21 VDD.n44 0.75308
R109 VDD.n21 VDD.n45 0.75308
R110 VDD.n31 VDD.n53 0.75308
R111 VDD.n47 VDD.n9 0.75308
R112 VDD.n46 VDD.n8 0.75308
R113 VDD.n50 VDD.n12 0.75308
R114 VDD.n49 VDD.n11 0.75308
R115 VDD.n52 VDD.n15 0.75308
R116 VDD.n22 VDD.n14 0.75308
R117 VDD VDD.n59 0.597573
R118 VDD.n57 VDD.t50 0.517741
R119 VDD.n58 VDD.t40 0.517741
R120 VDD.n60 VDD.t0 0.395849
R121 VDD.n59 VDD.n56 0.35172
R122 VDD.n29 VDD.t6 0.347439
R123 VDD.n0 VDD.n33 0.222999
R124 VDD.n2 VDD.n25 0.199822
R125 VDD.n16 VDD.n13 0.183684
R126 VDD.n13 VDD.n10 0.183684
R127 VDD.n10 VDD.n7 0.183684
R128 VDD.n7 VDD.n6 0.183684
R129 VDD.n6 VDD.n5 0.183684
R130 VDD.n5 VDD.n4 0.183684
R131 VDD.n4 VDD.n3 0.183684
R132 VDD.n33 VDD.n17 0.181347
R133 VDD.n28 VDD.n36 0.099072
R134 VDD.n32 VDD.n31 0.174604
R135 VDD.n52 VDD.n22 0.155757
R136 VDD.n7 VDD.n32 0.152545
R137 VDD.n24 VDD.n23 0.152127
R138 VDD.n18 VDD.n17 0.0814646
R139 VDD.n2 VDD.n1 0.0766266
R140 VDD.n0 VDD.n25 0.139213
R141 VDD.n49 VDD.n51 0.0585658
R142 VDD.n50 VDD.n49 0.116817
R143 VDD.n46 VDD.n48 0.0585658
R144 VDD.n47 VDD.n46 0.116817
R145 VDD.n31 VDD.n30 0.0501977
R146 VDD.n39 VDD.n42 0.0585658
R147 VDD.n41 VDD.n39 0.116817
R148 VDD.n34 VDD.n37 0.0585658
R149 VDD.n36 VDD.n34 0.116817
R150 VDD.n21 VDD.n20 0.116756
R151 VDD.n20 VDD.n32 0.116351
R152 VSS.t150 VSS.n43 2824.33
R153 VSS.n374 VSS.n286 18957.8
R154 VSS.t179 VSS.n43 170.041
R155 VSS.n154 VSS.n153 1094.66
R156 VSS.t154 VSS.n469 657.683
R157 VSS.t150 VSS.t178 301.887
R158 VSS.t149 VSS.t153 224.619
R159 VSS.t152 VSS.t154 179.696
R160 VSS.t153 VSS.t152 157.233
R161 VSS.n470 VSS.t149 142.626
R162 VSS.t178 VSS.n92 109.811
R163 VSS.n477 VSS.n476 69.913
R164 VSS.t4 VSS.n39 31.5502
R165 VSS.t160 VSS.n475 48.555
R166 VSS.n472 VSS.t40 47.8044
R167 VSS.n40 VSS.t180 45.1788
R168 VSS.n474 VSS.t0 43.4374
R169 VSS.t2 VSS.n472 37.5655
R170 VSS.t156 VSS.n40 15.7829
R171 VSS.n475 VSS.t4 32.6297
R172 VSS.n471 VSS.t164 30.9232
R173 VSS.n38 VSS.n40 0.0278401
R174 VSS.n473 VSS.t2 26.3726
R175 VSS.n511 VSS.n58 25.2835
R176 VSS.n375 VSS.n374 21.7962
R177 VSS.n306 VSS.t88 20.8203
R178 VSS.t0 VSS.n473 20.6825
R179 VSS.t164 VSS.n470 20.4783
R180 VSS.t180 VSS.n474 18.976
R181 VSS.n458 VSS.t165 17.3443
R182 VSS.n460 VSS.t41 17.3443
R183 VSS.n555 VSS.n554 17.0005
R184 VSS.n555 VSS.n157 17.0005
R185 VSS.n555 VSS.n158 17.0005
R186 VSS.n556 VSS.n555 17.0005
R187 VSS.n555 VSS.n159 17.0005
R188 VSS.n555 VSS.n160 17.0005
R189 VSS.n555 VSS.n161 17.0005
R190 VSS.n555 VSS.n162 17.0005
R191 VSS.n555 VSS.n163 17.0005
R192 VSS.n555 VSS.n164 17.0005
R193 VSS.n555 VSS.n165 17.0005
R194 VSS.n555 VSS.n166 17.0005
R195 VSS.n555 VSS.n167 17.0005
R196 VSS.n555 VSS.n168 17.0005
R197 VSS.n555 VSS.n552 17.0005
R198 VSS.n555 VSS.n553 17.0005
R199 VSS.n540 VSS.n539 17.0005
R200 VSS.n540 VSS.n190 17.0005
R201 VSS.n540 VSS.n535 17.0005
R202 VSS.n540 VSS.n191 17.0005
R203 VSS.n540 VSS.n534 17.0005
R204 VSS.n540 VSS.n192 17.0005
R205 VSS.n540 VSS.n532 17.0005
R206 VSS.n540 VSS.n193 17.0005
R207 VSS.n540 VSS.n531 17.0005
R208 VSS.n12 VSS.n540 2.8034
R209 VSS.n540 VSS.n194 17.0005
R210 VSS.n540 VSS.n530 17.0005
R211 VSS.n540 VSS.n195 17.0005
R212 VSS.n540 VSS.n529 17.0005
R213 VSS.n540 VSS.n196 17.0005
R214 VSS.n540 VSS.n198 17.0005
R215 VSS.n540 VSS.n197 17.0005
R216 VSS.n559 VSS.n558 17.0005
R217 VSS.n559 VSS.n121 17.0005
R218 VSS.n559 VSS.n156 17.0005
R219 VSS.n559 VSS.n122 17.0005
R220 VSS.n559 VSS.n155 17.0005
R221 VSS.n559 VSS.n123 17.0005
R222 VSS.n559 VSS.n152 17.0005
R223 VSS.n559 VSS.n124 17.0005
R224 VSS.n559 VSS.n151 17.0005
R225 VSS.n559 VSS.n125 17.0005
R226 VSS.n559 VSS.n150 17.0005
R227 VSS.n559 VSS.n126 17.0005
R228 VSS.n559 VSS.n149 17.0005
R229 VSS.n559 VSS.n127 17.0005
R230 VSS.n559 VSS.n148 17.0005
R231 VSS.n559 VSS.n128 17.0005
R232 VSS.n559 VSS.n147 17.0005
R233 VSS.n559 VSS.n129 17.0005
R234 VSS.n559 VSS.n146 17.0005
R235 VSS.n559 VSS.n130 17.0005
R236 VSS.n559 VSS.n145 17.0005
R237 VSS.n559 VSS.n131 17.0005
R238 VSS.n559 VSS.n144 17.0005
R239 VSS.n559 VSS.n132 17.0005
R240 VSS.n559 VSS.n143 17.0005
R241 VSS.n559 VSS.n133 17.0005
R242 VSS.n559 VSS.n142 17.0005
R243 VSS.n559 VSS.n134 17.0005
R244 VSS.n559 VSS.n141 17.0005
R245 VSS.n559 VSS.n135 17.0005
R246 VSS.n559 VSS.n140 17.0005
R247 VSS.n560 VSS.n559 17.0005
R248 VSS.n559 VSS.n139 17.0005
R249 VSS.n559 VSS.n136 17.0005
R250 VSS.n559 VSS.n138 17.0005
R251 VSS.n45 VSS.n44 0.799564
R252 VSS.n562 VSS.n561 17.0005
R253 VSS.n562 VSS.n47 17.0005
R254 VSS.n562 VSS.n68 17.0005
R255 VSS.n562 VSS.n48 17.0005
R256 VSS.n562 VSS.n67 17.0005
R257 VSS.n562 VSS.n49 17.0005
R258 VSS.n562 VSS.n66 17.0005
R259 VSS.n562 VSS.n50 17.0005
R260 VSS.n562 VSS.n65 17.0005
R261 VSS.n562 VSS.n51 17.0005
R262 VSS.n562 VSS.n64 17.0005
R263 VSS.n562 VSS.n52 17.0005
R264 VSS.n562 VSS.n63 17.0005
R265 VSS.n562 VSS.n53 17.0005
R266 VSS.n562 VSS.n62 17.0005
R267 VSS.n562 VSS.n54 17.0005
R268 VSS.n562 VSS.n61 17.0005
R269 VSS.n562 VSS.n58 17.0005
R270 VSS.n562 VSS.n69 17.0005
R271 VSS.n562 VSS.n93 17.0005
R272 VSS.n562 VSS.n94 17.0005
R273 VSS.n562 VSS.n95 17.0005
R274 VSS.n562 VSS.n96 17.0005
R275 VSS.n562 VSS.n97 17.0005
R276 VSS.n562 VSS.n98 17.0005
R277 VSS.n562 VSS.n99 17.0005
R278 VSS.n562 VSS.n100 17.0005
R279 VSS.n562 VSS.n101 17.0005
R280 VSS.n562 VSS.n102 17.0005
R281 VSS.n562 VSS.n103 17.0005
R282 VSS.n562 VSS.n104 17.0005
R283 VSS.n562 VSS.n107 17.0005
R284 VSS.n562 VSS.n108 17.0005
R285 VSS.n562 VSS.n109 17.0005
R286 VSS.n562 VSS.n110 17.0005
R287 VSS.n562 VSS.n111 17.0005
R288 VSS.n562 VSS.n112 17.0005
R289 VSS.n562 VSS.n113 17.0005
R290 VSS.n562 VSS.n114 17.0005
R291 VSS.n562 VSS.n115 17.0005
R292 VSS.n25 VSS.n5 0.0445345
R293 VSS.n562 VSS.n116 17.0005
R294 VSS.n562 VSS.n117 17.0005
R295 VSS.n562 VSS.n118 17.0005
R296 VSS.n562 VSS.n119 17.0005
R297 VSS.n562 VSS.n92 17.0005
R298 VSS.n562 VSS.n86 17.0005
R299 VSS.n562 VSS.n85 17.0005
R300 VSS.n562 VSS.n84 17.0005
R301 VSS.n562 VSS.n83 17.0005
R302 VSS.n562 VSS.n82 17.0005
R303 VSS.n562 VSS.n81 17.0005
R304 VSS.n562 VSS.n80 17.0005
R305 VSS.n562 VSS.n79 17.0005
R306 VSS.n562 VSS.n78 17.0005
R307 VSS.n562 VSS.n77 17.0005
R308 VSS.n562 VSS.n76 17.0005
R309 VSS.n562 VSS.n75 17.0005
R310 VSS.n562 VSS.n74 17.0005
R311 VSS.n562 VSS.n73 17.0005
R312 VSS.n562 VSS.n72 17.0005
R313 VSS.n562 VSS.n71 17.0005
R314 VSS.n562 VSS.n70 17.0005
R315 VSS.n38 VSS.n34 4.23471
R316 VSS.n23 VSS.n26 0.0988086
R317 VSS.n470 VSS.n38 17.0005
R318 VSS.n469 VSS.n320 16.9166
R319 VSS.n516 VSS.n208 16.9166
R320 VSS.n517 VSS.n209 16.9166
R321 VSS.n447 VSS.n199 16.9166
R322 VSS.n232 VSS.n207 16.9166
R323 VSS.n448 VSS.n200 16.9166
R324 VSS.n231 VSS.n206 16.9166
R325 VSS.n449 VSS.n201 16.9166
R326 VSS.n450 VSS.n202 16.9166
R327 VSS.n229 VSS.n204 16.9166
R328 VSS.n452 VSS.n203 16.9166
R329 VSS.n26 VSS.t155 16.4809
R330 VSS.n27 VSS.t159 16.4809
R331 VSS.t40 VSS.n471 16.1318
R332 VSS.n60 VSS.t48 15.6019
R333 VSS.t83 VSS.n87 15.6019
R334 VSS.n91 VSS.t85 14.4834
R335 VSS.n59 VSS.t46 14.4827
R336 VSS.t6 VSS.n39 11.1952
R337 VSS.t46 VSS.n55 12.9739
R338 VSS.t85 VSS.n88 12.9739
R339 VSS.n484 VSS.n483 12.8307
R340 VSS.n223 VSS.n222 12.8307
R341 VSS.n218 VSS.n217 12.8307
R342 VSS.n213 VSS.n212 12.8307
R343 VSS.t44 VSS.n58 12.4533
R344 VSS.n92 VSS.t86 12.4533
R345 VSS.n135 VSS.n119 12.3761
R346 VSS.n141 VSS.n118 12.3761
R347 VSS.n141 VSS.n117 12.3761
R348 VSS.n134 VSS.n116 12.3761
R349 VSS.n133 VSS.n115 12.3761
R350 VSS.n133 VSS.n114 12.3761
R351 VSS.n143 VSS.n113 12.3761
R352 VSS.n144 VSS.n112 12.3761
R353 VSS.n144 VSS.n111 12.3761
R354 VSS.n131 VSS.n111 12.3761
R355 VSS.n145 VSS.n110 12.3761
R356 VSS.n145 VSS.n109 12.3761
R357 VSS.n130 VSS.n109 12.3761
R358 VSS.n130 VSS.n108 12.3761
R359 VSS.n146 VSS.n107 12.3761
R360 VSS.n129 VSS.n107 12.3761
R361 VSS.n129 VSS.n104 12.3761
R362 VSS.n147 VSS.n104 12.3761
R363 VSS.n128 VSS.n103 12.3761
R364 VSS.n128 VSS.n102 12.3761
R365 VSS.n148 VSS.n102 12.3761
R366 VSS.n148 VSS.n101 12.3761
R367 VSS.n127 VSS.n100 12.3761
R368 VSS.n149 VSS.n100 12.3761
R369 VSS.n149 VSS.n99 12.3761
R370 VSS.n150 VSS.n98 12.3761
R371 VSS.n125 VSS.n97 12.3761
R372 VSS.n125 VSS.n96 12.3761
R373 VSS.n124 VSS.n95 12.3761
R374 VSS.n152 VSS.n94 12.3761
R375 VSS.n152 VSS.n93 12.3761
R376 VSS.n123 VSS.n69 12.3761
R377 VSS.n501 VSS.t97 12.076
R378 VSS.n476 VSS.t160 11.8925
R379 VSS.n366 VSS.t91 11.7116
R380 VSS.n132 VSS.t65 11.6482
R381 VSS.n126 VSS.t68 11.6482
R382 VSS.n519 VSS.n30 11.5239
R383 VSS.t163 VSS.n226 11.3213
R384 VSS.n479 VSS.n477 11.061
R385 VSS.t59 VSS.n116 10.9202
R386 VSS.t70 VSS.n95 10.9202
R387 VSS.t91 VSS.n262 10.4104
R388 VSS.n230 VSS.t95 10.4104
R389 VSS.t174 VSS.n117 9.82821
R390 VSS.n142 VSS.t175 9.82821
R391 VSS.t176 VSS.n114 9.82821
R392 VSS.n132 VSS.t177 9.82821
R393 VSS.n126 VSS.t137 9.82821
R394 VSS.t138 VSS.n97 9.82821
R395 VSS.n151 VSS.t139 9.82821
R396 VSS.t140 VSS.n94 9.82821
R397 VSS.n341 VSS.n46 9.76416
R398 VSS.n29 VSS.n46 9.75964
R399 VSS.n457 VSS.t115 9.50586
R400 VSS.t66 VSS.n110 9.46422
R401 VSS.t67 VSS.n101 9.46422
R402 VSS.n88 VSS.t83 9.19965
R403 VSS.t48 VSS.n55 9.19965
R404 VSS.n197 VSS.n60 9.18684
R405 VSS.n554 VSS.n87 9.18684
R406 VSS.n153 VSS.n119 9.10023
R407 VSS.n154 VSS.n69 9.10023
R408 VSS.n135 VSS.t58 8.73624
R409 VSS.n123 VSS.t75 8.73624
R410 VSS.n515 VSS.n511 8.5005
R411 VSS.n515 VSS.n213 8.5005
R412 VSS.n515 VSS.n507 8.5005
R413 VSS.n515 VSS.n218 8.5005
R414 VSS.n515 VSS.n501 8.5005
R415 VSS.n515 VSS.n223 8.5005
R416 VSS.n515 VSS.n489 8.5005
R417 VSS.n515 VSS.n226 8.5005
R418 VSS.n515 VSS.n483 8.5005
R419 VSS.n515 VSS.n227 8.5005
R420 VSS.n212 VSS.n210 8.5005
R421 VSS.n217 VSS.n210 8.5005
R422 VSS.n222 VSS.n210 8.5005
R423 VSS.n506 VSS.n210 8.5005
R424 VSS.n500 VSS.n210 8.5005
R425 VSS.n484 VSS.n210 8.5005
R426 VSS.n515 VSS.t93 8.5005
R427 VSS.n515 VSS.n479 8.5005
R428 VSS.n515 VSS.n228 8.5005
R429 VSS.n515 VSS.n452 8.5005
R430 VSS.n515 VSS.n229 8.5005
R431 VSS.n515 VSS.n450 8.5005
R432 VSS.n515 VSS.n230 8.5005
R433 VSS.n515 VSS.n449 8.5005
R434 VSS.n515 VSS.n231 8.5005
R435 VSS.n515 VSS.n448 8.5005
R436 VSS.n515 VSS.n232 8.5005
R437 VSS.n515 VSS.n447 8.5005
R438 VSS.n515 VSS.n209 8.5005
R439 VSS.n516 VSS.n515 8.5005
R440 VSS.n515 VSS.n233 8.5005
R441 VSS.n515 VSS.n446 8.5005
R442 VSS.n515 VSS.n234 8.5005
R443 VSS.n515 VSS.n443 8.5005
R444 VSS.n515 VSS.n235 8.5005
R445 VSS.n515 VSS.n440 8.5005
R446 VSS.n515 VSS.n236 8.5005
R447 VSS.n515 VSS.n437 8.5005
R448 VSS.n515 VSS.n239 8.5005
R449 VSS.n515 VSS.n434 8.5005
R450 VSS.n515 VSS.n240 8.5005
R451 VSS.n515 VSS.n431 8.5005
R452 VSS.n515 VSS.n241 8.5005
R453 VSS.n515 VSS.n428 8.5005
R454 VSS.n515 VSS.n242 8.5005
R455 VSS.n515 VSS.n425 8.5005
R456 VSS.n515 VSS.n243 8.5005
R457 VSS.n515 VSS.n422 8.5005
R458 VSS.n515 VSS.n244 8.5005
R459 VSS.n515 VSS.n419 8.5005
R460 VSS.n515 VSS.n245 8.5005
R461 VSS.n515 VSS.n416 8.5005
R462 VSS.n515 VSS.n246 8.5005
R463 VSS.n515 VSS.n247 8.5005
R464 VSS.n515 VSS.n411 8.5005
R465 VSS.n515 VSS.n248 8.5005
R466 VSS.n515 VSS.n408 8.5005
R467 VSS.n515 VSS.n249 8.5005
R468 VSS.n515 VSS.n405 8.5005
R469 VSS.n515 VSS.n250 8.5005
R470 VSS.n515 VSS.n402 8.5005
R471 VSS.n515 VSS.n251 8.5005
R472 VSS.n515 VSS.n399 8.5005
R473 VSS.n515 VSS.n252 8.5005
R474 VSS.n515 VSS.n396 8.5005
R475 VSS.n515 VSS.n253 8.5005
R476 VSS.n515 VSS.n393 8.5005
R477 VSS.n515 VSS.n254 8.5005
R478 VSS.n515 VSS.n387 8.5005
R479 VSS.n515 VSS.n255 8.5005
R480 VSS.n515 VSS.n384 8.5005
R481 VSS.n515 VSS.n256 8.5005
R482 VSS.n515 VSS.n381 8.5005
R483 VSS.n515 VSS.n257 8.5005
R484 VSS.n515 VSS.n378 8.5005
R485 VSS.n515 VSS.n258 8.5005
R486 VSS.n515 VSS.n375 8.5005
R487 VSS.n515 VSS.n259 8.5005
R488 VSS.n515 VSS.n372 8.5005
R489 VSS.n515 VSS.n260 8.5005
R490 VSS.n515 VSS.n369 8.5005
R491 VSS.n515 VSS.n261 8.5005
R492 VSS.n515 VSS.n366 8.5005
R493 VSS.n515 VSS.n262 8.5005
R494 VSS.n515 VSS.n364 8.5005
R495 VSS.n515 VSS.n263 8.5005
R496 VSS.n515 VSS.n361 8.5005
R497 VSS.n515 VSS.n264 8.5005
R498 VSS.n515 VSS.n358 8.5005
R499 VSS.n515 VSS.n265 8.5005
R500 VSS.n515 VSS.n355 8.5005
R501 VSS.n515 VSS.n266 8.5005
R502 VSS.n515 VSS.n352 8.5005
R503 VSS.n515 VSS.n267 8.5005
R504 VSS.n515 VSS.n349 8.5005
R505 VSS.n515 VSS.n268 8.5005
R506 VSS.n515 VSS.n346 8.5005
R507 VSS.n515 VSS.n269 8.5005
R508 VSS.n515 VSS.n329 8.5005
R509 VSS.n515 VSS.n270 8.5005
R510 VSS.n515 VSS.n326 8.5005
R511 VSS.n515 VSS.n271 8.5005
R512 VSS.n515 VSS.n323 8.5005
R513 VSS.n515 VSS.n272 8.5005
R514 VSS.n515 VSS.n320 8.5005
R515 VSS.n515 VSS.n273 8.5005
R516 VSS.n515 VSS.n318 8.5005
R517 VSS.n515 VSS.n274 8.5005
R518 VSS.n515 VSS.n315 8.5005
R519 VSS.n515 VSS.n275 8.5005
R520 VSS.n515 VSS.n312 8.5005
R521 VSS.n515 VSS.n276 8.5005
R522 VSS.n515 VSS.n309 8.5005
R523 VSS.n515 VSS.n277 8.5005
R524 VSS.n515 VSS.n306 8.5005
R525 VSS.n515 VSS.n278 8.5005
R526 VSS.n515 VSS.n304 8.5005
R527 VSS.n515 VSS.n279 8.5005
R528 VSS.n515 VSS.n301 8.5005
R529 VSS.n515 VSS.n280 8.5005
R530 VSS.n515 VSS.n298 8.5005
R531 VSS.n515 VSS.n281 8.5005
R532 VSS.n515 VSS.n295 8.5005
R533 VSS.n515 VSS.n282 8.5005
R534 VSS.n515 VSS.n292 8.5005
R535 VSS.n515 VSS.n283 8.5005
R536 VSS.n515 VSS.n289 8.5005
R537 VSS.n515 VSS.n284 8.5005
R538 VSS.n515 VSS.n286 8.5005
R539 VSS.n229 VSS.n210 8.5005
R540 VSS.n450 VSS.n210 8.5005
R541 VSS.n230 VSS.n210 8.5005
R542 VSS.n449 VSS.n210 8.5005
R543 VSS.n231 VSS.n210 8.5005
R544 VSS.n448 VSS.n210 8.5005
R545 VSS.n232 VSS.n210 8.5005
R546 VSS.n447 VSS.n210 8.5005
R547 VSS.n210 VSS.n209 8.5005
R548 VSS.n516 VSS.n210 8.5005
R549 VSS.n562 VSS.n42 2.41243
R550 VSS.n3 VSS.n2 0.0855692
R551 VSS.n23 VSS.n22 0.0305716
R552 VSS.n555 VSS.n9 2.08697
R553 VSS.n555 VSS.n36 4.2321
R554 VSS.n540 VSS.n533 8.49147
R555 VSS.n198 VSS.n54 8.30239
R556 VSS.n529 VSS.n53 8.30239
R557 VSS.n195 VSS.n63 8.30239
R558 VSS.n194 VSS.n64 8.30239
R559 VSS.n531 VSS.n51 8.30239
R560 VSS.n192 VSS.n66 8.30239
R561 VSS.n161 VSS.n76 8.30239
R562 VSS.n164 VSS.n79 8.30239
R563 VSS.n165 VSS.n80 8.30239
R564 VSS.n167 VSS.n82 8.30239
R565 VSS.n168 VSS.n83 8.30239
R566 VSS.n553 VSS.n85 8.30239
R567 VSS.n478 VSS.n228 7.89854
R568 VSS.n446 VSS.n444 7.89854
R569 VSS.n372 VSS.n370 7.89854
R570 VSS.n364 VSS.n362 7.89854
R571 VSS.n319 VSS.n273 7.89854
R572 VSS.n305 VSS.n278 7.89854
R573 VSS.n451 VSS.n228 7.89788
R574 VSS.n373 VSS.n258 7.89788
R575 VSS.n365 VSS.n261 7.89788
R576 VSS.n323 VSS.n322 7.89788
R577 VSS.n309 VSS.n308 7.89788
R578 VSS.n285 VSS.n284 7.89788
R579 VSS.n342 VSS.n341 7.76695
R580 VSS.n59 VSS.t44 7.69091
R581 VSS.t86 VSS.n91 7.69022
R582 VSS.n507 VSS.t151 7.54767
R583 VSS.n215 VSS.n214 7.31333
R584 VSS.n220 VSS.n219 7.31333
R585 VSS.n498 VSS.n224 7.31333
R586 VSS.n510 VSS.n509 7.31333
R587 VSS.n504 VSS.n503 7.31333
R588 VSS.n496 VSS.n495 7.31333
R589 VSS.n493 VSS.n492 7.31333
R590 VSS.n491 VSS.n490 7.31333
R591 VSS.n488 VSS.n487 7.31333
R592 VSS.n481 VSS.n480 7.31333
R593 VSS.n482 VSS.n481 7.31333
R594 VSS.n487 VSS.n485 7.31333
R595 VSS.n488 VSS.n486 7.31333
R596 VSS.n492 VSS.n491 7.31333
R597 VSS.n495 VSS.n493 7.31333
R598 VSS.n496 VSS.n494 7.31333
R599 VSS.n494 VSS.n224 7.31333
R600 VSS.n499 VSS.n498 7.31333
R601 VSS.n499 VSS.n497 7.31333
R602 VSS.n221 VSS.n220 7.31333
R603 VSS.n504 VSS.n502 7.31333
R604 VSS.n216 VSS.n215 7.31333
R605 VSS.n508 VSS.n211 7.31333
R606 VSS.n509 VSS.n508 7.31333
R607 VSS.n146 VSS.t61 7.28029
R608 VSS.n147 VSS.t63 7.28029
R609 VSS.n532 VSS.t167 6.98163
R610 VSS.n191 VSS.t169 6.98163
R611 VSS.n159 VSS.t145 6.98163
R612 VSS.n162 VSS.t147 6.98163
R613 VSS.n446 VSS.n445 6.70183
R614 VSS.n441 VSS.n234 6.70183
R615 VSS.n443 VSS.n442 6.70183
R616 VSS.n438 VSS.n235 6.70183
R617 VSS.n440 VSS.n439 6.70183
R618 VSS.n435 VSS.n236 6.70183
R619 VSS.n437 VSS.n436 6.70183
R620 VSS.n432 VSS.n239 6.70183
R621 VSS.n434 VSS.n433 6.70183
R622 VSS.n429 VSS.n240 6.70183
R623 VSS.n431 VSS.n430 6.70183
R624 VSS.n426 VSS.n241 6.70183
R625 VSS.n428 VSS.n427 6.70183
R626 VSS.n423 VSS.n242 6.70183
R627 VSS.n425 VSS.n424 6.70183
R628 VSS.n420 VSS.n243 6.70183
R629 VSS.n422 VSS.n421 6.70183
R630 VSS.n417 VSS.n244 6.70183
R631 VSS.n419 VSS.n418 6.70183
R632 VSS.n414 VSS.n245 6.70183
R633 VSS.n416 VSS.n415 6.70183
R634 VSS.n412 VSS.n246 6.70183
R635 VSS.n409 VSS.n247 6.70183
R636 VSS.n411 VSS.n410 6.70183
R637 VSS.n406 VSS.n248 6.70183
R638 VSS.n408 VSS.n407 6.70183
R639 VSS.n403 VSS.n249 6.70183
R640 VSS.n405 VSS.n404 6.70183
R641 VSS.n400 VSS.n250 6.70183
R642 VSS.n402 VSS.n401 6.70183
R643 VSS.n397 VSS.n251 6.70183
R644 VSS.n399 VSS.n398 6.70183
R645 VSS.n394 VSS.n252 6.70183
R646 VSS.n396 VSS.n395 6.70183
R647 VSS.n391 VSS.n253 6.70183
R648 VSS.n393 VSS.n392 6.70183
R649 VSS.n385 VSS.n254 6.70183
R650 VSS.n387 VSS.n386 6.70183
R651 VSS.n382 VSS.n255 6.70183
R652 VSS.n384 VSS.n383 6.70183
R653 VSS.n379 VSS.n256 6.70183
R654 VSS.n381 VSS.n380 6.70183
R655 VSS.n376 VSS.n257 6.70183
R656 VSS.n378 VSS.n377 6.70183
R657 VSS.n372 VSS.n371 6.70183
R658 VSS.n367 VSS.n260 6.70183
R659 VSS.n369 VSS.n368 6.70183
R660 VSS.n364 VSS.n363 6.70183
R661 VSS.n359 VSS.n263 6.70183
R662 VSS.n361 VSS.n360 6.70183
R663 VSS.n356 VSS.n264 6.70183
R664 VSS.n358 VSS.n357 6.70183
R665 VSS.n353 VSS.n265 6.70183
R666 VSS.n355 VSS.n354 6.70183
R667 VSS.n350 VSS.n266 6.70183
R668 VSS.n352 VSS.n351 6.70183
R669 VSS.n347 VSS.n267 6.70183
R670 VSS.n349 VSS.n348 6.70183
R671 VSS.n344 VSS.n268 6.70183
R672 VSS.n346 VSS.n345 6.70183
R673 VSS.n327 VSS.n269 6.70183
R674 VSS.n329 VSS.n328 6.70183
R675 VSS.n324 VSS.n270 6.70183
R676 VSS.n326 VSS.n325 6.70183
R677 VSS.n321 VSS.n271 6.70183
R678 VSS.n316 VSS.n273 6.70183
R679 VSS.n318 VSS.n317 6.70183
R680 VSS.n313 VSS.n274 6.70183
R681 VSS.n315 VSS.n314 6.70183
R682 VSS.n310 VSS.n275 6.70183
R683 VSS.n312 VSS.n311 6.70183
R684 VSS.n307 VSS.n276 6.70183
R685 VSS.n302 VSS.n278 6.70183
R686 VSS.n304 VSS.n303 6.70183
R687 VSS.n299 VSS.n279 6.70183
R688 VSS.n301 VSS.n300 6.70183
R689 VSS.n296 VSS.n280 6.70183
R690 VSS.n298 VSS.n297 6.70183
R691 VSS.n293 VSS.n281 6.70183
R692 VSS.n295 VSS.n294 6.70183
R693 VSS.n290 VSS.n282 6.70183
R694 VSS.n292 VSS.n291 6.70183
R695 VSS.n287 VSS.n283 6.70183
R696 VSS.n289 VSS.n288 6.70183
R697 VSS.t93 VSS.n413 6.70183
R698 VSS.n288 VSS.n284 6.70183
R699 VSS.n289 VSS.n287 6.70183
R700 VSS.n291 VSS.n283 6.70183
R701 VSS.n292 VSS.n290 6.70183
R702 VSS.n294 VSS.n282 6.70183
R703 VSS.n295 VSS.n293 6.70183
R704 VSS.n297 VSS.n281 6.70183
R705 VSS.n298 VSS.n296 6.70183
R706 VSS.n300 VSS.n280 6.70183
R707 VSS.n301 VSS.n299 6.70183
R708 VSS.n303 VSS.n279 6.70183
R709 VSS.n304 VSS.n302 6.70183
R710 VSS.n309 VSS.n307 6.70183
R711 VSS.n311 VSS.n276 6.70183
R712 VSS.n312 VSS.n310 6.70183
R713 VSS.n314 VSS.n275 6.70183
R714 VSS.n315 VSS.n313 6.70183
R715 VSS.n317 VSS.n274 6.70183
R716 VSS.n318 VSS.n316 6.70183
R717 VSS.n323 VSS.n321 6.70183
R718 VSS.n325 VSS.n271 6.70183
R719 VSS.n326 VSS.n324 6.70183
R720 VSS.n328 VSS.n270 6.70183
R721 VSS.n329 VSS.n327 6.70183
R722 VSS.n345 VSS.n269 6.70183
R723 VSS.n346 VSS.n344 6.70183
R724 VSS.n348 VSS.n268 6.70183
R725 VSS.n349 VSS.n347 6.70183
R726 VSS.n351 VSS.n267 6.70183
R727 VSS.n352 VSS.n350 6.70183
R728 VSS.n354 VSS.n266 6.70183
R729 VSS.n355 VSS.n353 6.70183
R730 VSS.n357 VSS.n265 6.70183
R731 VSS.n358 VSS.n356 6.70183
R732 VSS.n360 VSS.n264 6.70183
R733 VSS.n361 VSS.n359 6.70183
R734 VSS.n363 VSS.n263 6.70183
R735 VSS.n368 VSS.n261 6.70183
R736 VSS.n369 VSS.n367 6.70183
R737 VSS.n371 VSS.n260 6.70183
R738 VSS.n377 VSS.n258 6.70183
R739 VSS.n378 VSS.n376 6.70183
R740 VSS.n380 VSS.n257 6.70183
R741 VSS.n381 VSS.n379 6.70183
R742 VSS.n383 VSS.n256 6.70183
R743 VSS.n384 VSS.n382 6.70183
R744 VSS.n386 VSS.n255 6.70183
R745 VSS.n387 VSS.n385 6.70183
R746 VSS.n392 VSS.n254 6.70183
R747 VSS.n393 VSS.n391 6.70183
R748 VSS.n395 VSS.n253 6.70183
R749 VSS.n396 VSS.n394 6.70183
R750 VSS.n398 VSS.n252 6.70183
R751 VSS.n399 VSS.n397 6.70183
R752 VSS.n401 VSS.n251 6.70183
R753 VSS.n402 VSS.n400 6.70183
R754 VSS.n404 VSS.n250 6.70183
R755 VSS.n405 VSS.n403 6.70183
R756 VSS.n407 VSS.n249 6.70183
R757 VSS.n408 VSS.n406 6.70183
R758 VSS.n410 VSS.n248 6.70183
R759 VSS.n411 VSS.n409 6.70183
R760 VSS.n413 VSS.n247 6.70183
R761 VSS.t93 VSS.n412 6.70183
R762 VSS.n415 VSS.n246 6.70183
R763 VSS.n416 VSS.n414 6.70183
R764 VSS.n418 VSS.n245 6.70183
R765 VSS.n419 VSS.n417 6.70183
R766 VSS.n421 VSS.n244 6.70183
R767 VSS.n422 VSS.n420 6.70183
R768 VSS.n424 VSS.n243 6.70183
R769 VSS.n425 VSS.n423 6.70183
R770 VSS.n427 VSS.n242 6.70183
R771 VSS.n428 VSS.n426 6.70183
R772 VSS.n430 VSS.n241 6.70183
R773 VSS.n431 VSS.n429 6.70183
R774 VSS.n433 VSS.n240 6.70183
R775 VSS.n434 VSS.n432 6.70183
R776 VSS.n436 VSS.n239 6.70183
R777 VSS.n437 VSS.n435 6.70183
R778 VSS.n439 VSS.n236 6.70183
R779 VSS.n440 VSS.n438 6.70183
R780 VSS.n442 VSS.n235 6.70183
R781 VSS.n443 VSS.n441 6.70183
R782 VSS.n445 VSS.n234 6.70183
R783 VSS.t95 VSS.n205 6.50668
R784 VSS.n477 VSS.n227 6.41559
R785 VSS.n561 VSS.n560 6.41559
R786 VSS.n122 VSS.n70 6.41559
R787 VSS.n562 VSS.n60 6.17223
R788 VSS.n562 VSS.n87 6.17223
R789 VSS.n461 VSS.t3 6.07511
R790 VSS.n454 VSS.t1 6.07511
R791 VSS.n456 VSS.t113 5.93097
R792 VSS.n518 VSS.n208 5.66717
R793 VSS.n518 VSS.n517 5.66717
R794 VSS.n518 VSS.n199 5.66717
R795 VSS.n518 VSS.n207 5.66717
R796 VSS.n518 VSS.n200 5.66717
R797 VSS.n518 VSS.n206 5.66717
R798 VSS.n518 VSS.n201 5.66717
R799 VSS.n518 VSS.n205 5.66717
R800 VSS.n518 VSS.n202 5.66717
R801 VSS.n518 VSS.n204 5.66717
R802 VSS.n518 VSS.n203 5.66717
R803 VSS.n19 VSS.n24 0.0538158
R804 VSS.n28 VSS.n18 0.054147
R805 VSS.n34 VSS.t162 3.20134
R806 VSS.n38 VSS.n23 2.81319
R807 VSS.n9 VSS.n21 0.0728955
R808 VSS.n12 VSS.n20 0.0486537
R809 VSS.t151 VSS.n506 5.28352
R810 VSS.n469 VSS.n272 5.20544
R811 VSS.n233 VSS.n208 5.20544
R812 VSS.n517 VSS.n516 5.20544
R813 VSS.n209 VSS.n199 5.20544
R814 VSS.n447 VSS.n207 5.20544
R815 VSS.n232 VSS.n200 5.20544
R816 VSS.n448 VSS.n206 5.20544
R817 VSS.n231 VSS.n201 5.20544
R818 VSS.n449 VSS.n205 5.20544
R819 VSS.n230 VSS.n202 5.20544
R820 VSS.n450 VSS.n204 5.20544
R821 VSS.n229 VSS.n203 5.20544
R822 VSS.n412 VSS.n210 5.15059
R823 VSS.n445 VSS.n210 5.15059
R824 VSS.n441 VSS.n210 5.15059
R825 VSS.n442 VSS.n210 5.15059
R826 VSS.n438 VSS.n210 5.15059
R827 VSS.n439 VSS.n210 5.15059
R828 VSS.n435 VSS.n210 5.15059
R829 VSS.n436 VSS.n210 5.15059
R830 VSS.n432 VSS.n210 5.15059
R831 VSS.n433 VSS.n210 5.15059
R832 VSS.n429 VSS.n210 5.15059
R833 VSS.n430 VSS.n210 5.15059
R834 VSS.n426 VSS.n210 5.15059
R835 VSS.n427 VSS.n210 5.15059
R836 VSS.n423 VSS.n210 5.15059
R837 VSS.n424 VSS.n210 5.15059
R838 VSS.n420 VSS.n210 5.15059
R839 VSS.n421 VSS.n210 5.15059
R840 VSS.n417 VSS.n210 5.15059
R841 VSS.n418 VSS.n210 5.15059
R842 VSS.n414 VSS.n210 5.15059
R843 VSS.n415 VSS.n210 5.15059
R844 VSS.n413 VSS.n210 5.15059
R845 VSS.n409 VSS.n210 5.15059
R846 VSS.n410 VSS.n210 5.15059
R847 VSS.n406 VSS.n210 5.15059
R848 VSS.n407 VSS.n210 5.15059
R849 VSS.n403 VSS.n210 5.15059
R850 VSS.n404 VSS.n210 5.15059
R851 VSS.n400 VSS.n210 5.15059
R852 VSS.n401 VSS.n210 5.15059
R853 VSS.n397 VSS.n210 5.15059
R854 VSS.n398 VSS.n210 5.15059
R855 VSS.n394 VSS.n210 5.15059
R856 VSS.n395 VSS.n210 5.15059
R857 VSS.n391 VSS.n210 5.15059
R858 VSS.n392 VSS.n210 5.15059
R859 VSS.n385 VSS.n210 5.15059
R860 VSS.n386 VSS.n210 5.15059
R861 VSS.n382 VSS.n210 5.15059
R862 VSS.n383 VSS.n210 5.15059
R863 VSS.n379 VSS.n210 5.15059
R864 VSS.n380 VSS.n210 5.15059
R865 VSS.n376 VSS.n210 5.15059
R866 VSS.n377 VSS.n210 5.15059
R867 VSS.n371 VSS.n210 5.15059
R868 VSS.n367 VSS.n210 5.15059
R869 VSS.n368 VSS.n210 5.15059
R870 VSS.n363 VSS.n210 5.15059
R871 VSS.n359 VSS.n210 5.15059
R872 VSS.n360 VSS.n210 5.15059
R873 VSS.n356 VSS.n210 5.15059
R874 VSS.n357 VSS.n210 5.15059
R875 VSS.n353 VSS.n210 5.15059
R876 VSS.n354 VSS.n210 5.15059
R877 VSS.n350 VSS.n210 5.15059
R878 VSS.n351 VSS.n210 5.15059
R879 VSS.n347 VSS.n210 5.15059
R880 VSS.n348 VSS.n210 5.15059
R881 VSS.n344 VSS.n210 5.15059
R882 VSS.n345 VSS.n210 5.15059
R883 VSS.n327 VSS.n210 5.15059
R884 VSS.n328 VSS.n210 5.15059
R885 VSS.n324 VSS.n210 5.15059
R886 VSS.n325 VSS.n210 5.15059
R887 VSS.n321 VSS.n210 5.15059
R888 VSS.n316 VSS.n210 5.15059
R889 VSS.n317 VSS.n210 5.15059
R890 VSS.n313 VSS.n210 5.15059
R891 VSS.n314 VSS.n210 5.15059
R892 VSS.n310 VSS.n210 5.15059
R893 VSS.n311 VSS.n210 5.15059
R894 VSS.n307 VSS.n210 5.15059
R895 VSS.n302 VSS.n210 5.15059
R896 VSS.n303 VSS.n210 5.15059
R897 VSS.n299 VSS.n210 5.15059
R898 VSS.n300 VSS.n210 5.15059
R899 VSS.n296 VSS.n210 5.15059
R900 VSS.n297 VSS.n210 5.15059
R901 VSS.n293 VSS.n210 5.15059
R902 VSS.n294 VSS.n210 5.15059
R903 VSS.n290 VSS.n210 5.15059
R904 VSS.n291 VSS.n210 5.15059
R905 VSS.n287 VSS.n210 5.15059
R906 VSS.n288 VSS.n210 5.15059
R907 VSS.t61 VSS.n108 5.09635
R908 VSS.t63 VSS.n103 5.09635
R909 VSS.t14 VSS.n62 5.09484
R910 VSS.t20 VSS.n65 5.09484
R911 VSS.t21 VSS.n49 5.09484
R912 VSS.t8 VSS.n68 5.09484
R913 VSS.n139 VSS.t171 5.09484
R914 VSS.n561 VSS.t172 5.09484
R915 VSS.t142 VSS.n70 5.09484
R916 VSS.n156 VSS.t143 5.09484
R917 VSS.t24 VSS.n72 5.09484
R918 VSS.t28 VSS.n75 5.09484
R919 VSS.t31 VSS.n78 5.09484
R920 VSS.t37 VSS.n84 5.09484
R921 VSS.n197 VSS.t49 4.90616
R922 VSS.n554 VSS.t82 4.90616
R923 VSS.n550 VSS.n30 4.69693
R924 VSS.n341 VSS.n340 4.67815
R925 VSS.n196 VSS.n54 4.5288
R926 VSS.n530 VSS.n63 4.5288
R927 VSS.n194 VSS.n52 4.5288
R928 VSS.n193 VSS.n51 4.5288
R929 VSS.n532 VSS.n65 4.5288
R930 VSS.n191 VSS.n49 4.5288
R931 VSS.n190 VSS.n48 4.5288
R932 VSS.n539 VSS.n68 4.5288
R933 VSS.n157 VSS.n72 4.5288
R934 VSS.n158 VSS.n73 4.5288
R935 VSS.n159 VSS.n75 4.5288
R936 VSS.n162 VSS.n78 4.5288
R937 VSS.n163 VSS.n79 4.5288
R938 VSS.n165 VSS.n81 4.5288
R939 VSS.n166 VSS.n82 4.5288
R940 VSS.n552 VSS.n85 4.5288
R941 VSS.n547 VSS.n174 4.5005
R942 VSS.n546 VSS.n545 4.5005
R943 VSS.n544 VSS.n184 4.5005
R944 VSS.n38 VSS.n468 4.23094
R945 VSS.n38 VSS.n453 4.23094
R946 VSS.n38 VSS.n462 4.23094
R947 VSS.n555 VSS.n551 4.22744
R948 VSS.n540 VSS.n538 4.22744
R949 VSS.n540 VSS.n528 4.22744
R950 VSS.t51 VSS.n62 4.15144
R951 VSS.t55 VSS.n48 4.15144
R952 VSS.t76 VSS.n73 4.15144
R953 VSS.t80 VSS.n84 4.15144
R954 VSS.n476 VSS.n38 3.97732
R955 VSS.t17 VSS.t42 3.96276
R956 VSS.t29 VSS.t79 3.96276
R957 VSS.n479 VSS.n478 3.9496
R958 VSS.n444 VSS.n233 3.9496
R959 VSS.n370 VSS.n259 3.9496
R960 VSS.n362 VSS.n262 3.9496
R961 VSS.n320 VSS.n319 3.9496
R962 VSS.n306 VSS.n305 3.9496
R963 VSS.n286 VSS.n285 3.94944
R964 VSS.n308 VSS.n277 3.94944
R965 VSS.n322 VSS.n272 3.94944
R966 VSS.n366 VSS.n365 3.94944
R967 VSS.n375 VSS.n373 3.94944
R968 VSS.n452 VSS.n451 3.94944
R969 VSS.n520 VSS.n518 3.89224
R970 VSS.n212 VSS.n211 3.65691
R971 VSS.n217 VSS.n216 3.65691
R972 VSS.n222 VSS.n221 3.65691
R973 VSS.n485 VSS.n484 3.65691
R974 VSS.n483 VSS.n482 3.65691
R975 VSS.n505 VSS.n213 3.65691
R976 VSS.n502 VSS.n218 3.65691
R977 VSS.n497 VSS.n223 3.65691
R978 VSS.n486 VSS.n226 3.65691
R979 VSS.n480 VSS.n227 3.65691
R980 VSS.n490 VSS.n489 3.65691
R981 VSS.n500 VSS.n219 3.65691
R982 VSS.n503 VSS.n501 3.65691
R983 VSS.n506 VSS.n214 3.65691
R984 VSS.n507 VSS.n505 3.65691
R985 VSS.n511 VSS.n510 3.65691
R986 VSS.n543 VSS.n185 3.46952
R987 VSS.t49 VSS.n61 3.39673
R988 VSS.n534 VSS.t53 3.39673
R989 VSS.t56 VSS.n47 3.39673
R990 VSS.t71 VSS.n71 3.39673
R991 VSS.n160 VSS.t73 3.39673
R992 VSS.t82 VSS.n86 3.39673
R993 VSS.n562 VSS.n57 3.38773
R994 VSS.n562 VSS.n25 1.67295
R995 VSS.n42 VSS.n120 0.0574968
R996 VSS.n562 VSS.n8 3.3874
R997 VSS.n562 VSS.n3 0.953895
R998 VSS.n562 VSS.n90 3.38737
R999 VSS.n562 VSS.n6 3.38722
R1000 VSS.n549 VSS.n32 3.3755
R1001 VSS.n543 VSS.n31 3.3755
R1002 VSS.n38 VSS.n464 3.37539
R1003 VSS.n38 VSS.n455 3.37539
R1004 VSS.n38 VSS.n459 3.37539
R1005 VSS.n198 VSS.t12 3.20805
R1006 VSS.n196 VSS.t14 3.20805
R1007 VSS.n195 VSS.t16 3.20805
R1008 VSS.n530 VSS.t17 3.20805
R1009 VSS.n531 VSS.t19 3.20805
R1010 VSS.n192 VSS.t10 3.20805
R1011 VSS.n535 VSS.t23 3.20805
R1012 VSS.n556 VSS.t26 3.20805
R1013 VSS.n161 VSS.t33 3.20805
R1014 VSS.n164 VSS.t34 3.20805
R1015 VSS.n166 VSS.t29 3.20805
R1016 VSS.n167 VSS.t35 3.20805
R1017 VSS.n552 VSS.t37 3.20805
R1018 VSS.n553 VSS.t38 3.20805
R1019 VSS.n463 VSS.t181 3.14902
R1020 VSS.n26 VSS.t157 3.14902
R1021 VSS.n22 VSS.t158 3.14902
R1022 VSS.n465 VSS.t7 3.14902
R1023 VSS.n467 VSS.t5 3.14902
R1024 VSS.n27 VSS.t161 3.14902
R1025 VSS.n478 VSS.n210 3.03556
R1026 VSS.n444 VSS.n210 3.03556
R1027 VSS.n370 VSS.n210 3.03556
R1028 VSS.n362 VSS.n210 3.03556
R1029 VSS.n319 VSS.n210 3.03556
R1030 VSS.n305 VSS.n210 3.03556
R1031 VSS.n451 VSS.n210 3.03537
R1032 VSS.n373 VSS.n210 3.03537
R1033 VSS.n365 VSS.n210 3.03537
R1034 VSS.n322 VSS.n210 3.03537
R1035 VSS.n308 VSS.n210 3.03537
R1036 VSS.n285 VSS.n210 3.03537
R1037 VSS.n560 VSS.t56 3.01937
R1038 VSS.n122 VSS.t71 3.01937
R1039 VSS.n172 VSS.n18 3.0005
R1040 VSS.n0 VSS.n8 3.0005
R1041 VSS.n171 VSS.n6 3.0005
R1042 VSS.n33 VSS.n19 3.0005
R1043 VSS.n520 VSS.n519 2.9309
R1044 VSS.n131 VSS.t66 2.91241
R1045 VSS.n127 VSS.t67 2.91241
R1046 VSS.n562 VSS.n24 1.86454
R1047 VSS.n562 VSS.n106 2.81756
R1048 VSS.n562 VSS.n28 1.86416
R1049 VSS.n38 VSS.n466 2.80331
R1050 VSS.n523 VSS.t13 2.79558
R1051 VSS.n187 VSS.t22 2.79551
R1052 VSS.n526 VSS.t15 2.79551
R1053 VSS.n189 VSS.t18 2.79551
R1054 VSS.n11 VSS.t11 2.79551
R1055 VSS.n176 VSS.t32 2.79551
R1056 VSS.n177 VSS.t30 2.79551
R1057 VSS.n178 VSS.t36 2.79551
R1058 VSS.n175 VSS.t27 2.79551
R1059 VSS.n170 VSS.t39 2.79543
R1060 VSS.n548 VSS.t25 2.79543
R1061 VSS.n186 VSS.t9 2.79543
R1062 VSS.n458 VSS.n457 2.69572
R1063 VSS.t168 VSS.t21 2.64201
R1064 VSS.t146 VSS.t28 2.64201
R1065 VSS.n562 VSS.n91 2.58141
R1066 VSS.n562 VSS.n88 2.58141
R1067 VSS.n562 VSS.n55 2.58141
R1068 VSS.n562 VSS.n59 2.58141
R1069 VSS.t173 VSS.n118 2.54843
R1070 VSS.n134 VSS.t174 2.54843
R1071 VSS.t175 VSS.n115 2.54843
R1072 VSS.n143 VSS.t176 2.54843
R1073 VSS.t177 VSS.n112 2.54843
R1074 VSS.t137 VSS.n99 2.54843
R1075 VSS.n150 VSS.t138 2.54843
R1076 VSS.t139 VSS.n96 2.54843
R1077 VSS.n124 VSS.t140 2.54843
R1078 VSS.t141 VSS.n93 2.54843
R1079 VSS.n179 VSS.n170 2.46314
R1080 VSS.n32 VSS.n548 2.4382
R1081 VSS.n31 VSS.n186 2.4382
R1082 VSS.n515 VSS.n509 2.42304
R1083 VSS.n515 VSS.n211 2.42304
R1084 VSS.n515 VSS.n214 2.42304
R1085 VSS.n515 VSS.n216 2.42304
R1086 VSS.n515 VSS.n504 2.42304
R1087 VSS.n515 VSS.n219 2.42304
R1088 VSS.n515 VSS.n221 2.42304
R1089 VSS.n515 VSS.n499 2.42304
R1090 VSS.n515 VSS.n224 2.42304
R1091 VSS.n515 VSS.n496 2.42304
R1092 VSS.n515 VSS.n493 2.42304
R1093 VSS.n515 VSS.n491 2.42304
R1094 VSS.n515 VSS.n488 2.42304
R1095 VSS.n515 VSS.n485 2.42304
R1096 VSS.n515 VSS.n481 2.42304
R1097 VSS.n510 VSS.n210 2.42304
R1098 VSS.n505 VSS.n210 2.42304
R1099 VSS.n502 VSS.n210 2.42304
R1100 VSS.n503 VSS.n210 2.42304
R1101 VSS.n497 VSS.n210 2.42304
R1102 VSS.n494 VSS.n210 2.42304
R1103 VSS.n495 VSS.n210 2.42304
R1104 VSS.n492 VSS.n210 2.42304
R1105 VSS.n490 VSS.n210 2.42304
R1106 VSS.n486 VSS.n210 2.42304
R1107 VSS.n487 VSS.n210 2.42304
R1108 VSS.n508 VSS.n210 2.42304
R1109 VSS.n215 VSS.n210 2.42304
R1110 VSS.n220 VSS.n210 2.42304
R1111 VSS.n498 VSS.n210 2.42304
R1112 VSS.n482 VSS.n210 2.42304
R1113 VSS.n480 VSS.n210 2.42304
R1114 VSS.n524 VSS.n523 2.31388
R1115 VSS.n31 VSS.n187 2.31337
R1116 VSS.n526 VSS.n525 2.31337
R1117 VSS.n189 VSS.n188 2.31337
R1118 VSS.n542 VSS.n11 2.31337
R1119 VSS.n183 VSS.n176 2.31337
R1120 VSS.n180 VSS.n177 2.31337
R1121 VSS.n179 VSS.n178 2.31337
R1122 VSS.n32 VSS.n175 2.31337
R1123 VSS.n43 VSS.n41 20.3969
R1124 VSS.n334 VSS.t132 2.21127
R1125 VSS.n340 VSS.t127 2.21116
R1126 VSS.n389 VSS.t92 2.21097
R1127 VSS.n512 VSS.t96 2.21097
R1128 VSS.n330 VSS.t136 2.21085
R1129 VSS.n388 VSS.t90 2.21085
R1130 VSS.n338 VSS.t128 2.21049
R1131 VSS.n513 VSS.t98 2.21049
R1132 VSS.n237 VSS.t94 2.21046
R1133 VSS.n342 VSS.t89 2.21039
R1134 VSS.n332 VSS.t134 2.21033
R1135 VSS.n336 VSS.t130 2.21016
R1136 VSS.n512 VSS.t110 2.20295
R1137 VSS.n237 VSS.t108 2.20263
R1138 VSS.n332 VSS.t124 2.20263
R1139 VSS.n389 VSS.t106 2.20245
R1140 VSS.n336 VSS.t120 2.20187
R1141 VSS.n388 VSS.t104 2.20171
R1142 VSS.n513 VSS.t112 2.20167
R1143 VSS.n330 VSS.t126 2.2016
R1144 VSS.n342 VSS.t103 2.20157
R1145 VSS.n338 VSS.t118 2.20156
R1146 VSS.n334 VSS.t122 2.20127
R1147 VSS.n340 VSS.t117 2.20108
R1148 VSS.n137 VSS.t55 2.07597
R1149 VSS.n557 VSS.t76 2.07597
R1150 VSS.n535 VSS.n138 1.88729
R1151 VSS.n539 VSS.n139 1.88729
R1152 VSS.n157 VSS.n156 1.88729
R1153 VSS.n558 VSS.n556 1.88729
R1154 VSS.n153 VSS.n140 1.69861
R1155 VSS.n155 VSS.n154 1.69861
R1156 VSS.n17 VSS.n16 0.290062
R1157 VSS.n1 VSS.n16 0.77644
R1158 VSS.n14 VSS.n15 0.0393303
R1159 VSS.n29 VSS 0.769639
R1160 VSS.n57 VSS.t45 1.61937
R1161 VSS.n90 VSS.t87 1.61903
R1162 VSS.n489 VSS.t163 1.50993
R1163 VSS.n89 VSS.t84 1.47409
R1164 VSS.n5 VSS.t57 1.47407
R1165 VSS.n18 VSS.t81 1.47407
R1166 VSS.n56 VSS.t47 1.47396
R1167 VSS.n18 VSS.t78 1.4739
R1168 VSS.n7 VSS.t72 1.47389
R1169 VSS.n120 VSS.t54 1.47382
R1170 VSS.n4 VSS.t62 1.47378
R1171 VSS.n8 VSS.t69 1.47378
R1172 VSS.n19 VSS.t50 1.47378
R1173 VSS.n19 VSS.t43 1.47328
R1174 VSS.n6 VSS.t60 1.47324
R1175 VSS.n105 VSS.t64 1.47324
R1176 VSS.n2 VSS.t74 1.47265
R1177 VSS.n142 VSS.t59 1.45646
R1178 VSS.n151 VSS.t70 1.45646
R1179 VSS.n137 VSS.n44 1.39195
R1180 VSS.t12 VSS.n61 1.32125
R1181 VSS.t16 VSS.n53 1.32125
R1182 VSS.t19 VSS.n64 1.32125
R1183 VSS.t166 VSS.t52 1.32125
R1184 VSS.t52 VSS.t20 1.32125
R1185 VSS.t167 VSS.n50 1.32125
R1186 VSS.t10 VSS.n50 1.32125
R1187 VSS.t169 VSS.n67 1.32125
R1188 VSS.t23 VSS.n67 1.32125
R1189 VSS.t170 VSS.n136 1.32125
R1190 VSS.n136 VSS.t8 1.32125
R1191 VSS.t171 VSS.n47 1.32125
R1192 VSS.n140 VSS.t172 1.32125
R1193 VSS.n155 VSS.t142 1.32125
R1194 VSS.t143 VSS.n71 1.32125
R1195 VSS.n121 VSS.t24 1.32125
R1196 VSS.t144 VSS.n121 1.32125
R1197 VSS.t26 VSS.n74 1.32125
R1198 VSS.t145 VSS.n74 1.32125
R1199 VSS.t33 VSS.n77 1.32125
R1200 VSS.t147 VSS.n77 1.32125
R1201 VSS.t77 VSS.t31 1.32125
R1202 VSS.t148 VSS.t77 1.32125
R1203 VSS.t34 VSS.n80 1.32125
R1204 VSS.t35 VSS.n83 1.32125
R1205 VSS.t38 VSS.n86 1.32125
R1206 VSS.t88 VSS.n277 1.30174
R1207 VSS.t42 VSS.n52 1.13258
R1208 VSS.t53 VSS.n66 1.13258
R1209 VSS.t73 VSS.n76 1.13258
R1210 VSS.t79 VSS.n81 1.13258
R1211 VSS.n521 VSS.n185 1.1255
R1212 VSS.t58 VSS.t173 1.09247
R1213 VSS.t75 VSS.t141 1.09247
R1214 VSS.n519 VSS.n44 1.04917
R1215 VSS.n45 VSS.n557 2.23894
R1216 VSS.n456 VSS.n46 0.762586
R1217 VSS.t97 VSS.n500 0.755217
R1218 VSS.n541 VSS.n13 0.7505
R1219 VSS.n182 VSS.n181 0.7505
R1220 VSS.t65 VSS.n113 0.728479
R1221 VSS.t68 VSS.n98 0.728479
R1222 VSS.n457 VSS.n456 0.674942
R1223 VSS.n193 VSS.t166 0.566538
R1224 VSS.n534 VSS.t168 0.566538
R1225 VSS.n190 VSS.t170 0.566538
R1226 VSS.n158 VSS.t144 0.566538
R1227 VSS.n160 VSS.t146 0.566538
R1228 VSS.n163 VSS.t148 0.566538
R1229 VSS.n536 VSS.n187 0.561603
R1230 VSS.n527 VSS.n526 0.561603
R1231 VSS.n20 VSS.n189 0.561603
R1232 VSS.n13 VSS.n11 0.561603
R1233 VSS.n176 VSS.n35 0.561603
R1234 VSS.n177 VSS.n37 0.561603
R1235 VSS.n178 VSS.n169 0.561603
R1236 VSS.n175 VSS.n10 0.561603
R1237 VSS.n550 VSS.n170 0.56142
R1238 VSS.n548 VSS.n21 0.56142
R1239 VSS.n537 VSS.n186 0.56142
R1240 VSS.n523 VSS.n522 0.56108
R1241 VSS.n529 VSS.t51 0.377858
R1242 VSS.n168 VSS.t80 0.377858
R1243 VSS.n173 VSS.n41 0.353904
R1244 VSS.n546 VSS.n184 0.337235
R1245 VSS.n547 VSS.n546 0.337235
R1246 VSS.n374 VSS.n259 0.325809
R1247 VSS.n16 VSS.n41 0.318978
R1248 VSS.n559 VSS.n45 0.255694
R1249 VSS.n29 VSS.n15 0.891691
R1250 VSS.n15 VSS.n33 0.497407
R1251 VSS.n472 VSS.n38 0.245325
R1252 VSS.n338 VSS.n337 0.243424
R1253 VSS.n390 VSS.n388 0.243424
R1254 VSS.n343 VSS.n342 0.242716
R1255 VSS.n340 VSS.n339 0.242681
R1256 VSS.n171 VSS.n33 0.2425
R1257 VSS.n334 VSS.n333 0.24245
R1258 VSS.n237 VSS.n225 0.24245
R1259 VSS.n537 VSS.n184 0.241827
R1260 VSS.n21 VSS.n547 0.241827
R1261 VSS.n336 VSS.n335 0.240796
R1262 VSS.n389 VSS.n238 0.240796
R1263 VSS.n332 VSS.n331 0.239822
R1264 VSS.n514 VSS.n512 0.239822
R1265 VSS.n333 VSS.n332 0.227974
R1266 VSS.n512 VSS.n225 0.227974
R1267 VSS.n337 VSS.n336 0.227001
R1268 VSS.n390 VSS.n389 0.227001
R1269 VSS.n331 VSS.n330 0.225646
R1270 VSS.n514 VSS.n513 0.225646
R1271 VSS.n335 VSS.n334 0.224672
R1272 VSS.n238 VSS.n237 0.224672
R1273 VSS.n339 VSS.n338 0.223727
R1274 VSS.n388 VSS.n343 0.223715
R1275 VSS.n1 VSS.n0 0.104141
R1276 VSS.n515 VSS.n225 0.218846
R1277 VSS.n333 VSS.n210 0.218846
R1278 VSS.n515 VSS.n390 0.218846
R1279 VSS.n337 VSS.n210 0.218846
R1280 VSS.n515 VSS.n514 0.208386
R1281 VSS.n331 VSS.n210 0.208386
R1282 VSS.n515 VSS.n238 0.208386
R1283 VSS.n335 VSS.n210 0.208386
R1284 VSS.n515 VSS.n343 0.208371
R1285 VSS.n339 VSS.n210 0.20836
R1286 VSS.n138 VSS.n137 0.189179
R1287 VSS.n558 VSS.n557 0.189179
R1288 VSS.n525 VSS.n524 0.1501
R1289 VSS.n525 VSS.n188 0.1501
R1290 VSS.n180 VSS.n179 0.1501
R1291 VSS.t99 VSS.t101 0.143158
R1292 VSS.n30 VSS.n549 0.113321
R1293 VSS.n524 VSS.n185 0.106994
R1294 VSS.n466 VSS.n465 0.0927224
R1295 VSS.n467 VSS.n466 0.0891245
R1296 VSS.n522 VSS.n521 0.0846837
R1297 VSS.n455 VSS.n454 0.0814472
R1298 VSS.n462 VSS.n461 0.0794206
R1299 VSS.n463 VSS.n453 0.0784641
R1300 VSS.n527 VSS.n20 0.0779076
R1301 VSS.n460 VSS.n459 0.0776211
R1302 VSS.n468 VSS.n467 0.0773061
R1303 VSS.n173 VSS.n17 0.384827
R1304 VSS.n541 VSS.n188 0.0753
R1305 VSS.n542 VSS.n541 0.0753
R1306 VSS.n183 VSS.n182 0.0753
R1307 VSS.n182 VSS.n180 0.0753
R1308 VSS.n459 VSS.n458 0.0750054
R1309 VSS.n462 VSS.n460 0.0725235
R1310 VSS.n464 VSS.n463 0.0721359
R1311 VSS.n461 VSS.n455 0.0711793
R1312 VSS.n454 VSS.n453 0.0686974
R1313 VSS.n464 VSS.n26 0.0675776
R1314 VSS.n17 VSS.n172 0.379074
R1315 VSS.n172 VSS.n0 0.2425
R1316 VSS.n32 VSS.n183 0.175033
R1317 VSS.n31 VSS.n542 0.175033
R1318 VSS.n3 VSS.n7 0.104109
R1319 VSS.n16 VSS.n14 0.118427
R1320 VSS.n14 VSS 0.118427
R1321 VSS.n35 VSS.n10 0.117399
R1322 VSS.n10 VSS.n9 0.0439411
R1323 VSS.n13 VSS.n12 0.107833
R1324 VSS.n465 VSS.n22 0.0951565
R1325 VSS.n42 VSS.n19 0.0937229
R1326 VSS.n18 VSS.n2 0.0936293
R1327 VSS.n30 VSS.t99 0.0894317
R1328 VSS.n39 VSS.n38 0.0183207
R1329 VSS.n475 VSS.n38 0.0617935
R1330 VSS.n474 VSS.n38 0.0617935
R1331 VSS.n473 VSS.n38 0.0617935
R1332 VSS.n471 VSS.n38 0.0617935
R1333 VSS.n468 VSS.n27 0.061725
R1334 VSS.n551 VSS.n550 0.0594056
R1335 VSS.n538 VSS.n536 0.0594056
R1336 VSS.n528 VSS.n522 0.0594056
R1337 VSS.n181 VSS.n37 0.0587021
R1338 VSS.n528 VSS.n527 0.0586497
R1339 VSS.n538 VSS.n537 0.0586497
R1340 VSS.n551 VSS.n169 0.0586497
R1341 VSS.t101 VSS.n173 0.0585075
R1342 VSS.n533 VSS.n13 0.0582235
R1343 VSS.n536 VSS.n533 0.0582235
R1344 VSS.n37 VSS.n36 0.029764
R1345 VSS.n169 VSS.n36 0.0874875
R1346 VSS.n34 VSS.n27 0.0767479
R1347 VSS.n181 VSS.n35 0.0587021
R1348 VSS.n544 VSS.n543 0.0569103
R1349 VSS.n545 VSS.n544 0.0569103
R1350 VSS.n545 VSS.n174 0.0569103
R1351 VSS.n549 VSS.n174 0.0569103
R1352 VSS.n521 VSS.n520 0.0566224
R1353 VSS.n105 VSS.n8 0.0526643
R1354 VSS.n6 VSS.n4 0.0523614
R1355 VSS.n90 VSS.n89 0.051203
R1356 VSS.n57 VSS.n56 0.050601
R1357 VSS.n56 VSS.n24 0.0758859
R1358 VSS.n89 VSS.n28 0.0752027
R1359 VSS.n25 VSS.n120 0.091946
R1360 VSS.n4 VSS.n106 0.0474111
R1361 VSS.n106 VSS.n105 0.047074
R1362 VSS.n6 VSS.n5 0.0909208
R1363 VSS.n8 VSS.n7 0.0906189
R1364 VSS.n1 VSS.n171 0.148141
R1365 a_20954_346.n0 a_20954_346.t0 4.85847
R1366 a_20954_346.t15 a_20954_346.n2 4.83761
R1367 a_20954_346.n2 a_20954_346.t14 4.83657
R1368 a_20954_346.n2 a_20954_346.t13 4.83657
R1369 a_20954_346.n2 a_20954_346.t12 4.83657
R1370 a_20954_346.n1 a_20954_346.t11 4.83657
R1371 a_20954_346.n1 a_20954_346.t10 4.83657
R1372 a_20954_346.n1 a_20954_346.t9 4.83657
R1373 a_20954_346.n1 a_20954_346.t8 4.83657
R1374 a_20954_346.n1 a_20954_346.t7 4.83657
R1375 a_20954_346.n1 a_20954_346.t6 4.83657
R1376 a_20954_346.n1 a_20954_346.t5 4.83657
R1377 a_20954_346.n1 a_20954_346.t4 4.83657
R1378 a_20954_346.n0 a_20954_346.t3 4.83657
R1379 a_20954_346.n0 a_20954_346.t2 4.83657
R1380 a_20954_346.n0 a_20954_346.t1 4.83657
R1381 a_20954_346.n2 a_20954_346.t16 0.895788
R1382 a_20954_346.n1 a_20954_346.n0 0.175641
R1383 a_20954_346.n2 a_20954_346.n1 0.131856
R1384 a_11798_1180.n4 a_11798_1180.t25 3.17099
R1385 a_11798_1180.n5 a_11798_1180.t18 3.17099
R1386 a_11798_1180.n10 a_11798_1180.t15 2.79558
R1387 a_11798_1180.n32 a_11798_1180.t23 2.79551
R1388 a_11798_1180.n23 a_11798_1180.t22 2.79551
R1389 a_11798_1180.n24 a_11798_1180.t24 2.79551
R1390 a_11798_1180.n25 a_11798_1180.t26 2.79551
R1391 a_11798_1180.n26 a_11798_1180.t27 2.79551
R1392 a_11798_1180.n19 a_11798_1180.t16 2.79551
R1393 a_11798_1180.n11 a_11798_1180.t17 2.79551
R1394 a_11798_1180.n12 a_11798_1180.t19 2.79551
R1395 a_11798_1180.n13 a_11798_1180.t20 2.79551
R1396 a_11798_1180.n27 a_11798_1180.t28 2.79543
R1397 a_11798_1180.n14 a_11798_1180.t21 2.79543
R1398 a_11798_1180.t14 a_11798_1180.n8 2.61386
R1399 a_11798_1180.n1 a_11798_1180.t0 2.61061
R1400 a_11798_1180.n8 a_11798_1180.t12 2.5622
R1401 a_11798_1180.n2 a_11798_1180.t9 2.56207
R1402 a_11798_1180.n8 a_11798_1180.t13 2.56174
R1403 a_11798_1180.n2 a_11798_1180.t6 2.56174
R1404 a_11798_1180.n2 a_11798_1180.t7 2.56173
R1405 a_11798_1180.n2 a_11798_1180.t5 2.56173
R1406 a_11798_1180.n1 a_11798_1180.t3 2.56173
R1407 a_11798_1180.n7 a_11798_1180.t10 2.56161
R1408 a_11798_1180.n2 a_11798_1180.t8 2.56161
R1409 a_11798_1180.n1 a_11798_1180.t1 2.5616
R1410 a_11798_1180.n7 a_11798_1180.t11 2.56153
R1411 a_11798_1180.n2 a_11798_1180.t4 2.56147
R1412 a_11798_1180.n1 a_11798_1180.t2 2.56147
R1413 a_11798_1180.n20 a_11798_1180.n10 2.36008
R1414 a_11798_1180.n27 a_11798_1180.n21 2.35974
R1415 a_11798_1180.n14 a_11798_1180.n0 2.35974
R1416 a_11798_1180.n33 a_11798_1180.n23 2.35957
R1417 a_11798_1180.n33 a_11798_1180.n32 2.33977
R1418 a_11798_1180.n26 a_11798_1180.n21 2.33977
R1419 a_11798_1180.n20 a_11798_1180.n19 2.33977
R1420 a_11798_1180.n13 a_11798_1180.n0 2.33977
R1421 a_11798_1180.n24 a_11798_1180.n22 2.31337
R1422 a_11798_1180.n25 a_11798_1180.n3 2.31337
R1423 a_11798_1180.n11 a_11798_1180.n9 2.31337
R1424 a_11798_1180.n12 a_11798_1180.n0 2.31337
R1425 a_11798_1180.n31 a_11798_1180.n23 0.748603
R1426 a_11798_1180.n28 a_11798_1180.n27 0.74842
R1427 a_11798_1180.n15 a_11798_1180.n14 0.74842
R1428 a_11798_1180.n18 a_11798_1180.n10 0.74808
R1429 a_11798_1180.n32 a_11798_1180.n31 0.561603
R1430 a_11798_1180.n30 a_11798_1180.n24 0.561603
R1431 a_11798_1180.n29 a_11798_1180.n25 0.561603
R1432 a_11798_1180.n28 a_11798_1180.n26 0.561603
R1433 a_11798_1180.n19 a_11798_1180.n18 0.561603
R1434 a_11798_1180.n17 a_11798_1180.n11 0.561603
R1435 a_11798_1180.n16 a_11798_1180.n12 0.561603
R1436 a_11798_1180.n15 a_11798_1180.n13 0.561603
R1437 a_11798_1180.n4 a_11798_1180.n3 0.401975
R1438 a_11798_1180.n5 a_11798_1180.n0 0.401975
R1439 a_11798_1180.n5 a_11798_1180.n16 0.284179
R1440 a_11798_1180.n4 a_11798_1180.n29 0.284179
R1441 a_11798_1180.n1 a_11798_1180.n33 0.25306
R1442 a_11798_1180.n6 a_11798_1180.n21 0.0449208
R1443 a_11798_1180.n2 a_11798_1180.n20 0.25306
R1444 a_11798_1180.n2 a_11798_1180.n6 0.203345
R1445 a_11798_1180.n2 a_11798_1180.n1 0.196551
R1446 a_11798_1180.n7 a_11798_1180.n0 0.194161
R1447 a_11798_1180.n31 a_11798_1180.n30 0.1875
R1448 a_11798_1180.n30 a_11798_1180.n4 0.1875
R1449 a_11798_1180.n29 a_11798_1180.n28 0.1875
R1450 a_11798_1180.n18 a_11798_1180.n17 0.1875
R1451 a_11798_1180.n17 a_11798_1180.n5 0.1875
R1452 a_11798_1180.n16 a_11798_1180.n15 0.1875
R1453 a_11798_1180.n9 a_11798_1180.n0 0.153033
R1454 a_11798_1180.n22 a_11798_1180.n3 0.153033
R1455 a_11798_1180.n8 a_11798_1180.n7 0.147538
R1456 a_11798_1180.n7 a_11798_1180.n2 0.147538
R1457 a_11798_1180.n33 a_11798_1180.n22 0.106833
R1458 a_11798_1180.n3 a_11798_1180.n6 0.0449208
R1459 a_11798_1180.n20 a_11798_1180.n9 0.106833
R1460 a_5060_3002.n0 a_5060_3002.t4 53.6608
R1461 a_5060_3002.n3 a_5060_3002.t3 29.2688
R1462 a_5060_3002.n2 a_5060_3002.t5 24.2693
R1463 a_5060_3002.n1 a_5060_3002.t1 24.2693
R1464 a_5060_3002.t0 a_5060_3002.n3 15.6064
R1465 a_5060_3002.n0 a_5060_3002.t2 9.21754
R1466 a_5060_3002.n3 a_5060_3002.n2 1.7693
R1467 a_5060_3002.n2 a_5060_3002.n1 0.543167
R1468 a_5060_3002.n1 a_5060_3002.n0 0.320233
R1469 a_5560_3922.n0 a_5560_3922.t0 27.72
R1470 a_5560_3922.n0 a_5560_3922.t1 24.1197
R1471 a_5560_3922.t2 a_5560_3922.n0 9.38813
R1472 a_5560_5708.n0 a_5560_5708.t2 55.2712
R1473 a_5560_5708.n0 a_5560_5708.t1 27.8842
R1474 a_5560_5708.t0 a_5560_5708.n0 7.50485
R1475 a_5060_5708.n0 a_5060_5708.t1 34.3045
R1476 a_5060_5708.t0 a_5060_5708.n0 5.85564
R1477 a_5060_5708.t0 a_5060_5708.n0 5.85498
R1478 a_6568_6136.n2 a_6568_6136.t2 19.9393
R1479 a_6568_6136.n0 a_6568_6136.t4 19.6783
R1480 a_6568_6136.n1 a_6568_6136.t0 17.974
R1481 a_6568_6136.n2 a_6568_6136.n1 5.04317
R1482 a_6568_6136.n0 a_6568_6136.t1 4.81727
R1483 a_6568_6136.n1 a_6568_6136.n0 4.76157
R1484 a_6568_6136.t3 a_6568_6136.n2 3.15445
R1485 a_5948_4416.n0 a_5948_4416.t2 30.2902
R1486 a_5948_4416.n0 a_5948_4416.t1 27.2706
R1487 a_5948_4416.t0 a_5948_4416.n0 11.5346
R1488 vco_feed_0.en_b.n0 vco_feed_0.en_b.t1 27.1774
R1489 vco_feed_0.en_b.n4 vco_feed_0.en_b.t6 24.9608
R1490 vco_feed_0.en_b.n3 vco_feed_0.en_b.t3 24.8442
R1491 vco_feed_0.en_b.n1 vco_feed_0.en_b.t7 20.7725
R1492 vco_feed_0.en_b.n1 vco_feed_0.en_b.t5 20.4909
R1493 vco_feed_0.en_b.n0 vco_feed_0.en_b.t4 20.4287
R1494 vco_feed_0.en_b.n0 vco_feed_0.en_b.t0 12.1418
R1495 vco_feed_0.en_b vco_feed_0.en_b.t2 5.74905
R1496 vco_feed_0.en_b.n2 vco_feed_0.en_b.n1 5.30277
R1497 vco_feed_0.en_b.n2 vco_feed_0.en_b.n0 4.5269
R1498 vco_feed_0.en_b vco_feed_0.en_b.n4 2.33103
R1499 vco_feed_0.en_b.n3 vco_feed_0.en_b.n2 0.562233
R1500 vco_feed_0.en_b.n4 vco_feed_0.en_b.n3 0.469833
R1501 vco_feed_0.vdd_core.n15 vco_feed_0.vdd_core.t11 6.57599
R1502 vco_feed_0.vdd_core.n25 vco_feed_0.vdd_core.t14 6.57599
R1503 vco_feed_0.vdd_core.n27 vco_feed_0.vdd_core.t22 6.5301
R1504 vco_feed_0.vdd_core.n17 vco_feed_0.vdd_core.t7 6.52949
R1505 vco_feed_0.vdd_core.n17 vco_feed_0.vdd_core.t5 6.52949
R1506 vco_feed_0.vdd_core.n15 vco_feed_0.vdd_core.t9 6.52949
R1507 vco_feed_0.vdd_core.n17 vco_feed_0.vdd_core.t3 6.52949
R1508 vco_feed_0.vdd_core.n27 vco_feed_0.vdd_core.t20 6.52949
R1509 vco_feed_0.vdd_core.n27 vco_feed_0.vdd_core.t18 6.52949
R1510 vco_feed_0.vdd_core.n25 vco_feed_0.vdd_core.t16 6.52949
R1511 vco_feed_0.vdd_core.n1 vco_feed_0.vdd_core.t13 4.1356
R1512 vco_feed_0.vdd_core.n0 vco_feed_0.vdd_core.t2 3.9789
R1513 vco_feed_0.vdd_core.n12 vco_feed_0.vdd_core.t27 3.51966
R1514 vco_feed_0.vdd_core.n13 vco_feed_0.vdd_core.t29 3.51966
R1515 vco_feed_0.vdd_core.n16 vco_feed_0.vdd_core.t31 3.51966
R1516 vco_feed_0.vdd_core.n30 vco_feed_0.vdd_core.t28 3.4996
R1517 vco_feed_0.vdd_core.n3 vco_feed_0.vdd_core.t30 3.4996
R1518 vco_feed_0.vdd_core.n26 vco_feed_0.vdd_core.t32 3.4996
R1519 vco_feed_0.vdd_core vco_feed_0.vdd_core.n22 1.55887
R1520 vco_feed_0.vdd_core.n7 vco_feed_0.vdd_core.n23 1.5005
R1521 vco_feed_0.vdd_core.n8 vco_feed_0.vdd_core.n21 1.5005
R1522 vco_feed_0.vdd_core vco_feed_0.vdd_core.n2 0.838
R1523 vco_feed_0.vdd_core.n18 vco_feed_0.vdd_core.n1 0.778589
R1524 vco_feed_0.vdd_core.n28 vco_feed_0.vdd_core.n0 0.778576
R1525 vco_feed_0.vdd_core.n24 vco_feed_0.vdd_core.n7 0.76851
R1526 vco_feed_0.vdd_core.n8 vco_feed_0.vdd_core.n5 0.767758
R1527 vco_feed_0.vdd_core.n1 vco_feed_0.vdd_core.n5 0.751792
R1528 vco_feed_0.vdd_core.n0 vco_feed_0.vdd_core.n24 0.751041
R1529 vco_feed_0.vdd_core.n0 vco_feed_0.vdd_core.n10 0.741729
R1530 vco_feed_0.vdd_core.n1 vco_feed_0.vdd_core.n4 0.741729
R1531 vco_feed_0.vdd_core.n2 vco_feed_0.vdd_core.t26 0.733642
R1532 vco_feed_0.vdd_core.n3 vco_feed_0.vdd_core.n29 0.703434
R1533 vco_feed_0.vdd_core.n19 vco_feed_0.vdd_core.n14 0.703434
R1534 vco_feed_0.vdd_core.n7 vco_feed_0.vdd_core.n6 0.498551
R1535 vco_feed_0.vdd_core.n8 vco_feed_0.vdd_core.n11 0.498121
R1536 vco_feed_0.vdd_core.n2 vco_feed_0.vdd_core 0.461569
R1537 vco_feed_0.vdd_core.n17 vco_feed_0.vdd_core.n16 0.33314
R1538 vco_feed_0.vdd_core.n26 vco_feed_0.vdd_core.n3 0.29442
R1539 vco_feed_0.vdd_core.n13 vco_feed_0.vdd_core.n12 0.29442
R1540 vco_feed_0.vdd_core.n2 vco_feed_0.vdd_core 0.197117
R1541 vco_feed_0.vdd_core.n27 vco_feed_0.vdd_core.n26 0.175092
R1542 vco_feed_0.vdd_core.n14 vco_feed_0.vdd_core.n13 0.14834
R1543 vco_feed_0.vdd_core.n16 vco_feed_0.vdd_core.n14 0.14658
R1544 vco_feed_0.vdd_core.n22 vco_feed_0.vdd_core 0.08575
R1545 vco_feed_0.vdd_core.n4 vco_feed_0.vdd_core.n11 0.0703453
R1546 vco_feed_0.vdd_core.n10 vco_feed_0.vdd_core.n6 0.0703239
R1547 vco_feed_0.vdd_core.n29 vco_feed_0.vdd_core.n28 0.0593402
R1548 vco_feed_0.vdd_core.n19 vco_feed_0.vdd_core.n18 0.0593402
R1549 vco_feed_0.vdd_core vco_feed_0.vdd_core.t0 0.0484286
R1550 vco_feed_0.vdd_core vco_feed_0.vdd_core.t24 0.0484286
R1551 vco_feed_0.vdd_core.n17 vco_feed_0.vdd_core.n15 0.0378886
R1552 vco_feed_0.vdd_core.n27 vco_feed_0.vdd_core.n25 0.0378886
R1553 vco_feed_0.vdd_core.n24 vco_feed_0.vdd_core.n9 0.0338276
R1554 vco_feed_0.vdd_core.n20 vco_feed_0.vdd_core.n5 0.0334354
R1555 vco_feed_0.vdd_core.n28 vco_feed_0.vdd_core.n6 0.026738
R1556 vco_feed_0.vdd_core.n18 vco_feed_0.vdd_core.n11 0.0267154
R1557 vco_feed_0.vdd_core.n29 vco_feed_0.vdd_core.n9 0.020388
R1558 vco_feed_0.vdd_core.n20 vco_feed_0.vdd_core.n19 0.020388
R1559 vco_feed_0.vdd_core.n23 vco_feed_0.vdd_core.n10 0.0195413
R1560 vco_feed_0.vdd_core.n21 vco_feed_0.vdd_core.n4 0.0195413
R1561 vco_feed_0.vdd_core vco_feed_0.vdd_core.n30 0.0181
R1562 vco_feed_0.vdd_core.n12 vco_feed_0.vdd_core 0.0181
R1563 vco_feed_0.vdd_core.n21 vco_feed_0.vdd_core.n20 0.0149711
R1564 vco_feed_0.vdd_core.n23 vco_feed_0.vdd_core.n9 0.01458
R1565 vco_feed_0.vdd_core vco_feed_0.vdd_core.n22 1.16546
R1566 vco_feed_0.vdd_core.n30 vco_feed_0.vdd_core.n3 0.29442
R1567 vco_feed_0.vdd_core.n1 vco_feed_0.vdd_core.n17 0.219295
R1568 vco_feed_0.vdd_core.n0 vco_feed_0.vdd_core.n27 0.219294
R1569 vco_feed_0.vdd_core.n2 vco_feed_0.vdd_core 0.187579
R1570 vco_feed_0.vdd_core vco_feed_0.vdd_core.n8 0.166326
R1571 vco_feed_0.vdd_core.n7 vco_feed_0.vdd_core 0.166326
R1572 vco_bias_0.vbn_buf.n3 vco_bias_0.vbn_buf.t0 45.045
R1573 vco_bias_0.vbn_buf.n2 vco_bias_0.vbn_buf.t4 34.2391
R1574 vco_bias_0.vbn_buf.n2 vco_bias_0.vbn_buf.t3 28.5544
R1575 vco_bias_0.vbn_buf.n1 vco_bias_0.vbn_buf.n0 22.7415
R1576 vco_bias_0.vbn_buf.n0 vco_bias_0.vbn_buf.t2 21.7736
R1577 vco_bias_0.vbn_buf.n4 vco_bias_0.vbn_buf.t1 17.2373
R1578 vco_bias_0.vbn_buf.n4 vco_bias_0.vbn_buf.n3 13.5293
R1579 vco_bias_0.vbn_buf.n3 vco_bias_0.vbn_buf.n2 6.9349
R1580 vco_bias_0.vbn_buf vco_bias_0.vbn_buf.n4 2.55837
R1581 vco_bias_0.vbn_buf vco_bias_0.vbn_buf.n1 0.2645
R1582 vco_bias_0.vbn_buf.n1 vco_bias_0.vbn_buf 0.1985
R1583 vco_bias_0.vbn_buf.n0 vco_bias_0.vbn_buf 0.1105
C0 VDD rf_out_n 2.80242f
C1 vco_feed_0.en_b rf_out_p 0.07782f
C2 rf_out_n a_10100_3480# 0.69013f
C3 VDD vco_feed_0.vdd_core 0.47549f
C4 rf_out_p vtune 0.03484f
C5 VDD a_10100_3480# 0.39132f
C6 a_5560_4008# VDD 0.03954f
C7 vco_feed_0.en_b vco_bias_0.vbn_buf 1.04162f
C8 vco_bias_0.vbn_buf vtune 0.06767f
C9 a_14668_2644# vtune 0.18112f
C10 vco_bias_0.vbn_buf rf_out_p 0.20879f
C11 a_14668_2644# rf_out_p 0.86364f
C12 a_9450_4394# vtune 0.18112f
C13 a_1560_1090# a_1160_1390# 0.17942f
C14 a_14668_2644# vco_bias_0.vbn_buf 0.01754f
C15 a_19050_4480# a_14668_2644# 0.03458f
C16 vco_bias_0.vbn_buf a_9450_4394# 0.03118f
C17 a_14668_2644# a_9450_4394# 0.17478f
C18 a_1160_1390# vco_bias_0.vbn_buf 0.029f
C19 vco_bias_0.vbg_buf a_1560_1090# 0.06101f
C20 vco_bias_0.vbg_buf vco_feed_0.en_b 0.17737f
C21 vco_bias_0.vbg_buf vtune 0.13019f
C22 vco_bias_0.vbn_buf a_9450_4480# 0.01693f
C23 vco_feed_0.en_b di_en 0.50415f
C24 vco_bias_0.vbg_buf vco_bias_0.vbn_buf 4.94304f
C25 vco_bias_0.vbg_buf a_14668_2644# 0.05315f
C26 rf_out_p a_16500_3480# 0.69013f
C27 a_9450_4480# a_9450_4394# 0.03458f
C28 vco_bias_0.vbg_buf a_19050_4480# 0.04459f
C29 vco_bias_0.vbg_buf a_5060_3088# 0.01628f
C30 a_1560_1090# VDD 0.0235f
C31 vco_feed_0.en_b rf_out_n 0.07832f
C32 vco_feed_0.vdd_core a_24640_164# 1.18592f
C33 a_14668_2644# a_16500_3480# 0.02469f
C34 vco_bias_0.vbg_buf a_9450_4394# 0.06224f
C35 rf_out_n vtune 0.03484f
C36 VDD a_24640_164# 0.04569f
C37 vco_feed_0.en_b VDD 5.96589f
C38 vco_bias_0.vbn_buf di_en 0.11188f
C39 vco_feed_0.vdd_core vtune 11.8836f
C40 VDD vtune 0.11507f
C41 vco_feed_0.en_b a_5560_4008# 0.04005f
C42 vco_bias_0.vbg_buf a_1160_1390# 0.05206f
C43 rf_out_n rf_out_p 0.01393f
C44 vco_feed_0.vdd_core rf_out_p 0.06006f
C45 VDD rf_out_p 2.82306f
C46 vco_bias_0.vbn_buf rf_out_n 0.29297f
C47 vco_bias_0.vbn_buf vco_feed_0.vdd_core 0.30754f
C48 a_14668_2644# vco_feed_0.vdd_core 1.69789f
C49 VDD vco_bias_0.vbn_buf 1.61103f
C50 VDD a_14668_2644# 0.63222f
C51 a_19050_4480# vco_feed_0.vdd_core 0.01117f
C52 vco_bias_0.vbg_buf a_9450_4480# 0.04475f
C53 rf_out_n a_9450_4394# 0.86364f
C54 vco_feed_0.vdd_core a_9450_4394# 1.68741f
C55 a_5560_4008# a_5060_3088# 0.02516f
C56 VDD a_9450_4394# 0.63222f
C57 a_10100_3480# a_9450_4394# 0.02469f
C58 a_1160_1390# VDD 0.01323f
C59 vco_bias_0.vbg_buf di_en 2.11143f
C60 vco_bias_0.vbg_buf vco_feed_0.vdd_core 1.49466f
C61 vco_bias_0.vbg_buf VDD 2.36676f
C62 vco_bias_0.vbg_buf a_5560_4008# 0.01107f
C63 VDD a_16500_3480# 0.39132f
C64 VDD di_en 0.59914f
C65 vco_feed_0.en_b vtune 0.09037f
C66 vco_feed_0.vdd_core rf_out_n 0.05799f
C67 rf_out_p VSS 4.53458f
C68 rf_out_n VSS 4.39544f
C69 di_en VSS 2.96542f
C70 vtune VSS 4.66542f
C71 VDD VSS 41.61788f
C72 vco_feed_0.en_b VSS 15.66407f
C73 vco_bias_0.vbg_buf VSS 0.51558f
C74 vco_bias_0.vbn_buf VSS 0.12876p
C75 vco_bias_0.vbn_buf.n0 VSS 0.11526f
C76 vco_bias_0.vbn_buf.n1 VSS 0.06531f
C77 vco_bias_0.vbn_buf.n2 VSS 0.12484f
C78 vco_bias_0.vbn_buf.t0 VSS 2.22236f
C79 vco_bias_0.vbn_buf.n3 VSS 0.17794f
C80 vco_bias_0.vbn_buf.t1 VSS 0.08971f
C81 vco_bias_0.vbn_buf.n4 VSS 0.12041f
C82 vco_feed_0.vdd_core.n0 VSS 0.07645f
C83 vco_feed_0.vdd_core.n1 VSS 0.08182f
C84 vco_feed_0.vdd_core.n2 VSS 0.27951f
C85 vco_feed_0.vdd_core.n3 VSS 0.22396f
C86 vco_feed_0.vdd_core.n7 VSS 0.02947f
C87 vco_feed_0.vdd_core.n8 VSS 0.02947f
C88 vco_feed_0.vdd_core.t0 VSS 0.23711f
C89 vco_feed_0.vdd_core.t26 VSS 7.16974f
C90 vco_feed_0.vdd_core.t24 VSS 0.23711f
C91 vco_feed_0.vdd_core.n12 VSS 0.03409f
C92 vco_feed_0.vdd_core.n13 VSS 0.04541f
C93 vco_feed_0.vdd_core.n14 VSS 0.19067f
C94 vco_feed_0.vdd_core.t11 VSS 0.03126f
C95 vco_feed_0.vdd_core.n16 VSS 0.04862f
C96 vco_feed_0.vdd_core.n17 VSS 0.04693f
C97 vco_feed_0.vdd_core.n19 VSS 0.06862f
C98 vco_feed_0.vdd_core.n22 VSS 4.03642f
C99 vco_feed_0.vdd_core.n26 VSS 0.04758f
C100 vco_feed_0.vdd_core.t22 VSS 0.02233f
C101 vco_feed_0.vdd_core.n27 VSS 0.03166f
C102 vco_feed_0.vdd_core.n29 VSS 0.06862f
C103 vco_feed_0.vdd_core.n30 VSS 0.03304f
C104 vco_feed_0.en_b.n0 VSS 0.8487f
C105 vco_feed_0.en_b.n1 VSS 0.6768f
C106 vco_feed_0.en_b.t1 VSS 0.1191f
C107 vco_feed_0.en_b.t0 VSS 0.17973f
C108 vco_feed_0.en_b.n2 VSS 0.23039f
C109 vco_feed_0.en_b.n3 VSS 0.343f
C110 vco_feed_0.en_b.n4 VSS 0.54606f
C111 a_5948_4416.t1 VSS 0.13851f
C112 a_5948_4416.n0 VSS 1.96244f
C113 a_5948_4416.t0 VSS 0.26279f
C114 a_6568_6136.t0 VSS 0.5401f
C115 a_6568_6136.t1 VSS 0.50162f
C116 a_6568_6136.n0 VSS 0.63435f
C117 a_6568_6136.n1 VSS 0.95112f
C118 a_6568_6136.n2 VSS 0.63482f
C119 a_6568_6136.t3 VSS 1.01602f
C120 a_5060_5708.t1 VSS 1.3759f
C121 a_5060_5708.n0 VSS 1.50793f
C122 a_5060_5708.t0 VSS 0.33299f
C123 a_5560_5708.t2 VSS 2.67282f
C124 a_5560_5708.t1 VSS 0.77883f
C125 a_5560_5708.n0 VSS 3.70239f
C126 a_5560_5708.t0 VSS 1.32485f
C127 a_5560_3922.t0 VSS 0.72757f
C128 a_5560_3922.n0 VSS 0.98077f
C129 a_5560_3922.t2 VSS 0.50206f
C130 a_5060_3002.t4 VSS 2.59353f
C131 a_5060_3002.t2 VSS 0.53368f
C132 a_5060_3002.n0 VSS 1.35031f
C133 a_5060_3002.n1 VSS 0.23446f
C134 a_5060_3002.n2 VSS 0.37813f
C135 a_5060_3002.t3 VSS 1.13746f
C136 a_5060_3002.n3 VSS 1.2638f
C137 a_5060_3002.t0 VSS 0.20414f
C138 a_11798_1180.n0 VSS 0.68187f
C139 a_11798_1180.n1 VSS 2.26995f
C140 a_11798_1180.n2 VSS 3.86767f
C141 a_11798_1180.n3 VSS 0.35095f
C142 a_11798_1180.n4 VSS 0.10604f
C143 a_11798_1180.n5 VSS 0.10604f
C144 a_11798_1180.n7 VSS 1.55238f
C145 a_11798_1180.n8 VSS 1.52482f
C146 a_11798_1180.n9 VSS 0.09373f
C147 a_11798_1180.t15 VSS 0.06738f
C148 a_11798_1180.n10 VSS 0.05421f
C149 a_11798_1180.t17 VSS 2.98976f
C150 a_11798_1180.n11 VSS 0.04067f
C151 a_11798_1180.t18 VSS 0.08014f
C152 a_11798_1180.t19 VSS 0.07523f
C153 a_11798_1180.n12 VSS 0.04067f
C154 a_11798_1180.t20 VSS 0.07523f
C155 a_11798_1180.n13 VSS 0.04148f
C156 a_11798_1180.t21 VSS 0.06738f
C157 a_11798_1180.n14 VSS 0.0542f
C158 a_11798_1180.n15 VSS 0.10568f
C159 a_11798_1180.n16 VSS 0.06947f
C160 a_11798_1180.n17 VSS 0.06947f
C161 a_11798_1180.n18 VSS 0.10567f
C162 a_11798_1180.t16 VSS 0.34581f
C163 a_11798_1180.n19 VSS 0.04148f
C164 a_11798_1180.n20 VSS 0.33093f
C165 a_11798_1180.n21 VSS 0.33092f
C166 a_11798_1180.n22 VSS 0.09373f
C167 a_11798_1180.t22 VSS 0.06738f
C168 a_11798_1180.n23 VSS 0.05421f
C169 a_11798_1180.t24 VSS 0.07523f
C170 a_11798_1180.n24 VSS 0.04067f
C171 a_11798_1180.t25 VSS 0.08014f
C172 a_11798_1180.t26 VSS 2.98455f
C173 a_11798_1180.n25 VSS 0.04067f
C174 a_11798_1180.t27 VSS 0.07523f
C175 a_11798_1180.n26 VSS 0.04148f
C176 a_11798_1180.t28 VSS 0.06738f
C177 a_11798_1180.n27 VSS 0.0542f
C178 a_11798_1180.n28 VSS 0.10568f
C179 a_11798_1180.n29 VSS 0.06947f
C180 a_11798_1180.n30 VSS 0.06947f
C181 a_11798_1180.n31 VSS 0.10567f
C182 a_11798_1180.t23 VSS 0.33302f
C183 a_11798_1180.n32 VSS 0.04148f
C184 a_11798_1180.n33 VSS 0.33092f
C185 a_11798_1180.t0 VSS 0.24203f
C186 a_11798_1180.t1 VSS 0.23548f
C187 a_11798_1180.t2 VSS 0.23547f
C188 a_11798_1180.t3 VSS 0.23548f
C189 a_11798_1180.t4 VSS 0.23547f
C190 a_11798_1180.t5 VSS 0.23548f
C191 a_11798_1180.t6 VSS 0.23548f
C192 a_11798_1180.t7 VSS 0.23548f
C193 a_11798_1180.t8 VSS 0.23548f
C194 a_11798_1180.t9 VSS 0.23547f
C195 a_11798_1180.t10 VSS 0.23548f
C196 a_11798_1180.t11 VSS 0.23547f
C197 a_11798_1180.t12 VSS 0.90435f
C198 a_11798_1180.t13 VSS 0.23548f
C199 a_11798_1180.t14 VSS 0.24199f
C200 a_20954_346.n0 VSS 2.01654f
C201 a_20954_346.n1 VSS 4.41857f
C202 a_20954_346.n2 VSS 14.9331f
C203 a_20954_346.t16 VSS 15.84959f
C204 a_20954_346.t0 VSS 0.1871f
C205 a_20954_346.t1 VSS 0.18547f
C206 a_20954_346.t2 VSS 0.18547f
C207 a_20954_346.t3 VSS 0.18547f
C208 a_20954_346.t4 VSS 0.18547f
C209 a_20954_346.t5 VSS 0.18547f
C210 a_20954_346.t6 VSS 0.18547f
C211 a_20954_346.t7 VSS 3.04277f
C212 a_20954_346.t8 VSS 0.18547f
C213 a_20954_346.t9 VSS 0.18547f
C214 a_20954_346.t10 VSS 0.18547f
C215 a_20954_346.t11 VSS 0.18547f
C216 a_20954_346.t12 VSS 0.18547f
C217 a_20954_346.t13 VSS 0.18547f
C218 a_20954_346.t14 VSS 0.18547f
C219 a_20954_346.t15 VSS 0.18546f
C220 VSS.t99 VSS 0.13177p
C221 VSS.t81 VSS 0.66888f
C222 VSS.t39 VSS 0.01963f
C223 VSS.t9 VSS 0.02853f
C224 VSS.t108 VSS 2.98334f
C225 VSS.t117 VSS 57.606f
C226 VSS.t118 VSS 57.606f
C227 VSS.t130 VSS 1.0078f
C228 VSS.t132 VSS 1.0078f
C229 VSS.t90 VSS 2.97913f
C230 VSS.t106 VSS 2.98334f
C231 VSS.t92 VSS 2.97913f
C232 VSS.t1 VSS 0.07184f
C233 VSS.t165 VSS 0.0401f
C234 VSS.t115 VSS 0.54116f
C235 VSS.t41 VSS 0.0714f
C236 VSS.t3 VSS 0.04619f
C237 VSS.t181 VSS 0.17725f
C238 VSS.t7 VSS 0.18756f
C239 VSS.t5 VSS 0.18756f
C240 VDD.n0 VSS 0.29284f
C241 VDD.n2 VSS 0.12767f
C242 VDD.n3 VSS 0.15306f
C243 VDD.n4 VSS 0.17314f
C244 VDD.n5 VSS 0.17314f
C245 VDD.n6 VSS 0.17314f
C246 VDD.n7 VSS 1.77755f
C247 VDD.n8 VSS 0.03116f
C248 VDD.n9 VSS 0.03116f
C249 VDD.n10 VSS 0.17314f
C250 VDD.n11 VSS 0.03116f
C251 VDD.n12 VSS 0.03116f
C252 VDD.n13 VSS 0.17314f
C253 VDD.n14 VSS 0.03116f
C254 VDD.n15 VSS 0.03116f
C255 VDD.n16 VSS 0.23963f
C256 VDD.n17 VSS 0.32384f
C257 VDD.n18 VSS 0.05723f
C258 VDD.n19 VSS 0.09368f
C259 VDD.n20 VSS 0.01062f
C260 VDD.n21 VSS 0.10424f
C261 VDD.n22 VSS 0.09455f
C262 VDD.n23 VSS 0.07603f
C263 VDD.n24 VSS 1.26499f
C264 VDD.n25 VSS 0.11719f
C265 VDD.n26 VSS 0.03116f
C266 VDD.n27 VSS 0.08501f
C267 VDD.n29 VSS 0.48244f
C268 VDD.n31 VSS 0.05503f
C269 VDD.n32 VSS 0.07444f
C270 VDD.n33 VSS 0.07848f
C271 VDD.n34 VSS 0.05483f
C272 VDD.n35 VSS 0.03116f
C273 VDD.n36 VSS 0.05483f
C274 VDD.n38 VSS 0.03116f
C275 VDD.n39 VSS 0.05483f
C276 VDD.n40 VSS 0.03116f
C277 VDD.n41 VSS 0.05483f
C278 VDD.n43 VSS 0.03116f
C279 VDD.n44 VSS 0.03116f
C280 VDD.n45 VSS 0.03116f
C281 VDD.n46 VSS 0.05483f
C282 VDD.n47 VSS 0.05483f
C283 VDD.n49 VSS 0.05483f
C284 VDD.n50 VSS 0.05483f
C285 VDD.n52 VSS 0.05483f
C286 VDD.t17 VSS 0.06217f
C287 VDD.t21 VSS 2.91332f
C288 VDD.t19 VSS 0.05602f
C289 VDD.t16 VSS 0.05602f
C290 VDD.t14 VSS 0.05602f
C291 VDD.t12 VSS 0.05602f
C292 VDD.t10 VSS 0.05602f
C293 VDD.t8 VSS 0.05602f
C294 VDD.t7 VSS 0.05022f
C295 VDD.t6 VSS 4.18702f
C296 VDD.t24 VSS 0.05602f
C297 VDD.n53 VSS 0.03116f
C298 VDD.t26 VSS 0.05602f
C299 VDD.t29 VSS 0.05602f
C300 VDD.t31 VSS 0.05602f
C301 VDD.t28 VSS 0.05602f
C302 VDD.t34 VSS 0.05602f
C303 VDD.t36 VSS 0.05602f
C304 VDD.t38 VSS 0.05022f
C305 VDD.n54 VSS 0.03746f
C306 VDD.n55 VSS 0.03652f
C307 VDD.n56 VSS 4.49991f
C308 VDD.t50 VSS 1.00333f
C309 VDD.n57 VSS 5.78576f
C310 VDD.t40 VSS 1.00284f
C311 VDD.n58 VSS 5.78576f
C312 VDD.n59 VSS 4.16159f
C313 VDD.t4 VSS 0.06581f
C314 VDD.t39 VSS 0.07544f
C315 VDD.t5 VSS 0.25412f
C316 VDD.t1 VSS 0.49353f
C317 VDD.t48 VSS 0.17857f
C318 VDD.t49 VSS 0.17443f
C319 VDD.t2 VSS 0.49181f
C320 VDD.t45 VSS 0.17443f
C321 VDD.t46 VSS 0.17443f
C322 VDD.t3 VSS 0.12372f
C323 VDD.t42 VSS 0.02437f
C324 VDD.t43 VSS 0.02437f
C325 VDD.t0 VSS 5.21326f
C326 VDD.n60 VSS 0.42758f
C327 vtune.t2 VSS 3.75866f
C328 vtune.t0 VSS 3.74482f
C329 vtune.n0 VSS 0.40206f
C330 vtune.t4 VSS 3.74482f
C331 vtune.n1 VSS 1.0161f
C332 di_en.n0 VSS 1.9503f
C333 rf_out_n.n0 VSS 1.06634f
C334 rf_out_n.n1 VSS 1.66923f
C335 rf_out_n.t5 VSS 0.13431f
C336 rf_out_n.t4 VSS 3.04235f
C337 rf_out_n.t3 VSS 0.13303f
C338 rf_out_n.t6 VSS 0.13303f
C339 rf_out_n.t2 VSS 0.39082f
C340 rf_out_n.t1 VSS 0.13303f
C341 rf_out_n.t0 VSS 1.92597f
C342 rf_out_n.n2 VSS 5.13496f
C343 rf_out_p.n0 VSS 1.45971f
C344 rf_out_p.n1 VSS 1.25918f
C345 rf_out_p.t3 VSS 0.13349f
C346 rf_out_p.t4 VSS 3.31733f
C347 rf_out_p.t5 VSS 0.13222f
C348 rf_out_p.t2 VSS 0.13222f
C349 rf_out_p.t0 VSS 0.13222f
C350 rf_out_p.t1 VSS 0.13222f
C351 rf_out_p.t6 VSS 1.91957f
C352 rf_out_p.n2 VSS 5.10366f
.ends

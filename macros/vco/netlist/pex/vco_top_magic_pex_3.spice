* PEX produced on Sat Nov  7 10:25:03 PM CET 2026 using /foss/tools/sak/sak-pex.sh with m=3 and s=1 (extresist threshold=1000 mOhm, minres=100 mOhm, mindelay=0 ps)
* NGSPICE file created from vco_top_pex.ext - technology: ihp-sg13g2

.subckt vco_top_pex di_en VDD VSS vtune rf_out_p rf_out_n
X0 VSS.t90 vco_feed_0.vdd_core.t13 vco_feed_0.vdd_core.t22 VSS.t89 sg13_lv_nmos ad=0.68p pd=4.68u as=0.38p ps=2.38u w=2u l=0.13u
X1 VSS.t15 vco_feed_0.vdd_core.t2 vco_feed_0.vdd_core.t11 VSS.t14 sg13_lv_nmos ad=0.68p pd=4.68u as=0.38p ps=2.38u w=2u l=0.13u
X2 a_20954_346.t7 vco_feed_0.en_b.t2 VDD.t21 VDD.t5 sg13_lv_pmos ad=0.57p pd=3.38u as=0.57p ps=3.38u w=3u l=0.13u
X3 VDD.t15 vco_feed_0.en_b.t2 a_20954_346.t4 VDD.t5 sg13_lv_pmos ad=0.57p pd=3.38u as=0.57p ps=3.38u w=3u l=0.13u
X4 VSS.t117 VSS.t114 VSS.t116 VSS.t115 sg13_lv_nmos ad=0.85p pd=5.68u as=0 ps=0 w=2.5u l=0.5u
X5 VDD.t16 vco_feed_0.en_b.t2 a_20954_346.t7 VDD.t5 sg13_lv_pmos ad=0.57p pd=3.38u as=0.57p ps=3.38u w=3u l=0.13u
X6 a_20954_346.t5 vco_feed_0.en_b.t2 VDD.t15 VDD.t5 sg13_lv_pmos ad=0.57p pd=3.38u as=0.57p ps=3.38u w=3u l=0.13u
X7 rf_out_n.t6 a_9450_4394# a_11798_1180.t26 VSS.t178 sg13_lv_nmos ad=0.38p pd=2.38u as=0.38p ps=2.38u w=2u l=0.13u
X8 VDD.t27 vco_feed_0.en_b.t2 a_20954_346.t10 VDD.t5 sg13_lv_pmos ad=0.57p pd=3.38u as=0.57p ps=3.38u w=3u l=0.13u
X9 a_20954_346.t8 vco_feed_0.en_b.t2 VDD.t16 VDD.t5 sg13_lv_pmos ad=0.57p pd=3.38u as=0.57p ps=3.38u w=3u l=0.13u
X10 rf_out_n.t2 a_9450_4394# a_11798_1180.t24 VSS.t174 sg13_lv_nmos ad=0.38p pd=2.38u as=0.38p ps=2.38u w=2u l=0.13u
X11 VSS.t161 vco_bias_0.vbn_buf.t2 a_11798_1180.t19 VSS.t160 sg13_lv_nmos ad=0.95p pd=5.38u as=0.95p ps=5.38u w=5u l=0.5u
X12 a_11798_1180.t17 vco_bias_0.vbn_buf.t2 VSS.t154 VSS.t155 sg13_lv_nmos ad=0.95p pd=5.38u as=0.95p ps=5.38u w=5u l=0.5u
X13 a_11798_1180.t7 vco_bias_0.vbn_buf.t2 VSS.t125 VSS.t124 sg13_lv_nmos ad=0.95p pd=5.38u as=1.7p ps=10.68u w=5u l=0.5u
X14 VSS.t94 vco_bias_0.vbn_buf.t3 VSS.t92 VSS.t38 sg13_lv_nmos ad=1.52p pd=8.38u as=0 ps=0 w=8u l=10u
X15 a_5060_3002.t3 a_5060_3002.t2 VSS.t102 VSS.t101 sg13_lv_nmos ad=0.85p pd=5.68u as=0.85p ps=5.68u w=2.5u l=0.5u
X16 VSS.t98 vco_bias_0.vbn_buf.t3 VSS.t96 VSS.t42 sg13_lv_nmos ad=1.52p pd=8.38u as=0 ps=0 w=8u l=10u
X17 VSS.t133 vco_bias_0.vbn_buf.t2 a_11798_1180.t10 VSS.t135 sg13_lv_nmos ad=0.95p pd=5.38u as=0.95p ps=5.38u w=5u l=0.5u
X18 VSS.t81 vco_feed_0.vdd_core.t13 vco_feed_0.vdd_core.t18 VSS.t85 sg13_lv_nmos ad=0.38p pd=2.38u as=0.38p ps=2.38u w=2u l=0.13u
X19 vco_bias_0.vbn_buf.t0 vco_feed_0.en_b.t3 VSS.t70 VSS.t69 sg13_lv_nmos ad=0.34p pd=2.68u as=0.34p ps=2.68u w=1u l=0.13u
X20 a_11798_1180.t2 a_14668_2644# rf_out_p.t3 VSS.t3 sg13_lv_nmos ad=0.38p pd=2.38u as=0.38p ps=2.38u w=2u l=0.13u
X21 VSS.t64 vco_bias_0.vbn_buf.t4 VSS.t62 VSS.t40 sg13_lv_nmos ad=1.52p pd=8.38u as=0 ps=0 w=8u l=10u
X22 a_20954_346.t11 vco_feed_0.en_b.t2 VDD.t27 VDD.t5 sg13_lv_pmos ad=0.57p pd=3.38u as=0.57p ps=3.38u w=3u l=0.13u
X23 VDD.t23 vco_feed_0.en_b.t2 a_20954_346.t8 VDD.t5 sg13_lv_pmos ad=0.57p pd=3.38u as=0.57p ps=3.38u w=3u l=0.13u
X24 rf_out_p.t5 a_14668_2644# a_11798_1180.t0 VSS.t0 sg13_lv_nmos ad=0.38p pd=2.38u as=0.68p ps=4.68u w=2u l=0.13u
X25 VSS.t37 vco_bias_0.vbg_buf VSS.t36 VSS.t35 sg13_lv_nmos ad=2.72p pd=16.68u as=0 ps=0 w=8u l=10u
X26 a_5948_4416.t1 vco_feed_0.en_b.t7 VDD.t2 VDD.t0 sg13_lv_pmos ad=0.34p pd=2.68u as=0.34p ps=2.68u w=1u l=0.13u
X27 VSS.t53 vco_bias_0.vbg_buf VSS.t51 VSS.t42 sg13_lv_nmos ad=1.52p pd=8.38u as=0 ps=0 w=8u l=10u
X28 a_5560_5708.t1 a_5560_3922.t0 VSS.t106 rppd l=8.5u w=0.5u
X29 a_5060_3002.t4 vco_feed_0.en_b.t4 VSS.t121 VSS.t120 sg13_lv_nmos ad=0.34p pd=2.68u as=0.34p ps=2.68u w=1u l=0.13u
X30 VSS.t24 vco_feed_0.vdd_core.t2 vco_feed_0.vdd_core.t5 VSS.t23 sg13_lv_nmos ad=0.38p pd=2.38u as=0.38p ps=2.38u w=2u l=0.13u
X31 vco_feed_0.vdd_core.t20 vco_feed_0.vdd_core.t13 VSS.t81 VSS.t80 sg13_lv_nmos ad=0.38p pd=2.38u as=0.38p ps=2.38u w=2u l=0.13u
X32 vco_feed_0.vdd_core.t16 vco_feed_0.vdd_core.t13 VSS.t78 VSS.t79 sg13_lv_nmos ad=0.38p pd=2.38u as=0.38p ps=2.38u w=2u l=0.13u
X33 vco_bias_0.vbg_buf a_5560_5708.t2 VSS.t168 rhigh l=32u w=0.5u
X34 vco_feed_0.vdd_core.t9 vco_feed_0.vdd_core.t2 VSS.t17 VSS.t16 sg13_lv_nmos ad=0.38p pd=2.38u as=0.38p ps=2.38u w=2u l=0.13u
X35 vco_feed_0.en_b.t1 di_en.t0 VSS.t119 VSS.t118 sg13_lv_nmos ad=0.17p pd=1.68u as=0.17p ps=1.68u w=0.5u l=0.13u
X36 VDD.t29 vco_feed_0.en_b.t2 a_20954_346.t11 VDD.t5 sg13_lv_pmos ad=0.57p pd=3.38u as=0.57p ps=3.38u w=3u l=0.13u
N37 vco_feed_0.vdd_core.t30 vtune.t6 sg13_hv_svaricap l=0.3u w=26.34u
X38 a_20954_346.t9 vco_feed_0.en_b.t2 VDD.t23 VDD.t5 sg13_lv_pmos ad=0.57p pd=3.38u as=0.57p ps=3.38u w=3u l=0.13u
X39 a_11798_1180.t5 a_14668_2644# rf_out_p.t1 VSS.t9 sg13_lv_nmos ad=0.38p pd=2.38u as=0.38p ps=2.38u w=2u l=0.13u
X40 VSS.t51 vco_bias_0.vbg_buf VSS.t49 VSS.t40 sg13_lv_nmos ad=1.52p pd=8.38u as=0 ps=0 w=8u l=10u
X41 VSS.t154 vco_bias_0.vbn_buf.t2 a_11798_1180.t16 VSS.t153 sg13_lv_nmos ad=0.95p pd=5.38u as=0.95p ps=5.38u w=5u l=0.5u
X42 vco_bias_0.vbg_buf VSS.t31 cap_cmim l=19.1u w=17.5u
X43 VSS.t127 vco_bias_0.vbn_buf.t2 a_11798_1180.t7 VSS.t126 sg13_lv_nmos ad=0.95p pd=5.38u as=0.95p ps=5.38u w=5u l=0.5u
X44 a_11798_1180.t20 vco_bias_0.vbn_buf.t2 VSS.t161 VSS.t162 sg13_lv_nmos ad=0.95p pd=5.38u as=0.95p ps=5.38u w=5u l=0.5u
X45 vco_bias_0.vbn_buf.t1 a_5060_3002.t1 VSS.t103 rhigh l=32u w=0.5u
X46 a_11798_1180.t21 vco_bias_0.vbn_buf.t2 VSS.t164 VSS.t165 sg13_lv_nmos ad=0.95p pd=5.38u as=0.95p ps=5.38u w=5u l=0.5u
X47 a_20954_346.t12 vco_feed_0.en_b.t2 VDD.t29 VDD.t5 sg13_lv_pmos ad=0.57p pd=3.38u as=0.57p ps=3.38u w=3u l=0.13u
X48 VDD.t25 vco_feed_0.en_b.t2 a_20954_346.t9 VDD.t5 sg13_lv_pmos ad=0.57p pd=3.38u as=0.57p ps=3.38u w=3u l=0.13u
N49 vco_feed_0.vdd_core.t29 vtune.t6 sg13_hv_svaricap l=0.3u w=26.34u
X50 VDD.t30 vco_feed_0.en_b.t2 a_20954_346.t12 VDD.t5 sg13_lv_pmos ad=0.57p pd=3.38u as=0.57p ps=3.38u w=3u l=0.13u
X51 a_20954_346.t10 vco_feed_0.en_b.t2 VDD.t25 VDD.t5 sg13_lv_pmos ad=0.57p pd=3.38u as=0.57p ps=3.38u w=3u l=0.13u
X52 VSS.t96 vco_bias_0.vbn_buf.t3 VSS.t94 VSS.t40 sg13_lv_nmos ad=1.52p pd=8.38u as=0 ps=0 w=8u l=10u
X53 a_11798_1180.t27 a_9450_4394# rf_out_n.t6 VSS.t179 sg13_lv_nmos ad=0.38p pd=2.38u as=0.38p ps=2.38u w=2u l=0.13u
X54 VDD.t37 vco_feed_0.en_b.t2 a_20954_346.t15 VDD.t5 sg13_lv_pmos ad=1.02p pd=6.68u as=0.57p ps=3.38u w=3u l=0.13u
X55 a_20954_346.t13 vco_feed_0.en_b.t2 VDD.t30 VDD.t5 sg13_lv_pmos ad=0.57p pd=3.38u as=0.57p ps=3.38u w=3u l=0.13u
X56 a_11798_1180.t11 vco_bias_0.vbn_buf.t2 VSS.t133 VSS.t132 sg13_lv_nmos ad=0.95p pd=5.38u as=0.95p ps=5.38u w=5u l=0.5u
X57 a_11798_1180.t25 a_9450_4394# rf_out_n.t2 VSS.t175 sg13_lv_nmos ad=0.38p pd=2.38u as=0.38p ps=2.38u w=2u l=0.13u
X58 VSS.t39 vco_bias_0.vbg_buf VSS.t37 VSS.t38 sg13_lv_nmos ad=1.52p pd=8.38u as=0 ps=0 w=8u l=10u
X59 VSS.t146 vco_bias_0.vbn_buf.t2 a_11798_1180.t14 VSS.t145 sg13_lv_nmos ad=0.95p pd=5.38u as=0.95p ps=5.38u w=5u l=0.5u
X60 VSS.t55 vco_bias_0.vbg_buf VSS.t53 VSS.t44 sg13_lv_nmos ad=1.52p pd=8.38u as=0 ps=0 w=8u l=10u
X61 VDD.t45 VDD.t43 VDD.t44 VDD.t0 sg13_lv_pmos ad=1.7p pd=10.68u as=0 ps=0 w=5u l=0.5u
X62 VSS.t164 vco_bias_0.vbn_buf.t2 a_11798_1180.t20 VSS.t163 sg13_lv_nmos ad=0.95p pd=5.38u as=0.95p ps=5.38u w=5u l=0.5u
X63 VSS.t87 vco_feed_0.vdd_core.t13 vco_feed_0.vdd_core.t20 VSS.t86 sg13_lv_nmos ad=0.38p pd=2.38u as=0.38p ps=2.38u w=2u l=0.13u
X64 VSS.t167 vco_bias_0.vbn_buf.t2 a_11798_1180.t21 VSS.t166 sg13_lv_nmos ad=1.7p pd=10.68u as=0.95p ps=5.38u w=5u l=0.5u
X65 VSS.t60 vco_bias_0.vbn_buf.t4 VSS.t59 VSS.t35 sg13_lv_nmos ad=2.72p pd=16.68u as=0 ps=0 w=8u l=10u
X66 VSS.t28 vco_feed_0.vdd_core.t2 vco_feed_0.vdd_core.t9 VSS.t27 sg13_lv_nmos ad=0.38p pd=2.38u as=0.38p ps=2.38u w=2u l=0.13u
X67 VDD.t33 vco_feed_0.en_b.t2 a_20954_346.t13 VDD.t5 sg13_lv_pmos ad=0.57p pd=3.38u as=0.57p ps=3.38u w=3u l=0.13u
X68 VDD.t42 VDD.t40 VDD.t41 VDD.t0 sg13_lv_pmos ad=0.34p pd=2.68u as=0 ps=0 w=1u l=0.13u
X69 VDD.t38 rf_out_p.t6 VSS.t107 rppd l=1.65u w=10u
X70 a_6568_6136.t2 a_5948_4416.t2 VDD.t4 VDD.t0 sg13_lv_pmos ad=0.34p pd=2.68u as=0.34p ps=2.68u w=1u l=0.13u
X71 a_20954_346.t14 vco_feed_0.en_b.t2 VDD.t33 VDD.t5 sg13_lv_pmos ad=0.57p pd=3.38u as=0.57p ps=3.38u w=3u l=0.13u
X72 rf_out_p.t2 a_14668_2644# a_11798_1180.t5 VSS.t10 sg13_lv_nmos ad=0.38p pd=2.38u as=0.38p ps=2.38u w=2u l=0.13u
X73 vco_feed_0.en_b.t0 di_en.t1 VDD.t49 VDD.t0 sg13_lv_pmos ad=0.34p pd=2.68u as=0.34p ps=2.68u w=1u l=0.13u
X74 a_11798_1180.t14 vco_bias_0.vbn_buf.t2 VSS.t143 VSS.t144 sg13_lv_nmos ad=0.95p pd=5.38u as=0.95p ps=5.38u w=5u l=0.5u
X75 rf_out_p.t0 a_14668_2644# a_11798_1180.t3 VSS.t6 sg13_lv_nmos ad=0.38p pd=2.38u as=0.38p ps=2.38u w=2u l=0.13u
X76 VSS.t68 vco_bias_0.vbn_buf.t4 VSS.t66 VSS.t44 sg13_lv_nmos ad=1.52p pd=8.38u as=0 ps=0 w=8u l=10u
X77 vco_feed_0.vdd_core.t7 vco_feed_0.vdd_core.t2 VSS.t24 VSS.t25 sg13_lv_nmos ad=0.38p pd=2.38u as=0.38p ps=2.38u w=2u l=0.13u
X78 VSS.t152 vco_bias_0.vbn_buf.t2 a_11798_1180.t17 VSS.t156 sg13_lv_nmos ad=0.95p pd=5.38u as=0.95p ps=5.38u w=5u l=0.5u
X79 a_11798_1180.t15 vco_bias_0.vbn_buf.t2 VSS.t146 VSS.t147 sg13_lv_nmos ad=0.95p pd=5.38u as=0.95p ps=5.38u w=5u l=0.5u
X80 vco_feed_0.vdd_core.t3 vco_feed_0.vdd_core.t2 VSS.t19 VSS.t18 sg13_lv_nmos ad=0.38p pd=2.38u as=0.68p ps=4.68u w=2u l=0.13u
X81 VSS.t158 vco_bias_0.vbn_buf.t2 a_11798_1180.t18 VSS.t157 sg13_lv_nmos ad=0.95p pd=5.38u as=0.95p ps=5.38u w=5u l=0.5u
X82 VSS.t83 vco_feed_0.vdd_core.t13 vco_feed_0.vdd_core.t16 VSS.t84 sg13_lv_nmos ad=0.38p pd=2.38u as=0.38p ps=2.38u w=2u l=0.13u
X83 VDD.t35 vco_feed_0.en_b.t2 a_20954_346.t14 VDD.t5 sg13_lv_pmos ad=0.57p pd=3.38u as=0.57p ps=3.38u w=3u l=0.13u
X84 rf_out_n.t4 a_9450_4394# a_11798_1180.t22 VSS.t170 sg13_lv_nmos ad=0.38p pd=2.38u as=0.68p ps=4.68u w=2u l=0.13u
N85 vco_feed_0.vdd_core.t27 vtune.t2 sg13_hv_svaricap l=0.3u w=26.34u
X86 a_5560_5708.t0 a_6568_6136.t4 VDD.t1 VDD.t0 sg13_lv_pmos ad=1.7p pd=10.68u as=1.7p ps=10.68u w=5u l=0.5u
X87 VSS.t21 vco_feed_0.vdd_core.t2 vco_feed_0.vdd_core.t3 VSS.t20 sg13_lv_nmos ad=0.38p pd=2.38u as=0.38p ps=2.38u w=2u l=0.13u
X88 VSS.t92 vco_bias_0.vbn_buf.t3 VSS.t91 VSS.t35 sg13_lv_nmos ad=2.72p pd=16.68u as=0 ps=0 w=8u l=10u
X89 a_20954_346.t15 vco_feed_0.en_b.t2 VDD.t35 VDD.t5 sg13_lv_pmos ad=0.57p pd=3.38u as=0.57p ps=3.38u w=3u l=0.13u
X90 rf_out_n.t3 a_9450_4394# a_11798_1180.t27 VSS.t180 sg13_lv_nmos ad=0.38p pd=2.38u as=0.38p ps=2.38u w=2u l=0.13u
X91 VSS.t47 vco_bias_0.vbg_buf VSS.t46 VSS.t35 sg13_lv_nmos ad=2.72p pd=16.68u as=0 ps=0 w=8u l=10u
X92 rf_out_n.t5 a_9450_4394# a_11798_1180.t25 VSS.t176 sg13_lv_nmos ad=0.38p pd=2.38u as=0.38p ps=2.38u w=2u l=0.13u
X93 a_5060_5708.t0 vco_feed_0.en_b.t6 VDD.t3 VDD.t0 sg13_lv_pmos ad=0.68p pd=4.68u as=0.68p ps=4.68u w=2u l=0.13u
X94 VSS.t129 vco_bias_0.vbn_buf.t2 a_11798_1180.t8 VSS.t131 sg13_lv_nmos ad=0.95p pd=5.38u as=0.95p ps=5.38u w=5u l=0.5u
X95 VDD.t7 vco_feed_0.en_b.t2 a_20954_346.t0 VDD.t5 sg13_lv_pmos ad=0.57p pd=3.38u as=0.57p ps=3.38u w=3u l=0.13u
X96 a_11798_1180.t12 vco_bias_0.vbn_buf.t2 VSS.t137 VSS.t138 sg13_lv_nmos ad=0.95p pd=5.38u as=0.95p ps=5.38u w=5u l=0.5u
N97 vco_feed_0.vdd_core.t31 vtune.t0 sg13_hv_svaricap l=0.3u w=26.34u
X98 a_11798_1180.t18 vco_bias_0.vbn_buf.t2 VSS.t152 VSS.t151 sg13_lv_nmos ad=0.95p pd=5.38u as=0.95p ps=5.38u w=5u l=0.5u
X99 a_11798_1180.t19 vco_bias_0.vbn_buf.t2 VSS.t158 VSS.t159 sg13_lv_nmos ad=0.95p pd=5.38u as=0.95p ps=5.38u w=5u l=0.5u
X100 a_9450_4394# vco_feed_0.vdd_core.t25 cap_cmim l=10u w=10u
X101 a_20954_346.t1 vco_feed_0.en_b.t2 VDD.t7 VDD.t5 sg13_lv_pmos ad=0.57p pd=3.38u as=0.57p ps=3.38u w=3u l=0.13u
X102 a_11798_1180.t1 a_14668_2644# rf_out_p.t5 VSS.t1 sg13_lv_nmos ad=0.38p pd=2.38u as=0.38p ps=2.38u w=2u l=0.13u
X103 VSS.t100 vco_bias_0.vbn_buf.t3 VSS.t98 VSS.t44 sg13_lv_nmos ad=1.52p pd=8.38u as=0 ps=0 w=8u l=10u
X104 VSS.t113 VSS.t110 VSS.t112 VSS.t111 sg13_lv_nmos ad=0.85p pd=5.68u as=0 ps=0 w=2.5u l=0.5u
X105 vco_feed_0.vdd_core.t22 vco_feed_0.vdd_core.t13 VSS.t87 VSS.t88 sg13_lv_nmos ad=0.38p pd=2.38u as=0.38p ps=2.38u w=2u l=0.13u
X106 vco_feed_0.vdd_core.t11 vco_feed_0.vdd_core.t2 VSS.t28 VSS.t29 sg13_lv_nmos ad=0.38p pd=2.38u as=0.38p ps=2.38u w=2u l=0.13u
X107 a_11798_1180.t8 vco_bias_0.vbn_buf.t2 VSS.t127 VSS.t130 sg13_lv_nmos ad=0.95p pd=5.38u as=0.95p ps=5.38u w=5u l=0.5u
X108 VDD.t9 vco_feed_0.en_b.t2 a_20954_346.t1 VDD.t5 sg13_lv_pmos ad=0.57p pd=3.38u as=0.57p ps=3.38u w=3u l=0.13u
X109 VSS.t137 vco_bias_0.vbn_buf.t2 a_11798_1180.t11 VSS.t136 sg13_lv_nmos ad=0.95p pd=5.38u as=0.95p ps=5.38u w=5u l=0.5u
X110 a_11798_1180.t9 vco_bias_0.vbn_buf.t2 VSS.t129 VSS.t128 sg13_lv_nmos ad=0.95p pd=5.38u as=0.95p ps=5.38u w=5u l=0.5u
X111 a_11798_1180.t4 a_14668_2644# rf_out_p.t0 VSS.t7 sg13_lv_nmos ad=0.38p pd=2.38u as=0.38p ps=2.38u w=2u l=0.13u
X112 rf_out_p.t4 a_14668_2644# a_11798_1180.t2 VSS.t4 sg13_lv_nmos ad=0.38p pd=2.38u as=0.38p ps=2.38u w=2u l=0.13u
X113 VSS.t43 vco_bias_0.vbg_buf VSS.t41 VSS.t42 sg13_lv_nmos ad=1.52p pd=8.38u as=0 ps=0 w=8u l=10u
X114 VDD.t48 VDD.t46 VDD.t47 VDD.t0 sg13_lv_pmos ad=1.7p pd=10.68u as=0 ps=0 w=5u l=0.5u
X115 a_14668_2644# vco_feed_0.vdd_core.t0 cap_cmim l=10u w=10u
X116 VSS.t140 vco_bias_0.vbn_buf.t2 a_11798_1180.t12 VSS.t139 sg13_lv_nmos ad=0.95p pd=5.38u as=0.95p ps=5.38u w=5u l=0.5u
X117 a_11798_1180.t16 vco_bias_0.vbn_buf.t2 VSS.t149 VSS.t150 sg13_lv_nmos ad=0.95p pd=5.38u as=0.95p ps=5.38u w=5u l=0.5u
X118 a_5560_3922.t2 a_5560_3922.t1 VSS.t58 VSS.t57 sg13_lv_nmos ad=0.85p pd=5.68u as=0.85p ps=5.68u w=2.5u l=0.5u
X119 a_11798_1180.t23 a_9450_4394# rf_out_n.t4 VSS.t171 sg13_lv_nmos ad=0.38p pd=2.38u as=0.38p ps=2.38u w=2u l=0.13u
X120 VSS.t49 vco_bias_0.vbg_buf VSS.t47 VSS.t38 sg13_lv_nmos ad=1.52p pd=8.38u as=0 ps=0 w=8u l=10u
X121 a_20954_346.t2 vco_feed_0.en_b.t2 VDD.t9 VDD.t5 sg13_lv_pmos ad=0.57p pd=3.38u as=0.57p ps=3.38u w=3u l=0.13u
X122 VSS.t41 vco_bias_0.vbg_buf VSS.t39 VSS.t40 sg13_lv_nmos ad=1.52p pd=8.38u as=0 ps=0 w=8u l=10u
X123 VSS.t17 vco_feed_0.vdd_core.t2 vco_feed_0.vdd_core.t7 VSS.t26 sg13_lv_nmos ad=0.38p pd=2.38u as=0.38p ps=2.38u w=2u l=0.13u
X124 a_6568_6136.t1 a_6568_6136.t0 VDD.t50 VDD.t0 sg13_lv_pmos ad=1.7p pd=10.68u as=1.7p ps=10.68u w=5u l=0.5u
X125 vco_feed_0.vdd_core.t18 vco_feed_0.vdd_core.t13 VSS.t83 VSS.t82 sg13_lv_nmos ad=0.38p pd=2.38u as=0.38p ps=2.38u w=2u l=0.13u
X126 a_11798_1180.t28 a_9450_4394# rf_out_n.t3 VSS.t181 sg13_lv_nmos ad=0.68p pd=4.68u as=0.38p ps=2.38u w=2u l=0.13u
X127 vco_feed_0.vdd_core.t14 vco_feed_0.vdd_core.t13 VSS.t76 VSS.t75 sg13_lv_nmos ad=0.38p pd=2.38u as=0.68p ps=4.68u w=2u l=0.13u
X128 vco_feed_0.vdd_core VSS.t71 cap_cmim l=39u w=56u
X129 VDD.t11 vco_feed_0.en_b.t2 a_20954_346.t2 VDD.t5 sg13_lv_pmos ad=0.57p pd=3.38u as=0.57p ps=3.38u w=3u l=0.13u
X130 a_11798_1180.t26 a_9450_4394# rf_out_n.t5 VSS.t177 sg13_lv_nmos ad=0.38p pd=2.38u as=0.38p ps=2.38u w=2u l=0.13u
X131 a_20954_346.t0 vco_feed_0.en_b.t2 VDD.t6 VDD.t5 sg13_lv_pmos ad=0.57p pd=3.38u as=1.02p ps=6.68u w=3u l=0.13u
X132 VDD.t17 vco_feed_0.en_b.t2 a_20954_346.t5 VDD.t5 sg13_lv_pmos ad=0.57p pd=3.38u as=0.57p ps=3.38u w=3u l=0.13u
X133 a_11798_1180.t24 a_9450_4394# rf_out_n.t1 VSS.t173 sg13_lv_nmos ad=0.38p pd=2.38u as=0.38p ps=2.38u w=2u l=0.13u
N134 vco_feed_0.vdd_core.t28 vtune.t2 sg13_hv_svaricap l=0.3u w=26.34u
X135 vco_bias_0.vbg_buf a_14668_2644# VSS.t169 rhigh l=8u w=0.5u
X136 a_20954_346.t3 vco_feed_0.en_b.t2 VDD.t11 VDD.t5 sg13_lv_pmos ad=0.57p pd=3.38u as=0.57p ps=3.38u w=3u l=0.13u
X137 VSS.t123 vco_bias_0.vbn_buf.t2 a_11798_1180.t9 VSS.t122 sg13_lv_nmos ad=0.95p pd=5.38u as=0.95p ps=5.38u w=5u l=0.5u
X138 a_6568_6136.t3 a_5060_3002.t5 VSS.t105 VSS.t104 sg13_lv_nmos ad=0.85p pd=5.68u as=0.85p ps=5.68u w=2.5u l=0.5u
X139 vco_feed_0.vdd_core.t5 vco_feed_0.vdd_core.t2 VSS.t21 VSS.t22 sg13_lv_nmos ad=0.38p pd=2.38u as=0.38p ps=2.38u w=2u l=0.13u
X140 VSS.t149 vco_bias_0.vbn_buf.t2 a_11798_1180.t15 VSS.t148 sg13_lv_nmos ad=0.95p pd=5.38u as=0.95p ps=5.38u w=5u l=0.5u
X141 a_11798_1180.t13 vco_bias_0.vbn_buf.t2 VSS.t140 VSS.t141 sg13_lv_nmos ad=0.95p pd=5.38u as=0.95p ps=5.38u w=5u l=0.5u
X142 VSS.t78 vco_feed_0.vdd_core.t13 vco_feed_0.vdd_core.t14 VSS.t77 sg13_lv_nmos ad=0.38p pd=2.38u as=0.38p ps=2.38u w=2u l=0.13u
X143 a_5948_4416.t0 vco_feed_0.en_b.t5 VSS.t13 VSS.t12 sg13_lv_nmos ad=0.17p pd=1.68u as=0.17p ps=1.68u w=0.5u l=0.13u
X144 vco_bias_0.vbg_buf VSS.t33 cap_cmim l=7.28u w=13.6u
X145 a_20954_346.t16 vco_feed_0.vdd_core.t24 VSS.t109 rppd l=8.8u w=17.3u
X146 rf_out_p.t3 a_14668_2644# a_11798_1180.t1 VSS.t2 sg13_lv_nmos ad=0.38p pd=2.38u as=0.38p ps=2.38u w=2u l=0.13u
X147 a_20954_346.t6 vco_feed_0.en_b.t2 VDD.t17 VDD.t5 sg13_lv_pmos ad=0.57p pd=3.38u as=0.57p ps=3.38u w=3u l=0.13u
X148 VDD.t13 vco_feed_0.en_b.t2 a_20954_346.t3 VDD.t5 sg13_lv_pmos ad=0.57p pd=3.38u as=0.57p ps=3.38u w=3u l=0.13u
N149 vco_feed_0.vdd_core.t32 vtune.t0 sg13_hv_svaricap l=0.3u w=26.34u
X150 VDD.t39 rf_out_n.t0 VSS.t108 rppd l=1.65u w=10u
X151 VSS.t45 vco_bias_0.vbg_buf VSS.t43 VSS.t44 sg13_lv_nmos ad=1.52p pd=8.38u as=0 ps=0 w=8u l=10u
X152 VSS.t62 vco_bias_0.vbn_buf.t4 VSS.t60 VSS.t38 sg13_lv_nmos ad=1.52p pd=8.38u as=0 ps=0 w=8u l=10u
X153 VSS.t66 vco_bias_0.vbn_buf.t4 VSS.t64 VSS.t42 sg13_lv_nmos ad=1.52p pd=8.38u as=0 ps=0 w=8u l=10u
X154 vco_feed_0.vdd_core VSS.t73 cap_cmim l=25.5u w=42u
X155 VDD.t21 vco_feed_0.en_b.t2 a_20954_346.t6 VDD.t5 sg13_lv_pmos ad=0.57p pd=3.38u as=0.57p ps=3.38u w=3u l=0.13u
X156 a_20954_346.t4 vco_feed_0.en_b.t2 VDD.t13 VDD.t5 sg13_lv_pmos ad=0.57p pd=3.38u as=0.57p ps=3.38u w=3u l=0.13u
X157 a_11798_1180.t6 a_14668_2644# rf_out_p.t2 VSS.t11 sg13_lv_nmos ad=0.68p pd=4.68u as=0.38p ps=2.38u w=2u l=0.13u
X158 a_5060_5708.t1 a_5060_3002.t0 VSS.t56 rppd l=13.1u w=0.5u
X159 rf_out_p.t1 a_14668_2644# a_11798_1180.t4 VSS.t8 sg13_lv_nmos ad=0.38p pd=2.38u as=0.38p ps=2.38u w=2u l=0.13u
X160 vco_bias_0.vbg_buf a_9450_4394# VSS.t30 rhigh l=8u w=0.5u
X161 a_11798_1180.t3 a_14668_2644# rf_out_p.t4 VSS.t5 sg13_lv_nmos ad=0.38p pd=2.38u as=0.38p ps=2.38u w=2u l=0.13u
X162 a_11798_1180.t10 vco_bias_0.vbn_buf.t2 VSS.t123 VSS.t134 sg13_lv_nmos ad=0.95p pd=5.38u as=0.95p ps=5.38u w=5u l=0.5u
X163 VSS.t143 vco_bias_0.vbn_buf.t2 a_11798_1180.t13 VSS.t142 sg13_lv_nmos ad=0.95p pd=5.38u as=0.95p ps=5.38u w=5u l=0.5u
X164 rf_out_n.t1 a_9450_4394# a_11798_1180.t23 VSS.t172 sg13_lv_nmos ad=0.38p pd=2.38u as=0.38p ps=2.38u w=2u l=0.13u
R0 rf_out_p.n0 rf_out_p.t5 6.56137
R1 rf_out_p.n1 rf_out_p.t2 6.52949
R2 rf_out_p.n1 rf_out_p.t1 6.52949
R3 rf_out_p.n0 rf_out_p.t0 6.52949
R4 rf_out_p.n0 rf_out_p.t4 6.52949
R5 rf_out_p.n0 rf_out_p.t3 6.52949
R6 rf_out_p rf_out_p.n2 1.88238
R7 rf_out_p.n2 rf_out_p.t6 1.62005
R8 rf_out_p.n1 rf_out_p.n0 0.128045
R9 rf_out_p.n2 rf_out_p.n1 0.117417
R10 rf_out_n.n0 rf_out_n.t3 6.56137
R11 rf_out_n.n0 rf_out_n.t6 6.52949
R12 rf_out_n.n0 rf_out_n.t5 6.52949
R13 rf_out_n.n1 rf_out_n.t2 6.52949
R14 rf_out_n.n1 rf_out_n.t1 6.52949
R15 rf_out_n.n1 rf_out_n.t4 6.52949
R16 rf_out_n rf_out_n.n2 1.88238
R17 rf_out_n.n2 rf_out_n.t0 1.62005
R18 rf_out_n.n1 rf_out_n.n0 0.128045
R19 rf_out_n.n2 rf_out_n.n1 0.117417
R20 di_en.n0 di_en.t0 21.6583
R21 di_en.n0 di_en.t1 19.605
R22 di_en di_en.n0 14.2582
R23 vtune.n0 vtune.t0 16.1774
R24 vtune vtune.n1 16.1137
R25 vtune.n0 vtune.t6 14.7078
R26 vtune.n1 vtune.t2 14.7078
R27 vtune.n1 vtune.n0 1.4701
R28 VDD VDD.n24 32.7055
R29 VDD.n17 VDD.t46 17.5809
R30 VDD.n0 VDD.t43 17.5809
R31 VDD.n60 VDD.n1 1.2602
R32 VDD.n18 VDD.t47 2.54491
R33 VDD.n2 VDD.t40 15.8062
R34 VDD.n57 VDD.n56 10.8262
R35 VDD.n59 VDD.n58 10.8262
R36 VDD.n20 VDD.n29 3.37066
R37 VDD.n25 VDD.t41 6.07554
R38 VDD.n2 VDD.t42 6.07554
R39 VDD.n19 VDD.t4 6.07554
R40 VDD.n23 VDD.t49 6.07554
R41 VDD.n24 VDD.t2 6.07554
R42 VDD.n1 VDD.n19 0.0656783
R43 VDD.n54 VDD.n22 0.830556
R44 VDD.n22 VDD.n29 2.80696
R45 VDD.n52 VDD.n51 0.0585658
R46 VDD.n51 VDD.n29 2.7974
R47 VDD.n50 VDD.n48 0.0585658
R48 VDD.n48 VDD.n29 2.7974
R49 VDD.n47 VDD.n30 0.066765
R50 VDD.n21 VDD.n42 0.0585658
R51 VDD.n42 VDD.n29 2.7974
R52 VDD.n41 VDD.n37 0.0585658
R53 VDD.n37 VDD.n29 2.7974
R54 VDD.n28 VDD.n29 2.37707
R55 VDD.n19 VDD.n23 0.1061
R56 VDD.n30 VDD.n29 2.3909
R57 VDD.n27 VDD.n28 0.0743661
R58 VDD.n58 VDD.n57 3.7073
R59 VDD.n25 VDD.t3 3.45404
R60 VDD.n24 VDD.n60 3.37539
R61 VDD.n60 VDD.n0 1.51113
R62 VDD.n60 VDD.n18 1.16155
R63 VDD.n32 VDD.t16 2.57245
R64 VDD.n17 VDD.t50 2.36482
R65 VDD.n0 VDD.t45 2.36417
R66 VDD.n0 VDD.t44 2.36383
R67 VDD.n33 VDD.t1 2.3637
R68 VDD.n17 VDD.t48 2.36348
R69 VDD.n3 VDD.n55 2.10932
R70 VDD.n54 VDD.n16 2.10932
R71 VDD.n55 VDD.t6 2.06537
R72 VDD.n54 VDD.t37 2.06537
R73 VDD.n26 VDD.t7 2.06506
R74 VDD.n35 VDD.t9 2.06506
R75 VDD.n38 VDD.t11 2.06506
R76 VDD.n40 VDD.t13 2.06506
R77 VDD.n43 VDD.t15 2.06506
R78 VDD.n44 VDD.t17 2.06506
R79 VDD.n45 VDD.t21 2.06506
R80 VDD.n53 VDD.t23 2.06506
R81 VDD.n9 VDD.t25 2.06506
R82 VDD.n8 VDD.t27 2.06506
R83 VDD.n12 VDD.t29 2.06506
R84 VDD.n11 VDD.t30 2.06506
R85 VDD.n15 VDD.t33 2.06506
R86 VDD.n14 VDD.t35 2.06506
R87 VDD.n3 VDD.n26 2.01733
R88 VDD.n4 VDD.n35 2.01733
R89 VDD.n4 VDD.n38 2.01733
R90 VDD.n5 VDD.n40 2.01733
R91 VDD.n5 VDD.n43 2.01733
R92 VDD.n6 VDD.n44 2.01733
R93 VDD.n6 VDD.n45 2.01733
R94 VDD.n53 VDD.n7 2.01733
R95 VDD.n10 VDD.n9 2.01733
R96 VDD.n10 VDD.n8 2.01733
R97 VDD.n13 VDD.n12 2.01733
R98 VDD.n13 VDD.n11 2.01733
R99 VDD.n16 VDD.n15 2.01733
R100 VDD.n16 VDD.n14 2.01733
R101 VDD.n56 VDD.n7 0.833598
R102 VDD.n55 VDD.n27 0.811613
R103 VDD.n27 VDD.n26 0.75308
R104 VDD.n36 VDD.n35 0.75308
R105 VDD.n34 VDD.n38 0.75308
R106 VDD.n41 VDD.n40 0.75308
R107 VDD.n39 VDD.n43 0.75308
R108 VDD.n21 VDD.n44 0.75308
R109 VDD.n21 VDD.n45 0.75308
R110 VDD.n31 VDD.n53 0.75308
R111 VDD.n47 VDD.n9 0.75308
R112 VDD.n46 VDD.n8 0.75308
R113 VDD.n50 VDD.n12 0.75308
R114 VDD.n49 VDD.n11 0.75308
R115 VDD.n52 VDD.n15 0.75308
R116 VDD.n22 VDD.n14 0.75308
R117 VDD VDD.n59 0.597573
R118 VDD.n57 VDD.t38 0.517741
R119 VDD.n58 VDD.t39 0.517741
R120 VDD.n60 VDD.t0 0.395849
R121 VDD.n59 VDD.n56 0.35172
R122 VDD.n29 VDD.t5 0.347439
R123 VDD.n0 VDD.n33 0.222999
R124 VDD.n2 VDD.n25 0.199822
R125 VDD.n16 VDD.n13 0.183684
R126 VDD.n13 VDD.n10 0.183684
R127 VDD.n10 VDD.n7 0.183684
R128 VDD.n7 VDD.n6 0.183684
R129 VDD.n6 VDD.n5 0.183684
R130 VDD.n5 VDD.n4 0.183684
R131 VDD.n4 VDD.n3 0.183684
R132 VDD.n33 VDD.n17 0.181347
R133 VDD.n28 VDD.n36 0.099072
R134 VDD.n32 VDD.n31 0.174604
R135 VDD.n52 VDD.n22 0.155757
R136 VDD.n7 VDD.n32 0.152545
R137 VDD.n24 VDD.n23 0.152127
R138 VDD.n18 VDD.n17 0.0814646
R139 VDD.n2 VDD.n1 0.0766266
R140 VDD.n0 VDD.n25 0.139213
R141 VDD.n49 VDD.n51 0.0585658
R142 VDD.n50 VDD.n49 0.116817
R143 VDD.n46 VDD.n48 0.0585658
R144 VDD.n47 VDD.n46 0.116817
R145 VDD.n31 VDD.n30 0.0501977
R146 VDD.n39 VDD.n42 0.0585658
R147 VDD.n41 VDD.n39 0.116817
R148 VDD.n34 VDD.n37 0.0585658
R149 VDD.n36 VDD.n34 0.116817
R150 VDD.n21 VDD.n20 0.116756
R151 VDD.n20 VDD.n32 0.116351
R152 VSS.t169 VSS.n47 2824.33
R153 VSS.n374 VSS.n286 18957.8
R154 VSS.n41 VSS.n47 20.3972
R155 VSS.n156 VSS.n155 1094.66
R156 VSS.t103 VSS.n471 657.683
R157 VSS.t169 VSS.t107 301.887
R158 VSS.t106 VSS.t56 224.619
R159 VSS.t168 VSS.t103 179.696
R160 VSS.t56 VSS.t168 157.233
R161 VSS.n472 VSS.t106 142.626
R162 VSS.t107 VSS.n94 109.811
R163 VSS.n479 VSS.n478 69.913
R164 VSS.t101 VSS.n39 31.5502
R165 VSS.t115 VSS.n477 48.555
R166 VSS.n474 VSS.t118 47.8044
R167 VSS.n38 VSS.t57 45.1788
R168 VSS.n476 VSS.t69 43.4374
R169 VSS.t120 VSS.n474 37.5655
R170 VSS.n477 VSS.t101 32.6297
R171 VSS.n473 VSS.t12 30.9232
R172 VSS.n38 VSS.t111 15.7829
R173 VSS.n475 VSS.t120 26.3726
R174 VSS.n515 VSS.n60 25.2835
R175 VSS.n375 VSS.n374 21.7962
R176 VSS.n306 VSS.t35 20.8203
R177 VSS.t69 VSS.n475 20.6825
R178 VSS.t12 VSS.n472 20.4783
R179 VSS.t57 VSS.n476 18.976
R180 VSS.n460 VSS.t13 17.3443
R181 VSS.n462 VSS.t119 17.3443
R182 VSS.n560 VSS.n559 17.0005
R183 VSS.n560 VSS.n159 17.0005
R184 VSS.n560 VSS.n160 17.0005
R185 VSS.n561 VSS.n560 17.0005
R186 VSS.n560 VSS.n162 17.0005
R187 VSS.n560 VSS.n163 17.0005
R188 VSS.n560 VSS.n164 17.0005
R189 VSS.n560 VSS.n165 17.0005
R190 VSS.n560 VSS.n166 17.0005
R191 VSS.n560 VSS.n167 17.0005
R192 VSS.n560 VSS.n35 3.38141
R193 VSS.n560 VSS.n168 17.0005
R194 VSS.n560 VSS.n169 17.0005
R195 VSS.n560 VSS.n170 17.0005
R196 VSS.n560 VSS.n171 17.0005
R197 VSS.n560 VSS.n557 17.0005
R198 VSS.n560 VSS.n558 17.0005
R199 VSS.n544 VSS.n543 17.0005
R200 VSS.n544 VSS.n194 17.0005
R201 VSS.n544 VSS.n539 17.0005
R202 VSS.n544 VSS.n195 17.0005
R203 VSS.n544 VSS.n538 17.0005
R204 VSS.n544 VSS.n196 17.0005
R205 VSS.n544 VSS.n536 17.0005
R206 VSS.n544 VSS.n197 17.0005
R207 VSS.n544 VSS.n535 17.0005
R208 VSS.n14 VSS.n544 2.8034
R209 VSS.n544 VSS.n198 17.0005
R210 VSS.n544 VSS.n534 17.0005
R211 VSS.n544 VSS.n199 17.0005
R212 VSS.n544 VSS.n533 17.0005
R213 VSS.n544 VSS.n200 17.0005
R214 VSS.n544 VSS.n202 17.0005
R215 VSS.n544 VSS.n201 17.0005
R216 VSS.n564 VSS.n563 17.0005
R217 VSS.n564 VSS.n123 17.0005
R218 VSS.n564 VSS.n158 17.0005
R219 VSS.n564 VSS.n124 17.0005
R220 VSS.n564 VSS.n157 17.0005
R221 VSS.n564 VSS.n125 17.0005
R222 VSS.n564 VSS.n154 17.0005
R223 VSS.n564 VSS.n126 17.0005
R224 VSS.n564 VSS.n153 17.0005
R225 VSS.n564 VSS.n127 17.0005
R226 VSS.n564 VSS.n152 17.0005
R227 VSS.n564 VSS.n128 17.0005
R228 VSS.n564 VSS.n151 17.0005
R229 VSS.n564 VSS.n129 17.0005
R230 VSS.n564 VSS.n150 17.0005
R231 VSS.n564 VSS.n130 17.0005
R232 VSS.n564 VSS.n149 17.0005
R233 VSS.n564 VSS.n131 17.0005
R234 VSS.n564 VSS.n148 17.0005
R235 VSS.n564 VSS.n132 17.0005
R236 VSS.n564 VSS.n147 17.0005
R237 VSS.n564 VSS.n133 17.0005
R238 VSS.n564 VSS.n146 17.0005
R239 VSS.n564 VSS.n134 17.0005
R240 VSS.n564 VSS.n145 17.0005
R241 VSS.n564 VSS.n135 17.0005
R242 VSS.n564 VSS.n144 17.0005
R243 VSS.n564 VSS.n136 17.0005
R244 VSS.n564 VSS.n143 17.0005
R245 VSS.n564 VSS.n137 17.0005
R246 VSS.n564 VSS.n142 17.0005
R247 VSS.n565 VSS.n564 17.0005
R248 VSS.n564 VSS.n141 17.0005
R249 VSS.n564 VSS.n138 17.0005
R250 VSS.n564 VSS.n140 17.0005
R251 VSS.n46 VSS.n45 0.799564
R252 VSS.n567 VSS.n566 17.0005
R253 VSS.n567 VSS.n49 17.0005
R254 VSS.n567 VSS.n70 17.0005
R255 VSS.n567 VSS.n50 17.0005
R256 VSS.n567 VSS.n69 17.0005
R257 VSS.n567 VSS.n51 17.0005
R258 VSS.n567 VSS.n68 17.0005
R259 VSS.n567 VSS.n52 17.0005
R260 VSS.n567 VSS.n67 17.0005
R261 VSS.n567 VSS.n53 17.0005
R262 VSS.n567 VSS.n66 17.0005
R263 VSS.n567 VSS.n54 17.0005
R264 VSS.n567 VSS.n65 17.0005
R265 VSS.n567 VSS.n55 17.0005
R266 VSS.n567 VSS.n64 17.0005
R267 VSS.n567 VSS.n56 17.0005
R268 VSS.n567 VSS.n63 17.0005
R269 VSS.n567 VSS.n60 17.0005
R270 VSS.n567 VSS.n71 17.0005
R271 VSS.n567 VSS.n95 17.0005
R272 VSS.n567 VSS.n96 17.0005
R273 VSS.n567 VSS.n97 17.0005
R274 VSS.n567 VSS.n98 17.0005
R275 VSS.n567 VSS.n99 17.0005
R276 VSS.n567 VSS.n100 17.0005
R277 VSS.n567 VSS.n101 17.0005
R278 VSS.n567 VSS.n102 17.0005
R279 VSS.n567 VSS.n103 17.0005
R280 VSS.n567 VSS.n104 17.0005
R281 VSS.n567 VSS.n107 17.0005
R282 VSS.n567 VSS.n108 17.0005
R283 VSS.n567 VSS.n109 17.0005
R284 VSS.n567 VSS.n110 17.0005
R285 VSS.n567 VSS.n111 17.0005
R286 VSS.n567 VSS.n112 17.0005
R287 VSS.n567 VSS.n113 17.0005
R288 VSS.n567 VSS.n114 17.0005
R289 VSS.n567 VSS.n115 17.0005
R290 VSS.n567 VSS.n116 17.0005
R291 VSS.n567 VSS.n117 17.0005
R292 VSS.n20 VSS.n7 0.0445345
R293 VSS.n567 VSS.n118 17.0005
R294 VSS.n567 VSS.n119 17.0005
R295 VSS.n567 VSS.n120 17.0005
R296 VSS.n567 VSS.n121 17.0005
R297 VSS.n567 VSS.n94 17.0005
R298 VSS.n567 VSS.n88 17.0005
R299 VSS.n567 VSS.n87 17.0005
R300 VSS.n567 VSS.n86 17.0005
R301 VSS.n567 VSS.n85 17.0005
R302 VSS.n567 VSS.n84 17.0005
R303 VSS.n567 VSS.n83 17.0005
R304 VSS.n567 VSS.n82 17.0005
R305 VSS.n567 VSS.n81 17.0005
R306 VSS.n567 VSS.n80 17.0005
R307 VSS.n567 VSS.n79 17.0005
R308 VSS.n567 VSS.n78 17.0005
R309 VSS.n567 VSS.n77 17.0005
R310 VSS.n567 VSS.n76 17.0005
R311 VSS.n567 VSS.n75 17.0005
R312 VSS.n567 VSS.n74 17.0005
R313 VSS.n567 VSS.n73 17.0005
R314 VSS.n567 VSS.n72 17.0005
R315 VSS.n37 VSS.n34 4.23471
R316 VSS.n18 VSS.n21 0.0988086
R317 VSS.n472 VSS.n37 17.0005
R318 VSS.n471 VSS.n320 16.9166
R319 VSS.n520 VSS.n212 16.9166
R320 VSS.n521 VSS.n213 16.9166
R321 VSS.n447 VSS.n203 16.9166
R322 VSS.n232 VSS.n211 16.9166
R323 VSS.n448 VSS.n204 16.9166
R324 VSS.n231 VSS.n210 16.9166
R325 VSS.n449 VSS.n205 16.9166
R326 VSS.n450 VSS.n206 16.9166
R327 VSS.n229 VSS.n208 16.9166
R328 VSS.n452 VSS.n207 16.9166
R329 VSS.n21 VSS.t110 16.4809
R330 VSS.n22 VSS.t114 16.4809
R331 VSS.t118 VSS.n473 16.1318
R332 VSS.n62 VSS.t130 15.6019
R333 VSS.t163 VSS.n89 15.6019
R334 VSS.n93 VSS.t165 14.4834
R335 VSS.n61 VSS.t126 14.4827
R336 VSS.t104 VSS.n39 11.1952
R337 VSS.t126 VSS.n57 12.9739
R338 VSS.t165 VSS.n90 12.9739
R339 VSS.n491 VSS.n490 12.8307
R340 VSS.n220 VSS.n219 12.8307
R341 VSS.n508 VSS.n506 12.8307
R342 VSS.n216 VSS.n215 12.8307
R343 VSS.t124 VSS.n60 12.4533
R344 VSS.n94 VSS.t166 12.4533
R345 VSS.n137 VSS.n121 12.3761
R346 VSS.n143 VSS.n120 12.3761
R347 VSS.n143 VSS.n119 12.3761
R348 VSS.n136 VSS.n118 12.3761
R349 VSS.n135 VSS.n117 12.3761
R350 VSS.n135 VSS.n116 12.3761
R351 VSS.n145 VSS.n115 12.3761
R352 VSS.n146 VSS.n114 12.3761
R353 VSS.n146 VSS.n113 12.3761
R354 VSS.n133 VSS.n113 12.3761
R355 VSS.n147 VSS.n112 12.3761
R356 VSS.n147 VSS.n111 12.3761
R357 VSS.n132 VSS.n111 12.3761
R358 VSS.n132 VSS.n110 12.3761
R359 VSS.n148 VSS.n109 12.3761
R360 VSS.n131 VSS.n109 12.3761
R361 VSS.n131 VSS.n108 12.3761
R362 VSS.n149 VSS.n108 12.3761
R363 VSS.n130 VSS.n107 12.3761
R364 VSS.n130 VSS.n104 12.3761
R365 VSS.n150 VSS.n104 12.3761
R366 VSS.n150 VSS.n103 12.3761
R367 VSS.n129 VSS.n102 12.3761
R368 VSS.n151 VSS.n102 12.3761
R369 VSS.n151 VSS.n101 12.3761
R370 VSS.n152 VSS.n100 12.3761
R371 VSS.n127 VSS.n99 12.3761
R372 VSS.n127 VSS.n98 12.3761
R373 VSS.n126 VSS.n97 12.3761
R374 VSS.n154 VSS.n96 12.3761
R375 VSS.n154 VSS.n95 12.3761
R376 VSS.n125 VSS.n71 12.3761
R377 VSS.n504 VSS.t44 12.076
R378 VSS.n478 VSS.t115 11.8925
R379 VSS.n366 VSS.t38 11.7116
R380 VSS.n134 VSS.t141 11.6482
R381 VSS.n128 VSS.t148 11.6482
R382 VSS.n523 VSS.n30 11.5239
R383 VSS.n226 VSS.t30 11.3213
R384 VSS.n479 VSS.n454 11.061
R385 VSS.t139 VSS.n118 10.9202
R386 VSS.t150 VSS.n97 10.9202
R387 VSS.t38 VSS.n262 10.4104
R388 VSS.n230 VSS.t42 10.4104
R389 VSS.t178 VSS.n119 9.82821
R390 VSS.n144 VSS.t179 9.82821
R391 VSS.t180 VSS.n116 9.82821
R392 VSS.n134 VSS.t181 9.82821
R393 VSS.n128 VSS.t0 9.82821
R394 VSS.t1 VSS.n99 9.82821
R395 VSS.n153 VSS.t2 9.82821
R396 VSS.t3 VSS.n96 9.82821
R397 VSS.n341 VSS.n48 9.76416
R398 VSS.n29 VSS.n48 9.75964
R399 VSS.n459 VSS.t33 9.50586
R400 VSS.t142 VSS.n112 9.46422
R401 VSS.t147 VSS.n103 9.46422
R402 VSS.n90 VSS.t163 9.19965
R403 VSS.t130 VSS.n57 9.19965
R404 VSS.n201 VSS.n62 9.18684
R405 VSS.n559 VSS.n89 9.18684
R406 VSS.n155 VSS.n121 9.10023
R407 VSS.n156 VSS.n71 9.10023
R408 VSS.n137 VSS.t138 8.73624
R409 VSS.n125 VSS.t153 8.73624
R410 VSS.n519 VSS.n515 8.5005
R411 VSS.n519 VSS.n215 8.5005
R412 VSS.n519 VSS.n510 8.5005
R413 VSS.n519 VSS.n218 8.5005
R414 VSS.n519 VSS.n506 8.5005
R415 VSS.n519 VSS.n219 8.5005
R416 VSS.n519 VSS.n504 8.5005
R417 VSS.n519 VSS.n222 8.5005
R418 VSS.n519 VSS.n491 8.5005
R419 VSS.n519 VSS.n226 8.5005
R420 VSS.n216 VSS.n214 8.5005
R421 VSS.n220 VSS.n214 8.5005
R422 VSS.n225 VSS.n214 8.5005
R423 VSS.n508 VSS.n214 8.5005
R424 VSS.n490 VSS.n214 8.5005
R425 VSS.n480 VSS.n214 8.5005
R426 VSS.n519 VSS.t40 8.5005
R427 VSS.n519 VSS.n454 8.5005
R428 VSS.n519 VSS.n228 8.5005
R429 VSS.n519 VSS.n452 8.5005
R430 VSS.n519 VSS.n229 8.5005
R431 VSS.n519 VSS.n450 8.5005
R432 VSS.n519 VSS.n230 8.5005
R433 VSS.n519 VSS.n449 8.5005
R434 VSS.n519 VSS.n231 8.5005
R435 VSS.n519 VSS.n448 8.5005
R436 VSS.n519 VSS.n232 8.5005
R437 VSS.n519 VSS.n447 8.5005
R438 VSS.n519 VSS.n213 8.5005
R439 VSS.n520 VSS.n519 8.5005
R440 VSS.n519 VSS.n233 8.5005
R441 VSS.n519 VSS.n446 8.5005
R442 VSS.n519 VSS.n234 8.5005
R443 VSS.n519 VSS.n443 8.5005
R444 VSS.n519 VSS.n235 8.5005
R445 VSS.n519 VSS.n440 8.5005
R446 VSS.n519 VSS.n236 8.5005
R447 VSS.n519 VSS.n437 8.5005
R448 VSS.n519 VSS.n239 8.5005
R449 VSS.n519 VSS.n434 8.5005
R450 VSS.n519 VSS.n240 8.5005
R451 VSS.n519 VSS.n431 8.5005
R452 VSS.n519 VSS.n241 8.5005
R453 VSS.n519 VSS.n428 8.5005
R454 VSS.n519 VSS.n242 8.5005
R455 VSS.n519 VSS.n425 8.5005
R456 VSS.n519 VSS.n243 8.5005
R457 VSS.n519 VSS.n422 8.5005
R458 VSS.n519 VSS.n244 8.5005
R459 VSS.n519 VSS.n419 8.5005
R460 VSS.n519 VSS.n245 8.5005
R461 VSS.n519 VSS.n416 8.5005
R462 VSS.n519 VSS.n246 8.5005
R463 VSS.n519 VSS.n247 8.5005
R464 VSS.n519 VSS.n411 8.5005
R465 VSS.n519 VSS.n248 8.5005
R466 VSS.n519 VSS.n408 8.5005
R467 VSS.n519 VSS.n249 8.5005
R468 VSS.n519 VSS.n405 8.5005
R469 VSS.n519 VSS.n250 8.5005
R470 VSS.n519 VSS.n402 8.5005
R471 VSS.n519 VSS.n251 8.5005
R472 VSS.n519 VSS.n399 8.5005
R473 VSS.n519 VSS.n252 8.5005
R474 VSS.n519 VSS.n396 8.5005
R475 VSS.n519 VSS.n253 8.5005
R476 VSS.n519 VSS.n393 8.5005
R477 VSS.n519 VSS.n254 8.5005
R478 VSS.n519 VSS.n387 8.5005
R479 VSS.n519 VSS.n255 8.5005
R480 VSS.n519 VSS.n384 8.5005
R481 VSS.n519 VSS.n256 8.5005
R482 VSS.n519 VSS.n381 8.5005
R483 VSS.n519 VSS.n257 8.5005
R484 VSS.n519 VSS.n378 8.5005
R485 VSS.n519 VSS.n258 8.5005
R486 VSS.n519 VSS.n375 8.5005
R487 VSS.n519 VSS.n259 8.5005
R488 VSS.n519 VSS.n372 8.5005
R489 VSS.n519 VSS.n260 8.5005
R490 VSS.n519 VSS.n369 8.5005
R491 VSS.n519 VSS.n261 8.5005
R492 VSS.n519 VSS.n366 8.5005
R493 VSS.n519 VSS.n262 8.5005
R494 VSS.n519 VSS.n364 8.5005
R495 VSS.n519 VSS.n263 8.5005
R496 VSS.n519 VSS.n361 8.5005
R497 VSS.n519 VSS.n264 8.5005
R498 VSS.n519 VSS.n358 8.5005
R499 VSS.n519 VSS.n265 8.5005
R500 VSS.n519 VSS.n355 8.5005
R501 VSS.n519 VSS.n266 8.5005
R502 VSS.n519 VSS.n352 8.5005
R503 VSS.n519 VSS.n267 8.5005
R504 VSS.n519 VSS.n349 8.5005
R505 VSS.n519 VSS.n268 8.5005
R506 VSS.n519 VSS.n346 8.5005
R507 VSS.n519 VSS.n269 8.5005
R508 VSS.n519 VSS.n329 8.5005
R509 VSS.n519 VSS.n270 8.5005
R510 VSS.n519 VSS.n326 8.5005
R511 VSS.n519 VSS.n271 8.5005
R512 VSS.n519 VSS.n323 8.5005
R513 VSS.n519 VSS.n272 8.5005
R514 VSS.n519 VSS.n320 8.5005
R515 VSS.n519 VSS.n273 8.5005
R516 VSS.n519 VSS.n318 8.5005
R517 VSS.n519 VSS.n274 8.5005
R518 VSS.n519 VSS.n315 8.5005
R519 VSS.n519 VSS.n275 8.5005
R520 VSS.n519 VSS.n312 8.5005
R521 VSS.n519 VSS.n276 8.5005
R522 VSS.n519 VSS.n309 8.5005
R523 VSS.n519 VSS.n277 8.5005
R524 VSS.n519 VSS.n306 8.5005
R525 VSS.n519 VSS.n278 8.5005
R526 VSS.n519 VSS.n304 8.5005
R527 VSS.n519 VSS.n279 8.5005
R528 VSS.n519 VSS.n301 8.5005
R529 VSS.n519 VSS.n280 8.5005
R530 VSS.n519 VSS.n298 8.5005
R531 VSS.n519 VSS.n281 8.5005
R532 VSS.n519 VSS.n295 8.5005
R533 VSS.n519 VSS.n282 8.5005
R534 VSS.n519 VSS.n292 8.5005
R535 VSS.n519 VSS.n283 8.5005
R536 VSS.n519 VSS.n289 8.5005
R537 VSS.n519 VSS.n284 8.5005
R538 VSS.n519 VSS.n286 8.5005
R539 VSS.n229 VSS.n214 8.5005
R540 VSS.n450 VSS.n214 8.5005
R541 VSS.n230 VSS.n214 8.5005
R542 VSS.n449 VSS.n214 8.5005
R543 VSS.n231 VSS.n214 8.5005
R544 VSS.n448 VSS.n214 8.5005
R545 VSS.n232 VSS.n214 8.5005
R546 VSS.n447 VSS.n214 8.5005
R547 VSS.n214 VSS.n213 8.5005
R548 VSS.n520 VSS.n214 8.5005
R549 VSS.n567 VSS.n44 2.41243
R550 VSS.n3 VSS.n2 0.0856528
R551 VSS.n18 VSS.n17 0.0305716
R552 VSS.n544 VSS.n537 8.49147
R553 VSS.n202 VSS.n56 8.30239
R554 VSS.n533 VSS.n55 8.30239
R555 VSS.n199 VSS.n65 8.30239
R556 VSS.n198 VSS.n66 8.30239
R557 VSS.n535 VSS.n53 8.30239
R558 VSS.n196 VSS.n68 8.30239
R559 VSS.n164 VSS.n78 8.30239
R560 VSS.n167 VSS.n81 8.30239
R561 VSS.n168 VSS.n82 8.30239
R562 VSS.n170 VSS.n84 8.30239
R563 VSS.n171 VSS.n85 8.30239
R564 VSS.n558 VSS.n87 8.30239
R565 VSS.n453 VSS.n228 7.89854
R566 VSS.n446 VSS.n444 7.89854
R567 VSS.n372 VSS.n370 7.89854
R568 VSS.n364 VSS.n362 7.89854
R569 VSS.n319 VSS.n273 7.89854
R570 VSS.n305 VSS.n278 7.89854
R571 VSS.n451 VSS.n228 7.89788
R572 VSS.n373 VSS.n258 7.89788
R573 VSS.n365 VSS.n261 7.89788
R574 VSS.n323 VSS.n322 7.89788
R575 VSS.n309 VSS.n308 7.89788
R576 VSS.n285 VSS.n284 7.89788
R577 VSS.n342 VSS.n341 7.76695
R578 VSS.n61 VSS.t124 7.69091
R579 VSS.t166 VSS.n93 7.69022
R580 VSS.n510 VSS.t108 7.54767
R581 VSS.n502 VSS.n500 7.31333
R582 VSS.n498 VSS.n497 7.31333
R583 VSS.n494 VSS.n493 7.31333
R584 VSS.n487 VSS.n485 7.31333
R585 VSS.n483 VSS.n481 7.31333
R586 VSS.n502 VSS.n501 7.31333
R587 VSS.n497 VSS.n496 7.31333
R588 VSS.n487 VSS.n486 7.31333
R589 VSS.n484 VSS.n483 7.31333
R590 VSS.n484 VSS.n482 7.31333
R591 VSS.n482 VSS.n227 7.31333
R592 VSS.n486 VSS.n227 7.31333
R593 VSS.n488 VSS.n223 7.31333
R594 VSS.n489 VSS.n488 7.31333
R595 VSS.n493 VSS.n492 7.31333
R596 VSS.n495 VSS.n494 7.31333
R597 VSS.n496 VSS.n495 7.31333
R598 VSS.n499 VSS.n498 7.31333
R599 VSS.n501 VSS.n499 7.31333
R600 VSS.n503 VSS.n221 7.31333
R601 VSS.n509 VSS.n507 7.31333
R602 VSS.n513 VSS.n512 7.31333
R603 VSS.n513 VSS.n511 7.31333
R604 VSS.n511 VSS.n217 7.31333
R605 VSS.n148 VSS.t144 7.28029
R606 VSS.n149 VSS.t145 7.28029
R607 VSS.n536 VSS.t171 6.98163
R608 VSS.n195 VSS.t173 6.98163
R609 VSS.n162 VSS.t8 6.98163
R610 VSS.n165 VSS.t10 6.98163
R611 VSS.n446 VSS.n445 6.70183
R612 VSS.n441 VSS.n234 6.70183
R613 VSS.n443 VSS.n442 6.70183
R614 VSS.n438 VSS.n235 6.70183
R615 VSS.n440 VSS.n439 6.70183
R616 VSS.n435 VSS.n236 6.70183
R617 VSS.n437 VSS.n436 6.70183
R618 VSS.n432 VSS.n239 6.70183
R619 VSS.n434 VSS.n433 6.70183
R620 VSS.n429 VSS.n240 6.70183
R621 VSS.n431 VSS.n430 6.70183
R622 VSS.n426 VSS.n241 6.70183
R623 VSS.n428 VSS.n427 6.70183
R624 VSS.n423 VSS.n242 6.70183
R625 VSS.n425 VSS.n424 6.70183
R626 VSS.n420 VSS.n243 6.70183
R627 VSS.n422 VSS.n421 6.70183
R628 VSS.n417 VSS.n244 6.70183
R629 VSS.n419 VSS.n418 6.70183
R630 VSS.n414 VSS.n245 6.70183
R631 VSS.n416 VSS.n415 6.70183
R632 VSS.n412 VSS.n246 6.70183
R633 VSS.n409 VSS.n247 6.70183
R634 VSS.n411 VSS.n410 6.70183
R635 VSS.n406 VSS.n248 6.70183
R636 VSS.n408 VSS.n407 6.70183
R637 VSS.n403 VSS.n249 6.70183
R638 VSS.n405 VSS.n404 6.70183
R639 VSS.n400 VSS.n250 6.70183
R640 VSS.n402 VSS.n401 6.70183
R641 VSS.n397 VSS.n251 6.70183
R642 VSS.n399 VSS.n398 6.70183
R643 VSS.n394 VSS.n252 6.70183
R644 VSS.n396 VSS.n395 6.70183
R645 VSS.n391 VSS.n253 6.70183
R646 VSS.n393 VSS.n392 6.70183
R647 VSS.n385 VSS.n254 6.70183
R648 VSS.n387 VSS.n386 6.70183
R649 VSS.n382 VSS.n255 6.70183
R650 VSS.n384 VSS.n383 6.70183
R651 VSS.n379 VSS.n256 6.70183
R652 VSS.n381 VSS.n380 6.70183
R653 VSS.n376 VSS.n257 6.70183
R654 VSS.n378 VSS.n377 6.70183
R655 VSS.n372 VSS.n371 6.70183
R656 VSS.n367 VSS.n260 6.70183
R657 VSS.n369 VSS.n368 6.70183
R658 VSS.n364 VSS.n363 6.70183
R659 VSS.n359 VSS.n263 6.70183
R660 VSS.n361 VSS.n360 6.70183
R661 VSS.n356 VSS.n264 6.70183
R662 VSS.n358 VSS.n357 6.70183
R663 VSS.n353 VSS.n265 6.70183
R664 VSS.n355 VSS.n354 6.70183
R665 VSS.n350 VSS.n266 6.70183
R666 VSS.n352 VSS.n351 6.70183
R667 VSS.n347 VSS.n267 6.70183
R668 VSS.n349 VSS.n348 6.70183
R669 VSS.n344 VSS.n268 6.70183
R670 VSS.n346 VSS.n345 6.70183
R671 VSS.n327 VSS.n269 6.70183
R672 VSS.n329 VSS.n328 6.70183
R673 VSS.n324 VSS.n270 6.70183
R674 VSS.n326 VSS.n325 6.70183
R675 VSS.n321 VSS.n271 6.70183
R676 VSS.n316 VSS.n273 6.70183
R677 VSS.n318 VSS.n317 6.70183
R678 VSS.n313 VSS.n274 6.70183
R679 VSS.n315 VSS.n314 6.70183
R680 VSS.n310 VSS.n275 6.70183
R681 VSS.n312 VSS.n311 6.70183
R682 VSS.n307 VSS.n276 6.70183
R683 VSS.n302 VSS.n278 6.70183
R684 VSS.n304 VSS.n303 6.70183
R685 VSS.n299 VSS.n279 6.70183
R686 VSS.n301 VSS.n300 6.70183
R687 VSS.n296 VSS.n280 6.70183
R688 VSS.n298 VSS.n297 6.70183
R689 VSS.n293 VSS.n281 6.70183
R690 VSS.n295 VSS.n294 6.70183
R691 VSS.n290 VSS.n282 6.70183
R692 VSS.n292 VSS.n291 6.70183
R693 VSS.n287 VSS.n283 6.70183
R694 VSS.n289 VSS.n288 6.70183
R695 VSS.t40 VSS.n413 6.70183
R696 VSS.n288 VSS.n284 6.70183
R697 VSS.n289 VSS.n287 6.70183
R698 VSS.n291 VSS.n283 6.70183
R699 VSS.n292 VSS.n290 6.70183
R700 VSS.n294 VSS.n282 6.70183
R701 VSS.n295 VSS.n293 6.70183
R702 VSS.n297 VSS.n281 6.70183
R703 VSS.n298 VSS.n296 6.70183
R704 VSS.n300 VSS.n280 6.70183
R705 VSS.n301 VSS.n299 6.70183
R706 VSS.n303 VSS.n279 6.70183
R707 VSS.n304 VSS.n302 6.70183
R708 VSS.n309 VSS.n307 6.70183
R709 VSS.n311 VSS.n276 6.70183
R710 VSS.n312 VSS.n310 6.70183
R711 VSS.n314 VSS.n275 6.70183
R712 VSS.n315 VSS.n313 6.70183
R713 VSS.n317 VSS.n274 6.70183
R714 VSS.n318 VSS.n316 6.70183
R715 VSS.n323 VSS.n321 6.70183
R716 VSS.n325 VSS.n271 6.70183
R717 VSS.n326 VSS.n324 6.70183
R718 VSS.n328 VSS.n270 6.70183
R719 VSS.n329 VSS.n327 6.70183
R720 VSS.n345 VSS.n269 6.70183
R721 VSS.n346 VSS.n344 6.70183
R722 VSS.n348 VSS.n268 6.70183
R723 VSS.n349 VSS.n347 6.70183
R724 VSS.n351 VSS.n267 6.70183
R725 VSS.n352 VSS.n350 6.70183
R726 VSS.n354 VSS.n266 6.70183
R727 VSS.n355 VSS.n353 6.70183
R728 VSS.n357 VSS.n265 6.70183
R729 VSS.n358 VSS.n356 6.70183
R730 VSS.n360 VSS.n264 6.70183
R731 VSS.n361 VSS.n359 6.70183
R732 VSS.n363 VSS.n263 6.70183
R733 VSS.n368 VSS.n261 6.70183
R734 VSS.n369 VSS.n367 6.70183
R735 VSS.n371 VSS.n260 6.70183
R736 VSS.n377 VSS.n258 6.70183
R737 VSS.n378 VSS.n376 6.70183
R738 VSS.n380 VSS.n257 6.70183
R739 VSS.n381 VSS.n379 6.70183
R740 VSS.n383 VSS.n256 6.70183
R741 VSS.n384 VSS.n382 6.70183
R742 VSS.n386 VSS.n255 6.70183
R743 VSS.n387 VSS.n385 6.70183
R744 VSS.n392 VSS.n254 6.70183
R745 VSS.n393 VSS.n391 6.70183
R746 VSS.n395 VSS.n253 6.70183
R747 VSS.n396 VSS.n394 6.70183
R748 VSS.n398 VSS.n252 6.70183
R749 VSS.n399 VSS.n397 6.70183
R750 VSS.n401 VSS.n251 6.70183
R751 VSS.n402 VSS.n400 6.70183
R752 VSS.n404 VSS.n250 6.70183
R753 VSS.n405 VSS.n403 6.70183
R754 VSS.n407 VSS.n249 6.70183
R755 VSS.n408 VSS.n406 6.70183
R756 VSS.n410 VSS.n248 6.70183
R757 VSS.n411 VSS.n409 6.70183
R758 VSS.n413 VSS.n247 6.70183
R759 VSS.t40 VSS.n412 6.70183
R760 VSS.n415 VSS.n246 6.70183
R761 VSS.n416 VSS.n414 6.70183
R762 VSS.n418 VSS.n245 6.70183
R763 VSS.n419 VSS.n417 6.70183
R764 VSS.n421 VSS.n244 6.70183
R765 VSS.n422 VSS.n420 6.70183
R766 VSS.n424 VSS.n243 6.70183
R767 VSS.n425 VSS.n423 6.70183
R768 VSS.n427 VSS.n242 6.70183
R769 VSS.n428 VSS.n426 6.70183
R770 VSS.n430 VSS.n241 6.70183
R771 VSS.n431 VSS.n429 6.70183
R772 VSS.n433 VSS.n240 6.70183
R773 VSS.n434 VSS.n432 6.70183
R774 VSS.n436 VSS.n239 6.70183
R775 VSS.n437 VSS.n435 6.70183
R776 VSS.n439 VSS.n236 6.70183
R777 VSS.n440 VSS.n438 6.70183
R778 VSS.n442 VSS.n235 6.70183
R779 VSS.n443 VSS.n441 6.70183
R780 VSS.n445 VSS.n234 6.70183
R781 VSS.t42 VSS.n209 6.50668
R782 VSS.n480 VSS.n479 6.41559
R783 VSS.n566 VSS.n565 6.41559
R784 VSS.n124 VSS.n72 6.41559
R785 VSS.n567 VSS.n62 6.17223
R786 VSS.n567 VSS.n89 6.17223
R787 VSS.n463 VSS.t121 6.07511
R788 VSS.n456 VSS.t70 6.07511
R789 VSS.n458 VSS.t31 5.93097
R790 VSS.n522 VSS.n212 5.66717
R791 VSS.n522 VSS.n521 5.66717
R792 VSS.n522 VSS.n203 5.66717
R793 VSS.n522 VSS.n211 5.66717
R794 VSS.n522 VSS.n204 5.66717
R795 VSS.n522 VSS.n210 5.66717
R796 VSS.n522 VSS.n205 5.66717
R797 VSS.n522 VSS.n209 5.66717
R798 VSS.n522 VSS.n206 5.66717
R799 VSS.n522 VSS.n208 5.66717
R800 VSS.n522 VSS.n207 5.66717
R801 VSS.n5 VSS.n19 0.0538158
R802 VSS.n23 VSS.n4 0.0543663
R803 VSS.n34 VSS.t117 3.20134
R804 VSS.n37 VSS.n18 2.81319
R805 VSS.n560 VSS.n12 5.65086
R806 VSS.n14 VSS.n13 0.0486537
R807 VSS.t108 VSS.n218 5.28352
R808 VSS.n471 VSS.n272 5.20544
R809 VSS.n233 VSS.n212 5.20544
R810 VSS.n521 VSS.n520 5.20544
R811 VSS.n213 VSS.n203 5.20544
R812 VSS.n447 VSS.n211 5.20544
R813 VSS.n232 VSS.n204 5.20544
R814 VSS.n448 VSS.n210 5.20544
R815 VSS.n231 VSS.n205 5.20544
R816 VSS.n449 VSS.n209 5.20544
R817 VSS.n230 VSS.n206 5.20544
R818 VSS.n450 VSS.n208 5.20544
R819 VSS.n229 VSS.n207 5.20544
R820 VSS.n412 VSS.n214 5.15059
R821 VSS.n445 VSS.n214 5.15059
R822 VSS.n441 VSS.n214 5.15059
R823 VSS.n442 VSS.n214 5.15059
R824 VSS.n438 VSS.n214 5.15059
R825 VSS.n439 VSS.n214 5.15059
R826 VSS.n435 VSS.n214 5.15059
R827 VSS.n436 VSS.n214 5.15059
R828 VSS.n432 VSS.n214 5.15059
R829 VSS.n433 VSS.n214 5.15059
R830 VSS.n429 VSS.n214 5.15059
R831 VSS.n430 VSS.n214 5.15059
R832 VSS.n426 VSS.n214 5.15059
R833 VSS.n427 VSS.n214 5.15059
R834 VSS.n423 VSS.n214 5.15059
R835 VSS.n424 VSS.n214 5.15059
R836 VSS.n420 VSS.n214 5.15059
R837 VSS.n421 VSS.n214 5.15059
R838 VSS.n417 VSS.n214 5.15059
R839 VSS.n418 VSS.n214 5.15059
R840 VSS.n414 VSS.n214 5.15059
R841 VSS.n415 VSS.n214 5.15059
R842 VSS.n413 VSS.n214 5.15059
R843 VSS.n409 VSS.n214 5.15059
R844 VSS.n410 VSS.n214 5.15059
R845 VSS.n406 VSS.n214 5.15059
R846 VSS.n407 VSS.n214 5.15059
R847 VSS.n403 VSS.n214 5.15059
R848 VSS.n404 VSS.n214 5.15059
R849 VSS.n400 VSS.n214 5.15059
R850 VSS.n401 VSS.n214 5.15059
R851 VSS.n397 VSS.n214 5.15059
R852 VSS.n398 VSS.n214 5.15059
R853 VSS.n394 VSS.n214 5.15059
R854 VSS.n395 VSS.n214 5.15059
R855 VSS.n391 VSS.n214 5.15059
R856 VSS.n392 VSS.n214 5.15059
R857 VSS.n385 VSS.n214 5.15059
R858 VSS.n386 VSS.n214 5.15059
R859 VSS.n382 VSS.n214 5.15059
R860 VSS.n383 VSS.n214 5.15059
R861 VSS.n379 VSS.n214 5.15059
R862 VSS.n380 VSS.n214 5.15059
R863 VSS.n376 VSS.n214 5.15059
R864 VSS.n377 VSS.n214 5.15059
R865 VSS.n371 VSS.n214 5.15059
R866 VSS.n367 VSS.n214 5.15059
R867 VSS.n368 VSS.n214 5.15059
R868 VSS.n363 VSS.n214 5.15059
R869 VSS.n359 VSS.n214 5.15059
R870 VSS.n360 VSS.n214 5.15059
R871 VSS.n356 VSS.n214 5.15059
R872 VSS.n357 VSS.n214 5.15059
R873 VSS.n353 VSS.n214 5.15059
R874 VSS.n354 VSS.n214 5.15059
R875 VSS.n350 VSS.n214 5.15059
R876 VSS.n351 VSS.n214 5.15059
R877 VSS.n347 VSS.n214 5.15059
R878 VSS.n348 VSS.n214 5.15059
R879 VSS.n344 VSS.n214 5.15059
R880 VSS.n345 VSS.n214 5.15059
R881 VSS.n327 VSS.n214 5.15059
R882 VSS.n328 VSS.n214 5.15059
R883 VSS.n324 VSS.n214 5.15059
R884 VSS.n325 VSS.n214 5.15059
R885 VSS.n321 VSS.n214 5.15059
R886 VSS.n316 VSS.n214 5.15059
R887 VSS.n317 VSS.n214 5.15059
R888 VSS.n313 VSS.n214 5.15059
R889 VSS.n314 VSS.n214 5.15059
R890 VSS.n310 VSS.n214 5.15059
R891 VSS.n311 VSS.n214 5.15059
R892 VSS.n307 VSS.n214 5.15059
R893 VSS.n302 VSS.n214 5.15059
R894 VSS.n303 VSS.n214 5.15059
R895 VSS.n299 VSS.n214 5.15059
R896 VSS.n300 VSS.n214 5.15059
R897 VSS.n296 VSS.n214 5.15059
R898 VSS.n297 VSS.n214 5.15059
R899 VSS.n293 VSS.n214 5.15059
R900 VSS.n294 VSS.n214 5.15059
R901 VSS.n290 VSS.n214 5.15059
R902 VSS.n291 VSS.n214 5.15059
R903 VSS.n287 VSS.n214 5.15059
R904 VSS.n288 VSS.n214 5.15059
R905 VSS.t144 VSS.n110 5.09635
R906 VSS.t145 VSS.n107 5.09635
R907 VSS.t20 VSS.n64 5.09484
R908 VSS.t26 VSS.n67 5.09484
R909 VSS.t27 VSS.n51 5.09484
R910 VSS.t14 VSS.n70 5.09484
R911 VSS.n141 VSS.t175 5.09484
R912 VSS.n566 VSS.t176 5.09484
R913 VSS.t5 VSS.n72 5.09484
R914 VSS.n158 VSS.t6 5.09484
R915 VSS.t75 VSS.n74 5.09484
R916 VSS.t79 VSS.n77 5.09484
R917 VSS.t82 VSS.n80 5.09484
R918 VSS.t88 VSS.n86 5.09484
R919 VSS.n201 VSS.t131 4.90616
R920 VSS.n559 VSS.t162 4.90616
R921 VSS.n555 VSS.n30 4.69693
R922 VSS.n341 VSS.n340 4.67815
R923 VSS.n200 VSS.n56 4.5288
R924 VSS.n534 VSS.n65 4.5288
R925 VSS.n198 VSS.n54 4.5288
R926 VSS.n197 VSS.n53 4.5288
R927 VSS.n536 VSS.n67 4.5288
R928 VSS.n195 VSS.n51 4.5288
R929 VSS.n194 VSS.n50 4.5288
R930 VSS.n543 VSS.n70 4.5288
R931 VSS.n159 VSS.n74 4.5288
R932 VSS.n160 VSS.n75 4.5288
R933 VSS.n162 VSS.n77 4.5288
R934 VSS.n165 VSS.n80 4.5288
R935 VSS.n166 VSS.n81 4.5288
R936 VSS.n168 VSS.n83 4.5288
R937 VSS.n169 VSS.n84 4.5288
R938 VSS.n557 VSS.n87 4.5288
R939 VSS.n551 VSS.n177 4.5005
R940 VSS.n550 VSS.n549 4.5005
R941 VSS.n548 VSS.n187 4.5005
R942 VSS.n37 VSS.n470 4.23094
R943 VSS.n37 VSS.n455 4.23094
R944 VSS.n37 VSS.n464 4.23094
R945 VSS.n560 VSS.n556 4.22744
R946 VSS.n544 VSS.n542 4.22744
R947 VSS.n544 VSS.n532 4.22744
R948 VSS.n560 VSS.n161 4.22725
R949 VSS.t128 VSS.n64 4.15144
R950 VSS.t132 VSS.n50 4.15144
R951 VSS.t156 VSS.n75 4.15144
R952 VSS.t160 VSS.n86 4.15144
R953 VSS.n478 VSS.n37 3.97732
R954 VSS.t23 VSS.t122 3.96276
R955 VSS.t80 VSS.t159 3.96276
R956 VSS.n454 VSS.n453 3.9496
R957 VSS.n444 VSS.n233 3.9496
R958 VSS.n370 VSS.n259 3.9496
R959 VSS.n362 VSS.n262 3.9496
R960 VSS.n320 VSS.n319 3.9496
R961 VSS.n306 VSS.n305 3.9496
R962 VSS.n286 VSS.n285 3.94944
R963 VSS.n308 VSS.n277 3.94944
R964 VSS.n322 VSS.n272 3.94944
R965 VSS.n366 VSS.n365 3.94944
R966 VSS.n375 VSS.n373 3.94944
R967 VSS.n452 VSS.n451 3.94944
R968 VSS.n524 VSS.n522 3.89224
R969 VSS.n217 VSS.n216 3.65691
R970 VSS.n509 VSS.n508 3.65691
R971 VSS.n221 VSS.n220 3.65691
R972 VSS.n490 VSS.n489 3.65691
R973 VSS.n225 VSS.n223 3.65691
R974 VSS.n481 VSS.n480 3.65691
R975 VSS.n512 VSS.n510 3.65691
R976 VSS.n506 VSS.n505 3.65691
R977 VSS.n492 VSS.n491 3.65691
R978 VSS.n514 VSS.n215 3.65691
R979 VSS.n507 VSS.n218 3.65691
R980 VSS.n485 VSS.n226 3.65691
R981 VSS.n500 VSS.n222 3.65691
R982 VSS.n504 VSS.n503 3.65691
R983 VSS.n505 VSS.n219 3.65691
R984 VSS.n515 VSS.n514 3.65691
R985 VSS.n547 VSS.n188 3.46952
R986 VSS.t131 VSS.n63 3.39673
R987 VSS.n538 VSS.t135 3.39673
R988 VSS.t136 VSS.n49 3.39673
R989 VSS.t155 VSS.n73 3.39673
R990 VSS.n163 VSS.t151 3.39673
R991 VSS.t162 VSS.n88 3.39673
R992 VSS.n567 VSS.n59 3.38773
R993 VSS.n567 VSS.n20 1.67295
R994 VSS.n44 VSS.n122 0.0574968
R995 VSS.n567 VSS.n92 3.38737
R996 VSS.n567 VSS.n8 3.38722
R997 VSS.n567 VSS.n10 3.38722
R998 VSS.n567 VSS.n3 0.95387
R999 VSS.n554 VSS.n32 3.3755
R1000 VSS.n547 VSS.n31 3.3755
R1001 VSS.n37 VSS.n466 3.37539
R1002 VSS.n37 VSS.n457 3.37539
R1003 VSS.n37 VSS.n461 3.37539
R1004 VSS.n202 VSS.t18 3.20805
R1005 VSS.n200 VSS.t20 3.20805
R1006 VSS.n199 VSS.t22 3.20805
R1007 VSS.n534 VSS.t23 3.20805
R1008 VSS.n535 VSS.t25 3.20805
R1009 VSS.n196 VSS.t16 3.20805
R1010 VSS.n539 VSS.t29 3.20805
R1011 VSS.n561 VSS.t77 3.20805
R1012 VSS.n164 VSS.t84 3.20805
R1013 VSS.n167 VSS.t85 3.20805
R1014 VSS.n169 VSS.t80 3.20805
R1015 VSS.n170 VSS.t86 3.20805
R1016 VSS.n557 VSS.t88 3.20805
R1017 VSS.n558 VSS.t89 3.20805
R1018 VSS.n465 VSS.t58 3.14902
R1019 VSS.n21 VSS.t112 3.14902
R1020 VSS.n17 VSS.t113 3.14902
R1021 VSS.n467 VSS.t105 3.14902
R1022 VSS.n469 VSS.t102 3.14902
R1023 VSS.n22 VSS.t116 3.14902
R1024 VSS.n453 VSS.n214 3.03556
R1025 VSS.n444 VSS.n214 3.03556
R1026 VSS.n370 VSS.n214 3.03556
R1027 VSS.n362 VSS.n214 3.03556
R1028 VSS.n319 VSS.n214 3.03556
R1029 VSS.n305 VSS.n214 3.03556
R1030 VSS.n451 VSS.n214 3.03537
R1031 VSS.n373 VSS.n214 3.03537
R1032 VSS.n365 VSS.n214 3.03537
R1033 VSS.n322 VSS.n214 3.03537
R1034 VSS.n308 VSS.n214 3.03537
R1035 VSS.n285 VSS.n214 3.03537
R1036 VSS.n565 VSS.t136 3.01937
R1037 VSS.n124 VSS.t155 3.01937
R1038 VSS.n175 VSS.n4 3.0005
R1039 VSS.n0 VSS.n10 3.0005
R1040 VSS.n174 VSS.n8 3.0005
R1041 VSS.n33 VSS.n5 3.0005
R1042 VSS.n524 VSS.n523 2.9309
R1043 VSS.n133 VSS.t142 2.91241
R1044 VSS.n129 VSS.t147 2.91241
R1045 VSS.n567 VSS.n19 1.86454
R1046 VSS.n567 VSS.n23 1.86421
R1047 VSS.n567 VSS.n106 2.81756
R1048 VSS.n37 VSS.n468 2.80331
R1049 VSS.n527 VSS.t19 2.79558
R1050 VSS.n190 VSS.t28 2.79551
R1051 VSS.n530 VSS.t21 2.79551
R1052 VSS.n193 VSS.t24 2.79551
R1053 VSS.n191 VSS.t17 2.79551
R1054 VSS.n180 VSS.t83 2.79551
R1055 VSS.n181 VSS.t81 2.79551
R1056 VSS.n182 VSS.t87 2.79551
R1057 VSS.n179 VSS.t78 2.79551
R1058 VSS.n173 VSS.t90 2.79543
R1059 VSS.n553 VSS.t76 2.79543
R1060 VSS.n189 VSS.t15 2.79543
R1061 VSS.n460 VSS.n459 2.69572
R1062 VSS.t172 VSS.t27 2.64201
R1063 VSS.t9 VSS.t79 2.64201
R1064 VSS.n567 VSS.n93 2.58141
R1065 VSS.n567 VSS.n90 2.58141
R1066 VSS.n567 VSS.n57 2.58141
R1067 VSS.n567 VSS.n61 2.58141
R1068 VSS.t177 VSS.n120 2.54843
R1069 VSS.n136 VSS.t178 2.54843
R1070 VSS.t179 VSS.n117 2.54843
R1071 VSS.n145 VSS.t180 2.54843
R1072 VSS.t181 VSS.n114 2.54843
R1073 VSS.t0 VSS.n101 2.54843
R1074 VSS.n152 VSS.t1 2.54843
R1075 VSS.t2 VSS.n98 2.54843
R1076 VSS.n126 VSS.t3 2.54843
R1077 VSS.t4 VSS.n95 2.54843
R1078 VSS.n183 VSS.n173 2.46314
R1079 VSS.n32 VSS.n553 2.4382
R1080 VSS.n31 VSS.n189 2.4382
R1081 VSS.n519 VSS.n217 2.42304
R1082 VSS.n519 VSS.n513 2.42304
R1083 VSS.n519 VSS.n509 2.42304
R1084 VSS.n519 VSS.n221 2.42304
R1085 VSS.n519 VSS.n502 2.42304
R1086 VSS.n519 VSS.n499 2.42304
R1087 VSS.n519 VSS.n497 2.42304
R1088 VSS.n519 VSS.n495 2.42304
R1089 VSS.n519 VSS.n493 2.42304
R1090 VSS.n519 VSS.n489 2.42304
R1091 VSS.n519 VSS.n223 2.42304
R1092 VSS.n519 VSS.n487 2.42304
R1093 VSS.n519 VSS.n227 2.42304
R1094 VSS.n519 VSS.n484 2.42304
R1095 VSS.n519 VSS.n481 2.42304
R1096 VSS.n514 VSS.n214 2.42304
R1097 VSS.n511 VSS.n214 2.42304
R1098 VSS.n507 VSS.n214 2.42304
R1099 VSS.n503 VSS.n214 2.42304
R1100 VSS.n501 VSS.n214 2.42304
R1101 VSS.n496 VSS.n214 2.42304
R1102 VSS.n486 VSS.n214 2.42304
R1103 VSS.n482 VSS.n214 2.42304
R1104 VSS.n512 VSS.n214 2.42304
R1105 VSS.n505 VSS.n214 2.42304
R1106 VSS.n500 VSS.n214 2.42304
R1107 VSS.n498 VSS.n214 2.42304
R1108 VSS.n494 VSS.n214 2.42304
R1109 VSS.n492 VSS.n214 2.42304
R1110 VSS.n488 VSS.n214 2.42304
R1111 VSS.n485 VSS.n214 2.42304
R1112 VSS.n483 VSS.n214 2.42304
R1113 VSS.n528 VSS.n527 2.31388
R1114 VSS.n31 VSS.n190 2.31337
R1115 VSS.n530 VSS.n529 2.31337
R1116 VSS.n193 VSS.n192 2.31337
R1117 VSS.n546 VSS.n191 2.31337
R1118 VSS.n186 VSS.n180 2.31337
R1119 VSS.n184 VSS.n181 2.31337
R1120 VSS.n183 VSS.n182 2.31337
R1121 VSS.n32 VSS.n179 2.31337
R1122 VSS.n340 VSS.t46 2.2117
R1123 VSS.n388 VSS.t92 2.21155
R1124 VSS.n516 VSS.t98 2.21132
R1125 VSS.n517 VSS.t100 2.21131
R1126 VSS.n237 VSS.t96 2.21129
R1127 VSS.n389 VSS.t94 2.21114
R1128 VSS.n332 VSS.t53 2.2111
R1129 VSS.n338 VSS.t47 2.21059
R1130 VSS.n342 VSS.t91 2.21042
R1131 VSS.n330 VSS.t55 2.21006
R1132 VSS.n334 VSS.t51 2.20998
R1133 VSS.n336 VSS.t49 2.2098
R1134 VSS.n338 VSS.t37 2.203
R1135 VSS.n332 VSS.t43 2.20292
R1136 VSS.n334 VSS.t41 2.20231
R1137 VSS.n388 VSS.t60 2.2019
R1138 VSS.n389 VSS.t62 2.20168
R1139 VSS.n516 VSS.t66 2.20158
R1140 VSS.n342 VSS.t59 2.20146
R1141 VSS.n330 VSS.t45 2.20145
R1142 VSS.n336 VSS.t39 2.2011
R1143 VSS.n517 VSS.t68 2.20096
R1144 VSS.n237 VSS.t64 2.20092
R1145 VSS.n340 VSS.t36 2.2007
R1146 VSS.n139 VSS.t132 2.07597
R1147 VSS.n562 VSS.t156 2.07597
R1148 VSS.n539 VSS.n140 1.88729
R1149 VSS.n543 VSS.n141 1.88729
R1150 VSS.n159 VSS.n158 1.88729
R1151 VSS.n563 VSS.n561 1.88729
R1152 VSS.n47 VSS.t109 170.041
R1153 VSS.n155 VSS.n142 1.69861
R1154 VSS.n157 VSS.n156 1.69861
R1155 VSS.n43 VSS.n42 0.769721
R1156 VSS.n25 VSS.n40 0.766889
R1157 VSS.n1 VSS.n25 0.77644
R1158 VSS.n26 VSS.n33 0.303484
R1159 VSS.n24 VSS.n26 0.291053
R1160 VSS.n27 VSS.n28 0.189906
R1161 VSS.n29 VSS 0.769639
R1162 VSS.n59 VSS.t125 1.62019
R1163 VSS.n92 VSS.t167 1.61888
R1164 VSS.t30 VSS.n225 1.50993
R1165 VSS.n105 VSS.t146 1.47429
R1166 VSS.n91 VSS.t164 1.47408
R1167 VSS.n4 VSS.t158 1.47389
R1168 VSS.n9 VSS.t154 1.47382
R1169 VSS.n10 VSS.t149 1.47378
R1170 VSS.n5 VSS.t129 1.47367
R1171 VSS.n6 VSS.t143 1.47367
R1172 VSS.n5 VSS.t123 1.47359
R1173 VSS.n7 VSS.t137 1.47359
R1174 VSS.n2 VSS.t152 1.47341
R1175 VSS.n58 VSS.t127 1.47333
R1176 VSS.n4 VSS.t161 1.47324
R1177 VSS.n122 VSS.t133 1.47305
R1178 VSS.n8 VSS.t140 1.47305
R1179 VSS.n144 VSS.t139 1.45646
R1180 VSS.n153 VSS.t150 1.45646
R1181 VSS.n139 VSS.n45 1.3933
R1182 VSS.t18 VSS.n63 1.32125
R1183 VSS.t22 VSS.n55 1.32125
R1184 VSS.t25 VSS.n66 1.32125
R1185 VSS.t170 VSS.t134 1.32125
R1186 VSS.t134 VSS.t26 1.32125
R1187 VSS.t171 VSS.n52 1.32125
R1188 VSS.t16 VSS.n52 1.32125
R1189 VSS.t173 VSS.n69 1.32125
R1190 VSS.t29 VSS.n69 1.32125
R1191 VSS.t174 VSS.n138 1.32125
R1192 VSS.n138 VSS.t14 1.32125
R1193 VSS.t175 VSS.n49 1.32125
R1194 VSS.n142 VSS.t176 1.32125
R1195 VSS.n157 VSS.t5 1.32125
R1196 VSS.t6 VSS.n73 1.32125
R1197 VSS.n123 VSS.t75 1.32125
R1198 VSS.t7 VSS.n123 1.32125
R1199 VSS.t77 VSS.n76 1.32125
R1200 VSS.t8 VSS.n76 1.32125
R1201 VSS.t84 VSS.n79 1.32125
R1202 VSS.t10 VSS.n79 1.32125
R1203 VSS.t157 VSS.t82 1.32125
R1204 VSS.t11 VSS.t157 1.32125
R1205 VSS.t85 VSS.n82 1.32125
R1206 VSS.t86 VSS.n85 1.32125
R1207 VSS.t89 VSS.n88 1.32125
R1208 VSS.t35 VSS.n277 1.30174
R1209 VSS.t122 VSS.n54 1.13258
R1210 VSS.t135 VSS.n68 1.13258
R1211 VSS.t151 VSS.n78 1.13258
R1212 VSS.t159 VSS.n83 1.13258
R1213 VSS.n525 VSS.n188 1.1255
R1214 VSS.t138 VSS.t177 1.09247
R1215 VSS.t153 VSS.t4 1.09247
R1216 VSS.n523 VSS.n45 1.04917
R1217 VSS.n46 VSS.n562 2.23894
R1218 VSS.n458 VSS.n48 0.762586
R1219 VSS.t44 VSS.n222 0.755217
R1220 VSS.n545 VSS.n16 0.7505
R1221 VSS.n185 VSS.n11 0.7505
R1222 VSS.t141 VSS.n115 0.728479
R1223 VSS.t148 VSS.n100 0.728479
R1224 VSS.n459 VSS.n458 0.674942
R1225 VSS.n197 VSS.t170 0.566538
R1226 VSS.n538 VSS.t172 0.566538
R1227 VSS.n194 VSS.t174 0.566538
R1228 VSS.n160 VSS.t7 0.566538
R1229 VSS.n163 VSS.t9 0.566538
R1230 VSS.n166 VSS.t11 0.566538
R1231 VSS.n540 VSS.n190 0.561603
R1232 VSS.n531 VSS.n530 0.561603
R1233 VSS.n13 VSS.n193 0.561603
R1234 VSS.n15 VSS.n191 0.561603
R1235 VSS.n180 VSS.n36 0.561603
R1236 VSS.n181 VSS.n12 0.561603
R1237 VSS.n182 VSS.n172 0.561603
R1238 VSS.n179 VSS.n178 0.561603
R1239 VSS.n555 VSS.n173 0.56142
R1240 VSS.n553 VSS.n552 0.56142
R1241 VSS.n541 VSS.n189 0.56142
R1242 VSS.n527 VSS.n526 0.56108
R1243 VSS.n533 VSS.t128 0.377858
R1244 VSS.n171 VSS.t160 0.377858
R1245 VSS.n176 VSS.n41 0.353904
R1246 VSS.n550 VSS.n187 0.337235
R1247 VSS.n551 VSS.n550 0.337235
R1248 VSS.n374 VSS.n259 0.325809
R1249 VSS.n42 VSS.n41 0.318978
R1250 VSS.n564 VSS.n46 0.255694
R1251 VSS.n29 VSS.n28 0.765102
R1252 VSS.n28 VSS.n26 0.956287
R1253 VSS.n40 VSS.n43 0.504324
R1254 VSS.n474 VSS.n37 0.245325
R1255 VSS.n338 VSS.n337 0.243424
R1256 VSS.n390 VSS.n388 0.243424
R1257 VSS.n343 VSS.n342 0.242716
R1258 VSS.n340 VSS.n339 0.242681
R1259 VSS.n174 VSS.n33 0.2425
R1260 VSS.n175 VSS.n0 0.2425
R1261 VSS.n334 VSS.n333 0.24245
R1262 VSS.n237 VSS.n224 0.24245
R1263 VSS.n541 VSS.n187 0.241827
R1264 VSS.n552 VSS.n551 0.241827
R1265 VSS.n336 VSS.n335 0.240796
R1266 VSS.n389 VSS.n238 0.240796
R1267 VSS.n332 VSS.n331 0.239822
R1268 VSS.n518 VSS.n516 0.239822
R1269 VSS.n333 VSS.n332 0.227974
R1270 VSS.n516 VSS.n224 0.227974
R1271 VSS.n337 VSS.n336 0.227001
R1272 VSS.n390 VSS.n389 0.227001
R1273 VSS.n331 VSS.n330 0.225646
R1274 VSS.n518 VSS.n517 0.225646
R1275 VSS.n335 VSS.n334 0.224672
R1276 VSS.n238 VSS.n237 0.224672
R1277 VSS.n339 VSS.n338 0.223727
R1278 VSS.n388 VSS.n343 0.223715
R1279 VSS.n1 VSS.n0 0.104141
R1280 VSS.n519 VSS.n224 0.218846
R1281 VSS.n333 VSS.n214 0.218846
R1282 VSS.n519 VSS.n390 0.218846
R1283 VSS.n337 VSS.n214 0.218846
R1284 VSS.n519 VSS.n518 0.208386
R1285 VSS.n331 VSS.n214 0.208386
R1286 VSS.n519 VSS.n238 0.208386
R1287 VSS.n335 VSS.n214 0.208386
R1288 VSS.n519 VSS.n343 0.208371
R1289 VSS.n339 VSS.n214 0.20836
R1290 VSS.n140 VSS.n139 0.189179
R1291 VSS.n563 VSS.n562 0.189179
R1292 VSS.n529 VSS.n528 0.1501
R1293 VSS.n529 VSS.n192 0.1501
R1294 VSS.n184 VSS.n183 0.1501
R1295 VSS.t71 VSS.t73 0.143158
R1296 VSS.n30 VSS.n554 0.113321
R1297 VSS.n528 VSS.n188 0.106994
R1298 VSS.n468 VSS.n467 0.0927224
R1299 VSS.n469 VSS.n468 0.0891245
R1300 VSS.n526 VSS.n525 0.0846837
R1301 VSS.n457 VSS.n456 0.0814472
R1302 VSS.n464 VSS.n463 0.0794206
R1303 VSS.n465 VSS.n455 0.0784641
R1304 VSS.n531 VSS.n13 0.0779076
R1305 VSS.n462 VSS.n461 0.0776211
R1306 VSS.n172 VSS.n12 0.0775723
R1307 VSS.n470 VSS.n469 0.0773061
R1308 VSS.n176 VSS.n43 0.194298
R1309 VSS.n545 VSS.n192 0.0753
R1310 VSS.n546 VSS.n545 0.0753
R1311 VSS.n186 VSS.n185 0.0753
R1312 VSS.n185 VSS.n184 0.0753
R1313 VSS.n461 VSS.n460 0.0750054
R1314 VSS.n464 VSS.n462 0.0725235
R1315 VSS.n466 VSS.n465 0.0721359
R1316 VSS.n463 VSS.n457 0.0711793
R1317 VSS.n456 VSS.n455 0.0686974
R1318 VSS.n466 VSS.n21 0.0675776
R1319 VSS.n40 VSS.n175 0.189244
R1320 VSS.n32 VSS.n186 0.175033
R1321 VSS.n31 VSS.n546 0.175033
R1322 VSS.n3 VSS.n9 0.104022
R1323 VSS.n12 VSS.n11 0.0969892
R1324 VSS.n16 VSS.n14 0.0486893
R1325 VSS.n467 VSS.n17 0.0951565
R1326 VSS.n44 VSS.n5 0.0937229
R1327 VSS.n4 VSS.n2 0.0936293
R1328 VSS.n39 VSS.n37 0.0183207
R1329 VSS.n477 VSS.n37 0.0617935
R1330 VSS.n38 VSS.n37 0.0278401
R1331 VSS.n476 VSS.n37 0.0617935
R1332 VSS.n475 VSS.n37 0.0617935
R1333 VSS.n473 VSS.n37 0.0617935
R1334 VSS.n470 VSS.n22 0.061725
R1335 VSS.n11 VSS.n36 0.0596436
R1336 VSS.n556 VSS.n555 0.0594056
R1337 VSS.n542 VSS.n540 0.0594056
R1338 VSS.n532 VSS.n526 0.0594056
R1339 VSS.n552 VSS.n161 0.059027
R1340 VSS.n178 VSS.n161 0.059027
R1341 VSS.n532 VSS.n531 0.0586497
R1342 VSS.n542 VSS.n541 0.0586497
R1343 VSS.n556 VSS.n172 0.0586497
R1344 VSS.t73 VSS.n176 0.0585075
R1345 VSS.n537 VSS.n15 0.0582235
R1346 VSS.n540 VSS.n537 0.0582235
R1347 VSS.n178 VSS.n35 0.0932316
R1348 VSS.n30 VSS.t71 0.0894317
R1349 VSS.n34 VSS.n22 0.0767479
R1350 VSS.n27 VSS 0.0594637
R1351 VSS.n27 VSS.n24 0.0594637
R1352 VSS.n25 VSS.n24 0.0594637
R1353 VSS.n42 VSS.n25 0.0594637
R1354 VSS.n36 VSS.n35 0.0239808
R1355 VSS.n548 VSS.n547 0.0569103
R1356 VSS.n549 VSS.n548 0.0569103
R1357 VSS.n549 VSS.n177 0.0569103
R1358 VSS.n554 VSS.n177 0.0569103
R1359 VSS.n525 VSS.n524 0.0566224
R1360 VSS.n105 VSS.n10 0.0523614
R1361 VSS.n8 VSS.n6 0.0523614
R1362 VSS.n92 VSS.n91 0.051203
R1363 VSS.n59 VSS.n58 0.050601
R1364 VSS.n58 VSS.n19 0.0758859
R1365 VSS.n20 VSS.n122 0.091946
R1366 VSS.n91 VSS.n23 0.0749793
R1367 VSS.n6 VSS.n106 0.0474111
R1368 VSS.n10 VSS.n9 0.0909208
R1369 VSS.n8 VSS.n7 0.0909208
R1370 VSS.n16 VSS.n15 0.0596436
R1371 VSS.n106 VSS.n105 0.047074
R1372 VSS.n1 VSS.n174 0.148141
R1373 a_20954_346.n0 a_20954_346.t0 4.85847
R1374 a_20954_346.t15 a_20954_346.n2 4.83761
R1375 a_20954_346.n2 a_20954_346.t14 4.83657
R1376 a_20954_346.n2 a_20954_346.t13 4.83657
R1377 a_20954_346.n2 a_20954_346.t12 4.83657
R1378 a_20954_346.n1 a_20954_346.t11 4.83657
R1379 a_20954_346.n1 a_20954_346.t10 4.83657
R1380 a_20954_346.n1 a_20954_346.t9 4.83657
R1381 a_20954_346.n1 a_20954_346.t8 4.83657
R1382 a_20954_346.n1 a_20954_346.t7 4.83657
R1383 a_20954_346.n1 a_20954_346.t6 4.83657
R1384 a_20954_346.n1 a_20954_346.t5 4.83657
R1385 a_20954_346.n1 a_20954_346.t4 4.83657
R1386 a_20954_346.n0 a_20954_346.t3 4.83657
R1387 a_20954_346.n0 a_20954_346.t2 4.83657
R1388 a_20954_346.n0 a_20954_346.t1 4.83657
R1389 a_20954_346.n2 a_20954_346.t16 0.895788
R1390 a_20954_346.n1 a_20954_346.n0 0.175641
R1391 a_20954_346.n2 a_20954_346.n1 0.131856
R1392 a_11798_1180.n4 a_11798_1180.t25 3.17099
R1393 a_11798_1180.n5 a_11798_1180.t3 3.17099
R1394 a_11798_1180.n10 a_11798_1180.t0 2.79558
R1395 a_11798_1180.n32 a_11798_1180.t23 2.79551
R1396 a_11798_1180.n23 a_11798_1180.t22 2.79551
R1397 a_11798_1180.n24 a_11798_1180.t24 2.79551
R1398 a_11798_1180.n25 a_11798_1180.t26 2.79551
R1399 a_11798_1180.n26 a_11798_1180.t27 2.79551
R1400 a_11798_1180.n19 a_11798_1180.t1 2.79551
R1401 a_11798_1180.n11 a_11798_1180.t2 2.79551
R1402 a_11798_1180.n12 a_11798_1180.t4 2.79551
R1403 a_11798_1180.n13 a_11798_1180.t5 2.79551
R1404 a_11798_1180.n27 a_11798_1180.t28 2.79543
R1405 a_11798_1180.n14 a_11798_1180.t6 2.79543
R1406 a_11798_1180.t21 a_11798_1180.n8 2.61386
R1407 a_11798_1180.n1 a_11798_1180.t7 2.61061
R1408 a_11798_1180.n2 a_11798_1180.t12 2.56233
R1409 a_11798_1180.n2 a_11798_1180.t15 2.56207
R1410 a_11798_1180.n1 a_11798_1180.t9 2.56207
R1411 a_11798_1180.n8 a_11798_1180.t19 2.56174
R1412 a_11798_1180.n7 a_11798_1180.t18 2.56174
R1413 a_11798_1180.n2 a_11798_1180.t14 2.56174
R1414 a_11798_1180.n2 a_11798_1180.t13 2.56174
R1415 a_11798_1180.n7 a_11798_1180.t17 2.56173
R1416 a_11798_1180.n1 a_11798_1180.t8 2.56173
R1417 a_11798_1180.n2 a_11798_1180.t11 2.56173
R1418 a_11798_1180.n1 a_11798_1180.t10 2.56173
R1419 a_11798_1180.n2 a_11798_1180.t16 2.56147
R1420 a_11798_1180.n8 a_11798_1180.t20 2.56143
R1421 a_11798_1180.n20 a_11798_1180.n10 2.36008
R1422 a_11798_1180.n27 a_11798_1180.n21 2.35974
R1423 a_11798_1180.n14 a_11798_1180.n0 2.35974
R1424 a_11798_1180.n33 a_11798_1180.n23 2.35957
R1425 a_11798_1180.n33 a_11798_1180.n32 2.33977
R1426 a_11798_1180.n26 a_11798_1180.n21 2.33977
R1427 a_11798_1180.n20 a_11798_1180.n19 2.33977
R1428 a_11798_1180.n13 a_11798_1180.n0 2.33977
R1429 a_11798_1180.n24 a_11798_1180.n22 2.31337
R1430 a_11798_1180.n25 a_11798_1180.n3 2.31337
R1431 a_11798_1180.n11 a_11798_1180.n9 2.31337
R1432 a_11798_1180.n12 a_11798_1180.n0 2.31337
R1433 a_11798_1180.n31 a_11798_1180.n23 0.748603
R1434 a_11798_1180.n28 a_11798_1180.n27 0.74842
R1435 a_11798_1180.n15 a_11798_1180.n14 0.74842
R1436 a_11798_1180.n18 a_11798_1180.n10 0.74808
R1437 a_11798_1180.n32 a_11798_1180.n31 0.561603
R1438 a_11798_1180.n30 a_11798_1180.n24 0.561603
R1439 a_11798_1180.n29 a_11798_1180.n25 0.561603
R1440 a_11798_1180.n28 a_11798_1180.n26 0.561603
R1441 a_11798_1180.n19 a_11798_1180.n18 0.561603
R1442 a_11798_1180.n17 a_11798_1180.n11 0.561603
R1443 a_11798_1180.n16 a_11798_1180.n12 0.561603
R1444 a_11798_1180.n15 a_11798_1180.n13 0.561603
R1445 a_11798_1180.n4 a_11798_1180.n3 0.401975
R1446 a_11798_1180.n5 a_11798_1180.n0 0.401975
R1447 a_11798_1180.n5 a_11798_1180.n16 0.284179
R1448 a_11798_1180.n4 a_11798_1180.n29 0.284179
R1449 a_11798_1180.n1 a_11798_1180.n33 0.25306
R1450 a_11798_1180.n6 a_11798_1180.n21 0.0449208
R1451 a_11798_1180.n2 a_11798_1180.n20 0.25306
R1452 a_11798_1180.n2 a_11798_1180.n6 0.203345
R1453 a_11798_1180.n2 a_11798_1180.n1 0.196551
R1454 a_11798_1180.n7 a_11798_1180.n0 0.194161
R1455 a_11798_1180.n31 a_11798_1180.n30 0.1875
R1456 a_11798_1180.n30 a_11798_1180.n4 0.1875
R1457 a_11798_1180.n29 a_11798_1180.n28 0.1875
R1458 a_11798_1180.n18 a_11798_1180.n17 0.1875
R1459 a_11798_1180.n17 a_11798_1180.n5 0.1875
R1460 a_11798_1180.n16 a_11798_1180.n15 0.1875
R1461 a_11798_1180.n9 a_11798_1180.n0 0.153033
R1462 a_11798_1180.n22 a_11798_1180.n3 0.153033
R1463 a_11798_1180.n8 a_11798_1180.n7 0.147538
R1464 a_11798_1180.n7 a_11798_1180.n2 0.147538
R1465 a_11798_1180.n33 a_11798_1180.n22 0.106833
R1466 a_11798_1180.n3 a_11798_1180.n6 0.0449208
R1467 a_11798_1180.n20 a_11798_1180.n9 0.106833
R1468 a_5060_3002.n0 a_5060_3002.t1 53.6608
R1469 a_5060_3002.n3 a_5060_3002.t0 29.2688
R1470 a_5060_3002.n2 a_5060_3002.t5 24.2693
R1471 a_5060_3002.n1 a_5060_3002.t2 24.2693
R1472 a_5060_3002.t4 a_5060_3002.n3 15.6064
R1473 a_5060_3002.n0 a_5060_3002.t3 9.21754
R1474 a_5060_3002.n3 a_5060_3002.n2 1.7693
R1475 a_5060_3002.n2 a_5060_3002.n1 0.543167
R1476 a_5060_3002.n1 a_5060_3002.n0 0.320233
R1477 a_5560_3922.n0 a_5560_3922.t0 27.72
R1478 a_5560_3922.n0 a_5560_3922.t1 24.1197
R1479 a_5560_3922.t2 a_5560_3922.n0 9.38813
R1480 a_5560_5708.n0 a_5560_5708.t2 55.2712
R1481 a_5560_5708.n0 a_5560_5708.t1 27.8842
R1482 a_5560_5708.t0 a_5560_5708.n0 7.50485
R1483 a_5060_5708.n0 a_5060_5708.t1 34.3045
R1484 a_5060_5708.t0 a_5060_5708.n0 5.85564
R1485 a_5060_5708.t0 a_5060_5708.n0 5.85498
R1486 a_6568_6136.n2 a_6568_6136.t0 19.9393
R1487 a_6568_6136.n0 a_6568_6136.t4 19.6783
R1488 a_6568_6136.n1 a_6568_6136.t2 17.974
R1489 a_6568_6136.n2 a_6568_6136.n1 5.04317
R1490 a_6568_6136.n0 a_6568_6136.t3 4.81727
R1491 a_6568_6136.n1 a_6568_6136.n0 4.76157
R1492 a_6568_6136.t1 a_6568_6136.n2 3.15445
R1493 a_5948_4416.n0 a_5948_4416.t2 30.2902
R1494 a_5948_4416.n0 a_5948_4416.t0 27.2706
R1495 a_5948_4416.t1 a_5948_4416.n0 11.5346
R1496 vco_feed_0.en_b.n0 vco_feed_0.en_b.t1 27.1774
R1497 vco_feed_0.en_b.n4 vco_feed_0.en_b.t6 24.9608
R1498 vco_feed_0.en_b.n3 vco_feed_0.en_b.t3 24.8442
R1499 vco_feed_0.en_b.n1 vco_feed_0.en_b.t7 20.7725
R1500 vco_feed_0.en_b.n1 vco_feed_0.en_b.t5 20.4909
R1501 vco_feed_0.en_b.n0 vco_feed_0.en_b.t4 20.4287
R1502 vco_feed_0.en_b.n0 vco_feed_0.en_b.t0 12.1418
R1503 vco_feed_0.en_b vco_feed_0.en_b.t2 5.74905
R1504 vco_feed_0.en_b.n2 vco_feed_0.en_b.n1 5.30277
R1505 vco_feed_0.en_b.n2 vco_feed_0.en_b.n0 4.5269
R1506 vco_feed_0.en_b vco_feed_0.en_b.n4 2.33103
R1507 vco_feed_0.en_b.n3 vco_feed_0.en_b.n2 0.562233
R1508 vco_feed_0.en_b.n4 vco_feed_0.en_b.n3 0.469833
R1509 vco_feed_0.vdd_core.n15 vco_feed_0.vdd_core.t11 6.57599
R1510 vco_feed_0.vdd_core.n25 vco_feed_0.vdd_core.t14 6.57599
R1511 vco_feed_0.vdd_core.n27 vco_feed_0.vdd_core.t22 6.5301
R1512 vco_feed_0.vdd_core.n17 vco_feed_0.vdd_core.t7 6.52949
R1513 vco_feed_0.vdd_core.n17 vco_feed_0.vdd_core.t5 6.52949
R1514 vco_feed_0.vdd_core.n15 vco_feed_0.vdd_core.t9 6.52949
R1515 vco_feed_0.vdd_core.n17 vco_feed_0.vdd_core.t3 6.52949
R1516 vco_feed_0.vdd_core.n27 vco_feed_0.vdd_core.t20 6.52949
R1517 vco_feed_0.vdd_core.n27 vco_feed_0.vdd_core.t18 6.52949
R1518 vco_feed_0.vdd_core.n25 vco_feed_0.vdd_core.t16 6.52949
R1519 vco_feed_0.vdd_core.n1 vco_feed_0.vdd_core.t13 4.1356
R1520 vco_feed_0.vdd_core.n0 vco_feed_0.vdd_core.t2 3.9789
R1521 vco_feed_0.vdd_core.n12 vco_feed_0.vdd_core.t27 3.51966
R1522 vco_feed_0.vdd_core.n13 vco_feed_0.vdd_core.t29 3.51966
R1523 vco_feed_0.vdd_core.n16 vco_feed_0.vdd_core.t31 3.51966
R1524 vco_feed_0.vdd_core.n30 vco_feed_0.vdd_core.t28 3.4996
R1525 vco_feed_0.vdd_core.n3 vco_feed_0.vdd_core.t30 3.4996
R1526 vco_feed_0.vdd_core.n26 vco_feed_0.vdd_core.t32 3.4996
R1527 vco_feed_0.vdd_core vco_feed_0.vdd_core.n22 1.55887
R1528 vco_feed_0.vdd_core.n7 vco_feed_0.vdd_core.n23 1.5005
R1529 vco_feed_0.vdd_core.n8 vco_feed_0.vdd_core.n21 1.5005
R1530 vco_feed_0.vdd_core vco_feed_0.vdd_core.n2 0.838
R1531 vco_feed_0.vdd_core.n18 vco_feed_0.vdd_core.n1 0.778589
R1532 vco_feed_0.vdd_core.n28 vco_feed_0.vdd_core.n0 0.778576
R1533 vco_feed_0.vdd_core.n24 vco_feed_0.vdd_core.n7 0.76851
R1534 vco_feed_0.vdd_core.n8 vco_feed_0.vdd_core.n5 0.767758
R1535 vco_feed_0.vdd_core.n1 vco_feed_0.vdd_core.n5 0.751792
R1536 vco_feed_0.vdd_core.n0 vco_feed_0.vdd_core.n24 0.751041
R1537 vco_feed_0.vdd_core.n0 vco_feed_0.vdd_core.n10 0.741729
R1538 vco_feed_0.vdd_core.n1 vco_feed_0.vdd_core.n4 0.741729
R1539 vco_feed_0.vdd_core.n2 vco_feed_0.vdd_core.t24 0.733642
R1540 vco_feed_0.vdd_core.n3 vco_feed_0.vdd_core.n29 0.703434
R1541 vco_feed_0.vdd_core.n19 vco_feed_0.vdd_core.n14 0.703434
R1542 vco_feed_0.vdd_core.n7 vco_feed_0.vdd_core.n6 0.498551
R1543 vco_feed_0.vdd_core.n8 vco_feed_0.vdd_core.n11 0.498121
R1544 vco_feed_0.vdd_core.n2 vco_feed_0.vdd_core 0.461569
R1545 vco_feed_0.vdd_core.n17 vco_feed_0.vdd_core.n16 0.33314
R1546 vco_feed_0.vdd_core.n26 vco_feed_0.vdd_core.n3 0.29442
R1547 vco_feed_0.vdd_core.n13 vco_feed_0.vdd_core.n12 0.29442
R1548 vco_feed_0.vdd_core.n2 vco_feed_0.vdd_core 0.197117
R1549 vco_feed_0.vdd_core.n27 vco_feed_0.vdd_core.n26 0.175092
R1550 vco_feed_0.vdd_core.n14 vco_feed_0.vdd_core.n13 0.14834
R1551 vco_feed_0.vdd_core.n16 vco_feed_0.vdd_core.n14 0.14658
R1552 vco_feed_0.vdd_core.n22 vco_feed_0.vdd_core 0.08575
R1553 vco_feed_0.vdd_core.n4 vco_feed_0.vdd_core.n11 0.0703453
R1554 vco_feed_0.vdd_core.n10 vco_feed_0.vdd_core.n6 0.0703239
R1555 vco_feed_0.vdd_core.n29 vco_feed_0.vdd_core.n28 0.0593402
R1556 vco_feed_0.vdd_core.n19 vco_feed_0.vdd_core.n18 0.0593402
R1557 vco_feed_0.vdd_core vco_feed_0.vdd_core.t0 0.0484286
R1558 vco_feed_0.vdd_core vco_feed_0.vdd_core.t25 0.0484286
R1559 vco_feed_0.vdd_core.n17 vco_feed_0.vdd_core.n15 0.0378886
R1560 vco_feed_0.vdd_core.n27 vco_feed_0.vdd_core.n25 0.0378886
R1561 vco_feed_0.vdd_core.n24 vco_feed_0.vdd_core.n9 0.0338276
R1562 vco_feed_0.vdd_core.n20 vco_feed_0.vdd_core.n5 0.0334354
R1563 vco_feed_0.vdd_core.n28 vco_feed_0.vdd_core.n6 0.026738
R1564 vco_feed_0.vdd_core.n18 vco_feed_0.vdd_core.n11 0.0267154
R1565 vco_feed_0.vdd_core.n29 vco_feed_0.vdd_core.n9 0.020388
R1566 vco_feed_0.vdd_core.n20 vco_feed_0.vdd_core.n19 0.020388
R1567 vco_feed_0.vdd_core.n23 vco_feed_0.vdd_core.n10 0.0195413
R1568 vco_feed_0.vdd_core.n21 vco_feed_0.vdd_core.n4 0.0195413
R1569 vco_feed_0.vdd_core vco_feed_0.vdd_core.n30 0.0181
R1570 vco_feed_0.vdd_core.n12 vco_feed_0.vdd_core 0.0181
R1571 vco_feed_0.vdd_core.n21 vco_feed_0.vdd_core.n20 0.0149711
R1572 vco_feed_0.vdd_core.n23 vco_feed_0.vdd_core.n9 0.01458
R1573 vco_feed_0.vdd_core vco_feed_0.vdd_core.n22 1.16546
R1574 vco_feed_0.vdd_core.n30 vco_feed_0.vdd_core.n3 0.29442
R1575 vco_feed_0.vdd_core.n1 vco_feed_0.vdd_core.n17 0.219295
R1576 vco_feed_0.vdd_core.n0 vco_feed_0.vdd_core.n27 0.219294
R1577 vco_feed_0.vdd_core.n2 vco_feed_0.vdd_core 0.187579
R1578 vco_feed_0.vdd_core vco_feed_0.vdd_core.n8 0.166326
R1579 vco_feed_0.vdd_core.n7 vco_feed_0.vdd_core 0.166326
R1580 vco_bias_0.vbn_buf.n3 vco_bias_0.vbn_buf.t1 45.045
R1581 vco_bias_0.vbn_buf.n2 vco_bias_0.vbn_buf.t4 34.2391
R1582 vco_bias_0.vbn_buf.n2 vco_bias_0.vbn_buf.t3 28.5544
R1583 vco_bias_0.vbn_buf.n1 vco_bias_0.vbn_buf.n0 22.7415
R1584 vco_bias_0.vbn_buf.n0 vco_bias_0.vbn_buf.t2 21.7736
R1585 vco_bias_0.vbn_buf.n4 vco_bias_0.vbn_buf.t0 17.2373
R1586 vco_bias_0.vbn_buf.n4 vco_bias_0.vbn_buf.n3 13.5293
R1587 vco_bias_0.vbn_buf.n3 vco_bias_0.vbn_buf.n2 6.9349
R1588 vco_bias_0.vbn_buf vco_bias_0.vbn_buf.n4 2.55837
R1589 vco_bias_0.vbn_buf vco_bias_0.vbn_buf.n1 0.2645
R1590 vco_bias_0.vbn_buf.n1 vco_bias_0.vbn_buf 0.1985
R1591 vco_bias_0.vbn_buf.n0 vco_bias_0.vbn_buf 0.1105
C0 a_19050_4480# a_14668_2644# 0.03458f
C1 vco_bias_0.vbg_buf a_5560_4008# 0.01107f
C2 a_10100_3480# rf_out_n 0.69013f
C3 a_9450_4394# rf_out_n 0.86364f
C4 a_9450_4394# vco_feed_0.vdd_core 1.68741f
C5 vco_bias_0.vbg_buf a_9450_4480# 0.04475f
C6 a_1560_1090# VDD 0.0235f
C7 a_10100_3480# VDD 0.39132f
C8 a_9450_4394# a_14668_2644# 0.17478f
C9 vco_bias_0.vbg_buf vco_bias_0.vbn_buf 4.94304f
C10 a_9450_4394# VDD 0.63222f
C11 vtune rf_out_n 0.03484f
C12 vco_feed_0.vdd_core a_24640_164# 1.18592f
C13 vtune vco_feed_0.vdd_core 11.8836f
C14 a_5560_4008# vco_feed_0.en_b 0.04005f
C15 a_9450_4480# vco_bias_0.vbn_buf 0.01693f
C16 a_24640_164# VDD 0.04569f
C17 a_16500_3480# a_14668_2644# 0.02469f
C18 vtune a_14668_2644# 0.18112f
C19 vco_bias_0.vbg_buf vco_feed_0.en_b 0.17737f
C20 a_16500_3480# VDD 0.39132f
C21 vtune VDD 0.11507f
C22 VDD di_en 0.59914f
C23 vco_bias_0.vbg_buf a_19050_4480# 0.04459f
C24 rf_out_p vco_bias_0.vbn_buf 0.20879f
C25 vco_feed_0.en_b vco_bias_0.vbn_buf 1.04162f
C26 vco_feed_0.en_b rf_out_p 0.07782f
C27 vco_bias_0.vbg_buf a_1560_1090# 0.06101f
C28 vco_bias_0.vbg_buf a_9450_4394# 0.06224f
C29 a_1160_1390# VDD 0.01323f
C30 a_9450_4394# a_9450_4480# 0.03458f
C31 vtune vco_bias_0.vbg_buf 0.13019f
C32 a_9450_4394# vco_bias_0.vbn_buf 0.03118f
C33 vco_bias_0.vbg_buf di_en 2.11143f
C34 vco_feed_0.vdd_core rf_out_n 0.05799f
C35 vtune vco_bias_0.vbn_buf 0.06767f
C36 VDD rf_out_n 2.80242f
C37 vco_feed_0.vdd_core a_14668_2644# 1.69789f
C38 vco_feed_0.vdd_core VDD 0.47549f
C39 di_en vco_bias_0.vbn_buf 0.11188f
C40 a_16500_3480# rf_out_p 0.69013f
C41 vtune rf_out_p 0.03484f
C42 a_14668_2644# VDD 0.63222f
C43 vtune vco_feed_0.en_b 0.09037f
C44 vco_feed_0.en_b di_en 0.50415f
C45 vco_bias_0.vbg_buf a_1160_1390# 0.05206f
C46 a_9450_4394# a_10100_3480# 0.02469f
C47 a_1160_1390# vco_bias_0.vbn_buf 0.029f
C48 vtune a_9450_4394# 0.18112f
C49 vco_bias_0.vbg_buf vco_feed_0.vdd_core 1.49466f
C50 a_5560_4008# a_5060_3088# 0.02516f
C51 a_5560_4008# VDD 0.03954f
C52 vco_bias_0.vbg_buf a_14668_2644# 0.05315f
C53 vco_bias_0.vbg_buf a_5060_3088# 0.01628f
C54 vco_bias_0.vbg_buf VDD 2.36676f
C55 rf_out_n vco_bias_0.vbn_buf 0.29297f
C56 vco_feed_0.vdd_core vco_bias_0.vbn_buf 0.30754f
C57 rf_out_p rf_out_n 0.01393f
C58 vco_feed_0.vdd_core rf_out_p 0.06006f
C59 a_14668_2644# vco_bias_0.vbn_buf 0.01754f
C60 VDD vco_bias_0.vbn_buf 1.61103f
C61 vco_feed_0.en_b rf_out_n 0.07832f
C62 a_1160_1390# a_1560_1090# 0.17942f
C63 a_14668_2644# rf_out_p 0.86364f
C64 rf_out_p VDD 2.82306f
C65 a_19050_4480# vco_feed_0.vdd_core 0.01117f
C66 vco_feed_0.en_b VDD 5.96589f
C67 rf_out_p VSS 4.53458f
C68 rf_out_n VSS 4.39544f
C69 di_en VSS 2.96542f
C70 vtune VSS 4.66542f
C71 VDD VSS 41.61788f
C72 vco_feed_0.en_b VSS 15.66407f
C73 vco_bias_0.vbg_buf VSS 0.51558f
C74 vco_bias_0.vbn_buf VSS 0.12876p
C75 vco_bias_0.vbn_buf.n0 VSS 0.11526f
C76 vco_bias_0.vbn_buf.n1 VSS 0.06531f
C77 vco_bias_0.vbn_buf.n2 VSS 0.12484f
C78 vco_bias_0.vbn_buf.t1 VSS 2.22236f
C79 vco_bias_0.vbn_buf.n3 VSS 0.17794f
C80 vco_bias_0.vbn_buf.t0 VSS 0.08971f
C81 vco_bias_0.vbn_buf.n4 VSS 0.12041f
C82 vco_feed_0.vdd_core.n0 VSS 0.07645f
C83 vco_feed_0.vdd_core.n1 VSS 0.08182f
C84 vco_feed_0.vdd_core.n2 VSS 0.27951f
C85 vco_feed_0.vdd_core.n3 VSS 0.22396f
C86 vco_feed_0.vdd_core.n7 VSS 0.02947f
C87 vco_feed_0.vdd_core.n8 VSS 0.02947f
C88 vco_feed_0.vdd_core.t0 VSS 0.23711f
C89 vco_feed_0.vdd_core.t24 VSS 7.16974f
C90 vco_feed_0.vdd_core.t25 VSS 0.23711f
C91 vco_feed_0.vdd_core.n12 VSS 0.03409f
C92 vco_feed_0.vdd_core.n13 VSS 0.04541f
C93 vco_feed_0.vdd_core.n14 VSS 0.19067f
C94 vco_feed_0.vdd_core.t11 VSS 0.03126f
C95 vco_feed_0.vdd_core.n16 VSS 0.04862f
C96 vco_feed_0.vdd_core.n17 VSS 0.04693f
C97 vco_feed_0.vdd_core.n19 VSS 0.06862f
C98 vco_feed_0.vdd_core.n22 VSS 4.03642f
C99 vco_feed_0.vdd_core.n26 VSS 0.04758f
C100 vco_feed_0.vdd_core.t22 VSS 0.02233f
C101 vco_feed_0.vdd_core.n27 VSS 0.03166f
C102 vco_feed_0.vdd_core.n29 VSS 0.06862f
C103 vco_feed_0.vdd_core.n30 VSS 0.03304f
C104 vco_feed_0.en_b.n0 VSS 0.8487f
C105 vco_feed_0.en_b.n1 VSS 0.6768f
C106 vco_feed_0.en_b.t1 VSS 0.1191f
C107 vco_feed_0.en_b.t0 VSS 0.17973f
C108 vco_feed_0.en_b.n2 VSS 0.23039f
C109 vco_feed_0.en_b.n3 VSS 0.343f
C110 vco_feed_0.en_b.n4 VSS 0.54606f
C111 a_5948_4416.t0 VSS 0.13851f
C112 a_5948_4416.n0 VSS 1.96244f
C113 a_5948_4416.t1 VSS 0.26279f
C114 a_6568_6136.t2 VSS 0.5401f
C115 a_6568_6136.t3 VSS 0.50162f
C116 a_6568_6136.n0 VSS 0.63435f
C117 a_6568_6136.n1 VSS 0.95112f
C118 a_6568_6136.n2 VSS 0.63482f
C119 a_6568_6136.t1 VSS 1.01602f
C120 a_5060_5708.t1 VSS 1.3759f
C121 a_5060_5708.n0 VSS 1.50793f
C122 a_5060_5708.t0 VSS 0.33299f
C123 a_5560_5708.t2 VSS 2.67282f
C124 a_5560_5708.t1 VSS 0.77883f
C125 a_5560_5708.n0 VSS 3.70239f
C126 a_5560_5708.t0 VSS 1.32485f
C127 a_5560_3922.t0 VSS 0.72757f
C128 a_5560_3922.n0 VSS 0.98077f
C129 a_5560_3922.t2 VSS 0.50206f
C130 a_5060_3002.t1 VSS 2.59353f
C131 a_5060_3002.t3 VSS 0.53368f
C132 a_5060_3002.n0 VSS 1.35031f
C133 a_5060_3002.n1 VSS 0.23446f
C134 a_5060_3002.n2 VSS 0.37813f
C135 a_5060_3002.t0 VSS 1.13746f
C136 a_5060_3002.n3 VSS 1.2638f
C137 a_5060_3002.t4 VSS 0.20414f
C138 a_11798_1180.n0 VSS 0.68187f
C139 a_11798_1180.n1 VSS 2.26995f
C140 a_11798_1180.n2 VSS 3.86767f
C141 a_11798_1180.n3 VSS 0.35095f
C142 a_11798_1180.n4 VSS 0.10604f
C143 a_11798_1180.n5 VSS 0.10604f
C144 a_11798_1180.n7 VSS 1.55238f
C145 a_11798_1180.n8 VSS 1.52482f
C146 a_11798_1180.n9 VSS 0.09373f
C147 a_11798_1180.t0 VSS 0.06738f
C148 a_11798_1180.n10 VSS 0.05421f
C149 a_11798_1180.t2 VSS 2.98976f
C150 a_11798_1180.n11 VSS 0.04067f
C151 a_11798_1180.t3 VSS 0.08014f
C152 a_11798_1180.t4 VSS 0.07523f
C153 a_11798_1180.n12 VSS 0.04067f
C154 a_11798_1180.t5 VSS 0.07523f
C155 a_11798_1180.n13 VSS 0.04148f
C156 a_11798_1180.t6 VSS 0.06738f
C157 a_11798_1180.n14 VSS 0.0542f
C158 a_11798_1180.n15 VSS 0.10568f
C159 a_11798_1180.n16 VSS 0.06947f
C160 a_11798_1180.n17 VSS 0.06947f
C161 a_11798_1180.n18 VSS 0.10567f
C162 a_11798_1180.t1 VSS 0.34581f
C163 a_11798_1180.n19 VSS 0.04148f
C164 a_11798_1180.n20 VSS 0.33093f
C165 a_11798_1180.n21 VSS 0.33092f
C166 a_11798_1180.n22 VSS 0.09373f
C167 a_11798_1180.t22 VSS 0.06738f
C168 a_11798_1180.n23 VSS 0.05421f
C169 a_11798_1180.t24 VSS 0.07523f
C170 a_11798_1180.n24 VSS 0.04067f
C171 a_11798_1180.t25 VSS 0.08014f
C172 a_11798_1180.t26 VSS 2.98455f
C173 a_11798_1180.n25 VSS 0.04067f
C174 a_11798_1180.t27 VSS 0.07523f
C175 a_11798_1180.n26 VSS 0.04148f
C176 a_11798_1180.t28 VSS 0.06738f
C177 a_11798_1180.n27 VSS 0.0542f
C178 a_11798_1180.n28 VSS 0.10568f
C179 a_11798_1180.n29 VSS 0.06947f
C180 a_11798_1180.n30 VSS 0.06947f
C181 a_11798_1180.n31 VSS 0.10567f
C182 a_11798_1180.t23 VSS 0.33302f
C183 a_11798_1180.n32 VSS 0.04148f
C184 a_11798_1180.n33 VSS 0.33092f
C185 a_11798_1180.t7 VSS 0.24203f
C186 a_11798_1180.t8 VSS 0.23548f
C187 a_11798_1180.t9 VSS 0.23547f
C188 a_11798_1180.t10 VSS 0.23547f
C189 a_11798_1180.t11 VSS 0.23547f
C190 a_11798_1180.t12 VSS 0.23547f
C191 a_11798_1180.t13 VSS 0.23548f
C192 a_11798_1180.t14 VSS 0.23548f
C193 a_11798_1180.t15 VSS 0.23547f
C194 a_11798_1180.t16 VSS 0.23547f
C195 a_11798_1180.t17 VSS 0.23548f
C196 a_11798_1180.t18 VSS 0.23548f
C197 a_11798_1180.t19 VSS 0.90436f
C198 a_11798_1180.t20 VSS 0.23547f
C199 a_11798_1180.t21 VSS 0.24199f
C200 a_20954_346.n0 VSS 2.01654f
C201 a_20954_346.n1 VSS 4.41857f
C202 a_20954_346.n2 VSS 14.9331f
C203 a_20954_346.t16 VSS 15.84959f
C204 a_20954_346.t0 VSS 0.1871f
C205 a_20954_346.t1 VSS 0.18547f
C206 a_20954_346.t2 VSS 0.18547f
C207 a_20954_346.t3 VSS 0.18547f
C208 a_20954_346.t4 VSS 0.18547f
C209 a_20954_346.t5 VSS 0.18547f
C210 a_20954_346.t6 VSS 0.18547f
C211 a_20954_346.t7 VSS 3.04277f
C212 a_20954_346.t8 VSS 0.18547f
C213 a_20954_346.t9 VSS 0.18547f
C214 a_20954_346.t10 VSS 0.18547f
C215 a_20954_346.t11 VSS 0.18547f
C216 a_20954_346.t12 VSS 0.18547f
C217 a_20954_346.t13 VSS 0.18547f
C218 a_20954_346.t14 VSS 0.18547f
C219 a_20954_346.t15 VSS 0.18546f
C220 VSS.t71 VSS 0.13177p
C221 VSS.t161 VSS 0.66888f
C222 VSS.t90 VSS 0.01963f
C223 VSS.t15 VSS 0.02853f
C224 VSS.t64 VSS 2.98334f
C225 VSS.t36 VSS 57.606f
C226 VSS.t37 VSS 57.606f
C227 VSS.t49 VSS 1.0078f
C228 VSS.t51 VSS 1.0078f
C229 VSS.t92 VSS 2.97913f
C230 VSS.t62 VSS 2.98334f
C231 VSS.t94 VSS 2.97913f
C232 VSS.t70 VSS 0.07184f
C233 VSS.t13 VSS 0.0401f
C234 VSS.t33 VSS 0.54116f
C235 VSS.t119 VSS 0.0714f
C236 VSS.t121 VSS 0.04619f
C237 VSS.t58 VSS 0.17725f
C238 VSS.t105 VSS 0.18756f
C239 VSS.t102 VSS 0.18756f
C240 VDD.n0 VSS 0.29284f
C241 VDD.n2 VSS 0.12767f
C242 VDD.n3 VSS 0.15306f
C243 VDD.n4 VSS 0.17314f
C244 VDD.n5 VSS 0.17314f
C245 VDD.n6 VSS 0.17314f
C246 VDD.n7 VSS 1.77755f
C247 VDD.n8 VSS 0.03116f
C248 VDD.n9 VSS 0.03116f
C249 VDD.n10 VSS 0.17314f
C250 VDD.n11 VSS 0.03116f
C251 VDD.n12 VSS 0.03116f
C252 VDD.n13 VSS 0.17314f
C253 VDD.n14 VSS 0.03116f
C254 VDD.n15 VSS 0.03116f
C255 VDD.n16 VSS 0.23963f
C256 VDD.n17 VSS 0.32384f
C257 VDD.n18 VSS 0.05723f
C258 VDD.n19 VSS 0.09368f
C259 VDD.n20 VSS 0.01062f
C260 VDD.n21 VSS 0.10424f
C261 VDD.n22 VSS 0.09455f
C262 VDD.n23 VSS 0.07603f
C263 VDD.n24 VSS 1.26499f
C264 VDD.n25 VSS 0.11719f
C265 VDD.n26 VSS 0.03116f
C266 VDD.n27 VSS 0.08501f
C267 VDD.n29 VSS 0.48244f
C268 VDD.n31 VSS 0.05503f
C269 VDD.n32 VSS 0.07444f
C270 VDD.n33 VSS 0.07849f
C271 VDD.n34 VSS 0.05483f
C272 VDD.n35 VSS 0.03116f
C273 VDD.n36 VSS 0.05483f
C274 VDD.n38 VSS 0.03116f
C275 VDD.n39 VSS 0.05483f
C276 VDD.n40 VSS 0.03116f
C277 VDD.n41 VSS 0.05483f
C278 VDD.n43 VSS 0.03116f
C279 VDD.n44 VSS 0.03116f
C280 VDD.n45 VSS 0.03116f
C281 VDD.n46 VSS 0.05483f
C282 VDD.n47 VSS 0.05483f
C283 VDD.n49 VSS 0.05483f
C284 VDD.n50 VSS 0.05483f
C285 VDD.n52 VSS 0.05483f
C286 VDD.t16 VSS 0.06217f
C287 VDD.t21 VSS 2.91332f
C288 VDD.t17 VSS 0.05602f
C289 VDD.t15 VSS 0.05602f
C290 VDD.t13 VSS 0.05602f
C291 VDD.t11 VSS 0.05602f
C292 VDD.t9 VSS 0.05602f
C293 VDD.t7 VSS 0.05602f
C294 VDD.t6 VSS 0.05022f
C295 VDD.t5 VSS 4.18702f
C296 VDD.t23 VSS 0.05602f
C297 VDD.n53 VSS 0.03116f
C298 VDD.t25 VSS 0.05602f
C299 VDD.t27 VSS 0.05602f
C300 VDD.t29 VSS 0.05602f
C301 VDD.t30 VSS 0.05602f
C302 VDD.t33 VSS 0.05602f
C303 VDD.t35 VSS 0.05602f
C304 VDD.t37 VSS 0.05022f
C305 VDD.n54 VSS 0.03746f
C306 VDD.n55 VSS 0.03652f
C307 VDD.n56 VSS 4.49991f
C308 VDD.t38 VSS 1.00333f
C309 VDD.n57 VSS 5.78576f
C310 VDD.t39 VSS 1.00284f
C311 VDD.n58 VSS 5.78576f
C312 VDD.n59 VSS 4.16159f
C313 VDD.t2 VSS 0.06581f
C314 VDD.t49 VSS 0.07544f
C315 VDD.t4 VSS 0.25412f
C316 VDD.t50 VSS 0.49353f
C317 VDD.t47 VSS 0.17857f
C318 VDD.t48 VSS 0.17443f
C319 VDD.t1 VSS 0.4918f
C320 VDD.t44 VSS 0.17443f
C321 VDD.t45 VSS 0.17443f
C322 VDD.t3 VSS 0.12372f
C323 VDD.t41 VSS 0.02437f
C324 VDD.t42 VSS 0.02437f
C325 VDD.t0 VSS 5.21326f
C326 VDD.n60 VSS 0.42758f
C327 vtune.t0 VSS 3.75866f
C328 vtune.t6 VSS 3.74482f
C329 vtune.n0 VSS 0.40206f
C330 vtune.t2 VSS 3.74482f
C331 vtune.n1 VSS 1.0161f
C332 di_en.n0 VSS 1.9503f
C333 rf_out_n.n0 VSS 1.06634f
C334 rf_out_n.n1 VSS 1.66923f
C335 rf_out_n.t3 VSS 0.13431f
C336 rf_out_n.t6 VSS 3.04235f
C337 rf_out_n.t5 VSS 0.13303f
C338 rf_out_n.t2 VSS 0.13303f
C339 rf_out_n.t1 VSS 0.39082f
C340 rf_out_n.t4 VSS 0.13303f
C341 rf_out_n.t0 VSS 1.92597f
C342 rf_out_n.n2 VSS 5.13496f
C343 rf_out_p.n0 VSS 1.45971f
C344 rf_out_p.n1 VSS 1.25918f
C345 rf_out_p.t5 VSS 0.13349f
C346 rf_out_p.t3 VSS 3.31733f
C347 rf_out_p.t4 VSS 0.13222f
C348 rf_out_p.t0 VSS 0.13222f
C349 rf_out_p.t1 VSS 0.13222f
C350 rf_out_p.t2 VSS 0.13222f
C351 rf_out_p.t6 VSS 1.91957f
C352 rf_out_p.n2 VSS 5.10366f
.ends

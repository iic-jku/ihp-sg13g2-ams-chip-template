* PEX produced on Sun Nov  1 12:41:50 AM CET 2026 using /foss/tools/sak/sak-pex.sh with m=3 and s=1 (extresist threshold=10000 mOhm, minres=1000 mOhm, mindelay=1 ps)
* NGSPICE file created from vco_buf_pex.ext - technology: ihp-sg13g2

.subckt vco_buf_pex vbn_buf vbg_buf VDD VSS rf_p rf_n rf_out_p rf_out_n
X0 a_n2502_n1000# vbn_buf VSS VSS.t0 sg13_lv_nmos ad=0.95p pd=5.38u as=1.7p ps=10.68u w=5u l=0.5u
X1 a_n2502_n1000# vbn_buf VSS VSS.t6 sg13_lv_nmos ad=0.95p pd=5.38u as=0.95p ps=5.38u w=5u l=0.5u
X2 a_n2502_n1000# vbn_buf VSS VSS.t8 sg13_lv_nmos ad=0.95p pd=5.38u as=0.95p ps=5.38u w=5u l=0.5u
X3 VSS vbn_buf a_n2502_n1000# VSS.t21 sg13_lv_nmos ad=0.95p pd=5.38u as=0.95p ps=5.38u w=5u l=0.5u
X4 VSS vbn_buf a_n2502_n1000# VSS.t23 sg13_lv_nmos ad=0.95p pd=5.38u as=0.95p ps=5.38u w=5u l=0.5u
X5 a_n2502_n1000# a_n4850_2214# rf_out_n VSS.t37 sg13_lv_nmos ad=0.38p pd=2.38u as=0.38p ps=2.38u w=2u l=0.13u
X6 a_n2502_n1000# vbn_buf VSS VSS.t14 sg13_lv_nmos ad=0.95p pd=5.38u as=0.95p ps=5.38u w=5u l=0.5u
X7 a_n2502_n1000# vbn_buf VSS VSS.t22 sg13_lv_nmos ad=0.95p pd=5.38u as=0.95p ps=5.38u w=5u l=0.5u
X8 a_n2502_n1000# vbn_buf VSS VSS.t24 sg13_lv_nmos ad=0.95p pd=5.38u as=0.95p ps=5.38u w=5u l=0.5u
X9 vbg_buf a_n4850_2214# VSS.t42 rhigh l=8u w=0.5u
X10 a_n2502_n1000# a_n4850_2214# rf_out_n VSS.t35 sg13_lv_nmos ad=0.38p pd=2.38u as=0.38p ps=2.38u w=2u l=0.13u
X11 rf_out_n a_n4850_2214# a_n2502_n1000# VSS.t36 sg13_lv_nmos ad=0.38p pd=2.38u as=0.38p ps=2.38u w=2u l=0.13u
X12 VSS vbn_buf a_n2502_n1000# VSS.t5 sg13_lv_nmos ad=0.95p pd=5.38u as=0.95p ps=5.38u w=5u l=0.5u
X13 rf_out_n a_n4850_2214# a_n2502_n1000# VSS.t34 sg13_lv_nmos ad=0.38p pd=2.38u as=0.38p ps=2.38u w=2u l=0.13u
X14 a_n2502_n1000# a_n4850_2214# rf_out_n VSS.t33 sg13_lv_nmos ad=0.38p pd=2.38u as=0.38p ps=2.38u w=2u l=0.13u
X15 rf_out_p a_368_464# a_n2502_n1000# VSS.t44 sg13_lv_nmos ad=0.38p pd=2.38u as=0.68p ps=4.68u w=2u l=0.13u
X16 rf_out_n a_n4850_2214# a_n2502_n1000# VSS.t32 sg13_lv_nmos ad=0.38p pd=2.38u as=0.38p ps=2.38u w=2u l=0.13u
X17 a_n2502_n1000# a_368_464# rf_out_p VSS.t45 sg13_lv_nmos ad=0.38p pd=2.38u as=0.38p ps=2.38u w=2u l=0.13u
X18 a_n2502_n1000# vbn_buf VSS VSS.t4 sg13_lv_nmos ad=0.95p pd=5.38u as=0.95p ps=5.38u w=5u l=0.5u
X19 VSS vbn_buf a_n2502_n1000# VSS.t13 sg13_lv_nmos ad=0.95p pd=5.38u as=0.95p ps=5.38u w=5u l=0.5u
X20 VSS vbn_buf a_n2502_n1000# VSS.t25 sg13_lv_nmos ad=0.95p pd=5.38u as=0.95p ps=5.38u w=5u l=0.5u
X21 VDD rf_out_p VSS.t43 rppd l=1.65u w=10u
X22 rf_out_p a_368_464# a_n2502_n1000# VSS.t46 sg13_lv_nmos ad=0.38p pd=2.38u as=0.38p ps=2.38u w=2u l=0.13u
X23 a_n2502_n1000# a_n4850_2214# rf_out_n VSS.t31 sg13_lv_nmos ad=0.38p pd=2.38u as=0.38p ps=2.38u w=2u l=0.13u
X24 a_n2502_n1000# vbn_buf VSS VSS.t16 sg13_lv_nmos ad=0.95p pd=5.38u as=0.95p ps=5.38u w=5u l=0.5u
X25 a_368_464# rf_n cap_cmim l=10u w=10u
X26 VDD rf_out_n VSS.t42 rppd l=1.65u w=10u
X27 a_n2502_n1000# a_368_464# rf_out_p VSS.t47 sg13_lv_nmos ad=0.38p pd=2.38u as=0.38p ps=2.38u w=2u l=0.13u
X28 rf_out_n a_n4850_2214# a_n2502_n1000# VSS.t30 sg13_lv_nmos ad=0.38p pd=2.38u as=0.68p ps=4.68u w=2u l=0.13u
X29 a_n2502_n1000# vbn_buf VSS VSS.t12 sg13_lv_nmos ad=0.95p pd=5.38u as=0.95p ps=5.38u w=5u l=0.5u
X30 a_n2502_n1000# vbn_buf VSS VSS.t26 sg13_lv_nmos ad=0.95p pd=5.38u as=0.95p ps=5.38u w=5u l=0.5u
X31 vbg_buf a_368_464# VSS.t43 rhigh l=8u w=0.5u
X32 rf_out_p a_368_464# a_n2502_n1000# VSS.t48 sg13_lv_nmos ad=0.38p pd=2.38u as=0.38p ps=2.38u w=2u l=0.13u
X33 a_n2502_n1000# a_368_464# rf_out_p VSS.t49 sg13_lv_nmos ad=0.38p pd=2.38u as=0.38p ps=2.38u w=2u l=0.13u
X34 rf_out_p a_368_464# a_n2502_n1000# VSS.t50 sg13_lv_nmos ad=0.38p pd=2.38u as=0.38p ps=2.38u w=2u l=0.13u
X35 VSS vbn_buf a_n2502_n1000# VSS.t11 sg13_lv_nmos ad=0.95p pd=5.38u as=0.95p ps=5.38u w=5u l=0.5u
X36 VSS vbn_buf a_n2502_n1000# VSS.t9 sg13_lv_nmos ad=0.95p pd=5.38u as=0.95p ps=5.38u w=5u l=0.5u
X37 a_n4850_2214# rf_p cap_cmim l=10u w=10u
X38 a_n2502_n1000# vbn_buf VSS VSS.t2 sg13_lv_nmos ad=0.95p pd=5.38u as=0.95p ps=5.38u w=5u l=0.5u
X39 a_n2502_n1000# vbn_buf VSS VSS.t18 sg13_lv_nmos ad=0.95p pd=5.38u as=0.95p ps=5.38u w=5u l=0.5u
X40 a_n2502_n1000# vbn_buf VSS VSS.t20 sg13_lv_nmos ad=0.95p pd=5.38u as=0.95p ps=5.38u w=5u l=0.5u
X41 a_n2502_n1000# a_n4850_2214# rf_out_n VSS.t41 sg13_lv_nmos ad=0.68p pd=4.68u as=0.38p ps=2.38u w=2u l=0.13u
X42 a_n2502_n1000# a_368_464# rf_out_p VSS.t51 sg13_lv_nmos ad=0.38p pd=2.38u as=0.38p ps=2.38u w=2u l=0.13u
X43 a_n2502_n1000# vbn_buf VSS VSS.t10 sg13_lv_nmos ad=0.95p pd=5.38u as=0.95p ps=5.38u w=5u l=0.5u
X44 rf_out_n a_n4850_2214# a_n2502_n1000# VSS.t40 sg13_lv_nmos ad=0.38p pd=2.38u as=0.38p ps=2.38u w=2u l=0.13u
X45 rf_out_p a_368_464# a_n2502_n1000# VSS.t52 sg13_lv_nmos ad=0.38p pd=2.38u as=0.38p ps=2.38u w=2u l=0.13u
X46 VSS vbn_buf a_n2502_n1000# VSS.t1 sg13_lv_nmos ad=0.95p pd=5.38u as=0.95p ps=5.38u w=5u l=0.5u
X47 VSS vbn_buf a_n2502_n1000# VSS.t3 sg13_lv_nmos ad=0.95p pd=5.38u as=0.95p ps=5.38u w=5u l=0.5u
X48 VSS vbn_buf a_n2502_n1000# VSS.t17 sg13_lv_nmos ad=0.95p pd=5.38u as=0.95p ps=5.38u w=5u l=0.5u
X49 VSS vbn_buf a_n2502_n1000# VSS.t19 sg13_lv_nmos ad=0.95p pd=5.38u as=0.95p ps=5.38u w=5u l=0.5u
X50 a_n2502_n1000# vbn_buf VSS VSS.t28 sg13_lv_nmos ad=0.95p pd=5.38u as=0.95p ps=5.38u w=5u l=0.5u
X51 a_n2502_n1000# a_n4850_2214# rf_out_n VSS.t39 sg13_lv_nmos ad=0.38p pd=2.38u as=0.38p ps=2.38u w=2u l=0.13u
X52 a_n2502_n1000# a_368_464# rf_out_p VSS.t53 sg13_lv_nmos ad=0.38p pd=2.38u as=0.38p ps=2.38u w=2u l=0.13u
X53 rf_out_n a_n4850_2214# a_n2502_n1000# VSS.t38 sg13_lv_nmos ad=0.38p pd=2.38u as=0.38p ps=2.38u w=2u l=0.13u
X54 rf_out_p a_368_464# a_n2502_n1000# VSS.t54 sg13_lv_nmos ad=0.38p pd=2.38u as=0.38p ps=2.38u w=2u l=0.13u
X55 a_n2502_n1000# a_368_464# rf_out_p VSS.t55 sg13_lv_nmos ad=0.68p pd=4.68u as=0.38p ps=2.38u w=2u l=0.13u
X56 VSS vbn_buf a_n2502_n1000# VSS.t7 sg13_lv_nmos ad=0.95p pd=5.38u as=0.95p ps=5.38u w=5u l=0.5u
X57 VSS vbn_buf a_n2502_n1000# VSS.t15 sg13_lv_nmos ad=0.95p pd=5.38u as=0.95p ps=5.38u w=5u l=0.5u
X58 VSS vbn_buf a_n2502_n1000# VSS.t27 sg13_lv_nmos ad=0.95p pd=5.38u as=0.95p ps=5.38u w=5u l=0.5u
X59 VSS vbn_buf a_n2502_n1000# VSS.t29 sg13_lv_nmos ad=1.7p pd=10.68u as=0.95p ps=5.38u w=5u l=0.5u
R0 VSS.n19 VSS.t5 38.3285
R1 VSS.t24 VSS.n2 38.3285
R2 VSS.n22 VSS.t2 36.3949
R3 VSS.t27 VSS.n39 36.3949
R4 VSS.t14 VSS.n11 34.4613
R5 VSS.n11 VSS.t15 34.4613
R6 VSS.t3 VSS.n22 32.5277
R7 VSS.n39 VSS.t26 32.5277
R8 VSS.t0 VSS.t42 31.9051
R9 VSS.t43 VSS.t29 31.9051
R10 VSS.t4 VSS.n19 30.5941
R11 VSS.n2 VSS.t25 30.5941
R12 VSS.t28 VSS.n0 29.5762
R13 VSS.n21 VSS.t1 29.5754
R14 VSS.n24 VSS.t31 29.4881
R15 VSS.t33 VSS.n16 29.4881
R16 VSS.n26 VSS.t35 29.4881
R17 VSS.t50 VSS.n6 29.4881
R18 VSS.n37 VSS.t52 29.4881
R19 VSS.t54 VSS.n3 29.4881
R20 VSS.t13 VSS.n30 28.6605
R21 VSS.n32 VSS.t16 28.6605
R22 VSS.t41 VSS.t12 28.5213
R23 VSS.t17 VSS.t44 28.5213
R24 VSS.t10 VSS.n13 28.0379
R25 VSS.n34 VSS.t19 28.0379
R26 VSS.t1 VSS.n20 25.709
R27 VSS.n40 VSS.t28 25.7081
R28 VSS.n38 VSS.t55 24.2588
R29 VSS.t30 VSS.n18 24.2579
R30 VSS.n27 VSS.t9 24.1707
R31 VSS.t20 VSS.n7 24.1707
R32 VSS.n31 VSS.t13 23.7754
R33 VSS.t16 VSS.n10 23.7745
R34 VSS.n25 VSS.t8 22.237
R35 VSS.t21 VSS.n5 22.237
R36 VSS.t25 VSS.n1 21.8418
R37 VSS.n23 VSS.t4 21.8409
R38 VSS.t38 VSS.n28 21.4094
R39 VSS.n12 VSS.t40 21.4094
R40 VSS.t45 VSS.n9 21.4094
R41 VSS.n33 VSS.t47 21.4094
R42 VSS.n23 VSS.t3 19.9082
R43 VSS.t26 VSS.n1 19.9073
R44 VSS.t32 VSS.n16 19.82
R45 VSS.n26 VSS.t34 19.82
R46 VSS.t36 VSS.n13 19.82
R47 VSS.n29 VSS.t38 19.82
R48 VSS.t40 VSS.t12 19.82
R49 VSS.t17 VSS.t45 19.82
R50 VSS.t47 VSS.n8 19.82
R51 VSS.n34 VSS.t49 19.82
R52 VSS.t51 VSS.n6 19.82
R53 VSS.n37 VSS.t53 19.82
R54 VSS.t15 VSS.n10 17.9746
R55 VSS.n31 VSS.t14 17.9737
R56 VSS VSS.t17 17.9673
R57 VSS VSS.t12 17.9673
R58 VSS VSS.t43 17.0005
R59 VSS VSS.n3 17.0005
R60 VSS VSS.n37 17.0005
R61 VSS VSS.n5 17.0005
R62 VSS VSS.n36 17.0005
R63 VSS VSS.n6 17.0005
R64 VSS VSS.n35 17.0005
R65 VSS VSS.n7 17.0005
R66 VSS VSS.n34 17.0005
R67 VSS VSS.n8 17.0005
R68 VSS VSS.n29 17.0005
R69 VSS VSS.n13 17.0005
R70 VSS VSS.n27 17.0005
R71 VSS VSS.n14 17.0005
R72 VSS VSS.n26 17.0005
R73 VSS VSS.n15 17.0005
R74 VSS VSS.n25 17.0005
R75 VSS VSS.n16 17.0005
R76 VSS VSS.n24 17.0005
R77 VSS VSS.t42 17.0005
R78 VSS.n24 VSS.t6 16.4362
R79 VSS.t23 VSS.n3 16.4362
R80 VSS.n40 VSS.t27 16.0409
R81 VSS.t2 VSS.n20 16.0401
R82 VSS.t11 VSS.t39 14.986
R83 VSS.t46 VSS.t18 14.986
R84 VSS.n29 VSS.t11 14.5026
R85 VSS.t18 VSS.n8 14.5026
R86 VSS.t5 VSS.n18 14.1073
R87 VSS.n38 VSS.t24 14.1065
R88 VSS.t34 VSS.n15 13.0524
R89 VSS.n27 VSS.t36 13.0524
R90 VSS.t49 VSS.n7 13.0524
R91 VSS.n36 VSS.t51 13.0524
R92 VSS.n21 VSS.t0 12.1737
R93 VSS.t29 VSS.n0 12.1729
R94 VSS.t31 VSS.n17 11.7414
R95 VSS.n28 VSS.t37 11.7414
R96 VSS.t39 VSS.n12 11.7414
R97 VSS.n30 VSS.t41 11.7414
R98 VSS.t44 VSS.n32 11.7414
R99 VSS.n9 VSS.t46 11.7414
R100 VSS.t48 VSS.n33 11.7414
R101 VSS.n4 VSS.t54 11.7414
R102 VSS.n17 VSS.t7 11.258
R103 VSS.t22 VSS.n4 11.258
R104 VSS.t8 VSS.n15 10.6354
R105 VSS.n36 VSS.t21 10.6354
R106 VSS.t7 VSS.t32 10.152
R107 VSS.t53 VSS.t22 10.152
R108 VSS.t9 VSS.n14 8.70176
R109 VSS.n35 VSS.t20 8.70176
R110 VSS VSS.n39 4.32273
R111 VSS VSS.n2 4.32273
R112 VSS VSS.n4 4.32273
R113 VSS VSS.n33 4.32273
R114 VSS VSS.n9 4.32273
R115 VSS VSS.n32 4.32273
R116 VSS VSS.n11 4.32273
R117 VSS VSS.n30 4.32273
R118 VSS VSS.n12 4.32273
R119 VSS VSS.n28 4.32273
R120 VSS VSS.n17 4.32273
R121 VSS VSS.n19 4.32273
R122 VSS VSS.n22 4.32273
R123 VSS.t6 VSS.t30 3.38432
R124 VSS.n25 VSS.t33 3.38432
R125 VSS.t35 VSS.n14 3.38432
R126 VSS.n35 VSS.t50 3.38432
R127 VSS.t52 VSS.n5 3.38432
R128 VSS.t55 VSS.t23 3.38432
R129 VSS.t37 VSS.t10 1.45071
R130 VSS.t19 VSS.t48 1.45071
R131 VSS VSS.n0 1.17569
R132 VSS VSS.n1 1.17569
R133 VSS VSS.n38 1.17569
R134 VSS VSS.n10 1.17569
R135 VSS VSS.n31 1.17569
R136 VSS VSS.n18 1.17569
R137 VSS VSS.n23 1.17569
R138 VSS VSS.n20 1.17569
R139 VSS VSS.n21 1.17569
R140 VSS VSS.n40 1.17569
C0 rf_p rf_n 0.03818f
C1 a_368_464# rf_out_p 0.6427f
C2 a_n4850_2214# vbn_buf 0.01624f
C3 vbn_buf a_368_464# 0.01624f
C4 rf_out_n a_n2502_n1000# 2.5325f
C5 rf_p rf_out_n 0.0158f
C6 a_2200_1300# rf_n 0.01479f
C7 VDD rf_out_p 0.15624f
C8 a_n4850_2214# a_368_464# 0.145f
C9 a_n4850_2214# vbg_buf 0.05308f
C10 a_n4200_1300# vbn_buf 0.01632f
C11 a_368_464# vbg_buf 0.05308f
C12 rf_n rf_out_p 0.0158f
C13 a_n4850_2214# a_n4850_2300# 0.03458f
C14 a_n4850_2214# VDD 0.48463f
C15 a_n2502_n1000# rf_out_p 2.5325f
C16 a_n4200_1300# a_n4850_2214# 0.0615f
C17 VDD a_368_464# 0.48463f
C18 rf_out_n rf_out_p 0.01053f
C19 vbn_buf a_n2502_n1000# 6.04923f
C20 a_n4850_2300# vbg_buf 0.03836f
C21 vbn_buf rf_out_n 0.19497f
C22 a_2200_1300# rf_out_p 0.47902f
C23 a_368_464# rf_n 1.57748f
C24 a_n4850_2214# a_n2502_n1000# 0.39463f
C25 a_n4200_1300# VDD 0.32168f
C26 a_n4850_2214# rf_p 1.57748f
C27 a_368_464# a_n2502_n1000# 0.39463f
C28 rf_n vbg_buf 0.56344f
C29 a_n4850_2214# rf_out_n 0.6427f
C30 a_4750_2300# a_368_464# 0.03458f
C31 rf_p vbg_buf 0.56344f
C32 VDD rf_n 0.09747f
C33 a_4750_2300# vbg_buf 0.03836f
C34 a_2200_1300# a_368_464# 0.0615f
C35 rf_p VDD 0.09747f
C36 vbn_buf rf_out_p 0.17164f
C37 a_n4200_1300# rf_p 0.01479f
C38 rf_out_n VDD 0.15624f
C39 a_n4200_1300# rf_out_n 0.47902f
C40 a_2200_1300# VDD 0.32168f
C41 rf_n VSS 1.94814f
C42 rf_p VSS 1.94814f
C43 rf_out_p VSS 6.64986f
C44 rf_out_n VSS 6.62788f
C45 VDD VSS 7.66154f
C46 vbg_buf VSS 5.03305f
C47 a_n2502_n1000# VSS 23.96543f
.ends

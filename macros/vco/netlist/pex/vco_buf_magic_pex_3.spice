* PEX produced on Sat Nov  7 09:43:00 PM CET 2026 using /foss/tools/sak/sak-pex.sh with m=3 and s=1 (extresist threshold=1000 mOhm, minres=100 mOhm, mindelay=0 ps)
* NGSPICE file created from vco_buf_pex.ext - technology: ihp-sg13g2

.subckt vco_buf_pex vbn_buf vbg_buf VDD VSS rf_p rf_n rf_out_p rf_out_n
X0 a_n2502_n1000.t0 vbn_buf.t0 VSS.t3 VSS.t2 sg13_lv_nmos ad=0.95p pd=5.38u as=1.7p ps=10.68u w=5u l=0.5u
X1 a_n2502_n1000.t3 vbn_buf.t0 VSS.t11 VSS.t12 sg13_lv_nmos ad=0.95p pd=5.38u as=0.95p ps=5.38u w=5u l=0.5u
X2 a_n2502_n1000.t4 vbn_buf.t0 VSS.t1 VSS.t0 sg13_lv_nmos ad=0.95p pd=5.38u as=0.95p ps=5.38u w=5u l=0.5u
X3 VSS.t33 vbn_buf.t0 a_n2502_n1000.t10 VSS.t32 sg13_lv_nmos ad=0.95p pd=5.38u as=0.95p ps=5.38u w=5u l=0.5u
X4 VSS.t36 vbn_buf.t0 a_n2502_n1000.t11 VSS.t35 sg13_lv_nmos ad=0.95p pd=5.38u as=0.95p ps=5.38u w=5u l=0.5u
X5 a_n2502_n1000.t19 a_n4850_2214# rf_out_n.t3 VSS.t53 sg13_lv_nmos ad=0.38p pd=2.38u as=0.38p ps=2.38u w=2u l=0.13u
X6 a_n2502_n1000.t7 vbn_buf.t0 VSS.t23 VSS.t24 sg13_lv_nmos ad=0.95p pd=5.38u as=0.95p ps=5.38u w=5u l=0.5u
X7 a_n2502_n1000.t11 vbn_buf.t0 VSS.t33 VSS.t34 sg13_lv_nmos ad=0.95p pd=5.38u as=0.95p ps=5.38u w=5u l=0.5u
X8 a_n2502_n1000.t12 vbn_buf.t0 VSS.t36 VSS.t37 sg13_lv_nmos ad=0.95p pd=5.38u as=0.95p ps=5.38u w=5u l=0.5u
X9 vbg_buf.t0 a_n4850_2214# VSS.t58 rhigh l=8u w=0.5u
X10 a_n2502_n1000.t18 a_n4850_2214# rf_out_n.t2 VSS.t51 sg13_lv_nmos ad=0.38p pd=2.38u as=0.38p ps=2.38u w=2u l=0.13u
X11 rf_out_n.t3 a_n4850_2214# a_n2502_n1000.t18 VSS.t52 sg13_lv_nmos ad=0.38p pd=2.38u as=0.38p ps=2.38u w=2u l=0.13u
X12 VSS.t11 vbn_buf.t0 a_n2502_n1000.t2 VSS.t10 sg13_lv_nmos ad=0.95p pd=5.38u as=0.95p ps=5.38u w=5u l=0.5u
X13 rf_out_n.t2 a_n4850_2214# a_n2502_n1000.t17 VSS.t50 sg13_lv_nmos ad=0.38p pd=2.38u as=0.38p ps=2.38u w=2u l=0.13u
X14 a_n2502_n1000.t17 a_n4850_2214# rf_out_n.t1 VSS.t49 sg13_lv_nmos ad=0.38p pd=2.38u as=0.38p ps=2.38u w=2u l=0.13u
X15 rf_out_p.t5 a_368_464# a_n2502_n1000.t22 VSS.t62 sg13_lv_nmos ad=0.38p pd=2.38u as=0.68p ps=4.68u w=2u l=0.13u
X16 rf_out_n.t1 a_n4850_2214# a_n2502_n1000.t16 VSS.t48 sg13_lv_nmos ad=0.38p pd=2.38u as=0.38p ps=2.38u w=2u l=0.13u
X17 a_n2502_n1000.t23 a_368_464# rf_out_p.t5 VSS.t63 sg13_lv_nmos ad=0.38p pd=2.38u as=0.38p ps=2.38u w=2u l=0.13u
X18 a_n2502_n1000.t2 vbn_buf.t0 VSS.t8 VSS.t9 sg13_lv_nmos ad=0.95p pd=5.38u as=0.95p ps=5.38u w=5u l=0.5u
X19 VSS.t23 vbn_buf.t0 a_n2502_n1000.t6 VSS.t22 sg13_lv_nmos ad=0.95p pd=5.38u as=0.95p ps=5.38u w=5u l=0.5u
X20 VSS.t41 vbn_buf.t0 a_n2502_n1000.t12 VSS.t40 sg13_lv_nmos ad=0.95p pd=5.38u as=0.95p ps=5.38u w=5u l=0.5u
X21 VDD.t0 rf_out_p.t0 VSS.t60 rppd l=1.65u w=10u
X22 rf_out_p.t6 a_368_464# a_n2502_n1000.t23 VSS.t64 sg13_lv_nmos ad=0.38p pd=2.38u as=0.38p ps=2.38u w=2u l=0.13u
X23 a_n2502_n1000.t16 a_n4850_2214# rf_out_n.t0 VSS.t47 sg13_lv_nmos ad=0.38p pd=2.38u as=0.38p ps=2.38u w=2u l=0.13u
X24 a_n2502_n1000.t8 vbn_buf.t0 VSS.t26 VSS.t27 sg13_lv_nmos ad=0.95p pd=5.38u as=0.95p ps=5.38u w=5u l=0.5u
X25 a_368_464# rf_n cap_cmim l=10u w=10u
X26 VDD.t1 rf_out_n.t6 VSS.t61 rppd l=1.65u w=10u
X27 a_n2502_n1000.t24 a_368_464# rf_out_p.t6 VSS.t65 sg13_lv_nmos ad=0.38p pd=2.38u as=0.38p ps=2.38u w=2u l=0.13u
X28 rf_out_n.t0 a_n4850_2214# a_n2502_n1000.t15 VSS.t46 sg13_lv_nmos ad=0.38p pd=2.38u as=0.68p ps=4.68u w=2u l=0.13u
X29 a_n2502_n1000.t6 vbn_buf.t0 VSS.t20 VSS.t19 sg13_lv_nmos ad=0.95p pd=5.38u as=0.95p ps=5.38u w=5u l=0.5u
X30 a_n2502_n1000.t13 vbn_buf.t0 VSS.t41 VSS.t42 sg13_lv_nmos ad=0.95p pd=5.38u as=0.95p ps=5.38u w=5u l=0.5u
X31 vbg_buf.t1 a_368_464# VSS.t59 rhigh l=8u w=0.5u
X32 rf_out_p.t3 a_368_464# a_n2502_n1000.t24 VSS.t66 sg13_lv_nmos ad=0.38p pd=2.38u as=0.38p ps=2.38u w=2u l=0.13u
X33 a_n2502_n1000.t25 a_368_464# rf_out_p.t3 VSS.t67 sg13_lv_nmos ad=0.38p pd=2.38u as=0.38p ps=2.38u w=2u l=0.13u
X34 rf_out_p.t4 a_368_464# a_n2502_n1000.t25 VSS.t68 sg13_lv_nmos ad=0.38p pd=2.38u as=0.38p ps=2.38u w=2u l=0.13u
X35 VSS.t20 vbn_buf.t0 a_n2502_n1000.t5 VSS.t21 sg13_lv_nmos ad=0.95p pd=5.38u as=0.95p ps=5.38u w=5u l=0.5u
X36 VSS.t15 vbn_buf.t0 a_n2502_n1000.t4 VSS.t14 sg13_lv_nmos ad=0.95p pd=5.38u as=0.95p ps=5.38u w=5u l=0.5u
X37 a_n4850_2214# rf_p cap_cmim l=10u w=10u
X38 a_n2502_n1000.t1 vbn_buf.t0 VSS.t5 VSS.t6 sg13_lv_nmos ad=0.95p pd=5.38u as=0.95p ps=5.38u w=5u l=0.5u
X39 a_n2502_n1000.t9 vbn_buf.t0 VSS.t29 VSS.t30 sg13_lv_nmos ad=0.95p pd=5.38u as=0.95p ps=5.38u w=5u l=0.5u
X40 a_n2502_n1000.t10 vbn_buf.t0 VSS.t17 VSS.t31 sg13_lv_nmos ad=0.95p pd=5.38u as=0.95p ps=5.38u w=5u l=0.5u
X41 a_n2502_n1000.t21 a_n4850_2214# rf_out_n.t5 VSS.t57 sg13_lv_nmos ad=0.68p pd=4.68u as=0.38p ps=2.38u w=2u l=0.13u
X42 a_n2502_n1000.t26 a_368_464# rf_out_p.t4 VSS.t69 sg13_lv_nmos ad=0.38p pd=2.38u as=0.38p ps=2.38u w=2u l=0.13u
X43 a_n2502_n1000.t5 vbn_buf.t0 VSS.t15 VSS.t18 sg13_lv_nmos ad=0.95p pd=5.38u as=0.95p ps=5.38u w=5u l=0.5u
X44 rf_out_n.t5 a_n4850_2214# a_n2502_n1000.t20 VSS.t56 sg13_lv_nmos ad=0.38p pd=2.38u as=0.38p ps=2.38u w=2u l=0.13u
X45 rf_out_p.t1 a_368_464# a_n2502_n1000.t26 VSS.t70 sg13_lv_nmos ad=0.38p pd=2.38u as=0.38p ps=2.38u w=2u l=0.13u
X46 VSS.t5 vbn_buf.t0 a_n2502_n1000.t0 VSS.t4 sg13_lv_nmos ad=0.95p pd=5.38u as=0.95p ps=5.38u w=5u l=0.5u
X47 VSS.t8 vbn_buf.t0 a_n2502_n1000.t1 VSS.t7 sg13_lv_nmos ad=0.95p pd=5.38u as=0.95p ps=5.38u w=5u l=0.5u
X48 VSS.t29 vbn_buf.t0 a_n2502_n1000.t8 VSS.t28 sg13_lv_nmos ad=0.95p pd=5.38u as=0.95p ps=5.38u w=5u l=0.5u
X49 VSS.t17 vbn_buf.t0 a_n2502_n1000.t9 VSS.t16 sg13_lv_nmos ad=0.95p pd=5.38u as=0.95p ps=5.38u w=5u l=0.5u
X50 a_n2502_n1000.t14 vbn_buf.t0 VSS.t39 VSS.t43 sg13_lv_nmos ad=0.95p pd=5.38u as=0.95p ps=5.38u w=5u l=0.5u
X51 a_n2502_n1000.t20 a_n4850_2214# rf_out_n.t4 VSS.t55 sg13_lv_nmos ad=0.38p pd=2.38u as=0.38p ps=2.38u w=2u l=0.13u
X52 a_n2502_n1000.t27 a_368_464# rf_out_p.t1 VSS.t71 sg13_lv_nmos ad=0.38p pd=2.38u as=0.38p ps=2.38u w=2u l=0.13u
X53 rf_out_n.t4 a_n4850_2214# a_n2502_n1000.t19 VSS.t54 sg13_lv_nmos ad=0.38p pd=2.38u as=0.38p ps=2.38u w=2u l=0.13u
X54 rf_out_p.t2 a_368_464# a_n2502_n1000.t27 VSS.t72 sg13_lv_nmos ad=0.38p pd=2.38u as=0.38p ps=2.38u w=2u l=0.13u
X55 a_n2502_n1000.t28 a_368_464# rf_out_p.t2 VSS.t73 sg13_lv_nmos ad=0.68p pd=4.68u as=0.38p ps=2.38u w=2u l=0.13u
X56 VSS.t1 vbn_buf.t0 a_n2502_n1000.t3 VSS.t13 sg13_lv_nmos ad=0.95p pd=5.38u as=0.95p ps=5.38u w=5u l=0.5u
X57 VSS.t26 vbn_buf.t0 a_n2502_n1000.t7 VSS.t25 sg13_lv_nmos ad=0.95p pd=5.38u as=0.95p ps=5.38u w=5u l=0.5u
X58 VSS.t39 vbn_buf.t0 a_n2502_n1000.t13 VSS.t38 sg13_lv_nmos ad=0.95p pd=5.38u as=0.95p ps=5.38u w=5u l=0.5u
X59 VSS.t45 vbn_buf.t0 a_n2502_n1000.t14 VSS.t44 sg13_lv_nmos ad=1.7p pd=10.68u as=0.95p ps=5.38u w=5u l=0.5u
R0 vbn_buf vbn_buf.t0 21.8204
R1 rf_out_p.n0 rf_out_p.t5 6.56137
R2 rf_out_p.n1 rf_out_p.t2 6.52949
R3 rf_out_p.n1 rf_out_p.t1 6.52949
R4 rf_out_p.n0 rf_out_p.t4 6.52949
R5 rf_out_p.n0 rf_out_p.t3 6.52949
R6 rf_out_p.n0 rf_out_p.t6 6.52949
R7 rf_out_p.n2 rf_out_p.t0 1.62005
R8 rf_out_p rf_out_p.n2 1.37345
R9 rf_out_p.n1 rf_out_p.n0 0.128045
R10 rf_out_p.n2 rf_out_p.n1 0.117417
R11 rf_out_n.n0 rf_out_n.t5 6.56137
R12 rf_out_n.n0 rf_out_n.t4 6.52949
R13 rf_out_n.n0 rf_out_n.t3 6.52949
R14 rf_out_n.n1 rf_out_n.t2 6.52949
R15 rf_out_n.n1 rf_out_n.t1 6.52949
R16 rf_out_n.n1 rf_out_n.t0 6.52949
R17 rf_out_n.n2 rf_out_n.t6 1.62005
R18 rf_out_n rf_out_n.n2 1.37345
R19 rf_out_n.n1 rf_out_n.n0 0.128045
R20 rf_out_n.n2 rf_out_n.n1 0.117417
R21 VDD.n0 VDD.t0 4.22454
R22 VDD.n0 VDD.t1 0.517741
R23 VDD VDD.n0 0.338648
R24 vbg_buf.n0 vbg_buf.t1 40.1901
R25 vbg_buf.n0 vbg_buf.t0 33.1501
R26 vbg_buf vbg_buf.n0 0.293833
R27 VSS.t61 VSS.t58 773.446
R28 VSS.t60 VSS.t59 773.446
R29 VSS.n33 VSS.t61 281.341
R30 VSS.n56 VSS.t60 281.341
R31 VSS.n31 VSS.t10 38.3285
R32 VSS.t37 VSS.n13 38.3285
R33 VSS.n35 VSS.t6 36.3949
R34 VSS.t38 VSS.n54 36.3949
R35 VSS.t24 VSS.n22 34.4613
R36 VSS.n22 VSS.t25 34.4613
R37 VSS.t7 VSS.n35 32.5277
R38 VSS.n54 VSS.t42 32.5277
R39 VSS.t2 VSS.n33 31.9051
R40 VSS.n56 VSS.t44 31.9051
R41 VSS.t9 VSS.n31 30.5941
R42 VSS.n13 VSS.t40 30.5941
R43 VSS.t43 VSS.n11 29.5762
R44 VSS.n34 VSS.t4 29.5754
R45 VSS.n37 VSS.t47 29.4881
R46 VSS.t49 VSS.n28 29.4881
R47 VSS.n39 VSS.t51 29.4881
R48 VSS.t68 VSS.n17 29.4881
R49 VSS.n52 VSS.t70 29.4881
R50 VSS.t72 VSS.n14 29.4881
R51 VSS.t22 VSS.n43 28.6605
R52 VSS.n45 VSS.t27 28.6605
R53 VSS.t57 VSS.t19 28.5213
R54 VSS.t28 VSS.t62 28.5213
R55 VSS.t18 VSS.n25 28.0379
R56 VSS.n49 VSS.t16 28.0379
R57 VSS.t4 VSS.n32 25.709
R58 VSS.n55 VSS.t43 25.7081
R59 VSS.n53 VSS.t73 24.2588
R60 VSS.t46 VSS.n30 24.2579
R61 VSS.n40 VSS.t14 24.1707
R62 VSS.t31 VSS.n18 24.1707
R63 VSS.n44 VSS.t22 23.7754
R64 VSS.t27 VSS.n21 23.7745
R65 VSS.n38 VSS.t0 22.237
R66 VSS.t32 VSS.n16 22.237
R67 VSS.t40 VSS.n12 21.8418
R68 VSS.n36 VSS.t9 21.8409
R69 VSS.t54 VSS.n41 21.4094
R70 VSS.n24 VSS.t56 21.4094
R71 VSS.t63 VSS.n20 21.4094
R72 VSS.n47 VSS.t65 21.4094
R73 VSS.n36 VSS.t7 19.9082
R74 VSS.t42 VSS.n12 19.9073
R75 VSS.t48 VSS.n28 19.82
R76 VSS.n39 VSS.t50 19.82
R77 VSS.t52 VSS.n25 19.82
R78 VSS.n42 VSS.t54 19.82
R79 VSS.t56 VSS.n23 19.82
R80 VSS.n46 VSS.t63 19.82
R81 VSS.t65 VSS.n19 19.82
R82 VSS.n49 VSS.t67 19.82
R83 VSS.t69 VSS.n17 19.82
R84 VSS.n52 VSS.t71 19.82
R85 VSS.t25 VSS.n21 17.9746
R86 VSS.n44 VSS.t24 17.9737
R87 VSS.n57 VSS.n56 17.0005
R88 VSS.n57 VSS.n14 17.0005
R89 VSS.n57 VSS.n52 17.0005
R90 VSS.n57 VSS.n16 17.0005
R91 VSS.n57 VSS.n51 17.0005
R92 VSS.n57 VSS.n17 17.0005
R93 VSS.n57 VSS.n50 17.0005
R94 VSS.n57 VSS.n18 17.0005
R95 VSS.n57 VSS.n49 17.0005
R96 VSS.n57 VSS.n19 17.0005
R97 VSS.n57 VSS.n46 17.0005
R98 VSS.n57 VSS.n23 17.0005
R99 VSS.n57 VSS.n42 17.0005
R100 VSS.n57 VSS.n25 17.0005
R101 VSS.n57 VSS.n40 17.0005
R102 VSS.n57 VSS.n26 17.0005
R103 VSS.n57 VSS.n39 17.0005
R104 VSS.n57 VSS.n27 17.0005
R105 VSS.n57 VSS.n38 17.0005
R106 VSS.n57 VSS.n28 17.0005
R107 VSS.n57 VSS.n37 17.0005
R108 VSS.n57 VSS.n33 17.0005
R109 VSS VSS.n57 3.38758
R110 VSS.n37 VSS.t12 16.4362
R111 VSS.t35 VSS.n14 16.4362
R112 VSS.n55 VSS.t38 16.0409
R113 VSS.t6 VSS.n32 16.0401
R114 VSS.t21 VSS.t55 14.986
R115 VSS.t64 VSS.t30 14.986
R116 VSS.n42 VSS.t21 14.5026
R117 VSS.t30 VSS.n19 14.5026
R118 VSS.t10 VSS.n30 14.1073
R119 VSS.n53 VSS.t37 14.1065
R120 VSS.t50 VSS.n27 13.0524
R121 VSS.n40 VSS.t52 13.0524
R122 VSS.t67 VSS.n18 13.0524
R123 VSS.n51 VSS.t69 13.0524
R124 VSS.n34 VSS.t2 12.1737
R125 VSS.t44 VSS.n11 12.1729
R126 VSS.t47 VSS.n29 11.7414
R127 VSS.n41 VSS.t53 11.7414
R128 VSS.t55 VSS.n24 11.7414
R129 VSS.n43 VSS.t57 11.7414
R130 VSS.t62 VSS.n45 11.7414
R131 VSS.n20 VSS.t64 11.7414
R132 VSS.t66 VSS.n47 11.7414
R133 VSS.n15 VSS.t72 11.7414
R134 VSS.n29 VSS.t13 11.258
R135 VSS.t34 VSS.n15 11.258
R136 VSS.t0 VSS.n27 10.6354
R137 VSS.n51 VSS.t32 10.6354
R138 VSS.t13 VSS.t48 10.152
R139 VSS.t71 VSS.t34 10.152
R140 VSS.t14 VSS.n26 8.70176
R141 VSS.n50 VSS.t31 8.70176
R142 VSS.n57 VSS.n54 4.32273
R143 VSS.n57 VSS.n13 4.32273
R144 VSS.n57 VSS.n15 4.32273
R145 VSS.n57 VSS.n47 4.32273
R146 VSS.n57 VSS.n20 4.32273
R147 VSS.n57 VSS.n45 4.32273
R148 VSS.n57 VSS.n22 4.32273
R149 VSS.n57 VSS.n43 4.32273
R150 VSS.n57 VSS.n24 4.32273
R151 VSS.n57 VSS.n41 4.32273
R152 VSS.n57 VSS.n29 4.32273
R153 VSS.n57 VSS.n31 4.32273
R154 VSS.n57 VSS.n35 4.32273
R155 VSS.n5 VSS.n7 0.0782428
R156 VSS.n57 VSS.n8 1.11025
R157 VSS.n57 VSS.n4 1.02806
R158 VSS.n57 VSS.n10 1.11047
R159 VSS.n57 VSS.n1 1.02783
R160 VSS.t12 VSS.t46 3.38432
R161 VSS.n38 VSS.t49 3.38432
R162 VSS.t51 VSS.n26 3.38432
R163 VSS.n50 VSS.t68 3.38432
R164 VSS.t70 VSS.n16 3.38432
R165 VSS.t73 VSS.t35 3.38432
R166 VSS.n57 VSS.n5 1.50405
R167 VSS.n4 VSS.n3 0.0606977
R168 VSS.n1 VSS.n0 0.0613044
R169 VSS.n7 VSS.t45 1.61924
R170 VSS VSS.t3 1.58487
R171 VSS.n3 VSS.t29 1.47437
R172 VSS.n0 VSS.t8 1.47429
R173 VSS.n8 VSS.t33 1.47429
R174 VSS.n48 VSS.t17 1.4742
R175 VSS VSS.t5 1.47414
R176 VSS.n7 VSS.t39 1.47409
R177 VSS.n2 VSS.t23 1.47396
R178 VSS.n6 VSS.t36 1.47389
R179 VSS.n6 VSS.t41 1.47382
R180 VSS.n2 VSS.t20 1.47367
R181 VSS.n3 VSS.t26 1.47356
R182 VSS.n9 VSS.t1 1.47354
R183 VSS.n0 VSS.t11 1.47335
R184 VSS.n10 VSS.t15 1.47324
R185 VSS.t53 VSS.t18 1.45071
R186 VSS.t16 VSS.t66 1.45071
R187 VSS.n57 VSS.n11 1.17569
R188 VSS.n57 VSS.n55 1.17569
R189 VSS.n57 VSS.n12 1.17569
R190 VSS.n57 VSS.n53 1.17569
R191 VSS.n57 VSS.n21 1.17569
R192 VSS.n57 VSS.n44 1.17569
R193 VSS.n57 VSS.n30 1.17569
R194 VSS.n57 VSS.n36 1.17569
R195 VSS.n57 VSS.n32 1.17569
R196 VSS.n57 VSS.n34 1.17569
R197 VSS.t19 VSS.n23 0.967306
R198 VSS.n46 VSS.t28 0.967306
R199 VSS VSS.n0 0.180309
R200 VSS.n3 VSS.n2 0.145251
R201 VSS.n10 VSS.n2 0.134323
R202 VSS.n8 VSS.n6 0.133313
R203 VSS.n6 VSS.n5 0.117522
R204 VSS.n10 VSS.n9 0.0937261
R205 VSS.n48 VSS.n8 0.0937082
R206 VSS.n48 VSS.n4 0.124327
R207 VSS.n1 VSS.n9 0.123677
R208 a_n2502_n1000.n4 a_n2502_n1000.t18 3.17099
R209 a_n2502_n1000.n5 a_n2502_n1000.t25 3.17099
R210 a_n2502_n1000.n10 a_n2502_n1000.t22 2.79558
R211 a_n2502_n1000.n32 a_n2502_n1000.t16 2.79551
R212 a_n2502_n1000.n23 a_n2502_n1000.t15 2.79551
R213 a_n2502_n1000.n24 a_n2502_n1000.t17 2.79551
R214 a_n2502_n1000.n25 a_n2502_n1000.t19 2.79551
R215 a_n2502_n1000.n26 a_n2502_n1000.t20 2.79551
R216 a_n2502_n1000.n19 a_n2502_n1000.t23 2.79551
R217 a_n2502_n1000.n11 a_n2502_n1000.t24 2.79551
R218 a_n2502_n1000.n12 a_n2502_n1000.t26 2.79551
R219 a_n2502_n1000.n13 a_n2502_n1000.t27 2.79551
R220 a_n2502_n1000.n27 a_n2502_n1000.t21 2.79543
R221 a_n2502_n1000.n14 a_n2502_n1000.t28 2.79543
R222 a_n2502_n1000.t14 a_n2502_n1000.n8 2.61386
R223 a_n2502_n1000.n1 a_n2502_n1000.t0 2.61062
R224 a_n2502_n1000.n8 a_n2502_n1000.t12 2.56233
R225 a_n2502_n1000.n7 a_n2502_n1000.t11 2.56233
R226 a_n2502_n1000.n1 a_n2502_n1000.t2 2.56233
R227 a_n2502_n1000.n7 a_n2502_n1000.t10 2.56173
R228 a_n2502_n1000.n1 a_n2502_n1000.t1 2.56173
R229 a_n2502_n1000.n2 a_n2502_n1000.t4 2.56173
R230 a_n2502_n1000.n8 a_n2502_n1000.t13 2.56161
R231 a_n2502_n1000.n2 a_n2502_n1000.t5 2.56161
R232 a_n2502_n1000.n1 a_n2502_n1000.t3 2.56161
R233 a_n2502_n1000.n2 a_n2502_n1000.t9 2.56147
R234 a_n2502_n1000.n2 a_n2502_n1000.t7 2.56147
R235 a_n2502_n1000.n2 a_n2502_n1000.t8 2.56146
R236 a_n2502_n1000.n2 a_n2502_n1000.t6 2.56146
R237 a_n2502_n1000.n20 a_n2502_n1000.n10 2.36008
R238 a_n2502_n1000.n27 a_n2502_n1000.n21 2.35974
R239 a_n2502_n1000.n14 a_n2502_n1000.n0 2.35974
R240 a_n2502_n1000.n33 a_n2502_n1000.n23 2.35957
R241 a_n2502_n1000.n33 a_n2502_n1000.n32 2.33977
R242 a_n2502_n1000.n26 a_n2502_n1000.n21 2.33977
R243 a_n2502_n1000.n20 a_n2502_n1000.n19 2.33977
R244 a_n2502_n1000.n13 a_n2502_n1000.n0 2.33977
R245 a_n2502_n1000.n24 a_n2502_n1000.n22 2.31337
R246 a_n2502_n1000.n25 a_n2502_n1000.n3 2.31337
R247 a_n2502_n1000.n11 a_n2502_n1000.n9 2.31337
R248 a_n2502_n1000.n12 a_n2502_n1000.n0 2.31337
R249 a_n2502_n1000.n31 a_n2502_n1000.n23 0.748603
R250 a_n2502_n1000.n28 a_n2502_n1000.n27 0.74842
R251 a_n2502_n1000.n15 a_n2502_n1000.n14 0.74842
R252 a_n2502_n1000.n18 a_n2502_n1000.n10 0.74808
R253 a_n2502_n1000.n32 a_n2502_n1000.n31 0.561603
R254 a_n2502_n1000.n30 a_n2502_n1000.n24 0.561603
R255 a_n2502_n1000.n29 a_n2502_n1000.n25 0.561603
R256 a_n2502_n1000.n28 a_n2502_n1000.n26 0.561603
R257 a_n2502_n1000.n19 a_n2502_n1000.n18 0.561603
R258 a_n2502_n1000.n17 a_n2502_n1000.n11 0.561603
R259 a_n2502_n1000.n16 a_n2502_n1000.n12 0.561603
R260 a_n2502_n1000.n15 a_n2502_n1000.n13 0.561603
R261 a_n2502_n1000.n4 a_n2502_n1000.n3 0.401975
R262 a_n2502_n1000.n5 a_n2502_n1000.n0 0.401975
R263 a_n2502_n1000.n5 a_n2502_n1000.n16 0.284179
R264 a_n2502_n1000.n4 a_n2502_n1000.n29 0.284179
R265 a_n2502_n1000.n1 a_n2502_n1000.n33 0.25306
R266 a_n2502_n1000.n6 a_n2502_n1000.n21 0.0449208
R267 a_n2502_n1000.n2 a_n2502_n1000.n20 0.25306
R268 a_n2502_n1000.n2 a_n2502_n1000.n6 0.203345
R269 a_n2502_n1000.n2 a_n2502_n1000.n1 0.196551
R270 a_n2502_n1000.n7 a_n2502_n1000.n0 0.194161
R271 a_n2502_n1000.n31 a_n2502_n1000.n30 0.1875
R272 a_n2502_n1000.n30 a_n2502_n1000.n4 0.1875
R273 a_n2502_n1000.n29 a_n2502_n1000.n28 0.1875
R274 a_n2502_n1000.n18 a_n2502_n1000.n17 0.1875
R275 a_n2502_n1000.n17 a_n2502_n1000.n5 0.1875
R276 a_n2502_n1000.n16 a_n2502_n1000.n15 0.1875
R277 a_n2502_n1000.n9 a_n2502_n1000.n0 0.153033
R278 a_n2502_n1000.n22 a_n2502_n1000.n3 0.153033
R279 a_n2502_n1000.n8 a_n2502_n1000.n7 0.147538
R280 a_n2502_n1000.n7 a_n2502_n1000.n2 0.147538
R281 a_n2502_n1000.n33 a_n2502_n1000.n22 0.106833
R282 a_n2502_n1000.n3 a_n2502_n1000.n6 0.0449208
R283 a_n2502_n1000.n20 a_n2502_n1000.n9 0.106833
C0 rf_out_n a_n4200_1300# 0.69013f
C1 a_368_464# a_2200_1300# 0.04749f
C2 VDD rf_p 0.09697f
C3 vbn_buf a_368_464# 0.01754f
C4 VDD a_368_464# 0.53338f
C5 a_n4850_2214# vbn_buf 0.01754f
C6 a_n4850_2214# a_n4850_2300# 0.03458f
C7 a_n4850_2214# rf_p 1.64409f
C8 a_n4850_2214# VDD 0.53338f
C9 rf_out_p a_2200_1300# 0.69013f
C10 rf_n rf_p 0.03659f
C11 vbg_buf a_n4850_2300# 0.04459f
C12 rf_n VDD 0.09697f
C13 vbg_buf rf_p 0.56344f
C14 a_n4850_2214# a_368_464# 0.19327f
C15 vbn_buf rf_out_p 0.20801f
C16 rf_n a_368_464# 1.64409f
C17 rf_out_p VDD 0.39724f
C18 vbg_buf a_368_464# 0.05435f
C19 rf_out_p a_368_464# 0.91597f
C20 a_4750_2300# a_368_464# 0.03458f
C21 vbg_buf a_n4850_2214# 0.05435f
C22 vbg_buf rf_n 0.56344f
C23 rf_out_p rf_n 0.07918f
C24 a_n4200_1300# VDD 0.32168f
C25 vbg_buf a_4750_2300# 0.04459f
C26 a_n4850_2214# a_n4200_1300# 0.04749f
C27 rf_out_n vbn_buf 0.28739f
C28 rf_out_n rf_p 0.07918f
C29 rf_out_n VDD 0.39724f
C30 rf_out_n a_n4850_2214# 0.91597f
C31 rf_out_n rf_out_p 0.01393f
C32 VDD a_2200_1300# 0.32168f
C33 rf_n VSS 1.91868f
C34 rf_p VSS 1.91868f
C35 vbn_buf VSS 19.18742f
C36 rf_out_p VSS 4.0516f
C37 rf_out_n VSS 3.91747f
C38 VDD VSS 6.27275f
C39 vbg_buf VSS 4.04247f
C40 a_n2502_n1000.n0 VSS 0.65385f
C41 a_n2502_n1000.n1 VSS 2.17667f
C42 a_n2502_n1000.n2 VSS 3.70874f
C43 a_n2502_n1000.n3 VSS 0.33653f
C44 a_n2502_n1000.n4 VSS 0.10168f
C45 a_n2502_n1000.n5 VSS 0.10168f
C46 a_n2502_n1000.n7 VSS 1.48859f
C47 a_n2502_n1000.n8 VSS 1.46217f
C48 a_n2502_n1000.n9 VSS 0.08988f
C49 a_n2502_n1000.t22 VSS 3.00632f
C50 a_n2502_n1000.n10 VSS 0.05198f
C51 a_n2502_n1000.t24 VSS 0.33772f
C52 a_n2502_n1000.n11 VSS 0.039f
C53 a_n2502_n1000.t25 VSS 0.07685f
C54 a_n2502_n1000.t26 VSS 0.07214f
C55 a_n2502_n1000.n12 VSS 0.039f
C56 a_n2502_n1000.t27 VSS 0.07214f
C57 a_n2502_n1000.n13 VSS 0.03978f
C58 a_n2502_n1000.t28 VSS 0.06461f
C59 a_n2502_n1000.n14 VSS 0.05198f
C60 a_n2502_n1000.n15 VSS 0.10133f
C61 a_n2502_n1000.n16 VSS 0.06662f
C62 a_n2502_n1000.n17 VSS 0.06662f
C63 a_n2502_n1000.n18 VSS 0.10133f
C64 a_n2502_n1000.t23 VSS 0.07214f
C65 a_n2502_n1000.n19 VSS 0.03978f
C66 a_n2502_n1000.n20 VSS 0.31733f
C67 a_n2502_n1000.n21 VSS 0.31732f
C68 a_n2502_n1000.n22 VSS 0.08988f
C69 a_n2502_n1000.t15 VSS 0.06461f
C70 a_n2502_n1000.n23 VSS 0.05198f
C71 a_n2502_n1000.t17 VSS 0.07214f
C72 a_n2502_n1000.n24 VSS 0.039f
C73 a_n2502_n1000.t18 VSS 0.34243f
C74 a_n2502_n1000.t19 VSS 3.01386f
C75 a_n2502_n1000.n25 VSS 0.039f
C76 a_n2502_n1000.t20 VSS 0.07214f
C77 a_n2502_n1000.n26 VSS 0.03978f
C78 a_n2502_n1000.t21 VSS 0.06461f
C79 a_n2502_n1000.n27 VSS 0.05198f
C80 a_n2502_n1000.n28 VSS 0.10133f
C81 a_n2502_n1000.n29 VSS 0.06662f
C82 a_n2502_n1000.n30 VSS 0.06662f
C83 a_n2502_n1000.n31 VSS 0.10133f
C84 a_n2502_n1000.t16 VSS 0.07214f
C85 a_n2502_n1000.n32 VSS 0.03978f
C86 a_n2502_n1000.n33 VSS 0.31732f
C87 a_n2502_n1000.t0 VSS 2.64462f
C88 a_n2502_n1000.t1 VSS 0.2258f
C89 a_n2502_n1000.t2 VSS 0.2258f
C90 a_n2502_n1000.t3 VSS 0.2258f
C91 a_n2502_n1000.t4 VSS 0.2258f
C92 a_n2502_n1000.t5 VSS 0.2258f
C93 a_n2502_n1000.t6 VSS 0.2258f
C94 a_n2502_n1000.t7 VSS 0.2258f
C95 a_n2502_n1000.t8 VSS 0.2258f
C96 a_n2502_n1000.t9 VSS 0.2258f
C97 a_n2502_n1000.t10 VSS 0.2258f
C98 a_n2502_n1000.t11 VSS 0.2258f
C99 a_n2502_n1000.t12 VSS 0.2258f
C100 a_n2502_n1000.t13 VSS 0.2258f
C101 a_n2502_n1000.t14 VSS 0.23204f
C102 VSS.t3 VSS 2.41253f
C103 vbg_buf.t0 VSS 0.54433f
C104 vbg_buf.t1 VSS 0.6544f
C105 vbg_buf.n0 VSS 1.16384f
C106 VDD.t0 VSS 2.00384f
C107 VDD.t1 VSS 0.98799f
C108 VDD.n0 VSS 1.08147f
C109 rf_out_n.n0 VSS 0.83221f
C110 rf_out_n.n1 VSS 1.30272f
C111 rf_out_n.t5 VSS 0.10482f
C112 rf_out_n.t4 VSS 0.10382f
C113 rf_out_n.t3 VSS 3.04554f
C114 rf_out_n.t2 VSS 0.3694f
C115 rf_out_n.t1 VSS 0.10382f
C116 rf_out_n.t0 VSS 0.10382f
C117 rf_out_n.t6 VSS 1.67761f
C118 rf_out_n.n2 VSS 3.90785f
C119 rf_out_p.n0 VSS 1.13456f
C120 rf_out_p.n1 VSS 0.9787f
C121 rf_out_p.t5 VSS 3.04547f
C122 rf_out_p.t6 VSS 0.10277f
C123 rf_out_p.t3 VSS 0.36835f
C124 rf_out_p.t4 VSS 0.10277f
C125 rf_out_p.t1 VSS 0.10277f
C126 rf_out_p.t2 VSS 0.10277f
C127 rf_out_p.t0 VSS 1.66864f
C128 rf_out_p.n2 VSS 3.86818f
.ends

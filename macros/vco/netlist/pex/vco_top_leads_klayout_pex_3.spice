* Capacitances rebuilt per net pair from the C-coupled extraction vco_top_leads_CC.spice (magic#557):
* 0.5547 pF in 160 net pairs, the full-RC run had 0.6629 pF, 0.0 fF of it between pairs without coupling.
* NGSPICE file created from vco_top_leads.ext - technology: ihp-sg13g2

.subckt vco_top_leads di_en vtune VDD VSS rf_out_p rf_out_n vco_ind_LA
+ vco_ind_LB vco_ind_LC vco_var_rf_p vco_var_rf_n vco_var_VSS
X0 VSS.t134 vco_var_rf_p.t7 vco_var_rf_n.t4 VSS.t133 sg13_lv_nmos ad=0.68p pd=4.68u as=0.38p ps=2.38u w=2u l=0.13u
X1 VSS.t164 vco_var_rf_n.t7 vco_var_rf_p.t0 VSS.t163 sg13_lv_nmos ad=0.68p pd=4.68u as=0.38p ps=2.38u w=2u l=0.13u
X2 a_20954_346.t7 vco_feed_0.en_b.t2 VDD.t17 VDD.t3 sg13_lv_pmos ad=0.57p pd=3.38u as=0.57p ps=3.38u w=3u l=0.13u
X3 VDD.t13 vco_feed_0.en_b.t2 a_20954_346.t4 VDD.t3 sg13_lv_pmos ad=0.57p pd=3.38u as=0.57p ps=3.38u w=3u l=0.13u
X4 VSS.t115 VSS.t112 VSS.t114 VSS.t113 sg13_lv_nmos ad=0.85p pd=5.68u as=0 ps=0 w=2.5u l=0.5u
X5 VDD.t19 vco_feed_0.en_b.t2 a_20954_346.t7 VDD.t3 sg13_lv_pmos ad=0.57p pd=3.38u as=0.57p ps=3.38u w=3u l=0.13u
X6 a_20954_346.t5 vco_feed_0.en_b.t2 VDD.t13 VDD.t3 sg13_lv_pmos ad=0.57p pd=3.38u as=0.57p ps=3.38u w=3u l=0.13u
X7 rf_out_n.t3 vco_buf_in_p.t1 a_11798_1180.t26 VSS.t178 sg13_lv_nmos ad=0.38p pd=2.38u as=0.38p ps=2.38u w=2u l=0.13u
X8 VDD.t28 vco_feed_0.en_b.t2 a_20954_346.t10 VDD.t3 sg13_lv_pmos ad=0.57p pd=3.38u as=0.57p ps=3.38u w=3u l=0.13u
X9 a_20954_346.t8 vco_feed_0.en_b.t2 VDD.t19 VDD.t3 sg13_lv_pmos ad=0.57p pd=3.38u as=0.57p ps=3.38u w=3u l=0.13u
X10 rf_out_n.t5 vco_buf_in_p.t1 a_11798_1180.t24 VSS.t174 sg13_lv_nmos ad=0.38p pd=2.38u as=0.38p ps=2.38u w=2u l=0.13u
X11 VSS.t55 vco_bias_0.vbn_buf.t2 a_11798_1180.t12 VSS.t54 sg13_lv_nmos ad=0.95p pd=5.38u as=0.95p ps=5.38u w=5u l=0.5u
X12 a_11798_1180.t10 vco_bias_0.vbn_buf.t2 VSS.t46 VSS.t45 sg13_lv_nmos ad=0.95p pd=5.38u as=0.95p ps=5.38u w=5u l=0.5u
X13 a_11798_1180.t0 vco_bias_0.vbn_buf.t2 VSS.t17 VSS.t16 sg13_lv_nmos ad=0.95p pd=5.38u as=1.7p ps=10.68u w=5u l=0.5u
X14 VSS.t66 vco_bias_0.vbn_buf.t3 VSS.t64 VSS.t65 sg13_lv_nmos ad=1.52p pd=8.38u as=0 ps=0 w=8u l=10u
X15 a_5060_3002.t2 a_5060_3002.t1 VSS.t5 VSS.t4 sg13_lv_nmos ad=0.85p pd=5.68u as=0.85p ps=5.68u w=2.5u l=0.5u
X16 VSS.t70 vco_bias_0.vbn_buf.t3 VSS.t68 VSS.t69 sg13_lv_nmos ad=1.52p pd=8.38u as=0 ps=0 w=8u l=10u
X17 VSS.t28 vco_bias_0.vbn_buf.t2 a_11798_1180.t3 VSS.t27 sg13_lv_nmos ad=0.95p pd=5.38u as=0.95p ps=5.38u w=5u l=0.5u
X18 VSS.t128 vco_var_rf_p.t7 vco_var_rf_n.t0 VSS.t127 sg13_lv_nmos ad=0.38p pd=2.38u as=0.38p ps=2.38u w=2u l=0.13u
X19 vco_bias_0.vbn_buf.t0 vco_feed_0.en_b.t3 VSS.t7 VSS.t6 sg13_lv_nmos ad=0.34p pd=2.68u as=0.34p ps=2.68u w=1u l=0.13u
X20 a_11798_1180.t17 vco_buf_in_n.t1 rf_out_p.t3 VSS.t140 sg13_lv_nmos ad=0.38p pd=2.38u as=0.38p ps=2.38u w=2u l=0.13u
X21 VSS.t78 vco_bias_0.vbn_buf.t4 VSS.t76 VSS.t67 sg13_lv_nmos ad=1.52p pd=8.38u as=0 ps=0 w=8u l=10u
X22 a_20954_346.t11 vco_feed_0.en_b.t2 VDD.t28 VDD.t3 sg13_lv_pmos ad=0.57p pd=3.38u as=0.57p ps=3.38u w=3u l=0.13u
X23 VDD.t21 vco_feed_0.en_b.t2 a_20954_346.t8 VDD.t3 sg13_lv_pmos ad=0.57p pd=3.38u as=0.57p ps=3.38u w=3u l=0.13u
X24 rf_out_p.t2 vco_buf_in_n.t1 a_11798_1180.t15 VSS.t137 sg13_lv_nmos ad=0.38p pd=2.38u as=0.68p ps=4.68u w=2u l=0.13u
X25 VSS.t88 vco_bias_0.vbg_buf VSS.t87 VSS.t62 sg13_lv_nmos ad=2.72p pd=16.68u as=0 ps=0 w=8u l=10u
X26 a_5948_4416.t1 vco_feed_0.en_b.t7 VDD.t36 VDD.t0 sg13_lv_pmos ad=0.34p pd=2.68u as=0.34p ps=2.68u w=1u l=0.13u
X27 VSS.t104 vco_bias_0.vbg_buf VSS.t102 VSS.t69 sg13_lv_nmos ad=1.52p pd=8.38u as=0 ps=0 w=8u l=10u
X28 a_5560_5708.t1 a_5560_3922.t0 VSS.t107 rppd l=8.5u w=0.5u
X29 a_5060_3002.t0 vco_feed_0.en_b.t4 VSS.t15 VSS.t14 sg13_lv_nmos ad=0.34p pd=2.68u as=0.34p ps=2.68u w=1u l=0.13u
X30 VSS.t155 vco_var_rf_n.t7 vco_var_rf_p.t2 VSS.t154 sg13_lv_nmos ad=0.38p pd=2.38u as=0.38p ps=2.38u w=2u l=0.13u
X31 vco_var_rf_n.t1 vco_var_rf_p.t7 VSS.t128 VSS.t129 sg13_lv_nmos ad=0.38p pd=2.38u as=0.38p ps=2.38u w=2u l=0.13u
X32 vco_var_rf_n.t3 vco_var_rf_p.t7 VSS.t122 VSS.t123 sg13_lv_nmos ad=0.38p pd=2.38u as=0.38p ps=2.38u w=2u l=0.13u
X33 vco_bias_0.vbg_buf a_5560_5708.t2 VSS.t118 rhigh l=32u w=0.5u
X34 vco_var_rf_p.t4 vco_var_rf_n.t7 VSS.t158 VSS.t159 sg13_lv_nmos ad=0.38p pd=2.38u as=0.38p ps=2.38u w=2u l=0.13u
X35 vco_feed_0.en_b.t0 di_en.t0 VSS.t167 VSS.t166 sg13_lv_nmos ad=0.17p pd=1.68u as=0.17p ps=1.68u w=0.5u l=0.13u
X36 VDD.t25 vco_feed_0.en_b.t2 a_20954_346.t11 VDD.t3 sg13_lv_pmos ad=0.57p pd=3.38u as=0.57p ps=3.38u w=3u l=0.13u
X37 a_20954_346.t9 vco_feed_0.en_b.t2 VDD.t21 VDD.t3 sg13_lv_pmos ad=0.57p pd=3.38u as=0.57p ps=3.38u w=3u l=0.13u
X38 a_11798_1180.t20 vco_buf_in_n.t1 rf_out_p.t0 VSS.t146 sg13_lv_nmos ad=0.38p pd=2.38u as=0.38p ps=2.38u w=2u l=0.13u
X39 VSS.t102 vco_bias_0.vbg_buf VSS.t100 VSS.t67 sg13_lv_nmos ad=1.52p pd=8.38u as=0 ps=0 w=8u l=10u
X40 VSS.t46 vco_bias_0.vbn_buf.t2 a_11798_1180.t9 VSS.t49 sg13_lv_nmos ad=0.95p pd=5.38u as=0.95p ps=5.38u w=5u l=0.5u
X41 vco_bias_0.vbg_buf VSS.t83 cap_cmim l=19.1u w=17.5u
X42 VSS.t19 vco_bias_0.vbn_buf.t2 a_11798_1180.t0 VSS.t18 sg13_lv_nmos ad=0.95p pd=5.38u as=0.95p ps=5.38u w=5u l=0.5u
X43 a_11798_1180.t13 vco_bias_0.vbn_buf.t2 VSS.t55 VSS.t56 sg13_lv_nmos ad=0.95p pd=5.38u as=0.95p ps=5.38u w=5u l=0.5u
X44 vco_bias_0.vbn_buf.t1 a_5060_3002.t3 VSS.t136 rhigh l=32u w=0.5u
X45 a_11798_1180.t14 vco_bias_0.vbn_buf.t2 VSS.t58 VSS.t59 sg13_lv_nmos ad=0.95p pd=5.38u as=0.95p ps=5.38u w=5u l=0.5u
X46 a_20954_346.t12 vco_feed_0.en_b.t2 VDD.t25 VDD.t3 sg13_lv_pmos ad=0.57p pd=3.38u as=0.57p ps=3.38u w=3u l=0.13u
X47 VDD.t23 vco_feed_0.en_b.t2 a_20954_346.t9 VDD.t3 sg13_lv_pmos ad=0.57p pd=3.38u as=0.57p ps=3.38u w=3u l=0.13u
X48 VDD.t27 vco_feed_0.en_b.t2 a_20954_346.t12 VDD.t3 sg13_lv_pmos ad=0.57p pd=3.38u as=0.57p ps=3.38u w=3u l=0.13u
X49 a_20954_346.t10 vco_feed_0.en_b.t2 VDD.t23 VDD.t3 sg13_lv_pmos ad=0.57p pd=3.38u as=0.57p ps=3.38u w=3u l=0.13u
X50 VSS.t68 vco_bias_0.vbn_buf.t3 VSS.t66 VSS.t67 sg13_lv_nmos ad=1.52p pd=8.38u as=0 ps=0 w=8u l=10u
X51 a_11798_1180.t27 vco_buf_in_p.t1 rf_out_n.t3 VSS.t179 sg13_lv_nmos ad=0.38p pd=2.38u as=0.38p ps=2.38u w=2u l=0.13u
X52 VDD.t35 vco_feed_0.en_b.t2 a_20954_346.t15 VDD.t3 sg13_lv_pmos ad=1.02p pd=6.68u as=0.57p ps=3.38u w=3u l=0.13u
X53 a_20954_346.t13 vco_feed_0.en_b.t2 VDD.t27 VDD.t3 sg13_lv_pmos ad=0.57p pd=3.38u as=0.57p ps=3.38u w=3u l=0.13u
X54 a_11798_1180.t4 vco_bias_0.vbn_buf.t2 VSS.t28 VSS.t29 sg13_lv_nmos ad=0.95p pd=5.38u as=0.95p ps=5.38u w=5u l=0.5u
X55 a_11798_1180.t25 vco_buf_in_p.t1 rf_out_n.t5 VSS.t175 sg13_lv_nmos ad=0.38p pd=2.38u as=0.38p ps=2.38u w=2u l=0.13u
X56 VSS.t90 vco_bias_0.vbg_buf VSS.t88 VSS.t65 sg13_lv_nmos ad=1.52p pd=8.38u as=0 ps=0 w=8u l=10u
X57 VSS.t40 vco_bias_0.vbn_buf.t2 a_11798_1180.t7 VSS.t39 sg13_lv_nmos ad=0.95p pd=5.38u as=0.95p ps=5.38u w=5u l=0.5u
X58 VSS.t106 vco_bias_0.vbg_buf VSS.t104 VSS.t71 sg13_lv_nmos ad=1.52p pd=8.38u as=0 ps=0 w=8u l=10u
X59 VDD.t45 VDD.t43 VDD.t44 VDD.t0 sg13_lv_pmos ad=1.7p pd=10.68u as=0 ps=0 w=5u l=0.5u
X60 VSS.t58 vco_bias_0.vbn_buf.t2 a_11798_1180.t13 VSS.t57 sg13_lv_nmos ad=0.95p pd=5.38u as=0.95p ps=5.38u w=5u l=0.5u
X61 VSS.t131 vco_var_rf_p.t7 vco_var_rf_n.t1 VSS.t130 sg13_lv_nmos ad=0.38p pd=2.38u as=0.38p ps=2.38u w=2u l=0.13u
X62 VSS.t61 vco_bias_0.vbn_buf.t2 a_11798_1180.t14 VSS.t60 sg13_lv_nmos ad=1.7p pd=10.68u as=0.95p ps=5.38u w=5u l=0.5u
X63 VSS.t74 vco_bias_0.vbn_buf.t4 VSS.t73 VSS.t62 sg13_lv_nmos ad=2.72p pd=16.68u as=0 ps=0 w=8u l=10u
X64 VSS.t161 vco_var_rf_n.t7 vco_var_rf_p.t4 VSS.t160 sg13_lv_nmos ad=0.38p pd=2.38u as=0.38p ps=2.38u w=2u l=0.13u
X65 VDD.t32 vco_feed_0.en_b.t2 a_20954_346.t13 VDD.t3 sg13_lv_pmos ad=0.57p pd=3.38u as=0.57p ps=3.38u w=3u l=0.13u
X66 VDD.t42 VDD.t40 VDD.t41 VDD.t0 sg13_lv_pmos ad=0.34p pd=2.68u as=0 ps=0 w=1u l=0.13u
X67 VDD.t39 rf_out_p.t6 VSS.t116 rppd l=1.65u w=10u
X68 a_6568_6136.t0 a_5948_4416.t2 VDD.t38 VDD.t0 sg13_lv_pmos ad=0.34p pd=2.68u as=0.34p ps=2.68u w=1u l=0.13u
X69 a_20954_346.t14 vco_feed_0.en_b.t2 VDD.t32 VDD.t3 sg13_lv_pmos ad=0.57p pd=3.38u as=0.57p ps=3.38u w=3u l=0.13u
X70 rf_out_p.t1 vco_buf_in_n.t1 a_11798_1180.t20 VSS.t147 sg13_lv_nmos ad=0.38p pd=2.38u as=0.38p ps=2.38u w=2u l=0.13u
X71 vco_feed_0.en_b.t1 di_en.t1 VDD.t50 VDD.t0 sg13_lv_pmos ad=0.34p pd=2.68u as=0.34p ps=2.68u w=1u l=0.13u
X72 a_11798_1180.t7 vco_bias_0.vbn_buf.t2 VSS.t37 VSS.t38 sg13_lv_nmos ad=0.95p pd=5.38u as=0.95p ps=5.38u w=5u l=0.5u
X73 rf_out_p.t5 vco_buf_in_n.t1 a_11798_1180.t18 VSS.t143 sg13_lv_nmos ad=0.38p pd=2.38u as=0.38p ps=2.38u w=2u l=0.13u
X74 VSS.t82 vco_bias_0.vbn_buf.t4 VSS.t80 VSS.t71 sg13_lv_nmos ad=1.52p pd=8.38u as=0 ps=0 w=8u l=10u
X75 vco_var_rf_p.t3 vco_var_rf_n.t7 VSS.t155 VSS.t156 sg13_lv_nmos ad=0.38p pd=2.38u as=0.38p ps=2.38u w=2u l=0.13u
X76 VSS.t48 vco_bias_0.vbn_buf.t2 a_11798_1180.t10 VSS.t50 sg13_lv_nmos ad=0.95p pd=5.38u as=0.95p ps=5.38u w=5u l=0.5u
X77 a_11798_1180.t8 vco_bias_0.vbn_buf.t2 VSS.t40 VSS.t41 sg13_lv_nmos ad=0.95p pd=5.38u as=0.95p ps=5.38u w=5u l=0.5u
X78 vco_var_rf_p.t1 vco_var_rf_n.t7 VSS.t150 VSS.t149 sg13_lv_nmos ad=0.38p pd=2.38u as=0.68p ps=4.68u w=2u l=0.13u
X79 VSS.t52 vco_bias_0.vbn_buf.t2 a_11798_1180.t11 VSS.t51 sg13_lv_nmos ad=0.95p pd=5.38u as=0.95p ps=5.38u w=5u l=0.5u
X80 VSS.t125 vco_var_rf_p.t7 vco_var_rf_n.t3 VSS.t124 sg13_lv_nmos ad=0.38p pd=2.38u as=0.38p ps=2.38u w=2u l=0.13u
X81 VDD.t26 vco_feed_0.en_b.t2 a_20954_346.t14 VDD.t3 sg13_lv_pmos ad=0.57p pd=3.38u as=0.57p ps=3.38u w=3u l=0.13u
X82 rf_out_n.t0 vco_buf_in_p.t1 a_11798_1180.t22 VSS.t170 sg13_lv_nmos ad=0.38p pd=2.38u as=0.68p ps=4.68u w=2u l=0.13u
X83 a_5560_5708.t0 a_6568_6136.t4 VDD.t2 VDD.t0 sg13_lv_pmos ad=1.7p pd=10.68u as=1.7p ps=10.68u w=5u l=0.5u
X84 VSS.t152 vco_var_rf_n.t7 vco_var_rf_p.t1 VSS.t151 sg13_lv_nmos ad=0.38p pd=2.38u as=0.38p ps=2.38u w=2u l=0.13u
X85 VSS.t64 vco_bias_0.vbn_buf.t3 VSS.t63 VSS.t62 sg13_lv_nmos ad=2.72p pd=16.68u as=0 ps=0 w=8u l=10u
X86 a_20954_346.t15 vco_feed_0.en_b.t2 VDD.t26 VDD.t3 sg13_lv_pmos ad=0.57p pd=3.38u as=0.57p ps=3.38u w=3u l=0.13u
X87 rf_out_n.t1 vco_buf_in_p.t1 a_11798_1180.t27 VSS.t180 sg13_lv_nmos ad=0.38p pd=2.38u as=0.38p ps=2.38u w=2u l=0.13u
X88 VSS.t98 vco_bias_0.vbg_buf VSS.t97 VSS.t62 sg13_lv_nmos ad=2.72p pd=16.68u as=0 ps=0 w=8u l=10u
X89 rf_out_n.t2 vco_buf_in_p.t1 a_11798_1180.t25 VSS.t176 sg13_lv_nmos ad=0.38p pd=2.38u as=0.38p ps=2.38u w=2u l=0.13u
X90 a_5060_5708.t0 vco_feed_0.en_b.t6 VDD.t37 VDD.t0 sg13_lv_pmos ad=0.68p pd=4.68u as=0.68p ps=4.68u w=2u l=0.13u
X91 VSS.t22 vco_bias_0.vbn_buf.t2 a_11798_1180.t1 VSS.t21 sg13_lv_nmos ad=0.95p pd=5.38u as=0.95p ps=5.38u w=5u l=0.5u
X92 VDD.t5 vco_feed_0.en_b.t2 a_20954_346.t0 VDD.t3 sg13_lv_pmos ad=0.57p pd=3.38u as=0.57p ps=3.38u w=3u l=0.13u
X93 a_11798_1180.t5 vco_bias_0.vbn_buf.t2 VSS.t31 VSS.t32 sg13_lv_nmos ad=0.95p pd=5.38u as=0.95p ps=5.38u w=5u l=0.5u
X94 a_11798_1180.t11 vco_bias_0.vbn_buf.t2 VSS.t48 VSS.t47 sg13_lv_nmos ad=0.95p pd=5.38u as=0.95p ps=5.38u w=5u l=0.5u
X95 a_11798_1180.t12 vco_bias_0.vbn_buf.t2 VSS.t52 VSS.t53 sg13_lv_nmos ad=0.95p pd=5.38u as=0.95p ps=5.38u w=5u l=0.5u
X96 vco_buf_in_p vco_var_rf_p.t5 cap_cmim l=10u w=10u
X97 a_20954_346.t1 vco_feed_0.en_b.t2 VDD.t5 VDD.t3 sg13_lv_pmos ad=0.57p pd=3.38u as=0.57p ps=3.38u w=3u l=0.13u
X98 a_11798_1180.t16 vco_buf_in_n.t1 rf_out_p.t2 VSS.t138 sg13_lv_nmos ad=0.38p pd=2.38u as=0.38p ps=2.38u w=2u l=0.13u
X99 VSS.t72 vco_bias_0.vbn_buf.t3 VSS.t70 VSS.t71 sg13_lv_nmos ad=1.52p pd=8.38u as=0 ps=0 w=8u l=10u
X100 VSS.t111 VSS.t108 VSS.t110 VSS.t109 sg13_lv_nmos ad=0.85p pd=5.68u as=0 ps=0 w=2.5u l=0.5u
X101 vco_var_rf_n.t4 vco_var_rf_p.t7 VSS.t131 VSS.t132 sg13_lv_nmos ad=0.38p pd=2.38u as=0.38p ps=2.38u w=2u l=0.13u
X102 vco_var_rf_p.t0 vco_var_rf_n.t7 VSS.t161 VSS.t162 sg13_lv_nmos ad=0.38p pd=2.38u as=0.38p ps=2.38u w=2u l=0.13u
X103 a_11798_1180.t1 vco_bias_0.vbn_buf.t2 VSS.t19 VSS.t20 sg13_lv_nmos ad=0.95p pd=5.38u as=0.95p ps=5.38u w=5u l=0.5u
X104 VDD.t7 vco_feed_0.en_b.t2 a_20954_346.t1 VDD.t3 sg13_lv_pmos ad=0.57p pd=3.38u as=0.57p ps=3.38u w=3u l=0.13u
X105 VSS.t31 vco_bias_0.vbn_buf.t2 a_11798_1180.t4 VSS.t30 sg13_lv_nmos ad=0.95p pd=5.38u as=0.95p ps=5.38u w=5u l=0.5u
X106 a_11798_1180.t2 vco_bias_0.vbn_buf.t2 VSS.t22 VSS.t23 sg13_lv_nmos ad=0.95p pd=5.38u as=0.95p ps=5.38u w=5u l=0.5u
X107 a_11798_1180.t19 vco_buf_in_n.t1 rf_out_p.t5 VSS.t144 sg13_lv_nmos ad=0.38p pd=2.38u as=0.38p ps=2.38u w=2u l=0.13u
X108 rf_out_p.t4 vco_buf_in_n.t1 a_11798_1180.t17 VSS.t141 sg13_lv_nmos ad=0.38p pd=2.38u as=0.38p ps=2.38u w=2u l=0.13u
X109 VSS.t94 vco_bias_0.vbg_buf VSS.t92 VSS.t69 sg13_lv_nmos ad=1.52p pd=8.38u as=0 ps=0 w=8u l=10u
X110 VDD.t48 VDD.t46 VDD.t47 VDD.t0 sg13_lv_pmos ad=1.7p pd=10.68u as=0 ps=0 w=5u l=0.5u
X111 vco_buf_in_n vco_var_rf_n.t5 cap_cmim l=10u w=10u
X112 VSS.t34 vco_bias_0.vbn_buf.t2 a_11798_1180.t5 VSS.t33 sg13_lv_nmos ad=0.95p pd=5.38u as=0.95p ps=5.38u w=5u l=0.5u
X113 a_11798_1180.t9 vco_bias_0.vbn_buf.t2 VSS.t43 VSS.t44 sg13_lv_nmos ad=0.95p pd=5.38u as=0.95p ps=5.38u w=5u l=0.5u
X114 a_5560_3922.t2 a_5560_3922.t1 VSS.t1 VSS.t0 sg13_lv_nmos ad=0.85p pd=5.68u as=0.85p ps=5.68u w=2.5u l=0.5u
X115 a_11798_1180.t23 vco_buf_in_p.t1 rf_out_n.t0 VSS.t171 sg13_lv_nmos ad=0.38p pd=2.38u as=0.38p ps=2.38u w=2u l=0.13u
X116 VSS.t100 vco_bias_0.vbg_buf VSS.t98 VSS.t65 sg13_lv_nmos ad=1.52p pd=8.38u as=0 ps=0 w=8u l=10u
X117 a_20954_346.t2 vco_feed_0.en_b.t2 VDD.t7 VDD.t3 sg13_lv_pmos ad=0.57p pd=3.38u as=0.57p ps=3.38u w=3u l=0.13u
X118 VSS.t92 vco_bias_0.vbg_buf VSS.t90 VSS.t67 sg13_lv_nmos ad=1.52p pd=8.38u as=0 ps=0 w=8u l=10u
X119 VSS.t158 vco_var_rf_n.t7 vco_var_rf_p.t3 VSS.t157 sg13_lv_nmos ad=0.38p pd=2.38u as=0.38p ps=2.38u w=2u l=0.13u
X120 a_6568_6136.t2 a_6568_6136.t1 VDD.t1 VDD.t0 sg13_lv_pmos ad=1.7p pd=10.68u as=1.7p ps=10.68u w=5u l=0.5u
X121 vco_var_rf_n.t0 vco_var_rf_p.t7 VSS.t125 VSS.t126 sg13_lv_nmos ad=0.38p pd=2.38u as=0.38p ps=2.38u w=2u l=0.13u
X122 a_11798_1180.t28 vco_buf_in_p.t1 rf_out_n.t1 VSS.t181 sg13_lv_nmos ad=0.68p pd=4.68u as=0.38p ps=2.38u w=2u l=0.13u
X123 vco_var_rf_n.t2 vco_var_rf_p.t7 VSS.t120 VSS.t119 sg13_lv_nmos ad=0.38p pd=2.38u as=0.68p ps=4.68u w=2u l=0.13u
X124 vco_ind_LC.t1 VSS.t8 cap_cmim l=39u w=56u
X125 VDD.t9 vco_feed_0.en_b.t2 a_20954_346.t2 VDD.t3 sg13_lv_pmos ad=0.57p pd=3.38u as=0.57p ps=3.38u w=3u l=0.13u
X126 a_11798_1180.t26 vco_buf_in_p.t1 rf_out_n.t2 VSS.t177 sg13_lv_nmos ad=0.38p pd=2.38u as=0.38p ps=2.38u w=2u l=0.13u
X127 a_20954_346.t0 vco_feed_0.en_b.t2 VDD.t4 VDD.t3 sg13_lv_pmos ad=0.57p pd=3.38u as=1.02p ps=6.68u w=3u l=0.13u
X128 VDD.t15 vco_feed_0.en_b.t2 a_20954_346.t5 VDD.t3 sg13_lv_pmos ad=0.57p pd=3.38u as=0.57p ps=3.38u w=3u l=0.13u
X129 a_11798_1180.t24 vco_buf_in_p.t1 rf_out_n.t4 VSS.t173 sg13_lv_nmos ad=0.38p pd=2.38u as=0.38p ps=2.38u w=2u l=0.13u
X130 vco_bias_0.vbg_buf vco_buf_in_n.t0 VSS.t117 rhigh l=8u w=0.5u
X131 a_20954_346.t3 vco_feed_0.en_b.t2 VDD.t9 VDD.t3 sg13_lv_pmos ad=0.57p pd=3.38u as=0.57p ps=3.38u w=3u l=0.13u
X132 VSS.t25 vco_bias_0.vbn_buf.t2 a_11798_1180.t2 VSS.t24 sg13_lv_nmos ad=0.95p pd=5.38u as=0.95p ps=5.38u w=5u l=0.5u
X133 a_6568_6136.t3 a_5060_3002.t5 VSS.t3 VSS.t2 sg13_lv_nmos ad=0.85p pd=5.68u as=0.85p ps=5.68u w=2.5u l=0.5u
X134 vco_var_rf_p.t2 vco_var_rf_n.t7 VSS.t152 VSS.t153 sg13_lv_nmos ad=0.38p pd=2.38u as=0.38p ps=2.38u w=2u l=0.13u
X135 VSS.t43 vco_bias_0.vbn_buf.t2 a_11798_1180.t8 VSS.t42 sg13_lv_nmos ad=0.95p pd=5.38u as=0.95p ps=5.38u w=5u l=0.5u
X136 a_11798_1180.t6 vco_bias_0.vbn_buf.t2 VSS.t34 VSS.t35 sg13_lv_nmos ad=0.95p pd=5.38u as=0.95p ps=5.38u w=5u l=0.5u
X137 VSS.t122 vco_var_rf_p.t7 vco_var_rf_n.t2 VSS.t121 sg13_lv_nmos ad=0.38p pd=2.38u as=0.38p ps=2.38u w=2u l=0.13u
X138 a_5948_4416.t0 vco_feed_0.en_b.t5 VSS.t13 VSS.t12 sg13_lv_nmos ad=0.17p pd=1.68u as=0.17p ps=1.68u w=0.5u l=0.13u
X139 vco_bias_0.vbg_buf VSS.t85 cap_cmim l=7.28u w=13.6u
X140 a_20954_346.t16 vco_ind_LC.t0 VSS.t165 rppd l=8.8u w=17.3u
X141 rf_out_p.t3 vco_buf_in_n.t1 a_11798_1180.t16 VSS.t139 sg13_lv_nmos ad=0.38p pd=2.38u as=0.38p ps=2.38u w=2u l=0.13u
X142 a_20954_346.t6 vco_feed_0.en_b.t2 VDD.t15 VDD.t3 sg13_lv_pmos ad=0.57p pd=3.38u as=0.57p ps=3.38u w=3u l=0.13u
X143 VDD.t11 vco_feed_0.en_b.t2 a_20954_346.t3 VDD.t3 sg13_lv_pmos ad=0.57p pd=3.38u as=0.57p ps=3.38u w=3u l=0.13u
X144 VDD.t49 rf_out_n.t6 VSS.t135 rppd l=1.65u w=10u
X145 VSS.t96 vco_bias_0.vbg_buf VSS.t94 VSS.t71 sg13_lv_nmos ad=1.52p pd=8.38u as=0 ps=0 w=8u l=10u
X146 VSS.t76 vco_bias_0.vbn_buf.t4 VSS.t74 VSS.t65 sg13_lv_nmos ad=1.52p pd=8.38u as=0 ps=0 w=8u l=10u
X147 VSS.t80 vco_bias_0.vbn_buf.t4 VSS.t78 VSS.t69 sg13_lv_nmos ad=1.52p pd=8.38u as=0 ps=0 w=8u l=10u
X148 vco_ind_LC.t1 VSS.t10 cap_cmim l=25.5u w=42u
X149 VDD.t17 vco_feed_0.en_b.t2 a_20954_346.t6 VDD.t3 sg13_lv_pmos ad=0.57p pd=3.38u as=0.57p ps=3.38u w=3u l=0.13u
X150 a_20954_346.t4 vco_feed_0.en_b.t2 VDD.t11 VDD.t3 sg13_lv_pmos ad=0.57p pd=3.38u as=0.57p ps=3.38u w=3u l=0.13u
X151 a_11798_1180.t21 vco_buf_in_n.t1 rf_out_p.t1 VSS.t148 sg13_lv_nmos ad=0.68p pd=4.68u as=0.38p ps=2.38u w=2u l=0.13u
X152 a_5060_5708.t1 a_5060_3002.t4 VSS.t168 rppd l=13.1u w=0.5u
X153 rf_out_p.t0 vco_buf_in_n.t1 a_11798_1180.t19 VSS.t145 sg13_lv_nmos ad=0.38p pd=2.38u as=0.38p ps=2.38u w=2u l=0.13u
X154 vco_bias_0.vbg_buf vco_buf_in_p.t0 VSS.t169 rhigh l=8u w=0.5u
X155 a_11798_1180.t18 vco_buf_in_n.t1 rf_out_p.t4 VSS.t142 sg13_lv_nmos ad=0.38p pd=2.38u as=0.38p ps=2.38u w=2u l=0.13u
X156 a_11798_1180.t3 vco_bias_0.vbn_buf.t2 VSS.t25 VSS.t26 sg13_lv_nmos ad=0.95p pd=5.38u as=0.95p ps=5.38u w=5u l=0.5u
X157 VSS.t37 vco_bias_0.vbn_buf.t2 a_11798_1180.t6 VSS.t36 sg13_lv_nmos ad=0.95p pd=5.38u as=0.95p ps=5.38u w=5u l=0.5u
X158 rf_out_n.t4 vco_buf_in_p.t1 a_11798_1180.t23 VSS.t172 sg13_lv_nmos ad=0.38p pd=2.38u as=0.38p ps=2.38u w=2u l=0.13u
C0 vco_buf_in_p vco_buf_in_n 1.7478e-16
C1 VDD a_24640_164# 4.569e-17
C2 vco_bias_0.vbn_buf VDD 1.61103e-15
C3 vco_bias_0.vbg_buf di_en 2.11143e-15
C4 rf_out_n vco_buf_in_p 8.6364e-16
C5 vco_bias_0.vbn_buf a_1160_1390# 2.9e-17
C6 vco_var_rf_n vco_bias_0.vbg_buf 5.8809e-16
C7 vco_var_rf_p rf_out_n 5.799e-17
C8 vco_buf_in_p vco_bias_0.vbg_buf 6.224e-17
C9 vco_var_rf_n vco_var_rf_p 4.00797e-15
C10 a_1560_1090# vco_bias_0.vbg_buf 6.101e-17
C11 vtune vco_feed_0.en_b 9.037e-17
C12 vco_var_rf_p vco_bias_0.vbg_buf 8.721e-16
C13 rf_out_p VDD 2.82306e-15
C14 a_16500_3480# VDD 3.9132e-16
C15 vco_var_rf_p vco_buf_in_p 1.68023e-15
C16 a_10100_3480# VDD 3.9132e-16
C17 vco_bias_0.vbn_buf vco_buf_in_n 1.754e-17
C18 vco_bias_0.vbn_buf rf_out_n 2.9297e-16
C19 VDD vco_ind_LC 2.0001e-16
C20 vco_bias_0.vbn_buf di_en 1.1188e-16
C21 vco_var_rf_n vco_bias_0.vbn_buf 2.147e-17
C22 vtune VDD 1.1507e-16
C23 vco_bias_0.vbn_buf vco_bias_0.vbg_buf 4.94304e-15
C24 a_5560_4008# a_5060_3088# 2.516e-17
C25 rf_out_p vco_buf_in_n 8.6364e-16
C26 vco_bias_0.vbn_buf vco_buf_in_p 3.118e-17
C27 a_16500_3480# vco_buf_in_n 2.469e-17
C28 rf_out_p rf_out_n 1.393e-17
C29 vco_bias_0.vbn_buf vco_var_rf_p 2.834e-16
C30 a_5560_4008# vco_feed_0.en_b 4.005e-17
C31 a_10100_3480# rf_out_n 6.9013e-16
C32 vco_ind_LC vco_buf_in_n 1.048e-17
C33 vco_var_rf_n rf_out_p 5.799e-17
C34 vco_feed_0.en_b VDD 5.96589e-15
C35 vtune vco_buf_in_n 1.8112e-16
C36 vco_var_rf_n vco_ind_LC 1.02141e-15
C37 a_10100_3480# vco_buf_in_p 2.469e-17
C38 vtune rf_out_n 3.484e-17
C39 a_19050_4480# vco_buf_in_n 3.458e-17
C40 vco_ind_LC vco_bias_0.vbg_buf 2.913e-17
C41 a_5560_4008# VDD 3.954e-17
C42 vco_var_rf_n vtune 5.282e-17
C43 vtune vco_bias_0.vbg_buf 1.3019e-16
C44 vco_var_rf_p vco_ind_LC 5.494e-16
C45 a_1160_1390# VDD 1.323e-17
C46 a_19050_4480# vco_bias_0.vbg_buf 4.459e-17
C47 vtune vco_buf_in_p 1.8112e-16
C48 a_9450_4480# vco_bias_0.vbg_buf 4.475e-17
C49 vco_feed_0.en_b rf_out_n 7.832e-17
C50 vco_var_rf_p vtune 1.0305e-16
C51 a_9450_4480# vco_buf_in_p 3.458e-17
C52 a_5060_3088# vco_bias_0.vbg_buf 1.628e-17
C53 vco_bias_0.vbn_buf rf_out_p 2.0879e-16
C54 vco_feed_0.en_b di_en 5.0415e-16
C55 vco_feed_0.en_b vco_bias_0.vbg_buf 1.7737e-16
C56 vco_ind_LC a_24640_164# 1.18592e-15
C57 VDD vco_buf_in_n 6.3222e-16
C58 VDD rf_out_n 2.80242e-15
C59 vco_bias_0.vbn_buf vtune 6.767e-17
C60 a_16500_3480# rf_out_p 6.9013e-16
C61 a_5560_4008# vco_bias_0.vbg_buf 1.107e-17
C62 VDD di_en 5.9914e-16
C63 vco_var_rf_n VDD 1.3774e-16
C64 vco_bias_0.vbn_buf a_9450_4480# 1.693e-17
C65 VDD vco_bias_0.vbg_buf 2.36676e-15
C66 a_1160_1390# vco_bias_0.vbg_buf 5.206e-17
C67 VDD vco_buf_in_p 6.3222e-16
C68 VDD a_1560_1090# 2.35e-17
C69 vco_var_rf_p VDD 1.3774e-16
C70 vco_bias_0.vbn_buf vco_feed_0.en_b 1.04162e-15
C71 vtune rf_out_p 3.484e-17
C72 a_1160_1390# a_1560_1090# 1.7942e-16
C73 vco_var_rf_n vco_buf_in_n 1.68023e-15
C74 vco_buf_in_n vco_bias_0.vbg_buf 5.315e-17
C75 a_19050_4480# vco_ind_LC 1.117e-17
C76 rf_out_p vco_feed_0.en_b 7.782e-17
R0 vco_ind_LC.t1 vco_ind_LC.t0 1.63487
R1 vco_ind_LC vco_ind_LC.t1 0.424556
R2 rf_out_p.n0 rf_out_p.t2 6.56137
R3 rf_out_p.n1 rf_out_p.t1 6.52949
R4 rf_out_p.n1 rf_out_p.t0 6.52949
R5 rf_out_p.n0 rf_out_p.t5 6.52949
R6 rf_out_p.n0 rf_out_p.t4 6.52949
R7 rf_out_p.n0 rf_out_p.t3 6.52949
R8 rf_out_p rf_out_p.n2 1.88238
R9 rf_out_p.n2 rf_out_p.t6 1.62005
R10 rf_out_p.n1 rf_out_p.n0 0.128045
R11 rf_out_p.n2 rf_out_p.n1 0.117417
R12 rf_out_n.n0 rf_out_n.t1 6.56137
R13 rf_out_n.n0 rf_out_n.t3 6.52949
R14 rf_out_n.n0 rf_out_n.t2 6.52949
R15 rf_out_n.n1 rf_out_n.t5 6.52949
R16 rf_out_n.n1 rf_out_n.t4 6.52949
R17 rf_out_n.n1 rf_out_n.t0 6.52949
R18 rf_out_n rf_out_n.n2 1.88238
R19 rf_out_n.n2 rf_out_n.t6 1.62005
R20 rf_out_n.n1 rf_out_n.n0 0.128045
R21 rf_out_n.n2 rf_out_n.n1 0.117417
R22 vco_buf_in_n.n0 vco_buf_in_n.t0 27.0805
R23 vco_buf_in_n vco_buf_in_n.n0 3.71514
R24 vco_buf_in_n.n0 vco_buf_in_n.t1 2.05808
R25 vco_buf_in_p.n0 vco_buf_in_p.t0 27.0805
R26 vco_buf_in_p vco_buf_in_p.n0 3.72028
R27 vco_buf_in_p.n0 vco_buf_in_p.t1 2.05789
R28 di_en.n0 di_en.t0 21.6583
R29 di_en.n0 di_en.t1 19.605
R30 di_en di_en.n0 14.2582
R31 vco_var_rf_p.n1 vco_var_rf_p.t0 6.57599
R32 vco_var_rf_p.n1 vco_var_rf_p.t3 6.52949
R33 vco_var_rf_p.n1 vco_var_rf_p.t2 6.52949
R34 vco_var_rf_p.n1 vco_var_rf_p.t4 6.52949
R35 vco_var_rf_p.n1 vco_var_rf_p.t1 6.52949
R36 vco_var_rf_p vco_var_rf_p.t5 4.85508
R37 vco_var_rf_p.n0 vco_var_rf_p.t7 4.13789
R38 vco_ind_LA vco_var_rf_p.n2 0.424928
R39 vco_var_rf_p.n2 vco_var_rf_p.n3 0.714879
R40 vco_var_rf_p.n0 vco_var_rf_p.n2 0.321512
R41 vco_var_rf_p.n3 vco_var_rf_p.n1 0.47922
R42 vco_var_rf_p.n3 vco_var_rf_p 0.47746
R43 vco_var_rf_p.n1 vco_var_rf_p.n0 0.183969
R44 vco_var_rf_n.n1 vco_var_rf_n.t2 6.57599
R45 vco_var_rf_n.n1 vco_var_rf_n.t4 6.52949
R46 vco_var_rf_n.n1 vco_var_rf_n.t1 6.52949
R47 vco_var_rf_n.n1 vco_var_rf_n.t3 6.52949
R48 vco_var_rf_n.n1 vco_var_rf_n.t0 6.52949
R49 vco_var_rf_n vco_var_rf_n.t5 5.01313
R50 vco_var_rf_n.n2 vco_var_rf_n.t7 3.9789
R51 vco_var_rf_n.n3 vco_var_rf_n.n0 0.725616
R52 vco_var_rf_n.n2 vco_var_rf_n.n0 0.35066
R53 vco_ind_LB vco_var_rf_n.n0 0.413472
R54 vco_var_rf_n.n1 vco_var_rf_n.n3 0.47922
R55 vco_var_rf_n.n3 vco_var_rf_n 0.319412
R56 vco_var_rf_n.n2 vco_var_rf_n.n1 0.166369
R57 VDD VDD.n24 32.7055
R58 VDD.n17 VDD.t46 17.5809
R59 VDD.n0 VDD.t43 17.5809
R60 VDD.n60 VDD.n1 1.2602
R61 VDD.n18 VDD.t47 2.54497
R62 VDD.n2 VDD.t40 15.8062
R63 VDD.n57 VDD.n56 10.8262
R64 VDD.n59 VDD.n58 10.8262
R65 VDD.n20 VDD.n29 3.37066
R66 VDD.n25 VDD.t41 6.07554
R67 VDD.n2 VDD.t42 6.07554
R68 VDD.n19 VDD.t38 6.07554
R69 VDD.n23 VDD.t50 6.07554
R70 VDD.n24 VDD.t36 6.07554
R71 VDD.n1 VDD.n19 0.0656783
R72 VDD.n54 VDD.n22 0.830556
R73 VDD.n22 VDD.n29 2.80696
R74 VDD.n52 VDD.n51 0.0585658
R75 VDD.n51 VDD.n29 2.7974
R76 VDD.n50 VDD.n48 0.0585658
R77 VDD.n48 VDD.n29 2.7974
R78 VDD.n47 VDD.n30 0.066765
R79 VDD.n21 VDD.n42 0.0585658
R80 VDD.n42 VDD.n29 2.7974
R81 VDD.n41 VDD.n37 0.0585658
R82 VDD.n37 VDD.n29 2.7974
R83 VDD.n28 VDD.n29 2.37707
R84 VDD.n19 VDD.n23 0.1061
R85 VDD.n30 VDD.n29 2.3909
R86 VDD.n27 VDD.n28 0.0743661
R87 VDD.n58 VDD.n57 3.7073
R88 VDD.n25 VDD.t37 3.45404
R89 VDD.n24 VDD.n60 3.37539
R90 VDD.n60 VDD.n0 1.51113
R91 VDD.n60 VDD.n18 1.16155
R92 VDD.n32 VDD.t19 2.57245
R93 VDD.n0 VDD.t44 2.36417
R94 VDD.n17 VDD.t48 2.36416
R95 VDD.n17 VDD.t1 2.36408
R96 VDD.n33 VDD.t2 2.36389
R97 VDD.n0 VDD.t45 2.36389
R98 VDD.n3 VDD.n55 2.10932
R99 VDD.n54 VDD.n16 2.10932
R100 VDD.n55 VDD.t4 2.06537
R101 VDD.n54 VDD.t35 2.06537
R102 VDD.n26 VDD.t5 2.06506
R103 VDD.n35 VDD.t7 2.06506
R104 VDD.n38 VDD.t9 2.06506
R105 VDD.n40 VDD.t11 2.06506
R106 VDD.n43 VDD.t13 2.06506
R107 VDD.n44 VDD.t15 2.06506
R108 VDD.n45 VDD.t17 2.06506
R109 VDD.n53 VDD.t21 2.06506
R110 VDD.n9 VDD.t23 2.06506
R111 VDD.n8 VDD.t28 2.06506
R112 VDD.n12 VDD.t25 2.06506
R113 VDD.n11 VDD.t27 2.06506
R114 VDD.n15 VDD.t32 2.06506
R115 VDD.n14 VDD.t26 2.06506
R116 VDD.n3 VDD.n26 2.01733
R117 VDD.n4 VDD.n35 2.01733
R118 VDD.n4 VDD.n38 2.01733
R119 VDD.n5 VDD.n40 2.01733
R120 VDD.n5 VDD.n43 2.01733
R121 VDD.n6 VDD.n44 2.01733
R122 VDD.n6 VDD.n45 2.01733
R123 VDD.n53 VDD.n7 2.01733
R124 VDD.n10 VDD.n9 2.01733
R125 VDD.n10 VDD.n8 2.01733
R126 VDD.n13 VDD.n12 2.01733
R127 VDD.n13 VDD.n11 2.01733
R128 VDD.n16 VDD.n15 2.01733
R129 VDD.n16 VDD.n14 2.01733
R130 VDD.n56 VDD.n7 0.833598
R131 VDD.n55 VDD.n27 0.811613
R132 VDD.n27 VDD.n26 0.75308
R133 VDD.n36 VDD.n35 0.75308
R134 VDD.n34 VDD.n38 0.75308
R135 VDD.n41 VDD.n40 0.75308
R136 VDD.n39 VDD.n43 0.75308
R137 VDD.n21 VDD.n44 0.75308
R138 VDD.n21 VDD.n45 0.75308
R139 VDD.n31 VDD.n53 0.75308
R140 VDD.n47 VDD.n9 0.75308
R141 VDD.n46 VDD.n8 0.75308
R142 VDD.n50 VDD.n12 0.75308
R143 VDD.n49 VDD.n11 0.75308
R144 VDD.n52 VDD.n15 0.75308
R145 VDD.n22 VDD.n14 0.75308
R146 VDD VDD.n59 0.597573
R147 VDD.n57 VDD.t39 0.517741
R148 VDD.n58 VDD.t49 0.517741
R149 VDD.n60 VDD.t0 0.395849
R150 VDD.n59 VDD.n56 0.35172
R151 VDD.n29 VDD.t3 0.347439
R152 VDD.n0 VDD.n33 0.222999
R153 VDD.n2 VDD.n25 0.199822
R154 VDD.n16 VDD.n13 0.183684
R155 VDD.n13 VDD.n10 0.183684
R156 VDD.n10 VDD.n7 0.183684
R157 VDD.n7 VDD.n6 0.183684
R158 VDD.n6 VDD.n5 0.183684
R159 VDD.n5 VDD.n4 0.183684
R160 VDD.n4 VDD.n3 0.183684
R161 VDD.n33 VDD.n17 0.181347
R162 VDD.n28 VDD.n36 0.099072
R163 VDD.n32 VDD.n31 0.174604
R164 VDD.n52 VDD.n22 0.155757
R165 VDD.n7 VDD.n32 0.152545
R166 VDD.n24 VDD.n23 0.152127
R167 VDD.n18 VDD.n17 0.0814646
R168 VDD.n2 VDD.n1 0.0766266
R169 VDD.n0 VDD.n25 0.139213
R170 VDD.n49 VDD.n51 0.0585658
R171 VDD.n50 VDD.n49 0.116817
R172 VDD.n46 VDD.n48 0.0585658
R173 VDD.n47 VDD.n46 0.116817
R174 VDD.n31 VDD.n30 0.0501977
R175 VDD.n39 VDD.n42 0.0585658
R176 VDD.n41 VDD.n39 0.116817
R177 VDD.n34 VDD.n37 0.0585658
R178 VDD.n36 VDD.n34 0.116817
R179 VDD.n21 VDD.n20 0.116756
R180 VDD.n20 VDD.n32 0.116351
R181 VSS.n479 VSS.n42 384.529
R182 VSS.t117 VSS.n479 1462.65
R183 VSS.t136 VSS.n346 657.683
R184 VSS.t116 VSS.t117 303.798
R185 VSS.t107 VSS.t168 224.619
R186 VSS.t118 VSS.t136 179.696
R187 VSS.n479 VSS.t165 157.661
R188 VSS.t168 VSS.t118 157.233
R189 VSS.n347 VSS.t107 142.626
R190 VSS.n480 VSS.t116 110.507
R191 VSS.n354 VSS.n353 69.913
R192 VSS.n40 VSS.t2 11.1952
R193 VSS.t113 VSS.n352 48.555
R194 VSS.n349 VSS.t166 47.8044
R195 VSS.n41 VSS.t0 45.1788
R196 VSS.n351 VSS.t6 43.4374
R197 VSS.t14 VSS.n349 37.5655
R198 VSS.n352 VSS.t4 32.6297
R199 VSS.n348 VSS.t12 30.9232
R200 VSS.n41 VSS.t109 15.7829
R201 VSS.n350 VSS.t14 26.3726
R202 VSS.n373 VSS.n74 25.4435
R203 VSS.t62 VSS.n154 24.4173
R204 VSS.t6 VSS.n350 20.6825
R205 VSS.t12 VSS.n347 20.4783
R206 VSS.t0 VSS.n351 18.976
R207 VSS.n335 VSS.t13 17.3443
R208 VSS.n337 VSS.t167 17.3443
R209 VSS.n346 VSS.n284 17.102
R210 VSS.n476 VSS.n475 17.0005
R211 VSS.n475 VSS.n400 17.0005
R212 VSS.n475 VSS.n401 17.0005
R213 VSS.n475 VSS.n403 17.0005
R214 VSS.n475 VSS.n404 17.0005
R215 VSS.n475 VSS.n405 17.0005
R216 VSS.n475 VSS.n406 17.0005
R217 VSS.n475 VSS.n407 17.0005
R218 VSS.n475 VSS.n408 17.0005
R219 VSS.n475 VSS.n409 17.0005
R220 VSS.n475 VSS.n37 3.38141
R221 VSS.n475 VSS.n410 17.0005
R222 VSS.n475 VSS.n411 17.0005
R223 VSS.n475 VSS.n412 17.0005
R224 VSS.n475 VSS.n413 17.0005
R225 VSS.n475 VSS.n473 17.0005
R226 VSS.n475 VSS.n474 17.0005
R227 VSS.n456 VSS.n455 17.0005
R228 VSS.n456 VSS.n430 17.0005
R229 VSS.n456 VSS.n452 17.0005
R230 VSS.n456 VSS.n431 17.0005
R231 VSS.n456 VSS.n451 17.0005
R232 VSS.n456 VSS.n432 17.0005
R233 VSS.n456 VSS.n449 17.0005
R234 VSS.n456 VSS.n433 17.0005
R235 VSS.n456 VSS.n448 17.0005
R236 VSS.n14 VSS.n456 2.8034
R237 VSS.n456 VSS.n434 17.0005
R238 VSS.n456 VSS.n447 17.0005
R239 VSS.n456 VSS.n435 17.0005
R240 VSS.n456 VSS.n446 17.0005
R241 VSS.n456 VSS.n436 17.0005
R242 VSS.n456 VSS.n438 17.0005
R243 VSS.n456 VSS.n437 17.0005
R244 VSS.n481 VSS.n480 17.0005
R245 VSS.n481 VSS.n47 17.0005
R246 VSS.n481 VSS.n399 17.0005
R247 VSS.n481 VSS.n48 17.0005
R248 VSS.n481 VSS.n398 17.0005
R249 VSS.n481 VSS.n49 17.0005
R250 VSS.n481 VSS.n397 17.0005
R251 VSS.n481 VSS.n50 17.0005
R252 VSS.n481 VSS.n396 17.0005
R253 VSS.n481 VSS.n51 17.0005
R254 VSS.n481 VSS.n395 17.0005
R255 VSS.n481 VSS.n52 17.0005
R256 VSS.n481 VSS.n394 17.0005
R257 VSS.n481 VSS.n53 17.0005
R258 VSS.n481 VSS.n393 17.0005
R259 VSS.n481 VSS.n54 17.0005
R260 VSS.n481 VSS.n392 17.0005
R261 VSS.n481 VSS.n55 17.0005
R262 VSS.n481 VSS.n391 17.0005
R263 VSS.n481 VSS.n56 17.0005
R264 VSS.n481 VSS.n10 1.6725
R265 VSS.n481 VSS.n95 17.0005
R266 VSS.n481 VSS.n60 17.0005
R267 VSS.n19 VSS.n7 0.0446828
R268 VSS.n481 VSS.n88 17.0005
R269 VSS.n481 VSS.n62 17.0005
R270 VSS.n481 VSS.n86 17.0005
R271 VSS.n481 VSS.n63 17.0005
R272 VSS.n481 VSS.n84 17.0005
R273 VSS.n481 VSS.n64 17.0005
R274 VSS.n481 VSS.n83 17.0005
R275 VSS.n481 VSS.n65 17.0005
R276 VSS.n481 VSS.n82 17.0005
R277 VSS.n481 VSS.n66 17.0005
R278 VSS.n481 VSS.n81 17.0005
R279 VSS.n481 VSS.n67 17.0005
R280 VSS.n481 VSS.n80 17.0005
R281 VSS.n481 VSS.n68 17.0005
R282 VSS.n481 VSS.n79 17.0005
R283 VSS.n481 VSS.n69 17.0005
R284 VSS.n481 VSS.n78 17.0005
R285 VSS.n481 VSS.n70 17.0005
R286 VSS.n481 VSS.n77 17.0005
R287 VSS.n481 VSS.n74 17.0005
R288 VSS.n39 VSS.n36 4.23471
R289 VSS.n18 VSS.n20 0.0988086
R290 VSS.n347 VSS.n39 17.0005
R291 VSS.n20 VSS.t108 16.4809
R292 VSS.n21 VSS.t112 16.4809
R293 VSS.t166 VSS.n348 16.1318
R294 VSS.n76 VSS.t20 15.6926
R295 VSS.t57 VSS.n477 15.6926
R296 VSS.t38 VSS.n59 14.9331
R297 VSS.n59 VSS.t39 14.9331
R298 VSS.t59 VSS.n44 14.555
R299 VSS.n75 VSS.t18 14.5543
R300 VSS.n40 VSS.n39 0.0183207
R301 VSS.t18 VSS.n71 13.0361
R302 VSS.n478 VSS.t59 13.0354
R303 VSS.n357 VSS.n106 12.9119
R304 VSS.n223 VSS.n207 12.9119
R305 VSS.n359 VSS.n103 12.9119
R306 VSS.n364 VSS.n99 12.9119
R307 VSS.t36 VSS.n89 12.6546
R308 VSS.n94 VSS.t41 12.6546
R309 VSS.t16 VSS.n74 12.5321
R310 VSS.n480 VSS.t60 12.5321
R311 VSS.n90 VSS.t36 12.2766
R312 VSS.t41 VSS.n58 12.2759
R313 VSS.t71 VSS.n211 12.1524
R314 VSS.n353 VSS.t113 11.8925
R315 VSS.n296 VSS.t65 11.84
R316 VSS.n328 VSS.t69 11.84
R317 VSS.n484 VSS.n30 11.5239
R318 VSS.t169 VSS.n225 11.3929
R319 VSS.t181 VSS.t35 11.203
R320 VSS.t42 VSS.t137 11.203
R321 VSS.n355 VSS.n354 11.1823
R322 VSS.t32 VSS.n62 11.0132
R323 VSS.n391 VSS.t49 11.0132
R324 VSS.t65 VSS.n264 10.5245
R325 VSS.t69 VSS.n231 10.5245
R326 VSS.t39 VSS.n58 9.99808
R327 VSS.n90 VSS.t38 9.99739
R328 VSS.t178 VSS.n87 9.80648
R329 VSS.n61 VSS.t180 9.80648
R330 VSS.t138 VSS.n57 9.80648
R331 VSS.n96 VSS.t140 9.80648
R332 VSS.n387 VSS.n386 9.76416
R333 VSS.n388 VSS.n387 9.63922
R334 VSS.n334 VSS.t85 9.50586
R335 VSS.n86 VSS.t30 9.49417
R336 VSS.t45 VSS.n55 9.49417
R337 VSS.n478 VSS.t57 9.23859
R338 VSS.t20 VSS.n71 9.23789
R339 VSS.n437 VSS.n76 9.23686
R340 VSS.n477 VSS.n476 9.23686
R341 VSS.n371 VSS.n366 8.5005
R342 VSS.n371 VSS.n217 8.5005
R343 VSS.n371 VSS.n364 8.5005
R344 VSS.n371 VSS.n220 8.5005
R345 VSS.n371 VSS.n359 8.5005
R346 VSS.n371 VSS.n223 8.5005
R347 VSS.n371 VSS.n358 8.5005
R348 VSS.n371 VSS.n225 8.5005
R349 VSS.n371 VSS.n357 8.5005
R350 VSS.n371 VSS.n228 8.5005
R351 VSS.n374 VSS.n373 8.5005
R352 VSS.n374 VSS.n211 8.5005
R353 VSS.n374 VSS.n207 8.5005
R354 VSS.n374 VSS.n99 8.5005
R355 VSS.n374 VSS.n103 8.5005
R356 VSS.n374 VSS.n106 8.5005
R357 VSS.n371 VSS.t67 8.5005
R358 VSS.n371 VSS.n355 8.5005
R359 VSS.n371 VSS.n229 8.5005
R360 VSS.n371 VSS.n330 8.5005
R361 VSS.n371 VSS.n230 8.5005
R362 VSS.n371 VSS.n329 8.5005
R363 VSS.n371 VSS.n231 8.5005
R364 VSS.n371 VSS.n328 8.5005
R365 VSS.n371 VSS.n232 8.5005
R366 VSS.n371 VSS.n327 8.5005
R367 VSS.n371 VSS.n233 8.5005
R368 VSS.n371 VSS.n326 8.5005
R369 VSS.n371 VSS.n234 8.5005
R370 VSS.n371 VSS.n325 8.5005
R371 VSS.n371 VSS.n235 8.5005
R372 VSS.n371 VSS.n324 8.5005
R373 VSS.n371 VSS.n236 8.5005
R374 VSS.n371 VSS.n323 8.5005
R375 VSS.n371 VSS.n237 8.5005
R376 VSS.n371 VSS.n322 8.5005
R377 VSS.n371 VSS.n238 8.5005
R378 VSS.n371 VSS.n321 8.5005
R379 VSS.n371 VSS.n241 8.5005
R380 VSS.n371 VSS.n320 8.5005
R381 VSS.n371 VSS.n242 8.5005
R382 VSS.n371 VSS.n319 8.5005
R383 VSS.n371 VSS.n243 8.5005
R384 VSS.n371 VSS.n318 8.5005
R385 VSS.n371 VSS.n244 8.5005
R386 VSS.n371 VSS.n317 8.5005
R387 VSS.n371 VSS.n245 8.5005
R388 VSS.n371 VSS.n316 8.5005
R389 VSS.n371 VSS.n246 8.5005
R390 VSS.n371 VSS.n315 8.5005
R391 VSS.n371 VSS.n247 8.5005
R392 VSS.n371 VSS.n314 8.5005
R393 VSS.n371 VSS.n248 8.5005
R394 VSS.n371 VSS.n249 8.5005
R395 VSS.n371 VSS.n313 8.5005
R396 VSS.n371 VSS.n250 8.5005
R397 VSS.n371 VSS.n312 8.5005
R398 VSS.n371 VSS.n251 8.5005
R399 VSS.n371 VSS.n311 8.5005
R400 VSS.n371 VSS.n252 8.5005
R401 VSS.n371 VSS.n310 8.5005
R402 VSS.n371 VSS.n253 8.5005
R403 VSS.n371 VSS.n309 8.5005
R404 VSS.n371 VSS.n254 8.5005
R405 VSS.n371 VSS.n308 8.5005
R406 VSS.n371 VSS.n255 8.5005
R407 VSS.n371 VSS.n307 8.5005
R408 VSS.n371 VSS.n256 8.5005
R409 VSS.n371 VSS.n303 8.5005
R410 VSS.n371 VSS.n257 8.5005
R411 VSS.n371 VSS.n302 8.5005
R412 VSS.n371 VSS.n258 8.5005
R413 VSS.n371 VSS.n301 8.5005
R414 VSS.n371 VSS.n259 8.5005
R415 VSS.n371 VSS.n300 8.5005
R416 VSS.n371 VSS.n260 8.5005
R417 VSS.n371 VSS.n299 8.5005
R418 VSS.n371 VSS.n261 8.5005
R419 VSS.n371 VSS.n298 8.5005
R420 VSS.n371 VSS.n262 8.5005
R421 VSS.n371 VSS.n297 8.5005
R422 VSS.n371 VSS.n263 8.5005
R423 VSS.n371 VSS.n296 8.5005
R424 VSS.n371 VSS.n264 8.5005
R425 VSS.n371 VSS.n295 8.5005
R426 VSS.n371 VSS.n265 8.5005
R427 VSS.n371 VSS.n294 8.5005
R428 VSS.n371 VSS.n266 8.5005
R429 VSS.n371 VSS.n293 8.5005
R430 VSS.n371 VSS.n267 8.5005
R431 VSS.n371 VSS.n292 8.5005
R432 VSS.n371 VSS.n268 8.5005
R433 VSS.n371 VSS.n291 8.5005
R434 VSS.n371 VSS.n269 8.5005
R435 VSS.n371 VSS.n290 8.5005
R436 VSS.n371 VSS.n270 8.5005
R437 VSS.n371 VSS.n289 8.5005
R438 VSS.n371 VSS.n271 8.5005
R439 VSS.n371 VSS.n287 8.5005
R440 VSS.n371 VSS.n272 8.5005
R441 VSS.n371 VSS.n286 8.5005
R442 VSS.n371 VSS.n273 8.5005
R443 VSS.n371 VSS.n285 8.5005
R444 VSS.n371 VSS.n274 8.5005
R445 VSS.n371 VSS.n284 8.5005
R446 VSS.n371 VSS.n275 8.5005
R447 VSS.n371 VSS.n283 8.5005
R448 VSS.n371 VSS.n276 8.5005
R449 VSS.n371 VSS.n282 8.5005
R450 VSS.n371 VSS.n277 8.5005
R451 VSS.n371 VSS.n281 8.5005
R452 VSS.n371 VSS.n278 8.5005
R453 VSS.n371 VSS.n280 8.5005
R454 VSS.n371 VSS.n279 8.5005
R455 VSS.n3 VSS.n4 0.043527
R456 VSS.n481 VSS.n5 2.41243
R457 VSS.n18 VSS.n17 0.0305716
R458 VSS.n456 VSS.n450 8.49147
R459 VSS.n438 VSS.n70 8.35493
R460 VSS.n446 VSS.n69 8.35493
R461 VSS.n435 VSS.n79 8.35493
R462 VSS.n434 VSS.n80 8.35493
R463 VSS.n448 VSS.n67 8.35493
R464 VSS.n432 VSS.n82 8.35493
R465 VSS.n406 VSS.n52 8.35493
R466 VSS.n409 VSS.n396 8.35493
R467 VSS.n410 VSS.n50 8.35493
R468 VSS.n412 VSS.n49 8.35493
R469 VSS.n413 VSS.n398 8.35493
R470 VSS.n474 VSS.n399 8.35493
R471 VSS.n229 VSS.n202 7.94466
R472 VSS.n232 VSS.n199 7.94466
R473 VSS.n295 VSS.n139 7.94466
R474 VSS.n275 VSS.n159 7.94466
R475 VSS.n329 VSS.n109 7.944
R476 VSS.n263 VSS.n169 7.944
R477 VSS.n285 VSS.n149 7.944
R478 VSS.n280 VSS.n153 7.944
R479 VSS.t176 VSS.n62 7.78531
R480 VSS.n88 VSS.t178 7.78531
R481 VSS.t180 VSS.n60 7.78531
R482 VSS.n95 VSS.t138 7.78531
R483 VSS.t140 VSS.n56 7.78531
R484 VSS.n391 VSS.t142 7.78531
R485 VSS.n386 VSS.n98 7.76695
R486 VSS.n75 VSS.t16 7.7196
R487 VSS.t60 VSS.n44 7.71891
R488 VSS.n366 VSS.t135 7.59544
R489 VSS.n218 VSS.n101 7.33963
R490 VSS.n363 VSS.n102 7.33963
R491 VSS.n221 VSS.n105 7.33963
R492 VSS.n367 VSS.n214 7.33963
R493 VSS.n363 VSS.n210 7.33963
R494 VSS.n362 VSS.n209 7.33963
R495 VSS.n361 VSS.n208 7.33963
R496 VSS.n227 VSS.n203 7.33963
R497 VSS.n227 VSS.n204 7.33963
R498 VSS.n226 VSS.n204 7.33963
R499 VSS.n226 VSS.n107 7.33963
R500 VSS.n356 VSS.n107 7.33963
R501 VSS.n222 VSS.n105 7.33963
R502 VSS.n221 VSS.n104 7.33963
R503 VSS.n360 VSS.n208 7.33963
R504 VSS.n361 VSS.n209 7.33963
R505 VSS.n362 VSS.n210 7.33963
R506 VSS.n219 VSS.n101 7.33963
R507 VSS.n218 VSS.n100 7.33963
R508 VSS.n365 VSS.n212 7.33963
R509 VSS.n216 VSS.n213 7.33963
R510 VSS.n216 VSS.n214 7.33963
R511 VSS.n367 VSS.n215 7.33963
R512 VSS.n372 VSS.n215 7.33963
R513 VSS.n449 VSS.t171 7.02582
R514 VSS.n431 VSS.t173 7.02582
R515 VSS.n455 VSS.t175 7.02582
R516 VSS.n400 VSS.t143 7.02582
R517 VSS.n404 VSS.t145 7.02582
R518 VSS.n407 VSS.t147 7.02582
R519 VSS.n229 VSS.n201 6.74614
R520 VSS.n330 VSS.n108 6.74614
R521 VSS.n230 VSS.n200 6.74614
R522 VSS.n232 VSS.n198 6.74614
R523 VSS.n327 VSS.n110 6.74614
R524 VSS.n233 VSS.n197 6.74614
R525 VSS.n326 VSS.n111 6.74614
R526 VSS.n234 VSS.n196 6.74614
R527 VSS.n325 VSS.n112 6.74614
R528 VSS.n235 VSS.n195 6.74614
R529 VSS.n324 VSS.n113 6.74614
R530 VSS.n236 VSS.n194 6.74614
R531 VSS.n323 VSS.n114 6.74614
R532 VSS.n237 VSS.n193 6.74614
R533 VSS.n322 VSS.n115 6.74614
R534 VSS.n238 VSS.n192 6.74614
R535 VSS.n321 VSS.n116 6.74614
R536 VSS.n241 VSS.n191 6.74614
R537 VSS.n320 VSS.n117 6.74614
R538 VSS.n242 VSS.n190 6.74614
R539 VSS.n319 VSS.n118 6.74614
R540 VSS.n243 VSS.n189 6.74614
R541 VSS.n318 VSS.n119 6.74614
R542 VSS.n244 VSS.n188 6.74614
R543 VSS.n317 VSS.n120 6.74614
R544 VSS.n245 VSS.n187 6.74614
R545 VSS.n316 VSS.n121 6.74614
R546 VSS.n246 VSS.n186 6.74614
R547 VSS.n315 VSS.n122 6.74614
R548 VSS.n247 VSS.n185 6.74614
R549 VSS.n314 VSS.n123 6.74614
R550 VSS.n248 VSS.n184 6.74614
R551 VSS.n249 VSS.n183 6.74614
R552 VSS.n313 VSS.n125 6.74614
R553 VSS.n250 VSS.n182 6.74614
R554 VSS.n312 VSS.n126 6.74614
R555 VSS.n251 VSS.n181 6.74614
R556 VSS.n311 VSS.n127 6.74614
R557 VSS.n252 VSS.n180 6.74614
R558 VSS.n310 VSS.n128 6.74614
R559 VSS.n253 VSS.n179 6.74614
R560 VSS.n309 VSS.n129 6.74614
R561 VSS.n254 VSS.n178 6.74614
R562 VSS.n308 VSS.n130 6.74614
R563 VSS.n255 VSS.n177 6.74614
R564 VSS.n307 VSS.n131 6.74614
R565 VSS.n256 VSS.n176 6.74614
R566 VSS.n303 VSS.n132 6.74614
R567 VSS.n257 VSS.n175 6.74614
R568 VSS.n302 VSS.n133 6.74614
R569 VSS.n258 VSS.n174 6.74614
R570 VSS.n301 VSS.n134 6.74614
R571 VSS.n259 VSS.n173 6.74614
R572 VSS.n300 VSS.n135 6.74614
R573 VSS.n260 VSS.n172 6.74614
R574 VSS.n299 VSS.n136 6.74614
R575 VSS.n261 VSS.n171 6.74614
R576 VSS.n298 VSS.n137 6.74614
R577 VSS.n262 VSS.n170 6.74614
R578 VSS.n297 VSS.n138 6.74614
R579 VSS.n295 VSS.n140 6.74614
R580 VSS.n265 VSS.n168 6.74614
R581 VSS.n294 VSS.n141 6.74614
R582 VSS.n266 VSS.n167 6.74614
R583 VSS.n293 VSS.n142 6.74614
R584 VSS.n267 VSS.n166 6.74614
R585 VSS.n292 VSS.n143 6.74614
R586 VSS.n268 VSS.n165 6.74614
R587 VSS.n291 VSS.n144 6.74614
R588 VSS.n269 VSS.n164 6.74614
R589 VSS.n290 VSS.n145 6.74614
R590 VSS.n270 VSS.n163 6.74614
R591 VSS.n289 VSS.n146 6.74614
R592 VSS.n271 VSS.n162 6.74614
R593 VSS.n287 VSS.n147 6.74614
R594 VSS.n272 VSS.n161 6.74614
R595 VSS.n286 VSS.n148 6.74614
R596 VSS.n273 VSS.n160 6.74614
R597 VSS.n275 VSS.n158 6.74614
R598 VSS.n283 VSS.n150 6.74614
R599 VSS.n276 VSS.n157 6.74614
R600 VSS.n282 VSS.n151 6.74614
R601 VSS.n277 VSS.n156 6.74614
R602 VSS.n281 VSS.n152 6.74614
R603 VSS.n278 VSS.n155 6.74614
R604 VSS.t67 VSS.n124 6.74614
R605 VSS.n280 VSS.n155 6.74614
R606 VSS.n278 VSS.n152 6.74614
R607 VSS.n281 VSS.n156 6.74614
R608 VSS.n277 VSS.n151 6.74614
R609 VSS.n282 VSS.n157 6.74614
R610 VSS.n276 VSS.n150 6.74614
R611 VSS.n283 VSS.n158 6.74614
R612 VSS.n285 VSS.n160 6.74614
R613 VSS.n273 VSS.n148 6.74614
R614 VSS.n286 VSS.n161 6.74614
R615 VSS.n272 VSS.n147 6.74614
R616 VSS.n287 VSS.n162 6.74614
R617 VSS.n271 VSS.n146 6.74614
R618 VSS.n289 VSS.n163 6.74614
R619 VSS.n270 VSS.n145 6.74614
R620 VSS.n290 VSS.n164 6.74614
R621 VSS.n269 VSS.n144 6.74614
R622 VSS.n291 VSS.n165 6.74614
R623 VSS.n268 VSS.n143 6.74614
R624 VSS.n292 VSS.n166 6.74614
R625 VSS.n267 VSS.n142 6.74614
R626 VSS.n293 VSS.n167 6.74614
R627 VSS.n266 VSS.n141 6.74614
R628 VSS.n294 VSS.n168 6.74614
R629 VSS.n265 VSS.n140 6.74614
R630 VSS.n263 VSS.n138 6.74614
R631 VSS.n297 VSS.n170 6.74614
R632 VSS.n262 VSS.n137 6.74614
R633 VSS.n298 VSS.n171 6.74614
R634 VSS.n261 VSS.n136 6.74614
R635 VSS.n299 VSS.n172 6.74614
R636 VSS.n260 VSS.n135 6.74614
R637 VSS.n300 VSS.n173 6.74614
R638 VSS.n259 VSS.n134 6.74614
R639 VSS.n301 VSS.n174 6.74614
R640 VSS.n258 VSS.n133 6.74614
R641 VSS.n302 VSS.n175 6.74614
R642 VSS.n257 VSS.n132 6.74614
R643 VSS.n303 VSS.n176 6.74614
R644 VSS.n256 VSS.n131 6.74614
R645 VSS.n307 VSS.n177 6.74614
R646 VSS.n255 VSS.n130 6.74614
R647 VSS.n308 VSS.n178 6.74614
R648 VSS.n254 VSS.n129 6.74614
R649 VSS.n309 VSS.n179 6.74614
R650 VSS.n253 VSS.n128 6.74614
R651 VSS.n310 VSS.n180 6.74614
R652 VSS.n252 VSS.n127 6.74614
R653 VSS.n311 VSS.n181 6.74614
R654 VSS.n251 VSS.n126 6.74614
R655 VSS.n312 VSS.n182 6.74614
R656 VSS.n250 VSS.n125 6.74614
R657 VSS.n313 VSS.n183 6.74614
R658 VSS.n249 VSS.n124 6.74614
R659 VSS.t67 VSS.n184 6.74614
R660 VSS.n248 VSS.n123 6.74614
R661 VSS.n314 VSS.n185 6.74614
R662 VSS.n247 VSS.n122 6.74614
R663 VSS.n315 VSS.n186 6.74614
R664 VSS.n246 VSS.n121 6.74614
R665 VSS.n316 VSS.n187 6.74614
R666 VSS.n245 VSS.n120 6.74614
R667 VSS.n317 VSS.n188 6.74614
R668 VSS.n244 VSS.n119 6.74614
R669 VSS.n318 VSS.n189 6.74614
R670 VSS.n243 VSS.n118 6.74614
R671 VSS.n319 VSS.n190 6.74614
R672 VSS.n242 VSS.n117 6.74614
R673 VSS.n320 VSS.n191 6.74614
R674 VSS.n241 VSS.n116 6.74614
R675 VSS.n321 VSS.n192 6.74614
R676 VSS.n238 VSS.n115 6.74614
R677 VSS.n322 VSS.n193 6.74614
R678 VSS.n237 VSS.n114 6.74614
R679 VSS.n323 VSS.n194 6.74614
R680 VSS.n236 VSS.n113 6.74614
R681 VSS.n324 VSS.n195 6.74614
R682 VSS.n235 VSS.n112 6.74614
R683 VSS.n325 VSS.n196 6.74614
R684 VSS.n234 VSS.n111 6.74614
R685 VSS.n326 VSS.n197 6.74614
R686 VSS.n233 VSS.n110 6.74614
R687 VSS.n327 VSS.n198 6.74614
R688 VSS.n329 VSS.n200 6.74614
R689 VSS.n230 VSS.n108 6.74614
R690 VSS.n330 VSS.n201 6.74614
R691 VSS.n354 VSS.n228 6.4562
R692 VSS.n481 VSS.n477 6.16155
R693 VSS.n481 VSS.n96 6.16155
R694 VSS.n481 VSS.n57 6.16155
R695 VSS.n481 VSS.n94 6.16155
R696 VSS.n481 VSS.n59 6.16155
R697 VSS.n481 VSS.n89 6.16155
R698 VSS.n481 VSS.n61 6.16155
R699 VSS.n481 VSS.n87 6.16155
R700 VSS.n481 VSS.n76 6.16155
R701 VSS.n338 VSS.t15 6.07511
R702 VSS.n332 VSS.t7 6.07511
R703 VSS.n87 VSS.t177 6.00901
R704 VSS.t179 VSS.n61 6.00901
R705 VSS.n89 VSS.t181 6.00901
R706 VSS.t137 VSS.n94 6.00901
R707 VSS.n57 VSS.t139 6.00901
R708 VSS.t141 VSS.n96 6.00901
R709 VSS.n97 VSS.t83 5.93097
R710 VSS.t33 VSS.t179 5.88658
R711 VSS.t139 VSS.t44 5.88658
R712 VSS.n88 VSS.t33 5.6967
R713 VSS.t44 VSS.n56 5.6967
R714 VSS.n23 VSS.n2 0.0546951
R715 VSS.n22 VSS.n6 0.0538158
R716 VSS.n36 VSS.t115 3.20134
R717 VSS.n39 VSS.n18 2.81319
R718 VSS.n475 VSS.n12 5.65086
R719 VSS.n14 VSS.n13 0.0486537
R720 VSS.t135 VSS.n217 5.31696
R721 VSS.n346 VSS.n274 5.2625
R722 VSS.n374 VSS.n184 5.12843
R723 VSS.n374 VSS.n201 5.12843
R724 VSS.n374 VSS.n108 5.12843
R725 VSS.n374 VSS.n200 5.12843
R726 VSS.n374 VSS.n198 5.12843
R727 VSS.n374 VSS.n110 5.12843
R728 VSS.n374 VSS.n197 5.12843
R729 VSS.n374 VSS.n111 5.12843
R730 VSS.n374 VSS.n196 5.12843
R731 VSS.n374 VSS.n112 5.12843
R732 VSS.n374 VSS.n195 5.12843
R733 VSS.n374 VSS.n113 5.12843
R734 VSS.n374 VSS.n194 5.12843
R735 VSS.n374 VSS.n114 5.12843
R736 VSS.n374 VSS.n193 5.12843
R737 VSS.n374 VSS.n115 5.12843
R738 VSS.n374 VSS.n192 5.12843
R739 VSS.n374 VSS.n116 5.12843
R740 VSS.n374 VSS.n191 5.12843
R741 VSS.n374 VSS.n117 5.12843
R742 VSS.n374 VSS.n190 5.12843
R743 VSS.n374 VSS.n118 5.12843
R744 VSS.n374 VSS.n189 5.12843
R745 VSS.n374 VSS.n119 5.12843
R746 VSS.n374 VSS.n188 5.12843
R747 VSS.n374 VSS.n120 5.12843
R748 VSS.n374 VSS.n187 5.12843
R749 VSS.n374 VSS.n121 5.12843
R750 VSS.n374 VSS.n186 5.12843
R751 VSS.n374 VSS.n122 5.12843
R752 VSS.n374 VSS.n185 5.12843
R753 VSS.n374 VSS.n123 5.12843
R754 VSS.n374 VSS.n124 5.12843
R755 VSS.n374 VSS.n183 5.12843
R756 VSS.n374 VSS.n125 5.12843
R757 VSS.n374 VSS.n182 5.12843
R758 VSS.n374 VSS.n126 5.12843
R759 VSS.n374 VSS.n181 5.12843
R760 VSS.n374 VSS.n127 5.12843
R761 VSS.n374 VSS.n180 5.12843
R762 VSS.n374 VSS.n128 5.12843
R763 VSS.n374 VSS.n179 5.12843
R764 VSS.n374 VSS.n129 5.12843
R765 VSS.n374 VSS.n178 5.12843
R766 VSS.n374 VSS.n130 5.12843
R767 VSS.n374 VSS.n177 5.12843
R768 VSS.n374 VSS.n131 5.12843
R769 VSS.n374 VSS.n176 5.12843
R770 VSS.n374 VSS.n132 5.12843
R771 VSS.n374 VSS.n175 5.12843
R772 VSS.n374 VSS.n133 5.12843
R773 VSS.n374 VSS.n174 5.12843
R774 VSS.n374 VSS.n134 5.12843
R775 VSS.n374 VSS.n173 5.12843
R776 VSS.n374 VSS.n135 5.12843
R777 VSS.n374 VSS.n172 5.12843
R778 VSS.n374 VSS.n136 5.12843
R779 VSS.n374 VSS.n171 5.12843
R780 VSS.n374 VSS.n137 5.12843
R781 VSS.n374 VSS.n170 5.12843
R782 VSS.n374 VSS.n138 5.12843
R783 VSS.n374 VSS.n140 5.12843
R784 VSS.n374 VSS.n168 5.12843
R785 VSS.n374 VSS.n141 5.12843
R786 VSS.n374 VSS.n167 5.12843
R787 VSS.n374 VSS.n142 5.12843
R788 VSS.n374 VSS.n166 5.12843
R789 VSS.n374 VSS.n143 5.12843
R790 VSS.n374 VSS.n165 5.12843
R791 VSS.n374 VSS.n144 5.12843
R792 VSS.n374 VSS.n164 5.12843
R793 VSS.n374 VSS.n145 5.12843
R794 VSS.n374 VSS.n163 5.12843
R795 VSS.n374 VSS.n146 5.12843
R796 VSS.n374 VSS.n162 5.12843
R797 VSS.n374 VSS.n147 5.12843
R798 VSS.n374 VSS.n161 5.12843
R799 VSS.n374 VSS.n148 5.12843
R800 VSS.n374 VSS.n160 5.12843
R801 VSS.n374 VSS.n158 5.12843
R802 VSS.n374 VSS.n150 5.12843
R803 VSS.n374 VSS.n157 5.12843
R804 VSS.n374 VSS.n151 5.12843
R805 VSS.n374 VSS.n156 5.12843
R806 VSS.n374 VSS.n152 5.12843
R807 VSS.n374 VSS.n155 5.12843
R808 VSS.t151 VSS.n78 5.12708
R809 VSS.t157 VSS.n81 5.12708
R810 VSS.t160 VSS.n65 5.12708
R811 VSS.t163 VSS.n84 5.12708
R812 VSS.n86 VSS.t176 5.12708
R813 VSS.t142 VSS.n55 5.12708
R814 VSS.t119 VSS.n54 5.12708
R815 VSS.t123 VSS.n394 5.12708
R816 VSS.t126 VSS.n51 5.12708
R817 VSS.t132 VSS.n48 5.12708
R818 VSS.n437 VSS.t21 4.93721
R819 VSS.n476 VSS.t56 4.93721
R820 VSS.n471 VSS.n30 4.69693
R821 VSS.n386 VSS.n385 4.67815
R822 VSS.n436 VSS.n70 4.55746
R823 VSS.n447 VSS.n79 4.55746
R824 VSS.n434 VSS.n68 4.55746
R825 VSS.n433 VSS.n67 4.55746
R826 VSS.n449 VSS.n81 4.55746
R827 VSS.n431 VSS.n65 4.55746
R828 VSS.n430 VSS.n64 4.55746
R829 VSS.n455 VSS.n84 4.55746
R830 VSS.n400 VSS.n54 4.55746
R831 VSS.n401 VSS.n393 4.55746
R832 VSS.n404 VSS.n394 4.55746
R833 VSS.n407 VSS.n51 4.55746
R834 VSS.n408 VSS.n396 4.55746
R835 VSS.n410 VSS.n397 4.55746
R836 VSS.n411 VSS.n49 4.55746
R837 VSS.n473 VSS.n399 4.55746
R838 VSS.n464 VSS.n463 4.5005
R839 VSS.n462 VSS.n421 4.5005
R840 VSS.n461 VSS.n460 4.5005
R841 VSS.n10 VSS.n390 0.0881593
R842 VSS.n39 VSS.n345 4.23094
R843 VSS.n39 VSS.n331 4.23094
R844 VSS.n39 VSS.n339 4.23094
R845 VSS.n475 VSS.n472 4.22744
R846 VSS.n456 VSS.n454 4.22744
R847 VSS.n456 VSS.n445 4.22744
R848 VSS.n475 VSS.n402 4.22725
R849 VSS.t23 VSS.n78 4.17772
R850 VSS.n452 VSS.t29 4.17772
R851 VSS.t29 VSS.n64 4.17772
R852 VSS.t50 VSS.n393 4.17772
R853 VSS.n403 VSS.t50 4.17772
R854 VSS.t54 VSS.n48 4.17772
R855 VSS.t154 VSS.t24 3.98784
R856 VSS.t129 VSS.t53 3.98784
R857 VSS.n353 VSS.n39 3.97732
R858 VSS.n355 VSS.n202 3.97266
R859 VSS.n328 VSS.n199 3.97266
R860 VSS.n264 VSS.n139 3.97266
R861 VSS.n284 VSS.n159 3.97266
R862 VSS.n279 VSS.n153 3.9725
R863 VSS.n274 VSS.n149 3.9725
R864 VSS.n296 VSS.n169 3.9725
R865 VSS.n231 VSS.n109 3.9725
R866 VSS.n373 VSS.n372 3.67007
R867 VSS.n365 VSS.n99 3.67007
R868 VSS.n219 VSS.n211 3.67007
R869 VSS.n360 VSS.n103 3.67007
R870 VSS.n222 VSS.n207 3.67007
R871 VSS.n356 VSS.n106 3.67007
R872 VSS.n364 VSS.n100 3.67007
R873 VSS.n359 VSS.n104 3.67007
R874 VSS.n217 VSS.n212 3.67007
R875 VSS.n223 VSS.n206 3.67007
R876 VSS.n225 VSS.n205 3.67007
R877 VSS.n228 VSS.n203 3.67007
R878 VSS.n357 VSS.n205 3.67007
R879 VSS.n358 VSS.n206 3.67007
R880 VSS.n220 VSS.n102 3.67007
R881 VSS.n366 VSS.n213 3.67007
R882 VSS.n459 VSS.n424 3.46952
R883 VSS.t21 VSS.n77 3.41822
R884 VSS.n451 VSS.t27 3.41822
R885 VSS.t30 VSS.n63 3.41822
R886 VSS.n392 VSS.t45 3.41822
R887 VSS.n405 VSS.t47 3.41822
R888 VSS.t56 VSS.n47 3.41822
R889 VSS.n481 VSS.n45 3.38773
R890 VSS.n481 VSS.n73 3.38773
R891 VSS.n481 VSS.n4 1.385
R892 VSS.n10 VSS.n9 0.0454629
R893 VSS.n481 VSS.n8 3.38758
R894 VSS.n481 VSS.n19 1.67292
R895 VSS.n5 VSS.n85 0.0574968
R896 VSS.n32 VSS.n465 3.3755
R897 VSS.n459 VSS.n31 3.3755
R898 VSS.n39 VSS.n341 3.37539
R899 VSS.n39 VSS.n333 3.37539
R900 VSS.n39 VSS.n336 3.37539
R901 VSS.n438 VSS.t149 3.22835
R902 VSS.n436 VSS.t151 3.22835
R903 VSS.n435 VSS.t153 3.22835
R904 VSS.n447 VSS.t154 3.22835
R905 VSS.n448 VSS.t156 3.22835
R906 VSS.n432 VSS.t159 3.22835
R907 VSS.n452 VSS.t162 3.22835
R908 VSS.n403 VSS.t121 3.22835
R909 VSS.n406 VSS.t124 3.22835
R910 VSS.n409 VSS.t127 3.22835
R911 VSS.n411 VSS.t129 3.22835
R912 VSS.n412 VSS.t130 3.22835
R913 VSS.n473 VSS.t132 3.22835
R914 VSS.n474 VSS.t133 3.22835
R915 VSS.n340 VSS.t1 3.14902
R916 VSS.n20 VSS.t110 3.14902
R917 VSS.n17 VSS.t111 3.14902
R918 VSS.n342 VSS.t3 3.14902
R919 VSS.n344 VSS.t5 3.14902
R920 VSS.n21 VSS.t114 3.14902
R921 VSS.n374 VSS.n202 3.02019
R922 VSS.n374 VSS.n199 3.02019
R923 VSS.n374 VSS.n139 3.02019
R924 VSS.n374 VSS.n159 3.02019
R925 VSS.n374 VSS.n109 3.02
R926 VSS.n374 VSS.n169 3.02
R927 VSS.n374 VSS.n149 3.02
R928 VSS.n374 VSS.n153 3.02
R929 VSS.n482 VSS.n2 3.0005
R930 VSS.n9 VSS.n0 3.0005
R931 VSS.n33 VSS.n8 3.0005
R932 VSS.n34 VSS.n6 3.0005
R933 VSS.n484 VSS.n43 2.98702
R934 VSS.n481 VSS.n23 1.86425
R935 VSS.n481 VSS.n93 2.81806
R936 VSS.n481 VSS.n22 1.86454
R937 VSS.n39 VSS.n343 2.80331
R938 VSS.n440 VSS.t150 2.79558
R939 VSS.n426 VSS.t161 2.79551
R940 VSS.n443 VSS.t152 2.79551
R941 VSS.n429 VSS.t155 2.79551
R942 VSS.n427 VSS.t158 2.79551
R943 VSS.n417 VSS.t125 2.79551
R944 VSS.n416 VSS.t128 2.79551
R945 VSS.n415 VSS.t131 2.79551
R946 VSS.n419 VSS.t122 2.79551
R947 VSS.n470 VSS.t134 2.79543
R948 VSS.n420 VSS.t120 2.79543
R949 VSS.n425 VSS.t164 2.79543
R950 VSS.n335 VSS.n334 2.69572
R951 VSS.t172 VSS.t160 2.65873
R952 VSS.t174 VSS.t163 2.65873
R953 VSS.t144 VSS.t119 2.65873
R954 VSS.t146 VSS.t123 2.65873
R955 VSS.n481 VSS.n44 2.57114
R956 VSS.n481 VSS.n478 2.57114
R957 VSS.n481 VSS.n58 2.57114
R958 VSS.n481 VSS.n90 2.57114
R959 VSS.n481 VSS.n71 2.57114
R960 VSS.n481 VSS.n75 2.57114
R961 VSS.n470 VSS.n469 2.46314
R962 VSS.n32 VSS.n420 2.4382
R963 VSS.n31 VSS.n425 2.4382
R964 VSS.n372 VSS.n371 2.41647
R965 VSS.n371 VSS.n367 2.41647
R966 VSS.n371 VSS.n216 2.41647
R967 VSS.n371 VSS.n365 2.41647
R968 VSS.n371 VSS.n218 2.41647
R969 VSS.n371 VSS.n219 2.41647
R970 VSS.n371 VSS.n363 2.41647
R971 VSS.n371 VSS.n362 2.41647
R972 VSS.n371 VSS.n361 2.41647
R973 VSS.n371 VSS.n360 2.41647
R974 VSS.n371 VSS.n221 2.41647
R975 VSS.n371 VSS.n222 2.41647
R976 VSS.n371 VSS.n356 2.41647
R977 VSS.n371 VSS.n226 2.41647
R978 VSS.n371 VSS.n227 2.41647
R979 VSS.n374 VSS.n215 2.41647
R980 VSS.n374 VSS.n214 2.41647
R981 VSS.n374 VSS.n213 2.41647
R982 VSS.n374 VSS.n212 2.41647
R983 VSS.n374 VSS.n210 2.41647
R984 VSS.n374 VSS.n209 2.41647
R985 VSS.n374 VSS.n208 2.41647
R986 VSS.n374 VSS.n206 2.41647
R987 VSS.n374 VSS.n205 2.41647
R988 VSS.n374 VSS.n204 2.41647
R989 VSS.n374 VSS.n203 2.41647
R990 VSS.n374 VSS.n100 2.41647
R991 VSS.n374 VSS.n101 2.41647
R992 VSS.n374 VSS.n102 2.41647
R993 VSS.n374 VSS.n104 2.41647
R994 VSS.n374 VSS.n105 2.41647
R995 VSS.n374 VSS.n107 2.41647
R996 VSS.n441 VSS.n440 2.31388
R997 VSS.n31 VSS.n426 2.31337
R998 VSS.n443 VSS.n442 2.31337
R999 VSS.n429 VSS.n428 2.31337
R1000 VSS.n458 VSS.n427 2.31337
R1001 VSS.n466 VSS.n417 2.31337
R1002 VSS.n468 VSS.n416 2.31337
R1003 VSS.n469 VSS.n415 2.31337
R1004 VSS.n32 VSS.n419 2.31337
R1005 VSS.n368 VSS.t70 2.21155
R1006 VSS.n369 VSS.t72 2.21097
R1007 VSS.n98 VSS.t63 2.21095
R1008 VSS.n383 VSS.t98 2.21087
R1009 VSS.n305 VSS.t66 2.21086
R1010 VSS.n375 VSS.t106 2.21082
R1011 VSS.n239 VSS.t68 2.21079
R1012 VSS.n379 VSS.t102 2.21049
R1013 VSS.n304 VSS.t64 2.21026
R1014 VSS.n381 VSS.t100 2.21008
R1015 VSS.n377 VSS.t104 2.20998
R1016 VSS.n385 VSS.t97 2.2097
R1017 VSS.n98 VSS.t73 2.20308
R1018 VSS.n239 VSS.t78 2.20296
R1019 VSS.n369 VSS.t82 2.20266
R1020 VSS.n381 VSS.t90 2.20262
R1021 VSS.n379 VSS.t92 2.20251
R1022 VSS.n383 VSS.t88 2.20242
R1023 VSS.n305 VSS.t76 2.20241
R1024 VSS.n368 VSS.t80 2.20239
R1025 VSS.n304 VSS.t74 2.2023
R1026 VSS.n377 VSS.t94 2.20193
R1027 VSS.n385 VSS.t87 2.20166
R1028 VSS.n375 VSS.t96 2.20121
R1029 VSS.n388 VSS 1.66046
R1030 VSS.n26 VSS.n25 0.290062
R1031 VSS.n27 VSS.n1 0.77644
R1032 VSS.n27 VSS.n35 0.771635
R1033 VSS.n24 VSS.n28 0.288598
R1034 VSS VSS.n29 0.452569
R1035 VSS.n389 VSS 1.65452
R1036 VSS.n73 VSS.t17 1.61916
R1037 VSS.n45 VSS.t61 1.61738
R1038 VSS.n358 VSS.t169 1.51949
R1039 VSS.n72 VSS.t19 1.47437
R1040 VSS.n6 VSS.t25 1.47396
R1041 VSS.n8 VSS.t34 1.47382
R1042 VSS.n3 VSS.t48 1.47382
R1043 VSS.n2 VSS.t55 1.47367
R1044 VSS.n92 VSS.t40 1.47359
R1045 VSS.n6 VSS.t22 1.47344
R1046 VSS.n85 VSS.t28 1.47335
R1047 VSS.n7 VSS.t31 1.47335
R1048 VSS.n2 VSS.t52 1.47335
R1049 VSS.n46 VSS.t58 1.47335
R1050 VSS.n91 VSS.t37 1.47324
R1051 VSS.n9 VSS.t43 1.4729
R1052 VSS.n390 VSS.t46 1.4729
R1053 VSS.t149 VSS.n77 1.32961
R1054 VSS.t153 VSS.n69 1.32961
R1055 VSS.t156 VSS.n80 1.32961
R1056 VSS.t170 VSS.t26 1.32961
R1057 VSS.t26 VSS.t157 1.32961
R1058 VSS.t171 VSS.n66 1.32961
R1059 VSS.t159 VSS.n66 1.32961
R1060 VSS.t173 VSS.n83 1.32961
R1061 VSS.t162 VSS.n83 1.32961
R1062 VSS.t175 VSS.n63 1.32961
R1063 VSS.t143 VSS.n392 1.32961
R1064 VSS.t121 VSS.n53 1.32961
R1065 VSS.t145 VSS.n53 1.32961
R1066 VSS.t124 VSS.n395 1.32961
R1067 VSS.t147 VSS.n395 1.32961
R1068 VSS.t51 VSS.t126 1.32961
R1069 VSS.t148 VSS.t51 1.32961
R1070 VSS.t127 VSS.n50 1.32961
R1071 VSS.t130 VSS.n398 1.32961
R1072 VSS.t133 VSS.n47 1.32961
R1073 VSS.n279 VSS.t62 1.316
R1074 VSS.t24 VSS.n68 1.13974
R1075 VSS.t27 VSS.n82 1.13974
R1076 VSS.t47 VSS.n52 1.13974
R1077 VSS.t53 VSS.n397 1.13974
R1078 VSS.n424 VSS.n43 1.1255
R1079 vco_var_VSS VSS.n484 0.903417
R1080 VSS.n387 VSS.n97 0.762586
R1081 VSS.n220 VSS.t71 0.759994
R1082 VSS.n457 VSS.n16 0.7505
R1083 VSS.n467 VSS.n11 0.7505
R1084 VSS.n334 VSS.n97 0.674942
R1085 VSS.n374 VSS.n154 0.572518
R1086 VSS.n371 VSS.n154 0.57194
R1087 VSS.n433 VSS.t170 0.57012
R1088 VSS.n451 VSS.t172 0.57012
R1089 VSS.n430 VSS.t174 0.57012
R1090 VSS.t177 VSS.t32 0.57012
R1091 VSS.t49 VSS.t141 0.57012
R1092 VSS.n401 VSS.t144 0.57012
R1093 VSS.n405 VSS.t146 0.57012
R1094 VSS.n408 VSS.t148 0.57012
R1095 VSS.n453 VSS.n426 0.561603
R1096 VSS.n444 VSS.n443 0.561603
R1097 VSS.n13 VSS.n429 0.561603
R1098 VSS.n15 VSS.n427 0.561603
R1099 VSS.n417 VSS.n38 0.561603
R1100 VSS.n416 VSS.n12 0.561603
R1101 VSS.n415 VSS.n414 0.561603
R1102 VSS.n419 VSS.n418 0.561603
R1103 VSS.n471 VSS.n470 0.56142
R1104 VSS.n422 VSS.n420 0.56142
R1105 VSS.n425 VSS.n423 0.56142
R1106 VSS.n440 VSS.n439 0.56108
R1107 VSS.n446 VSS.t23 0.380247
R1108 VSS.t35 VSS.n60 0.380247
R1109 VSS.n95 VSS.t42 0.380247
R1110 VSS.n413 VSS.t54 0.380247
R1111 VSS.n483 VSS.n42 0.353904
R1112 VSS.n462 VSS.n461 0.337235
R1113 VSS.n463 VSS.n462 0.337235
R1114 VSS.n25 VSS.n42 0.318978
R1115 VSS.n389 VSS.n29 0.492876
R1116 VSS.n29 VSS.n28 0.807767
R1117 VSS.n35 VSS.n28 0.692189
R1118 VSS.n389 VSS.n388 0.25856
R1119 VSS.n349 VSS.n39 0.245325
R1120 VSS.n383 VSS.n382 0.243424
R1121 VSS.n306 VSS.n304 0.243424
R1122 VSS.n288 VSS.n98 0.242716
R1123 VSS.n385 VSS.n384 0.242681
R1124 VSS.n34 VSS.n35 0.113752
R1125 VSS.n379 VSS.n378 0.24245
R1126 VSS.n239 VSS.n224 0.24245
R1127 VSS.n461 VSS.n423 0.241827
R1128 VSS.n463 VSS.n422 0.241827
R1129 VSS.n381 VSS.n380 0.240796
R1130 VSS.n305 VSS.n240 0.240796
R1131 VSS.n377 VSS.n376 0.239822
R1132 VSS.n370 VSS.n368 0.239822
R1133 VSS.n378 VSS.n377 0.227974
R1134 VSS.n368 VSS.n224 0.227974
R1135 VSS.n382 VSS.n381 0.227001
R1136 VSS.n306 VSS.n305 0.227001
R1137 VSS.n376 VSS.n375 0.225646
R1138 VSS.n370 VSS.n369 0.225646
R1139 VSS.n380 VSS.n379 0.224672
R1140 VSS.n240 VSS.n239 0.224672
R1141 VSS.n384 VSS.n383 0.223727
R1142 VSS.n304 VSS.n288 0.223715
R1143 VSS.n0 VSS.n1 0.104141
R1144 VSS.n371 VSS.n224 0.218846
R1145 VSS.n378 VSS.n374 0.218846
R1146 VSS.n371 VSS.n306 0.218846
R1147 VSS.n382 VSS.n374 0.218846
R1148 VSS.n371 VSS.n370 0.208386
R1149 VSS.n376 VSS.n374 0.208386
R1150 VSS.n371 VSS.n240 0.208386
R1151 VSS.n380 VSS.n374 0.208386
R1152 VSS.n371 VSS.n288 0.208371
R1153 VSS.n384 VSS.n374 0.20836
R1154 VSS.n442 VSS.n441 0.1501
R1155 VSS.n442 VSS.n428 0.1501
R1156 VSS.n469 VSS.n468 0.1501
R1157 VSS.t8 VSS.t10 0.143158
R1158 VSS.n465 VSS.n30 0.113321
R1159 VSS.n441 VSS.n424 0.106994
R1160 VSS.n343 VSS.n342 0.0927224
R1161 VSS.n344 VSS.n343 0.0891245
R1162 VSS.n439 VSS.n43 0.0846837
R1163 VSS.n333 VSS.n332 0.0814472
R1164 VSS.n339 VSS.n338 0.0794206
R1165 VSS.n340 VSS.n331 0.0784641
R1166 VSS.n444 VSS.n13 0.0779076
R1167 VSS.n337 VSS.n336 0.0776211
R1168 VSS.n414 VSS.n12 0.0775723
R1169 VSS.n345 VSS.n344 0.0773061
R1170 VSS.n483 VSS.n26 0.384827
R1171 VSS.n457 VSS.n428 0.0753
R1172 VSS.n458 VSS.n457 0.0753
R1173 VSS.n467 VSS.n466 0.0753
R1174 VSS.n468 VSS.n467 0.0753
R1175 VSS.n336 VSS.n335 0.0750054
R1176 VSS.n339 VSS.n337 0.0725235
R1177 VSS.n341 VSS.n340 0.0721359
R1178 VSS.n338 VSS.n333 0.0711793
R1179 VSS.n332 VSS.n331 0.0686974
R1180 VSS.n341 VSS.n20 0.0675776
R1181 VSS.n26 VSS.n482 0.379074
R1182 VSS.t4 VSS.n40 31.5502
R1183 VSS.n34 VSS.n33 0.2425
R1184 VSS.n482 VSS.n0 0.2425
R1185 VSS.n466 VSS.n32 0.175033
R1186 VSS.n31 VSS.n458 0.175033
R1187 VSS.n12 VSS.n11 0.0969892
R1188 VSS.n16 VSS.n14 0.0486893
R1189 VSS.n342 VSS.n17 0.0951565
R1190 VSS.n6 VSS.n5 0.0937229
R1191 VSS.n352 VSS.n39 0.0617935
R1192 VSS.n41 VSS.n39 0.0278401
R1193 VSS.n351 VSS.n39 0.0617935
R1194 VSS.n350 VSS.n39 0.0617935
R1195 VSS.n348 VSS.n39 0.0617935
R1196 VSS.n345 VSS.n21 0.061725
R1197 VSS.n11 VSS.n38 0.0596436
R1198 VSS.n472 VSS.n471 0.0594056
R1199 VSS.n454 VSS.n453 0.0594056
R1200 VSS.n445 VSS.n439 0.0594056
R1201 VSS.n422 VSS.n402 0.059027
R1202 VSS.n418 VSS.n402 0.059027
R1203 VSS.n445 VSS.n444 0.0586497
R1204 VSS.n454 VSS.n423 0.0586497
R1205 VSS.n472 VSS.n414 0.0586497
R1206 VSS.t10 VSS.n483 0.0585075
R1207 VSS.n450 VSS.n15 0.0582235
R1208 VSS.n453 VSS.n450 0.0582235
R1209 VSS.n418 VSS.n37 0.0932316
R1210 VSS.n3 VSS.n2 0.0932024
R1211 VSS.n30 VSS.t8 0.0894317
R1212 VSS.n27 VSS.n25 0.0889456
R1213 VSS VSS.n24 0.0889456
R1214 VSS.n36 VSS.n21 0.0767479
R1215 VSS.n46 VSS.n23 0.0746472
R1216 VSS.n24 VSS.n27 0.0594637
R1217 VSS.n38 VSS.n37 0.0239808
R1218 VSS.n460 VSS.n459 0.0569103
R1219 VSS.n460 VSS.n421 0.0569103
R1220 VSS.n464 VSS.n421 0.0569103
R1221 VSS.n465 VSS.n464 0.0569103
R1222 VSS.n92 VSS.n9 0.0529665
R1223 VSS.n46 VSS.n45 0.0518066
R1224 VSS.n91 VSS.n8 0.0517609
R1225 VSS.n73 VSS.n72 0.050601
R1226 VSS.n72 VSS.n22 0.0758859
R1227 VSS.n93 VSS.n91 0.0480833
R1228 VSS.n19 VSS.n85 0.0920921
R1229 VSS.n8 VSS.n7 0.0912242
R1230 VSS.n16 VSS.n15 0.0596436
R1231 VSS.n390 VSS.n4 0.107126
R1232 VSS.n93 VSS.n92 0.0464069
R1233 VSS.n1 VSS.n33 0.148141
R1234 a_20954_346.n0 a_20954_346.t0 4.85847
R1235 a_20954_346.t15 a_20954_346.n2 4.83761
R1236 a_20954_346.n2 a_20954_346.t14 4.83657
R1237 a_20954_346.n2 a_20954_346.t13 4.83657
R1238 a_20954_346.n2 a_20954_346.t12 4.83657
R1239 a_20954_346.n1 a_20954_346.t11 4.83657
R1240 a_20954_346.n1 a_20954_346.t10 4.83657
R1241 a_20954_346.n1 a_20954_346.t9 4.83657
R1242 a_20954_346.n1 a_20954_346.t8 4.83657
R1243 a_20954_346.n1 a_20954_346.t7 4.83657
R1244 a_20954_346.n1 a_20954_346.t6 4.83657
R1245 a_20954_346.n1 a_20954_346.t5 4.83657
R1246 a_20954_346.n1 a_20954_346.t4 4.83657
R1247 a_20954_346.n0 a_20954_346.t3 4.83657
R1248 a_20954_346.n0 a_20954_346.t2 4.83657
R1249 a_20954_346.n0 a_20954_346.t1 4.83657
R1250 a_20954_346.n2 a_20954_346.t16 0.895788
R1251 a_20954_346.n1 a_20954_346.n0 0.175641
R1252 a_20954_346.n2 a_20954_346.n1 0.131856
R1253 a_11798_1180.n4 a_11798_1180.t25 3.17099
R1254 a_11798_1180.n5 a_11798_1180.t18 3.17099
R1255 a_11798_1180.n10 a_11798_1180.t15 2.79558
R1256 a_11798_1180.n32 a_11798_1180.t23 2.79551
R1257 a_11798_1180.n23 a_11798_1180.t22 2.79551
R1258 a_11798_1180.n24 a_11798_1180.t24 2.79551
R1259 a_11798_1180.n25 a_11798_1180.t26 2.79551
R1260 a_11798_1180.n26 a_11798_1180.t27 2.79551
R1261 a_11798_1180.n19 a_11798_1180.t16 2.79551
R1262 a_11798_1180.n11 a_11798_1180.t17 2.79551
R1263 a_11798_1180.n12 a_11798_1180.t19 2.79551
R1264 a_11798_1180.n13 a_11798_1180.t20 2.79551
R1265 a_11798_1180.n27 a_11798_1180.t28 2.79543
R1266 a_11798_1180.n14 a_11798_1180.t21 2.79543
R1267 a_11798_1180.t14 a_11798_1180.n8 2.61386
R1268 a_11798_1180.n1 a_11798_1180.t0 2.61074
R1269 a_11798_1180.n1 a_11798_1180.t2 2.56233
R1270 a_11798_1180.n2 a_11798_1180.t5 2.5622
R1271 a_11798_1180.n7 a_11798_1180.t10 2.56207
R1272 a_11798_1180.n2 a_11798_1180.t7 2.56206
R1273 a_11798_1180.n2 a_11798_1180.t9 2.56174
R1274 a_11798_1180.n2 a_11798_1180.t4 2.56174
R1275 a_11798_1180.n1 a_11798_1180.t3 2.56174
R1276 a_11798_1180.n2 a_11798_1180.t6 2.56173
R1277 a_11798_1180.n1 a_11798_1180.t1 2.56173
R1278 a_11798_1180.n8 a_11798_1180.t13 2.5616
R1279 a_11798_1180.n8 a_11798_1180.t12 2.5616
R1280 a_11798_1180.n7 a_11798_1180.t11 2.5616
R1281 a_11798_1180.n2 a_11798_1180.t8 2.5616
R1282 a_11798_1180.n20 a_11798_1180.n10 2.36008
R1283 a_11798_1180.n27 a_11798_1180.n21 2.35974
R1284 a_11798_1180.n14 a_11798_1180.n0 2.35974
R1285 a_11798_1180.n33 a_11798_1180.n23 2.35957
R1286 a_11798_1180.n33 a_11798_1180.n32 2.33977
R1287 a_11798_1180.n26 a_11798_1180.n21 2.33977
R1288 a_11798_1180.n20 a_11798_1180.n19 2.33977
R1289 a_11798_1180.n13 a_11798_1180.n0 2.33977
R1290 a_11798_1180.n24 a_11798_1180.n22 2.31337
R1291 a_11798_1180.n25 a_11798_1180.n3 2.31337
R1292 a_11798_1180.n11 a_11798_1180.n9 2.31337
R1293 a_11798_1180.n12 a_11798_1180.n0 2.31337
R1294 a_11798_1180.n31 a_11798_1180.n23 0.748603
R1295 a_11798_1180.n28 a_11798_1180.n27 0.74842
R1296 a_11798_1180.n15 a_11798_1180.n14 0.74842
R1297 a_11798_1180.n18 a_11798_1180.n10 0.74808
R1298 a_11798_1180.n32 a_11798_1180.n31 0.561603
R1299 a_11798_1180.n30 a_11798_1180.n24 0.561603
R1300 a_11798_1180.n29 a_11798_1180.n25 0.561603
R1301 a_11798_1180.n28 a_11798_1180.n26 0.561603
R1302 a_11798_1180.n19 a_11798_1180.n18 0.561603
R1303 a_11798_1180.n17 a_11798_1180.n11 0.561603
R1304 a_11798_1180.n16 a_11798_1180.n12 0.561603
R1305 a_11798_1180.n15 a_11798_1180.n13 0.561603
R1306 a_11798_1180.n4 a_11798_1180.n3 0.401975
R1307 a_11798_1180.n5 a_11798_1180.n0 0.401975
R1308 a_11798_1180.n5 a_11798_1180.n16 0.284179
R1309 a_11798_1180.n4 a_11798_1180.n29 0.284179
R1310 a_11798_1180.n1 a_11798_1180.n33 0.25306
R1311 a_11798_1180.n6 a_11798_1180.n21 0.0449208
R1312 a_11798_1180.n2 a_11798_1180.n20 0.25306
R1313 a_11798_1180.n2 a_11798_1180.n6 0.203345
R1314 a_11798_1180.n2 a_11798_1180.n1 0.196551
R1315 a_11798_1180.n7 a_11798_1180.n0 0.194161
R1316 a_11798_1180.n31 a_11798_1180.n30 0.1875
R1317 a_11798_1180.n30 a_11798_1180.n4 0.1875
R1318 a_11798_1180.n29 a_11798_1180.n28 0.1875
R1319 a_11798_1180.n18 a_11798_1180.n17 0.1875
R1320 a_11798_1180.n17 a_11798_1180.n5 0.1875
R1321 a_11798_1180.n16 a_11798_1180.n15 0.1875
R1322 a_11798_1180.n9 a_11798_1180.n0 0.153033
R1323 a_11798_1180.n22 a_11798_1180.n3 0.153033
R1324 a_11798_1180.n8 a_11798_1180.n7 0.147538
R1325 a_11798_1180.n7 a_11798_1180.n2 0.147538
R1326 a_11798_1180.n33 a_11798_1180.n22 0.106833
R1327 a_11798_1180.n3 a_11798_1180.n6 0.0449208
R1328 a_11798_1180.n20 a_11798_1180.n9 0.106833
R1329 a_5060_3002.n0 a_5060_3002.t3 53.6608
R1330 a_5060_3002.n3 a_5060_3002.t4 29.2688
R1331 a_5060_3002.n2 a_5060_3002.t5 24.2693
R1332 a_5060_3002.n1 a_5060_3002.t1 24.2693
R1333 a_5060_3002.t0 a_5060_3002.n3 15.6064
R1334 a_5060_3002.n0 a_5060_3002.t2 9.21754
R1335 a_5060_3002.n3 a_5060_3002.n2 1.7693
R1336 a_5060_3002.n2 a_5060_3002.n1 0.543167
R1337 a_5060_3002.n1 a_5060_3002.n0 0.320233
R1338 a_5560_3922.n0 a_5560_3922.t0 27.72
R1339 a_5560_3922.n0 a_5560_3922.t1 24.1197
R1340 a_5560_3922.t2 a_5560_3922.n0 9.38813
R1341 a_5560_5708.n0 a_5560_5708.t2 55.2712
R1342 a_5560_5708.n0 a_5560_5708.t1 27.8842
R1343 a_5560_5708.t0 a_5560_5708.n0 7.50485
R1344 a_5060_5708.n0 a_5060_5708.t1 34.3045
R1345 a_5060_5708.t0 a_5060_5708.n0 5.85564
R1346 a_5060_5708.t0 a_5060_5708.n0 5.85498
R1347 a_6568_6136.n2 a_6568_6136.t1 19.9393
R1348 a_6568_6136.n0 a_6568_6136.t4 19.6783
R1349 a_6568_6136.n1 a_6568_6136.t0 17.974
R1350 a_6568_6136.n2 a_6568_6136.n1 5.04317
R1351 a_6568_6136.n0 a_6568_6136.t3 4.81727
R1352 a_6568_6136.n1 a_6568_6136.n0 4.76157
R1353 a_6568_6136.t2 a_6568_6136.n2 3.15445
R1354 a_5948_4416.n0 a_5948_4416.t2 30.2902
R1355 a_5948_4416.n0 a_5948_4416.t0 27.2706
R1356 a_5948_4416.t1 a_5948_4416.n0 11.5346
R1357 vco_feed_0.en_b.n0 vco_feed_0.en_b.t0 27.1774
R1358 vco_feed_0.en_b.n4 vco_feed_0.en_b.t6 24.9608
R1359 vco_feed_0.en_b.n3 vco_feed_0.en_b.t3 24.8442
R1360 vco_feed_0.en_b.n1 vco_feed_0.en_b.t7 20.7725
R1361 vco_feed_0.en_b.n1 vco_feed_0.en_b.t5 20.4909
R1362 vco_feed_0.en_b.n0 vco_feed_0.en_b.t4 20.4287
R1363 vco_feed_0.en_b.n0 vco_feed_0.en_b.t1 12.1418
R1364 vco_feed_0.en_b vco_feed_0.en_b.t2 5.74905
R1365 vco_feed_0.en_b.n2 vco_feed_0.en_b.n1 5.30277
R1366 vco_feed_0.en_b.n2 vco_feed_0.en_b.n0 4.5269
R1367 vco_feed_0.en_b vco_feed_0.en_b.n4 2.33103
R1368 vco_feed_0.en_b.n3 vco_feed_0.en_b.n2 0.562233
R1369 vco_feed_0.en_b.n4 vco_feed_0.en_b.n3 0.469833
R1370 vco_bias_0.vbn_buf.n3 vco_bias_0.vbn_buf.t1 45.045
R1371 vco_bias_0.vbn_buf.n2 vco_bias_0.vbn_buf.t4 34.2391
R1372 vco_bias_0.vbn_buf.n2 vco_bias_0.vbn_buf.t3 28.5544
R1373 vco_bias_0.vbn_buf.n1 vco_bias_0.vbn_buf.n0 22.7415
R1374 vco_bias_0.vbn_buf.n0 vco_bias_0.vbn_buf.t2 21.7736
R1375 vco_bias_0.vbn_buf.n4 vco_bias_0.vbn_buf.t0 17.2373
R1376 vco_bias_0.vbn_buf.n4 vco_bias_0.vbn_buf.n3 13.5293
R1377 vco_bias_0.vbn_buf.n3 vco_bias_0.vbn_buf.n2 6.9349
R1378 vco_bias_0.vbn_buf vco_bias_0.vbn_buf.n4 2.55837
R1379 vco_bias_0.vbn_buf vco_bias_0.vbn_buf.n1 0.2645
R1380 vco_bias_0.vbn_buf.n1 vco_bias_0.vbn_buf 0.1985
R1381 vco_bias_0.vbn_buf.n0 vco_bias_0.vbn_buf 0.1105
C77 vtune VSS 3.224e-15
C78 vco_ind_LC VSS 2.30438e-14
C79 rf_out_p VSS 1.41837e-15
C80 rf_out_n VSS 1.34029e-15
C81 vco_buf_in_n VSS 5.55341e-15
C82 vco_buf_in_p VSS 5.53371e-15
C83 di_en VSS 6.67482e-16
C84 vco_var_rf_p VSS 1.329e-14
C85 vco_ind_LA VSS 4.32216e-16
C86 vco_var_rf_n VSS 1.42965e-14
C87 vco_ind_LB VSS 4.28087e-16
C88 VDD VSS 1.9843e-14
C89 vco_feed_0.en_b VSS 6.22562e-15 ; **FLOATING
C90 vco_bias_0.vbg_buf VSS 1.165e-13 ; **FLOATING
C91 vco_bias_0.vbn_buf VSS 1.14713e-13 ; **FLOATING
C92 vco_bias_0.vbn_buf.t2 VSS 1.19159e-15 ; **FLOATING
C93 vco_bias_0.vbn_buf.n0 VSS 1.02668e-16 ; **FLOATING
C94 vco_bias_0.vbn_buf.n1 VSS 5.81761e-17 ; **FLOATING
C95 vco_bias_0.vbn_buf.t4 VSS 5.31473e-15 ; **FLOATING
C96 vco_bias_0.vbn_buf.t3 VSS 5.30722e-15 ; **FLOATING
C97 vco_bias_0.vbn_buf.n2 VSS 1.11203e-16 ; **FLOATING
C98 vco_bias_0.vbn_buf.t1 VSS 1.97991e-15 ; **FLOATING
C99 vco_bias_0.vbn_buf.n3 VSS 1.58501e-16 ; **FLOATING
C100 vco_bias_0.vbn_buf.t0 VSS 1.59116e-17 ; **FLOATING
C101 vco_bias_0.vbn_buf.n4 VSS 1.07256e-16 ; **FLOATING
C102 vco_feed_0.en_b.n0 VSS 3.37312e-16 ; **FLOATING
C103 vco_feed_0.en_b.t2 VSS 2.27124e-15 ; **FLOATING
C104 vco_feed_0.en_b.t7 VSS 3.88066e-17 ; **FLOATING
C105 vco_feed_0.en_b.t5 VSS 3.18712e-17 ; **FLOATING
C106 vco_feed_0.en_b.n1 VSS 2.68991e-16 ; **FLOATING
C107 vco_feed_0.en_b.t4 VSS 3.672e-17 ; **FLOATING
C108 vco_feed_0.en_b.t0 VSS 1.89621e-17 ; **FLOATING
C109 vco_feed_0.en_b.t1 VSS 4.82023e-17 ; **FLOATING
C110 vco_feed_0.en_b.n2 VSS 9.15676e-17 ; **FLOATING
C111 vco_feed_0.en_b.t3 VSS 5.7105e-17 ; **FLOATING
C112 vco_feed_0.en_b.n3 VSS 1.36324e-16 ; **FLOATING
C113 vco_feed_0.en_b.t6 VSS 6.99545e-17 ; **FLOATING
C114 vco_feed_0.en_b.n4 VSS 2.17029e-16 ; **FLOATING
C115 a_5948_4416.t0 VSS 8.54341e-18 ; **FLOATING
C116 a_5948_4416.t2 VSS 4.11726e-17 ; **FLOATING
C117 a_5948_4416.n0 VSS 1.70368e-16 ; **FLOATING
C118 a_5948_4416.t1 VSS 1.85757e-17 ; **FLOATING
C119 a_6568_6136.t1 VSS 9.43151e-17 ; **FLOATING
C120 a_6568_6136.t0 VSS 3.64069e-17 ; **FLOATING
C121 a_6568_6136.t3 VSS 3.77383e-17 ; **FLOATING
C122 a_6568_6136.t4 VSS 9.39005e-17 ; **FLOATING
C123 a_6568_6136.n0 VSS 7.62276e-17 ; **FLOATING
C124 a_6568_6136.n1 VSS 1.14293e-16 ; **FLOATING
C125 a_6568_6136.n2 VSS 7.62841e-17 ; **FLOATING
C126 a_6568_6136.t2 VSS 7.49346e-17 ; **FLOATING
C127 a_5060_5708.t1 VSS 5.21386e-16 ; **FLOATING
C128 a_5060_5708.n0 VSS 5.71417e-16 ; **FLOATING
C129 a_5060_5708.t0 VSS 9.28369e-17 ; **FLOATING
C130 a_5560_5708.t2 VSS 1.17145e-15 ; **FLOATING
C131 a_5560_5708.t1 VSS 3.41348e-16 ; **FLOATING
C132 a_5560_5708.n0 VSS 1.62269e-15 ; **FLOATING
C133 a_5560_5708.t0 VSS 4.09417e-16 ; **FLOATING
C134 a_5560_3922.t0 VSS 6.7083e-16 ; **FLOATING
C135 a_5560_3922.t1 VSS 3.26854e-16 ; **FLOATING
C136 a_5560_3922.n0 VSS 9.04285e-16 ; **FLOATING
C137 a_5560_3922.t2 VSS 2.9947e-16 ; **FLOATING
C138 a_5060_3002.t3 VSS 2.36213e-15 ; **FLOATING
C139 a_5060_3002.t2 VSS 3.15239e-16 ; **FLOATING
C140 a_5060_3002.n0 VSS 1.22983e-15 ; **FLOATING
C141 a_5060_3002.t1 VSS 3.4166e-16 ; **FLOATING
C142 a_5060_3002.n1 VSS 2.13541e-16 ; **FLOATING
C143 a_5060_3002.t5 VSS 3.4166e-16 ; **FLOATING
C144 a_5060_3002.n2 VSS 3.44393e-16 ; **FLOATING
C145 a_5060_3002.t4 VSS 1.03597e-15 ; **FLOATING
C146 a_5060_3002.n3 VSS 1.15104e-15 ; **FLOATING
C147 a_5060_3002.t0 VSS 1.43857e-16 ; **FLOATING
C148 a_11798_1180.n0 VSS 5.85169e-16 ; **FLOATING
C149 a_11798_1180.n1 VSS 1.94803e-15 ; **FLOATING
C150 a_11798_1180.n2 VSS 3.31917e-15 ; **FLOATING
C151 a_11798_1180.n3 VSS 3.01179e-16 ; **FLOATING
C152 a_11798_1180.n4 VSS 9.10018e-17 ; **FLOATING
C153 a_11798_1180.n5 VSS 9.10018e-17 ; **FLOATING
C154 a_11798_1180.n7 VSS 1.33224e-15 ; **FLOATING
C155 a_11798_1180.n8 VSS 1.30858e-15 ; **FLOATING
C156 a_11798_1180.n9 VSS 8.04375e-17 ; **FLOATING
C157 a_11798_1180.t15 VSS 5.78244e-17 ; **FLOATING
C158 a_11798_1180.n10 VSS 4.65221e-17 ; **FLOATING
C159 a_11798_1180.t17 VSS 6.45611e-17 ; **FLOATING
C160 a_11798_1180.n11 VSS 3.49023e-17 ; **FLOATING
C161 a_11798_1180.t18 VSS 6.87748e-17 ; **FLOATING
C162 a_11798_1180.t19 VSS 6.45611e-17 ; **FLOATING
C163 a_11798_1180.n12 VSS 3.49023e-17 ; **FLOATING
C164 a_11798_1180.t20 VSS 6.45611e-17 ; **FLOATING
C165 a_11798_1180.n13 VSS 3.55974e-17 ; **FLOATING
C166 a_11798_1180.t21 VSS 5.78244e-17 ; **FLOATING
C167 a_11798_1180.n14 VSS 4.65135e-17 ; **FLOATING
C168 a_11798_1180.n15 VSS 9.06928e-17 ; **FLOATING
C169 a_11798_1180.n16 VSS 5.9618e-17 ; **FLOATING
C170 a_11798_1180.n17 VSS 5.9618e-17 ; **FLOATING
C171 a_11798_1180.n18 VSS 9.06842e-17 ; **FLOATING
C172 a_11798_1180.t16 VSS 6.45611e-17 ; **FLOATING
C173 a_11798_1180.n19 VSS 3.55974e-17 ; **FLOATING
C174 a_11798_1180.n20 VSS 2.83999e-16 ; **FLOATING
C175 a_11798_1180.n21 VSS 2.8399e-16 ; **FLOATING
C176 a_11798_1180.n22 VSS 8.04375e-17 ; **FLOATING
C177 a_11798_1180.t22 VSS 5.78244e-17 ; **FLOATING
C178 a_11798_1180.n23 VSS 4.65221e-17 ; **FLOATING
C179 a_11798_1180.t24 VSS 6.45611e-17 ; **FLOATING
C180 a_11798_1180.n24 VSS 3.49023e-17 ; **FLOATING
C181 a_11798_1180.t25 VSS 6.87748e-17 ; **FLOATING
C182 a_11798_1180.t26 VSS 6.45611e-17 ; **FLOATING
C183 a_11798_1180.n25 VSS 3.49023e-17 ; **FLOATING
C184 a_11798_1180.t27 VSS 6.45611e-17 ; **FLOATING
C185 a_11798_1180.n26 VSS 3.55974e-17 ; **FLOATING
C186 a_11798_1180.t28 VSS 5.78244e-17 ; **FLOATING
C187 a_11798_1180.n27 VSS 4.65135e-17 ; **FLOATING
C188 a_11798_1180.n28 VSS 9.06928e-17 ; **FLOATING
C189 a_11798_1180.n29 VSS 5.9618e-17 ; **FLOATING
C190 a_11798_1180.n30 VSS 5.9618e-17 ; **FLOATING
C191 a_11798_1180.n31 VSS 9.06842e-17 ; **FLOATING
C192 a_11798_1180.t23 VSS 6.45611e-17 ; **FLOATING
C193 a_11798_1180.n32 VSS 3.55974e-17 ; **FLOATING
C194 a_11798_1180.n33 VSS 2.8399e-16 ; **FLOATING
C195 a_11798_1180.t0 VSS 2.07706e-16 ; **FLOATING
C196 a_11798_1180.t1 VSS 2.02085e-16 ; **FLOATING
C197 a_11798_1180.t2 VSS 2.02076e-16 ; **FLOATING
C198 a_11798_1180.t3 VSS 2.02085e-16 ; **FLOATING
C199 a_11798_1180.t4 VSS 2.02085e-16 ; **FLOATING
C200 a_11798_1180.t5 VSS 2.02076e-16 ; **FLOATING
C201 a_11798_1180.t6 VSS 2.02085e-16 ; **FLOATING
C202 a_11798_1180.t7 VSS 2.02076e-16 ; **FLOATING
C203 a_11798_1180.t8 VSS 2.02085e-16 ; **FLOATING
C204 a_11798_1180.t9 VSS 2.02085e-16 ; **FLOATING
C205 a_11798_1180.t10 VSS 2.02076e-16 ; **FLOATING
C206 a_11798_1180.t11 VSS 2.02085e-16 ; **FLOATING
C207 a_11798_1180.t12 VSS 2.02085e-16 ; **FLOATING
C208 a_11798_1180.t13 VSS 2.02085e-16 ; **FLOATING
C209 a_11798_1180.t14 VSS 2.07672e-16 ; **FLOATING
C210 a_20954_346.n0 VSS 8.27911e-16 ; **FLOATING
C211 a_20954_346.n1 VSS 1.81409e-15 ; **FLOATING
C212 a_20954_346.n2 VSS 6.13094e-15 ; **FLOATING
C213 a_20954_346.t16 VSS 6.50721e-15 ; **FLOATING
C214 a_20954_346.t0 VSS 7.68158e-17 ; **FLOATING
C215 a_20954_346.t1 VSS 7.61466e-17 ; **FLOATING
C216 a_20954_346.t2 VSS 7.61466e-17 ; **FLOATING
C217 a_20954_346.t3 VSS 7.61466e-17 ; **FLOATING
C218 a_20954_346.t4 VSS 7.61466e-17 ; **FLOATING
C219 a_20954_346.t5 VSS 7.61466e-17 ; **FLOATING
C220 a_20954_346.t6 VSS 7.61466e-17 ; **FLOATING
C221 a_20954_346.t7 VSS 7.61466e-17 ; **FLOATING
C222 a_20954_346.t8 VSS 7.61466e-17 ; **FLOATING
C223 a_20954_346.t9 VSS 7.61466e-17 ; **FLOATING
C224 a_20954_346.t10 VSS 7.61466e-17 ; **FLOATING
C225 a_20954_346.t11 VSS 7.61466e-17 ; **FLOATING
C226 a_20954_346.t12 VSS 7.61466e-17 ; **FLOATING
C227 a_20954_346.t13 VSS 7.61466e-17 ; **FLOATING
C228 a_20954_346.t14 VSS 7.61466e-17 ; **FLOATING
C229 a_20954_346.t15 VSS 7.61425e-17 ; **FLOATING
C230 VDD.n0 VSS 1.39623e-16 ; **FLOATING
C231 VDD.n2 VSS 6.08719e-17 ; **FLOATING
C232 VDD.n3 VSS 7.29776e-17 ; **FLOATING
C233 VDD.n4 VSS 8.25516e-17 ; **FLOATING
C234 VDD.n5 VSS 8.25516e-17 ; **FLOATING
C235 VDD.n6 VSS 8.25516e-17 ; **FLOATING
C236 VDD.n7 VSS 8.4752e-16 ; **FLOATING
C237 VDD.n8 VSS 1.48568e-17 ; **FLOATING
C238 VDD.n9 VSS 1.48568e-17 ; **FLOATING
C239 VDD.n10 VSS 8.25516e-17 ; **FLOATING
C240 VDD.n11 VSS 1.48568e-17 ; **FLOATING
C241 VDD.n12 VSS 1.48568e-17 ; **FLOATING
C242 VDD.n13 VSS 8.25516e-17 ; **FLOATING
C243 VDD.n14 VSS 1.48568e-17 ; **FLOATING
C244 VDD.n15 VSS 1.48568e-17 ; **FLOATING
C245 VDD.n16 VSS 1.14253e-16 ; **FLOATING
C246 VDD.n17 VSS 1.54404e-16 ; **FLOATING
C247 VDD.n18 VSS 2.72867e-17 ; **FLOATING
C248 VDD.n19 VSS 4.46658e-17 ; **FLOATING
C249 VDD.n20 VSS 5.06352e-18 ; **FLOATING
C250 VDD.n21 VSS 4.97007e-17 ; **FLOATING
C251 VDD.n22 VSS 4.50806e-17 ; **FLOATING
C252 VDD.n23 VSS 3.62504e-17 ; **FLOATING
C253 VDD.n24 VSS 6.03136e-16 ; **FLOATING
C254 VDD.n25 VSS 5.58751e-17 ; **FLOATING
C255 VDD.n26 VSS 1.48568e-17 ; **FLOATING
C256 VDD.n27 VSS 4.0532e-17 ; **FLOATING
C257 VDD.n29 VSS 2.30023e-16 ; **FLOATING
C258 VDD.n31 VSS 2.62378e-17 ; **FLOATING
C259 VDD.n32 VSS 3.54923e-17 ; **FLOATING
C260 VDD.n33 VSS 3.74186e-17 ; **FLOATING
C261 VDD.n34 VSS 2.61424e-17 ; **FLOATING
C262 VDD.n35 VSS 1.48568e-17 ; **FLOATING
C263 VDD.n36 VSS 2.61424e-17 ; **FLOATING
C264 VDD.n38 VSS 1.48568e-17 ; **FLOATING
C265 VDD.n39 VSS 2.61424e-17 ; **FLOATING
C266 VDD.n40 VSS 1.48568e-17 ; **FLOATING
C267 VDD.n41 VSS 2.61424e-17 ; **FLOATING
C268 VDD.n43 VSS 1.48568e-17 ; **FLOATING
C269 VDD.n44 VSS 1.48568e-17 ; **FLOATING
C270 VDD.n45 VSS 1.48568e-17 ; **FLOATING
C271 VDD.n46 VSS 2.61424e-17 ; **FLOATING
C272 VDD.n47 VSS 2.61424e-17 ; **FLOATING
C273 VDD.n49 VSS 2.61424e-17 ; **FLOATING
C274 VDD.n50 VSS 2.61424e-17 ; **FLOATING
C275 VDD.n52 VSS 2.61424e-17 ; **FLOATING
C276 VDD.t19 VSS 2.96421e-17 ; **FLOATING
C277 VDD.t17 VSS 2.67098e-17 ; **FLOATING
C278 VDD.t15 VSS 2.67098e-17 ; **FLOATING
C279 VDD.t13 VSS 2.67098e-17 ; **FLOATING
C280 VDD.t11 VSS 2.67098e-17 ; **FLOATING
C281 VDD.t9 VSS 2.67098e-17 ; **FLOATING
C282 VDD.t7 VSS 2.67098e-17 ; **FLOATING
C283 VDD.t5 VSS 2.67098e-17 ; **FLOATING
C284 VDD.t4 VSS 2.39444e-17 ; **FLOATING
C285 VDD.t3 VSS 1.99633e-15 ; **FLOATING
C286 VDD.t21 VSS 2.67098e-17 ; **FLOATING
C287 VDD.n53 VSS 1.48568e-17 ; **FLOATING
C288 VDD.t23 VSS 2.67098e-17 ; **FLOATING
C289 VDD.t28 VSS 2.67098e-17 ; **FLOATING
C290 VDD.t25 VSS 2.67098e-17 ; **FLOATING
C291 VDD.t27 VSS 2.67098e-17 ; **FLOATING
C292 VDD.t32 VSS 2.67098e-17 ; **FLOATING
C293 VDD.t26 VSS 2.67098e-17 ; **FLOATING
C294 VDD.t35 VSS 2.39444e-17 ; **FLOATING
C295 VDD.n54 VSS 1.78606e-17 ; **FLOATING
C296 VDD.n55 VSS 1.74124e-17 ; **FLOATING
C297 VDD.n56 VSS 2.14552e-15 ; **FLOATING
C298 VDD.t39 VSS 4.78379e-16 ; **FLOATING
C299 VDD.n57 VSS 2.7586e-15 ; **FLOATING
C300 VDD.t49 VSS 4.78145e-16 ; **FLOATING
C301 VDD.n58 VSS 2.7586e-15 ; **FLOATING
C302 VDD.n59 VSS 1.98421e-15 ; **FLOATING
C303 VDD.t36 VSS 8.10068e-18 ; **FLOATING
C304 VDD.t50 VSS 8.10068e-18 ; **FLOATING
C305 VDD.t38 VSS 8.10068e-18 ; **FLOATING
C306 VDD.t1 VSS 4.81988e-17 ; **FLOATING
C307 VDD.t46 VSS 6.99309e-17 ; **FLOATING
C308 VDD.t47 VSS 5.01775e-17 ; **FLOATING
C309 VDD.t48 VSS 4.81988e-17 ; **FLOATING
C310 VDD.t2 VSS 4.82036e-17 ; **FLOATING
C311 VDD.t44 VSS 4.82036e-17 ; **FLOATING
C312 VDD.t45 VSS 4.82036e-17 ; **FLOATING
C313 VDD.t43 VSS 6.99309e-17 ; **FLOATING
C314 VDD.t37 VSS 1.70262e-17 ; **FLOATING
C315 VDD.t41 VSS 8.10068e-18 ; **FLOATING
C316 VDD.t42 VSS 8.10068e-18 ; **FLOATING
C317 VDD.t40 VSS 7.03743e-18 ; **FLOATING
C318 VDD.t0 VSS 2.48564e-15 ; **FLOATING
C319 VDD.n60 VSS 2.03866e-16 ; **FLOATING
C320 vco_var_rf_n.n0 VSS 4.71722e-16 ; **FLOATING
C321 vco_var_rf_n.n1 VSS 3.44657e-16 ; **FLOATING
C322 vco_var_rf_n.n2 VSS 3.66503e-16 ; **FLOATING
C323 vco_var_rf_n.t2 VSS 1.39062e-17 ; **FLOATING
C324 vco_var_rf_n.t3 VSS 1.37559e-17 ; **FLOATING
C325 vco_var_rf_n.t1 VSS 1.37559e-17 ; **FLOATING
C326 vco_var_rf_n.t5 VSS 1.7853e-15 ; **FLOATING
C327 vco_var_rf_n.n3 VSS 1.20798e-15 ; **FLOATING
C328 vco_var_rf_n.t4 VSS 1.37559e-17 ; **FLOATING
C329 vco_var_rf_n.t0 VSS 1.37559e-17 ; **FLOATING
C330 vco_var_rf_n.t7 VSS 2.91157e-16 ; **FLOATING
C331 vco_var_rf_p.n0 VSS 4.00293e-16 ; **FLOATING
C332 vco_var_rf_p.n1 VSS 3.54531e-16 ; **FLOATING
C333 vco_var_rf_p.n2 VSS 4.74369e-16 ; **FLOATING
C334 vco_var_rf_p.t7 VSS 2.01474e-16 ; **FLOATING
C335 vco_var_rf_p.t0 VSS 1.39856e-17 ; **FLOATING
C336 vco_var_rf_p.t4 VSS 1.38385e-17 ; **FLOATING
C337 vco_var_rf_p.t2 VSS 1.38385e-17 ; **FLOATING
C338 vco_var_rf_p.t3 VSS 1.38385e-17 ; **FLOATING
C339 vco_var_rf_p.t1 VSS 1.38385e-17 ; **FLOATING
C340 vco_var_rf_p.t5 VSS 1.78785e-15 ; **FLOATING
C341 vco_var_rf_p.n3 VSS 1.28011e-15 ; **FLOATING
C342 di_en.t0 VSS 3.21404e-17 ; **FLOATING
C343 di_en.t1 VSS 2.63174e-17 ; **FLOATING
C344 di_en.n0 VSS 4.3899e-16 ; **FLOATING
C345 vco_buf_in_p.t0 VSS 3.13182e-16 ; **FLOATING
C346 vco_buf_in_p.t1 VSS 1.22555e-16 ; **FLOATING
C347 vco_buf_in_p.n0 VSS 3.24195e-16 ; **FLOATING
C348 vco_buf_in_n.t0 VSS 3.29423e-16 ; **FLOATING
C349 vco_buf_in_n.t1 VSS 1.22828e-16 ; **FLOATING
C350 vco_buf_in_n.n0 VSS 3.23958e-16 ; **FLOATING
C351 rf_out_n.n0 VSS 3.25157e-16 ; **FLOATING
C352 rf_out_n.n1 VSS 5.08995e-16 ; **FLOATING
C353 rf_out_n.t1 VSS 4.09549e-17 ; **FLOATING
C354 rf_out_n.t3 VSS 4.05646e-17 ; **FLOATING
C355 rf_out_n.t2 VSS 4.05646e-17 ; **FLOATING
C356 rf_out_n.t5 VSS 4.05646e-17 ; **FLOATING
C357 rf_out_n.t4 VSS 4.05646e-17 ; **FLOATING
C358 rf_out_n.t0 VSS 4.05646e-17 ; **FLOATING
C359 rf_out_n.t6 VSS 5.87282e-16 ; **FLOATING
C360 rf_out_n.n2 VSS 1.56579e-15 ; **FLOATING
C361 rf_out_p.n0 VSS 4.56582e-16 ; **FLOATING
C362 rf_out_p.n1 VSS 3.93858e-16 ; **FLOATING
C363 rf_out_p.t2 VSS 4.17543e-17 ; **FLOATING
C364 rf_out_p.t3 VSS 4.1357e-17 ; **FLOATING
C365 rf_out_p.t4 VSS 4.1357e-17 ; **FLOATING
C366 rf_out_p.t5 VSS 4.1357e-17 ; **FLOATING
C367 rf_out_p.t0 VSS 4.1357e-17 ; **FLOATING
C368 rf_out_p.t1 VSS 4.1357e-17 ; **FLOATING
C369 rf_out_p.t6 VSS 6.00421e-16 ; **FLOATING
C370 rf_out_p.n2 VSS 1.59637e-15 ; **FLOATING
C371 vco_ind_LC.t1 VSS 7.50303e-15 ; **FLOATING
C372 vco_ind_LC.t0 VSS 5.65938e-15 ; **FLOATING
Cpexcaps0 a_5560_3922.n0 vco_bias_0.vbn_buf 1.1041e-16
Cpexcaps1 a_6568_6136.n0 vco_bias_0.vbg_buf 6.052e-17
Cpexcaps2 a_5060_3002.n0 a_5060_3088# 1.6001e-16
Cpexcaps3 a_5948_4416.n0 vco_bias_0.vbn_buf 5.694e-17
Cpexcaps4 VDD a_5560_3922.n0 3.807e-17
Cpexcaps5 VDD a_5948_4416.n0 5.4158e-16
Cpexcaps6 a_5060_3088# a_5060_5708.n0 4.473e-17
Cpexcaps7 a_11798_1180.n0 rf_out_n 5.43569e-15
Cpexcaps8 a_5560_5708.n0 vco_feed_0.en_b 9.729e-16
Cpexcaps9 a_5060_3002.n0 vco_bias_0.vbg_buf 1.0933e-16
Cpexcaps10 a_5560_5708.n0 vco_bias_0.vbn_buf 1.1403e-16
Cpexcaps11 VDD a_5560_5708.n0 7.3988e-16
Cpexcaps12 a_5060_5708.n0 vco_bias_0.vbg_buf 6.712e-17
Cpexcaps13 a_11798_1180.n0 rf_out_p 5.43569e-15
Cpexcaps14 a_5060_3002.n0 a_6568_6136.n0 5.4053e-16
Cpexcaps15 a_5560_3922.n0 vco_bias_0.vbg_buf 8.461e-17
Cpexcaps16 a_5060_3002.n0 di_en 2.091e-17
Cpexcaps17 a_5948_4416.n0 vco_bias_0.vbg_buf 8.974e-17
Cpexcaps18 a_5060_5708.n0 a_6568_6136.n0 4.613e-17
Cpexcaps19 a_5060_3002.n0 a_5560_4008# 1.375e-17
Cpexcaps20 a_1560_1090# a_5060_3002.n0 1.292e-17
Cpexcaps21 a_5060_5708.n0 di_en 3.461e-17
Cpexcaps22 a_5560_3922.n0 a_6568_6136.n0 2.017e-17
Cpexcaps23 a_5948_4416.n0 a_6568_6136.n0 1.8081e-16
Cpexcaps24 a_1160_1390# a_5060_3002.n0 3.029e-17
Cpexcaps25 a_20954_346.n0 vco_ind_LC 6.73114e-15
Cpexcaps26 a_5560_3922.n0 di_en 3.357e-17
Cpexcaps27 a_5948_4416.n0 di_en 5.4427e-16
Cpexcaps28 a_5560_5708.n0 vco_bias_0.vbg_buf 6.439e-17
Cpexcaps29 a_5560_3922.n0 a_5560_4008# 8.577e-17
Cpexcaps30 a_5060_3002.n0 a_5060_5708.n0 2.947e-17
Cpexcaps31 a_20954_346.n0 vco_feed_0.en_b 1.77578e-15
Cpexcaps32 a_5060_3002.n0 a_5560_3922.n0 1.14087e-15
Cpexcaps33 a_11798_1180.n0 vco_buf_in_p 6.7412e-16
Cpexcaps34 a_5560_5708.n0 a_6568_6136.n0 1.4475e-15
Cpexcaps35 VDD a_20954_346.n0 2.00535e-14
Cpexcaps36 a_5060_3002.n0 a_5948_4416.n0 2.188e-17
Cpexcaps37 a_6568_6136.n0 vco_feed_0.en_b 4.6022e-16
Cpexcaps38 a_11798_1180.n0 vco_feed_0.en_b 9.314e-17
Cpexcaps39 a_5560_5708.n0 di_en 2.601e-17
Cpexcaps40 a_6568_6136.n0 vco_bias_0.vbn_buf 1.8893e-16
Cpexcaps41 a_5060_5708.n0 a_5948_4416.n0 6.35e-17
Cpexcaps42 a_5560_4008# a_5560_5708.n0 5.126e-17
Cpexcaps43 a_20954_346.n0 a_24640_164# 4.48501e-15
Cpexcaps44 a_11798_1180.n0 vco_bias_0.vbn_buf 4.5225e-15
Cpexcaps45 a_1560_1090# a_5560_5708.n0 3.113e-17
Cpexcaps46 VDD a_6568_6136.n0 2.07678e-15
Cpexcaps47 VDD a_11798_1180.n0 2.528e-16
Cpexcaps48 a_5560_3922.n0 a_5948_4416.n0 4.189e-17
Cpexcaps49 a_5060_3002.n0 a_5560_5708.n0 8.6224e-16
Cpexcaps50 a_5060_3002.n0 vco_feed_0.en_b 2.05821e-15
Cpexcaps51 a_5060_5708.n0 a_5560_5708.n0 1.05064e-15
Cpexcaps52 a_5060_3002.n0 vco_bias_0.vbn_buf 5.343e-17
Cpexcaps53 a_5060_5708.n0 vco_feed_0.en_b 2.2592e-16
Cpexcaps54 VDD a_5060_3002.n0 7.086e-17
Cpexcaps55 a_11798_1180.n0 vco_buf_in_n 6.7412e-16
Cpexcaps56 a_5060_5708.n0 vco_bias_0.vbn_buf 1.9153e-16
Cpexcaps57 a_5560_3922.n0 vco_feed_0.en_b 2.4975e-16
Cpexcaps58 a_5560_5708.n0 a_5948_4416.n0 1.3792e-16
Cpexcaps59 VDD a_5060_5708.n0 4.8738e-16
Cpexcaps60 a_5948_4416.n0 vco_feed_0.en_b 1.06442e-15
Cpexcaps61 a_11798_1180.n0 vtune 3.7376e-16
.ends

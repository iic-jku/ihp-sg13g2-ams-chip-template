* Capacitances rebuilt per net pair from the C-coupled extraction vco_top_leads_CC.spice (magic#557):
* 0.4307 pF in 127 net pairs, the full-RC run had 0.4771 pF, 0.0 fF of it between pairs without coupling.
* NGSPICE file created from vco_top_leads.ext - technology: ihp-sg13g2

.subckt vco_top_leads ibias_100u di_en vtune VDD vdd_core VSS rf_out_p rf_out_n
+ vco_ind_LA vco_ind_LB vco_ind_LC vco_var_rf_p vco_var_rf_n vco_var_VSS
X0 VSS.t150 vco_var_rf_p.t7 vco_var_rf_n.t3 VSS.t149 sg13_lv_nmos ad=0.68p pd=4.68u as=0.38p ps=2.38u w=2u l=0.13u
X1 VSS.t95 vco_var_rf_n.t7 vco_var_rf_p.t1 VSS.t94 sg13_lv_nmos ad=0.68p pd=4.68u as=0.38p ps=2.38u w=2u l=0.13u
X2 a_1474_1090.t1 a_2654_4840.t4 VDD.t8 VDD.t7 sg13_lv_pmos ad=1.7p pd=10.68u as=1.7p ps=10.68u w=5u l=0.5u
X3 rf_out_n.t5 vco_buf_in_p.t1 a_11798_1180.t19 VSS.t104 sg13_lv_nmos ad=0.38p pd=2.38u as=0.38p ps=2.38u w=2u l=0.13u
X4 rf_out_n.t1 vco_buf_in_p.t1 a_11798_1180.t17 VSS.t100 sg13_lv_nmos ad=0.38p pd=2.38u as=0.38p ps=2.38u w=2u l=0.13u
X5 VSS.t50 vco_bias_0.vbn_buf.t2 a_11798_1180.t12 VSS.t51 sg13_lv_nmos ad=0.95p pd=5.38u as=0.95p ps=5.38u w=5u l=0.5u
X6 a_11798_1180.t10 vco_bias_0.vbn_buf.t2 VSS.t43 VSS.t44 sg13_lv_nmos ad=0.95p pd=5.38u as=0.95p ps=5.38u w=5u l=0.5u
X7 a_11798_1180.t0 vco_bias_0.vbn_buf.t2 VSS.t14 VSS.t13 sg13_lv_nmos ad=0.95p pd=5.38u as=1.7p ps=10.68u w=5u l=0.5u
X8 VSS.t62 vco_bias_0.vbn_buf.t3 VSS.t60 VSS.t3 sg13_lv_nmos ad=1.52p pd=8.38u as=0 ps=0 w=8u l=10u
X9 VSS.t23 vco_bias_0.vbn_buf.t2 a_11798_1180.t3 VSS.t22 sg13_lv_nmos ad=0.95p pd=5.38u as=0.95p ps=5.38u w=5u l=0.5u
X10 VSS.t66 vco_bias_0.vbn_buf.t3 VSS.t64 VSS.t7 sg13_lv_nmos ad=1.52p pd=8.38u as=0 ps=0 w=8u l=10u
X11 VSS.t144 vco_var_rf_p.t7 vco_var_rf_n.t1 VSS.t143 sg13_lv_nmos ad=0.38p pd=2.38u as=0.38p ps=2.38u w=2u l=0.13u
X12 a_11798_1180.t24 vco_buf_in_n.t1 rf_out_p.t4 VSS.t154 sg13_lv_nmos ad=0.38p pd=2.38u as=0.38p ps=2.38u w=2u l=0.13u
X13 VSS.t6 vco_bias_0.vbn_buf.t4 VSS.t4 VSS.t5 sg13_lv_nmos ad=1.52p pd=8.38u as=0 ps=0 w=8u l=10u
X14 rf_out_p.t3 vco_buf_in_n.t1 a_11798_1180.t22 VSS.t151 sg13_lv_nmos ad=0.38p pd=2.38u as=0.68p ps=4.68u w=2u l=0.13u
X15 ibias_100u.t0 a_1254_2820.t3 VSS.t77 VSS.t69 sg13_lv_nmos ad=0.34p pd=2.68u as=0.34p ps=2.68u w=1u l=0.13u
X16 VSS.t113 vco_bias_0.vbg_buf VSS.t112 VSS.t0 sg13_lv_nmos ad=2.72p pd=16.68u as=0 ps=0 w=8u l=10u
X17 VSS.t129 vco_bias_0.vbg_buf VSS.t127 VSS.t7 sg13_lv_nmos ad=1.52p pd=8.38u as=0 ps=0 w=8u l=10u
X18 VSS.t86 vco_var_rf_n.t7 vco_var_rf_p.t3 VSS.t85 sg13_lv_nmos ad=0.38p pd=2.38u as=0.38p ps=2.38u w=2u l=0.13u
X19 vco_var_rf_n.t4 vco_var_rf_p.t7 VSS.t144 VSS.t145 sg13_lv_nmos ad=0.38p pd=2.38u as=0.38p ps=2.38u w=2u l=0.13u
X20 vco_var_rf_n.t0 vco_var_rf_p.t7 VSS.t138 VSS.t139 sg13_lv_nmos ad=0.38p pd=2.38u as=0.38p ps=2.38u w=2u l=0.13u
X21 a_1474_1090.t0 vco_bias_0.vbg_buf VSS.t79 rhigh l=32u w=0.5u
X22 a_2654_4840.t3 a_1954_2820.t2 VDD.t3 VDD.t2 sg13_lv_pmos ad=0.34p pd=2.68u as=0.34p ps=2.68u w=1u l=0.13u
X23 vco_var_rf_p.t0 vco_var_rf_n.t7 VSS.t89 VSS.t90 sg13_lv_nmos ad=0.38p pd=2.38u as=0.38p ps=2.38u w=2u l=0.13u
X24 a_11798_1180.t27 vco_buf_in_n.t1 rf_out_p.t1 VSS.t160 sg13_lv_nmos ad=0.38p pd=2.38u as=0.38p ps=2.38u w=2u l=0.13u
X25 a_1954_2820.t1 a_1254_2820.t4 VSS.t72 VSS.t71 sg13_lv_nmos ad=0.17p pd=1.68u as=0.17p ps=1.68u w=0.5u l=0.13u
X26 VSS.t43 vco_bias_0.vbn_buf.t2 a_11798_1180.t9 VSS.t42 sg13_lv_nmos ad=0.95p pd=5.38u as=0.95p ps=5.38u w=5u l=0.5u
X27 VSS.t127 vco_bias_0.vbg_buf VSS.t125 VSS.t5 sg13_lv_nmos ad=1.52p pd=8.38u as=0 ps=0 w=8u l=10u
X28 VSS.t16 vco_bias_0.vbn_buf.t2 a_11798_1180.t0 VSS.t15 sg13_lv_nmos ad=0.95p pd=5.38u as=0.95p ps=5.38u w=5u l=0.5u
X29 a_11798_1180.t13 vco_bias_0.vbn_buf.t2 VSS.t50 VSS.t49 sg13_lv_nmos ad=0.95p pd=5.38u as=0.95p ps=5.38u w=5u l=0.5u
X30 ibias_100u.t3 vco_bias_0.vbn_buf.t0 VSS.t133 rhigh l=32u w=0.5u
X31 a_11798_1180.t14 vco_bias_0.vbn_buf.t2 VSS.t53 VSS.t54 sg13_lv_nmos ad=0.95p pd=5.38u as=0.95p ps=5.38u w=5u l=0.5u
X32 a_1254_2820.t0 di_en.t1 VDD.t11 VDD.t10 sg13_lv_pmos ad=0.34p pd=2.68u as=0.34p ps=2.68u w=1u l=0.13u
X33 a_5428_2384.t1 a_5428_2384.t0 VSS.t58 VSS.t57 sg13_lv_nmos ad=0.85p pd=5.68u as=0.85p ps=5.68u w=2.5u l=0.5u
X34 a_11798_1180.t20 vco_buf_in_p.t1 rf_out_n.t5 VSS.t105 sg13_lv_nmos ad=0.38p pd=2.38u as=0.38p ps=2.38u w=2u l=0.13u
X35 VSS.t64 vco_bias_0.vbn_buf.t3 VSS.t62 VSS.t5 sg13_lv_nmos ad=1.52p pd=8.38u as=0 ps=0 w=8u l=10u
X36 a_11798_1180.t4 vco_bias_0.vbn_buf.t2 VSS.t23 VSS.t28 sg13_lv_nmos ad=0.95p pd=5.38u as=0.95p ps=5.38u w=5u l=0.5u
X37 a_11798_1180.t18 vco_buf_in_p.t1 rf_out_n.t1 VSS.t101 sg13_lv_nmos ad=0.38p pd=2.38u as=0.38p ps=2.38u w=2u l=0.13u
X38 VSS.t39 vco_bias_0.vbn_buf.t2 a_11798_1180.t7 VSS.t38 sg13_lv_nmos ad=0.95p pd=5.38u as=0.95p ps=5.38u w=5u l=0.5u
X39 VSS.t115 vco_bias_0.vbg_buf VSS.t113 VSS.t3 sg13_lv_nmos ad=1.52p pd=8.38u as=0 ps=0 w=8u l=10u
X40 a_2654_4840.t2 ibias_100u.t4 VSS.t110 VSS.t57 sg13_lv_nmos ad=0.85p pd=5.68u as=0.85p ps=5.68u w=2.5u l=0.5u
X41 VSS.t131 vco_bias_0.vbg_buf VSS.t129 VSS.t9 sg13_lv_nmos ad=1.52p pd=8.38u as=0 ps=0 w=8u l=10u
X42 VSS.t53 vco_bias_0.vbn_buf.t2 a_11798_1180.t13 VSS.t52 sg13_lv_nmos ad=0.95p pd=5.38u as=0.95p ps=5.38u w=5u l=0.5u
X43 VSS.t147 vco_var_rf_p.t7 vco_var_rf_n.t4 VSS.t146 sg13_lv_nmos ad=0.38p pd=2.38u as=0.38p ps=2.38u w=2u l=0.13u
X44 VSS.t56 vco_bias_0.vbn_buf.t2 a_11798_1180.t14 VSS.t55 sg13_lv_nmos ad=1.7p pd=10.68u as=0.95p ps=5.38u w=5u l=0.5u
X45 VSS.t2 vco_bias_0.vbn_buf.t4 VSS.t1 VSS.t0 sg13_lv_nmos ad=2.72p pd=16.68u as=0 ps=0 w=8u l=10u
X46 VSS.t92 vco_var_rf_n.t7 vco_var_rf_p.t0 VSS.t91 sg13_lv_nmos ad=0.38p pd=2.38u as=0.38p ps=2.38u w=2u l=0.13u
X47 VDD.t6 rf_out_p.t0 VSS.t78 rppd l=1.65u w=10u
X48 rf_out_p.t2 vco_buf_in_n.t1 a_11798_1180.t27 VSS.t161 sg13_lv_nmos ad=0.38p pd=2.38u as=0.38p ps=2.38u w=2u l=0.13u
X49 a_2654_4840.t1 a_2654_4840.t0 VDD.t5 VDD.t4 sg13_lv_pmos ad=1.7p pd=10.68u as=1.7p ps=10.68u w=5u l=0.5u
X50 a_11798_1180.t7 vco_bias_0.vbn_buf.t2 VSS.t36 VSS.t37 sg13_lv_nmos ad=0.95p pd=5.38u as=0.95p ps=5.38u w=5u l=0.5u
X51 rf_out_p.t6 vco_buf_in_n.t1 a_11798_1180.t25 VSS.t157 sg13_lv_nmos ad=0.38p pd=2.38u as=0.38p ps=2.38u w=2u l=0.13u
X52 VSS.t10 vco_bias_0.vbn_buf.t4 VSS.t8 VSS.t9 sg13_lv_nmos ad=1.52p pd=8.38u as=0 ps=0 w=8u l=10u
X53 vco_var_rf_p.t4 vco_var_rf_n.t7 VSS.t86 VSS.t87 sg13_lv_nmos ad=0.38p pd=2.38u as=0.38p ps=2.38u w=2u l=0.13u
X54 VSS.t25 vco_bias_0.vbn_buf.t2 a_11798_1180.t10 VSS.t24 sg13_lv_nmos ad=0.95p pd=5.38u as=0.95p ps=5.38u w=5u l=0.5u
X55 a_11798_1180.t8 vco_bias_0.vbn_buf.t2 VSS.t39 VSS.t40 sg13_lv_nmos ad=0.95p pd=5.38u as=0.95p ps=5.38u w=5u l=0.5u
X56 vco_var_rf_p.t2 vco_var_rf_n.t7 VSS.t81 VSS.t80 sg13_lv_nmos ad=0.38p pd=2.38u as=0.68p ps=4.68u w=2u l=0.13u
X57 VSS.t47 vco_bias_0.vbn_buf.t2 a_11798_1180.t11 VSS.t46 sg13_lv_nmos ad=0.95p pd=5.38u as=0.95p ps=5.38u w=5u l=0.5u
X58 VSS.t141 vco_var_rf_p.t7 vco_var_rf_n.t0 VSS.t140 sg13_lv_nmos ad=0.38p pd=2.38u as=0.38p ps=2.38u w=2u l=0.13u
X59 rf_out_n.t4 vco_buf_in_p.t1 a_11798_1180.t15 VSS.t96 sg13_lv_nmos ad=0.38p pd=2.38u as=0.68p ps=4.68u w=2u l=0.13u
X60 a_1954_2820.t0 a_1254_2820.t5 VDD.t1 VDD.t0 sg13_lv_pmos ad=0.34p pd=2.68u as=0.34p ps=2.68u w=1u l=0.13u
X61 VSS.t83 vco_var_rf_n.t7 vco_var_rf_p.t2 VSS.t82 sg13_lv_nmos ad=0.38p pd=2.38u as=0.38p ps=2.38u w=2u l=0.13u
X62 rf_out_n.t2 vco_buf_in_p.t1 a_11798_1180.t20 VSS.t106 sg13_lv_nmos ad=0.38p pd=2.38u as=0.38p ps=2.38u w=2u l=0.13u
X63 VSS.t60 vco_bias_0.vbn_buf.t3 VSS.t59 VSS.t0 sg13_lv_nmos ad=2.72p pd=16.68u as=0 ps=0 w=8u l=10u
X64 rf_out_n.t3 vco_buf_in_p.t1 a_11798_1180.t18 VSS.t102 sg13_lv_nmos ad=0.38p pd=2.38u as=0.38p ps=2.38u w=2u l=0.13u
X65 VSS.t123 vco_bias_0.vbg_buf VSS.t122 VSS.t0 sg13_lv_nmos ad=2.72p pd=16.68u as=0 ps=0 w=8u l=10u
X66 VSS.t18 vco_bias_0.vbn_buf.t2 a_11798_1180.t1 VSS.t20 sg13_lv_nmos ad=0.95p pd=5.38u as=0.95p ps=5.38u w=5u l=0.5u
X67 a_11798_1180.t5 vco_bias_0.vbn_buf.t2 VSS.t30 VSS.t31 sg13_lv_nmos ad=0.95p pd=5.38u as=0.95p ps=5.38u w=5u l=0.5u
X68 a_11798_1180.t11 vco_bias_0.vbn_buf.t2 VSS.t25 VSS.t45 sg13_lv_nmos ad=0.95p pd=5.38u as=0.95p ps=5.38u w=5u l=0.5u
X69 a_11798_1180.t12 vco_bias_0.vbn_buf.t2 VSS.t47 VSS.t48 sg13_lv_nmos ad=0.95p pd=5.38u as=0.95p ps=5.38u w=5u l=0.5u
X70 vco_buf_in_p vco_var_rf_p.t5 cap_cmim l=10u w=10u
X71 a_11798_1180.t23 vco_buf_in_n.t1 rf_out_p.t3 VSS.t152 sg13_lv_nmos ad=0.38p pd=2.38u as=0.38p ps=2.38u w=2u l=0.13u
X72 VSS.t68 vco_bias_0.vbn_buf.t3 VSS.t66 VSS.t9 sg13_lv_nmos ad=1.52p pd=8.38u as=0 ps=0 w=8u l=10u
X73 vco_var_rf_n.t3 vco_var_rf_p.t7 VSS.t147 VSS.t148 sg13_lv_nmos ad=0.38p pd=2.38u as=0.38p ps=2.38u w=2u l=0.13u
X74 vco_var_rf_p.t1 vco_var_rf_n.t7 VSS.t92 VSS.t93 sg13_lv_nmos ad=0.38p pd=2.38u as=0.38p ps=2.38u w=2u l=0.13u
X75 a_11798_1180.t1 vco_bias_0.vbn_buf.t2 VSS.t16 VSS.t19 sg13_lv_nmos ad=0.95p pd=5.38u as=0.95p ps=5.38u w=5u l=0.5u
X76 ibias_100u.t2 ibias_100u.t1 VSS.t109 VSS.t57 sg13_lv_nmos ad=0.85p pd=5.68u as=0.85p ps=5.68u w=2.5u l=0.5u
X77 VSS.t30 vco_bias_0.vbn_buf.t2 a_11798_1180.t4 VSS.t29 sg13_lv_nmos ad=0.95p pd=5.38u as=0.95p ps=5.38u w=5u l=0.5u
X78 a_11798_1180.t2 vco_bias_0.vbn_buf.t2 VSS.t18 VSS.t17 sg13_lv_nmos ad=0.95p pd=5.38u as=0.95p ps=5.38u w=5u l=0.5u
X79 a_11798_1180.t26 vco_buf_in_n.t1 rf_out_p.t6 VSS.t158 sg13_lv_nmos ad=0.38p pd=2.38u as=0.38p ps=2.38u w=2u l=0.13u
X80 rf_out_p.t5 vco_buf_in_n.t1 a_11798_1180.t24 VSS.t155 sg13_lv_nmos ad=0.38p pd=2.38u as=0.38p ps=2.38u w=2u l=0.13u
X81 a_1474_1090.t2 a_5428_2384.t2 VSS.t163 rppd l=8.5u w=0.5u
X82 vco_bias_0.vbn_buf.t1 a_1254_2820.t2 VSS.t70 VSS.t69 sg13_lv_nmos ad=0.34p pd=2.68u as=0.34p ps=2.68u w=1u l=0.13u
X83 VSS.t119 vco_bias_0.vbg_buf VSS.t117 VSS.t7 sg13_lv_nmos ad=1.52p pd=8.38u as=0 ps=0 w=8u l=10u
X84 vco_buf_in_n vco_var_rf_n.t5 cap_cmim l=10u w=10u
X85 VSS.t33 vco_bias_0.vbn_buf.t2 a_11798_1180.t5 VSS.t32 sg13_lv_nmos ad=0.95p pd=5.38u as=0.95p ps=5.38u w=5u l=0.5u
X86 a_11798_1180.t9 vco_bias_0.vbn_buf.t2 VSS.t27 VSS.t26 sg13_lv_nmos ad=0.95p pd=5.38u as=0.95p ps=5.38u w=5u l=0.5u
X87 a_11798_1180.t16 vco_buf_in_p.t1 rf_out_n.t4 VSS.t97 sg13_lv_nmos ad=0.38p pd=2.38u as=0.38p ps=2.38u w=2u l=0.13u
X88 VSS.t125 vco_bias_0.vbg_buf VSS.t123 VSS.t3 sg13_lv_nmos ad=1.52p pd=8.38u as=0 ps=0 w=8u l=10u
X89 VSS.t117 vco_bias_0.vbg_buf VSS.t115 VSS.t5 sg13_lv_nmos ad=1.52p pd=8.38u as=0 ps=0 w=8u l=10u
X90 VSS.t89 vco_var_rf_n.t7 vco_var_rf_p.t4 VSS.t88 sg13_lv_nmos ad=0.38p pd=2.38u as=0.38p ps=2.38u w=2u l=0.13u
X91 vco_var_rf_n.t1 vco_var_rf_p.t7 VSS.t141 VSS.t142 sg13_lv_nmos ad=0.38p pd=2.38u as=0.38p ps=2.38u w=2u l=0.13u
X92 a_11798_1180.t21 vco_buf_in_p.t1 rf_out_n.t2 VSS.t107 sg13_lv_nmos ad=0.68p pd=4.68u as=0.38p ps=2.38u w=2u l=0.13u
X93 vco_var_rf_n.t2 vco_var_rf_p.t7 VSS.t136 VSS.t135 sg13_lv_nmos ad=0.38p pd=2.38u as=0.68p ps=4.68u w=2u l=0.13u
X94 vco_ind_LC VSS.t73 cap_cmim l=39u w=56u
X95 a_11798_1180.t19 vco_buf_in_p.t1 rf_out_n.t3 VSS.t103 sg13_lv_nmos ad=0.38p pd=2.38u as=0.38p ps=2.38u w=2u l=0.13u
X96 a_11798_1180.t17 vco_buf_in_p.t1 rf_out_n.t0 VSS.t99 sg13_lv_nmos ad=0.38p pd=2.38u as=0.38p ps=2.38u w=2u l=0.13u
X97 VSS.t12 vco_bias_0.vbn_buf.t2 a_11798_1180.t2 VSS.t11 sg13_lv_nmos ad=0.95p pd=5.38u as=0.95p ps=5.38u w=5u l=0.5u
X98 vco_bias_0.vbg_buf vco_buf_in_n.t0 VSS.t132 rhigh l=8u w=0.5u
X99 vco_var_rf_p.t3 vco_var_rf_n.t7 VSS.t83 VSS.t84 sg13_lv_nmos ad=0.38p pd=2.38u as=0.38p ps=2.38u w=2u l=0.13u
X100 VSS.t27 vco_bias_0.vbn_buf.t2 a_11798_1180.t8 VSS.t41 sg13_lv_nmos ad=0.95p pd=5.38u as=0.95p ps=5.38u w=5u l=0.5u
X101 a_11798_1180.t6 vco_bias_0.vbn_buf.t2 VSS.t33 VSS.t34 sg13_lv_nmos ad=0.95p pd=5.38u as=0.95p ps=5.38u w=5u l=0.5u
X102 VSS.t138 vco_var_rf_p.t7 vco_var_rf_n.t2 VSS.t137 sg13_lv_nmos ad=0.38p pd=2.38u as=0.38p ps=2.38u w=2u l=0.13u
X103 rf_out_p.t4 vco_buf_in_n.t1 a_11798_1180.t23 VSS.t153 sg13_lv_nmos ad=0.38p pd=2.38u as=0.38p ps=2.38u w=2u l=0.13u
X104 a_1254_2820.t1 di_en.t0 VSS.t111 VSS.t71 sg13_lv_nmos ad=0.17p pd=1.68u as=0.17p ps=1.68u w=0.5u l=0.13u
X105 VDD.t9 rf_out_n.t6 VSS.t108 rppd l=1.65u w=10u
X106 VSS.t121 vco_bias_0.vbg_buf VSS.t119 VSS.t9 sg13_lv_nmos ad=1.52p pd=8.38u as=0 ps=0 w=8u l=10u
X107 VSS.t4 vco_bias_0.vbn_buf.t4 VSS.t2 VSS.t3 sg13_lv_nmos ad=1.52p pd=8.38u as=0 ps=0 w=8u l=10u
X108 VSS.t8 vco_bias_0.vbn_buf.t4 VSS.t6 VSS.t7 sg13_lv_nmos ad=1.52p pd=8.38u as=0 ps=0 w=8u l=10u
X109 vco_ind_LC VSS.t75 cap_cmim l=25.5u w=42u
X110 a_11798_1180.t28 vco_buf_in_n.t1 rf_out_p.t2 VSS.t162 sg13_lv_nmos ad=0.68p pd=4.68u as=0.38p ps=2.38u w=2u l=0.13u
X111 rf_out_p.t1 vco_buf_in_n.t1 a_11798_1180.t26 VSS.t159 sg13_lv_nmos ad=0.38p pd=2.38u as=0.38p ps=2.38u w=2u l=0.13u
X112 a_11798_1180.t25 vco_buf_in_n.t1 rf_out_p.t5 VSS.t156 sg13_lv_nmos ad=0.38p pd=2.38u as=0.38p ps=2.38u w=2u l=0.13u
X113 vco_bias_0.vbg_buf vco_buf_in_p.t0 VSS.t134 rhigh l=8u w=0.5u
X114 a_11798_1180.t3 vco_bias_0.vbn_buf.t2 VSS.t12 VSS.t21 sg13_lv_nmos ad=0.95p pd=5.38u as=0.95p ps=5.38u w=5u l=0.5u
X115 VSS.t36 vco_bias_0.vbn_buf.t2 a_11798_1180.t6 VSS.t35 sg13_lv_nmos ad=0.95p pd=5.38u as=0.95p ps=5.38u w=5u l=0.5u
X116 rf_out_n.t0 vco_buf_in_p.t1 a_11798_1180.t16 VSS.t98 sg13_lv_nmos ad=0.38p pd=2.38u as=0.38p ps=2.38u w=2u l=0.13u
C0 vco_ind_LC vco_bias_0.vbg_buf 2.913e-17
C1 vco_var_rf_n VDD 9.747e-17
C2 ibias_100u a_1160_1390# 3.496e-17
C3 vco_buf_in_n a_19050_4480# 3.458e-17
C4 vco_buf_in_n vtune 1.8199e-16
C5 vco_bias_0.vbg_buf vco_var_rf_n 5.8809e-16
C6 vco_bias_0.vbg_buf a_6760_4250# 1.222e-17
C7 vco_ind_LC a_19050_4480# 1.117e-17
C8 vco_bias_0.vbn_buf ibias_100u 2.722e-17
C9 rf_out_n VDD 4.2538e-16
C10 vtune vco_var_rf_n 5.282e-17
C11 vco_bias_0.vbn_buf a_1160_1390# 3.745e-17
C12 vco_var_rf_p vco_ind_LC 5.4907e-16
C13 vco_bias_0.vbg_buf VDD 5.7968e-16
C14 vco_bias_0.vbn_buf vco_buf_in_p 3.328e-17
C15 VDD a_1560_1090# 6.442e-17
C16 a_10100_3480# rf_out_n 4.7902e-16
C17 ibias_100u di_en 1.7791e-16
C18 vco_var_rf_p vco_var_rf_n 4.49965e-15
C19 vco_bias_0.vbg_buf a_1560_1090# 3.72e-17
C20 rf_out_n vtune 3.195e-17
C21 a_10100_3480# VDD 3.5541e-16
C22 vco_bias_0.vbg_buf a_9450_4480# 6.417e-17
C23 vtune VDD 3.1574e-16
C24 rf_out_p vco_bias_0.vbn_buf 1.7253e-16
C25 vco_bias_0.vbg_buf a_19050_4480# 4.459e-17
C26 vco_bias_0.vbg_buf vtune 1.3019e-16
C27 rf_out_p a_16500_3480# 4.7902e-16
C28 vco_bias_0.vbn_buf di_en 4.963e-17
C29 vco_var_rf_p rf_out_n 1.574e-17
C30 vco_buf_in_n vco_buf_in_p 1.7478e-16
C31 vco_var_rf_p VDD 9.747e-17
C32 vco_buf_in_n vco_bias_0.vbn_buf 1.681e-17
C33 vco_var_rf_p vco_bias_0.vbg_buf 8.721e-16
C34 vco_buf_in_n a_16500_3480# 6.15e-17
C35 vco_buf_in_n rf_out_p 9.7363e-16
C36 vco_bias_0.vbn_buf vco_var_rf_n 2.147e-17
C37 vco_bias_0.vbn_buf a_6760_4250# 4.32e-17
C38 a_10100_3480# vco_var_rf_p 1.479e-17
C39 vco_var_rf_p vtune 1.0305e-16
C40 ibias_100u VDD 2.007e-16
C41 vco_var_rf_n a_16500_3480# 1.479e-17
C42 rf_out_p vco_var_rf_n 1.574e-17
C43 a_1160_1390# VDD 3.038e-17
C44 rf_out_n vco_buf_in_p 9.7363e-16
C45 vco_bias_0.vbn_buf rf_out_n 1.9807e-16
C46 vco_buf_in_n vco_ind_LC 1.048e-17
C47 vco_buf_in_p VDD 5.5386e-16
C48 a_1160_1390# a_1560_1090# 1.7942e-16
C49 vco_bias_0.vbn_buf VDD 4.1633e-16
C50 vco_bias_0.vbg_buf vco_buf_in_p 6.261e-17
C51 vco_bias_0.vbg_buf vco_bias_0.vbn_buf 5.05194e-15
C52 vco_buf_in_n vco_var_rf_n 1.68039e-15
C53 VDD a_16500_3480# 3.2168e-16
C54 rf_out_p rf_out_n 1.053e-17
C55 a_9450_4480# vco_buf_in_p 3.458e-17
C56 vco_ind_LC vco_var_rf_n 1.02248e-15
C57 rf_out_p VDD 4.1138e-16
C58 a_10100_3480# vco_buf_in_p 6.15e-17
C59 a_10100_3480# vco_bias_0.vbn_buf 1.657e-17
C60 vco_buf_in_p vtune 1.8199e-16
C61 vco_bias_0.vbn_buf vtune 9.328e-17
C62 di_en VDD 2.3329e-16
C63 vco_bias_0.vbg_buf di_en 6.388e-17
C64 vco_buf_in_n VDD 5.3384e-16
C65 rf_out_p vtune 3.195e-17
C66 vco_var_rf_p vco_buf_in_p 1.68039e-15
C67 vco_ind_LC VDD 4.1391e-16
C68 vco_buf_in_n vco_bias_0.vbg_buf 5.315e-17
C69 vco_var_rf_p vco_bias_0.vbn_buf 2.9334e-16
R0 ibias_100u.n3 ibias_100u.t3 54.3738
R1 ibias_100u.n0 ibias_100u.t4 34.6784
R2 ibias_100u.n1 ibias_100u.t1 34.2252
R3 ibias_100u.n2 ibias_100u.t0 20.5585
R4 ibias_100u.n0 ibias_100u.t2 14.6093
R5 ibias_100u.n3 ibias_100u.n2 1.7473
R6 ibias_100u ibias_100u.n3 1.2149
R7 ibias_100u.n2 ibias_100u.n1 0.5351
R8 ibias_100u.n1 ibias_100u.n0 0.3173
R9 rf_out_p rf_out_p.n2 6.6125
R10 rf_out_p.n0 rf_out_p.t3 4.77599
R11 rf_out_p.n1 rf_out_p.t2 4.72949
R12 rf_out_p.n1 rf_out_p.t1 4.72949
R13 rf_out_p.n0 rf_out_p.t6 4.72949
R14 rf_out_p.n0 rf_out_p.t5 4.72949
R15 rf_out_p.n0 rf_out_p.t4 4.72949
R16 rf_out_p.n2 rf_out_p.t0 2.40801
R17 rf_out_p.n2 rf_out_p.n1 0.685593
R18 rf_out_p.n1 rf_out_p.n0 0.186531
R19 rf_out_n rf_out_n.n2 6.6125
R20 rf_out_n.n0 rf_out_n.t2 4.77599
R21 rf_out_n.n0 rf_out_n.t5 4.72949
R22 rf_out_n.n0 rf_out_n.t3 4.72949
R23 rf_out_n.n1 rf_out_n.t1 4.72949
R24 rf_out_n.n1 rf_out_n.t0 4.72949
R25 rf_out_n.n1 rf_out_n.t4 4.72949
R26 rf_out_n.n2 rf_out_n.t6 2.40801
R27 rf_out_n.n2 rf_out_n.n1 0.685593
R28 rf_out_n.n1 rf_out_n.n0 0.186531
R29 vco_buf_in_n.n0 vco_buf_in_n.t0 27.0805
R30 vco_buf_in_n vco_buf_in_n.n0 3.71514
R31 vco_buf_in_n.n0 vco_buf_in_n.t1 2.05808
R32 vco_buf_in_p.n0 vco_buf_in_p.t0 27.0805
R33 vco_buf_in_p vco_buf_in_p.n0 3.72028
R34 vco_buf_in_p.n0 vco_buf_in_p.t1 2.05789
R35 di_en.n0 di_en.t1 26.3252
R36 di_en.n0 di_en.t0 24.5065
R37 di_en di_en.n0 10.1632
R38 vco_var_rf_p vco_var_rf_p.t5 4.85508
R39 vco_var_rf_p.n0 vco_var_rf_p.t1 4.75718
R40 vco_var_rf_p.n1 vco_var_rf_p.t2 4.81938
R41 vco_var_rf_p.n0 vco_var_rf_p.t0 4.72949
R42 vco_var_rf_p.n0 vco_var_rf_p.t4 4.72949
R43 vco_var_rf_p.n0 vco_var_rf_p.t3 4.72949
R44 vco_var_rf_p.n4 vco_var_rf_p.t7 4.13789
R45 vco_ind_LA vco_var_rf_p.n3 0.424928
R46 vco_var_rf_p.n2 vco_var_rf_p.n1 0.225881
R47 vco_var_rf_p.n3 vco_var_rf_p.n5 0.714879
R48 vco_var_rf_p.n4 vco_var_rf_p.n3 0.321512
R49 vco_var_rf_p.n5 vco_var_rf_p.n2 0.47922
R50 vco_var_rf_p.n5 vco_var_rf_p 0.47746
R51 vco_var_rf_p.n0 vco_var_rf_p.n1 0.0646573
R52 vco_var_rf_p.n2 vco_var_rf_p.n4 0.163811
R53 vco_var_rf_n vco_var_rf_n.t5 5.01313
R54 vco_var_rf_n.n0 vco_var_rf_n.t2 4.75718
R55 vco_var_rf_n.n1 vco_var_rf_n.t3 4.81949
R56 vco_var_rf_n.n0 vco_var_rf_n.t4 4.72949
R57 vco_var_rf_n.n0 vco_var_rf_n.t1 4.72949
R58 vco_var_rf_n.n0 vco_var_rf_n.t0 4.72949
R59 vco_var_rf_n.n4 vco_var_rf_n.t7 3.9789
R60 vco_var_rf_n.n5 vco_var_rf_n.n3 0.725624
R61 vco_var_rf_n.n2 vco_var_rf_n.n1 0.2259
R62 vco_var_rf_n.n3 vco_var_rf_n.n4 0.35065
R63 vco_ind_LB vco_var_rf_n.n3 0.413372
R64 vco_var_rf_n.n5 vco_var_rf_n.n2 0.47922
R65 vco_var_rf_n.n5 vco_var_rf_n 0.319412
R66 vco_var_rf_n.n0 vco_var_rf_n.n1 0.0645602
R67 vco_var_rf_n.n2 vco_var_rf_n.n4 0.146211
R68 VDD VDD.n9 17.6809
R69 VDD.n7 VDD.t10 17.0005
R70 VDD.n5 VDD.t0 17.0005
R71 VDD.n3 VDD.t2 17.0005
R72 VDD VDD.n8 16.7718
R73 VDD.n1 VDD.t4 11.3356
R74 VDD.n0 VDD.t7 11.3356
R75 VDD.n7 VDD.t11 6.19097
R76 VDD.n5 VDD.t1 6.19097
R77 VDD.n3 VDD.t3 6.19097
R78 VDD.n9 VDD.t6 4.22454
R79 VDD.n0 VDD.t8 2.44406
R80 VDD.n1 VDD.t5 2.44327
R81 VDD.n2 VDD.n0 1.42463
R82 VDD.n4 VDD.n2 0.851625
R83 VDD.n8 VDD.n7 0.751488
R84 VDD.n6 VDD.n5 0.751488
R85 VDD.n4 VDD.n3 0.751488
R86 VDD.n9 VDD.t9 0.517741
R87 VDD.n8 VDD.n6 0.370375
R88 VDD.n6 VDD.n4 0.370375
R89 VDD.n2 VDD.n1 0.143127
R90 VSS.n240 VSS.n239 2420.69
R91 VSS.n239 VSS.n223 1880.72
R92 VSS.n239 VSS.t71 900.284
R93 VSS.n232 VSS.t133 358.603
R94 VSS.t78 VSS.t132 303.798
R95 VSS.t133 VSS.t79 141.554
R96 VSS.n400 VSS.t78 110.507
R97 VSS.n232 VSS.n186 89.1795
R98 VSS.t69 VSS.t57 70.7775
R99 VSS.n236 VSS.n186 52.3755
R100 VSS.n238 VSS.n236 47.1851
R101 VSS.t57 VSS.n238 33.0298
R102 VSS.n245 VSS.n63 25.4435
R103 VSS.t71 VSS.t69 23.5928
R104 VSS.n208 VSS.n90 21.2107
R105 VSS.n203 VSS.n99 21.2107
R106 VSS.n213 VSS.n88 21.2107
R107 VSS.n197 VSS.n102 21.2107
R108 VSS.n214 VSS.n86 21.2107
R109 VSS.n195 VSS.n110 21.2107
R110 VSS.n189 VSS.n113 21.2107
R111 VSS.n223 VSS.n93 21.0223
R112 VSS.n205 VSS.t0 19.9631
R113 VSS.n237 VSS.t111 17.4597
R114 VSS.n224 VSS.t72 17.4597
R115 VSS.n238 VSS.n237 17.0005
R116 VSS.n238 VSS.n224 17.0005
R117 VSS.n236 VSS.n225 17.0005
R118 VSS.n236 VSS.n235 17.0005
R119 VSS.n386 VSS.n385 17.0005
R120 VSS.n386 VSS.n370 17.0005
R121 VSS.n386 VSS.n384 17.0005
R122 VSS.n386 VSS.n371 17.0005
R123 VSS.n386 VSS.n383 17.0005
R124 VSS.n386 VSS.n372 17.0005
R125 VSS.n386 VSS.n382 17.0005
R126 VSS.n386 VSS.n373 17.0005
R127 VSS.n386 VSS.n381 17.0005
R128 VSS.n386 VSS.n374 17.0005
R129 VSS.n386 VSS.n380 17.0005
R130 VSS.n386 VSS.n375 17.0005
R131 VSS.n386 VSS.n379 17.0005
R132 VSS.n386 VSS.n376 17.0005
R133 VSS.n386 VSS.n378 17.0005
R134 VSS.n386 VSS.n377 17.0005
R135 VSS.n397 VSS.n396 17.0005
R136 VSS.n396 VSS.n363 17.0005
R137 VSS.n396 VSS.n395 17.0005
R138 VSS.n396 VSS.n364 17.0005
R139 VSS.n396 VSS.n394 17.0005
R140 VSS.n396 VSS.n365 17.0005
R141 VSS.n396 VSS.n393 17.0005
R142 VSS.n396 VSS.n366 17.0005
R143 VSS.n396 VSS.n392 17.0005
R144 VSS.n396 VSS.n367 17.0005
R145 VSS.n396 VSS.n391 17.0005
R146 VSS.n396 VSS.n368 17.0005
R147 VSS.n396 VSS.n390 17.0005
R148 VSS.n396 VSS.n369 17.0005
R149 VSS.n396 VSS.n389 17.0005
R150 VSS.n396 VSS.n388 17.0005
R151 VSS.n401 VSS.n400 17.0005
R152 VSS.n401 VSS.n38 17.0005
R153 VSS.n401 VSS.n362 17.0005
R154 VSS.n401 VSS.n39 17.0005
R155 VSS.n401 VSS.n361 17.0005
R156 VSS.n401 VSS.n40 17.0005
R157 VSS.n401 VSS.n360 17.0005
R158 VSS.n401 VSS.n41 17.0005
R159 VSS.n401 VSS.n359 17.0005
R160 VSS.n401 VSS.n42 17.0005
R161 VSS.n401 VSS.n358 17.0005
R162 VSS.n401 VSS.n43 17.0005
R163 VSS.n401 VSS.n357 17.0005
R164 VSS.n401 VSS.n44 17.0005
R165 VSS.n401 VSS.n356 17.0005
R166 VSS.n401 VSS.n45 17.0005
R167 VSS.n401 VSS.n355 17.0005
R168 VSS.n401 VSS.n46 17.0005
R169 VSS.n401 VSS.n354 17.0005
R170 VSS.n401 VSS.n47 17.0005
R171 VSS.n401 VSS.n352 17.0005
R172 VSS.n401 VSS.n51 17.0005
R173 VSS.n401 VSS.n348 17.0005
R174 VSS.n401 VSS.n53 17.0005
R175 VSS.n401 VSS.n346 17.0005
R176 VSS.n401 VSS.n54 17.0005
R177 VSS.n401 VSS.n73 17.0005
R178 VSS.n401 VSS.n55 17.0005
R179 VSS.n401 VSS.n72 17.0005
R180 VSS.n401 VSS.n56 17.0005
R181 VSS.n401 VSS.n71 17.0005
R182 VSS.n401 VSS.n57 17.0005
R183 VSS.n401 VSS.n70 17.0005
R184 VSS.n401 VSS.n58 17.0005
R185 VSS.n401 VSS.n69 17.0005
R186 VSS.n401 VSS.n59 17.0005
R187 VSS.n401 VSS.n68 17.0005
R188 VSS.n401 VSS.n60 17.0005
R189 VSS.n401 VSS.n67 17.0005
R190 VSS.n401 VSS.n61 17.0005
R191 VSS.n401 VSS.n66 17.0005
R192 VSS.n401 VSS.n63 17.0005
R193 VSS.n65 VSS.t19 15.6926
R194 VSS.t52 VSS.n398 15.6926
R195 VSS.t37 VSS.n50 14.9331
R196 VSS.n50 VSS.t38 14.9331
R197 VSS.t54 VSS.n37 14.555
R198 VSS.n64 VSS.t15 14.5543
R199 VSS.n327 VSS.n186 14.3486
R200 VSS.t15 VSS.n62 13.0361
R201 VSS.n399 VSS.t54 13.0354
R202 VSS.t35 VSS.n349 12.6546
R203 VSS.n351 VSS.t40 12.6546
R204 VSS.t13 VSS.n63 12.5321
R205 VSS.n400 VSS.t55 12.5321
R206 VSS.n241 VSS.n240 12.4771
R207 VSS.n350 VSS.t35 12.2766
R208 VSS.t40 VSS.n49 12.2759
R209 VSS.t9 VSS.n261 12.1524
R210 VSS.t163 VSS.n306 11.7727
R211 VSS.n404 VSS.t73 11.5239
R212 VSS.n280 VSS.t134 11.3929
R213 VSS.n232 VSS.n231 11.3338
R214 VSS.n232 VSS.n227 11.3338
R215 VSS.n233 VSS.n232 11.3338
R216 VSS.t3 VSS.n84 11.2294
R217 VSS.t107 VSS.t34 11.203
R218 VSS.t41 VSS.t151 11.203
R219 VSS.t31 VSS.n53 11.0132
R220 VSS.n354 VSS.t42 11.0132
R221 VSS.t38 VSS.n49 9.99808
R222 VSS.n350 VSS.t37 9.99739
R223 VSS.n106 VSS.t3 9.98179
R224 VSS.t104 VSS.n347 9.80648
R225 VSS.n52 VSS.t106 9.80648
R226 VSS.t152 VSS.n48 9.80648
R227 VSS.n353 VSS.t154 9.80648
R228 VSS.n344 VSS.n343 9.75612
R229 VSS.n346 VSS.t29 9.49417
R230 VSS.t44 VSS.n46 9.49417
R231 VSS.n190 VSS.n78 9.43808
R232 VSS.n191 VSS.n79 9.43808
R233 VSS.n193 VSS.n80 9.43808
R234 VSS.n196 VSS.n83 9.43808
R235 VSS.n216 VSS.n85 9.43808
R236 VSS.n207 VSS.n92 9.43808
R237 VSS.n244 VSS.n114 9.43808
R238 VSS.n222 VSS.n108 9.43808
R239 VSS.n219 VSS.n105 9.43808
R240 VSS.n218 VSS.n104 9.43808
R241 VSS.n216 VSS.n103 9.43808
R242 VSS.n211 VSS.n97 9.43808
R243 VSS.n210 VSS.n96 9.43808
R244 VSS.n207 VSS.n94 9.43808
R245 VSS.n204 VSS.n91 9.43808
R246 VSS.n209 VSS.n96 9.43808
R247 VSS.n210 VSS.n97 9.43808
R248 VSS.n211 VSS.n98 9.43808
R249 VSS.n202 VSS.n100 9.43808
R250 VSS.n201 VSS.n100 9.43808
R251 VSS.n201 VSS.n89 9.43808
R252 VSS.n212 VSS.n89 9.43808
R253 VSS.n198 VSS.n101 9.43808
R254 VSS.n215 VSS.n103 9.43808
R255 VSS.n217 VSS.n85 9.43808
R256 VSS.n217 VSS.n104 9.43808
R257 VSS.n218 VSS.n105 9.43808
R258 VSS.n220 VSS.n107 9.43808
R259 VSS.n196 VSS.n107 9.43808
R260 VSS.n221 VSS.n83 9.43808
R261 VSS.n221 VSS.n108 9.43808
R262 VSS.n222 VSS.n109 9.43808
R263 VSS.n194 VSS.n82 9.43808
R264 VSS.n242 VSS.n80 9.43808
R265 VSS.n242 VSS.n111 9.43808
R266 VSS.n191 VSS.n111 9.43808
R267 VSS.n190 VSS.n79 9.43808
R268 VSS.n243 VSS.n78 9.43808
R269 VSS.n243 VSS.n112 9.43808
R270 VSS.n188 VSS.n77 9.43808
R271 VSS.n244 VSS.n77 9.43808
R272 VSS.n187 VSS.n114 9.43808
R273 VSS.n187 VSS.n76 9.43808
R274 VSS.n34 VSS.n344 9.55191
R275 VSS.n399 VSS.t52 9.23859
R276 VSS.t19 VSS.n62 9.23789
R277 VSS.n377 VSS.n65 9.23686
R278 VSS.n398 VSS.n397 9.23686
R279 VSS.n402 VSS.n22 9.0005
R280 VSS.n0 VSS.n345 9.0005
R281 VSS.n240 VSS.n81 8.73412
R282 VSS.n328 VSS.n327 8.5005
R283 VSS.n328 VSS.n189 8.5005
R284 VSS.n328 VSS.n241 8.5005
R285 VSS.n328 VSS.n195 8.5005
R286 VSS.n328 VSS.n214 8.5005
R287 VSS.n328 VSS.n197 8.5005
R288 VSS.n328 VSS.n213 8.5005
R289 VSS.n328 VSS.n203 8.5005
R290 VSS.n328 VSS.n208 8.5005
R291 VSS.n328 VSS.n205 8.5005
R292 VSS.n328 VSS.n206 8.5005
R293 VSS.n331 VSS.n113 8.5005
R294 VSS.n331 VSS.n110 8.5005
R295 VSS.n331 VSS.n106 8.5005
R296 VSS.n331 VSS.n102 8.5005
R297 VSS.n331 VSS.n99 8.5005
R298 VSS.n331 VSS.n95 8.5005
R299 VSS.n331 VSS.n81 8.5005
R300 VSS.n331 VSS.n84 8.5005
R301 VSS.n331 VSS.n86 8.5005
R302 VSS.n331 VSS.n88 8.5005
R303 VSS.n331 VSS.n90 8.5005
R304 VSS.n328 VSS.n245 8.5005
R305 VSS.n328 VSS.n248 8.5005
R306 VSS.n328 VSS.n249 8.5005
R307 VSS.n328 VSS.n250 8.5005
R308 VSS.n328 VSS.n251 8.5005
R309 VSS.n328 VSS.n252 8.5005
R310 VSS.n328 VSS.n253 8.5005
R311 VSS.n328 VSS.n254 8.5005
R312 VSS.n328 VSS.n255 8.5005
R313 VSS.n328 VSS.n256 8.5005
R314 VSS.n328 VSS.n257 8.5005
R315 VSS.n328 VSS.n258 8.5005
R316 VSS.n328 VSS.n259 8.5005
R317 VSS.n328 VSS.n260 8.5005
R318 VSS.n328 VSS.n261 8.5005
R319 VSS.n328 VSS.n262 8.5005
R320 VSS.n328 VSS.n263 8.5005
R321 VSS.n328 VSS.n264 8.5005
R322 VSS.n328 VSS.n265 8.5005
R323 VSS.n328 VSS.n266 8.5005
R324 VSS.n328 VSS.n267 8.5005
R325 VSS.n328 VSS.n268 8.5005
R326 VSS.n328 VSS.n269 8.5005
R327 VSS.n328 VSS.n270 8.5005
R328 VSS.n328 VSS.n271 8.5005
R329 VSS.n328 VSS.n272 8.5005
R330 VSS.n328 VSS.n273 8.5005
R331 VSS.n328 VSS.n274 8.5005
R332 VSS.n328 VSS.n275 8.5005
R333 VSS.n328 VSS.n276 8.5005
R334 VSS.n328 VSS.n277 8.5005
R335 VSS.n328 VSS.n280 8.5005
R336 VSS.n328 VSS.n281 8.5005
R337 VSS.n328 VSS.n282 8.5005
R338 VSS.n328 VSS.n283 8.5005
R339 VSS.n328 VSS.n284 8.5005
R340 VSS.n328 VSS.n285 8.5005
R341 VSS.n328 VSS.n286 8.5005
R342 VSS.n328 VSS.n287 8.5005
R343 VSS.n328 VSS.n288 8.5005
R344 VSS.n328 VSS.n289 8.5005
R345 VSS.n328 VSS.n290 8.5005
R346 VSS.n328 VSS.n291 8.5005
R347 VSS.n328 VSS.n292 8.5005
R348 VSS.n328 VSS.n293 8.5005
R349 VSS.n328 VSS.n294 8.5005
R350 VSS.n328 VSS.n295 8.5005
R351 VSS.n328 VSS.n296 8.5005
R352 VSS.n328 VSS.n297 8.5005
R353 VSS.n328 VSS.n298 8.5005
R354 VSS.n328 VSS.n299 8.5005
R355 VSS.n328 VSS.n300 8.5005
R356 VSS.n328 VSS.n301 8.5005
R357 VSS.n328 VSS.n302 8.5005
R358 VSS.n328 VSS.n303 8.5005
R359 VSS.n328 VSS.n304 8.5005
R360 VSS.n328 VSS.n305 8.5005
R361 VSS.n328 VSS.n306 8.5005
R362 VSS.n328 VSS.n307 8.5005
R363 VSS.n328 VSS.n308 8.5005
R364 VSS.n328 VSS.n309 8.5005
R365 VSS.n328 VSS.n313 8.5005
R366 VSS.n328 VSS.n314 8.5005
R367 VSS.n328 VSS.n315 8.5005
R368 VSS.n328 VSS.n316 8.5005
R369 VSS.n328 VSS.n317 8.5005
R370 VSS.n328 VSS.n318 8.5005
R371 VSS.n328 VSS.n319 8.5005
R372 VSS.n328 VSS.n320 8.5005
R373 VSS.n328 VSS.n321 8.5005
R374 VSS.n328 VSS.n322 8.5005
R375 VSS.n328 VSS.n323 8.5005
R376 VSS.n328 VSS.n324 8.5005
R377 VSS.n328 VSS.n325 8.5005
R378 VSS.n328 VSS.n326 8.5005
R379 VSS.n328 VSS.n185 8.5005
R380 VSS.n329 VSS.n328 8.5005
R381 VSS.n378 VSS.n61 8.35493
R382 VSS.n379 VSS.n60 8.35493
R383 VSS.n375 VSS.n68 8.35493
R384 VSS.n374 VSS.n69 8.35493
R385 VSS.n381 VSS.n58 8.35493
R386 VSS.n372 VSS.n71 8.35493
R387 VSS.n391 VSS.n43 8.35493
R388 VSS.n366 VSS.n359 8.35493
R389 VSS.n393 VSS.n41 8.35493
R390 VSS.n394 VSS.n40 8.35493
R391 VSS.n364 VSS.n361 8.35493
R392 VSS.n363 VSS.n362 8.35493
R393 VSS.t102 VSS.n53 7.78531
R394 VSS.n348 VSS.t104 7.78531
R395 VSS.t106 VSS.n51 7.78531
R396 VSS.n352 VSS.t152 7.78531
R397 VSS.t154 VSS.n47 7.78531
R398 VSS.n354 VSS.t156 7.78531
R399 VSS.n343 VSS.n75 7.76695
R400 VSS.n64 VSS.t13 7.7196
R401 VSS.t55 VSS.n37 7.71891
R402 VSS.t108 VSS.n253 7.59544
R403 VSS.n382 VSS.t97 7.02582
R404 VSS.n371 VSS.t99 7.02582
R405 VSS.n385 VSS.t101 7.02582
R406 VSS.n388 VSS.t157 7.02582
R407 VSS.n390 VSS.t159 7.02582
R408 VSS.n367 VSS.t161 7.02582
R409 VSS.n186 VSS.t5 6.86263
R410 VSS.n295 VSS.t7 6.83594
R411 VSS.n235 VSS.t70 6.19054
R412 VSS.n225 VSS.t77 6.19054
R413 VSS.n331 VSS.n116 6.16155
R414 VSS.n331 VSS.n117 6.16155
R415 VSS.n331 VSS.n118 6.16155
R416 VSS.n331 VSS.n119 6.16155
R417 VSS.n331 VSS.n122 6.16155
R418 VSS.n331 VSS.n123 6.16155
R419 VSS.n331 VSS.n124 6.16155
R420 VSS.n331 VSS.n125 6.16155
R421 VSS.n331 VSS.n126 6.16155
R422 VSS.n331 VSS.n129 6.16155
R423 VSS.n331 VSS.n130 6.16155
R424 VSS.n331 VSS.n131 6.16155
R425 VSS.n331 VSS.n132 6.16155
R426 VSS.n331 VSS.n133 6.16155
R427 VSS.n331 VSS.n134 6.16155
R428 VSS.n331 VSS.n135 6.16155
R429 VSS.n331 VSS.n136 6.16155
R430 VSS.n331 VSS.n137 6.16155
R431 VSS.n331 VSS.n138 6.16155
R432 VSS.n331 VSS.n139 6.16155
R433 VSS.n331 VSS.n140 6.16155
R434 VSS.n331 VSS.n141 6.16155
R435 VSS.n331 VSS.n144 6.16155
R436 VSS.n331 VSS.n145 6.16155
R437 VSS.n331 VSS.n146 6.16155
R438 VSS.n331 VSS.n147 6.16155
R439 VSS.n331 VSS.n148 6.16155
R440 VSS.n331 VSS.n149 6.16155
R441 VSS.n331 VSS.n150 6.16155
R442 VSS.n331 VSS.n151 6.16155
R443 VSS.n331 VSS.n152 6.16155
R444 VSS.n331 VSS.n153 6.16155
R445 VSS.n331 VSS.n154 6.16155
R446 VSS.n331 VSS.n155 6.16155
R447 VSS.n331 VSS.n158 6.16155
R448 VSS.n331 VSS.n159 6.16155
R449 VSS.n331 VSS.n160 6.16155
R450 VSS.n331 VSS.n161 6.16155
R451 VSS.n331 VSS.n162 6.16155
R452 VSS.n331 VSS.n163 6.16155
R453 VSS.n331 VSS.n164 6.16155
R454 VSS.n331 VSS.n165 6.16155
R455 VSS.n331 VSS.n166 6.16155
R456 VSS.n331 VSS.n169 6.16155
R457 VSS.n331 VSS.n170 6.16155
R458 VSS.n331 VSS.n171 6.16155
R459 VSS.n331 VSS.n172 6.16155
R460 VSS.n331 VSS.n173 6.16155
R461 VSS.n331 VSS.n174 6.16155
R462 VSS.n331 VSS.n175 6.16155
R463 VSS.n331 VSS.n176 6.16155
R464 VSS.n331 VSS.n177 6.16155
R465 VSS.n331 VSS.n178 6.16155
R466 VSS.n331 VSS.n179 6.16155
R467 VSS.n331 VSS.n180 6.16155
R468 VSS.n331 VSS.n181 6.16155
R469 VSS.n331 VSS.n182 6.16155
R470 VSS.n331 VSS.n183 6.16155
R471 VSS.n331 VSS.n184 6.16155
R472 VSS.n401 VSS.n398 6.16155
R473 VSS.n401 VSS.n353 6.16155
R474 VSS.n401 VSS.n48 6.16155
R475 VSS.n401 VSS.n351 6.16155
R476 VSS.n401 VSS.n50 6.16155
R477 VSS.n401 VSS.n349 6.16155
R478 VSS.n401 VSS.n52 6.16155
R479 VSS.n401 VSS.n347 6.16155
R480 VSS.n401 VSS.n65 6.16155
R481 VSS.t7 VSS.n294 6.07645
R482 VSS.n347 VSS.t103 6.00901
R483 VSS.t105 VSS.n52 6.00901
R484 VSS.n349 VSS.t107 6.00901
R485 VSS.t151 VSS.n351 6.00901
R486 VSS.n48 VSS.t153 6.00901
R487 VSS.t155 VSS.n353 6.00901
R488 VSS.t32 VSS.t105 5.88658
R489 VSS.t153 VSS.t26 5.88658
R490 VSS.n248 VSS.n115 5.71594
R491 VSS.n255 VSS.n121 5.71594
R492 VSS.n263 VSS.n128 5.71594
R493 VSS.n281 VSS.n143 5.71594
R494 VSS.n296 VSS.n157 5.71594
R495 VSS.n308 VSS.n168 5.71594
R496 VSS.n252 VSS.n120 5.71529
R497 VSS.n260 VSS.n127 5.71529
R498 VSS.n276 VSS.n142 5.71529
R499 VSS.n293 VSS.n156 5.71529
R500 VSS.n305 VSS.n167 5.71529
R501 VSS.n330 VSS.n185 5.71529
R502 VSS.n348 VSS.t32 5.6967
R503 VSS.t26 VSS.n47 5.6967
R504 VSS.n386 VSS.n27 5.65086
R505 VSS.n386 VSS.n3 2.80696
R506 VSS.n5 VSS.n26 0.066765
R507 VSS.n30 VSS.n31 0.0585658
R508 VSS.n396 VSS.n30 2.7974
R509 VSS.n8 VSS.n29 0.066765
R510 VSS.n396 VSS.n25 5.65086
R511 VSS.n254 VSS.t108 5.31696
R512 VSS.t82 VSS.n67 5.12708
R513 VSS.t88 VSS.n70 5.12708
R514 VSS.t91 VSS.n56 5.12708
R515 VSS.t94 VSS.n73 5.12708
R516 VSS.n346 VSS.t102 5.12708
R517 VSS.t156 VSS.n46 5.12708
R518 VSS.t135 VSS.n45 5.12708
R519 VSS.t139 VSS.n357 5.12708
R520 VSS.t142 VSS.n42 5.12708
R521 VSS.t148 VSS.n39 5.12708
R522 VSS.n377 VSS.t20 4.93721
R523 VSS.n397 VSS.t49 4.93721
R524 VSS.n188 VSS.n113 4.71929
R525 VSS.n194 VSS.n110 4.71929
R526 VSS.n220 VSS.n84 4.71929
R527 VSS.n215 VSS.n86 4.71929
R528 VSS.n198 VSS.n102 4.71929
R529 VSS.n212 VSS.n88 4.71929
R530 VSS.n202 VSS.n99 4.71929
R531 VSS.n209 VSS.n90 4.71929
R532 VSS.n204 VSS.n95 4.71929
R533 VSS.n327 VSS.n76 4.71929
R534 VSS.n241 VSS.n82 4.71929
R535 VSS.n214 VSS.n87 4.71929
R536 VSS.n208 VSS.n91 4.71929
R537 VSS.n189 VSS.n112 4.71929
R538 VSS.n195 VSS.n109 4.71929
R539 VSS.n203 VSS.n98 4.71929
R540 VSS.n206 VSS.n94 4.71929
R541 VSS.n205 VSS.n92 4.71929
R542 VSS.n213 VSS.n101 4.71929
R543 VSS.n197 VSS.n87 4.71929
R544 VSS.n219 VSS.n106 4.71929
R545 VSS.n193 VSS.n81 4.71929
R546 VSS.n31 VSS.t73 4.69693
R547 VSS.n248 VSS.n116 4.6799
R548 VSS.n249 VSS.n117 4.6799
R549 VSS.n250 VSS.n118 4.6799
R550 VSS.n251 VSS.n119 4.6799
R551 VSS.n255 VSS.n122 4.6799
R552 VSS.n256 VSS.n123 4.6799
R553 VSS.n257 VSS.n124 4.6799
R554 VSS.n258 VSS.n125 4.6799
R555 VSS.n259 VSS.n126 4.6799
R556 VSS.n263 VSS.n129 4.6799
R557 VSS.n264 VSS.n130 4.6799
R558 VSS.n265 VSS.n131 4.6799
R559 VSS.n266 VSS.n132 4.6799
R560 VSS.n267 VSS.n133 4.6799
R561 VSS.n268 VSS.n134 4.6799
R562 VSS.n269 VSS.n135 4.6799
R563 VSS.n270 VSS.n136 4.6799
R564 VSS.n271 VSS.n137 4.6799
R565 VSS.n272 VSS.n138 4.6799
R566 VSS.n273 VSS.n139 4.6799
R567 VSS.n274 VSS.n140 4.6799
R568 VSS.n275 VSS.n141 4.6799
R569 VSS.n281 VSS.n144 4.6799
R570 VSS.n282 VSS.n145 4.6799
R571 VSS.n283 VSS.n146 4.6799
R572 VSS.n284 VSS.n147 4.6799
R573 VSS.n285 VSS.n148 4.6799
R574 VSS.n286 VSS.n149 4.6799
R575 VSS.n287 VSS.n150 4.6799
R576 VSS.n288 VSS.n151 4.6799
R577 VSS.n289 VSS.n152 4.6799
R578 VSS.n290 VSS.n153 4.6799
R579 VSS.n291 VSS.n154 4.6799
R580 VSS.n292 VSS.n155 4.6799
R581 VSS.n296 VSS.n158 4.6799
R582 VSS.n297 VSS.n159 4.6799
R583 VSS.n298 VSS.n160 4.6799
R584 VSS.n299 VSS.n161 4.6799
R585 VSS.n300 VSS.n162 4.6799
R586 VSS.n301 VSS.n163 4.6799
R587 VSS.n302 VSS.n164 4.6799
R588 VSS.n303 VSS.n165 4.6799
R589 VSS.n304 VSS.n166 4.6799
R590 VSS.n308 VSS.n169 4.6799
R591 VSS.n309 VSS.n170 4.6799
R592 VSS.n313 VSS.n171 4.6799
R593 VSS.n314 VSS.n172 4.6799
R594 VSS.n315 VSS.n173 4.6799
R595 VSS.n316 VSS.n174 4.6799
R596 VSS.n317 VSS.n175 4.6799
R597 VSS.n318 VSS.n176 4.6799
R598 VSS.n319 VSS.n177 4.6799
R599 VSS.n320 VSS.n178 4.6799
R600 VSS.n321 VSS.n179 4.6799
R601 VSS.n322 VSS.n180 4.6799
R602 VSS.n323 VSS.n181 4.6799
R603 VSS.n324 VSS.n182 4.6799
R604 VSS.n325 VSS.n183 4.6799
R605 VSS.n326 VSS.n184 4.6799
R606 VSS.n185 VSS.n184 4.6799
R607 VSS.n326 VSS.n183 4.6799
R608 VSS.n325 VSS.n182 4.6799
R609 VSS.n324 VSS.n181 4.6799
R610 VSS.n323 VSS.n180 4.6799
R611 VSS.n322 VSS.n179 4.6799
R612 VSS.n321 VSS.n178 4.6799
R613 VSS.n320 VSS.n177 4.6799
R614 VSS.n319 VSS.n176 4.6799
R615 VSS.n318 VSS.n175 4.6799
R616 VSS.n317 VSS.n174 4.6799
R617 VSS.n316 VSS.n173 4.6799
R618 VSS.n315 VSS.n172 4.6799
R619 VSS.n314 VSS.n171 4.6799
R620 VSS.n313 VSS.n170 4.6799
R621 VSS.n309 VSS.n169 4.6799
R622 VSS.n305 VSS.n166 4.6799
R623 VSS.n304 VSS.n165 4.6799
R624 VSS.n303 VSS.n164 4.6799
R625 VSS.n302 VSS.n163 4.6799
R626 VSS.n301 VSS.n162 4.6799
R627 VSS.n300 VSS.n161 4.6799
R628 VSS.n299 VSS.n160 4.6799
R629 VSS.n298 VSS.n159 4.6799
R630 VSS.n297 VSS.n158 4.6799
R631 VSS.n293 VSS.n155 4.6799
R632 VSS.n292 VSS.n154 4.6799
R633 VSS.n291 VSS.n153 4.6799
R634 VSS.n290 VSS.n152 4.6799
R635 VSS.n289 VSS.n151 4.6799
R636 VSS.n288 VSS.n150 4.6799
R637 VSS.n287 VSS.n149 4.6799
R638 VSS.n286 VSS.n148 4.6799
R639 VSS.n285 VSS.n147 4.6799
R640 VSS.n284 VSS.n146 4.6799
R641 VSS.n283 VSS.n145 4.6799
R642 VSS.n282 VSS.n144 4.6799
R643 VSS.n276 VSS.n141 4.6799
R644 VSS.n275 VSS.n140 4.6799
R645 VSS.n274 VSS.n139 4.6799
R646 VSS.n273 VSS.n138 4.6799
R647 VSS.n272 VSS.n137 4.6799
R648 VSS.n271 VSS.n136 4.6799
R649 VSS.n270 VSS.n135 4.6799
R650 VSS.n269 VSS.n134 4.6799
R651 VSS.n268 VSS.n133 4.6799
R652 VSS.n267 VSS.n132 4.6799
R653 VSS.n266 VSS.n131 4.6799
R654 VSS.n265 VSS.n130 4.6799
R655 VSS.n264 VSS.n129 4.6799
R656 VSS.n260 VSS.n126 4.6799
R657 VSS.n259 VSS.n125 4.6799
R658 VSS.n258 VSS.n124 4.6799
R659 VSS.n257 VSS.n123 4.6799
R660 VSS.n256 VSS.n122 4.6799
R661 VSS.n252 VSS.n119 4.6799
R662 VSS.n251 VSS.n118 4.6799
R663 VSS.n250 VSS.n117 4.6799
R664 VSS.n249 VSS.n116 4.6799
R665 VSS.n343 VSS.n342 4.67815
R666 VSS.n9 VSS.n2 4.59452
R667 VSS.n376 VSS.n61 4.55746
R668 VSS.n380 VSS.n68 4.55746
R669 VSS.n374 VSS.n59 4.55746
R670 VSS.n373 VSS.n58 4.55746
R671 VSS.n382 VSS.n70 4.55746
R672 VSS.n371 VSS.n56 4.55746
R673 VSS.n370 VSS.n55 4.55746
R674 VSS.n385 VSS.n73 4.55746
R675 VSS.n388 VSS.n45 4.55746
R676 VSS.n389 VSS.n356 4.55746
R677 VSS.n390 VSS.n357 4.55746
R678 VSS.n367 VSS.n42 4.55746
R679 VSS.n392 VSS.n359 4.55746
R680 VSS.n393 VSS.n360 4.55746
R681 VSS.n365 VSS.n40 4.55746
R682 VSS.n395 VSS.n362 4.55746
R683 VSS.n24 VSS.n12 4.5005
R684 VSS.n12 VSS.n387 4.5005
R685 VSS.n11 VSS.n10 2.16985
R686 VSS.n9 VSS.n35 4.5005
R687 VSS.n386 VSS.n5 2.3909
R688 VSS.n396 VSS.n8 2.3909
R689 VSS.n329 VSS.n186 4.17772
R690 VSS.t17 VSS.n67 4.17772
R691 VSS.n384 VSS.t28 4.17772
R692 VSS.t28 VSS.n55 4.17772
R693 VSS.t24 VSS.n356 4.17772
R694 VSS.n369 VSS.t24 4.17772
R695 VSS.t51 VSS.n39 4.17772
R696 VSS.t85 VSS.t11 3.98784
R697 VSS.t145 VSS.t48 3.98784
R698 VSS.n331 VSS.n115 3.76308
R699 VSS.n331 VSS.n121 3.76308
R700 VSS.n331 VSS.n128 3.76308
R701 VSS.n331 VSS.n143 3.76308
R702 VSS.n331 VSS.n157 3.76308
R703 VSS.n331 VSS.n168 3.76308
R704 VSS.n331 VSS.n120 3.7629
R705 VSS.n331 VSS.n127 3.7629
R706 VSS.n331 VSS.n142 3.7629
R707 VSS.n331 VSS.n156 3.7629
R708 VSS.n331 VSS.n167 3.7629
R709 VSS.n331 VSS.n330 3.7629
R710 VSS.n24 VSS.t138 3.45423
R711 VSS.n7 VSS.t141 3.45423
R712 VSS.n29 VSS.t144 3.45423
R713 VSS.n28 VSS.t147 3.45423
R714 VSS.n6 VSS.t83 3.45423
R715 VSS.n26 VSS.t86 3.45423
R716 VSS.n3 VSS.t89 3.45423
R717 VSS.n35 VSS.t92 3.45423
R718 VSS.n25 VSS.t136 3.45313
R719 VSS.n31 VSS.t150 3.45313
R720 VSS.n2 VSS.t81 3.45313
R721 VSS.n27 VSS.t95 3.45313
R722 VSS.n223 VSS.n206 3.43157
R723 VSS.t20 VSS.n66 3.41822
R724 VSS.n383 VSS.t22 3.41822
R725 VSS.t29 VSS.n54 3.41822
R726 VSS.n355 VSS.t44 3.41822
R727 VSS.n368 VSS.t45 3.41822
R728 VSS.t49 VSS.n38 3.41822
R729 VSS.n18 VSS.n17 0.0783198
R730 VSS.n401 VSS.n22 1.11025
R731 VSS.n401 VSS.n15 1.02806
R732 VSS.n401 VSS.n1 0.627529
R733 VSS.n1 VSS.n0 0.10267
R734 VSS.n20 VSS.n19 0.0776913
R735 VSS.n378 VSS.t80 3.22835
R736 VSS.n376 VSS.t82 3.22835
R737 VSS.n375 VSS.t84 3.22835
R738 VSS.n380 VSS.t85 3.22835
R739 VSS.n381 VSS.t87 3.22835
R740 VSS.n372 VSS.t90 3.22835
R741 VSS.n384 VSS.t93 3.22835
R742 VSS.n369 VSS.t137 3.22835
R743 VSS.n391 VSS.t140 3.22835
R744 VSS.n366 VSS.t143 3.22835
R745 VSS.n365 VSS.t145 3.22835
R746 VSS.n394 VSS.t146 3.22835
R747 VSS.n395 VSS.t148 3.22835
R748 VSS.n363 VSS.t149 3.22835
R749 VSS.n233 VSS.t58 3.22826
R750 VSS.n227 VSS.t110 3.22826
R751 VSS.n231 VSS.t109 3.22826
R752 VSS.n404 VSS.n2 2.98702
R753 VSS.n245 VSS.n115 2.85835
R754 VSS.n254 VSS.n121 2.85835
R755 VSS.n262 VSS.n128 2.85835
R756 VSS.n280 VSS.n143 2.85835
R757 VSS.n295 VSS.n157 2.85835
R758 VSS.n307 VSS.n168 2.85835
R759 VSS.n330 VSS.n329 2.85814
R760 VSS.n306 VSS.n167 2.85814
R761 VSS.n294 VSS.n156 2.85814
R762 VSS.n277 VSS.n142 2.85814
R763 VSS.n261 VSS.n127 2.85814
R764 VSS.n253 VSS.n120 2.85814
R765 VSS.n401 VSS.n18 1.50398
R766 VSS.n15 VSS.n14 0.0606977
R767 VSS.n401 VSS.n20 1.50426
R768 VSS.t98 VSS.t91 2.65873
R769 VSS.t100 VSS.t94 2.65873
R770 VSS.t158 VSS.t135 2.65873
R771 VSS.t160 VSS.t139 2.65873
R772 VSS.n401 VSS.n37 2.57114
R773 VSS.n401 VSS.n399 2.57114
R774 VSS.n401 VSS.n49 2.57114
R775 VSS.n401 VSS.n350 2.57114
R776 VSS.n401 VSS.n62 2.57114
R777 VSS.n401 VSS.n64 2.57114
R778 VSS.n19 VSS.t14 2.40099
R779 VSS.n17 VSS.t56 2.40072
R780 VSS.n16 VSS.t50 2.36048
R781 VSS.n14 VSS.t27 2.36035
R782 VSS.n0 VSS.t12 2.36001
R783 VSS.n0 VSS.t18 2.35987
R784 VSS.n0 VSS.t23 2.35987
R785 VSS.n19 VSS.t16 2.3598
R786 VSS.n13 VSS.t33 2.3598
R787 VSS.n14 VSS.t39 2.3598
R788 VSS.n16 VSS.t47 2.35974
R789 VSS.n21 VSS.t43 2.35958
R790 VSS.n13 VSS.t36 2.35935
R791 VSS.n17 VSS.t53 2.35933
R792 VSS.n23 VSS.t30 2.35906
R793 VSS.n22 VSS.t25 2.35861
R794 VSS.n334 VSS.t129 2.21157
R795 VSS.n199 VSS.t60 2.21136
R796 VSS.n75 VSS.t59 2.21095
R797 VSS.n246 VSS.t68 2.21091
R798 VSS.n332 VSS.t131 2.21089
R799 VSS.n342 VSS.t122 2.21087
R800 VSS.n310 VSS.t64 2.21067
R801 VSS.n340 VSS.t123 2.21056
R802 VSS.n336 VSS.t127 2.21043
R803 VSS.n311 VSS.t62 2.21041
R804 VSS.n278 VSS.t66 2.21006
R805 VSS.n338 VSS.t125 2.21005
R806 VSS.n75 VSS.t1 2.20309
R807 VSS.n246 VSS.t10 2.20303
R808 VSS.n338 VSS.t115 2.20268
R809 VSS.n278 VSS.t8 2.20263
R810 VSS.n336 VSS.t117 2.20259
R811 VSS.n332 VSS.t121 2.2021
R812 VSS.n340 VSS.t113 2.20205
R813 VSS.n334 VSS.t119 2.20193
R814 VSS.n199 VSS.t2 2.20189
R815 VSS.n311 VSS.t4 2.2015
R816 VSS.n310 VSS.t6 2.20136
R817 VSS.n342 VSS.t112 2.20083
R818 VSS.n328 VSS.n187 1.89185
R819 VSS.n328 VSS.n244 1.89185
R820 VSS.n328 VSS.n188 1.89185
R821 VSS.n328 VSS.n243 1.89185
R822 VSS.n328 VSS.n190 1.89185
R823 VSS.n328 VSS.n191 1.89185
R824 VSS.n328 VSS.n242 1.89185
R825 VSS.n328 VSS.n193 1.89185
R826 VSS.n328 VSS.n194 1.89185
R827 VSS.n328 VSS.n222 1.89185
R828 VSS.n328 VSS.n221 1.89185
R829 VSS.n328 VSS.n196 1.89185
R830 VSS.n328 VSS.n220 1.89185
R831 VSS.n328 VSS.n219 1.89185
R832 VSS.n328 VSS.n218 1.89185
R833 VSS.n328 VSS.n217 1.89185
R834 VSS.n328 VSS.n216 1.89185
R835 VSS.n328 VSS.n215 1.89185
R836 VSS.n328 VSS.n198 1.89185
R837 VSS.n328 VSS.n212 1.89185
R838 VSS.n328 VSS.n201 1.89185
R839 VSS.n328 VSS.n202 1.89185
R840 VSS.n328 VSS.n211 1.89185
R841 VSS.n328 VSS.n210 1.89185
R842 VSS.n328 VSS.n209 1.89185
R843 VSS.n328 VSS.n204 1.89185
R844 VSS.n328 VSS.n207 1.89185
R845 VSS.n331 VSS.n114 1.89185
R846 VSS.n331 VSS.n112 1.89185
R847 VSS.n331 VSS.n111 1.89185
R848 VSS.n331 VSS.n109 1.89185
R849 VSS.n331 VSS.n108 1.89185
R850 VSS.n331 VSS.n107 1.89185
R851 VSS.n331 VSS.n105 1.89185
R852 VSS.n331 VSS.n104 1.89185
R853 VSS.n331 VSS.n103 1.89185
R854 VSS.n331 VSS.n101 1.89185
R855 VSS.n331 VSS.n100 1.89185
R856 VSS.n331 VSS.n98 1.89185
R857 VSS.n331 VSS.n97 1.89185
R858 VSS.n331 VSS.n96 1.89185
R859 VSS.n331 VSS.n94 1.89185
R860 VSS.n331 VSS.n76 1.89185
R861 VSS.n331 VSS.n77 1.89185
R862 VSS.n331 VSS.n78 1.89185
R863 VSS.n331 VSS.n79 1.89185
R864 VSS.n331 VSS.n80 1.89185
R865 VSS.n331 VSS.n82 1.89185
R866 VSS.n331 VSS.n83 1.89185
R867 VSS.n331 VSS.n85 1.89185
R868 VSS.n331 VSS.n87 1.89185
R869 VSS.n331 VSS.n89 1.89185
R870 VSS.n331 VSS.n91 1.89185
R871 VSS.n331 VSS.n92 1.89185
R872 VSS.n36 VSS.n4 0.766777
R873 VSS.n4 VSS.n32 0.288546
R874 VSS VSS.n33 0.189868
R875 VSS VSS.n34 0.776964
R876 VSS.t134 VSS.n277 1.51949
R877 VSS.t80 VSS.n66 1.32961
R878 VSS.t84 VSS.n60 1.32961
R879 VSS.t87 VSS.n69 1.32961
R880 VSS.t96 VSS.t21 1.32961
R881 VSS.t21 VSS.t88 1.32961
R882 VSS.t97 VSS.n57 1.32961
R883 VSS.t90 VSS.n57 1.32961
R884 VSS.t99 VSS.n72 1.32961
R885 VSS.t93 VSS.n72 1.32961
R886 VSS.t101 VSS.n54 1.32961
R887 VSS.t157 VSS.n355 1.32961
R888 VSS.t137 VSS.n44 1.32961
R889 VSS.t159 VSS.n44 1.32961
R890 VSS.t140 VSS.n358 1.32961
R891 VSS.t161 VSS.n358 1.32961
R892 VSS.t46 VSS.t142 1.32961
R893 VSS.t162 VSS.t46 1.32961
R894 VSS.t143 VSS.n41 1.32961
R895 VSS.t146 VSS.n361 1.32961
R896 VSS.t149 VSS.n38 1.32961
R897 VSS.t0 VSS.n95 1.24816
R898 VSS.n307 VSS.t163 1.13974
R899 VSS.t11 VSS.n59 1.13974
R900 VSS.t22 VSS.n71 1.13974
R901 VSS.t45 VSS.n43 1.13974
R902 VSS.t48 VSS.n360 1.13974
R903 vco_var_VSS VSS.n404 0.903417
R904 VSS.n331 VSS.n93 0.776316
R905 VSS.n328 VSS.n93 0.775772
R906 VSS.n262 VSS.t9 0.759994
R907 VSS.n373 VSS.t96 0.57012
R908 VSS.n383 VSS.t98 0.57012
R909 VSS.n370 VSS.t100 0.57012
R910 VSS.t103 VSS.t31 0.57012
R911 VSS.t42 VSS.t155 0.57012
R912 VSS.n389 VSS.t158 0.57012
R913 VSS.n368 VSS.t160 0.57012
R914 VSS.n392 VSS.t162 0.57012
R915 VSS.n403 VSS.n402 0.551994
R916 VSS.n234 VSS.n233 0.513002
R917 VSS.n237 VSS.n74 0.479883
R918 VSS.n228 VSS.n224 0.479883
R919 VSS.n235 VSS.n234 0.411981
R920 VSS.n229 VSS.n225 0.411981
R921 VSS.n379 VSS.t17 0.380247
R922 VSS.t34 VSS.n51 0.380247
R923 VSS.n352 VSS.t41 0.380247
R924 VSS.n364 VSS.t51 0.380247
R925 VSS.n230 VSS.n229 0.370375
R926 VSS.n229 VSS.n228 0.370375
R927 VSS.n228 VSS.n74 0.370375
R928 VSS.n387 VSS.n11 0.50003
R929 VSS.n234 VSS.n226 0.3195
R930 VSS.n230 VSS.n226 0.3195
R931 VSS.t75 VSS.n403 0.264692
R932 VSS.n34 VSS.n33 0.75765
R933 VSS.n33 VSS.n32 0.959389
R934 VSS.t73 VSS.t75 0.252013
R935 VSS.n344 VSS.n74 0.248
R936 VSS.n340 VSS.n339 0.243424
R937 VSS.n199 VSS.n192 0.243424
R938 VSS.n11 VSS.n27 0.404622
R939 VSS.n387 VSS.n25 0.241827
R940 VSS.n342 VSS.n341 0.241769
R941 VSS.n200 VSS.n75 0.241769
R942 VSS.n336 VSS.n335 0.237318
R943 VSS.n310 VSS.n279 0.237318
R944 VSS.n312 VSS.n311 0.234764
R945 VSS.n338 VSS.n337 0.234752
R946 VSS.n334 VSS.n333 0.234686
R947 VSS.n278 VSS.n247 0.234686
R948 VSS.n335 VSS.n334 0.231239
R949 VSS.n279 VSS.n278 0.231239
R950 VSS.n337 VSS.n336 0.229708
R951 VSS.n312 VSS.n310 0.229696
R952 VSS.n333 VSS.n332 0.228745
R953 VSS.n247 VSS.n246 0.228745
R954 VSS.n339 VSS.n338 0.227001
R955 VSS.n311 VSS.n192 0.227001
R956 VSS.n341 VSS.n340 0.223699
R957 VSS.n200 VSS.n199 0.223699
R958 VSS.n328 VSS.n192 0.218846
R959 VSS.n339 VSS.n331 0.218846
R960 VSS.n328 VSS.n279 0.21564
R961 VSS.n335 VSS.n331 0.21564
R962 VSS.n328 VSS.n200 0.208386
R963 VSS.n341 VSS.n331 0.208386
R964 VSS.n328 VSS.n247 0.20534
R965 VSS.n333 VSS.n331 0.20534
R966 VSS.n337 VSS.n331 0.203693
R967 VSS.n328 VSS.n312 0.203693
R968 VSS.n403 VSS.n4 0.197134
R969 VSS.n345 VSS.n36 0.299243
R970 VSS.n227 VSS.n226 0.143127
R971 VSS.n231 VSS.n230 0.143127
R972 VSS.n345 VSS.n32 0.402928
R973 VSS.n402 VSS.n36 0.211243
R974 VSS VSS.n4 0.210343
R975 VSS.n12 VSS.t73 0.202252
R976 VSS.n6 VSS.n2 0.201739
R977 VSS.n20 VSS.n0 0.162986
R978 VSS.n23 VSS.n1 0.0684967
R979 VSS.n14 VSS.n13 0.145251
R980 VSS.n35 VSS.n3 0.136372
R981 VSS.n23 VSS.n13 0.134323
R982 VSS.n22 VSS.n16 0.133313
R983 VSS.n18 VSS.n16 0.117589
R984 VSS.n30 VSS.n28 0.0585658
R985 VSS.n29 VSS.n28 0.116817
R986 VSS.n8 VSS.n7 0.0501977
R987 VSS.n3 VSS.n26 0.116817
R988 VSS.n6 VSS.n5 0.0501977
R989 VSS.n25 VSS.n24 0.116817
R990 VSS.n35 VSS.n27 0.097735
R991 VSS.n22 VSS.n21 0.0937082
R992 VSS.n21 VSS.n15 0.124327
R993 VSS.n24 VSS.n7 0.117555
R994 VSS.n12 VSS.n10 0.113321
R995 VSS.n10 VSS.n9 0.113321
R996 a_11798_1180.n0 a_11798_1180.n4 9.42143
R997 a_11798_1180.n1 a_11798_1180.n12 9.42143
R998 a_11798_1180.n1 a_11798_1180.n5 9.42143
R999 a_11798_1180.n1 a_11798_1180.n6 9.42143
R1000 a_11798_1180.n2 a_11798_1180.n9 9.42143
R1001 a_11798_1180.n2 a_11798_1180.n7 9.42143
R1002 a_11798_1180.n4 a_11798_1180.t15 3.60374
R1003 a_11798_1180.n5 a_11798_1180.t21 3.60255
R1004 a_11798_1180.n6 a_11798_1180.t22 3.60255
R1005 a_11798_1180.n7 a_11798_1180.t28 3.60255
R1006 a_11798_1180.n4 a_11798_1180.t16 3.45423
R1007 a_11798_1180.n13 a_11798_1180.t17 3.45423
R1008 a_11798_1180.n11 a_11798_1180.t19 3.45423
R1009 a_11798_1180.n5 a_11798_1180.t20 3.45423
R1010 a_11798_1180.n12 a_11798_1180.t18 3.45423
R1011 a_11798_1180.n6 a_11798_1180.t23 3.45423
R1012 a_11798_1180.n10 a_11798_1180.t24 3.45423
R1013 a_11798_1180.n8 a_11798_1180.t26 3.45423
R1014 a_11798_1180.n7 a_11798_1180.t27 3.45423
R1015 a_11798_1180.n9 a_11798_1180.t25 3.45423
R1016 a_11798_1180.t14 a_11798_1180.n3 2.61386
R1017 a_11798_1180.n0 a_11798_1180.t0 2.61047
R1018 a_11798_1180.n3 a_11798_1180.t13 2.56233
R1019 a_11798_1180.n1 a_11798_1180.t6 2.5622
R1020 a_11798_1180.n1 a_11798_1180.t5 2.5622
R1021 a_11798_1180.n1 a_11798_1180.t9 2.5622
R1022 a_11798_1180.n1 a_11798_1180.t8 2.56214
R1023 a_11798_1180.n2 a_11798_1180.t10 2.56207
R1024 a_11798_1180.n2 a_11798_1180.t11 2.56174
R1025 a_11798_1180.n0 a_11798_1180.t1 2.56173
R1026 a_11798_1180.n0 a_11798_1180.t2 2.56161
R1027 a_11798_1180.n3 a_11798_1180.t12 2.5616
R1028 a_11798_1180.n1 a_11798_1180.t7 2.5616
R1029 a_11798_1180.n1 a_11798_1180.t4 2.5616
R1030 a_11798_1180.n0 a_11798_1180.t3 2.5616
R1031 a_11798_1180.n2 a_11798_1180.n1 0.245563
R1032 a_11798_1180.n8 a_11798_1180.n7 0.225083
R1033 a_11798_1180.n6 a_11798_1180.n10 0.225083
R1034 a_11798_1180.n11 a_11798_1180.n5 0.225083
R1035 a_11798_1180.n4 a_11798_1180.n13 0.225083
R1036 a_11798_1180.n1 a_11798_1180.n0 0.196551
R1037 a_11798_1180.n13 a_11798_1180.n12 0.1875
R1038 a_11798_1180.n12 a_11798_1180.n11 0.1875
R1039 a_11798_1180.n10 a_11798_1180.n9 0.1875
R1040 a_11798_1180.n9 a_11798_1180.n8 0.1875
R1041 a_11798_1180.n3 a_11798_1180.n2 0.147538
R1042 a_5428_2384.n0 a_5428_2384.t2 36.3628
R1043 a_5428_2384.n0 a_5428_2384.t0 35.246
R1044 a_5428_2384.t1 a_5428_2384.n0 15.3137
R1045 a_1474_1090.n0 a_1474_1090.t0 60.5214
R1046 a_1474_1090.n0 a_1474_1090.t2 33.8343
R1047 a_1474_1090.n1 a_1474_1090.n0 12.0028
R1048 a_1474_1090.t1 a_1474_1090.n1 2.87353
R1049 a_1474_1090.t1 a_1474_1090.n1 2.86853
R1050 a_1954_2820.n0 a_1954_2820.t2 44.3673
R1051 a_1954_2820.n0 a_1954_2820.t1 27.0418
R1052 a_1954_2820.t0 a_1954_2820.n0 12.2034
R1053 a_1254_2820.n0 a_1254_2820.t2 36.0512
R1054 a_1254_2820.n0 a_1254_2820.t3 33.7412
R1055 a_1254_2820.n3 a_1254_2820.t1 26.8072
R1056 a_1254_2820.n1 a_1254_2820.t5 26.0905
R1057 a_1254_2820.n1 a_1254_2820.t4 24.7412
R1058 a_1254_2820.t0 a_1254_2820.n3 12.4381
R1059 a_1254_2820.n3 a_1254_2820.n2 9.512
R1060 a_1254_2820.n2 a_1254_2820.n1 9.0005
R1061 a_1254_2820.n2 a_1254_2820.n0 0.7705
R1062 a_2654_4840.n1 a_2654_4840.t4 36.3944
R1063 a_2654_4840.n0 a_2654_4840.t0 34.4012
R1064 a_2654_4840.n0 a_2654_4840.t3 22.0391
R1065 a_2654_4840.n2 a_2654_4840.n1 9.0005
R1066 a_2654_4840.n2 a_2654_4840.t2 5.84394
R1067 a_2654_4840.t1 a_2654_4840.n2 4.67685
R1068 a_2654_4840.n1 a_2654_4840.n0 0.3173
R1069 vco_bias_0.vbn_buf.n3 vco_bias_0.vbn_buf.t0 55.3125
R1070 vco_bias_0.vbn_buf.n1 vco_bias_0.vbn_buf.t4 34.2391
R1071 vco_bias_0.vbn_buf.n1 vco_bias_0.vbn_buf.t3 28.5544
R1072 vco_bias_0.vbn_buf.n2 vco_bias_0.vbn_buf.n1 23.0981
R1073 vco_bias_0.vbn_buf.n0 vco_bias_0.vbn_buf.t2 21.7736
R1074 vco_bias_0.vbn_buf.n2 vco_bias_0.vbn_buf.t1 21.4968
R1075 vco_bias_0.vbn_buf vco_bias_0.vbn_buf.n0 20.8275
R1076 vco_bias_0.vbn_buf.n3 vco_bias_0.vbn_buf.n2 3.1069
R1077 vco_bias_0.vbn_buf vco_bias_0.vbn_buf.n3 1.2149
R1078 vco_bias_0.vbn_buf.n0 vco_bias_0.vbn_buf 0.1105
C70 vco_ind_LC VSS 2.32648e-14
C71 vtune VSS 3.19352e-15
C72 ibias_100u VSS 2.06688e-15
C73 rf_out_p VSS 1.8492e-15
C74 rf_out_n VSS 1.82405e-15
C75 vco_buf_in_n VSS 5.51288e-15
C76 vco_buf_in_p VSS 5.4881e-15
C77 di_en VSS 7.84682e-16
C78 vco_var_rf_p VSS 1.11584e-14
C79 vco_ind_LA VSS 4.25688e-16
C80 vco_var_rf_n VSS 1.21576e-14
C81 vco_ind_LB VSS 4.24353e-16
C82 VDD VSS 3.20599e-14
C83 vco_bias_0.vbg_buf VSS 1.1187e-13 ; **FLOATING
C84 vco_bias_0.vbn_buf VSS 1.1098e-13 ; **FLOATING
C85 vco_bias_0.vbn_buf.t2 VSS 1.23301e-15 ; **FLOATING
C86 vco_bias_0.vbn_buf.n0 VSS 8.42184e-17 ; **FLOATING
C87 vco_bias_0.vbn_buf.t4 VSS 5.49949e-15 ; **FLOATING
C88 vco_bias_0.vbn_buf.t3 VSS 5.49172e-15 ; **FLOATING
C89 vco_bias_0.vbn_buf.n1 VSS 1.75101e-16 ; **FLOATING
C90 vco_bias_0.vbn_buf.t1 VSS 1.93643e-17 ; **FLOATING
C91 vco_bias_0.vbn_buf.n2 VSS 1.60783e-16 ; **FLOATING
C92 vco_bias_0.vbn_buf.t0 VSS 1.79553e-15 ; **FLOATING
C93 vco_bias_0.vbn_buf.n3 VSS 9.05465e-17 ; **FLOATING
C94 a_2654_4840.t2 VSS 1.31803e-16 ; **FLOATING
C95 a_2654_4840.t4 VSS 3.38124e-16 ; **FLOATING
C96 a_2654_4840.t3 VSS 1.22266e-16 ; **FLOATING
C97 a_2654_4840.t0 VSS 3.22524e-16 ; **FLOATING
C98 a_2654_4840.n0 VSS 4.28718e-16 ; **FLOATING
C99 a_2654_4840.n1 VSS 4.52309e-16 ; **FLOATING
C100 a_2654_4840.n2 VSS 3.52822e-16 ; **FLOATING
C101 a_2654_4840.t1 VSS 2.65094e-16 ; **FLOATING
C102 a_1254_2820.t1 VSS 2.81576e-17 ; **FLOATING
C103 a_1254_2820.t2 VSS 1.37121e-16 ; **FLOATING
C104 a_1254_2820.t3 VSS 1.1242e-16 ; **FLOATING
C105 a_1254_2820.n0 VSS 8.19543e-16 ; **FLOATING
C106 a_1254_2820.t5 VSS 8.60592e-17 ; **FLOATING
C107 a_1254_2820.t4 VSS 6.61387e-17 ; **FLOATING
C108 a_1254_2820.n1 VSS 4.40624e-16 ; **FLOATING
C109 a_1254_2820.n2 VSS 2.17391e-16 ; **FLOATING
C110 a_1254_2820.n3 VSS 4.01172e-16 ; **FLOATING
C111 a_1254_2820.t0 VSS 8.40944e-17 ; **FLOATING
C112 a_1954_2820.t1 VSS 2.30288e-17 ; **FLOATING
C113 a_1954_2820.t2 VSS 1.81055e-16 ; **FLOATING
C114 a_1954_2820.n0 VSS 5.34895e-16 ; **FLOATING
C115 a_1954_2820.t0 VSS 6.20921e-17 ; **FLOATING
C116 a_1474_1090.t2 VSS 4.91664e-16 ; **FLOATING
C117 a_1474_1090.t0 VSS 1.79538e-15 ; **FLOATING
C118 a_1474_1090.n0 VSS 1.71299e-15 ; **FLOATING
C119 a_1474_1090.n1 VSS 3.25663e-16 ; **FLOATING
C120 a_1474_1090.t1 VSS 2.19516e-16 ; **FLOATING
C121 a_5428_2384.t2 VSS 6.43399e-16 ; **FLOATING
C122 a_5428_2384.t0 VSS 3.19636e-16 ; **FLOATING
C123 a_5428_2384.n0 VSS 1.12422e-15 ; **FLOATING
C124 a_5428_2384.t1 VSS 3.66936e-16 ; **FLOATING
C125 a_11798_1180.n0 VSS 1.47185e-15 ; **FLOATING
C126 a_11798_1180.n1 VSS 2.53504e-15 ; **FLOATING
C127 a_11798_1180.n2 VSS 1.0342e-15 ; **FLOATING
C128 a_11798_1180.n3 VSS 9.74605e-16 ; **FLOATING
C129 a_11798_1180.n4 VSS 1.02142e-16 ; **FLOATING
C130 a_11798_1180.n5 VSS 1.02142e-16 ; **FLOATING
C131 a_11798_1180.n6 VSS 1.02142e-16 ; **FLOATING
C132 a_11798_1180.n7 VSS 1.02142e-16 ; **FLOATING
C133 a_11798_1180.t28 VSS 4.79678e-17 ; **FLOATING
C134 a_11798_1180.t25 VSS 5.1338e-17 ; **FLOATING
C135 a_11798_1180.t26 VSS 5.1338e-17 ; **FLOATING
C136 a_11798_1180.t27 VSS 5.1338e-17 ; **FLOATING
C137 a_11798_1180.n8 VSS 5.73399e-17 ; **FLOATING
C138 a_11798_1180.n9 VSS 6.00109e-17 ; **FLOATING
C139 a_11798_1180.t23 VSS 5.1338e-17 ; **FLOATING
C140 a_11798_1180.t24 VSS 5.1338e-17 ; **FLOATING
C141 a_11798_1180.n10 VSS 5.73399e-17 ; **FLOATING
C142 a_11798_1180.t22 VSS 4.79678e-17 ; **FLOATING
C143 a_11798_1180.t21 VSS 4.79678e-17 ; **FLOATING
C144 a_11798_1180.t18 VSS 5.1338e-17 ; **FLOATING
C145 a_11798_1180.t19 VSS 5.1338e-17 ; **FLOATING
C146 a_11798_1180.t20 VSS 5.1338e-17 ; **FLOATING
C147 a_11798_1180.n11 VSS 5.73399e-17 ; **FLOATING
C148 a_11798_1180.n12 VSS 6.00109e-17 ; **FLOATING
C149 a_11798_1180.t16 VSS 5.1338e-17 ; **FLOATING
C150 a_11798_1180.t17 VSS 5.1338e-17 ; **FLOATING
C151 a_11798_1180.n13 VSS 5.73399e-17 ; **FLOATING
C152 a_11798_1180.t15 VSS 4.79757e-17 ; **FLOATING
C153 a_11798_1180.t0 VSS 1.54697e-16 ; **FLOATING
C154 a_11798_1180.t1 VSS 1.5051e-16 ; **FLOATING
C155 a_11798_1180.t2 VSS 1.5051e-16 ; **FLOATING
C156 a_11798_1180.t3 VSS 1.5051e-16 ; **FLOATING
C157 a_11798_1180.t4 VSS 1.5051e-16 ; **FLOATING
C158 a_11798_1180.t5 VSS 1.50502e-16 ; **FLOATING
C159 a_11798_1180.t6 VSS 1.50502e-16 ; **FLOATING
C160 a_11798_1180.t7 VSS 1.5051e-16 ; **FLOATING
C161 a_11798_1180.t8 VSS 1.50502e-16 ; **FLOATING
C162 a_11798_1180.t9 VSS 1.50502e-16 ; **FLOATING
C163 a_11798_1180.t10 VSS 1.50502e-16 ; **FLOATING
C164 a_11798_1180.t11 VSS 1.5051e-16 ; **FLOATING
C165 a_11798_1180.t12 VSS 1.5051e-16 ; **FLOATING
C166 a_11798_1180.t13 VSS 1.50502e-16 ; **FLOATING
C167 a_11798_1180.t14 VSS 1.54666e-16 ; **FLOATING
C168 VDD.t7 VSS 1.59232e-16 ; **FLOATING
C169 VDD.t8 VSS 2.59891e-17 ; **FLOATING
C170 VDD.n0 VSS 8.91257e-17 ; **FLOATING
C171 VDD.t4 VSS 1.59232e-16 ; **FLOATING
C172 VDD.t5 VSS 2.59891e-17 ; **FLOATING
C173 VDD.n1 VSS 3.28424e-17 ; **FLOATING
C174 VDD.n2 VSS 9.91682e-17 ; **FLOATING
C175 VDD.t2 VSS 5.59169e-17 ; **FLOATING
C176 VDD.n3 VSS 4.10696e-17 ; **FLOATING
C177 VDD.n4 VSS 7.49695e-17 ; **FLOATING
C178 VDD.t0 VSS 5.59169e-17 ; **FLOATING
C179 VDD.n5 VSS 4.10696e-17 ; **FLOATING
C180 VDD.n6 VSS 5.78072e-17 ; **FLOATING
C181 VDD.t10 VSS 5.59169e-17 ; **FLOATING
C182 VDD.n7 VSS 4.10696e-17 ; **FLOATING
C183 VDD.n8 VSS 1.26223e-16 ; **FLOATING
C184 VDD.t6 VSS 9.93315e-16 ; **FLOATING
C185 VDD.t9 VSS 7.14563e-16 ; **FLOATING
C186 VDD.n9 VSS 7.44824e-16 ; **FLOATING
C187 vco_var_rf_n.n0 VSS 9.8177e-17 ; **FLOATING
C188 vco_var_rf_n.n1 VSS 2.04739e-17 ; **FLOATING
C189 vco_var_rf_n.n2 VSS 2.98595e-16 ; **FLOATING
C190 vco_var_rf_n.n3 VSS 4.67625e-16 ; **FLOATING
C191 vco_var_rf_n.t7 VSS 2.88619e-16 ; **FLOATING
C192 vco_var_rf_n.n4 VSS 3.63312e-16 ; **FLOATING
C193 vco_var_rf_n.t1 VSS 1.14703e-17 ; **FLOATING
C194 vco_var_rf_n.t0 VSS 1.14703e-17 ; **FLOATING
C195 vco_var_rf_n.t2 VSS 1.15586e-17 ; **FLOATING
C196 vco_var_rf_n.t3 VSS 1.18236e-17 ; **FLOATING
C197 vco_var_rf_n.t4 VSS 1.14703e-17 ; **FLOATING
C198 vco_var_rf_n.t5 VSS 1.76976e-15 ; **FLOATING
C199 vco_var_rf_n.n5 VSS 1.19747e-15 ; **FLOATING
C200 vco_var_rf_p.n0 VSS 9.81183e-17 ; **FLOATING
C201 vco_var_rf_p.n1 VSS 2.04595e-17 ; **FLOATING
C202 vco_var_rf_p.n2 VSS 3.06145e-16 ; **FLOATING
C203 vco_var_rf_p.n3 VSS 4.67209e-16 ; **FLOATING
C204 vco_var_rf_p.n4 VSS 3.94259e-16 ; **FLOATING
C205 vco_var_rf_p.t7 VSS 1.98432e-16 ; **FLOATING
C206 vco_var_rf_p.t2 VSS 1.18168e-17 ; **FLOATING
C207 vco_var_rf_p.t0 VSS 1.14597e-17 ; **FLOATING
C208 vco_var_rf_p.t1 VSS 1.15523e-17 ; **FLOATING
C209 vco_var_rf_p.t4 VSS 1.14597e-17 ; **FLOATING
C210 vco_var_rf_p.t3 VSS 1.14597e-17 ; **FLOATING
C211 vco_var_rf_p.t5 VSS 1.76087e-15 ; **FLOATING
C212 vco_var_rf_p.n5 VSS 1.2608e-15 ; **FLOATING
C213 di_en.t1 VSS 4.84273e-17 ; **FLOATING
C214 di_en.t0 VSS 3.53876e-17 ; **FLOATING
C215 di_en.n0 VSS 2.48433e-16 ; **FLOATING
C216 vco_buf_in_p.t0 VSS 3.27077e-16 ; **FLOATING
C217 vco_buf_in_p.t1 VSS 1.18723e-16 ; **FLOATING
C218 vco_buf_in_p.n0 VSS 3.14045e-16 ; **FLOATING
C219 vco_buf_in_n.t0 VSS 3.3477e-16 ; **FLOATING
C220 vco_buf_in_n.t1 VSS 1.1857e-16 ; **FLOATING
C221 vco_buf_in_n.n0 VSS 3.12735e-16 ; **FLOATING
C222 rf_out_n.n0 VSS 3.06775e-16 ; **FLOATING
C223 rf_out_n.n1 VSS 3.7997e-16 ; **FLOATING
C224 rf_out_n.t6 VSS 7.85037e-16 ; **FLOATING
C225 rf_out_n.t2 VSS 4.93034e-17 ; **FLOATING
C226 rf_out_n.t5 VSS 4.85737e-17 ; **FLOATING
C227 rf_out_n.t3 VSS 4.85737e-17 ; **FLOATING
C228 rf_out_n.t1 VSS 4.85737e-17 ; **FLOATING
C229 rf_out_n.t0 VSS 4.85737e-17 ; **FLOATING
C230 rf_out_n.t4 VSS 4.85737e-17 ; **FLOATING
C231 rf_out_n.n2 VSS 3.40349e-16 ; **FLOATING
C232 rf_out_p.n0 VSS 4.23195e-16 ; **FLOATING
C233 rf_out_p.n1 VSS 2.63693e-16 ; **FLOATING
C234 rf_out_p.t0 VSS 7.89114e-16 ; **FLOATING
C235 rf_out_p.t3 VSS 4.93098e-17 ; **FLOATING
C236 rf_out_p.t4 VSS 4.85831e-17 ; **FLOATING
C237 rf_out_p.t5 VSS 4.85831e-17 ; **FLOATING
C238 rf_out_p.t6 VSS 4.85831e-17 ; **FLOATING
C239 rf_out_p.t1 VSS 4.85831e-17 ; **FLOATING
C240 rf_out_p.t2 VSS 4.85831e-17 ; **FLOATING
C241 rf_out_p.n2 VSS 3.40413e-16 ; **FLOATING
C242 ibias_100u.t4 VSS 1.50584e-16 ; **FLOATING
C243 ibias_100u.t2 VSS 1.58812e-16 ; **FLOATING
C244 ibias_100u.n0 VSS 1.93817e-16 ; **FLOATING
C245 ibias_100u.t1 VSS 1.49167e-16 ; **FLOATING
C246 ibias_100u.n1 VSS 1.23443e-16 ; **FLOATING
C247 ibias_100u.t0 VSS 7.37141e-17 ; **FLOATING
C248 ibias_100u.n2 VSS 1.81469e-16 ; **FLOATING
C249 ibias_100u.t3 VSS 1.44896e-15 ; **FLOATING
C250 ibias_100u.n3 VSS 3.54853e-16 ; **FLOATING
Rpexcapstie0 vdd_core vco_ind_LC 1m
Cpexcaps0 a_1474_1090.n0 a_1560_1090# 3.72e-17
Cpexcaps1 a_1254_2820.n0 a_2654_4840.n0 1.1994e-16
Cpexcaps2 a_1474_1090.n0 vco_bias_0.vbg_buf 5.415e-17
Cpexcaps3 a_5428_2384.n0 vco_bias_0.vbn_buf 1.02459e-15
Cpexcaps4 a_1254_2820.n0 di_en 3.0274e-16
Cpexcaps5 a_1254_2820.n0 a_1954_2820.n0 5.4548e-16
Cpexcaps6 a_11798_1180.n0 rf_out_p 2.53404e-15
Cpexcaps7 VDD a_2654_4840.n0 1.26593e-15
Cpexcaps8 a_1474_1090.n0 a_2654_4840.n0 1.27583e-15
Cpexcaps9 a_11798_1180.n0 rf_out_n 2.53404e-15
Cpexcaps10 VDD a_1954_2820.n0 2.2541e-16
Cpexcaps11 a_1474_1090.n0 a_1954_2820.n0 1.065e-16
Cpexcaps12 a_2654_4840.n0 vco_bias_0.vbg_buf 2.237e-16
Cpexcaps13 a_1954_2820.n0 vco_bias_0.vbg_buf 9.651e-17
Cpexcaps14 a_1474_1090.n0 a_6760_4250# 3.091e-17
Cpexcaps15 a_1954_2820.n0 a_2654_4840.n0 1.5878e-16
Cpexcaps16 a_1254_2820.n0 vco_bias_0.vbn_buf 1.8509e-16
Cpexcaps17 a_1474_1090.n0 vco_bias_0.vbn_buf 4.0649e-16
Cpexcaps18 a_11798_1180.n0 vco_bias_0.vbn_buf 6.04922e-15
Cpexcaps19 a_11798_1180.n0 vtune 3.5675e-16
Cpexcaps20 a_2654_4840.n0 vco_bias_0.vbn_buf 2.7632e-16
Cpexcaps21 a_11798_1180.n0 vco_buf_in_p 4.0108e-16
Cpexcaps22 a_1954_2820.n0 vco_bias_0.vbn_buf 8.551e-17
Cpexcaps23 a_1474_1090.n0 a_5428_2384.n0 5.624e-16
Cpexcaps24 a_5428_2384.n0 vco_bias_0.vbg_buf 5.904e-17
Cpexcaps25 a_1160_1390# a_1474_1090.n0 2.451e-17
Cpexcaps26 a_1254_2820.n0 ibias_100u 6.2359e-16
Cpexcaps27 a_11798_1180.n0 vco_buf_in_n 4.0108e-16
Cpexcaps28 a_2654_4840.n0 a_5428_2384.n0 1.6582e-16
Cpexcaps29 a_1474_1090.n0 ibias_100u 3.3078e-16
Cpexcaps30 a_5428_2384.n0 a_6760_4250# 6.042e-17
Cpexcaps31 VDD a_1254_2820.n0 2.2664e-16
Cpexcaps32 a_1254_2820.n0 a_1474_1090.n0 1.616e-16
Cpexcaps33 a_2654_4840.n0 ibias_100u 5.5444e-16
Cpexcaps34 VDD a_1474_1090.n0 2.7203e-16
Cpexcaps35 a_1254_2820.n0 vco_bias_0.vbg_buf 1.0523e-16
Cpexcaps36 VDD a_11798_1180.n0 1.2738e-16
Cpexcaps37 a_1954_2820.n0 ibias_100u 2.7709e-16
.ends

* Capacitances rebuilt per net pair from the C-coupled extraction vco_top_leads_CC.spice (magic#557):
* 0.4446 pF in 137 net pairs, the full-RC run had 0.5139 pF, 0.0 fF of it between pairs without coupling.
* NGSPICE file created from vco_top_leads.ext - technology: ihp-sg13g2

.subckt vco_top_leads ibias_100u di_en vtune VDD vdd_core VSS rf_out_p rf_out_n
+ vco_ind_LA vco_ind_LB vco_ind_LC vco_var_rf_p vco_var_rf_n vco_var_VSS
X0 VSS.t83 vco_var_rf_p.t7 vco_var_rf_n.t1 VSS.t82 sg13_lv_nmos ad=0.68p pd=4.68u as=0.38p ps=2.38u w=2u l=0.13u
X1 VSS.t117 vco_var_rf_n.t7 vco_var_rf_p.t3 VSS.t116 sg13_lv_nmos ad=0.68p pd=4.68u as=0.38p ps=2.38u w=2u l=0.13u
X2 VSS.t63 VSS.t60 VSS.t62 VSS.t61 sg13_lv_nmos ad=0.85p pd=5.68u as=0 ps=0 w=2.5u l=0.5u
X3 rf_out_n.t0 vco_buf_in_p.t1 a_11798_1180.t26 VSS.t176 sg13_lv_nmos ad=0.38p pd=2.38u as=0.38p ps=2.38u w=2u l=0.13u
X4 rf_out_n.t4 vco_buf_in_p.t1 a_11798_1180.t24 VSS.t172 sg13_lv_nmos ad=0.38p pd=2.38u as=0.38p ps=2.38u w=2u l=0.13u
X5 VSS.t131 vco_bias_0.vbn_buf.t2 a_11798_1180.t19 VSS.t130 sg13_lv_nmos ad=0.95p pd=5.38u as=0.95p ps=5.38u w=5u l=0.5u
X6 a_11798_1180.t17 vco_bias_0.vbn_buf.t2 VSS.t154 VSS.t155 sg13_lv_nmos ad=0.95p pd=5.38u as=0.95p ps=5.38u w=5u l=0.5u
X7 a_11798_1180.t7 vco_bias_0.vbn_buf.t2 VSS.t123 VSS.t122 sg13_lv_nmos ad=0.95p pd=5.38u as=1.7p ps=10.68u w=5u l=0.5u
X8 VSS.t4 vco_bias_0.vbn_buf.t3 VSS.t2 VSS.t3 sg13_lv_nmos ad=1.52p pd=8.38u as=0 ps=0 w=8u l=10u
X9 ibias_100u.t3 ibias_100u.t2 VSS.t121 VSS.t120 sg13_lv_nmos ad=0.85p pd=5.68u as=0.85p ps=5.68u w=2.5u l=0.5u
X10 VSS.t8 vco_bias_0.vbn_buf.t3 VSS.t6 VSS.t7 sg13_lv_nmos ad=1.52p pd=8.38u as=0 ps=0 w=8u l=10u
X11 VSS.t140 vco_bias_0.vbn_buf.t2 a_11798_1180.t10 VSS.t139 sg13_lv_nmos ad=0.95p pd=5.38u as=0.95p ps=5.38u w=5u l=0.5u
X12 VSS.t77 vco_var_rf_p.t7 vco_var_rf_n.t3 VSS.t76 sg13_lv_nmos ad=0.38p pd=2.38u as=0.38p ps=2.38u w=2u l=0.13u
X13 a_11798_1180.t2 vco_buf_in_n.t1 rf_out_p.t3 VSS.t88 sg13_lv_nmos ad=0.38p pd=2.38u as=0.38p ps=2.38u w=2u l=0.13u
X14 vco_bias_0.vbn_buf.t1 a_5905_4552.t2 VSS.t28 VSS.t27 sg13_lv_nmos ad=0.34p pd=2.68u as=0.34p ps=2.68u w=1u l=0.13u
X15 VSS.t22 vco_bias_0.vbn_buf.t4 VSS.t20 VSS.t5 sg13_lv_nmos ad=1.52p pd=8.38u as=0 ps=0 w=8u l=10u
X16 rf_out_p.t4 vco_buf_in_n.t1 a_11798_1180.t0 VSS.t85 sg13_lv_nmos ad=0.38p pd=2.38u as=0.68p ps=4.68u w=2u l=0.13u
X17 a_5948_4416.t1 a_5905_4552.t5 VDD.t3 VDD.t0 sg13_lv_pmos ad=0.34p pd=2.68u as=0.34p ps=2.68u w=1u l=0.13u
X18 VSS.t35 vco_bias_0.vbg_buf VSS.t34 VSS.t0 sg13_lv_nmos ad=2.72p pd=16.68u as=0 ps=0 w=8u l=10u
X19 VSS.t51 vco_bias_0.vbg_buf VSS.t49 VSS.t7 sg13_lv_nmos ad=1.52p pd=8.38u as=0 ps=0 w=8u l=10u
X20 ibias_100u.t0 a_5905_4552.t3 VSS.t14 VSS.t13 sg13_lv_nmos ad=0.34p pd=2.68u as=0.34p ps=2.68u w=1u l=0.13u
X21 a_5560_5708.t1 a_5560_3922.t0 VSS.t84 rppd l=8.5u w=0.5u
X22 VSS.t108 vco_var_rf_n.t7 vco_var_rf_p.t0 VSS.t107 sg13_lv_nmos ad=0.38p pd=2.38u as=0.38p ps=2.38u w=2u l=0.13u
X23 vco_var_rf_n.t4 vco_var_rf_p.t7 VSS.t77 VSS.t78 sg13_lv_nmos ad=0.38p pd=2.38u as=0.38p ps=2.38u w=2u l=0.13u
X24 vco_var_rf_n.t2 vco_var_rf_p.t7 VSS.t71 VSS.t72 sg13_lv_nmos ad=0.38p pd=2.38u as=0.38p ps=2.38u w=2u l=0.13u
X25 vco_bias_0.vbg_buf a_5560_5708.t2 VSS.t101 rhigh l=32u w=0.5u
X26 vco_var_rf_p.t2 vco_var_rf_n.t7 VSS.t111 VSS.t112 sg13_lv_nmos ad=0.38p pd=2.38u as=0.38p ps=2.38u w=2u l=0.13u
X27 a_5905_4552.t1 di_en.t0 VSS.t66 VSS.t65 sg13_lv_nmos ad=0.17p pd=1.68u as=0.17p ps=1.68u w=0.5u l=0.13u
X28 a_11798_1180.t5 vco_buf_in_n.t1 rf_out_p.t2 VSS.t94 sg13_lv_nmos ad=0.38p pd=2.38u as=0.38p ps=2.38u w=2u l=0.13u
X29 VSS.t154 vco_bias_0.vbn_buf.t2 a_11798_1180.t16 VSS.t153 sg13_lv_nmos ad=0.95p pd=5.38u as=0.95p ps=5.38u w=5u l=0.5u
X30 VSS.t49 vco_bias_0.vbg_buf VSS.t47 VSS.t5 sg13_lv_nmos ad=1.52p pd=8.38u as=0 ps=0 w=8u l=10u
X31 vco_bias_0.vbg_buf VSS.t30 cap_cmim l=19.1u w=19.5u
X32 VSS.t125 vco_bias_0.vbn_buf.t2 a_11798_1180.t7 VSS.t124 sg13_lv_nmos ad=0.95p pd=5.38u as=0.95p ps=5.38u w=5u l=0.5u
X33 a_11798_1180.t20 vco_bias_0.vbn_buf.t2 VSS.t131 VSS.t162 sg13_lv_nmos ad=0.95p pd=5.38u as=0.95p ps=5.38u w=5u l=0.5u
X34 vco_bias_0.vbn_buf.t0 ibias_100u.t1 VSS.t64 rhigh l=32u w=0.5u
X35 a_11798_1180.t21 vco_bias_0.vbn_buf.t2 VSS.t164 VSS.t165 sg13_lv_nmos ad=0.95p pd=5.38u as=0.95p ps=5.38u w=5u l=0.5u
X36 VSS.t6 vco_bias_0.vbn_buf.t3 VSS.t4 VSS.t5 sg13_lv_nmos ad=1.52p pd=8.38u as=0 ps=0 w=8u l=10u
X37 a_11798_1180.t27 vco_buf_in_p.t1 rf_out_n.t0 VSS.t177 sg13_lv_nmos ad=0.38p pd=2.38u as=0.38p ps=2.38u w=2u l=0.13u
X38 a_11798_1180.t11 vco_bias_0.vbn_buf.t2 VSS.t140 VSS.t141 sg13_lv_nmos ad=0.95p pd=5.38u as=0.95p ps=5.38u w=5u l=0.5u
X39 a_11798_1180.t25 vco_buf_in_p.t1 rf_out_n.t4 VSS.t173 sg13_lv_nmos ad=0.38p pd=2.38u as=0.38p ps=2.38u w=2u l=0.13u
X40 VSS.t150 vco_bias_0.vbn_buf.t2 a_11798_1180.t14 VSS.t151 sg13_lv_nmos ad=0.95p pd=5.38u as=0.95p ps=5.38u w=5u l=0.5u
X41 VSS.t37 vco_bias_0.vbg_buf VSS.t35 VSS.t3 sg13_lv_nmos ad=1.52p pd=8.38u as=0 ps=0 w=8u l=10u
X42 VSS.t53 vco_bias_0.vbg_buf VSS.t51 VSS.t9 sg13_lv_nmos ad=1.52p pd=8.38u as=0 ps=0 w=8u l=10u
X43 VDD.t13 VDD.t11 VDD.t12 VDD.t0 sg13_lv_pmos ad=1.7p pd=10.68u as=0 ps=0 w=5u l=0.5u
X44 VSS.t164 vco_bias_0.vbn_buf.t2 a_11798_1180.t20 VSS.t163 sg13_lv_nmos ad=0.95p pd=5.38u as=0.95p ps=5.38u w=5u l=0.5u
X45 VSS.t80 vco_var_rf_p.t7 vco_var_rf_n.t4 VSS.t79 sg13_lv_nmos ad=0.38p pd=2.38u as=0.38p ps=2.38u w=2u l=0.13u
X46 VSS.t167 vco_bias_0.vbn_buf.t2 a_11798_1180.t21 VSS.t166 sg13_lv_nmos ad=1.7p pd=10.68u as=0.95p ps=5.38u w=5u l=0.5u
X47 VSS.t18 vco_bias_0.vbn_buf.t4 VSS.t17 VSS.t0 sg13_lv_nmos ad=2.72p pd=16.68u as=0 ps=0 w=8u l=10u
X48 VSS.t114 vco_var_rf_n.t7 vco_var_rf_p.t2 VSS.t113 sg13_lv_nmos ad=0.38p pd=2.38u as=0.38p ps=2.38u w=2u l=0.13u
X49 VDD.t17 rf_out_p.t6 VSS.t29 rppd l=1.65u w=10u
X50 VDD.t7 VDD.t5 VDD.t6 VDD.t0 sg13_lv_pmos ad=0.34p pd=2.68u as=0 ps=0 w=1u l=0.13u
X51 VDD.t10 VDD.t8 VDD.t9 VDD.t0 sg13_lv_pmos ad=1.7p pd=10.68u as=0 ps=0 w=5u l=0.5u
X52 a_6568_6136.t0 a_5948_4416.t2 VDD.t4 VDD.t0 sg13_lv_pmos ad=0.34p pd=2.68u as=0.34p ps=2.68u w=1u l=0.13u
X53 rf_out_p.t5 vco_buf_in_n.t1 a_11798_1180.t5 VSS.t95 sg13_lv_nmos ad=0.38p pd=2.38u as=0.38p ps=2.38u w=2u l=0.13u
X54 a_5905_4552.t0 di_en.t1 VDD.t19 VDD.t0 sg13_lv_pmos ad=0.34p pd=2.68u as=0.34p ps=2.68u w=1u l=0.13u
X55 a_11798_1180.t14 vco_bias_0.vbn_buf.t2 VSS.t147 VSS.t148 sg13_lv_nmos ad=0.95p pd=5.38u as=0.95p ps=5.38u w=5u l=0.5u
X56 rf_out_p.t1 vco_buf_in_n.t1 a_11798_1180.t3 VSS.t91 sg13_lv_nmos ad=0.38p pd=2.38u as=0.38p ps=2.38u w=2u l=0.13u
X57 VSS.t26 vco_bias_0.vbn_buf.t4 VSS.t24 VSS.t9 sg13_lv_nmos ad=1.52p pd=8.38u as=0 ps=0 w=8u l=10u
X58 vco_var_rf_p.t1 vco_var_rf_n.t7 VSS.t108 VSS.t109 sg13_lv_nmos ad=0.38p pd=2.38u as=0.38p ps=2.38u w=2u l=0.13u
X59 VSS.t157 vco_bias_0.vbn_buf.t2 a_11798_1180.t17 VSS.t156 sg13_lv_nmos ad=0.95p pd=5.38u as=0.95p ps=5.38u w=5u l=0.5u
X60 a_11798_1180.t15 vco_bias_0.vbn_buf.t2 VSS.t150 VSS.t149 sg13_lv_nmos ad=0.95p pd=5.38u as=0.95p ps=5.38u w=5u l=0.5u
X61 vco_var_rf_p.t4 vco_var_rf_n.t7 VSS.t103 VSS.t102 sg13_lv_nmos ad=0.38p pd=2.38u as=0.68p ps=4.68u w=2u l=0.13u
X62 VSS.t159 vco_bias_0.vbn_buf.t2 a_11798_1180.t18 VSS.t161 sg13_lv_nmos ad=0.95p pd=5.38u as=0.95p ps=5.38u w=5u l=0.5u
X63 VSS.t74 vco_var_rf_p.t7 vco_var_rf_n.t2 VSS.t73 sg13_lv_nmos ad=0.38p pd=2.38u as=0.38p ps=2.38u w=2u l=0.13u
X64 rf_out_n.t2 vco_buf_in_p.t1 a_11798_1180.t22 VSS.t168 sg13_lv_nmos ad=0.38p pd=2.38u as=0.68p ps=4.68u w=2u l=0.13u
X65 a_5560_5708.t0 a_6568_6136.t4 VDD.t2 VDD.t0 sg13_lv_pmos ad=1.7p pd=10.68u as=1.7p ps=10.68u w=5u l=0.5u
X66 VSS.t105 vco_var_rf_n.t7 vco_var_rf_p.t4 VSS.t104 sg13_lv_nmos ad=0.38p pd=2.38u as=0.38p ps=2.38u w=2u l=0.13u
X67 VSS.t2 vco_bias_0.vbn_buf.t3 VSS.t1 VSS.t0 sg13_lv_nmos ad=2.72p pd=16.68u as=0 ps=0 w=8u l=10u
X68 rf_out_n.t1 vco_buf_in_p.t1 a_11798_1180.t27 VSS.t178 sg13_lv_nmos ad=0.38p pd=2.38u as=0.38p ps=2.38u w=2u l=0.13u
X69 rf_out_n.t5 vco_buf_in_p.t1 a_11798_1180.t25 VSS.t174 sg13_lv_nmos ad=0.38p pd=2.38u as=0.38p ps=2.38u w=2u l=0.13u
X70 VSS.t45 vco_bias_0.vbg_buf VSS.t44 VSS.t0 sg13_lv_nmos ad=2.72p pd=16.68u as=0 ps=0 w=8u l=10u
X71 VSS.t128 vco_bias_0.vbn_buf.t2 a_11798_1180.t8 VSS.t127 sg13_lv_nmos ad=0.95p pd=5.38u as=0.95p ps=5.38u w=5u l=0.5u
X72 a_11798_1180.t12 vco_bias_0.vbn_buf.t2 VSS.t143 VSS.t144 sg13_lv_nmos ad=0.95p pd=5.38u as=0.95p ps=5.38u w=5u l=0.5u
X73 a_11798_1180.t18 vco_bias_0.vbn_buf.t2 VSS.t157 VSS.t160 sg13_lv_nmos ad=0.95p pd=5.38u as=0.95p ps=5.38u w=5u l=0.5u
X74 a_11798_1180.t19 vco_bias_0.vbn_buf.t2 VSS.t159 VSS.t158 sg13_lv_nmos ad=0.95p pd=5.38u as=0.95p ps=5.38u w=5u l=0.5u
X75 vco_buf_in_p vco_var_rf_p.t5 cap_cmim l=10u w=10u
X76 a_11798_1180.t1 vco_buf_in_n.t1 rf_out_p.t4 VSS.t86 sg13_lv_nmos ad=0.38p pd=2.38u as=0.38p ps=2.38u w=2u l=0.13u
X77 VSS.t10 vco_bias_0.vbn_buf.t3 VSS.t8 VSS.t9 sg13_lv_nmos ad=1.52p pd=8.38u as=0 ps=0 w=8u l=10u
X78 VSS.t59 VSS.t56 VSS.t58 VSS.t57 sg13_lv_nmos ad=0.85p pd=5.68u as=0 ps=0 w=2.5u l=0.5u
X79 vco_var_rf_n.t1 vco_var_rf_p.t7 VSS.t80 VSS.t81 sg13_lv_nmos ad=0.38p pd=2.38u as=0.38p ps=2.38u w=2u l=0.13u
X80 vco_var_rf_p.t3 vco_var_rf_n.t7 VSS.t114 VSS.t115 sg13_lv_nmos ad=0.38p pd=2.38u as=0.38p ps=2.38u w=2u l=0.13u
X81 a_11798_1180.t8 vco_bias_0.vbn_buf.t2 VSS.t125 VSS.t126 sg13_lv_nmos ad=0.95p pd=5.38u as=0.95p ps=5.38u w=5u l=0.5u
X82 VSS.t143 vco_bias_0.vbn_buf.t2 a_11798_1180.t11 VSS.t142 sg13_lv_nmos ad=0.95p pd=5.38u as=0.95p ps=5.38u w=5u l=0.5u
X83 a_11798_1180.t9 vco_bias_0.vbn_buf.t2 VSS.t128 VSS.t129 sg13_lv_nmos ad=0.95p pd=5.38u as=0.95p ps=5.38u w=5u l=0.5u
X84 a_11798_1180.t4 vco_buf_in_n.t1 rf_out_p.t1 VSS.t92 sg13_lv_nmos ad=0.38p pd=2.38u as=0.38p ps=2.38u w=2u l=0.13u
X85 rf_out_p.t0 vco_buf_in_n.t1 a_11798_1180.t2 VSS.t89 sg13_lv_nmos ad=0.38p pd=2.38u as=0.38p ps=2.38u w=2u l=0.13u
X86 VDD.t16 VDD.t14 VDD.t15 VDD.t0 sg13_lv_pmos ad=1.7p pd=10.68u as=0 ps=0 w=5u l=0.5u
X87 VSS.t41 vco_bias_0.vbg_buf VSS.t39 VSS.t7 sg13_lv_nmos ad=1.52p pd=8.38u as=0 ps=0 w=8u l=10u
X88 vco_buf_in_n vco_var_rf_n.t5 cap_cmim l=10u w=10u
X89 VSS.t135 vco_bias_0.vbn_buf.t2 a_11798_1180.t12 VSS.t134 sg13_lv_nmos ad=0.95p pd=5.38u as=0.95p ps=5.38u w=5u l=0.5u
X90 a_11798_1180.t16 vco_bias_0.vbn_buf.t2 VSS.t137 VSS.t136 sg13_lv_nmos ad=0.95p pd=5.38u as=0.95p ps=5.38u w=5u l=0.5u
X91 a_11798_1180.t23 vco_buf_in_p.t1 rf_out_n.t2 VSS.t169 sg13_lv_nmos ad=0.38p pd=2.38u as=0.38p ps=2.38u w=2u l=0.13u
X92 a_5560_3922.t2 a_5560_3922.t1 VSS.t12 VSS.t11 sg13_lv_nmos ad=0.85p pd=5.68u as=0.85p ps=5.68u w=2.5u l=0.5u
X93 VSS.t47 vco_bias_0.vbg_buf VSS.t45 VSS.t3 sg13_lv_nmos ad=1.52p pd=8.38u as=0 ps=0 w=8u l=10u
X94 VSS.t39 vco_bias_0.vbg_buf VSS.t37 VSS.t5 sg13_lv_nmos ad=1.52p pd=8.38u as=0 ps=0 w=8u l=10u
X95 VSS.t111 vco_var_rf_n.t7 vco_var_rf_p.t1 VSS.t110 sg13_lv_nmos ad=0.38p pd=2.38u as=0.38p ps=2.38u w=2u l=0.13u
X96 a_6568_6136.t2 a_6568_6136.t1 VDD.t1 VDD.t0 sg13_lv_pmos ad=1.7p pd=10.68u as=1.7p ps=10.68u w=5u l=0.5u
X97 vco_var_rf_n.t3 vco_var_rf_p.t7 VSS.t74 VSS.t75 sg13_lv_nmos ad=0.38p pd=2.38u as=0.38p ps=2.38u w=2u l=0.13u
X98 a_11798_1180.t28 vco_buf_in_p.t1 rf_out_n.t1 VSS.t179 sg13_lv_nmos ad=0.68p pd=4.68u as=0.38p ps=2.38u w=2u l=0.13u
X99 vco_var_rf_n.t0 vco_var_rf_p.t7 VSS.t69 VSS.t68 sg13_lv_nmos ad=0.38p pd=2.38u as=0.68p ps=4.68u w=2u l=0.13u
X100 vco_ind_LC VSS.t97 cap_cmim l=39u w=56u
X101 a_11798_1180.t26 vco_buf_in_p.t1 rf_out_n.t5 VSS.t175 sg13_lv_nmos ad=0.38p pd=2.38u as=0.38p ps=2.38u w=2u l=0.13u
X102 a_11798_1180.t24 vco_buf_in_p.t1 rf_out_n.t3 VSS.t171 sg13_lv_nmos ad=0.38p pd=2.38u as=0.38p ps=2.38u w=2u l=0.13u
X103 VSS.t133 vco_bias_0.vbn_buf.t2 a_11798_1180.t9 VSS.t138 sg13_lv_nmos ad=0.95p pd=5.38u as=0.95p ps=5.38u w=5u l=0.5u
X104 vco_bias_0.vbg_buf vco_buf_in_n.t0 VSS.t67 rhigh l=8u w=0.5u
X105 a_6568_6136.t3 ibias_100u.t4 VSS.t119 VSS.t118 sg13_lv_nmos ad=0.85p pd=5.68u as=0.85p ps=5.68u w=2.5u l=0.5u
X106 vco_var_rf_p.t0 vco_var_rf_n.t7 VSS.t105 VSS.t106 sg13_lv_nmos ad=0.38p pd=2.38u as=0.38p ps=2.38u w=2u l=0.13u
X107 VSS.t137 vco_bias_0.vbn_buf.t2 a_11798_1180.t15 VSS.t152 sg13_lv_nmos ad=0.95p pd=5.38u as=0.95p ps=5.38u w=5u l=0.5u
X108 a_11798_1180.t13 vco_bias_0.vbn_buf.t2 VSS.t135 VSS.t145 sg13_lv_nmos ad=0.95p pd=5.38u as=0.95p ps=5.38u w=5u l=0.5u
X109 VSS.t71 vco_var_rf_p.t7 vco_var_rf_n.t0 VSS.t70 sg13_lv_nmos ad=0.38p pd=2.38u as=0.38p ps=2.38u w=2u l=0.13u
X110 a_5948_4416.t0 a_5905_4552.t4 VSS.t16 VSS.t15 sg13_lv_nmos ad=0.17p pd=1.68u as=0.17p ps=1.68u w=0.5u l=0.13u
X111 vco_bias_0.vbg_buf VSS.t32 cap_cmim l=7.28u w=13.6u
X112 rf_out_p.t3 vco_buf_in_n.t1 a_11798_1180.t1 VSS.t87 sg13_lv_nmos ad=0.38p pd=2.38u as=0.38p ps=2.38u w=2u l=0.13u
X113 VDD.t18 rf_out_n.t6 VSS.t54 rppd l=1.65u w=10u
X114 VSS.t43 vco_bias_0.vbg_buf VSS.t41 VSS.t9 sg13_lv_nmos ad=1.52p pd=8.38u as=0 ps=0 w=8u l=10u
X115 VSS.t20 vco_bias_0.vbn_buf.t4 VSS.t18 VSS.t3 sg13_lv_nmos ad=1.52p pd=8.38u as=0 ps=0 w=8u l=10u
X116 VSS.t24 vco_bias_0.vbn_buf.t4 VSS.t22 VSS.t7 sg13_lv_nmos ad=1.52p pd=8.38u as=0 ps=0 w=8u l=10u
X117 vco_ind_LC VSS.t99 cap_cmim l=25.5u w=42u
X118 a_11798_1180.t6 vco_buf_in_n.t1 rf_out_p.t5 VSS.t96 sg13_lv_nmos ad=0.68p pd=4.68u as=0.38p ps=2.38u w=2u l=0.13u
X119 rf_out_p.t2 vco_buf_in_n.t1 a_11798_1180.t4 VSS.t93 sg13_lv_nmos ad=0.38p pd=2.38u as=0.38p ps=2.38u w=2u l=0.13u
X120 a_11798_1180.t3 vco_buf_in_n.t1 rf_out_p.t0 VSS.t90 sg13_lv_nmos ad=0.38p pd=2.38u as=0.38p ps=2.38u w=2u l=0.13u
X121 vco_bias_0.vbg_buf vco_buf_in_p.t0 VSS.t55 rhigh l=8u w=0.5u
X122 a_11798_1180.t10 vco_bias_0.vbn_buf.t2 VSS.t133 VSS.t132 sg13_lv_nmos ad=0.95p pd=5.38u as=0.95p ps=5.38u w=5u l=0.5u
X123 VSS.t147 vco_bias_0.vbn_buf.t2 a_11798_1180.t13 VSS.t146 sg13_lv_nmos ad=0.95p pd=5.38u as=0.95p ps=5.38u w=5u l=0.5u
X124 rf_out_n.t3 vco_buf_in_p.t1 a_11798_1180.t23 VSS.t170 sg13_lv_nmos ad=0.38p pd=2.38u as=0.38p ps=2.38u w=2u l=0.13u
C0 vco_buf_in_p a_10100_3480# 6.15e-17
C1 vco_var_rf_p vco_var_rf_n 4.49965e-15
C2 vco_var_rf_p rf_out_n 1.574e-17
C3 a_1160_1390# ibias_100u 2.97e-17
C4 a_1560_1090# a_1160_1390# 1.7942e-16
C5 vco_bias_0.vbn_buf rf_out_p 1.7253e-16
C6 ibias_100u VDD 5.0906e-16
C7 a_1560_1090# VDD 6.439e-17
C8 vco_bias_0.vbn_buf a_10100_3480# 1.657e-17
C9 vco_ind_LC vco_var_rf_n 1.02248e-15
C10 a_16500_3480# rf_out_p 4.7902e-16
C11 vco_bias_0.vbg_buf ibias_100u 1.5817e-15
C12 vco_bias_0.vbg_buf a_1560_1090# 6.332e-17
C13 vco_bias_0.vbn_buf ibias_100u 1.8745e-16
C14 vco_var_rf_p VDD 9.747e-17
C15 vco_var_rf_p vco_buf_in_p 1.68039e-15
C16 vco_ind_LC vco_buf_in_n 1.048e-17
C17 vco_var_rf_p vtune 1.0305e-16
C18 vco_bias_0.vbg_buf vco_var_rf_p 8.721e-16
C19 vco_ind_LC VDD 4.1391e-16
C20 a_19050_4480# vco_ind_LC 1.117e-17
C21 vco_var_rf_p vco_bias_0.vbn_buf 2.9334e-16
C22 vco_bias_0.vbg_buf vco_ind_LC 2.913e-17
C23 a_1560_1090# ibias_100u 1.292e-17
C24 vco_var_rf_p a_10100_3480# 1.479e-17
C25 vco_var_rf_n vco_buf_in_n 1.68039e-15
C26 di_en VDD 5.9704e-16
C27 vco_var_rf_n VDD 9.747e-17
C28 rf_out_n VDD 4.2538e-16
C29 vtune vco_var_rf_n 5.282e-17
C30 rf_out_n vco_buf_in_p 9.7363e-16
C31 vco_bias_0.vbg_buf di_en 1.53374e-15
C32 vco_bias_0.vbg_buf vco_var_rf_n 5.8809e-16
C33 vtune rf_out_n 3.195e-17
C34 vco_bias_0.vbn_buf di_en 1.0308e-16
C35 vco_bias_0.vbn_buf vco_var_rf_n 2.147e-17
C36 a_5560_4008# VDD 4.042e-17
C37 VDD vco_buf_in_n 5.3384e-16
C38 vco_bias_0.vbn_buf rf_out_n 1.9807e-16
C39 rf_out_p vco_var_rf_n 1.574e-17
C40 a_19050_4480# vco_buf_in_n 3.458e-17
C41 a_1160_1390# VDD 3.027e-17
C42 vco_buf_in_p vco_buf_in_n 1.7478e-16
C43 rf_out_n rf_out_p 1.053e-17
C44 a_16500_3480# vco_var_rf_n 1.479e-17
C45 vco_bias_0.vbg_buf a_5560_4008# 1.338e-17
C46 vtune vco_buf_in_n 1.8199e-16
C47 vco_bias_0.vbg_buf vco_buf_in_n 5.315e-17
C48 vco_buf_in_p a_9450_4480# 3.458e-17
C49 rf_out_n a_10100_3480# 4.7902e-16
C50 vco_buf_in_p VDD 5.5386e-16
C51 vco_bias_0.vbg_buf a_1160_1390# 5.51e-17
C52 vtune VDD 3.1574e-16
C53 vco_bias_0.vbn_buf vco_buf_in_n 1.681e-17
C54 vco_var_rf_p vco_ind_LC 5.4907e-16
C55 vco_bias_0.vbg_buf a_9450_4480# 4.475e-17
C56 vco_bias_0.vbg_buf VDD 2.38433e-15
C57 vtune vco_buf_in_p 1.8199e-16
C58 vco_bias_0.vbn_buf a_1160_1390# 2.9e-17
C59 ibias_100u di_en 3.44752e-15
C60 vco_bias_0.vbg_buf a_19050_4480# 4.459e-17
C61 vco_bias_0.vbg_buf vco_buf_in_p 6.224e-17
C62 rf_out_p vco_buf_in_n 9.7363e-16
C63 vco_bias_0.vbn_buf a_9450_4480# 1.693e-17
C64 vco_bias_0.vbn_buf VDD 1.39392e-15
C65 vco_bias_0.vbg_buf vtune 1.3019e-16
C66 a_16500_3480# vco_buf_in_n 6.15e-17
C67 vco_bias_0.vbn_buf vco_buf_in_p 3.045e-17
C68 rf_out_p VDD 4.1138e-16
C69 vtune vco_bias_0.vbn_buf 9.328e-17
C70 a_16500_3480# VDD 3.2168e-16
C71 vco_bias_0.vbg_buf vco_bias_0.vbn_buf 4.95375e-15
C72 a_10100_3480# VDD 3.5541e-16
C73 vtune rf_out_p 3.195e-17
R0 rf_out_p rf_out_p.n2 6.6125
R1 rf_out_p.n0 rf_out_p.t4 4.77599
R2 rf_out_p.n1 rf_out_p.t5 4.72949
R3 rf_out_p.n1 rf_out_p.t2 4.72949
R4 rf_out_p.n0 rf_out_p.t1 4.72949
R5 rf_out_p.n0 rf_out_p.t0 4.72949
R6 rf_out_p.n0 rf_out_p.t3 4.72949
R7 rf_out_p.n2 rf_out_p.t6 2.40801
R8 rf_out_p.n2 rf_out_p.n1 0.685593
R9 rf_out_p.n1 rf_out_p.n0 0.186531
R10 rf_out_n rf_out_n.n2 6.6125
R11 rf_out_n.n0 rf_out_n.t1 4.77599
R12 rf_out_n.n0 rf_out_n.t0 4.72949
R13 rf_out_n.n0 rf_out_n.t5 4.72949
R14 rf_out_n.n1 rf_out_n.t4 4.72949
R15 rf_out_n.n1 rf_out_n.t3 4.72949
R16 rf_out_n.n1 rf_out_n.t2 4.72949
R17 rf_out_n.n2 rf_out_n.t6 2.40801
R18 rf_out_n.n2 rf_out_n.n1 0.685593
R19 rf_out_n.n1 rf_out_n.n0 0.186531
R20 vco_buf_in_n.n0 vco_buf_in_n.t0 27.0805
R21 vco_buf_in_n vco_buf_in_n.n0 3.71514
R22 vco_buf_in_n.n0 vco_buf_in_n.t1 2.05808
R23 vco_buf_in_p.n0 vco_buf_in_p.t0 27.0805
R24 vco_buf_in_p vco_buf_in_p.n0 3.72028
R25 vco_buf_in_p.n0 vco_buf_in_p.t1 2.05789
R26 ibias_100u.n3 ibias_100u.t1 48.8821
R27 ibias_100u.n0 ibias_100u.t4 24.2693
R28 ibias_100u.n1 ibias_100u.t2 24.2693
R29 ibias_100u ibias_100u.n3 19.3314
R30 ibias_100u.n0 ibias_100u.t0 17.3756
R31 ibias_100u.n2 ibias_100u.t3 9.21754
R32 ibias_100u.n3 ibias_100u.n2 4.77917
R33 ibias_100u.n1 ibias_100u.n0 0.543167
R34 ibias_100u.n2 ibias_100u.n1 0.320233
R35 di_en.n0 di_en.t0 21.6583
R36 di_en.n0 di_en.t1 19.605
R37 di_en di_en.n0 14.2582
R38 vco_var_rf_p vco_var_rf_p.t5 4.85508
R39 vco_var_rf_p.n0 vco_var_rf_p.t3 4.75718
R40 vco_var_rf_p.n1 vco_var_rf_p.t4 4.81938
R41 vco_var_rf_p.n0 vco_var_rf_p.t2 4.72949
R42 vco_var_rf_p.n0 vco_var_rf_p.t1 4.72949
R43 vco_var_rf_p.n0 vco_var_rf_p.t0 4.72949
R44 vco_var_rf_p.n4 vco_var_rf_p.t7 4.13789
R45 vco_ind_LA vco_var_rf_p.n3 0.424928
R46 vco_var_rf_p.n2 vco_var_rf_p.n1 0.225881
R47 vco_var_rf_p.n3 vco_var_rf_p.n5 0.714879
R48 vco_var_rf_p.n4 vco_var_rf_p.n3 0.321512
R49 vco_var_rf_p.n5 vco_var_rf_p.n2 0.47922
R50 vco_var_rf_p.n5 vco_var_rf_p 0.47746
R51 vco_var_rf_p.n0 vco_var_rf_p.n1 0.0646573
R52 vco_var_rf_p.n2 vco_var_rf_p.n4 0.163811
R53 vco_var_rf_n vco_var_rf_n.t5 5.01313
R54 vco_var_rf_n.n0 vco_var_rf_n.t0 4.75718
R55 vco_var_rf_n.n1 vco_var_rf_n.t1 4.81949
R56 vco_var_rf_n.n0 vco_var_rf_n.t4 4.72949
R57 vco_var_rf_n.n0 vco_var_rf_n.t3 4.72949
R58 vco_var_rf_n.n0 vco_var_rf_n.t2 4.72949
R59 vco_var_rf_n.n4 vco_var_rf_n.t7 3.9789
R60 vco_var_rf_n.n5 vco_var_rf_n.n3 0.725624
R61 vco_var_rf_n.n2 vco_var_rf_n.n1 0.2259
R62 vco_var_rf_n.n3 vco_var_rf_n.n4 0.35065
R63 vco_ind_LB vco_var_rf_n.n3 0.413372
R64 vco_var_rf_n.n5 vco_var_rf_n.n2 0.47922
R65 vco_var_rf_n.n5 vco_var_rf_n 0.319412
R66 vco_var_rf_n.n0 vco_var_rf_n.n1 0.0645602
R67 vco_var_rf_n.n2 vco_var_rf_n.n4 0.146211
R68 VDD VDD.n6 22.5016
R69 VDD VDD.n12 17.6809
R70 VDD.n0 VDD.t14 17.5809
R71 VDD.n2 VDD.t11 17.5809
R72 VDD.n8 VDD.t8 17.5809
R73 VDD.n7 VDD.n8 0.0636783
R74 VDD.n11 VDD.n7 1.85672
R75 VDD.n3 VDD.t15 2.54484
R76 VDD.n10 VDD.t5 15.8062
R77 VDD.n11 VDD.n9 2.10335
R78 VDD.n8 VDD.t6 6.07554
R79 VDD.n8 VDD.t7 6.07554
R80 VDD.n4 VDD.t4 6.07554
R81 VDD.n5 VDD.t19 6.07554
R82 VDD.n6 VDD.t3 6.07554
R83 VDD.n11 VDD.n4 2.40129
R84 VDD.n4 VDD.n5 0.1061
R85 VDD.n12 VDD.t17 4.22454
R86 VDD.n6 VDD.n11 3.37539
R87 VDD.n11 VDD.n3 1.16155
R88 VDD.n1 VDD.t2 2.36473
R89 VDD.n0 VDD.t1 2.36454
R90 VDD.n2 VDD.t13 2.36428
R91 VDD.n2 VDD.t9 2.36411
R92 VDD.n2 VDD.t10 2.36364
R93 VDD.n1 VDD.t12 2.36338
R94 VDD.n0 VDD.t16 2.36308
R95 VDD.n12 VDD.t18 0.517741
R96 VDD.n11 VDD.t0 0.395849
R97 VDD.n1 VDD.n0 0.181347
R98 VDD.n6 VDD.n5 0.152127
R99 VDD.n3 VDD.n0 0.0814646
R100 VDD.n10 VDD.n4 0.144689
R101 VDD.n9 VDD.n1 0.139765
R102 VDD.n9 VDD.n2 0.137132
R103 VDD.n2 VDD.n7 0.120382
R104 VDD.n8 VDD.n10 0.102865
R105 VSS.t64 VSS.n255 657.683
R106 VSS.t84 VSS.t101 381.851
R107 VSS.t29 VSS.t67 303.798
R108 VSS.t101 VSS.t64 179.696
R109 VSS.n345 VSS.t29 110.507
R110 VSS.n256 VSS.n7 70.6476
R111 VSS.n8 VSS.t118 11.2345
R112 VSS.t61 VSS.n7 8.96376
R113 VSS.n6 VSS.t65 12.0533
R114 VSS.n9 VSS.t11 13.3662
R115 VSS.n8 VSS.t120 16.0214
R116 VSS.n10 VSS.t15 9.25867
R117 VSS.n9 VSS.t57 15.8457
R118 VSS.n170 VSS.n80 25.4435
R119 VSS.n132 VSS.t0 24.4181
R120 VSS.n193 VSS.n134 22.364
R121 VSS.n192 VSS.n140 22.364
R122 VSS.n206 VSS.n125 22.364
R123 VSS.n190 VSS.n145 22.364
R124 VSS.n216 VSS.n120 22.364
R125 VSS.n189 VSS.t5 22.364
R126 VSS.n231 VSS.n113 22.364
R127 VSS.n186 VSS.n159 22.364
R128 VSS.t27 VSS.n6 13.9985
R129 VSS.n10 VSS.t84 147.716
R130 VSS.n247 VSS.t16 17.3443
R131 VSS.n249 VSS.t66 17.3443
R132 VSS.n255 VSS.n198 17.102
R133 VSS.n35 VSS.n34 0.0686681
R134 VSS.n10 VSS.n6 7.68641
R135 VSS.n331 VSS.n330 17.0005
R136 VSS.n331 VSS.n315 17.0005
R137 VSS.n331 VSS.n329 17.0005
R138 VSS.n331 VSS.n316 17.0005
R139 VSS.n331 VSS.n328 17.0005
R140 VSS.n331 VSS.n317 17.0005
R141 VSS.n331 VSS.n327 17.0005
R142 VSS.n331 VSS.n318 17.0005
R143 VSS.n331 VSS.n326 17.0005
R144 VSS.n331 VSS.n319 17.0005
R145 VSS.n331 VSS.n325 17.0005
R146 VSS.n331 VSS.n320 17.0005
R147 VSS.n331 VSS.n324 17.0005
R148 VSS.n331 VSS.n321 17.0005
R149 VSS.n331 VSS.n323 17.0005
R150 VSS.n331 VSS.n322 17.0005
R151 VSS.n342 VSS.n341 17.0005
R152 VSS.n341 VSS.n308 17.0005
R153 VSS.n341 VSS.n340 17.0005
R154 VSS.n341 VSS.n309 17.0005
R155 VSS.n341 VSS.n339 17.0005
R156 VSS.n341 VSS.n310 17.0005
R157 VSS.n341 VSS.n338 17.0005
R158 VSS.n341 VSS.n311 17.0005
R159 VSS.n341 VSS.n337 17.0005
R160 VSS.n341 VSS.n312 17.0005
R161 VSS.n341 VSS.n336 17.0005
R162 VSS.n341 VSS.n313 17.0005
R163 VSS.n341 VSS.n335 17.0005
R164 VSS.n341 VSS.n314 17.0005
R165 VSS.n341 VSS.n334 17.0005
R166 VSS.n341 VSS.n333 17.0005
R167 VSS.n346 VSS.n345 17.0005
R168 VSS.n346 VSS.n55 17.0005
R169 VSS.n346 VSS.n307 17.0005
R170 VSS.n346 VSS.n56 17.0005
R171 VSS.n346 VSS.n306 17.0005
R172 VSS.n346 VSS.n57 17.0005
R173 VSS.n346 VSS.n305 17.0005
R174 VSS.n346 VSS.n58 17.0005
R175 VSS.n346 VSS.n304 17.0005
R176 VSS.n346 VSS.n59 17.0005
R177 VSS.n346 VSS.n303 17.0005
R178 VSS.n346 VSS.n60 17.0005
R179 VSS.n346 VSS.n302 17.0005
R180 VSS.n346 VSS.n61 17.0005
R181 VSS.n346 VSS.n301 17.0005
R182 VSS.n346 VSS.n62 17.0005
R183 VSS.n346 VSS.n300 17.0005
R184 VSS.n346 VSS.n63 17.0005
R185 VSS.n346 VSS.n299 17.0005
R186 VSS.n346 VSS.n64 17.0005
R187 VSS.n346 VSS.n297 17.0005
R188 VSS.n346 VSS.n68 17.0005
R189 VSS.n346 VSS.n293 17.0005
R190 VSS.n346 VSS.n70 17.0005
R191 VSS.n346 VSS.n291 17.0005
R192 VSS.n346 VSS.n71 17.0005
R193 VSS.n346 VSS.n90 17.0005
R194 VSS.n346 VSS.n72 17.0005
R195 VSS.n346 VSS.n89 17.0005
R196 VSS.n346 VSS.n73 17.0005
R197 VSS.n346 VSS.n88 17.0005
R198 VSS.n346 VSS.n74 17.0005
R199 VSS.n346 VSS.n87 17.0005
R200 VSS.n346 VSS.n75 17.0005
R201 VSS.n346 VSS.n86 17.0005
R202 VSS.n346 VSS.n76 17.0005
R203 VSS.n346 VSS.n85 17.0005
R204 VSS.n346 VSS.n77 17.0005
R205 VSS.n346 VSS.n84 17.0005
R206 VSS.n346 VSS.n78 17.0005
R207 VSS.n346 VSS.n83 17.0005
R208 VSS.n346 VSS.n80 17.0005
R209 VSS.n4 VSS.t56 16.4809
R210 VSS.n34 VSS.t60 16.4809
R211 VSS.n82 VSS.t126 15.6926
R212 VSS.t163 VSS.n343 15.6926
R213 VSS.t148 VSS.n67 14.9331
R214 VSS.n67 VSS.t151 14.9331
R215 VSS.t165 VSS.n54 14.555
R216 VSS.n81 VSS.t124 14.5543
R217 VSS.t124 VSS.n79 13.0361
R218 VSS.n344 VSS.t165 13.0354
R219 VSS.n259 VSS.n104 12.9119
R220 VSS.n261 VSS.n100 12.9119
R221 VSS.n178 VSS.n164 12.9119
R222 VSS.n264 VSS.n97 12.9119
R223 VSS.n175 VSS.n166 12.9119
R224 VSS.n267 VSS.n94 12.9119
R225 VSS.n171 VSS.n169 12.9119
R226 VSS.t146 VSS.n294 12.6546
R227 VSS.n296 VSS.t149 12.6546
R228 VSS.t122 VSS.n80 12.5321
R229 VSS.n345 VSS.t166 12.5321
R230 VSS.n295 VSS.t146 12.2766
R231 VSS.t149 VSS.n66 12.2759
R232 VSS.n266 VSS.t9 12.1524
R233 VSS.n210 VSS.t3 11.84
R234 VSS.n243 VSS.t7 11.84
R235 VSS.n349 VSS.n19 11.5239
R236 VSS.n181 VSS.t55 11.3929
R237 VSS.t179 VSS.t145 11.203
R238 VSS.t152 VSS.t85 11.203
R239 VSS.n257 VSS.n256 11.1823
R240 VSS.t144 VSS.n70 11.0132
R241 VSS.n299 VSS.t153 11.0132
R242 VSS.t3 VSS.n191 10.5245
R243 VSS.t7 VSS.n185 10.5245
R244 VSS.t151 VSS.n66 9.99808
R245 VSS.n295 VSS.t148 9.99739
R246 VSS.t176 VSS.n292 9.80648
R247 VSS.n69 VSS.t178 9.80648
R248 VSS.t86 VSS.n65 9.80648
R249 VSS.n298 VSS.t88 9.80648
R250 VSS.n289 VSS.n288 9.76416
R251 VSS.n233 VSS.n112 9.65968
R252 VSS.n224 VSS.n117 9.65968
R253 VSS.n222 VSS.n118 9.65968
R254 VSS.n221 VSS.n119 9.65968
R255 VSS.n239 VSS.n157 9.65968
R256 VSS.n238 VSS.n156 9.65968
R257 VSS.n237 VSS.n155 9.65968
R258 VSS.n236 VSS.n154 9.65968
R259 VSS.n235 VSS.n153 9.65968
R260 VSS.n233 VSS.n152 9.65968
R261 VSS.n227 VSS.n150 9.65968
R262 VSS.n226 VSS.n149 9.65968
R263 VSS.n224 VSS.n148 9.65968
R264 VSS.n221 VSS.n147 9.65968
R265 VSS.n214 VSS.n146 9.65968
R266 VSS.n209 VSS.n142 9.65968
R267 VSS.n208 VSS.n141 9.65968
R268 VSS.n201 VSS.n138 9.65968
R269 VSS.n200 VSS.n137 9.65968
R270 VSS.n196 VSS.n136 9.65968
R271 VSS.n195 VSS.n135 9.65968
R272 VSS.n194 VSS.n133 9.65968
R273 VSS.n196 VSS.n135 9.65968
R274 VSS.n197 VSS.n136 9.65968
R275 VSS.n197 VSS.n130 9.65968
R276 VSS.n199 VSS.n137 9.65968
R277 VSS.n200 VSS.n138 9.65968
R278 VSS.n201 VSS.n139 9.65968
R279 VSS.n203 VSS.n128 9.65968
R280 VSS.n204 VSS.n128 9.65968
R281 VSS.n204 VSS.n127 9.65968
R282 VSS.n205 VSS.n127 9.65968
R283 VSS.n205 VSS.n126 9.65968
R284 VSS.n207 VSS.n141 9.65968
R285 VSS.n208 VSS.n142 9.65968
R286 VSS.n209 VSS.n143 9.65968
R287 VSS.n211 VSS.n124 9.65968
R288 VSS.n212 VSS.n124 9.65968
R289 VSS.n212 VSS.n123 9.65968
R290 VSS.n213 VSS.n123 9.65968
R291 VSS.n213 VSS.n122 9.65968
R292 VSS.n214 VSS.n122 9.65968
R293 VSS.n215 VSS.n146 9.65968
R294 VSS.n215 VSS.n121 9.65968
R295 VSS.n217 VSS.n147 9.65968
R296 VSS.n222 VSS.n119 9.65968
R297 VSS.n223 VSS.n118 9.65968
R298 VSS.n223 VSS.n148 9.65968
R299 VSS.n225 VSS.n117 9.65968
R300 VSS.n225 VSS.n149 9.65968
R301 VSS.n226 VSS.n150 9.65968
R302 VSS.n227 VSS.n151 9.65968
R303 VSS.n228 VSS.n116 9.65968
R304 VSS.n229 VSS.n116 9.65968
R305 VSS.n229 VSS.n115 9.65968
R306 VSS.n230 VSS.n115 9.65968
R307 VSS.n230 VSS.n114 9.65968
R308 VSS.n232 VSS.n152 9.65968
R309 VSS.n234 VSS.n112 9.65968
R310 VSS.n234 VSS.n153 9.65968
R311 VSS.n235 VSS.n154 9.65968
R312 VSS.n236 VSS.n155 9.65968
R313 VSS.n237 VSS.n156 9.65968
R314 VSS.n238 VSS.n157 9.65968
R315 VSS.n239 VSS.n158 9.65968
R316 VSS.n240 VSS.n111 9.65968
R317 VSS.n241 VSS.n111 9.65968
R318 VSS.n241 VSS.n110 9.65968
R319 VSS.n242 VSS.n110 9.65968
R320 VSS.n242 VSS.n109 9.65968
R321 VSS.n244 VSS.n108 9.65968
R322 VSS.n244 VSS.n107 9.65968
R323 VSS.n245 VSS.n107 9.65968
R324 VSS.n245 VSS.n106 9.65968
R325 VSS.n246 VSS.t32 9.50586
R326 VSS.n291 VSS.t142 9.49417
R327 VSS.t155 VSS.n63 9.49417
R328 VSS.n50 VSS.n289 9.47095
R329 VSS.n344 VSS.t163 9.23859
R330 VSS.t126 VSS.n79 9.23789
R331 VSS.n322 VSS.n82 9.23686
R332 VSS.n343 VSS.n342 9.23686
R333 VSS.n347 VSS.n31 9.0005
R334 VSS.n32 VSS.n290 9.0005
R335 VSS.n273 VSS.n170 8.5005
R336 VSS.n273 VSS.n171 8.5005
R337 VSS.n273 VSS.n268 8.5005
R338 VSS.n273 VSS.n172 8.5005
R339 VSS.n273 VSS.n267 8.5005
R340 VSS.n273 VSS.n175 8.5005
R341 VSS.n273 VSS.n266 8.5005
R342 VSS.n273 VSS.n176 8.5005
R343 VSS.n273 VSS.n264 8.5005
R344 VSS.n273 VSS.n178 8.5005
R345 VSS.n273 VSS.n261 8.5005
R346 VSS.n273 VSS.n181 8.5005
R347 VSS.n273 VSS.n259 8.5005
R348 VSS.n273 VSS.n184 8.5005
R349 VSS.n276 VSS.n169 8.5005
R350 VSS.n276 VSS.n166 8.5005
R351 VSS.n276 VSS.n164 8.5005
R352 VSS.n276 VSS.n161 8.5005
R353 VSS.n276 VSS.n94 8.5005
R354 VSS.n276 VSS.n97 8.5005
R355 VSS.n276 VSS.n100 8.5005
R356 VSS.n276 VSS.n104 8.5005
R357 VSS.n276 VSS.n159 8.5005
R358 VSS.n276 VSS.t5 8.5005
R359 VSS.n276 VSS.n145 8.5005
R360 VSS.n276 VSS.n140 8.5005
R361 VSS.n276 VSS.n134 8.5005
R362 VSS.n276 VSS.n113 8.5005
R363 VSS.n276 VSS.n120 8.5005
R364 VSS.n276 VSS.n125 8.5005
R365 VSS.n276 VSS.n129 8.5005
R366 VSS.n276 VSS.n131 8.5005
R367 VSS.n273 VSS.n257 8.5005
R368 VSS.n273 VSS.n185 8.5005
R369 VSS.n273 VSS.n243 8.5005
R370 VSS.n273 VSS.n186 8.5005
R371 VSS.n273 VSS.n231 8.5005
R372 VSS.n273 VSS.n189 8.5005
R373 VSS.n273 VSS.n216 8.5005
R374 VSS.n273 VSS.n190 8.5005
R375 VSS.n273 VSS.n210 8.5005
R376 VSS.n273 VSS.n191 8.5005
R377 VSS.n273 VSS.n206 8.5005
R378 VSS.n273 VSS.n192 8.5005
R379 VSS.n273 VSS.n198 8.5005
R380 VSS.n273 VSS.n193 8.5005
R381 VSS.n323 VSS.n78 8.35493
R382 VSS.n324 VSS.n77 8.35493
R383 VSS.n320 VSS.n85 8.35493
R384 VSS.n319 VSS.n86 8.35493
R385 VSS.n326 VSS.n75 8.35493
R386 VSS.n317 VSS.n88 8.35493
R387 VSS.n336 VSS.n60 8.35493
R388 VSS.n311 VSS.n304 8.35493
R389 VSS.n338 VSS.n58 8.35493
R390 VSS.n339 VSS.n57 8.35493
R391 VSS.n309 VSS.n306 8.35493
R392 VSS.n308 VSS.n307 8.35493
R393 VSS.t174 VSS.n70 7.78531
R394 VSS.n293 VSS.t176 7.78531
R395 VSS.t178 VSS.n68 7.78531
R396 VSS.n297 VSS.t86 7.78531
R397 VSS.t88 VSS.n64 7.78531
R398 VSS.n299 VSS.t90 7.78531
R399 VSS.n288 VSS.n92 7.76695
R400 VSS.n81 VSS.t122 7.7196
R401 VSS.t166 VSS.n54 7.71891
R402 VSS.n268 VSS.t54 7.59544
R403 VSS.n173 VSS.n93 7.33963
R404 VSS.n265 VSS.n96 7.33963
R405 VSS.n262 VSS.n99 7.33963
R406 VSS.n182 VSS.n102 7.33963
R407 VSS.n269 VSS.n167 7.33963
R408 VSS.n260 VSS.n162 7.33963
R409 VSS.n183 VSS.n160 7.33963
R410 VSS.n183 VSS.n105 7.33963
R411 VSS.n258 VSS.n105 7.33963
R412 VSS.n182 VSS.n103 7.33963
R413 VSS.n179 VSS.n162 7.33963
R414 VSS.n179 VSS.n101 7.33963
R415 VSS.n263 VSS.n99 7.33963
R416 VSS.n263 VSS.n163 7.33963
R417 VSS.n177 VSS.n98 7.33963
R418 VSS.n174 VSS.n95 7.33963
R419 VSS.n269 VSS.n168 7.33963
R420 VSS.n275 VSS.n274 7.33963
R421 VSS.n327 VSS.t169 7.02582
R422 VSS.n316 VSS.t171 7.02582
R423 VSS.n330 VSS.t173 7.02582
R424 VSS.n333 VSS.t91 7.02582
R425 VSS.n335 VSS.t93 7.02582
R426 VSS.n312 VSS.t95 7.02582
R427 VSS.n256 VSS.n184 6.4562
R428 VSS.n346 VSS.n343 6.16155
R429 VSS.n346 VSS.n298 6.16155
R430 VSS.n346 VSS.n65 6.16155
R431 VSS.n346 VSS.n296 6.16155
R432 VSS.n346 VSS.n67 6.16155
R433 VSS.n346 VSS.n294 6.16155
R434 VSS.n346 VSS.n69 6.16155
R435 VSS.n346 VSS.n292 6.16155
R436 VSS.n346 VSS.n82 6.16155
R437 VSS.n250 VSS.t14 6.07511
R438 VSS.n1 VSS.t28 6.07511
R439 VSS.n292 VSS.t175 6.00901
R440 VSS.t177 VSS.n69 6.00901
R441 VSS.n294 VSS.t179 6.00901
R442 VSS.t85 VSS.n296 6.00901
R443 VSS.n65 VSS.t87 6.00901
R444 VSS.t89 VSS.n298 6.00901
R445 VSS.n91 VSS.t30 5.92636
R446 VSS.t134 VSS.t177 5.88658
R447 VSS.t87 VSS.t136 5.88658
R448 VSS.n293 VSS.t134 5.6967
R449 VSS.t136 VSS.n64 5.6967
R450 VSS.n34 VSS.t63 3.20134
R451 VSS.n5 VSS.n47 0.0750609
R452 VSS.n331 VSS.n42 5.65086
R453 VSS.n51 VSS.n41 0.0974311
R454 VSS.n331 VSS.n41 2.80696
R455 VSS.n11 VSS.n39 0.066765
R456 VSS.n45 VSS.n46 0.0585658
R457 VSS.n341 VSS.n45 2.7974
R458 VSS.n15 VSS.n44 0.066765
R459 VSS.n341 VSS.n37 5.65086
R460 VSS.t54 VSS.n172 5.31696
R461 VSS.n255 VSS.n129 5.2625
R462 VSS.t104 VSS.n84 5.12708
R463 VSS.t110 VSS.n87 5.12708
R464 VSS.t113 VSS.n73 5.12708
R465 VSS.t116 VSS.n90 5.12708
R466 VSS.n291 VSS.t174 5.12708
R467 VSS.t90 VSS.n63 5.12708
R468 VSS.t68 VSS.n62 5.12708
R469 VSS.t72 VSS.n302 5.12708
R470 VSS.t75 VSS.n59 5.12708
R471 VSS.t81 VSS.n56 5.12708
R472 VSS.n322 VSS.t127 4.93721
R473 VSS.n342 VSS.t162 4.93721
R474 VSS.n257 VSS.n106 4.83009
R475 VSS.n243 VSS.n109 4.83009
R476 VSS.n231 VSS.n114 4.83009
R477 VSS.n216 VSS.n121 4.83009
R478 VSS.n206 VSS.n126 4.83009
R479 VSS.n198 VSS.n130 4.83009
R480 VSS.n186 VSS.n158 4.83009
R481 VSS.n189 VSS.n151 4.83009
R482 VSS.n190 VSS.n144 4.83009
R483 VSS.n191 VSS.n143 4.83009
R484 VSS.n192 VSS.n139 4.83009
R485 VSS.n193 VSS.n133 4.83009
R486 VSS.n232 VSS.n113 4.83009
R487 VSS.n217 VSS.n120 4.83009
R488 VSS.n207 VSS.n125 4.83009
R489 VSS.n199 VSS.n129 4.83009
R490 VSS.n194 VSS.n131 4.83009
R491 VSS.n195 VSS.n134 4.83009
R492 VSS.n203 VSS.n140 4.83009
R493 VSS.n210 VSS.n144 4.83009
R494 VSS.n211 VSS.n145 4.83009
R495 VSS.n228 VSS.t5 4.83009
R496 VSS.n240 VSS.n159 4.83009
R497 VSS.n185 VSS.n108 4.83009
R498 VSS.n46 VSS.n19 4.69693
R499 VSS.n288 VSS.n287 4.67815
R500 VSS.n16 VSS.n53 4.59452
R501 VSS.n321 VSS.n78 4.55746
R502 VSS.n325 VSS.n85 4.55746
R503 VSS.n319 VSS.n76 4.55746
R504 VSS.n318 VSS.n75 4.55746
R505 VSS.n327 VSS.n87 4.55746
R506 VSS.n316 VSS.n73 4.55746
R507 VSS.n315 VSS.n72 4.55746
R508 VSS.n330 VSS.n90 4.55746
R509 VSS.n333 VSS.n62 4.55746
R510 VSS.n334 VSS.n301 4.55746
R511 VSS.n335 VSS.n302 4.55746
R512 VSS.n312 VSS.n59 4.55746
R513 VSS.n337 VSS.n304 4.55746
R514 VSS.n338 VSS.n305 4.55746
R515 VSS.n310 VSS.n57 4.55746
R516 VSS.n340 VSS.n307 4.55746
R517 VSS.n36 VSS.n20 4.5005
R518 VSS.n20 VSS.n332 4.5005
R519 VSS.n18 VSS.n17 2.16985
R520 VSS.n16 VSS.n51 4.5005
R521 VSS.n6 VSS.n35 2.08334
R522 VSS.n6 VSS.n2 1.8585
R523 VSS.n6 VSS.n251 4.23094
R524 VSS.n331 VSS.n11 2.3909
R525 VSS.n341 VSS.n15 2.3909
R526 VSS.t129 VSS.n84 4.17772
R527 VSS.n329 VSS.t141 4.17772
R528 VSS.t141 VSS.n72 4.17772
R529 VSS.t156 VSS.n301 4.17772
R530 VSS.n314 VSS.t156 4.17772
R531 VSS.t130 VSS.n56 4.17772
R532 VSS.t107 VSS.t138 3.98784
R533 VSS.t78 VSS.t158 3.98784
R534 VSS.n7 VSS.n6 2.99824
R535 VSS.n274 VSS.n169 3.67007
R536 VSS.n174 VSS.n166 3.67007
R537 VSS.n265 VSS.n97 3.67007
R538 VSS.n177 VSS.n164 3.67007
R539 VSS.n262 VSS.n100 3.67007
R540 VSS.n258 VSS.n104 3.67007
R541 VSS.n267 VSS.n95 3.67007
R542 VSS.n264 VSS.n98 3.67007
R543 VSS.n261 VSS.n101 3.67007
R544 VSS.n259 VSS.n103 3.67007
R545 VSS.n171 VSS.n168 3.67007
R546 VSS.n175 VSS.n165 3.67007
R547 VSS.n178 VSS.n163 3.67007
R548 VSS.n184 VSS.n160 3.67007
R549 VSS.n181 VSS.n102 3.67007
R550 VSS.n260 VSS.n161 3.67007
R551 VSS.n176 VSS.n96 3.67007
R552 VSS.n266 VSS.n165 3.67007
R553 VSS.n173 VSS.n94 3.67007
R554 VSS.n172 VSS.n93 3.67007
R555 VSS.n268 VSS.n167 3.67007
R556 VSS.n275 VSS.n170 3.67007
R557 VSS.n36 VSS.t71 3.45423
R558 VSS.n14 VSS.t74 3.45423
R559 VSS.n44 VSS.t77 3.45423
R560 VSS.n43 VSS.t80 3.45423
R561 VSS.n13 VSS.t105 3.45423
R562 VSS.n39 VSS.t108 3.45423
R563 VSS.n40 VSS.t111 3.45423
R564 VSS.n51 VSS.t114 3.45423
R565 VSS.n37 VSS.t69 3.45313
R566 VSS.n46 VSS.t83 3.45313
R567 VSS.n12 VSS.t103 3.45313
R568 VSS.n42 VSS.t117 3.45313
R569 VSS.t127 VSS.n83 3.41822
R570 VSS.n328 VSS.t139 3.41822
R571 VSS.t142 VSS.n71 3.41822
R572 VSS.n300 VSS.t155 3.41822
R573 VSS.n313 VSS.t160 3.41822
R574 VSS.t162 VSS.n55 3.41822
R575 VSS.n27 VSS.n26 0.0783198
R576 VSS.n346 VSS.n31 1.11025
R577 VSS.n346 VSS.n24 1.02806
R578 VSS.n346 VSS.n33 1.11047
R579 VSS.n346 VSS.n38 1.67243
R580 VSS.n29 VSS.n28 0.0776913
R581 VSS.n6 VSS.n5 1.51113
R582 VSS.n6 VSS.n248 3.37539
R583 VSS.n323 VSS.t102 3.22835
R584 VSS.n321 VSS.t104 3.22835
R585 VSS.n320 VSS.t106 3.22835
R586 VSS.n325 VSS.t107 3.22835
R587 VSS.n326 VSS.t109 3.22835
R588 VSS.n317 VSS.t112 3.22835
R589 VSS.n329 VSS.t115 3.22835
R590 VSS.n314 VSS.t70 3.22835
R591 VSS.n336 VSS.t73 3.22835
R592 VSS.n311 VSS.t76 3.22835
R593 VSS.n310 VSS.t78 3.22835
R594 VSS.n339 VSS.t79 3.22835
R595 VSS.n340 VSS.t81 3.22835
R596 VSS.n308 VSS.t82 3.22835
R597 VSS.n3 VSS.t12 3.14902
R598 VSS.n4 VSS.t58 3.14902
R599 VSS.n47 VSS.t59 3.14902
R600 VSS.n252 VSS.t119 3.14902
R601 VSS.n254 VSS.t121 3.14902
R602 VSS.n34 VSS.t62 3.14902
R603 VSS.n349 VSS.n53 2.98702
R604 VSS.n346 VSS.n27 1.50398
R605 VSS.n24 VSS.n23 0.0606977
R606 VSS.n346 VSS.n29 1.50426
R607 VSS.n6 VSS.n253 2.80331
R608 VSS.n247 VSS.n246 2.69572
R609 VSS.t170 VSS.t113 2.65873
R610 VSS.t172 VSS.t116 2.65873
R611 VSS.t92 VSS.t68 2.65873
R612 VSS.t94 VSS.t72 2.65873
R613 VSS.n346 VSS.n54 2.57114
R614 VSS.n346 VSS.n344 2.57114
R615 VSS.n346 VSS.n66 2.57114
R616 VSS.n346 VSS.n295 2.57114
R617 VSS.n346 VSS.n79 2.57114
R618 VSS.n346 VSS.n81 2.57114
R619 VSS.n274 VSS.n273 2.41647
R620 VSS.n273 VSS.n269 2.41647
R621 VSS.n273 VSS.n173 2.41647
R622 VSS.n273 VSS.n174 2.41647
R623 VSS.n273 VSS.n265 2.41647
R624 VSS.n273 VSS.n177 2.41647
R625 VSS.n273 VSS.n263 2.41647
R626 VSS.n273 VSS.n262 2.41647
R627 VSS.n273 VSS.n179 2.41647
R628 VSS.n273 VSS.n260 2.41647
R629 VSS.n273 VSS.n182 2.41647
R630 VSS.n273 VSS.n258 2.41647
R631 VSS.n273 VSS.n183 2.41647
R632 VSS.n276 VSS.n275 2.41647
R633 VSS.n276 VSS.n168 2.41647
R634 VSS.n276 VSS.n167 2.41647
R635 VSS.n276 VSS.n165 2.41647
R636 VSS.n276 VSS.n163 2.41647
R637 VSS.n276 VSS.n162 2.41647
R638 VSS.n276 VSS.n160 2.41647
R639 VSS.n276 VSS.n93 2.41647
R640 VSS.n276 VSS.n95 2.41647
R641 VSS.n276 VSS.n96 2.41647
R642 VSS.n276 VSS.n98 2.41647
R643 VSS.n276 VSS.n99 2.41647
R644 VSS.n276 VSS.n101 2.41647
R645 VSS.n276 VSS.n102 2.41647
R646 VSS.n276 VSS.n103 2.41647
R647 VSS.n276 VSS.n105 2.41647
R648 VSS.n28 VSS.t123 2.40187
R649 VSS.n26 VSS.t167 2.40061
R650 VSS.n23 VSS.t150 2.36054
R651 VSS.n25 VSS.t159 2.3605
R652 VSS.n21 VSS.t133 2.36035
R653 VSS.n31 VSS.t157 2.36016
R654 VSS.n28 VSS.t125 2.35993
R655 VSS.n30 VSS.t154 2.35987
R656 VSS.n21 VSS.t128 2.35975
R657 VSS.n22 VSS.t135 2.3595
R658 VSS.n25 VSS.t131 2.35944
R659 VSS.n23 VSS.t137 2.35935
R660 VSS.n33 VSS.t143 2.35901
R661 VSS.n22 VSS.t147 2.35901
R662 VSS.n32 VSS.t140 2.35898
R663 VSS.n26 VSS.t164 2.35874
R664 VSS.n287 VSS.t44 2.21155
R665 VSS.n283 VSS.t47 2.21151
R666 VSS.n285 VSS.t45 2.21147
R667 VSS.n270 VSS.t8 2.21123
R668 VSS.n218 VSS.t2 2.21085
R669 VSS.n279 VSS.t51 2.21053
R670 VSS.n219 VSS.t4 2.21047
R671 VSS.n281 VSS.t49 2.21047
R672 VSS.n277 VSS.t53 2.21028
R673 VSS.n187 VSS.t6 2.2102
R674 VSS.n92 VSS.t1 2.21
R675 VSS.n271 VSS.t10 2.2097
R676 VSS.n92 VSS.t17 2.20308
R677 VSS.n285 VSS.t35 2.20303
R678 VSS.n187 VSS.t22 2.20296
R679 VSS.n279 VSS.t41 2.20281
R680 VSS.n281 VSS.t39 2.20247
R681 VSS.n287 VSS.t34 2.2022
R682 VSS.n270 VSS.t24 2.20215
R683 VSS.n219 VSS.t20 2.20188
R684 VSS.n218 VSS.t18 2.20173
R685 VSS.n283 VSS.t37 2.2017
R686 VSS.n271 VSS.t26 2.20154
R687 VSS.n277 VSS.t43 2.20146
R688 VSS.n276 VSS.n158 1.83646
R689 VSS.n276 VSS.n157 1.83646
R690 VSS.n276 VSS.n156 1.83646
R691 VSS.n276 VSS.n155 1.83646
R692 VSS.n276 VSS.n154 1.83646
R693 VSS.n276 VSS.n153 1.83646
R694 VSS.n276 VSS.n152 1.83646
R695 VSS.n276 VSS.n151 1.83646
R696 VSS.n276 VSS.n150 1.83646
R697 VSS.n276 VSS.n149 1.83646
R698 VSS.n276 VSS.n148 1.83646
R699 VSS.n276 VSS.n147 1.83646
R700 VSS.n276 VSS.n146 1.83646
R701 VSS.n276 VSS.n144 1.83646
R702 VSS.n276 VSS.n143 1.83646
R703 VSS.n276 VSS.n142 1.83646
R704 VSS.n276 VSS.n141 1.83646
R705 VSS.n276 VSS.n139 1.83646
R706 VSS.n276 VSS.n138 1.83646
R707 VSS.n276 VSS.n137 1.83646
R708 VSS.n276 VSS.n136 1.83646
R709 VSS.n276 VSS.n135 1.83646
R710 VSS.n276 VSS.n133 1.83646
R711 VSS.n276 VSS.n106 1.83646
R712 VSS.n276 VSS.n107 1.83646
R713 VSS.n276 VSS.n108 1.83646
R714 VSS.n276 VSS.n109 1.83646
R715 VSS.n276 VSS.n110 1.83646
R716 VSS.n276 VSS.n111 1.83646
R717 VSS.n276 VSS.n112 1.83646
R718 VSS.n276 VSS.n114 1.83646
R719 VSS.n276 VSS.n115 1.83646
R720 VSS.n276 VSS.n116 1.83646
R721 VSS.n276 VSS.n117 1.83646
R722 VSS.n276 VSS.n118 1.83646
R723 VSS.n276 VSS.n119 1.83646
R724 VSS.n276 VSS.n121 1.83646
R725 VSS.n276 VSS.n122 1.83646
R726 VSS.n276 VSS.n123 1.83646
R727 VSS.n276 VSS.n124 1.83646
R728 VSS.n276 VSS.n126 1.83646
R729 VSS.n276 VSS.n127 1.83646
R730 VSS.n276 VSS.n128 1.83646
R731 VSS.n276 VSS.n130 1.83646
R732 VSS.n273 VSS.n228 1.83646
R733 VSS.n273 VSS.n245 1.83646
R734 VSS.n273 VSS.n244 1.83646
R735 VSS.n273 VSS.n242 1.83646
R736 VSS.n273 VSS.n241 1.83646
R737 VSS.n273 VSS.n240 1.83646
R738 VSS.n273 VSS.n239 1.83646
R739 VSS.n273 VSS.n238 1.83646
R740 VSS.n273 VSS.n237 1.83646
R741 VSS.n273 VSS.n236 1.83646
R742 VSS.n273 VSS.n235 1.83646
R743 VSS.n273 VSS.n234 1.83646
R744 VSS.n273 VSS.n233 1.83646
R745 VSS.n273 VSS.n232 1.83646
R746 VSS.n273 VSS.n230 1.83646
R747 VSS.n273 VSS.n229 1.83646
R748 VSS.n273 VSS.n227 1.83646
R749 VSS.n273 VSS.n226 1.83646
R750 VSS.n273 VSS.n225 1.83646
R751 VSS.n273 VSS.n224 1.83646
R752 VSS.n273 VSS.n223 1.83646
R753 VSS.n273 VSS.n222 1.83646
R754 VSS.n273 VSS.n221 1.83646
R755 VSS.n273 VSS.n217 1.83646
R756 VSS.n273 VSS.n215 1.83646
R757 VSS.n273 VSS.n214 1.83646
R758 VSS.n273 VSS.n213 1.83646
R759 VSS.n273 VSS.n212 1.83646
R760 VSS.n273 VSS.n211 1.83646
R761 VSS.n273 VSS.n209 1.83646
R762 VSS.n273 VSS.n208 1.83646
R763 VSS.n273 VSS.n207 1.83646
R764 VSS.n273 VSS.n205 1.83646
R765 VSS.n273 VSS.n204 1.83646
R766 VSS.n273 VSS.n203 1.83646
R767 VSS.n273 VSS.n201 1.83646
R768 VSS.n273 VSS.n200 1.83646
R769 VSS.n273 VSS.n199 1.83646
R770 VSS.n273 VSS.n197 1.83646
R771 VSS.n273 VSS.n196 1.83646
R772 VSS.n273 VSS.n195 1.83646
R773 VSS.n273 VSS.n194 1.83646
R774 VSS.n52 VSS.n0 0.766777
R775 VSS.n0 VSS.n48 0.288546
R776 VSS VSS.n49 0.189868
R777 VSS VSS.n50 0.776964
R778 VSS.t55 VSS.n161 1.51949
R779 VSS.t102 VSS.n83 1.32961
R780 VSS.t106 VSS.n77 1.32961
R781 VSS.t109 VSS.n86 1.32961
R782 VSS.t168 VSS.t132 1.32961
R783 VSS.t132 VSS.t110 1.32961
R784 VSS.t169 VSS.n74 1.32961
R785 VSS.t112 VSS.n74 1.32961
R786 VSS.t171 VSS.n89 1.32961
R787 VSS.t115 VSS.n89 1.32961
R788 VSS.t173 VSS.n71 1.32961
R789 VSS.t91 VSS.n300 1.32961
R790 VSS.t70 VSS.n61 1.32961
R791 VSS.t93 VSS.n61 1.32961
R792 VSS.t73 VSS.n303 1.32961
R793 VSS.t95 VSS.n303 1.32961
R794 VSS.t161 VSS.t75 1.32961
R795 VSS.t96 VSS.t161 1.32961
R796 VSS.t76 VSS.n58 1.32961
R797 VSS.t79 VSS.n306 1.32961
R798 VSS.t82 VSS.n55 1.32961
R799 VSS.t0 VSS.n131 1.316
R800 VSS.t138 VSS.n76 1.13974
R801 VSS.t139 VSS.n88 1.13974
R802 VSS.t160 VSS.n60 1.13974
R803 VSS.t158 VSS.n305 1.13974
R804 vco_var_VSS VSS.n349 0.903417
R805 VSS.n289 VSS.n91 0.762586
R806 VSS.t9 VSS.n176 0.759994
R807 VSS.n246 VSS.n91 0.674942
R808 VSS.n276 VSS.n132 0.570744
R809 VSS.n273 VSS.n132 0.57024
R810 VSS.n318 VSS.t168 0.57012
R811 VSS.n328 VSS.t170 0.57012
R812 VSS.n315 VSS.t172 0.57012
R813 VSS.t175 VSS.t144 0.57012
R814 VSS.t153 VSS.t89 0.57012
R815 VSS.n334 VSS.t92 0.57012
R816 VSS.n313 VSS.t94 0.57012
R817 VSS.n337 VSS.t96 0.57012
R818 VSS.n348 VSS.n347 0.551994
R819 VSS.n324 VSS.t129 0.380247
R820 VSS.t145 VSS.n68 0.380247
R821 VSS.n297 VSS.t152 0.380247
R822 VSS.n309 VSS.t130 0.380247
R823 VSS.n332 VSS.n18 0.50003
R824 VSS.t99 VSS.n348 0.264692
R825 VSS.n50 VSS.n49 0.75765
R826 VSS.n49 VSS.n48 0.959389
R827 VSS.t97 VSS.t99 0.252013
R828 VSS.t13 VSS.n6 15.5114
R829 VSS.n285 VSS.n284 0.243424
R830 VSS.n220 VSS.n218 0.243424
R831 VSS.n287 VSS.n286 0.242716
R832 VSS.n202 VSS.n92 0.242716
R833 VSS.n281 VSS.n280 0.24245
R834 VSS.n187 VSS.n180 0.24245
R835 VSS.n18 VSS.n42 0.404622
R836 VSS.n332 VSS.n37 0.241827
R837 VSS.n283 VSS.n282 0.240796
R838 VSS.n219 VSS.n188 0.240796
R839 VSS.n279 VSS.n278 0.239822
R840 VSS.n272 VSS.n270 0.239822
R841 VSS.n280 VSS.n279 0.227974
R842 VSS.n270 VSS.n180 0.227974
R843 VSS.n284 VSS.n283 0.227001
R844 VSS.n220 VSS.n219 0.227001
R845 VSS.n278 VSS.n277 0.225646
R846 VSS.n272 VSS.n271 0.225646
R847 VSS.n282 VSS.n281 0.224672
R848 VSS.n188 VSS.n187 0.224672
R849 VSS.n286 VSS.n285 0.223715
R850 VSS.n218 VSS.n202 0.223715
R851 VSS.n273 VSS.n180 0.218846
R852 VSS.n280 VSS.n276 0.218846
R853 VSS.n284 VSS.n276 0.218846
R854 VSS.n273 VSS.n220 0.218846
R855 VSS.n273 VSS.n272 0.208386
R856 VSS.n278 VSS.n276 0.208386
R857 VSS.n282 VSS.n276 0.208386
R858 VSS.n273 VSS.n188 0.208386
R859 VSS.n286 VSS.n276 0.208371
R860 VSS.n273 VSS.n202 0.208371
R861 VSS.n348 VSS.n0 0.197134
R862 VSS.n290 VSS.n52 0.299243
R863 VSS.n20 VSS.n19 0.113321
R864 VSS.n253 VSS.n252 0.0927224
R865 VSS.n254 VSS.n253 0.0891245
R866 VSS.n290 VSS.n48 0.402928
R867 VSS.n347 VSS.n52 0.211243
R868 VSS VSS.n0 0.210343
R869 VSS.n3 VSS.n1 0.146661
R870 VSS.n45 VSS.n43 0.0585658
R871 VSS.n44 VSS.n43 0.116817
R872 VSS.n15 VSS.n14 0.0501977
R873 VSS.n40 VSS.n39 0.116817
R874 VSS.n13 VSS.n11 0.0501977
R875 VSS.n37 VSS.n36 0.116817
R876 VSS.n5 VSS.n4 0.0537818
R877 VSS.n51 VSS.n42 0.097735
R878 VSS.n252 VSS.n47 0.0951565
R879 VSS.n30 VSS.n24 0.124327
R880 VSS.n38 VSS.n32 0.0873931
R881 VSS.n19 VSS.t97 0.0894317
R882 VSS.n12 VSS.n53 0.0846837
R883 VSS.n2 VSS.n1 0.0455524
R884 VSS.n251 VSS.n250 0.0794206
R885 VSS.n41 VSS.n40 0.0394405
R886 VSS.n249 VSS.n248 0.0776211
R887 VSS.n35 VSS.n254 0.145414
R888 VSS.n23 VSS.n22 0.145251
R889 VSS.n4 VSS.n3 0.139213
R890 VSS.n9 VSS.n6 0.134756
R891 VSS.n29 VSS.n21 0.0647961
R892 VSS.n33 VSS.n22 0.134323
R893 VSS.n31 VSS.n25 0.133313
R894 VSS.n27 VSS.n25 0.117589
R895 VSS.n36 VSS.n14 0.117555
R896 VSS.n13 VSS.n12 0.117555
R897 VSS.n20 VSS.n17 0.113321
R898 VSS.n17 VSS.n16 0.113321
R899 VSS.n38 VSS.n21 0.0986904
R900 VSS.n33 VSS.n32 0.0937261
R901 VSS.n31 VSS.n30 0.0937082
R902 VSS.n8 VSS.n6 0.0411729
R903 VSS.n248 VSS.n247 0.0750054
R904 VSS.n251 VSS.n249 0.0725235
R905 VSS.n250 VSS.n2 0.107222
R906 a_11798_1180.n0 a_11798_1180.n4 9.42143
R907 a_11798_1180.n1 a_11798_1180.n12 9.42143
R908 a_11798_1180.n1 a_11798_1180.n5 9.42143
R909 a_11798_1180.n1 a_11798_1180.n6 9.42143
R910 a_11798_1180.n2 a_11798_1180.n9 9.42143
R911 a_11798_1180.n2 a_11798_1180.n7 9.42143
R912 a_11798_1180.n4 a_11798_1180.t22 3.60374
R913 a_11798_1180.n5 a_11798_1180.t28 3.60255
R914 a_11798_1180.n6 a_11798_1180.t0 3.60255
R915 a_11798_1180.n7 a_11798_1180.t6 3.60255
R916 a_11798_1180.n4 a_11798_1180.t23 3.45423
R917 a_11798_1180.n13 a_11798_1180.t24 3.45423
R918 a_11798_1180.n11 a_11798_1180.t26 3.45423
R919 a_11798_1180.n5 a_11798_1180.t27 3.45423
R920 a_11798_1180.n12 a_11798_1180.t25 3.45423
R921 a_11798_1180.n6 a_11798_1180.t1 3.45423
R922 a_11798_1180.n10 a_11798_1180.t2 3.45423
R923 a_11798_1180.n8 a_11798_1180.t4 3.45423
R924 a_11798_1180.n7 a_11798_1180.t5 3.45423
R925 a_11798_1180.n9 a_11798_1180.t3 3.45423
R926 a_11798_1180.t21 a_11798_1180.n3 2.61386
R927 a_11798_1180.n0 a_11798_1180.t7 2.61108
R928 a_11798_1180.n1 a_11798_1180.t15 2.56207
R929 a_11798_1180.n1 a_11798_1180.t13 2.56207
R930 a_11798_1180.n0 a_11798_1180.t9 2.56207
R931 a_11798_1180.n1 a_11798_1180.t12 2.56174
R932 a_11798_1180.n0 a_11798_1180.t8 2.56173
R933 a_11798_1180.n1 a_11798_1180.t11 2.5617
R934 a_11798_1180.n3 a_11798_1180.t20 2.56161
R935 a_11798_1180.n1 a_11798_1180.t14 2.56161
R936 a_11798_1180.n0 a_11798_1180.t10 2.56161
R937 a_11798_1180.n3 a_11798_1180.t19 2.5616
R938 a_11798_1180.n2 a_11798_1180.t18 2.56159
R939 a_11798_1180.n2 a_11798_1180.t17 2.56146
R940 a_11798_1180.n1 a_11798_1180.t16 2.56146
R941 a_11798_1180.n2 a_11798_1180.n1 0.245563
R942 a_11798_1180.n8 a_11798_1180.n7 0.225083
R943 a_11798_1180.n6 a_11798_1180.n10 0.225083
R944 a_11798_1180.n11 a_11798_1180.n5 0.225083
R945 a_11798_1180.n4 a_11798_1180.n13 0.225083
R946 a_11798_1180.n1 a_11798_1180.n0 0.196551
R947 a_11798_1180.n13 a_11798_1180.n12 0.1875
R948 a_11798_1180.n12 a_11798_1180.n11 0.1875
R949 a_11798_1180.n10 a_11798_1180.n9 0.1875
R950 a_11798_1180.n9 a_11798_1180.n8 0.1875
R951 a_11798_1180.n3 a_11798_1180.n2 0.147538
R952 a_5560_3922.n0 a_5560_3922.t0 27.72
R953 a_5560_3922.n0 a_5560_3922.t1 24.1197
R954 a_5560_3922.t2 a_5560_3922.n0 9.38813
R955 a_5560_5708.n0 a_5560_5708.t2 55.2712
R956 a_5560_5708.n0 a_5560_5708.t1 27.8842
R957 a_5560_5708.t0 a_5560_5708.n0 7.50485
R958 a_6568_6136.n2 a_6568_6136.t1 19.9393
R959 a_6568_6136.n0 a_6568_6136.t4 19.6783
R960 a_6568_6136.n1 a_6568_6136.t0 17.974
R961 a_6568_6136.n2 a_6568_6136.n1 5.04317
R962 a_6568_6136.n0 a_6568_6136.t3 4.81727
R963 a_6568_6136.n1 a_6568_6136.n0 4.76157
R964 a_6568_6136.t2 a_6568_6136.n2 3.15445
R965 a_5948_4416.n0 a_5948_4416.t2 30.2902
R966 a_5948_4416.n0 a_5948_4416.t0 27.2706
R967 a_5948_4416.t1 a_5948_4416.n0 11.5346
R968 a_5905_4552.n0 a_5905_4552.t1 27.1774
R969 a_5905_4552.n2 a_5905_4552.t2 25.4059
R970 a_5905_4552.n1 a_5905_4552.t5 20.7725
R971 a_5905_4552.n1 a_5905_4552.t4 20.4909
R972 a_5905_4552.n0 a_5905_4552.t3 20.4287
R973 a_5905_4552.t0 a_5905_4552.n0 12.1418
R974 a_5905_4552.n2 a_5905_4552.n1 5.30277
R975 a_5905_4552.n0 a_5905_4552.n2 4.5269
R976 vco_bias_0.vbn_buf.n3 vco_bias_0.vbn_buf.t0 45.045
R977 vco_bias_0.vbn_buf.n2 vco_bias_0.vbn_buf.t4 34.2391
R978 vco_bias_0.vbn_buf.n2 vco_bias_0.vbn_buf.t3 28.5544
R979 vco_bias_0.vbn_buf.n1 vco_bias_0.vbn_buf.n0 22.7415
R980 vco_bias_0.vbn_buf.n0 vco_bias_0.vbn_buf.t2 21.7736
R981 vco_bias_0.vbn_buf.n4 vco_bias_0.vbn_buf.t1 17.2373
R982 vco_bias_0.vbn_buf.n4 vco_bias_0.vbn_buf.n3 13.5293
R983 vco_bias_0.vbn_buf.n3 vco_bias_0.vbn_buf.n2 6.9349
R984 vco_bias_0.vbn_buf vco_bias_0.vbn_buf.n4 2.55837
R985 vco_bias_0.vbn_buf vco_bias_0.vbn_buf.n1 0.2645
R986 vco_bias_0.vbn_buf.n1 vco_bias_0.vbn_buf 0.1985
R987 vco_bias_0.vbn_buf.n0 vco_bias_0.vbn_buf 0.1105
C74 vco_ind_LC VSS 2.32648e-14
C75 vtune VSS 3.19352e-15
C76 rf_out_p VSS 1.8492e-15
C77 rf_out_n VSS 1.82402e-15
C78 vco_buf_in_n VSS 5.51288e-15
C79 vco_buf_in_p VSS 5.47704e-15
C80 ibias_100u VSS 2.74418e-15
C81 di_en VSS 3.5159e-16
C82 vco_var_rf_p VSS 1.11584e-14
C83 vco_ind_LA VSS 4.25688e-16
C84 vco_var_rf_n VSS 1.21576e-14
C85 vco_ind_LB VSS 4.24353e-16
C86 VDD VSS 2.7711e-14
C87 vco_bias_0.vbg_buf VSS 1.1663e-13 ; **FLOATING
C88 vco_bias_0.vbn_buf VSS 1.11969e-13 ; **FLOATING
C89 vco_bias_0.vbn_buf.t2 VSS 1.23938e-15 ; **FLOATING
C90 vco_bias_0.vbn_buf.n0 VSS 1.06787e-16 ; **FLOATING
C91 vco_bias_0.vbn_buf.n1 VSS 6.05034e-17 ; **FLOATING
C92 vco_bias_0.vbn_buf.t4 VSS 5.52789e-15 ; **FLOATING
C93 vco_bias_0.vbn_buf.t3 VSS 5.52008e-15 ; **FLOATING
C94 vco_bias_0.vbn_buf.n2 VSS 1.15657e-16 ; **FLOATING
C95 vco_bias_0.vbn_buf.t0 VSS 1.96753e-15 ; **FLOATING
C96 vco_bias_0.vbn_buf.n3 VSS 1.6485e-16 ; **FLOATING
C97 vco_bias_0.vbn_buf.t1 VSS 1.6554e-17 ; **FLOATING
C98 vco_bias_0.vbn_buf.n4 VSS 1.11554e-16 ; **FLOATING
C99 a_5905_4552.n0 VSS 4.30736e-16 ; **FLOATING
C100 a_5905_4552.t3 VSS 4.68875e-17 ; **FLOATING
C101 a_5905_4552.t2 VSS 7.64974e-17 ; **FLOATING
C102 a_5905_4552.t5 VSS 4.95572e-17 ; **FLOATING
C103 a_5905_4552.t4 VSS 4.06985e-17 ; **FLOATING
C104 a_5905_4552.n1 VSS 3.43491e-16 ; **FLOATING
C105 a_5905_4552.n2 VSS 2.752e-16 ; **FLOATING
C106 a_5905_4552.t1 VSS 2.42136e-17 ; **FLOATING
C107 a_5905_4552.t0 VSS 6.15483e-17 ; **FLOATING
C108 a_5948_4416.t0 VSS 8.86242e-18 ; **FLOATING
C109 a_5948_4416.t2 VSS 4.27057e-17 ; **FLOATING
C110 a_5948_4416.n0 VSS 1.76715e-16 ; **FLOATING
C111 a_5948_4416.t1 VSS 1.92672e-17 ; **FLOATING
C112 a_6568_6136.t1 VSS 9.55676e-17 ; **FLOATING
C113 a_6568_6136.t0 VSS 3.68905e-17 ; **FLOATING
C114 a_6568_6136.t3 VSS 3.82396e-17 ; **FLOATING
C115 a_6568_6136.t4 VSS 9.51468e-17 ; **FLOATING
C116 a_6568_6136.n0 VSS 7.72401e-17 ; **FLOATING
C117 a_6568_6136.n1 VSS 1.1581e-16 ; **FLOATING
C118 a_6568_6136.n2 VSS 7.72968e-17 ; **FLOATING
C119 a_6568_6136.t2 VSS 7.59288e-17 ; **FLOATING
C120 a_5560_5708.t2 VSS 1.37511e-15 ; **FLOATING
C121 a_5560_5708.t1 VSS 4.19876e-16 ; **FLOATING
C122 a_5560_5708.n0 VSS 1.55806e-15 ; **FLOATING
C123 a_5560_5708.t0 VSS 3.93109e-16 ; **FLOATING
C124 a_5560_3922.t0 VSS 8.84189e-16 ; **FLOATING
C125 a_5560_3922.t1 VSS 3.28782e-16 ; **FLOATING
C126 a_5560_3922.n0 VSS 9.09619e-16 ; **FLOATING
C127 a_5560_3922.t2 VSS 3.01241e-16 ; **FLOATING
C128 a_11798_1180.n0 VSS 1.47186e-15 ; **FLOATING
C129 a_11798_1180.n1 VSS 2.53503e-15 ; **FLOATING
C130 a_11798_1180.n2 VSS 1.0342e-15 ; **FLOATING
C131 a_11798_1180.n3 VSS 9.74607e-16 ; **FLOATING
C132 a_11798_1180.n4 VSS 1.02142e-16 ; **FLOATING
C133 a_11798_1180.n5 VSS 1.02142e-16 ; **FLOATING
C134 a_11798_1180.n6 VSS 1.02142e-16 ; **FLOATING
C135 a_11798_1180.n7 VSS 1.02142e-16 ; **FLOATING
C136 a_11798_1180.t6 VSS 4.79679e-17 ; **FLOATING
C137 a_11798_1180.t3 VSS 5.13381e-17 ; **FLOATING
C138 a_11798_1180.t4 VSS 5.13381e-17 ; **FLOATING
C139 a_11798_1180.t5 VSS 5.13381e-17 ; **FLOATING
C140 a_11798_1180.n8 VSS 5.734e-17 ; **FLOATING
C141 a_11798_1180.n9 VSS 6.0011e-17 ; **FLOATING
C142 a_11798_1180.t1 VSS 5.13381e-17 ; **FLOATING
C143 a_11798_1180.t2 VSS 5.13381e-17 ; **FLOATING
C144 a_11798_1180.n10 VSS 5.734e-17 ; **FLOATING
C145 a_11798_1180.t0 VSS 4.79679e-17 ; **FLOATING
C146 a_11798_1180.t28 VSS 4.79679e-17 ; **FLOATING
C147 a_11798_1180.t25 VSS 5.13381e-17 ; **FLOATING
C148 a_11798_1180.t26 VSS 5.13381e-17 ; **FLOATING
C149 a_11798_1180.t27 VSS 5.13381e-17 ; **FLOATING
C150 a_11798_1180.n11 VSS 5.734e-17 ; **FLOATING
C151 a_11798_1180.n12 VSS 6.0011e-17 ; **FLOATING
C152 a_11798_1180.t23 VSS 5.13381e-17 ; **FLOATING
C153 a_11798_1180.t24 VSS 5.13381e-17 ; **FLOATING
C154 a_11798_1180.n13 VSS 5.734e-17 ; **FLOATING
C155 a_11798_1180.t22 VSS 4.79758e-17 ; **FLOATING
C156 a_11798_1180.t7 VSS 1.5469e-16 ; **FLOATING
C157 a_11798_1180.t8 VSS 1.50503e-16 ; **FLOATING
C158 a_11798_1180.t9 VSS 1.50503e-16 ; **FLOATING
C159 a_11798_1180.t10 VSS 1.50511e-16 ; **FLOATING
C160 a_11798_1180.t11 VSS 1.50511e-16 ; **FLOATING
C161 a_11798_1180.t12 VSS 1.50511e-16 ; **FLOATING
C162 a_11798_1180.t13 VSS 1.50503e-16 ; **FLOATING
C163 a_11798_1180.t14 VSS 1.50511e-16 ; **FLOATING
C164 a_11798_1180.t15 VSS 1.50503e-16 ; **FLOATING
C165 a_11798_1180.t16 VSS 1.50503e-16 ; **FLOATING
C166 a_11798_1180.t17 VSS 1.50503e-16 ; **FLOATING
C167 a_11798_1180.t18 VSS 1.50503e-16 ; **FLOATING
C168 a_11798_1180.t19 VSS 1.50511e-16 ; **FLOATING
C169 a_11798_1180.t20 VSS 1.50511e-16 ; **FLOATING
C170 a_11798_1180.t21 VSS 1.54666e-16 ; **FLOATING
C171 VDD.n0 VSS 1.06381e-16 ; **FLOATING
C172 VDD.n1 VSS 5.12687e-17 ; **FLOATING
C173 VDD.n2 VSS 9.57036e-17 ; **FLOATING
C174 VDD.n3 VSS 1.87969e-17 ; **FLOATING
C175 VDD.n4 VSS 3.07742e-17 ; **FLOATING
C176 VDD.n5 VSS 2.49734e-17 ; **FLOATING
C177 VDD.n6 VSS 2.55961e-16 ; **FLOATING
C178 VDD.n8 VSS 6.69737e-17 ; **FLOATING
C179 VDD.t8 VSS 4.81769e-17 ; **FLOATING
C180 VDD.t11 VSS 4.81769e-17 ; **FLOATING
C181 VDD.t1 VSS 3.32087e-17 ; **FLOATING
C182 VDD.t14 VSS 4.81769e-17 ; **FLOATING
C183 VDD.t15 VSS 3.45668e-17 ; **FLOATING
C184 VDD.t16 VSS 3.32087e-17 ; **FLOATING
C185 VDD.t2 VSS 3.32087e-17 ; **FLOATING
C186 VDD.t12 VSS 3.32087e-17 ; **FLOATING
C187 VDD.t13 VSS 3.32087e-17 ; **FLOATING
C188 VDD.t9 VSS 3.32087e-17 ; **FLOATING
C189 VDD.t10 VSS 3.32087e-17 ; **FLOATING
C190 VDD.n10 VSS 2.69022e-17 ; **FLOATING
C191 VDD.t0 VSS 1.71251e-15 ; **FLOATING
C192 VDD.n11 VSS 1.40456e-16 ; **FLOATING
C193 VDD.t17 VSS 1.00323e-15 ; **FLOATING
C194 VDD.t18 VSS 6.4251e-16 ; **FLOATING
C195 VDD.n12 VSS 9.65647e-16 ; **FLOATING
C196 vco_var_rf_n.n0 VSS 9.8177e-17 ; **FLOATING
C197 vco_var_rf_n.n1 VSS 2.04739e-17 ; **FLOATING
C198 vco_var_rf_n.n2 VSS 2.98595e-16 ; **FLOATING
C199 vco_var_rf_n.n3 VSS 4.67625e-16 ; **FLOATING
C200 vco_var_rf_n.t7 VSS 2.88619e-16 ; **FLOATING
C201 vco_var_rf_n.n4 VSS 3.63312e-16 ; **FLOATING
C202 vco_var_rf_n.t3 VSS 1.14703e-17 ; **FLOATING
C203 vco_var_rf_n.t2 VSS 1.14703e-17 ; **FLOATING
C204 vco_var_rf_n.t0 VSS 1.15586e-17 ; **FLOATING
C205 vco_var_rf_n.t1 VSS 1.18236e-17 ; **FLOATING
C206 vco_var_rf_n.t4 VSS 1.14703e-17 ; **FLOATING
C207 vco_var_rf_n.t5 VSS 1.76976e-15 ; **FLOATING
C208 vco_var_rf_n.n5 VSS 1.19747e-15 ; **FLOATING
C209 vco_var_rf_p.n0 VSS 9.81183e-17 ; **FLOATING
C210 vco_var_rf_p.n1 VSS 2.04595e-17 ; **FLOATING
C211 vco_var_rf_p.n2 VSS 3.06145e-16 ; **FLOATING
C212 vco_var_rf_p.n3 VSS 4.67209e-16 ; **FLOATING
C213 vco_var_rf_p.n4 VSS 3.94259e-16 ; **FLOATING
C214 vco_var_rf_p.t7 VSS 1.98432e-16 ; **FLOATING
C215 vco_var_rf_p.t4 VSS 1.18168e-17 ; **FLOATING
C216 vco_var_rf_p.t2 VSS 1.14597e-17 ; **FLOATING
C217 vco_var_rf_p.t3 VSS 1.15523e-17 ; **FLOATING
C218 vco_var_rf_p.t1 VSS 1.14597e-17 ; **FLOATING
C219 vco_var_rf_p.t0 VSS 1.14597e-17 ; **FLOATING
C220 vco_var_rf_p.t5 VSS 1.76087e-15 ; **FLOATING
C221 vco_var_rf_p.n5 VSS 1.2608e-15 ; **FLOATING
C222 di_en.t0 VSS 2.2779e-17 ; **FLOATING
C223 di_en.t1 VSS 1.86511e-17 ; **FLOATING
C224 di_en.n0 VSS 3.11119e-16 ; **FLOATING
C225 ibias_100u.t1 VSS 1.08973e-15 ; **FLOATING
C226 ibias_100u.t0 VSS 1.02584e-16 ; **FLOATING
C227 ibias_100u.t4 VSS 1.97833e-16 ; **FLOATING
C228 ibias_100u.n0 VSS 3.69584e-16 ; **FLOATING
C229 ibias_100u.t2 VSS 1.97833e-16 ; **FLOATING
C230 ibias_100u.n1 VSS 1.23647e-16 ; **FLOATING
C231 ibias_100u.t3 VSS 1.82532e-16 ; **FLOATING
C232 ibias_100u.n2 VSS 1.20866e-16 ; **FLOATING
C233 ibias_100u.n3 VSS 1.31305e-15 ; **FLOATING
C234 vco_buf_in_p.t0 VSS 3.1736e-16 ; **FLOATING
C235 vco_buf_in_p.t1 VSS 1.18541e-16 ; **FLOATING
C236 vco_buf_in_p.n0 VSS 3.13565e-16 ; **FLOATING
C237 vco_buf_in_n.t0 VSS 3.3477e-16 ; **FLOATING
C238 vco_buf_in_n.t1 VSS 1.1857e-16 ; **FLOATING
C239 vco_buf_in_n.n0 VSS 3.12735e-16 ; **FLOATING
C240 rf_out_n.n0 VSS 3.06785e-16 ; **FLOATING
C241 rf_out_n.n1 VSS 3.79983e-16 ; **FLOATING
C242 rf_out_n.t6 VSS 7.8504e-16 ; **FLOATING
C243 rf_out_n.t1 VSS 4.93021e-17 ; **FLOATING
C244 rf_out_n.t0 VSS 4.85725e-17 ; **FLOATING
C245 rf_out_n.t5 VSS 4.85725e-17 ; **FLOATING
C246 rf_out_n.t4 VSS 4.85725e-17 ; **FLOATING
C247 rf_out_n.t3 VSS 4.85725e-17 ; **FLOATING
C248 rf_out_n.t2 VSS 4.85725e-17 ; **FLOATING
C249 rf_out_n.n2 VSS 3.40354e-16 ; **FLOATING
C250 rf_out_p.n0 VSS 4.23195e-16 ; **FLOATING
C251 rf_out_p.n1 VSS 2.63693e-16 ; **FLOATING
C252 rf_out_p.t6 VSS 7.89114e-16 ; **FLOATING
C253 rf_out_p.t4 VSS 4.93098e-17 ; **FLOATING
C254 rf_out_p.t3 VSS 4.85831e-17 ; **FLOATING
C255 rf_out_p.t0 VSS 4.85831e-17 ; **FLOATING
C256 rf_out_p.t1 VSS 4.85831e-17 ; **FLOATING
C257 rf_out_p.t2 VSS 4.85831e-17 ; **FLOATING
C258 rf_out_p.t5 VSS 4.85831e-17 ; **FLOATING
C259 rf_out_p.n2 VSS 3.40413e-16 ; **FLOATING
Rpexcapstie0 vdd_core vco_ind_LC 1m
Cpexcaps0 a_5560_4008# a_5560_5708.n0 5.3e-17
Cpexcaps1 a_5905_4552.n0 a_6568_6136.n0 7.264e-17
Cpexcaps2 a_11798_1180.n0 rf_out_p 2.53404e-15
Cpexcaps3 a_5905_4552.n0 vco_bias_0.vbg_buf 1.6213e-16
Cpexcaps4 a_5560_3922.n0 a_5560_4008# 9.126e-17
Cpexcaps5 VDD a_5948_4416.n0 5.4401e-16
Cpexcaps6 a_5948_4416.n0 vco_bias_0.vbn_buf 5.771e-17
Cpexcaps7 a_11798_1180.n0 vco_buf_in_p 4.0108e-16
Cpexcaps8 a_5560_5708.n0 a_5948_4416.n0 1.6024e-16
Cpexcaps9 a_11798_1180.n0 rf_out_n 2.53404e-15
Cpexcaps10 VDD a_11798_1180.n0 1.2738e-16
Cpexcaps11 a_5560_5708.n0 di_en 3.858e-17
Cpexcaps12 a_5560_3922.n0 a_5948_4416.n0 4.656e-17
Cpexcaps13 a_11798_1180.n0 vco_bias_0.vbn_buf 6.04922e-15
Cpexcaps14 a_5560_4008# a_5905_4552.n0 3.974e-17
Cpexcaps15 a_5560_3922.n0 di_en 3.824e-17
Cpexcaps16 a_11798_1180.n0 vtune 3.5675e-16
Cpexcaps17 a_5560_5708.n0 ibias_100u 9.9498e-16
Cpexcaps18 a_5560_3922.n0 ibias_100u 5.3009e-16
Cpexcaps19 a_5948_4416.n0 a_6568_6136.n0 1.8081e-16
Cpexcaps20 a_5948_4416.n0 vco_bias_0.vbg_buf 9.547e-17
Cpexcaps21 VDD a_5560_5708.n0 8.6118e-16
Cpexcaps22 a_5905_4552.n0 a_5948_4416.n0 1.06822e-15
Cpexcaps23 VDD a_5560_3922.n0 1.1452e-16
Cpexcaps24 a_5560_5708.n0 vco_bias_0.vbn_buf 4.2469e-16
Cpexcaps25 a_6568_6136.n0 ibias_100u 7.627e-16
Cpexcaps26 a_5905_4552.n0 di_en 5.0854e-16
Cpexcaps27 a_5560_3922.n0 vco_bias_0.vbn_buf 1.1052e-16
Cpexcaps28 a_5905_4552.n0 ibias_100u 5.0957e-16
Cpexcaps29 a_5560_3922.n0 a_5560_5708.n0 1.742e-17
Cpexcaps30 VDD a_6568_6136.n0 2.10852e-15
Cpexcaps31 a_6568_6136.n0 vco_bias_0.vbn_buf 1.9969e-16
Cpexcaps32 VDD a_5905_4552.n0 5.0906e-16
Cpexcaps33 a_5560_5708.n0 a_6568_6136.n0 1.44745e-15
Cpexcaps34 a_5560_5708.n0 vco_bias_0.vbg_buf 8.219e-17
Cpexcaps35 a_5905_4552.n0 vco_bias_0.vbn_buf 2.135e-16
Cpexcaps36 a_5560_3922.n0 a_6568_6136.n0 1.989e-17
Cpexcaps37 a_5560_3922.n0 vco_bias_0.vbg_buf 9.131e-17
Cpexcaps38 a_5560_5708.n0 a_5905_4552.n0 1.3701e-16
Cpexcaps39 a_5560_3922.n0 a_5905_4552.n0 3.3637e-16
Cpexcaps40 a_5948_4416.n0 di_en 5.4427e-16
Cpexcaps41 a_6568_6136.n0 vco_bias_0.vbg_buf 6.214e-17
Cpexcaps42 a_11798_1180.n0 vco_buf_in_n 4.0108e-16
Cpexcaps43 a_1560_1090# a_5560_5708.n0 3.113e-17
.ends

* Capacitances rebuilt per net pair from the C-coupled extraction vco_top_leads_CC.spice (magic#557):
* 0.5547 pF in 160 net pairs, the full-RC run had 0.6629 pF, 0.0 fF of it between pairs without coupling.
* NGSPICE file created from vco_top_leads.ext - technology: ihp-sg13g2

.subckt vco_top_leads di_en vtune VDD VSS rf_out_p rf_out_n vco_ind_LA
+ vco_ind_LB vco_ind_LC vco_var_rf_p vco_var_rf_n vco_var_VSS
X0 VSS.t176 vco_var_rf_p.t7 vco_var_rf_n.t6 VSS.t175 sg13_lv_nmos ad=0.68p pd=4.68u as=0.38p ps=2.38u w=2u l=0.13u
X1 VSS.t96 vco_var_rf_n.t7 vco_var_rf_p.t1 VSS.t95 sg13_lv_nmos ad=0.68p pd=4.68u as=0.38p ps=2.38u w=2u l=0.13u
X2 a_20954_346.t7 vco_feed_0.en_b.t2 VDD.t19 VDD.t4 sg13_lv_pmos ad=0.57p pd=3.38u as=0.57p ps=3.38u w=3u l=0.13u
X3 VDD.t14 vco_feed_0.en_b.t2 a_20954_346.t4 VDD.t4 sg13_lv_pmos ad=0.57p pd=3.38u as=0.57p ps=3.38u w=3u l=0.13u
X4 VSS.t22 VSS.t19 VSS.t21 VSS.t20 sg13_lv_nmos ad=0.85p pd=5.68u as=0 ps=0 w=2.5u l=0.5u
X5 VDD.t16 vco_feed_0.en_b.t2 a_20954_346.t7 VDD.t4 sg13_lv_pmos ad=0.57p pd=3.38u as=0.57p ps=3.38u w=3u l=0.13u
X6 a_20954_346.t5 vco_feed_0.en_b.t2 VDD.t14 VDD.t4 sg13_lv_pmos ad=0.57p pd=3.38u as=0.57p ps=3.38u w=3u l=0.13u
X7 rf_out_n.t4 vco_buf_in_p.t1 a_11798_1180.t11 VSS.t105 sg13_lv_nmos ad=0.38p pd=2.38u as=0.38p ps=2.38u w=2u l=0.13u
X8 VDD.t28 vco_feed_0.en_b.t2 a_20954_346.t10 VDD.t4 sg13_lv_pmos ad=0.57p pd=3.38u as=0.57p ps=3.38u w=3u l=0.13u
X9 a_20954_346.t8 vco_feed_0.en_b.t2 VDD.t16 VDD.t4 sg13_lv_pmos ad=0.57p pd=3.38u as=0.57p ps=3.38u w=3u l=0.13u
X10 rf_out_n.t2 vco_buf_in_p.t1 a_11798_1180.t9 VSS.t101 sg13_lv_nmos ad=0.38p pd=2.38u as=0.38p ps=2.38u w=2u l=0.13u
X11 VSS.t154 vco_bias_0.vbn_buf.t2 a_11798_1180.t26 VSS.t153 sg13_lv_nmos ad=0.95p pd=5.38u as=0.95p ps=5.38u w=5u l=0.5u
X12 a_11798_1180.t24 vco_bias_0.vbn_buf.t2 VSS.t145 VSS.t144 sg13_lv_nmos ad=0.95p pd=5.38u as=0.95p ps=5.38u w=5u l=0.5u
X13 a_11798_1180.t14 vco_bias_0.vbn_buf.t2 VSS.t118 VSS.t117 sg13_lv_nmos ad=0.95p pd=5.38u as=1.7p ps=10.68u w=5u l=0.5u
X14 VSS.t4 vco_bias_0.vbn_buf.t3 VSS.t2 VSS.t3 sg13_lv_nmos ad=1.52p pd=8.38u as=0 ps=0 w=8u l=10u
X15 a_5060_3002.t1 a_5060_3002.t0 VSS.t13 VSS.t12 sg13_lv_nmos ad=0.85p pd=5.68u as=0.85p ps=5.68u w=2.5u l=0.5u
X16 VSS.t8 vco_bias_0.vbn_buf.t3 VSS.t6 VSS.t7 sg13_lv_nmos ad=1.52p pd=8.38u as=0 ps=0 w=8u l=10u
X17 VSS.t127 vco_bias_0.vbn_buf.t2 a_11798_1180.t17 VSS.t126 sg13_lv_nmos ad=0.95p pd=5.38u as=0.95p ps=5.38u w=5u l=0.5u
X18 VSS.t170 vco_var_rf_p.t7 vco_var_rf_n.t3 VSS.t169 sg13_lv_nmos ad=0.38p pd=2.38u as=0.38p ps=2.38u w=2u l=0.13u
X19 vco_bias_0.vbn_buf.t0 vco_feed_0.en_b.t3 VSS.t54 VSS.t53 sg13_lv_nmos ad=0.34p pd=2.68u as=0.34p ps=2.68u w=1u l=0.13u
X20 a_11798_1180.t2 vco_buf_in_n.t1 rf_out_p.t4 VSS.t72 sg13_lv_nmos ad=0.38p pd=2.38u as=0.38p ps=2.38u w=2u l=0.13u
X21 VSS.t62 vco_bias_0.vbn_buf.t4 VSS.t60 VSS.t5 sg13_lv_nmos ad=1.52p pd=8.38u as=0 ps=0 w=8u l=10u
X22 a_20954_346.t11 vco_feed_0.en_b.t2 VDD.t28 VDD.t4 sg13_lv_pmos ad=0.57p pd=3.38u as=0.57p ps=3.38u w=3u l=0.13u
X23 VDD.t22 vco_feed_0.en_b.t2 a_20954_346.t8 VDD.t4 sg13_lv_pmos ad=0.57p pd=3.38u as=0.57p ps=3.38u w=3u l=0.13u
X24 rf_out_p.t2 vco_buf_in_n.t1 a_11798_1180.t0 VSS.t69 sg13_lv_nmos ad=0.38p pd=2.38u as=0.68p ps=4.68u w=2u l=0.13u
X25 VSS.t28 vco_bias_0.vbg_buf VSS.t27 VSS.t0 sg13_lv_nmos ad=2.72p pd=16.68u as=0 ps=0 w=8u l=10u
X26 a_5948_4416.t0 vco_feed_0.en_b.t7 VDD.t37 VDD.t0 sg13_lv_pmos ad=0.34p pd=2.68u as=0.34p ps=2.68u w=1u l=0.13u
X27 VSS.t44 vco_bias_0.vbg_buf VSS.t42 VSS.t7 sg13_lv_nmos ad=1.52p pd=8.38u as=0 ps=0 w=8u l=10u
X28 a_5560_5708.t0 a_5560_3922.t2 VSS.t11 rppd l=8.5u w=0.5u
X29 a_5060_3002.t2 vco_feed_0.en_b.t4 VSS.t51 VSS.t50 sg13_lv_nmos ad=0.34p pd=2.68u as=0.34p ps=2.68u w=1u l=0.13u
X30 VSS.t87 vco_var_rf_n.t7 vco_var_rf_p.t3 VSS.t86 sg13_lv_nmos ad=0.38p pd=2.38u as=0.38p ps=2.38u w=2u l=0.13u
X31 vco_var_rf_n.t5 vco_var_rf_p.t7 VSS.t170 VSS.t171 sg13_lv_nmos ad=0.38p pd=2.38u as=0.38p ps=2.38u w=2u l=0.13u
X32 vco_var_rf_n.t2 vco_var_rf_p.t7 VSS.t164 VSS.t165 sg13_lv_nmos ad=0.38p pd=2.38u as=0.38p ps=2.38u w=2u l=0.13u
X33 vco_bias_0.vbg_buf a_5560_5708.t2 VSS.t181 rhigh l=32u w=0.5u
X34 vco_var_rf_p.t0 vco_var_rf_n.t7 VSS.t90 VSS.t91 sg13_lv_nmos ad=0.38p pd=2.38u as=0.38p ps=2.38u w=2u l=0.13u
X35 vco_feed_0.en_b.t0 di_en.t0 VSS.t114 VSS.t113 sg13_lv_nmos ad=0.17p pd=1.68u as=0.17p ps=1.68u w=0.5u l=0.13u
X36 VDD.t30 vco_feed_0.en_b.t2 a_20954_346.t11 VDD.t4 sg13_lv_pmos ad=0.57p pd=3.38u as=0.57p ps=3.38u w=3u l=0.13u
X37 a_20954_346.t9 vco_feed_0.en_b.t2 VDD.t22 VDD.t4 sg13_lv_pmos ad=0.57p pd=3.38u as=0.57p ps=3.38u w=3u l=0.13u
X38 a_11798_1180.t5 vco_buf_in_n.t1 rf_out_p.t5 VSS.t78 sg13_lv_nmos ad=0.38p pd=2.38u as=0.38p ps=2.38u w=2u l=0.13u
X39 VSS.t42 vco_bias_0.vbg_buf VSS.t40 VSS.t5 sg13_lv_nmos ad=1.52p pd=8.38u as=0 ps=0 w=8u l=10u
X40 VSS.t145 vco_bias_0.vbn_buf.t2 a_11798_1180.t23 VSS.t148 sg13_lv_nmos ad=0.95p pd=5.38u as=0.95p ps=5.38u w=5u l=0.5u
X41 vco_bias_0.vbg_buf VSS.t23 cap_cmim l=19.1u w=17.5u
X42 VSS.t120 vco_bias_0.vbn_buf.t2 a_11798_1180.t14 VSS.t119 sg13_lv_nmos ad=0.95p pd=5.38u as=0.95p ps=5.38u w=5u l=0.5u
X43 a_11798_1180.t27 vco_bias_0.vbn_buf.t2 VSS.t154 VSS.t159 sg13_lv_nmos ad=0.95p pd=5.38u as=0.95p ps=5.38u w=5u l=0.5u
X44 vco_bias_0.vbn_buf.t1 a_5060_3002.t4 VSS.t68 rhigh l=32u w=0.5u
X45 a_11798_1180.t28 vco_bias_0.vbn_buf.t2 VSS.t156 VSS.t155 sg13_lv_nmos ad=0.95p pd=5.38u as=0.95p ps=5.38u w=5u l=0.5u
X46 a_20954_346.t12 vco_feed_0.en_b.t2 VDD.t30 VDD.t4 sg13_lv_pmos ad=0.57p pd=3.38u as=0.57p ps=3.38u w=3u l=0.13u
X47 VDD.t24 vco_feed_0.en_b.t2 a_20954_346.t9 VDD.t4 sg13_lv_pmos ad=0.57p pd=3.38u as=0.57p ps=3.38u w=3u l=0.13u
X48 VDD.t27 vco_feed_0.en_b.t2 a_20954_346.t12 VDD.t4 sg13_lv_pmos ad=0.57p pd=3.38u as=0.57p ps=3.38u w=3u l=0.13u
X49 a_20954_346.t10 vco_feed_0.en_b.t2 VDD.t24 VDD.t4 sg13_lv_pmos ad=0.57p pd=3.38u as=0.57p ps=3.38u w=3u l=0.13u
X50 VSS.t6 vco_bias_0.vbn_buf.t3 VSS.t4 VSS.t5 sg13_lv_nmos ad=1.52p pd=8.38u as=0 ps=0 w=8u l=10u
X51 a_11798_1180.t12 vco_buf_in_p.t1 rf_out_n.t4 VSS.t106 sg13_lv_nmos ad=0.38p pd=2.38u as=0.38p ps=2.38u w=2u l=0.13u
X52 VDD.t36 vco_feed_0.en_b.t2 a_20954_346.t15 VDD.t4 sg13_lv_pmos ad=1.02p pd=6.68u as=0.57p ps=3.38u w=3u l=0.13u
X53 a_20954_346.t13 vco_feed_0.en_b.t2 VDD.t27 VDD.t4 sg13_lv_pmos ad=0.57p pd=3.38u as=0.57p ps=3.38u w=3u l=0.13u
X54 a_11798_1180.t18 vco_bias_0.vbn_buf.t2 VSS.t127 VSS.t128 sg13_lv_nmos ad=0.95p pd=5.38u as=0.95p ps=5.38u w=5u l=0.5u
X55 a_11798_1180.t10 vco_buf_in_p.t1 rf_out_n.t2 VSS.t102 sg13_lv_nmos ad=0.38p pd=2.38u as=0.38p ps=2.38u w=2u l=0.13u
X56 VSS.t30 vco_bias_0.vbg_buf VSS.t28 VSS.t3 sg13_lv_nmos ad=1.52p pd=8.38u as=0 ps=0 w=8u l=10u
X57 VSS.t139 vco_bias_0.vbn_buf.t2 a_11798_1180.t21 VSS.t138 sg13_lv_nmos ad=0.95p pd=5.38u as=0.95p ps=5.38u w=5u l=0.5u
X58 VSS.t46 vco_bias_0.vbg_buf VSS.t44 VSS.t9 sg13_lv_nmos ad=1.52p pd=8.38u as=0 ps=0 w=8u l=10u
X59 VDD.t44 VDD.t42 VDD.t43 VDD.t0 sg13_lv_pmos ad=1.7p pd=10.68u as=0 ps=0 w=5u l=0.5u
X60 VSS.t156 vco_bias_0.vbn_buf.t2 a_11798_1180.t27 VSS.t160 sg13_lv_nmos ad=0.95p pd=5.38u as=0.95p ps=5.38u w=5u l=0.5u
X61 VSS.t173 vco_var_rf_p.t7 vco_var_rf_n.t5 VSS.t172 sg13_lv_nmos ad=0.38p pd=2.38u as=0.38p ps=2.38u w=2u l=0.13u
X62 VSS.t158 vco_bias_0.vbn_buf.t2 a_11798_1180.t28 VSS.t157 sg13_lv_nmos ad=1.7p pd=10.68u as=0.95p ps=5.38u w=5u l=0.5u
X63 VSS.t58 vco_bias_0.vbn_buf.t4 VSS.t57 VSS.t0 sg13_lv_nmos ad=2.72p pd=16.68u as=0 ps=0 w=8u l=10u
X64 VSS.t93 vco_var_rf_n.t7 vco_var_rf_p.t0 VSS.t92 sg13_lv_nmos ad=0.38p pd=2.38u as=0.38p ps=2.38u w=2u l=0.13u
X65 VDD.t33 vco_feed_0.en_b.t2 a_20954_346.t13 VDD.t4 sg13_lv_pmos ad=0.57p pd=3.38u as=0.57p ps=3.38u w=3u l=0.13u
X66 VDD.t41 VDD.t39 VDD.t40 VDD.t0 sg13_lv_pmos ad=0.34p pd=2.68u as=0 ps=0 w=1u l=0.13u
X67 VDD.t38 rf_out_p.t6 VSS.t67 rppd l=1.65u w=10u
X68 a_6568_6136.t3 a_5948_4416.t2 VDD.t50 VDD.t0 sg13_lv_pmos ad=0.34p pd=2.68u as=0.34p ps=2.68u w=1u l=0.13u
X69 a_20954_346.t14 vco_feed_0.en_b.t2 VDD.t33 VDD.t4 sg13_lv_pmos ad=0.57p pd=3.38u as=0.57p ps=3.38u w=3u l=0.13u
X70 rf_out_p.t3 vco_buf_in_n.t1 a_11798_1180.t5 VSS.t79 sg13_lv_nmos ad=0.38p pd=2.38u as=0.38p ps=2.38u w=2u l=0.13u
X71 vco_feed_0.en_b.t1 di_en.t1 VDD.t48 VDD.t0 sg13_lv_pmos ad=0.34p pd=2.68u as=0.34p ps=2.68u w=1u l=0.13u
X72 a_11798_1180.t21 vco_bias_0.vbn_buf.t2 VSS.t136 VSS.t137 sg13_lv_nmos ad=0.95p pd=5.38u as=0.95p ps=5.38u w=5u l=0.5u
X73 rf_out_p.t1 vco_buf_in_n.t1 a_11798_1180.t3 VSS.t75 sg13_lv_nmos ad=0.38p pd=2.38u as=0.38p ps=2.38u w=2u l=0.13u
X74 VSS.t66 vco_bias_0.vbn_buf.t4 VSS.t64 VSS.t9 sg13_lv_nmos ad=1.52p pd=8.38u as=0 ps=0 w=8u l=10u
X75 vco_var_rf_p.t4 vco_var_rf_n.t7 VSS.t87 VSS.t88 sg13_lv_nmos ad=0.38p pd=2.38u as=0.38p ps=2.38u w=2u l=0.13u
X76 VSS.t147 vco_bias_0.vbn_buf.t2 a_11798_1180.t24 VSS.t149 sg13_lv_nmos ad=0.95p pd=5.38u as=0.95p ps=5.38u w=5u l=0.5u
X77 a_11798_1180.t22 vco_bias_0.vbn_buf.t2 VSS.t139 VSS.t140 sg13_lv_nmos ad=0.95p pd=5.38u as=0.95p ps=5.38u w=5u l=0.5u
X78 vco_var_rf_p.t2 vco_var_rf_n.t7 VSS.t82 VSS.t81 sg13_lv_nmos ad=0.38p pd=2.38u as=0.68p ps=4.68u w=2u l=0.13u
X79 VSS.t151 vco_bias_0.vbn_buf.t2 a_11798_1180.t25 VSS.t150 sg13_lv_nmos ad=0.95p pd=5.38u as=0.95p ps=5.38u w=5u l=0.5u
X80 VSS.t167 vco_var_rf_p.t7 vco_var_rf_n.t2 VSS.t166 sg13_lv_nmos ad=0.38p pd=2.38u as=0.38p ps=2.38u w=2u l=0.13u
X81 VDD.t26 vco_feed_0.en_b.t2 a_20954_346.t14 VDD.t4 sg13_lv_pmos ad=0.57p pd=3.38u as=0.57p ps=3.38u w=3u l=0.13u
X82 rf_out_n.t6 vco_buf_in_p.t1 a_11798_1180.t7 VSS.t97 sg13_lv_nmos ad=0.38p pd=2.38u as=0.68p ps=4.68u w=2u l=0.13u
X83 a_5560_5708.t1 a_6568_6136.t4 VDD.t49 VDD.t0 sg13_lv_pmos ad=1.7p pd=10.68u as=1.7p ps=10.68u w=5u l=0.5u
X84 VSS.t84 vco_var_rf_n.t7 vco_var_rf_p.t2 VSS.t83 sg13_lv_nmos ad=0.38p pd=2.38u as=0.38p ps=2.38u w=2u l=0.13u
X85 VSS.t2 vco_bias_0.vbn_buf.t3 VSS.t1 VSS.t0 sg13_lv_nmos ad=2.72p pd=16.68u as=0 ps=0 w=8u l=10u
X86 a_20954_346.t15 vco_feed_0.en_b.t2 VDD.t26 VDD.t4 sg13_lv_pmos ad=0.57p pd=3.38u as=0.57p ps=3.38u w=3u l=0.13u
X87 rf_out_n.t5 vco_buf_in_p.t1 a_11798_1180.t12 VSS.t107 sg13_lv_nmos ad=0.38p pd=2.38u as=0.38p ps=2.38u w=2u l=0.13u
X88 VSS.t38 vco_bias_0.vbg_buf VSS.t37 VSS.t0 sg13_lv_nmos ad=2.72p pd=16.68u as=0 ps=0 w=8u l=10u
X89 rf_out_n.t3 vco_buf_in_p.t1 a_11798_1180.t10 VSS.t103 sg13_lv_nmos ad=0.38p pd=2.38u as=0.38p ps=2.38u w=2u l=0.13u
X90 a_5060_5708.t0 vco_feed_0.en_b.t6 VDD.t2 VDD.t0 sg13_lv_pmos ad=0.68p pd=4.68u as=0.68p ps=4.68u w=2u l=0.13u
X91 VSS.t122 vco_bias_0.vbn_buf.t2 a_11798_1180.t15 VSS.t124 sg13_lv_nmos ad=0.95p pd=5.38u as=0.95p ps=5.38u w=5u l=0.5u
X92 VDD.t6 vco_feed_0.en_b.t2 a_20954_346.t0 VDD.t4 sg13_lv_pmos ad=0.57p pd=3.38u as=0.57p ps=3.38u w=3u l=0.13u
X93 a_11798_1180.t19 vco_bias_0.vbn_buf.t2 VSS.t130 VSS.t131 sg13_lv_nmos ad=0.95p pd=5.38u as=0.95p ps=5.38u w=5u l=0.5u
X94 a_11798_1180.t25 vco_bias_0.vbn_buf.t2 VSS.t147 VSS.t146 sg13_lv_nmos ad=0.95p pd=5.38u as=0.95p ps=5.38u w=5u l=0.5u
X95 a_11798_1180.t26 vco_bias_0.vbn_buf.t2 VSS.t151 VSS.t152 sg13_lv_nmos ad=0.95p pd=5.38u as=0.95p ps=5.38u w=5u l=0.5u
X96 vco_buf_in_p vco_var_rf_p.t5 cap_cmim l=10u w=10u
X97 a_20954_346.t1 vco_feed_0.en_b.t2 VDD.t6 VDD.t4 sg13_lv_pmos ad=0.57p pd=3.38u as=0.57p ps=3.38u w=3u l=0.13u
X98 a_11798_1180.t1 vco_buf_in_n.t1 rf_out_p.t2 VSS.t70 sg13_lv_nmos ad=0.38p pd=2.38u as=0.38p ps=2.38u w=2u l=0.13u
X99 VSS.t10 vco_bias_0.vbn_buf.t3 VSS.t8 VSS.t9 sg13_lv_nmos ad=1.52p pd=8.38u as=0 ps=0 w=8u l=10u
X100 VSS.t18 VSS.t15 VSS.t17 VSS.t16 sg13_lv_nmos ad=0.85p pd=5.68u as=0 ps=0 w=2.5u l=0.5u
X101 vco_var_rf_n.t6 vco_var_rf_p.t7 VSS.t173 VSS.t174 sg13_lv_nmos ad=0.38p pd=2.38u as=0.38p ps=2.38u w=2u l=0.13u
X102 vco_var_rf_p.t1 vco_var_rf_n.t7 VSS.t93 VSS.t94 sg13_lv_nmos ad=0.38p pd=2.38u as=0.38p ps=2.38u w=2u l=0.13u
X103 a_11798_1180.t15 vco_bias_0.vbn_buf.t2 VSS.t120 VSS.t123 sg13_lv_nmos ad=0.95p pd=5.38u as=0.95p ps=5.38u w=5u l=0.5u
X104 VDD.t8 vco_feed_0.en_b.t2 a_20954_346.t1 VDD.t4 sg13_lv_pmos ad=0.57p pd=3.38u as=0.57p ps=3.38u w=3u l=0.13u
X105 VSS.t130 vco_bias_0.vbn_buf.t2 a_11798_1180.t18 VSS.t129 sg13_lv_nmos ad=0.95p pd=5.38u as=0.95p ps=5.38u w=5u l=0.5u
X106 a_11798_1180.t16 vco_bias_0.vbn_buf.t2 VSS.t122 VSS.t121 sg13_lv_nmos ad=0.95p pd=5.38u as=0.95p ps=5.38u w=5u l=0.5u
X107 a_11798_1180.t4 vco_buf_in_n.t1 rf_out_p.t1 VSS.t76 sg13_lv_nmos ad=0.38p pd=2.38u as=0.38p ps=2.38u w=2u l=0.13u
X108 rf_out_p.t0 vco_buf_in_n.t1 a_11798_1180.t2 VSS.t73 sg13_lv_nmos ad=0.38p pd=2.38u as=0.38p ps=2.38u w=2u l=0.13u
X109 VSS.t34 vco_bias_0.vbg_buf VSS.t32 VSS.t7 sg13_lv_nmos ad=1.52p pd=8.38u as=0 ps=0 w=8u l=10u
X110 VDD.t47 VDD.t45 VDD.t46 VDD.t0 sg13_lv_pmos ad=1.7p pd=10.68u as=0 ps=0 w=5u l=0.5u
X111 vco_buf_in_n vco_var_rf_n.t0 cap_cmim l=10u w=10u
X112 VSS.t133 vco_bias_0.vbn_buf.t2 a_11798_1180.t19 VSS.t132 sg13_lv_nmos ad=0.95p pd=5.38u as=0.95p ps=5.38u w=5u l=0.5u
X113 a_11798_1180.t23 vco_bias_0.vbn_buf.t2 VSS.t142 VSS.t143 sg13_lv_nmos ad=0.95p pd=5.38u as=0.95p ps=5.38u w=5u l=0.5u
X114 a_5560_3922.t1 a_5560_3922.t0 VSS.t56 VSS.t55 sg13_lv_nmos ad=0.85p pd=5.68u as=0.85p ps=5.68u w=2.5u l=0.5u
X115 a_11798_1180.t8 vco_buf_in_p.t1 rf_out_n.t6 VSS.t98 sg13_lv_nmos ad=0.38p pd=2.38u as=0.38p ps=2.38u w=2u l=0.13u
X116 VSS.t40 vco_bias_0.vbg_buf VSS.t38 VSS.t3 sg13_lv_nmos ad=1.52p pd=8.38u as=0 ps=0 w=8u l=10u
X117 a_20954_346.t2 vco_feed_0.en_b.t2 VDD.t8 VDD.t4 sg13_lv_pmos ad=0.57p pd=3.38u as=0.57p ps=3.38u w=3u l=0.13u
X118 VSS.t32 vco_bias_0.vbg_buf VSS.t30 VSS.t5 sg13_lv_nmos ad=1.52p pd=8.38u as=0 ps=0 w=8u l=10u
X119 VSS.t90 vco_var_rf_n.t7 vco_var_rf_p.t4 VSS.t89 sg13_lv_nmos ad=0.38p pd=2.38u as=0.38p ps=2.38u w=2u l=0.13u
X120 a_6568_6136.t2 a_6568_6136.t1 VDD.t1 VDD.t0 sg13_lv_pmos ad=1.7p pd=10.68u as=1.7p ps=10.68u w=5u l=0.5u
X121 vco_var_rf_n.t3 vco_var_rf_p.t7 VSS.t167 VSS.t168 sg13_lv_nmos ad=0.38p pd=2.38u as=0.38p ps=2.38u w=2u l=0.13u
X122 a_11798_1180.t13 vco_buf_in_p.t1 rf_out_n.t5 VSS.t108 sg13_lv_nmos ad=0.68p pd=4.68u as=0.38p ps=2.38u w=2u l=0.13u
X123 vco_var_rf_n.t4 vco_var_rf_p.t7 VSS.t162 VSS.t161 sg13_lv_nmos ad=0.38p pd=2.38u as=0.68p ps=4.68u w=2u l=0.13u
X124 vco_ind_LC.t1 VSS.t109 cap_cmim l=39u w=56u
X125 VDD.t10 vco_feed_0.en_b.t2 a_20954_346.t2 VDD.t4 sg13_lv_pmos ad=0.57p pd=3.38u as=0.57p ps=3.38u w=3u l=0.13u
X126 a_11798_1180.t11 vco_buf_in_p.t1 rf_out_n.t3 VSS.t104 sg13_lv_nmos ad=0.38p pd=2.38u as=0.38p ps=2.38u w=2u l=0.13u
X127 a_20954_346.t0 vco_feed_0.en_b.t2 VDD.t5 VDD.t4 sg13_lv_pmos ad=0.57p pd=3.38u as=1.02p ps=6.68u w=3u l=0.13u
X128 VDD.t15 vco_feed_0.en_b.t2 a_20954_346.t5 VDD.t4 sg13_lv_pmos ad=0.57p pd=3.38u as=0.57p ps=3.38u w=3u l=0.13u
X129 a_11798_1180.t9 vco_buf_in_p.t1 rf_out_n.t1 VSS.t100 sg13_lv_nmos ad=0.38p pd=2.38u as=0.38p ps=2.38u w=2u l=0.13u
X130 vco_bias_0.vbg_buf vco_buf_in_n.t0 VSS.t14 rhigh l=8u w=0.5u
X131 a_20954_346.t3 vco_feed_0.en_b.t2 VDD.t10 VDD.t4 sg13_lv_pmos ad=0.57p pd=3.38u as=0.57p ps=3.38u w=3u l=0.13u
X132 VSS.t116 vco_bias_0.vbn_buf.t2 a_11798_1180.t16 VSS.t115 sg13_lv_nmos ad=0.95p pd=5.38u as=0.95p ps=5.38u w=5u l=0.5u
X133 a_6568_6136.t0 a_5060_3002.t5 VSS.t49 VSS.t48 sg13_lv_nmos ad=0.85p pd=5.68u as=0.85p ps=5.68u w=2.5u l=0.5u
X134 vco_var_rf_p.t3 vco_var_rf_n.t7 VSS.t84 VSS.t85 sg13_lv_nmos ad=0.38p pd=2.38u as=0.38p ps=2.38u w=2u l=0.13u
X135 VSS.t142 vco_bias_0.vbn_buf.t2 a_11798_1180.t22 VSS.t141 sg13_lv_nmos ad=0.95p pd=5.38u as=0.95p ps=5.38u w=5u l=0.5u
X136 a_11798_1180.t20 vco_bias_0.vbn_buf.t2 VSS.t133 VSS.t134 sg13_lv_nmos ad=0.95p pd=5.38u as=0.95p ps=5.38u w=5u l=0.5u
X137 VSS.t164 vco_var_rf_p.t7 vco_var_rf_n.t4 VSS.t163 sg13_lv_nmos ad=0.38p pd=2.38u as=0.38p ps=2.38u w=2u l=0.13u
X138 a_5948_4416.t1 vco_feed_0.en_b.t5 VSS.t179 VSS.t178 sg13_lv_nmos ad=0.17p pd=1.68u as=0.17p ps=1.68u w=0.5u l=0.13u
X139 vco_bias_0.vbg_buf VSS.t25 cap_cmim l=7.28u w=13.6u
X140 a_20954_346.t16 vco_ind_LC.t0 VSS.t180 rppd l=8.8u w=17.3u
X141 rf_out_p.t4 vco_buf_in_n.t1 a_11798_1180.t1 VSS.t71 sg13_lv_nmos ad=0.38p pd=2.38u as=0.38p ps=2.38u w=2u l=0.13u
X142 a_20954_346.t6 vco_feed_0.en_b.t2 VDD.t15 VDD.t4 sg13_lv_pmos ad=0.57p pd=3.38u as=0.57p ps=3.38u w=3u l=0.13u
X143 VDD.t12 vco_feed_0.en_b.t2 a_20954_346.t3 VDD.t4 sg13_lv_pmos ad=0.57p pd=3.38u as=0.57p ps=3.38u w=3u l=0.13u
X144 VDD.t3 rf_out_n.t0 VSS.t47 rppd l=1.65u w=10u
X145 VSS.t36 vco_bias_0.vbg_buf VSS.t34 VSS.t9 sg13_lv_nmos ad=1.52p pd=8.38u as=0 ps=0 w=8u l=10u
X146 VSS.t60 vco_bias_0.vbn_buf.t4 VSS.t58 VSS.t3 sg13_lv_nmos ad=1.52p pd=8.38u as=0 ps=0 w=8u l=10u
X147 VSS.t64 vco_bias_0.vbn_buf.t4 VSS.t62 VSS.t7 sg13_lv_nmos ad=1.52p pd=8.38u as=0 ps=0 w=8u l=10u
X148 vco_ind_LC.t1 VSS.t111 cap_cmim l=25.5u w=42u
X149 VDD.t19 vco_feed_0.en_b.t2 a_20954_346.t6 VDD.t4 sg13_lv_pmos ad=0.57p pd=3.38u as=0.57p ps=3.38u w=3u l=0.13u
X150 a_20954_346.t4 vco_feed_0.en_b.t2 VDD.t12 VDD.t4 sg13_lv_pmos ad=0.57p pd=3.38u as=0.57p ps=3.38u w=3u l=0.13u
X151 a_11798_1180.t6 vco_buf_in_n.t1 rf_out_p.t3 VSS.t80 sg13_lv_nmos ad=0.68p pd=4.68u as=0.38p ps=2.38u w=2u l=0.13u
X152 a_5060_5708.t1 a_5060_3002.t3 VSS.t52 rppd l=13.1u w=0.5u
X153 rf_out_p.t5 vco_buf_in_n.t1 a_11798_1180.t4 VSS.t77 sg13_lv_nmos ad=0.38p pd=2.38u as=0.38p ps=2.38u w=2u l=0.13u
X154 vco_bias_0.vbg_buf vco_buf_in_p.t0 VSS.t177 rhigh l=8u w=0.5u
X155 a_11798_1180.t3 vco_buf_in_n.t1 rf_out_p.t0 VSS.t74 sg13_lv_nmos ad=0.38p pd=2.38u as=0.38p ps=2.38u w=2u l=0.13u
X156 a_11798_1180.t17 vco_bias_0.vbn_buf.t2 VSS.t116 VSS.t125 sg13_lv_nmos ad=0.95p pd=5.38u as=0.95p ps=5.38u w=5u l=0.5u
X157 VSS.t136 vco_bias_0.vbn_buf.t2 a_11798_1180.t20 VSS.t135 sg13_lv_nmos ad=0.95p pd=5.38u as=0.95p ps=5.38u w=5u l=0.5u
X158 rf_out_n.t1 vco_buf_in_p.t1 a_11798_1180.t8 VSS.t99 sg13_lv_nmos ad=0.38p pd=2.38u as=0.38p ps=2.38u w=2u l=0.13u
C0 vco_feed_0.en_b vco_bias_0.vbg_buf 1.7737e-16
C1 vco_buf_in_p vco_var_rf_p 1.68023e-15
C2 a_10100_3480# rf_out_n 6.9013e-16
C3 a_16500_3480# vco_buf_in_n 2.469e-17
C4 vco_bias_0.vbg_buf vco_bias_0.vbn_buf 4.94304e-15
C5 vco_bias_0.vbn_buf vco_buf_in_n 1.754e-17
C6 VDD di_en 5.9914e-16
C7 vco_buf_in_n rf_out_p 8.6364e-16
C8 a_9450_4480# vco_buf_in_p 3.458e-17
C9 rf_out_n vco_var_rf_p 5.799e-17
C10 vtune vco_var_rf_n 5.282e-17
C11 vco_feed_0.en_b di_en 5.0415e-16
C12 vco_bias_0.vbn_buf di_en 1.1188e-16
C13 vco_bias_0.vbg_buf vco_var_rf_p 8.721e-16
C14 VDD a_24640_164# 4.569e-17
C15 a_1560_1090# vco_bias_0.vbg_buf 6.101e-17
C16 a_9450_4480# vco_bias_0.vbg_buf 4.475e-17
C17 vco_ind_LC vco_var_rf_p 5.494e-16
C18 vco_bias_0.vbg_buf vco_var_rf_n 5.8809e-16
C19 VDD a_16500_3480# 3.9132e-16
C20 VDD vco_feed_0.en_b 5.96589e-15
C21 vco_buf_in_n vco_var_rf_n 1.68023e-15
C22 VDD vco_bias_0.vbn_buf 1.61103e-15
C23 vco_buf_in_p vtune 1.8112e-16
C24 VDD rf_out_p 2.82306e-15
C25 a_1160_1390# vco_bias_0.vbg_buf 5.206e-17
C26 vco_ind_LC vco_var_rf_n 1.02141e-15
C27 rf_out_n vtune 3.484e-17
C28 vco_feed_0.en_b vco_bias_0.vbn_buf 1.04162e-15
C29 a_16500_3480# rf_out_p 6.9013e-16
C30 vco_feed_0.en_b rf_out_p 7.782e-17
C31 rf_out_n vco_buf_in_p 8.6364e-16
C32 VDD a_10100_3480# 3.9132e-16
C33 vco_bias_0.vbn_buf rf_out_p 2.0879e-16
C34 VDD vco_var_rf_p 1.3774e-16
C35 a_1560_1090# VDD 2.35e-17
C36 vco_bias_0.vbg_buf vtune 1.3019e-16
C37 a_5560_4008# vco_bias_0.vbg_buf 1.107e-17
C38 vco_buf_in_n vtune 1.8112e-16
C39 vco_bias_0.vbg_buf vco_buf_in_p 6.224e-17
C40 vco_buf_in_n vco_buf_in_p 1.7478e-16
C41 VDD vco_var_rf_n 1.3774e-16
C42 vco_bias_0.vbn_buf vco_var_rf_p 2.834e-16
C43 a_1160_1390# VDD 1.323e-17
C44 a_9450_4480# vco_bias_0.vbn_buf 1.693e-17
C45 a_5560_4008# a_5060_3088# 2.516e-17
C46 vco_bias_0.vbn_buf vco_var_rf_n 2.147e-17
C47 rf_out_p vco_var_rf_n 5.799e-17
C48 vco_bias_0.vbg_buf vco_buf_in_n 5.315e-17
C49 a_1160_1390# vco_bias_0.vbn_buf 2.9e-17
C50 vco_bias_0.vbg_buf vco_ind_LC 2.913e-17
C51 VDD vtune 1.1507e-16
C52 vco_bias_0.vbg_buf a_19050_4480# 4.459e-17
C53 VDD a_5560_4008# 3.954e-17
C54 vco_ind_LC vco_buf_in_n 1.048e-17
C55 vco_buf_in_n a_19050_4480# 3.458e-17
C56 VDD vco_buf_in_p 6.3222e-16
C57 vco_var_rf_p vco_var_rf_n 4.00797e-15
C58 vco_bias_0.vbg_buf di_en 2.11143e-15
C59 vco_ind_LC a_19050_4480# 1.117e-17
C60 vco_bias_0.vbg_buf a_5060_3088# 1.628e-17
C61 vco_feed_0.en_b vtune 9.037e-17
C62 VDD rf_out_n 2.80242e-15
C63 a_5560_4008# vco_feed_0.en_b 4.005e-17
C64 a_1160_1390# a_1560_1090# 1.7942e-16
C65 vco_bias_0.vbn_buf vtune 6.767e-17
C66 vtune rf_out_p 3.484e-17
C67 vco_bias_0.vbn_buf vco_buf_in_p 3.118e-17
C68 vco_feed_0.en_b rf_out_n 7.832e-17
C69 vco_bias_0.vbn_buf rf_out_n 2.9297e-16
C70 VDD vco_bias_0.vbg_buf 2.36676e-15
C71 rf_out_n rf_out_p 1.393e-17
C72 VDD vco_buf_in_n 6.3222e-16
C73 vtune vco_var_rf_p 1.0305e-16
C74 a_10100_3480# vco_buf_in_p 2.469e-17
C75 vco_ind_LC a_24640_164# 1.18592e-15
C76 VDD vco_ind_LC 2.0001e-16
R0 vco_ind_LC.t1 vco_ind_LC.t0 1.63487
R1 vco_ind_LC vco_ind_LC.t1 0.424556
R2 rf_out_p.n0 rf_out_p.t2 6.56137
R3 rf_out_p.n1 rf_out_p.t3 6.52949
R4 rf_out_p.n1 rf_out_p.t5 6.52949
R5 rf_out_p.n0 rf_out_p.t1 6.52949
R6 rf_out_p.n0 rf_out_p.t0 6.52949
R7 rf_out_p.n0 rf_out_p.t4 6.52949
R8 rf_out_p rf_out_p.n2 1.88238
R9 rf_out_p.n2 rf_out_p.t6 1.62005
R10 rf_out_p.n1 rf_out_p.n0 0.128045
R11 rf_out_p.n2 rf_out_p.n1 0.117417
R12 rf_out_n.n0 rf_out_n.t5 6.56137
R13 rf_out_n.n0 rf_out_n.t4 6.52949
R14 rf_out_n.n0 rf_out_n.t3 6.52949
R15 rf_out_n.n1 rf_out_n.t2 6.52949
R16 rf_out_n.n1 rf_out_n.t1 6.52949
R17 rf_out_n.n1 rf_out_n.t6 6.52949
R18 rf_out_n rf_out_n.n2 1.88238
R19 rf_out_n.n2 rf_out_n.t0 1.62005
R20 rf_out_n.n1 rf_out_n.n0 0.128045
R21 rf_out_n.n2 rf_out_n.n1 0.117417
R22 vco_buf_in_n.n0 vco_buf_in_n.t0 27.0805
R23 vco_buf_in_n vco_buf_in_n.n0 3.71514
R24 vco_buf_in_n.n0 vco_buf_in_n.t1 2.05808
R25 vco_buf_in_p.n0 vco_buf_in_p.t0 27.0805
R26 vco_buf_in_p vco_buf_in_p.n0 3.72028
R27 vco_buf_in_p.n0 vco_buf_in_p.t1 2.05789
R28 di_en.n0 di_en.t0 21.6583
R29 di_en.n0 di_en.t1 19.605
R30 di_en di_en.n0 14.2582
R31 vco_var_rf_p.n1 vco_var_rf_p.t1 6.57599
R32 vco_var_rf_p.n1 vco_var_rf_p.t4 6.52949
R33 vco_var_rf_p.n1 vco_var_rf_p.t3 6.52949
R34 vco_var_rf_p.n1 vco_var_rf_p.t0 6.52949
R35 vco_var_rf_p.n1 vco_var_rf_p.t2 6.52949
R36 vco_var_rf_p vco_var_rf_p.t5 4.85508
R37 vco_var_rf_p.n0 vco_var_rf_p.t7 4.13789
R38 vco_ind_LA vco_var_rf_p.n2 0.424928
R39 vco_var_rf_p.n2 vco_var_rf_p.n3 0.714879
R40 vco_var_rf_p.n0 vco_var_rf_p.n2 0.321512
R41 vco_var_rf_p.n3 vco_var_rf_p.n1 0.47922
R42 vco_var_rf_p.n3 vco_var_rf_p 0.47746
R43 vco_var_rf_p.n1 vco_var_rf_p.n0 0.183969
R44 vco_var_rf_n.n1 vco_var_rf_n.t4 6.57599
R45 vco_var_rf_n.n1 vco_var_rf_n.t6 6.52949
R46 vco_var_rf_n.n1 vco_var_rf_n.t5 6.52949
R47 vco_var_rf_n.n1 vco_var_rf_n.t2 6.52949
R48 vco_var_rf_n.n1 vco_var_rf_n.t3 6.52949
R49 vco_var_rf_n vco_var_rf_n.t0 5.01313
R50 vco_var_rf_n.n2 vco_var_rf_n.t7 3.9789
R51 vco_var_rf_n.n3 vco_var_rf_n.n0 0.725616
R52 vco_var_rf_n.n2 vco_var_rf_n.n0 0.35066
R53 vco_ind_LB vco_var_rf_n.n0 0.413472
R54 vco_var_rf_n.n1 vco_var_rf_n.n3 0.47922
R55 vco_var_rf_n.n3 vco_var_rf_n 0.319412
R56 vco_var_rf_n.n2 vco_var_rf_n.n1 0.166369
R57 VDD VDD.n24 32.7055
R58 VDD.n17 VDD.t45 17.5809
R59 VDD.n0 VDD.t42 17.5809
R60 VDD.n60 VDD.n1 1.2602
R61 VDD.n18 VDD.t46 2.54554
R62 VDD.n2 VDD.t39 15.8062
R63 VDD.n57 VDD.n56 10.8262
R64 VDD.n59 VDD.n58 10.8262
R65 VDD.n20 VDD.n29 3.37066
R66 VDD.n25 VDD.t40 6.07554
R67 VDD.n2 VDD.t41 6.07554
R68 VDD.n19 VDD.t50 6.07554
R69 VDD.n23 VDD.t48 6.07554
R70 VDD.n24 VDD.t37 6.07554
R71 VDD.n1 VDD.n19 0.0656783
R72 VDD.n54 VDD.n22 0.830556
R73 VDD.n22 VDD.n29 2.80696
R74 VDD.n52 VDD.n51 0.0585658
R75 VDD.n51 VDD.n29 2.7974
R76 VDD.n50 VDD.n48 0.0585658
R77 VDD.n48 VDD.n29 2.7974
R78 VDD.n47 VDD.n30 0.066765
R79 VDD.n21 VDD.n42 0.0585658
R80 VDD.n42 VDD.n29 2.7974
R81 VDD.n41 VDD.n37 0.0585658
R82 VDD.n37 VDD.n29 2.7974
R83 VDD.n28 VDD.n29 2.37707
R84 VDD.n19 VDD.n23 0.1061
R85 VDD.n30 VDD.n29 2.3909
R86 VDD.n27 VDD.n28 0.0743661
R87 VDD.n58 VDD.n57 3.7073
R88 VDD.n25 VDD.t2 3.45404
R89 VDD.n24 VDD.n60 3.37539
R90 VDD.n60 VDD.n0 1.51113
R91 VDD.n60 VDD.n18 1.16155
R92 VDD.n32 VDD.t16 2.57245
R93 VDD.n17 VDD.t47 2.36411
R94 VDD.n0 VDD.t44 2.36394
R95 VDD.n33 VDD.t49 2.36375
R96 VDD.n0 VDD.t43 2.36316
R97 VDD.n17 VDD.t1 2.36279
R98 VDD.n3 VDD.n55 2.10932
R99 VDD.n54 VDD.n16 2.10932
R100 VDD.n55 VDD.t5 2.06537
R101 VDD.n54 VDD.t36 2.06537
R102 VDD.n26 VDD.t6 2.06506
R103 VDD.n35 VDD.t8 2.06506
R104 VDD.n38 VDD.t10 2.06506
R105 VDD.n40 VDD.t12 2.06506
R106 VDD.n43 VDD.t14 2.06506
R107 VDD.n44 VDD.t15 2.06506
R108 VDD.n45 VDD.t19 2.06506
R109 VDD.n53 VDD.t22 2.06506
R110 VDD.n9 VDD.t24 2.06506
R111 VDD.n8 VDD.t28 2.06506
R112 VDD.n12 VDD.t30 2.06506
R113 VDD.n11 VDD.t27 2.06506
R114 VDD.n15 VDD.t33 2.06506
R115 VDD.n14 VDD.t26 2.06506
R116 VDD.n3 VDD.n26 2.01733
R117 VDD.n4 VDD.n35 2.01733
R118 VDD.n4 VDD.n38 2.01733
R119 VDD.n5 VDD.n40 2.01733
R120 VDD.n5 VDD.n43 2.01733
R121 VDD.n6 VDD.n44 2.01733
R122 VDD.n6 VDD.n45 2.01733
R123 VDD.n53 VDD.n7 2.01733
R124 VDD.n10 VDD.n9 2.01733
R125 VDD.n10 VDD.n8 2.01733
R126 VDD.n13 VDD.n12 2.01733
R127 VDD.n13 VDD.n11 2.01733
R128 VDD.n16 VDD.n15 2.01733
R129 VDD.n16 VDD.n14 2.01733
R130 VDD.n56 VDD.n7 0.833598
R131 VDD.n55 VDD.n27 0.811613
R132 VDD.n27 VDD.n26 0.75308
R133 VDD.n36 VDD.n35 0.75308
R134 VDD.n34 VDD.n38 0.75308
R135 VDD.n41 VDD.n40 0.75308
R136 VDD.n39 VDD.n43 0.75308
R137 VDD.n21 VDD.n44 0.75308
R138 VDD.n21 VDD.n45 0.75308
R139 VDD.n31 VDD.n53 0.75308
R140 VDD.n47 VDD.n9 0.75308
R141 VDD.n46 VDD.n8 0.75308
R142 VDD.n50 VDD.n12 0.75308
R143 VDD.n49 VDD.n11 0.75308
R144 VDD.n52 VDD.n15 0.75308
R145 VDD.n22 VDD.n14 0.75308
R146 VDD VDD.n59 0.597573
R147 VDD.n57 VDD.t38 0.517741
R148 VDD.n58 VDD.t3 0.517741
R149 VDD.n60 VDD.t0 0.395849
R150 VDD.n59 VDD.n56 0.35172
R151 VDD.n29 VDD.t4 0.347439
R152 VDD.n0 VDD.n33 0.222999
R153 VDD.n2 VDD.n25 0.199822
R154 VDD.n16 VDD.n13 0.183684
R155 VDD.n13 VDD.n10 0.183684
R156 VDD.n10 VDD.n7 0.183684
R157 VDD.n7 VDD.n6 0.183684
R158 VDD.n6 VDD.n5 0.183684
R159 VDD.n5 VDD.n4 0.183684
R160 VDD.n4 VDD.n3 0.183684
R161 VDD.n33 VDD.n17 0.181347
R162 VDD.n28 VDD.n36 0.099072
R163 VDD.n32 VDD.n31 0.174604
R164 VDD.n52 VDD.n22 0.155757
R165 VDD.n7 VDD.n32 0.152545
R166 VDD.n24 VDD.n23 0.152127
R167 VDD.n18 VDD.n17 0.0814646
R168 VDD.n2 VDD.n1 0.0766266
R169 VDD.n0 VDD.n25 0.139213
R170 VDD.n49 VDD.n51 0.0585658
R171 VDD.n50 VDD.n49 0.116817
R172 VDD.n46 VDD.n48 0.0585658
R173 VDD.n47 VDD.n46 0.116817
R174 VDD.n31 VDD.n30 0.0501977
R175 VDD.n39 VDD.n42 0.0585658
R176 VDD.n41 VDD.n39 0.116817
R177 VDD.n34 VDD.n37 0.0585658
R178 VDD.n36 VDD.n34 0.116817
R179 VDD.n21 VDD.n20 0.116756
R180 VDD.n20 VDD.n32 0.116351
R181 VSS.n479 VSS.n42 384.529
R182 VSS.t14 VSS.n479 1462.65
R183 VSS.t68 VSS.n345 657.683
R184 VSS.t67 VSS.t14 303.798
R185 VSS.t11 VSS.t52 224.619
R186 VSS.t181 VSS.t68 179.696
R187 VSS.n479 VSS.t180 157.661
R188 VSS.t52 VSS.t181 157.233
R189 VSS.n346 VSS.t11 142.626
R190 VSS.n480 VSS.t67 110.507
R191 VSS.n353 VSS.n352 69.913
R192 VSS.n41 VSS.t48 11.1952
R193 VSS.t20 VSS.n351 48.555
R194 VSS.n348 VSS.t113 47.8044
R195 VSS.n40 VSS.t55 45.1788
R196 VSS.n350 VSS.t53 43.4374
R197 VSS.t50 VSS.n348 37.5655
R198 VSS.n351 VSS.t12 32.6297
R199 VSS.n347 VSS.t178 30.9232
R200 VSS.n40 VSS.t16 15.7829
R201 VSS.n349 VSS.t50 26.3726
R202 VSS.n216 VSS.n74 25.4435
R203 VSS.t0 VSS.n157 24.4173
R204 VSS.t53 VSS.n349 20.6825
R205 VSS.t178 VSS.n346 20.4783
R206 VSS.t55 VSS.n350 18.976
R207 VSS.n334 VSS.t179 17.3443
R208 VSS.n336 VSS.t114 17.3443
R209 VSS.n345 VSS.n283 17.102
R210 VSS.n476 VSS.n475 17.0005
R211 VSS.n475 VSS.n399 17.0005
R212 VSS.n475 VSS.n400 17.0005
R213 VSS.n475 VSS.n401 17.0005
R214 VSS.n475 VSS.n403 17.0005
R215 VSS.n475 VSS.n404 17.0005
R216 VSS.n475 VSS.n405 17.0005
R217 VSS.n475 VSS.n406 17.0005
R218 VSS.n475 VSS.n407 17.0005
R219 VSS.n475 VSS.n408 17.0005
R220 VSS.n475 VSS.n409 17.0005
R221 VSS.n475 VSS.n410 17.0005
R222 VSS.n475 VSS.n411 17.0005
R223 VSS.n475 VSS.n412 17.0005
R224 VSS.n475 VSS.n473 17.0005
R225 VSS.n475 VSS.n474 17.0005
R226 VSS.n455 VSS.n454 17.0005
R227 VSS.n455 VSS.n429 17.0005
R228 VSS.n455 VSS.n451 17.0005
R229 VSS.n455 VSS.n430 17.0005
R230 VSS.n455 VSS.n450 17.0005
R231 VSS.n455 VSS.n431 17.0005
R232 VSS.n455 VSS.n448 17.0005
R233 VSS.n455 VSS.n432 17.0005
R234 VSS.n455 VSS.n447 17.0005
R235 VSS.n12 VSS.n455 2.8034
R236 VSS.n455 VSS.n433 17.0005
R237 VSS.n455 VSS.n446 17.0005
R238 VSS.n455 VSS.n434 17.0005
R239 VSS.n455 VSS.n445 17.0005
R240 VSS.n455 VSS.n435 17.0005
R241 VSS.n455 VSS.n437 17.0005
R242 VSS.n455 VSS.n436 17.0005
R243 VSS.n481 VSS.n480 17.0005
R244 VSS.n481 VSS.n47 17.0005
R245 VSS.n481 VSS.n398 17.0005
R246 VSS.n481 VSS.n48 17.0005
R247 VSS.n481 VSS.n397 17.0005
R248 VSS.n481 VSS.n49 17.0005
R249 VSS.n481 VSS.n396 17.0005
R250 VSS.n481 VSS.n50 17.0005
R251 VSS.n481 VSS.n395 17.0005
R252 VSS.n481 VSS.n51 17.0005
R253 VSS.n481 VSS.n394 17.0005
R254 VSS.n481 VSS.n52 17.0005
R255 VSS.n481 VSS.n393 17.0005
R256 VSS.n481 VSS.n53 17.0005
R257 VSS.n481 VSS.n392 17.0005
R258 VSS.n481 VSS.n54 17.0005
R259 VSS.n481 VSS.n391 17.0005
R260 VSS.n481 VSS.n55 17.0005
R261 VSS.n481 VSS.n390 17.0005
R262 VSS.n481 VSS.n56 17.0005
R263 VSS.n481 VSS.n10 1.6725
R264 VSS.n481 VSS.n95 17.0005
R265 VSS.n481 VSS.n60 17.0005
R266 VSS.n17 VSS.n7 0.0446828
R267 VSS.n481 VSS.n88 17.0005
R268 VSS.n481 VSS.n62 17.0005
R269 VSS.n481 VSS.n86 17.0005
R270 VSS.n481 VSS.n63 17.0005
R271 VSS.n481 VSS.n84 17.0005
R272 VSS.n481 VSS.n64 17.0005
R273 VSS.n481 VSS.n83 17.0005
R274 VSS.n481 VSS.n65 17.0005
R275 VSS.n481 VSS.n82 17.0005
R276 VSS.n481 VSS.n66 17.0005
R277 VSS.n481 VSS.n81 17.0005
R278 VSS.n481 VSS.n67 17.0005
R279 VSS.n481 VSS.n80 17.0005
R280 VSS.n481 VSS.n68 17.0005
R281 VSS.n481 VSS.n79 17.0005
R282 VSS.n481 VSS.n69 17.0005
R283 VSS.n481 VSS.n78 17.0005
R284 VSS.n481 VSS.n70 17.0005
R285 VSS.n481 VSS.n77 17.0005
R286 VSS.n481 VSS.n74 17.0005
R287 VSS.n39 VSS.n34 4.23471
R288 VSS.n16 VSS.n18 0.0988086
R289 VSS.n346 VSS.n39 17.0005
R290 VSS.n18 VSS.t15 16.4809
R291 VSS.n19 VSS.t19 16.4809
R292 VSS.t113 VSS.n347 16.1318
R293 VSS.n76 VSS.t123 15.6926
R294 VSS.t160 VSS.n477 15.6926
R295 VSS.t137 VSS.n59 14.9331
R296 VSS.n59 VSS.t138 14.9331
R297 VSS.t155 VSS.n44 14.555
R298 VSS.n75 VSS.t119 14.5543
R299 VSS.n41 VSS.n39 0.0183207
R300 VSS.t119 VSS.n71 13.0361
R301 VSS.n478 VSS.t155 13.0354
R302 VSS.n360 VSS.n107 12.9119
R303 VSS.n222 VSS.n214 12.9119
R304 VSS.n366 VSS.n102 12.9119
R305 VSS.t135 VSS.n89 12.6546
R306 VSS.n94 VSS.t140 12.6546
R307 VSS.t117 VSS.n74 12.5321
R308 VSS.n480 VSS.t157 12.5321
R309 VSS.n90 VSS.t135 12.2766
R310 VSS.t140 VSS.n58 12.2759
R311 VSS.n365 VSS.t9 12.1524
R312 VSS.n352 VSS.t20 11.8925
R313 VSS.n295 VSS.t3 11.84
R314 VSS.n327 VSS.t7 11.84
R315 VSS.n484 VSS.n28 11.5239
R316 VSS.n227 VSS.t177 11.3929
R317 VSS.t108 VSS.t134 11.203
R318 VSS.t141 VSS.t69 11.203
R319 VSS.n354 VSS.n353 11.1823
R320 VSS.t131 VSS.n62 11.0132
R321 VSS.n390 VSS.t148 11.0132
R322 VSS.t3 VSS.n263 10.5245
R323 VSS.t7 VSS.n230 10.5245
R324 VSS.t138 VSS.n58 9.99808
R325 VSS.n90 VSS.t137 9.99739
R326 VSS.t105 VSS.n87 9.80648
R327 VSS.n61 VSS.t107 9.80648
R328 VSS.t70 VSS.n57 9.80648
R329 VSS.n96 VSS.t72 9.80648
R330 VSS.n386 VSS.n385 9.76416
R331 VSS.n387 VSS.n386 9.63922
R332 VSS.n333 VSS.t25 9.50586
R333 VSS.n86 VSS.t129 9.49417
R334 VSS.t144 VSS.n55 9.49417
R335 VSS.n478 VSS.t160 9.23859
R336 VSS.t123 VSS.n71 9.23789
R337 VSS.n436 VSS.n76 9.23686
R338 VSS.n477 VSS.n476 9.23686
R339 VSS.n370 VSS.n216 8.5005
R340 VSS.n370 VSS.n219 8.5005
R341 VSS.n370 VSS.n366 8.5005
R342 VSS.n370 VSS.n222 8.5005
R343 VSS.n370 VSS.n365 8.5005
R344 VSS.n370 VSS.n223 8.5005
R345 VSS.n370 VSS.n360 8.5005
R346 VSS.n370 VSS.n227 8.5005
R347 VSS.n373 VSS.n215 8.5005
R348 VSS.n373 VSS.n214 8.5005
R349 VSS.n373 VSS.n209 8.5005
R350 VSS.n373 VSS.n102 8.5005
R351 VSS.n373 VSS.n107 8.5005
R352 VSS.n373 VSS.n110 8.5005
R353 VSS.n370 VSS.t5 8.5005
R354 VSS.n370 VSS.n354 8.5005
R355 VSS.n370 VSS.n228 8.5005
R356 VSS.n370 VSS.n329 8.5005
R357 VSS.n370 VSS.n229 8.5005
R358 VSS.n370 VSS.n328 8.5005
R359 VSS.n370 VSS.n230 8.5005
R360 VSS.n370 VSS.n327 8.5005
R361 VSS.n370 VSS.n231 8.5005
R362 VSS.n370 VSS.n326 8.5005
R363 VSS.n370 VSS.n232 8.5005
R364 VSS.n370 VSS.n325 8.5005
R365 VSS.n370 VSS.n233 8.5005
R366 VSS.n370 VSS.n324 8.5005
R367 VSS.n370 VSS.n234 8.5005
R368 VSS.n370 VSS.n323 8.5005
R369 VSS.n370 VSS.n235 8.5005
R370 VSS.n370 VSS.n322 8.5005
R371 VSS.n370 VSS.n236 8.5005
R372 VSS.n370 VSS.n321 8.5005
R373 VSS.n370 VSS.n237 8.5005
R374 VSS.n370 VSS.n320 8.5005
R375 VSS.n370 VSS.n240 8.5005
R376 VSS.n370 VSS.n319 8.5005
R377 VSS.n370 VSS.n241 8.5005
R378 VSS.n370 VSS.n318 8.5005
R379 VSS.n370 VSS.n242 8.5005
R380 VSS.n370 VSS.n317 8.5005
R381 VSS.n370 VSS.n243 8.5005
R382 VSS.n370 VSS.n316 8.5005
R383 VSS.n370 VSS.n244 8.5005
R384 VSS.n370 VSS.n315 8.5005
R385 VSS.n370 VSS.n245 8.5005
R386 VSS.n370 VSS.n314 8.5005
R387 VSS.n370 VSS.n246 8.5005
R388 VSS.n370 VSS.n313 8.5005
R389 VSS.n370 VSS.n247 8.5005
R390 VSS.n370 VSS.n248 8.5005
R391 VSS.n370 VSS.n312 8.5005
R392 VSS.n370 VSS.n249 8.5005
R393 VSS.n370 VSS.n311 8.5005
R394 VSS.n370 VSS.n250 8.5005
R395 VSS.n370 VSS.n310 8.5005
R396 VSS.n370 VSS.n251 8.5005
R397 VSS.n370 VSS.n309 8.5005
R398 VSS.n370 VSS.n252 8.5005
R399 VSS.n370 VSS.n308 8.5005
R400 VSS.n370 VSS.n253 8.5005
R401 VSS.n370 VSS.n307 8.5005
R402 VSS.n370 VSS.n254 8.5005
R403 VSS.n370 VSS.n306 8.5005
R404 VSS.n370 VSS.n255 8.5005
R405 VSS.n370 VSS.n302 8.5005
R406 VSS.n370 VSS.n256 8.5005
R407 VSS.n370 VSS.n301 8.5005
R408 VSS.n370 VSS.n257 8.5005
R409 VSS.n370 VSS.n300 8.5005
R410 VSS.n370 VSS.n258 8.5005
R411 VSS.n370 VSS.n299 8.5005
R412 VSS.n370 VSS.n259 8.5005
R413 VSS.n370 VSS.n298 8.5005
R414 VSS.n370 VSS.n260 8.5005
R415 VSS.n370 VSS.n297 8.5005
R416 VSS.n370 VSS.n261 8.5005
R417 VSS.n370 VSS.n296 8.5005
R418 VSS.n370 VSS.n262 8.5005
R419 VSS.n370 VSS.n295 8.5005
R420 VSS.n370 VSS.n263 8.5005
R421 VSS.n370 VSS.n294 8.5005
R422 VSS.n370 VSS.n264 8.5005
R423 VSS.n370 VSS.n293 8.5005
R424 VSS.n370 VSS.n265 8.5005
R425 VSS.n370 VSS.n292 8.5005
R426 VSS.n370 VSS.n266 8.5005
R427 VSS.n370 VSS.n291 8.5005
R428 VSS.n370 VSS.n267 8.5005
R429 VSS.n370 VSS.n290 8.5005
R430 VSS.n370 VSS.n268 8.5005
R431 VSS.n370 VSS.n289 8.5005
R432 VSS.n370 VSS.n269 8.5005
R433 VSS.n370 VSS.n288 8.5005
R434 VSS.n370 VSS.n270 8.5005
R435 VSS.n370 VSS.n286 8.5005
R436 VSS.n370 VSS.n271 8.5005
R437 VSS.n370 VSS.n285 8.5005
R438 VSS.n370 VSS.n272 8.5005
R439 VSS.n370 VSS.n284 8.5005
R440 VSS.n370 VSS.n273 8.5005
R441 VSS.n370 VSS.n283 8.5005
R442 VSS.n370 VSS.n274 8.5005
R443 VSS.n370 VSS.n282 8.5005
R444 VSS.n370 VSS.n275 8.5005
R445 VSS.n370 VSS.n281 8.5005
R446 VSS.n370 VSS.n276 8.5005
R447 VSS.n370 VSS.n280 8.5005
R448 VSS.n370 VSS.n277 8.5005
R449 VSS.n370 VSS.n279 8.5005
R450 VSS.n370 VSS.n278 8.5005
R451 VSS.n3 VSS.n4 0.043527
R452 VSS.n481 VSS.n5 2.41243
R453 VSS.n16 VSS.n15 0.0305716
R454 VSS.n475 VSS.n35 4.2321
R455 VSS.n475 VSS.n37 4.2321
R456 VSS.n455 VSS.n449 8.49147
R457 VSS.n437 VSS.n70 8.35493
R458 VSS.n445 VSS.n69 8.35493
R459 VSS.n434 VSS.n79 8.35493
R460 VSS.n433 VSS.n80 8.35493
R461 VSS.n447 VSS.n67 8.35493
R462 VSS.n431 VSS.n82 8.35493
R463 VSS.n405 VSS.n52 8.35493
R464 VSS.n408 VSS.n395 8.35493
R465 VSS.n409 VSS.n50 8.35493
R466 VSS.n411 VSS.n49 8.35493
R467 VSS.n412 VSS.n397 8.35493
R468 VSS.n474 VSS.n398 8.35493
R469 VSS.n228 VSS.n205 7.94466
R470 VSS.n231 VSS.n202 7.94466
R471 VSS.n294 VSS.n142 7.94466
R472 VSS.n274 VSS.n162 7.94466
R473 VSS.n328 VSS.n112 7.944
R474 VSS.n262 VSS.n172 7.944
R475 VSS.n284 VSS.n152 7.944
R476 VSS.n279 VSS.n156 7.944
R477 VSS.t103 VSS.n62 7.78531
R478 VSS.n88 VSS.t105 7.78531
R479 VSS.t107 VSS.n60 7.78531
R480 VSS.n95 VSS.t70 7.78531
R481 VSS.t72 VSS.n56 7.78531
R482 VSS.n390 VSS.t74 7.78531
R483 VSS.n385 VSS.n98 7.76695
R484 VSS.n75 VSS.t117 7.7196
R485 VSS.t157 VSS.n44 7.71891
R486 VSS.t47 VSS.n215 7.59544
R487 VSS.n371 VSS.n99 7.33963
R488 VSS.n217 VSS.n100 7.33963
R489 VSS.n220 VSS.n101 7.33963
R490 VSS.n364 VSS.n104 7.33963
R491 VSS.n224 VSS.n105 7.33963
R492 VSS.n362 VSS.n106 7.33963
R493 VSS.n358 VSS.n109 7.33963
R494 VSS.n364 VSS.n212 7.33963
R495 VSS.n362 VSS.n211 7.33963
R496 VSS.n361 VSS.n210 7.33963
R497 VSS.n358 VSS.n208 7.33963
R498 VSS.n357 VSS.n207 7.33963
R499 VSS.n356 VSS.n206 7.33963
R500 VSS.n355 VSS.n206 7.33963
R501 VSS.n356 VSS.n207 7.33963
R502 VSS.n357 VSS.n208 7.33963
R503 VSS.n225 VSS.n108 7.33963
R504 VSS.n359 VSS.n108 7.33963
R505 VSS.n361 VSS.n211 7.33963
R506 VSS.n224 VSS.n106 7.33963
R507 VSS.n363 VSS.n105 7.33963
R508 VSS.n363 VSS.n212 7.33963
R509 VSS.n221 VSS.n103 7.33963
R510 VSS.n218 VSS.n100 7.33963
R511 VSS.n217 VSS.n99 7.33963
R512 VSS.n372 VSS.n371 7.33963
R513 VSS.n448 VSS.t98 7.02582
R514 VSS.n430 VSS.t100 7.02582
R515 VSS.n454 VSS.t102 7.02582
R516 VSS.n399 VSS.t75 7.02582
R517 VSS.n403 VSS.t77 7.02582
R518 VSS.n406 VSS.t79 7.02582
R519 VSS.n228 VSS.n204 6.74614
R520 VSS.n329 VSS.n111 6.74614
R521 VSS.n229 VSS.n203 6.74614
R522 VSS.n231 VSS.n201 6.74614
R523 VSS.n326 VSS.n113 6.74614
R524 VSS.n232 VSS.n200 6.74614
R525 VSS.n325 VSS.n114 6.74614
R526 VSS.n233 VSS.n199 6.74614
R527 VSS.n324 VSS.n115 6.74614
R528 VSS.n234 VSS.n198 6.74614
R529 VSS.n323 VSS.n116 6.74614
R530 VSS.n235 VSS.n197 6.74614
R531 VSS.n322 VSS.n117 6.74614
R532 VSS.n236 VSS.n196 6.74614
R533 VSS.n321 VSS.n118 6.74614
R534 VSS.n237 VSS.n195 6.74614
R535 VSS.n320 VSS.n119 6.74614
R536 VSS.n240 VSS.n194 6.74614
R537 VSS.n319 VSS.n120 6.74614
R538 VSS.n241 VSS.n193 6.74614
R539 VSS.n318 VSS.n121 6.74614
R540 VSS.n242 VSS.n192 6.74614
R541 VSS.n317 VSS.n122 6.74614
R542 VSS.n243 VSS.n191 6.74614
R543 VSS.n316 VSS.n123 6.74614
R544 VSS.n244 VSS.n190 6.74614
R545 VSS.n315 VSS.n124 6.74614
R546 VSS.n245 VSS.n189 6.74614
R547 VSS.n314 VSS.n125 6.74614
R548 VSS.n246 VSS.n188 6.74614
R549 VSS.n313 VSS.n126 6.74614
R550 VSS.n247 VSS.n187 6.74614
R551 VSS.n248 VSS.n186 6.74614
R552 VSS.n312 VSS.n128 6.74614
R553 VSS.n249 VSS.n185 6.74614
R554 VSS.n311 VSS.n129 6.74614
R555 VSS.n250 VSS.n184 6.74614
R556 VSS.n310 VSS.n130 6.74614
R557 VSS.n251 VSS.n183 6.74614
R558 VSS.n309 VSS.n131 6.74614
R559 VSS.n252 VSS.n182 6.74614
R560 VSS.n308 VSS.n132 6.74614
R561 VSS.n253 VSS.n181 6.74614
R562 VSS.n307 VSS.n133 6.74614
R563 VSS.n254 VSS.n180 6.74614
R564 VSS.n306 VSS.n134 6.74614
R565 VSS.n255 VSS.n179 6.74614
R566 VSS.n302 VSS.n135 6.74614
R567 VSS.n256 VSS.n178 6.74614
R568 VSS.n301 VSS.n136 6.74614
R569 VSS.n257 VSS.n177 6.74614
R570 VSS.n300 VSS.n137 6.74614
R571 VSS.n258 VSS.n176 6.74614
R572 VSS.n299 VSS.n138 6.74614
R573 VSS.n259 VSS.n175 6.74614
R574 VSS.n298 VSS.n139 6.74614
R575 VSS.n260 VSS.n174 6.74614
R576 VSS.n297 VSS.n140 6.74614
R577 VSS.n261 VSS.n173 6.74614
R578 VSS.n296 VSS.n141 6.74614
R579 VSS.n294 VSS.n143 6.74614
R580 VSS.n264 VSS.n171 6.74614
R581 VSS.n293 VSS.n144 6.74614
R582 VSS.n265 VSS.n170 6.74614
R583 VSS.n292 VSS.n145 6.74614
R584 VSS.n266 VSS.n169 6.74614
R585 VSS.n291 VSS.n146 6.74614
R586 VSS.n267 VSS.n168 6.74614
R587 VSS.n290 VSS.n147 6.74614
R588 VSS.n268 VSS.n167 6.74614
R589 VSS.n289 VSS.n148 6.74614
R590 VSS.n269 VSS.n166 6.74614
R591 VSS.n288 VSS.n149 6.74614
R592 VSS.n270 VSS.n165 6.74614
R593 VSS.n286 VSS.n150 6.74614
R594 VSS.n271 VSS.n164 6.74614
R595 VSS.n285 VSS.n151 6.74614
R596 VSS.n272 VSS.n163 6.74614
R597 VSS.n274 VSS.n161 6.74614
R598 VSS.n282 VSS.n153 6.74614
R599 VSS.n275 VSS.n160 6.74614
R600 VSS.n281 VSS.n154 6.74614
R601 VSS.n276 VSS.n159 6.74614
R602 VSS.n280 VSS.n155 6.74614
R603 VSS.n277 VSS.n158 6.74614
R604 VSS.t5 VSS.n127 6.74614
R605 VSS.n279 VSS.n158 6.74614
R606 VSS.n277 VSS.n155 6.74614
R607 VSS.n280 VSS.n159 6.74614
R608 VSS.n276 VSS.n154 6.74614
R609 VSS.n281 VSS.n160 6.74614
R610 VSS.n275 VSS.n153 6.74614
R611 VSS.n282 VSS.n161 6.74614
R612 VSS.n284 VSS.n163 6.74614
R613 VSS.n272 VSS.n151 6.74614
R614 VSS.n285 VSS.n164 6.74614
R615 VSS.n271 VSS.n150 6.74614
R616 VSS.n286 VSS.n165 6.74614
R617 VSS.n270 VSS.n149 6.74614
R618 VSS.n288 VSS.n166 6.74614
R619 VSS.n269 VSS.n148 6.74614
R620 VSS.n289 VSS.n167 6.74614
R621 VSS.n268 VSS.n147 6.74614
R622 VSS.n290 VSS.n168 6.74614
R623 VSS.n267 VSS.n146 6.74614
R624 VSS.n291 VSS.n169 6.74614
R625 VSS.n266 VSS.n145 6.74614
R626 VSS.n292 VSS.n170 6.74614
R627 VSS.n265 VSS.n144 6.74614
R628 VSS.n293 VSS.n171 6.74614
R629 VSS.n264 VSS.n143 6.74614
R630 VSS.n262 VSS.n141 6.74614
R631 VSS.n296 VSS.n173 6.74614
R632 VSS.n261 VSS.n140 6.74614
R633 VSS.n297 VSS.n174 6.74614
R634 VSS.n260 VSS.n139 6.74614
R635 VSS.n298 VSS.n175 6.74614
R636 VSS.n259 VSS.n138 6.74614
R637 VSS.n299 VSS.n176 6.74614
R638 VSS.n258 VSS.n137 6.74614
R639 VSS.n300 VSS.n177 6.74614
R640 VSS.n257 VSS.n136 6.74614
R641 VSS.n301 VSS.n178 6.74614
R642 VSS.n256 VSS.n135 6.74614
R643 VSS.n302 VSS.n179 6.74614
R644 VSS.n255 VSS.n134 6.74614
R645 VSS.n306 VSS.n180 6.74614
R646 VSS.n254 VSS.n133 6.74614
R647 VSS.n307 VSS.n181 6.74614
R648 VSS.n253 VSS.n132 6.74614
R649 VSS.n308 VSS.n182 6.74614
R650 VSS.n252 VSS.n131 6.74614
R651 VSS.n309 VSS.n183 6.74614
R652 VSS.n251 VSS.n130 6.74614
R653 VSS.n310 VSS.n184 6.74614
R654 VSS.n250 VSS.n129 6.74614
R655 VSS.n311 VSS.n185 6.74614
R656 VSS.n249 VSS.n128 6.74614
R657 VSS.n312 VSS.n186 6.74614
R658 VSS.n248 VSS.n127 6.74614
R659 VSS.t5 VSS.n187 6.74614
R660 VSS.n247 VSS.n126 6.74614
R661 VSS.n313 VSS.n188 6.74614
R662 VSS.n246 VSS.n125 6.74614
R663 VSS.n314 VSS.n189 6.74614
R664 VSS.n245 VSS.n124 6.74614
R665 VSS.n315 VSS.n190 6.74614
R666 VSS.n244 VSS.n123 6.74614
R667 VSS.n316 VSS.n191 6.74614
R668 VSS.n243 VSS.n122 6.74614
R669 VSS.n317 VSS.n192 6.74614
R670 VSS.n242 VSS.n121 6.74614
R671 VSS.n318 VSS.n193 6.74614
R672 VSS.n241 VSS.n120 6.74614
R673 VSS.n319 VSS.n194 6.74614
R674 VSS.n240 VSS.n119 6.74614
R675 VSS.n320 VSS.n195 6.74614
R676 VSS.n237 VSS.n118 6.74614
R677 VSS.n321 VSS.n196 6.74614
R678 VSS.n236 VSS.n117 6.74614
R679 VSS.n322 VSS.n197 6.74614
R680 VSS.n235 VSS.n116 6.74614
R681 VSS.n323 VSS.n198 6.74614
R682 VSS.n234 VSS.n115 6.74614
R683 VSS.n324 VSS.n199 6.74614
R684 VSS.n233 VSS.n114 6.74614
R685 VSS.n325 VSS.n200 6.74614
R686 VSS.n232 VSS.n113 6.74614
R687 VSS.n326 VSS.n201 6.74614
R688 VSS.n328 VSS.n203 6.74614
R689 VSS.n229 VSS.n111 6.74614
R690 VSS.n329 VSS.n204 6.74614
R691 VSS.n353 VSS.n110 6.4562
R692 VSS.n481 VSS.n477 6.16155
R693 VSS.n481 VSS.n96 6.16155
R694 VSS.n481 VSS.n57 6.16155
R695 VSS.n481 VSS.n94 6.16155
R696 VSS.n481 VSS.n59 6.16155
R697 VSS.n481 VSS.n89 6.16155
R698 VSS.n481 VSS.n61 6.16155
R699 VSS.n481 VSS.n87 6.16155
R700 VSS.n481 VSS.n76 6.16155
R701 VSS.n337 VSS.t51 6.07511
R702 VSS.n331 VSS.t54 6.07511
R703 VSS.n87 VSS.t104 6.00901
R704 VSS.t106 VSS.n61 6.00901
R705 VSS.n89 VSS.t108 6.00901
R706 VSS.t69 VSS.n94 6.00901
R707 VSS.n57 VSS.t71 6.00901
R708 VSS.t73 VSS.n96 6.00901
R709 VSS.n97 VSS.t23 5.93097
R710 VSS.t132 VSS.t106 5.88658
R711 VSS.t71 VSS.t143 5.88658
R712 VSS.n88 VSS.t132 5.6967
R713 VSS.t143 VSS.n56 5.6967
R714 VSS.n21 VSS.n2 0.0546951
R715 VSS.n20 VSS.n6 0.0538158
R716 VSS.n34 VSS.t22 3.20134
R717 VSS.n39 VSS.n16 2.81319
R718 VSS.n12 VSS.n11 0.0486537
R719 VSS.n219 VSS.t47 5.31696
R720 VSS.n345 VSS.n273 5.2625
R721 VSS.n373 VSS.n187 5.12843
R722 VSS.n373 VSS.n204 5.12843
R723 VSS.n373 VSS.n111 5.12843
R724 VSS.n373 VSS.n203 5.12843
R725 VSS.n373 VSS.n201 5.12843
R726 VSS.n373 VSS.n113 5.12843
R727 VSS.n373 VSS.n200 5.12843
R728 VSS.n373 VSS.n114 5.12843
R729 VSS.n373 VSS.n199 5.12843
R730 VSS.n373 VSS.n115 5.12843
R731 VSS.n373 VSS.n198 5.12843
R732 VSS.n373 VSS.n116 5.12843
R733 VSS.n373 VSS.n197 5.12843
R734 VSS.n373 VSS.n117 5.12843
R735 VSS.n373 VSS.n196 5.12843
R736 VSS.n373 VSS.n118 5.12843
R737 VSS.n373 VSS.n195 5.12843
R738 VSS.n373 VSS.n119 5.12843
R739 VSS.n373 VSS.n194 5.12843
R740 VSS.n373 VSS.n120 5.12843
R741 VSS.n373 VSS.n193 5.12843
R742 VSS.n373 VSS.n121 5.12843
R743 VSS.n373 VSS.n192 5.12843
R744 VSS.n373 VSS.n122 5.12843
R745 VSS.n373 VSS.n191 5.12843
R746 VSS.n373 VSS.n123 5.12843
R747 VSS.n373 VSS.n190 5.12843
R748 VSS.n373 VSS.n124 5.12843
R749 VSS.n373 VSS.n189 5.12843
R750 VSS.n373 VSS.n125 5.12843
R751 VSS.n373 VSS.n188 5.12843
R752 VSS.n373 VSS.n126 5.12843
R753 VSS.n373 VSS.n127 5.12843
R754 VSS.n373 VSS.n186 5.12843
R755 VSS.n373 VSS.n128 5.12843
R756 VSS.n373 VSS.n185 5.12843
R757 VSS.n373 VSS.n129 5.12843
R758 VSS.n373 VSS.n184 5.12843
R759 VSS.n373 VSS.n130 5.12843
R760 VSS.n373 VSS.n183 5.12843
R761 VSS.n373 VSS.n131 5.12843
R762 VSS.n373 VSS.n182 5.12843
R763 VSS.n373 VSS.n132 5.12843
R764 VSS.n373 VSS.n181 5.12843
R765 VSS.n373 VSS.n133 5.12843
R766 VSS.n373 VSS.n180 5.12843
R767 VSS.n373 VSS.n134 5.12843
R768 VSS.n373 VSS.n179 5.12843
R769 VSS.n373 VSS.n135 5.12843
R770 VSS.n373 VSS.n178 5.12843
R771 VSS.n373 VSS.n136 5.12843
R772 VSS.n373 VSS.n177 5.12843
R773 VSS.n373 VSS.n137 5.12843
R774 VSS.n373 VSS.n176 5.12843
R775 VSS.n373 VSS.n138 5.12843
R776 VSS.n373 VSS.n175 5.12843
R777 VSS.n373 VSS.n139 5.12843
R778 VSS.n373 VSS.n174 5.12843
R779 VSS.n373 VSS.n140 5.12843
R780 VSS.n373 VSS.n173 5.12843
R781 VSS.n373 VSS.n141 5.12843
R782 VSS.n373 VSS.n143 5.12843
R783 VSS.n373 VSS.n171 5.12843
R784 VSS.n373 VSS.n144 5.12843
R785 VSS.n373 VSS.n170 5.12843
R786 VSS.n373 VSS.n145 5.12843
R787 VSS.n373 VSS.n169 5.12843
R788 VSS.n373 VSS.n146 5.12843
R789 VSS.n373 VSS.n168 5.12843
R790 VSS.n373 VSS.n147 5.12843
R791 VSS.n373 VSS.n167 5.12843
R792 VSS.n373 VSS.n148 5.12843
R793 VSS.n373 VSS.n166 5.12843
R794 VSS.n373 VSS.n149 5.12843
R795 VSS.n373 VSS.n165 5.12843
R796 VSS.n373 VSS.n150 5.12843
R797 VSS.n373 VSS.n164 5.12843
R798 VSS.n373 VSS.n151 5.12843
R799 VSS.n373 VSS.n163 5.12843
R800 VSS.n373 VSS.n161 5.12843
R801 VSS.n373 VSS.n153 5.12843
R802 VSS.n373 VSS.n160 5.12843
R803 VSS.n373 VSS.n154 5.12843
R804 VSS.n373 VSS.n159 5.12843
R805 VSS.n373 VSS.n155 5.12843
R806 VSS.n373 VSS.n158 5.12843
R807 VSS.t83 VSS.n78 5.12708
R808 VSS.t89 VSS.n81 5.12708
R809 VSS.t92 VSS.n65 5.12708
R810 VSS.t95 VSS.n84 5.12708
R811 VSS.n86 VSS.t103 5.12708
R812 VSS.t74 VSS.n55 5.12708
R813 VSS.t161 VSS.n54 5.12708
R814 VSS.t165 VSS.n393 5.12708
R815 VSS.t168 VSS.n51 5.12708
R816 VSS.t174 VSS.n48 5.12708
R817 VSS.n436 VSS.t124 4.93721
R818 VSS.n476 VSS.t159 4.93721
R819 VSS.n471 VSS.n28 4.69693
R820 VSS.n385 VSS.n384 4.67815
R821 VSS.n435 VSS.n70 4.55746
R822 VSS.n446 VSS.n79 4.55746
R823 VSS.n433 VSS.n68 4.55746
R824 VSS.n432 VSS.n67 4.55746
R825 VSS.n448 VSS.n81 4.55746
R826 VSS.n430 VSS.n65 4.55746
R827 VSS.n429 VSS.n64 4.55746
R828 VSS.n454 VSS.n84 4.55746
R829 VSS.n399 VSS.n54 4.55746
R830 VSS.n400 VSS.n392 4.55746
R831 VSS.n403 VSS.n393 4.55746
R832 VSS.n406 VSS.n51 4.55746
R833 VSS.n407 VSS.n395 4.55746
R834 VSS.n409 VSS.n396 4.55746
R835 VSS.n410 VSS.n49 4.55746
R836 VSS.n473 VSS.n398 4.55746
R837 VSS.n463 VSS.n462 4.5005
R838 VSS.n461 VSS.n420 4.5005
R839 VSS.n460 VSS.n459 4.5005
R840 VSS.n10 VSS.n389 0.0881593
R841 VSS.n39 VSS.n344 4.23094
R842 VSS.n39 VSS.n330 4.23094
R843 VSS.n39 VSS.n338 4.23094
R844 VSS.n475 VSS.n472 4.22744
R845 VSS.n455 VSS.n453 4.22744
R846 VSS.n455 VSS.n444 4.22744
R847 VSS.n475 VSS.n402 4.22725
R848 VSS.t121 VSS.n78 4.17772
R849 VSS.n451 VSS.t128 4.17772
R850 VSS.t128 VSS.n64 4.17772
R851 VSS.t149 VSS.n392 4.17772
R852 VSS.n401 VSS.t149 4.17772
R853 VSS.t153 VSS.n48 4.17772
R854 VSS.t86 VSS.t115 3.98784
R855 VSS.t171 VSS.t152 3.98784
R856 VSS.n352 VSS.n39 3.97732
R857 VSS.n354 VSS.n205 3.97266
R858 VSS.n327 VSS.n202 3.97266
R859 VSS.n263 VSS.n142 3.97266
R860 VSS.n283 VSS.n162 3.97266
R861 VSS.n278 VSS.n156 3.9725
R862 VSS.n273 VSS.n152 3.9725
R863 VSS.n295 VSS.n172 3.9725
R864 VSS.n230 VSS.n112 3.9725
R865 VSS.n218 VSS.n215 3.67007
R866 VSS.n221 VSS.n214 3.67007
R867 VSS.n359 VSS.n107 3.67007
R868 VSS.n225 VSS.n209 3.67007
R869 VSS.n355 VSS.n110 3.67007
R870 VSS.n366 VSS.n103 3.67007
R871 VSS.n222 VSS.n213 3.67007
R872 VSS.n227 VSS.n109 3.67007
R873 VSS.n360 VSS.n210 3.67007
R874 VSS.n223 VSS.n104 3.67007
R875 VSS.n365 VSS.n213 3.67007
R876 VSS.n220 VSS.n102 3.67007
R877 VSS.n219 VSS.n101 3.67007
R878 VSS.n372 VSS.n216 3.67007
R879 VSS.n458 VSS.n423 3.46952
R880 VSS.t124 VSS.n77 3.41822
R881 VSS.n450 VSS.t126 3.41822
R882 VSS.t129 VSS.n63 3.41822
R883 VSS.n391 VSS.t144 3.41822
R884 VSS.n404 VSS.t146 3.41822
R885 VSS.t159 VSS.n47 3.41822
R886 VSS.n481 VSS.n45 3.38773
R887 VSS.n481 VSS.n73 3.38773
R888 VSS.n481 VSS.n4 1.385
R889 VSS.n10 VSS.n9 0.0454629
R890 VSS.n481 VSS.n8 3.38758
R891 VSS.n481 VSS.n17 1.67292
R892 VSS.n5 VSS.n85 0.0574968
R893 VSS.n30 VSS.n464 3.3755
R894 VSS.n458 VSS.n29 3.3755
R895 VSS.n39 VSS.n340 3.37539
R896 VSS.n39 VSS.n332 3.37539
R897 VSS.n39 VSS.n335 3.37539
R898 VSS.n437 VSS.t81 3.22835
R899 VSS.n435 VSS.t83 3.22835
R900 VSS.n434 VSS.t85 3.22835
R901 VSS.n446 VSS.t86 3.22835
R902 VSS.n447 VSS.t88 3.22835
R903 VSS.n431 VSS.t91 3.22835
R904 VSS.n451 VSS.t94 3.22835
R905 VSS.n401 VSS.t163 3.22835
R906 VSS.n405 VSS.t166 3.22835
R907 VSS.n408 VSS.t169 3.22835
R908 VSS.n410 VSS.t171 3.22835
R909 VSS.n411 VSS.t172 3.22835
R910 VSS.n473 VSS.t174 3.22835
R911 VSS.n474 VSS.t175 3.22835
R912 VSS.n339 VSS.t56 3.14902
R913 VSS.n18 VSS.t17 3.14902
R914 VSS.n15 VSS.t18 3.14902
R915 VSS.n341 VSS.t49 3.14902
R916 VSS.n343 VSS.t13 3.14902
R917 VSS.n19 VSS.t21 3.14902
R918 VSS.n373 VSS.n205 3.02019
R919 VSS.n373 VSS.n202 3.02019
R920 VSS.n373 VSS.n142 3.02019
R921 VSS.n373 VSS.n162 3.02019
R922 VSS.n373 VSS.n112 3.02
R923 VSS.n373 VSS.n172 3.02
R924 VSS.n373 VSS.n152 3.02
R925 VSS.n373 VSS.n156 3.02
R926 VSS.n482 VSS.n2 3.0005
R927 VSS.n9 VSS.n0 3.0005
R928 VSS.n31 VSS.n8 3.0005
R929 VSS.n32 VSS.n6 3.0005
R930 VSS.n484 VSS.n43 2.98702
R931 VSS.n481 VSS.n21 1.86425
R932 VSS.n481 VSS.n93 2.81806
R933 VSS.n481 VSS.n20 1.86454
R934 VSS.n39 VSS.n342 2.80331
R935 VSS.n439 VSS.t82 2.79558
R936 VSS.n425 VSS.t93 2.79551
R937 VSS.n442 VSS.t84 2.79551
R938 VSS.n428 VSS.t87 2.79551
R939 VSS.n426 VSS.t90 2.79551
R940 VSS.n416 VSS.t167 2.79551
R941 VSS.n415 VSS.t170 2.79551
R942 VSS.n414 VSS.t173 2.79551
R943 VSS.n418 VSS.t164 2.79551
R944 VSS.n470 VSS.t176 2.79543
R945 VSS.n419 VSS.t162 2.79543
R946 VSS.n424 VSS.t96 2.79543
R947 VSS.n334 VSS.n333 2.69572
R948 VSS.t99 VSS.t92 2.65873
R949 VSS.t101 VSS.t95 2.65873
R950 VSS.t76 VSS.t161 2.65873
R951 VSS.t78 VSS.t165 2.65873
R952 VSS.n481 VSS.n44 2.57114
R953 VSS.n481 VSS.n478 2.57114
R954 VSS.n481 VSS.n58 2.57114
R955 VSS.n481 VSS.n90 2.57114
R956 VSS.n481 VSS.n71 2.57114
R957 VSS.n481 VSS.n75 2.57114
R958 VSS.n470 VSS.n469 2.46314
R959 VSS.n30 VSS.n419 2.4382
R960 VSS.n29 VSS.n424 2.4382
R961 VSS.n371 VSS.n370 2.41647
R962 VSS.n370 VSS.n217 2.41647
R963 VSS.n370 VSS.n218 2.41647
R964 VSS.n370 VSS.n220 2.41647
R965 VSS.n370 VSS.n221 2.41647
R966 VSS.n370 VSS.n364 2.41647
R967 VSS.n370 VSS.n363 2.41647
R968 VSS.n370 VSS.n224 2.41647
R969 VSS.n370 VSS.n362 2.41647
R970 VSS.n370 VSS.n361 2.41647
R971 VSS.n370 VSS.n359 2.41647
R972 VSS.n370 VSS.n225 2.41647
R973 VSS.n370 VSS.n358 2.41647
R974 VSS.n370 VSS.n357 2.41647
R975 VSS.n370 VSS.n356 2.41647
R976 VSS.n370 VSS.n355 2.41647
R977 VSS.n373 VSS.n372 2.41647
R978 VSS.n373 VSS.n213 2.41647
R979 VSS.n373 VSS.n212 2.41647
R980 VSS.n373 VSS.n211 2.41647
R981 VSS.n373 VSS.n210 2.41647
R982 VSS.n373 VSS.n208 2.41647
R983 VSS.n373 VSS.n207 2.41647
R984 VSS.n373 VSS.n206 2.41647
R985 VSS.n373 VSS.n99 2.41647
R986 VSS.n373 VSS.n100 2.41647
R987 VSS.n373 VSS.n101 2.41647
R988 VSS.n373 VSS.n103 2.41647
R989 VSS.n373 VSS.n104 2.41647
R990 VSS.n373 VSS.n105 2.41647
R991 VSS.n373 VSS.n106 2.41647
R992 VSS.n373 VSS.n108 2.41647
R993 VSS.n373 VSS.n109 2.41647
R994 VSS.n440 VSS.n439 2.31388
R995 VSS.n29 VSS.n425 2.31337
R996 VSS.n442 VSS.n441 2.31337
R997 VSS.n428 VSS.n427 2.31337
R998 VSS.n457 VSS.n426 2.31337
R999 VSS.n465 VSS.n416 2.31337
R1000 VSS.n468 VSS.n415 2.31337
R1001 VSS.n469 VSS.n414 2.31337
R1002 VSS.n30 VSS.n418 2.31337
R1003 VSS.n304 VSS.t4 2.21145
R1004 VSS.n303 VSS.t2 2.21129
R1005 VSS.n98 VSS.t1 2.21112
R1006 VSS.n378 VSS.t42 2.21082
R1007 VSS.n374 VSS.t46 2.2108
R1008 VSS.n367 VSS.t8 2.21077
R1009 VSS.n368 VSS.t10 2.21075
R1010 VSS.n380 VSS.t40 2.21066
R1011 VSS.n382 VSS.t38 2.20987
R1012 VSS.n384 VSS.t37 2.20978
R1013 VSS.n376 VSS.t44 2.20978
R1014 VSS.n238 VSS.t6 2.2097
R1015 VSS.n98 VSS.t57 2.20311
R1016 VSS.n374 VSS.t36 2.20295
R1017 VSS.n380 VSS.t30 2.20284
R1018 VSS.n376 VSS.t34 2.20277
R1019 VSS.n367 VSS.t64 2.20275
R1020 VSS.n384 VSS.t27 2.20256
R1021 VSS.n238 VSS.t62 2.20236
R1022 VSS.n303 VSS.t58 2.20197
R1023 VSS.n378 VSS.t32 2.20164
R1024 VSS.n368 VSS.t66 2.20141
R1025 VSS.n304 VSS.t60 2.20128
R1026 VSS.n382 VSS.t28 2.2007
R1027 VSS.n387 VSS 1.66046
R1028 VSS.n24 VSS.n23 0.290062
R1029 VSS.n25 VSS.n1 0.77644
R1030 VSS.n25 VSS.n33 0.771635
R1031 VSS.n22 VSS.n26 0.288598
R1032 VSS VSS.n27 0.452569
R1033 VSS.n388 VSS 1.65452
R1034 VSS.n73 VSS.t118 1.62057
R1035 VSS.n45 VSS.t158 1.61907
R1036 VSS.t177 VSS.n209 1.51949
R1037 VSS.n85 VSS.t127 1.47429
R1038 VSS.n6 VSS.t116 1.4742
R1039 VSS.n9 VSS.t142 1.47407
R1040 VSS.n6 VSS.t122 1.47396
R1041 VSS.n3 VSS.t147 1.47389
R1042 VSS.n2 VSS.t154 1.47367
R1043 VSS.n8 VSS.t133 1.47359
R1044 VSS.n92 VSS.t139 1.47359
R1045 VSS.n389 VSS.t145 1.47352
R1046 VSS.n7 VSS.t130 1.47335
R1047 VSS.n46 VSS.t156 1.47328
R1048 VSS.n91 VSS.t136 1.47324
R1049 VSS.n2 VSS.t151 1.47324
R1050 VSS.n72 VSS.t120 1.47281
R1051 VSS.t81 VSS.n77 1.32961
R1052 VSS.t85 VSS.n69 1.32961
R1053 VSS.t88 VSS.n80 1.32961
R1054 VSS.t97 VSS.t125 1.32961
R1055 VSS.t125 VSS.t89 1.32961
R1056 VSS.t98 VSS.n66 1.32961
R1057 VSS.t91 VSS.n66 1.32961
R1058 VSS.t100 VSS.n83 1.32961
R1059 VSS.t94 VSS.n83 1.32961
R1060 VSS.t102 VSS.n63 1.32961
R1061 VSS.t75 VSS.n391 1.32961
R1062 VSS.t163 VSS.n53 1.32961
R1063 VSS.t77 VSS.n53 1.32961
R1064 VSS.t166 VSS.n394 1.32961
R1065 VSS.t79 VSS.n394 1.32961
R1066 VSS.t150 VSS.t168 1.32961
R1067 VSS.t80 VSS.t150 1.32961
R1068 VSS.t169 VSS.n50 1.32961
R1069 VSS.t172 VSS.n397 1.32961
R1070 VSS.t175 VSS.n47 1.32961
R1071 VSS.n278 VSS.t0 1.316
R1072 VSS.t115 VSS.n68 1.13974
R1073 VSS.t126 VSS.n82 1.13974
R1074 VSS.t146 VSS.n52 1.13974
R1075 VSS.t152 VSS.n396 1.13974
R1076 VSS.n423 VSS.n43 1.1255
R1077 vco_var_VSS VSS.n484 0.903417
R1078 VSS.n386 VSS.n97 0.762586
R1079 VSS.t9 VSS.n223 0.759994
R1080 VSS.n456 VSS.n14 0.7505
R1081 VSS.n467 VSS.n466 0.7505
R1082 VSS.n333 VSS.n97 0.674942
R1083 VSS.n373 VSS.n157 0.572518
R1084 VSS.n370 VSS.n157 0.57194
R1085 VSS.n432 VSS.t97 0.57012
R1086 VSS.n450 VSS.t99 0.57012
R1087 VSS.n429 VSS.t101 0.57012
R1088 VSS.t104 VSS.t131 0.57012
R1089 VSS.t148 VSS.t73 0.57012
R1090 VSS.n400 VSS.t76 0.57012
R1091 VSS.n404 VSS.t78 0.57012
R1092 VSS.n407 VSS.t80 0.57012
R1093 VSS.n452 VSS.n425 0.561603
R1094 VSS.n443 VSS.n442 0.561603
R1095 VSS.n11 VSS.n428 0.561603
R1096 VSS.n13 VSS.n426 0.561603
R1097 VSS.n416 VSS.n36 0.561603
R1098 VSS.n415 VSS.n38 0.561603
R1099 VSS.n414 VSS.n413 0.561603
R1100 VSS.n418 VSS.n417 0.561603
R1101 VSS.n471 VSS.n470 0.56142
R1102 VSS.n421 VSS.n419 0.56142
R1103 VSS.n424 VSS.n422 0.56142
R1104 VSS.n439 VSS.n438 0.56108
R1105 VSS.n445 VSS.t121 0.380247
R1106 VSS.t134 VSS.n60 0.380247
R1107 VSS.n95 VSS.t141 0.380247
R1108 VSS.n412 VSS.t153 0.380247
R1109 VSS.n483 VSS.n42 0.353904
R1110 VSS.n461 VSS.n460 0.337235
R1111 VSS.n462 VSS.n461 0.337235
R1112 VSS.n23 VSS.n42 0.318978
R1113 VSS.n388 VSS.n27 0.492876
R1114 VSS.n27 VSS.n26 0.807767
R1115 VSS.n33 VSS.n26 0.692189
R1116 VSS.n388 VSS.n387 0.25856
R1117 VSS.n348 VSS.n39 0.245325
R1118 VSS.n382 VSS.n381 0.243424
R1119 VSS.n305 VSS.n303 0.243424
R1120 VSS.n287 VSS.n98 0.242716
R1121 VSS.n384 VSS.n383 0.242681
R1122 VSS.n32 VSS.n33 0.113752
R1123 VSS.n378 VSS.n377 0.24245
R1124 VSS.n238 VSS.n226 0.24245
R1125 VSS.n460 VSS.n422 0.241827
R1126 VSS.n462 VSS.n421 0.241827
R1127 VSS.n380 VSS.n379 0.240796
R1128 VSS.n304 VSS.n239 0.240796
R1129 VSS.n376 VSS.n375 0.239822
R1130 VSS.n369 VSS.n367 0.239822
R1131 VSS.n377 VSS.n376 0.227974
R1132 VSS.n367 VSS.n226 0.227974
R1133 VSS.n381 VSS.n380 0.227001
R1134 VSS.n305 VSS.n304 0.227001
R1135 VSS.n375 VSS.n374 0.225646
R1136 VSS.n369 VSS.n368 0.225646
R1137 VSS.n379 VSS.n378 0.224672
R1138 VSS.n239 VSS.n238 0.224672
R1139 VSS.n383 VSS.n382 0.223727
R1140 VSS.n303 VSS.n287 0.223715
R1141 VSS.n0 VSS.n1 0.104141
R1142 VSS.n370 VSS.n226 0.218846
R1143 VSS.n377 VSS.n373 0.218846
R1144 VSS.n370 VSS.n305 0.218846
R1145 VSS.n381 VSS.n373 0.218846
R1146 VSS.n370 VSS.n369 0.208386
R1147 VSS.n375 VSS.n373 0.208386
R1148 VSS.n370 VSS.n239 0.208386
R1149 VSS.n379 VSS.n373 0.208386
R1150 VSS.n370 VSS.n287 0.208371
R1151 VSS.n383 VSS.n373 0.20836
R1152 VSS.n441 VSS.n440 0.1501
R1153 VSS.n441 VSS.n427 0.1501
R1154 VSS.n469 VSS.n468 0.1501
R1155 VSS.t109 VSS.t111 0.143158
R1156 VSS.n464 VSS.n28 0.113321
R1157 VSS.n440 VSS.n423 0.106994
R1158 VSS.n342 VSS.n341 0.0927224
R1159 VSS.n343 VSS.n342 0.0891245
R1160 VSS.n438 VSS.n43 0.0846837
R1161 VSS.n332 VSS.n331 0.0814472
R1162 VSS.n338 VSS.n337 0.0794206
R1163 VSS.n339 VSS.n330 0.0784641
R1164 VSS.n443 VSS.n11 0.0779076
R1165 VSS.n336 VSS.n335 0.0776211
R1166 VSS.n344 VSS.n343 0.0773061
R1167 VSS.n483 VSS.n24 0.384827
R1168 VSS.n456 VSS.n427 0.0753
R1169 VSS.n457 VSS.n456 0.0753
R1170 VSS.n467 VSS.n465 0.0753
R1171 VSS.n468 VSS.n467 0.0753
R1172 VSS.n335 VSS.n334 0.0750054
R1173 VSS.n338 VSS.n336 0.0725235
R1174 VSS.n340 VSS.n339 0.0721359
R1175 VSS.n337 VSS.n332 0.0711793
R1176 VSS.n331 VSS.n330 0.0686974
R1177 VSS.n340 VSS.n18 0.0675776
R1178 VSS.n24 VSS.n482 0.379074
R1179 VSS.t12 VSS.n41 31.5502
R1180 VSS.n32 VSS.n31 0.2425
R1181 VSS.n482 VSS.n0 0.2425
R1182 VSS.n465 VSS.n30 0.175033
R1183 VSS.n29 VSS.n457 0.175033
R1184 VSS.n14 VSS.n12 0.0486893
R1185 VSS.n341 VSS.n15 0.0951565
R1186 VSS.n6 VSS.n5 0.0937229
R1187 VSS.n3 VSS.n2 0.0932024
R1188 VSS.n28 VSS.t109 0.0894317
R1189 VSS.n25 VSS.n23 0.0889456
R1190 VSS VSS.n22 0.0889456
R1191 VSS.n351 VSS.n39 0.0617935
R1192 VSS.n40 VSS.n39 0.0278401
R1193 VSS.n350 VSS.n39 0.0617935
R1194 VSS.n349 VSS.n39 0.0617935
R1195 VSS.n347 VSS.n39 0.0617935
R1196 VSS.n344 VSS.n19 0.061725
R1197 VSS.n472 VSS.n471 0.0594056
R1198 VSS.n453 VSS.n452 0.0594056
R1199 VSS.n444 VSS.n438 0.0594056
R1200 VSS.n421 VSS.n402 0.059027
R1201 VSS.n417 VSS.n402 0.059027
R1202 VSS.n466 VSS.n38 0.0587021
R1203 VSS.n444 VSS.n443 0.0586497
R1204 VSS.n453 VSS.n422 0.0586497
R1205 VSS.n472 VSS.n413 0.0586497
R1206 VSS.t111 VSS.n483 0.0585075
R1207 VSS.n449 VSS.n13 0.0582235
R1208 VSS.n452 VSS.n449 0.0582235
R1209 VSS.n417 VSS.n35 0.0874875
R1210 VSS.n36 VSS.n35 0.029764
R1211 VSS.n38 VSS.n37 0.029764
R1212 VSS.n413 VSS.n37 0.0874875
R1213 VSS.n34 VSS.n19 0.0767479
R1214 VSS.n46 VSS.n21 0.0746472
R1215 VSS.n22 VSS.n25 0.0594637
R1216 VSS.n466 VSS.n36 0.0587021
R1217 VSS.n459 VSS.n458 0.0569103
R1218 VSS.n459 VSS.n420 0.0569103
R1219 VSS.n463 VSS.n420 0.0569103
R1220 VSS.n464 VSS.n463 0.0569103
R1221 VSS.n92 VSS.n9 0.0529665
R1222 VSS.n46 VSS.n45 0.0518066
R1223 VSS.n91 VSS.n8 0.0517609
R1224 VSS.n73 VSS.n72 0.050601
R1225 VSS.n72 VSS.n20 0.0758859
R1226 VSS.n93 VSS.n91 0.0480833
R1227 VSS.n17 VSS.n85 0.0920921
R1228 VSS.n8 VSS.n7 0.0912242
R1229 VSS.n14 VSS.n13 0.0596436
R1230 VSS.n389 VSS.n4 0.107126
R1231 VSS.n93 VSS.n92 0.0464069
R1232 VSS.n1 VSS.n31 0.148141
R1233 a_20954_346.n0 a_20954_346.t0 4.85847
R1234 a_20954_346.t15 a_20954_346.n2 4.83761
R1235 a_20954_346.n2 a_20954_346.t14 4.83657
R1236 a_20954_346.n2 a_20954_346.t13 4.83657
R1237 a_20954_346.n2 a_20954_346.t12 4.83657
R1238 a_20954_346.n1 a_20954_346.t11 4.83657
R1239 a_20954_346.n1 a_20954_346.t10 4.83657
R1240 a_20954_346.n1 a_20954_346.t9 4.83657
R1241 a_20954_346.n1 a_20954_346.t8 4.83657
R1242 a_20954_346.n1 a_20954_346.t7 4.83657
R1243 a_20954_346.n1 a_20954_346.t6 4.83657
R1244 a_20954_346.n1 a_20954_346.t5 4.83657
R1245 a_20954_346.n1 a_20954_346.t4 4.83657
R1246 a_20954_346.n0 a_20954_346.t3 4.83657
R1247 a_20954_346.n0 a_20954_346.t2 4.83657
R1248 a_20954_346.n0 a_20954_346.t1 4.83657
R1249 a_20954_346.n2 a_20954_346.t16 0.895788
R1250 a_20954_346.n1 a_20954_346.n0 0.175641
R1251 a_20954_346.n2 a_20954_346.n1 0.131856
R1252 a_11798_1180.n4 a_11798_1180.t10 3.17099
R1253 a_11798_1180.n5 a_11798_1180.t3 3.17099
R1254 a_11798_1180.n10 a_11798_1180.t0 2.79558
R1255 a_11798_1180.n32 a_11798_1180.t8 2.79551
R1256 a_11798_1180.n23 a_11798_1180.t7 2.79551
R1257 a_11798_1180.n24 a_11798_1180.t9 2.79551
R1258 a_11798_1180.n25 a_11798_1180.t11 2.79551
R1259 a_11798_1180.n26 a_11798_1180.t12 2.79551
R1260 a_11798_1180.n19 a_11798_1180.t1 2.79551
R1261 a_11798_1180.n11 a_11798_1180.t2 2.79551
R1262 a_11798_1180.n12 a_11798_1180.t4 2.79551
R1263 a_11798_1180.n13 a_11798_1180.t5 2.79551
R1264 a_11798_1180.n27 a_11798_1180.t13 2.79543
R1265 a_11798_1180.n14 a_11798_1180.t6 2.79543
R1266 a_11798_1180.t28 a_11798_1180.n8 2.61386
R1267 a_11798_1180.n1 a_11798_1180.t14 2.61074
R1268 a_11798_1180.n8 a_11798_1180.t27 2.56233
R1269 a_11798_1180.n7 a_11798_1180.t24 2.5622
R1270 a_11798_1180.n2 a_11798_1180.t21 2.56207
R1271 a_11798_1180.n2 a_11798_1180.t20 2.56174
R1272 a_11798_1180.n1 a_11798_1180.t17 2.56174
R1273 a_11798_1180.n2 a_11798_1180.t23 2.56173
R1274 a_11798_1180.n8 a_11798_1180.t26 2.5617
R1275 a_11798_1180.n7 a_11798_1180.t25 2.56161
R1276 a_11798_1180.n1 a_11798_1180.t16 2.56161
R1277 a_11798_1180.n2 a_11798_1180.t19 2.56153
R1278 a_11798_1180.n2 a_11798_1180.t18 2.56147
R1279 a_11798_1180.n2 a_11798_1180.t22 2.56146
R1280 a_11798_1180.n1 a_11798_1180.t15 2.56146
R1281 a_11798_1180.n20 a_11798_1180.n10 2.36008
R1282 a_11798_1180.n27 a_11798_1180.n21 2.35974
R1283 a_11798_1180.n14 a_11798_1180.n0 2.35974
R1284 a_11798_1180.n33 a_11798_1180.n23 2.35957
R1285 a_11798_1180.n33 a_11798_1180.n32 2.33977
R1286 a_11798_1180.n26 a_11798_1180.n21 2.33977
R1287 a_11798_1180.n20 a_11798_1180.n19 2.33977
R1288 a_11798_1180.n13 a_11798_1180.n0 2.33977
R1289 a_11798_1180.n24 a_11798_1180.n22 2.31337
R1290 a_11798_1180.n25 a_11798_1180.n3 2.31337
R1291 a_11798_1180.n11 a_11798_1180.n9 2.31337
R1292 a_11798_1180.n12 a_11798_1180.n0 2.31337
R1293 a_11798_1180.n31 a_11798_1180.n23 0.748603
R1294 a_11798_1180.n28 a_11798_1180.n27 0.74842
R1295 a_11798_1180.n15 a_11798_1180.n14 0.74842
R1296 a_11798_1180.n18 a_11798_1180.n10 0.74808
R1297 a_11798_1180.n32 a_11798_1180.n31 0.561603
R1298 a_11798_1180.n30 a_11798_1180.n24 0.561603
R1299 a_11798_1180.n29 a_11798_1180.n25 0.561603
R1300 a_11798_1180.n28 a_11798_1180.n26 0.561603
R1301 a_11798_1180.n19 a_11798_1180.n18 0.561603
R1302 a_11798_1180.n17 a_11798_1180.n11 0.561603
R1303 a_11798_1180.n16 a_11798_1180.n12 0.561603
R1304 a_11798_1180.n15 a_11798_1180.n13 0.561603
R1305 a_11798_1180.n4 a_11798_1180.n3 0.401975
R1306 a_11798_1180.n5 a_11798_1180.n0 0.401975
R1307 a_11798_1180.n5 a_11798_1180.n16 0.284179
R1308 a_11798_1180.n4 a_11798_1180.n29 0.284179
R1309 a_11798_1180.n1 a_11798_1180.n33 0.25306
R1310 a_11798_1180.n6 a_11798_1180.n21 0.0449208
R1311 a_11798_1180.n2 a_11798_1180.n20 0.25306
R1312 a_11798_1180.n2 a_11798_1180.n6 0.203345
R1313 a_11798_1180.n2 a_11798_1180.n1 0.196551
R1314 a_11798_1180.n7 a_11798_1180.n0 0.194161
R1315 a_11798_1180.n31 a_11798_1180.n30 0.1875
R1316 a_11798_1180.n30 a_11798_1180.n4 0.1875
R1317 a_11798_1180.n29 a_11798_1180.n28 0.1875
R1318 a_11798_1180.n18 a_11798_1180.n17 0.1875
R1319 a_11798_1180.n17 a_11798_1180.n5 0.1875
R1320 a_11798_1180.n16 a_11798_1180.n15 0.1875
R1321 a_11798_1180.n9 a_11798_1180.n0 0.153033
R1322 a_11798_1180.n22 a_11798_1180.n3 0.153033
R1323 a_11798_1180.n8 a_11798_1180.n7 0.147538
R1324 a_11798_1180.n7 a_11798_1180.n2 0.147538
R1325 a_11798_1180.n33 a_11798_1180.n22 0.106833
R1326 a_11798_1180.n3 a_11798_1180.n6 0.0449208
R1327 a_11798_1180.n20 a_11798_1180.n9 0.106833
R1328 a_5060_3002.n0 a_5060_3002.t4 53.6608
R1329 a_5060_3002.n3 a_5060_3002.t3 29.2688
R1330 a_5060_3002.n2 a_5060_3002.t5 24.2693
R1331 a_5060_3002.n1 a_5060_3002.t0 24.2693
R1332 a_5060_3002.t2 a_5060_3002.n3 15.6064
R1333 a_5060_3002.n0 a_5060_3002.t1 9.21754
R1334 a_5060_3002.n3 a_5060_3002.n2 1.7693
R1335 a_5060_3002.n2 a_5060_3002.n1 0.543167
R1336 a_5060_3002.n1 a_5060_3002.n0 0.320233
R1337 a_5560_3922.n0 a_5560_3922.t2 27.72
R1338 a_5560_3922.n0 a_5560_3922.t0 24.1197
R1339 a_5560_3922.t1 a_5560_3922.n0 9.38813
R1340 a_5560_5708.n0 a_5560_5708.t2 55.2712
R1341 a_5560_5708.n0 a_5560_5708.t0 27.8842
R1342 a_5560_5708.t1 a_5560_5708.n0 7.50485
R1343 a_5060_5708.n0 a_5060_5708.t1 34.3045
R1344 a_5060_5708.t0 a_5060_5708.n0 5.85564
R1345 a_5060_5708.t0 a_5060_5708.n0 5.85498
R1346 a_6568_6136.n2 a_6568_6136.t1 19.9393
R1347 a_6568_6136.n0 a_6568_6136.t4 19.6783
R1348 a_6568_6136.n1 a_6568_6136.t3 17.974
R1349 a_6568_6136.n2 a_6568_6136.n1 5.04317
R1350 a_6568_6136.n0 a_6568_6136.t0 4.81727
R1351 a_6568_6136.n1 a_6568_6136.n0 4.76157
R1352 a_6568_6136.t2 a_6568_6136.n2 3.15445
R1353 a_5948_4416.n0 a_5948_4416.t2 30.2902
R1354 a_5948_4416.n0 a_5948_4416.t1 27.2706
R1355 a_5948_4416.t0 a_5948_4416.n0 11.5346
R1356 vco_feed_0.en_b.n0 vco_feed_0.en_b.t0 27.1774
R1357 vco_feed_0.en_b.n4 vco_feed_0.en_b.t6 24.9608
R1358 vco_feed_0.en_b.n3 vco_feed_0.en_b.t3 24.8442
R1359 vco_feed_0.en_b.n1 vco_feed_0.en_b.t7 20.7725
R1360 vco_feed_0.en_b.n1 vco_feed_0.en_b.t5 20.4909
R1361 vco_feed_0.en_b.n0 vco_feed_0.en_b.t4 20.4287
R1362 vco_feed_0.en_b.n0 vco_feed_0.en_b.t1 12.1418
R1363 vco_feed_0.en_b vco_feed_0.en_b.t2 5.74905
R1364 vco_feed_0.en_b.n2 vco_feed_0.en_b.n1 5.30277
R1365 vco_feed_0.en_b.n2 vco_feed_0.en_b.n0 4.5269
R1366 vco_feed_0.en_b vco_feed_0.en_b.n4 2.33103
R1367 vco_feed_0.en_b.n3 vco_feed_0.en_b.n2 0.562233
R1368 vco_feed_0.en_b.n4 vco_feed_0.en_b.n3 0.469833
R1369 vco_bias_0.vbn_buf.n3 vco_bias_0.vbn_buf.t1 45.045
R1370 vco_bias_0.vbn_buf.n2 vco_bias_0.vbn_buf.t4 34.2391
R1371 vco_bias_0.vbn_buf.n2 vco_bias_0.vbn_buf.t3 28.5544
R1372 vco_bias_0.vbn_buf.n1 vco_bias_0.vbn_buf.n0 22.7415
R1373 vco_bias_0.vbn_buf.n0 vco_bias_0.vbn_buf.t2 21.7736
R1374 vco_bias_0.vbn_buf.n4 vco_bias_0.vbn_buf.t0 17.2373
R1375 vco_bias_0.vbn_buf.n4 vco_bias_0.vbn_buf.n3 13.5293
R1376 vco_bias_0.vbn_buf.n3 vco_bias_0.vbn_buf.n2 6.9349
R1377 vco_bias_0.vbn_buf vco_bias_0.vbn_buf.n4 2.55837
R1378 vco_bias_0.vbn_buf vco_bias_0.vbn_buf.n1 0.2645
R1379 vco_bias_0.vbn_buf.n1 vco_bias_0.vbn_buf 0.1985
R1380 vco_bias_0.vbn_buf.n0 vco_bias_0.vbn_buf 0.1105
C77 vtune VSS 3.224e-15
C78 vco_ind_LC VSS 2.30438e-14
C79 rf_out_p VSS 1.41837e-15
C80 rf_out_n VSS 1.34029e-15
C81 vco_buf_in_n VSS 5.55341e-15
C82 vco_buf_in_p VSS 5.53371e-15
C83 di_en VSS 6.67482e-16
C84 vco_var_rf_p VSS 1.329e-14
C85 vco_ind_LA VSS 4.32216e-16
C86 vco_var_rf_n VSS 1.42965e-14
C87 vco_ind_LB VSS 4.28087e-16
C88 VDD VSS 1.9843e-14
C89 vco_feed_0.en_b VSS 6.22562e-15 ; **FLOATING
C90 vco_bias_0.vbg_buf VSS 1.165e-13 ; **FLOATING
C91 vco_bias_0.vbn_buf VSS 1.14713e-13 ; **FLOATING
C92 vco_bias_0.vbn_buf.t2 VSS 1.19159e-15 ; **FLOATING
C93 vco_bias_0.vbn_buf.n0 VSS 1.02668e-16 ; **FLOATING
C94 vco_bias_0.vbn_buf.n1 VSS 5.81761e-17 ; **FLOATING
C95 vco_bias_0.vbn_buf.t4 VSS 5.31473e-15 ; **FLOATING
C96 vco_bias_0.vbn_buf.t3 VSS 5.30722e-15 ; **FLOATING
C97 vco_bias_0.vbn_buf.n2 VSS 1.11203e-16 ; **FLOATING
C98 vco_bias_0.vbn_buf.t1 VSS 1.97991e-15 ; **FLOATING
C99 vco_bias_0.vbn_buf.n3 VSS 1.58501e-16 ; **FLOATING
C100 vco_bias_0.vbn_buf.t0 VSS 1.59116e-17 ; **FLOATING
C101 vco_bias_0.vbn_buf.n4 VSS 1.07256e-16 ; **FLOATING
C102 vco_feed_0.en_b.n0 VSS 3.37312e-16 ; **FLOATING
C103 vco_feed_0.en_b.t2 VSS 2.27124e-15 ; **FLOATING
C104 vco_feed_0.en_b.t7 VSS 3.88066e-17 ; **FLOATING
C105 vco_feed_0.en_b.t5 VSS 3.18712e-17 ; **FLOATING
C106 vco_feed_0.en_b.n1 VSS 2.68991e-16 ; **FLOATING
C107 vco_feed_0.en_b.t4 VSS 3.672e-17 ; **FLOATING
C108 vco_feed_0.en_b.t0 VSS 1.89621e-17 ; **FLOATING
C109 vco_feed_0.en_b.t1 VSS 4.82023e-17 ; **FLOATING
C110 vco_feed_0.en_b.n2 VSS 9.15676e-17 ; **FLOATING
C111 vco_feed_0.en_b.t3 VSS 5.7105e-17 ; **FLOATING
C112 vco_feed_0.en_b.n3 VSS 1.36324e-16 ; **FLOATING
C113 vco_feed_0.en_b.t6 VSS 6.99545e-17 ; **FLOATING
C114 vco_feed_0.en_b.n4 VSS 2.17029e-16 ; **FLOATING
C115 a_5948_4416.t1 VSS 8.54341e-18 ; **FLOATING
C116 a_5948_4416.t2 VSS 4.11726e-17 ; **FLOATING
C117 a_5948_4416.n0 VSS 1.70368e-16 ; **FLOATING
C118 a_5948_4416.t0 VSS 1.85757e-17 ; **FLOATING
C119 a_6568_6136.t1 VSS 9.43151e-17 ; **FLOATING
C120 a_6568_6136.t3 VSS 3.64069e-17 ; **FLOATING
C121 a_6568_6136.t0 VSS 3.77383e-17 ; **FLOATING
C122 a_6568_6136.t4 VSS 9.39005e-17 ; **FLOATING
C123 a_6568_6136.n0 VSS 7.62276e-17 ; **FLOATING
C124 a_6568_6136.n1 VSS 1.14293e-16 ; **FLOATING
C125 a_6568_6136.n2 VSS 7.62841e-17 ; **FLOATING
C126 a_6568_6136.t2 VSS 7.49346e-17 ; **FLOATING
C127 a_5060_5708.t1 VSS 5.21386e-16 ; **FLOATING
C128 a_5060_5708.n0 VSS 5.71417e-16 ; **FLOATING
C129 a_5060_5708.t0 VSS 9.28369e-17 ; **FLOATING
C130 a_5560_5708.t2 VSS 1.17145e-15 ; **FLOATING
C131 a_5560_5708.t0 VSS 3.41348e-16 ; **FLOATING
C132 a_5560_5708.n0 VSS 1.62269e-15 ; **FLOATING
C133 a_5560_5708.t1 VSS 4.09418e-16 ; **FLOATING
C134 a_5560_3922.t2 VSS 6.7083e-16 ; **FLOATING
C135 a_5560_3922.t0 VSS 3.26854e-16 ; **FLOATING
C136 a_5560_3922.n0 VSS 9.04285e-16 ; **FLOATING
C137 a_5560_3922.t1 VSS 2.9947e-16 ; **FLOATING
C138 a_5060_3002.t4 VSS 2.36213e-15 ; **FLOATING
C139 a_5060_3002.t1 VSS 3.15239e-16 ; **FLOATING
C140 a_5060_3002.n0 VSS 1.22983e-15 ; **FLOATING
C141 a_5060_3002.t0 VSS 3.4166e-16 ; **FLOATING
C142 a_5060_3002.n1 VSS 2.13541e-16 ; **FLOATING
C143 a_5060_3002.t5 VSS 3.4166e-16 ; **FLOATING
C144 a_5060_3002.n2 VSS 3.44393e-16 ; **FLOATING
C145 a_5060_3002.t3 VSS 1.03597e-15 ; **FLOATING
C146 a_5060_3002.n3 VSS 1.15104e-15 ; **FLOATING
C147 a_5060_3002.t2 VSS 1.43857e-16 ; **FLOATING
C148 a_11798_1180.n0 VSS 5.85171e-16 ; **FLOATING
C149 a_11798_1180.n1 VSS 1.94804e-15 ; **FLOATING
C150 a_11798_1180.n2 VSS 3.31918e-15 ; **FLOATING
C151 a_11798_1180.n3 VSS 3.0118e-16 ; **FLOATING
C152 a_11798_1180.n4 VSS 9.1002e-17 ; **FLOATING
C153 a_11798_1180.n5 VSS 9.1002e-17 ; **FLOATING
C154 a_11798_1180.n7 VSS 1.33223e-15 ; **FLOATING
C155 a_11798_1180.n8 VSS 1.30858e-15 ; **FLOATING
C156 a_11798_1180.n9 VSS 8.04377e-17 ; **FLOATING
C157 a_11798_1180.t0 VSS 5.78245e-17 ; **FLOATING
C158 a_11798_1180.n10 VSS 4.65222e-17 ; **FLOATING
C159 a_11798_1180.t2 VSS 6.45613e-17 ; **FLOATING
C160 a_11798_1180.n11 VSS 3.49024e-17 ; **FLOATING
C161 a_11798_1180.t3 VSS 6.8775e-17 ; **FLOATING
C162 a_11798_1180.t4 VSS 6.45613e-17 ; **FLOATING
C163 a_11798_1180.n12 VSS 3.49024e-17 ; **FLOATING
C164 a_11798_1180.t5 VSS 6.45613e-17 ; **FLOATING
C165 a_11798_1180.n13 VSS 3.55975e-17 ; **FLOATING
C166 a_11798_1180.t6 VSS 5.78245e-17 ; **FLOATING
C167 a_11798_1180.n14 VSS 4.65136e-17 ; **FLOATING
C168 a_11798_1180.n15 VSS 9.0693e-17 ; **FLOATING
C169 a_11798_1180.n16 VSS 5.96181e-17 ; **FLOATING
C170 a_11798_1180.n17 VSS 5.96181e-17 ; **FLOATING
C171 a_11798_1180.n18 VSS 9.06844e-17 ; **FLOATING
C172 a_11798_1180.t1 VSS 6.45613e-17 ; **FLOATING
C173 a_11798_1180.n19 VSS 3.55975e-17 ; **FLOATING
C174 a_11798_1180.n20 VSS 2.83999e-16 ; **FLOATING
C175 a_11798_1180.n21 VSS 2.83991e-16 ; **FLOATING
C176 a_11798_1180.n22 VSS 8.04377e-17 ; **FLOATING
C177 a_11798_1180.t7 VSS 5.78245e-17 ; **FLOATING
C178 a_11798_1180.n23 VSS 4.65222e-17 ; **FLOATING
C179 a_11798_1180.t9 VSS 6.45613e-17 ; **FLOATING
C180 a_11798_1180.n24 VSS 3.49024e-17 ; **FLOATING
C181 a_11798_1180.t10 VSS 6.8775e-17 ; **FLOATING
C182 a_11798_1180.t11 VSS 6.45613e-17 ; **FLOATING
C183 a_11798_1180.n25 VSS 3.49024e-17 ; **FLOATING
C184 a_11798_1180.t12 VSS 6.45613e-17 ; **FLOATING
C185 a_11798_1180.n26 VSS 3.55975e-17 ; **FLOATING
C186 a_11798_1180.t13 VSS 5.78245e-17 ; **FLOATING
C187 a_11798_1180.n27 VSS 4.65136e-17 ; **FLOATING
C188 a_11798_1180.n28 VSS 9.0693e-17 ; **FLOATING
C189 a_11798_1180.n29 VSS 5.96181e-17 ; **FLOATING
C190 a_11798_1180.n30 VSS 5.96181e-17 ; **FLOATING
C191 a_11798_1180.n31 VSS 9.06844e-17 ; **FLOATING
C192 a_11798_1180.t8 VSS 6.45613e-17 ; **FLOATING
C193 a_11798_1180.n32 VSS 3.55975e-17 ; **FLOATING
C194 a_11798_1180.n33 VSS 2.83991e-16 ; **FLOATING
C195 a_11798_1180.t14 VSS 2.07707e-16 ; **FLOATING
C196 a_11798_1180.t15 VSS 2.02077e-16 ; **FLOATING
C197 a_11798_1180.t16 VSS 2.02085e-16 ; **FLOATING
C198 a_11798_1180.t17 VSS 2.02085e-16 ; **FLOATING
C199 a_11798_1180.t18 VSS 2.02077e-16 ; **FLOATING
C200 a_11798_1180.t19 VSS 2.02077e-16 ; **FLOATING
C201 a_11798_1180.t20 VSS 2.02085e-16 ; **FLOATING
C202 a_11798_1180.t21 VSS 2.02077e-16 ; **FLOATING
C203 a_11798_1180.t22 VSS 2.02077e-16 ; **FLOATING
C204 a_11798_1180.t23 VSS 2.02085e-16 ; **FLOATING
C205 a_11798_1180.t24 VSS 2.02077e-16 ; **FLOATING
C206 a_11798_1180.t25 VSS 2.02085e-16 ; **FLOATING
C207 a_11798_1180.t26 VSS 2.02085e-16 ; **FLOATING
C208 a_11798_1180.t27 VSS 2.02077e-16 ; **FLOATING
C209 a_11798_1180.t28 VSS 2.07672e-16 ; **FLOATING
C210 a_20954_346.n0 VSS 8.27911e-16 ; **FLOATING
C211 a_20954_346.n1 VSS 1.81409e-15 ; **FLOATING
C212 a_20954_346.n2 VSS 6.13094e-15 ; **FLOATING
C213 a_20954_346.t16 VSS 6.50721e-15 ; **FLOATING
C214 a_20954_346.t0 VSS 7.68158e-17 ; **FLOATING
C215 a_20954_346.t1 VSS 7.61466e-17 ; **FLOATING
C216 a_20954_346.t2 VSS 7.61466e-17 ; **FLOATING
C217 a_20954_346.t3 VSS 7.61466e-17 ; **FLOATING
C218 a_20954_346.t4 VSS 7.61466e-17 ; **FLOATING
C219 a_20954_346.t5 VSS 7.61466e-17 ; **FLOATING
C220 a_20954_346.t6 VSS 7.61466e-17 ; **FLOATING
C221 a_20954_346.t7 VSS 7.61466e-17 ; **FLOATING
C222 a_20954_346.t8 VSS 7.61466e-17 ; **FLOATING
C223 a_20954_346.t9 VSS 7.61466e-17 ; **FLOATING
C224 a_20954_346.t10 VSS 7.61466e-17 ; **FLOATING
C225 a_20954_346.t11 VSS 7.61466e-17 ; **FLOATING
C226 a_20954_346.t12 VSS 7.61466e-17 ; **FLOATING
C227 a_20954_346.t13 VSS 7.61466e-17 ; **FLOATING
C228 a_20954_346.t14 VSS 7.61466e-17 ; **FLOATING
C229 a_20954_346.t15 VSS 7.61425e-17 ; **FLOATING
C230 VDD.n0 VSS 1.39623e-16 ; **FLOATING
C231 VDD.n2 VSS 6.08719e-17 ; **FLOATING
C232 VDD.n3 VSS 7.29776e-17 ; **FLOATING
C233 VDD.n4 VSS 8.25516e-17 ; **FLOATING
C234 VDD.n5 VSS 8.25516e-17 ; **FLOATING
C235 VDD.n6 VSS 8.25516e-17 ; **FLOATING
C236 VDD.n7 VSS 8.4752e-16 ; **FLOATING
C237 VDD.n8 VSS 1.48568e-17 ; **FLOATING
C238 VDD.n9 VSS 1.48568e-17 ; **FLOATING
C239 VDD.n10 VSS 8.25516e-17 ; **FLOATING
C240 VDD.n11 VSS 1.48568e-17 ; **FLOATING
C241 VDD.n12 VSS 1.48568e-17 ; **FLOATING
C242 VDD.n13 VSS 8.25516e-17 ; **FLOATING
C243 VDD.n14 VSS 1.48568e-17 ; **FLOATING
C244 VDD.n15 VSS 1.48568e-17 ; **FLOATING
C245 VDD.n16 VSS 1.14253e-16 ; **FLOATING
C246 VDD.n17 VSS 1.54399e-16 ; **FLOATING
C247 VDD.n18 VSS 2.72867e-17 ; **FLOATING
C248 VDD.n19 VSS 4.46658e-17 ; **FLOATING
C249 VDD.n20 VSS 5.06352e-18 ; **FLOATING
C250 VDD.n21 VSS 4.97007e-17 ; **FLOATING
C251 VDD.n22 VSS 4.50806e-17 ; **FLOATING
C252 VDD.n23 VSS 3.62504e-17 ; **FLOATING
C253 VDD.n24 VSS 6.03136e-16 ; **FLOATING
C254 VDD.n25 VSS 5.58751e-17 ; **FLOATING
C255 VDD.n26 VSS 1.48568e-17 ; **FLOATING
C256 VDD.n27 VSS 4.0532e-17 ; **FLOATING
C257 VDD.n29 VSS 2.30023e-16 ; **FLOATING
C258 VDD.n31 VSS 2.62378e-17 ; **FLOATING
C259 VDD.n32 VSS 3.54923e-17 ; **FLOATING
C260 VDD.n33 VSS 3.74233e-17 ; **FLOATING
C261 VDD.n34 VSS 2.61424e-17 ; **FLOATING
C262 VDD.n35 VSS 1.48568e-17 ; **FLOATING
C263 VDD.n36 VSS 2.61424e-17 ; **FLOATING
C264 VDD.n38 VSS 1.48568e-17 ; **FLOATING
C265 VDD.n39 VSS 2.61424e-17 ; **FLOATING
C266 VDD.n40 VSS 1.48568e-17 ; **FLOATING
C267 VDD.n41 VSS 2.61424e-17 ; **FLOATING
C268 VDD.n43 VSS 1.48568e-17 ; **FLOATING
C269 VDD.n44 VSS 1.48568e-17 ; **FLOATING
C270 VDD.n45 VSS 1.48568e-17 ; **FLOATING
C271 VDD.n46 VSS 2.61424e-17 ; **FLOATING
C272 VDD.n47 VSS 2.61424e-17 ; **FLOATING
C273 VDD.n49 VSS 2.61424e-17 ; **FLOATING
C274 VDD.n50 VSS 2.61424e-17 ; **FLOATING
C275 VDD.n52 VSS 2.61424e-17 ; **FLOATING
C276 VDD.t16 VSS 2.96421e-17 ; **FLOATING
C277 VDD.t19 VSS 2.67098e-17 ; **FLOATING
C278 VDD.t15 VSS 2.67098e-17 ; **FLOATING
C279 VDD.t14 VSS 2.67098e-17 ; **FLOATING
C280 VDD.t12 VSS 2.67098e-17 ; **FLOATING
C281 VDD.t10 VSS 2.67098e-17 ; **FLOATING
C282 VDD.t8 VSS 2.67098e-17 ; **FLOATING
C283 VDD.t6 VSS 2.67098e-17 ; **FLOATING
C284 VDD.t5 VSS 2.39444e-17 ; **FLOATING
C285 VDD.t4 VSS 1.99633e-15 ; **FLOATING
C286 VDD.t22 VSS 2.67098e-17 ; **FLOATING
C287 VDD.n53 VSS 1.48568e-17 ; **FLOATING
C288 VDD.t24 VSS 2.67098e-17 ; **FLOATING
C289 VDD.t28 VSS 2.67098e-17 ; **FLOATING
C290 VDD.t30 VSS 2.67098e-17 ; **FLOATING
C291 VDD.t27 VSS 2.67098e-17 ; **FLOATING
C292 VDD.t33 VSS 2.67098e-17 ; **FLOATING
C293 VDD.t26 VSS 2.67098e-17 ; **FLOATING
C294 VDD.t36 VSS 2.39444e-17 ; **FLOATING
C295 VDD.n54 VSS 1.78606e-17 ; **FLOATING
C296 VDD.n55 VSS 1.74124e-17 ; **FLOATING
C297 VDD.n56 VSS 2.14552e-15 ; **FLOATING
C298 VDD.t38 VSS 4.78379e-16 ; **FLOATING
C299 VDD.n57 VSS 2.7586e-15 ; **FLOATING
C300 VDD.t3 VSS 4.78145e-16 ; **FLOATING
C301 VDD.n58 VSS 2.7586e-15 ; **FLOATING
C302 VDD.n59 VSS 1.98421e-15 ; **FLOATING
C303 VDD.t37 VSS 8.10068e-18 ; **FLOATING
C304 VDD.t48 VSS 8.10068e-18 ; **FLOATING
C305 VDD.t50 VSS 8.10068e-18 ; **FLOATING
C306 VDD.t1 VSS 4.82036e-17 ; **FLOATING
C307 VDD.t45 VSS 6.99309e-17 ; **FLOATING
C308 VDD.t46 VSS 5.01727e-17 ; **FLOATING
C309 VDD.t47 VSS 4.82036e-17 ; **FLOATING
C310 VDD.t49 VSS 4.81988e-17 ; **FLOATING
C311 VDD.t43 VSS 4.82036e-17 ; **FLOATING
C312 VDD.t44 VSS 4.82036e-17 ; **FLOATING
C313 VDD.t42 VSS 6.99309e-17 ; **FLOATING
C314 VDD.t2 VSS 1.70262e-17 ; **FLOATING
C315 VDD.t40 VSS 8.10068e-18 ; **FLOATING
C316 VDD.t41 VSS 8.10068e-18 ; **FLOATING
C317 VDD.t39 VSS 7.03743e-18 ; **FLOATING
C318 VDD.t0 VSS 2.48564e-15 ; **FLOATING
C319 VDD.n60 VSS 2.03866e-16 ; **FLOATING
C320 vco_var_rf_n.n0 VSS 4.71722e-16 ; **FLOATING
C321 vco_var_rf_n.n1 VSS 3.44657e-16 ; **FLOATING
C322 vco_var_rf_n.n2 VSS 3.66503e-16 ; **FLOATING
C323 vco_var_rf_n.t4 VSS 1.39062e-17 ; **FLOATING
C324 vco_var_rf_n.t2 VSS 1.37559e-17 ; **FLOATING
C325 vco_var_rf_n.t5 VSS 1.37559e-17 ; **FLOATING
C326 vco_var_rf_n.t0 VSS 1.7853e-15 ; **FLOATING
C327 vco_var_rf_n.n3 VSS 1.20798e-15 ; **FLOATING
C328 vco_var_rf_n.t6 VSS 1.37559e-17 ; **FLOATING
C329 vco_var_rf_n.t3 VSS 1.37559e-17 ; **FLOATING
C330 vco_var_rf_n.t7 VSS 2.91157e-16 ; **FLOATING
C331 vco_var_rf_p.n0 VSS 4.00293e-16 ; **FLOATING
C332 vco_var_rf_p.n1 VSS 3.54531e-16 ; **FLOATING
C333 vco_var_rf_p.n2 VSS 4.74369e-16 ; **FLOATING
C334 vco_var_rf_p.t7 VSS 2.01474e-16 ; **FLOATING
C335 vco_var_rf_p.t1 VSS 1.39856e-17 ; **FLOATING
C336 vco_var_rf_p.t0 VSS 1.38385e-17 ; **FLOATING
C337 vco_var_rf_p.t3 VSS 1.38385e-17 ; **FLOATING
C338 vco_var_rf_p.t4 VSS 1.38385e-17 ; **FLOATING
C339 vco_var_rf_p.t2 VSS 1.38385e-17 ; **FLOATING
C340 vco_var_rf_p.t5 VSS 1.78785e-15 ; **FLOATING
C341 vco_var_rf_p.n3 VSS 1.28011e-15 ; **FLOATING
C342 di_en.t0 VSS 3.21404e-17 ; **FLOATING
C343 di_en.t1 VSS 2.63174e-17 ; **FLOATING
C344 di_en.n0 VSS 4.3899e-16 ; **FLOATING
C345 vco_buf_in_p.t0 VSS 3.13182e-16 ; **FLOATING
C346 vco_buf_in_p.t1 VSS 1.22555e-16 ; **FLOATING
C347 vco_buf_in_p.n0 VSS 3.24195e-16 ; **FLOATING
C348 vco_buf_in_n.t0 VSS 3.29423e-16 ; **FLOATING
C349 vco_buf_in_n.t1 VSS 1.22828e-16 ; **FLOATING
C350 vco_buf_in_n.n0 VSS 3.23958e-16 ; **FLOATING
C351 rf_out_n.n0 VSS 3.25157e-16 ; **FLOATING
C352 rf_out_n.n1 VSS 5.08995e-16 ; **FLOATING
C353 rf_out_n.t5 VSS 4.09549e-17 ; **FLOATING
C354 rf_out_n.t4 VSS 4.05646e-17 ; **FLOATING
C355 rf_out_n.t3 VSS 4.05646e-17 ; **FLOATING
C356 rf_out_n.t2 VSS 4.05646e-17 ; **FLOATING
C357 rf_out_n.t1 VSS 4.05646e-17 ; **FLOATING
C358 rf_out_n.t6 VSS 4.05646e-17 ; **FLOATING
C359 rf_out_n.t0 VSS 5.87282e-16 ; **FLOATING
C360 rf_out_n.n2 VSS 1.56579e-15 ; **FLOATING
C361 rf_out_p.n0 VSS 4.56582e-16 ; **FLOATING
C362 rf_out_p.n1 VSS 3.93858e-16 ; **FLOATING
C363 rf_out_p.t2 VSS 4.17543e-17 ; **FLOATING
C364 rf_out_p.t4 VSS 4.1357e-17 ; **FLOATING
C365 rf_out_p.t0 VSS 4.1357e-17 ; **FLOATING
C366 rf_out_p.t1 VSS 4.1357e-17 ; **FLOATING
C367 rf_out_p.t5 VSS 4.1357e-17 ; **FLOATING
C368 rf_out_p.t3 VSS 4.1357e-17 ; **FLOATING
C369 rf_out_p.t6 VSS 6.00421e-16 ; **FLOATING
C370 rf_out_p.n2 VSS 1.59637e-15 ; **FLOATING
C371 vco_ind_LC.t1 VSS 7.50303e-15 ; **FLOATING
C372 vco_ind_LC.t0 VSS 5.65938e-15 ; **FLOATING
Cpexcaps0 a_5060_3002.n0 a_5560_3922.n0 1.14087e-15
Cpexcaps1 a_5060_5708.n0 vco_bias_0.vbg_buf 6.712e-17
Cpexcaps2 a_11798_1180.n0 rf_out_p 5.43569e-15
Cpexcaps3 a_5948_4416.n0 vco_feed_0.en_b 1.06442e-15
Cpexcaps4 a_5060_3002.n0 vco_bias_0.vbg_buf 1.0933e-16
Cpexcaps5 a_5560_5708.n0 a_5948_4416.n0 1.3792e-16
Cpexcaps6 a_5948_4416.n0 di_en 5.4427e-16
Cpexcaps7 a_6568_6136.n0 vco_feed_0.en_b 4.6022e-16
Cpexcaps8 VDD a_5560_5708.n0 7.3988e-16
Cpexcaps9 a_5560_5708.n0 a_6568_6136.n0 1.4475e-15
Cpexcaps10 a_20954_346.n0 vco_ind_LC 6.73114e-15
Cpexcaps11 a_5060_3002.n0 a_5060_5708.n0 2.947e-17
Cpexcaps12 a_1560_1090# a_5060_3002.n0 1.292e-17
Cpexcaps13 VDD a_20954_346.n0 2.00535e-14
Cpexcaps14 a_11798_1180.n0 rf_out_n 5.43569e-15
Cpexcaps15 a_5948_4416.n0 vco_bias_0.vbn_buf 5.694e-17
Cpexcaps16 a_6568_6136.n0 vco_bias_0.vbn_buf 1.8893e-16
Cpexcaps17 a_5560_3922.n0 a_5948_4416.n0 4.189e-17
Cpexcaps18 a_11798_1180.n0 vco_buf_in_n 6.7412e-16
Cpexcaps19 VDD a_5560_3922.n0 3.807e-17
Cpexcaps20 a_5560_3922.n0 a_6568_6136.n0 2.017e-17
Cpexcaps21 a_5560_4008# a_5560_5708.n0 5.126e-17
Cpexcaps22 a_5560_5708.n0 vco_feed_0.en_b 9.729e-16
Cpexcaps23 a_5948_4416.n0 vco_bias_0.vbg_buf 8.974e-17
Cpexcaps24 a_1160_1390# a_5060_3002.n0 3.029e-17
Cpexcaps25 a_5560_5708.n0 di_en 2.601e-17
Cpexcaps26 a_6568_6136.n0 vco_bias_0.vbg_buf 6.052e-17
Cpexcaps27 VDD a_11798_1180.n0 2.528e-16
Cpexcaps28 a_20954_346.n0 vco_feed_0.en_b 1.77578e-15
Cpexcaps29 a_5060_5708.n0 a_5948_4416.n0 6.35e-17
Cpexcaps30 VDD a_5060_5708.n0 4.8738e-16
Cpexcaps31 a_5060_5708.n0 a_6568_6136.n0 4.613e-17
Cpexcaps32 a_5560_5708.n0 vco_bias_0.vbn_buf 1.1403e-16
Cpexcaps33 a_5560_3922.n0 a_5560_4008# 8.577e-17
Cpexcaps34 a_20954_346.n0 a_24640_164# 4.48501e-15
Cpexcaps35 a_5060_3002.n0 a_5948_4416.n0 2.188e-17
Cpexcaps36 a_5560_3922.n0 vco_feed_0.en_b 2.4975e-16
Cpexcaps37 VDD a_5060_3002.n0 7.086e-17
Cpexcaps38 a_5560_3922.n0 di_en 3.357e-17
Cpexcaps39 a_5060_3002.n0 a_6568_6136.n0 5.4053e-16
Cpexcaps40 a_5560_3922.n0 vco_bias_0.vbn_buf 1.1041e-16
Cpexcaps41 a_11798_1180.n0 vtune 3.7376e-16
Cpexcaps42 a_11798_1180.n0 vco_feed_0.en_b 9.314e-17
Cpexcaps43 a_5560_5708.n0 vco_bias_0.vbg_buf 6.439e-17
Cpexcaps44 a_5060_3088# a_5060_5708.n0 4.473e-17
Cpexcaps45 a_5060_5708.n0 vco_feed_0.en_b 2.2592e-16
Cpexcaps46 a_5060_5708.n0 a_5560_5708.n0 1.05064e-15
Cpexcaps47 a_5060_5708.n0 di_en 3.461e-17
Cpexcaps48 a_1560_1090# a_5560_5708.n0 3.113e-17
Cpexcaps49 a_5060_3002.n0 a_5560_4008# 1.375e-17
Cpexcaps50 a_11798_1180.n0 vco_bias_0.vbn_buf 4.5225e-15
Cpexcaps51 a_5060_3002.n0 a_5060_3088# 1.6001e-16
Cpexcaps52 a_5060_3002.n0 vco_feed_0.en_b 2.05821e-15
Cpexcaps53 a_5060_5708.n0 vco_bias_0.vbn_buf 1.9153e-16
Cpexcaps54 a_5060_3002.n0 a_5560_5708.n0 8.6224e-16
Cpexcaps55 a_11798_1180.n0 vco_buf_in_p 6.7412e-16
Cpexcaps56 a_5560_3922.n0 vco_bias_0.vbg_buf 8.461e-17
Cpexcaps57 a_5060_3002.n0 di_en 2.091e-17
Cpexcaps58 VDD a_5948_4416.n0 5.4158e-16
Cpexcaps59 a_5948_4416.n0 a_6568_6136.n0 1.8081e-16
Cpexcaps60 VDD a_6568_6136.n0 2.07678e-15
Cpexcaps61 a_5060_3002.n0 vco_bias_0.vbn_buf 5.343e-17
.ends

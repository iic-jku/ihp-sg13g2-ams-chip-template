* Capacitances rebuilt per net pair from the C-coupled extraction vco_top_leads_CC.spice (magic#557):
* 0.4285 pF in 127 net pairs, the full-RC run had 0.4659 pF, 0.0 fF of it between pairs without coupling.
* NGSPICE file created from vco_top_leads.ext - technology: ihp-sg13g2

.subckt vco_top_leads ibias_100u di_en vtune VDD vdd_core VSS rf_out_p rf_out_n
+ vco_ind_LA vco_ind_LB vco_ind_LC vco_var_rf_p vco_var_rf_n vco_var_VSS
X0 VSS.t150 vco_var_rf_p.t7 vco_var_rf_n.t3 VSS.t149 sg13_lv_nmos ad=0.68p pd=4.68u as=0.38p ps=2.38u w=2u l=0.13u
X1 VSS.t125 vco_var_rf_n.t7 vco_var_rf_p.t4 VSS.t124 sg13_lv_nmos ad=0.68p pd=4.68u as=0.38p ps=2.38u w=2u l=0.13u
X2 a_1474_1090.t2 a_2654_4840.t4 VDD.t6 VDD.t5 sg13_lv_pmos ad=1.7p pd=10.68u as=1.7p ps=10.68u w=5u l=0.5u
X3 rf_out_n.t6 a_9450_4394# a_11798_1180.t26 VSS.t159 sg13_lv_nmos ad=0.38p pd=2.38u as=0.38p ps=2.38u w=2u l=0.13u
X4 rf_out_n.t4 a_9450_4394# a_11798_1180.t24 VSS.t155 sg13_lv_nmos ad=0.38p pd=2.38u as=0.38p ps=2.38u w=2u l=0.13u
X5 VSS.t39 vco_bias_0.vbn_buf.t2 a_11798_1180.t12 VSS.t40 sg13_lv_nmos ad=0.95p pd=5.38u as=0.95p ps=5.38u w=5u l=0.5u
X6 a_11798_1180.t10 vco_bias_0.vbn_buf.t2 VSS.t32 VSS.t33 sg13_lv_nmos ad=0.95p pd=5.38u as=0.95p ps=5.38u w=5u l=0.5u
X7 a_11798_1180.t0 vco_bias_0.vbn_buf.t2 VSS.t7 VSS.t6 sg13_lv_nmos ad=0.95p pd=5.38u as=1.7p ps=10.68u w=5u l=0.5u
X8 VSS.t62 vco_bias_0.vbn_buf.t3 VSS.t60 VSS.t49 sg13_lv_nmos ad=1.52p pd=8.38u as=0 ps=0 w=8u l=10u
X9 VSS.t1 vco_bias_0.vbn_buf.t2 a_11798_1180.t3 VSS.t15 sg13_lv_nmos ad=0.95p pd=5.38u as=0.95p ps=5.38u w=5u l=0.5u
X10 VSS.t66 vco_bias_0.vbn_buf.t3 VSS.t64 VSS.t53 sg13_lv_nmos ad=1.52p pd=8.38u as=0 ps=0 w=8u l=10u
X11 VSS.t144 vco_var_rf_p.t7 vco_var_rf_n.t5 VSS.t143 sg13_lv_nmos ad=0.38p pd=2.38u as=0.38p ps=2.38u w=2u l=0.13u
X12 a_11798_1180.t17 a_14668_2644# rf_out_p.t1 VSS.t101 sg13_lv_nmos ad=0.38p pd=2.38u as=0.38p ps=2.38u w=2u l=0.13u
X13 VSS.t52 vco_bias_0.vbn_buf.t4 VSS.t50 VSS.t51 sg13_lv_nmos ad=1.52p pd=8.38u as=0 ps=0 w=8u l=10u
X14 rf_out_p.t5 a_14668_2644# a_11798_1180.t15 VSS.t98 sg13_lv_nmos ad=0.38p pd=2.38u as=0.68p ps=4.68u w=2u l=0.13u
X15 ibias_100u.t0 a_1254_2820.t3 VSS.t73 VSS.t69 sg13_lv_nmos ad=0.34p pd=2.68u as=0.34p ps=2.68u w=1u l=0.13u
X16 VSS.t75 vco_bias_0.vbg_buf VSS.t74 VSS.t46 sg13_lv_nmos ad=2.72p pd=16.68u as=0 ps=0 w=8u l=10u
X17 VSS.t91 vco_bias_0.vbg_buf VSS.t89 VSS.t53 sg13_lv_nmos ad=1.52p pd=8.38u as=0 ps=0 w=8u l=10u
X18 VSS.t116 vco_var_rf_n.t7 vco_var_rf_p.t0 VSS.t115 sg13_lv_nmos ad=0.38p pd=2.38u as=0.38p ps=2.38u w=2u l=0.13u
X19 vco_var_rf_n.t6 vco_var_rf_p.t7 VSS.t144 VSS.t145 sg13_lv_nmos ad=0.38p pd=2.38u as=0.38p ps=2.38u w=2u l=0.13u
X20 vco_var_rf_n.t4 vco_var_rf_p.t7 VSS.t138 VSS.t139 sg13_lv_nmos ad=0.38p pd=2.38u as=0.38p ps=2.38u w=2u l=0.13u
X21 a_1474_1090.t1 vco_bias_0.vbg_buf VSS.t96 rhigh l=32u w=0.5u
X22 a_2654_4840.t0 a_1954_2820.t2 VDD.t3 VDD.t2 sg13_lv_pmos ad=0.34p pd=2.68u as=0.34p ps=2.68u w=1u l=0.13u
X23 vco_var_rf_p.t3 vco_var_rf_n.t7 VSS.t119 VSS.t120 sg13_lv_nmos ad=0.38p pd=2.38u as=0.38p ps=2.38u w=2u l=0.13u
X24 a_11798_1180.t20 a_14668_2644# rf_out_p.t6 VSS.t107 sg13_lv_nmos ad=0.38p pd=2.38u as=0.38p ps=2.38u w=2u l=0.13u
X25 a_1954_2820.t1 a_1254_2820.t4 VSS.t72 VSS.t71 sg13_lv_nmos ad=0.17p pd=1.68u as=0.17p ps=1.68u w=0.5u l=0.13u
X26 VSS.t32 vco_bias_0.vbn_buf.t2 a_11798_1180.t9 VSS.t31 sg13_lv_nmos ad=0.95p pd=5.38u as=0.95p ps=5.38u w=5u l=0.5u
X27 VSS.t89 vco_bias_0.vbg_buf VSS.t87 VSS.t51 sg13_lv_nmos ad=1.52p pd=8.38u as=0 ps=0 w=8u l=10u
X28 VSS.t9 vco_bias_0.vbn_buf.t2 a_11798_1180.t0 VSS.t8 sg13_lv_nmos ad=0.95p pd=5.38u as=0.95p ps=5.38u w=5u l=0.5u
X29 a_11798_1180.t13 vco_bias_0.vbn_buf.t2 VSS.t39 VSS.t38 sg13_lv_nmos ad=0.95p pd=5.38u as=0.95p ps=5.38u w=5u l=0.5u
X30 ibias_100u.t3 vco_bias_0.vbn_buf.t1 VSS.t134 rhigh l=32u w=0.5u
X31 a_11798_1180.t14 vco_bias_0.vbn_buf.t2 VSS.t42 VSS.t43 sg13_lv_nmos ad=0.95p pd=5.38u as=0.95p ps=5.38u w=5u l=0.5u
X32 a_1254_2820.t1 di_en.t1 VDD.t9 VDD.t8 sg13_lv_pmos ad=0.34p pd=2.68u as=0.34p ps=2.68u w=1u l=0.13u
X33 a_5428_2384.t1 a_5428_2384.t0 VSS.t58 VSS.t57 sg13_lv_nmos ad=0.85p pd=5.68u as=0.85p ps=5.68u w=2.5u l=0.5u
X34 a_11798_1180.t27 a_9450_4394# rf_out_n.t6 VSS.t160 sg13_lv_nmos ad=0.38p pd=2.38u as=0.38p ps=2.38u w=2u l=0.13u
X35 VSS.t64 vco_bias_0.vbn_buf.t3 VSS.t62 VSS.t51 sg13_lv_nmos ad=1.52p pd=8.38u as=0 ps=0 w=8u l=10u
X36 a_11798_1180.t4 vco_bias_0.vbn_buf.t2 VSS.t1 VSS.t0 sg13_lv_nmos ad=0.95p pd=5.38u as=0.95p ps=5.38u w=5u l=0.5u
X37 a_11798_1180.t25 a_9450_4394# rf_out_n.t4 VSS.t156 sg13_lv_nmos ad=0.38p pd=2.38u as=0.38p ps=2.38u w=2u l=0.13u
X38 VSS.t28 vco_bias_0.vbn_buf.t2 a_11798_1180.t7 VSS.t27 sg13_lv_nmos ad=0.95p pd=5.38u as=0.95p ps=5.38u w=5u l=0.5u
X39 VSS.t77 vco_bias_0.vbg_buf VSS.t75 VSS.t49 sg13_lv_nmos ad=1.52p pd=8.38u as=0 ps=0 w=8u l=10u
X40 a_2654_4840.t1 ibias_100u.t4 VSS.t127 VSS.t57 sg13_lv_nmos ad=0.85p pd=5.68u as=0.85p ps=5.68u w=2.5u l=0.5u
X41 VSS.t93 vco_bias_0.vbg_buf VSS.t91 VSS.t55 sg13_lv_nmos ad=1.52p pd=8.38u as=0 ps=0 w=8u l=10u
X42 VSS.t42 vco_bias_0.vbn_buf.t2 a_11798_1180.t13 VSS.t41 sg13_lv_nmos ad=0.95p pd=5.38u as=0.95p ps=5.38u w=5u l=0.5u
X43 VSS.t147 vco_var_rf_p.t7 vco_var_rf_n.t6 VSS.t146 sg13_lv_nmos ad=0.38p pd=2.38u as=0.38p ps=2.38u w=2u l=0.13u
X44 VSS.t45 vco_bias_0.vbn_buf.t2 a_11798_1180.t14 VSS.t44 sg13_lv_nmos ad=1.7p pd=10.68u as=0.95p ps=5.38u w=5u l=0.5u
X45 VSS.t48 vco_bias_0.vbn_buf.t4 VSS.t47 VSS.t46 sg13_lv_nmos ad=2.72p pd=16.68u as=0 ps=0 w=8u l=10u
X46 VSS.t122 vco_var_rf_n.t7 vco_var_rf_p.t3 VSS.t121 sg13_lv_nmos ad=0.38p pd=2.38u as=0.38p ps=2.38u w=2u l=0.13u
X47 VDD.t4 rf_out_p.t0 VSS.t97 rppd l=1.65u w=10u
X48 rf_out_p.t3 a_14668_2644# a_11798_1180.t20 VSS.t108 sg13_lv_nmos ad=0.38p pd=2.38u as=0.38p ps=2.38u w=2u l=0.13u
X49 a_2654_4840.t3 a_2654_4840.t2 VDD.t11 VDD.t10 sg13_lv_pmos ad=1.7p pd=10.68u as=1.7p ps=10.68u w=5u l=0.5u
X50 a_11798_1180.t7 vco_bias_0.vbn_buf.t2 VSS.t25 VSS.t26 sg13_lv_nmos ad=0.95p pd=5.38u as=0.95p ps=5.38u w=5u l=0.5u
X51 rf_out_p.t4 a_14668_2644# a_11798_1180.t18 VSS.t104 sg13_lv_nmos ad=0.38p pd=2.38u as=0.38p ps=2.38u w=2u l=0.13u
X52 VSS.t56 vco_bias_0.vbn_buf.t4 VSS.t54 VSS.t55 sg13_lv_nmos ad=1.52p pd=8.38u as=0 ps=0 w=8u l=10u
X53 vco_var_rf_p.t1 vco_var_rf_n.t7 VSS.t116 VSS.t117 sg13_lv_nmos ad=0.38p pd=2.38u as=0.38p ps=2.38u w=2u l=0.13u
X54 VSS.t3 vco_bias_0.vbn_buf.t2 a_11798_1180.t10 VSS.t2 sg13_lv_nmos ad=0.95p pd=5.38u as=0.95p ps=5.38u w=5u l=0.5u
X55 a_11798_1180.t8 vco_bias_0.vbn_buf.t2 VSS.t28 VSS.t29 sg13_lv_nmos ad=0.95p pd=5.38u as=0.95p ps=5.38u w=5u l=0.5u
X56 vco_var_rf_p.t2 vco_var_rf_n.t7 VSS.t111 VSS.t110 sg13_lv_nmos ad=0.38p pd=2.38u as=0.68p ps=4.68u w=2u l=0.13u
X57 VSS.t36 vco_bias_0.vbn_buf.t2 a_11798_1180.t11 VSS.t35 sg13_lv_nmos ad=0.95p pd=5.38u as=0.95p ps=5.38u w=5u l=0.5u
X58 VSS.t141 vco_var_rf_p.t7 vco_var_rf_n.t4 VSS.t140 sg13_lv_nmos ad=0.38p pd=2.38u as=0.38p ps=2.38u w=2u l=0.13u
X59 rf_out_n.t1 a_9450_4394# a_11798_1180.t22 VSS.t151 sg13_lv_nmos ad=0.38p pd=2.38u as=0.68p ps=4.68u w=2u l=0.13u
X60 a_1954_2820.t0 a_1254_2820.t5 VDD.t1 VDD.t0 sg13_lv_pmos ad=0.34p pd=2.68u as=0.34p ps=2.68u w=1u l=0.13u
X61 VSS.t113 vco_var_rf_n.t7 vco_var_rf_p.t2 VSS.t112 sg13_lv_nmos ad=0.38p pd=2.38u as=0.38p ps=2.38u w=2u l=0.13u
X62 rf_out_n.t3 a_9450_4394# a_11798_1180.t27 VSS.t161 sg13_lv_nmos ad=0.38p pd=2.38u as=0.38p ps=2.38u w=2u l=0.13u
X63 VSS.t60 vco_bias_0.vbn_buf.t3 VSS.t59 VSS.t46 sg13_lv_nmos ad=2.72p pd=16.68u as=0 ps=0 w=8u l=10u
X64 rf_out_n.t5 a_9450_4394# a_11798_1180.t25 VSS.t157 sg13_lv_nmos ad=0.38p pd=2.38u as=0.38p ps=2.38u w=2u l=0.13u
X65 VSS.t85 vco_bias_0.vbg_buf VSS.t84 VSS.t46 sg13_lv_nmos ad=2.72p pd=16.68u as=0 ps=0 w=8u l=10u
X66 VSS.t11 vco_bias_0.vbn_buf.t2 a_11798_1180.t1 VSS.t13 sg13_lv_nmos ad=0.95p pd=5.38u as=0.95p ps=5.38u w=5u l=0.5u
X67 a_11798_1180.t5 vco_bias_0.vbn_buf.t2 VSS.t17 VSS.t18 sg13_lv_nmos ad=0.95p pd=5.38u as=0.95p ps=5.38u w=5u l=0.5u
X68 a_11798_1180.t11 vco_bias_0.vbn_buf.t2 VSS.t3 VSS.t34 sg13_lv_nmos ad=0.95p pd=5.38u as=0.95p ps=5.38u w=5u l=0.5u
X69 a_11798_1180.t12 vco_bias_0.vbn_buf.t2 VSS.t36 VSS.t37 sg13_lv_nmos ad=0.95p pd=5.38u as=0.95p ps=5.38u w=5u l=0.5u
X70 a_9450_4394# vco_var_rf_p.t5 cap_cmim l=10u w=10u
X71 a_11798_1180.t16 a_14668_2644# rf_out_p.t5 VSS.t99 sg13_lv_nmos ad=0.38p pd=2.38u as=0.38p ps=2.38u w=2u l=0.13u
X72 VSS.t68 vco_bias_0.vbn_buf.t3 VSS.t66 VSS.t55 sg13_lv_nmos ad=1.52p pd=8.38u as=0 ps=0 w=8u l=10u
X73 vco_var_rf_n.t3 vco_var_rf_p.t7 VSS.t147 VSS.t148 sg13_lv_nmos ad=0.38p pd=2.38u as=0.38p ps=2.38u w=2u l=0.13u
X74 vco_var_rf_p.t4 vco_var_rf_n.t7 VSS.t122 VSS.t123 sg13_lv_nmos ad=0.38p pd=2.38u as=0.38p ps=2.38u w=2u l=0.13u
X75 a_11798_1180.t1 vco_bias_0.vbn_buf.t2 VSS.t9 VSS.t12 sg13_lv_nmos ad=0.95p pd=5.38u as=0.95p ps=5.38u w=5u l=0.5u
X76 ibias_100u.t2 ibias_100u.t1 VSS.t126 VSS.t57 sg13_lv_nmos ad=0.85p pd=5.68u as=0.85p ps=5.68u w=2.5u l=0.5u
X77 VSS.t17 vco_bias_0.vbn_buf.t2 a_11798_1180.t4 VSS.t16 sg13_lv_nmos ad=0.95p pd=5.38u as=0.95p ps=5.38u w=5u l=0.5u
X78 a_11798_1180.t2 vco_bias_0.vbn_buf.t2 VSS.t11 VSS.t10 sg13_lv_nmos ad=0.95p pd=5.38u as=0.95p ps=5.38u w=5u l=0.5u
X79 a_11798_1180.t19 a_14668_2644# rf_out_p.t4 VSS.t105 sg13_lv_nmos ad=0.38p pd=2.38u as=0.38p ps=2.38u w=2u l=0.13u
X80 rf_out_p.t2 a_14668_2644# a_11798_1180.t17 VSS.t102 sg13_lv_nmos ad=0.38p pd=2.38u as=0.38p ps=2.38u w=2u l=0.13u
X81 a_1474_1090.t0 a_5428_2384.t2 VSS.t94 rppd l=8.5u w=0.5u
X82 vco_bias_0.vbn_buf.t0 a_1254_2820.t2 VSS.t70 VSS.t69 sg13_lv_nmos ad=0.34p pd=2.68u as=0.34p ps=2.68u w=1u l=0.13u
X83 VSS.t81 vco_bias_0.vbg_buf VSS.t79 VSS.t53 sg13_lv_nmos ad=1.52p pd=8.38u as=0 ps=0 w=8u l=10u
X84 a_14668_2644# vco_var_rf_n.t0 cap_cmim l=10u w=10u
X85 VSS.t20 vco_bias_0.vbn_buf.t2 a_11798_1180.t5 VSS.t19 sg13_lv_nmos ad=0.95p pd=5.38u as=0.95p ps=5.38u w=5u l=0.5u
X86 a_11798_1180.t9 vco_bias_0.vbn_buf.t2 VSS.t22 VSS.t21 sg13_lv_nmos ad=0.95p pd=5.38u as=0.95p ps=5.38u w=5u l=0.5u
X87 a_11798_1180.t23 a_9450_4394# rf_out_n.t1 VSS.t152 sg13_lv_nmos ad=0.38p pd=2.38u as=0.38p ps=2.38u w=2u l=0.13u
X88 VSS.t87 vco_bias_0.vbg_buf VSS.t85 VSS.t49 sg13_lv_nmos ad=1.52p pd=8.38u as=0 ps=0 w=8u l=10u
X89 VSS.t79 vco_bias_0.vbg_buf VSS.t77 VSS.t51 sg13_lv_nmos ad=1.52p pd=8.38u as=0 ps=0 w=8u l=10u
X90 VSS.t119 vco_var_rf_n.t7 vco_var_rf_p.t1 VSS.t118 sg13_lv_nmos ad=0.38p pd=2.38u as=0.38p ps=2.38u w=2u l=0.13u
X91 vco_var_rf_n.t5 vco_var_rf_p.t7 VSS.t141 VSS.t142 sg13_lv_nmos ad=0.38p pd=2.38u as=0.38p ps=2.38u w=2u l=0.13u
X92 a_11798_1180.t28 a_9450_4394# rf_out_n.t3 VSS.t162 sg13_lv_nmos ad=0.68p pd=4.68u as=0.38p ps=2.38u w=2u l=0.13u
X93 vco_var_rf_n.t2 vco_var_rf_p.t7 VSS.t136 VSS.t135 sg13_lv_nmos ad=0.38p pd=2.38u as=0.68p ps=4.68u w=2u l=0.13u
X94 vco_ind_LC VSS.t130 cap_cmim l=39u w=56u
X95 a_11798_1180.t26 a_9450_4394# rf_out_n.t5 VSS.t158 sg13_lv_nmos ad=0.38p pd=2.38u as=0.38p ps=2.38u w=2u l=0.13u
X96 a_11798_1180.t24 a_9450_4394# rf_out_n.t2 VSS.t154 sg13_lv_nmos ad=0.38p pd=2.38u as=0.38p ps=2.38u w=2u l=0.13u
X97 VSS.t5 vco_bias_0.vbn_buf.t2 a_11798_1180.t2 VSS.t4 sg13_lv_nmos ad=0.95p pd=5.38u as=0.95p ps=5.38u w=5u l=0.5u
X98 vco_bias_0.vbg_buf a_14668_2644# VSS.t95 rhigh l=8u w=0.5u
X99 vco_var_rf_p.t0 vco_var_rf_n.t7 VSS.t113 VSS.t114 sg13_lv_nmos ad=0.38p pd=2.38u as=0.38p ps=2.38u w=2u l=0.13u
X100 VSS.t22 vco_bias_0.vbn_buf.t2 a_11798_1180.t8 VSS.t30 sg13_lv_nmos ad=0.95p pd=5.38u as=0.95p ps=5.38u w=5u l=0.5u
X101 a_11798_1180.t6 vco_bias_0.vbn_buf.t2 VSS.t20 VSS.t23 sg13_lv_nmos ad=0.95p pd=5.38u as=0.95p ps=5.38u w=5u l=0.5u
X102 VSS.t138 vco_var_rf_p.t7 vco_var_rf_n.t2 VSS.t137 sg13_lv_nmos ad=0.38p pd=2.38u as=0.38p ps=2.38u w=2u l=0.13u
X103 rf_out_p.t1 a_14668_2644# a_11798_1180.t16 VSS.t100 sg13_lv_nmos ad=0.38p pd=2.38u as=0.38p ps=2.38u w=2u l=0.13u
X104 a_1254_2820.t0 di_en.t0 VSS.t163 VSS.t71 sg13_lv_nmos ad=0.17p pd=1.68u as=0.17p ps=1.68u w=0.5u l=0.13u
X105 VDD.t7 rf_out_n.t0 VSS.t129 rppd l=1.65u w=10u
X106 VSS.t83 vco_bias_0.vbg_buf VSS.t81 VSS.t55 sg13_lv_nmos ad=1.52p pd=8.38u as=0 ps=0 w=8u l=10u
X107 VSS.t50 vco_bias_0.vbn_buf.t4 VSS.t48 VSS.t49 sg13_lv_nmos ad=1.52p pd=8.38u as=0 ps=0 w=8u l=10u
X108 VSS.t54 vco_bias_0.vbn_buf.t4 VSS.t52 VSS.t53 sg13_lv_nmos ad=1.52p pd=8.38u as=0 ps=0 w=8u l=10u
X109 vco_ind_LC VSS.t132 cap_cmim l=25.5u w=42u
X110 a_11798_1180.t21 a_14668_2644# rf_out_p.t3 VSS.t109 sg13_lv_nmos ad=0.68p pd=4.68u as=0.38p ps=2.38u w=2u l=0.13u
X111 rf_out_p.t6 a_14668_2644# a_11798_1180.t19 VSS.t106 sg13_lv_nmos ad=0.38p pd=2.38u as=0.38p ps=2.38u w=2u l=0.13u
X112 a_11798_1180.t18 a_14668_2644# rf_out_p.t2 VSS.t103 sg13_lv_nmos ad=0.38p pd=2.38u as=0.38p ps=2.38u w=2u l=0.13u
X113 vco_bias_0.vbg_buf a_9450_4394# VSS.t128 rhigh l=8u w=0.5u
X114 a_11798_1180.t3 vco_bias_0.vbn_buf.t2 VSS.t5 VSS.t14 sg13_lv_nmos ad=0.95p pd=5.38u as=0.95p ps=5.38u w=5u l=0.5u
X115 VSS.t25 vco_bias_0.vbn_buf.t2 a_11798_1180.t6 VSS.t24 sg13_lv_nmos ad=0.95p pd=5.38u as=0.95p ps=5.38u w=5u l=0.5u
X116 rf_out_n.t2 a_9450_4394# a_11798_1180.t23 VSS.t153 sg13_lv_nmos ad=0.38p pd=2.38u as=0.38p ps=2.38u w=2u l=0.13u
C0 ibias_100u VDD 1.9944e-16
C1 vco_var_rf_n vco_bias_0.vbn_buf 2.147e-17
C2 a_16500_3480# VDD 3.2168e-16
C3 vco_ind_LC vco_var_rf_n 1.02248e-15
C4 VDD a_10100_3480# 3.5541e-16
C5 rf_out_n VDD 4.295e-16
C6 vco_var_rf_n a_14668_2644# 1.61363e-15
C7 a_9450_4394# vco_var_rf_p 1.61363e-15
C8 vco_bias_0.vbg_buf a_1560_1090# 3.586e-17
C9 vco_ind_LC a_19050_4480# 1.117e-17
C10 ibias_100u vco_bias_0.vbn_buf 2.722e-17
C11 vco_bias_0.vbg_buf a_9450_4394# 6.134e-17
C12 di_en VDD 2.3329e-16
C13 a_14668_2644# a_19050_4480# 3.458e-17
C14 vtune a_9450_4394# 1.3593e-16
C15 vco_bias_0.vbn_buf a_10100_3480# 1.657e-17
C16 rf_out_n vco_bias_0.vbn_buf 1.9616e-16
C17 a_16500_3480# a_14668_2644# 6.15e-17
C18 vco_bias_0.vbg_buf a_6760_4250# 1.222e-17
C19 vco_bias_0.vbg_buf vco_var_rf_p 8.721e-16
C20 vtune vco_var_rf_p 1.0739e-16
C21 di_en vco_bias_0.vbn_buf 4.963e-17
C22 vtune rf_out_p 3.195e-17
C23 vco_bias_0.vbn_buf VDD 4.152e-16
C24 a_9450_4394# a_9450_4480# 3.458e-17
C25 vco_ind_LC VDD 4.1391e-16
C26 vtune vco_bias_0.vbg_buf 1.3019e-16
C27 VDD a_14668_2644# 4.8463e-16
C28 ibias_100u a_1160_1390# 3.363e-17
C29 vco_var_rf_n vco_var_rf_p 4.50125e-15
C30 vco_var_rf_n rf_out_p 1.58e-17
C31 a_9450_4394# a_10100_3480# 6.15e-17
C32 rf_out_n a_9450_4394# 6.427e-16
C33 vco_bias_0.vbg_buf vco_var_rf_n 5.8809e-16
C34 vco_bias_0.vbg_buf a_9450_4480# 5.793e-17
C35 vtune vco_var_rf_n 5.716e-17
C36 vco_bias_0.vbn_buf a_14668_2644# 1.624e-17
C37 vco_ind_LC a_14668_2644# 1.048e-17
C38 vco_var_rf_p a_10100_3480# 1.479e-17
C39 vco_bias_0.vbg_buf a_19050_4480# 3.836e-17
C40 a_1560_1090# VDD 6.45e-17
C41 a_16500_3480# rf_out_p 4.7902e-16
C42 rf_out_n vco_var_rf_p 1.58e-17
C43 a_1160_1390# VDD 3.044e-17
C44 a_9450_4394# VDD 5.0447e-16
C45 rf_out_n rf_out_p 1.053e-17
C46 vtune rf_out_n 3.195e-17
C47 vco_var_rf_p VDD 9.747e-17
C48 a_1160_1390# vco_bias_0.vbn_buf 3.612e-17
C49 a_9450_4394# vco_bias_0.vbn_buf 3.271e-17
C50 rf_out_p VDD 4.155e-16
C51 vco_bias_0.vbg_buf di_en 6.388e-17
C52 vco_var_rf_n a_16500_3480# 1.479e-17
C53 vco_bias_0.vbg_buf VDD 5.7293e-16
C54 a_9450_4394# a_14668_2644# 1.402e-16
C55 vtune VDD 3.1839e-16
C56 vco_bias_0.vbn_buf a_6760_4250# 4.32e-17
C57 vco_var_rf_p vco_bias_0.vbn_buf 2.9334e-16
C58 vco_ind_LC vco_var_rf_p 5.4907e-16
C59 rf_out_p vco_bias_0.vbn_buf 1.7253e-16
C60 vco_bias_0.vbg_buf vco_bias_0.vbn_buf 5.04344e-15
C61 vco_bias_0.vbg_buf vco_ind_LC 2.892e-17
C62 vtune vco_bias_0.vbn_buf 9.328e-17
C63 rf_out_p a_14668_2644# 6.427e-16
C64 vco_var_rf_n VDD 9.747e-17
C65 rf_out_n a_10100_3480# 4.7902e-16
C66 vco_bias_0.vbg_buf a_14668_2644# 5.188e-17
C67 a_1560_1090# a_1160_1390# 1.7942e-16
C68 vtune a_14668_2644# 1.3593e-16
C69 di_en ibias_100u 1.7714e-16
R0 ibias_100u.n3 ibias_100u.t3 54.3738
R1 ibias_100u.n0 ibias_100u.t4 34.6784
R2 ibias_100u.n1 ibias_100u.t1 34.2252
R3 ibias_100u.n2 ibias_100u.t0 20.5585
R4 ibias_100u.n0 ibias_100u.t2 14.6093
R5 ibias_100u.n3 ibias_100u.n2 1.7473
R6 ibias_100u ibias_100u.n3 1.2149
R7 ibias_100u.n2 ibias_100u.n1 0.5351
R8 ibias_100u.n1 ibias_100u.n0 0.3173
R9 rf_out_p rf_out_p.n2 6.6125
R10 rf_out_p.n0 rf_out_p.t5 4.77599
R11 rf_out_p.n1 rf_out_p.t3 4.72949
R12 rf_out_p.n1 rf_out_p.t6 4.72949
R13 rf_out_p.n0 rf_out_p.t4 4.72949
R14 rf_out_p.n0 rf_out_p.t2 4.72949
R15 rf_out_p.n0 rf_out_p.t1 4.72949
R16 rf_out_p.n2 rf_out_p.t0 2.40801
R17 rf_out_p.n2 rf_out_p.n1 0.685593
R18 rf_out_p.n1 rf_out_p.n0 0.186531
R19 rf_out_n rf_out_n.n2 6.6125
R20 rf_out_n.n0 rf_out_n.t3 4.77599
R21 rf_out_n.n0 rf_out_n.t6 4.72949
R22 rf_out_n.n0 rf_out_n.t5 4.72949
R23 rf_out_n.n1 rf_out_n.t4 4.72949
R24 rf_out_n.n1 rf_out_n.t2 4.72949
R25 rf_out_n.n1 rf_out_n.t1 4.72949
R26 rf_out_n.n2 rf_out_n.t0 2.40801
R27 rf_out_n.n2 rf_out_n.n1 0.685593
R28 rf_out_n.n1 rf_out_n.n0 0.186531
R29 di_en.n0 di_en.t1 26.3252
R30 di_en.n0 di_en.t0 24.5065
R31 di_en di_en.n0 10.1632
R32 vco_var_rf_p vco_var_rf_p.t5 4.85508
R33 vco_var_rf_p.n0 vco_var_rf_p.t4 4.75718
R34 vco_var_rf_p.n1 vco_var_rf_p.t2 4.81938
R35 vco_var_rf_p.n0 vco_var_rf_p.t3 4.72949
R36 vco_var_rf_p.n0 vco_var_rf_p.t1 4.72949
R37 vco_var_rf_p.n0 vco_var_rf_p.t0 4.72949
R38 vco_var_rf_p.n4 vco_var_rf_p.t7 4.13789
R39 vco_ind_LA vco_var_rf_p.n3 0.424928
R40 vco_var_rf_p.n2 vco_var_rf_p.n1 0.225881
R41 vco_var_rf_p.n3 vco_var_rf_p.n5 0.714879
R42 vco_var_rf_p.n4 vco_var_rf_p.n3 0.321512
R43 vco_var_rf_p.n5 vco_var_rf_p.n2 0.47922
R44 vco_var_rf_p.n5 vco_var_rf_p 0.47746
R45 vco_var_rf_p.n0 vco_var_rf_p.n1 0.0646573
R46 vco_var_rf_p.n2 vco_var_rf_p.n4 0.163811
R47 vco_var_rf_n vco_var_rf_n.t0 5.01313
R48 vco_var_rf_n.n0 vco_var_rf_n.t2 4.75718
R49 vco_var_rf_n.n1 vco_var_rf_n.t3 4.81949
R50 vco_var_rf_n.n0 vco_var_rf_n.t6 4.72949
R51 vco_var_rf_n.n0 vco_var_rf_n.t5 4.72949
R52 vco_var_rf_n.n0 vco_var_rf_n.t4 4.72949
R53 vco_var_rf_n.n4 vco_var_rf_n.t7 3.9789
R54 vco_var_rf_n.n5 vco_var_rf_n.n3 0.725624
R55 vco_var_rf_n.n2 vco_var_rf_n.n1 0.2259
R56 vco_var_rf_n.n3 vco_var_rf_n.n4 0.35065
R57 vco_ind_LB vco_var_rf_n.n3 0.413372
R58 vco_var_rf_n.n5 vco_var_rf_n.n2 0.47922
R59 vco_var_rf_n.n5 vco_var_rf_n 0.319412
R60 vco_var_rf_n.n0 vco_var_rf_n.n1 0.0645602
R61 vco_var_rf_n.n2 vco_var_rf_n.n4 0.146211
R62 VDD VDD.n9 17.6809
R63 VDD.n7 VDD.t8 17.0005
R64 VDD.n5 VDD.t0 17.0005
R65 VDD.n3 VDD.t2 17.0005
R66 VDD VDD.n8 16.7718
R67 VDD.n1 VDD.t10 11.3356
R68 VDD.n0 VDD.t5 11.3356
R69 VDD.n7 VDD.t9 6.19097
R70 VDD.n5 VDD.t1 6.19097
R71 VDD.n3 VDD.t3 6.19097
R72 VDD.n9 VDD.t4 4.22454
R73 VDD.n0 VDD.t6 2.44339
R74 VDD.n1 VDD.t11 2.44272
R75 VDD.n2 VDD.n0 1.42463
R76 VDD.n4 VDD.n2 0.851625
R77 VDD.n8 VDD.n7 0.751488
R78 VDD.n6 VDD.n5 0.751488
R79 VDD.n4 VDD.n3 0.751488
R80 VDD.n9 VDD.t7 0.517741
R81 VDD.n8 VDD.n6 0.370375
R82 VDD.n6 VDD.n4 0.370375
R83 VDD.n2 VDD.n1 0.143127
R84 VSS.n188 VSS.n186 2420.69
R85 VSS.n188 VSS.n187 1880.72
R86 VSS.t71 VSS.n188 900.284
R87 VSS.n185 VSS.t134 358.603
R88 VSS.t97 VSS.t95 303.798
R89 VSS.t134 VSS.t96 141.554
R90 VSS.n398 VSS.t97 110.507
R91 VSS.n203 VSS.n185 89.1795
R92 VSS.t57 VSS.t69 70.7775
R93 VSS.n203 VSS.n202 52.3755
R94 VSS.n202 VSS.n190 47.1851
R95 VSS.n190 VSS.t57 33.0298
R96 VSS.n243 VSS.n63 25.4435
R97 VSS.t69 VSS.t71 23.5928
R98 VSS.n225 VSS.n98 21.2107
R99 VSS.n231 VSS.n86 21.2107
R100 VSS.n216 VSS.n102 21.2107
R101 VSS.n237 VSS.n80 21.2107
R102 VSS.n205 VSS.n112 21.2107
R103 VSS.n187 VSS.n95 21.0225
R104 VSS.t46 VSS.n93 19.9631
R105 VSS.n189 VSS.t163 17.4597
R106 VSS.n192 VSS.t72 17.4597
R107 VSS.n190 VSS.n189 17.0005
R108 VSS.n192 VSS.n190 17.0005
R109 VSS.n202 VSS.n191 17.0005
R110 VSS.n202 VSS.n201 17.0005
R111 VSS.n384 VSS.n383 17.0005
R112 VSS.n384 VSS.n368 17.0005
R113 VSS.n384 VSS.n382 17.0005
R114 VSS.n384 VSS.n369 17.0005
R115 VSS.n384 VSS.n381 17.0005
R116 VSS.n384 VSS.n370 17.0005
R117 VSS.n384 VSS.n380 17.0005
R118 VSS.n384 VSS.n371 17.0005
R119 VSS.n384 VSS.n379 17.0005
R120 VSS.n384 VSS.n372 17.0005
R121 VSS.n384 VSS.n378 17.0005
R122 VSS.n384 VSS.n373 17.0005
R123 VSS.n384 VSS.n377 17.0005
R124 VSS.n384 VSS.n374 17.0005
R125 VSS.n384 VSS.n376 17.0005
R126 VSS.n384 VSS.n375 17.0005
R127 VSS.n395 VSS.n394 17.0005
R128 VSS.n394 VSS.n361 17.0005
R129 VSS.n394 VSS.n393 17.0005
R130 VSS.n394 VSS.n362 17.0005
R131 VSS.n394 VSS.n392 17.0005
R132 VSS.n394 VSS.n363 17.0005
R133 VSS.n394 VSS.n391 17.0005
R134 VSS.n394 VSS.n364 17.0005
R135 VSS.n394 VSS.n390 17.0005
R136 VSS.n394 VSS.n365 17.0005
R137 VSS.n394 VSS.n389 17.0005
R138 VSS.n394 VSS.n366 17.0005
R139 VSS.n394 VSS.n388 17.0005
R140 VSS.n394 VSS.n367 17.0005
R141 VSS.n394 VSS.n387 17.0005
R142 VSS.n394 VSS.n386 17.0005
R143 VSS.n399 VSS.n398 17.0005
R144 VSS.n399 VSS.n38 17.0005
R145 VSS.n399 VSS.n360 17.0005
R146 VSS.n399 VSS.n39 17.0005
R147 VSS.n399 VSS.n359 17.0005
R148 VSS.n399 VSS.n40 17.0005
R149 VSS.n399 VSS.n358 17.0005
R150 VSS.n399 VSS.n41 17.0005
R151 VSS.n399 VSS.n357 17.0005
R152 VSS.n399 VSS.n42 17.0005
R153 VSS.n399 VSS.n356 17.0005
R154 VSS.n399 VSS.n43 17.0005
R155 VSS.n399 VSS.n355 17.0005
R156 VSS.n399 VSS.n44 17.0005
R157 VSS.n399 VSS.n354 17.0005
R158 VSS.n399 VSS.n45 17.0005
R159 VSS.n399 VSS.n353 17.0005
R160 VSS.n399 VSS.n46 17.0005
R161 VSS.n399 VSS.n352 17.0005
R162 VSS.n399 VSS.n47 17.0005
R163 VSS.n399 VSS.n350 17.0005
R164 VSS.n399 VSS.n51 17.0005
R165 VSS.n399 VSS.n346 17.0005
R166 VSS.n399 VSS.n53 17.0005
R167 VSS.n399 VSS.n344 17.0005
R168 VSS.n399 VSS.n54 17.0005
R169 VSS.n399 VSS.n73 17.0005
R170 VSS.n399 VSS.n55 17.0005
R171 VSS.n399 VSS.n72 17.0005
R172 VSS.n399 VSS.n56 17.0005
R173 VSS.n399 VSS.n71 17.0005
R174 VSS.n399 VSS.n57 17.0005
R175 VSS.n399 VSS.n70 17.0005
R176 VSS.n399 VSS.n58 17.0005
R177 VSS.n399 VSS.n69 17.0005
R178 VSS.n399 VSS.n59 17.0005
R179 VSS.n399 VSS.n68 17.0005
R180 VSS.n399 VSS.n60 17.0005
R181 VSS.n399 VSS.n67 17.0005
R182 VSS.n399 VSS.n61 17.0005
R183 VSS.n399 VSS.n66 17.0005
R184 VSS.n399 VSS.n63 17.0005
R185 VSS.n65 VSS.t12 15.6926
R186 VSS.t41 VSS.n396 15.6926
R187 VSS.t26 VSS.n50 14.9331
R188 VSS.n50 VSS.t27 14.9331
R189 VSS.t43 VSS.n37 14.555
R190 VSS.n64 VSS.t8 14.5543
R191 VSS.n325 VSS.n203 14.3486
R192 VSS.t8 VSS.n62 13.0361
R193 VSS.n397 VSS.t43 13.0354
R194 VSS.t24 VSS.n347 12.6546
R195 VSS.n349 VSS.t29 12.6546
R196 VSS.t6 VSS.n63 12.5321
R197 VSS.n398 VSS.t44 12.5321
R198 VSS.n186 VSS.n107 12.4771
R199 VSS.n348 VSS.t24 12.2766
R200 VSS.t29 VSS.n49 12.2759
R201 VSS.t55 VSS.n259 12.1524
R202 VSS.t94 VSS.n304 11.7727
R203 VSS.n402 VSS.t130 11.5239
R204 VSS.n278 VSS.t128 11.3929
R205 VSS.n195 VSS.n185 11.3338
R206 VSS.n197 VSS.n185 11.3338
R207 VSS.n199 VSS.n185 11.3338
R208 VSS.t49 VSS.n212 11.2294
R209 VSS.t162 VSS.t23 11.203
R210 VSS.t30 VSS.t98 11.203
R211 VSS.t18 VSS.n53 11.0132
R212 VSS.n352 VSS.t31 11.0132
R213 VSS.t27 VSS.n49 9.99808
R214 VSS.n348 VSS.t26 9.99739
R215 VSS.n234 VSS.t49 9.98179
R216 VSS.t159 VSS.n345 9.80648
R217 VSS.n52 VSS.t161 9.80648
R218 VSS.t99 VSS.n48 9.80648
R219 VSS.n351 VSS.t101 9.80648
R220 VSS.n342 VSS.n341 9.75612
R221 VSS.n344 VSS.t16 9.49417
R222 VSS.t33 VSS.n46 9.49417
R223 VSS.n207 VSS.n77 9.43808
R224 VSS.n209 VSS.n78 9.43808
R225 VSS.n213 VSS.n84 9.43808
R226 VSS.n217 VSS.n85 9.43808
R227 VSS.n220 VSS.n88 9.43808
R228 VSS.n221 VSS.n89 9.43808
R229 VSS.n222 VSS.n90 9.43808
R230 VSS.n223 VSS.n91 9.43808
R231 VSS.n226 VSS.n94 9.43808
R232 VSS.n242 VSS.n110 9.43808
R233 VSS.n240 VSS.n108 9.43808
R234 VSS.n238 VSS.n105 9.43808
R235 VSS.n235 VSS.n104 9.43808
R236 VSS.n233 VSS.n100 9.43808
R237 VSS.n227 VSS.n94 9.43808
R238 VSS.n229 VSS.n92 9.43808
R239 VSS.n229 VSS.n97 9.43808
R240 VSS.n224 VSS.n91 9.43808
R241 VSS.n223 VSS.n90 9.43808
R242 VSS.n222 VSS.n89 9.43808
R243 VSS.n221 VSS.n88 9.43808
R244 VSS.n220 VSS.n87 9.43808
R245 VSS.n230 VSS.n87 9.43808
R246 VSS.n217 VSS.n99 9.43808
R247 VSS.n232 VSS.n85 9.43808
R248 VSS.n232 VSS.n100 9.43808
R249 VSS.n233 VSS.n101 9.43808
R250 VSS.n215 VSS.n103 9.43808
R251 VSS.n214 VSS.n103 9.43808
R252 VSS.n214 VSS.n84 9.43808
R253 VSS.n213 VSS.n83 9.43808
R254 VSS.n235 VSS.n82 9.43808
R255 VSS.n211 VSS.n104 9.43808
R256 VSS.n211 VSS.n81 9.43808
R257 VSS.n236 VSS.n81 9.43808
R258 VSS.n238 VSS.n106 9.43808
R259 VSS.n210 VSS.n106 9.43808
R260 VSS.n239 VSS.n78 9.43808
R261 VSS.n239 VSS.n108 9.43808
R262 VSS.n240 VSS.n109 9.43808
R263 VSS.n207 VSS.n109 9.43808
R264 VSS.n241 VSS.n77 9.43808
R265 VSS.n241 VSS.n110 9.43808
R266 VSS.n242 VSS.n111 9.43808
R267 VSS.n206 VSS.n111 9.43808
R268 VSS.n204 VSS.n113 9.43808
R269 VSS.n204 VSS.n76 9.43808
R270 VSS.n34 VSS.n342 9.55191
R271 VSS.n397 VSS.t41 9.23859
R272 VSS.t12 VSS.n62 9.23789
R273 VSS.n375 VSS.n65 9.23686
R274 VSS.n396 VSS.n395 9.23686
R275 VSS.n400 VSS.n22 9.0005
R276 VSS.n0 VSS.n343 9.0005
R277 VSS.n186 VSS.n79 8.73412
R278 VSS.n326 VSS.n325 8.5005
R279 VSS.n326 VSS.n205 8.5005
R280 VSS.n326 VSS.n237 8.5005
R281 VSS.n326 VSS.n212 8.5005
R282 VSS.n326 VSS.n234 8.5005
R283 VSS.n326 VSS.n216 8.5005
R284 VSS.n326 VSS.n231 8.5005
R285 VSS.n326 VSS.n225 8.5005
R286 VSS.n326 VSS.n228 8.5005
R287 VSS.n329 VSS.n112 8.5005
R288 VSS.n329 VSS.n107 8.5005
R289 VSS.n329 VSS.n102 8.5005
R290 VSS.n329 VSS.n98 8.5005
R291 VSS.n329 VSS.n96 8.5005
R292 VSS.n329 VSS.n79 8.5005
R293 VSS.n329 VSS.n80 8.5005
R294 VSS.n329 VSS.n86 8.5005
R295 VSS.n329 VSS.n93 8.5005
R296 VSS.n326 VSS.n243 8.5005
R297 VSS.n326 VSS.n246 8.5005
R298 VSS.n326 VSS.n247 8.5005
R299 VSS.n326 VSS.n248 8.5005
R300 VSS.n326 VSS.n249 8.5005
R301 VSS.n326 VSS.n250 8.5005
R302 VSS.n326 VSS.n251 8.5005
R303 VSS.n326 VSS.n252 8.5005
R304 VSS.n326 VSS.n253 8.5005
R305 VSS.n326 VSS.n254 8.5005
R306 VSS.n326 VSS.n255 8.5005
R307 VSS.n326 VSS.n256 8.5005
R308 VSS.n326 VSS.n257 8.5005
R309 VSS.n326 VSS.n258 8.5005
R310 VSS.n326 VSS.n259 8.5005
R311 VSS.n326 VSS.n260 8.5005
R312 VSS.n326 VSS.n261 8.5005
R313 VSS.n326 VSS.n262 8.5005
R314 VSS.n326 VSS.n263 8.5005
R315 VSS.n326 VSS.n264 8.5005
R316 VSS.n326 VSS.n265 8.5005
R317 VSS.n326 VSS.n266 8.5005
R318 VSS.n326 VSS.n267 8.5005
R319 VSS.n326 VSS.n268 8.5005
R320 VSS.n326 VSS.n269 8.5005
R321 VSS.n326 VSS.n270 8.5005
R322 VSS.n326 VSS.n271 8.5005
R323 VSS.n326 VSS.n272 8.5005
R324 VSS.n326 VSS.n273 8.5005
R325 VSS.n326 VSS.n274 8.5005
R326 VSS.n326 VSS.n275 8.5005
R327 VSS.n326 VSS.n278 8.5005
R328 VSS.n326 VSS.n279 8.5005
R329 VSS.n326 VSS.n280 8.5005
R330 VSS.n326 VSS.n281 8.5005
R331 VSS.n326 VSS.n282 8.5005
R332 VSS.n326 VSS.n283 8.5005
R333 VSS.n326 VSS.n284 8.5005
R334 VSS.n326 VSS.n285 8.5005
R335 VSS.n326 VSS.n286 8.5005
R336 VSS.n326 VSS.n287 8.5005
R337 VSS.n326 VSS.n288 8.5005
R338 VSS.n326 VSS.n289 8.5005
R339 VSS.n326 VSS.n290 8.5005
R340 VSS.n326 VSS.n291 8.5005
R341 VSS.n326 VSS.n292 8.5005
R342 VSS.n326 VSS.n293 8.5005
R343 VSS.n326 VSS.n294 8.5005
R344 VSS.n326 VSS.n295 8.5005
R345 VSS.n326 VSS.n296 8.5005
R346 VSS.n326 VSS.n297 8.5005
R347 VSS.n326 VSS.n298 8.5005
R348 VSS.n326 VSS.n299 8.5005
R349 VSS.n326 VSS.n300 8.5005
R350 VSS.n326 VSS.n301 8.5005
R351 VSS.n326 VSS.n302 8.5005
R352 VSS.n326 VSS.n303 8.5005
R353 VSS.n326 VSS.n304 8.5005
R354 VSS.n326 VSS.n305 8.5005
R355 VSS.n326 VSS.n306 8.5005
R356 VSS.n326 VSS.n307 8.5005
R357 VSS.n326 VSS.n311 8.5005
R358 VSS.n326 VSS.n312 8.5005
R359 VSS.n326 VSS.n313 8.5005
R360 VSS.n326 VSS.n314 8.5005
R361 VSS.n326 VSS.n315 8.5005
R362 VSS.n326 VSS.n316 8.5005
R363 VSS.n326 VSS.n317 8.5005
R364 VSS.n326 VSS.n318 8.5005
R365 VSS.n326 VSS.n319 8.5005
R366 VSS.n326 VSS.n320 8.5005
R367 VSS.n326 VSS.n321 8.5005
R368 VSS.n326 VSS.n322 8.5005
R369 VSS.n326 VSS.n323 8.5005
R370 VSS.n326 VSS.n324 8.5005
R371 VSS.n326 VSS.n184 8.5005
R372 VSS.n327 VSS.n326 8.5005
R373 VSS.n376 VSS.n61 8.35493
R374 VSS.n377 VSS.n60 8.35493
R375 VSS.n373 VSS.n68 8.35493
R376 VSS.n372 VSS.n69 8.35493
R377 VSS.n379 VSS.n58 8.35493
R378 VSS.n370 VSS.n71 8.35493
R379 VSS.n389 VSS.n43 8.35493
R380 VSS.n364 VSS.n357 8.35493
R381 VSS.n391 VSS.n41 8.35493
R382 VSS.n392 VSS.n40 8.35493
R383 VSS.n362 VSS.n359 8.35493
R384 VSS.n361 VSS.n360 8.35493
R385 VSS.t157 VSS.n53 7.78531
R386 VSS.n346 VSS.t159 7.78531
R387 VSS.t161 VSS.n51 7.78531
R388 VSS.n350 VSS.t99 7.78531
R389 VSS.t101 VSS.n47 7.78531
R390 VSS.n352 VSS.t103 7.78531
R391 VSS.n341 VSS.n75 7.76695
R392 VSS.n64 VSS.t6 7.7196
R393 VSS.t44 VSS.n37 7.71891
R394 VSS.t129 VSS.n251 7.59544
R395 VSS.n380 VSS.t152 7.02582
R396 VSS.n369 VSS.t154 7.02582
R397 VSS.n383 VSS.t156 7.02582
R398 VSS.n386 VSS.t104 7.02582
R399 VSS.n388 VSS.t106 7.02582
R400 VSS.n365 VSS.t108 7.02582
R401 VSS.n203 VSS.t51 6.86263
R402 VSS.n293 VSS.t53 6.83594
R403 VSS.n201 VSS.t70 6.19054
R404 VSS.n191 VSS.t73 6.19054
R405 VSS.n329 VSS.n115 6.16155
R406 VSS.n329 VSS.n116 6.16155
R407 VSS.n329 VSS.n117 6.16155
R408 VSS.n329 VSS.n118 6.16155
R409 VSS.n329 VSS.n121 6.16155
R410 VSS.n329 VSS.n122 6.16155
R411 VSS.n329 VSS.n123 6.16155
R412 VSS.n329 VSS.n124 6.16155
R413 VSS.n329 VSS.n125 6.16155
R414 VSS.n329 VSS.n128 6.16155
R415 VSS.n329 VSS.n129 6.16155
R416 VSS.n329 VSS.n130 6.16155
R417 VSS.n329 VSS.n131 6.16155
R418 VSS.n329 VSS.n132 6.16155
R419 VSS.n329 VSS.n133 6.16155
R420 VSS.n329 VSS.n134 6.16155
R421 VSS.n329 VSS.n135 6.16155
R422 VSS.n329 VSS.n136 6.16155
R423 VSS.n329 VSS.n137 6.16155
R424 VSS.n329 VSS.n138 6.16155
R425 VSS.n329 VSS.n139 6.16155
R426 VSS.n329 VSS.n140 6.16155
R427 VSS.n329 VSS.n143 6.16155
R428 VSS.n329 VSS.n144 6.16155
R429 VSS.n329 VSS.n145 6.16155
R430 VSS.n329 VSS.n146 6.16155
R431 VSS.n329 VSS.n147 6.16155
R432 VSS.n329 VSS.n148 6.16155
R433 VSS.n329 VSS.n149 6.16155
R434 VSS.n329 VSS.n150 6.16155
R435 VSS.n329 VSS.n151 6.16155
R436 VSS.n329 VSS.n152 6.16155
R437 VSS.n329 VSS.n153 6.16155
R438 VSS.n329 VSS.n154 6.16155
R439 VSS.n329 VSS.n157 6.16155
R440 VSS.n329 VSS.n158 6.16155
R441 VSS.n329 VSS.n159 6.16155
R442 VSS.n329 VSS.n160 6.16155
R443 VSS.n329 VSS.n161 6.16155
R444 VSS.n329 VSS.n162 6.16155
R445 VSS.n329 VSS.n163 6.16155
R446 VSS.n329 VSS.n164 6.16155
R447 VSS.n329 VSS.n165 6.16155
R448 VSS.n329 VSS.n168 6.16155
R449 VSS.n329 VSS.n169 6.16155
R450 VSS.n329 VSS.n170 6.16155
R451 VSS.n329 VSS.n171 6.16155
R452 VSS.n329 VSS.n172 6.16155
R453 VSS.n329 VSS.n173 6.16155
R454 VSS.n329 VSS.n174 6.16155
R455 VSS.n329 VSS.n175 6.16155
R456 VSS.n329 VSS.n176 6.16155
R457 VSS.n329 VSS.n177 6.16155
R458 VSS.n329 VSS.n178 6.16155
R459 VSS.n329 VSS.n179 6.16155
R460 VSS.n329 VSS.n180 6.16155
R461 VSS.n329 VSS.n181 6.16155
R462 VSS.n329 VSS.n182 6.16155
R463 VSS.n329 VSS.n183 6.16155
R464 VSS.n399 VSS.n396 6.16155
R465 VSS.n399 VSS.n351 6.16155
R466 VSS.n399 VSS.n48 6.16155
R467 VSS.n399 VSS.n349 6.16155
R468 VSS.n399 VSS.n50 6.16155
R469 VSS.n399 VSS.n347 6.16155
R470 VSS.n399 VSS.n52 6.16155
R471 VSS.n399 VSS.n345 6.16155
R472 VSS.n399 VSS.n65 6.16155
R473 VSS.t53 VSS.n292 6.07645
R474 VSS.n345 VSS.t158 6.00901
R475 VSS.t160 VSS.n52 6.00901
R476 VSS.n347 VSS.t162 6.00901
R477 VSS.t98 VSS.n349 6.00901
R478 VSS.n48 VSS.t100 6.00901
R479 VSS.t102 VSS.n351 6.00901
R480 VSS.t19 VSS.t160 5.88658
R481 VSS.t100 VSS.t21 5.88658
R482 VSS.n246 VSS.n114 5.71594
R483 VSS.n253 VSS.n120 5.71594
R484 VSS.n261 VSS.n127 5.71594
R485 VSS.n279 VSS.n142 5.71594
R486 VSS.n294 VSS.n156 5.71594
R487 VSS.n306 VSS.n167 5.71594
R488 VSS.n250 VSS.n119 5.71529
R489 VSS.n258 VSS.n126 5.71529
R490 VSS.n274 VSS.n141 5.71529
R491 VSS.n291 VSS.n155 5.71529
R492 VSS.n303 VSS.n166 5.71529
R493 VSS.n328 VSS.n184 5.71529
R494 VSS.n346 VSS.t19 5.6967
R495 VSS.t21 VSS.n47 5.6967
R496 VSS.n384 VSS.n27 5.65086
R497 VSS.n384 VSS.n3 2.80696
R498 VSS.n5 VSS.n26 0.066765
R499 VSS.n30 VSS.n31 0.0585658
R500 VSS.n394 VSS.n30 2.7974
R501 VSS.n8 VSS.n29 0.066765
R502 VSS.n394 VSS.n25 5.65086
R503 VSS.n252 VSS.t129 5.31696
R504 VSS.t112 VSS.n67 5.12708
R505 VSS.t118 VSS.n70 5.12708
R506 VSS.t121 VSS.n56 5.12708
R507 VSS.t124 VSS.n73 5.12708
R508 VSS.n344 VSS.t157 5.12708
R509 VSS.t103 VSS.n46 5.12708
R510 VSS.t135 VSS.n45 5.12708
R511 VSS.t139 VSS.n355 5.12708
R512 VSS.t142 VSS.n42 5.12708
R513 VSS.t148 VSS.n39 5.12708
R514 VSS.n375 VSS.t13 4.93721
R515 VSS.n395 VSS.t38 4.93721
R516 VSS.n206 VSS.n112 4.71929
R517 VSS.n210 VSS.n107 4.71929
R518 VSS.n236 VSS.n80 4.71929
R519 VSS.n215 VSS.n102 4.71929
R520 VSS.n230 VSS.n86 4.71929
R521 VSS.n224 VSS.n98 4.71929
R522 VSS.n227 VSS.n96 4.71929
R523 VSS.n325 VSS.n76 4.71929
R524 VSS.n234 VSS.n83 4.71929
R525 VSS.n228 VSS.n92 4.71929
R526 VSS.n205 VSS.n113 4.71929
R527 VSS.n216 VSS.n101 4.71929
R528 VSS.n225 VSS.n97 4.71929
R529 VSS.n226 VSS.n93 4.71929
R530 VSS.n231 VSS.n99 4.71929
R531 VSS.n212 VSS.n82 4.71929
R532 VSS.n237 VSS.n105 4.71929
R533 VSS.n209 VSS.n79 4.71929
R534 VSS.n31 VSS.t130 4.69693
R535 VSS.n246 VSS.n115 4.6799
R536 VSS.n247 VSS.n116 4.6799
R537 VSS.n248 VSS.n117 4.6799
R538 VSS.n249 VSS.n118 4.6799
R539 VSS.n253 VSS.n121 4.6799
R540 VSS.n254 VSS.n122 4.6799
R541 VSS.n255 VSS.n123 4.6799
R542 VSS.n256 VSS.n124 4.6799
R543 VSS.n257 VSS.n125 4.6799
R544 VSS.n261 VSS.n128 4.6799
R545 VSS.n262 VSS.n129 4.6799
R546 VSS.n263 VSS.n130 4.6799
R547 VSS.n264 VSS.n131 4.6799
R548 VSS.n265 VSS.n132 4.6799
R549 VSS.n266 VSS.n133 4.6799
R550 VSS.n267 VSS.n134 4.6799
R551 VSS.n268 VSS.n135 4.6799
R552 VSS.n269 VSS.n136 4.6799
R553 VSS.n270 VSS.n137 4.6799
R554 VSS.n271 VSS.n138 4.6799
R555 VSS.n272 VSS.n139 4.6799
R556 VSS.n273 VSS.n140 4.6799
R557 VSS.n279 VSS.n143 4.6799
R558 VSS.n280 VSS.n144 4.6799
R559 VSS.n281 VSS.n145 4.6799
R560 VSS.n282 VSS.n146 4.6799
R561 VSS.n283 VSS.n147 4.6799
R562 VSS.n284 VSS.n148 4.6799
R563 VSS.n285 VSS.n149 4.6799
R564 VSS.n286 VSS.n150 4.6799
R565 VSS.n287 VSS.n151 4.6799
R566 VSS.n288 VSS.n152 4.6799
R567 VSS.n289 VSS.n153 4.6799
R568 VSS.n290 VSS.n154 4.6799
R569 VSS.n294 VSS.n157 4.6799
R570 VSS.n295 VSS.n158 4.6799
R571 VSS.n296 VSS.n159 4.6799
R572 VSS.n297 VSS.n160 4.6799
R573 VSS.n298 VSS.n161 4.6799
R574 VSS.n299 VSS.n162 4.6799
R575 VSS.n300 VSS.n163 4.6799
R576 VSS.n301 VSS.n164 4.6799
R577 VSS.n302 VSS.n165 4.6799
R578 VSS.n306 VSS.n168 4.6799
R579 VSS.n307 VSS.n169 4.6799
R580 VSS.n311 VSS.n170 4.6799
R581 VSS.n312 VSS.n171 4.6799
R582 VSS.n313 VSS.n172 4.6799
R583 VSS.n314 VSS.n173 4.6799
R584 VSS.n315 VSS.n174 4.6799
R585 VSS.n316 VSS.n175 4.6799
R586 VSS.n317 VSS.n176 4.6799
R587 VSS.n318 VSS.n177 4.6799
R588 VSS.n319 VSS.n178 4.6799
R589 VSS.n320 VSS.n179 4.6799
R590 VSS.n321 VSS.n180 4.6799
R591 VSS.n322 VSS.n181 4.6799
R592 VSS.n323 VSS.n182 4.6799
R593 VSS.n324 VSS.n183 4.6799
R594 VSS.n184 VSS.n183 4.6799
R595 VSS.n324 VSS.n182 4.6799
R596 VSS.n323 VSS.n181 4.6799
R597 VSS.n322 VSS.n180 4.6799
R598 VSS.n321 VSS.n179 4.6799
R599 VSS.n320 VSS.n178 4.6799
R600 VSS.n319 VSS.n177 4.6799
R601 VSS.n318 VSS.n176 4.6799
R602 VSS.n317 VSS.n175 4.6799
R603 VSS.n316 VSS.n174 4.6799
R604 VSS.n315 VSS.n173 4.6799
R605 VSS.n314 VSS.n172 4.6799
R606 VSS.n313 VSS.n171 4.6799
R607 VSS.n312 VSS.n170 4.6799
R608 VSS.n311 VSS.n169 4.6799
R609 VSS.n307 VSS.n168 4.6799
R610 VSS.n303 VSS.n165 4.6799
R611 VSS.n302 VSS.n164 4.6799
R612 VSS.n301 VSS.n163 4.6799
R613 VSS.n300 VSS.n162 4.6799
R614 VSS.n299 VSS.n161 4.6799
R615 VSS.n298 VSS.n160 4.6799
R616 VSS.n297 VSS.n159 4.6799
R617 VSS.n296 VSS.n158 4.6799
R618 VSS.n295 VSS.n157 4.6799
R619 VSS.n291 VSS.n154 4.6799
R620 VSS.n290 VSS.n153 4.6799
R621 VSS.n289 VSS.n152 4.6799
R622 VSS.n288 VSS.n151 4.6799
R623 VSS.n287 VSS.n150 4.6799
R624 VSS.n286 VSS.n149 4.6799
R625 VSS.n285 VSS.n148 4.6799
R626 VSS.n284 VSS.n147 4.6799
R627 VSS.n283 VSS.n146 4.6799
R628 VSS.n282 VSS.n145 4.6799
R629 VSS.n281 VSS.n144 4.6799
R630 VSS.n280 VSS.n143 4.6799
R631 VSS.n274 VSS.n140 4.6799
R632 VSS.n273 VSS.n139 4.6799
R633 VSS.n272 VSS.n138 4.6799
R634 VSS.n271 VSS.n137 4.6799
R635 VSS.n270 VSS.n136 4.6799
R636 VSS.n269 VSS.n135 4.6799
R637 VSS.n268 VSS.n134 4.6799
R638 VSS.n267 VSS.n133 4.6799
R639 VSS.n266 VSS.n132 4.6799
R640 VSS.n265 VSS.n131 4.6799
R641 VSS.n264 VSS.n130 4.6799
R642 VSS.n263 VSS.n129 4.6799
R643 VSS.n262 VSS.n128 4.6799
R644 VSS.n258 VSS.n125 4.6799
R645 VSS.n257 VSS.n124 4.6799
R646 VSS.n256 VSS.n123 4.6799
R647 VSS.n255 VSS.n122 4.6799
R648 VSS.n254 VSS.n121 4.6799
R649 VSS.n250 VSS.n118 4.6799
R650 VSS.n249 VSS.n117 4.6799
R651 VSS.n248 VSS.n116 4.6799
R652 VSS.n247 VSS.n115 4.6799
R653 VSS.n341 VSS.n340 4.67815
R654 VSS.n9 VSS.n2 4.59452
R655 VSS.n374 VSS.n61 4.55746
R656 VSS.n378 VSS.n68 4.55746
R657 VSS.n372 VSS.n59 4.55746
R658 VSS.n371 VSS.n58 4.55746
R659 VSS.n380 VSS.n70 4.55746
R660 VSS.n369 VSS.n56 4.55746
R661 VSS.n368 VSS.n55 4.55746
R662 VSS.n383 VSS.n73 4.55746
R663 VSS.n386 VSS.n45 4.55746
R664 VSS.n387 VSS.n354 4.55746
R665 VSS.n388 VSS.n355 4.55746
R666 VSS.n365 VSS.n42 4.55746
R667 VSS.n390 VSS.n357 4.55746
R668 VSS.n391 VSS.n358 4.55746
R669 VSS.n363 VSS.n40 4.55746
R670 VSS.n393 VSS.n360 4.55746
R671 VSS.n24 VSS.n12 4.5005
R672 VSS.n12 VSS.n385 4.5005
R673 VSS.n11 VSS.n10 2.16985
R674 VSS.n9 VSS.n35 4.5005
R675 VSS.n384 VSS.n5 2.3909
R676 VSS.n394 VSS.n8 2.3909
R677 VSS.n327 VSS.n203 4.17772
R678 VSS.t10 VSS.n67 4.17772
R679 VSS.n382 VSS.t0 4.17772
R680 VSS.t0 VSS.n55 4.17772
R681 VSS.t2 VSS.n354 4.17772
R682 VSS.n367 VSS.t2 4.17772
R683 VSS.t40 VSS.n39 4.17772
R684 VSS.t115 VSS.t4 3.98784
R685 VSS.t145 VSS.t37 3.98784
R686 VSS.n329 VSS.n114 3.76308
R687 VSS.n329 VSS.n120 3.76308
R688 VSS.n329 VSS.n127 3.76308
R689 VSS.n329 VSS.n142 3.76308
R690 VSS.n329 VSS.n156 3.76308
R691 VSS.n329 VSS.n167 3.76308
R692 VSS.n329 VSS.n119 3.7629
R693 VSS.n329 VSS.n126 3.7629
R694 VSS.n329 VSS.n141 3.7629
R695 VSS.n329 VSS.n155 3.7629
R696 VSS.n329 VSS.n166 3.7629
R697 VSS.n329 VSS.n328 3.7629
R698 VSS.n24 VSS.t138 3.45423
R699 VSS.n7 VSS.t141 3.45423
R700 VSS.n29 VSS.t144 3.45423
R701 VSS.n28 VSS.t147 3.45423
R702 VSS.n6 VSS.t113 3.45423
R703 VSS.n26 VSS.t116 3.45423
R704 VSS.n3 VSS.t119 3.45423
R705 VSS.n35 VSS.t122 3.45423
R706 VSS.n25 VSS.t136 3.45313
R707 VSS.n31 VSS.t150 3.45313
R708 VSS.n2 VSS.t111 3.45313
R709 VSS.n27 VSS.t125 3.45313
R710 VSS.n187 VSS.n96 3.43157
R711 VSS.t13 VSS.n66 3.41822
R712 VSS.n381 VSS.t15 3.41822
R713 VSS.t16 VSS.n54 3.41822
R714 VSS.n353 VSS.t33 3.41822
R715 VSS.n366 VSS.t34 3.41822
R716 VSS.t38 VSS.n38 3.41822
R717 VSS.n18 VSS.n17 0.0783198
R718 VSS.n399 VSS.n22 1.11025
R719 VSS.n399 VSS.n15 1.02806
R720 VSS.n399 VSS.n1 0.627529
R721 VSS.n1 VSS.n0 0.10267
R722 VSS.n20 VSS.n19 0.0776913
R723 VSS.n376 VSS.t110 3.22835
R724 VSS.n374 VSS.t112 3.22835
R725 VSS.n373 VSS.t114 3.22835
R726 VSS.n378 VSS.t115 3.22835
R727 VSS.n379 VSS.t117 3.22835
R728 VSS.n370 VSS.t120 3.22835
R729 VSS.n382 VSS.t123 3.22835
R730 VSS.n367 VSS.t137 3.22835
R731 VSS.n389 VSS.t140 3.22835
R732 VSS.n364 VSS.t143 3.22835
R733 VSS.n363 VSS.t145 3.22835
R734 VSS.n392 VSS.t146 3.22835
R735 VSS.n393 VSS.t148 3.22835
R736 VSS.n361 VSS.t149 3.22835
R737 VSS.n199 VSS.t58 3.22826
R738 VSS.n197 VSS.t127 3.22826
R739 VSS.n195 VSS.t126 3.22826
R740 VSS.n402 VSS.n2 2.98702
R741 VSS.n243 VSS.n114 2.85835
R742 VSS.n252 VSS.n120 2.85835
R743 VSS.n260 VSS.n127 2.85835
R744 VSS.n278 VSS.n142 2.85835
R745 VSS.n293 VSS.n156 2.85835
R746 VSS.n305 VSS.n167 2.85835
R747 VSS.n328 VSS.n327 2.85814
R748 VSS.n304 VSS.n166 2.85814
R749 VSS.n292 VSS.n155 2.85814
R750 VSS.n275 VSS.n141 2.85814
R751 VSS.n259 VSS.n126 2.85814
R752 VSS.n251 VSS.n119 2.85814
R753 VSS.n399 VSS.n18 1.50398
R754 VSS.n15 VSS.n14 0.0606977
R755 VSS.n399 VSS.n20 1.50426
R756 VSS.t153 VSS.t121 2.65873
R757 VSS.t155 VSS.t124 2.65873
R758 VSS.t105 VSS.t135 2.65873
R759 VSS.t107 VSS.t139 2.65873
R760 VSS.n399 VSS.n37 2.57114
R761 VSS.n399 VSS.n397 2.57114
R762 VSS.n399 VSS.n49 2.57114
R763 VSS.n399 VSS.n348 2.57114
R764 VSS.n399 VSS.n62 2.57114
R765 VSS.n399 VSS.n64 2.57114
R766 VSS.n19 VSS.t7 2.40272
R767 VSS.n17 VSS.t45 2.40105
R768 VSS.n19 VSS.t9 2.3605
R769 VSS.n0 VSS.t5 2.3605
R770 VSS.n13 VSS.t25 2.3605
R771 VSS.n16 VSS.t36 2.3605
R772 VSS.n17 VSS.t42 2.3605
R773 VSS.n21 VSS.t32 2.36036
R774 VSS.n14 VSS.t28 2.36013
R775 VSS.n14 VSS.t22 2.36013
R776 VSS.n22 VSS.t3 2.35975
R777 VSS.n0 VSS.t11 2.3595
R778 VSS.n16 VSS.t39 2.3591
R779 VSS.n23 VSS.t17 2.35901
R780 VSS.n0 VSS.t1 2.35889
R781 VSS.n13 VSS.t20 2.3588
R782 VSS.n330 VSS.t93 2.21148
R783 VSS.n338 VSS.t85 2.21131
R784 VSS.n218 VSS.t60 2.21089
R785 VSS.n334 VSS.t89 2.21083
R786 VSS.n332 VSS.t91 2.21074
R787 VSS.n309 VSS.t62 2.21067
R788 VSS.n336 VSS.t87 2.21062
R789 VSS.n75 VSS.t59 2.21047
R790 VSS.n340 VSS.t84 2.21041
R791 VSS.n276 VSS.t66 2.21022
R792 VSS.n308 VSS.t64 2.21005
R793 VSS.n244 VSS.t68 2.20993
R794 VSS.n75 VSS.t47 2.20311
R795 VSS.n332 VSS.t81 2.20274
R796 VSS.n330 VSS.t83 2.20262
R797 VSS.n308 VSS.t52 2.20239
R798 VSS.n276 VSS.t54 2.20205
R799 VSS.n334 VSS.t79 2.20196
R800 VSS.n340 VSS.t74 2.20191
R801 VSS.n244 VSS.t56 2.20186
R802 VSS.n218 VSS.t48 2.20176
R803 VSS.n309 VSS.t50 2.20174
R804 VSS.n336 VSS.t77 2.20166
R805 VSS.n338 VSS.t75 2.20159
R806 VSS.n326 VSS.n204 1.89185
R807 VSS.n326 VSS.n206 1.89185
R808 VSS.n326 VSS.n242 1.89185
R809 VSS.n326 VSS.n241 1.89185
R810 VSS.n326 VSS.n207 1.89185
R811 VSS.n326 VSS.n240 1.89185
R812 VSS.n326 VSS.n239 1.89185
R813 VSS.n326 VSS.n209 1.89185
R814 VSS.n326 VSS.n210 1.89185
R815 VSS.n326 VSS.n238 1.89185
R816 VSS.n326 VSS.n236 1.89185
R817 VSS.n326 VSS.n211 1.89185
R818 VSS.n326 VSS.n235 1.89185
R819 VSS.n326 VSS.n213 1.89185
R820 VSS.n326 VSS.n214 1.89185
R821 VSS.n326 VSS.n215 1.89185
R822 VSS.n326 VSS.n233 1.89185
R823 VSS.n326 VSS.n232 1.89185
R824 VSS.n326 VSS.n217 1.89185
R825 VSS.n326 VSS.n230 1.89185
R826 VSS.n326 VSS.n220 1.89185
R827 VSS.n326 VSS.n221 1.89185
R828 VSS.n326 VSS.n222 1.89185
R829 VSS.n326 VSS.n223 1.89185
R830 VSS.n326 VSS.n224 1.89185
R831 VSS.n326 VSS.n229 1.89185
R832 VSS.n326 VSS.n226 1.89185
R833 VSS.n326 VSS.n227 1.89185
R834 VSS.n329 VSS.n113 1.89185
R835 VSS.n329 VSS.n111 1.89185
R836 VSS.n329 VSS.n110 1.89185
R837 VSS.n329 VSS.n109 1.89185
R838 VSS.n329 VSS.n108 1.89185
R839 VSS.n329 VSS.n106 1.89185
R840 VSS.n329 VSS.n105 1.89185
R841 VSS.n329 VSS.n104 1.89185
R842 VSS.n329 VSS.n103 1.89185
R843 VSS.n329 VSS.n101 1.89185
R844 VSS.n329 VSS.n100 1.89185
R845 VSS.n329 VSS.n99 1.89185
R846 VSS.n329 VSS.n97 1.89185
R847 VSS.n329 VSS.n76 1.89185
R848 VSS.n329 VSS.n77 1.89185
R849 VSS.n329 VSS.n78 1.89185
R850 VSS.n329 VSS.n81 1.89185
R851 VSS.n329 VSS.n82 1.89185
R852 VSS.n329 VSS.n83 1.89185
R853 VSS.n329 VSS.n84 1.89185
R854 VSS.n329 VSS.n85 1.89185
R855 VSS.n329 VSS.n87 1.89185
R856 VSS.n329 VSS.n88 1.89185
R857 VSS.n329 VSS.n89 1.89185
R858 VSS.n329 VSS.n90 1.89185
R859 VSS.n329 VSS.n91 1.89185
R860 VSS.n329 VSS.n92 1.89185
R861 VSS.n329 VSS.n94 1.89185
R862 VSS.n36 VSS.n4 0.766777
R863 VSS.n4 VSS.n32 0.288546
R864 VSS VSS.n33 0.189868
R865 VSS VSS.n34 0.776964
R866 VSS.t128 VSS.n275 1.51949
R867 VSS.t110 VSS.n66 1.32961
R868 VSS.t114 VSS.n60 1.32961
R869 VSS.t117 VSS.n69 1.32961
R870 VSS.t151 VSS.t14 1.32961
R871 VSS.t14 VSS.t118 1.32961
R872 VSS.t152 VSS.n57 1.32961
R873 VSS.t120 VSS.n57 1.32961
R874 VSS.t154 VSS.n72 1.32961
R875 VSS.t123 VSS.n72 1.32961
R876 VSS.t156 VSS.n54 1.32961
R877 VSS.t104 VSS.n353 1.32961
R878 VSS.t137 VSS.n44 1.32961
R879 VSS.t106 VSS.n44 1.32961
R880 VSS.t140 VSS.n356 1.32961
R881 VSS.t108 VSS.n356 1.32961
R882 VSS.t35 VSS.t142 1.32961
R883 VSS.t109 VSS.t35 1.32961
R884 VSS.t143 VSS.n41 1.32961
R885 VSS.t146 VSS.n359 1.32961
R886 VSS.t149 VSS.n38 1.32961
R887 VSS.n228 VSS.t46 1.24816
R888 VSS.n305 VSS.t94 1.13974
R889 VSS.t4 VSS.n59 1.13974
R890 VSS.t15 VSS.n71 1.13974
R891 VSS.t34 VSS.n43 1.13974
R892 VSS.t37 VSS.n358 1.13974
R893 vco_var_VSS VSS.n402 0.903417
R894 VSS.n329 VSS.n95 0.775974
R895 VSS.n326 VSS.n95 0.775429
R896 VSS.n260 VSS.t55 0.759994
R897 VSS.n371 VSS.t151 0.57012
R898 VSS.n381 VSS.t153 0.57012
R899 VSS.n368 VSS.t155 0.57012
R900 VSS.t158 VSS.t18 0.57012
R901 VSS.t31 VSS.t102 0.57012
R902 VSS.n387 VSS.t105 0.57012
R903 VSS.n366 VSS.t107 0.57012
R904 VSS.n390 VSS.t109 0.57012
R905 VSS.n401 VSS.n400 0.551994
R906 VSS.n200 VSS.n199 0.513002
R907 VSS.n189 VSS.n74 0.479883
R908 VSS.n193 VSS.n192 0.479883
R909 VSS.n201 VSS.n200 0.411981
R910 VSS.n194 VSS.n191 0.411981
R911 VSS.n377 VSS.t10 0.380247
R912 VSS.t23 VSS.n51 0.380247
R913 VSS.n350 VSS.t30 0.380247
R914 VSS.n362 VSS.t40 0.380247
R915 VSS.n196 VSS.n194 0.370375
R916 VSS.n194 VSS.n193 0.370375
R917 VSS.n193 VSS.n74 0.370375
R918 VSS.n385 VSS.n11 0.50003
R919 VSS.n200 VSS.n198 0.3195
R920 VSS.n198 VSS.n196 0.3195
R921 VSS.t132 VSS.n401 0.264692
R922 VSS.n34 VSS.n33 0.75765
R923 VSS.n33 VSS.n32 0.959389
R924 VSS.t130 VSS.t132 0.252013
R925 VSS.n342 VSS.n74 0.248
R926 VSS.n338 VSS.n337 0.243424
R927 VSS.n218 VSS.n208 0.243424
R928 VSS.n11 VSS.n27 0.404622
R929 VSS.n385 VSS.n25 0.241827
R930 VSS.n340 VSS.n339 0.241769
R931 VSS.n219 VSS.n75 0.241769
R932 VSS.n334 VSS.n333 0.237318
R933 VSS.n308 VSS.n277 0.237318
R934 VSS.n310 VSS.n309 0.234764
R935 VSS.n336 VSS.n335 0.234752
R936 VSS.n332 VSS.n331 0.234686
R937 VSS.n276 VSS.n245 0.234686
R938 VSS.n333 VSS.n332 0.231239
R939 VSS.n277 VSS.n276 0.231239
R940 VSS.n335 VSS.n334 0.229708
R941 VSS.n310 VSS.n308 0.229696
R942 VSS.n331 VSS.n330 0.228745
R943 VSS.n245 VSS.n244 0.228745
R944 VSS.n337 VSS.n336 0.227001
R945 VSS.n309 VSS.n208 0.227001
R946 VSS.n339 VSS.n338 0.223699
R947 VSS.n219 VSS.n218 0.223699
R948 VSS.n326 VSS.n208 0.218846
R949 VSS.n337 VSS.n329 0.218846
R950 VSS.n326 VSS.n277 0.21564
R951 VSS.n333 VSS.n329 0.21564
R952 VSS.n326 VSS.n219 0.208386
R953 VSS.n339 VSS.n329 0.208386
R954 VSS.n326 VSS.n245 0.20534
R955 VSS.n331 VSS.n329 0.20534
R956 VSS.n335 VSS.n329 0.203693
R957 VSS.n326 VSS.n310 0.203693
R958 VSS.n401 VSS.n4 0.197134
R959 VSS.n343 VSS.n36 0.299243
R960 VSS.n198 VSS.n197 0.143127
R961 VSS.n196 VSS.n195 0.143127
R962 VSS.n343 VSS.n32 0.402928
R963 VSS.n400 VSS.n36 0.211243
R964 VSS VSS.n4 0.210343
R965 VSS.n12 VSS.t130 0.202252
R966 VSS.n6 VSS.n2 0.201739
R967 VSS.n20 VSS.n0 0.162986
R968 VSS.n23 VSS.n1 0.0684967
R969 VSS.n14 VSS.n13 0.145251
R970 VSS.n35 VSS.n3 0.136372
R971 VSS.n23 VSS.n13 0.134323
R972 VSS.n22 VSS.n16 0.133313
R973 VSS.n18 VSS.n16 0.117589
R974 VSS.n30 VSS.n28 0.0585658
R975 VSS.n29 VSS.n28 0.116817
R976 VSS.n8 VSS.n7 0.0501977
R977 VSS.n3 VSS.n26 0.116817
R978 VSS.n6 VSS.n5 0.0501977
R979 VSS.n25 VSS.n24 0.116817
R980 VSS.n35 VSS.n27 0.097735
R981 VSS.n22 VSS.n21 0.0937082
R982 VSS.n21 VSS.n15 0.124327
R983 VSS.n24 VSS.n7 0.117555
R984 VSS.n12 VSS.n10 0.113321
R985 VSS.n10 VSS.n9 0.113321
R986 a_11798_1180.n0 a_11798_1180.n4 9.42143
R987 a_11798_1180.n1 a_11798_1180.n12 9.42143
R988 a_11798_1180.n1 a_11798_1180.n5 9.42143
R989 a_11798_1180.n1 a_11798_1180.n6 9.42143
R990 a_11798_1180.n2 a_11798_1180.n9 9.42143
R991 a_11798_1180.n2 a_11798_1180.n7 9.42143
R992 a_11798_1180.n4 a_11798_1180.t22 3.60374
R993 a_11798_1180.n5 a_11798_1180.t28 3.60255
R994 a_11798_1180.n6 a_11798_1180.t15 3.60255
R995 a_11798_1180.n7 a_11798_1180.t21 3.60255
R996 a_11798_1180.n4 a_11798_1180.t23 3.45423
R997 a_11798_1180.n13 a_11798_1180.t24 3.45423
R998 a_11798_1180.n11 a_11798_1180.t26 3.45423
R999 a_11798_1180.n5 a_11798_1180.t27 3.45423
R1000 a_11798_1180.n12 a_11798_1180.t25 3.45423
R1001 a_11798_1180.n6 a_11798_1180.t16 3.45423
R1002 a_11798_1180.n10 a_11798_1180.t17 3.45423
R1003 a_11798_1180.n8 a_11798_1180.t19 3.45423
R1004 a_11798_1180.n7 a_11798_1180.t20 3.45423
R1005 a_11798_1180.n9 a_11798_1180.t18 3.45423
R1006 a_11798_1180.t14 a_11798_1180.n3 2.61386
R1007 a_11798_1180.n0 a_11798_1180.t0 2.61061
R1008 a_11798_1180.n1 a_11798_1180.t5 2.56233
R1009 a_11798_1180.n0 a_11798_1180.t2 2.56233
R1010 a_11798_1180.n2 a_11798_1180.t11 2.5622
R1011 a_11798_1180.n1 a_11798_1180.t8 2.56214
R1012 a_11798_1180.n2 a_11798_1180.t10 2.56174
R1013 a_11798_1180.n1 a_11798_1180.t9 2.56174
R1014 a_11798_1180.n1 a_11798_1180.t6 2.56174
R1015 a_11798_1180.n1 a_11798_1180.t7 2.56173
R1016 a_11798_1180.n1 a_11798_1180.t4 2.56173
R1017 a_11798_1180.n0 a_11798_1180.t1 2.56173
R1018 a_11798_1180.n3 a_11798_1180.t12 2.5616
R1019 a_11798_1180.n0 a_11798_1180.t3 2.5616
R1020 a_11798_1180.n3 a_11798_1180.t13 2.56146
R1021 a_11798_1180.n2 a_11798_1180.n1 0.245563
R1022 a_11798_1180.n8 a_11798_1180.n7 0.225083
R1023 a_11798_1180.n6 a_11798_1180.n10 0.225083
R1024 a_11798_1180.n11 a_11798_1180.n5 0.225083
R1025 a_11798_1180.n4 a_11798_1180.n13 0.225083
R1026 a_11798_1180.n1 a_11798_1180.n0 0.196551
R1027 a_11798_1180.n13 a_11798_1180.n12 0.1875
R1028 a_11798_1180.n12 a_11798_1180.n11 0.1875
R1029 a_11798_1180.n10 a_11798_1180.n9 0.1875
R1030 a_11798_1180.n9 a_11798_1180.n8 0.1875
R1031 a_11798_1180.n3 a_11798_1180.n2 0.147538
R1032 a_5428_2384.n0 a_5428_2384.t2 36.3628
R1033 a_5428_2384.n0 a_5428_2384.t0 35.246
R1034 a_5428_2384.t1 a_5428_2384.n0 15.3137
R1035 a_1474_1090.n0 a_1474_1090.t1 60.5214
R1036 a_1474_1090.n0 a_1474_1090.t0 33.8343
R1037 a_1474_1090.n1 a_1474_1090.n0 12.0028
R1038 a_1474_1090.t2 a_1474_1090.n1 2.87353
R1039 a_1474_1090.t2 a_1474_1090.n1 2.86853
R1040 a_1954_2820.n0 a_1954_2820.t2 44.3673
R1041 a_1954_2820.n0 a_1954_2820.t1 27.0418
R1042 a_1954_2820.t0 a_1954_2820.n0 12.2034
R1043 a_1254_2820.n0 a_1254_2820.t2 36.0512
R1044 a_1254_2820.n0 a_1254_2820.t3 33.7412
R1045 a_1254_2820.n3 a_1254_2820.t0 26.8072
R1046 a_1254_2820.n1 a_1254_2820.t5 26.0905
R1047 a_1254_2820.n1 a_1254_2820.t4 24.7412
R1048 a_1254_2820.t1 a_1254_2820.n3 12.4381
R1049 a_1254_2820.n3 a_1254_2820.n2 9.512
R1050 a_1254_2820.n2 a_1254_2820.n1 9.0005
R1051 a_1254_2820.n2 a_1254_2820.n0 0.7705
R1052 a_2654_4840.n1 a_2654_4840.t4 36.3944
R1053 a_2654_4840.n0 a_2654_4840.t2 34.4012
R1054 a_2654_4840.n0 a_2654_4840.t0 22.0391
R1055 a_2654_4840.n2 a_2654_4840.n1 9.0005
R1056 a_2654_4840.n2 a_2654_4840.t1 5.84394
R1057 a_2654_4840.t3 a_2654_4840.n2 4.67685
R1058 a_2654_4840.n1 a_2654_4840.n0 0.3173
R1059 vco_bias_0.vbn_buf.n3 vco_bias_0.vbn_buf.t1 55.3125
R1060 vco_bias_0.vbn_buf.n1 vco_bias_0.vbn_buf.t4 34.2391
R1061 vco_bias_0.vbn_buf.n1 vco_bias_0.vbn_buf.t3 28.5544
R1062 vco_bias_0.vbn_buf.n2 vco_bias_0.vbn_buf.n1 23.0981
R1063 vco_bias_0.vbn_buf.n0 vco_bias_0.vbn_buf.t2 21.7736
R1064 vco_bias_0.vbn_buf.n2 vco_bias_0.vbn_buf.t0 21.4968
R1065 vco_bias_0.vbn_buf vco_bias_0.vbn_buf.n0 20.8275
R1066 vco_bias_0.vbn_buf.n3 vco_bias_0.vbn_buf.n2 3.1069
R1067 vco_bias_0.vbn_buf vco_bias_0.vbn_buf.n3 1.2149
R1068 vco_bias_0.vbn_buf.n0 vco_bias_0.vbn_buf 0.1105
C70 vco_ind_LC VSS 2.3265e-14
C71 vtune VSS 3.28381e-15
C72 ibias_100u VSS 2.01863e-15
C73 rf_out_p VSS 1.97643e-15
C74 rf_out_n VSS 1.95341e-15
C75 di_en VSS 7.86304e-16
C76 vco_var_rf_p VSS 1.11976e-14
C77 vco_ind_LA VSS 4.23649e-16
C78 vco_var_rf_n VSS 1.21981e-14
C79 vco_ind_LB VSS 4.22212e-16
C80 VDD VSS 3.20936e-14
C81 a_14668_2644# VSS 5.83117e-15 ; **FLOATING
C82 a_9450_4394# VSS 5.80082e-15 ; **FLOATING
C83 vco_bias_0.vbg_buf VSS 1.1165e-13 ; **FLOATING
C84 vco_bias_0.vbn_buf VSS 1.10796e-13 ; **FLOATING
C85 vco_bias_0.vbn_buf.t2 VSS 1.23163e-15 ; **FLOATING
C86 vco_bias_0.vbn_buf.n0 VSS 8.36738e-17 ; **FLOATING
C87 vco_bias_0.vbn_buf.t4 VSS 5.4946e-15 ; **FLOATING
C88 vco_bias_0.vbn_buf.t3 VSS 5.48703e-15 ; **FLOATING
C89 vco_bias_0.vbn_buf.n1 VSS 1.72986e-16 ; **FLOATING
C90 vco_bias_0.vbn_buf.t0 VSS 1.93454e-17 ; **FLOATING
C91 vco_bias_0.vbn_buf.n2 VSS 1.60675e-16 ; **FLOATING
C92 vco_bias_0.vbn_buf.t1 VSS 1.79448e-15 ; **FLOATING
C93 vco_bias_0.vbn_buf.n3 VSS 8.94182e-17 ; **FLOATING
C94 a_2654_4840.t1 VSS 1.31803e-16 ; **FLOATING
C95 a_2654_4840.t4 VSS 3.38124e-16 ; **FLOATING
C96 a_2654_4840.t0 VSS 1.22266e-16 ; **FLOATING
C97 a_2654_4840.t2 VSS 3.22524e-16 ; **FLOATING
C98 a_2654_4840.n0 VSS 4.28718e-16 ; **FLOATING
C99 a_2654_4840.n1 VSS 4.52309e-16 ; **FLOATING
C100 a_2654_4840.n2 VSS 3.52822e-16 ; **FLOATING
C101 a_2654_4840.t3 VSS 2.65094e-16 ; **FLOATING
C102 a_1254_2820.t0 VSS 2.81576e-17 ; **FLOATING
C103 a_1254_2820.t2 VSS 1.37121e-16 ; **FLOATING
C104 a_1254_2820.t3 VSS 1.1242e-16 ; **FLOATING
C105 a_1254_2820.n0 VSS 8.19543e-16 ; **FLOATING
C106 a_1254_2820.t5 VSS 8.60592e-17 ; **FLOATING
C107 a_1254_2820.t4 VSS 6.61387e-17 ; **FLOATING
C108 a_1254_2820.n1 VSS 4.40624e-16 ; **FLOATING
C109 a_1254_2820.n2 VSS 2.17391e-16 ; **FLOATING
C110 a_1254_2820.n3 VSS 4.01172e-16 ; **FLOATING
C111 a_1254_2820.t1 VSS 8.40944e-17 ; **FLOATING
C112 a_1954_2820.t1 VSS 2.30288e-17 ; **FLOATING
C113 a_1954_2820.t2 VSS 1.81055e-16 ; **FLOATING
C114 a_1954_2820.n0 VSS 5.34895e-16 ; **FLOATING
C115 a_1954_2820.t0 VSS 6.20921e-17 ; **FLOATING
C116 a_1474_1090.t0 VSS 4.85804e-16 ; **FLOATING
C117 a_1474_1090.t1 VSS 1.76344e-15 ; **FLOATING
C118 a_1474_1090.n0 VSS 1.69222e-15 ; **FLOATING
C119 a_1474_1090.n1 VSS 3.23583e-16 ; **FLOATING
C120 a_1474_1090.t2 VSS 2.18117e-16 ; **FLOATING
C121 a_5428_2384.t2 VSS 6.43399e-16 ; **FLOATING
C122 a_5428_2384.t0 VSS 3.19636e-16 ; **FLOATING
C123 a_5428_2384.n0 VSS 1.12422e-15 ; **FLOATING
C124 a_5428_2384.t1 VSS 3.66936e-16 ; **FLOATING
C125 a_11798_1180.n0 VSS 1.47246e-15 ; **FLOATING
C126 a_11798_1180.n1 VSS 2.53607e-15 ; **FLOATING
C127 a_11798_1180.n2 VSS 1.03463e-15 ; **FLOATING
C128 a_11798_1180.n3 VSS 9.75008e-16 ; **FLOATING
C129 a_11798_1180.n4 VSS 1.02188e-16 ; **FLOATING
C130 a_11798_1180.n5 VSS 1.02188e-16 ; **FLOATING
C131 a_11798_1180.n6 VSS 1.02188e-16 ; **FLOATING
C132 a_11798_1180.n7 VSS 1.02188e-16 ; **FLOATING
C133 a_11798_1180.t21 VSS 4.79904e-17 ; **FLOATING
C134 a_11798_1180.t18 VSS 5.13576e-17 ; **FLOATING
C135 a_11798_1180.t19 VSS 5.13576e-17 ; **FLOATING
C136 a_11798_1180.t20 VSS 5.13576e-17 ; **FLOATING
C137 a_11798_1180.n8 VSS 5.73682e-17 ; **FLOATING
C138 a_11798_1180.n9 VSS 6.00352e-17 ; **FLOATING
C139 a_11798_1180.t16 VSS 5.13576e-17 ; **FLOATING
C140 a_11798_1180.t17 VSS 5.13576e-17 ; **FLOATING
C141 a_11798_1180.n10 VSS 5.73682e-17 ; **FLOATING
C142 a_11798_1180.t15 VSS 4.79904e-17 ; **FLOATING
C143 a_11798_1180.t28 VSS 4.79904e-17 ; **FLOATING
C144 a_11798_1180.t25 VSS 5.13576e-17 ; **FLOATING
C145 a_11798_1180.t26 VSS 5.13576e-17 ; **FLOATING
C146 a_11798_1180.t27 VSS 5.13576e-17 ; **FLOATING
C147 a_11798_1180.n11 VSS 5.73682e-17 ; **FLOATING
C148 a_11798_1180.n12 VSS 6.00352e-17 ; **FLOATING
C149 a_11798_1180.t23 VSS 5.13576e-17 ; **FLOATING
C150 a_11798_1180.t24 VSS 5.13576e-17 ; **FLOATING
C151 a_11798_1180.n13 VSS 5.73682e-17 ; **FLOATING
C152 a_11798_1180.t22 VSS 4.79904e-17 ; **FLOATING
C153 a_11798_1180.t0 VSS 1.54757e-16 ; **FLOATING
C154 a_11798_1180.t1 VSS 1.50572e-16 ; **FLOATING
C155 a_11798_1180.t2 VSS 1.50564e-16 ; **FLOATING
C156 a_11798_1180.t3 VSS 1.50572e-16 ; **FLOATING
C157 a_11798_1180.t4 VSS 1.50572e-16 ; **FLOATING
C158 a_11798_1180.t5 VSS 1.50564e-16 ; **FLOATING
C159 a_11798_1180.t6 VSS 1.50572e-16 ; **FLOATING
C160 a_11798_1180.t7 VSS 1.50572e-16 ; **FLOATING
C161 a_11798_1180.t8 VSS 1.50564e-16 ; **FLOATING
C162 a_11798_1180.t9 VSS 1.50572e-16 ; **FLOATING
C163 a_11798_1180.t10 VSS 1.50572e-16 ; **FLOATING
C164 a_11798_1180.t11 VSS 1.50564e-16 ; **FLOATING
C165 a_11798_1180.t12 VSS 1.50572e-16 ; **FLOATING
C166 a_11798_1180.t13 VSS 1.50564e-16 ; **FLOATING
C167 a_11798_1180.t14 VSS 1.54734e-16 ; **FLOATING
C168 VDD.t5 VSS 1.57421e-16 ; **FLOATING
C169 VDD.t6 VSS 2.56998e-17 ; **FLOATING
C170 VDD.n0 VSS 8.81088e-17 ; **FLOATING
C171 VDD.t10 VSS 1.57421e-16 ; **FLOATING
C172 VDD.t11 VSS 2.56998e-17 ; **FLOATING
C173 VDD.n1 VSS 3.24691e-17 ; **FLOATING
C174 VDD.n2 VSS 9.80332e-17 ; **FLOATING
C175 VDD.t2 VSS 5.52809e-17 ; **FLOATING
C176 VDD.n3 VSS 4.05988e-17 ; **FLOATING
C177 VDD.n4 VSS 7.41113e-17 ; **FLOATING
C178 VDD.t0 VSS 5.52809e-17 ; **FLOATING
C179 VDD.n5 VSS 4.05988e-17 ; **FLOATING
C180 VDD.n6 VSS 5.71422e-17 ; **FLOATING
C181 VDD.t8 VSS 5.52809e-17 ; **FLOATING
C182 VDD.n7 VSS 4.05988e-17 ; **FLOATING
C183 VDD.n8 VSS 1.2471e-16 ; **FLOATING
C184 VDD.t4 VSS 9.91116e-16 ; **FLOATING
C185 VDD.t7 VSS 7.15521e-16 ; **FLOATING
C186 VDD.n9 VSS 7.36246e-16 ; **FLOATING
C187 vco_var_rf_n.n0 VSS 9.76778e-17 ; **FLOATING
C188 vco_var_rf_n.n1 VSS 2.03669e-17 ; **FLOATING
C189 vco_var_rf_n.n2 VSS 2.97088e-16 ; **FLOATING
C190 vco_var_rf_n.n3 VSS 4.65269e-16 ; **FLOATING
C191 vco_var_rf_n.t7 VSS 2.87167e-16 ; **FLOATING
C192 vco_var_rf_n.n4 VSS 3.61479e-16 ; **FLOATING
C193 vco_var_rf_n.t5 VSS 1.14133e-17 ; **FLOATING
C194 vco_var_rf_n.t4 VSS 1.14133e-17 ; **FLOATING
C195 vco_var_rf_n.t2 VSS 1.15019e-17 ; **FLOATING
C196 vco_var_rf_n.t3 VSS 1.17677e-17 ; **FLOATING
C197 vco_var_rf_n.t6 VSS 1.14133e-17 ; **FLOATING
C198 vco_var_rf_n.t0 VSS 1.76084e-15 ; **FLOATING
C199 vco_var_rf_n.n5 VSS 1.19143e-15 ; **FLOATING
C200 vco_var_rf_p.n0 VSS 9.76443e-17 ; **FLOATING
C201 vco_var_rf_p.n1 VSS 2.03591e-17 ; **FLOATING
C202 vco_var_rf_p.n2 VSS 3.04678e-16 ; **FLOATING
C203 vco_var_rf_p.n3 VSS 4.64971e-16 ; **FLOATING
C204 vco_var_rf_p.n4 VSS 3.92361e-16 ; **FLOATING
C205 vco_var_rf_p.t7 VSS 1.97484e-16 ; **FLOATING
C206 vco_var_rf_p.t2 VSS 1.17579e-17 ; **FLOATING
C207 vco_var_rf_p.t3 VSS 1.14064e-17 ; **FLOATING
C208 vco_var_rf_p.t4 VSS 1.14993e-17 ; **FLOATING
C209 vco_var_rf_p.t1 VSS 1.14064e-17 ; **FLOATING
C210 vco_var_rf_p.t0 VSS 1.14064e-17 ; **FLOATING
C211 vco_var_rf_p.t5 VSS 1.75242e-15 ; **FLOATING
C212 vco_var_rf_p.n5 VSS 1.25475e-15 ; **FLOATING
C213 di_en.t1 VSS 4.84312e-17 ; **FLOATING
C214 di_en.t0 VSS 3.53953e-17 ; **FLOATING
C215 di_en.n0 VSS 2.48459e-16 ; **FLOATING
C216 rf_out_n.n0 VSS 3.01083e-16 ; **FLOATING
C217 rf_out_n.n1 VSS 3.72919e-16 ; **FLOATING
C218 rf_out_n.t0 VSS 7.97409e-16 ; **FLOATING
C219 rf_out_n.t3 VSS 4.83885e-17 ; **FLOATING
C220 rf_out_n.t6 VSS 4.76711e-17 ; **FLOATING
C221 rf_out_n.t5 VSS 4.76711e-17 ; **FLOATING
C222 rf_out_n.t4 VSS 4.76711e-17 ; **FLOATING
C223 rf_out_n.t2 VSS 4.76711e-17 ; **FLOATING
C224 rf_out_n.t1 VSS 4.76711e-17 ; **FLOATING
C225 rf_out_n.n2 VSS 3.3403e-16 ; **FLOATING
C226 rf_out_p.n0 VSS 4.14864e-16 ; **FLOATING
C227 rf_out_p.n1 VSS 2.585e-16 ; **FLOATING
C228 rf_out_p.t0 VSS 8.00861e-16 ; **FLOATING
C229 rf_out_p.t5 VSS 4.83418e-17 ; **FLOATING
C230 rf_out_p.t1 VSS 4.76237e-17 ; **FLOATING
C231 rf_out_p.t2 VSS 4.76237e-17 ; **FLOATING
C232 rf_out_p.t4 VSS 4.76237e-17 ; **FLOATING
C233 rf_out_p.t6 VSS 4.76237e-17 ; **FLOATING
C234 rf_out_p.t3 VSS 4.76237e-17 ; **FLOATING
C235 rf_out_p.n2 VSS 3.33715e-16 ; **FLOATING
C236 ibias_100u.t4 VSS 1.50906e-16 ; **FLOATING
C237 ibias_100u.t2 VSS 1.59146e-16 ; **FLOATING
C238 ibias_100u.n0 VSS 1.94229e-16 ; **FLOATING
C239 ibias_100u.t1 VSS 1.49487e-16 ; **FLOATING
C240 ibias_100u.n1 VSS 1.23708e-16 ; **FLOATING
C241 ibias_100u.t0 VSS 7.38703e-17 ; **FLOATING
C242 ibias_100u.n2 VSS 1.81855e-16 ; **FLOATING
C243 ibias_100u.t3 VSS 1.4392e-15 ; **FLOATING
C244 ibias_100u.n3 VSS 3.49849e-16 ; **FLOATING
Rpexcapstie0 vdd_core vco_ind_LC 1m
Cpexcaps0 a_1954_2820.n0 vco_bias_0.vbg_buf 9.651e-17
Cpexcaps1 a_2654_4840.n0 a_5428_2384.n0 1.6582e-16
Cpexcaps2 a_1474_1090.n0 vco_bias_0.vbg_buf 5.415e-17
Cpexcaps3 a_1254_2820.n0 a_2654_4840.n0 1.1994e-16
Cpexcaps4 a_1254_2820.n0 ibias_100u 6.2359e-16
Cpexcaps5 a_1954_2820.n0 a_2654_4840.n0 1.5878e-16
Cpexcaps6 a_1954_2820.n0 ibias_100u 2.7709e-16
Cpexcaps7 a_1160_1390# a_1474_1090.n0 2.153e-17
Cpexcaps8 VDD a_2654_4840.n0 1.26593e-15
Cpexcaps9 a_1474_1090.n0 a_2654_4840.n0 1.27583e-15
Cpexcaps10 a_2654_4840.n0 vco_bias_0.vbn_buf 2.7632e-16
Cpexcaps11 a_11798_1180.n0 vtune 3.5675e-16
Cpexcaps12 a_1474_1090.n0 ibias_100u 3.3046e-16
Cpexcaps13 a_1254_2820.n0 di_en 3.0274e-16
Cpexcaps14 a_11798_1180.n0 a_9450_4394# 3.9463e-16
Cpexcaps15 a_11798_1180.n0 a_14668_2644# 3.9463e-16
Cpexcaps16 a_1254_2820.n0 a_1954_2820.n0 5.4548e-16
Cpexcaps17 VDD a_11798_1180.n0 1.2738e-16
Cpexcaps18 a_11798_1180.n0 vco_bias_0.vbn_buf 6.04923e-15
Cpexcaps19 a_1474_1090.n0 a_5428_2384.n0 5.624e-16
Cpexcaps20 a_5428_2384.n0 vco_bias_0.vbn_buf 1.02459e-15
Cpexcaps21 VDD a_1254_2820.n0 2.2664e-16
Cpexcaps22 a_2654_4840.n0 vco_bias_0.vbg_buf 2.237e-16
Cpexcaps23 a_1254_2820.n0 a_1474_1090.n0 1.616e-16
Cpexcaps24 a_1254_2820.n0 vco_bias_0.vbn_buf 1.8509e-16
Cpexcaps25 a_11798_1180.n0 rf_out_p 2.53404e-15
Cpexcaps26 VDD a_1954_2820.n0 2.2541e-16
Cpexcaps27 a_1474_1090.n0 a_1954_2820.n0 1.065e-16
Cpexcaps28 a_1954_2820.n0 vco_bias_0.vbn_buf 8.551e-17
Cpexcaps29 a_11798_1180.n0 rf_out_n 2.53404e-15
Cpexcaps30 a_1474_1090.n0 a_1560_1090# 3.586e-17
Cpexcaps31 VDD a_1474_1090.n0 2.7003e-16
Cpexcaps32 a_1474_1090.n0 vco_bias_0.vbn_buf 4.0649e-16
Cpexcaps33 a_5428_2384.n0 a_6760_4250# 6.042e-17
Cpexcaps34 a_2654_4840.n0 ibias_100u 5.5444e-16
Cpexcaps35 a_5428_2384.n0 vco_bias_0.vbg_buf 5.904e-17
Cpexcaps36 a_1474_1090.n0 a_6760_4250# 3.091e-17
Cpexcaps37 a_1254_2820.n0 vco_bias_0.vbg_buf 1.0523e-16
.ends

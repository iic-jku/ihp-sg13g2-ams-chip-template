* PEX produced on Sat Nov  7 12:48:14 AM CET 2026 using /foss/tools/sak/sak-pex.sh with m=3 and s=1 (extresist threshold=1000 mOhm, minres=100 mOhm, mindelay=0 ps)
* NGSPICE file created from vco_bias_pex.ext - technology: ihp-sg13g2

.subckt vco_bias_pex ibias_100u di_en VDD VSS vbg_buf vbn_buf
X0 VSS.t37 vbn_buf.t3 VSS.t36 VSS.t12 sg13_lv_nmos ad=2.72p pd=16.68u as=0 ps=0 w=8u l=10u
X1 VSS.t16 vbg_buf.t4 VSS.t14 VSS.t15 sg13_lv_nmos ad=1.52p pd=8.38u as=0 ps=0 w=8u l=10u
X2 VSS.t20 vbg_buf.t4 VSS.t18 VSS.t19 sg13_lv_nmos ad=1.52p pd=8.38u as=0 ps=0 w=8u l=10u
X3 a_4788_n10584.t1 a_4745_n10448.t5 VDD.t4 VDD.t0 sg13_lv_pmos ad=0.34p pd=2.68u as=0.34p ps=2.68u w=1u l=0.13u
X4 a_4400_n11078.t1 a_4400_n11078.t0 VSS.t3 VSS.t2 sg13_lv_nmos ad=0.85p pd=5.68u as=0.85p ps=5.68u w=2.5u l=0.5u
X5 VSS.t39 vbn_buf.t3 VSS.t37 VSS.t15 sg13_lv_nmos ad=1.52p pd=8.38u as=0 ps=0 w=8u l=10u
X6 vbn_buf.t1 ibias_100u.t3 VSS.t68 rhigh l=32u w=0.5u
X7 VSS.t43 vbn_buf.t3 VSS.t41 VSS.t19 sg13_lv_nmos ad=1.52p pd=8.38u as=0 ps=0 w=8u l=10u
X8 VSS.t28 vbg_buf.t3 VSS.t26 VSS.t17 sg13_lv_nmos ad=1.52p pd=8.38u as=0 ps=0 w=8u l=10u
X9 vbn_buf.t0 a_4745_n10448.t2 VSS.t1 VSS.t0 sg13_lv_nmos ad=0.34p pd=2.68u as=0.34p ps=2.68u w=1u l=0.13u
X10 VSS.t32 vbg_buf.t3 VSS.t30 VSS.t21 sg13_lv_nmos ad=1.52p pd=8.38u as=0 ps=0 w=8u l=10u
X11 a_4788_n10584.t0 a_4745_n10448.t4 VSS.t7 VSS.t6 sg13_lv_nmos ad=0.17p pd=1.68u as=0.17p ps=1.68u w=0.5u l=0.13u
X12 vbg_buf.t2 VSS.t8 cap_cmim l=19.1u w=19.5u
X13 ibias_100u.t0 a_4745_n10448.t3 VSS.t5 VSS.t4 sg13_lv_nmos ad=0.34p pd=2.68u as=0.34p ps=2.68u w=1u l=0.13u
X14 a_4400_n9292.t0 a_5408_n8864.t4 VDD.t2 VDD.t0 sg13_lv_pmos ad=1.7p pd=10.68u as=1.7p ps=10.68u w=5u l=0.5u
X15 VDD.t8 VDD.t6 VDD.t7 VDD.t0 sg13_lv_pmos ad=0.34p pd=2.68u as=0 ps=0 w=1u l=0.13u
X16 a_4745_n10448.t0 di_en.t1 VDD.t5 VDD.t0 sg13_lv_pmos ad=0.34p pd=2.68u as=0.34p ps=2.68u w=1u l=0.13u
X17 a_4745_n10448.t1 di_en.t0 VSS.t34 VSS.t33 sg13_lv_nmos ad=0.17p pd=1.68u as=0.17p ps=1.68u w=0.5u l=0.13u
X18 VSS.t51 vbn_buf.t2 VSS.t49 VSS.t17 sg13_lv_nmos ad=1.52p pd=8.38u as=0 ps=0 w=8u l=10u
X19 VSS.t55 vbn_buf.t2 VSS.t53 VSS.t21 sg13_lv_nmos ad=1.52p pd=8.38u as=0 ps=0 w=8u l=10u
X20 ibias_100u.t2 ibias_100u.t1 VSS.t67 VSS.t66 sg13_lv_nmos ad=0.85p pd=5.68u as=0.85p ps=5.68u w=2.5u l=0.5u
X21 VSS.t24 vbg_buf.t3 VSS.t23 VSS.t12 sg13_lv_nmos ad=2.72p pd=16.68u as=0 ps=0 w=8u l=10u
X22 VSS.t18 vbg_buf.t4 VSS.t16 VSS.t17 sg13_lv_nmos ad=1.52p pd=8.38u as=0 ps=0 w=8u l=10u
X23 VSS.t22 vbg_buf.t4 VSS.t20 VSS.t21 sg13_lv_nmos ad=1.52p pd=8.38u as=0 ps=0 w=8u l=10u
X24 VSS.t26 vbg_buf.t3 VSS.t24 VSS.t15 sg13_lv_nmos ad=1.52p pd=8.38u as=0 ps=0 w=8u l=10u
X25 VSS.t30 vbg_buf.t3 VSS.t28 VSS.t19 sg13_lv_nmos ad=1.52p pd=8.38u as=0 ps=0 w=8u l=10u
X26 a_5408_n8864.t3 a_5408_n8864.t2 VDD.t3 VDD.t0 sg13_lv_pmos ad=1.7p pd=10.68u as=1.7p ps=10.68u w=5u l=0.5u
X27 VDD.t17 VDD.t15 VDD.t16 VDD.t0 sg13_lv_pmos ad=1.7p pd=10.68u as=0 ps=0 w=5u l=0.5u
X28 vbg_buf.t0 a_4400_n9292.t2 VSS.t69 rhigh l=32u w=0.5u
X29 VSS.t41 vbn_buf.t3 VSS.t39 VSS.t17 sg13_lv_nmos ad=1.52p pd=8.38u as=0 ps=0 w=8u l=10u
X30 VSS.t45 vbn_buf.t3 VSS.t43 VSS.t21 sg13_lv_nmos ad=1.52p pd=8.38u as=0 ps=0 w=8u l=10u
X31 VSS.t59 VSS.t56 VSS.t58 VSS.t57 sg13_lv_nmos ad=0.85p pd=5.68u as=0 ps=0 w=2.5u l=0.5u
X32 VDD.t11 VDD.t9 VDD.t10 VDD.t0 sg13_lv_pmos ad=1.7p pd=10.68u as=0 ps=0 w=5u l=0.5u
X33 VSS.t63 VSS.t60 VSS.t62 VSS.t61 sg13_lv_nmos ad=0.85p pd=5.68u as=0 ps=0 w=2.5u l=0.5u
X34 VSS.t47 vbn_buf.t2 VSS.t46 VSS.t12 sg13_lv_nmos ad=2.72p pd=16.68u as=0 ps=0 w=8u l=10u
X35 a_4400_n9292.t1 a_4400_n11078.t2 VSS.t35 rppd l=8.5u w=0.5u
X36 a_5408_n8864.t1 ibias_100u.t4 VSS.t65 VSS.t64 sg13_lv_nmos ad=0.85p pd=5.68u as=0.85p ps=5.68u w=2.5u l=0.5u
X37 vbg_buf.t1 VSS.t10 cap_cmim l=7.28u w=13.6u
X38 VSS.t14 vbg_buf.t4 VSS.t13 VSS.t12 sg13_lv_nmos ad=2.72p pd=16.68u as=0 ps=0 w=8u l=10u
X39 a_5408_n8864.t0 a_4788_n10584.t2 VDD.t1 VDD.t0 sg13_lv_pmos ad=0.34p pd=2.68u as=0.34p ps=2.68u w=1u l=0.13u
X40 VSS.t49 vbn_buf.t2 VSS.t47 VSS.t15 sg13_lv_nmos ad=1.52p pd=8.38u as=0 ps=0 w=8u l=10u
X41 VSS.t53 vbn_buf.t2 VSS.t51 VSS.t19 sg13_lv_nmos ad=1.52p pd=8.38u as=0 ps=0 w=8u l=10u
X42 VDD.t14 VDD.t12 VDD.t13 VDD.t0 sg13_lv_pmos ad=1.7p pd=10.68u as=0 ps=0 w=5u l=0.5u
R0 ibias_100u.n3 ibias_100u.t3 48.8821
R1 ibias_100u.n0 ibias_100u.t4 24.2693
R2 ibias_100u.n1 ibias_100u.t1 24.2693
R3 ibias_100u ibias_100u.n3 19.0968
R4 ibias_100u.n0 ibias_100u.t0 17.3756
R5 ibias_100u.n2 ibias_100u.t2 9.21754
R6 ibias_100u.n3 ibias_100u.n2 4.77917
R7 ibias_100u.n1 ibias_100u.n0 0.543167
R8 ibias_100u.n2 ibias_100u.n1 0.320233
R9 di_en.n0 di_en.t0 21.6583
R10 di_en.n0 di_en.t1 19.605
R11 di_en di_en.n0 14.0236
R12 vbg_buf.n1 vbg_buf.t0 50.3957
R13 vbg_buf.n0 vbg_buf.t4 33.9824
R14 vbg_buf.n0 vbg_buf.t3 28.2977
R15 vbg_buf.n3 vbg_buf.t1 9.68001
R16 vbg_buf.n2 vbg_buf.t2 9.57493
R17 vbg_buf.n2 vbg_buf.n1 7.7565
R18 vbg_buf.n3 vbg_buf.n2 4.54717
R19 vbg_buf vbg_buf.n3 3.37383
R20 vbg_buf.n1 vbg_buf.n0 0.522633
R21 vbn_buf.n1 vbn_buf.t1 45.045
R22 vbn_buf.n0 vbn_buf.t3 34.2391
R23 vbn_buf.n0 vbn_buf.t2 28.5544
R24 vbn_buf.n2 vbn_buf.t0 17.2377
R25 vbn_buf.n2 vbn_buf.n1 13.5293
R26 vbn_buf.n1 vbn_buf.n0 6.9349
R27 vbn_buf vbn_buf.n2 2.55837
R28 VDD.n0 VDD.t15 17.5809
R29 VDD.n2 VDD.t12 17.5809
R30 VDD.n8 VDD.t9 17.5809
R31 VDD.n7 VDD.n8 0.0636783
R32 VDD.n11 VDD.n7 1.85672
R33 VDD.n3 VDD.t16 2.54484
R34 VDD.n10 VDD.t6 15.8062
R35 VDD.n11 VDD.n9 2.10335
R36 VDD.n8 VDD.t7 6.07554
R37 VDD.n8 VDD.t8 6.07554
R38 VDD.n4 VDD.t1 6.07554
R39 VDD.n5 VDD.t5 6.07554
R40 VDD.n6 VDD.t4 6.07554
R41 VDD VDD.n6 5.67699
R42 VDD.n11 VDD.n4 2.40129
R43 VDD.n4 VDD.n5 0.1061
R44 VDD.n6 VDD.n11 3.37539
R45 VDD.n11 VDD.n3 1.16155
R46 VDD.n1 VDD.t2 2.36408
R47 VDD.n1 VDD.t13 2.36408
R48 VDD.n0 VDD.t3 2.3637
R49 VDD.n2 VDD.t14 2.36338
R50 VDD.n2 VDD.t10 2.36338
R51 VDD.n0 VDD.t17 2.36327
R52 VDD.n2 VDD.t11 2.36327
R53 VDD.n11 VDD.t0 0.395849
R54 VDD.n1 VDD.n0 0.181347
R55 VDD.n6 VDD.n5 0.152127
R56 VDD.n3 VDD.n0 0.0814646
R57 VDD.n10 VDD.n4 0.144689
R58 VDD.n9 VDD.n1 0.139765
R59 VDD.n9 VDD.n2 0.137132
R60 VDD.n2 VDD.n7 0.120382
R61 VDD.n8 VDD.n10 0.102865
R62 VSS.n97 VSS.n10 2602.16
R63 VSS.t68 VSS.n96 743.021
R64 VSS.t35 VSS.t69 456.336
R65 VSS.t69 VSS.t68 214.746
R66 VSS.n8 VSS.t64 12.3256
R67 VSS.n10 VSS.n8 2.7037
R68 VSS.n8 VSS.t33 13.4871
R69 VSS.n11 VSS.t2 15.243
R70 VSS.t57 VSS.n11 18.5501
R71 VSS.n8 VSS.t66 18.838
R72 VSS.n12 VSS.t6 11.8376
R73 VSS.n181 VSS.t21 26.4818
R74 VSS.t12 VSS.n53 26.4818
R75 VSS.n12 VSS.t35 179.981
R76 VSS.n134 VSS.n51 24.5138
R77 VSS.n131 VSS.n55 24.5138
R78 VSS.n136 VSS.n46 24.5138
R79 VSS.n127 VSS.n58 24.5138
R80 VSS.n122 VSS.n62 24.5138
R81 VSS.n147 VSS.n36 24.5138
R82 VSS.n119 VSS.n65 24.5138
R83 VSS.n151 VSS.n34 24.5138
R84 VSS.n116 VSS.n70 24.5138
R85 VSS.n157 VSS.n29 24.5138
R86 VSS.n108 VSS.n75 24.5138
R87 VSS.n163 VSS.n24 24.5138
R88 VSS.n165 VSS.n21 24.5138
R89 VSS.n104 VSS.n82 24.5138
R90 VSS.n170 VSS.n18 24.5138
R91 VSS.n174 VSS.n15 24.5138
R92 VSS.t0 VSS.n8 16.1111
R93 VSS.n96 VSS.n48 23.0719
R94 VSS.n97 VSS.n86 20.188
R95 VSS.n89 VSS.t7 17.3443
R96 VSS.n91 VSS.t34 17.3443
R97 VSS.n8 VSS.n7 2.08334
R98 VSS.n12 VSS.n8 7.79649
R99 VSS.n3 VSS.t56 16.4809
R100 VSS.n6 VSS.t60 16.4809
R101 VSS.n10 VSS.t61 10.526
R102 VSS.n142 VSS.t15 12.9781
R103 VSS.t19 VSS.n77 12.9781
R104 VSS.t15 VSS.n40 11.5362
R105 VSS.n105 VSS.t19 11.5362
R106 VSS.n100 VSS.n17 10.0399
R107 VSS.n102 VSS.n20 10.0399
R108 VSS.n109 VSS.n26 10.0399
R109 VSS.n112 VSS.n27 10.0399
R110 VSS.n113 VSS.n28 10.0399
R111 VSS.n114 VSS.n31 10.0399
R112 VSS.n117 VSS.n32 10.0399
R113 VSS.n152 VSS.n33 10.0399
R114 VSS.n143 VSS.n39 10.0399
R115 VSS.n123 VSS.n41 10.0399
R116 VSS.n125 VSS.n44 10.0399
R117 VSS.n129 VSS.n49 10.0399
R118 VSS.n173 VSS.n84 10.0399
R119 VSS.n169 VSS.n80 10.0399
R120 VSS.n168 VSS.n79 10.0399
R121 VSS.n167 VSS.n78 10.0399
R122 VSS.n156 VSS.n68 10.0399
R123 VSS.n155 VSS.n67 10.0399
R124 VSS.n145 VSS.n63 10.0399
R125 VSS.n143 VSS.n60 10.0399
R126 VSS.n140 VSS.n59 10.0399
R127 VSS.n133 VSS.n52 10.0399
R128 VSS.n130 VSS.n50 10.0399
R129 VSS.n135 VSS.n50 10.0399
R130 VSS.n135 VSS.n49 10.0399
R131 VSS.n128 VSS.n47 10.0399
R132 VSS.n137 VSS.n57 10.0399
R133 VSS.n126 VSS.n45 10.0399
R134 VSS.n139 VSS.n45 10.0399
R135 VSS.n139 VSS.n44 10.0399
R136 VSS.n125 VSS.n43 10.0399
R137 VSS.n140 VSS.n43 10.0399
R138 VSS.n124 VSS.n59 10.0399
R139 VSS.n124 VSS.n42 10.0399
R140 VSS.n141 VSS.n42 10.0399
R141 VSS.n141 VSS.n41 10.0399
R142 VSS.n144 VSS.n39 10.0399
R143 VSS.n144 VSS.n61 10.0399
R144 VSS.n121 VSS.n38 10.0399
R145 VSS.n145 VSS.n38 10.0399
R146 VSS.n120 VSS.n63 10.0399
R147 VSS.n120 VSS.n37 10.0399
R148 VSS.n146 VSS.n37 10.0399
R149 VSS.n118 VSS.n35 10.0399
R150 VSS.n153 VSS.n33 10.0399
R151 VSS.n153 VSS.n66 10.0399
R152 VSS.n117 VSS.n66 10.0399
R153 VSS.n154 VSS.n32 10.0399
R154 VSS.n154 VSS.n67 10.0399
R155 VSS.n155 VSS.n68 10.0399
R156 VSS.n115 VSS.n31 10.0399
R157 VSS.n114 VSS.n30 10.0399
R158 VSS.n158 VSS.n71 10.0399
R159 VSS.n113 VSS.n71 10.0399
R160 VSS.n159 VSS.n28 10.0399
R161 VSS.n159 VSS.n72 10.0399
R162 VSS.n112 VSS.n72 10.0399
R163 VSS.n160 VSS.n27 10.0399
R164 VSS.n160 VSS.n73 10.0399
R165 VSS.n109 VSS.n73 10.0399
R166 VSS.n161 VSS.n26 10.0399
R167 VSS.n161 VSS.n74 10.0399
R168 VSS.n107 VSS.n25 10.0399
R169 VSS.n162 VSS.n25 10.0399
R170 VSS.n164 VSS.n23 10.0399
R171 VSS.n164 VSS.n76 10.0399
R172 VSS.n106 VSS.n76 10.0399
R173 VSS.n166 VSS.n78 10.0399
R174 VSS.n167 VSS.n79 10.0399
R175 VSS.n168 VSS.n80 10.0399
R176 VSS.n169 VSS.n81 10.0399
R177 VSS.n103 VSS.n20 10.0399
R178 VSS.n102 VSS.n19 10.0399
R179 VSS.n171 VSS.n83 10.0399
R180 VSS.n100 VSS.n83 10.0399
R181 VSS.n172 VSS.n17 10.0399
R182 VSS.n172 VSS.n84 10.0399
R183 VSS.n173 VSS.n85 10.0399
R184 VSS.n99 VSS.n85 10.0399
R185 VSS.n175 VSS.n87 10.0399
R186 VSS VSS.n194 9.6573
R187 VSS.n88 VSS.t10 9.50586
R188 VSS.n180 VSS.n179 8.5005
R189 VSS.n179 VSS.n174 8.5005
R190 VSS.n179 VSS.n98 8.5005
R191 VSS.n179 VSS.n170 8.5005
R192 VSS.n179 VSS.n104 8.5005
R193 VSS.n179 VSS.n165 8.5005
R194 VSS.n179 VSS.n105 8.5005
R195 VSS.n179 VSS.n163 8.5005
R196 VSS.n179 VSS.n108 8.5005
R197 VSS.n179 VSS.n157 8.5005
R198 VSS.n179 VSS.n116 8.5005
R199 VSS.n179 VSS.n151 8.5005
R200 VSS.n179 VSS.n119 8.5005
R201 VSS.n179 VSS.n147 8.5005
R202 VSS.n179 VSS.n122 8.5005
R203 VSS.n179 VSS.n142 8.5005
R204 VSS.n179 VSS.n127 8.5005
R205 VSS.n179 VSS.n136 8.5005
R206 VSS.n179 VSS.n131 8.5005
R207 VSS.n179 VSS.n134 8.5005
R208 VSS.n179 VSS.n132 8.5005
R209 VSS.n182 VSS.n86 8.5005
R210 VSS.n182 VSS.n82 8.5005
R211 VSS.n182 VSS.n77 8.5005
R212 VSS.n182 VSS.n75 8.5005
R213 VSS.n182 VSS.n70 8.5005
R214 VSS.n182 VSS.n65 8.5005
R215 VSS.n182 VSS.n62 8.5005
R216 VSS.n182 VSS.n58 8.5005
R217 VSS.n182 VSS.n56 8.5005
R218 VSS.n182 VSS.n55 8.5005
R219 VSS.n182 VSS.n15 8.5005
R220 VSS.n182 VSS.n18 8.5005
R221 VSS.n182 VSS.n21 8.5005
R222 VSS.n182 VSS.n24 8.5005
R223 VSS.n182 VSS.n29 8.5005
R224 VSS.n182 VSS.n34 8.5005
R225 VSS.n182 VSS.n36 8.5005
R226 VSS.n182 VSS.n40 8.5005
R227 VSS.n182 VSS.n46 8.5005
R228 VSS.n182 VSS.n48 8.5005
R229 VSS.n182 VSS.n51 8.5005
R230 VSS.n194 VSS.n14 7.76695
R231 VSS.n92 VSS.t5 6.07511
R232 VSS.n0 VSS.t1 6.07511
R233 VSS.n13 VSS.t8 5.92636
R234 VSS.n7 VSS.t63 3.2695
R235 VSS.n4 VSS.n9 0.0750609
R236 VSS.n175 VSS.n15 5.02019
R237 VSS.n99 VSS.n86 5.02019
R238 VSS.n171 VSS.n18 5.02019
R239 VSS.n103 VSS.n82 5.02019
R240 VSS.n166 VSS.n21 5.02019
R241 VSS.n106 VSS.n77 5.02019
R242 VSS.n162 VSS.n24 5.02019
R243 VSS.n107 VSS.n75 5.02019
R244 VSS.n158 VSS.n29 5.02019
R245 VSS.n115 VSS.n70 5.02019
R246 VSS.n152 VSS.n34 5.02019
R247 VSS.n118 VSS.n65 5.02019
R248 VSS.n146 VSS.n36 5.02019
R249 VSS.n121 VSS.n62 5.02019
R250 VSS.n126 VSS.n58 5.02019
R251 VSS.n137 VSS.n46 5.02019
R252 VSS.n128 VSS.n56 5.02019
R253 VSS.n130 VSS.n55 5.02019
R254 VSS.n133 VSS.n51 5.02019
R255 VSS.n174 VSS.n16 5.02019
R256 VSS.n170 VSS.n19 5.02019
R257 VSS.n165 VSS.n22 5.02019
R258 VSS.n163 VSS.n23 5.02019
R259 VSS.n157 VSS.n30 5.02019
R260 VSS.n151 VSS.n35 5.02019
R261 VSS.n136 VSS.n47 5.02019
R262 VSS.n180 VSS.n87 5.02019
R263 VSS.n104 VSS.n81 5.02019
R264 VSS.n108 VSS.n74 5.02019
R265 VSS.n116 VSS.n69 5.02019
R266 VSS.n119 VSS.n64 5.02019
R267 VSS.n122 VSS.n61 5.02019
R268 VSS.n127 VSS.n57 5.02019
R269 VSS.n131 VSS.n54 5.02019
R270 VSS.n132 VSS.n52 5.02019
R271 VSS.n134 VSS.n54 5.02019
R272 VSS.n129 VSS.n48 5.02019
R273 VSS.n123 VSS.n40 5.02019
R274 VSS.n142 VSS.n60 5.02019
R275 VSS.n147 VSS.n64 5.02019
R276 VSS.n156 VSS.t17 5.02019
R277 VSS.t17 VSS.n69 5.02019
R278 VSS.n105 VSS.n22 5.02019
R279 VSS.n98 VSS.n16 5.02019
R280 VSS.n194 VSS.n193 4.67815
R281 VSS.n98 VSS.n97 4.32638
R282 VSS.n7 VSS.n6 0.0686078
R283 VSS.n8 VSS.n1 1.8585
R284 VSS.n8 VSS.n93 4.23094
R285 VSS.n8 VSS.n4 1.51113
R286 VSS.n8 VSS.n90 3.37539
R287 VSS.n2 VSS.t3 3.14902
R288 VSS.n3 VSS.t58 3.14902
R289 VSS.n9 VSS.t59 3.14902
R290 VSS.n94 VSS.t65 3.14902
R291 VSS.n5 VSS.t67 3.14902
R292 VSS.n6 VSS.t62 3.14902
R293 VSS.n8 VSS.n95 2.80331
R294 VSS.n89 VSS.n88 2.69572
R295 VSS.n185 VSS.t30 2.21124
R296 VSS.n110 VSS.t51 2.21094
R297 VSS.n193 VSS.t23 2.21082
R298 VSS.n14 VSS.t46 2.21073
R299 VSS.n149 VSS.t49 2.21067
R300 VSS.n189 VSS.t26 2.21045
R301 VSS.n187 VSS.t28 2.21042
R302 VSS.n148 VSS.t47 2.21035
R303 VSS.n191 VSS.t24 2.21018
R304 VSS.n177 VSS.t55 2.21008
R305 VSS.n183 VSS.t32 2.2097
R306 VSS.n176 VSS.t53 2.20952
R307 VSS.n14 VSS.t36 2.20312
R308 VSS.n148 VSS.t37 2.20286
R309 VSS.n189 VSS.t16 2.20249
R310 VSS.n110 VSS.t41 2.20233
R311 VSS.n193 VSS.t13 2.20207
R312 VSS.n185 VSS.t20 2.20198
R313 VSS.n149 VSS.t39 2.20196
R314 VSS.n187 VSS.t18 2.20178
R315 VSS.n177 VSS.t45 2.2017
R316 VSS.n183 VSS.t22 2.20168
R317 VSS.n191 VSS.t14 2.20124
R318 VSS.n176 VSS.t43 2.20097
R319 VSS.n179 VSS.n156 1.7414
R320 VSS.n179 VSS.n175 1.7414
R321 VSS.n179 VSS.n99 1.7414
R322 VSS.n179 VSS.n173 1.7414
R323 VSS.n179 VSS.n172 1.7414
R324 VSS.n179 VSS.n100 1.7414
R325 VSS.n179 VSS.n171 1.7414
R326 VSS.n179 VSS.n102 1.7414
R327 VSS.n179 VSS.n103 1.7414
R328 VSS.n179 VSS.n169 1.7414
R329 VSS.n179 VSS.n168 1.7414
R330 VSS.n179 VSS.n167 1.7414
R331 VSS.n179 VSS.n166 1.7414
R332 VSS.n179 VSS.n106 1.7414
R333 VSS.n179 VSS.n164 1.7414
R334 VSS.n179 VSS.n162 1.7414
R335 VSS.n179 VSS.n107 1.7414
R336 VSS.n179 VSS.n161 1.7414
R337 VSS.n179 VSS.n109 1.7414
R338 VSS.n179 VSS.n160 1.7414
R339 VSS.n179 VSS.n112 1.7414
R340 VSS.n179 VSS.n159 1.7414
R341 VSS.n179 VSS.n113 1.7414
R342 VSS.n179 VSS.n158 1.7414
R343 VSS.n179 VSS.n114 1.7414
R344 VSS.n179 VSS.n115 1.7414
R345 VSS.n179 VSS.n155 1.7414
R346 VSS.n179 VSS.n154 1.7414
R347 VSS.n179 VSS.n117 1.7414
R348 VSS.n179 VSS.n153 1.7414
R349 VSS.n179 VSS.n152 1.7414
R350 VSS.n179 VSS.n118 1.7414
R351 VSS.n179 VSS.n146 1.7414
R352 VSS.n179 VSS.n120 1.7414
R353 VSS.n179 VSS.n145 1.7414
R354 VSS.n179 VSS.n121 1.7414
R355 VSS.n179 VSS.n144 1.7414
R356 VSS.n179 VSS.n143 1.7414
R357 VSS.n179 VSS.n123 1.7414
R358 VSS.n179 VSS.n141 1.7414
R359 VSS.n179 VSS.n124 1.7414
R360 VSS.n179 VSS.n140 1.7414
R361 VSS.n179 VSS.n125 1.7414
R362 VSS.n179 VSS.n139 1.7414
R363 VSS.n179 VSS.n126 1.7414
R364 VSS.n179 VSS.n137 1.7414
R365 VSS.n179 VSS.n128 1.7414
R366 VSS.n179 VSS.n129 1.7414
R367 VSS.n179 VSS.n135 1.7414
R368 VSS.n179 VSS.n130 1.7414
R369 VSS.n179 VSS.n133 1.7414
R370 VSS.n182 VSS.n87 1.7414
R371 VSS.n182 VSS.n85 1.7414
R372 VSS.n182 VSS.n84 1.7414
R373 VSS.n182 VSS.n83 1.7414
R374 VSS.n182 VSS.n81 1.7414
R375 VSS.n182 VSS.n80 1.7414
R376 VSS.n182 VSS.n79 1.7414
R377 VSS.n182 VSS.n78 1.7414
R378 VSS.n182 VSS.n76 1.7414
R379 VSS.n182 VSS.n74 1.7414
R380 VSS.n182 VSS.n73 1.7414
R381 VSS.n182 VSS.n72 1.7414
R382 VSS.n182 VSS.n71 1.7414
R383 VSS.n182 VSS.n69 1.7414
R384 VSS.n182 VSS.n68 1.7414
R385 VSS.n182 VSS.n67 1.7414
R386 VSS.n182 VSS.n66 1.7414
R387 VSS.n182 VSS.n64 1.7414
R388 VSS.n182 VSS.n63 1.7414
R389 VSS.n182 VSS.n61 1.7414
R390 VSS.n182 VSS.n60 1.7414
R391 VSS.n182 VSS.n59 1.7414
R392 VSS.n182 VSS.n57 1.7414
R393 VSS.n182 VSS.n54 1.7414
R394 VSS.n182 VSS.n16 1.7414
R395 VSS.n182 VSS.n17 1.7414
R396 VSS.n182 VSS.n19 1.7414
R397 VSS.n182 VSS.n20 1.7414
R398 VSS.n182 VSS.n22 1.7414
R399 VSS.n182 VSS.n23 1.7414
R400 VSS.n182 VSS.n25 1.7414
R401 VSS.n182 VSS.n26 1.7414
R402 VSS.n182 VSS.n27 1.7414
R403 VSS.n182 VSS.n28 1.7414
R404 VSS.n182 VSS.n30 1.7414
R405 VSS.n182 VSS.n31 1.7414
R406 VSS.n182 VSS.n32 1.7414
R407 VSS.n182 VSS.n33 1.7414
R408 VSS.n182 VSS.n35 1.7414
R409 VSS.n182 VSS.n37 1.7414
R410 VSS.n182 VSS.n38 1.7414
R411 VSS.n182 VSS.n39 1.7414
R412 VSS.n182 VSS.n41 1.7414
R413 VSS.n182 VSS.n42 1.7414
R414 VSS.n182 VSS.n43 1.7414
R415 VSS.n182 VSS.n44 1.7414
R416 VSS.n182 VSS.n45 1.7414
R417 VSS.n182 VSS.n47 1.7414
R418 VSS.n182 VSS.n49 1.7414
R419 VSS.n182 VSS.n50 1.7414
R420 VSS.n182 VSS.n52 1.7414
R421 VSS.n132 VSS.t12 1.44246
R422 VSS.n96 VSS.n56 1.44246
R423 VSS.t21 VSS.n180 1.44246
R424 VSS VSS.n13 0.869444
R425 VSS.n88 VSS.n13 0.674942
R426 VSS.n182 VSS.n53 0.570609
R427 VSS.n182 VSS.n181 0.570558
R428 VSS.n179 VSS.n53 0.570098
R429 VSS.n181 VSS.n179 0.570046
R430 VSS.n191 VSS.n190 0.243424
R431 VSS.n150 VSS.n148 0.243424
R432 VSS.n138 VSS.n14 0.242716
R433 VSS.n193 VSS.n192 0.242681
R434 VSS.n187 VSS.n186 0.24245
R435 VSS.n110 VSS.n101 0.24245
R436 VSS.n189 VSS.n188 0.240796
R437 VSS.n149 VSS.n111 0.240796
R438 VSS.n185 VSS.n184 0.239822
R439 VSS.n178 VSS.n176 0.239822
R440 VSS.n186 VSS.n185 0.227974
R441 VSS.n176 VSS.n101 0.227974
R442 VSS.n190 VSS.n189 0.227001
R443 VSS.n150 VSS.n149 0.227001
R444 VSS.n184 VSS.n183 0.225646
R445 VSS.n178 VSS.n177 0.225646
R446 VSS.n188 VSS.n187 0.224672
R447 VSS.n111 VSS.n110 0.224672
R448 VSS.n192 VSS.n191 0.223727
R449 VSS.n148 VSS.n138 0.223715
R450 VSS.n179 VSS.n101 0.218846
R451 VSS.n179 VSS.n150 0.218846
R452 VSS.n186 VSS.n182 0.218846
R453 VSS.n190 VSS.n182 0.218846
R454 VSS.n179 VSS.n178 0.208386
R455 VSS.n179 VSS.n111 0.208386
R456 VSS.n184 VSS.n182 0.208386
R457 VSS.n188 VSS.n182 0.208386
R458 VSS.n179 VSS.n138 0.208371
R459 VSS.n192 VSS.n182 0.20836
R460 VSS.t4 VSS.n8 18.1558
R461 VSS.n2 VSS.n0 0.146661
R462 VSS.n3 VSS.n2 0.139213
R463 VSS.n11 VSS.n8 0.101081
R464 VSS.n4 VSS.n3 0.0537818
R465 VSS.n94 VSS.n9 0.0951565
R466 VSS.n95 VSS.n94 0.0927224
R467 VSS.n5 VSS.n95 0.0891245
R468 VSS.n1 VSS.n0 0.0455524
R469 VSS.n93 VSS.n92 0.0794206
R470 VSS.n91 VSS.n90 0.0776211
R471 VSS.n6 VSS.n5 0.0773061
R472 VSS.n90 VSS.n89 0.0750054
R473 VSS.n93 VSS.n91 0.0725235
R474 VSS.n92 VSS.n1 0.107222
R475 a_4400_n11078.n0 a_4400_n11078.t2 27.72
R476 a_4400_n11078.n0 a_4400_n11078.t0 24.1197
R477 a_4400_n11078.t1 a_4400_n11078.n0 9.38813
R478 a_4400_n9292.n0 a_4400_n9292.t2 55.2712
R479 a_4400_n9292.n0 a_4400_n9292.t1 27.8842
R480 a_4400_n9292.t0 a_4400_n9292.n0 7.50485
R481 a_5408_n8864.n2 a_5408_n8864.t2 19.9393
R482 a_5408_n8864.n0 a_5408_n8864.t4 19.6783
R483 a_5408_n8864.n1 a_5408_n8864.t0 17.974
R484 a_5408_n8864.n2 a_5408_n8864.n1 5.04317
R485 a_5408_n8864.n0 a_5408_n8864.t1 4.81727
R486 a_5408_n8864.n1 a_5408_n8864.n0 4.76157
R487 a_5408_n8864.t3 a_5408_n8864.n2 3.15445
R488 a_4788_n10584.n0 a_4788_n10584.t2 30.2902
R489 a_4788_n10584.n0 a_4788_n10584.t0 27.2706
R490 a_4788_n10584.t1 a_4788_n10584.n0 11.5346
R491 a_4745_n10448.n0 a_4745_n10448.t1 27.1774
R492 a_4745_n10448.n2 a_4745_n10448.t2 25.4059
R493 a_4745_n10448.n1 a_4745_n10448.t5 20.7725
R494 a_4745_n10448.n1 a_4745_n10448.t4 20.4909
R495 a_4745_n10448.n0 a_4745_n10448.t3 20.4287
R496 a_4745_n10448.t0 a_4745_n10448.n0 12.1418
R497 a_4745_n10448.n2 a_4745_n10448.n1 5.30277
R498 a_4745_n10448.n0 a_4745_n10448.n2 4.5269
C0 a_0_n13610# vbg_buf 0.0551f
C1 vbg_buf di_en 1.53374f
C2 VDD di_en 0.54649f
C3 vbn_buf vbg_buf 4.77604f
C4 a_400_n13910# ibias_100u 0.01292f
C5 vbg_buf ibias_100u 1.57098f
C6 vbn_buf VDD 0.81478f
C7 VDD ibias_100u 0.49223f
C8 a_400_n13910# vbg_buf 0.06332f
C9 a_0_n13610# vbn_buf 0.029f
C10 vbn_buf di_en 0.10256f
C11 a_0_n13610# ibias_100u 0.0297f
C12 di_en ibias_100u 3.35887f
C13 VDD vbg_buf 2.27717f
C14 a_4400_n10992# vbg_buf 0.01338f
C15 vbn_buf ibias_100u 0.14465f
C16 a_4400_n10992# VDD 0.04042f
C17 a_400_n13910# a_0_n13610# 0.17942f
C18 ibias_100u VSS 6.40579f
C19 di_en VSS 3.68536f
C20 vbg_buf VSS 0.1117p
C21 vbn_buf VSS 0.10923p
C22 VDD VSS 2.2899f
C23 a_4745_n10448.n0 VSS 1.13583f
C24 a_4745_n10448.n1 VSS 0.90577f
C25 a_4745_n10448.n2 VSS 0.72569f
C26 a_4745_n10448.t1 VSS 0.18534f
C27 a_4745_n10448.t0 VSS 0.26178f
C28 a_4788_n10584.t0 VSS 0.15048f
C29 a_4788_n10584.n0 VSS 1.93057f
C30 a_4788_n10584.t1 VSS 0.27583f
C31 a_5408_n8864.t0 VSS 0.52551f
C32 a_5408_n8864.t1 VSS 0.53158f
C33 a_5408_n8864.n0 VSS 0.61187f
C34 a_5408_n8864.n1 VSS 0.91741f
C35 a_5408_n8864.n2 VSS 0.61232f
C36 a_5408_n8864.t3 VSS 0.98001f
C37 a_4400_n9292.t2 VSS 2.42003f
C38 a_4400_n9292.t1 VSS 0.75748f
C39 a_4400_n9292.n0 VSS 2.65212f
C40 a_4400_n9292.t0 VSS 1.04601f
C41 a_4400_n11078.t2 VSS 0.72877f
C42 a_4400_n11078.n0 VSS 0.74973f
C43 a_4400_n11078.t1 VSS 0.38379f
C44 VSS.t8 VSS 4.16668f
C45 VSS.t36 VSS 1.59114f
C46 VSS.t1 VSS 0.10086f
C47 VSS.t7 VSS 0.05366f
C48 VSS.t10 VSS 1.19639f
C49 VSS.t34 VSS 0.1215f
C50 VSS.t5 VSS 0.06182f
C51 VSS.t3 VSS 0.1355f
C52 VSS.t65 VSS 0.22866f
C53 VSS.t67 VSS 0.22866f
C54 VSS.t51 VSS 1.58889f
C55 VSS.t37 VSS 1.59114f
C56 VSS.t49 VSS 1.58889f
C57 VSS.t14 VSS 1.31494f
C58 VSS.t16 VSS 1.31494f
C59 VSS.t26 VSS 1.3131f
C60 VSS.t28 VSS 1.3131f
C61 VDD.n0 VSS 0.29787f
C62 VDD.n1 VSS 0.14356f
C63 VDD.n2 VSS 0.26799f
C64 VDD.n3 VSS 0.05264f
C65 VDD.n4 VSS 0.08617f
C66 VDD.n5 VSS 0.06994f
C67 VDD.n6 VSS 0.35763f
C68 VDD.n8 VSS 0.18754f
C69 VDD.t4 VSS 0.08096f
C70 VDD.t5 VSS 0.1151f
C71 VDD.t1 VSS 0.2489f
C72 VDD.t3 VSS 0.47152f
C73 VDD.t16 VSS 0.16426f
C74 VDD.t17 VSS 0.16045f
C75 VDD.t2 VSS 0.46985f
C76 VDD.t13 VSS 0.16045f
C77 VDD.t14 VSS 0.16045f
C78 VDD.t10 VSS 0.16045f
C79 VDD.t11 VSS 0.16045f
C80 VDD.t7 VSS 0.02241f
C81 VDD.t8 VSS 0.02241f
C82 VDD.n10 VSS 0.07533f
C83 VDD.t0 VSS 4.79536f
C84 VDD.n11 VSS 0.39331f
C85 vbn_buf.n0 VSS 0.06658f
C86 vbn_buf.t1 VSS 2.16928f
C87 vbn_buf.n1 VSS 0.0949f
C88 vbn_buf.t0 VSS 0.11039f
C89 vbn_buf.n2 VSS 0.06422f
C90 vbg_buf.n0 VSS 0.03609f
C91 vbg_buf.t0 VSS 1.95699f
C92 vbg_buf.n1 VSS 0.05047f
C93 vbg_buf.n2 VSS 0.03009f
C94 vbg_buf.n3 VSS 0.02568f
C95 di_en.n0 VSS 3.26913f
C96 ibias_100u.t3 VSS 2.49979f
C97 ibias_100u.t0 VSS 0.29896f
C98 ibias_100u.n0 VSS 0.85435f
C99 ibias_100u.n1 VSS 0.28583f
C100 ibias_100u.t2 VSS 0.65061f
C101 ibias_100u.n2 VSS 0.2794f
C102 ibias_100u.n3 VSS 3.00988f
.ends

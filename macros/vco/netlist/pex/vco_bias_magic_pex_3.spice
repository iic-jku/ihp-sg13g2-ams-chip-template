* PEX produced on Sat Nov  7 10:25:00 PM CET 2026 using /foss/tools/sak/sak-pex.sh with m=3 and s=1 (extresist threshold=1000 mOhm, minres=100 mOhm, mindelay=0 ps)
* NGSPICE file created from vco_bias_pex.ext - technology: ihp-sg13g2

.subckt vco_bias_pex di_en VDD VSS vbg_buf vbn_buf en_b
X0 VSS.t52 vbn_buf.t3 VSS.t51 VSS.t18 sg13_lv_nmos ad=2.72p pd=16.68u as=0 ps=0 w=8u l=10u
X1 VSS.t22 vbg_buf.t4 VSS.t20 VSS.t21 sg13_lv_nmos ad=1.52p pd=8.38u as=0 ps=0 w=8u l=10u
X2 VSS.t26 vbg_buf.t4 VSS.t24 VSS.t25 sg13_lv_nmos ad=1.52p pd=8.38u as=0 ps=0 w=8u l=10u
X3 a_4788_n10584.t1 en_b.t6 VDD.t12 VDD.t0 sg13_lv_pmos ad=0.34p pd=2.68u as=0.34p ps=2.68u w=1u l=0.13u
X4 a_4400_n11078.t1 a_4400_n11078.t0 VSS.t3 VSS.t2 sg13_lv_nmos ad=0.85p pd=5.68u as=0.85p ps=5.68u w=2.5u l=0.5u
X5 VSS.t54 vbn_buf.t3 VSS.t52 VSS.t21 sg13_lv_nmos ad=1.52p pd=8.38u as=0 ps=0 w=8u l=10u
X6 vbn_buf.t0 a_3900_n11998.t1 VSS.t17 rhigh l=32u w=0.5u
X7 VSS.t58 vbn_buf.t3 VSS.t56 VSS.t25 sg13_lv_nmos ad=1.52p pd=8.38u as=0 ps=0 w=8u l=10u
X8 VSS.t38 vbg_buf.t3 VSS.t36 VSS.t23 sg13_lv_nmos ad=1.52p pd=8.38u as=0 ps=0 w=8u l=10u
X9 vbn_buf.t1 en_b.t2 VSS.t48 VSS.t47 sg13_lv_nmos ad=0.34p pd=2.68u as=0.34p ps=2.68u w=1u l=0.13u
X10 VSS.t42 vbg_buf.t3 VSS.t40 VSS.t27 sg13_lv_nmos ad=1.52p pd=8.38u as=0 ps=0 w=8u l=10u
X11 a_4788_n10584.t0 en_b.t4 VSS.t44 VSS.t43 sg13_lv_nmos ad=0.17p pd=1.68u as=0.17p ps=1.68u w=0.5u l=0.13u
X12 vbg_buf.t2 VSS.t29 cap_cmim l=19.1u w=17.5u
X13 a_3900_n11998.t2 en_b.t3 VSS.t46 VSS.t45 sg13_lv_nmos ad=0.34p pd=2.68u as=0.34p ps=2.68u w=1u l=0.13u
X14 a_4400_n9292.t2 a_5408_n8864.t4 VDD.t15 VDD.t0 sg13_lv_pmos ad=1.7p pd=10.68u as=1.7p ps=10.68u w=5u l=0.5u
X15 VDD.t5 VDD.t3 VDD.t4 VDD.t0 sg13_lv_pmos ad=0.34p pd=2.68u as=0 ps=0 w=1u l=0.13u
X16 en_b.t0 di_en.t1 VDD.t14 VDD.t0 sg13_lv_pmos ad=0.34p pd=2.68u as=0.34p ps=2.68u w=1u l=0.13u
X17 en_b.t1 di_en.t0 VSS.t50 VSS.t49 sg13_lv_nmos ad=0.17p pd=1.68u as=0.17p ps=1.68u w=0.5u l=0.13u
X18 VSS.t66 vbn_buf.t2 VSS.t64 VSS.t23 sg13_lv_nmos ad=1.52p pd=8.38u as=0 ps=0 w=8u l=10u
X19 VSS.t70 vbn_buf.t2 VSS.t68 VSS.t27 sg13_lv_nmos ad=1.52p pd=8.38u as=0 ps=0 w=8u l=10u
X20 a_3900_n11998.t4 a_3900_n11998.t3 VSS.t1 VSS.t0 sg13_lv_nmos ad=0.85p pd=5.68u as=0.85p ps=5.68u w=2.5u l=0.5u
X21 VSS.t34 vbg_buf.t3 VSS.t33 VSS.t18 sg13_lv_nmos ad=2.72p pd=16.68u as=0 ps=0 w=8u l=10u
X22 VSS.t24 vbg_buf.t4 VSS.t22 VSS.t23 sg13_lv_nmos ad=1.52p pd=8.38u as=0 ps=0 w=8u l=10u
X23 VSS.t28 vbg_buf.t4 VSS.t26 VSS.t27 sg13_lv_nmos ad=1.52p pd=8.38u as=0 ps=0 w=8u l=10u
X24 a_3900_n9292.t1 en_b.t5 VDD.t13 VDD.t0 sg13_lv_pmos ad=0.68p pd=4.68u as=0.68p ps=4.68u w=2u l=0.13u
X25 VSS.t36 vbg_buf.t3 VSS.t34 VSS.t21 sg13_lv_nmos ad=1.52p pd=8.38u as=0 ps=0 w=8u l=10u
X26 VSS.t40 vbg_buf.t3 VSS.t38 VSS.t25 sg13_lv_nmos ad=1.52p pd=8.38u as=0 ps=0 w=8u l=10u
X27 a_5408_n8864.t1 a_5408_n8864.t0 VDD.t2 VDD.t0 sg13_lv_pmos ad=1.7p pd=10.68u as=1.7p ps=10.68u w=5u l=0.5u
X28 VDD.t11 VDD.t9 VDD.t10 VDD.t0 sg13_lv_pmos ad=1.7p pd=10.68u as=0 ps=0 w=5u l=0.5u
X29 vbg_buf.t0 a_4400_n9292.t1 VSS.t16 rhigh l=32u w=0.5u
X30 VSS.t56 vbn_buf.t3 VSS.t54 VSS.t23 sg13_lv_nmos ad=1.52p pd=8.38u as=0 ps=0 w=8u l=10u
X31 VSS.t60 vbn_buf.t3 VSS.t58 VSS.t27 sg13_lv_nmos ad=1.52p pd=8.38u as=0 ps=0 w=8u l=10u
X32 VSS.t10 VSS.t7 VSS.t9 VSS.t8 sg13_lv_nmos ad=0.85p pd=5.68u as=0 ps=0 w=2.5u l=0.5u
X33 VSS.t14 VSS.t11 VSS.t13 VSS.t12 sg13_lv_nmos ad=0.85p pd=5.68u as=0 ps=0 w=2.5u l=0.5u
X34 VSS.t62 vbn_buf.t2 VSS.t61 VSS.t18 sg13_lv_nmos ad=2.72p pd=16.68u as=0 ps=0 w=8u l=10u
X35 a_4400_n9292.t0 a_4400_n11078.t2 VSS.t15 rppd l=8.5u w=0.5u
X36 a_5408_n8864.t3 a_3900_n11998.t5 VSS.t5 VSS.t4 sg13_lv_nmos ad=0.85p pd=5.68u as=0.85p ps=5.68u w=2.5u l=0.5u
X37 vbg_buf.t1 VSS.t31 cap_cmim l=7.28u w=13.6u
X38 VSS.t20 vbg_buf.t4 VSS.t19 VSS.t18 sg13_lv_nmos ad=2.72p pd=16.68u as=0 ps=0 w=8u l=10u
X39 a_5408_n8864.t2 a_4788_n10584.t2 VDD.t1 VDD.t0 sg13_lv_pmos ad=0.34p pd=2.68u as=0.34p ps=2.68u w=1u l=0.13u
X40 VSS.t64 vbn_buf.t2 VSS.t62 VSS.t21 sg13_lv_nmos ad=1.52p pd=8.38u as=0 ps=0 w=8u l=10u
X41 VSS.t68 vbn_buf.t2 VSS.t66 VSS.t25 sg13_lv_nmos ad=1.52p pd=8.38u as=0 ps=0 w=8u l=10u
X42 a_3900_n9292.t0 a_3900_n11998.t0 VSS.t6 rppd l=13.1u w=0.5u
X43 VDD.t8 VDD.t6 VDD.t7 VDD.t0 sg13_lv_pmos ad=1.7p pd=10.68u as=0 ps=0 w=5u l=0.5u
R0 di_en.n0 di_en.t0 21.6583
R1 di_en.n0 di_en.t1 19.605
R2 di_en di_en.n0 14.0236
R3 en_b.n0 en_b.t1 27.1774
R4 en_b.n4 en_b.t5 24.9608
R5 en_b.n3 en_b.t2 24.8442
R6 en_b.n1 en_b.t6 20.7725
R7 en_b.n1 en_b.t4 20.4909
R8 en_b.n0 en_b.t3 20.4287
R9 en_b.n0 en_b.t0 12.1423
R10 en_b.n2 en_b.n1 5.30277
R11 en_b.n2 en_b.n0 4.5269
R12 en_b en_b.n4 2.33103
R13 en_b.n3 en_b.n2 0.562233
R14 en_b.n4 en_b.n3 0.469833
R15 vbg_buf.n1 vbg_buf.t0 50.3957
R16 vbg_buf.n0 vbg_buf.t4 33.9824
R17 vbg_buf.n0 vbg_buf.t3 28.2977
R18 vbg_buf.n3 vbg_buf.t1 9.68001
R19 vbg_buf.n2 vbg_buf.t2 9.57631
R20 vbg_buf.n2 vbg_buf.n1 7.7565
R21 vbg_buf.n3 vbg_buf.n2 4.54717
R22 vbg_buf vbg_buf.n3 3.37383
R23 vbg_buf.n1 vbg_buf.n0 0.522633
R24 vbn_buf.n1 vbn_buf.t0 45.045
R25 vbn_buf.n0 vbn_buf.t3 34.2391
R26 vbn_buf.n0 vbn_buf.t2 28.5544
R27 vbn_buf.n2 vbn_buf.t1 17.2377
R28 vbn_buf.n2 vbn_buf.n1 13.5293
R29 vbn_buf.n1 vbn_buf.n0 6.9349
R30 vbn_buf vbn_buf.n2 2.55837
R31 VDD.n3 VDD.t9 17.5809
R32 VDD.n0 VDD.t6 17.5809
R33 VDD.n10 VDD.n1 1.2602
R34 VDD.n4 VDD.t10 2.54484
R35 VDD.n2 VDD.t3 15.8062
R36 VDD.n8 VDD.t4 6.07554
R37 VDD.n2 VDD.t5 6.07554
R38 VDD.n5 VDD.t1 6.07554
R39 VDD.n6 VDD.t14 6.07554
R40 VDD.n7 VDD.t12 6.07554
R41 VDD VDD.n7 5.67699
R42 VDD.n1 VDD.n5 0.0656783
R43 VDD.n5 VDD.n6 0.1061
R44 VDD.n8 VDD.t13 3.45404
R45 VDD.n7 VDD.n10 3.37539
R46 VDD.n10 VDD.n0 1.51113
R47 VDD.n10 VDD.n4 1.16155
R48 VDD.n0 VDD.t8 2.3646
R49 VDD.n0 VDD.t7 2.36411
R50 VDD.n3 VDD.t2 2.36357
R51 VDD.n3 VDD.t11 2.36338
R52 VDD.n9 VDD.t15 2.36338
R53 VDD.n10 VDD.t0 0.395849
R54 VDD.n0 VDD.n9 0.222999
R55 VDD.n2 VDD.n8 0.199822
R56 VDD.n9 VDD.n3 0.181347
R57 VDD.n7 VDD.n6 0.152127
R58 VDD.n4 VDD.n3 0.0814646
R59 VDD.n2 VDD.n1 0.0766266
R60 VDD.n0 VDD.n8 0.139213
R61 VSS.n11 VSS.n117 2602.16
R62 VSS.n126 VSS.t17 743.021
R63 VSS.t6 VSS.t15 268.433
R64 VSS.t17 VSS.t16 214.746
R65 VSS.t16 VSS.t6 187.904
R66 VSS.n10 VSS.t0 18.838
R67 VSS.n9 VSS.n11 2.7037
R68 VSS.n9 VSS.t49 13.4871
R69 VSS.n12 VSS.t2 15.243
R70 VSS.n9 VSS.n10 0.0236829
R71 VSS.n13 VSS.t43 11.8376
R72 VSS.t8 VSS.n12 18.5501
R73 VSS.n9 VSS.t45 18.1558
R74 VSS.n180 VSS.t27 26.4818
R75 VSS.t18 VSS.n54 26.4817
R76 VSS.t15 VSS.n13 179.981
R77 VSS.n132 VSS.n50 24.5138
R78 VSS.n134 VSS.n47 24.5138
R79 VSS.n114 VSS.n59 24.5138
R80 VSS.n138 VSS.n44 24.5138
R81 VSS.n109 VSS.n64 24.5138
R82 VSS.n145 VSS.n39 24.5138
R83 VSS.n106 VSS.n67 24.5138
R84 VSS.n150 VSS.n35 24.5138
R85 VSS.n101 VSS.t23 24.5138
R86 VSS.n155 VSS.n31 24.5138
R87 VSS.n98 VSS.n73 24.5138
R88 VSS.n157 VSS.n28 24.5138
R89 VSS.n94 VSS.n77 24.5138
R90 VSS.n91 VSS.n79 24.5138
R91 VSS.n166 VSS.n20 24.5138
R92 VSS.n9 VSS.t47 16.1111
R93 VSS.n127 VSS.n126 23.0719
R94 VSS.n117 VSS.n84 20.188
R95 VSS.n119 VSS.t44 17.3443
R96 VSS.n121 VSS.t50 17.3443
R97 VSS.n9 VSS.n7 2.08334
R98 VSS.n13 VSS.n9 7.79649
R99 VSS.n3 VSS.t7 16.4809
R100 VSS.n6 VSS.t11 16.4809
R101 VSS.n10 VSS.t4 12.3256
R102 VSS.t12 VSS.n11 10.526
R103 VSS.n141 VSS.t21 12.9781
R104 VSS.n162 VSS.t25 12.9781
R105 VSS.t21 VSS.n111 11.5362
R106 VSS.t25 VSS.n24 11.5362
R107 VSS.n170 VSS.n17 10.0399
R108 VSS.n168 VSS.n18 10.0399
R109 VSS.n89 VSS.n19 10.0399
R110 VSS.n163 VSS.n23 10.0399
R111 VSS.n92 VSS.n27 10.0399
R112 VSS.n99 VSS.n33 10.0399
R113 VSS.n104 VSS.n37 10.0399
R114 VSS.n110 VSS.n41 10.0399
R115 VSS.n112 VSS.n42 10.0399
R116 VSS.n140 VSS.n43 10.0399
R117 VSS.n113 VSS.n46 10.0399
R118 VSS.n133 VSS.n49 10.0399
R119 VSS.n174 VSS.n85 10.0399
R120 VSS.n172 VSS.n83 10.0399
R121 VSS.n170 VSS.n82 10.0399
R122 VSS.n160 VSS.n75 10.0399
R123 VSS.n159 VSS.n74 10.0399
R124 VSS.n152 VSS.n68 10.0399
R125 VSS.n142 VSS.n61 10.0399
R126 VSS.n140 VSS.n60 10.0399
R127 VSS.n137 VSS.n57 10.0399
R128 VSS.n131 VSS.n55 10.0399
R129 VSS.n130 VSS.n53 10.0399
R130 VSS.n130 VSS.n52 10.0399
R131 VSS.n131 VSS.n52 10.0399
R132 VSS.n128 VSS.n55 10.0399
R133 VSS.n128 VSS.n51 10.0399
R134 VSS.n116 VSS.n48 10.0399
R135 VSS.n135 VSS.n57 10.0399
R136 VSS.n137 VSS.n58 10.0399
R137 VSS.n115 VSS.n58 10.0399
R138 VSS.n113 VSS.n45 10.0399
R139 VSS.n139 VSS.n60 10.0399
R140 VSS.n112 VSS.n43 10.0399
R141 VSS.n142 VSS.n62 10.0399
R142 VSS.n110 VSS.n62 10.0399
R143 VSS.n143 VSS.n41 10.0399
R144 VSS.n143 VSS.n63 10.0399
R145 VSS.n108 VSS.n40 10.0399
R146 VSS.n144 VSS.n40 10.0399
R147 VSS.n146 VSS.n38 10.0399
R148 VSS.n146 VSS.n65 10.0399
R149 VSS.n107 VSS.n65 10.0399
R150 VSS.n107 VSS.n66 10.0399
R151 VSS.n105 VSS.n37 10.0399
R152 VSS.n104 VSS.n36 10.0399
R153 VSS.n151 VSS.n68 10.0399
R154 VSS.n152 VSS.n69 10.0399
R155 VSS.n103 VSS.n69 10.0399
R156 VSS.n103 VSS.n70 10.0399
R157 VSS.n102 VSS.n70 10.0399
R158 VSS.n100 VSS.n71 10.0399
R159 VSS.n100 VSS.n34 10.0399
R160 VSS.n153 VSS.n34 10.0399
R161 VSS.n153 VSS.n33 10.0399
R162 VSS.n99 VSS.n32 10.0399
R163 VSS.n154 VSS.n32 10.0399
R164 VSS.n156 VSS.n30 10.0399
R165 VSS.n156 VSS.n72 10.0399
R166 VSS.n97 VSS.n29 10.0399
R167 VSS.n158 VSS.n74 10.0399
R168 VSS.n159 VSS.n75 10.0399
R169 VSS.n160 VSS.n76 10.0399
R170 VSS.n93 VSS.n27 10.0399
R171 VSS.n92 VSS.n26 10.0399
R172 VSS.n161 VSS.n26 10.0399
R173 VSS.n161 VSS.n25 10.0399
R174 VSS.n164 VSS.n23 10.0399
R175 VSS.n164 VSS.n78 10.0399
R176 VSS.n90 VSS.n22 10.0399
R177 VSS.n165 VSS.n22 10.0399
R178 VSS.n165 VSS.n21 10.0399
R179 VSS.n167 VSS.n80 10.0399
R180 VSS.n89 VSS.n80 10.0399
R181 VSS.n168 VSS.n19 10.0399
R182 VSS.n169 VSS.n18 10.0399
R183 VSS.n169 VSS.n81 10.0399
R184 VSS.n87 VSS.n81 10.0399
R185 VSS.n87 VSS.n82 10.0399
R186 VSS.n171 VSS.n17 10.0399
R187 VSS.n171 VSS.n83 10.0399
R188 VSS.n173 VSS.n85 10.0399
R189 VSS.n174 VSS.n86 10.0399
R190 VSS VSS.n193 9.6573
R191 VSS.n118 VSS.t31 9.50586
R192 VSS.n179 VSS.n178 8.5005
R193 VSS.n178 VSS.n166 8.5005
R194 VSS.n178 VSS.n91 8.5005
R195 VSS.n178 VSS.n162 8.5005
R196 VSS.n178 VSS.n94 8.5005
R197 VSS.n178 VSS.n157 8.5005
R198 VSS.n178 VSS.n98 8.5005
R199 VSS.n178 VSS.n155 8.5005
R200 VSS.n178 VSS.n101 8.5005
R201 VSS.n178 VSS.n150 8.5005
R202 VSS.n178 VSS.n106 8.5005
R203 VSS.n178 VSS.n145 8.5005
R204 VSS.n178 VSS.n109 8.5005
R205 VSS.n178 VSS.n141 8.5005
R206 VSS.n178 VSS.n111 8.5005
R207 VSS.n178 VSS.n138 8.5005
R208 VSS.n178 VSS.n114 8.5005
R209 VSS.n178 VSS.n134 8.5005
R210 VSS.n178 VSS.n127 8.5005
R211 VSS.n178 VSS.n132 8.5005
R212 VSS.n178 VSS.n129 8.5005
R213 VSS.n181 VSS.n84 8.5005
R214 VSS.n181 VSS.n79 8.5005
R215 VSS.n181 VSS.n77 8.5005
R216 VSS.n181 VSS.n73 8.5005
R217 VSS.n181 VSS.t23 8.5005
R218 VSS.n181 VSS.n67 8.5005
R219 VSS.n181 VSS.n64 8.5005
R220 VSS.n181 VSS.n59 8.5005
R221 VSS.n181 VSS.n56 8.5005
R222 VSS.n181 VSS.n16 8.5005
R223 VSS.n181 VSS.n20 8.5005
R224 VSS.n181 VSS.n24 8.5005
R225 VSS.n181 VSS.n28 8.5005
R226 VSS.n181 VSS.n31 8.5005
R227 VSS.n181 VSS.n35 8.5005
R228 VSS.n181 VSS.n39 8.5005
R229 VSS.n181 VSS.n44 8.5005
R230 VSS.n181 VSS.n47 8.5005
R231 VSS.n181 VSS.n50 8.5005
R232 VSS.n193 VSS.n15 7.76695
R233 VSS.n122 VSS.t46 6.07511
R234 VSS.n0 VSS.t48 6.07511
R235 VSS.n14 VSS.t29 5.93097
R236 VSS.n7 VSS.t14 3.2695
R237 VSS.n4 VSS.n8 0.0750609
R238 VSS.n102 VSS.t23 5.02019
R239 VSS.n173 VSS.n16 5.02019
R240 VSS.n167 VSS.n20 5.02019
R241 VSS.n90 VSS.n79 5.02019
R242 VSS.n163 VSS.n24 5.02019
R243 VSS.n93 VSS.n77 5.02019
R244 VSS.n158 VSS.n28 5.02019
R245 VSS.n97 VSS.n73 5.02019
R246 VSS.n154 VSS.n31 5.02019
R247 VSS.n151 VSS.n35 5.02019
R248 VSS.n105 VSS.n67 5.02019
R249 VSS.n144 VSS.n39 5.02019
R250 VSS.n108 VSS.n64 5.02019
R251 VSS.n139 VSS.n44 5.02019
R252 VSS.n115 VSS.n59 5.02019
R253 VSS.n135 VSS.n47 5.02019
R254 VSS.n116 VSS.n56 5.02019
R255 VSS.n133 VSS.n50 5.02019
R256 VSS.n166 VSS.n21 5.02019
R257 VSS.n162 VSS.n25 5.02019
R258 VSS.n157 VSS.n29 5.02019
R259 VSS.n155 VSS.n30 5.02019
R260 VSS.n150 VSS.n36 5.02019
R261 VSS.n145 VSS.n38 5.02019
R262 VSS.n138 VSS.n45 5.02019
R263 VSS.n134 VSS.n48 5.02019
R264 VSS.n132 VSS.n51 5.02019
R265 VSS.n179 VSS.n86 5.02019
R266 VSS.n91 VSS.n78 5.02019
R267 VSS.n94 VSS.n76 5.02019
R268 VSS.n98 VSS.n72 5.02019
R269 VSS.n101 VSS.n71 5.02019
R270 VSS.n106 VSS.n66 5.02019
R271 VSS.n109 VSS.n63 5.02019
R272 VSS.n129 VSS.n53 5.02019
R273 VSS.n127 VSS.n49 5.02019
R274 VSS.n114 VSS.n46 5.02019
R275 VSS.n111 VSS.n42 5.02019
R276 VSS.n141 VSS.n61 5.02019
R277 VSS.n172 VSS.n84 5.02019
R278 VSS.n193 VSS.n192 4.67815
R279 VSS.n117 VSS.n16 4.32638
R280 VSS.n7 VSS.n6 0.0686078
R281 VSS.n9 VSS.n1 1.8585
R282 VSS.n9 VSS.n123 4.23094
R283 VSS.n9 VSS.n4 1.51113
R284 VSS.n9 VSS.n120 3.37539
R285 VSS.n2 VSS.t3 3.14902
R286 VSS.n3 VSS.t9 3.14902
R287 VSS.n8 VSS.t10 3.14902
R288 VSS.n124 VSS.t5 3.14902
R289 VSS.n5 VSS.t1 3.14902
R290 VSS.n6 VSS.t13 3.14902
R291 VSS.n9 VSS.n125 2.80331
R292 VSS.n119 VSS.n118 2.69572
R293 VSS.n182 VSS.t42 2.2114
R294 VSS.n147 VSS.t62 2.2112
R295 VSS.n192 VSS.t33 2.21075
R296 VSS.n15 VSS.t61 2.21065
R297 VSS.n95 VSS.t66 2.21049
R298 VSS.n184 VSS.t40 2.21045
R299 VSS.n186 VSS.t38 2.21044
R300 VSS.n188 VSS.t36 2.21041
R301 VSS.n176 VSS.t70 2.21008
R302 VSS.n190 VSS.t34 2.20978
R303 VSS.n175 VSS.t68 2.2097
R304 VSS.n148 VSS.t64 2.20952
R305 VSS.n15 VSS.t51 2.20308
R306 VSS.n190 VSS.t20 2.20274
R307 VSS.n175 VSS.t58 2.20269
R308 VSS.n147 VSS.t52 2.20259
R309 VSS.n186 VSS.t24 2.20193
R310 VSS.n148 VSS.t54 2.20187
R311 VSS.n192 VSS.t19 2.20175
R312 VSS.n184 VSS.t26 2.20156
R313 VSS.n95 VSS.t56 2.2014
R314 VSS.n188 VSS.t22 2.20135
R315 VSS.n182 VSS.t28 2.20131
R316 VSS.n176 VSS.t60 2.20128
R317 VSS.n178 VSS.n174 1.7414
R318 VSS.n178 VSS.n173 1.7414
R319 VSS.n178 VSS.n172 1.7414
R320 VSS.n178 VSS.n171 1.7414
R321 VSS.n178 VSS.n170 1.7414
R322 VSS.n178 VSS.n87 1.7414
R323 VSS.n178 VSS.n169 1.7414
R324 VSS.n178 VSS.n168 1.7414
R325 VSS.n178 VSS.n89 1.7414
R326 VSS.n178 VSS.n167 1.7414
R327 VSS.n178 VSS.n165 1.7414
R328 VSS.n178 VSS.n90 1.7414
R329 VSS.n178 VSS.n164 1.7414
R330 VSS.n178 VSS.n163 1.7414
R331 VSS.n178 VSS.n161 1.7414
R332 VSS.n178 VSS.n92 1.7414
R333 VSS.n178 VSS.n93 1.7414
R334 VSS.n178 VSS.n160 1.7414
R335 VSS.n178 VSS.n159 1.7414
R336 VSS.n178 VSS.n158 1.7414
R337 VSS.n178 VSS.n97 1.7414
R338 VSS.n178 VSS.n156 1.7414
R339 VSS.n178 VSS.n154 1.7414
R340 VSS.n178 VSS.n99 1.7414
R341 VSS.n178 VSS.n153 1.7414
R342 VSS.n178 VSS.n100 1.7414
R343 VSS.n178 VSS.n102 1.7414
R344 VSS.n178 VSS.n103 1.7414
R345 VSS.n178 VSS.n152 1.7414
R346 VSS.n178 VSS.n151 1.7414
R347 VSS.n178 VSS.n104 1.7414
R348 VSS.n178 VSS.n105 1.7414
R349 VSS.n178 VSS.n107 1.7414
R350 VSS.n178 VSS.n146 1.7414
R351 VSS.n178 VSS.n144 1.7414
R352 VSS.n178 VSS.n108 1.7414
R353 VSS.n178 VSS.n143 1.7414
R354 VSS.n178 VSS.n110 1.7414
R355 VSS.n178 VSS.n142 1.7414
R356 VSS.n178 VSS.n112 1.7414
R357 VSS.n178 VSS.n140 1.7414
R358 VSS.n178 VSS.n139 1.7414
R359 VSS.n178 VSS.n113 1.7414
R360 VSS.n178 VSS.n115 1.7414
R361 VSS.n178 VSS.n137 1.7414
R362 VSS.n178 VSS.n135 1.7414
R363 VSS.n178 VSS.n116 1.7414
R364 VSS.n178 VSS.n133 1.7414
R365 VSS.n178 VSS.n128 1.7414
R366 VSS.n178 VSS.n131 1.7414
R367 VSS.n178 VSS.n130 1.7414
R368 VSS.n181 VSS.n86 1.7414
R369 VSS.n181 VSS.n85 1.7414
R370 VSS.n181 VSS.n83 1.7414
R371 VSS.n181 VSS.n82 1.7414
R372 VSS.n181 VSS.n81 1.7414
R373 VSS.n181 VSS.n80 1.7414
R374 VSS.n181 VSS.n78 1.7414
R375 VSS.n181 VSS.n76 1.7414
R376 VSS.n181 VSS.n75 1.7414
R377 VSS.n181 VSS.n74 1.7414
R378 VSS.n181 VSS.n72 1.7414
R379 VSS.n181 VSS.n71 1.7414
R380 VSS.n181 VSS.n70 1.7414
R381 VSS.n181 VSS.n69 1.7414
R382 VSS.n181 VSS.n68 1.7414
R383 VSS.n181 VSS.n66 1.7414
R384 VSS.n181 VSS.n65 1.7414
R385 VSS.n181 VSS.n63 1.7414
R386 VSS.n181 VSS.n62 1.7414
R387 VSS.n181 VSS.n61 1.7414
R388 VSS.n181 VSS.n60 1.7414
R389 VSS.n181 VSS.n58 1.7414
R390 VSS.n181 VSS.n57 1.7414
R391 VSS.n181 VSS.n55 1.7414
R392 VSS.n181 VSS.n17 1.7414
R393 VSS.n181 VSS.n18 1.7414
R394 VSS.n181 VSS.n19 1.7414
R395 VSS.n181 VSS.n21 1.7414
R396 VSS.n181 VSS.n22 1.7414
R397 VSS.n181 VSS.n23 1.7414
R398 VSS.n181 VSS.n25 1.7414
R399 VSS.n181 VSS.n26 1.7414
R400 VSS.n181 VSS.n27 1.7414
R401 VSS.n181 VSS.n29 1.7414
R402 VSS.n181 VSS.n30 1.7414
R403 VSS.n181 VSS.n32 1.7414
R404 VSS.n181 VSS.n33 1.7414
R405 VSS.n181 VSS.n34 1.7414
R406 VSS.n181 VSS.n36 1.7414
R407 VSS.n181 VSS.n37 1.7414
R408 VSS.n181 VSS.n38 1.7414
R409 VSS.n181 VSS.n40 1.7414
R410 VSS.n181 VSS.n41 1.7414
R411 VSS.n181 VSS.n42 1.7414
R412 VSS.n181 VSS.n43 1.7414
R413 VSS.n181 VSS.n45 1.7414
R414 VSS.n181 VSS.n46 1.7414
R415 VSS.n181 VSS.n48 1.7414
R416 VSS.n181 VSS.n49 1.7414
R417 VSS.n181 VSS.n51 1.7414
R418 VSS.n181 VSS.n52 1.7414
R419 VSS.n181 VSS.n53 1.7414
R420 VSS.n129 VSS.t18 1.44246
R421 VSS.n126 VSS.n56 1.44246
R422 VSS.t27 VSS.n179 1.44246
R423 VSS VSS.n14 0.869444
R424 VSS.n118 VSS.n14 0.674942
R425 VSS.n181 VSS.n54 0.570751
R426 VSS.n181 VSS.n180 0.570631
R427 VSS.n178 VSS.n54 0.57024
R428 VSS.n180 VSS.n178 0.570119
R429 VSS.n190 VSS.n189 0.243424
R430 VSS.n149 VSS.n147 0.243424
R431 VSS.n136 VSS.n15 0.242716
R432 VSS.n192 VSS.n191 0.242681
R433 VSS.n186 VSS.n185 0.24245
R434 VSS.n95 VSS.n88 0.24245
R435 VSS.n188 VSS.n187 0.240796
R436 VSS.n148 VSS.n96 0.240796
R437 VSS.n184 VSS.n183 0.239822
R438 VSS.n177 VSS.n175 0.239822
R439 VSS.n185 VSS.n184 0.227974
R440 VSS.n175 VSS.n88 0.227974
R441 VSS.n189 VSS.n188 0.227001
R442 VSS.n149 VSS.n148 0.227001
R443 VSS.n183 VSS.n182 0.225646
R444 VSS.n177 VSS.n176 0.225646
R445 VSS.n187 VSS.n186 0.224672
R446 VSS.n96 VSS.n95 0.224672
R447 VSS.n191 VSS.n190 0.223727
R448 VSS.n147 VSS.n136 0.223715
R449 VSS.n178 VSS.n88 0.218846
R450 VSS.n178 VSS.n149 0.218846
R451 VSS.n185 VSS.n181 0.218846
R452 VSS.n189 VSS.n181 0.218846
R453 VSS.n178 VSS.n177 0.208386
R454 VSS.n178 VSS.n96 0.208386
R455 VSS.n183 VSS.n181 0.208386
R456 VSS.n187 VSS.n181 0.208386
R457 VSS.n178 VSS.n136 0.208371
R458 VSS.n191 VSS.n181 0.20836
R459 VSS.n2 VSS.n0 0.146661
R460 VSS.n3 VSS.n2 0.139213
R461 VSS.n4 VSS.n3 0.0537818
R462 VSS.n124 VSS.n8 0.0951565
R463 VSS.n125 VSS.n124 0.0927224
R464 VSS.n5 VSS.n125 0.0891245
R465 VSS.n1 VSS.n0 0.0455524
R466 VSS.n123 VSS.n122 0.0794206
R467 VSS.n9 VSS.n12 0.0778984
R468 VSS.n121 VSS.n120 0.0776211
R469 VSS.n6 VSS.n5 0.0773061
R470 VSS.n120 VSS.n119 0.0750054
R471 VSS.n123 VSS.n121 0.0725235
R472 VSS.n122 VSS.n1 0.107222
R473 a_3900_n11998.n3 a_3900_n11998.t1 53.6608
R474 a_3900_n11998.n0 a_3900_n11998.t0 29.2688
R475 a_3900_n11998.n1 a_3900_n11998.t5 24.2693
R476 a_3900_n11998.n2 a_3900_n11998.t3 24.2693
R477 a_3900_n11998.n0 a_3900_n11998.t2 15.6068
R478 a_3900_n11998.t4 a_3900_n11998.n3 9.21799
R479 a_3900_n11998.n1 a_3900_n11998.n0 1.7693
R480 a_3900_n11998.n2 a_3900_n11998.n1 0.543167
R481 a_3900_n11998.n3 a_3900_n11998.n2 0.320233
R482 a_4400_n11078.n0 a_4400_n11078.t2 27.72
R483 a_4400_n11078.n0 a_4400_n11078.t0 24.1197
R484 a_4400_n11078.t1 a_4400_n11078.n0 9.38813
R485 a_4400_n9292.n0 a_4400_n9292.t1 55.2712
R486 a_4400_n9292.n0 a_4400_n9292.t0 27.8842
R487 a_4400_n9292.t2 a_4400_n9292.n0 7.50485
R488 a_3900_n9292.n0 a_3900_n9292.t0 34.3045
R489 a_3900_n9292.t1 a_3900_n9292.n0 5.85564
R490 a_3900_n9292.t1 a_3900_n9292.n0 5.85498
R491 a_5408_n8864.n2 a_5408_n8864.t0 19.9393
R492 a_5408_n8864.n0 a_5408_n8864.t4 19.6783
R493 a_5408_n8864.n1 a_5408_n8864.t2 17.974
R494 a_5408_n8864.n2 a_5408_n8864.n1 5.04317
R495 a_5408_n8864.n0 a_5408_n8864.t3 4.81727
R496 a_5408_n8864.n1 a_5408_n8864.n0 4.76157
R497 a_5408_n8864.t1 a_5408_n8864.n2 3.15445
R498 a_4788_n10584.n0 a_4788_n10584.t2 30.2902
R499 a_4788_n10584.n0 a_4788_n10584.t0 27.2706
R500 a_4788_n10584.t1 a_4788_n10584.n0 11.5346
C0 vbg_buf en_b 0.1683f
C1 vbg_buf a_3900_n11912# 0.01628f
C2 en_b vbn_buf 0.4166f
C3 a_4400_n10992# VDD 0.03954f
C4 vbg_buf vbn_buf 4.76533f
C5 a_400_n13910# a_0_n13610# 0.17942f
C6 VDD en_b 0.93758f
C7 di_en en_b 0.50415f
C8 VDD vbg_buf 2.26632f
C9 VDD vbn_buf 0.61584f
C10 di_en vbg_buf 2.11143f
C11 di_en vbn_buf 0.11137f
C12 a_400_n13910# vbg_buf 0.06101f
C13 a_4400_n10992# en_b 0.04005f
C14 a_4400_n10992# a_3900_n11912# 0.02516f
C15 a_0_n13610# vbg_buf 0.05206f
C16 a_4400_n10992# vbg_buf 0.01107f
C17 di_en VDD 0.54858f
C18 a_0_n13610# vbn_buf 0.029f
C19 di_en VSS 2.90686f
C20 en_b VSS 1.93782f
C21 vbg_buf VSS 0.1115p
C22 vbn_buf VSS 0.10914p
C23 VDD VSS 2.35794f
C24 a_4788_n10584.t0 VSS 0.16705f
C25 a_4788_n10584.n0 VSS 1.96244f
C26 a_4788_n10584.t1 VSS 0.29754f
C27 a_5408_n8864.t2 VSS 0.53873f
C28 a_5408_n8864.t3 VSS 0.49951f
C29 a_5408_n8864.n0 VSS 0.63149f
C30 a_5408_n8864.n1 VSS 0.94683f
C31 a_5408_n8864.n2 VSS 0.63196f
C32 a_5408_n8864.t1 VSS 1.01144f
C33 a_3900_n9292.t0 VSS 1.3759f
C34 a_3900_n9292.n0 VSS 1.50793f
C35 a_3900_n9292.t1 VSS 0.39564f
C36 a_4400_n9292.t1 VSS 2.51083f
C37 a_4400_n9292.t0 VSS 0.74746f
C38 a_4400_n9292.n0 VSS 3.16871f
C39 a_4400_n9292.t2 VSS 1.18844f
C40 a_4400_n11078.t2 VSS 0.72757f
C41 a_4400_n11078.n0 VSS 0.98077f
C42 a_4400_n11078.t1 VSS 0.50206f
C43 a_3900_n11998.t1 VSS 2.54411f
C44 a_3900_n11998.t0 VSS 1.1365f
C45 a_3900_n11998.t2 VSS 0.23644f
C46 a_3900_n11998.n0 VSS 1.25917f
C47 a_3900_n11998.n1 VSS 0.37674f
C48 a_3900_n11998.n2 VSS 0.2336f
C49 a_3900_n11998.n3 VSS 1.34536f
C50 a_3900_n11998.t4 VSS 0.53171f
C51 VSS.t29 VSS 3.54928f
C52 VSS.t51 VSS 1.59037f
C53 VSS.t66 VSS 1.58812f
C54 VSS.t48 VSS 0.12297f
C55 VSS.t44 VSS 0.06864f
C56 VSS.t31 VSS 1.15331f
C57 VSS.t50 VSS 0.07169f
C58 VSS.t46 VSS 0.07907f
C59 VSS.t3 VSS 0.17725f
C60 VSS.t5 VSS 0.18687f
C61 VSS.t1 VSS 0.18687f
C62 VSS.t52 VSS 1.59037f
C63 VSS.t64 VSS 1.58812f
C64 VSS.t20 VSS 1.2676f
C65 VSS.t22 VSS 1.2676f
C66 VSS.t36 VSS 1.26583f
C67 VSS.t38 VSS 1.26583f
C68 VDD.n0 VSS 0.2859f
C69 VDD.n2 VSS 0.12464f
C70 VDD.n3 VSS 0.31616f
C71 VDD.n4 VSS 0.05587f
C72 VDD.n5 VSS 0.09146f
C73 VDD.n6 VSS 0.07423f
C74 VDD.n7 VSS 0.37958f
C75 VDD.n8 VSS 0.11441f
C76 VDD.n9 VSS 0.07663f
C77 VDD.t12 VSS 0.10016f
C78 VDD.t14 VSS 0.07528f
C79 VDD.t1 VSS 0.25371f
C80 VDD.t2 VSS 0.48937f
C81 VDD.t10 VSS 0.17434f
C82 VDD.t11 VSS 0.1703f
C83 VDD.t15 VSS 0.48765f
C84 VDD.t7 VSS 0.1703f
C85 VDD.t8 VSS 0.1703f
C86 VDD.t13 VSS 0.18552f
C87 VDD.t4 VSS 0.02379f
C88 VDD.t5 VSS 0.02379f
C89 VDD.t0 VSS 5.08971f
C90 VDD.n10 VSS 0.41745f
C91 vbn_buf.n0 VSS 0.06655f
C92 vbn_buf.t0 VSS 2.16645f
C93 vbn_buf.n1 VSS 0.09486f
C94 vbn_buf.t1 VSS 0.1325f
C95 vbn_buf.n2 VSS 0.06419f
C96 vbg_buf.n0 VSS 0.03479f
C97 vbg_buf.t0 VSS 1.95581f
C98 vbg_buf.n1 VSS 0.04866f
C99 vbg_buf.n2 VSS 0.02901f
C100 vbg_buf.n3 VSS 0.02476f
C101 en_b.n0 VSS 1.45282f
C102 en_b.n1 VSS 1.15856f
C103 en_b.t0 VSS 0.26629f
C104 en_b.t1 VSS 0.15335f
C105 en_b.n2 VSS 0.39438f
C106 en_b.n3 VSS 0.58715f
C107 en_b.n4 VSS 0.93475f
C108 di_en.n0 VSS 1.92891f
.ends

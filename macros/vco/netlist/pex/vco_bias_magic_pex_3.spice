* PEX produced on Sun Nov  1 12:41:48 AM CET 2026 using /foss/tools/sak/sak-pex.sh with m=3 and s=1 (extresist threshold=10000 mOhm, minres=1000 mOhm, mindelay=1 ps)
* NGSPICE file created from vco_bias_pex.ext - technology: ihp-sg13g2

.subckt vco_bias_pex ibias_100u di_en VDD VSS vbg_buf vbn_buf
X0 VSS.t1 vbn_buf VSS.t1 VSS.t0 sg13_lv_nmos ad=2.72p pd=16.68u as=0 ps=0 w=8u l=10u
X1 VSS.t1 vbg_buf VSS.t1 VSS.t2 sg13_lv_nmos ad=1.52p pd=8.38u as=0 ps=0 w=8u l=10u
X2 VSS.t1 vbg_buf VSS.t1 VSS.t4 sg13_lv_nmos ad=1.52p pd=8.38u as=0 ps=0 w=8u l=10u
X3 VSS.t1 vbn_buf VSS.t1 VSS.t2 sg13_lv_nmos ad=1.52p pd=8.38u as=0 ps=0 w=8u l=10u
X4 a_4268_n12616# a_4268_n12616# VSS.t18 VSS.t17 sg13_lv_nmos ad=0.85p pd=5.68u as=0.85p ps=5.68u w=2.5u l=0.5u
X5 ibias_100u vbn_buf VSS.t32 rhigh l=32u w=0.5u
X6 VSS.t1 vbn_buf VSS.t1 VSS.t4 sg13_lv_nmos ad=1.52p pd=8.38u as=0 ps=0 w=8u l=10u
X7 VSS.t1 vbg_buf VSS.t1 VSS.t3 sg13_lv_nmos ad=1.52p pd=8.38u as=0 ps=0 w=8u l=10u
X8 VSS.t1 vbg_buf VSS.t1 VSS.t5 sg13_lv_nmos ad=1.52p pd=8.38u as=0 ps=0 w=8u l=10u
X9 a_794_n12180# a_94_n12180# VDD VDD sg13_lv_pmos ad=0.34p pd=2.68u as=0.34p ps=2.68u w=1u l=0.13u
X10 a_1494_n10160# a_794_n12180# VDD VDD sg13_lv_pmos ad=0.34p pd=2.68u as=0.34p ps=2.68u w=1u l=0.13u
X11 ibias_100u a_94_n12180# VSS VSS.t13 sg13_lv_nmos ad=0.34p pd=2.68u as=0.34p ps=2.68u w=1u l=0.13u
X12 VSS.t1 vbn_buf VSS.t1 VSS.t3 sg13_lv_nmos ad=1.52p pd=8.38u as=0 ps=0 w=8u l=10u
X13 VSS.t1 vbn_buf VSS.t1 VSS.t5 sg13_lv_nmos ad=1.52p pd=8.38u as=0 ps=0 w=8u l=10u
X14 VSS.t1 vbg_buf VSS.t1 VSS.t0 sg13_lv_nmos ad=2.72p pd=16.68u as=0 ps=0 w=8u l=10u
X15 a_1494_n10160# a_1494_n10160# VDD VDD sg13_lv_pmos ad=1.7p pd=10.68u as=1.7p ps=10.68u w=5u l=0.5u
X16 VSS.t1 vbg_buf VSS.t1 VSS.t3 sg13_lv_nmos ad=1.52p pd=8.38u as=0 ps=0 w=8u l=10u
X17 VSS.t1 vbg_buf VSS.t1 VSS.t5 sg13_lv_nmos ad=1.52p pd=8.38u as=0 ps=0 w=8u l=10u
X18 a_94_n12180# di_en VDD VDD sg13_lv_pmos ad=0.34p pd=2.68u as=0.34p ps=2.68u w=1u l=0.13u
X19 a_1494_n10160# ibias_100u VSS.t14 VSS.t17 sg13_lv_nmos ad=0.85p pd=5.68u as=0.85p ps=5.68u w=2.5u l=0.5u
X20 VSS.t1 vbg_buf VSS.t1 VSS.t2 sg13_lv_nmos ad=1.52p pd=8.38u as=0 ps=0 w=8u l=10u
X21 VSS.t1 vbg_buf VSS.t1 VSS.t4 sg13_lv_nmos ad=1.52p pd=8.38u as=0 ps=0 w=8u l=10u
X22 a_794_n12180# a_94_n12180# VSS VSS.t11 sg13_lv_nmos ad=0.17p pd=1.68u as=0.17p ps=1.68u w=0.5u l=0.13u
X23 a_314_n13910# vbg_buf VSS.t32 rhigh l=32u w=0.5u
X24 VSS.t1 vbn_buf VSS.t1 VSS.t3 sg13_lv_nmos ad=1.52p pd=8.38u as=0 ps=0 w=8u l=10u
X25 VSS.t1 vbn_buf VSS.t1 VSS.t5 sg13_lv_nmos ad=1.52p pd=8.38u as=0 ps=0 w=8u l=10u
X26 ibias_100u ibias_100u VSS.t14 VSS.t17 sg13_lv_nmos ad=0.85p pd=5.68u as=0.85p ps=5.68u w=2.5u l=0.5u
X27 vbn_buf a_94_n12180# VSS.t14 VSS.t13 sg13_lv_nmos ad=0.34p pd=2.68u as=0.34p ps=2.68u w=1u l=0.13u
X28 VSS.t1 vbn_buf VSS.t1 VSS.t0 sg13_lv_nmos ad=2.72p pd=16.68u as=0 ps=0 w=8u l=10u
X29 a_314_n13910# a_4268_n12616# VSS.t19 rppd l=8.5u w=0.5u
X30 a_314_n13910# a_1494_n10160# VDD VDD sg13_lv_pmos ad=1.7p pd=10.68u as=1.7p ps=10.68u w=5u l=0.5u
X31 a_94_n12180# di_en VSS.t12 VSS.t11 sg13_lv_nmos ad=0.17p pd=1.68u as=0.17p ps=1.68u w=0.5u l=0.13u
X32 VSS.t1 vbg_buf VSS.t1 VSS.t0 sg13_lv_nmos ad=2.72p pd=16.68u as=0 ps=0 w=8u l=10u
X33 VSS.t1 vbn_buf VSS.t1 VSS.t2 sg13_lv_nmos ad=1.52p pd=8.38u as=0 ps=0 w=8u l=10u
X34 VSS.t1 vbn_buf VSS.t1 VSS.t4 sg13_lv_nmos ad=1.52p pd=8.38u as=0 ps=0 w=8u l=10u
R0 VSS.n13 VSS.n12 2420.69
R1 VSS.n12 VSS.n1 1881.03
R2 VSS.t19 VSS.n8 1071.75
R3 VSS.n12 VSS.n11 883.99
R4 VSS.n11 VSS.t19 777.904
R5 VSS.n7 VSS.t32 4.80212
R6 VSS.t13 VSS.t17 71.9085
R7 VSS.n10 VSS.n9 47.9391
R8 VSS.t17 VSS.n10 33.5575
R9 VSS.n11 VSS.t11 30.6812
R10 VSS.t11 VSS.t13 23.9698
R11 VSS.n1 VSS.t0 25.4005
R12 VSS.n10 VSS.t12 8.26788
R13 VSS.n9 VSS 17.0005
R14 VSS.n9 VSS.n7 14.6964
R15 VSS.n13 VSS.n5 17.2795
R16 VSS.t14 VSS.n7 0.568525
R17 VSS.t18 VSS.t32 11.3338
R18 VSS.t2 VSS.n5 15.9192
R19 VSS.n2 VSS.t3 6.45629
R20 VSS.t3 VSS.n4 6.4583
R21 VSS.n8 VSS.n6 13.1965
R22 VSS.n6 VSS.t4 14.5593
R23 VSS.t1 VSS.n5 0.00100578
R24 VSS.t1 VSS.n1 0.04439
R25 VSS.t1 VSS.n6 0.00104347
R26 VSS VSS.t1 12.4069
R27 VSS.n0 VSS.n8 17.2811
R28 VSS.n2 VSS.n13 13.2015
R29 VSS.t1 VSS.n3 0.00100002
R30 VSS.t1 VSS.n0 0.00100431
R31 VSS.n4 VSS.t4 15.9212
R32 VSS.t1 VSS.n4 0.00100005
R33 VSS.t1 VSS.n2 0.00101069
R34 VSS.n3 VSS.t2 14.5617
R35 VSS.n3 VSS.t0 5.03541
R36 VSS.t12 VSS 1.68824
R37 VSS.t14 VSS.t18 1.61282
R38 VSS.n0 VSS.t5 4.19453
R39 VSS.t14 VSS 1.00856
C0 a_314_n13910# ibias_100u 0.33052f
C1 a_5600_n10750# vbg_buf 0.01222f
C2 di_en vbn_buf 0.04963f
C3 a_0_n13610# ibias_100u 0.03363f
C4 a_94_n12180# vbn_buf 0.18509f
C5 a_5600_n10750# a_314_n13910# 0.03091f
C6 vbg_buf a_314_n13910# 0.05415f
C7 a_94_n12180# a_1494_n10160# 0.11994f
C8 di_en VDD 0.10564f
C9 a_94_n12180# VDD 0.22455f
C10 a_794_n12180# vbn_buf 0.08551f
C11 a_0_n13610# a_314_n13910# 0.02153f
C12 a_4268_n12616# vbn_buf 1.02135f
C13 di_en ibias_100u 0.17288f
C14 a_94_n12180# ibias_100u 0.62359f
C15 vbg_buf a_400_n13910# 0.03586f
C16 a_794_n12180# a_1494_n10160# 0.15878f
C17 a_314_n13910# a_400_n13910# 0.03586f
C18 a_4268_n12616# a_1494_n10160# 0.16582f
C19 a_794_n12180# VDD 0.22541f
C20 a_0_n13610# a_400_n13910# 0.17942f
C21 vbg_buf di_en 0.06388f
C22 vbg_buf a_94_n12180# 0.10523f
C23 a_794_n12180# ibias_100u 0.27709f
C24 vbn_buf a_1494_n10160# 0.27632f
C25 a_314_n13910# a_94_n12180# 0.1616f
C26 a_5600_n10750# a_4268_n12616# 0.06042f
C27 vbg_buf a_794_n12180# 0.09651f
C28 ibias_100u vbn_buf 0.02722f
C29 VDD a_1494_n10160# 1.26593f
C30 a_314_n13910# a_794_n12180# 0.1065f
C31 a_4268_n12616# vbg_buf 0.05904f
C32 a_4268_n12616# a_314_n13910# 0.5624f
C33 a_5600_n10750# vbn_buf 0.04144f
C34 ibias_100u a_1494_n10160# 0.55444f
C35 a_94_n12180# di_en 0.30274f
C36 vbg_buf vbn_buf 4.88082f
C37 a_314_n13910# vbn_buf 0.40649f
C38 vbg_buf a_1494_n10160# 0.2237f
C39 a_0_n13610# vbn_buf 0.03612f
C40 a_314_n13910# a_1494_n10160# 1.27583f
C41 vbg_buf VDD 0.56641f
C42 a_794_n12180# a_94_n12180# 0.54548f
C43 a_314_n13910# VDD 0.25123f
C44 VDD VSS 9.86445f
C45 a_4268_n12616# VSS 0.56436f
C46 a_314_n13910# VSS 5.68205f
C47 a_794_n12180# VSS 0.27579f
C48 VSS.t1 VSS 0.21787p
C49 VSS.t18 VSS 0.95186f
C50 VSS.t14 VSS 2.47949f
.ends

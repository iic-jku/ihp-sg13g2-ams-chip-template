* NGSPICE file created from vco_bias_pex.ext - technology: ihp-sg13g2

.subckt vco_bias_pex ibias_100u di_en VDD VSS vbg_buf vbn_buf
X0 VSS.t10 vbn_buf VSS.t10 VSS.t9 sg13_lv_nmos ad=2.72p pd=16.68u as=0 ps=0 w=8u l=10u
X1 VSS.t10 vbg_buf VSS.t10 VSS.t11 sg13_lv_nmos ad=1.52p pd=8.38u as=0 ps=0 w=8u l=10u
X2 VSS.t10 vbg_buf VSS.t10 VSS.t13 sg13_lv_nmos ad=1.52p pd=8.38u as=0 ps=0 w=8u l=10u
X3 VSS.t10 vbn_buf VSS.t10 VSS.t11 sg13_lv_nmos ad=1.52p pd=8.38u as=0 ps=0 w=8u l=10u
X4 a_4268_n12616# a_4268_n12616# VSS.t20 VSS.t2 sg13_lv_nmos ad=0.85p pd=5.68u as=0.85p ps=5.68u w=2.5u l=0.5u
X5 ibias_100u vbn_buf VSS.t8 rhigh l=32u w=0.5u
X6 VSS.t10 vbn_buf VSS.t10 VSS.t13 sg13_lv_nmos ad=1.52p pd=8.38u as=0 ps=0 w=8u l=10u
X7 VSS.t10 vbg_buf VSS.t10 VSS.t12 sg13_lv_nmos ad=1.52p pd=8.38u as=0 ps=0 w=8u l=10u
X8 VSS.t10 vbg_buf VSS.t10 VSS.t14 sg13_lv_nmos ad=1.52p pd=8.38u as=0 ps=0 w=8u l=10u
X9 a_794_n12180# a_94_n12180# VDD VDD sg13_lv_pmos ad=0.34p pd=2.68u as=0.34p ps=2.68u w=1u l=0.13u
X10 a_1494_n10160# a_794_n12180# VDD VDD sg13_lv_pmos ad=0.34p pd=2.68u as=0.34p ps=2.68u w=1u l=0.13u
X11 ibias_100u a_94_n12180# VSS VSS.t6 sg13_lv_nmos ad=0.34p pd=2.68u as=0.34p ps=2.68u w=1u l=0.13u
X12 VSS.t10 vbn_buf VSS.t10 VSS.t12 sg13_lv_nmos ad=1.52p pd=8.38u as=0 ps=0 w=8u l=10u
X13 VSS.t10 vbn_buf VSS.t10 VSS.t14 sg13_lv_nmos ad=1.52p pd=8.38u as=0 ps=0 w=8u l=10u
X14 VSS.t10 vbg_buf VSS.t10 VSS.t9 sg13_lv_nmos ad=2.72p pd=16.68u as=0 ps=0 w=8u l=10u
X15 a_1494_n10160# a_1494_n10160# VDD VDD sg13_lv_pmos ad=1.7p pd=10.68u as=1.7p ps=10.68u w=5u l=0.5u
X16 VSS.t10 vbg_buf VSS.t10 VSS.t12 sg13_lv_nmos ad=1.52p pd=8.38u as=0 ps=0 w=8u l=10u
X17 VSS.t10 vbg_buf VSS.t10 VSS.t14 sg13_lv_nmos ad=1.52p pd=8.38u as=0 ps=0 w=8u l=10u
X18 a_94_n12180# di_en VDD VDD sg13_lv_pmos ad=0.34p pd=2.68u as=0.34p ps=2.68u w=1u l=0.13u
X19 a_1494_n10160# ibias_100u VSS.t3 VSS.t2 sg13_lv_nmos ad=0.85p pd=5.68u as=0.85p ps=5.68u w=2.5u l=0.5u
X20 VSS.t10 vbg_buf VSS.t10 VSS.t11 sg13_lv_nmos ad=1.52p pd=8.38u as=0 ps=0 w=8u l=10u
X21 VSS.t10 vbg_buf VSS.t10 VSS.t13 sg13_lv_nmos ad=1.52p pd=8.38u as=0 ps=0 w=8u l=10u
X22 a_794_n12180# a_94_n12180# VSS VSS.t0 sg13_lv_nmos ad=0.17p pd=1.68u as=0.17p ps=1.68u w=0.5u l=0.13u
X23 a_314_n13910# vbg_buf VSS.t8 rhigh l=32u w=0.5u
X24 VSS.t10 vbn_buf VSS.t10 VSS.t12 sg13_lv_nmos ad=1.52p pd=8.38u as=0 ps=0 w=8u l=10u
X25 VSS.t10 vbn_buf VSS.t10 VSS.t14 sg13_lv_nmos ad=1.52p pd=8.38u as=0 ps=0 w=8u l=10u
X26 ibias_100u ibias_100u VSS.t3 VSS.t2 sg13_lv_nmos ad=0.85p pd=5.68u as=0.85p ps=5.68u w=2.5u l=0.5u
X27 vbn_buf a_94_n12180# VSS.t3 VSS.t6 sg13_lv_nmos ad=0.34p pd=2.68u as=0.34p ps=2.68u w=1u l=0.13u
X28 VSS.t10 vbn_buf VSS.t10 VSS.t9 sg13_lv_nmos ad=2.72p pd=16.68u as=0 ps=0 w=8u l=10u
X29 a_314_n13910# a_4268_n12616# VSS.t31 rppd l=8.5u w=0.5u
X30 a_314_n13910# a_1494_n10160# VDD VDD sg13_lv_pmos ad=1.7p pd=10.68u as=1.7p ps=10.68u w=5u l=0.5u
X31 a_94_n12180# di_en VSS.t1 VSS.t0 sg13_lv_nmos ad=0.17p pd=1.68u as=0.17p ps=1.68u w=0.5u l=0.13u
X32 VSS.t10 vbg_buf VSS.t10 VSS.t9 sg13_lv_nmos ad=2.72p pd=16.68u as=0 ps=0 w=8u l=10u
X33 VSS.t10 vbn_buf VSS.t10 VSS.t11 sg13_lv_nmos ad=1.52p pd=8.38u as=0 ps=0 w=8u l=10u
X34 VSS.t10 vbn_buf VSS.t10 VSS.t13 sg13_lv_nmos ad=1.52p pd=8.38u as=0 ps=0 w=8u l=10u
C0 vbg_buf a_94_n12180# 0.10523f
C1 a_0_n13610# a_314_n13910# 0.02153f
C2 vbg_buf di_en 0.06388f
C3 a_0_n13610# a_400_n13910# 0.17942f
C4 a_4268_n12616# a_5600_n10750# 0.06042f
C5 vbg_buf vbn_buf 4.88082f
C6 a_1494_n10160# vbn_buf 0.27632f
C7 a_4268_n12616# a_314_n13910# 0.5624f
C8 vbg_buf a_5600_n10750# 0.01222f
C9 di_en a_94_n12180# 0.30274f
C10 vbn_buf a_94_n12180# 0.18509f
C11 ibias_100u a_0_n13610# 0.03363f
C12 vbg_buf a_314_n13910# 0.05415f
C13 a_1494_n10160# a_314_n13910# 1.27583f
C14 vbn_buf di_en 0.04963f
C15 vbg_buf a_400_n13910# 0.03586f
C16 vbg_buf a_794_n12180# 0.09651f
C17 a_1494_n10160# a_794_n12180# 0.15878f
C18 a_5600_n10750# vbn_buf 0.04144f
C19 a_314_n13910# a_94_n12180# 0.1616f
C20 a_1494_n10160# ibias_100u 0.55444f
C21 a_794_n12180# a_94_n12180# 0.54548f
C22 vbn_buf a_314_n13910# 0.40649f
C23 VDD vbg_buf 0.56641f
C24 a_1494_n10160# VDD 1.26593f
C25 a_794_n12180# vbn_buf 0.08551f
C26 a_5600_n10750# a_314_n13910# 0.03091f
C27 ibias_100u a_94_n12180# 0.62359f
C28 ibias_100u di_en 0.17288f
C29 a_314_n13910# a_400_n13910# 0.03586f
C30 ibias_100u vbn_buf 0.02722f
C31 VDD a_94_n12180# 0.22455f
C32 a_794_n12180# a_314_n13910# 0.1065f
C33 VDD di_en 0.10564f
C34 a_1494_n10160# a_4268_n12616# 0.16582f
C35 a_4268_n12616# vbg_buf 0.05904f
C36 ibias_100u a_314_n13910# 0.33052f
C37 ibias_100u a_794_n12180# 0.27709f
C38 VDD a_314_n13910# 0.25123f
C39 a_1494_n10160# vbg_buf 0.2237f
C40 a_0_n13610# vbn_buf 0.03612f
C41 VDD a_794_n12180# 0.22541f
C42 a_4268_n12616# vbn_buf 1.02135f
C43 a_1494_n10160# a_94_n12180# 0.11994f
R0 VSS.n13 VSS.n12 2420.69
R1 VSS.n12 VSS.n5 1881.03
R2 VSS.t31 VSS.n8 1071.75
R3 VSS.n12 VSS.n11 883.99
R4 VSS.n11 VSS.t31 777.904
R5 VSS.n7 VSS.t8 4.80212
R6 VSS.t6 VSS.t2 71.9085
R7 VSS.n10 VSS.n9 47.9391
R8 VSS.t2 VSS.n10 33.5575
R9 VSS.n11 VSS.t0 30.6812
R10 VSS.t0 VSS.t6 23.9698
R11 VSS.n5 VSS.t9 25.4011
R12 VSS.n10 VSS.t1 8.26788
R13 VSS.n9 VSS 17.0005
R14 VSS.n9 VSS.n7 14.6964
R15 VSS.t3 VSS.n7 0.568525
R16 VSS.t20 VSS.t8 11.3338
R17 VSS.t11 VSS.n6 15.9192
R18 VSS.n8 VSS.n2 13.1979
R19 VSS.t10 VSS.n4 0.0010331
R20 VSS.t10 VSS.n5 0.0440943
R21 VSS VSS.t10 12.2615
R22 VSS.n13 VSS.n3 13.1995
R23 VSS.t12 VSS.n0 6.45734
R24 VSS.n3 VSS.t12 6.45935
R25 VSS.t10 VSS.n2 0.00100466
R26 VSS.n0 VSS.t13 15.9252
R27 VSS.t10 VSS.n0 0.00100004
R28 VSS.n1 VSS.t11 14.5597
R29 VSS.t10 VSS.n3 0.00100002
R30 VSS.n6 VSS.n13 17.2815
R31 VSS.n4 VSS.n8 17.285
R32 VSS.n2 VSS.t13 14.5587
R33 VSS.t10 VSS.n6 0.00100004
R34 VSS.t10 VSS.n1 0.00100075
R35 VSS.t1 VSS 1.68824
R36 VSS.t3 VSS.t20 1.61282
R37 VSS.t9 VSS.n1 5.03241
R38 VSS.n4 VSS.t14 4.2019
R39 VSS.t3 VSS 1.00856
C44 ibias_100u VSS 4.95898f
C45 di_en VSS 1.10315f
C46 vbg_buf VSS 0.10792p
C47 vbn_buf VSS 0.10995p
C48 VDD VSS 4.14812f
C49 a_4268_n12616# VSS 2.46808f ; **FLOATING
C50 a_314_n13910# VSS 4.44231f ; **FLOATING
C51 a_794_n12180# VSS 0.80596f ; **FLOATING
C52 a_94_n12180# VSS 2.40775f ; **FLOATING
C53 a_1494_n10160# VSS 2.42752f ; **FLOATING
.ends

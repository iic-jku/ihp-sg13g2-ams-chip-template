* Extracted by KLayout with SG13G2 LVS runset on : 07/11/2026 22:23

.SUBCKT vco_feed VDD VSS en_b vdd_core
M$1 VDD en_b \$8 VDD sg13_lv_pmos L=0.13u W=96u AS=18.69p AD=18.69p PS=111.46u
+ PD=111.46u rfmode=0
R$33 vdd_core \$8 VSS rppd w=17.3u l=8.8u ps=0u b=0 m=1
.ENDS vco_feed

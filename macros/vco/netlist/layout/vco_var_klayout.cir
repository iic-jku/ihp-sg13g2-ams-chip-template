* Extracted by KLayout with SG13G2 LVS runset on : 17/10/2026 22:43

.SUBCKT vco_var VSS rf_n rf_p vtune
C$1 rf_p vtune rf_n VSS sg13_hv_svaricap w=3.74u l=0.3u Nx=8
C$2 rf_p vtune rf_n VSS sg13_hv_svaricap w=3.74u l=0.3u Nx=8
C$3 rf_p vtune rf_n VSS sg13_hv_svaricap w=3.74u l=0.3u Nx=8
.ENDS vco_var

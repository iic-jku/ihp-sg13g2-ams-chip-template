* Extracted by KLayout with SG13G2 LVS runset on : 03/11/2026 23:37

.SUBCKT vco_core VSS rf_n rf_p vdd_core vtune
X$1 VSS vdd_core rf_n rf_p vco_ind
X$2 VSS rf_p vtune rf_n vco_var
M$1 VSS rf_p rf_n VSS sg13_lv_nmos L=0.13u W=20u AS=4.1p AD=4.1p PS=26.1u
+ PD=26.1u rfmode=0
M$11 VSS rf_n rf_p VSS sg13_lv_nmos L=0.13u W=20u AS=4.1p AD=4.1p PS=26.1u
+ PD=26.1u rfmode=0
C$21 vdd_core VSS cap_cmim w=56u l=39u A=2184p P=190u m=1
C$22 vdd_core VSS cap_cmim w=42u l=25.5u A=1071p P=135u m=1
.ENDS vco_core

.SUBCKT vco_var VSS rf_p vtune rf_n
C$1 rf_p vtune rf_n VSS sg13_hv_svaricap w=3.74u l=0.3u Nx=7
C$2 rf_p vtune rf_n VSS sg13_hv_svaricap w=3.74u l=0.3u Nx=7
C$3 rf_p vtune rf_n VSS sg13_hv_svaricap w=3.74u l=0.3u Nx=7
.ENDS vco_var

.SUBCKT vco_ind VSS LC LB LA
L$1 LA LC LB VSS inductor3 w=4u s=3.999u d=52.022u nr_r=2
.ENDS vco_ind

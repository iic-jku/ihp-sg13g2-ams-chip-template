* Extracted by KLayout with SG13G2 LVS runset on : 17/10/2026 22:41

.SUBCKT vco_bias VDD VSS di_en ibias_100u vbg_buf vbn_buf vbp_core
M$1 VSS \$12 \$12 VSS sg13_lv_nmos L=0.5u W=2.5u AS=0.85p AD=0.85p PS=5.68u
+ PD=5.68u rfmode=0
M$2 VSS ibias_100u ibias_100u VSS sg13_lv_nmos L=0.5u W=2.5u AS=0.85p AD=0.85p
+ PS=5.68u PD=5.68u rfmode=0
M$3 VSS ibias_100u \$11 VSS sg13_lv_nmos L=0.5u W=2.5u AS=0.85p AD=0.85p
+ PS=5.68u PD=5.68u rfmode=0
M$4 VSS \$30 vbn_buf VSS sg13_lv_nmos L=0.13u W=1u AS=0.34p AD=0.34p PS=2.68u
+ PD=2.68u rfmode=0
M$5 VSS di_en \$30 VSS sg13_lv_nmos L=0.13u W=0.5u AS=0.17p AD=0.17p PS=1.68u
+ PD=1.68u rfmode=0
M$6 VSS \$30 \$31 VSS sg13_lv_nmos L=0.13u W=0.5u AS=0.17p AD=0.17p PS=1.68u
+ PD=1.68u rfmode=0
M$7 VSS \$30 ibias_100u VSS sg13_lv_nmos L=0.13u W=1u AS=0.34p AD=0.34p
+ PS=2.68u PD=2.68u rfmode=0
M$8 VDD vbp_core vbg_buf VDD sg13_lv_pmos L=0.5u W=5u AS=1.7p AD=1.7p PS=10.68u
+ PD=10.68u rfmode=0
M$9 VDD \$31 vbp_core VDD sg13_lv_pmos L=0.13u W=1u AS=0.34p AD=0.34p PS=2.68u
+ PD=2.68u rfmode=0
M$10 VDD \$11 \$11 VDD sg13_lv_pmos L=0.5u W=5u AS=1.7p AD=1.7p PS=10.68u
+ PD=10.68u rfmode=0
M$11 VDD \$30 \$31 VDD sg13_lv_pmos L=0.13u W=1u AS=0.34p AD=0.34p PS=2.68u
+ PD=2.68u rfmode=0
M$12 VDD di_en \$30 VDD sg13_lv_pmos L=0.13u W=1u AS=0.34p AD=0.34p PS=2.68u
+ PD=2.68u rfmode=0
R$13 vbg_buf \$12 VSS rppd w=0.5u l=8.5u ps=0u b=0 m=1
R$14 ibias_100u vbn_buf VSS rhigh w=0.5u l=16u ps=0u b=0 m=1
R$15 \$11 vbp_core VSS rhigh w=0.5u l=16u ps=0u b=0 m=1
C$16 vbn_buf VSS cap_cmim w=30u l=30u A=900p P=120u m=1
C$17 vbg_buf VSS cap_cmim w=20u l=20u A=400p P=80u m=1
C$18 VDD vbp_core cap_cmim w=30u l=30u A=900p P=120u m=1
.ENDS vco_bias

*SPICE netlist created from verilog structural netlist module riscv_top by vlog2Spice (qflow)
*This file may contain array delimiters, not for use in simulation.

.include /foss/pdks/ihp-sg13g2/libs.ref/sg13g2_stdcell/spice/sg13g2_stdcell.spice

.subckt riscv_top VPWR VGND clk reset so si sclk
+ sram_ce sda_i sda_o sda_oe scl rx tx gpio_in[0]
+ gpio_in[1] gpio_in[2] gpio_in[3] gpio_out[0] gpio_out[1] gpio_out[2] gpio_out[3] analog_en
+ I_ae ds_I_oe ds_I_p_i ds_I_p_o ds_I_n_i ds_I_n_o lo_I_oe lo_I_i
+ lo_I_o lo_Ix_i lo_Ix_o lo_Qx_i lo_Qx_o lo_Q_i lo_Q_o lo_Q_oe
+ ds_Q_n_i ds_Q_n_o ds_Q_p_i ds_Q_p_o ds_Q_oe Q_ae

X_19574_ _12937_ \memory_i.freq_inst.dsmod_cos.i_ena_mod\ \memory_i.freq_inst.lo_gen.lo_i_r\ VPWR VGND sg13g2_nand2_1
X_19575_ _12938_ \memory_i.freq_inst.dsmod_cos.i_ena_mod\ VPWR VGND sg13g2_inv_1
X_19576_ _12939_ _12938_ VPWR VGND sg13g2_buf_1
X_19577_ _12940_ _12939_ VPWR VGND sg13g2_buf_1
X_19578_ _12941_ _12940_ VPWR VGND sg13g2_buf_1
X_19579_ _12942_ _12941_ \memory_i.freq_inst.lo_gen.lo_q_r\ VPWR VGND sg13g2_nand2_1
X_19580_ _12943_ \memory_i.freq_inst.cordic.rstn_i\ VPWR VGND sg13g2_inv_1
X_19581_ _12944_ _12943_ VPWR VGND sg13g2_buf_1
X_19582_ _12945_ _12944_ VPWR VGND sg13g2_buf_1
X_19583_ _12946_ _12945_ VPWR VGND sg13g2_buf_1
X_19584_ _01973_ _12937_ _12942_ _12946_ VPWR VGND sg13g2_a21oi_1
X_19585_ _00045_ \memory_i.sram_master.clk_counter[0]\ VPWR VGND sg13g2_inv_1
X_19586_ _12947_ reset VPWR VGND sg13g2_inv_1
X_19587_ _12948_ _12947_ VPWR VGND sg13g2_buf_1
X_19588_ _12949_ _12948_ VPWR VGND sg13g2_buf_1
X_19589_ _12950_ _12949_ VPWR VGND sg13g2_buf_1
X_19590_ _00002_ _12950_ VPWR VGND sg13g2_buf_1
X_19591_ _12951_ \memory_i.state[2]\ \memory_i.state[4]\ VPWR VGND sg13g2_or2_1
X_19592_ _12952_ _12951_ VPWR VGND sg13g2_buf_1
X_19593_ _12953_ \memory_i.state[1]\ \memory_i.state[6]\ _12952_ VPWR VGND sg13g2_nor3_1
X_19594_ _00001_ reset \control_i.state_q[3]\ _12953_ VPWR VGND sg13g2_and3_1
X_19595_ _00000_ reset \control_i.state_q[7]\ VPWR VGND sg13g2_and2_1
X_19596_ _12954_ \control_i.state_q[6]\ \control_i.state_q[4]\ VPWR VGND sg13g2_or2_1
X_19597_ _12955_ _12954_ VPWR VGND sg13g2_buf_1
X_19598_ _12956_ _12955_ VPWR VGND sg13g2_buf_1
X_19599_ _12957_ \control_i.state_q[3]\ \control_i.state_q[5]\ _12956_ VPWR VGND sg13g2_nor3_1
X_19600_ _12958_ _12957_ VPWR VGND sg13g2_buf_1
X_19601_ _12959_ _12947_ _12958_ VPWR VGND sg13g2_nor2_1
X_19602_ _00031_ _12959_ VPWR VGND sg13g2_inv_1
X_19603_ _12960_ \memory_i.sclk_flag\ VPWR VGND sg13g2_inv_1
X_19604_ _12961_ \memory_i.uart_transmitter.fsm_state[1]\ \memory_i.uart_transmitter.fsm_state[0]\ VPWR VGND sg13g2_nor2_1
X_19605_ _12962_ \memory_i.sram_master.state[3]\ VPWR VGND sg13g2_inv_1
X_19606_ _12963_ \memory_i.sram_master.state[0]\ VPWR VGND sg13g2_inv_1
X_19607_ _12964_ _12962_ _12963_ \memory_i.target[2]\ VPWR VGND sg13g2_a21oi_1
X_19608_ _12965_ \memory_i.target[2]\ _12961_ _12964_ VPWR VGND sg13g2_a21oi_1
X_19609_ _12966_ \memory_i.i2c_master.state[4]\ \memory_i.i2c_master.state[0]\ \memory_i.target[3]\ VPWR VGND sg13g2_o21ai_1
X_19610_ _12967_ \memory_i.target[3]\ _12965_ _12966_ VPWR VGND sg13g2_o21ai_1
X_19611_ _12968_ _12967_ VPWR VGND sg13g2_inv_1
X_19612_ _12969_ _12960_ _12968_ VPWR VGND sg13g2_nor2_1
X_19613_ _12970_ _00031_ _12969_ VPWR VGND sg13g2_nor2_1
X_19614_ _12971_ \rd_alu[25]\ \rd_alu[26]\ \rd_alu[24]\ VPWR VGND sg13g2_nor3_1
X_19615_ _12972_ \rd_alu[29]\ \rd_alu[30]\ VPWR VGND sg13g2_or2_1
X_19616_ _12973_ \rd_alu[28]\ \rd_alu[31]\ \rd_alu[27]\ _12972_ VPWR
+ VGND
+ sg13g2_nor4_1
X_19617_ _12974_ \control_i.state_q[6]\ \control_i.state_q[4]\ VPWR VGND sg13g2_nor2_1
X_19618_ _12975_ _12974_ VPWR VGND sg13g2_buf_1
X_19619_ _12976_ _12971_ _12973_ _12975_ VPWR VGND sg13g2_a21oi_1
X_19620_ _12977_ \rd_alu[23]\ _12955_ VPWR VGND sg13g2_nand2_1
X_19621_ _12978_ _12977_ VPWR VGND sg13g2_buf_1
X_19622_ _12979_ _12976_ _12978_ VPWR VGND sg13g2_nor2b_1
X_19623_ _12980_ _12979_ VPWR VGND sg13g2_buf_1
X_19624_ _12981_ \rd_alu[2]\ VPWR VGND sg13g2_inv_1
X_19625_ _12982_ \csr_i.pc[13]\ \csr_i.pc[12]\ \csr_i.pc[11]\ \csr_i.pc[6]\ VPWR
+ VGND
+ sg13g2_nor4_1
X_19626_ _12983_ \csr_i.pc[10]\ \csr_i.pc[9]\ VPWR VGND sg13g2_or2_1
X_19627_ _12984_ \csr_i.pc[8]\ \csr_i.pc[7]\ _12983_ VPWR VGND sg13g2_nor3_1
X_19628_ _12985_ \csr_i.pc[21]\ \csr_i.pc[20]\ \csr_i.pc[19]\ \csr_i.pc[14]\ VPWR
+ VGND
+ sg13g2_nor4_1
X_19629_ _12986_ \csr_i.pc[18]\ \csr_i.pc[17]\ \csr_i.pc[16]\ \csr_i.pc[15]\ VPWR
+ VGND
+ sg13g2_nor4_1
X_19630_ _12987_ _12982_ _12984_ _12985_ _12986_ VPWR
+ VGND
+ sg13g2_nand4_1
X_19631_ _12988_ \rd_alu[10]\ \rd_alu[7]\ \rd_alu[6]\ \rd_alu[8]\ VPWR
+ VGND
+ sg13g2_nor4_1
X_19632_ _12989_ \rd_alu[21]\ \rd_alu[19]\ \rd_alu[13]\ \rd_alu[9]\ VPWR
+ VGND
+ sg13g2_nor4_1
X_19633_ _12990_ \rd_alu[20]\ \rd_alu[18]\ \rd_alu[17]\ \rd_alu[11]\ VPWR
+ VGND
+ sg13g2_nor4_1
X_19634_ _12991_ \rd_alu[16]\ \rd_alu[15]\ \rd_alu[14]\ \rd_alu[12]\ VPWR
+ VGND
+ sg13g2_nor4_1
X_19635_ _12992_ _12988_ _12989_ _12990_ _12991_ VPWR
+ VGND
+ sg13g2_nand4_1
X_19636_ _12993_ _12987_ _12992_ _12955_ VPWR VGND sg13g2_mux2_1
X_19637_ _12994_ \csr_i.pc[5]\ \csr_i.pc[4]\ _12955_ VPWR VGND sg13g2_nor3_1
X_19638_ _12995_ \rd_alu[5]\ \rd_alu[4]\ _12975_ VPWR VGND sg13g2_nor3_1
X_19639_ _12996_ \csr_i.pc[3]\ _12975_ VPWR VGND sg13g2_and2_1
X_19640_ _12997_ \rd_alu[3]\ _12955_ _12996_ VPWR VGND sg13g2_a21oi_1
X_19641_ _12998_ _12994_ _12995_ _12997_ VPWR VGND sg13g2_o21ai_1
X_19642_ _12999_ \rd_alu[22]\ _12976_ _12993_ _12998_ VPWR
+ VGND
+ sg13g2_nor4_1
X_19643_ _13000_ _12978_ _12999_ VPWR VGND sg13g2_nand2b_1
X_19644_ _13001_ \rd_alu[0]\ _12955_ VPWR VGND sg13g2_and2_1
X_19645_ _13002_ \csr_i.pc[0]\ _12975_ _13001_ VPWR VGND sg13g2_a21oi_1
X_19646_ _13003_ _13002_ VPWR VGND sg13g2_buf_1
X_19647_ _13004_ \csr_i.pc[1]\ VPWR VGND sg13g2_inv_1
X_19648_ _13005_ _13004_ _12955_ VPWR VGND sg13g2_nor2_1
X_19649_ _13006_ \rd_alu[1]\ _12955_ _13005_ VPWR VGND sg13g2_a21oi_1
X_19650_ _13007_ _13003_ _13006_ VPWR VGND sg13g2_nand2_1
X_19651_ _13008_ _12981_ _13000_ _13007_ VPWR VGND sg13g2_or3_1
X_19652_ _13009_ _12980_ _13008_ VPWR VGND sg13g2_nor2b_1
X_19653_ _13010_ \alu_i.instruction[3]\ \alu_i.instruction[1]\ \alu_i.instruction[0]\ VPWR VGND sg13g2_nand3b_1
X_19654_ _13011_ _13010_ VPWR VGND sg13g2_buf_2
X_19655_ _13012_ \alu_i.instruction[4]\ \alu_i.instruction[2]\ _13011_ VPWR VGND sg13g2_nor3_1
X_19656_ _13013_ \alu_i.instruction[5]\ _13012_ VPWR VGND sg13g2_and2_1
X_19657_ _13014_ _13013_ VPWR VGND sg13g2_buf_1
X_19658_ _13015_ \alu_i.instruction[6]\ _13014_ VPWR VGND sg13g2_nor2b_1
X_19659_ _13016_ _12956_ _13015_ VPWR VGND sg13g2_and2_1
X_19660_ _13017_ _13016_ VPWR VGND sg13g2_buf_1
X_19661_ _13018_ \memory_i.state[0]\ _12959_ VPWR VGND sg13g2_nand2_1
X_19662_ _13019_ _13018_ VPWR VGND sg13g2_buf_1
X_19663_ _13020_ _13019_ VPWR VGND sg13g2_buf_1
X_19664_ _13021_ _13009_ _13017_ _13020_ VPWR VGND sg13g2_nor3_1
X_19665_ _00033_ \memory_i.state[2]\ _12970_ _13021_ VPWR VGND sg13g2_a21o_1
X_19666_ _13022_ _12980_ VPWR VGND sg13g2_buf_1
X_19667_ _13023_ _13022_ VPWR VGND sg13g2_buf_1
X_19668_ _13024_ _13020_ VPWR VGND sg13g2_buf_1
X_19669_ _13025_ _12975_ VPWR VGND sg13g2_buf_1
X_19670_ _13026_ \csr_i.pc[2]\ _13025_ VPWR VGND sg13g2_nand2_1
X_19671_ _13027_ _12981_ _13025_ _13026_ VPWR VGND sg13g2_o21ai_1
X_19672_ _13028_ _13007_ _13027_ VPWR VGND sg13g2_nand2_1
X_19673_ _13029_ _12999_ _13028_ VPWR VGND sg13g2_and2_1
X_19674_ _13030_ \csr_i.pc[5]\ \csr_i.pc[4]\ \csr_i.pc[3]\ VPWR VGND sg13g2_nand3_1
X_19675_ _13031_ _13030_ VPWR VGND sg13g2_buf_1
X_19676_ _13032_ \rd_alu[22]\ \rd_alu[2]\ _12978_ _13007_ VPWR
+ VGND
+ sg13g2_nor4_1
X_19677_ _13033_ _13031_ _13032_ VPWR VGND sg13g2_nor2_1
X_19678_ _13034_ \csr_i.pc[22]\ _13031_ _13033_ VPWR VGND sg13g2_a21oi_1
X_19679_ _13035_ \rd_alu[22]\ VPWR VGND sg13g2_inv_1
X_19680_ _13036_ \rd_alu[5]\ \rd_alu[4]\ \rd_alu[3]\ VPWR VGND sg13g2_nand3_1
X_19681_ _13037_ _13035_ _13036_ _13032_ VPWR VGND sg13g2_a21oi_1
X_19682_ _13038_ _12956_ _13037_ _12993_ VPWR VGND sg13g2_a21oi_1
X_19683_ _13039_ _12956_ _13034_ _13038_ VPWR VGND sg13g2_o21ai_1
X_19684_ _13040_ _12971_ _13039_ VPWR VGND sg13g2_and2_1
X_19685_ _13041_ _12976_ _12978_ _13029_ _13040_ VPWR
+ VGND
+ sg13g2_nor4_1
X_19686_ _13042_ _13000_ _12981_ VPWR VGND sg13g2_nand2b_1
X_19687_ _13043_ _13042_ VPWR VGND sg13g2_buf_1
X_19688_ _13044_ _13003_ _13006_ _13043_ VPWR VGND sg13g2_nor3_1
X_19689_ _13045_ _13041_ _13044_ VPWR VGND sg13g2_nor2_1
X_19690_ _00032_ _13023_ _13024_ _13045_ VPWR VGND sg13g2_nor3_1
X_19691_ _13046_ \memory_i.sram_master.write_reg\ VPWR VGND sg13g2_inv_1
X_19692_ _13047_ \memory_i.sram_master.index[2]\ \memory_i.sram_master.index[1]\ \memory_i.sram_master.index[0]\ VPWR VGND sg13g2_nor3_1
X_19693_ _13048_ _13047_ VPWR VGND sg13g2_buf_1
X_19694_ _13049_ \memory_i.sram_master.index[3]\ _13048_ VPWR VGND sg13g2_nor2b_1
X_19695_ _13050_ _13049_ VPWR VGND sg13g2_buf_1
X_19696_ _13051_ \memory_i.sram_master.index[4]\ _13050_ VPWR VGND sg13g2_nand2b_1
X_19697_ _13052_ _13051_ VPWR VGND sg13g2_buf_1
X_19698_ _13053_ \memory_i.sram_master.index[6]\ \memory_i.sram_master.index[5]\ _13052_ VPWR VGND sg13g2_nor3_1
X_19699_ _13054_ \memory_i.sram_master.index[7]\ _13053_ VPWR VGND sg13g2_nor2b_1
X_19700_ _13055_ _13054_ VPWR VGND sg13g2_buf_1
X_19701_ _13056_ _13046_ \memory_i.sram_master.posedge_trigger\ \memory_i.sram_master.state[2]\ _13055_ VPWR
+ VGND
+ sg13g2_nand4_1
X_19702_ _13057_ \memory_i.sram_master.posedge_trigger\ VPWR VGND sg13g2_inv_1
X_19703_ _13058_ _13057_ \memory_i.sram_master.state[6]\ VPWR VGND sg13g2_nand2_1
X_19704_ _13059_ reset \memory_i.target[0]\ _12952_ VPWR VGND sg13g2_nand3_1
X_19705_ _13060_ _13059_ VPWR VGND sg13g2_buf_1
X_19706_ _00030_ _13056_ _13058_ _13060_ VPWR VGND sg13g2_a21oi_1
X_19707_ _13061_ \memory_i.sram_master.write_reg\ \memory_i.sram_master.posedge_trigger\ \memory_i.sram_master.state[2]\ _13055_ VPWR
+ VGND
+ sg13g2_nand4_1
X_19708_ _13062_ \alu_i.funct3[1]\ _13025_ VPWR VGND sg13g2_nor2_1
X_19709_ _13063_ \alu_i.funct3[0]\ \memory_i.sram_master.index[3]\ VPWR VGND sg13g2_xor2_1
X_19710_ _13064_ \memory_i.sram_master.index[4]\ _13062_ _13063_ VPWR VGND sg13g2_nand3_1
X_19711_ _13065_ \memory_i.sram_master.index[4]\ \memory_i.sram_master.index[3]\ _13062_ VPWR VGND sg13g2_or3_1
X_19712_ _13066_ \memory_i.sram_master.index[5]\ VPWR VGND sg13g2_inv_1
X_19713_ _13067_ \memory_i.sram_master.index[7]\ \memory_i.sram_master.index[6]\ VPWR VGND sg13g2_nor2_1
X_19714_ _13068_ _13066_ \memory_i.sram_master.posedge_trigger\ _13048_ _13067_ VPWR
+ VGND
+ sg13g2_nand4_1
X_19715_ _13069_ _13064_ _13065_ _13068_ VPWR VGND sg13g2_a21oi_1
X_19716_ _13070_ _13069_ VPWR VGND sg13g2_inv_1
X_19717_ _13071_ \memory_i.sram_master.state[5]\ _13070_ VPWR VGND sg13g2_nand2_1
X_19718_ _00029_ _13061_ _13071_ _13060_ VPWR VGND sg13g2_a21oi_1
X_19719_ _13072_ \memory_i.sram_master.index[5]\ _13052_ VPWR VGND sg13g2_nor2_1
X_19720_ _13073_ _13072_ _13067_ VPWR VGND sg13g2_nand2_1
X_19721_ _13074_ \memory_i.sram_master.negedge_trigger\ \memory_i.sram_master.state[0]\ \memory_i.sram_master.state[4]\ VPWR VGND sg13g2_a21o_1
X_19722_ _13075_ \memory_i.sram_master.state[4]\ _13073_ _13074_ _13057_ VPWR
+ VGND
+ sg13g2_a22oi_1
X_19723_ _00028_ _13060_ _13075_ VPWR VGND sg13g2_nor2_1
X_19724_ _13076_ \memory_i.sram_master.state[5]\ \memory_i.sram_master.state[1]\ VPWR VGND sg13g2_nor2_1
X_19725_ _13077_ _13076_ _13069_ VPWR VGND sg13g2_nand2b_1
X_19726_ _00027_ _12962_ _13077_ _13060_ VPWR VGND sg13g2_a21oi_1
X_19727_ _13078_ \memory_i.sram_master.posedge_trigger\ \memory_i.sram_master.state[4]\ _13055_ VPWR VGND sg13g2_nand3_1
X_19728_ _13079_ _13057_ _13073_ \memory_i.sram_master.state[2]\ VPWR VGND sg13g2_o21ai_1
X_19729_ _00026_ _13078_ _13079_ _13060_ VPWR VGND sg13g2_a21oi_1
X_19730_ _13080_ \memory_i.sram_master.posedge_trigger\ \memory_i.sram_master.state[6]\ \memory_i.sram_master.state[1]\ _13070_ VPWR
+ VGND
+ sg13g2_a22oi_1
X_19731_ _00025_ _13060_ _13080_ VPWR VGND sg13g2_nor2_1
X_19732_ _13081_ \memory_i.sram_master.posedge_trigger\ \memory_i.sram_master.negedge_trigger\ VPWR VGND sg13g2_nor2b_1
X_19733_ _13082_ _13081_ VPWR VGND sg13g2_buf_1
X_19734_ _13083_ _13082_ \memory_i.sram_master.state[0]\ VPWR VGND sg13g2_nand2b_1
X_19735_ _00024_ _13060_ _13083_ VPWR VGND sg13g2_nand2b_1
X_19736_ _13084_ reset \memory_i.target[3]\ _12952_ VPWR VGND sg13g2_nand3_1
X_19737_ _13085_ _13084_ VPWR VGND sg13g2_buf_1
X_19738_ _13086_ _13085_ VPWR VGND sg13g2_buf_1
X_19739_ _13087_ \memory_i.i2c_master.scl_ratio[3]\ \memory_i.i2c_master.scl_counter[2]\ VPWR VGND sg13g2_xor2_1
X_19740_ _13088_ \memory_i.i2c_master.scl_ratio[13]\ \memory_i.i2c_master.scl_counter[12]\ VPWR VGND sg13g2_xor2_1
X_19741_ _13089_ \memory_i.i2c_master.scl_ratio[10]\ \memory_i.i2c_master.scl_counter[9]\ VPWR VGND sg13g2_xor2_1
X_19742_ _13090_ \memory_i.i2c_master.scl_ratio[8]\ \memory_i.i2c_master.scl_counter[7]\ VPWR VGND sg13g2_xor2_1
X_19743_ _13091_ _13087_ _13088_ _13089_ _13090_ VPWR
+ VGND
+ sg13g2_nor4_1
X_19744_ _13092_ \memory_i.i2c_master.scl_ratio[5]\ \memory_i.i2c_master.scl_counter[4]\ VPWR VGND sg13g2_xor2_1
X_19745_ _13093_ \memory_i.i2c_master.scl_ratio[2]\ \memory_i.i2c_master.scl_counter[1]\ VPWR VGND sg13g2_xor2_1
X_19746_ _13094_ \memory_i.i2c_master.scl_ratio[6]\ \memory_i.i2c_master.scl_counter[5]\ VPWR VGND sg13g2_xor2_1
X_19747_ _13095_ \memory_i.i2c_master.scl_ratio[15]\ \memory_i.i2c_master.scl_counter[14]\ VPWR VGND sg13g2_xor2_1
X_19748_ _13096_ _13092_ _13093_ _13094_ _13095_ VPWR
+ VGND
+ sg13g2_nor4_1
X_19749_ _13097_ \memory_i.i2c_master.scl_ratio[1]\ \memory_i.i2c_master.scl_counter[0]\ VPWR VGND sg13g2_xor2_1
X_19750_ _13098_ \memory_i.i2c_master.scl_ratio[11]\ \memory_i.i2c_master.scl_counter[10]\ VPWR VGND sg13g2_xor2_1
X_19751_ _13099_ \memory_i.i2c_master.scl_ratio[4]\ \memory_i.i2c_master.scl_counter[3]\ VPWR VGND sg13g2_xor2_1
X_19752_ _13100_ \memory_i.i2c_master.scl_ratio[12]\ \memory_i.i2c_master.scl_counter[11]\ VPWR VGND sg13g2_xor2_1
X_19753_ _13101_ _13097_ _13098_ _13099_ _13100_ VPWR
+ VGND
+ sg13g2_nor4_1
X_19754_ _13102_ \memory_i.i2c_master.scl_ratio[14]\ \memory_i.i2c_master.scl_counter[13]\ VPWR VGND sg13g2_xor2_1
X_19755_ _13103_ \memory_i.i2c_master.scl_ratio[7]\ \memory_i.i2c_master.scl_counter[6]\ VPWR VGND sg13g2_xor2_1
X_19756_ _13104_ \memory_i.i2c_master.scl_ratio[9]\ \memory_i.i2c_master.scl_counter[8]\ VPWR VGND sg13g2_xor2_1
X_19757_ _13105_ \memory_i.i2c_master.scl_counter[15]\ _13102_ _13103_ _13104_ VPWR
+ VGND
+ sg13g2_nor4_1
X_19758_ _13106_ _13091_ _13096_ _13101_ _13105_ VPWR
+ VGND
+ sg13g2_nand4_1
X_19759_ _13107_ _13106_ VPWR VGND sg13g2_buf_1
X_19760_ _13108_ \memory_i.i2c_master.state[3]\ \memory_i.i2c_master.state[10]\ VPWR VGND sg13g2_nor2_1
X_19761_ _13109_ \memory_i.i2c_master.state[8]\ _13108_ VPWR VGND sg13g2_nand2b_1
X_19762_ _13110_ \memory_i.i2c_master.state[1]\ \memory_i.i2c_master.state[5]\ VPWR VGND sg13g2_or2_1
X_19763_ _13111_ _13110_ VPWR VGND sg13g2_buf_1
X_19764_ _13112_ \memory_i.i2c_master.state[6]\ \memory_i.i2c_master.state[9]\ VPWR VGND sg13g2_or2_1
X_19765_ _13113_ \memory_i.i2c_master.state[2]\ _13109_ _13111_ _13112_ VPWR
+ VGND
+ sg13g2_nor4_1
X_19766_ _13114_ scl _13107_ _13113_ VPWR VGND sg13g2_nor3_1
X_19767_ _13115_ _13114_ VPWR VGND sg13g2_buf_1
X_19768_ _13116_ _13115_ VPWR VGND sg13g2_buf_1
X_19769_ _13117_ \memory_i.i2c_master.frame_index[0]\ VPWR VGND sg13g2_inv_1
X_19770_ _13118_ \memory_i.i2c_master.frame_index[1]\ \memory_i.i2c_mask[2]\ \memory_i.i2c_mask[0]\ VPWR VGND sg13g2_a21oi_1
X_19771_ _13119_ \memory_i.i2c_mask[1]\ \memory_i.i2c_mask[0]\ \memory_i.i2c_master.frame_index[1]\ VPWR VGND sg13g2_o21ai_1
X_19772_ _13120_ _13117_ _13118_ _13119_ VPWR VGND sg13g2_o21ai_1
X_19773_ _13121_ \memory_i.i2c_master.write\ \memory_i.i2c_master.state[2]\ _13120_ \memory_i.i2c_master.state[1]\ VPWR
+ VGND
+ sg13g2_a22oi_1
X_19774_ _13122_ _13121_ VPWR VGND sg13g2_inv_1
X_19775_ _13123_ \memory_i.i2c_master.index[1]\ \memory_i.i2c_master.index[0]\ VPWR VGND sg13g2_or2_1
X_19776_ _13124_ _13123_ VPWR VGND sg13g2_buf_1
X_19777_ _13125_ \memory_i.i2c_master.index[2]\ _13124_ VPWR VGND sg13g2_nor2_1
X_19778_ _13126_ _13125_ VPWR VGND sg13g2_buf_1
X_19779_ _13127_ _13116_ _13126_ VPWR VGND sg13g2_nand2_1
X_19780_ _13128_ _13116_ _13122_ _13127_ \memory_i.i2c_master.state[10]\ VPWR
+ VGND
+ sg13g2_a22oi_1
X_19781_ _00014_ _13086_ _13128_ VPWR VGND sg13g2_nor2_1
X_19782_ _13129_ \memory_i.i2c_master.state[3]\ _13116_ _13126_ VPWR VGND sg13g2_nand3_1
X_19783_ _13130_ _13115_ VPWR VGND sg13g2_inv_1
X_19784_ _13131_ \memory_i.i2c_master.state[9]\ _13130_ VPWR VGND sg13g2_nand2_1
X_19785_ _00023_ _13129_ _13131_ _13086_ VPWR VGND sg13g2_a21oi_1
X_19786_ _13132_ \memory_i.i2c_master.write\ VPWR VGND sg13g2_inv_1
X_19787_ _13133_ _13132_ \memory_i.i2c_master.state[2]\ \memory_i.i2c_master.state[5]\ _13120_ VPWR
+ VGND
+ sg13g2_a22oi_1
X_19788_ _13134_ _13133_ VPWR VGND sg13g2_inv_1
X_19789_ _13135_ \memory_i.i2c_master.state[8]\ _13127_ _13134_ _13116_ VPWR
+ VGND
+ sg13g2_a22oi_1
X_19790_ _00022_ _13086_ _13135_ VPWR VGND sg13g2_nor2_1
X_19791_ _13136_ _13120_ _13111_ VPWR VGND sg13g2_nand2b_1
X_19792_ _13137_ _13107_ _13136_ VPWR VGND sg13g2_nor2_1
X_19793_ _13138_ \memory_i.i2c_master.state[7]\ _13137_ VPWR VGND sg13g2_nor2_1
X_19794_ _13139_ scl VPWR VGND sg13g2_inv_1
X_19795_ _13140_ _13139_ _13107_ VPWR VGND sg13g2_nor2_1
X_19796_ _13141_ _13140_ VPWR VGND sg13g2_buf_1
X_19797_ _00021_ _13085_ _13138_ _13141_ VPWR VGND sg13g2_nor3_1
X_19798_ _13142_ \memory_i.i2c_master.state[6]\ _13130_ _13141_ \memory_i.i2c_master.state[0]\ VPWR
+ VGND
+ sg13g2_a22oi_1
X_19799_ _00020_ _13086_ _13142_ VPWR VGND sg13g2_nor2_1
X_19800_ _13143_ \memory_i.i2c_master.state[5]\ _13130_ VPWR VGND sg13g2_nand2_1
X_19801_ _13144_ \memory_i.i2c_master.state[8]\ _13116_ _13126_ VPWR VGND sg13g2_nand3_1
X_19802_ _00019_ _13143_ _13144_ _13086_ VPWR VGND sg13g2_a21oi_1
X_19803_ _13145_ \memory_i.i2c_master.state[7]\ _13141_ \memory_i.i2c_master.state[4]\ VPWR VGND sg13g2_a21oi_1
X_19804_ _00018_ _13086_ _13145_ VPWR VGND sg13g2_nor2_1
X_19805_ _13146_ \memory_i.i2c_master.state[6]\ _13116_ _13127_ \memory_i.i2c_master.state[3]\ VPWR
+ VGND
+ sg13g2_a22oi_1
X_19806_ _00017_ _13086_ _13146_ VPWR VGND sg13g2_nor2_1
X_19807_ _13147_ \memory_i.i2c_master.state[9]\ _13116_ VPWR VGND sg13g2_nand2_1
X_19808_ _13148_ \memory_i.i2c_master.state[2]\ _13130_ VPWR VGND sg13g2_nand2_1
X_19809_ _00016_ _13147_ _13148_ _13086_ VPWR VGND sg13g2_a21oi_1
X_19810_ _13149_ \memory_i.i2c_master.state[1]\ _13130_ VPWR VGND sg13g2_nand2_1
X_19811_ _13150_ \memory_i.i2c_master.state[10]\ _13116_ _13126_ VPWR VGND sg13g2_nand3_1
X_19812_ _00015_ _13149_ _13150_ _13086_ VPWR VGND sg13g2_a21oi_1
X_19813_ _13151_ _13139_ _13107_ \memory_i.i2c_master.state[0]\ VPWR VGND sg13g2_o21ai_1
X_19814_ _00013_ _13085_ _13151_ VPWR VGND sg13g2_nand2b_1
X_19815_ _13152_ \memory_i.freq_inst.transmit_state[3]\ \memory_i.freq_inst.transmit_state[1]\ VPWR VGND sg13g2_nor2_1
X_19816_ _13153_ \memory_i.freq_inst.transmit_counter[2]\ \memory_i.freq_inst.transmit_counter[1]\ \memory_i.freq_inst.transmit_counter[0]\ VPWR VGND sg13g2_nor3_1
X_19817_ _13154_ \memory_i.freq_inst.transmit_counter[3]\ _13153_ VPWR VGND sg13g2_nand2b_1
X_19818_ _13155_ _13154_ VPWR VGND sg13g2_buf_1
X_19819_ _13156_ \memory_i.freq_inst.transmit_counter[5]\ \memory_i.freq_inst.transmit_counter[4]\ _13155_ VPWR VGND sg13g2_nor3_1
X_19820_ _13157_ _13156_ VPWR VGND sg13g2_inv_1
X_19821_ _13158_ \memory_i.freq_inst.transmit_counter[7]\ \memory_i.freq_inst.transmit_counter[6]\ _13157_ VPWR VGND sg13g2_nor3_1
X_19822_ _13159_ _13152_ _13158_ VPWR VGND sg13g2_nor2_1
X_19823_ _13160_ \memory_i.freq_inst.transmit_state[1]\ _13159_ VPWR VGND sg13g2_nor2_1
X_19824_ _13161_ \memory_i.freq_inst.transmit_counter[7]\ \memory_i.freq_inst.transmit_counter[6]\ \memory_i.freq_inst.transmit_counter[5]\ VPWR VGND sg13g2_nor3_1
X_19825_ _13162_ \memory_i.freq_inst.transmit_state[3]\ _13161_ \memory_i.freq_inst.reset_n\ VPWR VGND sg13g2_o21ai_1
X_19826_ _00012_ _13160_ _13162_ VPWR VGND sg13g2_nor2_1
X_19827_ _13163_ \memory_i.freq_inst.cordic.shift_value[0]\ VPWR VGND sg13g2_inv_1
X_19828_ _13164_ _13163_ VPWR VGND sg13g2_buf_4
X_19829_ _13165_ _13164_ VPWR VGND sg13g2_buf_4
X_19830_ _13166_ _13165_ VPWR VGND sg13g2_buf_2
X_19831_ _13167_ _13166_ VPWR VGND sg13g2_buf_2
X_19832_ _13168_ _13167_ VPWR VGND sg13g2_buf_2
X_19833_ _13169_ \memory_i.freq_inst.cordic.shift_value[4]\ \memory_i.freq_inst.cordic.shift_value[3]\ VPWR VGND sg13g2_nand2_1
X_19834_ _13170_ _13169_ VPWR VGND sg13g2_buf_1
X_19835_ _13171_ _13170_ VPWR VGND sg13g2_inv_1
X_19836_ _13172_ \memory_i.freq_inst.cordic.shift_value[2]\ \memory_i.freq_inst.cordic.shift_value[1]\ VPWR VGND sg13g2_nand2_1
X_19837_ _13173_ _13172_ VPWR VGND sg13g2_inv_1
X_19838_ _13174_ _13168_ _13171_ _13173_ VPWR VGND sg13g2_nand3_1
X_19839_ _13175_ _13174_ VPWR VGND sg13g2_buf_1
X_19840_ _13176_ \memory_i.freq_inst.transmit_state[2]\ _13175_ VPWR VGND sg13g2_nand2_1
X_19841_ _13177_ _13176_ VPWR VGND sg13g2_buf_1
X_19842_ _13178_ \memory_i.freq_inst.start\ \memory_i.freq_inst.transmit_state[0]\ VPWR VGND sg13g2_nand2_1
X_19843_ _13179_ \memory_i.freq_inst.reset_n\ VPWR VGND sg13g2_inv_1
X_19844_ _13180_ _13179_ VPWR VGND sg13g2_buf_1
X_19845_ _00011_ _13177_ _13178_ _13180_ VPWR VGND sg13g2_a21oi_1
X_19846_ _13181_ _13171_ _13173_ VPWR VGND sg13g2_nand2_1
X_19847_ _13182_ \memory_i.freq_inst.cordic.shift_value[0]\ _13181_ VPWR VGND sg13g2_nor2_1
X_19848_ _13183_ _13182_ VPWR VGND sg13g2_buf_1
X_19849_ _13184_ _13183_ VPWR VGND sg13g2_buf_1
X_19850_ _13185_ _13161_ \memory_i.freq_inst.transmit_state[1]\ VPWR VGND sg13g2_nor2b_1
X_19851_ _13186_ \memory_i.freq_inst.transmit_state[3]\ _13158_ _13184_ \memory_i.freq_inst.transmit_state[2]\ _13185_
+ VPWR
+ VGND sg13g2_a221oi_1
X_19852_ _00010_ _13180_ _13186_ VPWR VGND sg13g2_nor2_1
X_19853_ _13187_ \memory_i.freq_inst.transmit_state[0]\ VPWR VGND sg13g2_inv_1
X_19854_ _00009_ \memory_i.freq_inst.start\ _13187_ \memory_i.freq_inst.reset_n\ VPWR VGND sg13g2_o21ai_1
X_19855_ _13188_ \control_i.state_q[2]\ VPWR VGND sg13g2_inv_1
X_19856_ _13189_ \alu_i.instruction[6]\ _13012_ VPWR VGND sg13g2_nor2b_1
X_19857_ _13190_ _13189_ VPWR VGND sg13g2_buf_1
X_19858_ _13191_ _13190_ VPWR VGND sg13g2_buf_1
X_19859_ _13192_ _13191_ VPWR VGND sg13g2_buf_1
X_19860_ _13193_ \alu_i.funct7[6]\ \alu_i.funct7[1]\ \alu_i.funct7[0]\ VPWR VGND sg13g2_nor3_1
X_19861_ _13194_ \alu_i.funct7[5]\ \alu_i.funct7[2]\ VPWR VGND sg13g2_nor2_1
X_19862_ _13195_ \alu_i.funct7[4]\ \alu_i.funct7[3]\ VPWR VGND sg13g2_nor2_1
X_19863_ _13196_ _13193_ _13194_ _13195_ VPWR VGND sg13g2_nand3_1
X_19864_ _13197_ \alu_i.instruction[4]\ VPWR VGND sg13g2_inv_1
X_19865_ _13198_ _13197_ \alu_i.instruction[2]\ _13011_ VPWR VGND sg13g2_nor3_1
X_19866_ _13199_ \alu_i.instruction[6]\ _13198_ VPWR VGND sg13g2_nand2b_1
X_19867_ _13200_ \alu_i.instruction[5]\ _13196_ _13199_ VPWR VGND sg13g2_a21oi_1
X_19868_ _13201_ _13200_ VPWR VGND sg13g2_buf_1
X_19869_ _13202_ _13201_ VPWR VGND sg13g2_inv_1
X_19870_ _13203_ \alu_i.funct3[1]\ VPWR VGND sg13g2_inv_1
X_19871_ _13204_ \alu_i.funct3[2]\ _13203_ VPWR VGND sg13g2_nor2_1
X_19872_ _13205_ _13203_ \alu_i.funct3[0]\ VPWR VGND sg13g2_nand2_1
X_19873_ _13206_ \alu_i.instruction[6]\ \alu_i.instruction[5]\ VPWR VGND sg13g2_nand2_1
X_19874_ _13207_ _13206_ VPWR VGND sg13g2_buf_2
X_19875_ _13208_ \alu_i.instruction[4]\ \alu_i.instruction[2]\ _13011_ _13207_ VPWR
+ VGND
+ sg13g2_nor4_1
X_19876_ _13209_ _13208_ VPWR VGND sg13g2_buf_1
X_19877_ _13210_ _13205_ _13201_ _13209_ VPWR VGND sg13g2_a21oi_1
X_19878_ _13211_ _13202_ _13204_ _13210_ VPWR VGND sg13g2_a21oi_1
X_19879_ _13212_ \alu_i.funct3[0]\ VPWR VGND sg13g2_inv_1
X_19880_ _13213_ \alu_i.funct3[1]\ _13212_ VPWR VGND sg13g2_nor2_1
X_19881_ _13214_ _13199_ _13196_ VPWR VGND sg13g2_nor2_1
X_19882_ _13215_ \alu_i.funct3[2]\ _13213_ _13214_ VPWR VGND sg13g2_nand3_1
X_19883_ _13216_ _13215_ VPWR VGND sg13g2_buf_1
X_19884_ _13217_ \alu_i.funct7[2]\ _13195_ \alu_i.funct7[5]\ VPWR VGND sg13g2_nand3b_1
X_19885_ _13218_ _13199_ _13217_ VPWR VGND sg13g2_nor2_1
X_19886_ _13219_ \alu_i.funct3[2]\ _13213_ _13193_ _13218_ VPWR
+ VGND
+ sg13g2_nand4_1
X_19887_ _13220_ _13219_ VPWR VGND sg13g2_buf_1
X_19888_ _13221_ _13216_ _13220_ VPWR VGND sg13g2_nand2_1
X_19889_ _13222_ _13207_ _13198_ VPWR VGND sg13g2_nor2b_1
X_19890_ _13223_ _13212_ _13204_ _13222_ VPWR VGND sg13g2_nand3_1
X_19891_ _13224_ _13223_ VPWR VGND sg13g2_buf_1
X_19892_ _13225_ \alu_i.instruction[1]\ \alu_i.instruction[0]\ VPWR VGND sg13g2_nand2_1
X_19893_ _13226_ \alu_i.instruction[4]\ \alu_i.instruction[2]\ VPWR VGND sg13g2_nand2b_1
X_19894_ _13227_ _13207_ _13226_ VPWR VGND sg13g2_or2_1
X_19895_ _13228_ _13227_ VPWR VGND sg13g2_buf_2
X_19896_ _13229_ _13225_ _13228_ VPWR VGND sg13g2_nor2_1
X_19897_ _13230_ _13229_ VPWR VGND sg13g2_buf_1
X_19898_ _13231_ \alu_i.instruction[4]\ \alu_i.instruction[2]\ VPWR VGND sg13g2_nand2_1
X_19899_ _13232_ \alu_i.instruction[6]\ _13011_ _13231_ VPWR VGND sg13g2_nor3_1
X_19900_ _13233_ _13232_ VPWR VGND sg13g2_buf_1
X_19901_ _13234_ \alu_i.funct3[2]\ _13205_ VPWR VGND sg13g2_nor2_1
X_19902_ _13235_ _13234_ VPWR VGND sg13g2_inv_1
X_19903_ _13236_ _13193_ VPWR VGND sg13g2_inv_1
X_19904_ _13237_ \alu_i.funct3[2]\ \alu_i.funct3[0]\ VPWR VGND sg13g2_or2_1
X_19905_ _13238_ \alu_i.funct3[1]\ _13236_ _13237_ VPWR VGND sg13g2_nor3_1
X_19906_ _13239_ \alu_i.funct7[4]\ \alu_i.funct7[3]\ _13194_ _13238_ VPWR
+ VGND
+ sg13g2_nand4_1
X_19907_ _13240_ _13207_ _13198_ VPWR VGND sg13g2_nand2b_1
X_19908_ _13241_ _13235_ _13239_ _13240_ VPWR VGND sg13g2_a21oi_1
X_19909_ _13242_ _13189_ _13230_ _13233_ _13241_ VPWR
+ VGND
+ sg13g2_nor4_1
X_19910_ _13243_ \alu_i.instruction[5]\ _13218_ _13238_ VPWR VGND sg13g2_nand3_1
X_19911_ _13244_ _13243_ VPWR VGND sg13g2_buf_1
X_19912_ _13245_ _13214_ _13234_ VPWR VGND sg13g2_nand2_1
X_19913_ _13246_ _13245_ VPWR VGND sg13g2_buf_1
X_19914_ _13247_ _13224_ _13242_ _13244_ _13246_ VPWR
+ VGND
+ sg13g2_nand4_1
X_19915_ _13248_ _13211_ _13221_ _13247_ VPWR VGND sg13g2_nor3_1
X_19916_ _13249_ _13188_ _13192_ _13248_ VPWR VGND sg13g2_nor3_1
X_19917_ _13250_ \control_i.state_q[4]\ _12953_ _13249_ VPWR VGND sg13g2_a21oi_1
X_19918_ _00008_ _00002_ _13250_ VPWR VGND sg13g2_nor2_1
X_19919_ _13251_ \control_i.load_access_fault\ \control_i.state_q[6]\ VPWR VGND sg13g2_nor2b_1
X_19920_ _13252_ \control_i.state_q[2]\ _13192_ _13251_ _12953_ VPWR
+ VGND
+ sg13g2_a22oi_1
X_19921_ _00007_ _00002_ _13252_ VPWR VGND sg13g2_nor2_1
X_19922_ _13253_ \control_i.pcflag\ VPWR VGND sg13g2_inv_1
X_19923_ _13254_ _13253_ VPWR VGND sg13g2_buf_1
X_19924_ _13255_ _13254_ VPWR VGND sg13g2_buf_1
X_19925_ _13256_ \csr_i.mie[16]\ \csr_i.mstatus[3]\ \csr_i.mip[16]\ VPWR VGND sg13g2_nand3_1
X_19926_ _13257_ _13256_ VPWR VGND sg13g2_buf_1
X_19927_ _13258_ \csr_i.mie[11]\ \csr_i.mip[11]\ \csr_i.mip[7]\ \csr_i.mie[7]\ VPWR
+ VGND
+ sg13g2_a22oi_1
X_19928_ _13259_ _13258_ \csr_i.mstatus[3]\ VPWR VGND sg13g2_nor2b_1
X_19929_ _13260_ _13259_ VPWR VGND sg13g2_inv_1
X_19930_ _13261_ _13257_ _13260_ VPWR VGND sg13g2_nand2_1
X_19931_ _13262_ _13255_ _13261_ VPWR VGND sg13g2_nor2_1
X_19932_ _13263_ \csr_i.pc[1]\ \csr_i.pc[0]\ \control_i.load_access_fault\ VPWR VGND sg13g2_nor3_1
X_19933_ _13264_ \control_i.state_q[5]\ _12953_ _13263_ VPWR VGND sg13g2_and3_1
X_19934_ _13265_ \control_i.jump_to_isr\ \control_i.state_q[0]\ _13262_ _13264_ VPWR
+ VGND
+ sg13g2_nor4_1
X_19935_ _00006_ _00002_ _13265_ VPWR VGND sg13g2_nor2_1
X_19936_ _13266_ _12953_ reset VPWR VGND sg13g2_nand2b_1
X_19937_ _13267_ \control_i.state_q[4]\ _13251_ VPWR VGND sg13g2_nor2_1
X_19938_ _00005_ _13266_ _13267_ VPWR VGND sg13g2_nor2_1
X_19939_ _13268_ \control_i.state_q[5]\ _13263_ \control_i.state_q[3]\ VPWR VGND sg13g2_a21oi_1
X_19940_ _00004_ _13266_ _13268_ VPWR VGND sg13g2_nor2_1
X_19941_ _13269_ \control_i.state_q[6]\ \control_i.load_access_fault\ \control_i.state_q[5]\ VPWR VGND sg13g2_a21oi_1
X_19942_ _13270_ _13263_ _13269_ VPWR VGND sg13g2_nor2_1
X_19943_ _13271_ \control_i.state_q[2]\ _13248_ _13261_ \control_i.pcflag\ _13270_
+ VPWR
+ VGND sg13g2_a221oi_1
X_19944_ _00003_ _00002_ _13271_ VPWR VGND sg13g2_nor2_1
X_19945_ _13272_ \memory_i.uart_receiver.cycle_counter[1]\ \memory_i.uart_receiver.CYCLES_PER_BIT[1]\ VPWR VGND sg13g2_xor2_1
X_19946_ _13273_ \memory_i.uart_receiver.cycle_counter[0]\ \memory_i.uart_receiver.CYCLES_PER_BIT[0]\ VPWR VGND sg13g2_xor2_1
X_19947_ _13274_ \memory_i.uart_receiver.cycle_counter[5]\ \memory_i.uart_receiver.CYCLES_PER_BIT[5]\ VPWR VGND sg13g2_xor2_1
X_19948_ _13275_ \memory_i.uart_receiver.cycle_counter[2]\ \memory_i.uart_receiver.CYCLES_PER_BIT[2]\ VPWR VGND sg13g2_xor2_1
X_19949_ _13276_ _13272_ _13273_ _13274_ _13275_ VPWR
+ VGND
+ sg13g2_nor4_1
X_19950_ _13277_ \memory_i.uart_receiver.cycle_counter[9]\ \memory_i.uart_receiver.CYCLES_PER_BIT[9]\ VPWR VGND sg13g2_xor2_1
X_19951_ _13278_ \memory_i.uart_receiver.cycle_counter[10]\ \memory_i.uart_receiver.CYCLES_PER_BIT[10]\ VPWR VGND sg13g2_xor2_1
X_19952_ _13279_ \memory_i.uart_receiver.cycle_counter[8]\ \memory_i.uart_receiver.CYCLES_PER_BIT[8]\ VPWR VGND sg13g2_xor2_1
X_19953_ _13280_ \memory_i.uart_receiver.cycle_counter[12]\ \memory_i.uart_receiver.CYCLES_PER_BIT[12]\ VPWR VGND sg13g2_xor2_1
X_19954_ _13281_ _13277_ _13278_ _13279_ _13280_ VPWR
+ VGND
+ sg13g2_nor4_1
X_19955_ _13282_ \memory_i.uart_receiver.cycle_counter[7]\ \memory_i.uart_receiver.CYCLES_PER_BIT[7]\ VPWR VGND sg13g2_xor2_1
X_19956_ _13283_ \memory_i.uart_receiver.cycle_counter[13]\ \memory_i.uart_receiver.CYCLES_PER_BIT[13]\ VPWR VGND sg13g2_xor2_1
X_19957_ _13284_ \memory_i.uart_receiver.cycle_counter[3]\ \memory_i.uart_receiver.CYCLES_PER_BIT[3]\ VPWR VGND sg13g2_xor2_1
X_19958_ _13285_ _13282_ _13283_ _13284_ VPWR VGND sg13g2_nor3_1
X_19959_ _13286_ \memory_i.uart_receiver.cycle_counter[6]\ \memory_i.uart_receiver.CYCLES_PER_BIT[6]\ VPWR VGND sg13g2_xor2_1
X_19960_ _13287_ \memory_i.uart_receiver.cycle_counter[11]\ \memory_i.uart_receiver.CYCLES_PER_BIT[11]\ VPWR VGND sg13g2_xor2_1
X_19961_ _13288_ \memory_i.uart_receiver.cycle_counter[14]\ \memory_i.uart_receiver.CYCLES_PER_BIT[14]\ VPWR VGND sg13g2_xor2_1
X_19962_ _13289_ \memory_i.uart_receiver.cycle_counter[4]\ \memory_i.uart_receiver.CYCLES_PER_BIT[4]\ VPWR VGND sg13g2_xor2_1
X_19963_ _13290_ _13286_ _13287_ _13288_ _13289_ VPWR
+ VGND
+ sg13g2_nor4_1
X_19964_ _13291_ _13276_ _13281_ _13285_ _13290_ VPWR
+ VGND
+ sg13g2_nand4_1
X_19965_ _13292_ _13291_ VPWR VGND sg13g2_buf_1
X_19966_ _13293_ \memory_i.uart_receiver.CYCLES_PER_BIT[15]\ VPWR VGND sg13g2_inv_1
X_19967_ _13294_ \memory_i.uart_receiver.fsm_state[3]\ \memory_i.uart_receiver.cycle_counter[15]\ _13293_ VPWR VGND sg13g2_nor3_1
X_19968_ _13295_ \memory_i.uart_receiver.cycle_counter[15]\ _13293_ _13294_ VPWR VGND sg13g2_a21oi_1
X_19969_ _13296_ _13292_ _13295_ VPWR VGND sg13g2_nand2b_1
X_19970_ _13297_ \memory_i.uart_receiver.bit_counter[3]\ VPWR VGND sg13g2_inv_1
X_19971_ _13298_ _13297_ \memory_i.uart_receiver.bit_counter[2]\ \memory_i.uart_receiver.bit_counter[1]\ \memory_i.uart_receiver.bit_counter[0]\ VPWR
+ VGND
+ sg13g2_nor4_1
X_19972_ _13299_ \memory_i.uart_receiver.fsm_state[3]\ _13296_ _13298_ \memory_i.uart_receiver.fsm_state[1]\ VPWR
+ VGND
+ sg13g2_a22oi_1
X_19973_ _00044_ _00002_ _13299_ VPWR VGND sg13g2_nor2_1
X_19974_ _13300_ \memory_i.uart_receiver.rxd_reg\ \memory_i.uart_receiver.fsm_state[0]\ VPWR VGND sg13g2_nor2b_1
X_19975_ _13301_ \memory_i.uart_receiver.fsm_state[2]\ _13296_ _13300_ VPWR VGND sg13g2_a21oi_1
X_19976_ _00043_ _00002_ _13301_ VPWR VGND sg13g2_nor2_1
X_19977_ _13302_ _13292_ _13295_ VPWR VGND sg13g2_nor2b_1
X_19978_ _13303_ \memory_i.uart_receiver.fsm_state[2]\ _13302_ VPWR VGND sg13g2_nand2_1
X_19979_ _13304_ _13298_ \memory_i.uart_receiver.fsm_state[1]\ VPWR VGND sg13g2_nand2b_1
X_19980_ _13305_ _12949_ VPWR VGND sg13g2_buf_1
X_19981_ _00042_ _13303_ _13304_ _13305_ VPWR VGND sg13g2_a21oi_1
X_19982_ _13306_ \memory_i.uart_receiver.fsm_state[3]\ _13302_ VPWR VGND sg13g2_nand2_1
X_19983_ _13307_ _12949_ VPWR VGND sg13g2_buf_1
X_19984_ _13308_ \memory_i.uart_receiver.rxd_reg\ \memory_i.uart_receiver.fsm_state[0]\ _13307_ VPWR VGND sg13g2_a21oi_1
X_19985_ _00041_ _13306_ _13308_ VPWR VGND sg13g2_nand2_1
X_19986_ _13309_ _12958_ \memory_i.state[0]\ VPWR VGND sg13g2_nand2b_1
X_19987_ _13310_ _13309_ VPWR VGND sg13g2_buf_1
X_19988_ _13311_ _13008_ _13310_ VPWR VGND sg13g2_nor2_1
X_19989_ _13312_ \memory_i.target[3]\ _13310_ _13311_ VPWR VGND sg13g2_a21oi_1
X_19990_ _00040_ _00002_ _13312_ VPWR VGND sg13g2_nor2_1
X_19991_ _13313_ \memory_i.target[2]\ _13310_ VPWR VGND sg13g2_nand2_1
X_19992_ _13314_ \memory_i.state[0]\ VPWR VGND sg13g2_inv_1
X_19993_ _13315_ _13017_ VPWR VGND sg13g2_inv_1
X_19994_ _13316_ _13314_ _13315_ VPWR VGND sg13g2_nor2_1
X_19995_ _13317_ \csr_i.pc[0]\ _13025_ _13001_ VPWR VGND sg13g2_a21o_1
X_19996_ _13318_ _13317_ VPWR VGND sg13g2_buf_1
X_19997_ _13319_ _13318_ _13006_ _13043_ VPWR VGND sg13g2_nor3_1
X_19998_ _13320_ _13316_ _13319_ VPWR VGND sg13g2_nand2_1
X_19999_ _00039_ _13313_ _13320_ _13305_ VPWR VGND sg13g2_a21oi_1
X_20000_ _13321_ \memory_i.target[0]\ _13310_ VPWR VGND sg13g2_nand2b_1
X_20001_ _13322_ _13023_ _13310_ _13321_ VPWR VGND sg13g2_o21ai_1
X_20002_ _00038_ reset _13322_ VPWR VGND sg13g2_nand2_1
X_20003_ _13323_ \memory_i.state[0]\ _12959_ _13009_ _13043_ VPWR
+ VGND
+ sg13g2_nand4_1
X_20004_ _13324_ _13314_ _13003_ _13315_ VPWR VGND sg13g2_nor3_1
X_20005_ _13325_ _13006_ VPWR VGND sg13g2_inv_1
X_20006_ _13326_ _13325_ _13043_ VPWR VGND sg13g2_nor2_1
X_20007_ _13327_ _12980_ _13326_ reset VPWR VGND sg13g2_nand3b_1
X_20008_ _13328_ _13327_ VPWR VGND sg13g2_inv_1
X_20009_ _13329_ _13318_ _13017_ _13019_ _13043_ VPWR
+ VGND
+ sg13g2_nor4_1
X_20010_ _13330_ \control_i.load_access_fault\ _12959_ _13324_ _13328_ _13329_
+ VPWR
+ VGND sg13g2_a221oi_1
X_20011_ _00037_ _13041_ _13323_ _13330_ VPWR VGND sg13g2_o21ai_1
X_20012_ _13331_ _12958_ _13003_ _13017_ VPWR VGND sg13g2_nor3_1
X_20013_ _13332_ _13003_ _13017_ _13331_ VPWR VGND sg13g2_a21oi_1
X_20014_ _00036_ _13314_ _13327_ _13332_ VPWR VGND sg13g2_nor3_1
X_20015_ _13333_ \memory_i.state[2]\ _12969_ \control_i.mem_valid\ VPWR VGND sg13g2_a21oi_1
X_20016_ _00035_ _00031_ _13333_ VPWR VGND sg13g2_nor2_1
X_20017_ _13334_ \rd_alu[2]\ _12978_ VPWR VGND sg13g2_nor2_1
X_20018_ _13335_ _12999_ _13003_ _13325_ _13334_ VPWR
+ VGND
+ sg13g2_nand4_1
X_20019_ _13336_ reset _13316_ VPWR VGND sg13g2_nand2_1
X_20020_ _13337_ _13009_ _13335_ _13336_ VPWR VGND sg13g2_a21oi_1
X_20021_ _00034_ \memory_i.state[4]\ _12970_ _13337_ VPWR VGND sg13g2_a21o_1
X_20022_ _13338_ \memory_i.ds_lo_conf[4]\ VPWR VGND sg13g2_inv_1
X_20023_ _13339_ \memory_i.freq_inst.lo_gen.lo_ctr_r[1]\ \memory_i.freq_inst.lo_gen.lo_ctr_r[0]\ \memory_i.ds_lo_conf[0]\ VPWR VGND sg13g2_and3_1
X_20024_ _13340_ \memory_i.freq_inst.lo_gen.lo_i_r\ \memory_i.freq_inst.lo_gen.lo_q_r\ \memory_i.ds_lo_conf[0]\ VPWR VGND sg13g2_nor3_1
X_20025_ _13341_ \memory_i.ds_lo_conf[1]\ VPWR VGND sg13g2_inv_1
X_20026_ _13342_ _13339_ _13340_ _13341_ VPWR VGND sg13g2_o21ai_1
X_20027_ _13343_ \memory_i.ds_lo_conf[0]\ \memory_i.freq_inst.lo_gen.lo_ctr_r[1]\ VPWR VGND sg13g2_nor2b_1
X_20028_ _13344_ \memory_i.freq_inst.lo_gen.lo_ctr_r[3]\ \memory_i.ds_lo_conf[0]\ _13343_ VPWR VGND sg13g2_a21o_1
X_20029_ _13345_ \memory_i.freq_inst.lo_gen.lo_ctr_r[2]\ \memory_i.ds_lo_conf[1]\ _13344_ VPWR VGND sg13g2_nand3_1
X_20030_ _13346_ _13338_ _13342_ _13345_ VPWR VGND sg13g2_nand3_1
X_20031_ _13347_ _13338_ \memory_i.ds_lo_conf[0]\ _13346_ VPWR VGND sg13g2_o21ai_1
X_20032_ _13348_ \memory_i.freq_inst.cordic.rstn_i\ lo_I_oe VPWR VGND sg13g2_nand2_1
X_20033_ _13349_ lo_I_oe lo_Qx_i VPWR VGND sg13g2_nand2b_1
X_20034_ lo_Qx_o _13347_ _13348_ _13349_ VPWR VGND sg13g2_o21ai_1
X_20035_ _13350_ \memory_i.freq_inst.lo_gen.lo_i_r\ \memory_i.freq_inst.lo_gen.lo_q_r\ VPWR VGND sg13g2_nand2_1
X_20036_ _13351_ \memory_i.freq_inst.lo_gen.lo_ctr_r[1]\ \memory_i.freq_inst.lo_gen.lo_ctr_r[0]\ \memory_i.ds_lo_conf[0]\ VPWR VGND sg13g2_nand3b_1
X_20037_ _13352_ \memory_i.ds_lo_conf[0]\ _13350_ _13351_ VPWR VGND sg13g2_o21ai_1
X_20038_ _13353_ \memory_i.ds_lo_conf[0]\ VPWR VGND sg13g2_inv_1
X_20039_ _13354_ \memory_i.freq_inst.lo_gen.lo_ctr_r[3]\ _13353_ \memory_i.freq_inst.lo_gen.lo_ctr_r[2]\ VPWR VGND sg13g2_o21ai_1
X_20040_ _13355_ \memory_i.freq_inst.lo_gen.lo_ctr_r[2]\ _13343_ _13354_ VPWR VGND sg13g2_o21ai_1
X_20041_ _13356_ \memory_i.ds_lo_conf[1]\ _13355_ VPWR VGND sg13g2_nand2_1
X_20042_ _13357_ \memory_i.ds_lo_conf[1]\ _13352_ _13356_ VPWR VGND sg13g2_o21ai_1
X_20043_ _13358_ \memory_i.ds_lo_conf[4]\ _13357_ VPWR VGND sg13g2_nor2_1
X_20044_ _13359_ \memory_i.ds_lo_conf[4]\ \memory_i.ds_lo_conf[2]\ _13358_ VPWR VGND sg13g2_a21oi_1
X_20045_ _13360_ lo_I_oe lo_Q_i VPWR VGND sg13g2_nand2b_1
X_20046_ lo_Q_o _13348_ _13359_ _13360_ VPWR VGND sg13g2_o21ai_1
X_20047_ _13361_ \memory_i.freq_inst.lo_gen.lo_ctr_r[3]\ \memory_i.ds_lo_conf[0]\ \memory_i.freq_inst.lo_gen.lo_ctr_r[2]\ VPWR VGND sg13g2_a21o_1
X_20048_ _13362_ \memory_i.freq_inst.lo_gen.lo_ctr_r[1]\ \memory_i.ds_lo_conf[0]\ \memory_i.freq_inst.lo_gen.lo_ctr_r[2]\ VPWR VGND sg13g2_o21ai_1
X_20049_ _13363_ _13361_ _13362_ \memory_i.ds_lo_conf[4]\ VPWR VGND sg13g2_a21o_1
X_20050_ _13364_ \memory_i.freq_inst.lo_gen.lo_ctr_r[0]\ \memory_i.freq_inst.lo_gen.lo_ctr_r[1]\ VPWR VGND sg13g2_nand2b_1
X_20051_ _13365_ \memory_i.freq_inst.lo_gen.lo_i_r\ VPWR VGND sg13g2_inv_1
X_20052_ _13366_ _13365_ \memory_i.freq_inst.lo_gen.lo_q_r\ _13353_ VPWR VGND sg13g2_nand3_1
X_20053_ _13367_ _13353_ _13364_ _13366_ VPWR VGND sg13g2_o21ai_1
X_20054_ _13368_ \memory_i.ds_lo_conf[4]\ \memory_i.ds_lo_conf[1]\ VPWR VGND sg13g2_nor2_1
X_20055_ _13369_ \memory_i.ds_lo_conf[1]\ _13363_ _13367_ _13368_ VPWR
+ VGND
+ sg13g2_a22oi_1
X_20056_ _13370_ lo_I_oe lo_Ix_i VPWR VGND sg13g2_nand2b_1
X_20057_ lo_Ix_o _13348_ _13369_ _13370_ VPWR VGND sg13g2_o21ai_1
X_20058_ _13371_ \memory_i.freq_inst.lo_gen.lo_ctr_r[2]\ \memory_i.ds_lo_conf[1]\ VPWR VGND sg13g2_nand2b_1
X_20059_ _13372_ \memory_i.freq_inst.lo_gen.lo_ctr_r[1]\ \memory_i.freq_inst.lo_gen.lo_ctr_r[0]\ _13353_ VPWR VGND sg13g2_nor3_1
X_20060_ _13373_ _13365_ \memory_i.freq_inst.lo_gen.lo_q_r\ \memory_i.ds_lo_conf[0]\ VPWR VGND sg13g2_nor3_1
X_20061_ _13374_ _13372_ _13373_ _13341_ VPWR VGND sg13g2_o21ai_1
X_20062_ _13375_ _13344_ _13371_ _13374_ VPWR VGND sg13g2_o21ai_1
X_20063_ _13376_ \memory_i.ds_lo_conf[3]\ \memory_i.ds_lo_conf[4]\ VPWR VGND sg13g2_nand2b_1
X_20064_ _13377_ \memory_i.ds_lo_conf[4]\ _13375_ _13376_ VPWR VGND sg13g2_o21ai_1
X_20065_ _13378_ lo_I_oe lo_I_i VPWR VGND sg13g2_nand2b_1
X_20066_ lo_I_o _13348_ _13377_ _13378_ VPWR VGND sg13g2_o21ai_1
X_20067_ _13379_ \memory_i.freq_inst.dsmod_cos.accu3_r[41]\ \memory_i.ds_lo_conf[5]\ VPWR VGND sg13g2_nand2_1
X_20068_ _13380_ \memory_i.ds_lo_conf[5]\ VPWR VGND sg13g2_inv_1
X_20069_ _13381_ \memory_i.freq_inst.dsmod_cos.accu1_r[39]\ _13380_ VPWR VGND sg13g2_nand2_1
X_20070_ _13382_ _13379_ _13381_ VPWR VGND sg13g2_and2_1
X_20071_ _13383_ _13382_ VPWR VGND sg13g2_buf_1
X_20072_ _13384_ \memory_i.freq_inst.dsmod_sin.accu3_r[41]\ \memory_i.ds_lo_conf[5]\ VPWR VGND sg13g2_and2_1
X_20073_ _13385_ \memory_i.freq_inst.dsmod_sin.accu1_r[39]\ _13380_ _13384_ VPWR VGND sg13g2_a21o_1
X_20074_ _13386_ _13385_ VPWR VGND sg13g2_buf_1
X_20075_ _13387_ _13386_ VPWR VGND sg13g2_buf_2
X_20076_ _13388_ \memory_i.ds_lo_conf[7]\ _13387_ VPWR VGND sg13g2_nor2_1
X_20077_ _13389_ \memory_i.ds_lo_conf[7]\ _13383_ _13388_ VPWR VGND sg13g2_a21oi_1
X_20078_ _13390_ \memory_i.ds_lo_conf[6]\ _13389_ VPWR VGND sg13g2_xnor2_1
X_20079_ _13391_ \memory_i.ds_defaults[4]\ \memory_i.ds_defaults[0]\ VPWR VGND sg13g2_nand2_1
X_20080_ _13392_ \memory_i.ds_defaults[4]\ _13390_ _13391_ VPWR VGND sg13g2_o21ai_1
X_20081_ ds_Q_n_o ds_Q_n_i _13392_ ds_I_oe VPWR VGND sg13g2_mux2_1
X_20082_ _13393_ \memory_i.ds_defaults[5]\ _13390_ VPWR VGND sg13g2_nor2b_1
X_20083_ _13394_ \memory_i.ds_defaults[5]\ \memory_i.ds_defaults[1]\ _13393_ VPWR VGND sg13g2_a21oi_1
X_20084_ _13395_ ds_I_oe ds_Q_p_i VPWR VGND sg13g2_nor2_1
X_20085_ ds_Q_p_o ds_I_oe _13394_ _13395_ VPWR VGND sg13g2_a21oi_1
X_20086_ _13396_ _13379_ _13381_ VPWR VGND sg13g2_nand2_1
X_20087_ _13397_ _13396_ VPWR VGND sg13g2_buf_1
X_20088_ _13398_ \memory_i.freq_inst.dsmod_sin.accu1_r[39]\ _13380_ _13384_ VPWR VGND sg13g2_a21oi_1
X_20089_ _13399_ _13398_ VPWR VGND sg13g2_buf_1
X_20090_ _13400_ _13399_ VPWR VGND sg13g2_buf_2
X_20091_ _13401_ \memory_i.ds_lo_conf[7]\ _13400_ VPWR VGND sg13g2_nand2_1
X_20092_ _13402_ \memory_i.ds_lo_conf[7]\ _13397_ _13401_ VPWR VGND sg13g2_o21ai_1
X_20093_ _13403_ \memory_i.ds_lo_conf[6]\ _13402_ VPWR VGND sg13g2_xor2_1
X_20094_ _13404_ \memory_i.ds_defaults[6]\ \memory_i.ds_defaults[2]\ VPWR VGND sg13g2_nand2_1
X_20095_ _13405_ \memory_i.ds_defaults[6]\ _13403_ _13404_ VPWR VGND sg13g2_o21ai_1
X_20096_ ds_I_n_o ds_I_n_i _13405_ ds_I_oe VPWR VGND sg13g2_mux2_1
X_20097_ _13406_ \memory_i.ds_defaults[7]\ _13403_ VPWR VGND sg13g2_nor2b_1
X_20098_ _13407_ \memory_i.ds_defaults[7]\ \memory_i.ds_defaults[3]\ _13406_ VPWR VGND sg13g2_a21oi_1
X_20099_ _13408_ ds_I_oe ds_I_p_i VPWR VGND sg13g2_nor2_1
X_20100_ ds_I_p_o ds_I_oe _13407_ _13408_ VPWR VGND sg13g2_a21oi_1
X_20101_ _13409_ \memory_i.i2c_master.index[1]\ \memory_i.i2c_master.index[0]\ VPWR VGND sg13g2_nor2_1
X_20102_ _13410_ \memory_i.datain_reg[4]\ \memory_i.datain_reg[12]\ \memory_i.datain_reg[20]\ \memory_i.datain_reg[28]\ \memory_i.i2c_master.frame_index[0]\
+ \memory_i.i2c_master.frame_index[1]\
+ VPWR VGND sg13g2_mux4_1
X_20103_ _13411_ \memory_i.i2c_master.state[10]\ \memory_i.i2c_addr[4]\ VPWR VGND sg13g2_nor2b_1
X_20104_ _13412_ \memory_i.i2c_master.state[10]\ _13410_ _13411_ VPWR VGND sg13g2_a21oi_1
X_20105_ _13413_ \memory_i.i2c_master.index[1]\ \memory_i.i2c_master.index[0]\ VPWR VGND sg13g2_nor2b_1
X_20106_ _13414_ _13413_ VPWR VGND sg13g2_buf_1
X_20107_ _13415_ \memory_i.datain_reg[5]\ \memory_i.datain_reg[13]\ \memory_i.datain_reg[21]\ \memory_i.datain_reg[29]\ \memory_i.i2c_master.frame_index[0]\
+ \memory_i.i2c_master.frame_index[1]\
+ VPWR VGND sg13g2_mux4_1
X_20108_ _13416_ \memory_i.i2c_master.state[10]\ \memory_i.i2c_addr[5]\ VPWR VGND sg13g2_nor2b_1
X_20109_ _13417_ \memory_i.i2c_master.state[10]\ _13415_ _13416_ VPWR VGND sg13g2_a21oi_1
X_20110_ _13418_ \memory_i.datain_reg[6]\ \memory_i.datain_reg[14]\ \memory_i.datain_reg[22]\ \memory_i.datain_reg[30]\ \memory_i.i2c_master.frame_index[0]\
+ \memory_i.i2c_master.frame_index[1]\
+ VPWR VGND sg13g2_mux4_1
X_20111_ _13419_ \memory_i.i2c_master.state[10]\ \memory_i.i2c_addr[6]\ VPWR VGND sg13g2_nor2b_1
X_20112_ _13420_ \memory_i.i2c_master.state[10]\ _13418_ _13419_ VPWR VGND sg13g2_a21oi_1
X_20113_ _13421_ \memory_i.datain_reg[7]\ \memory_i.datain_reg[23]\ \memory_i.datain_reg[15]\ \memory_i.datain_reg[31]\ \memory_i.i2c_master.frame_index[1]\
+ \memory_i.i2c_master.frame_index[0]\
+ VPWR VGND sg13g2_mux4_1
X_20114_ _13422_ \memory_i.i2c_master.index[0]\ \memory_i.i2c_master.state[10]\ _13421_ VPWR VGND sg13g2_nand3_1
X_20115_ _13423_ \memory_i.i2c_master.index[0]\ _13420_ _13422_ VPWR VGND sg13g2_o21ai_1
X_20116_ _13424_ _13423_ \memory_i.i2c_master.index[1]\ VPWR VGND sg13g2_nor2b_1
X_20117_ _13425_ _13409_ _13412_ _13414_ _13417_ _13424_
+ VPWR
+ VGND sg13g2_a221oi_1
X_20118_ _13426_ \memory_i.datain_reg[0]\ \memory_i.datain_reg[8]\ \memory_i.datain_reg[16]\ \memory_i.datain_reg[24]\ \memory_i.i2c_master.frame_index[0]\
+ \memory_i.i2c_master.frame_index[1]\
+ VPWR VGND sg13g2_mux4_1
X_20119_ _13427_ \memory_i.datain_reg[2]\ \memory_i.datain_reg[10]\ \memory_i.datain_reg[18]\ \memory_i.datain_reg[26]\ \memory_i.i2c_master.frame_index[0]\
+ \memory_i.i2c_master.frame_index[1]\
+ VPWR VGND sg13g2_mux4_1
X_20120_ _13428_ \memory_i.datain_reg[1]\ \memory_i.datain_reg[9]\ \memory_i.datain_reg[17]\ \memory_i.datain_reg[25]\ \memory_i.i2c_master.frame_index[0]\
+ \memory_i.i2c_master.frame_index[1]\
+ VPWR VGND sg13g2_mux4_1
X_20121_ _13429_ \memory_i.datain_reg[3]\ \memory_i.datain_reg[11]\ \memory_i.datain_reg[19]\ \memory_i.datain_reg[27]\ \memory_i.i2c_master.frame_index[0]\
+ \memory_i.i2c_master.frame_index[1]\
+ VPWR VGND sg13g2_mux4_1
X_20122_ _13430_ _13426_ _13427_ _13428_ _13429_ \memory_i.i2c_master.index[1]\
+ \memory_i.i2c_master.index[0]\
+ VPWR VGND sg13g2_mux4_1
X_20123_ _13431_ \memory_i.i2c_addr[0]\ \memory_i.i2c_addr[1]\ \memory_i.i2c_addr[2]\ \memory_i.i2c_addr[3]\ \memory_i.i2c_master.index[0]\
+ \memory_i.i2c_master.index[1]\
+ VPWR VGND sg13g2_mux4_1
X_20124_ _13432_ \memory_i.i2c_master.state[10]\ _13431_ VPWR VGND sg13g2_nor2b_1
X_20125_ _13433_ \memory_i.i2c_master.state[10]\ _13430_ _13432_ VPWR VGND sg13g2_a21oi_1
X_20126_ _13434_ \memory_i.i2c_master.index[2]\ _13433_ VPWR VGND sg13g2_nor2_1
X_20127_ _13435_ \memory_i.i2c_master.index[2]\ _13425_ _13434_ VPWR VGND sg13g2_a21oi_1
X_20128_ _13436_ \memory_i.i2c_master.state[5]\ \memory_i.i2c_master.state[7]\ _13112_ VPWR VGND sg13g2_nor3_1
X_20129_ _13437_ _13132_ \memory_i.i2c_master.state[9]\ _13108_ _13436_ VPWR
+ VGND
+ sg13g2_a22oi_1
X_20130_ sda_o _13108_ _13435_ _13437_ VPWR VGND sg13g2_o21ai_1
X_20131_ sda_oe \memory_i.i2c_master.state[1]\ \memory_i.i2c_master.state[2]\ \memory_i.i2c_master.state[8]\ VPWR VGND sg13g2_nor3_1
X_20132_ _13438_ \regs.registers[0][0]\ \regs.registers[1][0]\ \regs.registers[2][0]\ \regs.registers[3][0]\ \control_i.imm_gen_i.iword[15]\
+ \control_i.imm_gen_i.iword[16]\
+ VPWR VGND sg13g2_mux4_1
X_20133_ _13439_ \regs.registers[8][0]\ \regs.registers[9][0]\ \regs.registers[10][0]\ \regs.registers[11][0]\ \control_i.imm_gen_i.iword[15]\
+ \control_i.imm_gen_i.iword[16]\
+ VPWR VGND sg13g2_mux4_1
X_20134_ _13440_ \regs.registers[4][0]\ \regs.registers[5][0]\ \regs.registers[6][0]\ \regs.registers[7][0]\ \control_i.imm_gen_i.iword[15]\
+ \control_i.imm_gen_i.iword[16]\
+ VPWR VGND sg13g2_mux4_1
X_20135_ _13441_ \regs.registers[12][0]\ \regs.registers[13][0]\ \regs.registers[14][0]\ \regs.registers[15][0]\ \control_i.imm_gen_i.iword[15]\
+ \control_i.imm_gen_i.iword[16]\
+ VPWR VGND sg13g2_mux4_1
X_20136_ _13442_ _13438_ _13439_ _13440_ _13441_ \control_i.imm_gen_i.iword[18]\
+ \control_i.imm_gen_i.iword[17]\
+ VPWR VGND sg13g2_mux4_1
X_20137_ _00047_ reset _13442_ VPWR VGND sg13g2_and2_1
X_20138_ _13443_ \regs.registers[0][1]\ \regs.registers[1][1]\ \regs.registers[2][1]\ \regs.registers[3][1]\ \control_i.imm_gen_i.iword[15]\
+ \control_i.imm_gen_i.iword[16]\
+ VPWR VGND sg13g2_mux4_1
X_20139_ _13444_ \regs.registers[8][1]\ \regs.registers[9][1]\ \regs.registers[10][1]\ \regs.registers[11][1]\ \control_i.imm_gen_i.iword[15]\
+ \control_i.imm_gen_i.iword[16]\
+ VPWR VGND sg13g2_mux4_1
X_20140_ _13445_ \regs.registers[4][1]\ \regs.registers[5][1]\ \regs.registers[6][1]\ \regs.registers[7][1]\ \control_i.imm_gen_i.iword[15]\
+ \control_i.imm_gen_i.iword[16]\
+ VPWR VGND sg13g2_mux4_1
X_20141_ _13446_ \regs.registers[12][1]\ \regs.registers[13][1]\ \regs.registers[14][1]\ \regs.registers[15][1]\ \control_i.imm_gen_i.iword[15]\
+ \control_i.imm_gen_i.iword[16]\
+ VPWR VGND sg13g2_mux4_1
X_20142_ _13447_ _13443_ _13444_ _13445_ _13446_ \control_i.imm_gen_i.iword[18]\
+ \control_i.imm_gen_i.iword[17]\
+ VPWR VGND sg13g2_mux4_1
X_20143_ _00048_ reset _13447_ VPWR VGND sg13g2_and2_1
X_20144_ _13448_ \regs.registers[0][2]\ \regs.registers[1][2]\ \regs.registers[2][2]\ \regs.registers[3][2]\ \control_i.imm_gen_i.iword[15]\
+ \control_i.imm_gen_i.iword[16]\
+ VPWR VGND sg13g2_mux4_1
X_20145_ _13449_ \regs.registers[8][2]\ \regs.registers[9][2]\ \regs.registers[10][2]\ \regs.registers[11][2]\ \control_i.imm_gen_i.iword[15]\
+ \control_i.imm_gen_i.iword[16]\
+ VPWR VGND sg13g2_mux4_1
X_20146_ _13450_ \regs.registers[4][2]\ \regs.registers[5][2]\ \regs.registers[6][2]\ \regs.registers[7][2]\ \control_i.imm_gen_i.iword[15]\
+ \control_i.imm_gen_i.iword[16]\
+ VPWR VGND sg13g2_mux4_1
X_20147_ _13451_ \regs.registers[12][2]\ \regs.registers[13][2]\ \regs.registers[14][2]\ \regs.registers[15][2]\ \control_i.imm_gen_i.iword[15]\
+ \control_i.imm_gen_i.iword[16]\
+ VPWR VGND sg13g2_mux4_1
X_20148_ _13452_ _13448_ _13449_ _13450_ _13451_ \control_i.imm_gen_i.iword[18]\
+ \control_i.imm_gen_i.iword[17]\
+ VPWR VGND sg13g2_mux4_1
X_20149_ _00049_ reset _13452_ VPWR VGND sg13g2_and2_1
X_20150_ _13453_ \regs.registers[0][3]\ \regs.registers[1][3]\ \regs.registers[2][3]\ \regs.registers[3][3]\ \control_i.imm_gen_i.iword[15]\
+ \control_i.imm_gen_i.iword[16]\
+ VPWR VGND sg13g2_mux4_1
X_20151_ _13454_ \regs.registers[8][3]\ \regs.registers[9][3]\ \regs.registers[10][3]\ \regs.registers[11][3]\ \control_i.imm_gen_i.iword[15]\
+ \control_i.imm_gen_i.iword[16]\
+ VPWR VGND sg13g2_mux4_1
X_20152_ _13455_ \regs.registers[4][3]\ \regs.registers[5][3]\ \regs.registers[6][3]\ \regs.registers[7][3]\ \control_i.imm_gen_i.iword[15]\
+ \control_i.imm_gen_i.iword[16]\
+ VPWR VGND sg13g2_mux4_1
X_20153_ _13456_ \regs.registers[12][3]\ \regs.registers[13][3]\ \regs.registers[14][3]\ \regs.registers[15][3]\ \control_i.imm_gen_i.iword[15]\
+ \control_i.imm_gen_i.iword[16]\
+ VPWR VGND sg13g2_mux4_1
X_20154_ _13457_ _13453_ _13454_ _13455_ _13456_ \control_i.imm_gen_i.iword[18]\
+ \control_i.imm_gen_i.iword[17]\
+ VPWR VGND sg13g2_mux4_1
X_20155_ _00050_ reset _13457_ VPWR VGND sg13g2_and2_1
X_20156_ _13458_ \regs.registers[0][4]\ \regs.registers[1][4]\ \regs.registers[2][4]\ \regs.registers[3][4]\ \control_i.imm_gen_i.iword[15]\
+ \control_i.imm_gen_i.iword[16]\
+ VPWR VGND sg13g2_mux4_1
X_20157_ _13459_ \regs.registers[8][4]\ \regs.registers[9][4]\ \regs.registers[10][4]\ \regs.registers[11][4]\ \control_i.imm_gen_i.iword[15]\
+ \control_i.imm_gen_i.iword[16]\
+ VPWR VGND sg13g2_mux4_1
X_20158_ _13460_ \regs.registers[4][4]\ \regs.registers[5][4]\ \regs.registers[6][4]\ \regs.registers[7][4]\ \control_i.imm_gen_i.iword[15]\
+ \control_i.imm_gen_i.iword[16]\
+ VPWR VGND sg13g2_mux4_1
X_20159_ _13461_ \regs.registers[12][4]\ \regs.registers[13][4]\ \regs.registers[14][4]\ \regs.registers[15][4]\ \control_i.imm_gen_i.iword[15]\
+ \control_i.imm_gen_i.iword[16]\
+ VPWR VGND sg13g2_mux4_1
X_20160_ _13462_ _13458_ _13459_ _13460_ _13461_ \control_i.imm_gen_i.iword[18]\
+ \control_i.imm_gen_i.iword[17]\
+ VPWR VGND sg13g2_mux4_1
X_20161_ _00051_ reset _13462_ VPWR VGND sg13g2_and2_1
X_20162_ _13463_ \regs.registers[0][5]\ \regs.registers[1][5]\ \regs.registers[2][5]\ \regs.registers[3][5]\ \control_i.imm_gen_i.iword[15]\
+ \control_i.imm_gen_i.iword[16]\
+ VPWR VGND sg13g2_mux4_1
X_20163_ _13464_ \regs.registers[8][5]\ \regs.registers[9][5]\ \regs.registers[10][5]\ \regs.registers[11][5]\ \control_i.imm_gen_i.iword[15]\
+ \control_i.imm_gen_i.iword[16]\
+ VPWR VGND sg13g2_mux4_1
X_20164_ _13465_ \regs.registers[4][5]\ \regs.registers[5][5]\ \regs.registers[6][5]\ \regs.registers[7][5]\ \control_i.imm_gen_i.iword[15]\
+ \control_i.imm_gen_i.iword[16]\
+ VPWR VGND sg13g2_mux4_1
X_20165_ _13466_ \regs.registers[12][5]\ \regs.registers[13][5]\ \regs.registers[14][5]\ \regs.registers[15][5]\ \control_i.imm_gen_i.iword[15]\
+ \control_i.imm_gen_i.iword[16]\
+ VPWR VGND sg13g2_mux4_1
X_20166_ _13467_ _13463_ _13464_ _13465_ _13466_ \control_i.imm_gen_i.iword[18]\
+ \control_i.imm_gen_i.iword[17]\
+ VPWR VGND sg13g2_mux4_1
X_20167_ _00052_ reset _13467_ VPWR VGND sg13g2_and2_1
X_20168_ _13468_ \regs.registers[0][6]\ \regs.registers[1][6]\ \regs.registers[2][6]\ \regs.registers[3][6]\ \control_i.imm_gen_i.iword[15]\
+ \control_i.imm_gen_i.iword[16]\
+ VPWR VGND sg13g2_mux4_1
X_20169_ _13469_ \regs.registers[8][6]\ \regs.registers[9][6]\ \regs.registers[10][6]\ \regs.registers[11][6]\ \control_i.imm_gen_i.iword[15]\
+ \control_i.imm_gen_i.iword[16]\
+ VPWR VGND sg13g2_mux4_1
X_20170_ _13470_ \regs.registers[4][6]\ \regs.registers[5][6]\ \regs.registers[6][6]\ \regs.registers[7][6]\ \control_i.imm_gen_i.iword[15]\
+ \control_i.imm_gen_i.iword[16]\
+ VPWR VGND sg13g2_mux4_1
X_20171_ _13471_ \regs.registers[12][6]\ \regs.registers[13][6]\ \regs.registers[14][6]\ \regs.registers[15][6]\ \control_i.imm_gen_i.iword[15]\
+ \control_i.imm_gen_i.iword[16]\
+ VPWR VGND sg13g2_mux4_1
X_20172_ _13472_ _13468_ _13469_ _13470_ _13471_ \control_i.imm_gen_i.iword[18]\
+ \control_i.imm_gen_i.iword[17]\
+ VPWR VGND sg13g2_mux4_1
X_20173_ _00053_ reset _13472_ VPWR VGND sg13g2_and2_1
X_20174_ _13473_ \regs.registers[0][7]\ \regs.registers[1][7]\ \regs.registers[2][7]\ \regs.registers[3][7]\ \control_i.imm_gen_i.iword[15]\
+ \control_i.imm_gen_i.iword[16]\
+ VPWR VGND sg13g2_mux4_1
X_20175_ _13474_ \regs.registers[8][7]\ \regs.registers[9][7]\ \regs.registers[10][7]\ \regs.registers[11][7]\ \control_i.imm_gen_i.iword[15]\
+ \control_i.imm_gen_i.iword[16]\
+ VPWR VGND sg13g2_mux4_1
X_20176_ _13475_ \regs.registers[4][7]\ \regs.registers[5][7]\ \regs.registers[6][7]\ \regs.registers[7][7]\ \control_i.imm_gen_i.iword[15]\
+ \control_i.imm_gen_i.iword[16]\
+ VPWR VGND sg13g2_mux4_1
X_20177_ _13476_ \regs.registers[12][7]\ \regs.registers[13][7]\ \regs.registers[14][7]\ \regs.registers[15][7]\ \control_i.imm_gen_i.iword[15]\
+ \control_i.imm_gen_i.iword[16]\
+ VPWR VGND sg13g2_mux4_1
X_20178_ _13477_ _13473_ _13474_ _13475_ _13476_ \control_i.imm_gen_i.iword[18]\
+ \control_i.imm_gen_i.iword[17]\
+ VPWR VGND sg13g2_mux4_1
X_20179_ _00054_ reset _13477_ VPWR VGND sg13g2_and2_1
X_20180_ _13478_ \regs.registers[0][8]\ \regs.registers[1][8]\ \regs.registers[2][8]\ \regs.registers[3][8]\ \control_i.imm_gen_i.iword[15]\
+ \control_i.imm_gen_i.iword[16]\
+ VPWR VGND sg13g2_mux4_1
X_20181_ _13479_ \regs.registers[8][8]\ \regs.registers[9][8]\ \regs.registers[10][8]\ \regs.registers[11][8]\ \control_i.imm_gen_i.iword[15]\
+ \control_i.imm_gen_i.iword[16]\
+ VPWR VGND sg13g2_mux4_1
X_20182_ _13480_ \regs.registers[4][8]\ \regs.registers[5][8]\ \regs.registers[6][8]\ \regs.registers[7][8]\ \control_i.imm_gen_i.iword[15]\
+ \control_i.imm_gen_i.iword[16]\
+ VPWR VGND sg13g2_mux4_1
X_20183_ _13481_ \regs.registers[12][8]\ \regs.registers[13][8]\ \regs.registers[14][8]\ \regs.registers[15][8]\ \control_i.imm_gen_i.iword[15]\
+ \control_i.imm_gen_i.iword[16]\
+ VPWR VGND sg13g2_mux4_1
X_20184_ _13482_ _13478_ _13479_ _13480_ _13481_ \control_i.imm_gen_i.iword[18]\
+ \control_i.imm_gen_i.iword[17]\
+ VPWR VGND sg13g2_mux4_1
X_20185_ _00055_ reset _13482_ VPWR VGND sg13g2_and2_1
X_20186_ _13483_ \regs.registers[0][9]\ \regs.registers[1][9]\ \regs.registers[2][9]\ \regs.registers[3][9]\ \control_i.imm_gen_i.iword[15]\
+ \control_i.imm_gen_i.iword[16]\
+ VPWR VGND sg13g2_mux4_1
X_20187_ _13484_ \regs.registers[8][9]\ \regs.registers[9][9]\ \regs.registers[10][9]\ \regs.registers[11][9]\ \control_i.imm_gen_i.iword[15]\
+ \control_i.imm_gen_i.iword[16]\
+ VPWR VGND sg13g2_mux4_1
X_20188_ _13485_ \regs.registers[4][9]\ \regs.registers[5][9]\ \regs.registers[6][9]\ \regs.registers[7][9]\ \control_i.imm_gen_i.iword[15]\
+ \control_i.imm_gen_i.iword[16]\
+ VPWR VGND sg13g2_mux4_1
X_20189_ _13486_ \regs.registers[12][9]\ \regs.registers[13][9]\ \regs.registers[14][9]\ \regs.registers[15][9]\ \control_i.imm_gen_i.iword[15]\
+ \control_i.imm_gen_i.iword[16]\
+ VPWR VGND sg13g2_mux4_1
X_20190_ _13487_ _13483_ _13484_ _13485_ _13486_ \control_i.imm_gen_i.iword[18]\
+ \control_i.imm_gen_i.iword[17]\
+ VPWR VGND sg13g2_mux4_1
X_20191_ _00056_ reset _13487_ VPWR VGND sg13g2_and2_1
X_20192_ _13488_ \regs.registers[0][10]\ \regs.registers[1][10]\ \regs.registers[2][10]\ \regs.registers[3][10]\ \control_i.imm_gen_i.iword[15]\
+ \control_i.imm_gen_i.iword[16]\
+ VPWR VGND sg13g2_mux4_1
X_20193_ _13489_ \regs.registers[8][10]\ \regs.registers[9][10]\ \regs.registers[10][10]\ \regs.registers[11][10]\ \control_i.imm_gen_i.iword[15]\
+ \control_i.imm_gen_i.iword[16]\
+ VPWR VGND sg13g2_mux4_1
X_20194_ _13490_ \regs.registers[4][10]\ \regs.registers[5][10]\ \regs.registers[6][10]\ \regs.registers[7][10]\ \control_i.imm_gen_i.iword[15]\
+ \control_i.imm_gen_i.iword[16]\
+ VPWR VGND sg13g2_mux4_1
X_20195_ _13491_ \regs.registers[12][10]\ \regs.registers[13][10]\ \regs.registers[14][10]\ \regs.registers[15][10]\ \control_i.imm_gen_i.iword[15]\
+ \control_i.imm_gen_i.iword[16]\
+ VPWR VGND sg13g2_mux4_1
X_20196_ _13492_ _13488_ _13489_ _13490_ _13491_ \control_i.imm_gen_i.iword[18]\
+ \control_i.imm_gen_i.iword[17]\
+ VPWR VGND sg13g2_mux4_1
X_20197_ _00057_ reset _13492_ VPWR VGND sg13g2_and2_1
X_20198_ _13493_ \regs.registers[0][11]\ \regs.registers[1][11]\ \regs.registers[2][11]\ \regs.registers[3][11]\ \control_i.imm_gen_i.iword[15]\
+ \control_i.imm_gen_i.iword[16]\
+ VPWR VGND sg13g2_mux4_1
X_20199_ _13494_ \regs.registers[8][11]\ \regs.registers[9][11]\ \regs.registers[10][11]\ \regs.registers[11][11]\ \control_i.imm_gen_i.iword[15]\
+ \control_i.imm_gen_i.iword[16]\
+ VPWR VGND sg13g2_mux4_1
X_20200_ _13495_ \regs.registers[4][11]\ \regs.registers[5][11]\ \regs.registers[6][11]\ \regs.registers[7][11]\ \control_i.imm_gen_i.iword[15]\
+ \control_i.imm_gen_i.iword[16]\
+ VPWR VGND sg13g2_mux4_1
X_20201_ _13496_ \regs.registers[12][11]\ \regs.registers[13][11]\ \regs.registers[14][11]\ \regs.registers[15][11]\ \control_i.imm_gen_i.iword[15]\
+ \control_i.imm_gen_i.iword[16]\
+ VPWR VGND sg13g2_mux4_1
X_20202_ _13497_ _13493_ _13494_ _13495_ _13496_ \control_i.imm_gen_i.iword[18]\
+ \control_i.imm_gen_i.iword[17]\
+ VPWR VGND sg13g2_mux4_1
X_20203_ _00058_ reset _13497_ VPWR VGND sg13g2_and2_1
X_20204_ _13498_ \regs.registers[0][12]\ \regs.registers[1][12]\ \regs.registers[2][12]\ \regs.registers[3][12]\ \control_i.imm_gen_i.iword[15]\
+ \control_i.imm_gen_i.iword[16]\
+ VPWR VGND sg13g2_mux4_1
X_20205_ _13499_ \regs.registers[8][12]\ \regs.registers[9][12]\ \regs.registers[10][12]\ \regs.registers[11][12]\ \control_i.imm_gen_i.iword[15]\
+ \control_i.imm_gen_i.iword[16]\
+ VPWR VGND sg13g2_mux4_1
X_20206_ _13500_ \regs.registers[4][12]\ \regs.registers[5][12]\ \regs.registers[6][12]\ \regs.registers[7][12]\ \control_i.imm_gen_i.iword[15]\
+ \control_i.imm_gen_i.iword[16]\
+ VPWR VGND sg13g2_mux4_1
X_20207_ _13501_ \regs.registers[12][12]\ \regs.registers[13][12]\ \regs.registers[14][12]\ \regs.registers[15][12]\ \control_i.imm_gen_i.iword[15]\
+ \control_i.imm_gen_i.iword[16]\
+ VPWR VGND sg13g2_mux4_1
X_20208_ _13502_ _13498_ _13499_ _13500_ _13501_ \control_i.imm_gen_i.iword[18]\
+ \control_i.imm_gen_i.iword[17]\
+ VPWR VGND sg13g2_mux4_1
X_20209_ _00059_ reset _13502_ VPWR VGND sg13g2_and2_1
X_20210_ _13503_ \regs.registers[0][13]\ \regs.registers[1][13]\ \regs.registers[2][13]\ \regs.registers[3][13]\ \control_i.imm_gen_i.iword[15]\
+ \control_i.imm_gen_i.iword[16]\
+ VPWR VGND sg13g2_mux4_1
X_20211_ _13504_ \regs.registers[8][13]\ \regs.registers[9][13]\ \regs.registers[10][13]\ \regs.registers[11][13]\ \control_i.imm_gen_i.iword[15]\
+ \control_i.imm_gen_i.iword[16]\
+ VPWR VGND sg13g2_mux4_1
X_20212_ _13505_ \regs.registers[4][13]\ \regs.registers[5][13]\ \regs.registers[6][13]\ \regs.registers[7][13]\ \control_i.imm_gen_i.iword[15]\
+ \control_i.imm_gen_i.iword[16]\
+ VPWR VGND sg13g2_mux4_1
X_20213_ _13506_ \regs.registers[12][13]\ \regs.registers[13][13]\ \regs.registers[14][13]\ \regs.registers[15][13]\ \control_i.imm_gen_i.iword[15]\
+ \control_i.imm_gen_i.iword[16]\
+ VPWR VGND sg13g2_mux4_1
X_20214_ _13507_ _13503_ _13504_ _13505_ _13506_ \control_i.imm_gen_i.iword[18]\
+ \control_i.imm_gen_i.iword[17]\
+ VPWR VGND sg13g2_mux4_1
X_20215_ _00060_ reset _13507_ VPWR VGND sg13g2_and2_1
X_20216_ _13508_ \regs.registers[0][14]\ \regs.registers[1][14]\ \regs.registers[2][14]\ \regs.registers[3][14]\ \control_i.imm_gen_i.iword[15]\
+ \control_i.imm_gen_i.iword[16]\
+ VPWR VGND sg13g2_mux4_1
X_20217_ _13509_ \regs.registers[8][14]\ \regs.registers[9][14]\ \regs.registers[10][14]\ \regs.registers[11][14]\ \control_i.imm_gen_i.iword[15]\
+ \control_i.imm_gen_i.iword[16]\
+ VPWR VGND sg13g2_mux4_1
X_20218_ _13510_ \regs.registers[4][14]\ \regs.registers[5][14]\ \regs.registers[6][14]\ \regs.registers[7][14]\ \control_i.imm_gen_i.iword[15]\
+ \control_i.imm_gen_i.iword[16]\
+ VPWR VGND sg13g2_mux4_1
X_20219_ _13511_ \regs.registers[12][14]\ \regs.registers[13][14]\ \regs.registers[14][14]\ \regs.registers[15][14]\ \control_i.imm_gen_i.iword[15]\
+ \control_i.imm_gen_i.iword[16]\
+ VPWR VGND sg13g2_mux4_1
X_20220_ _13512_ _13508_ _13509_ _13510_ _13511_ \control_i.imm_gen_i.iword[18]\
+ \control_i.imm_gen_i.iword[17]\
+ VPWR VGND sg13g2_mux4_1
X_20221_ _00061_ reset _13512_ VPWR VGND sg13g2_and2_1
X_20222_ _13513_ \regs.registers[0][15]\ \regs.registers[1][15]\ \regs.registers[2][15]\ \regs.registers[3][15]\ \control_i.imm_gen_i.iword[15]\
+ \control_i.imm_gen_i.iword[16]\
+ VPWR VGND sg13g2_mux4_1
X_20223_ _13514_ \regs.registers[8][15]\ \regs.registers[9][15]\ \regs.registers[10][15]\ \regs.registers[11][15]\ \control_i.imm_gen_i.iword[15]\
+ \control_i.imm_gen_i.iword[16]\
+ VPWR VGND sg13g2_mux4_1
X_20224_ _13515_ \regs.registers[4][15]\ \regs.registers[5][15]\ \regs.registers[6][15]\ \regs.registers[7][15]\ \control_i.imm_gen_i.iword[15]\
+ \control_i.imm_gen_i.iword[16]\
+ VPWR VGND sg13g2_mux4_1
X_20225_ _13516_ \regs.registers[12][15]\ \regs.registers[13][15]\ \regs.registers[14][15]\ \regs.registers[15][15]\ \control_i.imm_gen_i.iword[15]\
+ \control_i.imm_gen_i.iword[16]\
+ VPWR VGND sg13g2_mux4_1
X_20226_ _13517_ _13513_ _13514_ _13515_ _13516_ \control_i.imm_gen_i.iword[18]\
+ \control_i.imm_gen_i.iword[17]\
+ VPWR VGND sg13g2_mux4_1
X_20227_ _00062_ reset _13517_ VPWR VGND sg13g2_and2_1
X_20228_ _13518_ \regs.registers[0][16]\ \regs.registers[1][16]\ \regs.registers[2][16]\ \regs.registers[3][16]\ \control_i.imm_gen_i.iword[15]\
+ \control_i.imm_gen_i.iword[16]\
+ VPWR VGND sg13g2_mux4_1
X_20229_ _13519_ \regs.registers[8][16]\ \regs.registers[9][16]\ \regs.registers[10][16]\ \regs.registers[11][16]\ \control_i.imm_gen_i.iword[15]\
+ \control_i.imm_gen_i.iword[16]\
+ VPWR VGND sg13g2_mux4_1
X_20230_ _13520_ \regs.registers[4][16]\ \regs.registers[5][16]\ \regs.registers[6][16]\ \regs.registers[7][16]\ \control_i.imm_gen_i.iword[15]\
+ \control_i.imm_gen_i.iword[16]\
+ VPWR VGND sg13g2_mux4_1
X_20231_ _13521_ \regs.registers[12][16]\ \regs.registers[13][16]\ \regs.registers[14][16]\ \regs.registers[15][16]\ \control_i.imm_gen_i.iword[15]\
+ \control_i.imm_gen_i.iword[16]\
+ VPWR VGND sg13g2_mux4_1
X_20232_ _13522_ _13518_ _13519_ _13520_ _13521_ \control_i.imm_gen_i.iword[18]\
+ \control_i.imm_gen_i.iword[17]\
+ VPWR VGND sg13g2_mux4_1
X_20233_ _00063_ reset _13522_ VPWR VGND sg13g2_and2_1
X_20234_ _13523_ \regs.registers[0][17]\ \regs.registers[1][17]\ \regs.registers[2][17]\ \regs.registers[3][17]\ \control_i.imm_gen_i.iword[15]\
+ \control_i.imm_gen_i.iword[16]\
+ VPWR VGND sg13g2_mux4_1
X_20235_ _13524_ \regs.registers[8][17]\ \regs.registers[9][17]\ \regs.registers[10][17]\ \regs.registers[11][17]\ \control_i.imm_gen_i.iword[15]\
+ \control_i.imm_gen_i.iword[16]\
+ VPWR VGND sg13g2_mux4_1
X_20236_ _13525_ \regs.registers[4][17]\ \regs.registers[5][17]\ \regs.registers[6][17]\ \regs.registers[7][17]\ \control_i.imm_gen_i.iword[15]\
+ \control_i.imm_gen_i.iword[16]\
+ VPWR VGND sg13g2_mux4_1
X_20237_ _13526_ \regs.registers[12][17]\ \regs.registers[13][17]\ \regs.registers[14][17]\ \regs.registers[15][17]\ \control_i.imm_gen_i.iword[15]\
+ \control_i.imm_gen_i.iword[16]\
+ VPWR VGND sg13g2_mux4_1
X_20238_ _13527_ _13523_ _13524_ _13525_ _13526_ \control_i.imm_gen_i.iword[18]\
+ \control_i.imm_gen_i.iword[17]\
+ VPWR VGND sg13g2_mux4_1
X_20239_ _00064_ reset _13527_ VPWR VGND sg13g2_and2_1
X_20240_ _13528_ \regs.registers[0][18]\ \regs.registers[1][18]\ \regs.registers[2][18]\ \regs.registers[3][18]\ \control_i.imm_gen_i.iword[15]\
+ \control_i.imm_gen_i.iword[16]\
+ VPWR VGND sg13g2_mux4_1
X_20241_ _13529_ \regs.registers[8][18]\ \regs.registers[9][18]\ \regs.registers[10][18]\ \regs.registers[11][18]\ \control_i.imm_gen_i.iword[15]\
+ \control_i.imm_gen_i.iword[16]\
+ VPWR VGND sg13g2_mux4_1
X_20242_ _13530_ \regs.registers[4][18]\ \regs.registers[5][18]\ \regs.registers[6][18]\ \regs.registers[7][18]\ \control_i.imm_gen_i.iword[15]\
+ \control_i.imm_gen_i.iword[16]\
+ VPWR VGND sg13g2_mux4_1
X_20243_ _13531_ \regs.registers[12][18]\ \regs.registers[13][18]\ \regs.registers[14][18]\ \regs.registers[15][18]\ \control_i.imm_gen_i.iword[15]\
+ \control_i.imm_gen_i.iword[16]\
+ VPWR VGND sg13g2_mux4_1
X_20244_ _13532_ _13528_ _13529_ _13530_ _13531_ \control_i.imm_gen_i.iword[18]\
+ \control_i.imm_gen_i.iword[17]\
+ VPWR VGND sg13g2_mux4_1
X_20245_ _00065_ reset _13532_ VPWR VGND sg13g2_and2_1
X_20246_ _13533_ \regs.registers[0][19]\ \regs.registers[1][19]\ \regs.registers[2][19]\ \regs.registers[3][19]\ \control_i.imm_gen_i.iword[15]\
+ \control_i.imm_gen_i.iword[16]\
+ VPWR VGND sg13g2_mux4_1
X_20247_ _13534_ \regs.registers[8][19]\ \regs.registers[9][19]\ \regs.registers[10][19]\ \regs.registers[11][19]\ \control_i.imm_gen_i.iword[15]\
+ \control_i.imm_gen_i.iword[16]\
+ VPWR VGND sg13g2_mux4_1
X_20248_ _13535_ \regs.registers[4][19]\ \regs.registers[5][19]\ \regs.registers[6][19]\ \regs.registers[7][19]\ \control_i.imm_gen_i.iword[15]\
+ \control_i.imm_gen_i.iword[16]\
+ VPWR VGND sg13g2_mux4_1
X_20249_ _13536_ \regs.registers[12][19]\ \regs.registers[13][19]\ \regs.registers[14][19]\ \regs.registers[15][19]\ \control_i.imm_gen_i.iword[15]\
+ \control_i.imm_gen_i.iword[16]\
+ VPWR VGND sg13g2_mux4_1
X_20250_ _13537_ _13533_ _13534_ _13535_ _13536_ \control_i.imm_gen_i.iword[18]\
+ \control_i.imm_gen_i.iword[17]\
+ VPWR VGND sg13g2_mux4_1
X_20251_ _00066_ reset _13537_ VPWR VGND sg13g2_and2_1
X_20252_ _13538_ \regs.registers[0][20]\ \regs.registers[1][20]\ \regs.registers[2][20]\ \regs.registers[3][20]\ \control_i.imm_gen_i.iword[15]\
+ \control_i.imm_gen_i.iword[16]\
+ VPWR VGND sg13g2_mux4_1
X_20253_ _13539_ \regs.registers[8][20]\ \regs.registers[9][20]\ \regs.registers[10][20]\ \regs.registers[11][20]\ \control_i.imm_gen_i.iword[15]\
+ \control_i.imm_gen_i.iword[16]\
+ VPWR VGND sg13g2_mux4_1
X_20254_ _13540_ \regs.registers[4][20]\ \regs.registers[5][20]\ \regs.registers[6][20]\ \regs.registers[7][20]\ \control_i.imm_gen_i.iword[15]\
+ \control_i.imm_gen_i.iword[16]\
+ VPWR VGND sg13g2_mux4_1
X_20255_ _13541_ \regs.registers[12][20]\ \regs.registers[13][20]\ \regs.registers[14][20]\ \regs.registers[15][20]\ \control_i.imm_gen_i.iword[15]\
+ \control_i.imm_gen_i.iword[16]\
+ VPWR VGND sg13g2_mux4_1
X_20256_ _13542_ _13538_ _13539_ _13540_ _13541_ \control_i.imm_gen_i.iword[18]\
+ \control_i.imm_gen_i.iword[17]\
+ VPWR VGND sg13g2_mux4_1
X_20257_ _00067_ reset _13542_ VPWR VGND sg13g2_and2_1
X_20258_ _13543_ \regs.registers[0][21]\ \regs.registers[1][21]\ \regs.registers[2][21]\ \regs.registers[3][21]\ \control_i.imm_gen_i.iword[15]\
+ \control_i.imm_gen_i.iword[16]\
+ VPWR VGND sg13g2_mux4_1
X_20259_ _13544_ \regs.registers[8][21]\ \regs.registers[9][21]\ \regs.registers[10][21]\ \regs.registers[11][21]\ \control_i.imm_gen_i.iword[15]\
+ \control_i.imm_gen_i.iword[16]\
+ VPWR VGND sg13g2_mux4_1
X_20260_ _13545_ \regs.registers[4][21]\ \regs.registers[5][21]\ \regs.registers[6][21]\ \regs.registers[7][21]\ \control_i.imm_gen_i.iword[15]\
+ \control_i.imm_gen_i.iword[16]\
+ VPWR VGND sg13g2_mux4_1
X_20261_ _13546_ \regs.registers[12][21]\ \regs.registers[13][21]\ \regs.registers[14][21]\ \regs.registers[15][21]\ \control_i.imm_gen_i.iword[15]\
+ \control_i.imm_gen_i.iword[16]\
+ VPWR VGND sg13g2_mux4_1
X_20262_ _13547_ _13543_ _13544_ _13545_ _13546_ \control_i.imm_gen_i.iword[18]\
+ \control_i.imm_gen_i.iword[17]\
+ VPWR VGND sg13g2_mux4_1
X_20263_ _00068_ reset _13547_ VPWR VGND sg13g2_and2_1
X_20264_ _13548_ \regs.registers[0][22]\ \regs.registers[1][22]\ \regs.registers[2][22]\ \regs.registers[3][22]\ \control_i.imm_gen_i.iword[15]\
+ \control_i.imm_gen_i.iword[16]\
+ VPWR VGND sg13g2_mux4_1
X_20265_ _13549_ \regs.registers[8][22]\ \regs.registers[9][22]\ \regs.registers[10][22]\ \regs.registers[11][22]\ \control_i.imm_gen_i.iword[15]\
+ \control_i.imm_gen_i.iword[16]\
+ VPWR VGND sg13g2_mux4_1
X_20266_ _13550_ \regs.registers[4][22]\ \regs.registers[5][22]\ \regs.registers[6][22]\ \regs.registers[7][22]\ \control_i.imm_gen_i.iword[15]\
+ \control_i.imm_gen_i.iword[16]\
+ VPWR VGND sg13g2_mux4_1
X_20267_ _13551_ \regs.registers[12][22]\ \regs.registers[13][22]\ \regs.registers[14][22]\ \regs.registers[15][22]\ \control_i.imm_gen_i.iword[15]\
+ \control_i.imm_gen_i.iword[16]\
+ VPWR VGND sg13g2_mux4_1
X_20268_ _13552_ _13548_ _13549_ _13550_ _13551_ \control_i.imm_gen_i.iword[18]\
+ \control_i.imm_gen_i.iword[17]\
+ VPWR VGND sg13g2_mux4_1
X_20269_ _00069_ reset _13552_ VPWR VGND sg13g2_and2_1
X_20270_ _13553_ \regs.registers[0][23]\ \regs.registers[1][23]\ \regs.registers[2][23]\ \regs.registers[3][23]\ \control_i.imm_gen_i.iword[15]\
+ \control_i.imm_gen_i.iword[16]\
+ VPWR VGND sg13g2_mux4_1
X_20271_ _13554_ \regs.registers[8][23]\ \regs.registers[9][23]\ \regs.registers[10][23]\ \regs.registers[11][23]\ \control_i.imm_gen_i.iword[15]\
+ \control_i.imm_gen_i.iword[16]\
+ VPWR VGND sg13g2_mux4_1
X_20272_ _13555_ \regs.registers[4][23]\ \regs.registers[5][23]\ \regs.registers[6][23]\ \regs.registers[7][23]\ \control_i.imm_gen_i.iword[15]\
+ \control_i.imm_gen_i.iword[16]\
+ VPWR VGND sg13g2_mux4_1
X_20273_ _13556_ \regs.registers[12][23]\ \regs.registers[13][23]\ \regs.registers[14][23]\ \regs.registers[15][23]\ \control_i.imm_gen_i.iword[15]\
+ \control_i.imm_gen_i.iword[16]\
+ VPWR VGND sg13g2_mux4_1
X_20274_ _13557_ _13553_ _13554_ _13555_ _13556_ \control_i.imm_gen_i.iword[18]\
+ \control_i.imm_gen_i.iword[17]\
+ VPWR VGND sg13g2_mux4_1
X_20275_ _00070_ reset _13557_ VPWR VGND sg13g2_and2_1
X_20276_ _13558_ \regs.registers[0][24]\ \regs.registers[1][24]\ \regs.registers[2][24]\ \regs.registers[3][24]\ \control_i.imm_gen_i.iword[15]\
+ \control_i.imm_gen_i.iword[16]\
+ VPWR VGND sg13g2_mux4_1
X_20277_ _13559_ \regs.registers[8][24]\ \regs.registers[9][24]\ \regs.registers[10][24]\ \regs.registers[11][24]\ \control_i.imm_gen_i.iword[15]\
+ \control_i.imm_gen_i.iword[16]\
+ VPWR VGND sg13g2_mux4_1
X_20278_ _13560_ \regs.registers[4][24]\ \regs.registers[5][24]\ \regs.registers[6][24]\ \regs.registers[7][24]\ \control_i.imm_gen_i.iword[15]\
+ \control_i.imm_gen_i.iword[16]\
+ VPWR VGND sg13g2_mux4_1
X_20279_ _13561_ \regs.registers[12][24]\ \regs.registers[13][24]\ \regs.registers[14][24]\ \regs.registers[15][24]\ \control_i.imm_gen_i.iword[15]\
+ \control_i.imm_gen_i.iword[16]\
+ VPWR VGND sg13g2_mux4_1
X_20280_ _13562_ _13558_ _13559_ _13560_ _13561_ \control_i.imm_gen_i.iword[18]\
+ \control_i.imm_gen_i.iword[17]\
+ VPWR VGND sg13g2_mux4_1
X_20281_ _00071_ reset _13562_ VPWR VGND sg13g2_and2_1
X_20282_ _13563_ \regs.registers[0][25]\ \regs.registers[1][25]\ \regs.registers[2][25]\ \regs.registers[3][25]\ \control_i.imm_gen_i.iword[15]\
+ \control_i.imm_gen_i.iword[16]\
+ VPWR VGND sg13g2_mux4_1
X_20283_ _13564_ \regs.registers[8][25]\ \regs.registers[9][25]\ \regs.registers[10][25]\ \regs.registers[11][25]\ \control_i.imm_gen_i.iword[15]\
+ \control_i.imm_gen_i.iword[16]\
+ VPWR VGND sg13g2_mux4_1
X_20284_ _13565_ \regs.registers[4][25]\ \regs.registers[5][25]\ \regs.registers[6][25]\ \regs.registers[7][25]\ \control_i.imm_gen_i.iword[15]\
+ \control_i.imm_gen_i.iword[16]\
+ VPWR VGND sg13g2_mux4_1
X_20285_ _13566_ \regs.registers[12][25]\ \regs.registers[13][25]\ \regs.registers[14][25]\ \regs.registers[15][25]\ \control_i.imm_gen_i.iword[15]\
+ \control_i.imm_gen_i.iword[16]\
+ VPWR VGND sg13g2_mux4_1
X_20286_ _13567_ _13563_ _13564_ _13565_ _13566_ \control_i.imm_gen_i.iword[18]\
+ \control_i.imm_gen_i.iword[17]\
+ VPWR VGND sg13g2_mux4_1
X_20287_ _00072_ reset _13567_ VPWR VGND sg13g2_and2_1
X_20288_ _13568_ \regs.registers[0][26]\ \regs.registers[1][26]\ \regs.registers[2][26]\ \regs.registers[3][26]\ \control_i.imm_gen_i.iword[15]\
+ \control_i.imm_gen_i.iword[16]\
+ VPWR VGND sg13g2_mux4_1
X_20289_ _13569_ \regs.registers[8][26]\ \regs.registers[9][26]\ \regs.registers[10][26]\ \regs.registers[11][26]\ \control_i.imm_gen_i.iword[15]\
+ \control_i.imm_gen_i.iword[16]\
+ VPWR VGND sg13g2_mux4_1
X_20290_ _13570_ \regs.registers[4][26]\ \regs.registers[5][26]\ \regs.registers[6][26]\ \regs.registers[7][26]\ \control_i.imm_gen_i.iword[15]\
+ \control_i.imm_gen_i.iword[16]\
+ VPWR VGND sg13g2_mux4_1
X_20291_ _13571_ \regs.registers[12][26]\ \regs.registers[13][26]\ \regs.registers[14][26]\ \regs.registers[15][26]\ \control_i.imm_gen_i.iword[15]\
+ \control_i.imm_gen_i.iword[16]\
+ VPWR VGND sg13g2_mux4_1
X_20292_ _13572_ _13568_ _13569_ _13570_ _13571_ \control_i.imm_gen_i.iword[18]\
+ \control_i.imm_gen_i.iword[17]\
+ VPWR VGND sg13g2_mux4_1
X_20293_ _00073_ reset _13572_ VPWR VGND sg13g2_and2_1
X_20294_ _13573_ \regs.registers[0][27]\ \regs.registers[1][27]\ \regs.registers[2][27]\ \regs.registers[3][27]\ \control_i.imm_gen_i.iword[15]\
+ \control_i.imm_gen_i.iword[16]\
+ VPWR VGND sg13g2_mux4_1
X_20295_ _13574_ \regs.registers[8][27]\ \regs.registers[9][27]\ \regs.registers[10][27]\ \regs.registers[11][27]\ \control_i.imm_gen_i.iword[15]\
+ \control_i.imm_gen_i.iword[16]\
+ VPWR VGND sg13g2_mux4_1
X_20296_ _13575_ \regs.registers[4][27]\ \regs.registers[5][27]\ \regs.registers[6][27]\ \regs.registers[7][27]\ \control_i.imm_gen_i.iword[15]\
+ \control_i.imm_gen_i.iword[16]\
+ VPWR VGND sg13g2_mux4_1
X_20297_ _13576_ \regs.registers[12][27]\ \regs.registers[13][27]\ \regs.registers[14][27]\ \regs.registers[15][27]\ \control_i.imm_gen_i.iword[15]\
+ \control_i.imm_gen_i.iword[16]\
+ VPWR VGND sg13g2_mux4_1
X_20298_ _13577_ _13573_ _13574_ _13575_ _13576_ \control_i.imm_gen_i.iword[18]\
+ \control_i.imm_gen_i.iword[17]\
+ VPWR VGND sg13g2_mux4_1
X_20299_ _00074_ reset _13577_ VPWR VGND sg13g2_and2_1
X_20300_ _13578_ \regs.registers[0][28]\ \regs.registers[1][28]\ \regs.registers[2][28]\ \regs.registers[3][28]\ \control_i.imm_gen_i.iword[15]\
+ \control_i.imm_gen_i.iword[16]\
+ VPWR VGND sg13g2_mux4_1
X_20301_ _13579_ \regs.registers[8][28]\ \regs.registers[9][28]\ \regs.registers[10][28]\ \regs.registers[11][28]\ \control_i.imm_gen_i.iword[15]\
+ \control_i.imm_gen_i.iword[16]\
+ VPWR VGND sg13g2_mux4_1
X_20302_ _13580_ \regs.registers[4][28]\ \regs.registers[5][28]\ \regs.registers[6][28]\ \regs.registers[7][28]\ \control_i.imm_gen_i.iword[15]\
+ \control_i.imm_gen_i.iword[16]\
+ VPWR VGND sg13g2_mux4_1
X_20303_ _13581_ \regs.registers[12][28]\ \regs.registers[13][28]\ \regs.registers[14][28]\ \regs.registers[15][28]\ \control_i.imm_gen_i.iword[15]\
+ \control_i.imm_gen_i.iword[16]\
+ VPWR VGND sg13g2_mux4_1
X_20304_ _13582_ _13578_ _13579_ _13580_ _13581_ \control_i.imm_gen_i.iword[18]\
+ \control_i.imm_gen_i.iword[17]\
+ VPWR VGND sg13g2_mux4_1
X_20305_ _00075_ reset _13582_ VPWR VGND sg13g2_and2_1
X_20306_ _13583_ \regs.registers[0][29]\ \regs.registers[1][29]\ \regs.registers[2][29]\ \regs.registers[3][29]\ \control_i.imm_gen_i.iword[15]\
+ \control_i.imm_gen_i.iword[16]\
+ VPWR VGND sg13g2_mux4_1
X_20307_ _13584_ \regs.registers[8][29]\ \regs.registers[9][29]\ \regs.registers[10][29]\ \regs.registers[11][29]\ \control_i.imm_gen_i.iword[15]\
+ \control_i.imm_gen_i.iword[16]\
+ VPWR VGND sg13g2_mux4_1
X_20308_ _13585_ \regs.registers[4][29]\ \regs.registers[5][29]\ \regs.registers[6][29]\ \regs.registers[7][29]\ \control_i.imm_gen_i.iword[15]\
+ \control_i.imm_gen_i.iword[16]\
+ VPWR VGND sg13g2_mux4_1
X_20309_ _13586_ \regs.registers[12][29]\ \regs.registers[13][29]\ \regs.registers[14][29]\ \regs.registers[15][29]\ \control_i.imm_gen_i.iword[15]\
+ \control_i.imm_gen_i.iword[16]\
+ VPWR VGND sg13g2_mux4_1
X_20310_ _13587_ _13583_ _13584_ _13585_ _13586_ \control_i.imm_gen_i.iword[18]\
+ \control_i.imm_gen_i.iword[17]\
+ VPWR VGND sg13g2_mux4_1
X_20311_ _00076_ reset _13587_ VPWR VGND sg13g2_and2_1
X_20312_ _13588_ \regs.registers[0][30]\ \regs.registers[1][30]\ \regs.registers[2][30]\ \regs.registers[3][30]\ \control_i.imm_gen_i.iword[15]\
+ \control_i.imm_gen_i.iword[16]\
+ VPWR VGND sg13g2_mux4_1
X_20313_ _13589_ \regs.registers[8][30]\ \regs.registers[9][30]\ \regs.registers[10][30]\ \regs.registers[11][30]\ \control_i.imm_gen_i.iword[15]\
+ \control_i.imm_gen_i.iword[16]\
+ VPWR VGND sg13g2_mux4_1
X_20314_ _13590_ \regs.registers[4][30]\ \regs.registers[5][30]\ \regs.registers[6][30]\ \regs.registers[7][30]\ \control_i.imm_gen_i.iword[15]\
+ \control_i.imm_gen_i.iword[16]\
+ VPWR VGND sg13g2_mux4_1
X_20315_ _13591_ \regs.registers[12][30]\ \regs.registers[13][30]\ \regs.registers[14][30]\ \regs.registers[15][30]\ \control_i.imm_gen_i.iword[15]\
+ \control_i.imm_gen_i.iword[16]\
+ VPWR VGND sg13g2_mux4_1
X_20316_ _13592_ _13588_ _13589_ _13590_ _13591_ \control_i.imm_gen_i.iword[18]\
+ \control_i.imm_gen_i.iword[17]\
+ VPWR VGND sg13g2_mux4_1
X_20317_ _00077_ reset _13592_ VPWR VGND sg13g2_and2_1
X_20318_ _13593_ \regs.registers[0][31]\ \regs.registers[1][31]\ \regs.registers[2][31]\ \regs.registers[3][31]\ \control_i.imm_gen_i.iword[15]\
+ \control_i.imm_gen_i.iword[16]\
+ VPWR VGND sg13g2_mux4_1
X_20319_ _13594_ \regs.registers[8][31]\ \regs.registers[9][31]\ \regs.registers[10][31]\ \regs.registers[11][31]\ \control_i.imm_gen_i.iword[15]\
+ \control_i.imm_gen_i.iword[16]\
+ VPWR VGND sg13g2_mux4_1
X_20320_ _13595_ \regs.registers[4][31]\ \regs.registers[5][31]\ \regs.registers[6][31]\ \regs.registers[7][31]\ \control_i.imm_gen_i.iword[15]\
+ \control_i.imm_gen_i.iword[16]\
+ VPWR VGND sg13g2_mux4_1
X_20321_ _13596_ \regs.registers[12][31]\ \regs.registers[13][31]\ \regs.registers[14][31]\ \regs.registers[15][31]\ \control_i.imm_gen_i.iword[15]\
+ \control_i.imm_gen_i.iword[16]\
+ VPWR VGND sg13g2_mux4_1
X_20322_ _13597_ _13593_ _13594_ _13595_ _13596_ \control_i.imm_gen_i.iword[18]\
+ \control_i.imm_gen_i.iword[17]\
+ VPWR VGND sg13g2_mux4_1
X_20323_ _00078_ reset _13597_ VPWR VGND sg13g2_and2_1
X_20324_ _13598_ \regs.registers[0][0]\ \regs.registers[1][0]\ \regs.registers[2][0]\ \regs.registers[3][0]\ \control_i.imm_gen_i.iword[20]\
+ \control_i.imm_gen_i.iword[21]\
+ VPWR VGND sg13g2_mux4_1
X_20325_ _13599_ \regs.registers[8][0]\ \regs.registers[9][0]\ \regs.registers[10][0]\ \regs.registers[11][0]\ \control_i.imm_gen_i.iword[20]\
+ \control_i.imm_gen_i.iword[21]\
+ VPWR VGND sg13g2_mux4_1
X_20326_ _13600_ \regs.registers[4][0]\ \regs.registers[5][0]\ \regs.registers[6][0]\ \regs.registers[7][0]\ \control_i.imm_gen_i.iword[20]\
+ \control_i.imm_gen_i.iword[21]\
+ VPWR VGND sg13g2_mux4_1
X_20327_ _13601_ \regs.registers[12][0]\ \regs.registers[13][0]\ \regs.registers[14][0]\ \regs.registers[15][0]\ \control_i.imm_gen_i.iword[20]\
+ \control_i.imm_gen_i.iword[21]\
+ VPWR VGND sg13g2_mux4_1
X_20328_ _13602_ _13598_ _13599_ _13600_ _13601_ \control_i.imm_gen_i.iword[23]\
+ \control_i.imm_gen_i.iword[22]\
+ VPWR VGND sg13g2_mux4_1
X_20329_ _00079_ reset _13602_ VPWR VGND sg13g2_and2_1
X_20330_ _13603_ \regs.registers[0][1]\ \regs.registers[1][1]\ \regs.registers[2][1]\ \regs.registers[3][1]\ \control_i.imm_gen_i.iword[20]\
+ \control_i.imm_gen_i.iword[21]\
+ VPWR VGND sg13g2_mux4_1
X_20331_ _13604_ \regs.registers[8][1]\ \regs.registers[9][1]\ \regs.registers[10][1]\ \regs.registers[11][1]\ \control_i.imm_gen_i.iword[20]\
+ \control_i.imm_gen_i.iword[21]\
+ VPWR VGND sg13g2_mux4_1
X_20332_ _13605_ \regs.registers[4][1]\ \regs.registers[5][1]\ \regs.registers[6][1]\ \regs.registers[7][1]\ \control_i.imm_gen_i.iword[20]\
+ \control_i.imm_gen_i.iword[21]\
+ VPWR VGND sg13g2_mux4_1
X_20333_ _13606_ \regs.registers[12][1]\ \regs.registers[13][1]\ \regs.registers[14][1]\ \regs.registers[15][1]\ \control_i.imm_gen_i.iword[20]\
+ \control_i.imm_gen_i.iword[21]\
+ VPWR VGND sg13g2_mux4_1
X_20334_ _13607_ _13603_ _13604_ _13605_ _13606_ \control_i.imm_gen_i.iword[23]\
+ \control_i.imm_gen_i.iword[22]\
+ VPWR VGND sg13g2_mux4_1
X_20335_ _00080_ reset _13607_ VPWR VGND sg13g2_and2_1
X_20336_ _13608_ \regs.registers[0][2]\ \regs.registers[1][2]\ \regs.registers[2][2]\ \regs.registers[3][2]\ \control_i.imm_gen_i.iword[20]\
+ \control_i.imm_gen_i.iword[21]\
+ VPWR VGND sg13g2_mux4_1
X_20337_ _13609_ \regs.registers[8][2]\ \regs.registers[9][2]\ \regs.registers[10][2]\ \regs.registers[11][2]\ \control_i.imm_gen_i.iword[20]\
+ \control_i.imm_gen_i.iword[21]\
+ VPWR VGND sg13g2_mux4_1
X_20338_ _13610_ \regs.registers[4][2]\ \regs.registers[5][2]\ \regs.registers[6][2]\ \regs.registers[7][2]\ \control_i.imm_gen_i.iword[20]\
+ \control_i.imm_gen_i.iword[21]\
+ VPWR VGND sg13g2_mux4_1
X_20339_ _13611_ \regs.registers[12][2]\ \regs.registers[13][2]\ \regs.registers[14][2]\ \regs.registers[15][2]\ \control_i.imm_gen_i.iword[20]\
+ \control_i.imm_gen_i.iword[21]\
+ VPWR VGND sg13g2_mux4_1
X_20340_ _13612_ _13608_ _13609_ _13610_ _13611_ \control_i.imm_gen_i.iword[23]\
+ \control_i.imm_gen_i.iword[22]\
+ VPWR VGND sg13g2_mux4_1
X_20341_ _00081_ reset _13612_ VPWR VGND sg13g2_and2_1
X_20342_ _13613_ \regs.registers[0][3]\ \regs.registers[1][3]\ \regs.registers[2][3]\ \regs.registers[3][3]\ \control_i.imm_gen_i.iword[20]\
+ \control_i.imm_gen_i.iword[21]\
+ VPWR VGND sg13g2_mux4_1
X_20343_ _13614_ \regs.registers[8][3]\ \regs.registers[9][3]\ \regs.registers[10][3]\ \regs.registers[11][3]\ \control_i.imm_gen_i.iword[20]\
+ \control_i.imm_gen_i.iword[21]\
+ VPWR VGND sg13g2_mux4_1
X_20344_ _13615_ \regs.registers[4][3]\ \regs.registers[5][3]\ \regs.registers[6][3]\ \regs.registers[7][3]\ \control_i.imm_gen_i.iword[20]\
+ \control_i.imm_gen_i.iword[21]\
+ VPWR VGND sg13g2_mux4_1
X_20345_ _13616_ \regs.registers[12][3]\ \regs.registers[13][3]\ \regs.registers[14][3]\ \regs.registers[15][3]\ \control_i.imm_gen_i.iword[20]\
+ \control_i.imm_gen_i.iword[21]\
+ VPWR VGND sg13g2_mux4_1
X_20346_ _13617_ _13613_ _13614_ _13615_ _13616_ \control_i.imm_gen_i.iword[23]\
+ \control_i.imm_gen_i.iword[22]\
+ VPWR VGND sg13g2_mux4_1
X_20347_ _00082_ reset _13617_ VPWR VGND sg13g2_and2_1
X_20348_ _13618_ \regs.registers[0][4]\ \regs.registers[1][4]\ \regs.registers[2][4]\ \regs.registers[3][4]\ \control_i.imm_gen_i.iword[20]\
+ \control_i.imm_gen_i.iword[21]\
+ VPWR VGND sg13g2_mux4_1
X_20349_ _13619_ \regs.registers[8][4]\ \regs.registers[9][4]\ \regs.registers[10][4]\ \regs.registers[11][4]\ \control_i.imm_gen_i.iword[20]\
+ \control_i.imm_gen_i.iword[21]\
+ VPWR VGND sg13g2_mux4_1
X_20350_ _13620_ \regs.registers[4][4]\ \regs.registers[5][4]\ \regs.registers[6][4]\ \regs.registers[7][4]\ \control_i.imm_gen_i.iword[20]\
+ \control_i.imm_gen_i.iword[21]\
+ VPWR VGND sg13g2_mux4_1
X_20351_ _13621_ \regs.registers[12][4]\ \regs.registers[13][4]\ \regs.registers[14][4]\ \regs.registers[15][4]\ \control_i.imm_gen_i.iword[20]\
+ \control_i.imm_gen_i.iword[21]\
+ VPWR VGND sg13g2_mux4_1
X_20352_ _13622_ _13618_ _13619_ _13620_ _13621_ \control_i.imm_gen_i.iword[23]\
+ \control_i.imm_gen_i.iword[22]\
+ VPWR VGND sg13g2_mux4_1
X_20353_ _00083_ reset _13622_ VPWR VGND sg13g2_and2_1
X_20354_ _13623_ \regs.registers[0][5]\ \regs.registers[1][5]\ \regs.registers[2][5]\ \regs.registers[3][5]\ \control_i.imm_gen_i.iword[20]\
+ \control_i.imm_gen_i.iword[21]\
+ VPWR VGND sg13g2_mux4_1
X_20355_ _13624_ \regs.registers[8][5]\ \regs.registers[9][5]\ \regs.registers[10][5]\ \regs.registers[11][5]\ \control_i.imm_gen_i.iword[20]\
+ \control_i.imm_gen_i.iword[21]\
+ VPWR VGND sg13g2_mux4_1
X_20356_ _13625_ \regs.registers[4][5]\ \regs.registers[5][5]\ \regs.registers[6][5]\ \regs.registers[7][5]\ \control_i.imm_gen_i.iword[20]\
+ \control_i.imm_gen_i.iword[21]\
+ VPWR VGND sg13g2_mux4_1
X_20357_ _13626_ \regs.registers[12][5]\ \regs.registers[13][5]\ \regs.registers[14][5]\ \regs.registers[15][5]\ \control_i.imm_gen_i.iword[20]\
+ \control_i.imm_gen_i.iword[21]\
+ VPWR VGND sg13g2_mux4_1
X_20358_ _13627_ _13623_ _13624_ _13625_ _13626_ \control_i.imm_gen_i.iword[23]\
+ \control_i.imm_gen_i.iword[22]\
+ VPWR VGND sg13g2_mux4_1
X_20359_ _00084_ reset _13627_ VPWR VGND sg13g2_and2_1
X_20360_ _13628_ \regs.registers[0][6]\ \regs.registers[1][6]\ \regs.registers[2][6]\ \regs.registers[3][6]\ \control_i.imm_gen_i.iword[20]\
+ \control_i.imm_gen_i.iword[21]\
+ VPWR VGND sg13g2_mux4_1
X_20361_ _13629_ \regs.registers[8][6]\ \regs.registers[9][6]\ \regs.registers[10][6]\ \regs.registers[11][6]\ \control_i.imm_gen_i.iword[20]\
+ \control_i.imm_gen_i.iword[21]\
+ VPWR VGND sg13g2_mux4_1
X_20362_ _13630_ \regs.registers[4][6]\ \regs.registers[5][6]\ \regs.registers[6][6]\ \regs.registers[7][6]\ \control_i.imm_gen_i.iword[20]\
+ \control_i.imm_gen_i.iword[21]\
+ VPWR VGND sg13g2_mux4_1
X_20363_ _13631_ \regs.registers[12][6]\ \regs.registers[13][6]\ \regs.registers[14][6]\ \regs.registers[15][6]\ \control_i.imm_gen_i.iword[20]\
+ \control_i.imm_gen_i.iword[21]\
+ VPWR VGND sg13g2_mux4_1
X_20364_ _13632_ _13628_ _13629_ _13630_ _13631_ \control_i.imm_gen_i.iword[23]\
+ \control_i.imm_gen_i.iword[22]\
+ VPWR VGND sg13g2_mux4_1
X_20365_ _00085_ reset _13632_ VPWR VGND sg13g2_and2_1
X_20366_ _13633_ \regs.registers[0][7]\ \regs.registers[1][7]\ \regs.registers[2][7]\ \regs.registers[3][7]\ \control_i.imm_gen_i.iword[20]\
+ \control_i.imm_gen_i.iword[21]\
+ VPWR VGND sg13g2_mux4_1
X_20367_ _13634_ \regs.registers[8][7]\ \regs.registers[9][7]\ \regs.registers[10][7]\ \regs.registers[11][7]\ \control_i.imm_gen_i.iword[20]\
+ \control_i.imm_gen_i.iword[21]\
+ VPWR VGND sg13g2_mux4_1
X_20368_ _13635_ \regs.registers[4][7]\ \regs.registers[5][7]\ \regs.registers[6][7]\ \regs.registers[7][7]\ \control_i.imm_gen_i.iword[20]\
+ \control_i.imm_gen_i.iword[21]\
+ VPWR VGND sg13g2_mux4_1
X_20369_ _13636_ \regs.registers[12][7]\ \regs.registers[13][7]\ \regs.registers[14][7]\ \regs.registers[15][7]\ \control_i.imm_gen_i.iword[20]\
+ \control_i.imm_gen_i.iword[21]\
+ VPWR VGND sg13g2_mux4_1
X_20370_ _13637_ _13633_ _13634_ _13635_ _13636_ \control_i.imm_gen_i.iword[23]\
+ \control_i.imm_gen_i.iword[22]\
+ VPWR VGND sg13g2_mux4_1
X_20371_ _00086_ reset _13637_ VPWR VGND sg13g2_and2_1
X_20372_ _13638_ \regs.registers[0][8]\ \regs.registers[1][8]\ \regs.registers[2][8]\ \regs.registers[3][8]\ \control_i.imm_gen_i.iword[20]\
+ \control_i.imm_gen_i.iword[21]\
+ VPWR VGND sg13g2_mux4_1
X_20373_ _13639_ \regs.registers[8][8]\ \regs.registers[9][8]\ \regs.registers[10][8]\ \regs.registers[11][8]\ \control_i.imm_gen_i.iword[20]\
+ \control_i.imm_gen_i.iword[21]\
+ VPWR VGND sg13g2_mux4_1
X_20374_ _13640_ \regs.registers[4][8]\ \regs.registers[5][8]\ \regs.registers[6][8]\ \regs.registers[7][8]\ \control_i.imm_gen_i.iword[20]\
+ \control_i.imm_gen_i.iword[21]\
+ VPWR VGND sg13g2_mux4_1
X_20375_ _13641_ \regs.registers[12][8]\ \regs.registers[13][8]\ \regs.registers[14][8]\ \regs.registers[15][8]\ \control_i.imm_gen_i.iword[20]\
+ \control_i.imm_gen_i.iword[21]\
+ VPWR VGND sg13g2_mux4_1
X_20376_ _13642_ _13638_ _13639_ _13640_ _13641_ \control_i.imm_gen_i.iword[23]\
+ \control_i.imm_gen_i.iword[22]\
+ VPWR VGND sg13g2_mux4_1
X_20377_ _00087_ reset _13642_ VPWR VGND sg13g2_and2_1
X_20378_ _13643_ \regs.registers[0][9]\ \regs.registers[1][9]\ \regs.registers[2][9]\ \regs.registers[3][9]\ \control_i.imm_gen_i.iword[20]\
+ \control_i.imm_gen_i.iword[21]\
+ VPWR VGND sg13g2_mux4_1
X_20379_ _13644_ \regs.registers[8][9]\ \regs.registers[9][9]\ \regs.registers[10][9]\ \regs.registers[11][9]\ \control_i.imm_gen_i.iword[20]\
+ \control_i.imm_gen_i.iword[21]\
+ VPWR VGND sg13g2_mux4_1
X_20380_ _13645_ \regs.registers[4][9]\ \regs.registers[5][9]\ \regs.registers[6][9]\ \regs.registers[7][9]\ \control_i.imm_gen_i.iword[20]\
+ \control_i.imm_gen_i.iword[21]\
+ VPWR VGND sg13g2_mux4_1
X_20381_ _13646_ \regs.registers[12][9]\ \regs.registers[13][9]\ \regs.registers[14][9]\ \regs.registers[15][9]\ \control_i.imm_gen_i.iword[20]\
+ \control_i.imm_gen_i.iword[21]\
+ VPWR VGND sg13g2_mux4_1
X_20382_ _13647_ _13643_ _13644_ _13645_ _13646_ \control_i.imm_gen_i.iword[23]\
+ \control_i.imm_gen_i.iword[22]\
+ VPWR VGND sg13g2_mux4_1
X_20383_ _00088_ reset _13647_ VPWR VGND sg13g2_and2_1
X_20384_ _13648_ \regs.registers[0][10]\ \regs.registers[1][10]\ \regs.registers[2][10]\ \regs.registers[3][10]\ \control_i.imm_gen_i.iword[20]\
+ \control_i.imm_gen_i.iword[21]\
+ VPWR VGND sg13g2_mux4_1
X_20385_ _13649_ \regs.registers[8][10]\ \regs.registers[9][10]\ \regs.registers[10][10]\ \regs.registers[11][10]\ \control_i.imm_gen_i.iword[20]\
+ \control_i.imm_gen_i.iword[21]\
+ VPWR VGND sg13g2_mux4_1
X_20386_ _13650_ \regs.registers[4][10]\ \regs.registers[5][10]\ \regs.registers[6][10]\ \regs.registers[7][10]\ \control_i.imm_gen_i.iword[20]\
+ \control_i.imm_gen_i.iword[21]\
+ VPWR VGND sg13g2_mux4_1
X_20387_ _13651_ \regs.registers[12][10]\ \regs.registers[13][10]\ \regs.registers[14][10]\ \regs.registers[15][10]\ \control_i.imm_gen_i.iword[20]\
+ \control_i.imm_gen_i.iword[21]\
+ VPWR VGND sg13g2_mux4_1
X_20388_ _13652_ _13648_ _13649_ _13650_ _13651_ \control_i.imm_gen_i.iword[23]\
+ \control_i.imm_gen_i.iword[22]\
+ VPWR VGND sg13g2_mux4_1
X_20389_ _00089_ reset _13652_ VPWR VGND sg13g2_and2_1
X_20390_ _13653_ \regs.registers[0][11]\ \regs.registers[1][11]\ \regs.registers[2][11]\ \regs.registers[3][11]\ \control_i.imm_gen_i.iword[20]\
+ \control_i.imm_gen_i.iword[21]\
+ VPWR VGND sg13g2_mux4_1
X_20391_ _13654_ \regs.registers[8][11]\ \regs.registers[9][11]\ \regs.registers[10][11]\ \regs.registers[11][11]\ \control_i.imm_gen_i.iword[20]\
+ \control_i.imm_gen_i.iword[21]\
+ VPWR VGND sg13g2_mux4_1
X_20392_ _13655_ \regs.registers[4][11]\ \regs.registers[5][11]\ \regs.registers[6][11]\ \regs.registers[7][11]\ \control_i.imm_gen_i.iword[20]\
+ \control_i.imm_gen_i.iword[21]\
+ VPWR VGND sg13g2_mux4_1
X_20393_ _13656_ \regs.registers[12][11]\ \regs.registers[13][11]\ \regs.registers[14][11]\ \regs.registers[15][11]\ \control_i.imm_gen_i.iword[20]\
+ \control_i.imm_gen_i.iword[21]\
+ VPWR VGND sg13g2_mux4_1
X_20394_ _13657_ _13653_ _13654_ _13655_ _13656_ \control_i.imm_gen_i.iword[23]\
+ \control_i.imm_gen_i.iword[22]\
+ VPWR VGND sg13g2_mux4_1
X_20395_ _00090_ reset _13657_ VPWR VGND sg13g2_and2_1
X_20396_ _13658_ \regs.registers[0][12]\ \regs.registers[1][12]\ \regs.registers[2][12]\ \regs.registers[3][12]\ \control_i.imm_gen_i.iword[20]\
+ \control_i.imm_gen_i.iword[21]\
+ VPWR VGND sg13g2_mux4_1
X_20397_ _13659_ \regs.registers[8][12]\ \regs.registers[9][12]\ \regs.registers[10][12]\ \regs.registers[11][12]\ \control_i.imm_gen_i.iword[20]\
+ \control_i.imm_gen_i.iword[21]\
+ VPWR VGND sg13g2_mux4_1
X_20398_ _13660_ \regs.registers[4][12]\ \regs.registers[5][12]\ \regs.registers[6][12]\ \regs.registers[7][12]\ \control_i.imm_gen_i.iword[20]\
+ \control_i.imm_gen_i.iword[21]\
+ VPWR VGND sg13g2_mux4_1
X_20399_ _13661_ \regs.registers[12][12]\ \regs.registers[13][12]\ \regs.registers[14][12]\ \regs.registers[15][12]\ \control_i.imm_gen_i.iword[20]\
+ \control_i.imm_gen_i.iword[21]\
+ VPWR VGND sg13g2_mux4_1
X_20400_ _13662_ _13658_ _13659_ _13660_ _13661_ \control_i.imm_gen_i.iword[23]\
+ \control_i.imm_gen_i.iword[22]\
+ VPWR VGND sg13g2_mux4_1
X_20401_ _00091_ reset _13662_ VPWR VGND sg13g2_and2_1
X_20402_ _13663_ \regs.registers[0][13]\ \regs.registers[1][13]\ \regs.registers[2][13]\ \regs.registers[3][13]\ \control_i.imm_gen_i.iword[20]\
+ \control_i.imm_gen_i.iword[21]\
+ VPWR VGND sg13g2_mux4_1
X_20403_ _13664_ \regs.registers[8][13]\ \regs.registers[9][13]\ \regs.registers[10][13]\ \regs.registers[11][13]\ \control_i.imm_gen_i.iword[20]\
+ \control_i.imm_gen_i.iword[21]\
+ VPWR VGND sg13g2_mux4_1
X_20404_ _13665_ \regs.registers[4][13]\ \regs.registers[5][13]\ \regs.registers[6][13]\ \regs.registers[7][13]\ \control_i.imm_gen_i.iword[20]\
+ \control_i.imm_gen_i.iword[21]\
+ VPWR VGND sg13g2_mux4_1
X_20405_ _13666_ \regs.registers[12][13]\ \regs.registers[13][13]\ \regs.registers[14][13]\ \regs.registers[15][13]\ \control_i.imm_gen_i.iword[20]\
+ \control_i.imm_gen_i.iword[21]\
+ VPWR VGND sg13g2_mux4_1
X_20406_ _13667_ _13663_ _13664_ _13665_ _13666_ \control_i.imm_gen_i.iword[23]\
+ \control_i.imm_gen_i.iword[22]\
+ VPWR VGND sg13g2_mux4_1
X_20407_ _00092_ reset _13667_ VPWR VGND sg13g2_and2_1
X_20408_ _13668_ \regs.registers[0][14]\ \regs.registers[1][14]\ \regs.registers[2][14]\ \regs.registers[3][14]\ \control_i.imm_gen_i.iword[20]\
+ \control_i.imm_gen_i.iword[21]\
+ VPWR VGND sg13g2_mux4_1
X_20409_ _13669_ \regs.registers[8][14]\ \regs.registers[9][14]\ \regs.registers[10][14]\ \regs.registers[11][14]\ \control_i.imm_gen_i.iword[20]\
+ \control_i.imm_gen_i.iword[21]\
+ VPWR VGND sg13g2_mux4_1
X_20410_ _13670_ \regs.registers[4][14]\ \regs.registers[5][14]\ \regs.registers[6][14]\ \regs.registers[7][14]\ \control_i.imm_gen_i.iword[20]\
+ \control_i.imm_gen_i.iword[21]\
+ VPWR VGND sg13g2_mux4_1
X_20411_ _13671_ \regs.registers[12][14]\ \regs.registers[13][14]\ \regs.registers[14][14]\ \regs.registers[15][14]\ \control_i.imm_gen_i.iword[20]\
+ \control_i.imm_gen_i.iword[21]\
+ VPWR VGND sg13g2_mux4_1
X_20412_ _13672_ _13668_ _13669_ _13670_ _13671_ \control_i.imm_gen_i.iword[23]\
+ \control_i.imm_gen_i.iword[22]\
+ VPWR VGND sg13g2_mux4_1
X_20413_ _00093_ reset _13672_ VPWR VGND sg13g2_and2_1
X_20414_ _13673_ \regs.registers[0][15]\ \regs.registers[1][15]\ \regs.registers[2][15]\ \regs.registers[3][15]\ \control_i.imm_gen_i.iword[20]\
+ \control_i.imm_gen_i.iword[21]\
+ VPWR VGND sg13g2_mux4_1
X_20415_ _13674_ \regs.registers[8][15]\ \regs.registers[9][15]\ \regs.registers[10][15]\ \regs.registers[11][15]\ \control_i.imm_gen_i.iword[20]\
+ \control_i.imm_gen_i.iword[21]\
+ VPWR VGND sg13g2_mux4_1
X_20416_ _13675_ \regs.registers[4][15]\ \regs.registers[5][15]\ \regs.registers[6][15]\ \regs.registers[7][15]\ \control_i.imm_gen_i.iword[20]\
+ \control_i.imm_gen_i.iword[21]\
+ VPWR VGND sg13g2_mux4_1
X_20417_ _13676_ \regs.registers[12][15]\ \regs.registers[13][15]\ \regs.registers[14][15]\ \regs.registers[15][15]\ \control_i.imm_gen_i.iword[20]\
+ \control_i.imm_gen_i.iword[21]\
+ VPWR VGND sg13g2_mux4_1
X_20418_ _13677_ _13673_ _13674_ _13675_ _13676_ \control_i.imm_gen_i.iword[23]\
+ \control_i.imm_gen_i.iword[22]\
+ VPWR VGND sg13g2_mux4_1
X_20419_ _00094_ reset _13677_ VPWR VGND sg13g2_and2_1
X_20420_ _13678_ \regs.registers[0][16]\ \regs.registers[1][16]\ \regs.registers[2][16]\ \regs.registers[3][16]\ \control_i.imm_gen_i.iword[20]\
+ \control_i.imm_gen_i.iword[21]\
+ VPWR VGND sg13g2_mux4_1
X_20421_ _13679_ \regs.registers[8][16]\ \regs.registers[9][16]\ \regs.registers[10][16]\ \regs.registers[11][16]\ \control_i.imm_gen_i.iword[20]\
+ \control_i.imm_gen_i.iword[21]\
+ VPWR VGND sg13g2_mux4_1
X_20422_ _13680_ \regs.registers[4][16]\ \regs.registers[5][16]\ \regs.registers[6][16]\ \regs.registers[7][16]\ \control_i.imm_gen_i.iword[20]\
+ \control_i.imm_gen_i.iword[21]\
+ VPWR VGND sg13g2_mux4_1
X_20423_ _13681_ \regs.registers[12][16]\ \regs.registers[13][16]\ \regs.registers[14][16]\ \regs.registers[15][16]\ \control_i.imm_gen_i.iword[20]\
+ \control_i.imm_gen_i.iword[21]\
+ VPWR VGND sg13g2_mux4_1
X_20424_ _13682_ _13678_ _13679_ _13680_ _13681_ \control_i.imm_gen_i.iword[23]\
+ \control_i.imm_gen_i.iword[22]\
+ VPWR VGND sg13g2_mux4_1
X_20425_ _00095_ reset _13682_ VPWR VGND sg13g2_and2_1
X_20426_ _13683_ \regs.registers[0][17]\ \regs.registers[1][17]\ \regs.registers[2][17]\ \regs.registers[3][17]\ \control_i.imm_gen_i.iword[20]\
+ \control_i.imm_gen_i.iword[21]\
+ VPWR VGND sg13g2_mux4_1
X_20427_ _13684_ \regs.registers[8][17]\ \regs.registers[9][17]\ \regs.registers[10][17]\ \regs.registers[11][17]\ \control_i.imm_gen_i.iword[20]\
+ \control_i.imm_gen_i.iword[21]\
+ VPWR VGND sg13g2_mux4_1
X_20428_ _13685_ \regs.registers[4][17]\ \regs.registers[5][17]\ \regs.registers[6][17]\ \regs.registers[7][17]\ \control_i.imm_gen_i.iword[20]\
+ \control_i.imm_gen_i.iword[21]\
+ VPWR VGND sg13g2_mux4_1
X_20429_ _13686_ \regs.registers[12][17]\ \regs.registers[13][17]\ \regs.registers[14][17]\ \regs.registers[15][17]\ \control_i.imm_gen_i.iword[20]\
+ \control_i.imm_gen_i.iword[21]\
+ VPWR VGND sg13g2_mux4_1
X_20430_ _13687_ _13683_ _13684_ _13685_ _13686_ \control_i.imm_gen_i.iword[23]\
+ \control_i.imm_gen_i.iword[22]\
+ VPWR VGND sg13g2_mux4_1
X_20431_ _00096_ reset _13687_ VPWR VGND sg13g2_and2_1
X_20432_ _13688_ \regs.registers[0][18]\ \regs.registers[1][18]\ \regs.registers[2][18]\ \regs.registers[3][18]\ \control_i.imm_gen_i.iword[20]\
+ \control_i.imm_gen_i.iword[21]\
+ VPWR VGND sg13g2_mux4_1
X_20433_ _13689_ \regs.registers[8][18]\ \regs.registers[9][18]\ \regs.registers[10][18]\ \regs.registers[11][18]\ \control_i.imm_gen_i.iword[20]\
+ \control_i.imm_gen_i.iword[21]\
+ VPWR VGND sg13g2_mux4_1
X_20434_ _13690_ \regs.registers[4][18]\ \regs.registers[5][18]\ \regs.registers[6][18]\ \regs.registers[7][18]\ \control_i.imm_gen_i.iword[20]\
+ \control_i.imm_gen_i.iword[21]\
+ VPWR VGND sg13g2_mux4_1
X_20435_ _13691_ \regs.registers[12][18]\ \regs.registers[13][18]\ \regs.registers[14][18]\ \regs.registers[15][18]\ \control_i.imm_gen_i.iword[20]\
+ \control_i.imm_gen_i.iword[21]\
+ VPWR VGND sg13g2_mux4_1
X_20436_ _13692_ _13688_ _13689_ _13690_ _13691_ \control_i.imm_gen_i.iword[23]\
+ \control_i.imm_gen_i.iword[22]\
+ VPWR VGND sg13g2_mux4_1
X_20437_ _00097_ reset _13692_ VPWR VGND sg13g2_and2_1
X_20438_ _13693_ \regs.registers[0][19]\ \regs.registers[1][19]\ \regs.registers[2][19]\ \regs.registers[3][19]\ \control_i.imm_gen_i.iword[20]\
+ \control_i.imm_gen_i.iword[21]\
+ VPWR VGND sg13g2_mux4_1
X_20439_ _13694_ \regs.registers[8][19]\ \regs.registers[9][19]\ \regs.registers[10][19]\ \regs.registers[11][19]\ \control_i.imm_gen_i.iword[20]\
+ \control_i.imm_gen_i.iword[21]\
+ VPWR VGND sg13g2_mux4_1
X_20440_ _13695_ \regs.registers[4][19]\ \regs.registers[5][19]\ \regs.registers[6][19]\ \regs.registers[7][19]\ \control_i.imm_gen_i.iword[20]\
+ \control_i.imm_gen_i.iword[21]\
+ VPWR VGND sg13g2_mux4_1
X_20441_ _13696_ \regs.registers[12][19]\ \regs.registers[13][19]\ \regs.registers[14][19]\ \regs.registers[15][19]\ \control_i.imm_gen_i.iword[20]\
+ \control_i.imm_gen_i.iword[21]\
+ VPWR VGND sg13g2_mux4_1
X_20442_ _13697_ _13693_ _13694_ _13695_ _13696_ \control_i.imm_gen_i.iword[23]\
+ \control_i.imm_gen_i.iword[22]\
+ VPWR VGND sg13g2_mux4_1
X_20443_ _00098_ reset _13697_ VPWR VGND sg13g2_and2_1
X_20444_ _13698_ \regs.registers[0][20]\ \regs.registers[1][20]\ \regs.registers[2][20]\ \regs.registers[3][20]\ \control_i.imm_gen_i.iword[20]\
+ \control_i.imm_gen_i.iword[21]\
+ VPWR VGND sg13g2_mux4_1
X_20445_ _13699_ \regs.registers[8][20]\ \regs.registers[9][20]\ \regs.registers[10][20]\ \regs.registers[11][20]\ \control_i.imm_gen_i.iword[20]\
+ \control_i.imm_gen_i.iword[21]\
+ VPWR VGND sg13g2_mux4_1
X_20446_ _13700_ \regs.registers[4][20]\ \regs.registers[5][20]\ \regs.registers[6][20]\ \regs.registers[7][20]\ \control_i.imm_gen_i.iword[20]\
+ \control_i.imm_gen_i.iword[21]\
+ VPWR VGND sg13g2_mux4_1
X_20447_ _13701_ \regs.registers[12][20]\ \regs.registers[13][20]\ \regs.registers[14][20]\ \regs.registers[15][20]\ \control_i.imm_gen_i.iword[20]\
+ \control_i.imm_gen_i.iword[21]\
+ VPWR VGND sg13g2_mux4_1
X_20448_ _13702_ _13698_ _13699_ _13700_ _13701_ \control_i.imm_gen_i.iword[23]\
+ \control_i.imm_gen_i.iword[22]\
+ VPWR VGND sg13g2_mux4_1
X_20449_ _00099_ reset _13702_ VPWR VGND sg13g2_and2_1
X_20450_ _13703_ \regs.registers[0][21]\ \regs.registers[1][21]\ \regs.registers[2][21]\ \regs.registers[3][21]\ \control_i.imm_gen_i.iword[20]\
+ \control_i.imm_gen_i.iword[21]\
+ VPWR VGND sg13g2_mux4_1
X_20451_ _13704_ \regs.registers[8][21]\ \regs.registers[9][21]\ \regs.registers[10][21]\ \regs.registers[11][21]\ \control_i.imm_gen_i.iword[20]\
+ \control_i.imm_gen_i.iword[21]\
+ VPWR VGND sg13g2_mux4_1
X_20452_ _13705_ \regs.registers[4][21]\ \regs.registers[5][21]\ \regs.registers[6][21]\ \regs.registers[7][21]\ \control_i.imm_gen_i.iword[20]\
+ \control_i.imm_gen_i.iword[21]\
+ VPWR VGND sg13g2_mux4_1
X_20453_ _13706_ \regs.registers[12][21]\ \regs.registers[13][21]\ \regs.registers[14][21]\ \regs.registers[15][21]\ \control_i.imm_gen_i.iword[20]\
+ \control_i.imm_gen_i.iword[21]\
+ VPWR VGND sg13g2_mux4_1
X_20454_ _13707_ _13703_ _13704_ _13705_ _13706_ \control_i.imm_gen_i.iword[23]\
+ \control_i.imm_gen_i.iword[22]\
+ VPWR VGND sg13g2_mux4_1
X_20455_ _00100_ reset _13707_ VPWR VGND sg13g2_and2_1
X_20456_ _13708_ \regs.registers[0][22]\ \regs.registers[1][22]\ \regs.registers[2][22]\ \regs.registers[3][22]\ \control_i.imm_gen_i.iword[20]\
+ \control_i.imm_gen_i.iword[21]\
+ VPWR VGND sg13g2_mux4_1
X_20457_ _13709_ \regs.registers[8][22]\ \regs.registers[9][22]\ \regs.registers[10][22]\ \regs.registers[11][22]\ \control_i.imm_gen_i.iword[20]\
+ \control_i.imm_gen_i.iword[21]\
+ VPWR VGND sg13g2_mux4_1
X_20458_ _13710_ \regs.registers[4][22]\ \regs.registers[5][22]\ \regs.registers[6][22]\ \regs.registers[7][22]\ \control_i.imm_gen_i.iword[20]\
+ \control_i.imm_gen_i.iword[21]\
+ VPWR VGND sg13g2_mux4_1
X_20459_ _13711_ \regs.registers[12][22]\ \regs.registers[13][22]\ \regs.registers[14][22]\ \regs.registers[15][22]\ \control_i.imm_gen_i.iword[20]\
+ \control_i.imm_gen_i.iword[21]\
+ VPWR VGND sg13g2_mux4_1
X_20460_ _13712_ _13708_ _13709_ _13710_ _13711_ \control_i.imm_gen_i.iword[23]\
+ \control_i.imm_gen_i.iword[22]\
+ VPWR VGND sg13g2_mux4_1
X_20461_ _00101_ reset _13712_ VPWR VGND sg13g2_and2_1
X_20462_ _13713_ \regs.registers[0][23]\ \regs.registers[1][23]\ \regs.registers[2][23]\ \regs.registers[3][23]\ \control_i.imm_gen_i.iword[20]\
+ \control_i.imm_gen_i.iword[21]\
+ VPWR VGND sg13g2_mux4_1
X_20463_ _13714_ \regs.registers[8][23]\ \regs.registers[9][23]\ \regs.registers[10][23]\ \regs.registers[11][23]\ \control_i.imm_gen_i.iword[20]\
+ \control_i.imm_gen_i.iword[21]\
+ VPWR VGND sg13g2_mux4_1
X_20464_ _13715_ \regs.registers[4][23]\ \regs.registers[5][23]\ \regs.registers[6][23]\ \regs.registers[7][23]\ \control_i.imm_gen_i.iword[20]\
+ \control_i.imm_gen_i.iword[21]\
+ VPWR VGND sg13g2_mux4_1
X_20465_ _13716_ \regs.registers[12][23]\ \regs.registers[13][23]\ \regs.registers[14][23]\ \regs.registers[15][23]\ \control_i.imm_gen_i.iword[20]\
+ \control_i.imm_gen_i.iword[21]\
+ VPWR VGND sg13g2_mux4_1
X_20466_ _13717_ _13713_ _13714_ _13715_ _13716_ \control_i.imm_gen_i.iword[23]\
+ \control_i.imm_gen_i.iword[22]\
+ VPWR VGND sg13g2_mux4_1
X_20467_ _00102_ reset _13717_ VPWR VGND sg13g2_and2_1
X_20468_ _13718_ \regs.registers[0][24]\ \regs.registers[1][24]\ \regs.registers[2][24]\ \regs.registers[3][24]\ \control_i.imm_gen_i.iword[20]\
+ \control_i.imm_gen_i.iword[21]\
+ VPWR VGND sg13g2_mux4_1
X_20469_ _13719_ \regs.registers[8][24]\ \regs.registers[9][24]\ \regs.registers[10][24]\ \regs.registers[11][24]\ \control_i.imm_gen_i.iword[20]\
+ \control_i.imm_gen_i.iword[21]\
+ VPWR VGND sg13g2_mux4_1
X_20470_ _13720_ \regs.registers[4][24]\ \regs.registers[5][24]\ \regs.registers[6][24]\ \regs.registers[7][24]\ \control_i.imm_gen_i.iword[20]\
+ \control_i.imm_gen_i.iword[21]\
+ VPWR VGND sg13g2_mux4_1
X_20471_ _13721_ \regs.registers[12][24]\ \regs.registers[13][24]\ \regs.registers[14][24]\ \regs.registers[15][24]\ \control_i.imm_gen_i.iword[20]\
+ \control_i.imm_gen_i.iword[21]\
+ VPWR VGND sg13g2_mux4_1
X_20472_ _13722_ _13718_ _13719_ _13720_ _13721_ \control_i.imm_gen_i.iword[23]\
+ \control_i.imm_gen_i.iword[22]\
+ VPWR VGND sg13g2_mux4_1
X_20473_ _00103_ reset _13722_ VPWR VGND sg13g2_and2_1
X_20474_ _13723_ \regs.registers[0][25]\ \regs.registers[1][25]\ \regs.registers[2][25]\ \regs.registers[3][25]\ \control_i.imm_gen_i.iword[20]\
+ \control_i.imm_gen_i.iword[21]\
+ VPWR VGND sg13g2_mux4_1
X_20475_ _13724_ \regs.registers[8][25]\ \regs.registers[9][25]\ \regs.registers[10][25]\ \regs.registers[11][25]\ \control_i.imm_gen_i.iword[20]\
+ \control_i.imm_gen_i.iword[21]\
+ VPWR VGND sg13g2_mux4_1
X_20476_ _13725_ \regs.registers[4][25]\ \regs.registers[5][25]\ \regs.registers[6][25]\ \regs.registers[7][25]\ \control_i.imm_gen_i.iword[20]\
+ \control_i.imm_gen_i.iword[21]\
+ VPWR VGND sg13g2_mux4_1
X_20477_ _13726_ \regs.registers[12][25]\ \regs.registers[13][25]\ \regs.registers[14][25]\ \regs.registers[15][25]\ \control_i.imm_gen_i.iword[20]\
+ \control_i.imm_gen_i.iword[21]\
+ VPWR VGND sg13g2_mux4_1
X_20478_ _13727_ _13723_ _13724_ _13725_ _13726_ \control_i.imm_gen_i.iword[23]\
+ \control_i.imm_gen_i.iword[22]\
+ VPWR VGND sg13g2_mux4_1
X_20479_ _00104_ reset _13727_ VPWR VGND sg13g2_and2_1
X_20480_ _13728_ \regs.registers[0][26]\ \regs.registers[1][26]\ \regs.registers[2][26]\ \regs.registers[3][26]\ \control_i.imm_gen_i.iword[20]\
+ \control_i.imm_gen_i.iword[21]\
+ VPWR VGND sg13g2_mux4_1
X_20481_ _13729_ \regs.registers[8][26]\ \regs.registers[9][26]\ \regs.registers[10][26]\ \regs.registers[11][26]\ \control_i.imm_gen_i.iword[20]\
+ \control_i.imm_gen_i.iword[21]\
+ VPWR VGND sg13g2_mux4_1
X_20482_ _13730_ \regs.registers[4][26]\ \regs.registers[5][26]\ \regs.registers[6][26]\ \regs.registers[7][26]\ \control_i.imm_gen_i.iword[20]\
+ \control_i.imm_gen_i.iword[21]\
+ VPWR VGND sg13g2_mux4_1
X_20483_ _13731_ \regs.registers[12][26]\ \regs.registers[13][26]\ \regs.registers[14][26]\ \regs.registers[15][26]\ \control_i.imm_gen_i.iword[20]\
+ \control_i.imm_gen_i.iword[21]\
+ VPWR VGND sg13g2_mux4_1
X_20484_ _13732_ _13728_ _13729_ _13730_ _13731_ \control_i.imm_gen_i.iword[23]\
+ \control_i.imm_gen_i.iword[22]\
+ VPWR VGND sg13g2_mux4_1
X_20485_ _00105_ reset _13732_ VPWR VGND sg13g2_and2_1
X_20486_ _13733_ \regs.registers[0][27]\ \regs.registers[1][27]\ \regs.registers[2][27]\ \regs.registers[3][27]\ \control_i.imm_gen_i.iword[20]\
+ \control_i.imm_gen_i.iword[21]\
+ VPWR VGND sg13g2_mux4_1
X_20487_ _13734_ \regs.registers[8][27]\ \regs.registers[9][27]\ \regs.registers[10][27]\ \regs.registers[11][27]\ \control_i.imm_gen_i.iword[20]\
+ \control_i.imm_gen_i.iword[21]\
+ VPWR VGND sg13g2_mux4_1
X_20488_ _13735_ \regs.registers[4][27]\ \regs.registers[5][27]\ \regs.registers[6][27]\ \regs.registers[7][27]\ \control_i.imm_gen_i.iword[20]\
+ \control_i.imm_gen_i.iword[21]\
+ VPWR VGND sg13g2_mux4_1
X_20489_ _13736_ \regs.registers[12][27]\ \regs.registers[13][27]\ \regs.registers[14][27]\ \regs.registers[15][27]\ \control_i.imm_gen_i.iword[20]\
+ \control_i.imm_gen_i.iword[21]\
+ VPWR VGND sg13g2_mux4_1
X_20490_ _13737_ _13733_ _13734_ _13735_ _13736_ \control_i.imm_gen_i.iword[23]\
+ \control_i.imm_gen_i.iword[22]\
+ VPWR VGND sg13g2_mux4_1
X_20491_ _00106_ reset _13737_ VPWR VGND sg13g2_and2_1
X_20492_ _13738_ \regs.registers[0][28]\ \regs.registers[1][28]\ \regs.registers[2][28]\ \regs.registers[3][28]\ \control_i.imm_gen_i.iword[20]\
+ \control_i.imm_gen_i.iword[21]\
+ VPWR VGND sg13g2_mux4_1
X_20493_ _13739_ \regs.registers[8][28]\ \regs.registers[9][28]\ \regs.registers[10][28]\ \regs.registers[11][28]\ \control_i.imm_gen_i.iword[20]\
+ \control_i.imm_gen_i.iword[21]\
+ VPWR VGND sg13g2_mux4_1
X_20494_ _13740_ \regs.registers[4][28]\ \regs.registers[5][28]\ \regs.registers[6][28]\ \regs.registers[7][28]\ \control_i.imm_gen_i.iword[20]\
+ \control_i.imm_gen_i.iword[21]\
+ VPWR VGND sg13g2_mux4_1
X_20495_ _13741_ \regs.registers[12][28]\ \regs.registers[13][28]\ \regs.registers[14][28]\ \regs.registers[15][28]\ \control_i.imm_gen_i.iword[20]\
+ \control_i.imm_gen_i.iword[21]\
+ VPWR VGND sg13g2_mux4_1
X_20496_ _13742_ _13738_ _13739_ _13740_ _13741_ \control_i.imm_gen_i.iword[23]\
+ \control_i.imm_gen_i.iword[22]\
+ VPWR VGND sg13g2_mux4_1
X_20497_ _00107_ reset _13742_ VPWR VGND sg13g2_and2_1
X_20498_ _13743_ \regs.registers[0][29]\ \regs.registers[1][29]\ \regs.registers[2][29]\ \regs.registers[3][29]\ \control_i.imm_gen_i.iword[20]\
+ \control_i.imm_gen_i.iword[21]\
+ VPWR VGND sg13g2_mux4_1
X_20499_ _13744_ \regs.registers[8][29]\ \regs.registers[9][29]\ \regs.registers[10][29]\ \regs.registers[11][29]\ \control_i.imm_gen_i.iword[20]\
+ \control_i.imm_gen_i.iword[21]\
+ VPWR VGND sg13g2_mux4_1
X_20500_ _13745_ \regs.registers[4][29]\ \regs.registers[5][29]\ \regs.registers[6][29]\ \regs.registers[7][29]\ \control_i.imm_gen_i.iword[20]\
+ \control_i.imm_gen_i.iword[21]\
+ VPWR VGND sg13g2_mux4_1
X_20501_ _13746_ \regs.registers[12][29]\ \regs.registers[13][29]\ \regs.registers[14][29]\ \regs.registers[15][29]\ \control_i.imm_gen_i.iword[20]\
+ \control_i.imm_gen_i.iword[21]\
+ VPWR VGND sg13g2_mux4_1
X_20502_ _13747_ _13743_ _13744_ _13745_ _13746_ \control_i.imm_gen_i.iword[23]\
+ \control_i.imm_gen_i.iword[22]\
+ VPWR VGND sg13g2_mux4_1
X_20503_ _00108_ reset _13747_ VPWR VGND sg13g2_and2_1
X_20504_ _13748_ \regs.registers[0][30]\ \regs.registers[1][30]\ \regs.registers[2][30]\ \regs.registers[3][30]\ \control_i.imm_gen_i.iword[20]\
+ \control_i.imm_gen_i.iword[21]\
+ VPWR VGND sg13g2_mux4_1
X_20505_ _13749_ \regs.registers[8][30]\ \regs.registers[9][30]\ \regs.registers[10][30]\ \regs.registers[11][30]\ \control_i.imm_gen_i.iword[20]\
+ \control_i.imm_gen_i.iword[21]\
+ VPWR VGND sg13g2_mux4_1
X_20506_ _13750_ \regs.registers[4][30]\ \regs.registers[5][30]\ \regs.registers[6][30]\ \regs.registers[7][30]\ \control_i.imm_gen_i.iword[20]\
+ \control_i.imm_gen_i.iword[21]\
+ VPWR VGND sg13g2_mux4_1
X_20507_ _13751_ \regs.registers[12][30]\ \regs.registers[13][30]\ \regs.registers[14][30]\ \regs.registers[15][30]\ \control_i.imm_gen_i.iword[20]\
+ \control_i.imm_gen_i.iword[21]\
+ VPWR VGND sg13g2_mux4_1
X_20508_ _13752_ _13748_ _13749_ _13750_ _13751_ \control_i.imm_gen_i.iword[23]\
+ \control_i.imm_gen_i.iword[22]\
+ VPWR VGND sg13g2_mux4_1
X_20509_ _00109_ reset _13752_ VPWR VGND sg13g2_and2_1
X_20510_ _13753_ \regs.registers[0][31]\ \regs.registers[1][31]\ \regs.registers[2][31]\ \regs.registers[3][31]\ \control_i.imm_gen_i.iword[20]\
+ \control_i.imm_gen_i.iword[21]\
+ VPWR VGND sg13g2_mux4_1
X_20511_ _13754_ \regs.registers[8][31]\ \regs.registers[9][31]\ \regs.registers[10][31]\ \regs.registers[11][31]\ \control_i.imm_gen_i.iword[20]\
+ \control_i.imm_gen_i.iword[21]\
+ VPWR VGND sg13g2_mux4_1
X_20512_ _13755_ \regs.registers[4][31]\ \regs.registers[5][31]\ \regs.registers[6][31]\ \regs.registers[7][31]\ \control_i.imm_gen_i.iword[20]\
+ \control_i.imm_gen_i.iword[21]\
+ VPWR VGND sg13g2_mux4_1
X_20513_ _13756_ \regs.registers[12][31]\ \regs.registers[13][31]\ \regs.registers[14][31]\ \regs.registers[15][31]\ \control_i.imm_gen_i.iword[20]\
+ \control_i.imm_gen_i.iword[21]\
+ VPWR VGND sg13g2_mux4_1
X_20514_ _13757_ _13753_ _13754_ _13755_ _13756_ \control_i.imm_gen_i.iword[23]\
+ \control_i.imm_gen_i.iword[22]\
+ VPWR VGND sg13g2_mux4_1
X_20515_ _00110_ reset _13757_ VPWR VGND sg13g2_and2_1
X_20516_ _13758_ \memory_i.addr_reg[0]\ VPWR VGND sg13g2_inv_1
X_20517_ _13759_ \memory_i.addr_reg[3]\ \memory_i.addr_reg[1]\ VPWR VGND sg13g2_nand2b_1
X_20518_ _13760_ _13758_ _13759_ VPWR VGND sg13g2_nor2_1
X_20519_ _13761_ \memory_i.addr_reg[13]\ \memory_i.addr_reg[12]\ \memory_i.addr_reg[15]\ \memory_i.addr_reg[14]\ VPWR
+ VGND
+ sg13g2_nor4_1
X_20520_ _13762_ \memory_i.addr_reg[9]\ \memory_i.addr_reg[8]\ \memory_i.addr_reg[11]\ \memory_i.addr_reg[10]\ VPWR
+ VGND
+ sg13g2_nor4_1
X_20521_ _13763_ _13761_ _13762_ VPWR VGND sg13g2_nand2_1
X_20522_ _13764_ _13763_ VPWR VGND sg13g2_buf_1
X_20523_ _13765_ \memory_i.addr_reg[7]\ \memory_i.addr_reg[6]\ VPWR VGND sg13g2_nor2_1
X_20524_ _13766_ \memory_i.addr_reg[17]\ \memory_i.addr_reg[16]\ \memory_i.addr_reg[19]\ \memory_i.addr_reg[22]\ VPWR
+ VGND
+ sg13g2_nor4_1
X_20525_ _13767_ _13765_ _13766_ VPWR VGND sg13g2_nand2_1
X_20526_ _13768_ \memory_i.addr_reg[25]\ VPWR VGND sg13g2_inv_1
X_20527_ _13769_ \memory_i.addr_reg[18]\ \memory_i.addr_reg[21]\ \memory_i.addr_reg[20]\ \memory_i.addr_reg[30]\ VPWR
+ VGND
+ sg13g2_nor4_1
X_20528_ _13770_ \memory_i.addr_reg[24]\ \memory_i.addr_reg[27]\ VPWR VGND sg13g2_nor2_1
X_20529_ _13771_ \memory_i.addr_reg[23]\ _13768_ _13769_ _13770_ VPWR
+ VGND
+ sg13g2_nand4_1
X_20530_ _13772_ \memory_i.addr_reg[26]\ \memory_i.addr_reg[29]\ \memory_i.addr_reg[28]\ \memory_i.addr_reg[31]\ VPWR
+ VGND
+ sg13g2_or4_1
X_20531_ _13773_ \memory_i.addr_reg[4]\ _13767_ _13771_ _13772_ VPWR
+ VGND
+ sg13g2_nor4_1
X_20532_ _13774_ _13773_ VPWR VGND sg13g2_inv_1
X_20533_ _13775_ \memory_i.addr_reg[2]\ \memory_i.addr_reg[5]\ _13764_ _13774_ VPWR
+ VGND
+ sg13g2_nor4_1
X_20534_ _13776_ \memory_i.state[1]\ VPWR VGND sg13g2_inv_1
X_20535_ _13777_ _13760_ _13775_ _13776_ VPWR VGND sg13g2_a21oi_1
X_20536_ _13778_ _13767_ _13771_ _13772_ VPWR VGND sg13g2_nor3_1
X_20537_ _13779_ \memory_i.addr_reg[4]\ _13778_ VPWR VGND sg13g2_nor2b_1
X_20538_ _13780_ _13779_ VPWR VGND sg13g2_buf_1
X_20539_ _13781_ _13780_ VPWR VGND sg13g2_inv_1
X_20540_ _13782_ \memory_i.addr_reg[5]\ _13764_ _13781_ VPWR VGND sg13g2_nor3_1
X_20541_ _13783_ \memory_i.addr_reg[1]\ \memory_i.addr_reg[0]\ VPWR VGND sg13g2_nor2_1
X_20542_ _13784_ \memory_i.addr_reg[3]\ _13783_ VPWR VGND sg13g2_and2_1
X_20543_ _13785_ _13784_ VPWR VGND sg13g2_buf_1
X_20544_ _13786_ \memory_i.addr_reg[4]\ _13778_ VPWR VGND sg13g2_and2_1
X_20545_ _13787_ _13786_ VPWR VGND sg13g2_buf_1
X_20546_ _13788_ \memory_i.addr_reg[5]\ _13787_ VPWR VGND sg13g2_nor2b_1
X_20547_ _13789_ _13788_ VPWR VGND sg13g2_buf_1
X_20548_ _13790_ \memory_i.addr_reg[2]\ _13785_ VPWR VGND sg13g2_nand2_1
X_20549_ _13791_ _13764_ _13790_ VPWR VGND sg13g2_nor2_1
X_20550_ _13792_ \memory_i.addr_reg[3]\ \memory_i.addr_reg[2]\ VPWR VGND sg13g2_nand2b_1
X_20551_ _13793_ \memory_i.addr_reg[1]\ \memory_i.addr_reg[0]\ _13764_ _13792_ VPWR
+ VGND
+ sg13g2_nor4_1
X_20552_ _13794_ _13789_ _13793_ VPWR VGND sg13g2_nand2_1
X_20553_ _13795_ _13794_ VPWR VGND sg13g2_buf_1
X_20554_ _13796_ _13795_ VPWR VGND sg13g2_inv_1
X_20555_ _13797_ _13782_ _13785_ _13789_ _13791_ _13796_
+ VPWR
+ VGND sg13g2_a221oi_1
X_20556_ _13798_ \memory_i.addr_reg[2]\ \memory_i.addr_reg[3]\ VPWR VGND sg13g2_nor2_1
X_20557_ _13799_ _13763_ _13798_ VPWR VGND sg13g2_nor2b_1
X_20558_ _13800_ _13799_ _13783_ VPWR VGND sg13g2_nand2_1
X_20559_ _13801_ _13800_ VPWR VGND sg13g2_inv_1
X_20560_ _13802_ \memory_i.addr_reg[5]\ _13780_ VPWR VGND sg13g2_and2_1
X_20561_ _13803_ _13802_ VPWR VGND sg13g2_buf_1
X_20562_ _13804_ _13801_ _13791_ _13803_ VPWR VGND sg13g2_o21ai_1
X_20563_ _13805_ \memory_i.addr_reg[1]\ VPWR VGND sg13g2_inv_1
X_20564_ _13806_ _13805_ \memory_i.addr_reg[0]\ _13792_ VPWR VGND sg13g2_nor3_1
X_20565_ _13807_ _13782_ _13806_ VPWR VGND sg13g2_nand2_1
X_20566_ _13808_ \memory_i.addr_reg[1]\ _13758_ VPWR VGND sg13g2_nor2_1
X_20567_ _13809_ \memory_i.addr_reg[5]\ _13764_ _13792_ VPWR VGND sg13g2_nor3_1
X_20568_ _13810_ _13780_ _13808_ _13809_ VPWR VGND sg13g2_nand3_1
X_20569_ _13811_ _13797_ _13804_ _13807_ _13810_ VPWR
+ VGND
+ sg13g2_nand4_1
X_20570_ _13812_ \memory_i.addr_reg[3]\ _13783_ VPWR VGND sg13g2_nand2_1
X_20571_ _13813_ _13812_ VPWR VGND sg13g2_buf_1
X_20572_ _13814_ \memory_i.addr_reg[2]\ _13764_ _13813_ VPWR VGND sg13g2_nor3_1
X_20573_ _13815_ _13801_ _13814_ _13787_ VPWR VGND sg13g2_o21ai_1
X_20574_ _13816_ \memory_i.addr_reg[2]\ _13764_ _13813_ VPWR VGND sg13g2_nor3_1
X_20575_ _13817_ _13780_ _13816_ _13793_ _13787_ VPWR
+ VGND
+ sg13g2_a22oi_1
X_20576_ _13818_ _13817_ VPWR VGND sg13g2_inv_1
X_20577_ _13819_ \memory_i.addr_reg[5]\ _13780_ VPWR VGND sg13g2_nand2_1
X_20578_ _13820_ _13819_ VPWR VGND sg13g2_buf_1
X_20579_ _13821_ _13761_ _13762_ _13798_ VPWR VGND sg13g2_nand3_1
X_20580_ _13822_ _13805_ \memory_i.addr_reg[0]\ _13820_ _13821_ VPWR
+ VGND
+ sg13g2_nor4_1
X_20581_ _13823_ _13822_ VPWR VGND sg13g2_buf_1
X_20582_ _13824_ _13803_ _13793_ _13818_ \memory_i.addr_reg[5]\ _13823_
+ VPWR
+ VGND sg13g2_a221oi_1
X_20583_ _13825_ \memory_i.addr_reg[5]\ _13780_ _13799_ _13808_ VPWR
+ VGND
+ sg13g2_nand4_1
X_20584_ _13826_ _13815_ _13824_ _13825_ VPWR VGND sg13g2_nand3_1
X_20585_ _13827_ _13811_ _13826_ VPWR VGND sg13g2_nor2_1
X_20586_ _13828_ _13827_ VPWR VGND sg13g2_buf_1
X_20587_ _13829_ _12969_ VPWR VGND sg13g2_inv_1
X_20588_ _13830_ \memory_i.state[2]\ \memory_i.state[1]\ \memory_i.state[0]\ VPWR VGND sg13g2_nor3_1
X_20589_ _13831_ \memory_i.state[2]\ _13829_ _13830_ VPWR VGND sg13g2_a21oi_1
X_20590_ _13832_ \memory_i.state[1]\ \memory_i.state[0]\ _13017_ VPWR VGND sg13g2_o21ai_1
X_20591_ _13833_ _12999_ _13334_ VPWR VGND sg13g2_nand2_1
X_20592_ _13834_ _13325_ _13833_ \memory_i.state[0]\ VPWR VGND sg13g2_o21ai_1
X_20593_ _13835_ _12959_ _13831_ _13832_ _13834_ VPWR
+ VGND
+ sg13g2_nand4_1
X_20594_ _13836_ _13777_ _13828_ _13835_ VPWR VGND sg13g2_a21oi_1
X_20595_ _13837_ _13836_ VPWR VGND sg13g2_buf_1
X_20596_ _13838_ _13837_ VPWR VGND sg13g2_buf_1
X_20597_ _13839_ \memory_i.target[3]\ \memory_i.sram_dataout[31]\ VPWR VGND sg13g2_nor2b_1
X_20598_ _13840_ \memory_i.target[3]\ \memory_i.i2c_dataout[31]\ _13839_ VPWR VGND sg13g2_a21oi_1
X_20599_ _13841_ \memory_i.sram_dataout[23]\ \memory_i.i2c_dataout[23]\ \memory_i.target[3]\ VPWR VGND sg13g2_mux2_1
X_20600_ _13842_ \alu_i.funct3[0]\ _13840_ VPWR VGND sg13g2_nor2_1
X_20601_ _13843_ \alu_i.funct3[0]\ _13841_ _13842_ VPWR VGND sg13g2_a21oi_1
X_20602_ _13844_ _13062_ VPWR VGND sg13g2_buf_1
X_20603_ _13845_ \alu_i.funct3[2]\ _13843_ _13844_ VPWR VGND sg13g2_o21ai_1
X_20604_ _13846_ _13845_ VPWR VGND sg13g2_buf_1
X_20605_ _13847_ _13846_ VPWR VGND sg13g2_buf_1
X_20606_ _13848_ _13203_ VPWR VGND sg13g2_buf_1
X_20607_ _13849_ _13848_ _12956_ VPWR VGND sg13g2_nand2_1
X_20608_ _13850_ _13849_ VPWR VGND sg13g2_buf_1
X_20609_ _13851_ \memory_i.target[3]\ \memory_i.sram_dataout[7]\ VPWR VGND sg13g2_nor2b_1
X_20610_ _13852_ \memory_i.target[3]\ \memory_i.i2c_dataout[7]\ _13851_ VPWR VGND sg13g2_a21oi_1
X_20611_ _13853_ _13850_ _13852_ VPWR VGND sg13g2_nand2_1
X_20612_ _13854_ \memory_i.target[0]\ _13847_ _13853_ VPWR VGND sg13g2_nand3_1
X_20613_ _13855_ \memory_i.target[0]\ _13840_ _13854_ VPWR VGND sg13g2_o21ai_1
X_20614_ _13856_ _13805_ \memory_i.addr_reg[0]\ VPWR VGND sg13g2_nand2_1
X_20615_ _13857_ _13820_ _13821_ _13856_ VPWR VGND sg13g2_nor3_1
X_20616_ _13858_ _13823_ _13857_ VPWR VGND sg13g2_nor2_1
X_20617_ _13859_ \memory_i.addr_reg[2]\ _13761_ _13762_ VPWR VGND sg13g2_nand3_1
X_20618_ _13860_ _13859_ VPWR VGND sg13g2_buf_1
X_20619_ _13861_ \memory_i.addr_reg[1]\ \memory_i.addr_reg[0]\ \memory_i.addr_reg[3]\ _13860_ VPWR
+ VGND
+ sg13g2_nor4_1
X_20620_ _13862_ _13803_ _13861_ VPWR VGND sg13g2_nand2_1
X_20621_ _13863_ _13862_ VPWR VGND sg13g2_buf_1
X_20622_ _13864_ _13815_ _13863_ VPWR VGND sg13g2_and2_1
X_20623_ _13865_ \memory_i.addr_reg[5]\ _13780_ VPWR VGND sg13g2_nand2b_1
X_20624_ _13866_ _13865_ VPWR VGND sg13g2_buf_1
X_20625_ _13867_ _13866_ _13813_ _13860_ VPWR VGND sg13g2_nor3_1
X_20626_ _13868_ _13867_ VPWR VGND sg13g2_buf_1
X_20627_ _13869_ _13789_ VPWR VGND sg13g2_inv_1
X_20628_ _13870_ _13813_ _13860_ _13869_ VPWR VGND sg13g2_nor3_1
X_20629_ _13871_ _13870_ VPWR VGND sg13g2_buf_1
X_20630_ _13872_ _13861_ _13789_ VPWR VGND sg13g2_and2_1
X_20631_ _13873_ _13872_ VPWR VGND sg13g2_buf_1
X_20632_ _13874_ _13868_ _13871_ _13873_ VPWR VGND sg13g2_nor3_1
X_20633_ _13875_ _13820_ _13800_ VPWR VGND sg13g2_nor2_1
X_20634_ _13876_ _13875_ VPWR VGND sg13g2_buf_1
X_20635_ _13877_ _13820_ _13813_ _13860_ VPWR VGND sg13g2_nor3_1
X_20636_ _13878_ _13877_ VPWR VGND sg13g2_buf_1
X_20637_ _13879_ \memory_i.addr_reg[3]\ _13866_ _13856_ _13860_ VPWR
+ VGND
+ sg13g2_nor4_1
X_20638_ _13880_ _13876_ _13878_ _13879_ VPWR VGND sg13g2_nor3_1
X_20639_ _13881_ _13858_ _13864_ _13874_ _13880_ VPWR
+ VGND
+ sg13g2_nand4_1
X_20640_ _13882_ \memory_i.addr_reg[2]\ _13764_ _13866_ _13813_ VPWR
+ VGND
+ sg13g2_nor4_1
X_20641_ _13883_ _13882_ VPWR VGND sg13g2_buf_1
X_20642_ _13884_ \memory_i.addr_reg[0]\ _13759_ _13866_ _13860_ VPWR
+ VGND
+ sg13g2_nor4_1
X_20643_ _13885_ _13884_ VPWR VGND sg13g2_buf_1
X_20644_ _13886_ _13780_ _13814_ _13861_ _13787_ VPWR
+ VGND
+ sg13g2_a22oi_1
X_20645_ _13887_ _13886_ \memory_i.addr_reg[5]\ VPWR VGND sg13g2_nor2b_1
X_20646_ _13888_ _13881_ _13883_ _13885_ _13887_ VPWR
+ VGND
+ sg13g2_nor4_1
X_20647_ _13889_ _13776_ _13888_ VPWR VGND sg13g2_nor2_1
X_20648_ _13890_ _13889_ VPWR VGND sg13g2_buf_1
X_20649_ _13891_ _13871_ VPWR VGND sg13g2_buf_1
X_20650_ _13892_ _13891_ VPWR VGND sg13g2_buf_1
X_20651_ _13893_ _13800_ _13869_ VPWR VGND sg13g2_nor2_1
X_20652_ _13894_ _13893_ VPWR VGND sg13g2_buf_1
X_20653_ _13895_ _13894_ VPWR VGND sg13g2_buf_1
X_20654_ _13896_ _13895_ VPWR VGND sg13g2_buf_1
X_20655_ _13897_ \memory_i.freq_inst.dsmod_cos.i_osr[1]\ _13892_ _13896_ \memory_i.mtimecmp[31]\ VPWR
+ VGND
+ sg13g2_a22oi_1
X_20656_ _13898_ _13873_ VPWR VGND sg13g2_buf_1
X_20657_ _13899_ _13898_ VPWR VGND sg13g2_buf_1
X_20658_ _13900_ \memory_i.mtimecmp[63]\ _13899_ VPWR VGND sg13g2_nand2_1
X_20659_ _13901_ _13868_ VPWR VGND sg13g2_buf_1
X_20660_ _13902_ _13901_ VPWR VGND sg13g2_buf_1
X_20661_ _13903_ _13883_ VPWR VGND sg13g2_buf_1
X_20662_ _13904_ _13903_ VPWR VGND sg13g2_buf_1
X_20663_ _13905_ \memory_i.mtime[63]\ _13902_ _13904_ \memory_i.mtime[31]\ VPWR
+ VGND
+ sg13g2_a22oi_1
X_20664_ _13906_ _13897_ _13900_ _13905_ VPWR VGND sg13g2_nand3_1
X_20665_ _13907_ \memory_i.state[2]\ _13855_ _13890_ _13906_ VPWR
+ VGND
+ sg13g2_a22oi_1
X_20666_ _13908_ _13837_ VPWR VGND sg13g2_buf_1
X_20667_ _13909_ \mem_dataout[31]\ _13908_ VPWR VGND sg13g2_nor2_1
X_20668_ _00111_ _13838_ _13907_ _13909_ VPWR VGND sg13g2_a21oi_1
X_20669_ _13910_ \memory_i.target[3]\ \memory_i.sram_dataout[30]\ VPWR VGND sg13g2_nor2b_1
X_20670_ _13911_ \memory_i.target[3]\ \memory_i.i2c_dataout[30]\ _13910_ VPWR VGND sg13g2_a21oi_1
X_20671_ _13912_ \memory_i.target[3]\ \memory_i.sram_dataout[6]\ VPWR VGND sg13g2_nor2b_1
X_20672_ _13913_ \memory_i.target[3]\ \memory_i.i2c_dataout[6]\ _13912_ VPWR VGND sg13g2_a21oi_1
X_20673_ _13914_ _13850_ _13913_ VPWR VGND sg13g2_nand2_1
X_20674_ _13915_ \memory_i.target[0]\ _13847_ _13914_ VPWR VGND sg13g2_nand3_1
X_20675_ _13916_ \memory_i.target[0]\ _13911_ _13915_ VPWR VGND sg13g2_o21ai_1
X_20676_ _13917_ \memory_i.freq_inst.dsmod_cos.i_osr[0]\ _13892_ _13896_ \memory_i.mtimecmp[30]\ VPWR
+ VGND
+ sg13g2_a22oi_1
X_20677_ _13918_ \memory_i.mtimecmp[62]\ _13899_ VPWR VGND sg13g2_nand2_1
X_20678_ _13919_ \memory_i.mtime[62]\ _13902_ _13904_ \memory_i.mtime[30]\ VPWR
+ VGND
+ sg13g2_a22oi_1
X_20679_ _13920_ _13917_ _13918_ _13919_ VPWR VGND sg13g2_nand3_1
X_20680_ _13921_ _13890_ VPWR VGND sg13g2_buf_1
X_20681_ _13922_ \memory_i.state[2]\ _13916_ _13920_ _13921_ VPWR
+ VGND
+ sg13g2_a22oi_1
X_20682_ _13923_ \mem_dataout[30]\ _13908_ VPWR VGND sg13g2_nor2_1
X_20683_ _00112_ _13838_ _13922_ _13923_ VPWR VGND sg13g2_a21oi_1
X_20684_ _13924_ \memory_i.target[3]\ \memory_i.sram_dataout[29]\ VPWR VGND sg13g2_nor2b_1
X_20685_ _13925_ \memory_i.target[3]\ \memory_i.i2c_dataout[29]\ _13924_ VPWR VGND sg13g2_a21oi_1
X_20686_ _13926_ \memory_i.target[3]\ \memory_i.sram_dataout[5]\ VPWR VGND sg13g2_nor2b_1
X_20687_ _13927_ \memory_i.target[3]\ \memory_i.i2c_dataout[5]\ _13926_ VPWR VGND sg13g2_a21oi_1
X_20688_ _13928_ _13850_ _13927_ VPWR VGND sg13g2_nand2_1
X_20689_ _13929_ \memory_i.target[0]\ _13847_ _13928_ VPWR VGND sg13g2_nand3_1
X_20690_ _13930_ \memory_i.target[0]\ _13925_ _13929_ VPWR VGND sg13g2_o21ai_1
X_20691_ _13931_ \memory_i.freq_inst.f_c[29]\ _13892_ _13896_ \memory_i.mtimecmp[29]\ VPWR
+ VGND
+ sg13g2_a22oi_1
X_20692_ _13932_ \memory_i.addr_reg[5]\ _13787_ VPWR VGND sg13g2_nand2_1
X_20693_ _13933_ _13800_ _13932_ VPWR VGND sg13g2_nor2_1
X_20694_ _13934_ _13933_ VPWR VGND sg13g2_buf_1
X_20695_ _13935_ _13934_ VPWR VGND sg13g2_buf_1
X_20696_ _13936_ _13935_ VPWR VGND sg13g2_buf_1
X_20697_ _13937_ \memory_i.mtimecmp[61]\ _13899_ _13936_ \memory_i.cordic_I[29]\ VPWR
+ VGND
+ sg13g2_a22oi_1
X_20698_ _13938_ \memory_i.mtime[61]\ _13902_ _13904_ \memory_i.mtime[29]\ VPWR
+ VGND
+ sg13g2_a22oi_1
X_20699_ _13939_ _13931_ _13937_ _13938_ VPWR VGND sg13g2_nand3_1
X_20700_ _13940_ \memory_i.state[2]\ _13930_ _13939_ _13921_ VPWR
+ VGND
+ sg13g2_a22oi_1
X_20701_ _13941_ \mem_dataout[29]\ _13908_ VPWR VGND sg13g2_nor2_1
X_20702_ _00113_ _13838_ _13940_ _13941_ VPWR VGND sg13g2_a21oi_1
X_20703_ _13942_ \memory_i.target[3]\ \memory_i.sram_dataout[28]\ VPWR VGND sg13g2_nor2b_1
X_20704_ _13943_ \memory_i.target[3]\ \memory_i.i2c_dataout[28]\ _13942_ VPWR VGND sg13g2_a21oi_1
X_20705_ _13944_ \memory_i.target[3]\ \memory_i.sram_dataout[4]\ VPWR VGND sg13g2_nor2b_1
X_20706_ _13945_ \memory_i.target[3]\ \memory_i.i2c_dataout[4]\ _13944_ VPWR VGND sg13g2_a21oi_1
X_20707_ _13946_ _13850_ _13945_ VPWR VGND sg13g2_nand2_1
X_20708_ _13947_ \memory_i.target[0]\ _13847_ _13946_ VPWR VGND sg13g2_nand3_1
X_20709_ _13948_ \memory_i.target[0]\ _13943_ _13947_ VPWR VGND sg13g2_o21ai_1
X_20710_ _13949_ \memory_i.freq_inst.f_c[28]\ _13892_ _13936_ \memory_i.cordic_I[28]\ VPWR
+ VGND
+ sg13g2_a22oi_1
X_20711_ _13950_ _13895_ VPWR VGND sg13g2_buf_1
X_20712_ _13951_ \memory_i.mtimecmp[60]\ _13899_ _13950_ \memory_i.mtimecmp[28]\ VPWR
+ VGND
+ sg13g2_a22oi_1
X_20713_ _13952_ \memory_i.mtime[60]\ _13902_ _13904_ \memory_i.mtime[28]\ VPWR
+ VGND
+ sg13g2_a22oi_1
X_20714_ _13953_ _13949_ _13951_ _13952_ VPWR VGND sg13g2_nand3_1
X_20715_ _13954_ _13890_ VPWR VGND sg13g2_buf_1
X_20716_ _13955_ \memory_i.state[2]\ _13948_ _13953_ _13954_ VPWR
+ VGND
+ sg13g2_a22oi_1
X_20717_ _13956_ \mem_dataout[28]\ _13908_ VPWR VGND sg13g2_nor2_1
X_20718_ _00114_ _13838_ _13955_ _13956_ VPWR VGND sg13g2_a21oi_1
X_20719_ _13957_ \memory_i.target[3]\ \memory_i.sram_dataout[27]\ VPWR VGND sg13g2_nor2b_1
X_20720_ _13958_ \memory_i.target[3]\ \memory_i.i2c_dataout[27]\ _13957_ VPWR VGND sg13g2_a21oi_1
X_20721_ _13959_ \memory_i.target[3]\ \memory_i.sram_dataout[3]\ VPWR VGND sg13g2_nor2b_1
X_20722_ _13960_ \memory_i.target[3]\ \memory_i.i2c_dataout[3]\ _13959_ VPWR VGND sg13g2_a21oi_1
X_20723_ _13961_ _13850_ _13960_ VPWR VGND sg13g2_nand2_1
X_20724_ _13962_ \memory_i.target[0]\ _13847_ _13961_ VPWR VGND sg13g2_nand3_1
X_20725_ _13963_ \memory_i.target[0]\ _13958_ _13962_ VPWR VGND sg13g2_o21ai_1
X_20726_ _13964_ \memory_i.freq_inst.f_c[27]\ _13892_ _13896_ \memory_i.mtimecmp[27]\ VPWR
+ VGND
+ sg13g2_a22oi_1
X_20727_ _13965_ \memory_i.mtimecmp[59]\ _13899_ _13936_ \memory_i.cordic_I[27]\ VPWR
+ VGND
+ sg13g2_a22oi_1
X_20728_ _13966_ \memory_i.mtime[59]\ _13902_ _13904_ \memory_i.mtime[27]\ VPWR
+ VGND
+ sg13g2_a22oi_1
X_20729_ _13967_ _13964_ _13965_ _13966_ VPWR VGND sg13g2_nand3_1
X_20730_ _13968_ \memory_i.state[2]\ _13963_ _13967_ _13954_ VPWR
+ VGND
+ sg13g2_a22oi_1
X_20731_ _13969_ \mem_dataout[27]\ _13908_ VPWR VGND sg13g2_nor2_1
X_20732_ _00115_ _13838_ _13968_ _13969_ VPWR VGND sg13g2_a21oi_1
X_20733_ _13970_ \memory_i.target[3]\ \memory_i.sram_dataout[26]\ VPWR VGND sg13g2_nor2b_1
X_20734_ _13971_ \memory_i.target[3]\ \memory_i.i2c_dataout[26]\ _13970_ VPWR VGND sg13g2_a21oi_1
X_20735_ _13972_ \memory_i.target[3]\ \memory_i.sram_dataout[2]\ VPWR VGND sg13g2_nor2b_1
X_20736_ _13973_ \memory_i.target[3]\ \memory_i.i2c_dataout[2]\ _13972_ VPWR VGND sg13g2_a21oi_1
X_20737_ _13974_ _13850_ _13973_ VPWR VGND sg13g2_nand2_1
X_20738_ _13975_ \memory_i.target[0]\ _13847_ _13974_ VPWR VGND sg13g2_nand3_1
X_20739_ _13976_ \memory_i.target[0]\ _13971_ _13975_ VPWR VGND sg13g2_o21ai_1
X_20740_ _13977_ \memory_i.freq_inst.f_c[26]\ _13892_ _13899_ \memory_i.mtimecmp[58]\ VPWR
+ VGND
+ sg13g2_a22oi_1
X_20741_ _13978_ \memory_i.mtimecmp[26]\ _13950_ _13936_ \memory_i.cordic_I[26]\ VPWR
+ VGND
+ sg13g2_a22oi_1
X_20742_ _13979_ \memory_i.mtime[58]\ _13902_ _13904_ \memory_i.mtime[26]\ VPWR
+ VGND
+ sg13g2_a22oi_1
X_20743_ _13980_ _13977_ _13978_ _13979_ VPWR VGND sg13g2_nand3_1
X_20744_ _13981_ \memory_i.state[2]\ _13976_ _13980_ _13954_ VPWR
+ VGND
+ sg13g2_a22oi_1
X_20745_ _13982_ \mem_dataout[26]\ _13908_ VPWR VGND sg13g2_nor2_1
X_20746_ _00116_ _13838_ _13981_ _13982_ VPWR VGND sg13g2_a21oi_1
X_20747_ _13983_ \memory_i.target[3]\ \memory_i.sram_dataout[25]\ VPWR VGND sg13g2_nor2b_1
X_20748_ _13984_ \memory_i.target[3]\ \memory_i.i2c_dataout[25]\ _13983_ VPWR VGND sg13g2_a21oi_1
X_20749_ _13985_ \memory_i.target[3]\ \memory_i.sram_dataout[1]\ VPWR VGND sg13g2_nor2b_1
X_20750_ _13986_ \memory_i.target[3]\ \memory_i.i2c_dataout[1]\ _13985_ VPWR VGND sg13g2_a21oi_1
X_20751_ _13987_ _13850_ _13986_ VPWR VGND sg13g2_nand2_1
X_20752_ _13988_ \memory_i.target[0]\ _13847_ _13987_ VPWR VGND sg13g2_nand3_1
X_20753_ _13989_ \memory_i.target[0]\ _13984_ _13988_ VPWR VGND sg13g2_o21ai_1
X_20754_ _13990_ \memory_i.freq_inst.f_c[25]\ _13892_ _13896_ \memory_i.mtimecmp[25]\ VPWR
+ VGND
+ sg13g2_a22oi_1
X_20755_ _13991_ \memory_i.mtimecmp[57]\ _13899_ _13936_ \memory_i.cordic_I[25]\ VPWR
+ VGND
+ sg13g2_a22oi_1
X_20756_ _13992_ \memory_i.mtime[57]\ _13902_ _13904_ \memory_i.mtime[25]\ VPWR
+ VGND
+ sg13g2_a22oi_1
X_20757_ _13993_ _13990_ _13991_ _13992_ VPWR VGND sg13g2_nand3_1
X_20758_ _13994_ \memory_i.state[2]\ _13989_ _13993_ _13954_ VPWR
+ VGND
+ sg13g2_a22oi_1
X_20759_ _13995_ \mem_dataout[25]\ _13908_ VPWR VGND sg13g2_nor2_1
X_20760_ _00117_ _13838_ _13994_ _13995_ VPWR VGND sg13g2_a21oi_1
X_20761_ _13996_ \memory_i.target[3]\ \memory_i.sram_dataout[24]\ VPWR VGND sg13g2_nor2b_1
X_20762_ _13997_ \memory_i.target[3]\ \memory_i.i2c_dataout[24]\ _13996_ VPWR VGND sg13g2_a21oi_1
X_20763_ _13998_ \memory_i.target[3]\ \memory_i.sram_dataout[0]\ VPWR VGND sg13g2_nor2b_1
X_20764_ _13999_ \memory_i.target[3]\ \memory_i.i2c_dataout[0]\ _13998_ VPWR VGND sg13g2_a21oi_1
X_20765_ _14000_ _13850_ _13999_ VPWR VGND sg13g2_nand2_1
X_20766_ _14001_ \memory_i.target[0]\ _13847_ _14000_ VPWR VGND sg13g2_nand3_1
X_20767_ _14002_ \memory_i.target[0]\ _13997_ _14001_ VPWR VGND sg13g2_o21ai_1
X_20768_ _14003_ \memory_i.freq_inst.f_c[24]\ _13892_ _13896_ \memory_i.mtimecmp[24]\ VPWR
+ VGND
+ sg13g2_a22oi_1
X_20769_ _14004_ \memory_i.mtimecmp[56]\ _13899_ _13936_ \memory_i.cordic_I[24]\ VPWR
+ VGND
+ sg13g2_a22oi_1
X_20770_ _14005_ \memory_i.mtime[56]\ _13902_ _13904_ \memory_i.mtime[24]\ VPWR
+ VGND
+ sg13g2_a22oi_1
X_20771_ _14006_ _14003_ _14004_ _14005_ VPWR VGND sg13g2_nand3_1
X_20772_ _14007_ \memory_i.state[2]\ _14002_ _14006_ _13954_ VPWR
+ VGND
+ sg13g2_a22oi_1
X_20773_ _14008_ \mem_dataout[24]\ _13908_ VPWR VGND sg13g2_nor2_1
X_20774_ _00118_ _13838_ _14007_ _14008_ VPWR VGND sg13g2_a21oi_1
X_20775_ _14009_ \memory_i.sram_dataout[15]\ \memory_i.i2c_dataout[15]\ \memory_i.target[3]\ VPWR VGND sg13g2_mux2_1
X_20776_ _14010_ _13844_ _14009_ _13847_ VPWR VGND sg13g2_o21ai_1
X_20777_ _14011_ \memory_i.target[0]\ _13841_ VPWR VGND sg13g2_nor2_1
X_20778_ _14012_ \memory_i.target[0]\ _14010_ _14011_ VPWR VGND sg13g2_a21oi_1
X_20779_ _14013_ \memory_i.freq_inst.f_c[23]\ _13892_ _13896_ \memory_i.mtimecmp[23]\ VPWR
+ VGND
+ sg13g2_a22oi_1
X_20780_ _14014_ _13898_ VPWR VGND sg13g2_buf_1
X_20781_ _14015_ \memory_i.mtimecmp[55]\ _14014_ _13936_ \memory_i.cordic_I[23]\ VPWR
+ VGND
+ sg13g2_a22oi_1
X_20782_ _14016_ \memory_i.mtime[55]\ _13902_ _13904_ \memory_i.mtime[23]\ VPWR
+ VGND
+ sg13g2_a22oi_1
X_20783_ _14017_ _14013_ _14015_ _14016_ VPWR VGND sg13g2_nand3_1
X_20784_ _14018_ \memory_i.state[2]\ _14012_ _14017_ _13954_ VPWR
+ VGND
+ sg13g2_a22oi_1
X_20785_ _14019_ _13837_ VPWR VGND sg13g2_buf_1
X_20786_ _14020_ \mem_dataout[23]\ _14019_ VPWR VGND sg13g2_nor2_1
X_20787_ _00119_ _13838_ _14018_ _14020_ VPWR VGND sg13g2_a21oi_1
X_20788_ _14021_ \memory_i.sram_dataout[14]\ \memory_i.i2c_dataout[14]\ \memory_i.target[3]\ VPWR VGND sg13g2_mux2_1
X_20789_ _14022_ _13844_ _14021_ _13847_ VPWR VGND sg13g2_o21ai_1
X_20790_ _14023_ \memory_i.sram_dataout[22]\ \memory_i.i2c_dataout[22]\ \memory_i.target[3]\ VPWR VGND sg13g2_mux2_1
X_20791_ _14024_ \memory_i.target[0]\ _14023_ VPWR VGND sg13g2_nor2_1
X_20792_ _14025_ \memory_i.target[0]\ _14022_ _14024_ VPWR VGND sg13g2_a21oi_1
X_20793_ _14026_ \memory_i.freq_inst.f_c[22]\ _13892_ _13896_ \memory_i.mtimecmp[22]\ VPWR
+ VGND
+ sg13g2_a22oi_1
X_20794_ _14027_ \memory_i.mtimecmp[54]\ _14014_ _13936_ \memory_i.cordic_I[22]\ VPWR
+ VGND
+ sg13g2_a22oi_1
X_20795_ _14028_ \memory_i.mtime[54]\ _13902_ _13904_ \memory_i.mtime[22]\ VPWR
+ VGND
+ sg13g2_a22oi_1
X_20796_ _14029_ _14026_ _14027_ _14028_ VPWR VGND sg13g2_nand3_1
X_20797_ _14030_ \memory_i.state[2]\ _14025_ _14029_ _13954_ VPWR
+ VGND
+ sg13g2_a22oi_1
X_20798_ _14031_ \mem_dataout[22]\ _14019_ VPWR VGND sg13g2_nor2_1
X_20799_ _00120_ _13838_ _14030_ _14031_ VPWR VGND sg13g2_a21oi_1
X_20800_ _14032_ _13837_ VPWR VGND sg13g2_buf_1
X_20801_ _14033_ \memory_i.sram_dataout[13]\ \memory_i.i2c_dataout[13]\ \memory_i.target[3]\ VPWR VGND sg13g2_mux2_1
X_20802_ _14034_ _13844_ _14033_ _13846_ VPWR VGND sg13g2_o21ai_1
X_20803_ _14035_ \memory_i.sram_dataout[21]\ \memory_i.i2c_dataout[21]\ \memory_i.target[3]\ VPWR VGND sg13g2_mux2_1
X_20804_ _14036_ \memory_i.target[0]\ _14035_ VPWR VGND sg13g2_nor2_1
X_20805_ _14037_ \memory_i.target[0]\ _14034_ _14036_ VPWR VGND sg13g2_a21oi_1
X_20806_ _14038_ _13891_ VPWR VGND sg13g2_buf_1
X_20807_ _14039_ \memory_i.freq_inst.f_c[21]\ _14038_ _13896_ \memory_i.mtimecmp[21]\ VPWR
+ VGND
+ sg13g2_a22oi_1
X_20808_ _14040_ \memory_i.mtimecmp[53]\ _14014_ _13936_ \memory_i.cordic_I[21]\ VPWR
+ VGND
+ sg13g2_a22oi_1
X_20809_ _14041_ _13901_ VPWR VGND sg13g2_buf_1
X_20810_ _14042_ _13903_ VPWR VGND sg13g2_buf_1
X_20811_ _14043_ \memory_i.mtime[53]\ _14041_ _14042_ \memory_i.mtime[21]\ VPWR
+ VGND
+ sg13g2_a22oi_1
X_20812_ _14044_ _14039_ _14040_ _14043_ VPWR VGND sg13g2_nand3_1
X_20813_ _14045_ \memory_i.state[2]\ _14037_ _14044_ _13954_ VPWR
+ VGND
+ sg13g2_a22oi_1
X_20814_ _14046_ \mem_dataout[21]\ _14019_ VPWR VGND sg13g2_nor2_1
X_20815_ _00121_ _14032_ _14045_ _14046_ VPWR VGND sg13g2_a21oi_1
X_20816_ _14047_ \memory_i.sram_dataout[12]\ \memory_i.i2c_dataout[12]\ \memory_i.target[3]\ VPWR VGND sg13g2_mux2_1
X_20817_ _14048_ _13844_ _14047_ _13846_ VPWR VGND sg13g2_o21ai_1
X_20818_ _14049_ \memory_i.sram_dataout[20]\ \memory_i.i2c_dataout[20]\ \memory_i.target[3]\ VPWR VGND sg13g2_mux2_1
X_20819_ _14050_ \memory_i.target[0]\ _14049_ VPWR VGND sg13g2_nor2_1
X_20820_ _14051_ \memory_i.target[0]\ _14048_ _14050_ VPWR VGND sg13g2_a21oi_1
X_20821_ _14052_ \memory_i.freq_inst.f_c[20]\ _14038_ _13899_ \memory_i.mtimecmp[52]\ VPWR
+ VGND
+ sg13g2_a22oi_1
X_20822_ _14053_ \memory_i.mtimecmp[20]\ _13950_ _13936_ \memory_i.cordic_I[20]\ VPWR
+ VGND
+ sg13g2_a22oi_1
X_20823_ _14054_ \memory_i.mtime[52]\ _14041_ _14042_ \memory_i.mtime[20]\ VPWR
+ VGND
+ sg13g2_a22oi_1
X_20824_ _14055_ _14052_ _14053_ _14054_ VPWR VGND sg13g2_nand3_1
X_20825_ _14056_ \memory_i.state[2]\ _14051_ _14055_ _13954_ VPWR
+ VGND
+ sg13g2_a22oi_1
X_20826_ _14057_ \mem_dataout[20]\ _14019_ VPWR VGND sg13g2_nor2_1
X_20827_ _00122_ _14032_ _14056_ _14057_ VPWR VGND sg13g2_a21oi_1
X_20828_ _14058_ \memory_i.sram_dataout[11]\ \memory_i.i2c_dataout[11]\ \memory_i.target[3]\ VPWR VGND sg13g2_mux2_1
X_20829_ _14059_ _13844_ _14058_ _13846_ VPWR VGND sg13g2_o21ai_1
X_20830_ _14060_ \memory_i.sram_dataout[19]\ \memory_i.i2c_dataout[19]\ \memory_i.target[3]\ VPWR VGND sg13g2_mux2_1
X_20831_ _14061_ \memory_i.target[0]\ _14060_ VPWR VGND sg13g2_nor2_1
X_20832_ _14062_ \memory_i.target[0]\ _14059_ _14061_ VPWR VGND sg13g2_a21oi_1
X_20833_ _14063_ \memory_i.freq_inst.f_c[19]\ _14038_ _13896_ \memory_i.mtimecmp[19]\ VPWR
+ VGND
+ sg13g2_a22oi_1
X_20834_ _14064_ _13935_ VPWR VGND sg13g2_buf_1
X_20835_ _14065_ \memory_i.mtimecmp[51]\ _14014_ _14064_ \memory_i.cordic_I[19]\ VPWR
+ VGND
+ sg13g2_a22oi_1
X_20836_ _14066_ \memory_i.mtime[51]\ _14041_ _14042_ \memory_i.mtime[19]\ VPWR
+ VGND
+ sg13g2_a22oi_1
X_20837_ _14067_ _14063_ _14065_ _14066_ VPWR VGND sg13g2_nand3_1
X_20838_ _14068_ \memory_i.state[2]\ _14062_ _14067_ _13954_ VPWR
+ VGND
+ sg13g2_a22oi_1
X_20839_ _14069_ \mem_dataout[19]\ _14019_ VPWR VGND sg13g2_nor2_1
X_20840_ _00123_ _14032_ _14068_ _14069_ VPWR VGND sg13g2_a21oi_1
X_20841_ _14070_ \memory_i.sram_dataout[10]\ \memory_i.i2c_dataout[10]\ \memory_i.target[3]\ VPWR VGND sg13g2_mux2_1
X_20842_ _14071_ _13844_ _14070_ _13846_ VPWR VGND sg13g2_o21ai_1
X_20843_ _14072_ \memory_i.sram_dataout[18]\ \memory_i.i2c_dataout[18]\ \memory_i.target[3]\ VPWR VGND sg13g2_mux2_1
X_20844_ _14073_ \memory_i.target[0]\ _14072_ VPWR VGND sg13g2_nor2_1
X_20845_ _14074_ \memory_i.target[0]\ _14071_ _14073_ VPWR VGND sg13g2_a21oi_1
X_20846_ _14075_ \memory_i.freq_inst.f_c[18]\ _14038_ _13950_ \memory_i.mtimecmp[18]\ VPWR
+ VGND
+ sg13g2_a22oi_1
X_20847_ _14076_ \memory_i.mtimecmp[50]\ _14014_ _14064_ \memory_i.cordic_I[18]\ VPWR
+ VGND
+ sg13g2_a22oi_1
X_20848_ _14077_ \memory_i.mtime[50]\ _14041_ _14042_ \memory_i.mtime[18]\ VPWR
+ VGND
+ sg13g2_a22oi_1
X_20849_ _14078_ _14075_ _14076_ _14077_ VPWR VGND sg13g2_nand3_1
X_20850_ _14079_ \memory_i.state[2]\ _14074_ _14078_ _13890_ VPWR
+ VGND
+ sg13g2_a22oi_1
X_20851_ _14080_ \mem_dataout[18]\ _14019_ VPWR VGND sg13g2_nor2_1
X_20852_ _00124_ _14032_ _14079_ _14080_ VPWR VGND sg13g2_a21oi_1
X_20853_ _14081_ \memory_i.sram_dataout[9]\ \memory_i.i2c_dataout[9]\ \memory_i.target[3]\ VPWR VGND sg13g2_mux2_1
X_20854_ _14082_ _13844_ _14081_ _13846_ VPWR VGND sg13g2_o21ai_1
X_20855_ _14083_ \memory_i.sram_dataout[17]\ \memory_i.i2c_dataout[17]\ \memory_i.target[3]\ VPWR VGND sg13g2_mux2_1
X_20856_ _14084_ \memory_i.target[0]\ _14083_ VPWR VGND sg13g2_nor2_1
X_20857_ _14085_ \memory_i.target[0]\ _14082_ _14084_ VPWR VGND sg13g2_a21oi_1
X_20858_ _14086_ \memory_i.freq_inst.f_c[17]\ _14038_ _13899_ \memory_i.mtimecmp[49]\ VPWR
+ VGND
+ sg13g2_a22oi_1
X_20859_ _14087_ \memory_i.mtimecmp[17]\ _13950_ _14064_ \memory_i.cordic_I[17]\ VPWR
+ VGND
+ sg13g2_a22oi_1
X_20860_ _14088_ \memory_i.mtime[49]\ _14041_ _14042_ \memory_i.mtime[17]\ VPWR
+ VGND
+ sg13g2_a22oi_1
X_20861_ _14089_ _14086_ _14087_ _14088_ VPWR VGND sg13g2_nand3_1
X_20862_ _14090_ \memory_i.state[2]\ _14085_ _14089_ _13890_ VPWR
+ VGND
+ sg13g2_a22oi_1
X_20863_ _14091_ \mem_dataout[17]\ _14019_ VPWR VGND sg13g2_nor2_1
X_20864_ _00125_ _14032_ _14090_ _14091_ VPWR VGND sg13g2_a21oi_1
X_20865_ _14092_ \memory_i.sram_dataout[8]\ \memory_i.i2c_dataout[8]\ \memory_i.target[3]\ VPWR VGND sg13g2_mux2_1
X_20866_ _14093_ _13844_ _14092_ _13846_ VPWR VGND sg13g2_o21ai_1
X_20867_ _14094_ \memory_i.sram_dataout[16]\ \memory_i.i2c_dataout[16]\ \memory_i.target[3]\ VPWR VGND sg13g2_mux2_1
X_20868_ _14095_ \memory_i.target[0]\ _14094_ VPWR VGND sg13g2_nor2_1
X_20869_ _14096_ \memory_i.target[0]\ _14093_ _14095_ VPWR VGND sg13g2_a21oi_1
X_20870_ _14097_ \memory_i.freq_inst.f_c[16]\ _14038_ _13950_ \memory_i.mtimecmp[16]\ VPWR
+ VGND
+ sg13g2_a22oi_1
X_20871_ _14098_ \memory_i.mtimecmp[48]\ _14014_ _14064_ \memory_i.cordic_I[16]\ VPWR
+ VGND
+ sg13g2_a22oi_1
X_20872_ _14099_ \memory_i.mtime[48]\ _14041_ _14042_ \memory_i.mtime[16]\ VPWR
+ VGND
+ sg13g2_a22oi_1
X_20873_ _14100_ _14097_ _14098_ _14099_ VPWR VGND sg13g2_nand3_1
X_20874_ _14101_ \memory_i.state[2]\ _14096_ _14100_ _13890_ VPWR
+ VGND
+ sg13g2_a22oi_1
X_20875_ _14102_ \mem_dataout[16]\ _14019_ VPWR VGND sg13g2_nor2_1
X_20876_ _00126_ _14032_ _14101_ _14102_ VPWR VGND sg13g2_a21oi_1
X_20877_ _14103_ \memory_i.addr_reg[2]\ _13764_ _13813_ VPWR VGND sg13g2_or3_1
X_20878_ _14104_ _14103_ VPWR VGND sg13g2_buf_1
X_20879_ _14105_ _13820_ _14104_ VPWR VGND sg13g2_nor2_1
X_20880_ _14106_ _14105_ VPWR VGND sg13g2_buf_1
X_20881_ _14107_ _14106_ VPWR VGND sg13g2_buf_1
X_20882_ _14108_ _13293_ _13863_ VPWR VGND sg13g2_nor2_1
X_20883_ _14109_ \memory_i.mtimecmp[47]\ _13898_ _14107_ \memory_i.uart_transmitter.CYCLES_PER_BIT[15]\ _14108_
+ VPWR
+ VGND sg13g2_a221oi_1
X_20884_ _14110_ \memory_i.mtimecmp[15]\ _13950_ _14064_ \memory_i.cordic_I[15]\ VPWR
+ VGND
+ sg13g2_a22oi_1
X_20885_ _14111_ _13878_ VPWR VGND sg13g2_buf_1
X_20886_ _14112_ \memory_i.freq_inst.f_c[15]\ _14038_ _14111_ \memory_i.i2c_master.scl_ratio[15]\ VPWR
+ VGND
+ sg13g2_a22oi_1
X_20887_ _14113_ \memory_i.mtime[47]\ _14041_ _14042_ \memory_i.mtime[15]\ VPWR
+ VGND
+ sg13g2_a22oi_1
X_20888_ _14114_ _14109_ _14110_ _14112_ _14113_ VPWR
+ VGND
+ sg13g2_nand4_1
X_20889_ _14115_ _13212_ _13844_ VPWR VGND sg13g2_nand2_1
X_20890_ _14116_ _14115_ VPWR VGND sg13g2_buf_1
X_20891_ _14117_ \alu_i.funct3[2]\ _12956_ _13840_ VPWR VGND sg13g2_a21oi_1
X_20892_ _14118_ _14116_ _14117_ VPWR VGND sg13g2_nand2b_1
X_20893_ _14119_ \memory_i.target[0]\ _14118_ VPWR VGND sg13g2_and2_1
X_20894_ _14120_ _14119_ VPWR VGND sg13g2_buf_1
X_20895_ _14121_ _13841_ _14116_ VPWR VGND sg13g2_nand2_1
X_20896_ _14122_ \memory_i.target[0]\ _14009_ \memory_i.state[2]\ VPWR VGND sg13g2_o21ai_1
X_20897_ _14123_ _14120_ _14121_ _14122_ VPWR VGND sg13g2_a21oi_1
X_20898_ _14124_ _13921_ _14114_ _14123_ VPWR VGND sg13g2_a21oi_1
X_20899_ _14125_ \mem_dataout[15]\ _14019_ VPWR VGND sg13g2_nor2_1
X_20900_ _00127_ _14032_ _14124_ _14125_ VPWR VGND sg13g2_a21oi_1
X_20901_ _14126_ _13803_ _13861_ VPWR VGND sg13g2_and2_1
X_20902_ _14127_ _14126_ VPWR VGND sg13g2_buf_1
X_20903_ _14128_ _14127_ VPWR VGND sg13g2_buf_1
X_20904_ _14129_ \memory_i.uart_receiver.CYCLES_PER_BIT[14]\ _14128_ VPWR VGND sg13g2_and2_1
X_20905_ _14130_ \memory_i.freq_inst.f_c[14]\ _13891_ _14111_ \memory_i.i2c_master.scl_ratio[14]\ _14129_
+ VPWR
+ VGND sg13g2_a221oi_1
X_20906_ _14131_ \memory_i.mtimecmp[14]\ _13950_ _14064_ \memory_i.cordic_I[14]\ VPWR
+ VGND
+ sg13g2_a22oi_1
X_20907_ _14132_ \memory_i.mtimecmp[46]\ _14014_ _14107_ \memory_i.uart_transmitter.CYCLES_PER_BIT[14]\ VPWR
+ VGND
+ sg13g2_a22oi_1
X_20908_ _14133_ \memory_i.mtime[46]\ _14041_ _14042_ \memory_i.mtime[14]\ VPWR
+ VGND
+ sg13g2_a22oi_1
X_20909_ _14134_ _14130_ _14131_ _14132_ _14133_ VPWR
+ VGND
+ sg13g2_nand4_1
X_20910_ _14135_ _14023_ _14116_ VPWR VGND sg13g2_nand2_1
X_20911_ _14136_ \memory_i.target[0]\ _14021_ \memory_i.state[2]\ VPWR VGND sg13g2_o21ai_1
X_20912_ _14137_ _14120_ _14135_ _14136_ VPWR VGND sg13g2_a21oi_1
X_20913_ _14138_ _13921_ _14134_ _14137_ VPWR VGND sg13g2_a21oi_1
X_20914_ _14139_ \mem_dataout[14]\ _14019_ VPWR VGND sg13g2_nor2_1
X_20915_ _00128_ _14032_ _14138_ _14139_ VPWR VGND sg13g2_a21oi_1
X_20916_ _14140_ \memory_i.uart_transmitter.CYCLES_PER_BIT[13]\ _14107_ VPWR VGND sg13g2_and2_1
X_20917_ _14141_ \memory_i.freq_inst.f_c[13]\ _13891_ _14014_ \memory_i.mtimecmp[45]\ _14140_
+ VPWR
+ VGND sg13g2_a221oi_1
X_20918_ _14142_ \memory_i.uart_receiver.CYCLES_PER_BIT[13]\ _14128_ _14064_ \memory_i.cordic_I[13]\ VPWR
+ VGND
+ sg13g2_a22oi_1
X_20919_ _14143_ \memory_i.i2c_master.scl_ratio[13]\ _14111_ _13895_ \memory_i.mtimecmp[13]\ VPWR
+ VGND
+ sg13g2_a22oi_1
X_20920_ _14144_ \memory_i.mtime[45]\ _14041_ _14042_ \memory_i.mtime[13]\ VPWR
+ VGND
+ sg13g2_a22oi_1
X_20921_ _14145_ _14141_ _14142_ _14143_ _14144_ VPWR
+ VGND
+ sg13g2_nand4_1
X_20922_ _14146_ _14035_ _14116_ VPWR VGND sg13g2_nand2_1
X_20923_ _14147_ \memory_i.target[0]\ _14033_ \memory_i.state[2]\ VPWR VGND sg13g2_o21ai_1
X_20924_ _14148_ _14120_ _14146_ _14147_ VPWR VGND sg13g2_a21oi_1
X_20925_ _14149_ _13921_ _14145_ _14148_ VPWR VGND sg13g2_a21oi_1
X_20926_ _14150_ _13837_ VPWR VGND sg13g2_buf_1
X_20927_ _14151_ \mem_dataout[13]\ _14150_ VPWR VGND sg13g2_nor2_1
X_20928_ _00129_ _14032_ _14149_ _14151_ VPWR VGND sg13g2_a21oi_1
X_20929_ _14152_ \memory_i.uart_transmitter.CYCLES_PER_BIT[12]\ _14107_ VPWR VGND sg13g2_and2_1
X_20930_ _14153_ \memory_i.mtimecmp[44]\ _13898_ _13895_ \memory_i.mtimecmp[12]\ _14152_
+ VPWR
+ VGND sg13g2_a221oi_1
X_20931_ _14154_ \memory_i.freq_inst.f_c[12]\ _14038_ _14064_ \memory_i.cordic_I[12]\ VPWR
+ VGND
+ sg13g2_a22oi_1
X_20932_ _14155_ \memory_i.uart_receiver.CYCLES_PER_BIT[12]\ _14128_ _14111_ \memory_i.i2c_master.scl_ratio[12]\ VPWR
+ VGND
+ sg13g2_a22oi_1
X_20933_ _14156_ \memory_i.mtime[44]\ _14041_ _14042_ \memory_i.mtime[12]\ VPWR
+ VGND
+ sg13g2_a22oi_1
X_20934_ _14157_ _14153_ _14154_ _14155_ _14156_ VPWR
+ VGND
+ sg13g2_nand4_1
X_20935_ _14158_ _14049_ _14116_ VPWR VGND sg13g2_nand2_1
X_20936_ _14159_ \memory_i.target[0]\ _14047_ \memory_i.state[2]\ VPWR VGND sg13g2_o21ai_1
X_20937_ _14160_ _14120_ _14158_ _14159_ VPWR VGND sg13g2_a21oi_1
X_20938_ _14161_ _13921_ _14157_ _14160_ VPWR VGND sg13g2_a21oi_1
X_20939_ _14162_ \mem_dataout[12]\ _14150_ VPWR VGND sg13g2_nor2_1
X_20940_ _00130_ _14032_ _14161_ _14162_ VPWR VGND sg13g2_a21oi_1
X_20941_ _14163_ _13837_ VPWR VGND sg13g2_buf_1
X_20942_ _14164_ \memory_i.uart_receiver.CYCLES_PER_BIT[11]\ _14128_ VPWR VGND sg13g2_and2_1
X_20943_ _14165_ \memory_i.freq_inst.f_c[11]\ _13891_ _14111_ \memory_i.i2c_master.scl_ratio[11]\ _14164_
+ VPWR
+ VGND sg13g2_a221oi_1
X_20944_ _14166_ \memory_i.mtimecmp[11]\ _13950_ _14064_ \memory_i.cordic_I[11]\ VPWR
+ VGND
+ sg13g2_a22oi_1
X_20945_ _14167_ \memory_i.mtimecmp[43]\ _14014_ _14107_ \memory_i.uart_transmitter.CYCLES_PER_BIT[11]\ VPWR
+ VGND
+ sg13g2_a22oi_1
X_20946_ _14168_ \memory_i.mtime[43]\ _13901_ _13903_ \memory_i.mtime[11]\ VPWR
+ VGND
+ sg13g2_a22oi_1
X_20947_ _14169_ _14165_ _14166_ _14167_ _14168_ VPWR
+ VGND
+ sg13g2_nand4_1
X_20948_ _14170_ _14060_ _14116_ VPWR VGND sg13g2_nand2_1
X_20949_ _14171_ \memory_i.target[0]\ _14058_ \memory_i.state[2]\ VPWR VGND sg13g2_o21ai_1
X_20950_ _14172_ _14120_ _14170_ _14171_ VPWR VGND sg13g2_a21oi_1
X_20951_ _14173_ _13921_ _14169_ _14172_ VPWR VGND sg13g2_a21oi_1
X_20952_ _14174_ \mem_dataout[11]\ _14150_ VPWR VGND sg13g2_nor2_1
X_20953_ _00131_ _14163_ _14173_ _14174_ VPWR VGND sg13g2_a21oi_1
X_20954_ _14175_ \memory_i.uart_transmitter.CYCLES_PER_BIT[10]\ _14107_ VPWR VGND sg13g2_and2_1
X_20955_ _14176_ \memory_i.mtimecmp[42]\ _13898_ _13895_ \memory_i.mtimecmp[10]\ _14175_
+ VPWR
+ VGND sg13g2_a221oi_1
X_20956_ _14177_ \memory_i.freq_inst.f_c[10]\ _14038_ _14064_ \memory_i.cordic_I[10]\ VPWR
+ VGND
+ sg13g2_a22oi_1
X_20957_ _14178_ \memory_i.uart_receiver.CYCLES_PER_BIT[10]\ _14128_ _14111_ \memory_i.i2c_master.scl_ratio[10]\ VPWR
+ VGND
+ sg13g2_a22oi_1
X_20958_ _14179_ \memory_i.mtime[42]\ _13901_ _13903_ \memory_i.mtime[10]\ VPWR
+ VGND
+ sg13g2_a22oi_1
X_20959_ _14180_ _14176_ _14177_ _14178_ _14179_ VPWR
+ VGND
+ sg13g2_nand4_1
X_20960_ _14181_ _14072_ _14116_ VPWR VGND sg13g2_nand2_1
X_20961_ _14182_ \memory_i.target[0]\ _14070_ \memory_i.state[2]\ VPWR VGND sg13g2_o21ai_1
X_20962_ _14183_ _14120_ _14181_ _14182_ VPWR VGND sg13g2_a21oi_1
X_20963_ _14184_ _13921_ _14180_ _14183_ VPWR VGND sg13g2_a21oi_1
X_20964_ _14185_ \mem_dataout[10]\ _14150_ VPWR VGND sg13g2_nor2_1
X_20965_ _00132_ _14163_ _14184_ _14185_ VPWR VGND sg13g2_a21oi_1
X_20966_ _14186_ \memory_i.uart_receiver.CYCLES_PER_BIT[9]\ _14128_ VPWR VGND sg13g2_and2_1
X_20967_ _14187_ \memory_i.freq_inst.f_c[9]\ _13891_ _14111_ \memory_i.i2c_master.scl_ratio[9]\ _14186_
+ VPWR
+ VGND sg13g2_a221oi_1
X_20968_ _14188_ \memory_i.mtimecmp[9]\ _13950_ _13935_ \memory_i.cordic_I[9]\ VPWR
+ VGND
+ sg13g2_a22oi_1
X_20969_ _14189_ \memory_i.mtimecmp[41]\ _14014_ _14107_ \memory_i.uart_transmitter.CYCLES_PER_BIT[9]\ VPWR
+ VGND
+ sg13g2_a22oi_1
X_20970_ _14190_ \memory_i.mtime[41]\ _13901_ _13903_ \memory_i.mtime[9]\ VPWR
+ VGND
+ sg13g2_a22oi_1
X_20971_ _14191_ _14187_ _14188_ _14189_ _14190_ VPWR
+ VGND
+ sg13g2_nand4_1
X_20972_ _14192_ _14083_ _14116_ VPWR VGND sg13g2_nand2_1
X_20973_ _14193_ \memory_i.target[0]\ _14081_ \memory_i.state[2]\ VPWR VGND sg13g2_o21ai_1
X_20974_ _14194_ _14120_ _14192_ _14193_ VPWR VGND sg13g2_a21oi_1
X_20975_ _14195_ _13921_ _14191_ _14194_ VPWR VGND sg13g2_a21oi_1
X_20976_ _14196_ \mem_dataout[9]\ _14150_ VPWR VGND sg13g2_nor2_1
X_20977_ _00133_ _14163_ _14195_ _14196_ VPWR VGND sg13g2_a21oi_1
X_20978_ _14197_ \memory_i.uart_transmitter.CYCLES_PER_BIT[8]\ _14107_ VPWR VGND sg13g2_and2_1
X_20979_ _14198_ \memory_i.mtimecmp[40]\ _13898_ _13895_ \memory_i.mtimecmp[8]\ _14197_
+ VPWR
+ VGND sg13g2_a221oi_1
X_20980_ _14199_ \memory_i.freq_inst.f_c[8]\ _14038_ _13935_ \memory_i.cordic_I[8]\ VPWR
+ VGND
+ sg13g2_a22oi_1
X_20981_ _14200_ \memory_i.uart_receiver.CYCLES_PER_BIT[8]\ _14128_ _14111_ \memory_i.i2c_master.scl_ratio[8]\ VPWR
+ VGND
+ sg13g2_a22oi_1
X_20982_ _14201_ \memory_i.mtime[40]\ _13901_ _13903_ \memory_i.mtime[8]\ VPWR
+ VGND
+ sg13g2_a22oi_1
X_20983_ _14202_ _14198_ _14199_ _14200_ _14201_ VPWR
+ VGND
+ sg13g2_nand4_1
X_20984_ _14203_ _14094_ _14116_ VPWR VGND sg13g2_nand2_1
X_20985_ _14204_ \memory_i.target[0]\ _14092_ \memory_i.state[2]\ VPWR VGND sg13g2_o21ai_1
X_20986_ _14205_ _14120_ _14203_ _14204_ VPWR VGND sg13g2_a21oi_1
X_20987_ _14206_ _13921_ _14202_ _14205_ VPWR VGND sg13g2_a21oi_1
X_20988_ _14207_ \mem_dataout[8]\ _14150_ VPWR VGND sg13g2_nor2_1
X_20989_ _00134_ _14163_ _14206_ _14207_ VPWR VGND sg13g2_a21oi_1
X_20990_ _14208_ _13840_ \memory_i.target[0]\ VPWR VGND sg13g2_nand2b_1
X_20991_ _14209_ \memory_i.target[0]\ _13852_ _14208_ VPWR VGND sg13g2_o21ai_1
X_20992_ _14210_ \memory_i.freq_inst.f_c[7]\ _13891_ _13895_ \memory_i.mtimecmp[7]\ VPWR
+ VGND
+ sg13g2_a22oi_1
X_20993_ _14211_ \memory_i.mtimecmp[39]\ _13898_ VPWR VGND sg13g2_nand2_1
X_20994_ _14212_ _14104_ _13869_ VPWR VGND sg13g2_nor2_1
X_20995_ _14213_ _14212_ VPWR VGND sg13g2_buf_1
X_20996_ _14214_ \memory_i.uart_receiver.CYCLES_PER_BIT[7]\ _14128_ _14213_ analog_en VPWR
+ VGND
+ sg13g2_a22oi_1
X_20997_ _14215_ _13876_ VPWR VGND sg13g2_buf_1
X_20998_ _14216_ \memory_i.ds_lo_conf[7]\ _14215_ _13934_ \memory_i.cordic_I[7]\ VPWR
+ VGND
+ sg13g2_a22oi_1
X_20999_ _14217_ _14210_ _14211_ _14214_ _14216_ VPWR
+ VGND
+ sg13g2_and4_1
X_21000_ _14218_ _14104_ _13932_ VPWR VGND sg13g2_nor2_1
X_21001_ _14219_ _14218_ VPWR VGND sg13g2_buf_1
X_21002_ _14220_ \memory_i.uart_receiver.uart_rx_data[7]\ _13823_ _14219_ \memory_i.ds_defaults[7]\ VPWR
+ VGND
+ sg13g2_a22oi_1
X_21003_ _14221_ \memory_i.i2c_master.scl_ratio[7]\ _14111_ _14107_ \memory_i.uart_transmitter.CYCLES_PER_BIT[7]\ VPWR
+ VGND
+ sg13g2_a22oi_1
X_21004_ _14222_ \memory_i.mtime[39]\ _13901_ _13903_ \memory_i.mtime[7]\ VPWR
+ VGND
+ sg13g2_a22oi_1
X_21005_ _14223_ _14217_ _14220_ _14221_ _14222_ VPWR
+ VGND
+ sg13g2_nand4_1
X_21006_ _14224_ \memory_i.state[2]\ _14209_ _14223_ _13890_ VPWR
+ VGND
+ sg13g2_a22oi_1
X_21007_ _14225_ \mem_dataout[7]\ _14150_ VPWR VGND sg13g2_nor2_1
X_21008_ _00135_ _14163_ _14224_ _14225_ VPWR VGND sg13g2_a21oi_1
X_21009_ _14226_ \memory_i.target[0]\ _13913_ VPWR VGND sg13g2_nor2b_1
X_21010_ _14227_ \memory_i.target[0]\ _13911_ _14226_ VPWR VGND sg13g2_a21oi_1
X_21011_ _14228_ \memory_i.uart_receiver.uart_rx_data[6]\ _13823_ _14219_ \memory_i.ds_defaults[6]\ VPWR
+ VGND
+ sg13g2_a22oi_1
X_21012_ _14229_ \memory_i.i2c_master.scl_ratio[6]\ _14111_ VPWR VGND sg13g2_nand2_1
X_21013_ _14230_ \memory_i.uart_transmitter.CYCLES_PER_BIT[6]\ _14106_ _14213_ I_ae VPWR
+ VGND
+ sg13g2_a22oi_1
X_21014_ _14231_ \memory_i.uart_receiver.CYCLES_PER_BIT[6]\ _14128_ _13876_ \memory_i.ds_lo_conf[6]\ VPWR
+ VGND
+ sg13g2_a22oi_1
X_21015_ _14232_ _14228_ _14229_ _14230_ _14231_ VPWR
+ VGND
+ sg13g2_and4_1
X_21016_ _14233_ \memory_i.freq_inst.f_c[6]\ _13891_ _13935_ \memory_i.cordic_I[6]\ VPWR
+ VGND
+ sg13g2_a22oi_1
X_21017_ _14234_ \memory_i.mtimecmp[38]\ _13898_ _13895_ \memory_i.mtimecmp[6]\ VPWR
+ VGND
+ sg13g2_a22oi_1
X_21018_ _14235_ \memory_i.mtime[38]\ _13901_ _13903_ \memory_i.mtime[6]\ VPWR
+ VGND
+ sg13g2_a22oi_1
X_21019_ _14236_ _14232_ _14233_ _14234_ _14235_ VPWR
+ VGND
+ sg13g2_nand4_1
X_21020_ _14237_ \memory_i.i2c_addr[6]\ _13828_ _14236_ VPWR VGND sg13g2_a21o_1
X_21021_ _14238_ \memory_i.state[2]\ _14227_ _14237_ \memory_i.state[1]\ VPWR
+ VGND
+ sg13g2_a22oi_1
X_21022_ _14239_ \mem_dataout[6]\ _14150_ VPWR VGND sg13g2_nor2_1
X_21023_ _00136_ _14163_ _14238_ _14239_ VPWR VGND sg13g2_a21oi_1
X_21024_ _14240_ \memory_i.target[0]\ _13927_ VPWR VGND sg13g2_nor2b_1
X_21025_ _14241_ \memory_i.target[0]\ _13925_ _14240_ VPWR VGND sg13g2_a21oi_1
X_21026_ _14242_ \memory_i.uart_receiver.uart_rx_data[5]\ _13823_ _13876_ \memory_i.ds_lo_conf[5]\ VPWR
+ VGND
+ sg13g2_a22oi_1
X_21027_ _14243_ \memory_i.mtimecmp[37]\ _13898_ VPWR VGND sg13g2_nand2_1
X_21028_ _14244_ \memory_i.i2c_master.scl_ratio[5]\ _13878_ _14213_ Q_ae VPWR
+ VGND
+ sg13g2_a22oi_1
X_21029_ _14245_ \memory_i.uart_receiver.CYCLES_PER_BIT[5]\ _14127_ _14219_ \memory_i.ds_defaults[5]\ VPWR
+ VGND
+ sg13g2_a22oi_1
X_21030_ _14246_ _14242_ _14243_ _14244_ _14245_ VPWR
+ VGND
+ sg13g2_and4_1
X_21031_ _14247_ \memory_i.cordic_I[5]\ _13935_ _14107_ \memory_i.uart_transmitter.CYCLES_PER_BIT[5]\ VPWR
+ VGND
+ sg13g2_a22oi_1
X_21032_ _14248_ \memory_i.freq_inst.f_c[5]\ _13891_ _13895_ \memory_i.mtimecmp[5]\ VPWR
+ VGND
+ sg13g2_a22oi_1
X_21033_ _14249_ \memory_i.mtime[37]\ _13868_ _13903_ \memory_i.mtime[5]\ VPWR
+ VGND
+ sg13g2_a22oi_1
X_21034_ _14250_ _14246_ _14247_ _14248_ _14249_ VPWR
+ VGND
+ sg13g2_nand4_1
X_21035_ _14251_ \memory_i.i2c_addr[5]\ _13828_ _14250_ VPWR VGND sg13g2_a21o_1
X_21036_ _14252_ \memory_i.state[2]\ _14241_ _14251_ \memory_i.state[1]\ VPWR
+ VGND
+ sg13g2_a22oi_1
X_21037_ _14253_ \mem_dataout[5]\ _14150_ VPWR VGND sg13g2_nor2_1
X_21038_ _00137_ _14163_ _14252_ _14253_ VPWR VGND sg13g2_a21oi_1
X_21039_ _14254_ \memory_i.freq_inst.f_c[4]\ _13891_ _13895_ \memory_i.mtimecmp[4]\ VPWR
+ VGND
+ sg13g2_a22oi_1
X_21040_ _14255_ \memory_i.uart_receiver.CYCLES_PER_BIT[4]\ _14128_ VPWR VGND sg13g2_nand2_1
X_21041_ _14256_ \memory_i.i2c_acks[4]\ _13885_ VPWR VGND sg13g2_and2_1
X_21042_ _14257_ \memory_i.mtime[36]\ _13868_ _13883_ \memory_i.mtime[4]\ _14256_
+ VPWR
+ VGND sg13g2_a221oi_1
X_21043_ _14258_ \memory_i.uart_transmitter.CYCLES_PER_BIT[4]\ _14106_ _14213_ ds_I_oe VPWR
+ VGND
+ sg13g2_a22oi_1
X_21044_ _14259_ \memory_i.ds_lo_conf[4]\ _13876_ _14219_ \memory_i.ds_defaults[4]\ VPWR
+ VGND
+ sg13g2_a22oi_1
X_21045_ _14260_ \memory_i.mtimecmp[36]\ _13873_ _13934_ \memory_i.cordic_I[4]\ VPWR
+ VGND
+ sg13g2_a22oi_1
X_21046_ _14261_ \memory_i.uart_receiver.uart_rx_data[4]\ _13823_ _13878_ \memory_i.i2c_master.scl_ratio[4]\ VPWR
+ VGND
+ sg13g2_a22oi_1
X_21047_ _14262_ _14258_ _14259_ _14260_ _14261_ VPWR
+ VGND
+ sg13g2_and4_1
X_21048_ _14263_ _14254_ _14255_ _14257_ _14262_ VPWR
+ VGND
+ sg13g2_nand4_1
X_21049_ _14264_ \memory_i.i2c_addr[4]\ _13828_ _14263_ VPWR VGND sg13g2_a21o_1
X_21050_ _14265_ \memory_i.target[0]\ _13945_ VPWR VGND sg13g2_nor2b_1
X_21051_ _14266_ \memory_i.target[0]\ _13943_ _14265_ VPWR VGND sg13g2_a21oi_1
X_21052_ _14267_ \memory_i.state[1]\ _14264_ _14266_ \memory_i.state[2]\ VPWR
+ VGND
+ sg13g2_a22oi_1
X_21053_ _14268_ \mem_dataout[4]\ _14150_ VPWR VGND sg13g2_nor2_1
X_21054_ _00138_ _14163_ _14267_ _14268_ VPWR VGND sg13g2_a21oi_1
X_21055_ _14269_ \alu_i.funct7[6]\ VPWR VGND sg13g2_inv_1
X_21056_ _14270_ \alu_i.instruction[3]\ _13230_ VPWR VGND sg13g2_and2_1
X_21057_ _14271_ _14270_ VPWR VGND sg13g2_buf_1
X_21058_ _14272_ \alu_i.instruction[2]\ \alu_i.instruction[4]\ VPWR VGND sg13g2_nand2b_1
X_21059_ _14273_ _13226_ _14272_ _13207_ VPWR VGND sg13g2_a21oi_1
X_21060_ _14274_ \alu_i.instruction[6]\ \alu_i.instruction[5]\ \alu_i.instruction[2]\ VPWR VGND sg13g2_nor3_1
X_21061_ _14275_ _14273_ _14274_ VPWR VGND sg13g2_nor2_1
X_21062_ _14276_ _13011_ _14275_ VPWR VGND sg13g2_nor2_1
X_21063_ _14277_ _14271_ _14276_ VPWR VGND sg13g2_or2_1
X_21064_ _14278_ _14277_ VPWR VGND sg13g2_buf_1
X_21065_ _14279_ _13014_ _14278_ VPWR VGND sg13g2_or2_1
X_21066_ _14280_ _14279_ VPWR VGND sg13g2_buf_1
X_21067_ _14281_ _13233_ _14280_ reset VPWR VGND sg13g2_o21ai_1
X_21068_ _14282_ _14281_ VPWR VGND sg13g2_buf_1
X_21069_ _14283_ _14282_ VPWR VGND sg13g2_buf_1
X_21070_ _00139_ _14269_ _14283_ VPWR VGND sg13g2_nor2_1
X_21071_ _14284_ \alu_i.funct7[6]\ _14280_ VPWR VGND sg13g2_nand2_1
X_21072_ _14285_ _14284_ VPWR VGND sg13g2_buf_1
X_21073_ _14286_ _13233_ VPWR VGND sg13g2_buf_1
X_21074_ _14287_ \alu_i.funct7[5]\ _14286_ VPWR VGND sg13g2_nand2_1
X_21075_ _00140_ _14285_ _14287_ _14283_ VPWR VGND sg13g2_a21oi_1
X_21076_ _14288_ \alu_i.funct7[4]\ _14286_ VPWR VGND sg13g2_nand2_1
X_21077_ _00141_ _14285_ _14288_ _14283_ VPWR VGND sg13g2_a21oi_1
X_21078_ _14289_ \alu_i.funct7[3]\ _14286_ VPWR VGND sg13g2_nand2_1
X_21079_ _00142_ _14285_ _14289_ _14283_ VPWR VGND sg13g2_a21oi_1
X_21080_ _14290_ \alu_i.funct7[2]\ _14286_ VPWR VGND sg13g2_nand2_1
X_21081_ _00143_ _14285_ _14290_ _14283_ VPWR VGND sg13g2_a21oi_1
X_21082_ _14291_ \alu_i.funct7[1]\ _14286_ VPWR VGND sg13g2_nand2_1
X_21083_ _00144_ _14285_ _14291_ _14283_ VPWR VGND sg13g2_a21oi_1
X_21084_ _14292_ \alu_i.funct7[0]\ _14286_ VPWR VGND sg13g2_nand2_1
X_21085_ _00145_ _14285_ _14292_ _14283_ VPWR VGND sg13g2_a21oi_1
X_21086_ _14293_ \control_i.imm_gen_i.iword[24]\ _14286_ VPWR VGND sg13g2_nand2_1
X_21087_ _00146_ _14285_ _14293_ _14283_ VPWR VGND sg13g2_a21oi_1
X_21088_ _14294_ \control_i.imm_gen_i.iword[23]\ _14286_ VPWR VGND sg13g2_nand2_1
X_21089_ _00147_ _14285_ _14294_ _14283_ VPWR VGND sg13g2_a21oi_1
X_21090_ _14295_ \control_i.imm_gen_i.iword[22]\ _14286_ VPWR VGND sg13g2_nand2_1
X_21091_ _14296_ _14282_ VPWR VGND sg13g2_buf_1
X_21092_ _00148_ _14285_ _14295_ _14296_ VPWR VGND sg13g2_a21oi_1
X_21093_ _14297_ \control_i.imm_gen_i.iword[21]\ _14286_ VPWR VGND sg13g2_nand2_1
X_21094_ _00149_ _14285_ _14297_ _14296_ VPWR VGND sg13g2_a21oi_1
X_21095_ _14298_ \control_i.imm_gen_i.iword[20]\ _13233_ VPWR VGND sg13g2_nand2_1
X_21096_ _00150_ _14284_ _14298_ _14296_ VPWR VGND sg13g2_a21oi_1
X_21097_ _14299_ _13015_ _14276_ \alu_i.funct7[6]\ VPWR VGND sg13g2_o21ai_1
X_21098_ _14300_ \alu_i.funct7[6]\ _13209_ VPWR VGND sg13g2_nand2_1
X_21099_ _14301_ _14299_ _14300_ VPWR VGND sg13g2_and2_1
X_21100_ _14302_ _14301_ VPWR VGND sg13g2_buf_1
X_21101_ _14303_ _13233_ _14271_ VPWR VGND sg13g2_or2_1
X_21102_ _14304_ _14303_ VPWR VGND sg13g2_buf_1
X_21103_ _14305_ \control_i.imm_gen_i.iword[19]\ _14304_ VPWR VGND sg13g2_nand2_1
X_21104_ _00151_ _14302_ _14305_ _14296_ VPWR VGND sg13g2_a21oi_1
X_21105_ _14306_ \control_i.imm_gen_i.iword[18]\ _14304_ VPWR VGND sg13g2_nand2_1
X_21106_ _00152_ _14302_ _14306_ _14296_ VPWR VGND sg13g2_a21oi_1
X_21107_ _14307_ \control_i.imm_gen_i.iword[17]\ _14304_ VPWR VGND sg13g2_nand2_1
X_21108_ _00153_ _14302_ _14307_ _14296_ VPWR VGND sg13g2_a21oi_1
X_21109_ _14308_ \control_i.imm_gen_i.iword[16]\ _14304_ VPWR VGND sg13g2_nand2_1
X_21110_ _00154_ _14302_ _14308_ _14296_ VPWR VGND sg13g2_a21oi_1
X_21111_ _14309_ \control_i.imm_gen_i.iword[15]\ _14304_ VPWR VGND sg13g2_nand2_1
X_21112_ _00155_ _14302_ _14309_ _14296_ VPWR VGND sg13g2_a21oi_1
X_21113_ _14310_ \alu_i.funct3[2]\ _14304_ VPWR VGND sg13g2_nand2_1
X_21114_ _00156_ _14302_ _14310_ _14296_ VPWR VGND sg13g2_a21oi_1
X_21115_ _14311_ \alu_i.funct3[1]\ _14304_ VPWR VGND sg13g2_nand2_1
X_21116_ _00157_ _14302_ _14311_ _14296_ VPWR VGND sg13g2_a21oi_1
X_21117_ _14312_ \alu_i.funct3[0]\ _14304_ VPWR VGND sg13g2_nand2_1
X_21118_ _00158_ _14302_ _14312_ _14282_ VPWR VGND sg13g2_a21oi_1
X_21119_ _14313_ \control_i.imm_gen_i.iword[7]\ _13209_ _14271_ \control_i.imm_gen_i.iword[20]\ VPWR
+ VGND
+ sg13g2_a22oi_1
X_21120_ _00159_ _14299_ _14313_ _14282_ VPWR VGND sg13g2_a21oi_1
X_21121_ _14314_ reset _14280_ VPWR VGND sg13g2_and2_1
X_21122_ _14315_ _14314_ VPWR VGND sg13g2_buf_1
X_21123_ _00160_ \alu_i.funct7[5]\ _14315_ VPWR VGND sg13g2_and2_1
X_21124_ _00161_ \alu_i.funct7[4]\ _14315_ VPWR VGND sg13g2_and2_1
X_21125_ _00162_ \alu_i.funct7[3]\ _14315_ VPWR VGND sg13g2_and2_1
X_21126_ _00163_ \alu_i.funct7[2]\ _14315_ VPWR VGND sg13g2_and2_1
X_21127_ _00164_ \alu_i.funct7[1]\ _14315_ VPWR VGND sg13g2_and2_1
X_21128_ _00165_ \alu_i.funct7[0]\ _14315_ VPWR VGND sg13g2_and2_1
X_21129_ _14316_ \control_i.imm_gen_i.iword[11]\ _13014_ _14278_ \control_i.imm_gen_i.iword[24]\ VPWR
+ VGND
+ sg13g2_a22oi_1
X_21130_ _00166_ _00002_ _14316_ VPWR VGND sg13g2_nor2_1
X_21131_ _14317_ \control_i.imm_gen_i.iword[10]\ _13014_ _14278_ \control_i.imm_gen_i.iword[23]\ VPWR
+ VGND
+ sg13g2_a22oi_1
X_21132_ _00167_ _00002_ _14317_ VPWR VGND sg13g2_nor2_1
X_21133_ _14318_ _13307_ VPWR VGND sg13g2_buf_1
X_21134_ _14319_ \control_i.imm_gen_i.iword[9]\ _13014_ _14278_ \control_i.imm_gen_i.iword[22]\ VPWR
+ VGND
+ sg13g2_a22oi_1
X_21135_ _00168_ _14318_ _14319_ VPWR VGND sg13g2_nor2_1
X_21136_ _14320_ \control_i.imm_gen_i.iword[8]\ _13014_ _14278_ \control_i.imm_gen_i.iword[21]\ VPWR
+ VGND
+ sg13g2_a22oi_1
X_21137_ _00169_ _14318_ _14320_ VPWR VGND sg13g2_nor2_1
X_21138_ _14321_ \control_i.imm_gen_i.iword[7]\ _13015_ _14276_ \control_i.imm_gen_i.iword[20]\ VPWR
+ VGND
+ sg13g2_a22oi_1
X_21139_ _00170_ _14283_ _14321_ VPWR VGND sg13g2_nor2_1
X_21140_ _00171_ reset \regs.registers[0][0]\ VPWR VGND sg13g2_and2_1
X_21141_ _00172_ reset \regs.registers[0][1]\ VPWR VGND sg13g2_and2_1
X_21142_ _00173_ reset \regs.registers[0][2]\ VPWR VGND sg13g2_and2_1
X_21143_ _00174_ reset \regs.registers[0][3]\ VPWR VGND sg13g2_and2_1
X_21144_ _00175_ reset \regs.registers[0][4]\ VPWR VGND sg13g2_and2_1
X_21145_ _00176_ reset \regs.registers[0][5]\ VPWR VGND sg13g2_and2_1
X_21146_ _00177_ reset \regs.registers[0][6]\ VPWR VGND sg13g2_and2_1
X_21147_ _00178_ reset \regs.registers[0][7]\ VPWR VGND sg13g2_and2_1
X_21148_ _00179_ reset \regs.registers[0][8]\ VPWR VGND sg13g2_and2_1
X_21149_ _00180_ reset \regs.registers[0][9]\ VPWR VGND sg13g2_and2_1
X_21150_ _00181_ reset \regs.registers[0][10]\ VPWR VGND sg13g2_and2_1
X_21151_ _00182_ reset \regs.registers[0][11]\ VPWR VGND sg13g2_and2_1
X_21152_ _00183_ reset \regs.registers[0][12]\ VPWR VGND sg13g2_and2_1
X_21153_ _00184_ reset \regs.registers[0][13]\ VPWR VGND sg13g2_and2_1
X_21154_ _00185_ reset \regs.registers[0][14]\ VPWR VGND sg13g2_and2_1
X_21155_ _00186_ reset \regs.registers[0][15]\ VPWR VGND sg13g2_and2_1
X_21156_ _00187_ reset \regs.registers[0][16]\ VPWR VGND sg13g2_and2_1
X_21157_ _00188_ reset \regs.registers[0][17]\ VPWR VGND sg13g2_and2_1
X_21158_ _00189_ reset \regs.registers[0][18]\ VPWR VGND sg13g2_and2_1
X_21159_ _00190_ reset \regs.registers[0][19]\ VPWR VGND sg13g2_and2_1
X_21160_ _00191_ reset \regs.registers[0][20]\ VPWR VGND sg13g2_and2_1
X_21161_ _00192_ reset \regs.registers[0][21]\ VPWR VGND sg13g2_and2_1
X_21162_ _00193_ reset \regs.registers[0][22]\ VPWR VGND sg13g2_and2_1
X_21163_ _00194_ reset \regs.registers[0][23]\ VPWR VGND sg13g2_and2_1
X_21164_ _00195_ reset \regs.registers[0][24]\ VPWR VGND sg13g2_and2_1
X_21165_ _00196_ reset \regs.registers[0][25]\ VPWR VGND sg13g2_and2_1
X_21166_ _00197_ reset \regs.registers[0][26]\ VPWR VGND sg13g2_and2_1
X_21167_ _00198_ reset \regs.registers[0][27]\ VPWR VGND sg13g2_and2_1
X_21168_ _00199_ reset \regs.registers[0][28]\ VPWR VGND sg13g2_and2_1
X_21169_ _00200_ reset \regs.registers[0][29]\ VPWR VGND sg13g2_and2_1
X_21170_ _00201_ reset \regs.registers[0][30]\ VPWR VGND sg13g2_and2_1
X_21171_ _00202_ reset \regs.registers[0][31]\ VPWR VGND sg13g2_and2_1
X_21172_ _14322_ _13230_ VPWR VGND sg13g2_buf_1
X_21173_ _14323_ _14322_ VPWR VGND sg13g2_buf_1
X_21174_ _14324_ \alu_i.funct3[2]\ _13203_ \alu_i.funct3[0]\ _13240_ VPWR
+ VGND
+ sg13g2_nor4_1
X_21175_ _14325_ _14324_ VPWR VGND sg13g2_buf_1
X_21176_ _14326_ _14325_ VPWR VGND sg13g2_buf_1
X_21177_ _14327_ \rd_alu[0]\ \mem_dataout[0]\ _13190_ VPWR VGND sg13g2_mux2_1
X_21178_ _14328_ _14325_ VPWR VGND sg13g2_buf_1
X_21179_ _14329_ \csr_i.addr_reg[1]\ \csr_i.addr_reg[3]\ VPWR VGND sg13g2_nor2_1
X_21180_ _14330_ \csr_i.addr_reg[11]\ \csr_i.addr_reg[10]\ VPWR VGND sg13g2_nor2_1
X_21181_ _14331_ \csr_i.addr_reg[8]\ \csr_i.addr_reg[9]\ _14330_ VPWR VGND sg13g2_nand3_1
X_21182_ _14332_ \csr_i.addr_reg[5]\ \csr_i.addr_reg[4]\ \csr_i.addr_reg[7]\ _14331_ VPWR
+ VGND
+ sg13g2_nor4_1
X_21183_ _14333_ \csr_i.addr_reg[2]\ _14332_ VPWR VGND sg13g2_nor2b_1
X_21184_ _14334_ \csr_i.addr_reg[0]\ \csr_i.addr_reg[6]\ _14329_ _14333_ VPWR
+ VGND
+ sg13g2_and4_1
X_21185_ _14335_ _14334_ VPWR VGND sg13g2_buf_1
X_21186_ _14336_ \csr_i.addr_reg[1]\ \csr_i.addr_reg[3]\ VPWR VGND sg13g2_or2_1
X_21187_ _14337_ \csr_i.addr_reg[0]\ \csr_i.addr_reg[6]\ _14336_ VPWR VGND sg13g2_nor3_1
X_21188_ _14338_ _14333_ _14337_ VPWR VGND sg13g2_and2_1
X_21189_ _14339_ _14338_ VPWR VGND sg13g2_buf_1
X_21190_ _14340_ \csr_i.addr_reg[2]\ _14332_ VPWR VGND sg13g2_nand2_1
X_21191_ _14341_ \csr_i.addr_reg[0]\ \csr_i.addr_reg[3]\ VPWR VGND sg13g2_nor2_1
X_21192_ _14342_ \csr_i.addr_reg[6]\ _14341_ VPWR VGND sg13g2_nand2_1
X_21193_ _14343_ \csr_i.addr_reg[1]\ _14340_ _14342_ VPWR VGND sg13g2_nor3_1
X_21194_ _14344_ _14343_ VPWR VGND sg13g2_buf_1
X_21195_ _14345_ \csr_i.mip[0]\ _14344_ VPWR VGND sg13g2_and2_1
X_21196_ _14346_ \csr_i.isr_return[0]\ _14335_ _14339_ \csr_i.mstatus[0]\ _14345_
+ VPWR
+ VGND sg13g2_a221oi_1
X_21197_ _14347_ \csr_i.addr_reg[0]\ _14329_ VPWR VGND sg13g2_nand2_1
X_21198_ _14348_ \csr_i.addr_reg[6]\ _14347_ _14340_ VPWR VGND sg13g2_nor3_1
X_21199_ _14349_ _14348_ VPWR VGND sg13g2_buf_1
X_21200_ _14350_ _14349_ VPWR VGND sg13g2_buf_1
X_21201_ _14351_ \csr_i.mtvec[0]\ _14350_ VPWR VGND sg13g2_nand2_1
X_21202_ _14352_ \csr_i.addr_reg[0]\ \csr_i.addr_reg[6]\ _14336_ _14340_ VPWR
+ VGND
+ sg13g2_nor4_1
X_21203_ _14353_ _14352_ VPWR VGND sg13g2_buf_1
X_21204_ _14354_ \csr_i.addr_reg[1]\ \csr_i.addr_reg[6]\ _14333_ _14341_ VPWR
+ VGND
+ sg13g2_and4_1
X_21205_ _14355_ _14354_ VPWR VGND sg13g2_buf_1
X_21206_ _14356_ \csr_i.mie[0]\ _14353_ _14355_ \csr_i.mcause[0]\ VPWR
+ VGND
+ sg13g2_a22oi_1
X_21207_ _14357_ _14328_ _14346_ _14351_ _14356_ VPWR
+ VGND
+ sg13g2_nand4_1
X_21208_ _14358_ _14326_ _14327_ _14357_ VPWR VGND sg13g2_o21ai_1
X_21209_ _14359_ \csr_i.pc[0]\ _14322_ VPWR VGND sg13g2_nand2_1
X_21210_ _14360_ _14323_ _14358_ _14359_ VPWR VGND sg13g2_o21ai_1
X_21211_ _14361_ reset _14360_ VPWR VGND sg13g2_nand2_1
X_21212_ _14362_ _14361_ VPWR VGND sg13g2_buf_1
X_21213_ _14363_ _14362_ VPWR VGND sg13g2_buf_1
X_21214_ _14364_ reset \control_i.pcflag\ VPWR VGND sg13g2_nand2_1
X_21215_ _14365_ \control_i.imm_gen_i.iword[10]\ \control_i.imm_gen_i.iword[9]\ VPWR VGND sg13g2_nor2_1
X_21216_ _14366_ \control_i.imm_gen_i.iword[8]\ \control_i.imm_gen_i.iword[7]\ VPWR VGND sg13g2_nor2_1
X_21217_ _14367_ _14365_ _14366_ VPWR VGND sg13g2_and2_1
X_21218_ _14368_ _13014_ _13241_ _14364_ _14367_ VPWR
+ VGND
+ sg13g2_nor4_1
X_21219_ _14369_ _14368_ VPWR VGND sg13g2_buf_1
X_21220_ _14370_ \control_i.imm_gen_i.iword[7]\ _14369_ \control_i.imm_gen_i.iword[8]\ VPWR VGND sg13g2_nand3b_1
X_21221_ _14371_ _14370_ VPWR VGND sg13g2_buf_1
X_21222_ _14372_ \control_i.imm_gen_i.iword[9]\ \control_i.imm_gen_i.iword[10]\ VPWR VGND sg13g2_nand2b_1
X_21223_ _14373_ _14372_ VPWR VGND sg13g2_buf_1
X_21224_ _14374_ _14371_ _14373_ VPWR VGND sg13g2_or2_1
X_21225_ _14375_ _14374_ VPWR VGND sg13g2_buf_1
X_21226_ _14376_ _14375_ VPWR VGND sg13g2_buf_1
X_21227_ _14377_ _14375_ VPWR VGND sg13g2_buf_1
X_21228_ _14378_ \regs.registers[10][0]\ _14377_ VPWR VGND sg13g2_nand2_1
X_21229_ _00203_ _14363_ _14376_ _14378_ VPWR VGND sg13g2_o21ai_1
X_21230_ _14379_ _14322_ VPWR VGND sg13g2_buf_1
X_21231_ _14380_ _14325_ VPWR VGND sg13g2_buf_1
X_21232_ _14381_ _13190_ VPWR VGND sg13g2_buf_1
X_21233_ _14382_ \rd_alu[1]\ \mem_dataout[1]\ _14381_ VPWR VGND sg13g2_mux2_1
X_21234_ _14383_ _14335_ VPWR VGND sg13g2_buf_1
X_21235_ _14384_ _14339_ VPWR VGND sg13g2_buf_1
X_21236_ _14385_ _14344_ VPWR VGND sg13g2_buf_1
X_21237_ _14386_ \csr_i.mip[1]\ _14385_ VPWR VGND sg13g2_and2_1
X_21238_ _14387_ \csr_i.isr_return[1]\ _14383_ _14384_ \csr_i.mstatus[1]\ _14386_
+ VPWR
+ VGND sg13g2_a221oi_1
X_21239_ _14388_ _14353_ VPWR VGND sg13g2_buf_1
X_21240_ _14389_ \csr_i.mie[1]\ _14388_ VPWR VGND sg13g2_nand2_1
X_21241_ _14390_ _14355_ VPWR VGND sg13g2_buf_1
X_21242_ _14391_ \csr_i.mtvec[1]\ _14350_ _14390_ \csr_i.mcause[1]\ VPWR
+ VGND
+ sg13g2_a22oi_1
X_21243_ _14392_ _14326_ _14387_ _14389_ _14391_ VPWR
+ VGND
+ sg13g2_nand4_1
X_21244_ _14393_ _14380_ _14382_ _14392_ VPWR VGND sg13g2_o21ai_1
X_21245_ _14394_ \csr_i.pc[1]\ _14322_ VPWR VGND sg13g2_nand2_1
X_21246_ _14395_ _14379_ _14393_ _14394_ VPWR VGND sg13g2_o21ai_1
X_21247_ _14396_ reset _14395_ VPWR VGND sg13g2_nand2_1
X_21248_ _14397_ _14396_ VPWR VGND sg13g2_buf_1
X_21249_ _14398_ _14397_ VPWR VGND sg13g2_buf_1
X_21250_ _14399_ \regs.registers[10][1]\ _14377_ VPWR VGND sg13g2_nand2_1
X_21251_ _00204_ _14376_ _14398_ _14399_ VPWR VGND sg13g2_o21ai_1
X_21252_ _14400_ _13190_ VPWR VGND sg13g2_buf_1
X_21253_ _14401_ \mem_dataout[2]\ _13190_ VPWR VGND sg13g2_nand2_1
X_21254_ _14402_ _12981_ _14400_ _14401_ VPWR VGND sg13g2_o21ai_1
X_21255_ _14403_ \csr_i.mip[2]\ _14385_ VPWR VGND sg13g2_and2_1
X_21256_ _14404_ \csr_i.isr_return[2]\ _14383_ _14384_ \csr_i.mstatus[2]\ _14403_
+ VPWR
+ VGND sg13g2_a221oi_1
X_21257_ _14405_ _14349_ VPWR VGND sg13g2_buf_1
X_21258_ _14406_ \csr_i.mtvec[2]\ _14405_ VPWR VGND sg13g2_nand2_1
X_21259_ _14407_ _14353_ VPWR VGND sg13g2_buf_1
X_21260_ _14408_ _14355_ VPWR VGND sg13g2_buf_1
X_21261_ _14409_ \csr_i.mie[2]\ _14407_ _14408_ \csr_i.mcause[2]\ VPWR
+ VGND
+ sg13g2_a22oi_1
X_21262_ _14410_ _14326_ _14404_ _14406_ _14409_ VPWR
+ VGND
+ sg13g2_nand4_1
X_21263_ _14411_ _14380_ _14402_ _14410_ VPWR VGND sg13g2_o21ai_1
X_21264_ _14412_ \csr_i.pc[2]\ VPWR VGND sg13g2_inv_1
X_21265_ _14413_ _14412_ _14322_ VPWR VGND sg13g2_nand2_1
X_21266_ _14414_ _14379_ _14411_ _14413_ VPWR VGND sg13g2_o21ai_1
X_21267_ _14415_ reset _14414_ VPWR VGND sg13g2_nand2_1
X_21268_ _14416_ _14415_ VPWR VGND sg13g2_buf_1
X_21269_ _14417_ _14416_ VPWR VGND sg13g2_buf_1
X_21270_ _14418_ \regs.registers[10][2]\ _14377_ VPWR VGND sg13g2_nand2_1
X_21271_ _00205_ _14376_ _14417_ _14418_ VPWR VGND sg13g2_o21ai_1
X_21272_ _14419_ \rd_alu[3]\ \mem_dataout[3]\ _14381_ VPWR VGND sg13g2_mux2_1
X_21273_ _14420_ \csr_i.mip[3]\ _14385_ VPWR VGND sg13g2_and2_1
X_21274_ _14421_ \csr_i.isr_return[3]\ _14383_ _14384_ \csr_i.mstatus[3]\ _14420_
+ VPWR
+ VGND sg13g2_a221oi_1
X_21275_ _14422_ \csr_i.mtvec[3]\ _14350_ VPWR VGND sg13g2_nand2_1
X_21276_ _14423_ \csr_i.mie[3]\ _14407_ _14408_ \csr_i.mcause[3]\ VPWR
+ VGND
+ sg13g2_a22oi_1
X_21277_ _14424_ _14326_ _14421_ _14422_ _14423_ VPWR
+ VGND
+ sg13g2_nand4_1
X_21278_ _14425_ _14380_ _14419_ _14424_ VPWR VGND sg13g2_o21ai_1
X_21279_ _14426_ \csr_i.pc[3]\ \csr_i.pc[2]\ VPWR VGND sg13g2_xor2_1
X_21280_ _14427_ _14323_ _14426_ VPWR VGND sg13g2_nand2_1
X_21281_ _14428_ _14379_ _14425_ _14427_ VPWR VGND sg13g2_o21ai_1
X_21282_ _14429_ reset _14428_ VPWR VGND sg13g2_nand2_1
X_21283_ _14430_ _14429_ VPWR VGND sg13g2_buf_1
X_21284_ _14431_ _14430_ VPWR VGND sg13g2_buf_1
X_21285_ _14432_ \regs.registers[10][3]\ _14377_ VPWR VGND sg13g2_nand2_1
X_21286_ _00206_ _14376_ _14431_ _14432_ VPWR VGND sg13g2_o21ai_1
X_21287_ _14433_ \rd_alu[4]\ \mem_dataout[4]\ _14381_ VPWR VGND sg13g2_mux2_1
X_21288_ _14434_ \csr_i.mip[4]\ _14385_ VPWR VGND sg13g2_and2_1
X_21289_ _14435_ \csr_i.isr_return[4]\ _14383_ _14384_ \csr_i.mstatus[4]\ _14434_
+ VPWR
+ VGND sg13g2_a221oi_1
X_21290_ _14436_ \csr_i.mtvec[4]\ _14350_ VPWR VGND sg13g2_nand2_1
X_21291_ _14437_ \csr_i.mie[4]\ _14407_ _14408_ \csr_i.mcause[4]\ VPWR
+ VGND
+ sg13g2_a22oi_1
X_21292_ _14438_ _14326_ _14435_ _14436_ _14437_ VPWR
+ VGND
+ sg13g2_nand4_1
X_21293_ _14439_ _14380_ _14433_ _14438_ VPWR VGND sg13g2_o21ai_1
X_21294_ _14440_ \csr_i.pc[3]\ \csr_i.pc[2]\ VPWR VGND sg13g2_nand2_1
X_21295_ _14441_ \csr_i.pc[4]\ _14440_ VPWR VGND sg13g2_xnor2_1
X_21296_ _14442_ _14323_ _14441_ VPWR VGND sg13g2_nand2_1
X_21297_ _14443_ _14379_ _14439_ _14442_ VPWR VGND sg13g2_o21ai_1
X_21298_ _14444_ reset _14443_ VPWR VGND sg13g2_nand2_1
X_21299_ _14445_ _14444_ VPWR VGND sg13g2_buf_1
X_21300_ _14446_ _14445_ VPWR VGND sg13g2_buf_1
X_21301_ _14447_ \regs.registers[10][4]\ _14377_ VPWR VGND sg13g2_nand2_1
X_21302_ _00207_ _14376_ _14446_ _14447_ VPWR VGND sg13g2_o21ai_1
X_21303_ _14448_ \rd_alu[5]\ \mem_dataout[5]\ _14381_ VPWR VGND sg13g2_mux2_1
X_21304_ _14449_ \csr_i.mip[5]\ _14385_ VPWR VGND sg13g2_and2_1
X_21305_ _14450_ \csr_i.isr_return[5]\ _14383_ _14384_ \csr_i.mstatus[5]\ _14449_
+ VPWR
+ VGND sg13g2_a221oi_1
X_21306_ _14451_ \csr_i.mie[5]\ _14407_ VPWR VGND sg13g2_nand2_1
X_21307_ _14452_ \csr_i.mtvec[5]\ _14350_ _14408_ \csr_i.mcause[5]\ VPWR
+ VGND
+ sg13g2_a22oi_1
X_21308_ _14453_ _14328_ _14450_ _14451_ _14452_ VPWR
+ VGND
+ sg13g2_nand4_1
X_21309_ _14454_ _14380_ _14448_ _14453_ VPWR VGND sg13g2_o21ai_1
X_21310_ _14455_ \csr_i.pc[4]\ \csr_i.pc[3]\ \csr_i.pc[2]\ VPWR VGND sg13g2_nand3_1
X_21311_ _14456_ \csr_i.pc[5]\ _14455_ VPWR VGND sg13g2_xnor2_1
X_21312_ _14457_ _14323_ _14456_ VPWR VGND sg13g2_nand2_1
X_21313_ _14458_ _14379_ _14454_ _14457_ VPWR VGND sg13g2_o21ai_1
X_21314_ _14459_ reset _14458_ VPWR VGND sg13g2_nand2_1
X_21315_ _14460_ _14459_ VPWR VGND sg13g2_buf_1
X_21316_ _14461_ _14460_ VPWR VGND sg13g2_buf_1
X_21317_ _14462_ \regs.registers[10][5]\ _14377_ VPWR VGND sg13g2_nand2_1
X_21318_ _00208_ _14376_ _14461_ _14462_ VPWR VGND sg13g2_o21ai_1
X_21319_ _14463_ _14335_ VPWR VGND sg13g2_buf_1
X_21320_ _14464_ _14463_ VPWR VGND sg13g2_buf_1
X_21321_ _14465_ _14390_ VPWR VGND sg13g2_buf_1
X_21322_ _14466_ \csr_i.isr_return[6]\ _14464_ _14465_ \csr_i.mcause[6]\ VPWR
+ VGND
+ sg13g2_a22oi_1
X_21323_ _14467_ _14388_ VPWR VGND sg13g2_buf_1
X_21324_ _14468_ _14405_ VPWR VGND sg13g2_buf_1
X_21325_ _14469_ \csr_i.mie[6]\ _14467_ _14468_ \csr_i.mtvec[6]\ VPWR
+ VGND
+ sg13g2_a22oi_1
X_21326_ _14470_ _14385_ VPWR VGND sg13g2_buf_1
X_21327_ _14471_ _14339_ VPWR VGND sg13g2_buf_1
X_21328_ _14472_ _13224_ VPWR VGND sg13g2_buf_1
X_21329_ _14473_ \csr_i.mip[6]\ _14470_ _14471_ \csr_i.mstatus[6]\ _14472_
+ VPWR
+ VGND sg13g2_a221oi_1
X_21330_ _14474_ _14466_ _14469_ _14473_ VPWR VGND sg13g2_nand3_1
X_21331_ _14475_ _13224_ VPWR VGND sg13g2_buf_1
X_21332_ _14476_ \mem_dataout[6]\ _14400_ VPWR VGND sg13g2_nand2b_1
X_21333_ _14477_ \rd_alu[6]\ _13191_ _14476_ VPWR VGND sg13g2_o21ai_1
X_21334_ _14478_ _13225_ _13228_ reset VPWR VGND sg13g2_o21ai_1
X_21335_ _14479_ _14478_ VPWR VGND sg13g2_buf_1
X_21336_ _14480_ _14479_ VPWR VGND sg13g2_buf_1
X_21337_ _14481_ _14475_ _14477_ _14480_ VPWR VGND sg13g2_a21oi_1
X_21338_ _14482_ _12947_ _13225_ _13228_ VPWR VGND sg13g2_nor3_1
X_21339_ _14483_ _14482_ VPWR VGND sg13g2_buf_1
X_21340_ _14484_ _14412_ _13031_ VPWR VGND sg13g2_nor2_1
X_21341_ _14485_ \csr_i.pc[6]\ _14484_ VPWR VGND sg13g2_xor2_1
X_21342_ _14486_ _14474_ _14481_ _14483_ _14485_ VPWR
+ VGND
+ sg13g2_a22oi_1
X_21343_ _14487_ _14486_ VPWR VGND sg13g2_buf_1
X_21344_ _14488_ _14487_ VPWR VGND sg13g2_buf_1
X_21345_ _14489_ \regs.registers[10][6]\ _14377_ VPWR VGND sg13g2_nand2_1
X_21346_ _00209_ _14376_ _14488_ _14489_ VPWR VGND sg13g2_o21ai_1
X_21347_ _14490_ \csr_i.mie[7]\ _14467_ _14468_ \csr_i.mtvec[7]\ VPWR
+ VGND
+ sg13g2_a22oi_1
X_21348_ _14491_ \csr_i.isr_return[7]\ _14464_ _14465_ \csr_i.mcause[7]\ VPWR
+ VGND
+ sg13g2_a22oi_1
X_21349_ _14492_ _14471_ VPWR VGND sg13g2_buf_1
X_21350_ _14493_ \csr_i.mip[7]\ _14470_ _14492_ \csr_i.mstatus[7]\ VPWR
+ VGND
+ sg13g2_a22oi_1
X_21351_ _14494_ _14380_ _14490_ _14491_ _14493_ VPWR
+ VGND
+ sg13g2_nand4_1
X_21352_ _14495_ _13224_ VPWR VGND sg13g2_buf_1
X_21353_ _14496_ _14381_ VPWR VGND sg13g2_buf_1
X_21354_ _14497_ _14400_ \rd_alu[7]\ VPWR VGND sg13g2_nor2b_1
X_21355_ _14498_ \mem_dataout[7]\ _14496_ _14497_ VPWR VGND sg13g2_a21oi_1
X_21356_ _14499_ _14495_ _14498_ _14479_ VPWR VGND sg13g2_a21oi_1
X_21357_ _14500_ \csr_i.pc[6]\ _14484_ VPWR VGND sg13g2_nand2_1
X_21358_ _14501_ \csr_i.pc[7]\ _14500_ VPWR VGND sg13g2_xnor2_1
X_21359_ _14502_ _14494_ _14499_ _14501_ _14483_ VPWR
+ VGND
+ sg13g2_a22oi_1
X_21360_ _14503_ _14502_ VPWR VGND sg13g2_buf_1
X_21361_ _14504_ _14503_ VPWR VGND sg13g2_buf_1
X_21362_ _14505_ _14375_ VPWR VGND sg13g2_buf_1
X_21363_ _14506_ \regs.registers[10][7]\ _14505_ VPWR VGND sg13g2_nand2_1
X_21364_ _00210_ _14376_ _14504_ _14506_ VPWR VGND sg13g2_o21ai_1
X_21365_ _14507_ \csr_i.mie[8]\ _14467_ _14468_ \csr_i.mtvec[8]\ VPWR
+ VGND
+ sg13g2_a22oi_1
X_21366_ _14508_ \csr_i.isr_return[8]\ _14464_ _14465_ \csr_i.mcause[8]\ VPWR
+ VGND
+ sg13g2_a22oi_1
X_21367_ _14509_ \csr_i.mip[8]\ _14470_ _14471_ \csr_i.mstatus[8]\ VPWR
+ VGND
+ sg13g2_a22oi_1
X_21368_ _14510_ _14380_ _14507_ _14508_ _14509_ VPWR
+ VGND
+ sg13g2_nand4_1
X_21369_ _14511_ _14400_ \rd_alu[8]\ VPWR VGND sg13g2_nor2b_1
X_21370_ _14512_ \mem_dataout[8]\ _14496_ _14511_ VPWR VGND sg13g2_a21oi_1
X_21371_ _14513_ _14495_ _14512_ _14479_ VPWR VGND sg13g2_a21oi_1
X_21372_ _14514_ \csr_i.pc[7]\ \csr_i.pc[6]\ _14484_ VPWR VGND sg13g2_and3_1
X_21373_ _14515_ _14514_ VPWR VGND sg13g2_buf_1
X_21374_ _14516_ \csr_i.pc[8]\ _14515_ VPWR VGND sg13g2_xor2_1
X_21375_ _14517_ _14510_ _14513_ _14516_ _14483_ VPWR
+ VGND
+ sg13g2_a22oi_1
X_21376_ _14518_ _14517_ VPWR VGND sg13g2_buf_1
X_21377_ _14519_ _14518_ VPWR VGND sg13g2_buf_1
X_21378_ _14520_ \regs.registers[10][8]\ _14505_ VPWR VGND sg13g2_nand2_1
X_21379_ _00211_ _14376_ _14519_ _14520_ VPWR VGND sg13g2_o21ai_1
X_21380_ _14521_ \rd_alu[9]\ \mem_dataout[9]\ _14381_ VPWR VGND sg13g2_mux2_1
X_21381_ _14522_ \csr_i.mip[9]\ _14385_ VPWR VGND sg13g2_and2_1
X_21382_ _14523_ \csr_i.isr_return[9]\ _14383_ _14384_ \csr_i.mstatus[9]\ _14522_
+ VPWR
+ VGND sg13g2_a221oi_1
X_21383_ _14524_ \csr_i.mie[9]\ _14407_ VPWR VGND sg13g2_nand2_1
X_21384_ _14525_ \csr_i.mtvec[9]\ _14349_ _14408_ \csr_i.mcause[9]\ VPWR
+ VGND
+ sg13g2_a22oi_1
X_21385_ _14526_ _14328_ _14523_ _14524_ _14525_ VPWR
+ VGND
+ sg13g2_nand4_1
X_21386_ _14527_ _14380_ _14521_ _14526_ VPWR VGND sg13g2_o21ai_1
X_21387_ _14528_ \csr_i.pc[8]\ _14515_ VPWR VGND sg13g2_nand2_1
X_21388_ _14529_ \csr_i.pc[9]\ _14528_ VPWR VGND sg13g2_xnor2_1
X_21389_ _14530_ _14323_ _14529_ VPWR VGND sg13g2_nand2_1
X_21390_ _14531_ _14379_ _14527_ _14530_ VPWR VGND sg13g2_o21ai_1
X_21391_ _14532_ reset _14531_ VPWR VGND sg13g2_nand2_1
X_21392_ _14533_ _14532_ VPWR VGND sg13g2_buf_1
X_21393_ _14534_ _14533_ VPWR VGND sg13g2_buf_1
X_21394_ _14535_ \regs.registers[10][9]\ _14505_ VPWR VGND sg13g2_nand2_1
X_21395_ _00212_ _14376_ _14534_ _14535_ VPWR VGND sg13g2_o21ai_1
X_21396_ _14536_ _14375_ VPWR VGND sg13g2_buf_1
X_21397_ _14537_ \csr_i.isr_return[10]\ _14464_ _14465_ \csr_i.mcause[10]\ VPWR
+ VGND
+ sg13g2_a22oi_1
X_21398_ _14538_ \csr_i.mie[10]\ _14467_ _14468_ \csr_i.mtvec[10]\ VPWR
+ VGND
+ sg13g2_a22oi_1
X_21399_ _14539_ \csr_i.mip[10]\ _14470_ _14471_ \csr_i.mstatus[10]\ VPWR
+ VGND
+ sg13g2_a22oi_1
X_21400_ _14540_ _14380_ _14537_ _14538_ _14539_ VPWR
+ VGND
+ sg13g2_nand4_1
X_21401_ _14541_ _14400_ \rd_alu[10]\ VPWR VGND sg13g2_nor2b_1
X_21402_ _14542_ \mem_dataout[10]\ _14496_ _14541_ VPWR VGND sg13g2_a21oi_1
X_21403_ _14543_ _14495_ _14542_ _14479_ VPWR VGND sg13g2_a21oi_1
X_21404_ _14544_ \csr_i.pc[9]\ \csr_i.pc[8]\ _14515_ VPWR VGND sg13g2_nand3_1
X_21405_ _14545_ \csr_i.pc[10]\ _14544_ VPWR VGND sg13g2_xnor2_1
X_21406_ _14546_ _14540_ _14543_ _14545_ _14483_ VPWR
+ VGND
+ sg13g2_a22oi_1
X_21407_ _14547_ _14546_ VPWR VGND sg13g2_buf_1
X_21408_ _14548_ _14547_ VPWR VGND sg13g2_buf_1
X_21409_ _14549_ \regs.registers[10][10]\ _14505_ VPWR VGND sg13g2_nand2_1
X_21410_ _00213_ _14536_ _14548_ _14549_ VPWR VGND sg13g2_o21ai_1
X_21411_ _14550_ \csr_i.mie[11]\ _14467_ _14468_ \csr_i.mtvec[11]\ VPWR
+ VGND
+ sg13g2_a22oi_1
X_21412_ _14551_ \csr_i.isr_return[11]\ _14464_ _14465_ \csr_i.mcause[11]\ VPWR
+ VGND
+ sg13g2_a22oi_1
X_21413_ _14552_ \csr_i.mip[11]\ _14470_ _14471_ \csr_i.mstatus[11]\ _14472_
+ VPWR
+ VGND sg13g2_a221oi_1
X_21414_ _14553_ _14550_ _14551_ _14552_ VPWR VGND sg13g2_nand3_1
X_21415_ _14554_ \mem_dataout[11]\ _14400_ VPWR VGND sg13g2_nand2b_1
X_21416_ _14555_ \rd_alu[11]\ _13191_ _14554_ VPWR VGND sg13g2_o21ai_1
X_21417_ _14556_ _14495_ _14555_ _14479_ VPWR VGND sg13g2_a21oi_1
X_21418_ _14557_ \csr_i.pc[10]\ VPWR VGND sg13g2_inv_1
X_21419_ _14558_ _14557_ _14544_ VPWR VGND sg13g2_nor2_1
X_21420_ _14559_ \csr_i.pc[11]\ _14558_ VPWR VGND sg13g2_xor2_1
X_21421_ _14560_ _14553_ _14556_ _14559_ _14483_ VPWR
+ VGND
+ sg13g2_a22oi_1
X_21422_ _14561_ _14560_ VPWR VGND sg13g2_buf_1
X_21423_ _14562_ _14561_ VPWR VGND sg13g2_buf_1
X_21424_ _14563_ \regs.registers[10][11]\ _14505_ VPWR VGND sg13g2_nand2_1
X_21425_ _00214_ _14536_ _14562_ _14563_ VPWR VGND sg13g2_o21ai_1
X_21426_ _14564_ \csr_i.mie[12]\ _14467_ _14468_ \csr_i.mtvec[12]\ VPWR
+ VGND
+ sg13g2_a22oi_1
X_21427_ _14565_ \csr_i.isr_return[12]\ _14464_ _14465_ \csr_i.mcause[12]\ VPWR
+ VGND
+ sg13g2_a22oi_1
X_21428_ _14566_ \csr_i.mip[12]\ _14470_ _14471_ \csr_i.mstatus[12]\ _14472_
+ VPWR
+ VGND sg13g2_a221oi_1
X_21429_ _14567_ _14564_ _14565_ _14566_ VPWR VGND sg13g2_nand3_1
X_21430_ _14568_ \mem_dataout[12]\ _14400_ VPWR VGND sg13g2_nand2b_1
X_21431_ _14569_ \rd_alu[12]\ _13191_ _14568_ VPWR VGND sg13g2_o21ai_1
X_21432_ _14570_ _14495_ _14569_ _14479_ VPWR VGND sg13g2_a21oi_1
X_21433_ _14571_ \csr_i.pc[11]\ _14558_ VPWR VGND sg13g2_nand2_1
X_21434_ _14572_ \csr_i.pc[12]\ _14571_ VPWR VGND sg13g2_xnor2_1
X_21435_ _14573_ _14567_ _14570_ _14572_ _14483_ VPWR
+ VGND
+ sg13g2_a22oi_1
X_21436_ _14574_ _14573_ VPWR VGND sg13g2_buf_1
X_21437_ _14575_ _14574_ VPWR VGND sg13g2_buf_1
X_21438_ _14576_ \regs.registers[10][12]\ _14505_ VPWR VGND sg13g2_nand2_1
X_21439_ _00215_ _14536_ _14575_ _14576_ VPWR VGND sg13g2_o21ai_1
X_21440_ _14577_ \rd_alu[13]\ \mem_dataout[13]\ _14381_ VPWR VGND sg13g2_mux2_1
X_21441_ _14578_ \csr_i.mip[13]\ _14385_ VPWR VGND sg13g2_and2_1
X_21442_ _14579_ \csr_i.isr_return[13]\ _14383_ _14384_ \csr_i.mstatus[13]\ _14578_
+ VPWR
+ VGND sg13g2_a221oi_1
X_21443_ _14580_ \csr_i.mtvec[13]\ _14350_ VPWR VGND sg13g2_nand2_1
X_21444_ _14581_ \csr_i.mie[13]\ _14407_ _14408_ \csr_i.mcause[13]\ VPWR
+ VGND
+ sg13g2_a22oi_1
X_21445_ _14582_ _14328_ _14579_ _14580_ _14581_ VPWR
+ VGND
+ sg13g2_nand4_1
X_21446_ _14583_ _14380_ _14577_ _14582_ VPWR VGND sg13g2_o21ai_1
X_21447_ _14584_ \csr_i.pc[12]\ \csr_i.pc[11]\ _14558_ VPWR VGND sg13g2_nand3_1
X_21448_ _14585_ \csr_i.pc[13]\ _14584_ VPWR VGND sg13g2_xnor2_1
X_21449_ _14586_ _14323_ _14585_ VPWR VGND sg13g2_nand2_1
X_21450_ _14587_ _14379_ _14583_ _14586_ VPWR VGND sg13g2_o21ai_1
X_21451_ _14588_ reset _14587_ VPWR VGND sg13g2_nand2_1
X_21452_ _14589_ _14588_ VPWR VGND sg13g2_buf_1
X_21453_ _14590_ _14589_ VPWR VGND sg13g2_buf_1
X_21454_ _14591_ \regs.registers[10][13]\ _14505_ VPWR VGND sg13g2_nand2_1
X_21455_ _00216_ _14536_ _14590_ _14591_ VPWR VGND sg13g2_o21ai_1
X_21456_ _14592_ \rd_alu[14]\ \mem_dataout[14]\ _14381_ VPWR VGND sg13g2_mux2_1
X_21457_ _14593_ \csr_i.mip[14]\ _14344_ VPWR VGND sg13g2_and2_1
X_21458_ _14594_ \csr_i.isr_return[14]\ _14383_ _14384_ \csr_i.mstatus[14]\ _14593_
+ VPWR
+ VGND sg13g2_a221oi_1
X_21459_ _14595_ \csr_i.mie[14]\ _14407_ VPWR VGND sg13g2_nand2_1
X_21460_ _14596_ \csr_i.mtvec[14]\ _14349_ _14408_ \csr_i.mcause[14]\ VPWR
+ VGND
+ sg13g2_a22oi_1
X_21461_ _14597_ _14328_ _14594_ _14595_ _14596_ VPWR
+ VGND
+ sg13g2_nand4_1
X_21462_ _14598_ _14326_ _14592_ _14597_ VPWR VGND sg13g2_o21ai_1
X_21463_ _14599_ \csr_i.pc[13]\ VPWR VGND sg13g2_inv_1
X_21464_ _14600_ _14599_ _14584_ VPWR VGND sg13g2_nor2_1
X_21465_ _14601_ \csr_i.pc[14]\ _14600_ VPWR VGND sg13g2_xor2_1
X_21466_ _14602_ _14323_ _14601_ VPWR VGND sg13g2_nand2_1
X_21467_ _14603_ _14379_ _14598_ _14602_ VPWR VGND sg13g2_o21ai_1
X_21468_ _14604_ reset _14603_ VPWR VGND sg13g2_nand2_1
X_21469_ _14605_ _14604_ VPWR VGND sg13g2_buf_1
X_21470_ _14606_ _14605_ VPWR VGND sg13g2_buf_1
X_21471_ _14607_ \regs.registers[10][14]\ _14505_ VPWR VGND sg13g2_nand2_1
X_21472_ _00217_ _14536_ _14606_ _14607_ VPWR VGND sg13g2_o21ai_1
X_21473_ _14608_ \rd_alu[15]\ \mem_dataout[15]\ _14381_ VPWR VGND sg13g2_mux2_1
X_21474_ _14609_ \csr_i.mip[15]\ _14344_ VPWR VGND sg13g2_and2_1
X_21475_ _14610_ \csr_i.isr_return[15]\ _14383_ _14384_ \csr_i.mstatus[15]\ _14609_
+ VPWR
+ VGND sg13g2_a221oi_1
X_21476_ _14611_ \csr_i.mtvec[15]\ _14350_ VPWR VGND sg13g2_nand2_1
X_21477_ _14612_ \csr_i.mie[15]\ _14407_ _14408_ \csr_i.mcause[15]\ VPWR
+ VGND
+ sg13g2_a22oi_1
X_21478_ _14613_ _14328_ _14610_ _14611_ _14612_ VPWR
+ VGND
+ sg13g2_nand4_1
X_21479_ _14614_ _14326_ _14608_ _14613_ VPWR VGND sg13g2_o21ai_1
X_21480_ _14615_ \csr_i.pc[14]\ _14600_ VPWR VGND sg13g2_nand2_1
X_21481_ _14616_ \csr_i.pc[15]\ _14615_ VPWR VGND sg13g2_xnor2_1
X_21482_ _14617_ _14322_ _14616_ VPWR VGND sg13g2_nand2_1
X_21483_ _14618_ _14379_ _14614_ _14617_ VPWR VGND sg13g2_o21ai_1
X_21484_ _14619_ reset _14618_ VPWR VGND sg13g2_nand2_1
X_21485_ _14620_ _14619_ VPWR VGND sg13g2_buf_1
X_21486_ _14621_ _14620_ VPWR VGND sg13g2_buf_1
X_21487_ _14622_ \regs.registers[10][15]\ _14505_ VPWR VGND sg13g2_nand2_1
X_21488_ _00218_ _14536_ _14621_ _14622_ VPWR VGND sg13g2_o21ai_1
X_21489_ _14623_ \csr_i.mie[16]\ _14467_ _14468_ \csr_i.mtvec[16]\ VPWR
+ VGND
+ sg13g2_a22oi_1
X_21490_ _14624_ \csr_i.isr_return[16]\ _14464_ _14465_ \csr_i.mcause[16]\ VPWR
+ VGND
+ sg13g2_a22oi_1
X_21491_ _14625_ \csr_i.mip[16]\ _14470_ _14471_ \csr_i.mstatus[16]\ _13224_
+ VPWR
+ VGND sg13g2_a221oi_1
X_21492_ _14626_ _14623_ _14624_ _14625_ VPWR VGND sg13g2_nand3_1
X_21493_ _14627_ \mem_dataout[16]\ _14400_ VPWR VGND sg13g2_nand2b_1
X_21494_ _14628_ \rd_alu[16]\ _13191_ _14627_ VPWR VGND sg13g2_o21ai_1
X_21495_ _14629_ _14495_ _14628_ _14479_ VPWR VGND sg13g2_a21oi_1
X_21496_ _14630_ \csr_i.pc[15]\ \csr_i.pc[14]\ _14600_ VPWR VGND sg13g2_nand3_1
X_21497_ _14631_ \csr_i.pc[16]\ _14630_ VPWR VGND sg13g2_xnor2_1
X_21498_ _14632_ _14626_ _14629_ _14631_ _14483_ VPWR
+ VGND
+ sg13g2_a22oi_1
X_21499_ _14633_ _14632_ VPWR VGND sg13g2_buf_1
X_21500_ _14634_ _14633_ VPWR VGND sg13g2_buf_1
X_21501_ _14635_ \regs.registers[10][16]\ _14505_ VPWR VGND sg13g2_nand2_1
X_21502_ _00219_ _14536_ _14634_ _14635_ VPWR VGND sg13g2_o21ai_1
X_21503_ _14636_ \rd_alu[17]\ \mem_dataout[17]\ _14381_ VPWR VGND sg13g2_mux2_1
X_21504_ _14637_ \csr_i.mip[17]\ _14344_ VPWR VGND sg13g2_and2_1
X_21505_ _14638_ \csr_i.isr_return[17]\ _14383_ _14384_ \csr_i.mstatus[17]\ _14637_
+ VPWR
+ VGND sg13g2_a221oi_1
X_21506_ _14639_ \csr_i.mtvec[17]\ _14350_ VPWR VGND sg13g2_nand2_1
X_21507_ _14640_ \csr_i.mie[17]\ _14407_ _14408_ \csr_i.mcause[17]\ VPWR
+ VGND
+ sg13g2_a22oi_1
X_21508_ _14641_ _14328_ _14638_ _14639_ _14640_ VPWR
+ VGND
+ sg13g2_nand4_1
X_21509_ _14642_ _14326_ _14636_ _14641_ VPWR VGND sg13g2_o21ai_1
X_21510_ _14643_ \csr_i.pc[16]\ VPWR VGND sg13g2_inv_1
X_21511_ _14644_ _14643_ _14630_ VPWR VGND sg13g2_nor2_1
X_21512_ _14645_ \csr_i.pc[17]\ _14644_ VPWR VGND sg13g2_xnor2_1
X_21513_ _14646_ _14645_ _14322_ VPWR VGND sg13g2_nand2b_1
X_21514_ _14647_ _14379_ _14642_ _14646_ VPWR VGND sg13g2_o21ai_1
X_21515_ _14648_ reset _14647_ VPWR VGND sg13g2_nand2_1
X_21516_ _14649_ _14648_ VPWR VGND sg13g2_buf_1
X_21517_ _14650_ _14649_ VPWR VGND sg13g2_buf_1
X_21518_ _14651_ \regs.registers[10][17]\ _14375_ VPWR VGND sg13g2_nand2_1
X_21519_ _00220_ _14536_ _14650_ _14651_ VPWR VGND sg13g2_o21ai_1
X_21520_ _14652_ \csr_i.mie[18]\ _14467_ _14468_ \csr_i.mtvec[18]\ VPWR
+ VGND
+ sg13g2_a22oi_1
X_21521_ _14653_ \csr_i.isr_return[18]\ _14464_ _14465_ \csr_i.mcause[18]\ VPWR
+ VGND
+ sg13g2_a22oi_1
X_21522_ _14654_ \csr_i.mip[18]\ _14470_ _14471_ \csr_i.mstatus[18]\ _13224_
+ VPWR
+ VGND sg13g2_a221oi_1
X_21523_ _14655_ _14652_ _14653_ _14654_ VPWR VGND sg13g2_nand3_1
X_21524_ _14656_ \mem_dataout[18]\ _14400_ VPWR VGND sg13g2_nand2b_1
X_21525_ _14657_ \rd_alu[18]\ _13191_ _14656_ VPWR VGND sg13g2_o21ai_1
X_21526_ _14658_ _14495_ _14657_ _14479_ VPWR VGND sg13g2_a21oi_1
X_21527_ _14659_ \csr_i.pc[17]\ _14644_ VPWR VGND sg13g2_nand2_1
X_21528_ _14660_ \csr_i.pc[18]\ _14659_ VPWR VGND sg13g2_xnor2_1
X_21529_ _14661_ _14655_ _14658_ _14660_ _14483_ VPWR
+ VGND
+ sg13g2_a22oi_1
X_21530_ _14662_ _14661_ VPWR VGND sg13g2_buf_1
X_21531_ _14663_ _14662_ VPWR VGND sg13g2_buf_1
X_21532_ _14664_ \regs.registers[10][18]\ _14375_ VPWR VGND sg13g2_nand2_1
X_21533_ _00221_ _14536_ _14663_ _14664_ VPWR VGND sg13g2_o21ai_1
X_21534_ _14665_ \rd_alu[19]\ \mem_dataout[19]\ _13190_ VPWR VGND sg13g2_mux2_1
X_21535_ _14666_ \csr_i.mip[19]\ _14344_ VPWR VGND sg13g2_and2_1
X_21536_ _14667_ \csr_i.isr_return[19]\ _14335_ _14339_ \csr_i.mstatus[19]\ _14666_
+ VPWR
+ VGND sg13g2_a221oi_1
X_21537_ _14668_ \csr_i.mtvec[19]\ _14350_ VPWR VGND sg13g2_nand2_1
X_21538_ _14669_ \csr_i.mie[19]\ _14407_ _14408_ \csr_i.mcause[19]\ VPWR
+ VGND
+ sg13g2_a22oi_1
X_21539_ _14670_ _14328_ _14667_ _14668_ _14669_ VPWR
+ VGND
+ sg13g2_nand4_1
X_21540_ _14671_ _14326_ _14665_ _14670_ VPWR VGND sg13g2_o21ai_1
X_21541_ _14672_ \csr_i.pc[18]\ \csr_i.pc[17]\ _14644_ VPWR VGND sg13g2_nand3_1
X_21542_ _14673_ \csr_i.pc[19]\ _14672_ VPWR VGND sg13g2_xnor2_1
X_21543_ _14674_ _14322_ _14673_ VPWR VGND sg13g2_nand2_1
X_21544_ _14675_ _14323_ _14671_ _14674_ VPWR VGND sg13g2_o21ai_1
X_21545_ _14676_ reset _14675_ VPWR VGND sg13g2_nand2_1
X_21546_ _14677_ _14676_ VPWR VGND sg13g2_buf_1
X_21547_ _14678_ _14677_ VPWR VGND sg13g2_buf_1
X_21548_ _14679_ \regs.registers[10][19]\ _14375_ VPWR VGND sg13g2_nand2_1
X_21549_ _00222_ _14536_ _14678_ _14679_ VPWR VGND sg13g2_o21ai_1
X_21550_ _14680_ \rd_alu[20]\ \mem_dataout[20]\ _13190_ VPWR VGND sg13g2_mux2_1
X_21551_ _14681_ \csr_i.mip[20]\ _14344_ VPWR VGND sg13g2_and2_1
X_21552_ _14682_ \csr_i.isr_return[20]\ _14335_ _14339_ \csr_i.mstatus[20]\ _14681_
+ VPWR
+ VGND sg13g2_a221oi_1
X_21553_ _14683_ \csr_i.mtvec[20]\ _14350_ VPWR VGND sg13g2_nand2_1
X_21554_ _14684_ \csr_i.mie[20]\ _14353_ _14355_ \csr_i.mcause[20]\ VPWR
+ VGND
+ sg13g2_a22oi_1
X_21555_ _14685_ _14328_ _14682_ _14683_ _14684_ VPWR
+ VGND
+ sg13g2_nand4_1
X_21556_ _14686_ _14326_ _14680_ _14685_ VPWR VGND sg13g2_o21ai_1
X_21557_ _14687_ \csr_i.pc[19]\ VPWR VGND sg13g2_inv_1
X_21558_ _14688_ _14687_ _14672_ VPWR VGND sg13g2_nor2_1
X_21559_ _14689_ \csr_i.pc[20]\ _14688_ VPWR VGND sg13g2_xor2_1
X_21560_ _14690_ _14322_ _14689_ VPWR VGND sg13g2_nand2_1
X_21561_ _14691_ _14323_ _14686_ _14690_ VPWR VGND sg13g2_o21ai_1
X_21562_ _14692_ reset _14691_ VPWR VGND sg13g2_nand2_1
X_21563_ _14693_ _14692_ VPWR VGND sg13g2_buf_1
X_21564_ _14694_ _14693_ VPWR VGND sg13g2_buf_1
X_21565_ _14695_ \regs.registers[10][20]\ _14375_ VPWR VGND sg13g2_nand2_1
X_21566_ _00223_ _14377_ _14694_ _14695_ VPWR VGND sg13g2_o21ai_1
X_21567_ _14696_ \csr_i.pc[20]\ _14688_ VPWR VGND sg13g2_nand2_1
X_21568_ _14697_ \csr_i.pc[21]\ _14696_ VPWR VGND sg13g2_xnor2_1
X_21569_ _14698_ \rd_alu[21]\ \mem_dataout[21]\ _13190_ VPWR VGND sg13g2_mux2_1
X_21570_ _14699_ \csr_i.mip[21]\ _14344_ VPWR VGND sg13g2_and2_1
X_21571_ _14700_ \csr_i.isr_return[21]\ _14335_ _14339_ \csr_i.mstatus[21]\ _14699_
+ VPWR
+ VGND sg13g2_a221oi_1
X_21572_ _14701_ \csr_i.mtvec[21]\ _14349_ VPWR VGND sg13g2_nand2_1
X_21573_ _14702_ \csr_i.mie[21]\ _14353_ _14355_ \csr_i.mcause[21]\ VPWR
+ VGND
+ sg13g2_a22oi_1
X_21574_ _14703_ _14325_ _14700_ _14701_ _14702_ VPWR
+ VGND
+ sg13g2_nand4_1
X_21575_ _14704_ _14328_ _14698_ _14703_ VPWR VGND sg13g2_o21ai_1
X_21576_ _14705_ _14322_ _14704_ VPWR VGND sg13g2_nor2_1
X_21577_ _14706_ _14323_ _14697_ _14705_ VPWR VGND sg13g2_a21oi_1
X_21578_ _14707_ _12948_ _14706_ VPWR VGND sg13g2_nor2_1
X_21579_ _14708_ _14707_ VPWR VGND sg13g2_buf_1
X_21580_ _14709_ _14708_ VPWR VGND sg13g2_buf_1
X_21581_ _14710_ _14371_ _14373_ VPWR VGND sg13g2_nor2_1
X_21582_ _14711_ _14710_ VPWR VGND sg13g2_buf_1
X_21583_ _00224_ \regs.registers[10][21]\ _14709_ _14711_ VPWR VGND sg13g2_mux2_1
X_21584_ _14712_ \csr_i.isr_return[22]\ _14464_ _14465_ \csr_i.mcause[22]\ VPWR
+ VGND
+ sg13g2_a22oi_1
X_21585_ _14713_ \csr_i.mie[22]\ _14467_ _14468_ \csr_i.mtvec[22]\ VPWR
+ VGND
+ sg13g2_a22oi_1
X_21586_ _14714_ \csr_i.mip[22]\ _14385_ _14471_ \csr_i.mstatus[22]\ _13224_
+ VPWR
+ VGND sg13g2_a221oi_1
X_21587_ _14715_ _14712_ _14713_ _14714_ VPWR VGND sg13g2_nand3_1
X_21588_ _14716_ \mem_dataout[22]\ _14400_ VPWR VGND sg13g2_nand2b_1
X_21589_ _14717_ \rd_alu[22]\ _13191_ _14716_ VPWR VGND sg13g2_o21ai_1
X_21590_ _14718_ _14495_ _14717_ _14479_ VPWR VGND sg13g2_a21oi_1
X_21591_ _14719_ \csr_i.pc[21]\ \csr_i.pc[20]\ _14688_ VPWR VGND sg13g2_nand3_1
X_21592_ _14720_ \csr_i.pc[22]\ _14719_ VPWR VGND sg13g2_xnor2_1
X_21593_ _14721_ _14715_ _14718_ _14720_ _14483_ VPWR
+ VGND
+ sg13g2_a22oi_1
X_21594_ _14722_ _14721_ VPWR VGND sg13g2_buf_1
X_21595_ _14723_ _14722_ VPWR VGND sg13g2_buf_1
X_21596_ _14724_ \regs.registers[10][22]\ _14375_ VPWR VGND sg13g2_nand2_1
X_21597_ _00225_ _14377_ _14723_ _14724_ VPWR VGND sg13g2_o21ai_1
X_21598_ _14725_ \csr_i.mepc[23]\ _14464_ _14465_ \csr_i.mcause[23]\ VPWR
+ VGND
+ sg13g2_a22oi_1
X_21599_ _14726_ \csr_i.mie[23]\ _14467_ _14468_ \csr_i.mtvec[23]\ VPWR
+ VGND
+ sg13g2_a22oi_1
X_21600_ _14727_ \csr_i.mip[23]\ _14470_ _14471_ \csr_i.mstatus[23]\ _14472_
+ VPWR
+ VGND sg13g2_a221oi_1
X_21601_ _14728_ _14725_ _14726_ _14727_ VPWR VGND sg13g2_nand3_1
X_21602_ _14729_ \mem_dataout[23]\ _13191_ VPWR VGND sg13g2_nand2b_1
X_21603_ _14730_ \rd_alu[23]\ _14496_ _14729_ VPWR VGND sg13g2_o21ai_1
X_21604_ _14731_ _14475_ _14730_ _14480_ VPWR VGND sg13g2_a21oi_1
X_21605_ _14732_ \csr_i.pc[22]\ _14483_ VPWR VGND sg13g2_nand2_1
X_21606_ _14733_ _14719_ _14732_ VPWR VGND sg13g2_nor2_1
X_21607_ _14734_ _14728_ _14731_ _14733_ VPWR VGND sg13g2_a21oi_1
X_21608_ _14735_ _14734_ VPWR VGND sg13g2_buf_1
X_21609_ _14736_ _14735_ VPWR VGND sg13g2_buf_1
X_21610_ _14737_ \regs.registers[10][23]\ _14375_ VPWR VGND sg13g2_nand2_1
X_21611_ _00226_ _14377_ _14736_ _14737_ VPWR VGND sg13g2_o21ai_1
X_21612_ _14738_ \csr_i.mepc[24]\ _14463_ _14390_ \csr_i.mcause[24]\ VPWR
+ VGND
+ sg13g2_a22oi_1
X_21613_ _14739_ \csr_i.mie[24]\ _14388_ _14405_ \csr_i.mtvec[24]\ VPWR
+ VGND
+ sg13g2_a22oi_1
X_21614_ _14740_ _14738_ _14739_ VPWR VGND sg13g2_and2_1
X_21615_ _14741_ _14385_ VPWR VGND sg13g2_buf_1
X_21616_ _14742_ \csr_i.mip[24]\ _14741_ _14492_ \csr_i.mstatus[24]\ _14495_
+ VPWR
+ VGND sg13g2_a221oi_1
X_21617_ _14743_ \mem_dataout[24]\ _14496_ VPWR VGND sg13g2_nand2b_1
X_21618_ _14744_ \rd_alu[24]\ _13192_ _14743_ VPWR VGND sg13g2_o21ai_1
X_21619_ _14745_ _14740_ _14742_ _14744_ _14475_ _14480_
+ VPWR
+ VGND sg13g2_a221oi_1
X_21620_ _14746_ _14745_ VPWR VGND sg13g2_buf_1
X_21621_ _14747_ _14746_ VPWR VGND sg13g2_buf_1
X_21622_ _00227_ \regs.registers[10][24]\ _14747_ _14711_ VPWR VGND sg13g2_mux2_1
X_21623_ _14748_ \csr_i.mie[25]\ _14388_ _14405_ \csr_i.mtvec[25]\ VPWR
+ VGND
+ sg13g2_a22oi_1
X_21624_ _14749_ \csr_i.mepc[25]\ _14463_ _14390_ \csr_i.mcause[25]\ VPWR
+ VGND
+ sg13g2_a22oi_1
X_21625_ _14750_ _14748_ _14749_ VPWR VGND sg13g2_and2_1
X_21626_ _14751_ \csr_i.mip[25]\ _14741_ _14492_ \csr_i.mstatus[25]\ _14495_
+ VPWR
+ VGND sg13g2_a221oi_1
X_21627_ _14752_ \mem_dataout[25]\ _14496_ VPWR VGND sg13g2_nand2b_1
X_21628_ _14753_ \rd_alu[25]\ _13192_ _14752_ VPWR VGND sg13g2_o21ai_1
X_21629_ _14754_ _14750_ _14751_ _14753_ _14475_ _14480_
+ VPWR
+ VGND sg13g2_a221oi_1
X_21630_ _14755_ _14754_ VPWR VGND sg13g2_buf_1
X_21631_ _14756_ _14755_ VPWR VGND sg13g2_buf_1
X_21632_ _00228_ \regs.registers[10][25]\ _14756_ _14711_ VPWR VGND sg13g2_mux2_1
X_21633_ _14757_ \csr_i.mepc[26]\ _14463_ _14390_ \csr_i.mcause[26]\ VPWR
+ VGND
+ sg13g2_a22oi_1
X_21634_ _14758_ \csr_i.mie[26]\ _14388_ _14405_ \csr_i.mtvec[26]\ VPWR
+ VGND
+ sg13g2_a22oi_1
X_21635_ _14759_ _14757_ _14758_ VPWR VGND sg13g2_and2_1
X_21636_ _14760_ \csr_i.mip[26]\ _14741_ _14492_ \csr_i.mstatus[26]\ _14472_
+ VPWR
+ VGND sg13g2_a221oi_1
X_21637_ _14761_ \mem_dataout[26]\ _14496_ VPWR VGND sg13g2_nand2b_1
X_21638_ _14762_ \rd_alu[26]\ _13192_ _14761_ VPWR VGND sg13g2_o21ai_1
X_21639_ _14763_ _14759_ _14760_ _14762_ _14475_ _14480_
+ VPWR
+ VGND sg13g2_a221oi_1
X_21640_ _14764_ _14763_ VPWR VGND sg13g2_buf_1
X_21641_ _14765_ _14764_ VPWR VGND sg13g2_buf_1
X_21642_ _00229_ \regs.registers[10][26]\ _14765_ _14711_ VPWR VGND sg13g2_mux2_1
X_21643_ _14766_ \csr_i.mie[27]\ _14388_ _14405_ \csr_i.mtvec[27]\ VPWR
+ VGND
+ sg13g2_a22oi_1
X_21644_ _14767_ \csr_i.mepc[27]\ _14463_ _14390_ \csr_i.mcause[27]\ VPWR
+ VGND
+ sg13g2_a22oi_1
X_21645_ _14768_ _14766_ _14767_ VPWR VGND sg13g2_and2_1
X_21646_ _14769_ \csr_i.mip[27]\ _14741_ _14492_ \csr_i.mstatus[27]\ _14472_
+ VPWR
+ VGND sg13g2_a221oi_1
X_21647_ _14770_ \mem_dataout[27]\ _14496_ VPWR VGND sg13g2_nand2b_1
X_21648_ _14771_ \rd_alu[27]\ _13192_ _14770_ VPWR VGND sg13g2_o21ai_1
X_21649_ _14772_ _14768_ _14769_ _14771_ _14475_ _14480_
+ VPWR
+ VGND sg13g2_a221oi_1
X_21650_ _14773_ _14772_ VPWR VGND sg13g2_buf_1
X_21651_ _14774_ _14773_ VPWR VGND sg13g2_buf_1
X_21652_ _00230_ \regs.registers[10][27]\ _14774_ _14711_ VPWR VGND sg13g2_mux2_1
X_21653_ _14775_ \csr_i.mie[28]\ _14388_ _14405_ \csr_i.mtvec[28]\ VPWR
+ VGND
+ sg13g2_a22oi_1
X_21654_ _14776_ \csr_i.mepc[28]\ _14463_ _14390_ \csr_i.mcause[28]\ VPWR
+ VGND
+ sg13g2_a22oi_1
X_21655_ _14777_ _14775_ _14776_ VPWR VGND sg13g2_and2_1
X_21656_ _14778_ \csr_i.mip[28]\ _14741_ _14492_ \csr_i.mstatus[28]\ _14472_
+ VPWR
+ VGND sg13g2_a221oi_1
X_21657_ _14779_ \mem_dataout[28]\ _14496_ VPWR VGND sg13g2_nand2b_1
X_21658_ _14780_ \rd_alu[28]\ _13192_ _14779_ VPWR VGND sg13g2_o21ai_1
X_21659_ _14781_ _14777_ _14778_ _14780_ _14475_ _14480_
+ VPWR
+ VGND sg13g2_a221oi_1
X_21660_ _14782_ _14781_ VPWR VGND sg13g2_buf_1
X_21661_ _14783_ _14782_ VPWR VGND sg13g2_buf_1
X_21662_ _00231_ \regs.registers[10][28]\ _14783_ _14711_ VPWR VGND sg13g2_mux2_1
X_21663_ _14784_ \csr_i.mie[29]\ _14388_ _14405_ \csr_i.mtvec[29]\ VPWR
+ VGND
+ sg13g2_a22oi_1
X_21664_ _14785_ \csr_i.mepc[29]\ _14463_ _14390_ \csr_i.mcause[29]\ VPWR
+ VGND
+ sg13g2_a22oi_1
X_21665_ _14786_ _14784_ _14785_ VPWR VGND sg13g2_and2_1
X_21666_ _14787_ \csr_i.mip[29]\ _14741_ _14492_ \csr_i.mstatus[29]\ _14472_
+ VPWR
+ VGND sg13g2_a221oi_1
X_21667_ _14788_ \mem_dataout[29]\ _14496_ VPWR VGND sg13g2_nand2b_1
X_21668_ _14789_ \rd_alu[29]\ _13192_ _14788_ VPWR VGND sg13g2_o21ai_1
X_21669_ _14790_ _14786_ _14787_ _14789_ _14475_ _14480_
+ VPWR
+ VGND sg13g2_a221oi_1
X_21670_ _14791_ _14790_ VPWR VGND sg13g2_buf_1
X_21671_ _14792_ _14791_ VPWR VGND sg13g2_buf_1
X_21672_ _00232_ \regs.registers[10][29]\ _14792_ _14711_ VPWR VGND sg13g2_mux2_1
X_21673_ _14793_ \csr_i.mie[30]\ _14388_ _14405_ \csr_i.mtvec[30]\ VPWR
+ VGND
+ sg13g2_a22oi_1
X_21674_ _14794_ \csr_i.mepc[30]\ _14463_ _14390_ \csr_i.mcause[30]\ VPWR
+ VGND
+ sg13g2_a22oi_1
X_21675_ _14795_ _14793_ _14794_ VPWR VGND sg13g2_and2_1
X_21676_ _14796_ \csr_i.mip[30]\ _14741_ _14492_ \csr_i.mstatus[30]\ _14472_
+ VPWR
+ VGND sg13g2_a221oi_1
X_21677_ _14797_ \mem_dataout[30]\ _13191_ VPWR VGND sg13g2_nand2b_1
X_21678_ _14798_ \rd_alu[30]\ _13192_ _14797_ VPWR VGND sg13g2_o21ai_1
X_21679_ _14799_ _14795_ _14796_ _14798_ _14475_ _14480_
+ VPWR
+ VGND sg13g2_a221oi_1
X_21680_ _14800_ _14799_ VPWR VGND sg13g2_buf_1
X_21681_ _14801_ _14800_ VPWR VGND sg13g2_buf_1
X_21682_ _00233_ \regs.registers[10][30]\ _14801_ _14711_ VPWR VGND sg13g2_mux2_1
X_21683_ _14802_ \csr_i.mie[31]\ _14388_ _14405_ \csr_i.mtvec[31]\ VPWR
+ VGND
+ sg13g2_a22oi_1
X_21684_ _14803_ \csr_i.mepc[31]\ _14463_ _14390_ \csr_i.mcause[31]\ VPWR
+ VGND
+ sg13g2_a22oi_1
X_21685_ _14804_ _14802_ _14803_ VPWR VGND sg13g2_and2_1
X_21686_ _14805_ \csr_i.mip[31]\ _14470_ _14492_ \csr_i.mstatus[31]\ _14472_
+ VPWR
+ VGND sg13g2_a221oi_1
X_21687_ _14806_ \mem_dataout[31]\ _13191_ VPWR VGND sg13g2_nand2b_1
X_21688_ _14807_ \rd_alu[31]\ _13192_ _14806_ VPWR VGND sg13g2_o21ai_1
X_21689_ _14808_ _14804_ _14805_ _14807_ _14475_ _14480_
+ VPWR
+ VGND sg13g2_a221oi_1
X_21690_ _14809_ _14808_ VPWR VGND sg13g2_buf_1
X_21691_ _14810_ _14809_ VPWR VGND sg13g2_buf_1
X_21692_ _00234_ \regs.registers[10][31]\ _14810_ _14711_ VPWR VGND sg13g2_mux2_1
X_21693_ _14811_ \control_i.imm_gen_i.iword[8]\ \control_i.imm_gen_i.iword[7]\ _14369_ VPWR VGND sg13g2_nand3_1
X_21694_ _14812_ _14811_ VPWR VGND sg13g2_buf_1
X_21695_ _14813_ _14373_ _14812_ VPWR VGND sg13g2_or2_1
X_21696_ _14814_ _14813_ VPWR VGND sg13g2_buf_1
X_21697_ _14815_ _14814_ VPWR VGND sg13g2_buf_1
X_21698_ _14816_ _14814_ VPWR VGND sg13g2_buf_1
X_21699_ _14817_ \regs.registers[11][0]\ _14816_ VPWR VGND sg13g2_nand2_1
X_21700_ _00235_ _14363_ _14815_ _14817_ VPWR VGND sg13g2_o21ai_1
X_21701_ _14818_ \regs.registers[11][1]\ _14816_ VPWR VGND sg13g2_nand2_1
X_21702_ _00236_ _14398_ _14815_ _14818_ VPWR VGND sg13g2_o21ai_1
X_21703_ _14819_ \regs.registers[11][2]\ _14816_ VPWR VGND sg13g2_nand2_1
X_21704_ _00237_ _14417_ _14815_ _14819_ VPWR VGND sg13g2_o21ai_1
X_21705_ _14820_ \regs.registers[11][3]\ _14816_ VPWR VGND sg13g2_nand2_1
X_21706_ _00238_ _14431_ _14815_ _14820_ VPWR VGND sg13g2_o21ai_1
X_21707_ _14821_ \regs.registers[11][4]\ _14816_ VPWR VGND sg13g2_nand2_1
X_21708_ _00239_ _14446_ _14815_ _14821_ VPWR VGND sg13g2_o21ai_1
X_21709_ _14822_ \regs.registers[11][5]\ _14816_ VPWR VGND sg13g2_nand2_1
X_21710_ _00240_ _14461_ _14815_ _14822_ VPWR VGND sg13g2_o21ai_1
X_21711_ _14823_ \regs.registers[11][6]\ _14816_ VPWR VGND sg13g2_nand2_1
X_21712_ _00241_ _14488_ _14815_ _14823_ VPWR VGND sg13g2_o21ai_1
X_21713_ _14824_ _14814_ VPWR VGND sg13g2_buf_1
X_21714_ _14825_ \regs.registers[11][7]\ _14824_ VPWR VGND sg13g2_nand2_1
X_21715_ _00242_ _14504_ _14815_ _14825_ VPWR VGND sg13g2_o21ai_1
X_21716_ _14826_ \regs.registers[11][8]\ _14824_ VPWR VGND sg13g2_nand2_1
X_21717_ _00243_ _14519_ _14815_ _14826_ VPWR VGND sg13g2_o21ai_1
X_21718_ _14827_ \regs.registers[11][9]\ _14824_ VPWR VGND sg13g2_nand2_1
X_21719_ _00244_ _14534_ _14815_ _14827_ VPWR VGND sg13g2_o21ai_1
X_21720_ _14828_ _14814_ VPWR VGND sg13g2_buf_1
X_21721_ _14829_ \regs.registers[11][10]\ _14824_ VPWR VGND sg13g2_nand2_1
X_21722_ _00245_ _14548_ _14828_ _14829_ VPWR VGND sg13g2_o21ai_1
X_21723_ _14830_ \regs.registers[11][11]\ _14824_ VPWR VGND sg13g2_nand2_1
X_21724_ _00246_ _14562_ _14828_ _14830_ VPWR VGND sg13g2_o21ai_1
X_21725_ _14831_ \regs.registers[11][12]\ _14824_ VPWR VGND sg13g2_nand2_1
X_21726_ _00247_ _14575_ _14828_ _14831_ VPWR VGND sg13g2_o21ai_1
X_21727_ _14832_ \regs.registers[11][13]\ _14824_ VPWR VGND sg13g2_nand2_1
X_21728_ _00248_ _14590_ _14828_ _14832_ VPWR VGND sg13g2_o21ai_1
X_21729_ _14833_ \regs.registers[11][14]\ _14824_ VPWR VGND sg13g2_nand2_1
X_21730_ _00249_ _14606_ _14828_ _14833_ VPWR VGND sg13g2_o21ai_1
X_21731_ _14834_ \regs.registers[11][15]\ _14824_ VPWR VGND sg13g2_nand2_1
X_21732_ _00250_ _14621_ _14828_ _14834_ VPWR VGND sg13g2_o21ai_1
X_21733_ _14835_ \regs.registers[11][16]\ _14824_ VPWR VGND sg13g2_nand2_1
X_21734_ _00251_ _14634_ _14828_ _14835_ VPWR VGND sg13g2_o21ai_1
X_21735_ _14836_ \regs.registers[11][17]\ _14814_ VPWR VGND sg13g2_nand2_1
X_21736_ _00252_ _14650_ _14828_ _14836_ VPWR VGND sg13g2_o21ai_1
X_21737_ _14837_ \regs.registers[11][18]\ _14814_ VPWR VGND sg13g2_nand2_1
X_21738_ _00253_ _14663_ _14828_ _14837_ VPWR VGND sg13g2_o21ai_1
X_21739_ _14838_ \regs.registers[11][19]\ _14814_ VPWR VGND sg13g2_nand2_1
X_21740_ _00254_ _14678_ _14828_ _14838_ VPWR VGND sg13g2_o21ai_1
X_21741_ _14839_ \regs.registers[11][20]\ _14814_ VPWR VGND sg13g2_nand2_1
X_21742_ _00255_ _14694_ _14816_ _14839_ VPWR VGND sg13g2_o21ai_1
X_21743_ _14840_ _14373_ _14812_ VPWR VGND sg13g2_nor2_1
X_21744_ _14841_ _14840_ VPWR VGND sg13g2_buf_1
X_21745_ _00256_ \regs.registers[11][21]\ _14709_ _14841_ VPWR VGND sg13g2_mux2_1
X_21746_ _14842_ \regs.registers[11][22]\ _14814_ VPWR VGND sg13g2_nand2_1
X_21747_ _00257_ _14723_ _14816_ _14842_ VPWR VGND sg13g2_o21ai_1
X_21748_ _14843_ \regs.registers[11][23]\ _14814_ VPWR VGND sg13g2_nand2_1
X_21749_ _00258_ _14736_ _14816_ _14843_ VPWR VGND sg13g2_o21ai_1
X_21750_ _00259_ \regs.registers[11][24]\ _14747_ _14841_ VPWR VGND sg13g2_mux2_1
X_21751_ _00260_ \regs.registers[11][25]\ _14756_ _14841_ VPWR VGND sg13g2_mux2_1
X_21752_ _00261_ \regs.registers[11][26]\ _14765_ _14841_ VPWR VGND sg13g2_mux2_1
X_21753_ _00262_ \regs.registers[11][27]\ _14774_ _14841_ VPWR VGND sg13g2_mux2_1
X_21754_ _00263_ \regs.registers[11][28]\ _14783_ _14841_ VPWR VGND sg13g2_mux2_1
X_21755_ _00264_ \regs.registers[11][29]\ _14792_ _14841_ VPWR VGND sg13g2_mux2_1
X_21756_ _00265_ \regs.registers[11][30]\ _14801_ _14841_ VPWR VGND sg13g2_mux2_1
X_21757_ _00266_ \regs.registers[11][31]\ _14810_ _14841_ VPWR VGND sg13g2_mux2_1
X_21758_ _14844_ _14366_ _14369_ VPWR VGND sg13g2_nand2_1
X_21759_ _14845_ \control_i.imm_gen_i.iword[10]\ \control_i.imm_gen_i.iword[9]\ VPWR VGND sg13g2_nand2_1
X_21760_ _14846_ _14845_ VPWR VGND sg13g2_buf_1
X_21761_ _14847_ _14844_ _14846_ VPWR VGND sg13g2_or2_1
X_21762_ _14848_ _14847_ VPWR VGND sg13g2_buf_1
X_21763_ _14849_ _14848_ VPWR VGND sg13g2_buf_1
X_21764_ _14850_ _14848_ VPWR VGND sg13g2_buf_1
X_21765_ _14851_ \regs.registers[12][0]\ _14850_ VPWR VGND sg13g2_nand2_1
X_21766_ _00267_ _14363_ _14849_ _14851_ VPWR VGND sg13g2_o21ai_1
X_21767_ _14852_ \regs.registers[12][1]\ _14850_ VPWR VGND sg13g2_nand2_1
X_21768_ _00268_ _14398_ _14849_ _14852_ VPWR VGND sg13g2_o21ai_1
X_21769_ _14853_ \regs.registers[12][2]\ _14850_ VPWR VGND sg13g2_nand2_1
X_21770_ _00269_ _14417_ _14849_ _14853_ VPWR VGND sg13g2_o21ai_1
X_21771_ _14854_ \regs.registers[12][3]\ _14850_ VPWR VGND sg13g2_nand2_1
X_21772_ _00270_ _14431_ _14849_ _14854_ VPWR VGND sg13g2_o21ai_1
X_21773_ _14855_ \regs.registers[12][4]\ _14850_ VPWR VGND sg13g2_nand2_1
X_21774_ _00271_ _14446_ _14849_ _14855_ VPWR VGND sg13g2_o21ai_1
X_21775_ _14856_ \regs.registers[12][5]\ _14850_ VPWR VGND sg13g2_nand2_1
X_21776_ _00272_ _14461_ _14849_ _14856_ VPWR VGND sg13g2_o21ai_1
X_21777_ _14857_ \regs.registers[12][6]\ _14850_ VPWR VGND sg13g2_nand2_1
X_21778_ _00273_ _14488_ _14849_ _14857_ VPWR VGND sg13g2_o21ai_1
X_21779_ _14858_ _14848_ VPWR VGND sg13g2_buf_1
X_21780_ _14859_ \regs.registers[12][7]\ _14858_ VPWR VGND sg13g2_nand2_1
X_21781_ _00274_ _14504_ _14849_ _14859_ VPWR VGND sg13g2_o21ai_1
X_21782_ _14860_ \regs.registers[12][8]\ _14858_ VPWR VGND sg13g2_nand2_1
X_21783_ _00275_ _14519_ _14849_ _14860_ VPWR VGND sg13g2_o21ai_1
X_21784_ _14861_ \regs.registers[12][9]\ _14858_ VPWR VGND sg13g2_nand2_1
X_21785_ _00276_ _14534_ _14849_ _14861_ VPWR VGND sg13g2_o21ai_1
X_21786_ _14862_ _14848_ VPWR VGND sg13g2_buf_1
X_21787_ _14863_ \regs.registers[12][10]\ _14858_ VPWR VGND sg13g2_nand2_1
X_21788_ _00277_ _14548_ _14862_ _14863_ VPWR VGND sg13g2_o21ai_1
X_21789_ _14864_ \regs.registers[12][11]\ _14858_ VPWR VGND sg13g2_nand2_1
X_21790_ _00278_ _14562_ _14862_ _14864_ VPWR VGND sg13g2_o21ai_1
X_21791_ _14865_ \regs.registers[12][12]\ _14858_ VPWR VGND sg13g2_nand2_1
X_21792_ _00279_ _14575_ _14862_ _14865_ VPWR VGND sg13g2_o21ai_1
X_21793_ _14866_ \regs.registers[12][13]\ _14858_ VPWR VGND sg13g2_nand2_1
X_21794_ _00280_ _14590_ _14862_ _14866_ VPWR VGND sg13g2_o21ai_1
X_21795_ _14867_ \regs.registers[12][14]\ _14858_ VPWR VGND sg13g2_nand2_1
X_21796_ _00281_ _14606_ _14862_ _14867_ VPWR VGND sg13g2_o21ai_1
X_21797_ _14868_ \regs.registers[12][15]\ _14858_ VPWR VGND sg13g2_nand2_1
X_21798_ _00282_ _14621_ _14862_ _14868_ VPWR VGND sg13g2_o21ai_1
X_21799_ _14869_ \regs.registers[12][16]\ _14858_ VPWR VGND sg13g2_nand2_1
X_21800_ _00283_ _14634_ _14862_ _14869_ VPWR VGND sg13g2_o21ai_1
X_21801_ _14870_ \regs.registers[12][17]\ _14848_ VPWR VGND sg13g2_nand2_1
X_21802_ _00284_ _14650_ _14862_ _14870_ VPWR VGND sg13g2_o21ai_1
X_21803_ _14871_ \regs.registers[12][18]\ _14848_ VPWR VGND sg13g2_nand2_1
X_21804_ _00285_ _14663_ _14862_ _14871_ VPWR VGND sg13g2_o21ai_1
X_21805_ _14872_ \regs.registers[12][19]\ _14848_ VPWR VGND sg13g2_nand2_1
X_21806_ _00286_ _14678_ _14862_ _14872_ VPWR VGND sg13g2_o21ai_1
X_21807_ _14873_ \regs.registers[12][20]\ _14848_ VPWR VGND sg13g2_nand2_1
X_21808_ _00287_ _14694_ _14850_ _14873_ VPWR VGND sg13g2_o21ai_1
X_21809_ _14874_ _14844_ _14846_ VPWR VGND sg13g2_nor2_1
X_21810_ _14875_ _14874_ VPWR VGND sg13g2_buf_1
X_21811_ _00288_ \regs.registers[12][21]\ _14709_ _14875_ VPWR VGND sg13g2_mux2_1
X_21812_ _14876_ \regs.registers[12][22]\ _14848_ VPWR VGND sg13g2_nand2_1
X_21813_ _00289_ _14723_ _14850_ _14876_ VPWR VGND sg13g2_o21ai_1
X_21814_ _14877_ \regs.registers[12][23]\ _14848_ VPWR VGND sg13g2_nand2_1
X_21815_ _00290_ _14736_ _14850_ _14877_ VPWR VGND sg13g2_o21ai_1
X_21816_ _00291_ \regs.registers[12][24]\ _14747_ _14875_ VPWR VGND sg13g2_mux2_1
X_21817_ _00292_ \regs.registers[12][25]\ _14756_ _14875_ VPWR VGND sg13g2_mux2_1
X_21818_ _00293_ \regs.registers[12][26]\ _14765_ _14875_ VPWR VGND sg13g2_mux2_1
X_21819_ _00294_ \regs.registers[12][27]\ _14774_ _14875_ VPWR VGND sg13g2_mux2_1
X_21820_ _00295_ \regs.registers[12][28]\ _14783_ _14875_ VPWR VGND sg13g2_mux2_1
X_21821_ _00296_ \regs.registers[12][29]\ _14792_ _14875_ VPWR VGND sg13g2_mux2_1
X_21822_ _00297_ \regs.registers[12][30]\ _14801_ _14875_ VPWR VGND sg13g2_mux2_1
X_21823_ _00298_ \regs.registers[12][31]\ _14810_ _14875_ VPWR VGND sg13g2_mux2_1
X_21824_ _14878_ \control_i.imm_gen_i.iword[7]\ _14369_ VPWR VGND sg13g2_nand2_1
X_21825_ _14879_ \control_i.imm_gen_i.iword[8]\ _14878_ VPWR VGND sg13g2_nor2_1
X_21826_ _14880_ _14846_ _14879_ VPWR VGND sg13g2_nand2b_1
X_21827_ _14881_ _14880_ VPWR VGND sg13g2_buf_1
X_21828_ _14882_ _14881_ VPWR VGND sg13g2_buf_1
X_21829_ _14883_ _14881_ VPWR VGND sg13g2_buf_1
X_21830_ _14884_ \regs.registers[13][0]\ _14883_ VPWR VGND sg13g2_nand2_1
X_21831_ _00299_ _14363_ _14882_ _14884_ VPWR VGND sg13g2_o21ai_1
X_21832_ _14885_ \regs.registers[13][1]\ _14883_ VPWR VGND sg13g2_nand2_1
X_21833_ _00300_ _14398_ _14882_ _14885_ VPWR VGND sg13g2_o21ai_1
X_21834_ _14886_ \regs.registers[13][2]\ _14883_ VPWR VGND sg13g2_nand2_1
X_21835_ _00301_ _14417_ _14882_ _14886_ VPWR VGND sg13g2_o21ai_1
X_21836_ _14887_ \regs.registers[13][3]\ _14883_ VPWR VGND sg13g2_nand2_1
X_21837_ _00302_ _14431_ _14882_ _14887_ VPWR VGND sg13g2_o21ai_1
X_21838_ _14888_ \regs.registers[13][4]\ _14883_ VPWR VGND sg13g2_nand2_1
X_21839_ _00303_ _14446_ _14882_ _14888_ VPWR VGND sg13g2_o21ai_1
X_21840_ _14889_ \regs.registers[13][5]\ _14883_ VPWR VGND sg13g2_nand2_1
X_21841_ _00304_ _14461_ _14882_ _14889_ VPWR VGND sg13g2_o21ai_1
X_21842_ _14890_ \regs.registers[13][6]\ _14883_ VPWR VGND sg13g2_nand2_1
X_21843_ _00305_ _14488_ _14882_ _14890_ VPWR VGND sg13g2_o21ai_1
X_21844_ _14891_ \regs.registers[13][7]\ _14883_ VPWR VGND sg13g2_nand2_1
X_21845_ _00306_ _14504_ _14882_ _14891_ VPWR VGND sg13g2_o21ai_1
X_21846_ _14892_ _14881_ VPWR VGND sg13g2_buf_1
X_21847_ _14893_ \regs.registers[13][8]\ _14892_ VPWR VGND sg13g2_nand2_1
X_21848_ _00307_ _14519_ _14882_ _14893_ VPWR VGND sg13g2_o21ai_1
X_21849_ _14894_ \regs.registers[13][9]\ _14892_ VPWR VGND sg13g2_nand2_1
X_21850_ _00308_ _14534_ _14882_ _14894_ VPWR VGND sg13g2_o21ai_1
X_21851_ _14895_ _14881_ VPWR VGND sg13g2_buf_1
X_21852_ _14896_ \regs.registers[13][10]\ _14892_ VPWR VGND sg13g2_nand2_1
X_21853_ _00309_ _14548_ _14895_ _14896_ VPWR VGND sg13g2_o21ai_1
X_21854_ _14897_ \regs.registers[13][11]\ _14892_ VPWR VGND sg13g2_nand2_1
X_21855_ _00310_ _14562_ _14895_ _14897_ VPWR VGND sg13g2_o21ai_1
X_21856_ _14898_ \regs.registers[13][12]\ _14892_ VPWR VGND sg13g2_nand2_1
X_21857_ _00311_ _14575_ _14895_ _14898_ VPWR VGND sg13g2_o21ai_1
X_21858_ _14899_ \regs.registers[13][13]\ _14892_ VPWR VGND sg13g2_nand2_1
X_21859_ _00312_ _14590_ _14895_ _14899_ VPWR VGND sg13g2_o21ai_1
X_21860_ _14900_ \regs.registers[13][14]\ _14892_ VPWR VGND sg13g2_nand2_1
X_21861_ _00313_ _14606_ _14895_ _14900_ VPWR VGND sg13g2_o21ai_1
X_21862_ _14901_ \regs.registers[13][15]\ _14892_ VPWR VGND sg13g2_nand2_1
X_21863_ _00314_ _14621_ _14895_ _14901_ VPWR VGND sg13g2_o21ai_1
X_21864_ _14902_ \regs.registers[13][16]\ _14892_ VPWR VGND sg13g2_nand2_1
X_21865_ _00315_ _14634_ _14895_ _14902_ VPWR VGND sg13g2_o21ai_1
X_21866_ _14903_ \regs.registers[13][17]\ _14892_ VPWR VGND sg13g2_nand2_1
X_21867_ _00316_ _14650_ _14895_ _14903_ VPWR VGND sg13g2_o21ai_1
X_21868_ _14904_ \regs.registers[13][18]\ _14881_ VPWR VGND sg13g2_nand2_1
X_21869_ _00317_ _14663_ _14895_ _14904_ VPWR VGND sg13g2_o21ai_1
X_21870_ _14905_ \regs.registers[13][19]\ _14881_ VPWR VGND sg13g2_nand2_1
X_21871_ _00318_ _14678_ _14895_ _14905_ VPWR VGND sg13g2_o21ai_1
X_21872_ _14906_ _14881_ VPWR VGND sg13g2_buf_1
X_21873_ _14907_ \regs.registers[13][20]\ _14881_ VPWR VGND sg13g2_nand2_1
X_21874_ _00319_ _14694_ _14906_ _14907_ VPWR VGND sg13g2_o21ai_1
X_21875_ _00320_ _14709_ \regs.registers[13][21]\ _14906_ VPWR VGND sg13g2_mux2_1
X_21876_ _14908_ \regs.registers[13][22]\ _14881_ VPWR VGND sg13g2_nand2_1
X_21877_ _00321_ _14723_ _14906_ _14908_ VPWR VGND sg13g2_o21ai_1
X_21878_ _14909_ \regs.registers[13][23]\ _14881_ VPWR VGND sg13g2_nand2_1
X_21879_ _00322_ _14736_ _14906_ _14909_ VPWR VGND sg13g2_o21ai_1
X_21880_ _00323_ _14747_ \regs.registers[13][24]\ _14906_ VPWR VGND sg13g2_mux2_1
X_21881_ _00324_ _14756_ \regs.registers[13][25]\ _14906_ VPWR VGND sg13g2_mux2_1
X_21882_ _00325_ _14765_ \regs.registers[13][26]\ _14906_ VPWR VGND sg13g2_mux2_1
X_21883_ _00326_ _14774_ \regs.registers[13][27]\ _14906_ VPWR VGND sg13g2_mux2_1
X_21884_ _00327_ _14783_ \regs.registers[13][28]\ _14906_ VPWR VGND sg13g2_mux2_1
X_21885_ _00328_ _14792_ \regs.registers[13][29]\ _14906_ VPWR VGND sg13g2_mux2_1
X_21886_ _00329_ _14801_ \regs.registers[13][30]\ _14883_ VPWR VGND sg13g2_mux2_1
X_21887_ _00330_ _14810_ \regs.registers[13][31]\ _14883_ VPWR VGND sg13g2_mux2_1
X_21888_ _14910_ _14371_ _14846_ VPWR VGND sg13g2_or2_1
X_21889_ _14911_ _14910_ VPWR VGND sg13g2_buf_1
X_21890_ _14912_ _14911_ VPWR VGND sg13g2_buf_1
X_21891_ _14913_ _14911_ VPWR VGND sg13g2_buf_1
X_21892_ _14914_ \regs.registers[14][0]\ _14913_ VPWR VGND sg13g2_nand2_1
X_21893_ _00331_ _14363_ _14912_ _14914_ VPWR VGND sg13g2_o21ai_1
X_21894_ _14915_ \regs.registers[14][1]\ _14913_ VPWR VGND sg13g2_nand2_1
X_21895_ _00332_ _14398_ _14912_ _14915_ VPWR VGND sg13g2_o21ai_1
X_21896_ _14916_ \regs.registers[14][2]\ _14913_ VPWR VGND sg13g2_nand2_1
X_21897_ _00333_ _14417_ _14912_ _14916_ VPWR VGND sg13g2_o21ai_1
X_21898_ _14917_ \regs.registers[14][3]\ _14913_ VPWR VGND sg13g2_nand2_1
X_21899_ _00334_ _14431_ _14912_ _14917_ VPWR VGND sg13g2_o21ai_1
X_21900_ _14918_ \regs.registers[14][4]\ _14913_ VPWR VGND sg13g2_nand2_1
X_21901_ _00335_ _14446_ _14912_ _14918_ VPWR VGND sg13g2_o21ai_1
X_21902_ _14919_ \regs.registers[14][5]\ _14913_ VPWR VGND sg13g2_nand2_1
X_21903_ _00336_ _14461_ _14912_ _14919_ VPWR VGND sg13g2_o21ai_1
X_21904_ _14920_ \regs.registers[14][6]\ _14913_ VPWR VGND sg13g2_nand2_1
X_21905_ _00337_ _14488_ _14912_ _14920_ VPWR VGND sg13g2_o21ai_1
X_21906_ _14921_ _14911_ VPWR VGND sg13g2_buf_1
X_21907_ _14922_ \regs.registers[14][7]\ _14921_ VPWR VGND sg13g2_nand2_1
X_21908_ _00338_ _14504_ _14912_ _14922_ VPWR VGND sg13g2_o21ai_1
X_21909_ _14923_ \regs.registers[14][8]\ _14921_ VPWR VGND sg13g2_nand2_1
X_21910_ _00339_ _14519_ _14912_ _14923_ VPWR VGND sg13g2_o21ai_1
X_21911_ _14924_ \regs.registers[14][9]\ _14921_ VPWR VGND sg13g2_nand2_1
X_21912_ _00340_ _14534_ _14912_ _14924_ VPWR VGND sg13g2_o21ai_1
X_21913_ _14925_ _14911_ VPWR VGND sg13g2_buf_1
X_21914_ _14926_ \regs.registers[14][10]\ _14921_ VPWR VGND sg13g2_nand2_1
X_21915_ _00341_ _14548_ _14925_ _14926_ VPWR VGND sg13g2_o21ai_1
X_21916_ _14927_ \regs.registers[14][11]\ _14921_ VPWR VGND sg13g2_nand2_1
X_21917_ _00342_ _14562_ _14925_ _14927_ VPWR VGND sg13g2_o21ai_1
X_21918_ _14928_ \regs.registers[14][12]\ _14921_ VPWR VGND sg13g2_nand2_1
X_21919_ _00343_ _14575_ _14925_ _14928_ VPWR VGND sg13g2_o21ai_1
X_21920_ _14929_ \regs.registers[14][13]\ _14921_ VPWR VGND sg13g2_nand2_1
X_21921_ _00344_ _14590_ _14925_ _14929_ VPWR VGND sg13g2_o21ai_1
X_21922_ _14930_ \regs.registers[14][14]\ _14921_ VPWR VGND sg13g2_nand2_1
X_21923_ _00345_ _14606_ _14925_ _14930_ VPWR VGND sg13g2_o21ai_1
X_21924_ _14931_ \regs.registers[14][15]\ _14921_ VPWR VGND sg13g2_nand2_1
X_21925_ _00346_ _14621_ _14925_ _14931_ VPWR VGND sg13g2_o21ai_1
X_21926_ _14932_ \regs.registers[14][16]\ _14921_ VPWR VGND sg13g2_nand2_1
X_21927_ _00347_ _14634_ _14925_ _14932_ VPWR VGND sg13g2_o21ai_1
X_21928_ _14933_ \regs.registers[14][17]\ _14911_ VPWR VGND sg13g2_nand2_1
X_21929_ _00348_ _14650_ _14925_ _14933_ VPWR VGND sg13g2_o21ai_1
X_21930_ _14934_ \regs.registers[14][18]\ _14911_ VPWR VGND sg13g2_nand2_1
X_21931_ _00349_ _14663_ _14925_ _14934_ VPWR VGND sg13g2_o21ai_1
X_21932_ _14935_ \regs.registers[14][19]\ _14911_ VPWR VGND sg13g2_nand2_1
X_21933_ _00350_ _14678_ _14925_ _14935_ VPWR VGND sg13g2_o21ai_1
X_21934_ _14936_ \regs.registers[14][20]\ _14911_ VPWR VGND sg13g2_nand2_1
X_21935_ _00351_ _14694_ _14913_ _14936_ VPWR VGND sg13g2_o21ai_1
X_21936_ _14937_ _14371_ _14846_ VPWR VGND sg13g2_nor2_1
X_21937_ _14938_ _14937_ VPWR VGND sg13g2_buf_1
X_21938_ _00352_ \regs.registers[14][21]\ _14709_ _14938_ VPWR VGND sg13g2_mux2_1
X_21939_ _14939_ \regs.registers[14][22]\ _14911_ VPWR VGND sg13g2_nand2_1
X_21940_ _00353_ _14723_ _14913_ _14939_ VPWR VGND sg13g2_o21ai_1
X_21941_ _14940_ \regs.registers[14][23]\ _14911_ VPWR VGND sg13g2_nand2_1
X_21942_ _00354_ _14736_ _14913_ _14940_ VPWR VGND sg13g2_o21ai_1
X_21943_ _00355_ \regs.registers[14][24]\ _14747_ _14938_ VPWR VGND sg13g2_mux2_1
X_21944_ _00356_ \regs.registers[14][25]\ _14756_ _14938_ VPWR VGND sg13g2_mux2_1
X_21945_ _00357_ \regs.registers[14][26]\ _14765_ _14938_ VPWR VGND sg13g2_mux2_1
X_21946_ _00358_ \regs.registers[14][27]\ _14774_ _14938_ VPWR VGND sg13g2_mux2_1
X_21947_ _00359_ \regs.registers[14][28]\ _14783_ _14938_ VPWR VGND sg13g2_mux2_1
X_21948_ _00360_ \regs.registers[14][29]\ _14792_ _14938_ VPWR VGND sg13g2_mux2_1
X_21949_ _00361_ \regs.registers[14][30]\ _14801_ _14938_ VPWR VGND sg13g2_mux2_1
X_21950_ _00362_ \regs.registers[14][31]\ _14810_ _14938_ VPWR VGND sg13g2_mux2_1
X_21951_ _14941_ _14812_ _14846_ VPWR VGND sg13g2_or2_1
X_21952_ _14942_ _14941_ VPWR VGND sg13g2_buf_1
X_21953_ _14943_ _14942_ VPWR VGND sg13g2_buf_1
X_21954_ _14944_ _14942_ VPWR VGND sg13g2_buf_1
X_21955_ _14945_ \regs.registers[15][0]\ _14944_ VPWR VGND sg13g2_nand2_1
X_21956_ _00363_ _14363_ _14943_ _14945_ VPWR VGND sg13g2_o21ai_1
X_21957_ _14946_ \regs.registers[15][1]\ _14944_ VPWR VGND sg13g2_nand2_1
X_21958_ _00364_ _14398_ _14943_ _14946_ VPWR VGND sg13g2_o21ai_1
X_21959_ _14947_ \regs.registers[15][2]\ _14944_ VPWR VGND sg13g2_nand2_1
X_21960_ _00365_ _14417_ _14943_ _14947_ VPWR VGND sg13g2_o21ai_1
X_21961_ _14948_ \regs.registers[15][3]\ _14944_ VPWR VGND sg13g2_nand2_1
X_21962_ _00366_ _14431_ _14943_ _14948_ VPWR VGND sg13g2_o21ai_1
X_21963_ _14949_ \regs.registers[15][4]\ _14944_ VPWR VGND sg13g2_nand2_1
X_21964_ _00367_ _14446_ _14943_ _14949_ VPWR VGND sg13g2_o21ai_1
X_21965_ _14950_ \regs.registers[15][5]\ _14944_ VPWR VGND sg13g2_nand2_1
X_21966_ _00368_ _14461_ _14943_ _14950_ VPWR VGND sg13g2_o21ai_1
X_21967_ _14951_ \regs.registers[15][6]\ _14944_ VPWR VGND sg13g2_nand2_1
X_21968_ _00369_ _14488_ _14943_ _14951_ VPWR VGND sg13g2_o21ai_1
X_21969_ _14952_ _14942_ VPWR VGND sg13g2_buf_1
X_21970_ _14953_ \regs.registers[15][7]\ _14952_ VPWR VGND sg13g2_nand2_1
X_21971_ _00370_ _14504_ _14943_ _14953_ VPWR VGND sg13g2_o21ai_1
X_21972_ _14954_ \regs.registers[15][8]\ _14952_ VPWR VGND sg13g2_nand2_1
X_21973_ _00371_ _14519_ _14943_ _14954_ VPWR VGND sg13g2_o21ai_1
X_21974_ _14955_ \regs.registers[15][9]\ _14952_ VPWR VGND sg13g2_nand2_1
X_21975_ _00372_ _14534_ _14943_ _14955_ VPWR VGND sg13g2_o21ai_1
X_21976_ _14956_ _14942_ VPWR VGND sg13g2_buf_1
X_21977_ _14957_ \regs.registers[15][10]\ _14952_ VPWR VGND sg13g2_nand2_1
X_21978_ _00373_ _14548_ _14956_ _14957_ VPWR VGND sg13g2_o21ai_1
X_21979_ _14958_ \regs.registers[15][11]\ _14952_ VPWR VGND sg13g2_nand2_1
X_21980_ _00374_ _14562_ _14956_ _14958_ VPWR VGND sg13g2_o21ai_1
X_21981_ _14959_ \regs.registers[15][12]\ _14952_ VPWR VGND sg13g2_nand2_1
X_21982_ _00375_ _14575_ _14956_ _14959_ VPWR VGND sg13g2_o21ai_1
X_21983_ _14960_ \regs.registers[15][13]\ _14952_ VPWR VGND sg13g2_nand2_1
X_21984_ _00376_ _14590_ _14956_ _14960_ VPWR VGND sg13g2_o21ai_1
X_21985_ _14961_ \regs.registers[15][14]\ _14952_ VPWR VGND sg13g2_nand2_1
X_21986_ _00377_ _14606_ _14956_ _14961_ VPWR VGND sg13g2_o21ai_1
X_21987_ _14962_ \regs.registers[15][15]\ _14952_ VPWR VGND sg13g2_nand2_1
X_21988_ _00378_ _14621_ _14956_ _14962_ VPWR VGND sg13g2_o21ai_1
X_21989_ _14963_ \regs.registers[15][16]\ _14952_ VPWR VGND sg13g2_nand2_1
X_21990_ _00379_ _14634_ _14956_ _14963_ VPWR VGND sg13g2_o21ai_1
X_21991_ _14964_ \regs.registers[15][17]\ _14942_ VPWR VGND sg13g2_nand2_1
X_21992_ _00380_ _14650_ _14956_ _14964_ VPWR VGND sg13g2_o21ai_1
X_21993_ _14965_ \regs.registers[15][18]\ _14942_ VPWR VGND sg13g2_nand2_1
X_21994_ _00381_ _14663_ _14956_ _14965_ VPWR VGND sg13g2_o21ai_1
X_21995_ _14966_ \regs.registers[15][19]\ _14942_ VPWR VGND sg13g2_nand2_1
X_21996_ _00382_ _14678_ _14956_ _14966_ VPWR VGND sg13g2_o21ai_1
X_21997_ _14967_ \regs.registers[15][20]\ _14942_ VPWR VGND sg13g2_nand2_1
X_21998_ _00383_ _14694_ _14944_ _14967_ VPWR VGND sg13g2_o21ai_1
X_21999_ _14968_ _14812_ _14846_ VPWR VGND sg13g2_nor2_1
X_22000_ _14969_ _14968_ VPWR VGND sg13g2_buf_1
X_22001_ _00384_ \regs.registers[15][21]\ _14709_ _14969_ VPWR VGND sg13g2_mux2_1
X_22002_ _14970_ \regs.registers[15][22]\ _14942_ VPWR VGND sg13g2_nand2_1
X_22003_ _00385_ _14723_ _14944_ _14970_ VPWR VGND sg13g2_o21ai_1
X_22004_ _14971_ \regs.registers[15][23]\ _14942_ VPWR VGND sg13g2_nand2_1
X_22005_ _00386_ _14736_ _14944_ _14971_ VPWR VGND sg13g2_o21ai_1
X_22006_ _00387_ \regs.registers[15][24]\ _14747_ _14969_ VPWR VGND sg13g2_mux2_1
X_22007_ _00388_ \regs.registers[15][25]\ _14756_ _14969_ VPWR VGND sg13g2_mux2_1
X_22008_ _00389_ \regs.registers[15][26]\ _14765_ _14969_ VPWR VGND sg13g2_mux2_1
X_22009_ _00390_ \regs.registers[15][27]\ _14774_ _14969_ VPWR VGND sg13g2_mux2_1
X_22010_ _00391_ \regs.registers[15][28]\ _14783_ _14969_ VPWR VGND sg13g2_mux2_1
X_22011_ _00392_ \regs.registers[15][29]\ _14792_ _14969_ VPWR VGND sg13g2_mux2_1
X_22012_ _00393_ \regs.registers[15][30]\ _14801_ _14969_ VPWR VGND sg13g2_mux2_1
X_22013_ _00394_ \regs.registers[15][31]\ _14810_ _14969_ VPWR VGND sg13g2_mux2_1
X_22014_ _14972_ _14365_ _14879_ VPWR VGND sg13g2_nand2_1
X_22015_ _14973_ _14972_ VPWR VGND sg13g2_buf_1
X_22016_ _14974_ _14973_ VPWR VGND sg13g2_buf_1
X_22017_ _14975_ _14973_ VPWR VGND sg13g2_buf_1
X_22018_ _14976_ \regs.registers[1][0]\ _14975_ VPWR VGND sg13g2_nand2_1
X_22019_ _00395_ _14363_ _14974_ _14976_ VPWR VGND sg13g2_o21ai_1
X_22020_ _14977_ \regs.registers[1][1]\ _14975_ VPWR VGND sg13g2_nand2_1
X_22021_ _00396_ _14398_ _14974_ _14977_ VPWR VGND sg13g2_o21ai_1
X_22022_ _14978_ \regs.registers[1][2]\ _14975_ VPWR VGND sg13g2_nand2_1
X_22023_ _00397_ _14417_ _14974_ _14978_ VPWR VGND sg13g2_o21ai_1
X_22024_ _14979_ \regs.registers[1][3]\ _14975_ VPWR VGND sg13g2_nand2_1
X_22025_ _00398_ _14431_ _14974_ _14979_ VPWR VGND sg13g2_o21ai_1
X_22026_ _14980_ \regs.registers[1][4]\ _14975_ VPWR VGND sg13g2_nand2_1
X_22027_ _00399_ _14446_ _14974_ _14980_ VPWR VGND sg13g2_o21ai_1
X_22028_ _14981_ \regs.registers[1][5]\ _14975_ VPWR VGND sg13g2_nand2_1
X_22029_ _00400_ _14461_ _14974_ _14981_ VPWR VGND sg13g2_o21ai_1
X_22030_ _14982_ \regs.registers[1][6]\ _14975_ VPWR VGND sg13g2_nand2_1
X_22031_ _00401_ _14488_ _14974_ _14982_ VPWR VGND sg13g2_o21ai_1
X_22032_ _14983_ \regs.registers[1][7]\ _14975_ VPWR VGND sg13g2_nand2_1
X_22033_ _00402_ _14504_ _14974_ _14983_ VPWR VGND sg13g2_o21ai_1
X_22034_ _14984_ _14973_ VPWR VGND sg13g2_buf_1
X_22035_ _14985_ \regs.registers[1][8]\ _14984_ VPWR VGND sg13g2_nand2_1
X_22036_ _00403_ _14519_ _14974_ _14985_ VPWR VGND sg13g2_o21ai_1
X_22037_ _14986_ \regs.registers[1][9]\ _14984_ VPWR VGND sg13g2_nand2_1
X_22038_ _00404_ _14534_ _14974_ _14986_ VPWR VGND sg13g2_o21ai_1
X_22039_ _14987_ _14973_ VPWR VGND sg13g2_buf_1
X_22040_ _14988_ \regs.registers[1][10]\ _14984_ VPWR VGND sg13g2_nand2_1
X_22041_ _00405_ _14548_ _14987_ _14988_ VPWR VGND sg13g2_o21ai_1
X_22042_ _14989_ \regs.registers[1][11]\ _14984_ VPWR VGND sg13g2_nand2_1
X_22043_ _00406_ _14562_ _14987_ _14989_ VPWR VGND sg13g2_o21ai_1
X_22044_ _14990_ \regs.registers[1][12]\ _14984_ VPWR VGND sg13g2_nand2_1
X_22045_ _00407_ _14575_ _14987_ _14990_ VPWR VGND sg13g2_o21ai_1
X_22046_ _14991_ \regs.registers[1][13]\ _14984_ VPWR VGND sg13g2_nand2_1
X_22047_ _00408_ _14590_ _14987_ _14991_ VPWR VGND sg13g2_o21ai_1
X_22048_ _14992_ \regs.registers[1][14]\ _14984_ VPWR VGND sg13g2_nand2_1
X_22049_ _00409_ _14606_ _14987_ _14992_ VPWR VGND sg13g2_o21ai_1
X_22050_ _14993_ \regs.registers[1][15]\ _14984_ VPWR VGND sg13g2_nand2_1
X_22051_ _00410_ _14621_ _14987_ _14993_ VPWR VGND sg13g2_o21ai_1
X_22052_ _14994_ \regs.registers[1][16]\ _14984_ VPWR VGND sg13g2_nand2_1
X_22053_ _00411_ _14634_ _14987_ _14994_ VPWR VGND sg13g2_o21ai_1
X_22054_ _14995_ \regs.registers[1][17]\ _14984_ VPWR VGND sg13g2_nand2_1
X_22055_ _00412_ _14650_ _14987_ _14995_ VPWR VGND sg13g2_o21ai_1
X_22056_ _14996_ \regs.registers[1][18]\ _14973_ VPWR VGND sg13g2_nand2_1
X_22057_ _00413_ _14663_ _14987_ _14996_ VPWR VGND sg13g2_o21ai_1
X_22058_ _14997_ \regs.registers[1][19]\ _14973_ VPWR VGND sg13g2_nand2_1
X_22059_ _00414_ _14678_ _14987_ _14997_ VPWR VGND sg13g2_o21ai_1
X_22060_ _14998_ _14973_ VPWR VGND sg13g2_buf_1
X_22061_ _14999_ \regs.registers[1][20]\ _14973_ VPWR VGND sg13g2_nand2_1
X_22062_ _00415_ _14694_ _14998_ _14999_ VPWR VGND sg13g2_o21ai_1
X_22063_ _00416_ _14709_ \regs.registers[1][21]\ _14998_ VPWR VGND sg13g2_mux2_1
X_22064_ _15000_ \regs.registers[1][22]\ _14973_ VPWR VGND sg13g2_nand2_1
X_22065_ _00417_ _14723_ _14998_ _15000_ VPWR VGND sg13g2_o21ai_1
X_22066_ _15001_ \regs.registers[1][23]\ _14973_ VPWR VGND sg13g2_nand2_1
X_22067_ _00418_ _14736_ _14998_ _15001_ VPWR VGND sg13g2_o21ai_1
X_22068_ _00419_ _14747_ \regs.registers[1][24]\ _14998_ VPWR VGND sg13g2_mux2_1
X_22069_ _00420_ _14756_ \regs.registers[1][25]\ _14998_ VPWR VGND sg13g2_mux2_1
X_22070_ _00421_ _14765_ \regs.registers[1][26]\ _14998_ VPWR VGND sg13g2_mux2_1
X_22071_ _00422_ _14774_ \regs.registers[1][27]\ _14998_ VPWR VGND sg13g2_mux2_1
X_22072_ _00423_ _14783_ \regs.registers[1][28]\ _14998_ VPWR VGND sg13g2_mux2_1
X_22073_ _00424_ _14792_ \regs.registers[1][29]\ _14998_ VPWR VGND sg13g2_mux2_1
X_22074_ _00425_ _14801_ \regs.registers[1][30]\ _14975_ VPWR VGND sg13g2_mux2_1
X_22075_ _00426_ _14810_ \regs.registers[1][31]\ _14975_ VPWR VGND sg13g2_mux2_1
X_22076_ _15002_ \control_i.imm_gen_i.iword[10]\ \control_i.imm_gen_i.iword[9]\ _14371_ VPWR VGND sg13g2_or3_1
X_22077_ _15003_ _15002_ VPWR VGND sg13g2_buf_1
X_22078_ _15004_ _15003_ VPWR VGND sg13g2_buf_1
X_22079_ _15005_ _15003_ VPWR VGND sg13g2_buf_1
X_22080_ _15006_ \regs.registers[2][0]\ _15005_ VPWR VGND sg13g2_nand2_1
X_22081_ _00427_ _14363_ _15004_ _15006_ VPWR VGND sg13g2_o21ai_1
X_22082_ _15007_ \regs.registers[2][1]\ _15005_ VPWR VGND sg13g2_nand2_1
X_22083_ _00428_ _14398_ _15004_ _15007_ VPWR VGND sg13g2_o21ai_1
X_22084_ _15008_ \regs.registers[2][2]\ _15005_ VPWR VGND sg13g2_nand2_1
X_22085_ _00429_ _14417_ _15004_ _15008_ VPWR VGND sg13g2_o21ai_1
X_22086_ _15009_ \regs.registers[2][3]\ _15005_ VPWR VGND sg13g2_nand2_1
X_22087_ _00430_ _14431_ _15004_ _15009_ VPWR VGND sg13g2_o21ai_1
X_22088_ _15010_ \regs.registers[2][4]\ _15005_ VPWR VGND sg13g2_nand2_1
X_22089_ _00431_ _14446_ _15004_ _15010_ VPWR VGND sg13g2_o21ai_1
X_22090_ _15011_ \regs.registers[2][5]\ _15005_ VPWR VGND sg13g2_nand2_1
X_22091_ _00432_ _14461_ _15004_ _15011_ VPWR VGND sg13g2_o21ai_1
X_22092_ _15012_ \regs.registers[2][6]\ _15005_ VPWR VGND sg13g2_nand2_1
X_22093_ _00433_ _14488_ _15004_ _15012_ VPWR VGND sg13g2_o21ai_1
X_22094_ _15013_ _15003_ VPWR VGND sg13g2_buf_1
X_22095_ _15014_ \regs.registers[2][7]\ _15013_ VPWR VGND sg13g2_nand2_1
X_22096_ _00434_ _14504_ _15004_ _15014_ VPWR VGND sg13g2_o21ai_1
X_22097_ _15015_ \regs.registers[2][8]\ _15013_ VPWR VGND sg13g2_nand2_1
X_22098_ _00435_ _14519_ _15004_ _15015_ VPWR VGND sg13g2_o21ai_1
X_22099_ _15016_ \regs.registers[2][9]\ _15013_ VPWR VGND sg13g2_nand2_1
X_22100_ _00436_ _14534_ _15004_ _15016_ VPWR VGND sg13g2_o21ai_1
X_22101_ _15017_ _15003_ VPWR VGND sg13g2_buf_1
X_22102_ _15018_ \regs.registers[2][10]\ _15013_ VPWR VGND sg13g2_nand2_1
X_22103_ _00437_ _14548_ _15017_ _15018_ VPWR VGND sg13g2_o21ai_1
X_22104_ _15019_ \regs.registers[2][11]\ _15013_ VPWR VGND sg13g2_nand2_1
X_22105_ _00438_ _14562_ _15017_ _15019_ VPWR VGND sg13g2_o21ai_1
X_22106_ _15020_ \regs.registers[2][12]\ _15013_ VPWR VGND sg13g2_nand2_1
X_22107_ _00439_ _14575_ _15017_ _15020_ VPWR VGND sg13g2_o21ai_1
X_22108_ _15021_ \regs.registers[2][13]\ _15013_ VPWR VGND sg13g2_nand2_1
X_22109_ _00440_ _14590_ _15017_ _15021_ VPWR VGND sg13g2_o21ai_1
X_22110_ _15022_ \regs.registers[2][14]\ _15013_ VPWR VGND sg13g2_nand2_1
X_22111_ _00441_ _14606_ _15017_ _15022_ VPWR VGND sg13g2_o21ai_1
X_22112_ _15023_ \regs.registers[2][15]\ _15013_ VPWR VGND sg13g2_nand2_1
X_22113_ _00442_ _14621_ _15017_ _15023_ VPWR VGND sg13g2_o21ai_1
X_22114_ _15024_ \regs.registers[2][16]\ _15013_ VPWR VGND sg13g2_nand2_1
X_22115_ _00443_ _14634_ _15017_ _15024_ VPWR VGND sg13g2_o21ai_1
X_22116_ _15025_ \regs.registers[2][17]\ _15003_ VPWR VGND sg13g2_nand2_1
X_22117_ _00444_ _14650_ _15017_ _15025_ VPWR VGND sg13g2_o21ai_1
X_22118_ _15026_ \regs.registers[2][18]\ _15003_ VPWR VGND sg13g2_nand2_1
X_22119_ _00445_ _14663_ _15017_ _15026_ VPWR VGND sg13g2_o21ai_1
X_22120_ _15027_ \regs.registers[2][19]\ _15003_ VPWR VGND sg13g2_nand2_1
X_22121_ _00446_ _14678_ _15017_ _15027_ VPWR VGND sg13g2_o21ai_1
X_22122_ _15028_ \regs.registers[2][20]\ _15003_ VPWR VGND sg13g2_nand2_1
X_22123_ _00447_ _14694_ _15005_ _15028_ VPWR VGND sg13g2_o21ai_1
X_22124_ _15029_ \control_i.imm_gen_i.iword[10]\ \control_i.imm_gen_i.iword[9]\ _14371_ VPWR VGND sg13g2_nor3_1
X_22125_ _15030_ _15029_ VPWR VGND sg13g2_buf_1
X_22126_ _00448_ \regs.registers[2][21]\ _14709_ _15030_ VPWR VGND sg13g2_mux2_1
X_22127_ _15031_ \regs.registers[2][22]\ _15003_ VPWR VGND sg13g2_nand2_1
X_22128_ _00449_ _14723_ _15005_ _15031_ VPWR VGND sg13g2_o21ai_1
X_22129_ _15032_ \regs.registers[2][23]\ _15003_ VPWR VGND sg13g2_nand2_1
X_22130_ _00450_ _14736_ _15005_ _15032_ VPWR VGND sg13g2_o21ai_1
X_22131_ _00451_ \regs.registers[2][24]\ _14747_ _15030_ VPWR VGND sg13g2_mux2_1
X_22132_ _00452_ \regs.registers[2][25]\ _14756_ _15030_ VPWR VGND sg13g2_mux2_1
X_22133_ _00453_ \regs.registers[2][26]\ _14765_ _15030_ VPWR VGND sg13g2_mux2_1
X_22134_ _00454_ \regs.registers[2][27]\ _14774_ _15030_ VPWR VGND sg13g2_mux2_1
X_22135_ _00455_ \regs.registers[2][28]\ _14783_ _15030_ VPWR VGND sg13g2_mux2_1
X_22136_ _00456_ \regs.registers[2][29]\ _14792_ _15030_ VPWR VGND sg13g2_mux2_1
X_22137_ _00457_ \regs.registers[2][30]\ _14801_ _15030_ VPWR VGND sg13g2_mux2_1
X_22138_ _00458_ \regs.registers[2][31]\ _14810_ _15030_ VPWR VGND sg13g2_mux2_1
X_22139_ _15033_ \control_i.imm_gen_i.iword[8]\ \control_i.imm_gen_i.iword[7]\ _14365_ _14369_ VPWR
+ VGND
+ sg13g2_nand4_1
X_22140_ _15034_ _15033_ VPWR VGND sg13g2_buf_1
X_22141_ _15035_ _15034_ VPWR VGND sg13g2_buf_1
X_22142_ _15036_ _15034_ VPWR VGND sg13g2_buf_1
X_22143_ _15037_ \regs.registers[3][0]\ _15036_ VPWR VGND sg13g2_nand2_1
X_22144_ _00459_ _14363_ _15035_ _15037_ VPWR VGND sg13g2_o21ai_1
X_22145_ _15038_ \regs.registers[3][1]\ _15036_ VPWR VGND sg13g2_nand2_1
X_22146_ _00460_ _14398_ _15035_ _15038_ VPWR VGND sg13g2_o21ai_1
X_22147_ _15039_ \regs.registers[3][2]\ _15036_ VPWR VGND sg13g2_nand2_1
X_22148_ _00461_ _14417_ _15035_ _15039_ VPWR VGND sg13g2_o21ai_1
X_22149_ _15040_ \regs.registers[3][3]\ _15036_ VPWR VGND sg13g2_nand2_1
X_22150_ _00462_ _14431_ _15035_ _15040_ VPWR VGND sg13g2_o21ai_1
X_22151_ _15041_ \regs.registers[3][4]\ _15036_ VPWR VGND sg13g2_nand2_1
X_22152_ _00463_ _14446_ _15035_ _15041_ VPWR VGND sg13g2_o21ai_1
X_22153_ _15042_ \regs.registers[3][5]\ _15036_ VPWR VGND sg13g2_nand2_1
X_22154_ _00464_ _14461_ _15035_ _15042_ VPWR VGND sg13g2_o21ai_1
X_22155_ _15043_ \regs.registers[3][6]\ _15036_ VPWR VGND sg13g2_nand2_1
X_22156_ _00465_ _14488_ _15035_ _15043_ VPWR VGND sg13g2_o21ai_1
X_22157_ _15044_ _15034_ VPWR VGND sg13g2_buf_1
X_22158_ _15045_ \regs.registers[3][7]\ _15044_ VPWR VGND sg13g2_nand2_1
X_22159_ _00466_ _14504_ _15035_ _15045_ VPWR VGND sg13g2_o21ai_1
X_22160_ _15046_ \regs.registers[3][8]\ _15044_ VPWR VGND sg13g2_nand2_1
X_22161_ _00467_ _14519_ _15035_ _15046_ VPWR VGND sg13g2_o21ai_1
X_22162_ _15047_ \regs.registers[3][9]\ _15044_ VPWR VGND sg13g2_nand2_1
X_22163_ _00468_ _14534_ _15035_ _15047_ VPWR VGND sg13g2_o21ai_1
X_22164_ _15048_ _15034_ VPWR VGND sg13g2_buf_1
X_22165_ _15049_ \regs.registers[3][10]\ _15044_ VPWR VGND sg13g2_nand2_1
X_22166_ _00469_ _14548_ _15048_ _15049_ VPWR VGND sg13g2_o21ai_1
X_22167_ _15050_ \regs.registers[3][11]\ _15044_ VPWR VGND sg13g2_nand2_1
X_22168_ _00470_ _14562_ _15048_ _15050_ VPWR VGND sg13g2_o21ai_1
X_22169_ _15051_ \regs.registers[3][12]\ _15044_ VPWR VGND sg13g2_nand2_1
X_22170_ _00471_ _14575_ _15048_ _15051_ VPWR VGND sg13g2_o21ai_1
X_22171_ _15052_ \regs.registers[3][13]\ _15044_ VPWR VGND sg13g2_nand2_1
X_22172_ _00472_ _14590_ _15048_ _15052_ VPWR VGND sg13g2_o21ai_1
X_22173_ _15053_ \regs.registers[3][14]\ _15044_ VPWR VGND sg13g2_nand2_1
X_22174_ _00473_ _14606_ _15048_ _15053_ VPWR VGND sg13g2_o21ai_1
X_22175_ _15054_ \regs.registers[3][15]\ _15044_ VPWR VGND sg13g2_nand2_1
X_22176_ _00474_ _14621_ _15048_ _15054_ VPWR VGND sg13g2_o21ai_1
X_22177_ _15055_ \regs.registers[3][16]\ _15044_ VPWR VGND sg13g2_nand2_1
X_22178_ _00475_ _14634_ _15048_ _15055_ VPWR VGND sg13g2_o21ai_1
X_22179_ _15056_ \regs.registers[3][17]\ _15034_ VPWR VGND sg13g2_nand2_1
X_22180_ _00476_ _14650_ _15048_ _15056_ VPWR VGND sg13g2_o21ai_1
X_22181_ _15057_ \regs.registers[3][18]\ _15034_ VPWR VGND sg13g2_nand2_1
X_22182_ _00477_ _14663_ _15048_ _15057_ VPWR VGND sg13g2_o21ai_1
X_22183_ _15058_ \regs.registers[3][19]\ _15034_ VPWR VGND sg13g2_nand2_1
X_22184_ _00478_ _14678_ _15048_ _15058_ VPWR VGND sg13g2_o21ai_1
X_22185_ _15059_ \regs.registers[3][20]\ _15034_ VPWR VGND sg13g2_nand2_1
X_22186_ _00479_ _14694_ _15036_ _15059_ VPWR VGND sg13g2_o21ai_1
X_22187_ _15060_ \control_i.imm_gen_i.iword[10]\ \control_i.imm_gen_i.iword[9]\ _14812_ VPWR VGND sg13g2_nor3_1
X_22188_ _15061_ _15060_ VPWR VGND sg13g2_buf_1
X_22189_ _00480_ \regs.registers[3][21]\ _14708_ _15061_ VPWR VGND sg13g2_mux2_1
X_22190_ _15062_ \regs.registers[3][22]\ _15034_ VPWR VGND sg13g2_nand2_1
X_22191_ _00481_ _14723_ _15036_ _15062_ VPWR VGND sg13g2_o21ai_1
X_22192_ _15063_ \regs.registers[3][23]\ _15034_ VPWR VGND sg13g2_nand2_1
X_22193_ _00482_ _14736_ _15036_ _15063_ VPWR VGND sg13g2_o21ai_1
X_22194_ _00483_ \regs.registers[3][24]\ _14746_ _15061_ VPWR VGND sg13g2_mux2_1
X_22195_ _00484_ \regs.registers[3][25]\ _14755_ _15061_ VPWR VGND sg13g2_mux2_1
X_22196_ _00485_ \regs.registers[3][26]\ _14764_ _15061_ VPWR VGND sg13g2_mux2_1
X_22197_ _00486_ \regs.registers[3][27]\ _14773_ _15061_ VPWR VGND sg13g2_mux2_1
X_22198_ _00487_ \regs.registers[3][28]\ _14782_ _15061_ VPWR VGND sg13g2_mux2_1
X_22199_ _00488_ \regs.registers[3][29]\ _14791_ _15061_ VPWR VGND sg13g2_mux2_1
X_22200_ _00489_ \regs.registers[3][30]\ _14800_ _15061_ VPWR VGND sg13g2_mux2_1
X_22201_ _00490_ \regs.registers[3][31]\ _14809_ _15061_ VPWR VGND sg13g2_mux2_1
X_22202_ _15064_ _14366_ _14369_ VPWR VGND sg13g2_and2_1
X_22203_ _15065_ \control_i.imm_gen_i.iword[10]\ \control_i.imm_gen_i.iword[9]\ VPWR VGND sg13g2_nor2b_1
X_22204_ _15066_ _15064_ _15065_ VPWR VGND sg13g2_nand2_1
X_22205_ _15067_ _15066_ VPWR VGND sg13g2_buf_1
X_22206_ _15068_ _15067_ VPWR VGND sg13g2_buf_1
X_22207_ _15069_ _15067_ VPWR VGND sg13g2_buf_1
X_22208_ _15070_ \regs.registers[4][0]\ _15069_ VPWR VGND sg13g2_nand2_1
X_22209_ _00491_ _14363_ _15068_ _15070_ VPWR VGND sg13g2_o21ai_1
X_22210_ _15071_ \regs.registers[4][1]\ _15069_ VPWR VGND sg13g2_nand2_1
X_22211_ _00492_ _14398_ _15068_ _15071_ VPWR VGND sg13g2_o21ai_1
X_22212_ _15072_ \regs.registers[4][2]\ _15069_ VPWR VGND sg13g2_nand2_1
X_22213_ _00493_ _14417_ _15068_ _15072_ VPWR VGND sg13g2_o21ai_1
X_22214_ _15073_ \regs.registers[4][3]\ _15069_ VPWR VGND sg13g2_nand2_1
X_22215_ _00494_ _14431_ _15068_ _15073_ VPWR VGND sg13g2_o21ai_1
X_22216_ _15074_ \regs.registers[4][4]\ _15069_ VPWR VGND sg13g2_nand2_1
X_22217_ _00495_ _14446_ _15068_ _15074_ VPWR VGND sg13g2_o21ai_1
X_22218_ _15075_ \regs.registers[4][5]\ _15069_ VPWR VGND sg13g2_nand2_1
X_22219_ _00496_ _14461_ _15068_ _15075_ VPWR VGND sg13g2_o21ai_1
X_22220_ _15076_ \regs.registers[4][6]\ _15069_ VPWR VGND sg13g2_nand2_1
X_22221_ _00497_ _14488_ _15068_ _15076_ VPWR VGND sg13g2_o21ai_1
X_22222_ _15077_ _15067_ VPWR VGND sg13g2_buf_1
X_22223_ _15078_ \regs.registers[4][7]\ _15077_ VPWR VGND sg13g2_nand2_1
X_22224_ _00498_ _14504_ _15068_ _15078_ VPWR VGND sg13g2_o21ai_1
X_22225_ _15079_ \regs.registers[4][8]\ _15077_ VPWR VGND sg13g2_nand2_1
X_22226_ _00499_ _14519_ _15068_ _15079_ VPWR VGND sg13g2_o21ai_1
X_22227_ _15080_ \regs.registers[4][9]\ _15077_ VPWR VGND sg13g2_nand2_1
X_22228_ _00500_ _14534_ _15068_ _15080_ VPWR VGND sg13g2_o21ai_1
X_22229_ _15081_ _15067_ VPWR VGND sg13g2_buf_1
X_22230_ _15082_ \regs.registers[4][10]\ _15077_ VPWR VGND sg13g2_nand2_1
X_22231_ _00501_ _14548_ _15081_ _15082_ VPWR VGND sg13g2_o21ai_1
X_22232_ _15083_ \regs.registers[4][11]\ _15077_ VPWR VGND sg13g2_nand2_1
X_22233_ _00502_ _14562_ _15081_ _15083_ VPWR VGND sg13g2_o21ai_1
X_22234_ _15084_ \regs.registers[4][12]\ _15077_ VPWR VGND sg13g2_nand2_1
X_22235_ _00503_ _14575_ _15081_ _15084_ VPWR VGND sg13g2_o21ai_1
X_22236_ _15085_ \regs.registers[4][13]\ _15077_ VPWR VGND sg13g2_nand2_1
X_22237_ _00504_ _14590_ _15081_ _15085_ VPWR VGND sg13g2_o21ai_1
X_22238_ _15086_ \regs.registers[4][14]\ _15077_ VPWR VGND sg13g2_nand2_1
X_22239_ _00505_ _14606_ _15081_ _15086_ VPWR VGND sg13g2_o21ai_1
X_22240_ _15087_ \regs.registers[4][15]\ _15077_ VPWR VGND sg13g2_nand2_1
X_22241_ _00506_ _14621_ _15081_ _15087_ VPWR VGND sg13g2_o21ai_1
X_22242_ _15088_ \regs.registers[4][16]\ _15077_ VPWR VGND sg13g2_nand2_1
X_22243_ _00507_ _14634_ _15081_ _15088_ VPWR VGND sg13g2_o21ai_1
X_22244_ _15089_ \regs.registers[4][17]\ _15067_ VPWR VGND sg13g2_nand2_1
X_22245_ _00508_ _14650_ _15081_ _15089_ VPWR VGND sg13g2_o21ai_1
X_22246_ _15090_ \regs.registers[4][18]\ _15067_ VPWR VGND sg13g2_nand2_1
X_22247_ _00509_ _14663_ _15081_ _15090_ VPWR VGND sg13g2_o21ai_1
X_22248_ _15091_ \regs.registers[4][19]\ _15067_ VPWR VGND sg13g2_nand2_1
X_22249_ _00510_ _14678_ _15081_ _15091_ VPWR VGND sg13g2_o21ai_1
X_22250_ _15092_ \regs.registers[4][20]\ _15067_ VPWR VGND sg13g2_nand2_1
X_22251_ _00511_ _14694_ _15069_ _15092_ VPWR VGND sg13g2_o21ai_1
X_22252_ _15093_ \control_i.imm_gen_i.iword[10]\ \control_i.imm_gen_i.iword[9]\ VPWR VGND sg13g2_nand2b_1
X_22253_ _15094_ _14844_ _15093_ VPWR VGND sg13g2_nor2_1
X_22254_ _15095_ _15094_ VPWR VGND sg13g2_buf_1
X_22255_ _00512_ \regs.registers[4][21]\ _14708_ _15095_ VPWR VGND sg13g2_mux2_1
X_22256_ _15096_ \regs.registers[4][22]\ _15067_ VPWR VGND sg13g2_nand2_1
X_22257_ _00513_ _14723_ _15069_ _15096_ VPWR VGND sg13g2_o21ai_1
X_22258_ _15097_ \regs.registers[4][23]\ _15067_ VPWR VGND sg13g2_nand2_1
X_22259_ _00514_ _14736_ _15069_ _15097_ VPWR VGND sg13g2_o21ai_1
X_22260_ _00515_ \regs.registers[4][24]\ _14746_ _15095_ VPWR VGND sg13g2_mux2_1
X_22261_ _00516_ \regs.registers[4][25]\ _14755_ _15095_ VPWR VGND sg13g2_mux2_1
X_22262_ _00517_ \regs.registers[4][26]\ _14764_ _15095_ VPWR VGND sg13g2_mux2_1
X_22263_ _00518_ \regs.registers[4][27]\ _14773_ _15095_ VPWR VGND sg13g2_mux2_1
X_22264_ _00519_ \regs.registers[4][28]\ _14782_ _15095_ VPWR VGND sg13g2_mux2_1
X_22265_ _00520_ \regs.registers[4][29]\ _14791_ _15095_ VPWR VGND sg13g2_mux2_1
X_22266_ _00521_ \regs.registers[4][30]\ _14800_ _15095_ VPWR VGND sg13g2_mux2_1
X_22267_ _00522_ \regs.registers[4][31]\ _14809_ _15095_ VPWR VGND sg13g2_mux2_1
X_22268_ _15098_ _14879_ _15065_ VPWR VGND sg13g2_nand2_1
X_22269_ _15099_ _15098_ VPWR VGND sg13g2_buf_1
X_22270_ _15100_ _15099_ VPWR VGND sg13g2_buf_1
X_22271_ _15101_ _15099_ VPWR VGND sg13g2_buf_1
X_22272_ _15102_ \regs.registers[5][0]\ _15101_ VPWR VGND sg13g2_nand2_1
X_22273_ _00523_ _14362_ _15100_ _15102_ VPWR VGND sg13g2_o21ai_1
X_22274_ _15103_ \regs.registers[5][1]\ _15101_ VPWR VGND sg13g2_nand2_1
X_22275_ _00524_ _14397_ _15100_ _15103_ VPWR VGND sg13g2_o21ai_1
X_22276_ _15104_ \regs.registers[5][2]\ _15101_ VPWR VGND sg13g2_nand2_1
X_22277_ _00525_ _14416_ _15100_ _15104_ VPWR VGND sg13g2_o21ai_1
X_22278_ _15105_ \regs.registers[5][3]\ _15101_ VPWR VGND sg13g2_nand2_1
X_22279_ _00526_ _14430_ _15100_ _15105_ VPWR VGND sg13g2_o21ai_1
X_22280_ _15106_ \regs.registers[5][4]\ _15101_ VPWR VGND sg13g2_nand2_1
X_22281_ _00527_ _14445_ _15100_ _15106_ VPWR VGND sg13g2_o21ai_1
X_22282_ _15107_ \regs.registers[5][5]\ _15101_ VPWR VGND sg13g2_nand2_1
X_22283_ _00528_ _14460_ _15100_ _15107_ VPWR VGND sg13g2_o21ai_1
X_22284_ _15108_ \regs.registers[5][6]\ _15101_ VPWR VGND sg13g2_nand2_1
X_22285_ _00529_ _14487_ _15100_ _15108_ VPWR VGND sg13g2_o21ai_1
X_22286_ _15109_ \regs.registers[5][7]\ _15101_ VPWR VGND sg13g2_nand2_1
X_22287_ _00530_ _14503_ _15100_ _15109_ VPWR VGND sg13g2_o21ai_1
X_22288_ _15110_ _15099_ VPWR VGND sg13g2_buf_1
X_22289_ _15111_ \regs.registers[5][8]\ _15110_ VPWR VGND sg13g2_nand2_1
X_22290_ _00531_ _14518_ _15100_ _15111_ VPWR VGND sg13g2_o21ai_1
X_22291_ _15112_ \regs.registers[5][9]\ _15110_ VPWR VGND sg13g2_nand2_1
X_22292_ _00532_ _14533_ _15100_ _15112_ VPWR VGND sg13g2_o21ai_1
X_22293_ _15113_ _15099_ VPWR VGND sg13g2_buf_1
X_22294_ _15114_ \regs.registers[5][10]\ _15110_ VPWR VGND sg13g2_nand2_1
X_22295_ _00533_ _14547_ _15113_ _15114_ VPWR VGND sg13g2_o21ai_1
X_22296_ _15115_ \regs.registers[5][11]\ _15110_ VPWR VGND sg13g2_nand2_1
X_22297_ _00534_ _14561_ _15113_ _15115_ VPWR VGND sg13g2_o21ai_1
X_22298_ _15116_ \regs.registers[5][12]\ _15110_ VPWR VGND sg13g2_nand2_1
X_22299_ _00535_ _14574_ _15113_ _15116_ VPWR VGND sg13g2_o21ai_1
X_22300_ _15117_ \regs.registers[5][13]\ _15110_ VPWR VGND sg13g2_nand2_1
X_22301_ _00536_ _14589_ _15113_ _15117_ VPWR VGND sg13g2_o21ai_1
X_22302_ _15118_ \regs.registers[5][14]\ _15110_ VPWR VGND sg13g2_nand2_1
X_22303_ _00537_ _14605_ _15113_ _15118_ VPWR VGND sg13g2_o21ai_1
X_22304_ _15119_ \regs.registers[5][15]\ _15110_ VPWR VGND sg13g2_nand2_1
X_22305_ _00538_ _14620_ _15113_ _15119_ VPWR VGND sg13g2_o21ai_1
X_22306_ _15120_ \regs.registers[5][16]\ _15110_ VPWR VGND sg13g2_nand2_1
X_22307_ _00539_ _14633_ _15113_ _15120_ VPWR VGND sg13g2_o21ai_1
X_22308_ _15121_ \regs.registers[5][17]\ _15110_ VPWR VGND sg13g2_nand2_1
X_22309_ _00540_ _14649_ _15113_ _15121_ VPWR VGND sg13g2_o21ai_1
X_22310_ _15122_ \regs.registers[5][18]\ _15099_ VPWR VGND sg13g2_nand2_1
X_22311_ _00541_ _14662_ _15113_ _15122_ VPWR VGND sg13g2_o21ai_1
X_22312_ _15123_ \regs.registers[5][19]\ _15099_ VPWR VGND sg13g2_nand2_1
X_22313_ _00542_ _14677_ _15113_ _15123_ VPWR VGND sg13g2_o21ai_1
X_22314_ _15124_ _15099_ VPWR VGND sg13g2_buf_1
X_22315_ _15125_ \regs.registers[5][20]\ _15099_ VPWR VGND sg13g2_nand2_1
X_22316_ _00543_ _14693_ _15124_ _15125_ VPWR VGND sg13g2_o21ai_1
X_22317_ _00544_ _14709_ \regs.registers[5][21]\ _15124_ VPWR VGND sg13g2_mux2_1
X_22318_ _15126_ \regs.registers[5][22]\ _15099_ VPWR VGND sg13g2_nand2_1
X_22319_ _00545_ _14722_ _15124_ _15126_ VPWR VGND sg13g2_o21ai_1
X_22320_ _15127_ \regs.registers[5][23]\ _15099_ VPWR VGND sg13g2_nand2_1
X_22321_ _00546_ _14735_ _15124_ _15127_ VPWR VGND sg13g2_o21ai_1
X_22322_ _00547_ _14747_ \regs.registers[5][24]\ _15124_ VPWR VGND sg13g2_mux2_1
X_22323_ _00548_ _14756_ \regs.registers[5][25]\ _15124_ VPWR VGND sg13g2_mux2_1
X_22324_ _00549_ _14765_ \regs.registers[5][26]\ _15124_ VPWR VGND sg13g2_mux2_1
X_22325_ _00550_ _14774_ \regs.registers[5][27]\ _15124_ VPWR VGND sg13g2_mux2_1
X_22326_ _00551_ _14783_ \regs.registers[5][28]\ _15124_ VPWR VGND sg13g2_mux2_1
X_22327_ _00552_ _14792_ \regs.registers[5][29]\ _15124_ VPWR VGND sg13g2_mux2_1
X_22328_ _00553_ _14801_ \regs.registers[5][30]\ _15101_ VPWR VGND sg13g2_mux2_1
X_22329_ _00554_ _14810_ \regs.registers[5][31]\ _15101_ VPWR VGND sg13g2_mux2_1
X_22330_ _15128_ _14371_ _15065_ VPWR VGND sg13g2_nand2b_1
X_22331_ _15129_ _15128_ VPWR VGND sg13g2_buf_1
X_22332_ _15130_ _15129_ VPWR VGND sg13g2_buf_1
X_22333_ _15131_ _15129_ VPWR VGND sg13g2_buf_1
X_22334_ _15132_ \regs.registers[6][0]\ _15131_ VPWR VGND sg13g2_nand2_1
X_22335_ _00555_ _14362_ _15130_ _15132_ VPWR VGND sg13g2_o21ai_1
X_22336_ _15133_ \regs.registers[6][1]\ _15131_ VPWR VGND sg13g2_nand2_1
X_22337_ _00556_ _14397_ _15130_ _15133_ VPWR VGND sg13g2_o21ai_1
X_22338_ _15134_ \regs.registers[6][2]\ _15131_ VPWR VGND sg13g2_nand2_1
X_22339_ _00557_ _14416_ _15130_ _15134_ VPWR VGND sg13g2_o21ai_1
X_22340_ _15135_ \regs.registers[6][3]\ _15131_ VPWR VGND sg13g2_nand2_1
X_22341_ _00558_ _14430_ _15130_ _15135_ VPWR VGND sg13g2_o21ai_1
X_22342_ _15136_ \regs.registers[6][4]\ _15131_ VPWR VGND sg13g2_nand2_1
X_22343_ _00559_ _14445_ _15130_ _15136_ VPWR VGND sg13g2_o21ai_1
X_22344_ _15137_ \regs.registers[6][5]\ _15131_ VPWR VGND sg13g2_nand2_1
X_22345_ _00560_ _14460_ _15130_ _15137_ VPWR VGND sg13g2_o21ai_1
X_22346_ _15138_ \regs.registers[6][6]\ _15131_ VPWR VGND sg13g2_nand2_1
X_22347_ _00561_ _14487_ _15130_ _15138_ VPWR VGND sg13g2_o21ai_1
X_22348_ _15139_ _15129_ VPWR VGND sg13g2_buf_1
X_22349_ _15140_ \regs.registers[6][7]\ _15139_ VPWR VGND sg13g2_nand2_1
X_22350_ _00562_ _14503_ _15130_ _15140_ VPWR VGND sg13g2_o21ai_1
X_22351_ _15141_ \regs.registers[6][8]\ _15139_ VPWR VGND sg13g2_nand2_1
X_22352_ _00563_ _14518_ _15130_ _15141_ VPWR VGND sg13g2_o21ai_1
X_22353_ _15142_ \regs.registers[6][9]\ _15139_ VPWR VGND sg13g2_nand2_1
X_22354_ _00564_ _14533_ _15130_ _15142_ VPWR VGND sg13g2_o21ai_1
X_22355_ _15143_ _15129_ VPWR VGND sg13g2_buf_1
X_22356_ _15144_ \regs.registers[6][10]\ _15139_ VPWR VGND sg13g2_nand2_1
X_22357_ _00565_ _14547_ _15143_ _15144_ VPWR VGND sg13g2_o21ai_1
X_22358_ _15145_ \regs.registers[6][11]\ _15139_ VPWR VGND sg13g2_nand2_1
X_22359_ _00566_ _14561_ _15143_ _15145_ VPWR VGND sg13g2_o21ai_1
X_22360_ _15146_ \regs.registers[6][12]\ _15139_ VPWR VGND sg13g2_nand2_1
X_22361_ _00567_ _14574_ _15143_ _15146_ VPWR VGND sg13g2_o21ai_1
X_22362_ _15147_ \regs.registers[6][13]\ _15139_ VPWR VGND sg13g2_nand2_1
X_22363_ _00568_ _14589_ _15143_ _15147_ VPWR VGND sg13g2_o21ai_1
X_22364_ _15148_ \regs.registers[6][14]\ _15139_ VPWR VGND sg13g2_nand2_1
X_22365_ _00569_ _14605_ _15143_ _15148_ VPWR VGND sg13g2_o21ai_1
X_22366_ _15149_ \regs.registers[6][15]\ _15139_ VPWR VGND sg13g2_nand2_1
X_22367_ _00570_ _14620_ _15143_ _15149_ VPWR VGND sg13g2_o21ai_1
X_22368_ _15150_ \regs.registers[6][16]\ _15139_ VPWR VGND sg13g2_nand2_1
X_22369_ _00571_ _14633_ _15143_ _15150_ VPWR VGND sg13g2_o21ai_1
X_22370_ _15151_ \regs.registers[6][17]\ _15129_ VPWR VGND sg13g2_nand2_1
X_22371_ _00572_ _14649_ _15143_ _15151_ VPWR VGND sg13g2_o21ai_1
X_22372_ _15152_ \regs.registers[6][18]\ _15129_ VPWR VGND sg13g2_nand2_1
X_22373_ _00573_ _14662_ _15143_ _15152_ VPWR VGND sg13g2_o21ai_1
X_22374_ _15153_ \regs.registers[6][19]\ _15129_ VPWR VGND sg13g2_nand2_1
X_22375_ _00574_ _14677_ _15143_ _15153_ VPWR VGND sg13g2_o21ai_1
X_22376_ _15154_ \regs.registers[6][20]\ _15129_ VPWR VGND sg13g2_nand2_1
X_22377_ _00575_ _14693_ _15131_ _15154_ VPWR VGND sg13g2_o21ai_1
X_22378_ _15155_ _14371_ _15093_ VPWR VGND sg13g2_nor2_1
X_22379_ _15156_ _15155_ VPWR VGND sg13g2_buf_1
X_22380_ _00576_ \regs.registers[6][21]\ _14708_ _15156_ VPWR VGND sg13g2_mux2_1
X_22381_ _15157_ \regs.registers[6][22]\ _15129_ VPWR VGND sg13g2_nand2_1
X_22382_ _00577_ _14722_ _15131_ _15157_ VPWR VGND sg13g2_o21ai_1
X_22383_ _15158_ \regs.registers[6][23]\ _15129_ VPWR VGND sg13g2_nand2_1
X_22384_ _00578_ _14735_ _15131_ _15158_ VPWR VGND sg13g2_o21ai_1
X_22385_ _00579_ \regs.registers[6][24]\ _14746_ _15156_ VPWR VGND sg13g2_mux2_1
X_22386_ _00580_ \regs.registers[6][25]\ _14755_ _15156_ VPWR VGND sg13g2_mux2_1
X_22387_ _00581_ \regs.registers[6][26]\ _14764_ _15156_ VPWR VGND sg13g2_mux2_1
X_22388_ _00582_ \regs.registers[6][27]\ _14773_ _15156_ VPWR VGND sg13g2_mux2_1
X_22389_ _00583_ \regs.registers[6][28]\ _14782_ _15156_ VPWR VGND sg13g2_mux2_1
X_22390_ _00584_ \regs.registers[6][29]\ _14791_ _15156_ VPWR VGND sg13g2_mux2_1
X_22391_ _00585_ \regs.registers[6][30]\ _14800_ _15156_ VPWR VGND sg13g2_mux2_1
X_22392_ _00586_ \regs.registers[6][31]\ _14809_ _15156_ VPWR VGND sg13g2_mux2_1
X_22393_ _15159_ _14812_ _15065_ VPWR VGND sg13g2_nand2b_1
X_22394_ _15160_ _15159_ VPWR VGND sg13g2_buf_1
X_22395_ _15161_ _15160_ VPWR VGND sg13g2_buf_1
X_22396_ _15162_ _15160_ VPWR VGND sg13g2_buf_1
X_22397_ _15163_ \regs.registers[7][0]\ _15162_ VPWR VGND sg13g2_nand2_1
X_22398_ _00587_ _14362_ _15161_ _15163_ VPWR VGND sg13g2_o21ai_1
X_22399_ _15164_ \regs.registers[7][1]\ _15162_ VPWR VGND sg13g2_nand2_1
X_22400_ _00588_ _14397_ _15161_ _15164_ VPWR VGND sg13g2_o21ai_1
X_22401_ _15165_ \regs.registers[7][2]\ _15162_ VPWR VGND sg13g2_nand2_1
X_22402_ _00589_ _14416_ _15161_ _15165_ VPWR VGND sg13g2_o21ai_1
X_22403_ _15166_ \regs.registers[7][3]\ _15162_ VPWR VGND sg13g2_nand2_1
X_22404_ _00590_ _14430_ _15161_ _15166_ VPWR VGND sg13g2_o21ai_1
X_22405_ _15167_ \regs.registers[7][4]\ _15162_ VPWR VGND sg13g2_nand2_1
X_22406_ _00591_ _14445_ _15161_ _15167_ VPWR VGND sg13g2_o21ai_1
X_22407_ _15168_ \regs.registers[7][5]\ _15162_ VPWR VGND sg13g2_nand2_1
X_22408_ _00592_ _14460_ _15161_ _15168_ VPWR VGND sg13g2_o21ai_1
X_22409_ _15169_ \regs.registers[7][6]\ _15162_ VPWR VGND sg13g2_nand2_1
X_22410_ _00593_ _14487_ _15161_ _15169_ VPWR VGND sg13g2_o21ai_1
X_22411_ _15170_ _15160_ VPWR VGND sg13g2_buf_1
X_22412_ _15171_ \regs.registers[7][7]\ _15170_ VPWR VGND sg13g2_nand2_1
X_22413_ _00594_ _14503_ _15161_ _15171_ VPWR VGND sg13g2_o21ai_1
X_22414_ _15172_ \regs.registers[7][8]\ _15170_ VPWR VGND sg13g2_nand2_1
X_22415_ _00595_ _14518_ _15161_ _15172_ VPWR VGND sg13g2_o21ai_1
X_22416_ _15173_ \regs.registers[7][9]\ _15170_ VPWR VGND sg13g2_nand2_1
X_22417_ _00596_ _14533_ _15161_ _15173_ VPWR VGND sg13g2_o21ai_1
X_22418_ _15174_ _15160_ VPWR VGND sg13g2_buf_1
X_22419_ _15175_ \regs.registers[7][10]\ _15170_ VPWR VGND sg13g2_nand2_1
X_22420_ _00597_ _14547_ _15174_ _15175_ VPWR VGND sg13g2_o21ai_1
X_22421_ _15176_ \regs.registers[7][11]\ _15170_ VPWR VGND sg13g2_nand2_1
X_22422_ _00598_ _14561_ _15174_ _15176_ VPWR VGND sg13g2_o21ai_1
X_22423_ _15177_ \regs.registers[7][12]\ _15170_ VPWR VGND sg13g2_nand2_1
X_22424_ _00599_ _14574_ _15174_ _15177_ VPWR VGND sg13g2_o21ai_1
X_22425_ _15178_ \regs.registers[7][13]\ _15170_ VPWR VGND sg13g2_nand2_1
X_22426_ _00600_ _14589_ _15174_ _15178_ VPWR VGND sg13g2_o21ai_1
X_22427_ _15179_ \regs.registers[7][14]\ _15170_ VPWR VGND sg13g2_nand2_1
X_22428_ _00601_ _14605_ _15174_ _15179_ VPWR VGND sg13g2_o21ai_1
X_22429_ _15180_ \regs.registers[7][15]\ _15170_ VPWR VGND sg13g2_nand2_1
X_22430_ _00602_ _14620_ _15174_ _15180_ VPWR VGND sg13g2_o21ai_1
X_22431_ _15181_ \regs.registers[7][16]\ _15170_ VPWR VGND sg13g2_nand2_1
X_22432_ _00603_ _14633_ _15174_ _15181_ VPWR VGND sg13g2_o21ai_1
X_22433_ _15182_ \regs.registers[7][17]\ _15160_ VPWR VGND sg13g2_nand2_1
X_22434_ _00604_ _14649_ _15174_ _15182_ VPWR VGND sg13g2_o21ai_1
X_22435_ _15183_ \regs.registers[7][18]\ _15160_ VPWR VGND sg13g2_nand2_1
X_22436_ _00605_ _14662_ _15174_ _15183_ VPWR VGND sg13g2_o21ai_1
X_22437_ _15184_ \regs.registers[7][19]\ _15160_ VPWR VGND sg13g2_nand2_1
X_22438_ _00606_ _14677_ _15174_ _15184_ VPWR VGND sg13g2_o21ai_1
X_22439_ _15185_ \regs.registers[7][20]\ _15160_ VPWR VGND sg13g2_nand2_1
X_22440_ _00607_ _14693_ _15162_ _15185_ VPWR VGND sg13g2_o21ai_1
X_22441_ _15186_ _14812_ _15093_ VPWR VGND sg13g2_nor2_1
X_22442_ _15187_ _15186_ VPWR VGND sg13g2_buf_1
X_22443_ _00608_ \regs.registers[7][21]\ _14708_ _15187_ VPWR VGND sg13g2_mux2_1
X_22444_ _15188_ \regs.registers[7][22]\ _15160_ VPWR VGND sg13g2_nand2_1
X_22445_ _00609_ _14722_ _15162_ _15188_ VPWR VGND sg13g2_o21ai_1
X_22446_ _15189_ \regs.registers[7][23]\ _15160_ VPWR VGND sg13g2_nand2_1
X_22447_ _00610_ _14735_ _15162_ _15189_ VPWR VGND sg13g2_o21ai_1
X_22448_ _00611_ \regs.registers[7][24]\ _14746_ _15187_ VPWR VGND sg13g2_mux2_1
X_22449_ _00612_ \regs.registers[7][25]\ _14755_ _15187_ VPWR VGND sg13g2_mux2_1
X_22450_ _00613_ \regs.registers[7][26]\ _14764_ _15187_ VPWR VGND sg13g2_mux2_1
X_22451_ _00614_ \regs.registers[7][27]\ _14773_ _15187_ VPWR VGND sg13g2_mux2_1
X_22452_ _00615_ \regs.registers[7][28]\ _14782_ _15187_ VPWR VGND sg13g2_mux2_1
X_22453_ _00616_ \regs.registers[7][29]\ _14791_ _15187_ VPWR VGND sg13g2_mux2_1
X_22454_ _00617_ \regs.registers[7][30]\ _14800_ _15187_ VPWR VGND sg13g2_mux2_1
X_22455_ _00618_ \regs.registers[7][31]\ _14809_ _15187_ VPWR VGND sg13g2_mux2_1
X_22456_ _15190_ _14373_ _15064_ VPWR VGND sg13g2_nand2b_1
X_22457_ _15191_ _15190_ VPWR VGND sg13g2_buf_1
X_22458_ _15192_ _15191_ VPWR VGND sg13g2_buf_1
X_22459_ _15193_ _15191_ VPWR VGND sg13g2_buf_1
X_22460_ _15194_ \regs.registers[8][0]\ _15193_ VPWR VGND sg13g2_nand2_1
X_22461_ _00619_ _14362_ _15192_ _15194_ VPWR VGND sg13g2_o21ai_1
X_22462_ _15195_ \regs.registers[8][1]\ _15193_ VPWR VGND sg13g2_nand2_1
X_22463_ _00620_ _14397_ _15192_ _15195_ VPWR VGND sg13g2_o21ai_1
X_22464_ _15196_ \regs.registers[8][2]\ _15193_ VPWR VGND sg13g2_nand2_1
X_22465_ _00621_ _14416_ _15192_ _15196_ VPWR VGND sg13g2_o21ai_1
X_22466_ _15197_ \regs.registers[8][3]\ _15193_ VPWR VGND sg13g2_nand2_1
X_22467_ _00622_ _14430_ _15192_ _15197_ VPWR VGND sg13g2_o21ai_1
X_22468_ _15198_ \regs.registers[8][4]\ _15193_ VPWR VGND sg13g2_nand2_1
X_22469_ _00623_ _14445_ _15192_ _15198_ VPWR VGND sg13g2_o21ai_1
X_22470_ _15199_ \regs.registers[8][5]\ _15193_ VPWR VGND sg13g2_nand2_1
X_22471_ _00624_ _14460_ _15192_ _15199_ VPWR VGND sg13g2_o21ai_1
X_22472_ _15200_ \regs.registers[8][6]\ _15193_ VPWR VGND sg13g2_nand2_1
X_22473_ _00625_ _14487_ _15192_ _15200_ VPWR VGND sg13g2_o21ai_1
X_22474_ _15201_ _15191_ VPWR VGND sg13g2_buf_1
X_22475_ _15202_ \regs.registers[8][7]\ _15201_ VPWR VGND sg13g2_nand2_1
X_22476_ _00626_ _14503_ _15192_ _15202_ VPWR VGND sg13g2_o21ai_1
X_22477_ _15203_ \regs.registers[8][8]\ _15201_ VPWR VGND sg13g2_nand2_1
X_22478_ _00627_ _14518_ _15192_ _15203_ VPWR VGND sg13g2_o21ai_1
X_22479_ _15204_ \regs.registers[8][9]\ _15201_ VPWR VGND sg13g2_nand2_1
X_22480_ _00628_ _14533_ _15192_ _15204_ VPWR VGND sg13g2_o21ai_1
X_22481_ _15205_ _15191_ VPWR VGND sg13g2_buf_1
X_22482_ _15206_ \regs.registers[8][10]\ _15201_ VPWR VGND sg13g2_nand2_1
X_22483_ _00629_ _14547_ _15205_ _15206_ VPWR VGND sg13g2_o21ai_1
X_22484_ _15207_ \regs.registers[8][11]\ _15201_ VPWR VGND sg13g2_nand2_1
X_22485_ _00630_ _14561_ _15205_ _15207_ VPWR VGND sg13g2_o21ai_1
X_22486_ _15208_ \regs.registers[8][12]\ _15201_ VPWR VGND sg13g2_nand2_1
X_22487_ _00631_ _14574_ _15205_ _15208_ VPWR VGND sg13g2_o21ai_1
X_22488_ _15209_ \regs.registers[8][13]\ _15201_ VPWR VGND sg13g2_nand2_1
X_22489_ _00632_ _14589_ _15205_ _15209_ VPWR VGND sg13g2_o21ai_1
X_22490_ _15210_ \regs.registers[8][14]\ _15201_ VPWR VGND sg13g2_nand2_1
X_22491_ _00633_ _14605_ _15205_ _15210_ VPWR VGND sg13g2_o21ai_1
X_22492_ _15211_ \regs.registers[8][15]\ _15201_ VPWR VGND sg13g2_nand2_1
X_22493_ _00634_ _14620_ _15205_ _15211_ VPWR VGND sg13g2_o21ai_1
X_22494_ _15212_ \regs.registers[8][16]\ _15201_ VPWR VGND sg13g2_nand2_1
X_22495_ _00635_ _14633_ _15205_ _15212_ VPWR VGND sg13g2_o21ai_1
X_22496_ _15213_ \regs.registers[8][17]\ _15191_ VPWR VGND sg13g2_nand2_1
X_22497_ _00636_ _14649_ _15205_ _15213_ VPWR VGND sg13g2_o21ai_1
X_22498_ _15214_ \regs.registers[8][18]\ _15191_ VPWR VGND sg13g2_nand2_1
X_22499_ _00637_ _14662_ _15205_ _15214_ VPWR VGND sg13g2_o21ai_1
X_22500_ _15215_ \regs.registers[8][19]\ _15191_ VPWR VGND sg13g2_nand2_1
X_22501_ _00638_ _14677_ _15205_ _15215_ VPWR VGND sg13g2_o21ai_1
X_22502_ _15216_ \regs.registers[8][20]\ _15191_ VPWR VGND sg13g2_nand2_1
X_22503_ _00639_ _14693_ _15193_ _15216_ VPWR VGND sg13g2_o21ai_1
X_22504_ _15217_ _14373_ _14844_ VPWR VGND sg13g2_nor2_1
X_22505_ _15218_ _15217_ VPWR VGND sg13g2_buf_1
X_22506_ _00640_ \regs.registers[8][21]\ _14708_ _15218_ VPWR VGND sg13g2_mux2_1
X_22507_ _15219_ \regs.registers[8][22]\ _15191_ VPWR VGND sg13g2_nand2_1
X_22508_ _00641_ _14722_ _15193_ _15219_ VPWR VGND sg13g2_o21ai_1
X_22509_ _15220_ \regs.registers[8][23]\ _15191_ VPWR VGND sg13g2_nand2_1
X_22510_ _00642_ _14735_ _15193_ _15220_ VPWR VGND sg13g2_o21ai_1
X_22511_ _00643_ \regs.registers[8][24]\ _14746_ _15218_ VPWR VGND sg13g2_mux2_1
X_22512_ _00644_ \regs.registers[8][25]\ _14755_ _15218_ VPWR VGND sg13g2_mux2_1
X_22513_ _00645_ \regs.registers[8][26]\ _14764_ _15218_ VPWR VGND sg13g2_mux2_1
X_22514_ _00646_ \regs.registers[8][27]\ _14773_ _15218_ VPWR VGND sg13g2_mux2_1
X_22515_ _00647_ \regs.registers[8][28]\ _14782_ _15218_ VPWR VGND sg13g2_mux2_1
X_22516_ _00648_ \regs.registers[8][29]\ _14791_ _15218_ VPWR VGND sg13g2_mux2_1
X_22517_ _00649_ \regs.registers[8][30]\ _14800_ _15218_ VPWR VGND sg13g2_mux2_1
X_22518_ _00650_ \regs.registers[8][31]\ _14809_ _15218_ VPWR VGND sg13g2_mux2_1
X_22519_ _15221_ _14373_ _14879_ VPWR VGND sg13g2_nand2b_1
X_22520_ _15222_ _15221_ VPWR VGND sg13g2_buf_1
X_22521_ _15223_ _15222_ VPWR VGND sg13g2_buf_1
X_22522_ _15224_ _15222_ VPWR VGND sg13g2_buf_1
X_22523_ _15225_ \regs.registers[9][0]\ _15224_ VPWR VGND sg13g2_nand2_1
X_22524_ _00651_ _14362_ _15223_ _15225_ VPWR VGND sg13g2_o21ai_1
X_22525_ _15226_ \regs.registers[9][1]\ _15224_ VPWR VGND sg13g2_nand2_1
X_22526_ _00652_ _14397_ _15223_ _15226_ VPWR VGND sg13g2_o21ai_1
X_22527_ _15227_ \regs.registers[9][2]\ _15224_ VPWR VGND sg13g2_nand2_1
X_22528_ _00653_ _14416_ _15223_ _15227_ VPWR VGND sg13g2_o21ai_1
X_22529_ _15228_ \regs.registers[9][3]\ _15224_ VPWR VGND sg13g2_nand2_1
X_22530_ _00654_ _14430_ _15223_ _15228_ VPWR VGND sg13g2_o21ai_1
X_22531_ _15229_ \regs.registers[9][4]\ _15224_ VPWR VGND sg13g2_nand2_1
X_22532_ _00655_ _14445_ _15223_ _15229_ VPWR VGND sg13g2_o21ai_1
X_22533_ _15230_ \regs.registers[9][5]\ _15224_ VPWR VGND sg13g2_nand2_1
X_22534_ _00656_ _14460_ _15223_ _15230_ VPWR VGND sg13g2_o21ai_1
X_22535_ _15231_ \regs.registers[9][6]\ _15224_ VPWR VGND sg13g2_nand2_1
X_22536_ _00657_ _14487_ _15223_ _15231_ VPWR VGND sg13g2_o21ai_1
X_22537_ _15232_ \regs.registers[9][7]\ _15224_ VPWR VGND sg13g2_nand2_1
X_22538_ _00658_ _14503_ _15223_ _15232_ VPWR VGND sg13g2_o21ai_1
X_22539_ _15233_ _15222_ VPWR VGND sg13g2_buf_1
X_22540_ _15234_ \regs.registers[9][8]\ _15233_ VPWR VGND sg13g2_nand2_1
X_22541_ _00659_ _14518_ _15223_ _15234_ VPWR VGND sg13g2_o21ai_1
X_22542_ _15235_ \regs.registers[9][9]\ _15233_ VPWR VGND sg13g2_nand2_1
X_22543_ _00660_ _14533_ _15223_ _15235_ VPWR VGND sg13g2_o21ai_1
X_22544_ _15236_ _15222_ VPWR VGND sg13g2_buf_1
X_22545_ _15237_ \regs.registers[9][10]\ _15233_ VPWR VGND sg13g2_nand2_1
X_22546_ _00661_ _14547_ _15236_ _15237_ VPWR VGND sg13g2_o21ai_1
X_22547_ _15238_ \regs.registers[9][11]\ _15233_ VPWR VGND sg13g2_nand2_1
X_22548_ _00662_ _14561_ _15236_ _15238_ VPWR VGND sg13g2_o21ai_1
X_22549_ _15239_ \regs.registers[9][12]\ _15233_ VPWR VGND sg13g2_nand2_1
X_22550_ _00663_ _14574_ _15236_ _15239_ VPWR VGND sg13g2_o21ai_1
X_22551_ _15240_ \regs.registers[9][13]\ _15233_ VPWR VGND sg13g2_nand2_1
X_22552_ _00664_ _14589_ _15236_ _15240_ VPWR VGND sg13g2_o21ai_1
X_22553_ _15241_ \regs.registers[9][14]\ _15233_ VPWR VGND sg13g2_nand2_1
X_22554_ _00665_ _14605_ _15236_ _15241_ VPWR VGND sg13g2_o21ai_1
X_22555_ _15242_ \regs.registers[9][15]\ _15233_ VPWR VGND sg13g2_nand2_1
X_22556_ _00666_ _14620_ _15236_ _15242_ VPWR VGND sg13g2_o21ai_1
X_22557_ _15243_ \regs.registers[9][16]\ _15233_ VPWR VGND sg13g2_nand2_1
X_22558_ _00667_ _14633_ _15236_ _15243_ VPWR VGND sg13g2_o21ai_1
X_22559_ _15244_ \regs.registers[9][17]\ _15233_ VPWR VGND sg13g2_nand2_1
X_22560_ _00668_ _14649_ _15236_ _15244_ VPWR VGND sg13g2_o21ai_1
X_22561_ _15245_ \regs.registers[9][18]\ _15222_ VPWR VGND sg13g2_nand2_1
X_22562_ _00669_ _14662_ _15236_ _15245_ VPWR VGND sg13g2_o21ai_1
X_22563_ _15246_ \regs.registers[9][19]\ _15222_ VPWR VGND sg13g2_nand2_1
X_22564_ _00670_ _14677_ _15236_ _15246_ VPWR VGND sg13g2_o21ai_1
X_22565_ _15247_ _15222_ VPWR VGND sg13g2_buf_1
X_22566_ _15248_ \regs.registers[9][20]\ _15222_ VPWR VGND sg13g2_nand2_1
X_22567_ _00671_ _14693_ _15247_ _15248_ VPWR VGND sg13g2_o21ai_1
X_22568_ _00672_ _14709_ \regs.registers[9][21]\ _15247_ VPWR VGND sg13g2_mux2_1
X_22569_ _15249_ \regs.registers[9][22]\ _15222_ VPWR VGND sg13g2_nand2_1
X_22570_ _00673_ _14722_ _15247_ _15249_ VPWR VGND sg13g2_o21ai_1
X_22571_ _15250_ \regs.registers[9][23]\ _15222_ VPWR VGND sg13g2_nand2_1
X_22572_ _00674_ _14735_ _15247_ _15250_ VPWR VGND sg13g2_o21ai_1
X_22573_ _00675_ _14747_ \regs.registers[9][24]\ _15247_ VPWR VGND sg13g2_mux2_1
X_22574_ _00676_ _14756_ \regs.registers[9][25]\ _15247_ VPWR VGND sg13g2_mux2_1
X_22575_ _00677_ _14765_ \regs.registers[9][26]\ _15247_ VPWR VGND sg13g2_mux2_1
X_22576_ _00678_ _14774_ \regs.registers[9][27]\ _15247_ VPWR VGND sg13g2_mux2_1
X_22577_ _00679_ _14783_ \regs.registers[9][28]\ _15247_ VPWR VGND sg13g2_mux2_1
X_22578_ _00680_ _14792_ \regs.registers[9][29]\ _15247_ VPWR VGND sg13g2_mux2_1
X_22579_ _00681_ _14801_ \regs.registers[9][30]\ _15224_ VPWR VGND sg13g2_mux2_1
X_22580_ _00682_ _14810_ \regs.registers[9][31]\ _15224_ VPWR VGND sg13g2_mux2_1
X_22581_ _15251_ _12949_ VPWR VGND sg13g2_buf_1
X_22582_ _15252_ _13209_ _13230_ VPWR VGND sg13g2_nor2_1
X_22583_ _15253_ \rd_alu[24]\ _15252_ VPWR VGND sg13g2_or2_1
X_22584_ _15254_ _15253_ VPWR VGND sg13g2_buf_1
X_22585_ _15255_ _15254_ VPWR VGND sg13g2_buf_1
X_22586_ _15256_ _13011_ _13207_ _13226_ VPWR VGND sg13g2_nor3_1
X_22587_ _15257_ _15256_ VPWR VGND sg13g2_buf_1
X_22588_ _15258_ \control_i.immediate[2]\ \rd_alu[2]\ _15257_ VPWR VGND sg13g2_mux2_1
X_22589_ _15259_ \control_i.immediate[0]\ \rd_alu[0]\ _15257_ VPWR VGND sg13g2_mux2_1
X_22590_ _15260_ _15259_ VPWR VGND sg13g2_buf_1
X_22591_ _15261_ \control_i.immediate[1]\ \rd_alu[1]\ _15257_ VPWR VGND sg13g2_mux2_1
X_22592_ _15262_ \csr_i.pc[0]\ _15260_ _15261_ VPWR VGND sg13g2_a21oi_1
X_22593_ _15263_ \csr_i.pc[0]\ _15261_ _15260_ VPWR VGND sg13g2_nand3_1
X_22594_ _15264_ _13004_ _15262_ _15263_ VPWR VGND sg13g2_o21ai_1
X_22595_ _15265_ \csr_i.pc[2]\ _15264_ VPWR VGND sg13g2_xnor2_1
X_22596_ _15266_ \rd_alu[23]\ _15265_ VPWR VGND sg13g2_nor2_1
X_22597_ _15267_ _15258_ _15266_ VPWR VGND sg13g2_xnor2_1
X_22598_ _15268_ \control_i.pcflag\ _13222_ VPWR VGND sg13g2_nand2_1
X_22599_ _15269_ _13239_ _15268_ VPWR VGND sg13g2_or2_1
X_22600_ _15270_ _15269_ VPWR VGND sg13g2_buf_1
X_22601_ _15271_ _13209_ _13230_ \rd_alu[23]\ VPWR VGND sg13g2_o21ai_1
X_22602_ _15272_ _15270_ _15271_ VPWR VGND sg13g2_and2_1
X_22603_ _15273_ _15272_ VPWR VGND sg13g2_buf_1
X_22604_ _15274_ _15273_ VPWR VGND sg13g2_buf_1
X_22605_ _15275_ _15274_ VPWR VGND sg13g2_buf_1
X_22606_ _15276_ \rd_alu[24]\ _15252_ VPWR VGND sg13g2_nor2_1
X_22607_ _15277_ _15276_ VPWR VGND sg13g2_buf_1
X_22608_ _15278_ _15277_ VPWR VGND sg13g2_buf_1
X_22609_ _15279_ \csr_i.pc[2]\ _15278_ VPWR VGND sg13g2_nor2_1
X_22610_ _15280_ \csr_i.isr_return[2]\ _15275_ _15279_ VPWR VGND sg13g2_o21ai_1
X_22611_ _15281_ _15255_ _15267_ _15280_ VPWR VGND sg13g2_o21ai_1
X_22612_ _15282_ \csr_i.isr_return[2]\ _15255_ VPWR VGND sg13g2_nand2_1
X_22613_ _15283_ _15275_ _15282_ \control_i.pcflag\ VPWR VGND sg13g2_o21ai_1
X_22614_ _15284_ \control_i.pcflag\ _15281_ _15283_ \csr_i.pc[2]\ \control_i.jump_to_isr\
+ VPWR
+ VGND sg13g2_a221oi_1
X_22615_ _15285_ \csr_i.mcause[31]\ \csr_i.mcause[0]\ VPWR VGND sg13g2_nand2_1
X_22616_ _15286_ \csr_i.mtvec[2]\ _15285_ VPWR VGND sg13g2_xor2_1
X_22617_ _15287_ \control_i.jump_to_isr\ _15286_ VPWR VGND sg13g2_and2_1
X_22618_ _00683_ _15251_ _15284_ _15287_ VPWR VGND sg13g2_nor3_1
X_22619_ _15288_ \csr_i.mcause[0]\ \csr_i.mtvec[2]\ VPWR VGND sg13g2_nand2_1
X_22620_ _15289_ \csr_i.mcause[1]\ _15288_ VPWR VGND sg13g2_xnor2_1
X_22621_ _15290_ \csr_i.mcause[31]\ _15289_ VPWR VGND sg13g2_nand2_1
X_22622_ _15291_ \csr_i.mtvec[3]\ _15290_ VPWR VGND sg13g2_xnor2_1
X_22623_ _15292_ \control_i.immediate[3]\ \rd_alu[3]\ _15257_ VPWR VGND sg13g2_mux2_1
X_22624_ _15293_ _15292_ VPWR VGND sg13g2_buf_1
X_22625_ _15294_ \rd_alu[23]\ VPWR VGND sg13g2_inv_1
X_22626_ _15295_ _15258_ _14412_ VPWR VGND sg13g2_nand2b_1
X_22627_ _15296_ \csr_i.pc[2]\ _15258_ VPWR VGND sg13g2_and2_1
X_22628_ _15297_ _15264_ _15295_ _15296_ VPWR VGND sg13g2_a21o_1
X_22629_ _15298_ _15297_ VPWR VGND sg13g2_buf_1
X_22630_ _15299_ \csr_i.pc[3]\ _15298_ VPWR VGND sg13g2_or2_1
X_22631_ _15300_ \csr_i.pc[3]\ _15298_ VPWR VGND sg13g2_nand2_1
X_22632_ _15301_ _15294_ _15299_ _15300_ VPWR VGND sg13g2_and3_1
X_22633_ _15302_ _15293_ _15301_ VPWR VGND sg13g2_xnor2_1
X_22634_ _15303_ \csr_i.isr_return[3]\ _14426_ _15274_ VPWR VGND sg13g2_mux2_1
X_22635_ _15304_ _15254_ _15303_ VPWR VGND sg13g2_nand2_1
X_22636_ _15305_ _15254_ _15302_ _15304_ VPWR VGND sg13g2_o21ai_1
X_22637_ _15306_ \control_i.pcflag\ \csr_i.pc[3]\ VPWR VGND sg13g2_nor2b_1
X_22638_ _15307_ \control_i.pcflag\ _15305_ _15306_ VPWR VGND sg13g2_a21oi_1
X_22639_ _15308_ \control_i.jump_to_isr\ _15307_ VPWR VGND sg13g2_nor2_1
X_22640_ _15309_ \control_i.jump_to_isr\ _15291_ _15308_ VPWR VGND sg13g2_a21oi_1
X_22641_ _00684_ _14318_ _15309_ VPWR VGND sg13g2_nor2_1
X_22642_ _15310_ _15277_ VPWR VGND sg13g2_buf_1
X_22643_ _15311_ _15310_ VPWR VGND sg13g2_buf_1
X_22644_ _15312_ \control_i.immediate[4]\ \rd_alu[4]\ _15257_ VPWR VGND sg13g2_mux2_1
X_22645_ _15313_ \csr_i.pc[3]\ _15298_ _15293_ VPWR VGND sg13g2_o21ai_1
X_22646_ _15314_ _15300_ _15313_ VPWR VGND sg13g2_nand2_1
X_22647_ _15315_ \csr_i.pc[4]\ _15314_ VPWR VGND sg13g2_xnor2_1
X_22648_ _15316_ \rd_alu[23]\ _15315_ VPWR VGND sg13g2_nor2_1
X_22649_ _15317_ _15312_ _15316_ VPWR VGND sg13g2_xor2_1
X_22650_ _15318_ \csr_i.isr_return[4]\ _15274_ VPWR VGND sg13g2_nor2_1
X_22651_ _15319_ _15270_ _15271_ VPWR VGND sg13g2_nand2_1
X_22652_ _15320_ _15319_ VPWR VGND sg13g2_buf_1
X_22653_ _15321_ _15320_ VPWR VGND sg13g2_buf_1
X_22654_ _15322_ _14441_ _15321_ VPWR VGND sg13g2_nor2_1
X_22655_ _15323_ _15278_ _15318_ _15322_ VPWR VGND sg13g2_nor3_1
X_22656_ _15324_ _15311_ _15317_ _15323_ VPWR VGND sg13g2_a21oi_1
X_22657_ _15325_ \csr_i.pc[4]\ \control_i.pcflag\ VPWR VGND sg13g2_nor2_1
X_22658_ _15326_ \control_i.pcflag\ _15324_ _15325_ VPWR VGND sg13g2_a21oi_1
X_22659_ _15327_ \csr_i.mcause[0]\ \csr_i.mtvec[2]\ \csr_i.mcause[1]\ VPWR VGND sg13g2_a21o_1
X_22660_ _15328_ \csr_i.mcause[1]\ \csr_i.mcause[0]\ \csr_i.mtvec[2]\ VPWR VGND sg13g2_and3_1
X_22661_ _15329_ \csr_i.mtvec[3]\ _15327_ _15328_ VPWR VGND sg13g2_a21oi_1
X_22662_ _15330_ \csr_i.mcause[2]\ _15329_ VPWR VGND sg13g2_xnor2_1
X_22663_ _15331_ \csr_i.mcause[31]\ _15330_ VPWR VGND sg13g2_nand2_1
X_22664_ _15332_ \csr_i.mtvec[4]\ _15331_ VPWR VGND sg13g2_xor2_1
X_22665_ _15333_ \control_i.jump_to_isr\ _15332_ VPWR VGND sg13g2_nand2_1
X_22666_ _15334_ \control_i.jump_to_isr\ _15326_ _15333_ VPWR VGND sg13g2_o21ai_1
X_22667_ _00685_ _14318_ _15334_ VPWR VGND sg13g2_nor2_1
X_22668_ _15335_ \csr_i.mcause[2]\ \csr_i.mtvec[4]\ \csr_i.mtvec[3]\ _15327_ _15328_
+ VPWR
+ VGND sg13g2_a221oi_1
X_22669_ _15336_ _15335_ VPWR VGND sg13g2_buf_1
X_22670_ _15337_ \csr_i.mcause[2]\ \csr_i.mtvec[4]\ VPWR VGND sg13g2_nor2_1
X_22671_ _15338_ _15336_ _15337_ VPWR VGND sg13g2_nor2_1
X_22672_ _15339_ \csr_i.mcause[3]\ _15338_ VPWR VGND sg13g2_xor2_1
X_22673_ _15340_ \csr_i.mcause[31]\ _15339_ VPWR VGND sg13g2_nand2_1
X_22674_ _15341_ \csr_i.mtvec[5]\ _15340_ VPWR VGND sg13g2_xnor2_1
X_22675_ _15342_ _15257_ VPWR VGND sg13g2_buf_1
X_22676_ _15343_ \control_i.immediate[5]\ \rd_alu[5]\ _15342_ VPWR VGND sg13g2_mux2_1
X_22677_ _15344_ \csr_i.pc[3]\ _15293_ _15298_ VPWR VGND sg13g2_a21oi_1
X_22678_ _15345_ \csr_i.pc[4]\ _15312_ VPWR VGND sg13g2_or2_1
X_22679_ _15346_ \csr_i.pc[3]\ _15293_ _15345_ VPWR VGND sg13g2_o21ai_1
X_22680_ _15347_ \csr_i.pc[4]\ _15312_ VPWR VGND sg13g2_nand2_1
X_22681_ _15348_ _15344_ _15346_ _15347_ VPWR VGND sg13g2_o21ai_1
X_22682_ _15349_ _15348_ VPWR VGND sg13g2_buf_1
X_22683_ _15350_ \csr_i.pc[5]\ _15349_ VPWR VGND sg13g2_xnor2_1
X_22684_ _15351_ \rd_alu[23]\ _15350_ VPWR VGND sg13g2_nor2_1
X_22685_ _15352_ _15343_ _15351_ VPWR VGND sg13g2_xnor2_1
X_22686_ _15353_ \csr_i.isr_return[5]\ _14456_ _15274_ VPWR VGND sg13g2_mux2_1
X_22687_ _15354_ _15254_ _15353_ VPWR VGND sg13g2_nand2_1
X_22688_ _15355_ _15254_ _15352_ _15354_ VPWR VGND sg13g2_o21ai_1
X_22689_ _15356_ \control_i.pcflag\ \csr_i.pc[5]\ VPWR VGND sg13g2_nor2b_1
X_22690_ _15357_ \control_i.pcflag\ _15355_ _15356_ VPWR VGND sg13g2_a21oi_1
X_22691_ _15358_ \control_i.jump_to_isr\ _15357_ VPWR VGND sg13g2_nor2_1
X_22692_ _15359_ \control_i.jump_to_isr\ _15341_ _15358_ VPWR VGND sg13g2_a21oi_1
X_22693_ _00686_ _14318_ _15359_ VPWR VGND sg13g2_nor2_1
X_22694_ _15360_ \csr_i.mtvec[5]\ VPWR VGND sg13g2_inv_1
X_22695_ _15361_ _15336_ _15337_ _15360_ VPWR VGND sg13g2_o21ai_1
X_22696_ _15362_ _15360_ _15336_ _15337_ VPWR VGND sg13g2_nor3_1
X_22697_ _15363_ \csr_i.mcause[3]\ _15361_ _15362_ VPWR VGND sg13g2_a21o_1
X_22698_ _15364_ _15363_ VPWR VGND sg13g2_buf_1
X_22699_ _15365_ \csr_i.mcause[4]\ _15364_ VPWR VGND sg13g2_xor2_1
X_22700_ _15366_ \csr_i.mcause[31]\ _15365_ VPWR VGND sg13g2_nand2_1
X_22701_ _15367_ \csr_i.mtvec[6]\ _15366_ VPWR VGND sg13g2_xnor2_1
X_22702_ _15368_ _15342_ \control_i.immediate[6]\ VPWR VGND sg13g2_nor2b_1
X_22703_ _15369_ \rd_alu[6]\ _15342_ _15368_ VPWR VGND sg13g2_a21oi_1
X_22704_ _15370_ _15343_ _15349_ VPWR VGND sg13g2_nand2_1
X_22705_ _15371_ _15343_ _15349_ \csr_i.pc[5]\ VPWR VGND sg13g2_o21ai_1
X_22706_ _15372_ _15370_ _15371_ VPWR VGND sg13g2_nand2_1
X_22707_ _15373_ \csr_i.pc[6]\ _15372_ VPWR VGND sg13g2_xnor2_1
X_22708_ _15374_ \rd_alu[23]\ _15373_ VPWR VGND sg13g2_nor2_1
X_22709_ _15375_ _15369_ _15374_ VPWR VGND sg13g2_xnor2_1
X_22710_ _15376_ \csr_i.isr_return[6]\ _15274_ VPWR VGND sg13g2_nor2_1
X_22711_ _15377_ _14485_ _15320_ VPWR VGND sg13g2_nor2_1
X_22712_ _15378_ _15310_ _15376_ _15377_ VPWR VGND sg13g2_nor3_1
X_22713_ _15379_ _15278_ _15375_ _15378_ VPWR VGND sg13g2_a21oi_1
X_22714_ _15380_ _13254_ _15379_ VPWR VGND sg13g2_nor2_1
X_22715_ _15381_ \csr_i.pc[6]\ _13255_ _15380_ VPWR VGND sg13g2_a21oi_1
X_22716_ _15382_ \control_i.jump_to_isr\ _15381_ VPWR VGND sg13g2_nor2_1
X_22717_ _15383_ \control_i.jump_to_isr\ _15367_ _15382_ VPWR VGND sg13g2_a21oi_1
X_22718_ _00687_ _14318_ _15383_ VPWR VGND sg13g2_nor2_1
X_22719_ _15384_ \csr_i.mtvec[6]\ _15364_ VPWR VGND sg13g2_nand2_1
X_22720_ _15385_ \csr_i.mtvec[6]\ _15364_ \csr_i.mcause[4]\ VPWR VGND sg13g2_o21ai_1
X_22721_ _15386_ _15384_ _15385_ VPWR VGND sg13g2_nand2_1
X_22722_ _15387_ \csr_i.mcause[5]\ _15386_ VPWR VGND sg13g2_xor2_1
X_22723_ _15388_ \csr_i.mcause[31]\ _15387_ VPWR VGND sg13g2_nand2_1
X_22724_ _15389_ \csr_i.mtvec[7]\ _15388_ VPWR VGND sg13g2_xnor2_1
X_22725_ _15390_ _15369_ _15370_ _15371_ VPWR VGND sg13g2_nand3_1
X_22726_ _15391_ _15370_ _15371_ _15369_ VPWR VGND sg13g2_a21oi_1
X_22727_ _15392_ \csr_i.pc[6]\ _15390_ _15391_ VPWR VGND sg13g2_a21o_1
X_22728_ _15393_ _15392_ VPWR VGND sg13g2_buf_1
X_22729_ _15394_ \csr_i.pc[7]\ _15393_ VPWR VGND sg13g2_xor2_1
X_22730_ _15395_ \control_i.immediate[7]\ \rd_alu[7]\ _15342_ VPWR VGND sg13g2_mux2_1
X_22731_ _15396_ _15395_ VPWR VGND sg13g2_buf_1
X_22732_ _15397_ _15294_ _15394_ _15396_ VPWR VGND sg13g2_a21oi_1
X_22733_ _15398_ _15294_ _15396_ _15394_ VPWR VGND sg13g2_nand3_1
X_22734_ _15399_ _15397_ _15398_ _15310_ VPWR VGND sg13g2_nand3b_1
X_22735_ _15400_ \csr_i.isr_return[7]\ _14501_ _15274_ VPWR VGND sg13g2_mux2_1
X_22736_ _15401_ _15254_ _15400_ VPWR VGND sg13g2_nand2_1
X_22737_ _15402_ _15399_ _15401_ _13254_ VPWR VGND sg13g2_a21oi_1
X_22738_ _15403_ \csr_i.pc[7]\ _13255_ _15402_ VPWR VGND sg13g2_a21oi_1
X_22739_ _15404_ \control_i.jump_to_isr\ _15403_ VPWR VGND sg13g2_nor2_1
X_22740_ _15405_ \control_i.jump_to_isr\ _15389_ _15404_ VPWR VGND sg13g2_a21oi_1
X_22741_ _00688_ _14318_ _15405_ VPWR VGND sg13g2_nor2_1
X_22742_ _15406_ \csr_i.mtvec[7]\ VPWR VGND sg13g2_inv_1
X_22743_ _15407_ _15406_ _15384_ _15385_ VPWR VGND sg13g2_nand3_1
X_22744_ _15408_ _15384_ _15385_ _15406_ VPWR VGND sg13g2_a21oi_1
X_22745_ _15409_ \csr_i.mcause[5]\ _15407_ _15408_ VPWR VGND sg13g2_a21o_1
X_22746_ _15410_ _15409_ VPWR VGND sg13g2_buf_1
X_22747_ _15411_ \csr_i.mcause[6]\ _15410_ VPWR VGND sg13g2_xor2_1
X_22748_ _15412_ \csr_i.mcause[31]\ _15411_ VPWR VGND sg13g2_nand2_1
X_22749_ _15413_ \csr_i.mtvec[8]\ _15412_ VPWR VGND sg13g2_xnor2_1
X_22750_ _15414_ _15342_ \control_i.immediate[8]\ VPWR VGND sg13g2_nor2b_1
X_22751_ _15415_ \rd_alu[8]\ _15342_ _15414_ VPWR VGND sg13g2_a21oi_1
X_22752_ _15416_ _15396_ _15393_ VPWR VGND sg13g2_nand2_1
X_22753_ _15417_ _15396_ _15393_ \csr_i.pc[7]\ VPWR VGND sg13g2_o21ai_1
X_22754_ _15418_ _15416_ _15417_ VPWR VGND sg13g2_nand2_1
X_22755_ _15419_ \csr_i.pc[8]\ _15418_ VPWR VGND sg13g2_xnor2_1
X_22756_ _15420_ \rd_alu[23]\ _15419_ VPWR VGND sg13g2_nor2_1
X_22757_ _15421_ _15415_ _15420_ VPWR VGND sg13g2_xnor2_1
X_22758_ _15422_ \csr_i.isr_return[8]\ _15274_ VPWR VGND sg13g2_nor2_1
X_22759_ _15423_ _14516_ _15320_ VPWR VGND sg13g2_nor2_1
X_22760_ _15424_ _15310_ _15422_ _15423_ VPWR VGND sg13g2_nor3_1
X_22761_ _15425_ _15278_ _15421_ _15424_ VPWR VGND sg13g2_a21oi_1
X_22762_ _15426_ _13254_ _15425_ VPWR VGND sg13g2_nor2_1
X_22763_ _15427_ \csr_i.pc[8]\ _13255_ _15426_ VPWR VGND sg13g2_a21oi_1
X_22764_ _15428_ \control_i.jump_to_isr\ _15427_ VPWR VGND sg13g2_nor2_1
X_22765_ _15429_ \control_i.jump_to_isr\ _15413_ _15428_ VPWR VGND sg13g2_a21oi_1
X_22766_ _00689_ _14318_ _15429_ VPWR VGND sg13g2_nor2_1
X_22767_ _15430_ \csr_i.mtvec[8]\ _15410_ VPWR VGND sg13g2_nand2_1
X_22768_ _15431_ \csr_i.mtvec[8]\ _15410_ \csr_i.mcause[6]\ VPWR VGND sg13g2_o21ai_1
X_22769_ _15432_ _15430_ _15431_ VPWR VGND sg13g2_nand2_1
X_22770_ _15433_ \csr_i.mcause[7]\ _15432_ VPWR VGND sg13g2_xor2_1
X_22771_ _15434_ \csr_i.mcause[31]\ _15433_ VPWR VGND sg13g2_nand2_1
X_22772_ _15435_ \csr_i.mtvec[9]\ _15434_ VPWR VGND sg13g2_xnor2_1
X_22773_ _15436_ _15342_ \control_i.immediate[9]\ VPWR VGND sg13g2_nor2b_1
X_22774_ _15437_ \rd_alu[9]\ _15342_ _15436_ VPWR VGND sg13g2_a21oi_1
X_22775_ _15438_ _15437_ VPWR VGND sg13g2_buf_1
X_22776_ _15439_ _15415_ _15416_ _15417_ VPWR VGND sg13g2_nand3_1
X_22777_ _15440_ _15439_ VPWR VGND sg13g2_buf_1
X_22778_ _15441_ _15416_ _15417_ _15415_ VPWR VGND sg13g2_a21oi_1
X_22779_ _15442_ \csr_i.pc[8]\ _15440_ _15441_ VPWR VGND sg13g2_a21oi_1
X_22780_ _15443_ \csr_i.pc[9]\ _15442_ VPWR VGND sg13g2_xor2_1
X_22781_ _15444_ \rd_alu[23]\ _15443_ VPWR VGND sg13g2_nor2_1
X_22782_ _15445_ _15438_ _15444_ VPWR VGND sg13g2_xnor2_1
X_22783_ _15446_ \csr_i.isr_return[9]\ _15274_ VPWR VGND sg13g2_nor2_1
X_22784_ _15447_ _14529_ _15320_ VPWR VGND sg13g2_nor2_1
X_22785_ _15448_ _15310_ _15446_ _15447_ VPWR VGND sg13g2_nor3_1
X_22786_ _15449_ _15278_ _15445_ _15448_ VPWR VGND sg13g2_a21oi_1
X_22787_ _15450_ _13254_ _15449_ VPWR VGND sg13g2_nor2_1
X_22788_ _15451_ \csr_i.pc[9]\ _13255_ _15450_ VPWR VGND sg13g2_a21oi_1
X_22789_ _15452_ \control_i.jump_to_isr\ _15451_ VPWR VGND sg13g2_nor2_1
X_22790_ _15453_ \control_i.jump_to_isr\ _15435_ _15452_ VPWR VGND sg13g2_a21oi_1
X_22791_ _00690_ _14318_ _15453_ VPWR VGND sg13g2_nor2_1
X_22792_ _15454_ \csr_i.mtvec[9]\ VPWR VGND sg13g2_inv_1
X_22793_ _15455_ _15454_ _15430_ _15431_ VPWR VGND sg13g2_nand3_1
X_22794_ _15456_ _15430_ _15431_ _15454_ VPWR VGND sg13g2_a21oi_1
X_22795_ _15457_ \csr_i.mcause[7]\ _15455_ _15456_ VPWR VGND sg13g2_a21o_1
X_22796_ _15458_ _15457_ VPWR VGND sg13g2_buf_1
X_22797_ _15459_ \csr_i.mcause[8]\ _15458_ VPWR VGND sg13g2_xor2_1
X_22798_ _15460_ \csr_i.mcause[31]\ _15459_ VPWR VGND sg13g2_nand2_1
X_22799_ _15461_ \csr_i.mtvec[10]\ _15460_ VPWR VGND sg13g2_xnor2_1
X_22800_ _15462_ \control_i.immediate[10]\ \rd_alu[10]\ _15342_ VPWR VGND sg13g2_mux2_1
X_22801_ _15463_ _15462_ VPWR VGND sg13g2_inv_1
X_22802_ _15464_ _15438_ _15442_ VPWR VGND sg13g2_nor2_1
X_22803_ _15465_ _15438_ _15442_ VPWR VGND sg13g2_nand2_1
X_22804_ _15466_ \csr_i.pc[9]\ _15464_ _15465_ VPWR VGND sg13g2_o21ai_1
X_22805_ _15467_ _14557_ _15466_ VPWR VGND sg13g2_xnor2_1
X_22806_ _15468_ \rd_alu[23]\ _15467_ VPWR VGND sg13g2_nor2_1
X_22807_ _15469_ _15463_ _15468_ VPWR VGND sg13g2_xnor2_1
X_22808_ _15470_ \csr_i.isr_return[10]\ _15273_ VPWR VGND sg13g2_nor2_1
X_22809_ _15471_ _14545_ _15320_ VPWR VGND sg13g2_nor2_1
X_22810_ _15472_ _15277_ _15470_ _15471_ VPWR VGND sg13g2_nor3_1
X_22811_ _15473_ _15278_ _15469_ _15472_ VPWR VGND sg13g2_a21oi_1
X_22812_ _15474_ _13254_ _15473_ VPWR VGND sg13g2_nor2_1
X_22813_ _15475_ \csr_i.pc[10]\ _13255_ _15474_ VPWR VGND sg13g2_a21oi_1
X_22814_ _15476_ \control_i.jump_to_isr\ _15475_ VPWR VGND sg13g2_nor2_1
X_22815_ _15477_ \control_i.jump_to_isr\ _15461_ _15476_ VPWR VGND sg13g2_a21oi_1
X_22816_ _00691_ _14318_ _15477_ VPWR VGND sg13g2_nor2_1
X_22817_ _15478_ _13307_ VPWR VGND sg13g2_buf_1
X_22818_ _15479_ \csr_i.mtvec[10]\ _15458_ VPWR VGND sg13g2_nand2_1
X_22819_ _15480_ \csr_i.mtvec[10]\ _15458_ \csr_i.mcause[8]\ VPWR VGND sg13g2_o21ai_1
X_22820_ _15481_ _15479_ _15480_ VPWR VGND sg13g2_nand2_1
X_22821_ _15482_ \csr_i.mcause[9]\ _15481_ VPWR VGND sg13g2_xor2_1
X_22822_ _15483_ \csr_i.mcause[31]\ _15482_ VPWR VGND sg13g2_nand2_1
X_22823_ _15484_ \csr_i.mtvec[11]\ _15483_ VPWR VGND sg13g2_xnor2_1
X_22824_ _15485_ _15342_ VPWR VGND sg13g2_buf_1
X_22825_ _15486_ \control_i.immediate[11]\ \rd_alu[11]\ _15485_ VPWR VGND sg13g2_mux2_1
X_22826_ _15487_ _15486_ VPWR VGND sg13g2_buf_1
X_22827_ _15488_ _15438_ _15463_ VPWR VGND sg13g2_nand2_1
X_22828_ _15489_ \csr_i.pc[9]\ _15462_ VPWR VGND sg13g2_or2_1
X_22829_ _15490_ \csr_i.pc[8]\ _15440_ _15488_ _15489_ _15441_
+ VPWR
+ VGND sg13g2_a221oi_1
X_22830_ _15491_ _14557_ _15438_ VPWR VGND sg13g2_nand2_1
X_22831_ _15492_ \csr_i.pc[8]\ _15440_ _15491_ _12983_ _15441_
+ VPWR
+ VGND sg13g2_a221oi_1
X_22832_ _15493_ \csr_i.pc[10]\ \csr_i.pc[9]\ VPWR VGND sg13g2_nor2_1
X_22833_ _15494_ _15493_ _15438_ _15463_ _14557_ VPWR
+ VGND
+ sg13g2_a22oi_1
X_22834_ _15495_ \csr_i.pc[9]\ _15488_ _15494_ VPWR VGND sg13g2_o21ai_1
X_22835_ _15496_ _15490_ _15492_ _15495_ VPWR VGND sg13g2_or3_1
X_22836_ _15497_ \csr_i.pc[11]\ _15496_ VPWR VGND sg13g2_xnor2_1
X_22837_ _15498_ _15294_ _15497_ VPWR VGND sg13g2_nand2_1
X_22838_ _15499_ _15487_ _15498_ VPWR VGND sg13g2_xnor2_1
X_22839_ _15500_ \csr_i.isr_return[11]\ _15273_ VPWR VGND sg13g2_nor2_1
X_22840_ _15501_ _14559_ _15320_ VPWR VGND sg13g2_nor2_1
X_22841_ _15502_ _15277_ _15500_ _15501_ VPWR VGND sg13g2_nor3_1
X_22842_ _15503_ _15310_ _15499_ _15502_ VPWR VGND sg13g2_a21oi_1
X_22843_ _15504_ _13254_ _15503_ VPWR VGND sg13g2_nor2_1
X_22844_ _15505_ \csr_i.pc[11]\ _13255_ _15504_ VPWR VGND sg13g2_a21oi_1
X_22845_ _15506_ \control_i.jump_to_isr\ _15505_ VPWR VGND sg13g2_nor2_1
X_22846_ _15507_ \control_i.jump_to_isr\ _15484_ _15506_ VPWR VGND sg13g2_a21oi_1
X_22847_ _00692_ _15478_ _15507_ VPWR VGND sg13g2_nor2_1
X_22848_ _15508_ \csr_i.mtvec[11]\ VPWR VGND sg13g2_inv_1
X_22849_ _15509_ _15508_ _15479_ _15480_ VPWR VGND sg13g2_nand3_1
X_22850_ _15510_ _15479_ _15480_ _15508_ VPWR VGND sg13g2_a21oi_1
X_22851_ _15511_ \csr_i.mcause[9]\ _15509_ _15510_ VPWR VGND sg13g2_a21oi_1
X_22852_ _15512_ \csr_i.mcause[10]\ _15511_ VPWR VGND sg13g2_xnor2_1
X_22853_ _15513_ \csr_i.mcause[31]\ _15512_ VPWR VGND sg13g2_nand2_1
X_22854_ _15514_ \csr_i.mtvec[12]\ _15513_ VPWR VGND sg13g2_xnor2_1
X_22855_ _15515_ \control_i.immediate[12]\ \rd_alu[12]\ _15485_ VPWR VGND sg13g2_mux2_1
X_22856_ _15516_ \csr_i.pc[11]\ _15487_ VPWR VGND sg13g2_nor2_1
X_22857_ _15517_ _15490_ _15492_ _15495_ _15516_ VPWR
+ VGND
+ sg13g2_nor4_1
X_22858_ _15518_ \csr_i.pc[11]\ _15487_ _15517_ VPWR VGND sg13g2_a21o_1
X_22859_ _15519_ \csr_i.pc[12]\ _15518_ VPWR VGND sg13g2_xnor2_1
X_22860_ _15520_ \rd_alu[23]\ _15519_ VPWR VGND sg13g2_nor2_1
X_22861_ _15521_ _15515_ _15520_ VPWR VGND sg13g2_xor2_1
X_22862_ _15522_ \csr_i.isr_return[12]\ _15273_ VPWR VGND sg13g2_nor2_1
X_22863_ _15523_ _14572_ _15320_ VPWR VGND sg13g2_nor2_1
X_22864_ _15524_ _15277_ _15522_ _15523_ VPWR VGND sg13g2_nor3_1
X_22865_ _15525_ _15310_ _15521_ _15524_ VPWR VGND sg13g2_a21oi_1
X_22866_ _15526_ _13254_ _15525_ VPWR VGND sg13g2_nor2_1
X_22867_ _15527_ \csr_i.pc[12]\ _13255_ _15526_ VPWR VGND sg13g2_a21oi_1
X_22868_ _15528_ \control_i.jump_to_isr\ _15527_ VPWR VGND sg13g2_nor2_1
X_22869_ _15529_ \control_i.jump_to_isr\ _15514_ _15528_ VPWR VGND sg13g2_a21oi_1
X_22870_ _00693_ _15478_ _15529_ VPWR VGND sg13g2_nor2_1
X_22871_ _15530_ \csr_i.mtvec[12]\ VPWR VGND sg13g2_inv_1
X_22872_ _15531_ _15530_ _15511_ VPWR VGND sg13g2_nand2_1
X_22873_ _15532_ _15530_ _15511_ VPWR VGND sg13g2_nor2_1
X_22874_ _15533_ \csr_i.mcause[10]\ _15531_ _15532_ VPWR VGND sg13g2_a21o_1
X_22875_ _15534_ \csr_i.mcause[11]\ _15533_ VPWR VGND sg13g2_xor2_1
X_22876_ _15535_ \csr_i.mcause[31]\ _15534_ VPWR VGND sg13g2_nand2_1
X_22877_ _15536_ \csr_i.mtvec[13]\ _15535_ VPWR VGND sg13g2_xnor2_1
X_22878_ _15537_ \control_i.jump_to_isr\ _15536_ VPWR VGND sg13g2_nand2_1
X_22879_ _15538_ _15485_ \control_i.immediate[13]\ VPWR VGND sg13g2_nor2b_1
X_22880_ _15539_ \rd_alu[13]\ _15485_ _15538_ VPWR VGND sg13g2_a21oi_1
X_22881_ _15540_ \csr_i.pc[11]\ _15487_ _15515_ \csr_i.pc[12]\ _15517_
+ VPWR
+ VGND sg13g2_a221oi_1
X_22882_ _15541_ _15540_ VPWR VGND sg13g2_buf_1
X_22883_ _15542_ \csr_i.pc[12]\ _15515_ VPWR VGND sg13g2_nor2_1
X_22884_ _15543_ _15541_ _15542_ VPWR VGND sg13g2_nor2_1
X_22885_ _15544_ \csr_i.pc[13]\ _15543_ VPWR VGND sg13g2_xnor2_1
X_22886_ _15545_ \rd_alu[23]\ _15544_ VPWR VGND sg13g2_nor2_1
X_22887_ _15546_ _15539_ _15545_ VPWR VGND sg13g2_xnor2_1
X_22888_ _15547_ \csr_i.isr_return[13]\ _15275_ VPWR VGND sg13g2_nor2_1
X_22889_ _15548_ _14585_ _15321_ VPWR VGND sg13g2_nor2_1
X_22890_ _15549_ _15278_ _15547_ _15548_ VPWR VGND sg13g2_nor3_1
X_22891_ _15550_ _15311_ _15546_ _15549_ VPWR VGND sg13g2_a21oi_1
X_22892_ _15551_ \csr_i.pc[13]\ \control_i.pcflag\ VPWR VGND sg13g2_nor2_1
X_22893_ _15552_ \control_i.pcflag\ _15550_ _15551_ VPWR VGND sg13g2_a21oi_1
X_22894_ _15553_ \control_i.jump_to_isr\ _15552_ VPWR VGND sg13g2_nand2b_1
X_22895_ _00694_ _15537_ _15553_ _13305_ VPWR VGND sg13g2_a21oi_1
X_22896_ _15554_ \control_i.immediate[14]\ \rd_alu[14]\ _15485_ VPWR VGND sg13g2_mux2_1
X_22897_ _15555_ _15554_ VPWR VGND sg13g2_buf_1
X_22898_ _15556_ _15541_ _15542_ _15539_ VPWR VGND sg13g2_o21ai_1
X_22899_ _15557_ _15539_ _15541_ _15542_ VPWR VGND sg13g2_nor3_1
X_22900_ _15558_ \csr_i.pc[13]\ _15556_ _15557_ VPWR VGND sg13g2_a21oi_1
X_22901_ _15559_ \csr_i.pc[14]\ _15558_ VPWR VGND sg13g2_xnor2_1
X_22902_ _15560_ _15294_ _15559_ VPWR VGND sg13g2_nand2_1
X_22903_ _15561_ _15555_ _15560_ VPWR VGND sg13g2_xnor2_1
X_22904_ _15562_ \csr_i.isr_return[14]\ _15274_ VPWR VGND sg13g2_nor2_1
X_22905_ _15563_ _14601_ _15321_ VPWR VGND sg13g2_nor2_1
X_22906_ _15564_ _15310_ _15562_ _15563_ VPWR VGND sg13g2_nor3_1
X_22907_ _15565_ _15311_ _15561_ _15564_ VPWR VGND sg13g2_a21oi_1
X_22908_ _15566_ \csr_i.pc[14]\ \control_i.pcflag\ VPWR VGND sg13g2_nor2_1
X_22909_ _15567_ \control_i.pcflag\ _15565_ _15566_ VPWR VGND sg13g2_a21oi_1
X_22910_ _15568_ \csr_i.mcause[11]\ \csr_i.mtvec[13]\ VPWR VGND sg13g2_or2_1
X_22911_ _15569_ \csr_i.mcause[11]\ \csr_i.mtvec[13]\ VPWR VGND sg13g2_and2_1
X_22912_ _15570_ _15533_ _15568_ _15569_ VPWR VGND sg13g2_a21oi_1
X_22913_ _15571_ \csr_i.mcause[12]\ _15570_ VPWR VGND sg13g2_xnor2_1
X_22914_ _15572_ \csr_i.mcause[31]\ _15571_ VPWR VGND sg13g2_nand2_1
X_22915_ _15573_ \csr_i.mtvec[14]\ _15572_ VPWR VGND sg13g2_xnor2_1
X_22916_ _15574_ _15567_ _15573_ \control_i.jump_to_isr\ VPWR VGND sg13g2_mux2_1
X_22917_ _00695_ reset _15574_ VPWR VGND sg13g2_and2_1
X_22918_ _15575_ \control_i.immediate[15]\ \rd_alu[15]\ _15485_ VPWR VGND sg13g2_mux2_1
X_22919_ _15576_ \csr_i.pc[14]\ _15555_ VPWR VGND sg13g2_nor2_1
X_22920_ _15577_ \csr_i.pc[14]\ _15555_ _15556_ \csr_i.pc[13]\ _15557_
+ VPWR
+ VGND sg13g2_a221oi_1
X_22921_ _15578_ _15576_ _15577_ VPWR VGND sg13g2_nor2_1
X_22922_ _15579_ \csr_i.pc[15]\ _15578_ VPWR VGND sg13g2_xnor2_1
X_22923_ _15580_ \rd_alu[23]\ _15579_ VPWR VGND sg13g2_nor2_1
X_22924_ _15581_ _15575_ _15580_ VPWR VGND sg13g2_xor2_1
X_22925_ _15582_ \csr_i.isr_return[15]\ _15274_ VPWR VGND sg13g2_nor2_1
X_22926_ _15583_ _14616_ _15320_ VPWR VGND sg13g2_nor2_1
X_22927_ _15584_ _15310_ _15582_ _15583_ VPWR VGND sg13g2_nor3_1
X_22928_ _15585_ _15278_ _15581_ _15584_ VPWR VGND sg13g2_a21oi_1
X_22929_ _15586_ _13254_ _15585_ VPWR VGND sg13g2_nor2_1
X_22930_ _15587_ \csr_i.pc[15]\ _13255_ _15586_ VPWR VGND sg13g2_a21oi_1
X_22931_ _15588_ \csr_i.mcause[11]\ \csr_i.mtvec[13]\ _15531_ \csr_i.mcause[10]\ _15532_
+ VPWR
+ VGND sg13g2_a221oi_1
X_22932_ _15589_ \csr_i.mcause[12]\ \csr_i.mtvec[14]\ _15568_ VPWR VGND sg13g2_o21ai_1
X_22933_ _15590_ \csr_i.mcause[12]\ \csr_i.mtvec[14]\ VPWR VGND sg13g2_nand2_1
X_22934_ _15591_ _15588_ _15589_ _15590_ VPWR VGND sg13g2_o21ai_1
X_22935_ _15592_ \csr_i.mcause[13]\ _15591_ VPWR VGND sg13g2_xor2_1
X_22936_ _15593_ \csr_i.mcause[31]\ _15592_ VPWR VGND sg13g2_nand2_1
X_22937_ _15594_ \csr_i.mtvec[15]\ _15593_ VPWR VGND sg13g2_xor2_1
X_22938_ _15595_ _15587_ _15594_ \control_i.jump_to_isr\ VPWR VGND sg13g2_mux2_1
X_22939_ _00696_ _15478_ _15595_ VPWR VGND sg13g2_nor2_1
X_22940_ _15596_ \csr_i.mcause[13]\ \csr_i.mtvec[15]\ VPWR VGND sg13g2_or2_1
X_22941_ _15597_ \csr_i.mcause[13]\ \csr_i.mtvec[15]\ VPWR VGND sg13g2_and2_1
X_22942_ _15598_ _15591_ _15596_ _15597_ VPWR VGND sg13g2_a21oi_1
X_22943_ _15599_ \csr_i.mcause[14]\ _15598_ VPWR VGND sg13g2_nor2_1
X_22944_ _15600_ \csr_i.mcause[14]\ _15598_ VPWR VGND sg13g2_and2_1
X_22945_ _15601_ _15599_ _15600_ \csr_i.mcause[31]\ VPWR VGND sg13g2_o21ai_1
X_22946_ _15602_ \csr_i.mtvec[16]\ _15601_ VPWR VGND sg13g2_xnor2_1
X_22947_ _15603_ \control_i.jump_to_isr\ _15602_ VPWR VGND sg13g2_nand2_1
X_22948_ _15604_ _15485_ \control_i.immediate[16]\ VPWR VGND sg13g2_nor2b_1
X_22949_ _15605_ \rd_alu[16]\ _15485_ _15604_ VPWR VGND sg13g2_a21oi_1
X_22950_ _15606_ \csr_i.pc[15]\ _15575_ VPWR VGND sg13g2_nor2_1
X_22951_ _15607_ \csr_i.pc[15]\ _15575_ VPWR VGND sg13g2_nand2_1
X_22952_ _15608_ _15555_ _15607_ VPWR VGND sg13g2_nand2b_1
X_22953_ _15609_ \csr_i.pc[14]\ _15607_ VPWR VGND sg13g2_nand2b_1
X_22954_ _15610_ \csr_i.pc[13]\ _15556_ _15608_ _15609_ _15557_
+ VPWR
+ VGND sg13g2_a221oi_1
X_22955_ _15611_ _15576_ _15607_ VPWR VGND sg13g2_and2_1
X_22956_ _15612_ _15606_ _15610_ _15611_ VPWR VGND sg13g2_or3_1
X_22957_ _15613_ _14643_ _15612_ VPWR VGND sg13g2_xnor2_1
X_22958_ _15614_ \rd_alu[23]\ _15613_ VPWR VGND sg13g2_nor2_1
X_22959_ _15615_ _15605_ _15614_ VPWR VGND sg13g2_xnor2_1
X_22960_ _15616_ \csr_i.isr_return[16]\ _15275_ VPWR VGND sg13g2_nor2_1
X_22961_ _15617_ _14631_ _15321_ VPWR VGND sg13g2_nor2_1
X_22962_ _15618_ _15278_ _15616_ _15617_ VPWR VGND sg13g2_nor3_1
X_22963_ _15619_ _15311_ _15615_ _15618_ VPWR VGND sg13g2_a21oi_1
X_22964_ _15620_ \csr_i.pc[16]\ \control_i.pcflag\ VPWR VGND sg13g2_nor2_1
X_22965_ _15621_ \control_i.pcflag\ _15619_ _15620_ VPWR VGND sg13g2_a21oi_1
X_22966_ _15622_ \control_i.jump_to_isr\ _15621_ VPWR VGND sg13g2_nand2b_1
X_22967_ _00697_ _15603_ _15622_ _13305_ VPWR VGND sg13g2_a21oi_1
X_22968_ _15623_ \csr_i.mtvec[17]\ VPWR VGND sg13g2_inv_1
X_22969_ _15624_ \csr_i.mcause[14]\ \csr_i.mtvec[16]\ VPWR VGND sg13g2_nor2_1
X_22970_ _15625_ \csr_i.mcause[14]\ \csr_i.mtvec[16]\ _15591_ _15596_ _15597_
+ VPWR
+ VGND sg13g2_a221oi_1
X_22971_ _15626_ _15625_ VPWR VGND sg13g2_buf_1
X_22972_ _15627_ _15624_ _15626_ VPWR VGND sg13g2_nor2_1
X_22973_ _15628_ \csr_i.mcause[15]\ _15627_ VPWR VGND sg13g2_xnor2_1
X_22974_ _15629_ _15628_ \csr_i.mcause[31]\ VPWR VGND sg13g2_nor2b_1
X_22975_ _15630_ _15623_ _15629_ VPWR VGND sg13g2_xnor2_1
X_22976_ _15631_ \control_i.jump_to_isr\ _15630_ VPWR VGND sg13g2_nand2_1
X_22977_ _15632_ _15485_ VPWR VGND sg13g2_buf_1
X_22978_ _15633_ \control_i.immediate[17]\ \rd_alu[17]\ _15632_ VPWR VGND sg13g2_mux2_1
X_22979_ _15634_ _15633_ VPWR VGND sg13g2_buf_1
X_22980_ _15635_ _15605_ _15607_ VPWR VGND sg13g2_and2_1
X_22981_ _15636_ _15576_ _15577_ _15635_ VPWR VGND sg13g2_o21ai_1
X_22982_ _15637_ _15605_ _15606_ _14643_ VPWR VGND sg13g2_a21oi_1
X_22983_ _15638_ _15605_ _15606_ _15610_ _15611_ VPWR
+ VGND
+ sg13g2_nor4_1
X_22984_ _15639_ _15636_ _15637_ _15638_ VPWR VGND sg13g2_a21o_1
X_22985_ _15640_ _15639_ VPWR VGND sg13g2_buf_1
X_22986_ _15641_ \csr_i.pc[17]\ _15640_ VPWR VGND sg13g2_or2_1
X_22987_ _15642_ \csr_i.pc[17]\ _15640_ VPWR VGND sg13g2_nand2_1
X_22988_ _15643_ _15294_ _15641_ _15642_ VPWR VGND sg13g2_and3_1
X_22989_ _15644_ _15634_ _15643_ VPWR VGND sg13g2_xor2_1
X_22990_ _15645_ _14645_ _15321_ VPWR VGND sg13g2_nor2_1
X_22991_ _15646_ \csr_i.isr_return[17]\ _15321_ _15645_ VPWR VGND sg13g2_a21oi_1
X_22992_ _15647_ _15278_ _15646_ VPWR VGND sg13g2_nor2_1
X_22993_ _15648_ _15311_ _15644_ _15647_ VPWR VGND sg13g2_a21oi_1
X_22994_ _15649_ \csr_i.pc[17]\ \control_i.pcflag\ VPWR VGND sg13g2_nor2_1
X_22995_ _15650_ \control_i.pcflag\ _15648_ _15649_ VPWR VGND sg13g2_a21oi_1
X_22996_ _15651_ \control_i.jump_to_isr\ _15650_ VPWR VGND sg13g2_nand2b_1
X_22997_ _00698_ _15631_ _15651_ _13305_ VPWR VGND sg13g2_a21oi_1
X_22998_ _15652_ _15624_ _15626_ _15623_ VPWR VGND sg13g2_o21ai_1
X_22999_ _15653_ _15623_ _15624_ _15626_ VPWR VGND sg13g2_nor3_1
X_23000_ _15654_ \csr_i.mcause[15]\ _15652_ _15653_ VPWR VGND sg13g2_a21oi_1
X_23001_ _15655_ \csr_i.mcause[16]\ _15654_ VPWR VGND sg13g2_xnor2_1
X_23002_ _15656_ \csr_i.mcause[31]\ _15655_ VPWR VGND sg13g2_nand2_1
X_23003_ _15657_ \csr_i.mtvec[18]\ _15656_ VPWR VGND sg13g2_xnor2_1
X_23004_ _15658_ \csr_i.pc[17]\ _15640_ _15634_ VPWR VGND sg13g2_o21ai_1
X_23005_ _15659_ _15642_ _15658_ VPWR VGND sg13g2_nand2_1
X_23006_ _15660_ \csr_i.pc[18]\ _15659_ VPWR VGND sg13g2_xnor2_1
X_23007_ _15661_ \rd_alu[23]\ _15660_ VPWR VGND sg13g2_nor2_1
X_23008_ _15662_ \control_i.immediate[18]\ \rd_alu[18]\ _15485_ VPWR VGND sg13g2_mux2_1
X_23009_ _15663_ _15661_ _15662_ VPWR VGND sg13g2_xnor2_1
X_23010_ _15664_ \csr_i.isr_return[18]\ _14660_ _15275_ VPWR VGND sg13g2_mux2_1
X_23011_ _15665_ _15255_ _15664_ VPWR VGND sg13g2_nand2_1
X_23012_ _15666_ _15255_ _15663_ _15665_ VPWR VGND sg13g2_o21ai_1
X_23013_ _15667_ _13254_ \control_i.jump_to_isr\ VPWR VGND sg13g2_nor2_1
X_23014_ _15668_ \csr_i.pc[18]\ VPWR VGND sg13g2_inv_1
X_23015_ _15669_ _15668_ \control_i.pcflag\ \control_i.jump_to_isr\ VPWR VGND sg13g2_nor3_1
X_23016_ _15670_ \control_i.jump_to_isr\ _15657_ _15666_ _15667_ _15669_
+ VPWR
+ VGND sg13g2_a221oi_1
X_23017_ _00699_ _15478_ _15670_ VPWR VGND sg13g2_nor2_1
X_23018_ _15671_ \csr_i.mcause[16]\ \csr_i.mtvec[18]\ VPWR VGND sg13g2_nand2_1
X_23019_ _15672_ \csr_i.mcause[16]\ \csr_i.mtvec[18]\ VPWR VGND sg13g2_nor2_1
X_23020_ _15673_ _15654_ _15671_ _15672_ VPWR VGND sg13g2_a21oi_1
X_23021_ _15674_ \csr_i.mcause[17]\ _15673_ VPWR VGND sg13g2_xor2_1
X_23022_ _15675_ \csr_i.mcause[31]\ _15674_ VPWR VGND sg13g2_nand2_1
X_23023_ _15676_ \csr_i.mtvec[19]\ _15675_ VPWR VGND sg13g2_xnor2_1
X_23024_ _15677_ _15662_ _15668_ VPWR VGND sg13g2_nand2b_1
X_23025_ _15678_ _15634_ _15677_ VPWR VGND sg13g2_and2_1
X_23026_ _15679_ \csr_i.pc[17]\ _15677_ VPWR VGND sg13g2_and2_1
X_23027_ _15680_ _15678_ _15679_ _15640_ VPWR VGND sg13g2_o21ai_1
X_23028_ _15681_ \csr_i.pc[17]\ _15634_ _15677_ VPWR VGND sg13g2_and3_1
X_23029_ _15682_ \csr_i.pc[18]\ _15662_ _15681_ VPWR VGND sg13g2_a21oi_1
X_23030_ _15683_ _15680_ _15682_ VPWR VGND sg13g2_nand2_1
X_23031_ _15684_ _14687_ _15683_ VPWR VGND sg13g2_xnor2_1
X_23032_ _15685_ _15294_ _15684_ VPWR VGND sg13g2_nand2_1
X_23033_ _15686_ _15632_ \control_i.immediate[19]\ VPWR VGND sg13g2_nor2b_1
X_23034_ _15687_ \rd_alu[19]\ _15632_ _15686_ VPWR VGND sg13g2_a21oi_1
X_23035_ _15688_ _15685_ _15687_ VPWR VGND sg13g2_xnor2_1
X_23036_ _15689_ \csr_i.isr_return[19]\ _14673_ _15275_ VPWR VGND sg13g2_mux2_1
X_23037_ _15690_ _15255_ _15689_ VPWR VGND sg13g2_nand2_1
X_23038_ _15691_ _15255_ _15688_ _15690_ VPWR VGND sg13g2_o21ai_1
X_23039_ _15692_ _14687_ \control_i.pcflag\ \control_i.jump_to_isr\ VPWR VGND sg13g2_nor3_1
X_23040_ _15693_ \control_i.jump_to_isr\ _15676_ _15691_ _15667_ _15692_
+ VPWR
+ VGND sg13g2_a221oi_1
X_23041_ _00700_ _15478_ _15693_ VPWR VGND sg13g2_nor2_1
X_23042_ _15694_ _15680_ _15682_ _15687_ VPWR VGND sg13g2_nand3_1
X_23043_ _15695_ _15680_ _15682_ _15687_ VPWR VGND sg13g2_a21oi_1
X_23044_ _15696_ \csr_i.pc[19]\ _15694_ _15695_ VPWR VGND sg13g2_a21oi_1
X_23045_ _15697_ \csr_i.pc[20]\ _15696_ VPWR VGND sg13g2_xor2_1
X_23046_ _15698_ \rd_alu[23]\ _15697_ VPWR VGND sg13g2_nor2_1
X_23047_ _15699_ \control_i.immediate[20]\ \rd_alu[20]\ _15632_ VPWR VGND sg13g2_mux2_1
X_23048_ _15700_ _15698_ _15699_ VPWR VGND sg13g2_xor2_1
X_23049_ _15701_ \csr_i.isr_return[20]\ _15321_ VPWR VGND sg13g2_and2_1
X_23050_ _15702_ _14689_ _15275_ _15701_ VPWR VGND sg13g2_a21oi_1
X_23051_ _15703_ _15311_ _15702_ _15667_ VPWR VGND sg13g2_o21ai_1
X_23052_ _15704_ _15311_ _15700_ _15703_ VPWR VGND sg13g2_a21oi_1
X_23053_ _15705_ \csr_i.mcause[17]\ \csr_i.mtvec[19]\ VPWR VGND sg13g2_and2_1
X_23054_ _15706_ \csr_i.mcause[17]\ \csr_i.mtvec[19]\ VPWR VGND sg13g2_or2_1
X_23055_ _15707_ _15673_ _15705_ _15706_ VPWR VGND sg13g2_o21ai_1
X_23056_ _15708_ \csr_i.mcause[18]\ _15707_ VPWR VGND sg13g2_xnor2_1
X_23057_ _15709_ \csr_i.mcause[31]\ _15708_ VPWR VGND sg13g2_nand2_1
X_23058_ _15710_ \csr_i.mtvec[20]\ _15709_ VPWR VGND sg13g2_xor2_1
X_23059_ _15711_ \control_i.jump_to_isr\ _15710_ VPWR VGND sg13g2_and2_1
X_23060_ _15712_ \csr_i.pc[20]\ \control_i.pcflag\ \control_i.jump_to_isr\ VPWR VGND sg13g2_nor3_1
X_23061_ _00701_ _13307_ _15704_ _15711_ _15712_ VPWR
+ VGND
+ sg13g2_nor4_1
X_23062_ _15713_ \csr_i.mcause[18]\ \csr_i.mtvec[20]\ VPWR VGND sg13g2_nor2_1
X_23063_ _15714_ \csr_i.mcause[18]\ \csr_i.mtvec[20]\ VPWR VGND sg13g2_nand2_1
X_23064_ _15715_ _15707_ _15713_ _15714_ VPWR VGND sg13g2_o21ai_1
X_23065_ _15716_ \csr_i.mcause[19]\ _15715_ VPWR VGND sg13g2_xor2_1
X_23066_ _15717_ \csr_i.mcause[31]\ _15716_ VPWR VGND sg13g2_nand2_1
X_23067_ _15718_ \csr_i.mtvec[21]\ _15717_ VPWR VGND sg13g2_xor2_1
X_23068_ _15719_ \csr_i.pc[20]\ _15699_ VPWR VGND sg13g2_or2_1
X_23069_ _15720_ \csr_i.pc[19]\ _15719_ VPWR VGND sg13g2_and2_1
X_23070_ _15721_ \csr_i.pc[20]\ _15699_ VPWR VGND sg13g2_and2_1
X_23071_ _15722_ _15695_ _15719_ _15720_ _15694_ _15721_
+ VPWR
+ VGND sg13g2_a221oi_1
X_23072_ _15723_ _15722_ VPWR VGND sg13g2_buf_1
X_23073_ _15724_ \csr_i.pc[21]\ _15723_ VPWR VGND sg13g2_xnor2_1
X_23074_ _15725_ _15294_ _15724_ VPWR VGND sg13g2_nand2_1
X_23075_ _15726_ \control_i.immediate[21]\ \rd_alu[21]\ _15632_ VPWR VGND sg13g2_mux2_1
X_23076_ _15727_ _15725_ _15726_ VPWR VGND sg13g2_xnor2_1
X_23077_ _15728_ \csr_i.isr_return[21]\ _15275_ VPWR VGND sg13g2_nor2_1
X_23078_ _15729_ _14697_ _15321_ VPWR VGND sg13g2_nor2_1
X_23079_ _15730_ _15311_ _15728_ _15729_ VPWR VGND sg13g2_nor3_1
X_23080_ _15731_ _15311_ _15727_ _15730_ VPWR VGND sg13g2_a21oi_1
X_23081_ _15732_ \csr_i.pc[21]\ \control_i.pcflag\ \control_i.jump_to_isr\ VPWR VGND sg13g2_nor3_1
X_23082_ _15733_ _15732_ reset VPWR VGND sg13g2_nand2b_1
X_23083_ _00702_ \control_i.jump_to_isr\ _15718_ _15731_ _15667_ _15733_
+ VPWR
+ VGND sg13g2_a221oi_1
X_23084_ _15734_ _12949_ VPWR VGND sg13g2_buf_1
X_23085_ _15735_ \csr_i.mcause[19]\ \csr_i.mtvec[21]\ VPWR VGND sg13g2_and2_1
X_23086_ _15736_ \csr_i.mcause[19]\ \csr_i.mtvec[21]\ VPWR VGND sg13g2_or2_1
X_23087_ _15737_ _15715_ _15735_ _15736_ VPWR VGND sg13g2_o21ai_1
X_23088_ _15738_ \csr_i.mcause[20]\ _15737_ VPWR VGND sg13g2_xnor2_1
X_23089_ _15739_ \csr_i.mcause[31]\ _15738_ VPWR VGND sg13g2_nand2_1
X_23090_ _15740_ \csr_i.mtvec[22]\ _15739_ VPWR VGND sg13g2_xnor2_1
X_23091_ _15741_ \rd_alu[23]\ _15255_ VPWR VGND sg13g2_nor2_1
X_23092_ _15742_ \csr_i.pc[22]\ VPWR VGND sg13g2_inv_1
X_23093_ _15743_ \control_i.immediate[22]\ \rd_alu[22]\ _15632_ VPWR VGND sg13g2_mux2_1
X_23094_ _15744_ _15742_ _15743_ VPWR VGND sg13g2_xnor2_1
X_23095_ _15745_ _15723_ _15726_ VPWR VGND sg13g2_nor2b_1
X_23096_ _15746_ _15726_ _15723_ VPWR VGND sg13g2_nand2b_1
X_23097_ _15747_ \csr_i.pc[21]\ _15745_ _15746_ VPWR VGND sg13g2_o21ai_1
X_23098_ _15748_ _15744_ _15747_ VPWR VGND sg13g2_xnor2_1
X_23099_ _15749_ \csr_i.isr_return[22]\ _14720_ _15275_ VPWR VGND sg13g2_mux2_1
X_23100_ _15750_ _15311_ _15749_ VPWR VGND sg13g2_nor2_1
X_23101_ _15751_ \rd_alu[23]\ _15743_ _15255_ VPWR VGND sg13g2_a21oi_1
X_23102_ _15752_ _15750_ _15751_ \control_i.pcflag\ VPWR VGND sg13g2_o21ai_1
X_23103_ _15753_ \control_i.jump_to_isr\ _15740_ _15741_ _15748_ _15752_
+ VPWR
+ VGND sg13g2_a221oi_1
X_23104_ _15754_ _15742_ _13255_ \control_i.jump_to_isr\ VPWR VGND sg13g2_a21oi_1
X_23105_ _15755_ \control_i.jump_to_isr\ _15740_ _15754_ VPWR VGND sg13g2_a21oi_1
X_23106_ _00703_ _15734_ _15753_ _15755_ VPWR VGND sg13g2_nor3_1
X_23107_ _15756_ \control_i.immediate[0]\ VPWR VGND sg13g2_inv_1
X_23108_ _15757_ _15756_ _15632_ VPWR VGND sg13g2_nor2_1
X_23109_ _15758_ \rd_alu[0]\ _15632_ _15757_ VPWR VGND sg13g2_a21oi_1
X_23110_ _15759_ \control_i.jump_to_isr\ \control_i.pcflag\ VPWR VGND sg13g2_nand2b_1
X_23111_ _15760_ \csr_i.isr_return[0]\ _15321_ _15310_ VPWR VGND sg13g2_a21oi_1
X_23112_ _15761_ _15294_ _15254_ _15260_ VPWR VGND sg13g2_nor3_1
X_23113_ _15762_ _15759_ _15760_ _15761_ VPWR VGND sg13g2_nor3_1
X_23114_ _15763_ _15275_ _15254_ _13253_ VPWR VGND sg13g2_a21oi_1
X_23115_ _15764_ \control_i.jump_to_isr\ _15763_ VPWR VGND sg13g2_nor2_1
X_23116_ _15765_ _15758_ _15762_ _15764_ VPWR VGND sg13g2_a21o_1
X_23117_ _15766_ \csr_i.pc[0]\ _15758_ _15741_ VPWR VGND sg13g2_o21ai_1
X_23118_ _15767_ \csr_i.pc[0]\ _15765_ _15766_ _15762_ VPWR
+ VGND
+ sg13g2_a22oi_1
X_23119_ _00704_ _15478_ _15767_ VPWR VGND sg13g2_nor2_1
X_23120_ _15768_ \csr_i.pc[0]\ _15260_ VPWR VGND sg13g2_nand2_1
X_23121_ _15769_ _13004_ _15768_ VPWR VGND sg13g2_xnor2_1
X_23122_ _15770_ \rd_alu[23]\ _15769_ VPWR VGND sg13g2_nor2_1
X_23123_ _15771_ _15261_ _15770_ VPWR VGND sg13g2_xnor2_1
X_23124_ _15772_ \csr_i.isr_return[1]\ _15321_ _15255_ VPWR VGND sg13g2_nand3_1
X_23125_ _15773_ _15255_ _15771_ _15772_ VPWR VGND sg13g2_o21ai_1
X_23126_ _15774_ \csr_i.pc[1]\ _15764_ _15773_ _15667_ VPWR
+ VGND
+ sg13g2_a22oi_1
X_23127_ _00705_ _15478_ _15774_ VPWR VGND sg13g2_nor2_1
X_23128_ _15775_ \memory_i.uart_transmitter.cycle_counter[11]\ \memory_i.uart_transmitter.CYCLES_PER_BIT[11]\ VPWR VGND sg13g2_xnor2_1
X_23129_ _15776_ \memory_i.uart_transmitter.cycle_counter[6]\ \memory_i.uart_transmitter.CYCLES_PER_BIT[6]\ VPWR VGND sg13g2_xnor2_1
X_23130_ _15777_ \memory_i.uart_transmitter.cycle_counter[9]\ \memory_i.uart_transmitter.CYCLES_PER_BIT[9]\ VPWR VGND sg13g2_xnor2_1
X_23131_ _15778_ \memory_i.uart_transmitter.cycle_counter[2]\ \memory_i.uart_transmitter.CYCLES_PER_BIT[2]\ VPWR VGND sg13g2_xnor2_1
X_23132_ _15779_ _15775_ _15776_ _15777_ _15778_ VPWR
+ VGND
+ sg13g2_nand4_1
X_23133_ _15780_ \memory_i.uart_transmitter.cycle_counter[15]\ \memory_i.uart_transmitter.CYCLES_PER_BIT[15]\ VPWR VGND sg13g2_xnor2_1
X_23134_ _15781_ \memory_i.uart_transmitter.cycle_counter[0]\ \memory_i.uart_transmitter.CYCLES_PER_BIT[0]\ VPWR VGND sg13g2_xnor2_1
X_23135_ _15782_ \memory_i.uart_transmitter.cycle_counter[3]\ \memory_i.uart_transmitter.CYCLES_PER_BIT[3]\ VPWR VGND sg13g2_xnor2_1
X_23136_ _15783_ \memory_i.uart_transmitter.cycle_counter[14]\ \memory_i.uart_transmitter.CYCLES_PER_BIT[14]\ VPWR VGND sg13g2_xnor2_1
X_23137_ _15784_ _15780_ _15781_ _15782_ _15783_ VPWR
+ VGND
+ sg13g2_nand4_1
X_23138_ _15785_ \memory_i.uart_transmitter.cycle_counter[8]\ \memory_i.uart_transmitter.CYCLES_PER_BIT[8]\ VPWR VGND sg13g2_xnor2_1
X_23139_ _15786_ \memory_i.uart_transmitter.cycle_counter[1]\ \memory_i.uart_transmitter.CYCLES_PER_BIT[1]\ VPWR VGND sg13g2_xnor2_1
X_23140_ _15787_ \memory_i.uart_transmitter.cycle_counter[4]\ \memory_i.uart_transmitter.CYCLES_PER_BIT[4]\ VPWR VGND sg13g2_xnor2_1
X_23141_ _15788_ \memory_i.uart_transmitter.cycle_counter[12]\ \memory_i.uart_transmitter.CYCLES_PER_BIT[12]\ VPWR VGND sg13g2_xnor2_1
X_23142_ _15789_ _15785_ _15786_ _15787_ _15788_ VPWR
+ VGND
+ sg13g2_nand4_1
X_23143_ _15790_ \memory_i.uart_transmitter.cycle_counter[5]\ \memory_i.uart_transmitter.CYCLES_PER_BIT[5]\ VPWR VGND sg13g2_xnor2_1
X_23144_ _15791_ \memory_i.uart_transmitter.cycle_counter[10]\ \memory_i.uart_transmitter.CYCLES_PER_BIT[10]\ VPWR VGND sg13g2_xnor2_1
X_23145_ _15792_ \memory_i.uart_transmitter.cycle_counter[13]\ \memory_i.uart_transmitter.CYCLES_PER_BIT[13]\ VPWR VGND sg13g2_xnor2_1
X_23146_ _15793_ \memory_i.uart_transmitter.cycle_counter[7]\ \memory_i.uart_transmitter.CYCLES_PER_BIT[7]\ VPWR VGND sg13g2_xnor2_1
X_23147_ _15794_ _15790_ _15791_ _15792_ _15793_ VPWR
+ VGND
+ sg13g2_nand4_1
X_23148_ _15795_ _15779_ _15784_ _15789_ _15794_ VPWR
+ VGND
+ sg13g2_nor4_1
X_23149_ _15796_ \memory_i.uart_transmitter.bit_counter[2]\ \memory_i.uart_transmitter.bit_counter[1]\ VPWR VGND sg13g2_nor2_1
X_23150_ _15797_ \memory_i.uart_transmitter.bit_counter[3]\ \memory_i.uart_transmitter.bit_counter[0]\ _15796_ VPWR VGND sg13g2_nand3b_1
X_23151_ _15798_ \memory_i.uart_transmitter.fsm_state[1]\ _15797_ VPWR VGND sg13g2_nand2_1
X_23152_ _15799_ \memory_i.uart_transmitter.fsm_state[1]\ _15795_ _15798_ VPWR VGND sg13g2_o21ai_1
X_23153_ _15800_ \memory_i.uart_transmitter.fsm_state[0]\ \memory_i.uart_transmitter.fsm_state[1]\ VPWR VGND sg13g2_nand2b_1
X_23154_ _15801_ \memory_i.uart_transmitter.bit_counter[0]\ _15796_ \memory_i.uart_transmitter.bit_counter[3]\ VPWR VGND sg13g2_nand3b_1
X_23155_ _15802_ \memory_i.uart_transmitter.uart_tx_en\ _12961_ VPWR VGND sg13g2_nand2_1
X_23156_ _15803_ _15802_ VPWR VGND sg13g2_buf_1
X_23157_ _15804_ _15800_ _15801_ _15803_ VPWR VGND sg13g2_o21ai_1
X_23158_ _15805_ \memory_i.uart_transmitter.fsm_state[0]\ _15799_ _15804_ VPWR VGND sg13g2_a21oi_1
X_23159_ _00706_ _15478_ _15805_ VPWR VGND sg13g2_nor2_1
X_23160_ _15806_ \memory_i.uart_transmitter.fsm_state[0]\ _15795_ \memory_i.uart_transmitter.fsm_state[1]\ VPWR VGND sg13g2_a21oi_1
X_23161_ _15807_ \memory_i.uart_transmitter.fsm_state[1]\ \memory_i.uart_transmitter.fsm_state[0]\ VPWR VGND sg13g2_nand2_1
X_23162_ _15808_ _15797_ _15807_ reset VPWR VGND sg13g2_o21ai_1
X_23163_ _00707_ _15806_ _15808_ VPWR VGND sg13g2_nor2_1
X_23164_ _15809_ \memory_i.freq_inst.dsmod_sin.fetch_ctr_r[3]\ \memory_i.freq_inst.dsmod_sin.fetch_ctr_r[2]\ \memory_i.freq_inst.dsmod_sin.fetch_ctr_r[1]\ \memory_i.freq_inst.dsmod_sin.fetch_ctr_r[0]\ VPWR
+ VGND
+ sg13g2_or4_1
X_23165_ _15810_ _12938_ \memory_i.freq_inst.dsmod_sin.fetch_ctr_r[4]\ _15809_ VPWR VGND sg13g2_nor3_1
X_23166_ _15811_ \memory_i.freq_inst.dsmod_sin.fetch_ctr_r[5]\ _15810_ VPWR VGND sg13g2_nand2b_1
X_23167_ _15812_ _15811_ VPWR VGND sg13g2_buf_1
X_23168_ _15813_ \memory_i.freq_inst.dsmod_sin.fetch_ctr_r[7]\ \memory_i.freq_inst.dsmod_sin.fetch_ctr_r[6]\ VPWR VGND sg13g2_nor2_1
X_23169_ _15814_ _15812_ _15813_ VPWR VGND sg13g2_nor2b_1
X_23170_ _15815_ _15814_ VPWR VGND sg13g2_buf_1
X_23171_ _15816_ _15815_ VPWR VGND sg13g2_buf_1
X_23172_ _15817_ _15816_ VPWR VGND sg13g2_buf_1
X_23173_ _15818_ \memory_i.freq_inst.dsmod_sin.data_ext_w[8]\ _15817_ VPWR VGND sg13g2_nand2_1
X_23174_ _15819_ _15812_ _15813_ VPWR VGND sg13g2_nand2b_1
X_23175_ _15820_ _15819_ VPWR VGND sg13g2_buf_1
X_23176_ _15821_ _15820_ VPWR VGND sg13g2_buf_1
X_23177_ _15822_ \memory_i.freq_inst.dsmod_sin.data_pre_r[8]\ _15821_ VPWR VGND sg13g2_nand2_1
X_23178_ _15823_ _12944_ VPWR VGND sg13g2_buf_1
X_23179_ _15824_ _15823_ VPWR VGND sg13g2_buf_1
X_23180_ _00708_ _15818_ _15822_ _15824_ VPWR VGND sg13g2_a21oi_1
X_23181_ _15825_ \memory_i.freq_inst.dsmod_sin.data_ext_w[9]\ _15817_ VPWR VGND sg13g2_nand2_1
X_23182_ _15826_ \memory_i.freq_inst.dsmod_sin.data_pre_r[9]\ _15821_ VPWR VGND sg13g2_nand2_1
X_23183_ _00709_ _15825_ _15826_ _15824_ VPWR VGND sg13g2_a21oi_1
X_23184_ _15827_ \memory_i.freq_inst.dsmod_sin.data_ext_w[10]\ _15817_ VPWR VGND sg13g2_nand2_1
X_23185_ _15828_ \memory_i.freq_inst.dsmod_sin.data_pre_r[10]\ _15821_ VPWR VGND sg13g2_nand2_1
X_23186_ _00710_ _15827_ _15828_ _15824_ VPWR VGND sg13g2_a21oi_1
X_23187_ _15829_ \memory_i.freq_inst.dsmod_sin.data_ext_w[11]\ _15817_ VPWR VGND sg13g2_nand2_1
X_23188_ _15830_ \memory_i.freq_inst.dsmod_sin.data_pre_r[11]\ _15821_ VPWR VGND sg13g2_nand2_1
X_23189_ _00711_ _15829_ _15830_ _15824_ VPWR VGND sg13g2_a21oi_1
X_23190_ _15831_ \memory_i.freq_inst.dsmod_sin.data_ext_w[12]\ _15817_ VPWR VGND sg13g2_nand2_1
X_23191_ _15832_ \memory_i.freq_inst.dsmod_sin.data_pre_r[12]\ _15821_ VPWR VGND sg13g2_nand2_1
X_23192_ _00712_ _15831_ _15832_ _15824_ VPWR VGND sg13g2_a21oi_1
X_23193_ _15833_ \memory_i.freq_inst.dsmod_sin.data_ext_w[13]\ _15817_ VPWR VGND sg13g2_nand2_1
X_23194_ _15834_ \memory_i.freq_inst.dsmod_sin.data_pre_r[13]\ _15821_ VPWR VGND sg13g2_nand2_1
X_23195_ _00713_ _15833_ _15834_ _15824_ VPWR VGND sg13g2_a21oi_1
X_23196_ _15835_ \memory_i.freq_inst.dsmod_sin.data_ext_w[14]\ _15817_ VPWR VGND sg13g2_nand2_1
X_23197_ _15836_ _15820_ VPWR VGND sg13g2_buf_1
X_23198_ _15837_ \memory_i.freq_inst.dsmod_sin.data_pre_r[14]\ _15836_ VPWR VGND sg13g2_nand2_1
X_23199_ _00714_ _15835_ _15837_ _15824_ VPWR VGND sg13g2_a21oi_1
X_23200_ _15838_ \memory_i.freq_inst.dsmod_sin.data_ext_w[15]\ _15817_ VPWR VGND sg13g2_nand2_1
X_23201_ _15839_ \memory_i.freq_inst.dsmod_sin.data_pre_r[15]\ _15836_ VPWR VGND sg13g2_nand2_1
X_23202_ _00715_ _15838_ _15839_ _15824_ VPWR VGND sg13g2_a21oi_1
X_23203_ _15840_ \memory_i.freq_inst.dsmod_sin.data_ext_w[16]\ _15817_ VPWR VGND sg13g2_nand2_1
X_23204_ _15841_ \memory_i.freq_inst.dsmod_sin.data_pre_r[16]\ _15836_ VPWR VGND sg13g2_nand2_1
X_23205_ _00716_ _15840_ _15841_ _15824_ VPWR VGND sg13g2_a21oi_1
X_23206_ _15842_ _15816_ VPWR VGND sg13g2_buf_1
X_23207_ _15843_ \memory_i.freq_inst.dsmod_sin.data_ext_w[17]\ _15842_ VPWR VGND sg13g2_nand2_1
X_23208_ _15844_ \memory_i.freq_inst.dsmod_sin.data_pre_r[17]\ _15836_ VPWR VGND sg13g2_nand2_1
X_23209_ _00717_ _15843_ _15844_ _15824_ VPWR VGND sg13g2_a21oi_1
X_23210_ _15845_ \memory_i.freq_inst.dsmod_sin.data_ext_w[18]\ _15842_ VPWR VGND sg13g2_nand2_1
X_23211_ _15846_ \memory_i.freq_inst.dsmod_sin.data_pre_r[18]\ _15836_ VPWR VGND sg13g2_nand2_1
X_23212_ _15847_ _12944_ VPWR VGND sg13g2_buf_1
X_23213_ _15848_ _15847_ VPWR VGND sg13g2_buf_1
X_23214_ _00718_ _15845_ _15846_ _15848_ VPWR VGND sg13g2_a21oi_1
X_23215_ _15849_ \memory_i.freq_inst.dsmod_sin.data_ext_w[19]\ _15842_ VPWR VGND sg13g2_nand2_1
X_23216_ _15850_ \memory_i.freq_inst.dsmod_sin.data_pre_r[19]\ _15836_ VPWR VGND sg13g2_nand2_1
X_23217_ _00719_ _15849_ _15850_ _15848_ VPWR VGND sg13g2_a21oi_1
X_23218_ _15851_ \memory_i.freq_inst.dsmod_sin.data_ext_w[20]\ _15842_ VPWR VGND sg13g2_nand2_1
X_23219_ _15852_ \memory_i.freq_inst.dsmod_sin.data_pre_r[20]\ _15836_ VPWR VGND sg13g2_nand2_1
X_23220_ _00720_ _15851_ _15852_ _15848_ VPWR VGND sg13g2_a21oi_1
X_23221_ _15853_ \memory_i.freq_inst.dsmod_sin.data_ext_w[21]\ _15842_ VPWR VGND sg13g2_nand2_1
X_23222_ _15854_ \memory_i.freq_inst.dsmod_sin.data_pre_r[21]\ _15836_ VPWR VGND sg13g2_nand2_1
X_23223_ _00721_ _15853_ _15854_ _15848_ VPWR VGND sg13g2_a21oi_1
X_23224_ _15855_ \memory_i.freq_inst.dsmod_sin.data_ext_w[22]\ _15842_ VPWR VGND sg13g2_nand2_1
X_23225_ _15856_ \memory_i.freq_inst.dsmod_sin.data_pre_r[22]\ _15836_ VPWR VGND sg13g2_nand2_1
X_23226_ _00722_ _15855_ _15856_ _15848_ VPWR VGND sg13g2_a21oi_1
X_23227_ _15857_ \memory_i.freq_inst.dsmod_sin.data_ext_w[23]\ _15842_ VPWR VGND sg13g2_nand2_1
X_23228_ _15858_ \memory_i.freq_inst.dsmod_sin.data_pre_r[23]\ _15836_ VPWR VGND sg13g2_nand2_1
X_23229_ _00723_ _15857_ _15858_ _15848_ VPWR VGND sg13g2_a21oi_1
X_23230_ _15859_ \memory_i.freq_inst.dsmod_sin.data_ext_w[24]\ _15842_ VPWR VGND sg13g2_nand2_1
X_23231_ _15860_ _15820_ VPWR VGND sg13g2_buf_1
X_23232_ _15861_ \memory_i.freq_inst.dsmod_sin.data_pre_r[24]\ _15860_ VPWR VGND sg13g2_nand2_1
X_23233_ _00724_ _15859_ _15861_ _15848_ VPWR VGND sg13g2_a21oi_1
X_23234_ _15862_ \memory_i.freq_inst.dsmod_sin.data_ext_w[25]\ _15842_ VPWR VGND sg13g2_nand2_1
X_23235_ _15863_ \memory_i.freq_inst.dsmod_sin.data_pre_r[25]\ _15860_ VPWR VGND sg13g2_nand2_1
X_23236_ _00725_ _15862_ _15863_ _15848_ VPWR VGND sg13g2_a21oi_1
X_23237_ _15864_ \memory_i.freq_inst.dsmod_sin.data_ext_w[26]\ _15842_ VPWR VGND sg13g2_nand2_1
X_23238_ _15865_ \memory_i.freq_inst.dsmod_sin.data_pre_r[26]\ _15860_ VPWR VGND sg13g2_nand2_1
X_23239_ _00726_ _15864_ _15865_ _15848_ VPWR VGND sg13g2_a21oi_1
X_23240_ _15866_ _15816_ VPWR VGND sg13g2_buf_1
X_23241_ _15867_ \memory_i.freq_inst.dsmod_sin.data_ext_w[27]\ _15866_ VPWR VGND sg13g2_nand2_1
X_23242_ _15868_ \memory_i.freq_inst.dsmod_sin.data_pre_r[27]\ _15860_ VPWR VGND sg13g2_nand2_1
X_23243_ _00727_ _15867_ _15868_ _15848_ VPWR VGND sg13g2_a21oi_1
X_23244_ _15869_ \memory_i.freq_inst.dsmod_sin.data_ext_w[28]\ _15866_ VPWR VGND sg13g2_nand2_1
X_23245_ _15870_ \memory_i.freq_inst.dsmod_sin.data_pre_r[28]\ _15860_ VPWR VGND sg13g2_nand2_1
X_23246_ _15871_ _15847_ VPWR VGND sg13g2_buf_1
X_23247_ _00728_ _15869_ _15870_ _15871_ VPWR VGND sg13g2_a21oi_1
X_23248_ _15872_ \memory_i.freq_inst.dsmod_sin.data_ext_w[29]\ _15866_ VPWR VGND sg13g2_nand2_1
X_23249_ _15873_ \memory_i.freq_inst.dsmod_sin.data_pre_r[29]\ _15860_ VPWR VGND sg13g2_nand2_1
X_23250_ _00729_ _15872_ _15873_ _15871_ VPWR VGND sg13g2_a21oi_1
X_23251_ _15874_ \memory_i.freq_inst.dsmod_sin.data_ext_w[30]\ _15866_ VPWR VGND sg13g2_nand2_1
X_23252_ _15875_ \memory_i.freq_inst.dsmod_sin.data_pre_r[30]\ _15860_ VPWR VGND sg13g2_nand2_1
X_23253_ _00730_ _15874_ _15875_ _15871_ VPWR VGND sg13g2_a21oi_1
X_23254_ _15876_ \memory_i.freq_inst.dsmod_sin.data_ext_w[31]\ _15866_ VPWR VGND sg13g2_nand2_1
X_23255_ _15877_ \memory_i.freq_inst.dsmod_sin.data_pre_r[31]\ _15860_ VPWR VGND sg13g2_nand2_1
X_23256_ _00731_ _15876_ _15877_ _15871_ VPWR VGND sg13g2_a21oi_1
X_23257_ _15878_ \memory_i.freq_inst.dsmod_sin.data_ext_w[32]\ _15866_ VPWR VGND sg13g2_nand2_1
X_23258_ _15879_ \memory_i.freq_inst.dsmod_sin.data_pre_r[32]\ _15860_ VPWR VGND sg13g2_nand2_1
X_23259_ _00732_ _15878_ _15879_ _15871_ VPWR VGND sg13g2_a21oi_1
X_23260_ _15880_ \memory_i.freq_inst.dsmod_sin.data_ext_w[33]\ _15866_ VPWR VGND sg13g2_nand2_1
X_23261_ _15881_ \memory_i.freq_inst.dsmod_sin.data_pre_r[33]\ _15860_ VPWR VGND sg13g2_nand2_1
X_23262_ _00733_ _15880_ _15881_ _15871_ VPWR VGND sg13g2_a21oi_1
X_23263_ _15882_ \memory_i.freq_inst.dsmod_sin.data_ext_w[34]\ _15866_ VPWR VGND sg13g2_nand2_1
X_23264_ _15883_ _15820_ VPWR VGND sg13g2_buf_1
X_23265_ _15884_ \memory_i.freq_inst.dsmod_sin.data_pre_r[34]\ _15883_ VPWR VGND sg13g2_nand2_1
X_23266_ _00734_ _15882_ _15884_ _15871_ VPWR VGND sg13g2_a21oi_1
X_23267_ _15885_ \memory_i.freq_inst.dsmod_sin.data_ext_w[35]\ _15866_ VPWR VGND sg13g2_nand2_1
X_23268_ _15886_ \memory_i.freq_inst.dsmod_sin.data_pre_r[35]\ _15883_ VPWR VGND sg13g2_nand2_1
X_23269_ _00735_ _15885_ _15886_ _15871_ VPWR VGND sg13g2_a21oi_1
X_23270_ _15887_ \memory_i.freq_inst.dsmod_sin.data_ext_w[36]\ _15866_ VPWR VGND sg13g2_nand2_1
X_23271_ _15888_ \memory_i.freq_inst.dsmod_sin.data_pre_r[36]\ _15883_ VPWR VGND sg13g2_nand2_1
X_23272_ _00736_ _15887_ _15888_ _15871_ VPWR VGND sg13g2_a21oi_1
X_23273_ _15889_ _15816_ VPWR VGND sg13g2_buf_1
X_23274_ _15890_ \memory_i.freq_inst.dsmod_sin.data_ext_w[37]\ _15889_ VPWR VGND sg13g2_nand2_1
X_23275_ _15891_ \memory_i.freq_inst.dsmod_sin.data_pre_r[37]\ _15883_ VPWR VGND sg13g2_nand2_1
X_23276_ _00737_ _15890_ _15891_ _15871_ VPWR VGND sg13g2_a21oi_1
X_23277_ _15892_ \memory_i.freq_inst.dsmod_cos.fetch_ctr_r[0]\ \memory_i.freq_inst.dsmod_cos.i_ena_mod\ VPWR VGND sg13g2_nand2b_1
X_23278_ _15893_ _15892_ VPWR VGND sg13g2_buf_1
X_23279_ _15894_ \memory_i.freq_inst.dsmod_cos.fetch_ctr_r[2]\ \memory_i.freq_inst.dsmod_cos.fetch_ctr_r[1]\ _15893_ VPWR VGND sg13g2_or3_1
X_23280_ _15895_ _15894_ VPWR VGND sg13g2_buf_1
X_23281_ _15896_ \memory_i.freq_inst.dsmod_cos.fetch_ctr_r[4]\ \memory_i.freq_inst.dsmod_cos.fetch_ctr_r[3]\ _15895_ VPWR VGND sg13g2_nor3_1
X_23282_ _15897_ \memory_i.freq_inst.dsmod_cos.fetch_ctr_r[5]\ _15896_ VPWR VGND sg13g2_nand2b_1
X_23283_ _15898_ _15897_ VPWR VGND sg13g2_buf_1
X_23284_ _15899_ \memory_i.freq_inst.dsmod_cos.fetch_ctr_r[7]\ \memory_i.freq_inst.dsmod_cos.fetch_ctr_r[6]\ VPWR VGND sg13g2_nor2_1
X_23285_ _15900_ _15898_ _15899_ VPWR VGND sg13g2_nor2b_1
X_23286_ _15901_ _15900_ VPWR VGND sg13g2_buf_1
X_23287_ _15902_ _15901_ VPWR VGND sg13g2_buf_1
X_23288_ _15903_ _15902_ VPWR VGND sg13g2_buf_1
X_23289_ _15904_ \memory_i.freq_inst.cosine[0]\ _15903_ VPWR VGND sg13g2_nand2_1
X_23290_ _15905_ _15898_ _15899_ VPWR VGND sg13g2_nand2b_1
X_23291_ _15906_ _15905_ VPWR VGND sg13g2_buf_1
X_23292_ _15907_ _15906_ VPWR VGND sg13g2_buf_1
X_23293_ _15908_ _15907_ VPWR VGND sg13g2_buf_1
X_23294_ _15909_ \memory_i.freq_inst.dsmod_cos.data_pre_r[8]\ _15908_ VPWR VGND sg13g2_nand2_1
X_23295_ _15910_ _15847_ VPWR VGND sg13g2_buf_1
X_23296_ _00738_ _15904_ _15909_ _15910_ VPWR VGND sg13g2_a21oi_1
X_23297_ _15911_ \memory_i.freq_inst.cosine[1]\ _15903_ VPWR VGND sg13g2_nand2_1
X_23298_ _15912_ \memory_i.freq_inst.dsmod_cos.data_pre_r[9]\ _15908_ VPWR VGND sg13g2_nand2_1
X_23299_ _00739_ _15911_ _15912_ _15910_ VPWR VGND sg13g2_a21oi_1
X_23300_ _15913_ \memory_i.freq_inst.cosine[2]\ _15903_ VPWR VGND sg13g2_nand2_1
X_23301_ _15914_ \memory_i.freq_inst.dsmod_cos.data_pre_r[10]\ _15908_ VPWR VGND sg13g2_nand2_1
X_23302_ _00740_ _15913_ _15914_ _15910_ VPWR VGND sg13g2_a21oi_1
X_23303_ _15915_ \memory_i.freq_inst.cosine[3]\ _15903_ VPWR VGND sg13g2_nand2_1
X_23304_ _15916_ \memory_i.freq_inst.dsmod_cos.data_pre_r[11]\ _15908_ VPWR VGND sg13g2_nand2_1
X_23305_ _00741_ _15915_ _15916_ _15910_ VPWR VGND sg13g2_a21oi_1
X_23306_ _15917_ \memory_i.freq_inst.cosine[4]\ _15903_ VPWR VGND sg13g2_nand2_1
X_23307_ _15918_ \memory_i.freq_inst.dsmod_cos.data_pre_r[12]\ _15908_ VPWR VGND sg13g2_nand2_1
X_23308_ _00742_ _15917_ _15918_ _15910_ VPWR VGND sg13g2_a21oi_1
X_23309_ _15919_ _15902_ VPWR VGND sg13g2_buf_1
X_23310_ _15920_ \memory_i.freq_inst.cosine[5]\ _15919_ VPWR VGND sg13g2_nand2_1
X_23311_ _15921_ \memory_i.freq_inst.dsmod_cos.data_pre_r[13]\ _15908_ VPWR VGND sg13g2_nand2_1
X_23312_ _00743_ _15920_ _15921_ _15910_ VPWR VGND sg13g2_a21oi_1
X_23313_ _15922_ \memory_i.freq_inst.cosine[6]\ _15919_ VPWR VGND sg13g2_nand2_1
X_23314_ _15923_ _15907_ VPWR VGND sg13g2_buf_1
X_23315_ _15924_ \memory_i.freq_inst.dsmod_cos.data_pre_r[14]\ _15923_ VPWR VGND sg13g2_nand2_1
X_23316_ _00744_ _15922_ _15924_ _15910_ VPWR VGND sg13g2_a21oi_1
X_23317_ _15925_ \memory_i.freq_inst.cosine[7]\ _15919_ VPWR VGND sg13g2_nand2_1
X_23318_ _15926_ \memory_i.freq_inst.dsmod_cos.data_pre_r[15]\ _15923_ VPWR VGND sg13g2_nand2_1
X_23319_ _00745_ _15925_ _15926_ _15910_ VPWR VGND sg13g2_a21oi_1
X_23320_ _15927_ \memory_i.freq_inst.cosine[8]\ _15919_ VPWR VGND sg13g2_nand2_1
X_23321_ _15928_ \memory_i.freq_inst.dsmod_cos.data_pre_r[16]\ _15923_ VPWR VGND sg13g2_nand2_1
X_23322_ _00746_ _15927_ _15928_ _15910_ VPWR VGND sg13g2_a21oi_1
X_23323_ _15929_ \memory_i.freq_inst.cosine[9]\ _15919_ VPWR VGND sg13g2_nand2_1
X_23324_ _15930_ \memory_i.freq_inst.dsmod_cos.data_pre_r[17]\ _15923_ VPWR VGND sg13g2_nand2_1
X_23325_ _00747_ _15929_ _15930_ _15910_ VPWR VGND sg13g2_a21oi_1
X_23326_ _15931_ \memory_i.freq_inst.cosine[10]\ _15919_ VPWR VGND sg13g2_nand2_1
X_23327_ _15932_ \memory_i.freq_inst.dsmod_cos.data_pre_r[18]\ _15923_ VPWR VGND sg13g2_nand2_1
X_23328_ _15933_ _15847_ VPWR VGND sg13g2_buf_1
X_23329_ _00748_ _15931_ _15932_ _15933_ VPWR VGND sg13g2_a21oi_1
X_23330_ _15934_ \memory_i.freq_inst.cosine[11]\ _15919_ VPWR VGND sg13g2_nand2_1
X_23331_ _15935_ \memory_i.freq_inst.dsmod_cos.data_pre_r[19]\ _15923_ VPWR VGND sg13g2_nand2_1
X_23332_ _00749_ _15934_ _15935_ _15933_ VPWR VGND sg13g2_a21oi_1
X_23333_ _15936_ \memory_i.freq_inst.cosine[12]\ _15919_ VPWR VGND sg13g2_nand2_1
X_23334_ _15937_ \memory_i.freq_inst.dsmod_cos.data_pre_r[20]\ _15923_ VPWR VGND sg13g2_nand2_1
X_23335_ _00750_ _15936_ _15937_ _15933_ VPWR VGND sg13g2_a21oi_1
X_23336_ _15938_ \memory_i.freq_inst.cosine[13]\ _15919_ VPWR VGND sg13g2_nand2_1
X_23337_ _15939_ \memory_i.freq_inst.dsmod_cos.data_pre_r[21]\ _15923_ VPWR VGND sg13g2_nand2_1
X_23338_ _00751_ _15938_ _15939_ _15933_ VPWR VGND sg13g2_a21oi_1
X_23339_ _15940_ \memory_i.freq_inst.cosine[14]\ _15919_ VPWR VGND sg13g2_nand2_1
X_23340_ _15941_ \memory_i.freq_inst.dsmod_cos.data_pre_r[22]\ _15923_ VPWR VGND sg13g2_nand2_1
X_23341_ _00752_ _15940_ _15941_ _15933_ VPWR VGND sg13g2_a21oi_1
X_23342_ _15942_ _15902_ VPWR VGND sg13g2_buf_1
X_23343_ _15943_ \memory_i.freq_inst.cosine[15]\ _15942_ VPWR VGND sg13g2_nand2_1
X_23344_ _15944_ \memory_i.freq_inst.dsmod_cos.data_pre_r[23]\ _15923_ VPWR VGND sg13g2_nand2_1
X_23345_ _00753_ _15943_ _15944_ _15933_ VPWR VGND sg13g2_a21oi_1
X_23346_ _15945_ \memory_i.freq_inst.cosine[16]\ _15942_ VPWR VGND sg13g2_nand2_1
X_23347_ _15946_ _15907_ VPWR VGND sg13g2_buf_1
X_23348_ _15947_ \memory_i.freq_inst.dsmod_cos.data_pre_r[24]\ _15946_ VPWR VGND sg13g2_nand2_1
X_23349_ _00754_ _15945_ _15947_ _15933_ VPWR VGND sg13g2_a21oi_1
X_23350_ _15948_ \memory_i.freq_inst.cosine[17]\ _15942_ VPWR VGND sg13g2_nand2_1
X_23351_ _15949_ \memory_i.freq_inst.dsmod_cos.data_pre_r[25]\ _15946_ VPWR VGND sg13g2_nand2_1
X_23352_ _00755_ _15948_ _15949_ _15933_ VPWR VGND sg13g2_a21oi_1
X_23353_ _15950_ \memory_i.freq_inst.cosine[18]\ _15942_ VPWR VGND sg13g2_nand2_1
X_23354_ _15951_ \memory_i.freq_inst.dsmod_cos.data_pre_r[26]\ _15946_ VPWR VGND sg13g2_nand2_1
X_23355_ _00756_ _15950_ _15951_ _15933_ VPWR VGND sg13g2_a21oi_1
X_23356_ _15952_ \memory_i.freq_inst.cosine[19]\ _15942_ VPWR VGND sg13g2_nand2_1
X_23357_ _15953_ \memory_i.freq_inst.dsmod_cos.data_pre_r[27]\ _15946_ VPWR VGND sg13g2_nand2_1
X_23358_ _00757_ _15952_ _15953_ _15933_ VPWR VGND sg13g2_a21oi_1
X_23359_ _15954_ \memory_i.freq_inst.cosine[20]\ _15942_ VPWR VGND sg13g2_nand2_1
X_23360_ _15955_ \memory_i.freq_inst.dsmod_cos.data_pre_r[28]\ _15946_ VPWR VGND sg13g2_nand2_1
X_23361_ _15956_ _15847_ VPWR VGND sg13g2_buf_1
X_23362_ _00758_ _15954_ _15955_ _15956_ VPWR VGND sg13g2_a21oi_1
X_23363_ _15957_ \memory_i.freq_inst.cosine[21]\ _15942_ VPWR VGND sg13g2_nand2_1
X_23364_ _15958_ \memory_i.freq_inst.dsmod_cos.data_pre_r[29]\ _15946_ VPWR VGND sg13g2_nand2_1
X_23365_ _00759_ _15957_ _15958_ _15956_ VPWR VGND sg13g2_a21oi_1
X_23366_ _15959_ \memory_i.freq_inst.cosine[22]\ _15942_ VPWR VGND sg13g2_nand2_1
X_23367_ _15960_ \memory_i.freq_inst.dsmod_cos.data_pre_r[30]\ _15946_ VPWR VGND sg13g2_nand2_1
X_23368_ _00760_ _15959_ _15960_ _15956_ VPWR VGND sg13g2_a21oi_1
X_23369_ _15961_ \memory_i.freq_inst.cosine[23]\ _15942_ VPWR VGND sg13g2_nand2_1
X_23370_ _15962_ \memory_i.freq_inst.dsmod_cos.data_pre_r[31]\ _15946_ VPWR VGND sg13g2_nand2_1
X_23371_ _00761_ _15961_ _15962_ _15956_ VPWR VGND sg13g2_a21oi_1
X_23372_ _15963_ \memory_i.freq_inst.cosine[24]\ _15942_ VPWR VGND sg13g2_nand2_1
X_23373_ _15964_ \memory_i.freq_inst.dsmod_cos.data_pre_r[32]\ _15946_ VPWR VGND sg13g2_nand2_1
X_23374_ _00762_ _15963_ _15964_ _15956_ VPWR VGND sg13g2_a21oi_1
X_23375_ _15965_ _15901_ VPWR VGND sg13g2_buf_1
X_23376_ _15966_ _15965_ VPWR VGND sg13g2_buf_1
X_23377_ _15967_ \memory_i.freq_inst.cosine[25]\ _15966_ VPWR VGND sg13g2_nand2_1
X_23378_ _15968_ \memory_i.freq_inst.dsmod_cos.data_pre_r[33]\ _15946_ VPWR VGND sg13g2_nand2_1
X_23379_ _00763_ _15967_ _15968_ _15956_ VPWR VGND sg13g2_a21oi_1
X_23380_ _15969_ \memory_i.freq_inst.cosine[26]\ _15966_ VPWR VGND sg13g2_nand2_1
X_23381_ _15970_ _15907_ VPWR VGND sg13g2_buf_1
X_23382_ _15971_ \memory_i.freq_inst.dsmod_cos.data_pre_r[34]\ _15970_ VPWR VGND sg13g2_nand2_1
X_23383_ _00764_ _15969_ _15971_ _15956_ VPWR VGND sg13g2_a21oi_1
X_23384_ _15972_ \memory_i.freq_inst.cosine[27]\ _15966_ VPWR VGND sg13g2_nand2_1
X_23385_ _15973_ \memory_i.freq_inst.dsmod_cos.data_pre_r[35]\ _15970_ VPWR VGND sg13g2_nand2_1
X_23386_ _00765_ _15972_ _15973_ _15956_ VPWR VGND sg13g2_a21oi_1
X_23387_ _15974_ \memory_i.freq_inst.cosine[28]\ _15966_ VPWR VGND sg13g2_nand2_1
X_23388_ _15975_ \memory_i.freq_inst.dsmod_cos.data_pre_r[36]\ _15970_ VPWR VGND sg13g2_nand2_1
X_23389_ _00766_ _15974_ _15975_ _15956_ VPWR VGND sg13g2_a21oi_1
X_23390_ _15976_ \memory_i.freq_inst.cosine[29]\ _15966_ VPWR VGND sg13g2_nand2_1
X_23391_ _15977_ \memory_i.freq_inst.dsmod_cos.data_pre_r[37]\ _15970_ VPWR VGND sg13g2_nand2_1
X_23392_ _00767_ _15976_ _15977_ _15956_ VPWR VGND sg13g2_a21oi_1
X_23393_ _15978_ _13235_ _15268_ VPWR VGND sg13g2_nor2_1
X_23394_ _15979_ _15978_ VPWR VGND sg13g2_buf_1
X_23395_ _15980_ _14492_ _15979_ VPWR VGND sg13g2_and2_1
X_23396_ _15981_ _15980_ VPWR VGND sg13g2_buf_1
X_23397_ _15982_ _15981_ VPWR VGND sg13g2_buf_1
X_23398_ _15983_ \control_i.jump_to_isr\ \csr_i.mstatus[3]\ VPWR VGND sg13g2_nand2b_1
X_23399_ _15984_ _15981_ VPWR VGND sg13g2_buf_1
X_23400_ _15985_ _15270_ _15983_ _15984_ VPWR VGND sg13g2_a21oi_1
X_23401_ _15986_ \csr_i.data_in[3]\ _15982_ _15985_ VPWR VGND sg13g2_a21oi_1
X_23402_ _00768_ _15478_ _15986_ VPWR VGND sg13g2_nor2_1
X_23403_ _15987_ _15984_ VPWR VGND sg13g2_buf_1
X_23404_ _15988_ \csr_i.data_in[0]\ _15987_ VPWR VGND sg13g2_nand2_1
X_23405_ _15989_ _15982_ \csr_i.mstatus[0]\ VPWR VGND sg13g2_nand2b_1
X_23406_ _00769_ _15988_ _15989_ _13305_ VPWR VGND sg13g2_a21oi_1
X_23407_ _15990_ \csr_i.data_in[1]\ _15987_ VPWR VGND sg13g2_nand2_1
X_23408_ _15991_ _15982_ \csr_i.mstatus[1]\ VPWR VGND sg13g2_nand2b_1
X_23409_ _00770_ _15990_ _15991_ _13305_ VPWR VGND sg13g2_a21oi_1
X_23410_ _15992_ \csr_i.data_in[2]\ _15987_ VPWR VGND sg13g2_nand2_1
X_23411_ _15993_ _15982_ \csr_i.mstatus[2]\ VPWR VGND sg13g2_nand2b_1
X_23412_ _15994_ _12950_ VPWR VGND sg13g2_buf_1
X_23413_ _00771_ _15992_ _15993_ _15994_ VPWR VGND sg13g2_a21oi_1
X_23414_ _15995_ \csr_i.data_in[4]\ _15987_ VPWR VGND sg13g2_nand2_1
X_23415_ _15996_ _15982_ \csr_i.mstatus[4]\ VPWR VGND sg13g2_nand2b_1
X_23416_ _00772_ _15995_ _15996_ _15994_ VPWR VGND sg13g2_a21oi_1
X_23417_ _15997_ \csr_i.data_in[5]\ _15987_ VPWR VGND sg13g2_nand2_1
X_23418_ _15998_ _15982_ \csr_i.mstatus[5]\ VPWR VGND sg13g2_nand2b_1
X_23419_ _00773_ _15997_ _15998_ _15994_ VPWR VGND sg13g2_a21oi_1
X_23420_ _15999_ \csr_i.data_in[6]\ _15987_ VPWR VGND sg13g2_nand2_1
X_23421_ _16000_ _15982_ \csr_i.mstatus[6]\ VPWR VGND sg13g2_nand2b_1
X_23422_ _00774_ _15999_ _16000_ _15994_ VPWR VGND sg13g2_a21oi_1
X_23423_ _16001_ \csr_i.data_in[7]\ _15987_ VPWR VGND sg13g2_nand2_1
X_23424_ _16002_ _15982_ \csr_i.mstatus[7]\ VPWR VGND sg13g2_nand2b_1
X_23425_ _00775_ _16001_ _16002_ _15994_ VPWR VGND sg13g2_a21oi_1
X_23426_ _16003_ \csr_i.data_in[8]\ _15987_ VPWR VGND sg13g2_nand2_1
X_23427_ _16004_ _15982_ \csr_i.mstatus[8]\ VPWR VGND sg13g2_nand2b_1
X_23428_ _00776_ _16003_ _16004_ _15994_ VPWR VGND sg13g2_a21oi_1
X_23429_ _16005_ \csr_i.data_in[9]\ _15987_ VPWR VGND sg13g2_nand2_1
X_23430_ _16006_ _15984_ VPWR VGND sg13g2_buf_1
X_23431_ _16007_ _16006_ \csr_i.mstatus[9]\ VPWR VGND sg13g2_nand2b_1
X_23432_ _00777_ _16005_ _16007_ _15994_ VPWR VGND sg13g2_a21oi_1
X_23433_ _16008_ \csr_i.data_in[10]\ _15987_ VPWR VGND sg13g2_nand2_1
X_23434_ _16009_ _16006_ \csr_i.mstatus[10]\ VPWR VGND sg13g2_nand2b_1
X_23435_ _00778_ _16008_ _16009_ _15994_ VPWR VGND sg13g2_a21oi_1
X_23436_ _16010_ _15984_ VPWR VGND sg13g2_buf_1
X_23437_ _16011_ \csr_i.data_in[11]\ _16010_ VPWR VGND sg13g2_nand2_1
X_23438_ _16012_ _16006_ \csr_i.mstatus[11]\ VPWR VGND sg13g2_nand2b_1
X_23439_ _00779_ _16011_ _16012_ _15994_ VPWR VGND sg13g2_a21oi_1
X_23440_ _16013_ \csr_i.data_in[12]\ _16010_ VPWR VGND sg13g2_nand2_1
X_23441_ _16014_ _16006_ \csr_i.mstatus[12]\ VPWR VGND sg13g2_nand2b_1
X_23442_ _00780_ _16013_ _16014_ _15994_ VPWR VGND sg13g2_a21oi_1
X_23443_ _16015_ \csr_i.data_in[13]\ _16010_ VPWR VGND sg13g2_nand2_1
X_23444_ _16016_ _16006_ \csr_i.mstatus[13]\ VPWR VGND sg13g2_nand2b_1
X_23445_ _16017_ _12950_ VPWR VGND sg13g2_buf_1
X_23446_ _00781_ _16015_ _16016_ _16017_ VPWR VGND sg13g2_a21oi_1
X_23447_ _16018_ \csr_i.data_in[14]\ _16010_ VPWR VGND sg13g2_nand2_1
X_23448_ _16019_ _16006_ \csr_i.mstatus[14]\ VPWR VGND sg13g2_nand2b_1
X_23449_ _00782_ _16018_ _16019_ _16017_ VPWR VGND sg13g2_a21oi_1
X_23450_ _16020_ \csr_i.data_in[15]\ _16010_ VPWR VGND sg13g2_nand2_1
X_23451_ _16021_ _16006_ \csr_i.mstatus[15]\ VPWR VGND sg13g2_nand2b_1
X_23452_ _00783_ _16020_ _16021_ _16017_ VPWR VGND sg13g2_a21oi_1
X_23453_ _16022_ \csr_i.data_in[16]\ _16010_ VPWR VGND sg13g2_nand2_1
X_23454_ _16023_ _16006_ \csr_i.mstatus[16]\ VPWR VGND sg13g2_nand2b_1
X_23455_ _00784_ _16022_ _16023_ _16017_ VPWR VGND sg13g2_a21oi_1
X_23456_ _16024_ \csr_i.data_in[17]\ _16010_ VPWR VGND sg13g2_nand2_1
X_23457_ _16025_ _16006_ \csr_i.mstatus[17]\ VPWR VGND sg13g2_nand2b_1
X_23458_ _00785_ _16024_ _16025_ _16017_ VPWR VGND sg13g2_a21oi_1
X_23459_ _16026_ \csr_i.data_in[18]\ _16010_ VPWR VGND sg13g2_nand2_1
X_23460_ _16027_ _16006_ \csr_i.mstatus[18]\ VPWR VGND sg13g2_nand2b_1
X_23461_ _00786_ _16026_ _16027_ _16017_ VPWR VGND sg13g2_a21oi_1
X_23462_ _16028_ \csr_i.data_in[19]\ _16010_ VPWR VGND sg13g2_nand2_1
X_23463_ _16029_ _15984_ VPWR VGND sg13g2_buf_1
X_23464_ _16030_ _16029_ \csr_i.mstatus[19]\ VPWR VGND sg13g2_nand2b_1
X_23465_ _00787_ _16028_ _16030_ _16017_ VPWR VGND sg13g2_a21oi_1
X_23466_ _16031_ \csr_i.data_in[20]\ _16010_ VPWR VGND sg13g2_nand2_1
X_23467_ _16032_ _16029_ \csr_i.mstatus[20]\ VPWR VGND sg13g2_nand2b_1
X_23468_ _00788_ _16031_ _16032_ _16017_ VPWR VGND sg13g2_a21oi_1
X_23469_ _16033_ _15984_ VPWR VGND sg13g2_buf_1
X_23470_ _16034_ \csr_i.data_in[21]\ _16033_ VPWR VGND sg13g2_nand2_1
X_23471_ _16035_ _16029_ \csr_i.mstatus[21]\ VPWR VGND sg13g2_nand2b_1
X_23472_ _00789_ _16034_ _16035_ _16017_ VPWR VGND sg13g2_a21oi_1
X_23473_ _16036_ \csr_i.data_in[22]\ _16033_ VPWR VGND sg13g2_nand2_1
X_23474_ _16037_ _16029_ \csr_i.mstatus[22]\ VPWR VGND sg13g2_nand2b_1
X_23475_ _00790_ _16036_ _16037_ _16017_ VPWR VGND sg13g2_a21oi_1
X_23476_ _16038_ \csr_i.data_in[23]\ _16033_ VPWR VGND sg13g2_nand2_1
X_23477_ _16039_ _16029_ \csr_i.mstatus[23]\ VPWR VGND sg13g2_nand2b_1
X_23478_ _16040_ _12950_ VPWR VGND sg13g2_buf_1
X_23479_ _00791_ _16038_ _16039_ _16040_ VPWR VGND sg13g2_a21oi_1
X_23480_ _16041_ \csr_i.data_in[24]\ _16033_ VPWR VGND sg13g2_nand2_1
X_23481_ _16042_ _16029_ \csr_i.mstatus[24]\ VPWR VGND sg13g2_nand2b_1
X_23482_ _00792_ _16041_ _16042_ _16040_ VPWR VGND sg13g2_a21oi_1
X_23483_ _16043_ \csr_i.data_in[25]\ _16033_ VPWR VGND sg13g2_nand2_1
X_23484_ _16044_ _16029_ \csr_i.mstatus[25]\ VPWR VGND sg13g2_nand2b_1
X_23485_ _00793_ _16043_ _16044_ _16040_ VPWR VGND sg13g2_a21oi_1
X_23486_ _16045_ \csr_i.data_in[26]\ _16033_ VPWR VGND sg13g2_nand2_1
X_23487_ _16046_ _16029_ \csr_i.mstatus[26]\ VPWR VGND sg13g2_nand2b_1
X_23488_ _00794_ _16045_ _16046_ _16040_ VPWR VGND sg13g2_a21oi_1
X_23489_ _16047_ \csr_i.data_in[27]\ _16033_ VPWR VGND sg13g2_nand2_1
X_23490_ _16048_ _16029_ \csr_i.mstatus[27]\ VPWR VGND sg13g2_nand2b_1
X_23491_ _00795_ _16047_ _16048_ _16040_ VPWR VGND sg13g2_a21oi_1
X_23492_ _16049_ \csr_i.data_in[28]\ _16033_ VPWR VGND sg13g2_nand2_1
X_23493_ _16050_ _16029_ \csr_i.mstatus[28]\ VPWR VGND sg13g2_nand2b_1
X_23494_ _00796_ _16049_ _16050_ _16040_ VPWR VGND sg13g2_a21oi_1
X_23495_ _16051_ \csr_i.data_in[29]\ _16033_ VPWR VGND sg13g2_nand2_1
X_23496_ _16052_ _15984_ \csr_i.mstatus[29]\ VPWR VGND sg13g2_nand2b_1
X_23497_ _00797_ _16051_ _16052_ _16040_ VPWR VGND sg13g2_a21oi_1
X_23498_ _16053_ \csr_i.data_in[30]\ _16033_ VPWR VGND sg13g2_nand2_1
X_23499_ _16054_ _15984_ \csr_i.mstatus[30]\ VPWR VGND sg13g2_nand2b_1
X_23500_ _00798_ _16053_ _16054_ _16040_ VPWR VGND sg13g2_a21oi_1
X_23501_ _16055_ \csr_i.data_in[31]\ _15982_ VPWR VGND sg13g2_nand2_1
X_23502_ _16056_ _15984_ \csr_i.mstatus[31]\ VPWR VGND sg13g2_nand2b_1
X_23503_ _00799_ _16055_ _16056_ _16040_ VPWR VGND sg13g2_a21oi_1
X_23504_ _16057_ \csr_i.addr_reg[2]\ _14332_ _14337_ _15979_ VPWR
+ VGND
+ sg13g2_and4_1
X_23505_ _16058_ _16057_ VPWR VGND sg13g2_buf_1
X_23506_ _16059_ _16058_ VPWR VGND sg13g2_buf_1
X_23507_ _16060_ _16059_ \csr_i.mie[0]\ VPWR VGND sg13g2_nand2b_1
X_23508_ _16061_ _16058_ VPWR VGND sg13g2_buf_1
X_23509_ _16062_ _16061_ VPWR VGND sg13g2_buf_1
X_23510_ _16063_ \csr_i.data_in[0]\ _16062_ VPWR VGND sg13g2_nand2_1
X_23511_ _00800_ _16060_ _16063_ _16040_ VPWR VGND sg13g2_a21oi_1
X_23512_ _16064_ _16059_ \csr_i.mie[1]\ VPWR VGND sg13g2_nand2b_1
X_23513_ _16065_ \csr_i.data_in[1]\ _16062_ VPWR VGND sg13g2_nand2_1
X_23514_ _16066_ _12950_ VPWR VGND sg13g2_buf_1
X_23515_ _00801_ _16064_ _16065_ _16066_ VPWR VGND sg13g2_a21oi_1
X_23516_ _16067_ _16059_ \csr_i.mie[2]\ VPWR VGND sg13g2_nand2b_1
X_23517_ _16068_ \csr_i.data_in[2]\ _16062_ VPWR VGND sg13g2_nand2_1
X_23518_ _00802_ _16067_ _16068_ _16066_ VPWR VGND sg13g2_a21oi_1
X_23519_ _16069_ _16059_ \csr_i.mie[3]\ VPWR VGND sg13g2_nand2b_1
X_23520_ _16070_ \csr_i.data_in[3]\ _16062_ VPWR VGND sg13g2_nand2_1
X_23521_ _00803_ _16069_ _16070_ _16066_ VPWR VGND sg13g2_a21oi_1
X_23522_ _16071_ _16059_ \csr_i.mie[4]\ VPWR VGND sg13g2_nand2b_1
X_23523_ _16072_ \csr_i.data_in[4]\ _16062_ VPWR VGND sg13g2_nand2_1
X_23524_ _00804_ _16071_ _16072_ _16066_ VPWR VGND sg13g2_a21oi_1
X_23525_ _16073_ _16059_ \csr_i.mie[5]\ VPWR VGND sg13g2_nand2b_1
X_23526_ _16074_ \csr_i.data_in[5]\ _16062_ VPWR VGND sg13g2_nand2_1
X_23527_ _00805_ _16073_ _16074_ _16066_ VPWR VGND sg13g2_a21oi_1
X_23528_ _16075_ _16059_ \csr_i.mie[6]\ VPWR VGND sg13g2_nand2b_1
X_23529_ _16076_ \csr_i.data_in[6]\ _16062_ VPWR VGND sg13g2_nand2_1
X_23530_ _00806_ _16075_ _16076_ _16066_ VPWR VGND sg13g2_a21oi_1
X_23531_ _16077_ _16059_ \csr_i.mie[7]\ VPWR VGND sg13g2_nand2b_1
X_23532_ _16078_ \csr_i.data_in[7]\ _16062_ VPWR VGND sg13g2_nand2_1
X_23533_ _00807_ _16077_ _16078_ _16066_ VPWR VGND sg13g2_a21oi_1
X_23534_ _16079_ _16061_ VPWR VGND sg13g2_buf_1
X_23535_ _16080_ _16079_ \csr_i.mie[8]\ VPWR VGND sg13g2_nand2b_1
X_23536_ _16081_ \csr_i.data_in[8]\ _16062_ VPWR VGND sg13g2_nand2_1
X_23537_ _00808_ _16080_ _16081_ _16066_ VPWR VGND sg13g2_a21oi_1
X_23538_ _16082_ _16079_ \csr_i.mie[9]\ VPWR VGND sg13g2_nand2b_1
X_23539_ _16083_ \csr_i.data_in[9]\ _16062_ VPWR VGND sg13g2_nand2_1
X_23540_ _00809_ _16082_ _16083_ _16066_ VPWR VGND sg13g2_a21oi_1
X_23541_ _16084_ _16079_ \csr_i.mie[10]\ VPWR VGND sg13g2_nand2b_1
X_23542_ _16085_ _16061_ VPWR VGND sg13g2_buf_1
X_23543_ _16086_ \csr_i.data_in[10]\ _16085_ VPWR VGND sg13g2_nand2_1
X_23544_ _00810_ _16084_ _16086_ _16066_ VPWR VGND sg13g2_a21oi_1
X_23545_ _16087_ _16079_ \csr_i.mie[11]\ VPWR VGND sg13g2_nand2b_1
X_23546_ _16088_ \csr_i.data_in[11]\ _16085_ VPWR VGND sg13g2_nand2_1
X_23547_ _16089_ _12950_ VPWR VGND sg13g2_buf_1
X_23548_ _00811_ _16087_ _16088_ _16089_ VPWR VGND sg13g2_a21oi_1
X_23549_ _16090_ _16079_ \csr_i.mie[12]\ VPWR VGND sg13g2_nand2b_1
X_23550_ _16091_ \csr_i.data_in[12]\ _16085_ VPWR VGND sg13g2_nand2_1
X_23551_ _00812_ _16090_ _16091_ _16089_ VPWR VGND sg13g2_a21oi_1
X_23552_ _16092_ _16079_ \csr_i.mie[13]\ VPWR VGND sg13g2_nand2b_1
X_23553_ _16093_ \csr_i.data_in[13]\ _16085_ VPWR VGND sg13g2_nand2_1
X_23554_ _00813_ _16092_ _16093_ _16089_ VPWR VGND sg13g2_a21oi_1
X_23555_ _16094_ _16079_ \csr_i.mie[14]\ VPWR VGND sg13g2_nand2b_1
X_23556_ _16095_ \csr_i.data_in[14]\ _16085_ VPWR VGND sg13g2_nand2_1
X_23557_ _00814_ _16094_ _16095_ _16089_ VPWR VGND sg13g2_a21oi_1
X_23558_ _16096_ _16079_ \csr_i.mie[15]\ VPWR VGND sg13g2_nand2b_1
X_23559_ _16097_ \csr_i.data_in[15]\ _16085_ VPWR VGND sg13g2_nand2_1
X_23560_ _00815_ _16096_ _16097_ _16089_ VPWR VGND sg13g2_a21oi_1
X_23561_ _16098_ _16079_ \csr_i.mie[16]\ VPWR VGND sg13g2_nand2b_1
X_23562_ _16099_ \csr_i.data_in[16]\ _16085_ VPWR VGND sg13g2_nand2_1
X_23563_ _00816_ _16098_ _16099_ _16089_ VPWR VGND sg13g2_a21oi_1
X_23564_ _16100_ _16079_ \csr_i.mie[17]\ VPWR VGND sg13g2_nand2b_1
X_23565_ _16101_ \csr_i.data_in[17]\ _16085_ VPWR VGND sg13g2_nand2_1
X_23566_ _00817_ _16100_ _16101_ _16089_ VPWR VGND sg13g2_a21oi_1
X_23567_ _16102_ _16061_ VPWR VGND sg13g2_buf_1
X_23568_ _16103_ _16102_ \csr_i.mie[18]\ VPWR VGND sg13g2_nand2b_1
X_23569_ _16104_ \csr_i.data_in[18]\ _16085_ VPWR VGND sg13g2_nand2_1
X_23570_ _00818_ _16103_ _16104_ _16089_ VPWR VGND sg13g2_a21oi_1
X_23571_ _16105_ _16102_ \csr_i.mie[19]\ VPWR VGND sg13g2_nand2b_1
X_23572_ _16106_ \csr_i.data_in[19]\ _16085_ VPWR VGND sg13g2_nand2_1
X_23573_ _00819_ _16105_ _16106_ _16089_ VPWR VGND sg13g2_a21oi_1
X_23574_ _16107_ _16102_ \csr_i.mie[20]\ VPWR VGND sg13g2_nand2b_1
X_23575_ _16108_ _16061_ VPWR VGND sg13g2_buf_1
X_23576_ _16109_ \csr_i.data_in[20]\ _16108_ VPWR VGND sg13g2_nand2_1
X_23577_ _00820_ _16107_ _16109_ _16089_ VPWR VGND sg13g2_a21oi_1
X_23578_ _16110_ _16102_ \csr_i.mie[21]\ VPWR VGND sg13g2_nand2b_1
X_23579_ _16111_ \csr_i.data_in[21]\ _16108_ VPWR VGND sg13g2_nand2_1
X_23580_ _16112_ _12948_ VPWR VGND sg13g2_buf_1
X_23581_ _16113_ _16112_ VPWR VGND sg13g2_buf_1
X_23582_ _00821_ _16110_ _16111_ _16113_ VPWR VGND sg13g2_a21oi_1
X_23583_ _16114_ _16102_ \csr_i.mie[22]\ VPWR VGND sg13g2_nand2b_1
X_23584_ _16115_ \csr_i.data_in[22]\ _16108_ VPWR VGND sg13g2_nand2_1
X_23585_ _00822_ _16114_ _16115_ _16113_ VPWR VGND sg13g2_a21oi_1
X_23586_ _16116_ _16102_ \csr_i.mie[23]\ VPWR VGND sg13g2_nand2b_1
X_23587_ _16117_ \csr_i.data_in[23]\ _16108_ VPWR VGND sg13g2_nand2_1
X_23588_ _00823_ _16116_ _16117_ _16113_ VPWR VGND sg13g2_a21oi_1
X_23589_ _16118_ _16102_ \csr_i.mie[24]\ VPWR VGND sg13g2_nand2b_1
X_23590_ _16119_ \csr_i.data_in[24]\ _16108_ VPWR VGND sg13g2_nand2_1
X_23591_ _00824_ _16118_ _16119_ _16113_ VPWR VGND sg13g2_a21oi_1
X_23592_ _16120_ _16102_ \csr_i.mie[25]\ VPWR VGND sg13g2_nand2b_1
X_23593_ _16121_ \csr_i.data_in[25]\ _16108_ VPWR VGND sg13g2_nand2_1
X_23594_ _00825_ _16120_ _16121_ _16113_ VPWR VGND sg13g2_a21oi_1
X_23595_ _16122_ _16102_ \csr_i.mie[26]\ VPWR VGND sg13g2_nand2b_1
X_23596_ _16123_ \csr_i.data_in[26]\ _16108_ VPWR VGND sg13g2_nand2_1
X_23597_ _00826_ _16122_ _16123_ _16113_ VPWR VGND sg13g2_a21oi_1
X_23598_ _16124_ _16102_ \csr_i.mie[27]\ VPWR VGND sg13g2_nand2b_1
X_23599_ _16125_ \csr_i.data_in[27]\ _16108_ VPWR VGND sg13g2_nand2_1
X_23600_ _00827_ _16124_ _16125_ _16113_ VPWR VGND sg13g2_a21oi_1
X_23601_ _16126_ _16061_ \csr_i.mie[28]\ VPWR VGND sg13g2_nand2b_1
X_23602_ _16127_ \csr_i.data_in[28]\ _16108_ VPWR VGND sg13g2_nand2_1
X_23603_ _00828_ _16126_ _16127_ _16113_ VPWR VGND sg13g2_a21oi_1
X_23604_ _16128_ _16061_ \csr_i.mie[29]\ VPWR VGND sg13g2_nand2b_1
X_23605_ _16129_ \csr_i.data_in[29]\ _16108_ VPWR VGND sg13g2_nand2_1
X_23606_ _00829_ _16128_ _16129_ _16113_ VPWR VGND sg13g2_a21oi_1
X_23607_ _16130_ _16061_ \csr_i.mie[30]\ VPWR VGND sg13g2_nand2b_1
X_23608_ _16131_ \csr_i.data_in[30]\ _16059_ VPWR VGND sg13g2_nand2_1
X_23609_ _00830_ _16130_ _16131_ _16113_ VPWR VGND sg13g2_a21oi_1
X_23610_ _16132_ _16061_ \csr_i.mie[31]\ VPWR VGND sg13g2_nand2b_1
X_23611_ _16133_ \csr_i.data_in[31]\ _16059_ VPWR VGND sg13g2_nand2_1
X_23612_ _16134_ _16112_ VPWR VGND sg13g2_buf_1
X_23613_ _00831_ _16132_ _16133_ _16134_ VPWR VGND sg13g2_a21oi_1
X_23614_ _16135_ \csr_i.addr_reg[6]\ _14347_ _14340_ VPWR VGND sg13g2_nor3_1
X_23615_ _16136_ _16135_ _15979_ VPWR VGND sg13g2_and2_1
X_23616_ _16137_ _16136_ VPWR VGND sg13g2_buf_1
X_23617_ _16138_ _16137_ VPWR VGND sg13g2_buf_1
X_23618_ _16139_ _16138_ \csr_i.mtvec[0]\ VPWR VGND sg13g2_nand2b_1
X_23619_ _16140_ _16137_ VPWR VGND sg13g2_buf_1
X_23620_ _16141_ _16140_ VPWR VGND sg13g2_buf_1
X_23621_ _16142_ \csr_i.data_in[0]\ _16141_ VPWR VGND sg13g2_nand2_1
X_23622_ _00832_ reset _16139_ _16142_ VPWR VGND sg13g2_nand3_1
X_23623_ _16143_ _16138_ \csr_i.mtvec[1]\ VPWR VGND sg13g2_nand2b_1
X_23624_ _16144_ \csr_i.data_in[1]\ _16141_ VPWR VGND sg13g2_nand2_1
X_23625_ _00833_ _16143_ _16144_ _16134_ VPWR VGND sg13g2_a21oi_1
X_23626_ _16145_ _16138_ \csr_i.mtvec[2]\ VPWR VGND sg13g2_nand2b_1
X_23627_ _16146_ \csr_i.data_in[2]\ _16141_ VPWR VGND sg13g2_nand2_1
X_23628_ _00834_ _16145_ _16146_ _16134_ VPWR VGND sg13g2_a21oi_1
X_23629_ _16147_ _16138_ \csr_i.mtvec[3]\ VPWR VGND sg13g2_nand2b_1
X_23630_ _16148_ \csr_i.data_in[3]\ _16141_ VPWR VGND sg13g2_nand2_1
X_23631_ _00835_ _16147_ _16148_ _16134_ VPWR VGND sg13g2_a21oi_1
X_23632_ _16149_ _16138_ \csr_i.mtvec[4]\ VPWR VGND sg13g2_nand2b_1
X_23633_ _16150_ \csr_i.data_in[4]\ _16141_ VPWR VGND sg13g2_nand2_1
X_23634_ _00836_ _16149_ _16150_ _16134_ VPWR VGND sg13g2_a21oi_1
X_23635_ _16151_ _16138_ \csr_i.mtvec[5]\ VPWR VGND sg13g2_nand2b_1
X_23636_ _16152_ \csr_i.data_in[5]\ _16141_ VPWR VGND sg13g2_nand2_1
X_23637_ _00837_ _16151_ _16152_ _16134_ VPWR VGND sg13g2_a21oi_1
X_23638_ _16153_ _16138_ \csr_i.mtvec[6]\ VPWR VGND sg13g2_nand2b_1
X_23639_ _16154_ \csr_i.data_in[6]\ _16141_ VPWR VGND sg13g2_nand2_1
X_23640_ _00838_ _16153_ _16154_ _16134_ VPWR VGND sg13g2_a21oi_1
X_23641_ _16155_ _16138_ \csr_i.mtvec[7]\ VPWR VGND sg13g2_nand2b_1
X_23642_ _16156_ \csr_i.data_in[7]\ _16141_ VPWR VGND sg13g2_nand2_1
X_23643_ _00839_ _16155_ _16156_ _16134_ VPWR VGND sg13g2_a21oi_1
X_23644_ _16157_ _16140_ VPWR VGND sg13g2_buf_1
X_23645_ _16158_ _16157_ \csr_i.mtvec[8]\ VPWR VGND sg13g2_nand2b_1
X_23646_ _16159_ \csr_i.data_in[8]\ _16141_ VPWR VGND sg13g2_nand2_1
X_23647_ _00840_ _16158_ _16159_ _16134_ VPWR VGND sg13g2_a21oi_1
X_23648_ _16160_ _16157_ \csr_i.mtvec[9]\ VPWR VGND sg13g2_nand2b_1
X_23649_ _16161_ \csr_i.data_in[9]\ _16141_ VPWR VGND sg13g2_nand2_1
X_23650_ _00841_ _16160_ _16161_ _16134_ VPWR VGND sg13g2_a21oi_1
X_23651_ _16162_ _16157_ \csr_i.mtvec[10]\ VPWR VGND sg13g2_nand2b_1
X_23652_ _16163_ _16140_ VPWR VGND sg13g2_buf_1
X_23653_ _16164_ \csr_i.data_in[10]\ _16163_ VPWR VGND sg13g2_nand2_1
X_23654_ _16165_ _16112_ VPWR VGND sg13g2_buf_1
X_23655_ _00842_ _16162_ _16164_ _16165_ VPWR VGND sg13g2_a21oi_1
X_23656_ _16166_ _16157_ \csr_i.mtvec[11]\ VPWR VGND sg13g2_nand2b_1
X_23657_ _16167_ \csr_i.data_in[11]\ _16163_ VPWR VGND sg13g2_nand2_1
X_23658_ _00843_ _16166_ _16167_ _16165_ VPWR VGND sg13g2_a21oi_1
X_23659_ _16168_ _16157_ \csr_i.mtvec[12]\ VPWR VGND sg13g2_nand2b_1
X_23660_ _16169_ \csr_i.data_in[12]\ _16163_ VPWR VGND sg13g2_nand2_1
X_23661_ _00844_ _16168_ _16169_ _16165_ VPWR VGND sg13g2_a21oi_1
X_23662_ _16170_ _16157_ \csr_i.mtvec[13]\ VPWR VGND sg13g2_nand2b_1
X_23663_ _16171_ \csr_i.data_in[13]\ _16163_ VPWR VGND sg13g2_nand2_1
X_23664_ _00845_ _16170_ _16171_ _16165_ VPWR VGND sg13g2_a21oi_1
X_23665_ _16172_ _16157_ \csr_i.mtvec[14]\ VPWR VGND sg13g2_nand2b_1
X_23666_ _16173_ \csr_i.data_in[14]\ _16163_ VPWR VGND sg13g2_nand2_1
X_23667_ _00846_ _16172_ _16173_ _16165_ VPWR VGND sg13g2_a21oi_1
X_23668_ _16174_ _16157_ \csr_i.mtvec[15]\ VPWR VGND sg13g2_nand2b_1
X_23669_ _16175_ \csr_i.data_in[15]\ _16163_ VPWR VGND sg13g2_nand2_1
X_23670_ _00847_ _16174_ _16175_ _16165_ VPWR VGND sg13g2_a21oi_1
X_23671_ _16176_ _16157_ \csr_i.mtvec[16]\ VPWR VGND sg13g2_nand2b_1
X_23672_ _16177_ \csr_i.data_in[16]\ _16163_ VPWR VGND sg13g2_nand2_1
X_23673_ _00848_ _16176_ _16177_ _16165_ VPWR VGND sg13g2_a21oi_1
X_23674_ _16178_ _16157_ \csr_i.mtvec[17]\ VPWR VGND sg13g2_nand2b_1
X_23675_ _16179_ \csr_i.data_in[17]\ _16163_ VPWR VGND sg13g2_nand2_1
X_23676_ _00849_ _16178_ _16179_ _16165_ VPWR VGND sg13g2_a21oi_1
X_23677_ _16180_ _16140_ VPWR VGND sg13g2_buf_1
X_23678_ _16181_ _16180_ \csr_i.mtvec[18]\ VPWR VGND sg13g2_nand2b_1
X_23679_ _16182_ \csr_i.data_in[18]\ _16163_ VPWR VGND sg13g2_nand2_1
X_23680_ _00850_ _16181_ _16182_ _16165_ VPWR VGND sg13g2_a21oi_1
X_23681_ _16183_ _16180_ \csr_i.mtvec[19]\ VPWR VGND sg13g2_nand2b_1
X_23682_ _16184_ \csr_i.data_in[19]\ _16163_ VPWR VGND sg13g2_nand2_1
X_23683_ _00851_ _16183_ _16184_ _16165_ VPWR VGND sg13g2_a21oi_1
X_23684_ _16185_ _16180_ \csr_i.mtvec[20]\ VPWR VGND sg13g2_nand2b_1
X_23685_ _16186_ _16140_ VPWR VGND sg13g2_buf_1
X_23686_ _16187_ \csr_i.data_in[20]\ _16186_ VPWR VGND sg13g2_nand2_1
X_23687_ _16188_ _16112_ VPWR VGND sg13g2_buf_1
X_23688_ _00852_ _16185_ _16187_ _16188_ VPWR VGND sg13g2_a21oi_1
X_23689_ _16189_ _16180_ \csr_i.mtvec[21]\ VPWR VGND sg13g2_nand2b_1
X_23690_ _16190_ \csr_i.data_in[21]\ _16186_ VPWR VGND sg13g2_nand2_1
X_23691_ _00853_ _16189_ _16190_ _16188_ VPWR VGND sg13g2_a21oi_1
X_23692_ _16191_ _16180_ \csr_i.mtvec[22]\ VPWR VGND sg13g2_nand2b_1
X_23693_ _16192_ \csr_i.data_in[22]\ _16186_ VPWR VGND sg13g2_nand2_1
X_23694_ _00854_ _16191_ _16192_ _16188_ VPWR VGND sg13g2_a21oi_1
X_23695_ _16193_ _16180_ \csr_i.mtvec[23]\ VPWR VGND sg13g2_nand2b_1
X_23696_ _16194_ \csr_i.data_in[23]\ _16186_ VPWR VGND sg13g2_nand2_1
X_23697_ _00855_ _16193_ _16194_ _16188_ VPWR VGND sg13g2_a21oi_1
X_23698_ _16195_ _16180_ \csr_i.mtvec[24]\ VPWR VGND sg13g2_nand2b_1
X_23699_ _16196_ \csr_i.data_in[24]\ _16186_ VPWR VGND sg13g2_nand2_1
X_23700_ _00856_ _16195_ _16196_ _16188_ VPWR VGND sg13g2_a21oi_1
X_23701_ _16197_ _16180_ \csr_i.mtvec[25]\ VPWR VGND sg13g2_nand2b_1
X_23702_ _16198_ \csr_i.data_in[25]\ _16186_ VPWR VGND sg13g2_nand2_1
X_23703_ _00857_ _16197_ _16198_ _16188_ VPWR VGND sg13g2_a21oi_1
X_23704_ _16199_ _16180_ \csr_i.mtvec[26]\ VPWR VGND sg13g2_nand2b_1
X_23705_ _16200_ \csr_i.data_in[26]\ _16186_ VPWR VGND sg13g2_nand2_1
X_23706_ _00858_ _16199_ _16200_ _16188_ VPWR VGND sg13g2_a21oi_1
X_23707_ _16201_ _16180_ \csr_i.mtvec[27]\ VPWR VGND sg13g2_nand2b_1
X_23708_ _16202_ \csr_i.data_in[27]\ _16186_ VPWR VGND sg13g2_nand2_1
X_23709_ _00859_ _16201_ _16202_ _16188_ VPWR VGND sg13g2_a21oi_1
X_23710_ _16203_ _16140_ \csr_i.mtvec[28]\ VPWR VGND sg13g2_nand2b_1
X_23711_ _16204_ \csr_i.data_in[28]\ _16186_ VPWR VGND sg13g2_nand2_1
X_23712_ _00860_ _16203_ _16204_ _16188_ VPWR VGND sg13g2_a21oi_1
X_23713_ _16205_ _16140_ \csr_i.mtvec[29]\ VPWR VGND sg13g2_nand2b_1
X_23714_ _16206_ \csr_i.data_in[29]\ _16186_ VPWR VGND sg13g2_nand2_1
X_23715_ _00861_ _16205_ _16206_ _16188_ VPWR VGND sg13g2_a21oi_1
X_23716_ _16207_ _16140_ \csr_i.mtvec[30]\ VPWR VGND sg13g2_nand2b_1
X_23717_ _16208_ \csr_i.data_in[30]\ _16138_ VPWR VGND sg13g2_nand2_1
X_23718_ _16209_ _16112_ VPWR VGND sg13g2_buf_1
X_23719_ _00862_ _16207_ _16208_ _16209_ VPWR VGND sg13g2_a21oi_1
X_23720_ _16210_ _16140_ \csr_i.mtvec[31]\ VPWR VGND sg13g2_nand2b_1
X_23721_ _16211_ \csr_i.data_in[31]\ _16138_ VPWR VGND sg13g2_nand2_1
X_23722_ _00863_ _16210_ _16211_ _16209_ VPWR VGND sg13g2_a21oi_1
X_23723_ _16212_ _14463_ _15979_ VPWR VGND sg13g2_and2_1
X_23724_ _16213_ _16212_ VPWR VGND sg13g2_buf_1
X_23725_ _16214_ _16213_ VPWR VGND sg13g2_buf_1
X_23726_ _16215_ _16214_ VPWR VGND sg13g2_buf_1
X_23727_ _16216_ _16214_ VPWR VGND sg13g2_buf_1
X_23728_ _16217_ \control_i.jump_to_isr\ \csr_i.isr_return[0]\ VPWR VGND sg13g2_nor2b_1
X_23729_ _16218_ \csr_i.pc[0]\ \control_i.jump_to_isr\ _16217_ VPWR VGND sg13g2_a21oi_1
X_23730_ _16219_ _16216_ _16218_ VPWR VGND sg13g2_nor2_1
X_23731_ _16220_ \csr_i.data_in[0]\ _16215_ _16219_ VPWR VGND sg13g2_a21oi_1
X_23732_ _00864_ _15478_ _16220_ VPWR VGND sg13g2_nor2_1
X_23733_ _16221_ _13307_ VPWR VGND sg13g2_buf_1
X_23734_ _16222_ \control_i.jump_to_isr\ \csr_i.isr_return[1]\ VPWR VGND sg13g2_nor2b_1
X_23735_ _16223_ \csr_i.pc[1]\ \control_i.jump_to_isr\ _16222_ VPWR VGND sg13g2_a21oi_1
X_23736_ _16224_ _16216_ _16223_ VPWR VGND sg13g2_nor2_1
X_23737_ _16225_ \csr_i.data_in[1]\ _16215_ _16224_ VPWR VGND sg13g2_a21oi_1
X_23738_ _00865_ _16221_ _16225_ VPWR VGND sg13g2_nor2_1
X_23739_ _16226_ \control_i.jump_to_isr\ \csr_i.isr_return[2]\ VPWR VGND sg13g2_nor2b_1
X_23740_ _16227_ \csr_i.pc[2]\ \control_i.jump_to_isr\ _16226_ VPWR VGND sg13g2_a21oi_1
X_23741_ _16228_ _16216_ _16227_ VPWR VGND sg13g2_nor2_1
X_23742_ _16229_ \csr_i.data_in[2]\ _16215_ _16228_ VPWR VGND sg13g2_a21oi_1
X_23743_ _00866_ _16221_ _16229_ VPWR VGND sg13g2_nor2_1
X_23744_ _16230_ \control_i.jump_to_isr\ \csr_i.isr_return[3]\ VPWR VGND sg13g2_nor2b_1
X_23745_ _16231_ \csr_i.pc[3]\ \control_i.jump_to_isr\ _16230_ VPWR VGND sg13g2_a21oi_1
X_23746_ _16232_ _16216_ _16231_ VPWR VGND sg13g2_nor2_1
X_23747_ _16233_ \csr_i.data_in[3]\ _16215_ _16232_ VPWR VGND sg13g2_a21oi_1
X_23748_ _00867_ _16221_ _16233_ VPWR VGND sg13g2_nor2_1
X_23749_ _16234_ \control_i.jump_to_isr\ \csr_i.isr_return[4]\ VPWR VGND sg13g2_nor2b_1
X_23750_ _16235_ \csr_i.pc[4]\ \control_i.jump_to_isr\ _16234_ VPWR VGND sg13g2_a21oi_1
X_23751_ _16236_ _16216_ _16235_ VPWR VGND sg13g2_nor2_1
X_23752_ _16237_ \csr_i.data_in[4]\ _16215_ _16236_ VPWR VGND sg13g2_a21oi_1
X_23753_ _00868_ _16221_ _16237_ VPWR VGND sg13g2_nor2_1
X_23754_ _16238_ \control_i.jump_to_isr\ \csr_i.isr_return[5]\ VPWR VGND sg13g2_nor2b_1
X_23755_ _16239_ \csr_i.pc[5]\ \control_i.jump_to_isr\ _16238_ VPWR VGND sg13g2_a21oi_1
X_23756_ _16240_ _16216_ _16239_ VPWR VGND sg13g2_nor2_1
X_23757_ _16241_ \csr_i.data_in[5]\ _16215_ _16240_ VPWR VGND sg13g2_a21oi_1
X_23758_ _00869_ _16221_ _16241_ VPWR VGND sg13g2_nor2_1
X_23759_ _16242_ \control_i.jump_to_isr\ \csr_i.isr_return[6]\ VPWR VGND sg13g2_nor2b_1
X_23760_ _16243_ \csr_i.pc[6]\ \control_i.jump_to_isr\ _16242_ VPWR VGND sg13g2_a21oi_1
X_23761_ _16244_ _16216_ _16243_ VPWR VGND sg13g2_nor2_1
X_23762_ _16245_ \csr_i.data_in[6]\ _16215_ _16244_ VPWR VGND sg13g2_a21oi_1
X_23763_ _00870_ _16221_ _16245_ VPWR VGND sg13g2_nor2_1
X_23764_ _16246_ \control_i.jump_to_isr\ \csr_i.isr_return[7]\ VPWR VGND sg13g2_nor2b_1
X_23765_ _16247_ \csr_i.pc[7]\ \control_i.jump_to_isr\ _16246_ VPWR VGND sg13g2_a21oi_1
X_23766_ _16248_ _16216_ _16247_ VPWR VGND sg13g2_nor2_1
X_23767_ _16249_ \csr_i.data_in[7]\ _16215_ _16248_ VPWR VGND sg13g2_a21oi_1
X_23768_ _00871_ _16221_ _16249_ VPWR VGND sg13g2_nor2_1
X_23769_ _16250_ _16214_ VPWR VGND sg13g2_buf_1
X_23770_ _16251_ \control_i.jump_to_isr\ \csr_i.isr_return[8]\ VPWR VGND sg13g2_nor2b_1
X_23771_ _16252_ \csr_i.pc[8]\ \control_i.jump_to_isr\ _16251_ VPWR VGND sg13g2_a21oi_1
X_23772_ _16253_ _16250_ _16252_ VPWR VGND sg13g2_nor2_1
X_23773_ _16254_ \csr_i.data_in[8]\ _16215_ _16253_ VPWR VGND sg13g2_a21oi_1
X_23774_ _00872_ _16221_ _16254_ VPWR VGND sg13g2_nor2_1
X_23775_ _16255_ \control_i.jump_to_isr\ \csr_i.isr_return[9]\ VPWR VGND sg13g2_nor2b_1
X_23776_ _16256_ \csr_i.pc[9]\ \control_i.jump_to_isr\ _16255_ VPWR VGND sg13g2_a21oi_1
X_23777_ _16257_ _16250_ _16256_ VPWR VGND sg13g2_nor2_1
X_23778_ _16258_ \csr_i.data_in[9]\ _16215_ _16257_ VPWR VGND sg13g2_a21oi_1
X_23779_ _00873_ _16221_ _16258_ VPWR VGND sg13g2_nor2_1
X_23780_ _16259_ _16214_ VPWR VGND sg13g2_buf_1
X_23781_ _16260_ \control_i.jump_to_isr\ \csr_i.isr_return[10]\ VPWR VGND sg13g2_nor2b_1
X_23782_ _16261_ \csr_i.pc[10]\ \control_i.jump_to_isr\ _16260_ VPWR VGND sg13g2_a21oi_1
X_23783_ _16262_ _16250_ _16261_ VPWR VGND sg13g2_nor2_1
X_23784_ _16263_ \csr_i.data_in[10]\ _16259_ _16262_ VPWR VGND sg13g2_a21oi_1
X_23785_ _00874_ _16221_ _16263_ VPWR VGND sg13g2_nor2_1
X_23786_ _16264_ _13307_ VPWR VGND sg13g2_buf_1
X_23787_ _16265_ \control_i.jump_to_isr\ \csr_i.isr_return[11]\ VPWR VGND sg13g2_nor2b_1
X_23788_ _16266_ \csr_i.pc[11]\ \control_i.jump_to_isr\ _16265_ VPWR VGND sg13g2_a21oi_1
X_23789_ _16267_ _16250_ _16266_ VPWR VGND sg13g2_nor2_1
X_23790_ _16268_ \csr_i.data_in[11]\ _16259_ _16267_ VPWR VGND sg13g2_a21oi_1
X_23791_ _00875_ _16264_ _16268_ VPWR VGND sg13g2_nor2_1
X_23792_ _16269_ \control_i.jump_to_isr\ \csr_i.isr_return[12]\ VPWR VGND sg13g2_nor2b_1
X_23793_ _16270_ \csr_i.pc[12]\ \control_i.jump_to_isr\ _16269_ VPWR VGND sg13g2_a21oi_1
X_23794_ _16271_ _16250_ _16270_ VPWR VGND sg13g2_nor2_1
X_23795_ _16272_ \csr_i.data_in[12]\ _16259_ _16271_ VPWR VGND sg13g2_a21oi_1
X_23796_ _00876_ _16264_ _16272_ VPWR VGND sg13g2_nor2_1
X_23797_ _16273_ \control_i.jump_to_isr\ \csr_i.isr_return[13]\ VPWR VGND sg13g2_nor2b_1
X_23798_ _16274_ \csr_i.pc[13]\ \control_i.jump_to_isr\ _16273_ VPWR VGND sg13g2_a21oi_1
X_23799_ _16275_ _16250_ _16274_ VPWR VGND sg13g2_nor2_1
X_23800_ _16276_ \csr_i.data_in[13]\ _16259_ _16275_ VPWR VGND sg13g2_a21oi_1
X_23801_ _00877_ _16264_ _16276_ VPWR VGND sg13g2_nor2_1
X_23802_ _16277_ \control_i.jump_to_isr\ \csr_i.isr_return[14]\ VPWR VGND sg13g2_nor2b_1
X_23803_ _16278_ \csr_i.pc[14]\ \control_i.jump_to_isr\ _16277_ VPWR VGND sg13g2_a21oi_1
X_23804_ _16279_ _16250_ _16278_ VPWR VGND sg13g2_nor2_1
X_23805_ _16280_ \csr_i.data_in[14]\ _16259_ _16279_ VPWR VGND sg13g2_a21oi_1
X_23806_ _00878_ _16264_ _16280_ VPWR VGND sg13g2_nor2_1
X_23807_ _16281_ \control_i.jump_to_isr\ \csr_i.isr_return[15]\ VPWR VGND sg13g2_nor2b_1
X_23808_ _16282_ \csr_i.pc[15]\ \control_i.jump_to_isr\ _16281_ VPWR VGND sg13g2_a21oi_1
X_23809_ _16283_ _16250_ _16282_ VPWR VGND sg13g2_nor2_1
X_23810_ _16284_ \csr_i.data_in[15]\ _16259_ _16283_ VPWR VGND sg13g2_a21oi_1
X_23811_ _00879_ _16264_ _16284_ VPWR VGND sg13g2_nor2_1
X_23812_ _16285_ \control_i.jump_to_isr\ \csr_i.isr_return[16]\ VPWR VGND sg13g2_nor2b_1
X_23813_ _16286_ \csr_i.pc[16]\ \control_i.jump_to_isr\ _16285_ VPWR VGND sg13g2_a21oi_1
X_23814_ _16287_ _16250_ _16286_ VPWR VGND sg13g2_nor2_1
X_23815_ _16288_ \csr_i.data_in[16]\ _16259_ _16287_ VPWR VGND sg13g2_a21oi_1
X_23816_ _00880_ _16264_ _16288_ VPWR VGND sg13g2_nor2_1
X_23817_ _16289_ \control_i.jump_to_isr\ \csr_i.isr_return[17]\ VPWR VGND sg13g2_nor2b_1
X_23818_ _16290_ \csr_i.pc[17]\ \control_i.jump_to_isr\ _16289_ VPWR VGND sg13g2_a21oi_1
X_23819_ _16291_ _16250_ _16290_ VPWR VGND sg13g2_nor2_1
X_23820_ _16292_ \csr_i.data_in[17]\ _16259_ _16291_ VPWR VGND sg13g2_a21oi_1
X_23821_ _00881_ _16264_ _16292_ VPWR VGND sg13g2_nor2_1
X_23822_ _16293_ _16213_ VPWR VGND sg13g2_buf_1
X_23823_ _16294_ \control_i.jump_to_isr\ \csr_i.isr_return[18]\ VPWR VGND sg13g2_nor2b_1
X_23824_ _16295_ \csr_i.pc[18]\ \control_i.jump_to_isr\ _16294_ VPWR VGND sg13g2_a21oi_1
X_23825_ _16296_ _16293_ _16295_ VPWR VGND sg13g2_nor2_1
X_23826_ _16297_ \csr_i.data_in[18]\ _16259_ _16296_ VPWR VGND sg13g2_a21oi_1
X_23827_ _00882_ _16264_ _16297_ VPWR VGND sg13g2_nor2_1
X_23828_ _16298_ \control_i.jump_to_isr\ \csr_i.isr_return[19]\ VPWR VGND sg13g2_nor2b_1
X_23829_ _16299_ \csr_i.pc[19]\ \control_i.jump_to_isr\ _16298_ VPWR VGND sg13g2_a21oi_1
X_23830_ _16300_ _16293_ _16299_ VPWR VGND sg13g2_nor2_1
X_23831_ _16301_ \csr_i.data_in[19]\ _16259_ _16300_ VPWR VGND sg13g2_a21oi_1
X_23832_ _00883_ _16264_ _16301_ VPWR VGND sg13g2_nor2_1
X_23833_ _16302_ _16214_ VPWR VGND sg13g2_buf_1
X_23834_ _16303_ \control_i.jump_to_isr\ \csr_i.isr_return[20]\ VPWR VGND sg13g2_nor2b_1
X_23835_ _16304_ \csr_i.pc[20]\ \control_i.jump_to_isr\ _16303_ VPWR VGND sg13g2_a21oi_1
X_23836_ _16305_ _16293_ _16304_ VPWR VGND sg13g2_nor2_1
X_23837_ _16306_ \csr_i.data_in[20]\ _16302_ _16305_ VPWR VGND sg13g2_a21oi_1
X_23838_ _00884_ _16264_ _16306_ VPWR VGND sg13g2_nor2_1
X_23839_ _16307_ _13307_ VPWR VGND sg13g2_buf_1
X_23840_ _16308_ \control_i.jump_to_isr\ \csr_i.isr_return[21]\ VPWR VGND sg13g2_nor2b_1
X_23841_ _16309_ \csr_i.pc[21]\ \control_i.jump_to_isr\ _16308_ VPWR VGND sg13g2_a21oi_1
X_23842_ _16310_ _16293_ _16309_ VPWR VGND sg13g2_nor2_1
X_23843_ _16311_ \csr_i.data_in[21]\ _16302_ _16310_ VPWR VGND sg13g2_a21oi_1
X_23844_ _00885_ _16307_ _16311_ VPWR VGND sg13g2_nor2_1
X_23845_ _16312_ \control_i.jump_to_isr\ \csr_i.isr_return[22]\ VPWR VGND sg13g2_nor2b_1
X_23846_ _16313_ \csr_i.pc[22]\ \control_i.jump_to_isr\ _16312_ VPWR VGND sg13g2_a21oi_1
X_23847_ _16314_ _16293_ _16313_ VPWR VGND sg13g2_nor2_1
X_23848_ _16315_ \csr_i.data_in[22]\ _16302_ _16314_ VPWR VGND sg13g2_a21oi_1
X_23849_ _00886_ _16307_ _16315_ VPWR VGND sg13g2_nor2_1
X_23850_ _16316_ \csr_i.mepc[23]\ VPWR VGND sg13g2_inv_1
X_23851_ _16317_ \control_i.jump_to_isr\ _16316_ _16293_ VPWR VGND sg13g2_nor3_1
X_23852_ _16318_ \csr_i.data_in[23]\ _16302_ _16317_ VPWR VGND sg13g2_a21oi_1
X_23853_ _00887_ _16307_ _16318_ VPWR VGND sg13g2_nor2_1
X_23854_ _16319_ \csr_i.mepc[24]\ VPWR VGND sg13g2_inv_1
X_23855_ _16320_ \control_i.jump_to_isr\ _16319_ _16293_ VPWR VGND sg13g2_nor3_1
X_23856_ _16321_ \csr_i.data_in[24]\ _16302_ _16320_ VPWR VGND sg13g2_a21oi_1
X_23857_ _00888_ _16307_ _16321_ VPWR VGND sg13g2_nor2_1
X_23858_ _16322_ \csr_i.mepc[25]\ VPWR VGND sg13g2_inv_1
X_23859_ _16323_ \control_i.jump_to_isr\ _16322_ _16293_ VPWR VGND sg13g2_nor3_1
X_23860_ _16324_ \csr_i.data_in[25]\ _16302_ _16323_ VPWR VGND sg13g2_a21oi_1
X_23861_ _00889_ _16307_ _16324_ VPWR VGND sg13g2_nor2_1
X_23862_ _16325_ \csr_i.mepc[26]\ VPWR VGND sg13g2_inv_1
X_23863_ _16326_ \control_i.jump_to_isr\ _16325_ _16293_ VPWR VGND sg13g2_nor3_1
X_23864_ _16327_ \csr_i.data_in[26]\ _16302_ _16326_ VPWR VGND sg13g2_a21oi_1
X_23865_ _00890_ _16307_ _16327_ VPWR VGND sg13g2_nor2_1
X_23866_ _16328_ \csr_i.mepc[27]\ VPWR VGND sg13g2_inv_1
X_23867_ _16329_ \control_i.jump_to_isr\ _16328_ _16293_ VPWR VGND sg13g2_nor3_1
X_23868_ _16330_ \csr_i.data_in[27]\ _16302_ _16329_ VPWR VGND sg13g2_a21oi_1
X_23869_ _00891_ _16307_ _16330_ VPWR VGND sg13g2_nor2_1
X_23870_ _16331_ \csr_i.mepc[28]\ VPWR VGND sg13g2_inv_1
X_23871_ _16332_ \control_i.jump_to_isr\ _16331_ _16214_ VPWR VGND sg13g2_nor3_1
X_23872_ _16333_ \csr_i.data_in[28]\ _16302_ _16332_ VPWR VGND sg13g2_a21oi_1
X_23873_ _00892_ _16307_ _16333_ VPWR VGND sg13g2_nor2_1
X_23874_ _16334_ \csr_i.mepc[29]\ VPWR VGND sg13g2_inv_1
X_23875_ _16335_ \control_i.jump_to_isr\ _16334_ _16214_ VPWR VGND sg13g2_nor3_1
X_23876_ _16336_ \csr_i.data_in[29]\ _16302_ _16335_ VPWR VGND sg13g2_a21oi_1
X_23877_ _00893_ _16307_ _16336_ VPWR VGND sg13g2_nor2_1
X_23878_ _16337_ \csr_i.mepc[30]\ VPWR VGND sg13g2_inv_1
X_23879_ _16338_ \control_i.jump_to_isr\ _16337_ _16214_ VPWR VGND sg13g2_nor3_1
X_23880_ _16339_ \csr_i.data_in[30]\ _16216_ _16338_ VPWR VGND sg13g2_a21oi_1
X_23881_ _00894_ _16307_ _16339_ VPWR VGND sg13g2_nor2_1
X_23882_ _16340_ _13307_ VPWR VGND sg13g2_buf_1
X_23883_ _16341_ \csr_i.mepc[31]\ VPWR VGND sg13g2_inv_1
X_23884_ _16342_ \control_i.jump_to_isr\ _16341_ _16214_ VPWR VGND sg13g2_nor3_1
X_23885_ _16343_ \csr_i.data_in[31]\ _16216_ _16342_ VPWR VGND sg13g2_a21oi_1
X_23886_ _00895_ _16340_ _16343_ VPWR VGND sg13g2_nor2_1
X_23887_ _16344_ \csr_i.mie[11]\ \csr_i.mip[11]\ _13257_ VPWR VGND sg13g2_a21o_1
X_23888_ _16345_ \csr_i.pc[1]\ \csr_i.pc[0]\ _13248_ VPWR VGND sg13g2_nor3_1
X_23889_ _16346_ \csr_i.addr_reg[1]\ \csr_i.addr_reg[6]\ _14333_ _14341_ VPWR
+ VGND
+ sg13g2_and4_1
X_23890_ _16347_ _16346_ _15979_ VPWR VGND sg13g2_and2_1
X_23891_ _16348_ _16347_ VPWR VGND sg13g2_buf_1
X_23892_ _16349_ _16348_ VPWR VGND sg13g2_buf_1
X_23893_ _16350_ \csr_i.data_in[0]\ _16349_ \control_i.load_access_fault\ VPWR VGND sg13g2_a21o_1
X_23894_ _16351_ _16345_ _16350_ _13259_ VPWR VGND sg13g2_a21o_1
X_23895_ _16352_ \csr_i.mie[11]\ \csr_i.mstatus[3]\ \csr_i.mip[11]\ VPWR VGND sg13g2_nand3_1
X_23896_ _16353_ _16352_ VPWR VGND sg13g2_buf_1
X_23897_ _16354_ _16353_ VPWR VGND sg13g2_inv_1
X_23898_ _16355_ \csr_i.mie[7]\ \csr_i.mstatus[3]\ \csr_i.mip[7]\ VPWR VGND sg13g2_nand3_1
X_23899_ _16356_ _16355_ VPWR VGND sg13g2_buf_1
X_23900_ _16357_ _13263_ _16356_ VPWR VGND sg13g2_nand2_1
X_23901_ _16358_ _13248_ _16357_ VPWR VGND sg13g2_nor2_1
X_23902_ _16359_ _13257_ _16358_ VPWR VGND sg13g2_nand2_1
X_23903_ _16360_ _16349_ _16354_ _16359_ VPWR VGND sg13g2_nor3_1
X_23904_ _16361_ _16344_ _16351_ _16360_ \csr_i.mcause[0]\ VPWR
+ VGND
+ sg13g2_a22oi_1
X_23905_ _00896_ _16340_ _16361_ VPWR VGND sg13g2_nor2_1
X_23906_ _16362_ _13263_ _16348_ VPWR VGND sg13g2_and2_1
X_23907_ _16363_ _16362_ VPWR VGND sg13g2_buf_1
X_23908_ _16364_ \csr_i.data_in[1]\ _16363_ _13259_ VPWR VGND sg13g2_a21oi_1
X_23909_ _16365_ _13248_ _16364_ VPWR VGND sg13g2_nand2b_1
X_23910_ _16366_ \csr_i.mcause[1]\ _16360_ _16365_ _16344_ VPWR
+ VGND
+ sg13g2_a22oi_1
X_23911_ _00897_ _16340_ _16366_ VPWR VGND sg13g2_nor2_1
X_23912_ _16367_ \csr_i.data_in[3]\ _13257_ _16356_ _16363_ VPWR
+ VGND
+ sg13g2_nand4_1
X_23913_ _16368_ _16353_ _16367_ VPWR VGND sg13g2_and2_1
X_23914_ _16369_ _16346_ _15979_ VPWR VGND sg13g2_nand2_1
X_23915_ _16370_ _16369_ VPWR VGND sg13g2_buf_1
X_23916_ _16371_ \csr_i.mcause[3]\ _13257_ _16370_ _16358_ VPWR
+ VGND
+ sg13g2_nand4_1
X_23917_ _00898_ _16368_ _16371_ _16209_ VPWR VGND sg13g2_a21oi_1
X_23918_ _16372_ \csr_i.mcause[31]\ _16360_ _16363_ \csr_i.data_in[31]\ _13261_
+ VPWR
+ VGND sg13g2_a221oi_1
X_23919_ _00899_ _16340_ _16372_ VPWR VGND sg13g2_nor2_1
X_23920_ _16373_ _16370_ VPWR VGND sg13g2_buf_1
X_23921_ _16374_ \csr_i.mcause[5]\ _16373_ VPWR VGND sg13g2_nand2_1
X_23922_ _16375_ _16349_ VPWR VGND sg13g2_buf_1
X_23923_ _16376_ \csr_i.data_in[5]\ _16375_ VPWR VGND sg13g2_nand2_1
X_23924_ _16377_ reset _16353_ VPWR VGND sg13g2_nand2_1
X_23925_ _16378_ _16359_ _16377_ VPWR VGND sg13g2_or2_1
X_23926_ _16379_ _16378_ VPWR VGND sg13g2_buf_1
X_23927_ _16380_ _16379_ VPWR VGND sg13g2_buf_1
X_23928_ _00900_ _16374_ _16376_ _16380_ VPWR VGND sg13g2_a21oi_1
X_23929_ _16381_ \csr_i.mcause[6]\ _16373_ VPWR VGND sg13g2_nand2_1
X_23930_ _16382_ \csr_i.data_in[6]\ _16375_ VPWR VGND sg13g2_nand2_1
X_23931_ _00901_ _16381_ _16382_ _16380_ VPWR VGND sg13g2_a21oi_1
X_23932_ _16383_ \csr_i.mcause[7]\ _16373_ VPWR VGND sg13g2_nand2_1
X_23933_ _16384_ \csr_i.data_in[7]\ _16375_ VPWR VGND sg13g2_nand2_1
X_23934_ _00902_ _16383_ _16384_ _16380_ VPWR VGND sg13g2_a21oi_1
X_23935_ _16385_ \csr_i.mcause[8]\ _16373_ VPWR VGND sg13g2_nand2_1
X_23936_ _16386_ \csr_i.data_in[8]\ _16375_ VPWR VGND sg13g2_nand2_1
X_23937_ _00903_ _16385_ _16386_ _16380_ VPWR VGND sg13g2_a21oi_1
X_23938_ _16387_ \csr_i.mcause[9]\ _16373_ VPWR VGND sg13g2_nand2_1
X_23939_ _16388_ \csr_i.data_in[9]\ _16375_ VPWR VGND sg13g2_nand2_1
X_23940_ _00904_ _16387_ _16388_ _16380_ VPWR VGND sg13g2_a21oi_1
X_23941_ _16389_ \csr_i.mcause[10]\ _16373_ VPWR VGND sg13g2_nand2_1
X_23942_ _16390_ \csr_i.data_in[10]\ _16375_ VPWR VGND sg13g2_nand2_1
X_23943_ _00905_ _16389_ _16390_ _16380_ VPWR VGND sg13g2_a21oi_1
X_23944_ _16391_ \csr_i.mcause[11]\ _16373_ VPWR VGND sg13g2_nand2_1
X_23945_ _16392_ \csr_i.data_in[11]\ _16375_ VPWR VGND sg13g2_nand2_1
X_23946_ _00906_ _16391_ _16392_ _16380_ VPWR VGND sg13g2_a21oi_1
X_23947_ _16393_ \csr_i.mcause[12]\ _16373_ VPWR VGND sg13g2_nand2_1
X_23948_ _16394_ \csr_i.data_in[12]\ _16375_ VPWR VGND sg13g2_nand2_1
X_23949_ _00907_ _16393_ _16394_ _16380_ VPWR VGND sg13g2_a21oi_1
X_23950_ _16395_ \csr_i.mcause[13]\ _16373_ VPWR VGND sg13g2_nand2_1
X_23951_ _16396_ \csr_i.data_in[13]\ _16375_ VPWR VGND sg13g2_nand2_1
X_23952_ _00908_ _16395_ _16396_ _16380_ VPWR VGND sg13g2_a21oi_1
X_23953_ _16397_ \csr_i.mcause[14]\ _16373_ VPWR VGND sg13g2_nand2_1
X_23954_ _16398_ \csr_i.data_in[14]\ _16375_ VPWR VGND sg13g2_nand2_1
X_23955_ _00909_ _16397_ _16398_ _16380_ VPWR VGND sg13g2_a21oi_1
X_23956_ _16399_ _16370_ VPWR VGND sg13g2_buf_1
X_23957_ _16400_ \csr_i.mcause[15]\ _16399_ VPWR VGND sg13g2_nand2_1
X_23958_ _16401_ _16349_ VPWR VGND sg13g2_buf_1
X_23959_ _16402_ \csr_i.data_in[15]\ _16401_ VPWR VGND sg13g2_nand2_1
X_23960_ _16403_ _16379_ VPWR VGND sg13g2_buf_1
X_23961_ _00910_ _16400_ _16402_ _16403_ VPWR VGND sg13g2_a21oi_1
X_23962_ _16404_ \csr_i.mcause[16]\ _16399_ VPWR VGND sg13g2_nand2_1
X_23963_ _16405_ \csr_i.data_in[16]\ _16401_ VPWR VGND sg13g2_nand2_1
X_23964_ _00911_ _16404_ _16405_ _16403_ VPWR VGND sg13g2_a21oi_1
X_23965_ _16406_ \csr_i.mcause[17]\ _16399_ VPWR VGND sg13g2_nand2_1
X_23966_ _16407_ \csr_i.data_in[17]\ _16401_ VPWR VGND sg13g2_nand2_1
X_23967_ _00912_ _16406_ _16407_ _16403_ VPWR VGND sg13g2_a21oi_1
X_23968_ _16408_ \csr_i.mcause[18]\ _16399_ VPWR VGND sg13g2_nand2_1
X_23969_ _16409_ \csr_i.data_in[18]\ _16401_ VPWR VGND sg13g2_nand2_1
X_23970_ _00913_ _16408_ _16409_ _16403_ VPWR VGND sg13g2_a21oi_1
X_23971_ _16410_ \csr_i.mcause[19]\ _16399_ VPWR VGND sg13g2_nand2_1
X_23972_ _16411_ \csr_i.data_in[19]\ _16401_ VPWR VGND sg13g2_nand2_1
X_23973_ _00914_ _16410_ _16411_ _16403_ VPWR VGND sg13g2_a21oi_1
X_23974_ _16412_ \csr_i.mcause[20]\ _16399_ VPWR VGND sg13g2_nand2_1
X_23975_ _16413_ \csr_i.data_in[20]\ _16401_ VPWR VGND sg13g2_nand2_1
X_23976_ _00915_ _16412_ _16413_ _16403_ VPWR VGND sg13g2_a21oi_1
X_23977_ _16414_ \csr_i.mcause[21]\ _16399_ VPWR VGND sg13g2_nand2_1
X_23978_ _16415_ \csr_i.data_in[21]\ _16401_ VPWR VGND sg13g2_nand2_1
X_23979_ _00916_ _16414_ _16415_ _16403_ VPWR VGND sg13g2_a21oi_1
X_23980_ _16416_ \csr_i.mcause[22]\ _16399_ VPWR VGND sg13g2_nand2_1
X_23981_ _16417_ \csr_i.data_in[22]\ _16401_ VPWR VGND sg13g2_nand2_1
X_23982_ _00917_ _16416_ _16417_ _16403_ VPWR VGND sg13g2_a21oi_1
X_23983_ _16418_ \csr_i.mcause[23]\ _16399_ VPWR VGND sg13g2_nand2_1
X_23984_ _16419_ \csr_i.data_in[23]\ _16401_ VPWR VGND sg13g2_nand2_1
X_23985_ _00918_ _16418_ _16419_ _16403_ VPWR VGND sg13g2_a21oi_1
X_23986_ _16420_ \csr_i.mcause[24]\ _16399_ VPWR VGND sg13g2_nand2_1
X_23987_ _16421_ \csr_i.data_in[24]\ _16401_ VPWR VGND sg13g2_nand2_1
X_23988_ _00919_ _16420_ _16421_ _16403_ VPWR VGND sg13g2_a21oi_1
X_23989_ _16422_ \csr_i.mcause[25]\ _16370_ VPWR VGND sg13g2_nand2_1
X_23990_ _16423_ \csr_i.data_in[25]\ _16349_ VPWR VGND sg13g2_nand2_1
X_23991_ _00920_ _16422_ _16423_ _16379_ VPWR VGND sg13g2_a21oi_1
X_23992_ _16424_ \csr_i.mcause[26]\ _16370_ VPWR VGND sg13g2_nand2_1
X_23993_ _16425_ \csr_i.data_in[26]\ _16349_ VPWR VGND sg13g2_nand2_1
X_23994_ _00921_ _16424_ _16425_ _16379_ VPWR VGND sg13g2_a21oi_1
X_23995_ _16426_ \csr_i.mcause[27]\ _16370_ VPWR VGND sg13g2_nand2_1
X_23996_ _16427_ \csr_i.data_in[27]\ _16349_ VPWR VGND sg13g2_nand2_1
X_23997_ _00922_ _16426_ _16427_ _16379_ VPWR VGND sg13g2_a21oi_1
X_23998_ _16428_ \csr_i.mcause[28]\ _16370_ VPWR VGND sg13g2_nand2_1
X_23999_ _16429_ \csr_i.data_in[28]\ _16349_ VPWR VGND sg13g2_nand2_1
X_24000_ _00923_ _16428_ _16429_ _16379_ VPWR VGND sg13g2_a21oi_1
X_24001_ _16430_ \csr_i.mcause[29]\ _16370_ VPWR VGND sg13g2_nand2_1
X_24002_ _16431_ \csr_i.data_in[29]\ _16349_ VPWR VGND sg13g2_nand2_1
X_24003_ _00924_ _16430_ _16431_ _16379_ VPWR VGND sg13g2_a21oi_1
X_24004_ _16432_ \csr_i.mcause[30]\ _16370_ VPWR VGND sg13g2_nand2_1
X_24005_ _16433_ \csr_i.data_in[30]\ _16349_ VPWR VGND sg13g2_nand2_1
X_24006_ _00925_ _16432_ _16433_ _16379_ VPWR VGND sg13g2_a21oi_1
X_24007_ _16434_ \csr_i.data_in[2]\ \csr_i.mcause[2]\ _16369_ VPWR VGND sg13g2_mux2_1
X_24008_ _16435_ \control_i.load_access_fault\ _16434_ _16345_ VPWR VGND sg13g2_o21ai_1
X_24009_ _16436_ reset _13257_ _16353_ VPWR VGND sg13g2_nand3_1
X_24010_ _00926_ _16356_ _16435_ _16436_ VPWR VGND sg13g2_a21oi_1
X_24011_ _16437_ \csr_i.data_in[4]\ \csr_i.mcause[4]\ _16370_ VPWR VGND sg13g2_mux2_1
X_24012_ _16438_ _16358_ _16437_ VPWR VGND sg13g2_nand2_1
X_24013_ _00927_ _13257_ _16438_ _16377_ VPWR VGND sg13g2_a21oi_1
X_24014_ _16439_ _14741_ _15979_ VPWR VGND sg13g2_and2_1
X_24015_ _16440_ _16439_ VPWR VGND sg13g2_buf_1
X_24016_ _16441_ \memory_i.mtimecmp[62]\ \memory_i.mtime[62]\ VPWR VGND sg13g2_nor2b_1
X_24017_ _16442_ \memory_i.mtime[63]\ _16441_ VPWR VGND sg13g2_nand2_1
X_24018_ _16443_ \memory_i.mtime[63]\ _16441_ VPWR VGND sg13g2_nor2_1
X_24019_ _16444_ _14741_ _15979_ _16442_ \memory_i.mtimecmp[63]\ _16443_
+ VPWR
+ VGND sg13g2_a221oi_1
X_24020_ _16445_ \csr_i.data_in[7]\ _16440_ _16444_ VPWR VGND sg13g2_a21oi_1
X_24021_ _16446_ \memory_i.mtimecmp[53]\ \memory_i.mtime[53]\ VPWR VGND sg13g2_nor2b_1
X_24022_ _16447_ \memory_i.mtimecmp[50]\ \memory_i.mtime[50]\ VPWR VGND sg13g2_nand2b_1
X_24023_ _16448_ \memory_i.mtime[51]\ VPWR VGND sg13g2_inv_1
X_24024_ _16449_ \memory_i.mtimecmp[51]\ _16447_ _16448_ VPWR VGND sg13g2_o21ai_1
X_24025_ _16450_ \memory_i.mtimecmp[51]\ _16447_ VPWR VGND sg13g2_nand2_1
X_24026_ _16451_ \memory_i.mtimecmp[52]\ \memory_i.mtime[52]\ VPWR VGND sg13g2_nor2b_1
X_24027_ _16452_ _16449_ _16450_ _16451_ VPWR VGND sg13g2_a21oi_1
X_24028_ _16453_ \memory_i.mtime[49]\ VPWR VGND sg13g2_inv_2
X_24029_ _16454_ \memory_i.mtimecmp[49]\ _16453_ VPWR VGND sg13g2_nor2_1
X_24030_ _16455_ \memory_i.mtimecmp[48]\ \memory_i.mtime[48]\ VPWR VGND sg13g2_nor2b_1
X_24031_ _16456_ \memory_i.mtime[50]\ \memory_i.mtimecmp[50]\ VPWR VGND sg13g2_nand2b_1
X_24032_ _16457_ \memory_i.mtimecmp[51]\ \memory_i.mtime[51]\ VPWR VGND sg13g2_xor2_1
X_24033_ _16458_ \memory_i.mtimecmp[49]\ _16453_ _16457_ VPWR VGND sg13g2_a21oi_1
X_24034_ _16459_ _16447_ _16456_ _16458_ VPWR VGND sg13g2_and3_1
X_24035_ _16460_ _16454_ _16455_ _16459_ VPWR VGND sg13g2_o21ai_1
X_24036_ _16461_ \memory_i.mtime[52]\ \memory_i.mtimecmp[52]\ VPWR VGND sg13g2_nor2b_1
X_24037_ _16462_ _16452_ _16460_ _16461_ VPWR VGND sg13g2_a21oi_1
X_24038_ _16463_ \memory_i.mtime[54]\ VPWR VGND sg13g2_inv_1
X_24039_ _16464_ \memory_i.mtimecmp[54]\ _16463_ VPWR VGND sg13g2_nor2_1
X_24040_ _16465_ \memory_i.mtime[54]\ \memory_i.mtimecmp[54]\ VPWR VGND sg13g2_nor2b_1
X_24041_ _16466_ \memory_i.mtime[53]\ \memory_i.mtimecmp[53]\ VPWR VGND sg13g2_nor2b_1
X_24042_ _16467_ \memory_i.mtimecmp[55]\ \memory_i.mtime[55]\ VPWR VGND sg13g2_xor2_1
X_24043_ _16468_ _16464_ _16465_ _16466_ _16467_ VPWR
+ VGND
+ sg13g2_nor4_1
X_24044_ _16469_ _16446_ _16462_ _16468_ VPWR VGND sg13g2_o21ai_1
X_24045_ _16470_ \memory_i.mtime[54]\ \memory_i.mtime[55]\ VPWR VGND sg13g2_nand2_1
X_24046_ _16471_ \memory_i.mtimecmp[54]\ _16470_ \memory_i.mtimecmp[55]\ VPWR VGND sg13g2_o21ai_1
X_24047_ _16472_ \memory_i.mtime[55]\ _16464_ _16471_ VPWR VGND sg13g2_o21ai_1
X_24048_ _16473_ \memory_i.mtimecmp[58]\ \memory_i.mtime[58]\ VPWR VGND sg13g2_xnor2_1
X_24049_ _16474_ \memory_i.mtimecmp[56]\ \memory_i.mtime[56]\ VPWR VGND sg13g2_xnor2_1
X_24050_ _16475_ \memory_i.mtimecmp[59]\ \memory_i.mtime[59]\ VPWR VGND sg13g2_xnor2_1
X_24051_ _16476_ \memory_i.mtimecmp[57]\ \memory_i.mtime[57]\ VPWR VGND sg13g2_xnor2_1
X_24052_ _16477_ _16473_ _16474_ _16475_ _16476_ VPWR
+ VGND
+ sg13g2_nand4_1
X_24053_ _16478_ _16469_ _16472_ _16477_ VPWR VGND sg13g2_a21oi_1
X_24054_ _16479_ \memory_i.mtime[60]\ VPWR VGND sg13g2_inv_1
X_24055_ _16480_ \memory_i.mtimecmp[61]\ \memory_i.mtime[61]\ VPWR VGND sg13g2_nand2b_1
X_24056_ _16481_ \memory_i.mtimecmp[60]\ _16479_ _16480_ VPWR VGND sg13g2_o21ai_1
X_24057_ _16482_ \memory_i.mtime[58]\ \memory_i.mtimecmp[58]\ VPWR VGND sg13g2_nor2b_1
X_24058_ _16483_ \memory_i.mtimecmp[56]\ \memory_i.mtime[56]\ VPWR VGND sg13g2_nor2b_1
X_24059_ _16484_ \memory_i.mtime[56]\ \memory_i.mtime[57]\ VPWR VGND sg13g2_nand2_1
X_24060_ _16485_ \memory_i.mtimecmp[56]\ _16484_ \memory_i.mtimecmp[57]\ VPWR VGND sg13g2_o21ai_1
X_24061_ _16486_ \memory_i.mtime[57]\ _16483_ _16485_ VPWR VGND sg13g2_o21ai_1
X_24062_ _16487_ \memory_i.mtimecmp[58]\ \memory_i.mtime[58]\ VPWR VGND sg13g2_nand2b_1
X_24063_ _16488_ _16482_ _16486_ _16487_ VPWR VGND sg13g2_o21ai_1
X_24064_ _16489_ \memory_i.mtime[59]\ _16488_ VPWR VGND sg13g2_nand2_1
X_24065_ _16490_ \memory_i.mtime[59]\ _16488_ VPWR VGND sg13g2_nor2_1
X_24066_ _16491_ \memory_i.mtimecmp[59]\ _16489_ _16490_ VPWR VGND sg13g2_a21oi_1
X_24067_ _16492_ _16478_ _16481_ _16491_ VPWR VGND sg13g2_nor3_1
X_24068_ _16493_ \memory_i.mtimecmp[45]\ \memory_i.mtime[45]\ VPWR VGND sg13g2_nor2b_1
X_24069_ _16494_ \memory_i.mtime[44]\ VPWR VGND sg13g2_inv_1
X_24070_ _16495_ \memory_i.mtimecmp[42]\ \memory_i.mtime[42]\ VPWR VGND sg13g2_xor2_1
X_24071_ _16496_ \memory_i.mtime[41]\ \memory_i.mtimecmp[41]\ VPWR VGND sg13g2_nor2b_1
X_24072_ _16497_ \memory_i.mtimecmp[43]\ \memory_i.mtime[43]\ VPWR VGND sg13g2_xor2_1
X_24073_ _16498_ _16495_ _16496_ _16497_ VPWR VGND sg13g2_nor3_1
X_24074_ _16499_ \memory_i.mtime[40]\ VPWR VGND sg13g2_inv_1
X_24075_ _16500_ \memory_i.mtimecmp[41]\ \memory_i.mtime[41]\ VPWR VGND sg13g2_nand2b_1
X_24076_ _16501_ \memory_i.mtimecmp[40]\ _16499_ _16500_ VPWR VGND sg13g2_o21ai_1
X_24077_ _16502_ \memory_i.mtimecmp[42]\ \memory_i.mtime[42]\ VPWR VGND sg13g2_nand2b_1
X_24078_ _16503_ \memory_i.mtime[43]\ VPWR VGND sg13g2_inv_1
X_24079_ _16504_ \memory_i.mtimecmp[43]\ _16502_ _16503_ VPWR VGND sg13g2_o21ai_1
X_24080_ _16505_ \memory_i.mtimecmp[43]\ _16502_ VPWR VGND sg13g2_nand2_1
X_24081_ _16506_ \memory_i.mtimecmp[44]\ _16494_ VPWR VGND sg13g2_nor2_1
X_24082_ _16507_ _16498_ _16501_ _16504_ _16505_ _16506_
+ VPWR
+ VGND sg13g2_a221oi_1
X_24083_ _16508_ \memory_i.mtimecmp[44]\ _16494_ _16507_ VPWR VGND sg13g2_a21oi_1
X_24084_ _16509_ \memory_i.mtimecmp[46]\ \memory_i.mtime[46]\ VPWR VGND sg13g2_nor2b_1
X_24085_ _16510_ \memory_i.mtime[46]\ \memory_i.mtimecmp[46]\ VPWR VGND sg13g2_nor2b_1
X_24086_ _16511_ \memory_i.mtime[45]\ \memory_i.mtimecmp[45]\ VPWR VGND sg13g2_nor2b_1
X_24087_ _16512_ \memory_i.mtimecmp[47]\ \memory_i.mtime[47]\ VPWR VGND sg13g2_xor2_1
X_24088_ _16513_ _16509_ _16510_ _16511_ _16512_ VPWR
+ VGND
+ sg13g2_nor4_1
X_24089_ _16514_ _16493_ _16508_ _16513_ VPWR VGND sg13g2_o21ai_1
X_24090_ _16515_ \memory_i.mtimecmp[47]\ VPWR VGND sg13g2_inv_1
X_24091_ _16516_ \memory_i.mtime[47]\ _16509_ _16515_ VPWR VGND sg13g2_a21o_1
X_24092_ _16517_ \memory_i.mtime[47]\ _16509_ _16516_ VPWR VGND sg13g2_o21ai_1
X_24093_ _16518_ _16492_ _16514_ _16517_ VPWR VGND sg13g2_nand3_1
X_24094_ _16519_ \memory_i.mtime[29]\ VPWR VGND sg13g2_inv_2
X_24095_ _16520_ \memory_i.mtimecmp[30]\ \memory_i.mtime[30]\ VPWR VGND sg13g2_nor2b_1
X_24096_ _16521_ \memory_i.mtime[30]\ \memory_i.mtime[31]\ VPWR VGND sg13g2_nand2_1
X_24097_ _16522_ \memory_i.mtimecmp[30]\ _16521_ \memory_i.mtimecmp[31]\ VPWR VGND sg13g2_o21ai_1
X_24098_ _16523_ \memory_i.mtime[31]\ _16520_ _16522_ VPWR VGND sg13g2_o21ai_1
X_24099_ _16524_ \memory_i.mtimecmp[29]\ _16519_ _16523_ VPWR VGND sg13g2_o21ai_1
X_24100_ _16525_ \memory_i.mtime[28]\ VPWR VGND sg13g2_inv_2
X_24101_ _16526_ \memory_i.mtimecmp[28]\ VPWR VGND sg13g2_inv_1
X_24102_ _16527_ \memory_i.mtimecmp[26]\ \memory_i.mtime[26]\ VPWR VGND sg13g2_xor2_1
X_24103_ _16528_ \memory_i.mtime[25]\ \memory_i.mtimecmp[25]\ VPWR VGND sg13g2_nor2b_1
X_24104_ _16529_ \memory_i.mtimecmp[27]\ \memory_i.mtime[27]\ VPWR VGND sg13g2_nor2b_1
X_24105_ _16530_ \memory_i.mtime[27]\ \memory_i.mtimecmp[27]\ VPWR VGND sg13g2_nor2b_1
X_24106_ _16531_ _16527_ _16528_ _16529_ _16530_ VPWR
+ VGND
+ sg13g2_nor4_1
X_24107_ _16532_ \memory_i.mtime[23]\ VPWR VGND sg13g2_inv_1
X_24108_ _16533_ \memory_i.mtime[24]\ VPWR VGND sg13g2_inv_2
X_24109_ _16534_ \memory_i.mtimecmp[22]\ VPWR VGND sg13g2_inv_1
X_24110_ _16535_ \memory_i.mtime[21]\ VPWR VGND sg13g2_inv_1
X_24111_ _16536_ \memory_i.mtimecmp[20]\ VPWR VGND sg13g2_inv_1
X_24112_ _16537_ \memory_i.mtime[19]\ VPWR VGND sg13g2_inv_4
X_24113_ _16538_ \memory_i.mtime[17]\ VPWR VGND sg13g2_inv_2
X_24114_ _16539_ \memory_i.mtime[15]\ VPWR VGND sg13g2_inv_1
X_24115_ _16540_ \memory_i.mtime[13]\ VPWR VGND sg13g2_inv_1
X_24116_ _16541_ \memory_i.mtime[11]\ VPWR VGND sg13g2_inv_1
X_24117_ _16542_ \memory_i.mtimecmp[10]\ VPWR VGND sg13g2_inv_1
X_24118_ _16543_ \memory_i.mtime[9]\ VPWR VGND sg13g2_inv_1
X_24119_ _16544_ \memory_i.mtime[7]\ VPWR VGND sg13g2_inv_1
X_24120_ _16545_ \memory_i.mtimecmp[5]\ VPWR VGND sg13g2_inv_1
X_24121_ _16546_ \memory_i.mtimecmp[3]\ VPWR VGND sg13g2_inv_1
X_24122_ _16547_ \memory_i.mtimecmp[2]\ VPWR VGND sg13g2_inv_1
X_24123_ _16548_ \memory_i.mtime[2]\ VPWR VGND sg13g2_inv_1
X_24124_ _16549_ \memory_i.mtime[0]\ \memory_i.mtimecmp[0]\ VPWR VGND sg13g2_nand2b_1
X_24125_ _16550_ \memory_i.mtime[1]\ _16549_ VPWR VGND sg13g2_nand2_1
X_24126_ _16551_ \memory_i.mtime[1]\ _16549_ VPWR VGND sg13g2_nor2_1
X_24127_ _16552_ \memory_i.mtimecmp[2]\ _16548_ _16550_ \memory_i.mtimecmp[1]\ _16551_
+ VPWR
+ VGND sg13g2_a221oi_1
X_24128_ _16553_ _16546_ \memory_i.mtime[3]\ \memory_i.mtime[2]\ _16547_ _16552_
+ VPWR
+ VGND sg13g2_a221oi_1
X_24129_ _16554_ \memory_i.mtime[4]\ \memory_i.mtimecmp[4]\ VPWR VGND sg13g2_nand2b_1
X_24130_ _16555_ _16546_ \memory_i.mtime[3]\ _16554_ VPWR VGND sg13g2_o21ai_1
X_24131_ _16556_ \memory_i.mtimecmp[4]\ \memory_i.mtime[4]\ VPWR VGND sg13g2_nand2b_1
X_24132_ _16557_ _16553_ _16555_ _16556_ VPWR VGND sg13g2_o21ai_1
X_24133_ _16558_ _16545_ \memory_i.mtime[5]\ _16557_ VPWR VGND sg13g2_o21ai_1
X_24134_ _16559_ \memory_i.mtimecmp[6]\ VPWR VGND sg13g2_inv_1
X_24135_ _16560_ _16545_ \memory_i.mtime[5]\ \memory_i.mtime[6]\ _16559_ VPWR
+ VGND
+ sg13g2_a22oi_1
X_24136_ _16561_ _16559_ \memory_i.mtime[6]\ VPWR VGND sg13g2_nor2_1
X_24137_ _16562_ \memory_i.mtimecmp[7]\ _16544_ _16558_ _16560_ _16561_
+ VPWR
+ VGND sg13g2_a221oi_1
X_24138_ _16563_ \memory_i.mtimecmp[8]\ \memory_i.mtime[8]\ VPWR VGND sg13g2_nand2b_1
X_24139_ _16564_ \memory_i.mtimecmp[7]\ _16544_ _16563_ VPWR VGND sg13g2_o21ai_1
X_24140_ _16565_ \memory_i.mtime[8]\ VPWR VGND sg13g2_inv_2
X_24141_ _16566_ \memory_i.mtimecmp[8]\ _16565_ VPWR VGND sg13g2_nand2_1
X_24142_ _16567_ _16562_ _16564_ _16566_ VPWR VGND sg13g2_o21ai_1
X_24143_ _16568_ \memory_i.mtimecmp[9]\ _16543_ _16567_ VPWR VGND sg13g2_o21ai_1
X_24144_ _16569_ \memory_i.mtime[10]\ VPWR VGND sg13g2_inv_1
X_24145_ _16570_ \memory_i.mtimecmp[9]\ _16543_ _16569_ \memory_i.mtimecmp[10]\ VPWR
+ VGND
+ sg13g2_a22oi_1
X_24146_ _16571_ _16542_ \memory_i.mtime[10]\ _16568_ _16570_ VPWR
+ VGND
+ sg13g2_a22oi_1
X_24147_ _16572_ \memory_i.mtimecmp[11]\ _16541_ _16571_ VPWR VGND sg13g2_a21o_1
X_24148_ _16573_ \memory_i.mtimecmp[11]\ VPWR VGND sg13g2_inv_1
X_24149_ _16574_ \memory_i.mtimecmp[12]\ VPWR VGND sg13g2_inv_1
X_24150_ _16575_ _16573_ \memory_i.mtime[11]\ \memory_i.mtime[12]\ _16574_ VPWR
+ VGND
+ sg13g2_a22oi_1
X_24151_ _16576_ _16574_ \memory_i.mtime[12]\ VPWR VGND sg13g2_nor2_1
X_24152_ _16577_ \memory_i.mtimecmp[13]\ _16540_ _16572_ _16575_ _16576_
+ VPWR
+ VGND sg13g2_a221oi_1
X_24153_ _16578_ \memory_i.mtimecmp[14]\ \memory_i.mtime[14]\ VPWR VGND sg13g2_nand2b_1
X_24154_ _16579_ \memory_i.mtimecmp[13]\ _16540_ _16578_ VPWR VGND sg13g2_o21ai_1
X_24155_ _16580_ \memory_i.mtime[14]\ \memory_i.mtimecmp[14]\ VPWR VGND sg13g2_nand2b_1
X_24156_ _16581_ _16577_ _16579_ _16580_ VPWR VGND sg13g2_o21ai_1
X_24157_ _16582_ \memory_i.mtimecmp[15]\ _16539_ _16581_ VPWR VGND sg13g2_a21o_1
X_24158_ _16583_ \memory_i.mtimecmp[15]\ VPWR VGND sg13g2_inv_1
X_24159_ _16584_ \memory_i.mtimecmp[16]\ VPWR VGND sg13g2_inv_1
X_24160_ _16585_ _16583_ \memory_i.mtime[15]\ \memory_i.mtime[16]\ _16584_ VPWR
+ VGND
+ sg13g2_a22oi_1
X_24161_ _16586_ _16584_ \memory_i.mtime[16]\ VPWR VGND sg13g2_nor2_1
X_24162_ _16587_ \memory_i.mtimecmp[17]\ _16538_ _16582_ _16585_ _16586_
+ VPWR
+ VGND sg13g2_a221oi_1
X_24163_ _16588_ \memory_i.mtimecmp[18]\ \memory_i.mtime[18]\ VPWR VGND sg13g2_nand2b_1
X_24164_ _16589_ \memory_i.mtimecmp[17]\ _16538_ _16588_ VPWR VGND sg13g2_o21ai_1
X_24165_ _16590_ \memory_i.mtime[18]\ \memory_i.mtimecmp[18]\ VPWR VGND sg13g2_nand2b_1
X_24166_ _16591_ _16587_ _16589_ _16590_ VPWR VGND sg13g2_o21ai_1
X_24167_ _16592_ \memory_i.mtimecmp[19]\ _16537_ _16591_ VPWR VGND sg13g2_o21ai_1
X_24168_ _16593_ \memory_i.mtime[20]\ VPWR VGND sg13g2_inv_1
X_24169_ _16594_ \memory_i.mtimecmp[19]\ _16537_ _16593_ \memory_i.mtimecmp[20]\ VPWR
+ VGND
+ sg13g2_a22oi_1
X_24170_ _16595_ _16536_ \memory_i.mtime[20]\ _16592_ _16594_ VPWR
+ VGND
+ sg13g2_a22oi_1
X_24171_ _16596_ \memory_i.mtimecmp[21]\ _16535_ _16595_ VPWR VGND sg13g2_o21ai_1
X_24172_ _16597_ \memory_i.mtime[22]\ VPWR VGND sg13g2_inv_1
X_24173_ _16598_ \memory_i.mtimecmp[21]\ _16535_ _16597_ \memory_i.mtimecmp[22]\ VPWR
+ VGND
+ sg13g2_a22oi_1
X_24174_ _16599_ _16534_ \memory_i.mtime[22]\ _16596_ _16598_ VPWR
+ VGND
+ sg13g2_a22oi_1
X_24175_ _16600_ \memory_i.mtimecmp[23]\ _16532_ _16533_ \memory_i.mtimecmp[24]\ _16599_
+ VPWR
+ VGND sg13g2_a221oi_1
X_24176_ _16601_ \memory_i.mtimecmp[24]\ _16533_ VPWR VGND sg13g2_nor2_1
X_24177_ _16602_ \memory_i.mtime[24]\ \memory_i.mtimecmp[24]\ VPWR VGND sg13g2_nor2b_1
X_24178_ _16603_ \memory_i.mtimecmp[23]\ _16532_ _16602_ VPWR VGND sg13g2_nor3_1
X_24179_ _16604_ _16600_ _16601_ _16603_ VPWR VGND sg13g2_or3_1
X_24180_ _16605_ \memory_i.mtimecmp[25]\ \memory_i.mtime[25]\ VPWR VGND sg13g2_nor2b_1
X_24181_ _16606_ \memory_i.mtime[25]\ \memory_i.mtime[26]\ VPWR VGND sg13g2_nand2_1
X_24182_ _16607_ \memory_i.mtimecmp[25]\ _16606_ \memory_i.mtimecmp[26]\ VPWR VGND sg13g2_o21ai_1
X_24183_ _16608_ \memory_i.mtime[26]\ _16605_ _16607_ VPWR VGND sg13g2_o21ai_1
X_24184_ _16609_ \memory_i.mtimecmp[27]\ \memory_i.mtime[27]\ VPWR VGND sg13g2_nand2b_1
X_24185_ _16610_ _16530_ _16608_ _16609_ VPWR VGND sg13g2_o21ai_1
X_24186_ _16611_ _16526_ \memory_i.mtime[28]\ _16531_ _16604_ _16610_
+ VPWR
+ VGND sg13g2_a221oi_1
X_24187_ _16612_ \memory_i.mtimecmp[28]\ _16525_ _16611_ VPWR VGND sg13g2_a21oi_1
X_24188_ _16613_ \memory_i.mtime[31]\ VPWR VGND sg13g2_inv_1
X_24189_ _16614_ \memory_i.mtimecmp[29]\ _16519_ VPWR VGND sg13g2_nand2_1
X_24190_ _16615_ \memory_i.mtime[30]\ \memory_i.mtimecmp[30]\ VPWR VGND sg13g2_nand2b_1
X_24191_ _16616_ _16614_ _16520_ _16615_ VPWR VGND sg13g2_o21ai_1
X_24192_ _16617_ \memory_i.mtimecmp[31]\ _16613_ _16616_ VPWR VGND sg13g2_o21ai_1
X_24193_ _16618_ \memory_i.mtimecmp[32]\ VPWR VGND sg13g2_inv_1
X_24194_ _16619_ \memory_i.mtimecmp[37]\ \memory_i.mtime[37]\ VPWR VGND sg13g2_nand2b_1
X_24195_ _16620_ _16618_ \memory_i.mtime[32]\ _16619_ VPWR VGND sg13g2_o21ai_1
X_24196_ _16621_ \memory_i.mtimecmp[31]\ _16613_ _16620_ VPWR VGND sg13g2_a21oi_1
X_24197_ _16622_ \memory_i.mtimecmp[38]\ \memory_i.mtime[38]\ VPWR VGND sg13g2_nand2b_1
X_24198_ _16623_ \memory_i.mtime[38]\ \memory_i.mtimecmp[38]\ VPWR VGND sg13g2_nand2b_1
X_24199_ _16624_ \memory_i.mtime[37]\ VPWR VGND sg13g2_inv_2
X_24200_ _16625_ \memory_i.mtimecmp[39]\ \memory_i.mtime[39]\ VPWR VGND sg13g2_xor2_1
X_24201_ _16626_ \memory_i.mtimecmp[37]\ _16624_ _16625_ VPWR VGND sg13g2_a21oi_1
X_24202_ _16627_ _16622_ _16623_ _16626_ VPWR VGND sg13g2_and3_1
X_24203_ _16628_ \memory_i.mtimecmp[33]\ VPWR VGND sg13g2_inv_1
X_24204_ _16629_ \memory_i.mtime[34]\ VPWR VGND sg13g2_inv_2
X_24205_ _16630_ \memory_i.mtimecmp[34]\ _16629_ VPWR VGND sg13g2_nor2_1
X_24206_ _16631_ \memory_i.mtime[34]\ \memory_i.mtimecmp[34]\ VPWR VGND sg13g2_nor2b_1
X_24207_ _16632_ \memory_i.mtimecmp[35]\ \memory_i.mtime[35]\ VPWR VGND sg13g2_xor2_1
X_24208_ _16633_ _16630_ _16631_ _16632_ VPWR VGND sg13g2_nor3_1
X_24209_ _16634_ _16628_ \memory_i.mtime[33]\ _16633_ VPWR VGND sg13g2_o21ai_1
X_24210_ _16635_ \memory_i.mtimecmp[36]\ VPWR VGND sg13g2_inv_1
X_24211_ _16636_ _16635_ \memory_i.mtime[36]\ VPWR VGND sg13g2_nor2_1
X_24212_ _16637_ _16618_ \memory_i.mtime[32]\ \memory_i.mtime[33]\ _16628_ VPWR
+ VGND
+ sg13g2_a22oi_1
X_24213_ _16638_ _16635_ \memory_i.mtime[36]\ VPWR VGND sg13g2_nand2_1
X_24214_ _16639_ _16636_ _16637_ _16638_ VPWR VGND sg13g2_nand3b_1
X_24215_ _16640_ _16634_ _16639_ VPWR VGND sg13g2_nor2_1
X_24216_ _16641_ _16617_ _16621_ _16627_ _16640_ VPWR
+ VGND
+ sg13g2_and4_1
X_24217_ _16642_ _16524_ _16612_ _16641_ VPWR VGND sg13g2_o21ai_1
X_24218_ _16643_ \memory_i.mtime[35]\ _16630_ VPWR VGND sg13g2_nand2_1
X_24219_ _16644_ \memory_i.mtimecmp[35]\ _16643_ VPWR VGND sg13g2_nand2_1
X_24220_ _16645_ \memory_i.mtime[35]\ _16630_ _16644_ VPWR VGND sg13g2_o21ai_1
X_24221_ _16646_ _16634_ _16637_ _16645_ VPWR VGND sg13g2_o21ai_1
X_24222_ _16647_ _16646_ _16638_ VPWR VGND sg13g2_nor2b_1
X_24223_ _16648_ _16636_ _16647_ _16619_ VPWR VGND sg13g2_o21ai_1
X_24224_ _16649_ \memory_i.mtime[38]\ \memory_i.mtime[39]\ VPWR VGND sg13g2_nand2_2
X_24225_ _16650_ \memory_i.mtimecmp[38]\ _16649_ \memory_i.mtimecmp[39]\ VPWR VGND sg13g2_o21ai_1
X_24226_ _16651_ \memory_i.mtime[39]\ _16622_ VPWR VGND sg13g2_nand2b_1
X_24227_ _16652_ _16627_ _16648_ _16650_ _16651_ VPWR
+ VGND
+ sg13g2_a22oi_1
X_24228_ _16653_ _16493_ _16501_ _16506_ VPWR VGND sg13g2_nor3_1
X_24229_ _16654_ \memory_i.mtimecmp[40]\ _16499_ _16494_ \memory_i.mtimecmp[44]\ VPWR
+ VGND
+ sg13g2_a22oi_1
X_24230_ _16655_ _16653_ _16654_ VPWR VGND sg13g2_and2_1
X_24231_ _16656_ _16513_ _16498_ _16655_ VPWR VGND sg13g2_nand3_1
X_24232_ _16657_ _16642_ _16652_ _16656_ VPWR VGND sg13g2_a21oi_1
X_24233_ _16658_ \memory_i.mtime[48]\ \memory_i.mtimecmp[48]\ VPWR VGND sg13g2_nor2b_1
X_24234_ _16659_ _16446_ _16454_ _16455_ _16658_ VPWR
+ VGND
+ sg13g2_nor4_1
X_24235_ _16660_ _16459_ _16659_ VPWR VGND sg13g2_nand2_1
X_24236_ _16661_ _16451_ _16461_ _16481_ _16660_ VPWR
+ VGND
+ sg13g2_nor4_1
X_24237_ _16662_ _16477_ _16468_ _16661_ VPWR VGND sg13g2_nand3b_1
X_24238_ _16663_ \memory_i.mtimecmp[62]\ \memory_i.mtime[62]\ VPWR VGND sg13g2_xnor2_1
X_24239_ _16664_ \memory_i.mtimecmp[60]\ _16479_ _16480_ VPWR VGND sg13g2_nand3_1
X_24240_ _16665_ \memory_i.mtime[61]\ VPWR VGND sg13g2_inv_2
X_24241_ _16666_ \memory_i.mtimecmp[63]\ \memory_i.mtime[63]\ VPWR VGND sg13g2_xor2_1
X_24242_ _16667_ \memory_i.mtimecmp[61]\ _16665_ _16666_ VPWR VGND sg13g2_a21oi_1
X_24243_ _16668_ reset _16663_ _16664_ _16667_ VPWR
+ VGND
+ sg13g2_nand4_1
X_24244_ _16669_ _14741_ _15979_ _16492_ _16662_ _16668_
+ VPWR
+ VGND sg13g2_a221oi_1
X_24245_ _16670_ _16518_ _16657_ _16669_ VPWR VGND sg13g2_o21ai_1
X_24246_ _00928_ _15734_ _16445_ _16670_ VPWR VGND sg13g2_o21ai_1
X_24247_ _16671_ _16440_ VPWR VGND sg13g2_buf_1
X_24248_ _16672_ \csr_i.mcause[4]\ \csr_i.mcause[2]\ \csr_i.mcause[30]\ \csr_i.mcause[29]\ VPWR
+ VGND
+ sg13g2_nor4_1
X_24249_ _16673_ \csr_i.mcause[8]\ \control_i.jump_to_isr\ VPWR VGND sg13g2_nor2b_1
X_24250_ _16674_ \csr_i.mcause[3]\ \csr_i.mcause[1]\ _16672_ _16673_ VPWR
+ VGND
+ sg13g2_nand4_1
X_24251_ _16675_ \csr_i.mcause[23]\ \csr_i.mcause[22]\ \csr_i.mcause[21]\ \csr_i.mcause[17]\ VPWR
+ VGND
+ sg13g2_nor4_1
X_24252_ _16676_ \csr_i.mcause[28]\ \csr_i.mcause[27]\ \csr_i.mcause[26]\ \csr_i.mcause[25]\ VPWR
+ VGND
+ sg13g2_nor4_1
X_24253_ _16677_ _16675_ _16676_ VPWR VGND sg13g2_nand2_1
X_24254_ _16678_ \csr_i.mcause[24]\ \csr_i.mcause[20]\ \csr_i.mcause[19]\ \csr_i.mcause[18]\ VPWR
+ VGND
+ sg13g2_or4_1
X_24255_ _16679_ _15285_ _16674_ _16677_ _16678_ VPWR
+ VGND
+ sg13g2_nor4_1
X_24256_ _16680_ \csr_i.mcause[16]\ \csr_i.mcause[7]\ \csr_i.mcause[6]\ \csr_i.mcause[5]\ VPWR
+ VGND
+ sg13g2_nor4_1
X_24257_ _16681_ \csr_i.mcause[12]\ \csr_i.mcause[11]\ \csr_i.mcause[10]\ \csr_i.mcause[9]\ VPWR
+ VGND
+ sg13g2_nor4_1
X_24258_ _16682_ \csr_i.mcause[15]\ \csr_i.mcause[14]\ \csr_i.mcause[13]\ VPWR VGND sg13g2_nor3_1
X_24259_ _16683_ _16679_ _16680_ _16681_ _16682_ VPWR
+ VGND
+ sg13g2_nand4_1
X_24260_ _16684_ \csr_i.mip[11]\ \csr_i.intr_ext_sync\ _16683_ VPWR VGND sg13g2_o21ai_1
X_24261_ _16685_ _16440_ _16684_ VPWR VGND sg13g2_nor2_1
X_24262_ _16686_ \csr_i.data_in[11]\ _16671_ _16685_ VPWR VGND sg13g2_a21oi_1
X_24263_ _00929_ _16340_ _16686_ VPWR VGND sg13g2_nor2_1
X_24264_ _16687_ \memory_i.uart_receiver.fsm_state[2]\ \memory_i.uart_receiver.fsm_state[1]\ _13300_ _13306_ VPWR
+ VGND
+ sg13g2_nor4_1
X_24265_ _16688_ \csr_i.mip[16]\ _16440_ _16687_ VPWR VGND sg13g2_nor3_1
X_24266_ _16689_ _16440_ VPWR VGND sg13g2_inv_1
X_24267_ _16690_ _16689_ VPWR VGND sg13g2_buf_1
X_24268_ _16691_ \csr_i.data_in[16]\ _16690_ reset VPWR VGND sg13g2_o21ai_1
X_24269_ _00930_ _16688_ _16691_ VPWR VGND sg13g2_nor2_1
X_24270_ _16692_ _16440_ VPWR VGND sg13g2_buf_1
X_24271_ _16693_ \csr_i.data_in[0]\ _16692_ VPWR VGND sg13g2_nand2_1
X_24272_ _16694_ _16689_ VPWR VGND sg13g2_buf_1
X_24273_ _16695_ \csr_i.mip[0]\ _16694_ VPWR VGND sg13g2_nand2_1
X_24274_ _00931_ _16693_ _16695_ _16209_ VPWR VGND sg13g2_a21oi_1
X_24275_ _16696_ \csr_i.data_in[1]\ _16692_ VPWR VGND sg13g2_nand2_1
X_24276_ _16697_ \csr_i.mip[1]\ _16694_ VPWR VGND sg13g2_nand2_1
X_24277_ _00932_ _16696_ _16697_ _16209_ VPWR VGND sg13g2_a21oi_1
X_24278_ _16698_ \csr_i.data_in[2]\ _16692_ VPWR VGND sg13g2_nand2_1
X_24279_ _16699_ \csr_i.mip[2]\ _16694_ VPWR VGND sg13g2_nand2_1
X_24280_ _00933_ _16698_ _16699_ _16209_ VPWR VGND sg13g2_a21oi_1
X_24281_ _16700_ \csr_i.data_in[3]\ _16692_ VPWR VGND sg13g2_nand2_1
X_24282_ _16701_ \csr_i.mip[3]\ _16694_ VPWR VGND sg13g2_nand2_1
X_24283_ _00934_ _16700_ _16701_ _16209_ VPWR VGND sg13g2_a21oi_1
X_24284_ _16702_ \csr_i.data_in[4]\ _16692_ VPWR VGND sg13g2_nand2_1
X_24285_ _16703_ \csr_i.mip[4]\ _16694_ VPWR VGND sg13g2_nand2_1
X_24286_ _00935_ _16702_ _16703_ _16209_ VPWR VGND sg13g2_a21oi_1
X_24287_ _16704_ \csr_i.data_in[5]\ _16692_ VPWR VGND sg13g2_nand2_1
X_24288_ _16705_ \csr_i.mip[5]\ _16694_ VPWR VGND sg13g2_nand2_1
X_24289_ _00936_ _16704_ _16705_ _16209_ VPWR VGND sg13g2_a21oi_1
X_24290_ _16706_ \csr_i.data_in[6]\ _16692_ VPWR VGND sg13g2_nand2_1
X_24291_ _16707_ \csr_i.mip[6]\ _16694_ VPWR VGND sg13g2_nand2_1
X_24292_ _00937_ _16706_ _16707_ _16209_ VPWR VGND sg13g2_a21oi_1
X_24293_ _16708_ \csr_i.data_in[8]\ _16692_ VPWR VGND sg13g2_nand2_1
X_24294_ _16709_ \csr_i.mip[8]\ _16694_ VPWR VGND sg13g2_nand2_1
X_24295_ _16710_ _16112_ VPWR VGND sg13g2_buf_1
X_24296_ _00938_ _16708_ _16709_ _16710_ VPWR VGND sg13g2_a21oi_1
X_24297_ _16711_ \csr_i.data_in[9]\ _16692_ VPWR VGND sg13g2_nand2_1
X_24298_ _16712_ \csr_i.mip[9]\ _16694_ VPWR VGND sg13g2_nand2_1
X_24299_ _00939_ _16711_ _16712_ _16710_ VPWR VGND sg13g2_a21oi_1
X_24300_ _16713_ \csr_i.data_in[10]\ _16692_ VPWR VGND sg13g2_nand2_1
X_24301_ _16714_ \csr_i.mip[10]\ _16694_ VPWR VGND sg13g2_nand2_1
X_24302_ _00940_ _16713_ _16714_ _16710_ VPWR VGND sg13g2_a21oi_1
X_24303_ _16715_ _16440_ VPWR VGND sg13g2_buf_1
X_24304_ _16716_ \csr_i.data_in[12]\ _16715_ VPWR VGND sg13g2_nand2_1
X_24305_ _16717_ _16689_ VPWR VGND sg13g2_buf_1
X_24306_ _16718_ \csr_i.mip[12]\ _16717_ VPWR VGND sg13g2_nand2_1
X_24307_ _00941_ _16716_ _16718_ _16710_ VPWR VGND sg13g2_a21oi_1
X_24308_ _16719_ \csr_i.data_in[13]\ _16715_ VPWR VGND sg13g2_nand2_1
X_24309_ _16720_ \csr_i.mip[13]\ _16717_ VPWR VGND sg13g2_nand2_1
X_24310_ _00942_ _16719_ _16720_ _16710_ VPWR VGND sg13g2_a21oi_1
X_24311_ _16721_ \csr_i.data_in[14]\ _16715_ VPWR VGND sg13g2_nand2_1
X_24312_ _16722_ \csr_i.mip[14]\ _16717_ VPWR VGND sg13g2_nand2_1
X_24313_ _00943_ _16721_ _16722_ _16710_ VPWR VGND sg13g2_a21oi_1
X_24314_ _16723_ \csr_i.data_in[15]\ _16715_ VPWR VGND sg13g2_nand2_1
X_24315_ _16724_ \csr_i.mip[15]\ _16717_ VPWR VGND sg13g2_nand2_1
X_24316_ _00944_ _16723_ _16724_ _16710_ VPWR VGND sg13g2_a21oi_1
X_24317_ _16725_ \csr_i.data_in[17]\ _16715_ VPWR VGND sg13g2_nand2_1
X_24318_ _16726_ \csr_i.mip[17]\ _16717_ VPWR VGND sg13g2_nand2_1
X_24319_ _00945_ _16725_ _16726_ _16710_ VPWR VGND sg13g2_a21oi_1
X_24320_ _16727_ \csr_i.data_in[18]\ _16715_ VPWR VGND sg13g2_nand2_1
X_24321_ _16728_ \csr_i.mip[18]\ _16717_ VPWR VGND sg13g2_nand2_1
X_24322_ _00946_ _16727_ _16728_ _16710_ VPWR VGND sg13g2_a21oi_1
X_24323_ _16729_ \csr_i.data_in[19]\ _16715_ VPWR VGND sg13g2_nand2_1
X_24324_ _16730_ \csr_i.mip[19]\ _16717_ VPWR VGND sg13g2_nand2_1
X_24325_ _00947_ _16729_ _16730_ _16710_ VPWR VGND sg13g2_a21oi_1
X_24326_ _16731_ \csr_i.data_in[20]\ _16715_ VPWR VGND sg13g2_nand2_1
X_24327_ _16732_ \csr_i.mip[20]\ _16717_ VPWR VGND sg13g2_nand2_1
X_24328_ _16733_ _16112_ VPWR VGND sg13g2_buf_1
X_24329_ _00948_ _16731_ _16732_ _16733_ VPWR VGND sg13g2_a21oi_1
X_24330_ _16734_ \csr_i.data_in[21]\ _16715_ VPWR VGND sg13g2_nand2_1
X_24331_ _16735_ \csr_i.mip[21]\ _16717_ VPWR VGND sg13g2_nand2_1
X_24332_ _00949_ _16734_ _16735_ _16733_ VPWR VGND sg13g2_a21oi_1
X_24333_ _16736_ \csr_i.data_in[22]\ _16715_ VPWR VGND sg13g2_nand2_1
X_24334_ _16737_ \csr_i.mip[22]\ _16717_ VPWR VGND sg13g2_nand2_1
X_24335_ _00950_ _16736_ _16737_ _16733_ VPWR VGND sg13g2_a21oi_1
X_24336_ _16738_ \csr_i.data_in[23]\ _16671_ VPWR VGND sg13g2_nand2_1
X_24337_ _16739_ \csr_i.mip[23]\ _16690_ VPWR VGND sg13g2_nand2_1
X_24338_ _00951_ _16738_ _16739_ _16733_ VPWR VGND sg13g2_a21oi_1
X_24339_ _16740_ \csr_i.data_in[24]\ _16671_ VPWR VGND sg13g2_nand2_1
X_24340_ _16741_ \csr_i.mip[24]\ _16690_ VPWR VGND sg13g2_nand2_1
X_24341_ _00952_ _16740_ _16741_ _16733_ VPWR VGND sg13g2_a21oi_1
X_24342_ _16742_ \csr_i.data_in[25]\ _16671_ VPWR VGND sg13g2_nand2_1
X_24343_ _16743_ \csr_i.mip[25]\ _16690_ VPWR VGND sg13g2_nand2_1
X_24344_ _00953_ _16742_ _16743_ _16733_ VPWR VGND sg13g2_a21oi_1
X_24345_ _16744_ \csr_i.data_in[26]\ _16671_ VPWR VGND sg13g2_nand2_1
X_24346_ _16745_ \csr_i.mip[26]\ _16690_ VPWR VGND sg13g2_nand2_1
X_24347_ _00954_ _16744_ _16745_ _16733_ VPWR VGND sg13g2_a21oi_1
X_24348_ _16746_ \csr_i.data_in[27]\ _16671_ VPWR VGND sg13g2_nand2_1
X_24349_ _16747_ \csr_i.mip[27]\ _16690_ VPWR VGND sg13g2_nand2_1
X_24350_ _00955_ _16746_ _16747_ _16733_ VPWR VGND sg13g2_a21oi_1
X_24351_ _16748_ \csr_i.data_in[28]\ _16671_ VPWR VGND sg13g2_nand2_1
X_24352_ _16749_ \csr_i.mip[28]\ _16690_ VPWR VGND sg13g2_nand2_1
X_24353_ _00956_ _16748_ _16749_ _16733_ VPWR VGND sg13g2_a21oi_1
X_24354_ _16750_ \csr_i.data_in[29]\ _16671_ VPWR VGND sg13g2_nand2_1
X_24355_ _16751_ \csr_i.mip[29]\ _16690_ VPWR VGND sg13g2_nand2_1
X_24356_ _00957_ _16750_ _16751_ _16733_ VPWR VGND sg13g2_a21oi_1
X_24357_ _16752_ \csr_i.data_in[30]\ _16671_ VPWR VGND sg13g2_nand2_1
X_24358_ _16753_ \csr_i.mip[30]\ _16690_ VPWR VGND sg13g2_nand2_1
X_24359_ _16754_ _12948_ VPWR VGND sg13g2_buf_1
X_24360_ _16755_ _16754_ VPWR VGND sg13g2_buf_1
X_24361_ _00958_ _16752_ _16753_ _16755_ VPWR VGND sg13g2_a21oi_1
X_24362_ _16756_ \csr_i.data_in[31]\ _16671_ VPWR VGND sg13g2_nand2_1
X_24363_ _16757_ \csr_i.mip[31]\ _16690_ VPWR VGND sg13g2_nand2_1
X_24364_ _00959_ _16756_ _16757_ _16755_ VPWR VGND sg13g2_a21oi_1
X_24365_ _16758_ \memory_i.datain[0]\ VPWR VGND sg13g2_inv_1
X_24366_ _16759_ _13007_ _13833_ VPWR VGND sg13g2_nor2_1
X_24367_ _16760_ _13316_ _16759_ VPWR VGND sg13g2_nand2_1
X_24368_ _16761_ _16760_ VPWR VGND sg13g2_buf_1
X_24369_ _16762_ gpio_out[0] _16761_ VPWR VGND sg13g2_nand2_1
X_24370_ _16763_ _16758_ _16761_ _16762_ VPWR VGND sg13g2_o21ai_1
X_24371_ _00960_ reset _16763_ VPWR VGND sg13g2_and2_1
X_24372_ _16764_ \memory_i.datain[1]\ VPWR VGND sg13g2_inv_1
X_24373_ _16765_ gpio_out[1] _16761_ VPWR VGND sg13g2_nand2_1
X_24374_ _16766_ _16764_ _16761_ _16765_ VPWR VGND sg13g2_o21ai_1
X_24375_ _00961_ reset _16766_ VPWR VGND sg13g2_and2_1
X_24376_ _16767_ \memory_i.datain[2]\ gpio_out[2] _16761_ VPWR VGND sg13g2_mux2_1
X_24377_ _00962_ reset _16767_ VPWR VGND sg13g2_and2_1
X_24378_ _16768_ \memory_i.datain[3]\ gpio_out[3] _16761_ VPWR VGND sg13g2_mux2_1
X_24379_ _00963_ reset _16768_ VPWR VGND sg13g2_and2_1
X_24380_ _16769_ \memory_i.ds_lo_conf[0]\ _14215_ VPWR VGND sg13g2_nand2_1
X_24381_ _16770_ \memory_i.uart_receiver.uart_rx_data[0]\ _13823_ _13935_ \memory_i.cordic_I[0]\ VPWR
+ VGND
+ sg13g2_a22oi_1
X_24382_ _16771_ \memory_i.mtime[0]\ _13883_ VPWR VGND sg13g2_nand2_1
X_24383_ _16772_ \memory_i.uart_transmitter.CYCLES_PER_BIT[0]\ _14106_ _14219_ \memory_i.ds_defaults[0]\ VPWR
+ VGND
+ sg13g2_a22oi_1
X_24384_ _16773_ \memory_i.mtime[32]\ _13868_ _13885_ \memory_i.i2c_acks[0]\ VPWR
+ VGND
+ sg13g2_a22oi_1
X_24385_ _16774_ _16771_ _16772_ _16773_ VPWR VGND sg13g2_nand3_1
X_24386_ _16775_ \memory_i.freq_inst.f_c[0]\ _13871_ _14213_ \memory_i.freq_inst.reset_n\ VPWR
+ VGND
+ sg13g2_a22oi_1
X_24387_ _16776_ \memory_i.uart_receiver.CYCLES_PER_BIT[0]\ _14127_ _13894_ \memory_i.mtimecmp[0]\ VPWR
+ VGND
+ sg13g2_a22oi_1
X_24388_ _16777_ \memory_i.uart_receiver.uart_rx_en\ _13857_ _13879_ \memory_i.i2c_mask[0]\ VPWR
+ VGND
+ sg13g2_a22oi_1
X_24389_ _16778_ \memory_i.mtimecmp[32]\ _13873_ _13878_ \memory_i.i2c_master.scl_ratio[0]\ VPWR
+ VGND
+ sg13g2_a22oi_1
X_24390_ _16779_ _16775_ _16776_ _16777_ _16778_ VPWR
+ VGND
+ sg13g2_nand4_1
X_24391_ _16780_ _16774_ _16779_ VPWR VGND sg13g2_nor2_1
X_24392_ _16781_ _16769_ _16770_ _16780_ VPWR VGND sg13g2_nand3_1
X_24393_ _16782_ \memory_i.i2c_addr[0]\ _13888_ _16781_ VPWR VGND sg13g2_a21oi_1
X_24394_ _16783_ \memory_i.state[2]\ \memory_i.state[1]\ _16759_ VPWR VGND sg13g2_nor3_1
X_24395_ _16784_ \memory_i.target[0]\ _13999_ VPWR VGND sg13g2_nor2b_1
X_24396_ _16785_ \memory_i.target[0]\ _13997_ _16784_ VPWR VGND sg13g2_a21oi_1
X_24397_ _16786_ \csr_i.intr_ext_sync\ _16783_ _16785_ \memory_i.state[2]\ VPWR
+ VGND
+ sg13g2_a22oi_1
X_24398_ _16787_ _13776_ _16782_ _16786_ VPWR VGND sg13g2_o21ai_1
X_24399_ _00964_ \mem_dataout[0]\ _16787_ _14163_ VPWR VGND sg13g2_mux2_1
X_24400_ _16788_ \memory_i.uart_receiver.recieved_data[7]\ \memory_i.uart_receiver.recieved_data[2]\ \memory_i.uart_receiver.recieved_data[1]\ \memory_i.uart_receiver.recieved_data[0]\ VPWR
+ VGND
+ sg13g2_nor4_1
X_24401_ _16789_ \memory_i.uart_receiver.recieved_data[6]\ \memory_i.uart_receiver.recieved_data[5]\ \memory_i.uart_receiver.recieved_data[4]\ \memory_i.uart_receiver.recieved_data[3]\ VPWR
+ VGND
+ sg13g2_nor4_1
X_24402_ _16790_ _16788_ _16789_ VPWR VGND sg13g2_nand2_1
X_24403_ _16791_ _13857_ _16687_ VPWR VGND sg13g2_nand2_1
X_24404_ _16792_ \memory_i.mtimecmp[1]\ _13894_ _14213_ \memory_i.freq_inst.start\ VPWR
+ VGND
+ sg13g2_a22oi_1
X_24405_ _16793_ _16790_ _16791_ _16792_ VPWR VGND sg13g2_o21ai_1
X_24406_ _16794_ \memory_i.cordic_I[1]\ _13934_ _14219_ \memory_i.ds_defaults[1]\ _16793_
+ VPWR
+ VGND sg13g2_a221oi_1
X_24407_ _16795_ \memory_i.mtime[1]\ _13903_ _13885_ \memory_i.i2c_acks[1]\ VPWR
+ VGND
+ sg13g2_a22oi_1
X_24408_ _16796_ \memory_i.mtime[33]\ _13901_ VPWR VGND sg13g2_nand2_1
X_24409_ _16797_ \memory_i.uart_receiver.uart_rx_data[1]\ _13823_ _14127_ \memory_i.uart_receiver.CYCLES_PER_BIT[1]\ VPWR
+ VGND
+ sg13g2_a22oi_1
X_24410_ _16798_ \memory_i.mtimecmp[33]\ _13873_ _13878_ \memory_i.i2c_master.scl_ratio[1]\ VPWR
+ VGND
+ sg13g2_a22oi_1
X_24411_ _16799_ \memory_i.ds_lo_conf[1]\ _13876_ _13879_ \memory_i.i2c_mask[1]\ VPWR
+ VGND
+ sg13g2_a22oi_1
X_24412_ _16800_ \memory_i.freq_inst.f_c[1]\ _13871_ _14106_ \memory_i.uart_transmitter.CYCLES_PER_BIT[1]\ VPWR
+ VGND
+ sg13g2_a22oi_1
X_24413_ _16801_ _16797_ _16798_ _16799_ _16800_ VPWR
+ VGND
+ sg13g2_and4_1
X_24414_ _16802_ _16794_ _16795_ _16796_ _16801_ VPWR
+ VGND
+ sg13g2_nand4_1
X_24415_ _16803_ \memory_i.i2c_addr[1]\ _13828_ _16802_ VPWR VGND sg13g2_a21oi_1
X_24416_ _16804_ \memory_i.target[0]\ _13986_ VPWR VGND sg13g2_nor2b_1
X_24417_ _16805_ \memory_i.target[0]\ _13984_ _16804_ VPWR VGND sg13g2_a21oi_1
X_24418_ _16806_ \memory_i.gpio_in_sync[1]\ _16783_ _16805_ \memory_i.state[2]\ VPWR
+ VGND
+ sg13g2_a22oi_1
X_24419_ _16807_ _13776_ _16803_ _16806_ VPWR VGND sg13g2_o21ai_1
X_24420_ _00965_ \mem_dataout[1]\ _16807_ _14163_ VPWR VGND sg13g2_mux2_1
X_24421_ _16808_ \memory_i.ds_lo_conf[2]\ _13876_ _13878_ \memory_i.i2c_master.scl_ratio[2]\ VPWR
+ VGND
+ sg13g2_a22oi_1
X_24422_ _16809_ \memory_i.uart_receiver.uart_rx_data[2]\ _13823_ _13894_ \memory_i.mtimecmp[2]\ VPWR
+ VGND
+ sg13g2_a22oi_1
X_24423_ _16810_ \memory_i.i2c_mask[2]\ _13879_ _13934_ \memory_i.cordic_I[2]\ VPWR
+ VGND
+ sg13g2_a22oi_1
X_24424_ _16811_ \memory_i.uart_receiver.CYCLES_PER_BIT[2]\ _14127_ _14219_ \memory_i.ds_defaults[2]\ VPWR
+ VGND
+ sg13g2_a22oi_1
X_24425_ _16812_ _16808_ _16809_ _16810_ _16811_ VPWR
+ VGND
+ sg13g2_nand4_1
X_24426_ _16813_ \memory_i.mtimecmp[34]\ _13873_ _14213_ _13187_ VPWR
+ VGND
+ sg13g2_a22oi_1
X_24427_ _16814_ \memory_i.freq_inst.f_c[2]\ _13871_ _14106_ \memory_i.uart_transmitter.CYCLES_PER_BIT[2]\ VPWR
+ VGND
+ sg13g2_a22oi_1
X_24428_ _16815_ _16813_ _16814_ VPWR VGND sg13g2_nand2_1
X_24429_ _16816_ _16812_ _16815_ VPWR VGND sg13g2_nor2_1
X_24430_ _16817_ \memory_i.mtime[2]\ _13883_ _13885_ \memory_i.i2c_acks[2]\ VPWR
+ VGND
+ sg13g2_a22oi_1
X_24431_ _16818_ \memory_i.mtime[34]\ _13901_ VPWR VGND sg13g2_nand2_1
X_24432_ _16819_ _16791_ _16816_ _16817_ _16818_ VPWR
+ VGND
+ sg13g2_nand4_1
X_24433_ _16820_ \memory_i.i2c_addr[2]\ _13828_ _16819_ VPWR VGND sg13g2_a21oi_1
X_24434_ _16821_ \memory_i.target[0]\ _13973_ VPWR VGND sg13g2_nor2b_1
X_24435_ _16822_ \memory_i.target[0]\ _13971_ _16821_ VPWR VGND sg13g2_a21oi_1
X_24436_ _16823_ \memory_i.gpio_in_sync[2]\ _16783_ _16822_ \memory_i.state[2]\ VPWR
+ VGND
+ sg13g2_a22oi_1
X_24437_ _16824_ _13776_ _16820_ _16823_ VPWR VGND sg13g2_o21ai_1
X_24438_ _00966_ \mem_dataout[2]\ _16824_ _13908_ VPWR VGND sg13g2_mux2_1
X_24439_ _16825_ \memory_i.i2c_acks[3]\ _13885_ VPWR VGND sg13g2_and2_1
X_24440_ _16826_ \memory_i.mtime[35]\ _13868_ _13883_ \memory_i.mtime[3]\ _16825_
+ VPWR
+ VGND sg13g2_a221oi_1
X_24441_ _16827_ \memory_i.uart_receiver.CYCLES_PER_BIT[3]\ _14127_ _14219_ \memory_i.ds_defaults[3]\ VPWR
+ VGND
+ sg13g2_a22oi_1
X_24442_ _16828_ \memory_i.ds_lo_conf[3]\ _13876_ _13878_ \memory_i.i2c_master.scl_ratio[3]\ VPWR
+ VGND
+ sg13g2_a22oi_1
X_24443_ _16829_ \memory_i.uart_receiver.uart_rx_data[3]\ _13823_ _13894_ \memory_i.mtimecmp[3]\ VPWR
+ VGND
+ sg13g2_a22oi_1
X_24444_ _16830_ \memory_i.freq_inst.f_c[3]\ _13871_ _14213_ lo_I_oe VPWR
+ VGND
+ sg13g2_a22oi_1
X_24445_ _16831_ _16827_ _16828_ _16829_ _16830_ VPWR
+ VGND
+ sg13g2_and4_1
X_24446_ _16832_ \memory_i.i2c_mask[3]\ _13879_ _13935_ \memory_i.cordic_I[3]\ VPWR
+ VGND
+ sg13g2_a22oi_1
X_24447_ _16833_ \memory_i.mtimecmp[35]\ _13898_ _14106_ \memory_i.uart_transmitter.CYCLES_PER_BIT[3]\ VPWR
+ VGND
+ sg13g2_a22oi_1
X_24448_ _16834_ _16826_ _16831_ _16832_ _16833_ VPWR
+ VGND
+ sg13g2_nand4_1
X_24449_ _16835_ \memory_i.i2c_addr[3]\ _13888_ _16834_ VPWR VGND sg13g2_a21oi_1
X_24450_ _16836_ \memory_i.target[0]\ _13960_ VPWR VGND sg13g2_nor2b_1
X_24451_ _16837_ \memory_i.target[0]\ _13958_ _16836_ VPWR VGND sg13g2_a21oi_1
X_24452_ _16838_ \memory_i.gpio_in_sync[3]\ _16783_ _16837_ \memory_i.state[2]\ VPWR
+ VGND
+ sg13g2_a22oi_1
X_24453_ _16839_ _13776_ _16835_ _16838_ VPWR VGND sg13g2_o21ai_1
X_24454_ _00967_ \mem_dataout[3]\ _16839_ _13908_ VPWR VGND sg13g2_mux2_1
X_24455_ _16840_ _13318_ _13020_ VPWR VGND sg13g2_nor2_1
X_24456_ _00968_ _13758_ _13024_ _16840_ VPWR VGND sg13g2_a21oi_1
X_24457_ _16841_ _13325_ _13020_ VPWR VGND sg13g2_nor2_1
X_24458_ _00969_ _13805_ _13024_ _16841_ VPWR VGND sg13g2_a21oi_1
X_24459_ _16842_ _13019_ VPWR VGND sg13g2_buf_1
X_24460_ _00970_ _13027_ \memory_i.addr_reg[2]\ _16842_ VPWR VGND sg13g2_mux2_1
X_24461_ _16843_ \memory_i.addr_reg[3]\ _16842_ VPWR VGND sg13g2_nand2_1
X_24462_ _00971_ _12997_ _13024_ _16843_ VPWR VGND sg13g2_o21ai_1
X_24463_ _16844_ _12956_ VPWR VGND sg13g2_buf_1
X_24464_ _16845_ _13025_ VPWR VGND sg13g2_buf_1
X_24465_ _16846_ \csr_i.pc[4]\ _16845_ VPWR VGND sg13g2_and2_1
X_24466_ _16847_ \rd_alu[4]\ _16844_ _16846_ VPWR VGND sg13g2_a21oi_1
X_24467_ _16848_ \memory_i.addr_reg[4]\ _16842_ VPWR VGND sg13g2_nand2_1
X_24468_ _00972_ _13024_ _16847_ _16848_ VPWR VGND sg13g2_o21ai_1
X_24469_ _16849_ \csr_i.pc[5]\ _16845_ VPWR VGND sg13g2_and2_1
X_24470_ _16850_ \rd_alu[5]\ _16844_ _16849_ VPWR VGND sg13g2_a21oi_1
X_24471_ _16851_ \memory_i.addr_reg[5]\ _16842_ VPWR VGND sg13g2_nand2_1
X_24472_ _00973_ _13024_ _16850_ _16851_ VPWR VGND sg13g2_o21ai_1
X_24473_ _16852_ _12956_ VPWR VGND sg13g2_buf_1
X_24474_ _16853_ \csr_i.pc[6]\ _16845_ VPWR VGND sg13g2_and2_1
X_24475_ _16854_ \rd_alu[6]\ _16852_ _16853_ VPWR VGND sg13g2_a21oi_1
X_24476_ _16855_ \memory_i.addr_reg[6]\ _16842_ VPWR VGND sg13g2_nand2_1
X_24477_ _00974_ _13024_ _16854_ _16855_ VPWR VGND sg13g2_o21ai_1
X_24478_ _16856_ \csr_i.pc[7]\ _16845_ VPWR VGND sg13g2_and2_1
X_24479_ _16857_ \rd_alu[7]\ _16852_ _16856_ VPWR VGND sg13g2_a21oi_1
X_24480_ _16858_ \memory_i.addr_reg[7]\ _16842_ VPWR VGND sg13g2_nand2_1
X_24481_ _00975_ _13024_ _16857_ _16858_ VPWR VGND sg13g2_o21ai_1
X_24482_ _16859_ \csr_i.pc[8]\ _16845_ VPWR VGND sg13g2_and2_1
X_24483_ _16860_ \rd_alu[8]\ _16852_ _16859_ VPWR VGND sg13g2_a21oi_1
X_24484_ _16861_ \memory_i.addr_reg[8]\ _16842_ VPWR VGND sg13g2_nand2_1
X_24485_ _00976_ _13024_ _16860_ _16861_ VPWR VGND sg13g2_o21ai_1
X_24486_ _16862_ _13020_ VPWR VGND sg13g2_buf_1
X_24487_ _16863_ \csr_i.pc[9]\ _16845_ VPWR VGND sg13g2_and2_1
X_24488_ _16864_ \rd_alu[9]\ _16852_ _16863_ VPWR VGND sg13g2_a21oi_1
X_24489_ _16865_ \memory_i.addr_reg[9]\ _16842_ VPWR VGND sg13g2_nand2_1
X_24490_ _00977_ _16862_ _16864_ _16865_ VPWR VGND sg13g2_o21ai_1
X_24491_ _16866_ _12956_ VPWR VGND sg13g2_buf_1
X_24492_ _16867_ _14557_ _16866_ VPWR VGND sg13g2_nor2_1
X_24493_ _16868_ \rd_alu[10]\ _16852_ _16867_ VPWR VGND sg13g2_a21oi_1
X_24494_ _16869_ _13020_ VPWR VGND sg13g2_buf_1
X_24495_ _16870_ \memory_i.addr_reg[10]\ _16869_ VPWR VGND sg13g2_nand2_1
X_24496_ _00978_ _16862_ _16868_ _16870_ VPWR VGND sg13g2_o21ai_1
X_24497_ _16871_ \csr_i.pc[11]\ _16845_ VPWR VGND sg13g2_and2_1
X_24498_ _16872_ \rd_alu[11]\ _16852_ _16871_ VPWR VGND sg13g2_a21oi_1
X_24499_ _16873_ \memory_i.addr_reg[11]\ _16869_ VPWR VGND sg13g2_nand2_1
X_24500_ _00979_ _16862_ _16872_ _16873_ VPWR VGND sg13g2_o21ai_1
X_24501_ _16874_ \csr_i.pc[12]\ _16845_ VPWR VGND sg13g2_and2_1
X_24502_ _16875_ \rd_alu[12]\ _16852_ _16874_ VPWR VGND sg13g2_a21oi_1
X_24503_ _16876_ \memory_i.addr_reg[12]\ _16869_ VPWR VGND sg13g2_nand2_1
X_24504_ _00980_ _16862_ _16875_ _16876_ VPWR VGND sg13g2_o21ai_1
X_24505_ _16877_ _14599_ _16866_ VPWR VGND sg13g2_nor2_1
X_24506_ _16878_ \rd_alu[13]\ _16852_ _16877_ VPWR VGND sg13g2_a21oi_1
X_24507_ _16879_ \memory_i.addr_reg[13]\ _16869_ VPWR VGND sg13g2_nand2_1
X_24508_ _00981_ _16862_ _16878_ _16879_ VPWR VGND sg13g2_o21ai_1
X_24509_ _16880_ \csr_i.pc[14]\ _13025_ VPWR VGND sg13g2_and2_1
X_24510_ _16881_ \rd_alu[14]\ _16852_ _16880_ VPWR VGND sg13g2_a21oi_1
X_24511_ _16882_ \memory_i.addr_reg[14]\ _16869_ VPWR VGND sg13g2_nand2_1
X_24512_ _00982_ _16862_ _16881_ _16882_ VPWR VGND sg13g2_o21ai_1
X_24513_ _16883_ \csr_i.pc[15]\ _13025_ VPWR VGND sg13g2_and2_1
X_24514_ _16884_ \rd_alu[15]\ _16852_ _16883_ VPWR VGND sg13g2_a21oi_1
X_24515_ _16885_ \memory_i.addr_reg[15]\ _16869_ VPWR VGND sg13g2_nand2_1
X_24516_ _00983_ _16862_ _16884_ _16885_ VPWR VGND sg13g2_o21ai_1
X_24517_ _16886_ _14643_ _16866_ VPWR VGND sg13g2_nor2_1
X_24518_ _16887_ \rd_alu[16]\ _16866_ _16886_ VPWR VGND sg13g2_a21oi_1
X_24519_ _16888_ \memory_i.addr_reg[16]\ _16869_ VPWR VGND sg13g2_nand2_1
X_24520_ _00984_ _16862_ _16887_ _16888_ VPWR VGND sg13g2_o21ai_1
X_24521_ _16889_ \csr_i.pc[17]\ _13025_ VPWR VGND sg13g2_and2_1
X_24522_ _16890_ \rd_alu[17]\ _16866_ _16889_ VPWR VGND sg13g2_a21oi_1
X_24523_ _16891_ \memory_i.addr_reg[17]\ _16869_ VPWR VGND sg13g2_nand2_1
X_24524_ _00985_ _16862_ _16890_ _16891_ VPWR VGND sg13g2_o21ai_1
X_24525_ _16892_ _15668_ _16866_ VPWR VGND sg13g2_nor2_1
X_24526_ _16893_ \rd_alu[18]\ _16866_ _16892_ VPWR VGND sg13g2_a21oi_1
X_24527_ _16894_ \memory_i.addr_reg[18]\ _16869_ VPWR VGND sg13g2_nand2_1
X_24528_ _00986_ _16862_ _16893_ _16894_ VPWR VGND sg13g2_o21ai_1
X_24529_ _16895_ _13020_ VPWR VGND sg13g2_buf_1
X_24530_ _16896_ _14687_ _12956_ VPWR VGND sg13g2_nor2_1
X_24531_ _16897_ \rd_alu[19]\ _16866_ _16896_ VPWR VGND sg13g2_a21oi_1
X_24532_ _16898_ \memory_i.addr_reg[19]\ _16869_ VPWR VGND sg13g2_nand2_1
X_24533_ _00987_ _16895_ _16897_ _16898_ VPWR VGND sg13g2_o21ai_1
X_24534_ _16899_ \csr_i.pc[20]\ _13025_ VPWR VGND sg13g2_and2_1
X_24535_ _16900_ \rd_alu[20]\ _16866_ _16899_ VPWR VGND sg13g2_a21oi_1
X_24536_ _16901_ _13019_ VPWR VGND sg13g2_buf_1
X_24537_ _16902_ \memory_i.addr_reg[20]\ _16901_ VPWR VGND sg13g2_nand2_1
X_24538_ _00988_ _16895_ _16900_ _16902_ VPWR VGND sg13g2_o21ai_1
X_24539_ _16903_ \csr_i.pc[21]\ _13025_ VPWR VGND sg13g2_and2_1
X_24540_ _16904_ \rd_alu[21]\ _16866_ _16903_ VPWR VGND sg13g2_a21oi_1
X_24541_ _16905_ \memory_i.addr_reg[21]\ _16901_ VPWR VGND sg13g2_nand2_1
X_24542_ _00989_ _16895_ _16904_ _16905_ VPWR VGND sg13g2_o21ai_1
X_24543_ _16906_ _13035_ _16845_ VPWR VGND sg13g2_nor2_1
X_24544_ _16907_ \csr_i.pc[22]\ _16845_ _16906_ VPWR VGND sg13g2_a21oi_1
X_24545_ _16908_ \memory_i.addr_reg[22]\ _16901_ VPWR VGND sg13g2_nand2_1
X_24546_ _00990_ _16895_ _16907_ _16908_ VPWR VGND sg13g2_o21ai_1
X_24547_ _16909_ \memory_i.addr_reg[23]\ _16901_ VPWR VGND sg13g2_nand2_1
X_24548_ _00991_ _12978_ _13024_ _16909_ VPWR VGND sg13g2_o21ai_1
X_24549_ _16910_ \rd_alu[24]\ _16844_ VPWR VGND sg13g2_nand2_1
X_24550_ _16911_ \memory_i.addr_reg[24]\ _16901_ VPWR VGND sg13g2_nand2_1
X_24551_ _00992_ _16895_ _16910_ _16911_ VPWR VGND sg13g2_o21ai_1
X_24552_ _16912_ \rd_alu[25]\ _16844_ VPWR VGND sg13g2_nand2_1
X_24553_ _16913_ \memory_i.addr_reg[25]\ _16901_ VPWR VGND sg13g2_nand2_1
X_24554_ _00993_ _16895_ _16912_ _16913_ VPWR VGND sg13g2_o21ai_1
X_24555_ _16914_ \rd_alu[26]\ _16844_ VPWR VGND sg13g2_nand2_1
X_24556_ _16915_ \memory_i.addr_reg[26]\ _16901_ VPWR VGND sg13g2_nand2_1
X_24557_ _00994_ _16895_ _16914_ _16915_ VPWR VGND sg13g2_o21ai_1
X_24558_ _16916_ \rd_alu[27]\ _16844_ VPWR VGND sg13g2_nand2_1
X_24559_ _16917_ \memory_i.addr_reg[27]\ _16901_ VPWR VGND sg13g2_nand2_1
X_24560_ _00995_ _16895_ _16916_ _16917_ VPWR VGND sg13g2_o21ai_1
X_24561_ _16918_ \rd_alu[28]\ _16844_ VPWR VGND sg13g2_nand2_1
X_24562_ _16919_ \memory_i.addr_reg[28]\ _16901_ VPWR VGND sg13g2_nand2_1
X_24563_ _00996_ _16895_ _16918_ _16919_ VPWR VGND sg13g2_o21ai_1
X_24564_ _16920_ \rd_alu[29]\ _16844_ VPWR VGND sg13g2_nand2_1
X_24565_ _16921_ \memory_i.addr_reg[29]\ _16901_ VPWR VGND sg13g2_nand2_1
X_24566_ _00997_ _16895_ _16920_ _16921_ VPWR VGND sg13g2_o21ai_1
X_24567_ _16922_ \rd_alu[30]\ _16844_ VPWR VGND sg13g2_nand2_1
X_24568_ _16923_ \memory_i.addr_reg[30]\ _13020_ VPWR VGND sg13g2_nand2_1
X_24569_ _00998_ _16842_ _16922_ _16923_ VPWR VGND sg13g2_o21ai_1
X_24570_ _16924_ \rd_alu[31]\ _16844_ VPWR VGND sg13g2_nand2_1
X_24571_ _16925_ \memory_i.addr_reg[31]\ _13020_ VPWR VGND sg13g2_nand2_1
X_24572_ _00999_ _16842_ _16924_ _16925_ VPWR VGND sg13g2_o21ai_1
X_24573_ _16926_ \memory_i.addr_reg[2]\ _13813_ VPWR VGND sg13g2_nor2_1
X_24574_ _16927_ _13776_ _13315_ VPWR VGND sg13g2_nor2_1
X_24575_ _16928_ _16927_ VPWR VGND sg13g2_buf_1
X_24576_ _16929_ _13782_ _16926_ _16928_ VPWR VGND sg13g2_nand3_1
X_24577_ _16930_ _16929_ VPWR VGND sg13g2_buf_1
X_24578_ _16931_ _16930_ VPWR VGND sg13g2_buf_1
X_24579_ _16932_ _16931_ VPWR VGND sg13g2_buf_1
X_24580_ _16933_ \memory_i.mtime[0]\ _16931_ VPWR VGND sg13g2_nand2_1
X_24581_ _16934_ \memory_i.datain_reg[0]\ _16932_ _16933_ VPWR VGND sg13g2_o21ai_1
X_24582_ _01000_ _16340_ _16934_ VPWR VGND sg13g2_nor2_1
X_24583_ _16935_ _16930_ VPWR VGND sg13g2_buf_1
X_24584_ _16936_ \memory_i.mtime[1]\ \memory_i.mtime[0]\ VPWR VGND sg13g2_xnor2_1
X_24585_ _16937_ _16935_ _16936_ VPWR VGND sg13g2_nand2_1
X_24586_ _16938_ \memory_i.datain_reg[1]\ _16932_ _16937_ VPWR VGND sg13g2_o21ai_1
X_24587_ _01001_ _16340_ _16938_ VPWR VGND sg13g2_nor2_1
X_24588_ _16939_ \memory_i.mtime[1]\ \memory_i.mtime[0]\ VPWR VGND sg13g2_nand2_1
X_24589_ _16940_ _16548_ _16939_ VPWR VGND sg13g2_xnor2_1
X_24590_ _16941_ _16935_ _16940_ VPWR VGND sg13g2_nand2_1
X_24591_ _16942_ \memory_i.datain_reg[2]\ _16932_ _16941_ VPWR VGND sg13g2_o21ai_1
X_24592_ _01002_ _16340_ _16942_ VPWR VGND sg13g2_nor2_1
X_24593_ _16943_ \memory_i.mtime[2]\ \memory_i.mtime[1]\ \memory_i.mtime[0]\ VPWR VGND sg13g2_and3_2
X_24594_ _16944_ _16943_ VPWR VGND sg13g2_buf_4
X_24595_ _16945_ \memory_i.mtime[3]\ _16944_ VPWR VGND sg13g2_xnor2_1
X_24596_ _16946_ _16935_ _16945_ VPWR VGND sg13g2_nand2_1
X_24597_ _16947_ \memory_i.datain_reg[3]\ _16932_ _16946_ VPWR VGND sg13g2_o21ai_1
X_24598_ _01003_ _16340_ _16947_ VPWR VGND sg13g2_nor2_1
X_24599_ _16948_ \memory_i.mtime[3]\ _16944_ VPWR VGND sg13g2_nand2_1
X_24600_ _16949_ \memory_i.mtime[4]\ _16948_ VPWR VGND sg13g2_xor2_1
X_24601_ _16950_ _16935_ _16949_ VPWR VGND sg13g2_nand2_1
X_24602_ _16951_ \memory_i.datain_reg[4]\ _16932_ _16950_ VPWR VGND sg13g2_o21ai_1
X_24603_ _01004_ _16340_ _16951_ VPWR VGND sg13g2_nor2_1
X_24604_ _16952_ _12949_ VPWR VGND sg13g2_buf_16
X_24605_ _16953_ _16952_ VPWR VGND sg13g2_buf_1
X_24606_ _16954_ \memory_i.mtime[4]\ \memory_i.mtime[3]\ _16944_ VPWR VGND sg13g2_nand3_1
X_24607_ _16955_ \memory_i.mtime[5]\ _16954_ VPWR VGND sg13g2_xor2_1
X_24608_ _16956_ _16935_ _16955_ VPWR VGND sg13g2_nand2_1
X_24609_ _16957_ \memory_i.datain_reg[5]\ _16932_ _16956_ VPWR VGND sg13g2_o21ai_1
X_24610_ _01005_ _16953_ _16957_ VPWR VGND sg13g2_nor2_1
X_24611_ _16958_ \memory_i.mtime[4]\ \memory_i.mtime[5]\ \memory_i.mtime[3]\ VPWR VGND sg13g2_and3_1
X_24612_ _16959_ _16944_ _16958_ VPWR VGND sg13g2_and2_1
X_24613_ _16960_ \memory_i.mtime[6]\ _16959_ VPWR VGND sg13g2_xnor2_1
X_24614_ _16961_ _16935_ _16960_ VPWR VGND sg13g2_nand2_1
X_24615_ _16962_ \memory_i.datain_reg[6]\ _16932_ _16961_ VPWR VGND sg13g2_o21ai_1
X_24616_ _01006_ _16953_ _16962_ VPWR VGND sg13g2_nor2_1
X_24617_ _16963_ \memory_i.mtime[6]\ _16959_ VPWR VGND sg13g2_nand2_1
X_24618_ _16964_ _16544_ _16963_ VPWR VGND sg13g2_xnor2_1
X_24619_ _16965_ _16935_ _16964_ VPWR VGND sg13g2_nand2_1
X_24620_ _16966_ \memory_i.datain_reg[7]\ _16932_ _16965_ VPWR VGND sg13g2_o21ai_1
X_24621_ _01007_ _16953_ _16966_ VPWR VGND sg13g2_nor2_1
X_24622_ _16967_ \memory_i.mtime[6]\ \memory_i.mtime[7]\ _16944_ _16958_ VPWR
+ VGND
+ sg13g2_nand4_1
X_24623_ _16968_ _16967_ VPWR VGND sg13g2_buf_4
X_24624_ _16969_ _16565_ _16968_ VPWR VGND sg13g2_xnor2_1
X_24625_ _16970_ _16935_ _16969_ VPWR VGND sg13g2_and2_1
X_24626_ _16971_ \memory_i.datain_reg[8]\ _16932_ VPWR VGND sg13g2_nor2_1
X_24627_ _01008_ _15734_ _16970_ _16971_ VPWR VGND sg13g2_nor3_1
X_24628_ _16972_ _16931_ VPWR VGND sg13g2_buf_1
X_24629_ _16973_ _16565_ _16968_ VPWR VGND sg13g2_nor2_2
X_24630_ _16974_ \memory_i.mtime[9]\ _16973_ VPWR VGND sg13g2_xnor2_1
X_24631_ _16975_ _16972_ _16974_ VPWR VGND sg13g2_nand2_1
X_24632_ _16976_ \memory_i.datain_reg[9]\ _16932_ _16975_ VPWR VGND sg13g2_o21ai_1
X_24633_ _01009_ _16953_ _16976_ VPWR VGND sg13g2_nor2_1
X_24634_ _16977_ _16931_ VPWR VGND sg13g2_buf_1
X_24635_ _16978_ \memory_i.mtime[9]\ _16973_ VPWR VGND sg13g2_nand2_1
X_24636_ _16979_ _16569_ _16978_ VPWR VGND sg13g2_xnor2_1
X_24637_ _16980_ _16972_ _16979_ VPWR VGND sg13g2_nand2_1
X_24638_ _16981_ \memory_i.datain_reg[10]\ _16977_ _16980_ VPWR VGND sg13g2_o21ai_1
X_24639_ _01010_ _16953_ _16981_ VPWR VGND sg13g2_nor2_1
X_24640_ _16982_ \memory_i.mtime[9]\ \memory_i.mtime[10]\ _16973_ VPWR VGND sg13g2_nand3_1
X_24641_ _16983_ _16541_ _16982_ VPWR VGND sg13g2_xnor2_1
X_24642_ _16984_ _16972_ _16983_ VPWR VGND sg13g2_nand2_1
X_24643_ _16985_ \memory_i.datain_reg[11]\ _16977_ _16984_ VPWR VGND sg13g2_o21ai_1
X_24644_ _01011_ _16953_ _16985_ VPWR VGND sg13g2_nor2_1
X_24645_ _16986_ \memory_i.mtime[9]\ \memory_i.mtime[10]\ \memory_i.mtime[11]\ _16973_ VPWR
+ VGND
+ sg13g2_nand4_1
X_24646_ _16987_ \memory_i.mtime[12]\ _16986_ VPWR VGND sg13g2_xor2_1
X_24647_ _16988_ _16972_ _16987_ VPWR VGND sg13g2_nand2_1
X_24648_ _16989_ \memory_i.datain_reg[12]\ _16977_ _16988_ VPWR VGND sg13g2_o21ai_1
X_24649_ _01012_ _16953_ _16989_ VPWR VGND sg13g2_nor2_1
X_24650_ _16990_ \memory_i.mtime[9]\ \memory_i.mtime[10]\ \memory_i.mtime[11]\ \memory_i.mtime[12]\ VPWR
+ VGND
+ sg13g2_nand4_1
X_24651_ _16991_ _16565_ _16968_ _16990_ VPWR VGND sg13g2_nor3_1
X_24652_ _16992_ \memory_i.mtime[13]\ _16991_ VPWR VGND sg13g2_xnor2_1
X_24653_ _16993_ _16972_ _16992_ VPWR VGND sg13g2_nand2_1
X_24654_ _16994_ \memory_i.datain_reg[13]\ _16977_ _16993_ VPWR VGND sg13g2_o21ai_1
X_24655_ _01013_ _16953_ _16994_ VPWR VGND sg13g2_nor2_1
X_24656_ _16995_ \memory_i.mtime[13]\ _16991_ VPWR VGND sg13g2_nand2_1
X_24657_ _16996_ \memory_i.mtime[14]\ _16995_ VPWR VGND sg13g2_xor2_1
X_24658_ _16997_ _16972_ _16996_ VPWR VGND sg13g2_nand2_1
X_24659_ _16998_ \memory_i.datain_reg[14]\ _16977_ _16997_ VPWR VGND sg13g2_o21ai_1
X_24660_ _01014_ _16953_ _16998_ VPWR VGND sg13g2_nor2_1
X_24661_ _16999_ \memory_i.mtime[13]\ \memory_i.mtime[14]\ _16991_ VPWR VGND sg13g2_nand3_1
X_24662_ _17000_ _16539_ _16999_ VPWR VGND sg13g2_xnor2_1
X_24663_ _17001_ _16972_ _17000_ VPWR VGND sg13g2_nand2_1
X_24664_ _17002_ \memory_i.datain_reg[15]\ _16977_ _17001_ VPWR VGND sg13g2_o21ai_1
X_24665_ _01015_ _16953_ _17002_ VPWR VGND sg13g2_nor2_1
X_24666_ _17003_ _16952_ VPWR VGND sg13g2_buf_1
X_24667_ _17004_ \memory_i.mtime[16]\ VPWR VGND sg13g2_inv_1
X_24668_ _17005_ \memory_i.mtime[13]\ \memory_i.mtime[14]\ \memory_i.mtime[15]\ _16991_ VPWR
+ VGND
+ sg13g2_nand4_1
X_24669_ _17006_ _17004_ _17005_ VPWR VGND sg13g2_xnor2_1
X_24670_ _17007_ _16972_ _17006_ VPWR VGND sg13g2_nand2_1
X_24671_ _17008_ \memory_i.datain_reg[16]\ _16977_ _17007_ VPWR VGND sg13g2_o21ai_1
X_24672_ _01016_ _17003_ _17008_ VPWR VGND sg13g2_nor2_1
X_24673_ _17009_ _17004_ _17005_ VPWR VGND sg13g2_or2_2
X_24674_ _17010_ _16538_ _17009_ VPWR VGND sg13g2_xnor2_1
X_24675_ _17011_ _16972_ _17010_ VPWR VGND sg13g2_nand2_1
X_24676_ _17012_ \memory_i.datain_reg[17]\ _16977_ _17011_ VPWR VGND sg13g2_o21ai_1
X_24677_ _01017_ _17003_ _17012_ VPWR VGND sg13g2_nor2_1
X_24678_ _17013_ _16538_ _17009_ VPWR VGND sg13g2_nor2_2
X_24679_ _17014_ \memory_i.mtime[18]\ _17013_ VPWR VGND sg13g2_xnor2_1
X_24680_ _17015_ _16972_ _17014_ VPWR VGND sg13g2_nand2_1
X_24681_ _17016_ \memory_i.datain_reg[18]\ _16977_ _17015_ VPWR VGND sg13g2_o21ai_1
X_24682_ _01018_ _17003_ _17016_ VPWR VGND sg13g2_nor2_1
X_24683_ _17017_ _16931_ VPWR VGND sg13g2_buf_1
X_24684_ _17018_ \memory_i.mtime[18]\ _17013_ VPWR VGND sg13g2_nand2_2
X_24685_ _17019_ _16537_ _17018_ VPWR VGND sg13g2_xnor2_1
X_24686_ _17020_ _17017_ _17019_ VPWR VGND sg13g2_nand2_1
X_24687_ _17021_ \memory_i.datain_reg[19]\ _16977_ _17020_ VPWR VGND sg13g2_o21ai_1
X_24688_ _01019_ _17003_ _17021_ VPWR VGND sg13g2_nor2_1
X_24689_ _17022_ _16931_ VPWR VGND sg13g2_buf_1
X_24690_ _17023_ _16537_ _17018_ VPWR VGND sg13g2_nor2_2
X_24691_ _17024_ \memory_i.mtime[20]\ _17023_ VPWR VGND sg13g2_xnor2_1
X_24692_ _17025_ _17017_ _17024_ VPWR VGND sg13g2_nand2_1
X_24693_ _17026_ \memory_i.datain_reg[20]\ _17022_ _17025_ VPWR VGND sg13g2_o21ai_1
X_24694_ _01020_ _17003_ _17026_ VPWR VGND sg13g2_nor2_1
X_24695_ _17027_ \memory_i.mtime[20]\ _17023_ VPWR VGND sg13g2_nand2_1
X_24696_ _17028_ _16535_ _17027_ VPWR VGND sg13g2_xnor2_1
X_24697_ _17029_ _17017_ _17028_ VPWR VGND sg13g2_nand2_1
X_24698_ _17030_ \memory_i.datain_reg[21]\ _17022_ _17029_ VPWR VGND sg13g2_o21ai_1
X_24699_ _01021_ _17003_ _17030_ VPWR VGND sg13g2_nor2_1
X_24700_ _17031_ \memory_i.mtime[20]\ \memory_i.mtime[21]\ _17023_ VPWR VGND sg13g2_nand3_1
X_24701_ _17032_ _16597_ _17031_ VPWR VGND sg13g2_xnor2_1
X_24702_ _17033_ _17017_ _17032_ VPWR VGND sg13g2_nand2_1
X_24703_ _17034_ \memory_i.datain_reg[22]\ _17022_ _17033_ VPWR VGND sg13g2_o21ai_1
X_24704_ _01022_ _17003_ _17034_ VPWR VGND sg13g2_nor2_1
X_24705_ _17035_ \memory_i.mtime[20]\ \memory_i.mtime[21]\ \memory_i.mtime[22]\ VPWR VGND sg13g2_nand3_1
X_24706_ _17036_ _16537_ _17018_ _17035_ VPWR VGND sg13g2_nor3_1
X_24707_ _17037_ \memory_i.mtime[23]\ _17036_ VPWR VGND sg13g2_xnor2_1
X_24708_ _17038_ _17017_ _17037_ VPWR VGND sg13g2_nand2_1
X_24709_ _17039_ \memory_i.datain_reg[23]\ _17022_ _17038_ VPWR VGND sg13g2_o21ai_1
X_24710_ _01023_ _17003_ _17039_ VPWR VGND sg13g2_nor2_1
X_24711_ _17040_ \memory_i.mtime[23]\ _17036_ VPWR VGND sg13g2_nand2_2
X_24712_ _17041_ _16533_ _17040_ VPWR VGND sg13g2_xnor2_1
X_24713_ _17042_ _17017_ _17041_ VPWR VGND sg13g2_nand2_1
X_24714_ _17043_ \memory_i.datain_reg[24]\ _17022_ _17042_ VPWR VGND sg13g2_o21ai_1
X_24715_ _01024_ _17003_ _17043_ VPWR VGND sg13g2_nor2_1
X_24716_ _17044_ _16533_ _17040_ VPWR VGND sg13g2_nor2_2
X_24717_ _17045_ \memory_i.mtime[25]\ _17044_ VPWR VGND sg13g2_xnor2_1
X_24718_ _17046_ _17017_ _17045_ VPWR VGND sg13g2_nand2_1
X_24719_ _17047_ \memory_i.datain_reg[25]\ _17022_ _17046_ VPWR VGND sg13g2_o21ai_1
X_24720_ _01025_ _17003_ _17047_ VPWR VGND sg13g2_nor2_1
X_24721_ _17048_ _16952_ VPWR VGND sg13g2_buf_1
X_24722_ _17049_ \memory_i.mtime[25]\ _17044_ VPWR VGND sg13g2_nand2_1
X_24723_ _17050_ \memory_i.mtime[26]\ _17049_ VPWR VGND sg13g2_xor2_1
X_24724_ _17051_ _17017_ _17050_ VPWR VGND sg13g2_nand2_1
X_24725_ _17052_ \memory_i.datain_reg[26]\ _17022_ _17051_ VPWR VGND sg13g2_o21ai_1
X_24726_ _01026_ _17048_ _17052_ VPWR VGND sg13g2_nor2_1
X_24727_ _17053_ _16606_ _17044_ VPWR VGND sg13g2_nand2b_1
X_24728_ _17054_ \memory_i.mtime[27]\ _17053_ VPWR VGND sg13g2_xor2_1
X_24729_ _17055_ _17017_ _17054_ VPWR VGND sg13g2_nand2_1
X_24730_ _17056_ \memory_i.datain_reg[27]\ _17022_ _17055_ VPWR VGND sg13g2_o21ai_1
X_24731_ _01027_ _17048_ _17056_ VPWR VGND sg13g2_nor2_1
X_24732_ _17057_ \memory_i.mtime[25]\ \memory_i.mtime[26]\ \memory_i.mtime[27]\ _17044_ VPWR
+ VGND
+ sg13g2_nand4_1
X_24733_ _17058_ _17057_ VPWR VGND sg13g2_buf_4
X_24734_ _17059_ _16525_ _17058_ VPWR VGND sg13g2_xnor2_1
X_24735_ _17060_ _17017_ _17059_ VPWR VGND sg13g2_nand2_1
X_24736_ _17061_ \memory_i.datain_reg[28]\ _17022_ _17060_ VPWR VGND sg13g2_o21ai_1
X_24737_ _01028_ _17048_ _17061_ VPWR VGND sg13g2_nor2_1
X_24738_ _17062_ _16525_ _17058_ VPWR VGND sg13g2_nor2_2
X_24739_ _17063_ \memory_i.mtime[29]\ _17062_ VPWR VGND sg13g2_xnor2_1
X_24740_ _17064_ _16931_ _17063_ VPWR VGND sg13g2_nand2_1
X_24741_ _17065_ \memory_i.datain_reg[29]\ _17022_ _17064_ VPWR VGND sg13g2_o21ai_1
X_24742_ _01029_ _17048_ _17065_ VPWR VGND sg13g2_nor2_1
X_24743_ _17066_ \memory_i.mtime[29]\ _17062_ VPWR VGND sg13g2_nand2_1
X_24744_ _17067_ \memory_i.mtime[30]\ _17066_ VPWR VGND sg13g2_xor2_1
X_24745_ _17068_ _16931_ _17067_ VPWR VGND sg13g2_nand2_1
X_24746_ _17069_ \memory_i.datain_reg[30]\ _16935_ _17068_ VPWR VGND sg13g2_o21ai_1
X_24747_ _01030_ _17048_ _17069_ VPWR VGND sg13g2_nor2_1
X_24748_ _17070_ \memory_i.mtime[29]\ \memory_i.mtime[30]\ _17062_ VPWR VGND sg13g2_nand3_1
X_24749_ _17071_ \memory_i.mtime[31]\ _17070_ VPWR VGND sg13g2_xor2_1
X_24750_ _17072_ _16931_ _17071_ VPWR VGND sg13g2_nand2_1
X_24751_ _17073_ \memory_i.datain_reg[31]\ _16935_ _17072_ VPWR VGND sg13g2_o21ai_1
X_24752_ _01031_ _17048_ _17073_ VPWR VGND sg13g2_nor2_1
X_24753_ _17074_ \memory_i.addr_reg[2]\ _13782_ _13785_ _16928_ VPWR
+ VGND
+ sg13g2_nand4_1
X_24754_ _17075_ _17074_ VPWR VGND sg13g2_buf_8
X_24755_ _17076_ _17075_ VPWR VGND sg13g2_buf_8
X_24756_ _17077_ _17076_ VPWR VGND sg13g2_buf_1
X_24757_ _17078_ _16525_ _16519_ _16521_ _17058_ VPWR
+ VGND
+ sg13g2_nor4_1
X_24758_ _17079_ \memory_i.mtime[32]\ _17078_ VPWR VGND sg13g2_xnor2_1
X_24759_ _17080_ _17079_ _17076_ VPWR VGND sg13g2_nand2_1
X_24760_ _17081_ \memory_i.datain_reg[0]\ _17077_ _17080_ VPWR VGND sg13g2_o21ai_1
X_24761_ _01032_ _17048_ _17081_ VPWR VGND sg13g2_nor2_1
X_24762_ _17082_ _17075_ VPWR VGND sg13g2_buf_16
X_24763_ _17083_ \memory_i.mtime[32]\ _17078_ VPWR VGND sg13g2_nand2_1
X_24764_ _17084_ \memory_i.mtime[33]\ _17083_ VPWR VGND sg13g2_xor2_1
X_24765_ _17085_ _17082_ _17084_ VPWR VGND sg13g2_nand2_1
X_24766_ _17086_ \memory_i.datain_reg[1]\ _17077_ _17085_ VPWR VGND sg13g2_o21ai_1
X_24767_ _01033_ _17048_ _17086_ VPWR VGND sg13g2_nor2_1
X_24768_ _17087_ \memory_i.mtime[32]\ \memory_i.mtime[33]\ _17078_ VPWR VGND sg13g2_nand3_1
X_24769_ _17088_ _16629_ _17087_ VPWR VGND sg13g2_xnor2_1
X_24770_ _17089_ _17082_ _17088_ VPWR VGND sg13g2_nand2_1
X_24771_ _17090_ \memory_i.datain_reg[2]\ _17077_ _17089_ VPWR VGND sg13g2_o21ai_1
X_24772_ _01034_ _17048_ _17090_ VPWR VGND sg13g2_nor2_1
X_24773_ _17091_ _16629_ _17087_ VPWR VGND sg13g2_nor2_2
X_24774_ _17092_ \memory_i.mtime[35]\ _17091_ VPWR VGND sg13g2_xnor2_1
X_24775_ _17093_ _17082_ _17092_ VPWR VGND sg13g2_nand2_1
X_24776_ _17094_ \memory_i.datain_reg[3]\ _17077_ _17093_ VPWR VGND sg13g2_o21ai_1
X_24777_ _01035_ _17048_ _17094_ VPWR VGND sg13g2_nor2_1
X_24778_ _17095_ _16952_ VPWR VGND sg13g2_buf_1
X_24779_ _17096_ \memory_i.mtime[35]\ _17091_ VPWR VGND sg13g2_nand2_1
X_24780_ _17097_ \memory_i.mtime[36]\ _17096_ VPWR VGND sg13g2_xor2_1
X_24781_ _17098_ _17082_ _17097_ VPWR VGND sg13g2_nand2_1
X_24782_ _17099_ \memory_i.datain_reg[4]\ _17077_ _17098_ VPWR VGND sg13g2_o21ai_1
X_24783_ _01036_ _17095_ _17099_ VPWR VGND sg13g2_nor2_1
X_24784_ _17100_ \memory_i.mtime[36]\ \memory_i.mtime[35]\ _17091_ VPWR VGND sg13g2_nand3_1
X_24785_ _17101_ _17100_ VPWR VGND sg13g2_buf_4
X_24786_ _17102_ _16624_ _17101_ VPWR VGND sg13g2_xnor2_1
X_24787_ _17103_ _17082_ _17102_ VPWR VGND sg13g2_nand2_1
X_24788_ _17104_ \memory_i.datain_reg[5]\ _17077_ _17103_ VPWR VGND sg13g2_o21ai_1
X_24789_ _01037_ _17095_ _17104_ VPWR VGND sg13g2_nor2_1
X_24790_ _17105_ _16624_ _17101_ VPWR VGND sg13g2_nor2_1
X_24791_ _17106_ \memory_i.mtime[38]\ _17105_ VPWR VGND sg13g2_xnor2_1
X_24792_ _17107_ _17082_ _17106_ VPWR VGND sg13g2_nand2_1
X_24793_ _17108_ \memory_i.datain_reg[6]\ _17077_ _17107_ VPWR VGND sg13g2_o21ai_1
X_24794_ _01038_ _17095_ _17108_ VPWR VGND sg13g2_nor2_1
X_24795_ _17109_ \memory_i.mtime[38]\ _17105_ VPWR VGND sg13g2_nand2_1
X_24796_ _17110_ \memory_i.mtime[39]\ _17109_ VPWR VGND sg13g2_xor2_1
X_24797_ _17111_ _17082_ _17110_ VPWR VGND sg13g2_nand2_1
X_24798_ _17112_ \memory_i.datain_reg[7]\ _17077_ _17111_ VPWR VGND sg13g2_o21ai_1
X_24799_ _01039_ _17095_ _17112_ VPWR VGND sg13g2_nor2_1
X_24800_ _17113_ _16649_ _17105_ VPWR VGND sg13g2_nand2b_1
X_24801_ _17114_ _16499_ _17113_ VPWR VGND sg13g2_xnor2_1
X_24802_ _17115_ _17082_ _17114_ VPWR VGND sg13g2_nand2_1
X_24803_ _17116_ \memory_i.datain_reg[8]\ _17077_ _17115_ VPWR VGND sg13g2_o21ai_1
X_24804_ _01040_ _17095_ _17116_ VPWR VGND sg13g2_nor2_1
X_24805_ _17117_ _17076_ VPWR VGND sg13g2_buf_1
X_24806_ _17118_ _16499_ _17113_ VPWR VGND sg13g2_nor2_1
X_24807_ _17119_ \memory_i.mtime[41]\ _17118_ VPWR VGND sg13g2_xnor2_1
X_24808_ _17120_ _17117_ _17119_ VPWR VGND sg13g2_nand2_1
X_24809_ _17121_ \memory_i.datain_reg[9]\ _17077_ _17120_ VPWR VGND sg13g2_o21ai_1
X_24810_ _01041_ _17095_ _17121_ VPWR VGND sg13g2_nor2_1
X_24811_ _17122_ _17076_ VPWR VGND sg13g2_buf_1
X_24812_ _17123_ \memory_i.mtime[40]\ \memory_i.mtime[41]\ VPWR VGND sg13g2_nand2_1
X_24813_ _17124_ _16624_ _16649_ _17101_ _17123_ VPWR
+ VGND
+ sg13g2_nor4_2
X_24814_ _17125_ \memory_i.mtime[42]\ _17124_ VPWR VGND sg13g2_xnor2_1
X_24815_ _17126_ _17117_ _17125_ VPWR VGND sg13g2_nand2_1
X_24816_ _17127_ \memory_i.datain_reg[10]\ _17122_ _17126_ VPWR VGND sg13g2_o21ai_1
X_24817_ _01042_ _17095_ _17127_ VPWR VGND sg13g2_nor2_1
X_24818_ _17128_ \memory_i.mtime[42]\ _17124_ VPWR VGND sg13g2_nand2_1
X_24819_ _17129_ _16503_ _17128_ VPWR VGND sg13g2_xnor2_1
X_24820_ _17130_ _17117_ _17129_ VPWR VGND sg13g2_nand2_1
X_24821_ _17131_ \memory_i.datain_reg[11]\ _17122_ _17130_ VPWR VGND sg13g2_o21ai_1
X_24822_ _01043_ _17095_ _17131_ VPWR VGND sg13g2_nor2_1
X_24823_ _17132_ \memory_i.mtime[42]\ \memory_i.mtime[43]\ VPWR VGND sg13g2_and2_2
X_24824_ _17133_ _17132_ VPWR VGND sg13g2_buf_4
X_24825_ _17134_ _17133_ _17124_ VPWR VGND sg13g2_nand2_1
X_24826_ _17135_ _16494_ _17134_ VPWR VGND sg13g2_xnor2_1
X_24827_ _17136_ _17117_ _17135_ VPWR VGND sg13g2_nand2_1
X_24828_ _17137_ \memory_i.datain_reg[12]\ _17122_ _17136_ VPWR VGND sg13g2_o21ai_1
X_24829_ _01044_ _17095_ _17137_ VPWR VGND sg13g2_nor2_1
X_24830_ _17138_ \memory_i.mtime[44]\ _17133_ _17124_ VPWR VGND sg13g2_nand3_1
X_24831_ _17139_ \memory_i.mtime[45]\ _17138_ VPWR VGND sg13g2_xor2_1
X_24832_ _17140_ _17117_ _17139_ VPWR VGND sg13g2_nand2_1
X_24833_ _17141_ \memory_i.datain_reg[13]\ _17122_ _17140_ VPWR VGND sg13g2_o21ai_1
X_24834_ _01045_ _17095_ _17141_ VPWR VGND sg13g2_nor2_1
X_24835_ _17142_ _16952_ VPWR VGND sg13g2_buf_1
X_24836_ _17143_ \memory_i.mtime[44]\ \memory_i.mtime[45]\ _17133_ _17124_ VPWR
+ VGND
+ sg13g2_and4_1
X_24837_ _17144_ _17143_ VPWR VGND sg13g2_buf_4
X_24838_ _17145_ \memory_i.mtime[46]\ _17144_ VPWR VGND sg13g2_xnor2_1
X_24839_ _17146_ _17117_ _17145_ VPWR VGND sg13g2_nand2_1
X_24840_ _17147_ \memory_i.datain_reg[14]\ _17122_ _17146_ VPWR VGND sg13g2_o21ai_1
X_24841_ _01046_ _17142_ _17147_ VPWR VGND sg13g2_nor2_1
X_24842_ _17148_ \memory_i.mtime[46]\ _17144_ VPWR VGND sg13g2_nand2_1
X_24843_ _17149_ \memory_i.mtime[47]\ _17148_ VPWR VGND sg13g2_xor2_1
X_24844_ _17150_ _17117_ _17149_ VPWR VGND sg13g2_nand2_1
X_24845_ _17151_ \memory_i.datain_reg[15]\ _17122_ _17150_ VPWR VGND sg13g2_o21ai_1
X_24846_ _01047_ _17142_ _17151_ VPWR VGND sg13g2_nor2_1
X_24847_ _17152_ \memory_i.mtime[46]\ \memory_i.mtime[47]\ _17144_ VPWR VGND sg13g2_nand3_1
X_24848_ _17153_ \memory_i.mtime[48]\ _17152_ VPWR VGND sg13g2_xor2_1
X_24849_ _17154_ _17117_ _17153_ VPWR VGND sg13g2_nand2_1
X_24850_ _17155_ \memory_i.datain_reg[16]\ _17122_ _17154_ VPWR VGND sg13g2_o21ai_1
X_24851_ _01048_ _17142_ _17155_ VPWR VGND sg13g2_nor2_1
X_24852_ _17156_ \memory_i.mtime[46]\ \memory_i.mtime[47]\ \memory_i.mtime[48]\ _17144_ VPWR
+ VGND
+ sg13g2_nand4_1
X_24853_ _17157_ _16453_ _17156_ VPWR VGND sg13g2_xnor2_1
X_24854_ _17158_ _17117_ _17157_ VPWR VGND sg13g2_nand2_1
X_24855_ _17159_ \memory_i.datain_reg[17]\ _17122_ _17158_ VPWR VGND sg13g2_o21ai_1
X_24856_ _01049_ _17142_ _17159_ VPWR VGND sg13g2_nor2_1
X_24857_ _17160_ _16453_ _17156_ VPWR VGND sg13g2_nor2_2
X_24858_ _17161_ \memory_i.mtime[50]\ _17160_ VPWR VGND sg13g2_xnor2_1
X_24859_ _17162_ _17117_ _17161_ VPWR VGND sg13g2_nand2_1
X_24860_ _17163_ \memory_i.datain_reg[18]\ _17122_ _17162_ VPWR VGND sg13g2_o21ai_1
X_24861_ _01050_ _17142_ _17163_ VPWR VGND sg13g2_nor2_1
X_24862_ _17164_ _17076_ VPWR VGND sg13g2_buf_1
X_24863_ _17165_ \memory_i.mtime[50]\ _17160_ VPWR VGND sg13g2_nand2_1
X_24864_ _17166_ _16448_ _17165_ VPWR VGND sg13g2_xnor2_1
X_24865_ _17167_ _17164_ _17166_ VPWR VGND sg13g2_nand2_1
X_24866_ _17168_ \memory_i.datain_reg[19]\ _17122_ _17167_ VPWR VGND sg13g2_o21ai_1
X_24867_ _01051_ _17142_ _17168_ VPWR VGND sg13g2_nor2_1
X_24868_ _17169_ _17076_ VPWR VGND sg13g2_buf_1
X_24869_ _17170_ \memory_i.mtime[50]\ \memory_i.mtime[51]\ VPWR VGND sg13g2_and2_1
X_24870_ _17171_ _17170_ VPWR VGND sg13g2_buf_2
X_24871_ _17172_ _17171_ _17160_ VPWR VGND sg13g2_nand2_1
X_24872_ _17173_ \memory_i.mtime[52]\ _17172_ VPWR VGND sg13g2_xor2_1
X_24873_ _17174_ _17164_ _17173_ VPWR VGND sg13g2_nand2_1
X_24874_ _17175_ \memory_i.datain_reg[20]\ _17169_ _17174_ VPWR VGND sg13g2_o21ai_1
X_24875_ _01052_ _17142_ _17175_ VPWR VGND sg13g2_nor2_1
X_24876_ _17176_ \memory_i.mtime[52]\ _17171_ _17160_ VPWR VGND sg13g2_nand3_1
X_24877_ _17177_ \memory_i.mtime[53]\ _17176_ VPWR VGND sg13g2_xor2_1
X_24878_ _17178_ _17164_ _17177_ VPWR VGND sg13g2_nand2_1
X_24879_ _17179_ \memory_i.datain_reg[21]\ _17169_ _17178_ VPWR VGND sg13g2_o21ai_1
X_24880_ _01053_ _17142_ _17179_ VPWR VGND sg13g2_nor2_1
X_24881_ _17180_ \memory_i.mtime[52]\ \memory_i.mtime[53]\ _17171_ _17160_ VPWR
+ VGND
+ sg13g2_nand4_1
X_24882_ _17181_ _17180_ VPWR VGND sg13g2_buf_4
X_24883_ _17182_ _16463_ _17181_ VPWR VGND sg13g2_xnor2_1
X_24884_ _17183_ _17164_ _17182_ VPWR VGND sg13g2_nand2_1
X_24885_ _17184_ \memory_i.datain_reg[22]\ _17169_ _17183_ VPWR VGND sg13g2_o21ai_1
X_24886_ _01054_ _17142_ _17184_ VPWR VGND sg13g2_nor2_1
X_24887_ _17185_ _16463_ _17181_ VPWR VGND sg13g2_nor2_1
X_24888_ _17186_ \memory_i.mtime[55]\ _17185_ VPWR VGND sg13g2_xnor2_1
X_24889_ _17187_ _17164_ _17186_ VPWR VGND sg13g2_nand2_1
X_24890_ _17188_ \memory_i.datain_reg[23]\ _17169_ _17187_ VPWR VGND sg13g2_o21ai_1
X_24891_ _01055_ _17142_ _17188_ VPWR VGND sg13g2_nor2_1
X_24892_ _17189_ _16952_ VPWR VGND sg13g2_buf_16
X_24893_ _17190_ _16470_ _17181_ VPWR VGND sg13g2_nor2_2
X_24894_ _17191_ \memory_i.mtime[56]\ _17190_ VPWR VGND sg13g2_xnor2_1
X_24895_ _17192_ _17164_ _17191_ VPWR VGND sg13g2_nand2_1
X_24896_ _17193_ \memory_i.datain_reg[24]\ _17169_ _17192_ VPWR VGND sg13g2_o21ai_1
X_24897_ _01056_ _17189_ _17193_ VPWR VGND sg13g2_nor2_1
X_24898_ _17194_ \memory_i.mtime[56]\ _17190_ VPWR VGND sg13g2_nand2_1
X_24899_ _17195_ \memory_i.mtime[57]\ _17194_ VPWR VGND sg13g2_xor2_1
X_24900_ _17196_ _17164_ _17195_ VPWR VGND sg13g2_nand2_1
X_24901_ _17197_ \memory_i.datain_reg[25]\ _17169_ _17196_ VPWR VGND sg13g2_o21ai_1
X_24902_ _01057_ _17189_ _17197_ VPWR VGND sg13g2_nor2_1
X_24903_ _17198_ _16484_ _17190_ VPWR VGND sg13g2_nand2b_1
X_24904_ _17199_ \memory_i.mtime[58]\ _17198_ VPWR VGND sg13g2_xor2_1
X_24905_ _17200_ _17164_ _17199_ VPWR VGND sg13g2_nand2_1
X_24906_ _17201_ \memory_i.datain_reg[26]\ _17169_ _17200_ VPWR VGND sg13g2_o21ai_1
X_24907_ _01058_ _17189_ _17201_ VPWR VGND sg13g2_nor2_1
X_24908_ _17202_ \memory_i.mtime[56]\ \memory_i.mtime[57]\ \memory_i.mtime[58]\ _17190_ VPWR
+ VGND
+ sg13g2_and4_1
X_24909_ _17203_ _17202_ VPWR VGND sg13g2_buf_4
X_24910_ _17204_ \memory_i.mtime[59]\ _17203_ VPWR VGND sg13g2_xnor2_1
X_24911_ _17205_ _17164_ _17204_ VPWR VGND sg13g2_nand2_1
X_24912_ _17206_ \memory_i.datain_reg[27]\ _17169_ _17205_ VPWR VGND sg13g2_o21ai_1
X_24913_ _01059_ _17189_ _17206_ VPWR VGND sg13g2_nor2_1
X_24914_ _17207_ \memory_i.mtime[59]\ _17203_ VPWR VGND sg13g2_nand2_1
X_24915_ _17208_ _16479_ _17207_ VPWR VGND sg13g2_xnor2_1
X_24916_ _17209_ _17164_ _17208_ VPWR VGND sg13g2_nand2_1
X_24917_ _17210_ \memory_i.datain_reg[28]\ _17169_ _17209_ VPWR VGND sg13g2_o21ai_1
X_24918_ _01060_ _17189_ _17210_ VPWR VGND sg13g2_nor2_1
X_24919_ _17211_ \memory_i.mtime[59]\ \memory_i.mtime[60]\ _17203_ VPWR VGND sg13g2_nand3_1
X_24920_ _17212_ _16665_ _17211_ VPWR VGND sg13g2_xnor2_1
X_24921_ _17213_ _17076_ _17212_ VPWR VGND sg13g2_nand2_1
X_24922_ _17214_ \memory_i.datain_reg[29]\ _17169_ _17213_ VPWR VGND sg13g2_o21ai_1
X_24923_ _01061_ _17189_ _17214_ VPWR VGND sg13g2_nor2_1
X_24924_ _17215_ _16665_ _17211_ VPWR VGND sg13g2_nor2_2
X_24925_ _17216_ \memory_i.mtime[62]\ _17215_ VPWR VGND sg13g2_xnor2_1
X_24926_ _17217_ _17076_ _17216_ VPWR VGND sg13g2_nand2_1
X_24927_ _17218_ \memory_i.datain_reg[30]\ _17082_ _17217_ VPWR VGND sg13g2_o21ai_1
X_24928_ _01062_ _17189_ _17218_ VPWR VGND sg13g2_nor2_1
X_24929_ _17219_ \memory_i.mtime[62]\ _17215_ VPWR VGND sg13g2_nand2_2
X_24930_ _17220_ \memory_i.mtime[63]\ _17219_ VPWR VGND sg13g2_xor2_1
X_24931_ _17221_ \memory_i.datain_reg[31]\ _17076_ VPWR VGND sg13g2_nor2_1
X_24932_ _17222_ _17082_ _17220_ _17221_ VPWR VGND sg13g2_a21oi_1
X_24933_ _01063_ reset _17222_ VPWR VGND sg13g2_and2_1
X_24934_ _17223_ \memory_i.state[1]\ _13017_ VPWR VGND sg13g2_nand2_1
X_24935_ _17224_ _17223_ VPWR VGND sg13g2_buf_1
X_24936_ _17225_ _13800_ _13869_ _17224_ VPWR VGND sg13g2_nor3_1
X_24937_ _17226_ _17225_ VPWR VGND sg13g2_buf_1
X_24938_ _17227_ _17226_ \memory_i.mtimecmp[0]\ VPWR VGND sg13g2_nand2b_1
X_24939_ _17228_ _17225_ VPWR VGND sg13g2_buf_1
X_24940_ _17229_ _17228_ VPWR VGND sg13g2_buf_1
X_24941_ _17230_ \memory_i.datain_reg[0]\ _17229_ VPWR VGND sg13g2_nand2_1
X_24942_ _01064_ _17227_ _17230_ _16755_ VPWR VGND sg13g2_a21oi_1
X_24943_ _17231_ _17226_ \memory_i.mtimecmp[1]\ VPWR VGND sg13g2_nand2b_1
X_24944_ _17232_ \memory_i.datain_reg[1]\ _17229_ VPWR VGND sg13g2_nand2_1
X_24945_ _01065_ _17231_ _17232_ _16755_ VPWR VGND sg13g2_a21oi_1
X_24946_ _17233_ _17226_ \memory_i.mtimecmp[2]\ VPWR VGND sg13g2_nand2b_1
X_24947_ _17234_ \memory_i.datain_reg[2]\ _17229_ VPWR VGND sg13g2_nand2_1
X_24948_ _01066_ _17233_ _17234_ _16755_ VPWR VGND sg13g2_a21oi_1
X_24949_ _17235_ _17226_ \memory_i.mtimecmp[3]\ VPWR VGND sg13g2_nand2b_1
X_24950_ _17236_ \memory_i.datain_reg[3]\ _17229_ VPWR VGND sg13g2_nand2_1
X_24951_ _01067_ _17235_ _17236_ _16755_ VPWR VGND sg13g2_a21oi_1
X_24952_ _17237_ _17226_ \memory_i.mtimecmp[4]\ VPWR VGND sg13g2_nand2b_1
X_24953_ _17238_ \memory_i.datain_reg[4]\ _17229_ VPWR VGND sg13g2_nand2_1
X_24954_ _01068_ _17237_ _17238_ _16755_ VPWR VGND sg13g2_a21oi_1
X_24955_ _17239_ _17226_ \memory_i.mtimecmp[5]\ VPWR VGND sg13g2_nand2b_1
X_24956_ _17240_ \memory_i.datain_reg[5]\ _17229_ VPWR VGND sg13g2_nand2_1
X_24957_ _01069_ _17239_ _17240_ _16755_ VPWR VGND sg13g2_a21oi_1
X_24958_ _17241_ _17226_ \memory_i.mtimecmp[6]\ VPWR VGND sg13g2_nand2b_1
X_24959_ _17242_ \memory_i.datain_reg[6]\ _17229_ VPWR VGND sg13g2_nand2_1
X_24960_ _01070_ _17241_ _17242_ _16755_ VPWR VGND sg13g2_a21oi_1
X_24961_ _17243_ _17226_ \memory_i.mtimecmp[7]\ VPWR VGND sg13g2_nand2b_1
X_24962_ _17244_ \memory_i.datain_reg[7]\ _17229_ VPWR VGND sg13g2_nand2_1
X_24963_ _01071_ _17243_ _17244_ _16755_ VPWR VGND sg13g2_a21oi_1
X_24964_ _17245_ _17228_ VPWR VGND sg13g2_buf_1
X_24965_ _17246_ _17245_ \memory_i.mtimecmp[8]\ VPWR VGND sg13g2_nand2b_1
X_24966_ _17247_ \memory_i.datain_reg[8]\ _17229_ VPWR VGND sg13g2_nand2_1
X_24967_ _17248_ _16754_ VPWR VGND sg13g2_buf_1
X_24968_ _01072_ _17246_ _17247_ _17248_ VPWR VGND sg13g2_a21oi_1
X_24969_ _17249_ _17245_ \memory_i.mtimecmp[9]\ VPWR VGND sg13g2_nand2b_1
X_24970_ _17250_ \memory_i.datain_reg[9]\ _17229_ VPWR VGND sg13g2_nand2_1
X_24971_ _01073_ _17249_ _17250_ _17248_ VPWR VGND sg13g2_a21oi_1
X_24972_ _17251_ _17245_ \memory_i.mtimecmp[10]\ VPWR VGND sg13g2_nand2b_1
X_24973_ _17252_ _17228_ VPWR VGND sg13g2_buf_1
X_24974_ _17253_ \memory_i.datain_reg[10]\ _17252_ VPWR VGND sg13g2_nand2_1
X_24975_ _01074_ _17251_ _17253_ _17248_ VPWR VGND sg13g2_a21oi_1
X_24976_ _17254_ _17245_ \memory_i.mtimecmp[11]\ VPWR VGND sg13g2_nand2b_1
X_24977_ _17255_ \memory_i.datain_reg[11]\ _17252_ VPWR VGND sg13g2_nand2_1
X_24978_ _01075_ _17254_ _17255_ _17248_ VPWR VGND sg13g2_a21oi_1
X_24979_ _17256_ _17245_ \memory_i.mtimecmp[12]\ VPWR VGND sg13g2_nand2b_1
X_24980_ _17257_ \memory_i.datain_reg[12]\ _17252_ VPWR VGND sg13g2_nand2_1
X_24981_ _01076_ _17256_ _17257_ _17248_ VPWR VGND sg13g2_a21oi_1
X_24982_ _17258_ _17245_ \memory_i.mtimecmp[13]\ VPWR VGND sg13g2_nand2b_1
X_24983_ _17259_ \memory_i.datain_reg[13]\ _17252_ VPWR VGND sg13g2_nand2_1
X_24984_ _01077_ _17258_ _17259_ _17248_ VPWR VGND sg13g2_a21oi_1
X_24985_ _17260_ _17245_ \memory_i.mtimecmp[14]\ VPWR VGND sg13g2_nand2b_1
X_24986_ _17261_ \memory_i.datain_reg[14]\ _17252_ VPWR VGND sg13g2_nand2_1
X_24987_ _01078_ _17260_ _17261_ _17248_ VPWR VGND sg13g2_a21oi_1
X_24988_ _17262_ _17245_ \memory_i.mtimecmp[15]\ VPWR VGND sg13g2_nand2b_1
X_24989_ _17263_ \memory_i.datain_reg[15]\ _17252_ VPWR VGND sg13g2_nand2_1
X_24990_ _01079_ _17262_ _17263_ _17248_ VPWR VGND sg13g2_a21oi_1
X_24991_ _17264_ _17245_ \memory_i.mtimecmp[16]\ VPWR VGND sg13g2_nand2b_1
X_24992_ _17265_ \memory_i.datain_reg[16]\ _17252_ VPWR VGND sg13g2_nand2_1
X_24993_ _01080_ _17264_ _17265_ _17248_ VPWR VGND sg13g2_a21oi_1
X_24994_ _17266_ _17245_ \memory_i.mtimecmp[17]\ VPWR VGND sg13g2_nand2b_1
X_24995_ _17267_ \memory_i.datain_reg[17]\ _17252_ VPWR VGND sg13g2_nand2_1
X_24996_ _01081_ _17266_ _17267_ _17248_ VPWR VGND sg13g2_a21oi_1
X_24997_ _17268_ _17228_ VPWR VGND sg13g2_buf_1
X_24998_ _17269_ _17268_ \memory_i.mtimecmp[18]\ VPWR VGND sg13g2_nand2b_1
X_24999_ _17270_ \memory_i.datain_reg[18]\ _17252_ VPWR VGND sg13g2_nand2_1
X_25000_ _17271_ _16754_ VPWR VGND sg13g2_buf_1
X_25001_ _01082_ _17269_ _17270_ _17271_ VPWR VGND sg13g2_a21oi_1
X_25002_ _17272_ _17268_ \memory_i.mtimecmp[19]\ VPWR VGND sg13g2_nand2b_1
X_25003_ _17273_ \memory_i.datain_reg[19]\ _17252_ VPWR VGND sg13g2_nand2_1
X_25004_ _01083_ _17272_ _17273_ _17271_ VPWR VGND sg13g2_a21oi_1
X_25005_ _17274_ _17268_ \memory_i.mtimecmp[20]\ VPWR VGND sg13g2_nand2b_1
X_25006_ _17275_ _17228_ VPWR VGND sg13g2_buf_1
X_25007_ _17276_ \memory_i.datain_reg[20]\ _17275_ VPWR VGND sg13g2_nand2_1
X_25008_ _01084_ _17274_ _17276_ _17271_ VPWR VGND sg13g2_a21oi_1
X_25009_ _17277_ _17268_ \memory_i.mtimecmp[21]\ VPWR VGND sg13g2_nand2b_1
X_25010_ _17278_ \memory_i.datain_reg[21]\ _17275_ VPWR VGND sg13g2_nand2_1
X_25011_ _01085_ _17277_ _17278_ _17271_ VPWR VGND sg13g2_a21oi_1
X_25012_ _17279_ _17268_ \memory_i.mtimecmp[22]\ VPWR VGND sg13g2_nand2b_1
X_25013_ _17280_ \memory_i.datain_reg[22]\ _17275_ VPWR VGND sg13g2_nand2_1
X_25014_ _01086_ _17279_ _17280_ _17271_ VPWR VGND sg13g2_a21oi_1
X_25015_ _17281_ _17268_ \memory_i.mtimecmp[23]\ VPWR VGND sg13g2_nand2b_1
X_25016_ _17282_ \memory_i.datain_reg[23]\ _17275_ VPWR VGND sg13g2_nand2_1
X_25017_ _01087_ _17281_ _17282_ _17271_ VPWR VGND sg13g2_a21oi_1
X_25018_ _17283_ _17268_ \memory_i.mtimecmp[24]\ VPWR VGND sg13g2_nand2b_1
X_25019_ _17284_ \memory_i.datain_reg[24]\ _17275_ VPWR VGND sg13g2_nand2_1
X_25020_ _01088_ _17283_ _17284_ _17271_ VPWR VGND sg13g2_a21oi_1
X_25021_ _17285_ _17268_ \memory_i.mtimecmp[25]\ VPWR VGND sg13g2_nand2b_1
X_25022_ _17286_ \memory_i.datain_reg[25]\ _17275_ VPWR VGND sg13g2_nand2_1
X_25023_ _01089_ _17285_ _17286_ _17271_ VPWR VGND sg13g2_a21oi_1
X_25024_ _17287_ _17268_ \memory_i.mtimecmp[26]\ VPWR VGND sg13g2_nand2b_1
X_25025_ _17288_ \memory_i.datain_reg[26]\ _17275_ VPWR VGND sg13g2_nand2_1
X_25026_ _01090_ _17287_ _17288_ _17271_ VPWR VGND sg13g2_a21oi_1
X_25027_ _17289_ _17268_ \memory_i.mtimecmp[27]\ VPWR VGND sg13g2_nand2b_1
X_25028_ _17290_ \memory_i.datain_reg[27]\ _17275_ VPWR VGND sg13g2_nand2_1
X_25029_ _01091_ _17289_ _17290_ _17271_ VPWR VGND sg13g2_a21oi_1
X_25030_ _17291_ _17228_ \memory_i.mtimecmp[28]\ VPWR VGND sg13g2_nand2b_1
X_25031_ _17292_ \memory_i.datain_reg[28]\ _17275_ VPWR VGND sg13g2_nand2_1
X_25032_ _17293_ _16754_ VPWR VGND sg13g2_buf_1
X_25033_ _01092_ _17291_ _17292_ _17293_ VPWR VGND sg13g2_a21oi_1
X_25034_ _17294_ _17228_ \memory_i.mtimecmp[29]\ VPWR VGND sg13g2_nand2b_1
X_25035_ _17295_ \memory_i.datain_reg[29]\ _17275_ VPWR VGND sg13g2_nand2_1
X_25036_ _01093_ _17294_ _17295_ _17293_ VPWR VGND sg13g2_a21oi_1
X_25037_ _17296_ _17228_ \memory_i.mtimecmp[30]\ VPWR VGND sg13g2_nand2b_1
X_25038_ _17297_ \memory_i.datain_reg[30]\ _17226_ VPWR VGND sg13g2_nand2_1
X_25039_ _01094_ _17296_ _17297_ _17293_ VPWR VGND sg13g2_a21oi_1
X_25040_ _17298_ _17228_ \memory_i.mtimecmp[31]\ VPWR VGND sg13g2_nand2b_1
X_25041_ _17299_ \memory_i.datain_reg[31]\ _17226_ VPWR VGND sg13g2_nand2_1
X_25042_ _01095_ _17298_ _17299_ _17293_ VPWR VGND sg13g2_a21oi_1
X_25043_ _17300_ _13795_ VPWR VGND sg13g2_buf_1
X_25044_ _17301_ _17224_ VPWR VGND sg13g2_buf_1
X_25045_ _17302_ _17301_ VPWR VGND sg13g2_buf_1
X_25046_ _17303_ _17300_ _17302_ \memory_i.mtimecmp[32]\ VPWR VGND sg13g2_o21ai_1
X_25047_ _17304_ _13795_ _17224_ VPWR VGND sg13g2_nor2_1
X_25048_ _17305_ _17304_ VPWR VGND sg13g2_buf_1
X_25049_ _17306_ _17305_ VPWR VGND sg13g2_buf_1
X_25050_ _17307_ \memory_i.datain_reg[0]\ _17306_ VPWR VGND sg13g2_nand2_1
X_25051_ _01096_ _17303_ _17307_ _17293_ VPWR VGND sg13g2_a21oi_1
X_25052_ _17308_ _17300_ _17302_ \memory_i.mtimecmp[33]\ VPWR VGND sg13g2_o21ai_1
X_25053_ _17309_ \memory_i.datain_reg[1]\ _17306_ VPWR VGND sg13g2_nand2_1
X_25054_ _01097_ _17308_ _17309_ _17293_ VPWR VGND sg13g2_a21oi_1
X_25055_ _17310_ _17300_ _17302_ \memory_i.mtimecmp[34]\ VPWR VGND sg13g2_o21ai_1
X_25056_ _17311_ \memory_i.datain_reg[2]\ _17306_ VPWR VGND sg13g2_nand2_1
X_25057_ _01098_ _17310_ _17311_ _17293_ VPWR VGND sg13g2_a21oi_1
X_25058_ _17312_ _17300_ _17302_ \memory_i.mtimecmp[35]\ VPWR VGND sg13g2_o21ai_1
X_25059_ _17313_ \memory_i.datain_reg[3]\ _17306_ VPWR VGND sg13g2_nand2_1
X_25060_ _01099_ _17312_ _17313_ _17293_ VPWR VGND sg13g2_a21oi_1
X_25061_ _17314_ _17300_ _17302_ \memory_i.mtimecmp[36]\ VPWR VGND sg13g2_o21ai_1
X_25062_ _17315_ \memory_i.datain_reg[4]\ _17306_ VPWR VGND sg13g2_nand2_1
X_25063_ _01100_ _17314_ _17315_ _17293_ VPWR VGND sg13g2_a21oi_1
X_25064_ _17316_ _17300_ _17302_ \memory_i.mtimecmp[37]\ VPWR VGND sg13g2_o21ai_1
X_25065_ _17317_ \memory_i.datain_reg[5]\ _17306_ VPWR VGND sg13g2_nand2_1
X_25066_ _01101_ _17316_ _17317_ _17293_ VPWR VGND sg13g2_a21oi_1
X_25067_ _17318_ _17300_ _17302_ \memory_i.mtimecmp[38]\ VPWR VGND sg13g2_o21ai_1
X_25068_ _17319_ \memory_i.datain_reg[6]\ _17306_ VPWR VGND sg13g2_nand2_1
X_25069_ _17320_ _16754_ VPWR VGND sg13g2_buf_1
X_25070_ _01102_ _17318_ _17319_ _17320_ VPWR VGND sg13g2_a21oi_1
X_25071_ _17321_ _17301_ VPWR VGND sg13g2_buf_1
X_25072_ _17322_ _17300_ _17321_ \memory_i.mtimecmp[39]\ VPWR VGND sg13g2_o21ai_1
X_25073_ _17323_ \memory_i.datain_reg[7]\ _17306_ VPWR VGND sg13g2_nand2_1
X_25074_ _01103_ _17322_ _17323_ _17320_ VPWR VGND sg13g2_a21oi_1
X_25075_ _17324_ _17300_ _17321_ \memory_i.mtimecmp[40]\ VPWR VGND sg13g2_o21ai_1
X_25076_ _17325_ \memory_i.datain_reg[8]\ _17306_ VPWR VGND sg13g2_nand2_1
X_25077_ _01104_ _17324_ _17325_ _17320_ VPWR VGND sg13g2_a21oi_1
X_25078_ _17326_ _17300_ _17321_ \memory_i.mtimecmp[41]\ VPWR VGND sg13g2_o21ai_1
X_25079_ _17327_ \memory_i.datain_reg[9]\ _17306_ VPWR VGND sg13g2_nand2_1
X_25080_ _01105_ _17326_ _17327_ _17320_ VPWR VGND sg13g2_a21oi_1
X_25081_ _17328_ _13795_ VPWR VGND sg13g2_buf_1
X_25082_ _17329_ _17328_ _17321_ \memory_i.mtimecmp[42]\ VPWR VGND sg13g2_o21ai_1
X_25083_ _17330_ _17305_ VPWR VGND sg13g2_buf_1
X_25084_ _17331_ \memory_i.datain_reg[10]\ _17330_ VPWR VGND sg13g2_nand2_1
X_25085_ _01106_ _17329_ _17331_ _17320_ VPWR VGND sg13g2_a21oi_1
X_25086_ _17332_ _17328_ _17321_ \memory_i.mtimecmp[43]\ VPWR VGND sg13g2_o21ai_1
X_25087_ _17333_ \memory_i.datain_reg[11]\ _17330_ VPWR VGND sg13g2_nand2_1
X_25088_ _01107_ _17332_ _17333_ _17320_ VPWR VGND sg13g2_a21oi_1
X_25089_ _17334_ _17328_ _17321_ \memory_i.mtimecmp[44]\ VPWR VGND sg13g2_o21ai_1
X_25090_ _17335_ \memory_i.datain_reg[12]\ _17330_ VPWR VGND sg13g2_nand2_1
X_25091_ _01108_ _17334_ _17335_ _17320_ VPWR VGND sg13g2_a21oi_1
X_25092_ _17336_ _17328_ _17321_ \memory_i.mtimecmp[45]\ VPWR VGND sg13g2_o21ai_1
X_25093_ _17337_ \memory_i.datain_reg[13]\ _17330_ VPWR VGND sg13g2_nand2_1
X_25094_ _01109_ _17336_ _17337_ _17320_ VPWR VGND sg13g2_a21oi_1
X_25095_ _17338_ _17328_ _17321_ \memory_i.mtimecmp[46]\ VPWR VGND sg13g2_o21ai_1
X_25096_ _17339_ \memory_i.datain_reg[14]\ _17330_ VPWR VGND sg13g2_nand2_1
X_25097_ _01110_ _17338_ _17339_ _17320_ VPWR VGND sg13g2_a21oi_1
X_25098_ _17340_ _17328_ _17321_ \memory_i.mtimecmp[47]\ VPWR VGND sg13g2_o21ai_1
X_25099_ _17341_ \memory_i.datain_reg[15]\ _17330_ VPWR VGND sg13g2_nand2_1
X_25100_ _01111_ _17340_ _17341_ _17320_ VPWR VGND sg13g2_a21oi_1
X_25101_ _17342_ _17328_ _17321_ \memory_i.mtimecmp[48]\ VPWR VGND sg13g2_o21ai_1
X_25102_ _17343_ \memory_i.datain_reg[16]\ _17330_ VPWR VGND sg13g2_nand2_1
X_25103_ _02215_ _16754_ VPWR VGND sg13g2_buf_1
X_25104_ _01112_ _17342_ _17343_ _02215_ VPWR VGND sg13g2_a21oi_1
X_25105_ _02216_ _17301_ VPWR VGND sg13g2_buf_1
X_25106_ _02217_ _17328_ _02216_ \memory_i.mtimecmp[49]\ VPWR VGND sg13g2_o21ai_1
X_25107_ _02218_ \memory_i.datain_reg[17]\ _17330_ VPWR VGND sg13g2_nand2_1
X_25108_ _01113_ _02217_ _02218_ _02215_ VPWR VGND sg13g2_a21oi_1
X_25109_ _02219_ _17328_ _02216_ \memory_i.mtimecmp[50]\ VPWR VGND sg13g2_o21ai_1
X_25110_ _02220_ \memory_i.datain_reg[18]\ _17330_ VPWR VGND sg13g2_nand2_1
X_25111_ _01114_ _02219_ _02220_ _02215_ VPWR VGND sg13g2_a21oi_1
X_25112_ _02221_ _17328_ _02216_ \memory_i.mtimecmp[51]\ VPWR VGND sg13g2_o21ai_1
X_25113_ _02222_ \memory_i.datain_reg[19]\ _17330_ VPWR VGND sg13g2_nand2_1
X_25114_ _01115_ _02221_ _02222_ _02215_ VPWR VGND sg13g2_a21oi_1
X_25115_ _02223_ _13795_ VPWR VGND sg13g2_buf_1
X_25116_ _02224_ _02223_ _02216_ \memory_i.mtimecmp[52]\ VPWR VGND sg13g2_o21ai_1
X_25117_ _02225_ _17305_ VPWR VGND sg13g2_buf_1
X_25118_ _02226_ \memory_i.datain_reg[20]\ _02225_ VPWR VGND sg13g2_nand2_1
X_25119_ _01116_ _02224_ _02226_ _02215_ VPWR VGND sg13g2_a21oi_1
X_25120_ _02227_ _02223_ _02216_ \memory_i.mtimecmp[53]\ VPWR VGND sg13g2_o21ai_1
X_25121_ _02228_ \memory_i.datain_reg[21]\ _02225_ VPWR VGND sg13g2_nand2_1
X_25122_ _01117_ _02227_ _02228_ _02215_ VPWR VGND sg13g2_a21oi_1
X_25123_ _02229_ _02223_ _02216_ \memory_i.mtimecmp[54]\ VPWR VGND sg13g2_o21ai_1
X_25124_ _02230_ \memory_i.datain_reg[22]\ _02225_ VPWR VGND sg13g2_nand2_1
X_25125_ _01118_ _02229_ _02230_ _02215_ VPWR VGND sg13g2_a21oi_1
X_25126_ _02231_ _02223_ _02216_ \memory_i.mtimecmp[55]\ VPWR VGND sg13g2_o21ai_1
X_25127_ _02232_ \memory_i.datain_reg[23]\ _02225_ VPWR VGND sg13g2_nand2_1
X_25128_ _01119_ _02231_ _02232_ _02215_ VPWR VGND sg13g2_a21oi_1
X_25129_ _02233_ _02223_ _02216_ \memory_i.mtimecmp[56]\ VPWR VGND sg13g2_o21ai_1
X_25130_ _02234_ \memory_i.datain_reg[24]\ _02225_ VPWR VGND sg13g2_nand2_1
X_25131_ _01120_ _02233_ _02234_ _02215_ VPWR VGND sg13g2_a21oi_1
X_25132_ _02235_ _02223_ _02216_ \memory_i.mtimecmp[57]\ VPWR VGND sg13g2_o21ai_1
X_25133_ _02236_ \memory_i.datain_reg[25]\ _02225_ VPWR VGND sg13g2_nand2_1
X_25134_ _01121_ _02235_ _02236_ _02215_ VPWR VGND sg13g2_a21oi_1
X_25135_ _02237_ _02223_ _02216_ \memory_i.mtimecmp[58]\ VPWR VGND sg13g2_o21ai_1
X_25136_ _02238_ \memory_i.datain_reg[26]\ _02225_ VPWR VGND sg13g2_nand2_1
X_25137_ _02239_ _16754_ VPWR VGND sg13g2_buf_1
X_25138_ _01122_ _02237_ _02238_ _02239_ VPWR VGND sg13g2_a21oi_1
X_25139_ _02240_ _17301_ VPWR VGND sg13g2_buf_1
X_25140_ _02241_ _02223_ _02240_ \memory_i.mtimecmp[59]\ VPWR VGND sg13g2_o21ai_1
X_25141_ _02242_ \memory_i.datain_reg[27]\ _02225_ VPWR VGND sg13g2_nand2_1
X_25142_ _01123_ _02241_ _02242_ _02239_ VPWR VGND sg13g2_a21oi_1
X_25143_ _02243_ _02223_ _02240_ \memory_i.mtimecmp[60]\ VPWR VGND sg13g2_o21ai_1
X_25144_ _02244_ \memory_i.datain_reg[28]\ _02225_ VPWR VGND sg13g2_nand2_1
X_25145_ _01124_ _02243_ _02244_ _02239_ VPWR VGND sg13g2_a21oi_1
X_25146_ _02245_ _02223_ _02240_ \memory_i.mtimecmp[61]\ VPWR VGND sg13g2_o21ai_1
X_25147_ _02246_ \memory_i.datain_reg[29]\ _02225_ VPWR VGND sg13g2_nand2_1
X_25148_ _01125_ _02245_ _02246_ _02239_ VPWR VGND sg13g2_a21oi_1
X_25149_ _02247_ _13795_ _02240_ \memory_i.mtimecmp[62]\ VPWR VGND sg13g2_o21ai_1
X_25150_ _02248_ \memory_i.datain_reg[30]\ _17305_ VPWR VGND sg13g2_nand2_1
X_25151_ _01126_ _02247_ _02248_ _02239_ VPWR VGND sg13g2_a21oi_1
X_25152_ _02249_ _13795_ _02240_ \memory_i.mtimecmp[63]\ VPWR VGND sg13g2_o21ai_1
X_25153_ _02250_ \memory_i.datain_reg[31]\ _17305_ VPWR VGND sg13g2_nand2_1
X_25154_ _01127_ _02249_ _02250_ _02239_ VPWR VGND sg13g2_a21oi_1
X_25155_ _02251_ _13315_ _13335_ _13009_ VPWR VGND sg13g2_o21ai_1
X_25156_ _02252_ _13041_ _13044_ _02251_ VPWR VGND sg13g2_nor3_1
X_25157_ _02253_ _13019_ _13326_ _02252_ VPWR VGND sg13g2_nor3_1
X_25158_ _02254_ _02253_ VPWR VGND sg13g2_buf_1
X_25159_ _02255_ _02254_ VPWR VGND sg13g2_buf_1
X_25160_ _02256_ _16758_ _13022_ VPWR VGND sg13g2_nor2_1
X_25161_ _02257_ \memory_i.datain[24]\ _13023_ _02256_ VPWR VGND sg13g2_a21oi_1
X_25162_ _02258_ _02253_ VPWR VGND sg13g2_buf_1
X_25163_ _02259_ \memory_i.datain_reg[0]\ _02258_ VPWR VGND sg13g2_nor2_1
X_25164_ _01128_ _02255_ _02257_ _02259_ VPWR VGND sg13g2_a21oi_1
X_25165_ _02260_ _16764_ _13022_ VPWR VGND sg13g2_nor2_1
X_25166_ _02261_ \memory_i.datain[25]\ _13023_ _02260_ VPWR VGND sg13g2_a21oi_1
X_25167_ _02262_ \memory_i.datain_reg[1]\ _02258_ VPWR VGND sg13g2_nor2_1
X_25168_ _01129_ _02255_ _02261_ _02262_ VPWR VGND sg13g2_a21oi_1
X_25169_ _02263_ _12980_ VPWR VGND sg13g2_buf_1
X_25170_ _02264_ _02263_ \memory_i.datain[2]\ VPWR VGND sg13g2_nor2b_1
X_25171_ _02265_ \memory_i.datain[26]\ _13023_ _02264_ VPWR VGND sg13g2_a21oi_1
X_25172_ _02266_ \memory_i.datain_reg[2]\ _02258_ VPWR VGND sg13g2_nor2_1
X_25173_ _01130_ _02255_ _02265_ _02266_ VPWR VGND sg13g2_a21oi_1
X_25174_ _02267_ _02263_ \memory_i.datain[3]\ VPWR VGND sg13g2_nor2b_1
X_25175_ _02268_ \memory_i.datain[27]\ _13023_ _02267_ VPWR VGND sg13g2_a21oi_1
X_25176_ _02269_ \memory_i.datain_reg[3]\ _02258_ VPWR VGND sg13g2_nor2_1
X_25177_ _01131_ _02255_ _02268_ _02269_ VPWR VGND sg13g2_a21oi_1
X_25178_ _02270_ _02263_ \memory_i.datain[4]\ VPWR VGND sg13g2_nor2b_1
X_25179_ _02271_ \memory_i.datain[28]\ _13023_ _02270_ VPWR VGND sg13g2_a21oi_1
X_25180_ _02272_ \memory_i.datain_reg[4]\ _02258_ VPWR VGND sg13g2_nor2_1
X_25181_ _01132_ _02255_ _02271_ _02272_ VPWR VGND sg13g2_a21oi_1
X_25182_ _02273_ _02263_ \memory_i.datain[5]\ VPWR VGND sg13g2_nor2b_1
X_25183_ _02274_ \memory_i.datain[29]\ _13023_ _02273_ VPWR VGND sg13g2_a21oi_1
X_25184_ _02275_ \memory_i.datain_reg[5]\ _02258_ VPWR VGND sg13g2_nor2_1
X_25185_ _01133_ _02255_ _02274_ _02275_ VPWR VGND sg13g2_a21oi_1
X_25186_ _02276_ _02263_ \memory_i.datain[6]\ VPWR VGND sg13g2_nor2b_1
X_25187_ _02277_ \memory_i.datain[30]\ _13023_ _02276_ VPWR VGND sg13g2_a21oi_1
X_25188_ _02278_ \memory_i.datain_reg[6]\ _02258_ VPWR VGND sg13g2_nor2_1
X_25189_ _01134_ _02255_ _02277_ _02278_ VPWR VGND sg13g2_a21oi_1
X_25190_ _02279_ _02263_ \memory_i.datain[7]\ VPWR VGND sg13g2_nor2b_1
X_25191_ _02280_ \memory_i.datain[31]\ _13023_ _02279_ VPWR VGND sg13g2_a21oi_1
X_25192_ _02281_ \memory_i.datain_reg[7]\ _02258_ VPWR VGND sg13g2_nor2_1
X_25193_ _01135_ _02255_ _02280_ _02281_ VPWR VGND sg13g2_a21oi_1
X_25194_ _02282_ _13022_ VPWR VGND sg13g2_buf_1
X_25195_ _02283_ _13022_ VPWR VGND sg13g2_buf_1
X_25196_ _02284_ _02283_ \memory_i.datain[8]\ VPWR VGND sg13g2_nor2b_1
X_25197_ _02285_ \memory_i.datain[16]\ _02282_ _02284_ VPWR VGND sg13g2_a21oi_1
X_25198_ _02286_ _02254_ VPWR VGND sg13g2_buf_1
X_25199_ _02287_ \memory_i.datain_reg[8]\ _02286_ VPWR VGND sg13g2_nor2_1
X_25200_ _01136_ _02255_ _02285_ _02287_ VPWR VGND sg13g2_a21oi_1
X_25201_ _02288_ _02283_ \memory_i.datain[9]\ VPWR VGND sg13g2_nor2b_1
X_25202_ _02289_ \memory_i.datain[17]\ _02282_ _02288_ VPWR VGND sg13g2_a21oi_1
X_25203_ _02290_ \memory_i.datain_reg[9]\ _02286_ VPWR VGND sg13g2_nor2_1
X_25204_ _01137_ _02255_ _02289_ _02290_ VPWR VGND sg13g2_a21oi_1
X_25205_ _02291_ _02254_ VPWR VGND sg13g2_buf_1
X_25206_ _02292_ _02283_ \memory_i.datain[10]\ VPWR VGND sg13g2_nor2b_1
X_25207_ _02293_ \memory_i.datain[18]\ _02282_ _02292_ VPWR VGND sg13g2_a21oi_1
X_25208_ _02294_ \memory_i.datain_reg[10]\ _02286_ VPWR VGND sg13g2_nor2_1
X_25209_ _01138_ _02291_ _02293_ _02294_ VPWR VGND sg13g2_a21oi_1
X_25210_ _02295_ _02283_ \memory_i.datain[11]\ VPWR VGND sg13g2_nor2b_1
X_25211_ _02296_ \memory_i.datain[19]\ _02282_ _02295_ VPWR VGND sg13g2_a21oi_1
X_25212_ _02297_ \memory_i.datain_reg[11]\ _02286_ VPWR VGND sg13g2_nor2_1
X_25213_ _01139_ _02291_ _02296_ _02297_ VPWR VGND sg13g2_a21oi_1
X_25214_ _02298_ _02283_ \memory_i.datain[12]\ VPWR VGND sg13g2_nor2b_1
X_25215_ _02299_ \memory_i.datain[20]\ _02282_ _02298_ VPWR VGND sg13g2_a21oi_1
X_25216_ _02300_ \memory_i.datain_reg[12]\ _02286_ VPWR VGND sg13g2_nor2_1
X_25217_ _01140_ _02291_ _02299_ _02300_ VPWR VGND sg13g2_a21oi_1
X_25218_ _02301_ _02283_ \memory_i.datain[13]\ VPWR VGND sg13g2_nor2b_1
X_25219_ _02302_ \memory_i.datain[21]\ _02282_ _02301_ VPWR VGND sg13g2_a21oi_1
X_25220_ _02303_ \memory_i.datain_reg[13]\ _02286_ VPWR VGND sg13g2_nor2_1
X_25221_ _01141_ _02291_ _02302_ _02303_ VPWR VGND sg13g2_a21oi_1
X_25222_ _02304_ _02283_ \memory_i.datain[14]\ VPWR VGND sg13g2_nor2b_1
X_25223_ _02305_ \memory_i.datain[22]\ _02282_ _02304_ VPWR VGND sg13g2_a21oi_1
X_25224_ _02306_ \memory_i.datain_reg[14]\ _02286_ VPWR VGND sg13g2_nor2_1
X_25225_ _01142_ _02291_ _02305_ _02306_ VPWR VGND sg13g2_a21oi_1
X_25226_ _02307_ _02283_ \memory_i.datain[15]\ VPWR VGND sg13g2_nor2b_1
X_25227_ _02308_ \memory_i.datain[23]\ _02282_ _02307_ VPWR VGND sg13g2_a21oi_1
X_25228_ _02309_ \memory_i.datain_reg[15]\ _02286_ VPWR VGND sg13g2_nor2_1
X_25229_ _01143_ _02291_ _02308_ _02309_ VPWR VGND sg13g2_a21oi_1
X_25230_ _02310_ _02283_ \memory_i.datain[16]\ VPWR VGND sg13g2_nor2b_1
X_25231_ _02311_ \memory_i.datain[8]\ _02282_ _02310_ VPWR VGND sg13g2_a21oi_1
X_25232_ _02312_ \memory_i.datain_reg[16]\ _02286_ VPWR VGND sg13g2_nor2_1
X_25233_ _01144_ _02291_ _02311_ _02312_ VPWR VGND sg13g2_a21oi_1
X_25234_ _02313_ _02283_ \memory_i.datain[17]\ VPWR VGND sg13g2_nor2b_1
X_25235_ _02314_ \memory_i.datain[9]\ _02282_ _02313_ VPWR VGND sg13g2_a21oi_1
X_25236_ _02315_ \memory_i.datain_reg[17]\ _02286_ VPWR VGND sg13g2_nor2_1
X_25237_ _01145_ _02291_ _02314_ _02315_ VPWR VGND sg13g2_a21oi_1
X_25238_ _02316_ _13022_ VPWR VGND sg13g2_buf_1
X_25239_ _02317_ _12980_ VPWR VGND sg13g2_buf_1
X_25240_ _02318_ _02317_ \memory_i.datain[18]\ VPWR VGND sg13g2_nor2b_1
X_25241_ _02319_ \memory_i.datain[10]\ _02316_ _02318_ VPWR VGND sg13g2_a21oi_1
X_25242_ _02320_ _02254_ VPWR VGND sg13g2_buf_1
X_25243_ _02321_ \memory_i.datain_reg[18]\ _02320_ VPWR VGND sg13g2_nor2_1
X_25244_ _01146_ _02291_ _02319_ _02321_ VPWR VGND sg13g2_a21oi_1
X_25245_ _02322_ _02317_ \memory_i.datain[19]\ VPWR VGND sg13g2_nor2b_1
X_25246_ _02323_ \memory_i.datain[11]\ _02316_ _02322_ VPWR VGND sg13g2_a21oi_1
X_25247_ _02324_ \memory_i.datain_reg[19]\ _02320_ VPWR VGND sg13g2_nor2_1
X_25248_ _01147_ _02291_ _02323_ _02324_ VPWR VGND sg13g2_a21oi_1
X_25249_ _02325_ _02254_ VPWR VGND sg13g2_buf_1
X_25250_ _02326_ _02317_ \memory_i.datain[20]\ VPWR VGND sg13g2_nor2b_1
X_25251_ _02327_ \memory_i.datain[12]\ _02316_ _02326_ VPWR VGND sg13g2_a21oi_1
X_25252_ _02328_ \memory_i.datain_reg[20]\ _02320_ VPWR VGND sg13g2_nor2_1
X_25253_ _01148_ _02325_ _02327_ _02328_ VPWR VGND sg13g2_a21oi_1
X_25254_ _02329_ _02317_ \memory_i.datain[21]\ VPWR VGND sg13g2_nor2b_1
X_25255_ _02330_ \memory_i.datain[13]\ _02316_ _02329_ VPWR VGND sg13g2_a21oi_1
X_25256_ _02331_ \memory_i.datain_reg[21]\ _02320_ VPWR VGND sg13g2_nor2_1
X_25257_ _01149_ _02325_ _02330_ _02331_ VPWR VGND sg13g2_a21oi_1
X_25258_ _02332_ _02317_ \memory_i.datain[22]\ VPWR VGND sg13g2_nor2b_1
X_25259_ _02333_ \memory_i.datain[14]\ _02316_ _02332_ VPWR VGND sg13g2_a21oi_1
X_25260_ _02334_ \memory_i.datain_reg[22]\ _02320_ VPWR VGND sg13g2_nor2_1
X_25261_ _01150_ _02325_ _02333_ _02334_ VPWR VGND sg13g2_a21oi_1
X_25262_ _02335_ _02317_ \memory_i.datain[23]\ VPWR VGND sg13g2_nor2b_1
X_25263_ _02336_ \memory_i.datain[15]\ _02316_ _02335_ VPWR VGND sg13g2_a21oi_1
X_25264_ _02337_ \memory_i.datain_reg[23]\ _02320_ VPWR VGND sg13g2_nor2_1
X_25265_ _01151_ _02325_ _02336_ _02337_ VPWR VGND sg13g2_a21oi_1
X_25266_ _02338_ _02317_ \memory_i.datain[24]\ VPWR VGND sg13g2_nor2b_1
X_25267_ _02339_ \memory_i.datain[0]\ _02316_ _02338_ VPWR VGND sg13g2_a21oi_1
X_25268_ _02340_ \memory_i.datain_reg[24]\ _02320_ VPWR VGND sg13g2_nor2_1
X_25269_ _01152_ _02325_ _02339_ _02340_ VPWR VGND sg13g2_a21oi_1
X_25270_ _02341_ _02317_ \memory_i.datain[25]\ VPWR VGND sg13g2_nor2b_1
X_25271_ _02342_ \memory_i.datain[1]\ _02316_ _02341_ VPWR VGND sg13g2_a21oi_1
X_25272_ _02343_ \memory_i.datain_reg[25]\ _02320_ VPWR VGND sg13g2_nor2_1
X_25273_ _01153_ _02325_ _02342_ _02343_ VPWR VGND sg13g2_a21oi_1
X_25274_ _02344_ _02317_ \memory_i.datain[26]\ VPWR VGND sg13g2_nor2b_1
X_25275_ _02345_ \memory_i.datain[2]\ _02316_ _02344_ VPWR VGND sg13g2_a21oi_1
X_25276_ _02346_ \memory_i.datain_reg[26]\ _02320_ VPWR VGND sg13g2_nor2_1
X_25277_ _01154_ _02325_ _02345_ _02346_ VPWR VGND sg13g2_a21oi_1
X_25278_ _02347_ _02317_ \memory_i.datain[27]\ VPWR VGND sg13g2_nor2b_1
X_25279_ _02348_ \memory_i.datain[3]\ _02316_ _02347_ VPWR VGND sg13g2_a21oi_1
X_25280_ _02349_ \memory_i.datain_reg[27]\ _02320_ VPWR VGND sg13g2_nor2_1
X_25281_ _01155_ _02325_ _02348_ _02349_ VPWR VGND sg13g2_a21oi_1
X_25282_ _02350_ _13022_ \memory_i.datain[28]\ VPWR VGND sg13g2_nor2b_1
X_25283_ _02351_ \memory_i.datain[4]\ _02263_ _02350_ VPWR VGND sg13g2_a21oi_1
X_25284_ _02352_ \memory_i.datain_reg[28]\ _02254_ VPWR VGND sg13g2_nor2_1
X_25285_ _01156_ _02325_ _02351_ _02352_ VPWR VGND sg13g2_a21oi_1
X_25286_ _02353_ _13022_ \memory_i.datain[29]\ VPWR VGND sg13g2_nor2b_1
X_25287_ _02354_ \memory_i.datain[5]\ _02263_ _02353_ VPWR VGND sg13g2_a21oi_1
X_25288_ _02355_ \memory_i.datain_reg[29]\ _02254_ VPWR VGND sg13g2_nor2_1
X_25289_ _01157_ _02325_ _02354_ _02355_ VPWR VGND sg13g2_a21oi_1
X_25290_ _02356_ _13022_ \memory_i.datain[30]\ VPWR VGND sg13g2_nor2b_1
X_25291_ _02357_ \memory_i.datain[6]\ _02263_ _02356_ VPWR VGND sg13g2_a21oi_1
X_25292_ _02358_ \memory_i.datain_reg[30]\ _02254_ VPWR VGND sg13g2_nor2_1
X_25293_ _01158_ _02258_ _02357_ _02358_ VPWR VGND sg13g2_a21oi_1
X_25294_ _02359_ _13022_ \memory_i.datain[31]\ VPWR VGND sg13g2_nor2b_1
X_25295_ _02360_ \memory_i.datain[7]\ _02263_ _02359_ VPWR VGND sg13g2_a21oi_1
X_25296_ _02361_ \memory_i.datain_reg[31]\ _02254_ VPWR VGND sg13g2_nor2_1
X_25297_ _01159_ _02258_ _02360_ _02361_ VPWR VGND sg13g2_a21oi_1
X_25298_ _02362_ \memory_i.i2c_master.write\ _13020_ _13316_ reset VPWR
+ VGND
+ sg13g2_a22oi_1
X_25299_ _01160_ _02362_ VPWR VGND sg13g2_inv_1
X_25300_ _02363_ _13760_ _13775_ _16928_ VPWR VGND sg13g2_and3_1
X_25301_ _02364_ _02363_ VPWR VGND sg13g2_buf_1
X_25302_ _02365_ _02364_ VPWR VGND sg13g2_buf_1
X_25303_ _02366_ _02365_ \memory_i.i2c_addr[0]\ VPWR VGND sg13g2_nand2b_1
X_25304_ _02367_ \memory_i.datain_reg[0]\ _02365_ VPWR VGND sg13g2_nand2_1
X_25305_ _01161_ _02366_ _02367_ _02239_ VPWR VGND sg13g2_a21oi_1
X_25306_ _02368_ _02365_ \memory_i.i2c_addr[1]\ VPWR VGND sg13g2_nand2b_1
X_25307_ _02369_ \memory_i.datain_reg[1]\ _02365_ VPWR VGND sg13g2_nand2_1
X_25308_ _01162_ _02368_ _02369_ _02239_ VPWR VGND sg13g2_a21oi_1
X_25309_ _02370_ _02365_ \memory_i.i2c_addr[2]\ VPWR VGND sg13g2_nand2b_1
X_25310_ _02371_ \memory_i.datain_reg[2]\ _02365_ VPWR VGND sg13g2_nand2_1
X_25311_ _01163_ _02370_ _02371_ _02239_ VPWR VGND sg13g2_a21oi_1
X_25312_ _02372_ _02364_ \memory_i.i2c_addr[3]\ VPWR VGND sg13g2_nand2b_1
X_25313_ _02373_ \memory_i.datain_reg[3]\ _02365_ VPWR VGND sg13g2_nand2_1
X_25314_ _01164_ _02372_ _02373_ _02239_ VPWR VGND sg13g2_a21oi_1
X_25315_ _02374_ _02364_ \memory_i.i2c_addr[4]\ VPWR VGND sg13g2_nand2b_1
X_25316_ _02375_ \memory_i.datain_reg[4]\ _02365_ VPWR VGND sg13g2_nand2_1
X_25317_ _02376_ _12948_ VPWR VGND sg13g2_buf_1
X_25318_ _02377_ _02376_ VPWR VGND sg13g2_buf_1
X_25319_ _01165_ _02374_ _02375_ _02377_ VPWR VGND sg13g2_a21oi_1
X_25320_ _02378_ _02364_ \memory_i.i2c_addr[5]\ VPWR VGND sg13g2_nand2b_1
X_25321_ _02379_ \memory_i.datain_reg[5]\ _02365_ VPWR VGND sg13g2_nand2_1
X_25322_ _01166_ _02378_ _02379_ _02377_ VPWR VGND sg13g2_a21oi_1
X_25323_ _02380_ _02364_ \memory_i.i2c_addr[6]\ VPWR VGND sg13g2_nand2b_1
X_25324_ _02381_ \memory_i.datain_reg[6]\ _02365_ VPWR VGND sg13g2_nand2_1
X_25325_ _01167_ _02380_ _02381_ _02377_ VPWR VGND sg13g2_a21oi_1
X_25326_ _02382_ _13810_ _17301_ VPWR VGND sg13g2_nor2_1
X_25327_ _02383_ _02382_ VPWR VGND sg13g2_buf_1
X_25328_ _02384_ _02383_ \memory_i.i2c_mask[0]\ VPWR VGND sg13g2_nor2b_1
X_25329_ _02385_ \memory_i.datain_reg[0]\ _02383_ _02384_ VPWR VGND sg13g2_a21oi_1
X_25330_ _01168_ reset _02385_ VPWR VGND sg13g2_nand2_1
X_25331_ _02386_ \memory_i.i2c_mask[1]\ VPWR VGND sg13g2_inv_1
X_25332_ _02387_ _02386_ _02383_ VPWR VGND sg13g2_nor2_1
X_25333_ _02388_ \memory_i.datain_reg[1]\ _02383_ _02387_ VPWR VGND sg13g2_a21oi_1
X_25334_ _01169_ reset _02388_ VPWR VGND sg13g2_nand2_1
X_25335_ _02389_ \memory_i.i2c_mask[2]\ VPWR VGND sg13g2_inv_1
X_25336_ _02390_ _02389_ _02383_ VPWR VGND sg13g2_nor2_1
X_25337_ _02391_ \memory_i.datain_reg[2]\ _02383_ _02390_ VPWR VGND sg13g2_a21oi_1
X_25338_ _01170_ reset _02391_ VPWR VGND sg13g2_nand2_1
X_25339_ _02392_ _02383_ \memory_i.i2c_mask[3]\ VPWR VGND sg13g2_nor2b_1
X_25340_ _02393_ \memory_i.datain_reg[3]\ _02383_ _02392_ VPWR VGND sg13g2_a21oi_1
X_25341_ _01171_ reset _02393_ VPWR VGND sg13g2_nand2_1
X_25342_ _01172_ reset gpio_in[0] VPWR VGND sg13g2_and2_1
X_25343_ _01173_ reset gpio_in[1] VPWR VGND sg13g2_and2_1
X_25344_ _01174_ reset gpio_in[2] VPWR VGND sg13g2_and2_1
X_25345_ _01175_ reset gpio_in[3] VPWR VGND sg13g2_and2_1
X_25346_ _02394_ _12958_ _12967_ _12960_ VPWR VGND sg13g2_o21ai_1
X_25347_ _02395_ \memory_i.sclk_flag\ _13310_ _02394_ _12952_ VPWR
+ VGND
+ sg13g2_a22oi_1
X_25348_ _01176_ _17189_ _02395_ VPWR VGND sg13g2_nor2_1
X_25349_ _02396_ _13803_ _13791_ VPWR VGND sg13g2_nand2_1
X_25350_ _02397_ _02396_ VPWR VGND sg13g2_buf_1
X_25351_ _02398_ _02397_ VPWR VGND sg13g2_buf_1
X_25352_ _02399_ _02398_ _02240_ \memory_i.i2c_master.scl_ratio[0]\ VPWR VGND sg13g2_o21ai_1
X_25353_ _02400_ _02397_ _17224_ VPWR VGND sg13g2_nor2_1
X_25354_ _02401_ _02400_ VPWR VGND sg13g2_buf_1
X_25355_ _02402_ _02401_ VPWR VGND sg13g2_buf_1
X_25356_ _02403_ \memory_i.datain_reg[0]\ _02402_ VPWR VGND sg13g2_nand2_1
X_25357_ _01177_ _02399_ _02403_ _02377_ VPWR VGND sg13g2_a21oi_1
X_25358_ _02404_ _02398_ _02240_ \memory_i.i2c_master.scl_ratio[1]\ VPWR VGND sg13g2_o21ai_1
X_25359_ _02405_ \memory_i.datain_reg[1]\ _02402_ VPWR VGND sg13g2_nand2_1
X_25360_ _01178_ _02404_ _02405_ _02377_ VPWR VGND sg13g2_a21oi_1
X_25361_ _02406_ _02398_ _17302_ \memory_i.i2c_master.scl_ratio[2]\ VPWR VGND sg13g2_o21ai_1
X_25362_ _02407_ \memory_i.datain_reg[2]\ _02402_ VPWR VGND sg13g2_nand2_1
X_25363_ _01179_ reset _02406_ _02407_ VPWR VGND sg13g2_nand3_1
X_25364_ _02408_ \memory_i.i2c_master.scl_ratio[3]\ VPWR VGND sg13g2_inv_1
X_25365_ _02409_ _02408_ _02401_ VPWR VGND sg13g2_nor2_1
X_25366_ _02410_ \memory_i.datain_reg[3]\ _02402_ _02409_ VPWR VGND sg13g2_a21oi_1
X_25367_ _01180_ reset _02410_ VPWR VGND sg13g2_nand2_1
X_25368_ _02411_ _02398_ _17302_ \memory_i.i2c_master.scl_ratio[4]\ VPWR VGND sg13g2_o21ai_1
X_25369_ _02412_ \memory_i.datain_reg[4]\ _02402_ VPWR VGND sg13g2_nand2_1
X_25370_ _01181_ reset _02411_ _02412_ VPWR VGND sg13g2_nand3_1
X_25371_ _02413_ _02398_ _17302_ \memory_i.i2c_master.scl_ratio[5]\ VPWR VGND sg13g2_o21ai_1
X_25372_ _02414_ \memory_i.datain_reg[5]\ _02402_ VPWR VGND sg13g2_nand2_1
X_25373_ _01182_ reset _02413_ _02414_ VPWR VGND sg13g2_nand3_1
X_25374_ _02415_ _02398_ _02240_ \memory_i.i2c_master.scl_ratio[6]\ VPWR VGND sg13g2_o21ai_1
X_25375_ _02416_ \memory_i.datain_reg[6]\ _02402_ VPWR VGND sg13g2_nand2_1
X_25376_ _01183_ _02415_ _02416_ _02377_ VPWR VGND sg13g2_a21oi_1
X_25377_ _02417_ _02398_ _02240_ \memory_i.i2c_master.scl_ratio[7]\ VPWR VGND sg13g2_o21ai_1
X_25378_ _02418_ \memory_i.datain_reg[7]\ _02402_ VPWR VGND sg13g2_nand2_1
X_25379_ _01184_ _02417_ _02418_ _02377_ VPWR VGND sg13g2_a21oi_1
X_25380_ _02419_ _02398_ _02240_ \memory_i.i2c_master.scl_ratio[8]\ VPWR VGND sg13g2_o21ai_1
X_25381_ _02420_ \memory_i.datain_reg[8]\ _02402_ VPWR VGND sg13g2_nand2_1
X_25382_ _01185_ _02419_ _02420_ _02377_ VPWR VGND sg13g2_a21oi_1
X_25383_ _02421_ _17301_ VPWR VGND sg13g2_buf_1
X_25384_ _02422_ _02398_ _02421_ \memory_i.i2c_master.scl_ratio[9]\ VPWR VGND sg13g2_o21ai_1
X_25385_ _02423_ \memory_i.datain_reg[9]\ _02402_ VPWR VGND sg13g2_nand2_1
X_25386_ _01186_ _02422_ _02423_ _02377_ VPWR VGND sg13g2_a21oi_1
X_25387_ _02424_ _02398_ _02421_ \memory_i.i2c_master.scl_ratio[10]\ VPWR VGND sg13g2_o21ai_1
X_25388_ _02425_ \memory_i.datain_reg[10]\ _02401_ VPWR VGND sg13g2_nand2_1
X_25389_ _01187_ _02424_ _02425_ _02377_ VPWR VGND sg13g2_a21oi_1
X_25390_ _02426_ _02397_ _02421_ \memory_i.i2c_master.scl_ratio[11]\ VPWR VGND sg13g2_o21ai_1
X_25391_ _02427_ \memory_i.datain_reg[11]\ _02401_ VPWR VGND sg13g2_nand2_1
X_25392_ _02428_ _02376_ VPWR VGND sg13g2_buf_1
X_25393_ _01188_ _02426_ _02427_ _02428_ VPWR VGND sg13g2_a21oi_1
X_25394_ _02429_ _02397_ _02421_ \memory_i.i2c_master.scl_ratio[12]\ VPWR VGND sg13g2_o21ai_1
X_25395_ _02430_ \memory_i.datain_reg[12]\ _02401_ VPWR VGND sg13g2_nand2_1
X_25396_ _01189_ _02429_ _02430_ _02428_ VPWR VGND sg13g2_a21oi_1
X_25397_ _02431_ _02397_ _02421_ \memory_i.i2c_master.scl_ratio[13]\ VPWR VGND sg13g2_o21ai_1
X_25398_ _02432_ \memory_i.datain_reg[13]\ _02401_ VPWR VGND sg13g2_nand2_1
X_25399_ _01190_ _02431_ _02432_ _02428_ VPWR VGND sg13g2_a21oi_1
X_25400_ _02433_ _02397_ _02421_ \memory_i.i2c_master.scl_ratio[14]\ VPWR VGND sg13g2_o21ai_1
X_25401_ _02434_ \memory_i.datain_reg[14]\ _02401_ VPWR VGND sg13g2_nand2_1
X_25402_ _01191_ _02433_ _02434_ _02428_ VPWR VGND sg13g2_a21oi_1
X_25403_ _02435_ _02397_ _02421_ \memory_i.i2c_master.scl_ratio[15]\ VPWR VGND sg13g2_o21ai_1
X_25404_ _02436_ \memory_i.datain_reg[15]\ _02401_ VPWR VGND sg13g2_nand2_1
X_25405_ _01192_ _02435_ _02436_ _02428_ VPWR VGND sg13g2_a21oi_1
X_25406_ _02437_ \memory_i.state[0]\ _13320_ VPWR VGND sg13g2_nand2_1
X_25407_ _02438_ \memory_i.target[2]\ _12968_ _02437_ VPWR VGND sg13g2_nand3_1
X_25408_ _02439_ \memory_i.uart_transmitter.uart_tx_en\ VPWR VGND sg13g2_inv_1
X_25409_ _02440_ _02439_ _13320_ \memory_i.state[4]\ VPWR VGND sg13g2_a21oi_1
X_25410_ _02441_ \memory_i.uart_transmitter.uart_tx_en\ _02438_ _02440_ VPWR VGND sg13g2_a21oi_1
X_25411_ _01193_ _00031_ _02441_ VPWR VGND sg13g2_nor2_1
X_25412_ _02442_ _13816_ VPWR VGND sg13g2_inv_1
X_25413_ _02443_ _13820_ _02442_ _17224_ VPWR VGND sg13g2_nor3_1
X_25414_ _02444_ _02443_ VPWR VGND sg13g2_buf_1
X_25415_ _02445_ _02444_ VPWR VGND sg13g2_buf_1
X_25416_ _02446_ _02445_ \memory_i.uart_transmitter.CYCLES_PER_BIT[0]\ VPWR VGND sg13g2_nand2b_1
X_25417_ _02447_ _02444_ VPWR VGND sg13g2_buf_1
X_25418_ _02448_ \memory_i.datain_reg[0]\ _02447_ VPWR VGND sg13g2_nand2_1
X_25419_ _01194_ _02446_ _02448_ _02428_ VPWR VGND sg13g2_a21oi_1
X_25420_ _02449_ _02444_ VPWR VGND sg13g2_buf_1
X_25421_ _02450_ _02449_ \memory_i.uart_transmitter.CYCLES_PER_BIT[1]\ VPWR VGND sg13g2_nand2b_1
X_25422_ _02451_ \memory_i.datain_reg[1]\ _02447_ VPWR VGND sg13g2_nand2_1
X_25423_ _01195_ _02450_ _02451_ _02428_ VPWR VGND sg13g2_a21oi_1
X_25424_ _02452_ _02449_ \memory_i.uart_transmitter.CYCLES_PER_BIT[2]\ VPWR VGND sg13g2_nand2b_1
X_25425_ _02453_ \memory_i.datain_reg[2]\ _02447_ VPWR VGND sg13g2_nand2_1
X_25426_ _01196_ _02452_ _02453_ _02428_ VPWR VGND sg13g2_a21oi_1
X_25427_ _02454_ _02445_ \memory_i.uart_transmitter.CYCLES_PER_BIT[3]\ VPWR VGND sg13g2_nand2b_1
X_25428_ _02455_ \memory_i.datain_reg[3]\ _02447_ VPWR VGND sg13g2_nand2_1
X_25429_ _01197_ reset _02454_ _02455_ VPWR VGND sg13g2_nand3_1
X_25430_ _02456_ _02449_ \memory_i.uart_transmitter.CYCLES_PER_BIT[4]\ VPWR VGND sg13g2_nand2b_1
X_25431_ _02457_ \memory_i.datain_reg[4]\ _02447_ VPWR VGND sg13g2_nand2_1
X_25432_ _01198_ _02456_ _02457_ _02428_ VPWR VGND sg13g2_a21oi_1
X_25433_ _02458_ _02445_ \memory_i.uart_transmitter.CYCLES_PER_BIT[5]\ VPWR VGND sg13g2_nand2b_1
X_25434_ _02459_ \memory_i.datain_reg[5]\ _02447_ VPWR VGND sg13g2_nand2_1
X_25435_ _01199_ reset _02458_ _02459_ VPWR VGND sg13g2_nand3_1
X_25436_ _02460_ _02445_ \memory_i.uart_transmitter.CYCLES_PER_BIT[6]\ VPWR VGND sg13g2_nand2b_1
X_25437_ _02461_ \memory_i.datain_reg[6]\ _02447_ VPWR VGND sg13g2_nand2_1
X_25438_ _01200_ reset _02460_ _02461_ VPWR VGND sg13g2_nand3_1
X_25439_ _02462_ _02449_ \memory_i.uart_transmitter.CYCLES_PER_BIT[7]\ VPWR VGND sg13g2_nand2b_1
X_25440_ _02463_ \memory_i.datain_reg[7]\ _02447_ VPWR VGND sg13g2_nand2_1
X_25441_ _01201_ _02462_ _02463_ _02428_ VPWR VGND sg13g2_a21oi_1
X_25442_ _02464_ _02449_ \memory_i.uart_transmitter.CYCLES_PER_BIT[8]\ VPWR VGND sg13g2_nand2b_1
X_25443_ _02465_ \memory_i.datain_reg[8]\ _02447_ VPWR VGND sg13g2_nand2_1
X_25444_ _02466_ _02376_ VPWR VGND sg13g2_buf_1
X_25445_ _01202_ _02464_ _02465_ _02466_ VPWR VGND sg13g2_a21oi_1
X_25446_ _02467_ _02449_ \memory_i.uart_transmitter.CYCLES_PER_BIT[9]\ VPWR VGND sg13g2_nand2b_1
X_25447_ _02468_ \memory_i.datain_reg[9]\ _02447_ VPWR VGND sg13g2_nand2_1
X_25448_ _01203_ _02467_ _02468_ _02466_ VPWR VGND sg13g2_a21oi_1
X_25449_ _02469_ _02449_ \memory_i.uart_transmitter.CYCLES_PER_BIT[10]\ VPWR VGND sg13g2_nand2b_1
X_25450_ _02470_ \memory_i.datain_reg[10]\ _02445_ VPWR VGND sg13g2_nand2_1
X_25451_ _01204_ _02469_ _02470_ _02466_ VPWR VGND sg13g2_a21oi_1
X_25452_ _02471_ _02449_ \memory_i.uart_transmitter.CYCLES_PER_BIT[11]\ VPWR VGND sg13g2_nand2b_1
X_25453_ _02472_ \memory_i.datain_reg[11]\ _02445_ VPWR VGND sg13g2_nand2_1
X_25454_ _01205_ _02471_ _02472_ _02466_ VPWR VGND sg13g2_a21oi_1
X_25455_ _02473_ _02449_ \memory_i.uart_transmitter.CYCLES_PER_BIT[12]\ VPWR VGND sg13g2_nand2b_1
X_25456_ _02474_ \memory_i.datain_reg[12]\ _02445_ VPWR VGND sg13g2_nand2_1
X_25457_ _01206_ _02473_ _02474_ _02466_ VPWR VGND sg13g2_a21oi_1
X_25458_ _02475_ _02449_ \memory_i.uart_transmitter.CYCLES_PER_BIT[13]\ VPWR VGND sg13g2_nand2b_1
X_25459_ _02476_ \memory_i.datain_reg[13]\ _02445_ VPWR VGND sg13g2_nand2_1
X_25460_ _01207_ _02475_ _02476_ _02466_ VPWR VGND sg13g2_a21oi_1
X_25461_ _02477_ _02444_ \memory_i.uart_transmitter.CYCLES_PER_BIT[14]\ VPWR VGND sg13g2_nand2b_1
X_25462_ _02478_ \memory_i.datain_reg[14]\ _02445_ VPWR VGND sg13g2_nand2_1
X_25463_ _01208_ _02477_ _02478_ _02466_ VPWR VGND sg13g2_a21oi_1
X_25464_ _02479_ _02444_ \memory_i.uart_transmitter.CYCLES_PER_BIT[15]\ VPWR VGND sg13g2_nand2b_1
X_25465_ _02480_ \memory_i.datain_reg[15]\ _02445_ VPWR VGND sg13g2_nand2_1
X_25466_ _01209_ _02479_ _02480_ _02466_ VPWR VGND sg13g2_a21oi_1
X_25467_ _02481_ _13825_ _17301_ VPWR VGND sg13g2_nor2_1
X_25468_ _02482_ \memory_i.uart_receiver.uart_rx_en\ \memory_i.datain_reg[0]\ _02481_ VPWR VGND sg13g2_mux2_1
X_25469_ _01210_ reset _02482_ VPWR VGND sg13g2_and2_1
X_25470_ _02483_ _13863_ VPWR VGND sg13g2_buf_1
X_25471_ _02484_ _02483_ _02421_ \memory_i.uart_receiver.CYCLES_PER_BIT[0]\ VPWR VGND sg13g2_o21ai_1
X_25472_ _02485_ _13803_ _13793_ _16928_ VPWR VGND sg13g2_and3_1
X_25473_ _02486_ _02485_ VPWR VGND sg13g2_buf_1
X_25474_ _02487_ _02486_ VPWR VGND sg13g2_buf_1
X_25475_ _02488_ \memory_i.datain_reg[0]\ _02487_ VPWR VGND sg13g2_nand2_1
X_25476_ _01211_ _02484_ _02488_ _02466_ VPWR VGND sg13g2_a21oi_1
X_25477_ _02489_ _02483_ _02421_ \memory_i.uart_receiver.CYCLES_PER_BIT[1]\ VPWR VGND sg13g2_o21ai_1
X_25478_ _02490_ \memory_i.datain_reg[1]\ _02487_ VPWR VGND sg13g2_nand2_1
X_25479_ _01212_ _02489_ _02490_ _02466_ VPWR VGND sg13g2_a21oi_1
X_25480_ _02491_ _02483_ _02421_ \memory_i.uart_receiver.CYCLES_PER_BIT[2]\ VPWR VGND sg13g2_o21ai_1
X_25481_ _02492_ \memory_i.datain_reg[2]\ _02487_ VPWR VGND sg13g2_nand2_1
X_25482_ _02493_ _02376_ VPWR VGND sg13g2_buf_1
X_25483_ _01213_ _02491_ _02492_ _02493_ VPWR VGND sg13g2_a21oi_1
X_25484_ _02494_ _02486_ \memory_i.uart_receiver.CYCLES_PER_BIT[3]\ VPWR VGND sg13g2_nand2b_1
X_25485_ _02495_ \memory_i.datain_reg[3]\ _02487_ VPWR VGND sg13g2_nand2_1
X_25486_ _01214_ reset _02494_ _02495_ VPWR VGND sg13g2_nand3_1
X_25487_ _02496_ _17301_ VPWR VGND sg13g2_buf_1
X_25488_ _02497_ _02483_ _02496_ \memory_i.uart_receiver.CYCLES_PER_BIT[4]\ VPWR VGND sg13g2_o21ai_1
X_25489_ _02498_ \memory_i.datain_reg[4]\ _02487_ VPWR VGND sg13g2_nand2_1
X_25490_ _01215_ _02497_ _02498_ _02493_ VPWR VGND sg13g2_a21oi_1
X_25491_ _02499_ _02486_ \memory_i.uart_receiver.CYCLES_PER_BIT[5]\ VPWR VGND sg13g2_nand2b_1
X_25492_ _02500_ \memory_i.datain_reg[5]\ _02487_ VPWR VGND sg13g2_nand2_1
X_25493_ _01216_ reset _02499_ _02500_ VPWR VGND sg13g2_nand3_1
X_25494_ _02501_ _02486_ \memory_i.uart_receiver.CYCLES_PER_BIT[6]\ VPWR VGND sg13g2_nand2b_1
X_25495_ _02502_ \memory_i.datain_reg[6]\ _02487_ VPWR VGND sg13g2_nand2_1
X_25496_ _01217_ reset _02501_ _02502_ VPWR VGND sg13g2_nand3_1
X_25497_ _02503_ _02483_ _02496_ \memory_i.uart_receiver.CYCLES_PER_BIT[7]\ VPWR VGND sg13g2_o21ai_1
X_25498_ _02504_ \memory_i.datain_reg[7]\ _02487_ VPWR VGND sg13g2_nand2_1
X_25499_ _01218_ _02503_ _02504_ _02493_ VPWR VGND sg13g2_a21oi_1
X_25500_ _02505_ _02483_ _02496_ \memory_i.uart_receiver.CYCLES_PER_BIT[8]\ VPWR VGND sg13g2_o21ai_1
X_25501_ _02506_ \memory_i.datain_reg[8]\ _02487_ VPWR VGND sg13g2_nand2_1
X_25502_ _01219_ _02505_ _02506_ _02493_ VPWR VGND sg13g2_a21oi_1
X_25503_ _02507_ _02483_ _02496_ \memory_i.uart_receiver.CYCLES_PER_BIT[9]\ VPWR VGND sg13g2_o21ai_1
X_25504_ _02508_ \memory_i.datain_reg[9]\ _02487_ VPWR VGND sg13g2_nand2_1
X_25505_ _01220_ _02507_ _02508_ _02493_ VPWR VGND sg13g2_a21oi_1
X_25506_ _02509_ _02483_ _02496_ \memory_i.uart_receiver.CYCLES_PER_BIT[10]\ VPWR VGND sg13g2_o21ai_1
X_25507_ _02510_ \memory_i.datain_reg[10]\ _02486_ VPWR VGND sg13g2_nand2_1
X_25508_ _01221_ _02509_ _02510_ _02493_ VPWR VGND sg13g2_a21oi_1
X_25509_ _02511_ _02483_ _02496_ \memory_i.uart_receiver.CYCLES_PER_BIT[11]\ VPWR VGND sg13g2_o21ai_1
X_25510_ _02512_ \memory_i.datain_reg[11]\ _02486_ VPWR VGND sg13g2_nand2_1
X_25511_ _01222_ _02511_ _02512_ _02493_ VPWR VGND sg13g2_a21oi_1
X_25512_ _02513_ _02483_ _02496_ \memory_i.uart_receiver.CYCLES_PER_BIT[12]\ VPWR VGND sg13g2_o21ai_1
X_25513_ _02514_ \memory_i.datain_reg[12]\ _02486_ VPWR VGND sg13g2_nand2_1
X_25514_ _01223_ _02513_ _02514_ _02493_ VPWR VGND sg13g2_a21oi_1
X_25515_ _02515_ _13863_ _02496_ \memory_i.uart_receiver.CYCLES_PER_BIT[13]\ VPWR VGND sg13g2_o21ai_1
X_25516_ _02516_ \memory_i.datain_reg[13]\ _02486_ VPWR VGND sg13g2_nand2_1
X_25517_ _01224_ _02515_ _02516_ _02493_ VPWR VGND sg13g2_a21oi_1
X_25518_ _02517_ _13863_ _02496_ \memory_i.uart_receiver.CYCLES_PER_BIT[14]\ VPWR VGND sg13g2_o21ai_1
X_25519_ _02518_ \memory_i.datain_reg[14]\ _02486_ VPWR VGND sg13g2_nand2_1
X_25520_ _01225_ _02517_ _02518_ _02493_ VPWR VGND sg13g2_a21oi_1
X_25521_ _02519_ _13863_ _02496_ \memory_i.uart_receiver.CYCLES_PER_BIT[15]\ VPWR VGND sg13g2_o21ai_1
X_25522_ _02520_ \memory_i.datain_reg[15]\ _02486_ VPWR VGND sg13g2_nand2_1
X_25523_ _02521_ _02376_ VPWR VGND sg13g2_buf_1
X_25524_ _01226_ _02519_ _02520_ _02521_ VPWR VGND sg13g2_a21oi_1
X_25525_ _02522_ _02442_ _13869_ _17224_ VPWR VGND sg13g2_nor3_1
X_25526_ _02523_ _02522_ VPWR VGND sg13g2_buf_1
X_25527_ _02524_ \memory_i.datain_reg[0]\ _02523_ VPWR VGND sg13g2_nand2_1
X_25528_ _02525_ _13179_ _02523_ _02524_ VPWR VGND sg13g2_o21ai_1
X_25529_ _02526_ _12958_ _02525_ reset VPWR VGND sg13g2_o21ai_1
X_25530_ _01227_ _02526_ VPWR VGND sg13g2_inv_1
X_25531_ _02527_ \memory_i.freq_inst.start\ \memory_i.datain_reg[1]\ _02523_ VPWR VGND sg13g2_mux2_1
X_25532_ _02528_ _12958_ _02527_ reset VPWR VGND sg13g2_o21ai_1
X_25533_ _01228_ _02528_ VPWR VGND sg13g2_inv_1
X_25534_ _02529_ _02523_ VPWR VGND sg13g2_buf_1
X_25535_ _02530_ _02529_ lo_I_oe VPWR VGND sg13g2_nand2b_1
X_25536_ _02531_ \memory_i.datain_reg[3]\ _02529_ VPWR VGND sg13g2_nand2_1
X_25537_ _01229_ reset _02530_ _02531_ VPWR VGND sg13g2_nand3_1
X_25538_ _02532_ _02529_ ds_I_oe VPWR VGND sg13g2_nand2b_1
X_25539_ _02533_ \memory_i.datain_reg[4]\ _02529_ VPWR VGND sg13g2_nand2_1
X_25540_ _01230_ reset _02532_ _02533_ VPWR VGND sg13g2_nand3_1
X_25541_ _02534_ _02529_ Q_ae VPWR VGND sg13g2_nand2b_1
X_25542_ _02535_ \memory_i.datain_reg[5]\ _02529_ VPWR VGND sg13g2_nand2_1
X_25543_ _01231_ _02534_ _02535_ _02521_ VPWR VGND sg13g2_a21oi_1
X_25544_ _02536_ _02529_ I_ae VPWR VGND sg13g2_nand2b_1
X_25545_ _02537_ \memory_i.datain_reg[6]\ _02529_ VPWR VGND sg13g2_nand2_1
X_25546_ _01232_ _02536_ _02537_ _02521_ VPWR VGND sg13g2_a21oi_1
X_25547_ _02538_ _02529_ analog_en VPWR VGND sg13g2_nand2b_1
X_25548_ _02539_ \memory_i.datain_reg[7]\ _02529_ VPWR VGND sg13g2_nand2_1
X_25549_ _01233_ reset _02538_ _02539_ VPWR VGND sg13g2_nand3_1
X_25550_ _02540_ _13789_ _13791_ _16928_ VPWR VGND sg13g2_nand3_1
X_25551_ _02541_ _02540_ VPWR VGND sg13g2_buf_1
X_25552_ _02542_ _02541_ VPWR VGND sg13g2_buf_1
X_25553_ _02543_ \memory_i.freq_inst.f_c[0]\ _02542_ VPWR VGND sg13g2_nand2_1
X_25554_ _02544_ _13764_ _13869_ _13790_ _17224_ VPWR
+ VGND
+ sg13g2_nor4_1
X_25555_ _02545_ _02544_ VPWR VGND sg13g2_buf_1
X_25556_ _02546_ _02545_ VPWR VGND sg13g2_buf_1
X_25557_ _02547_ \memory_i.datain_reg[0]\ _02546_ VPWR VGND sg13g2_nand2_1
X_25558_ _01234_ reset _02543_ _02547_ VPWR VGND sg13g2_nand3_1
X_25559_ _02548_ _02541_ VPWR VGND sg13g2_buf_1
X_25560_ _02549_ \memory_i.freq_inst.f_c[1]\ _02548_ VPWR VGND sg13g2_nand2_1
X_25561_ _02550_ _02545_ VPWR VGND sg13g2_buf_1
X_25562_ _02551_ \memory_i.datain_reg[1]\ _02550_ VPWR VGND sg13g2_nand2_1
X_25563_ _01235_ _02549_ _02551_ _02521_ VPWR VGND sg13g2_a21oi_1
X_25564_ _02552_ \memory_i.freq_inst.f_c[2]\ _02548_ VPWR VGND sg13g2_nand2_1
X_25565_ _02553_ \memory_i.datain_reg[2]\ _02550_ VPWR VGND sg13g2_nand2_1
X_25566_ _01236_ _02552_ _02553_ _02521_ VPWR VGND sg13g2_a21oi_1
X_25567_ _02554_ \memory_i.freq_inst.f_c[3]\ _02548_ VPWR VGND sg13g2_nand2_1
X_25568_ _02555_ \memory_i.datain_reg[3]\ _02550_ VPWR VGND sg13g2_nand2_1
X_25569_ _01237_ _02554_ _02555_ _02521_ VPWR VGND sg13g2_a21oi_1
X_25570_ _02556_ \memory_i.freq_inst.f_c[4]\ _02542_ VPWR VGND sg13g2_nand2_1
X_25571_ _02557_ \memory_i.datain_reg[4]\ _02546_ VPWR VGND sg13g2_nand2_1
X_25572_ _01238_ reset _02556_ _02557_ VPWR VGND sg13g2_nand3_1
X_25573_ _02558_ \memory_i.freq_inst.f_c[5]\ _02542_ VPWR VGND sg13g2_nand2_1
X_25574_ _02559_ \memory_i.datain_reg[5]\ _02546_ VPWR VGND sg13g2_nand2_1
X_25575_ _01239_ reset _02558_ _02559_ VPWR VGND sg13g2_nand3_1
X_25576_ _02560_ \memory_i.freq_inst.f_c[6]\ _02542_ VPWR VGND sg13g2_nand2_1
X_25577_ _02561_ \memory_i.datain_reg[6]\ _02546_ VPWR VGND sg13g2_nand2_1
X_25578_ _01240_ reset _02560_ _02561_ VPWR VGND sg13g2_nand3_1
X_25579_ _02562_ \memory_i.freq_inst.f_c[7]\ _02548_ VPWR VGND sg13g2_nand2_1
X_25580_ _02563_ \memory_i.datain_reg[7]\ _02550_ VPWR VGND sg13g2_nand2_1
X_25581_ _01241_ _02562_ _02563_ _02521_ VPWR VGND sg13g2_a21oi_1
X_25582_ _02564_ \memory_i.freq_inst.f_c[8]\ _02548_ VPWR VGND sg13g2_nand2_1
X_25583_ _02565_ \memory_i.datain_reg[8]\ _02550_ VPWR VGND sg13g2_nand2_1
X_25584_ _01242_ _02564_ _02565_ _02521_ VPWR VGND sg13g2_a21oi_1
X_25585_ _02566_ \memory_i.freq_inst.f_c[9]\ _02542_ VPWR VGND sg13g2_nand2_1
X_25586_ _02567_ \memory_i.datain_reg[9]\ _02546_ VPWR VGND sg13g2_nand2_1
X_25587_ _01243_ reset _02566_ _02567_ VPWR VGND sg13g2_nand3_1
X_25588_ _02568_ \memory_i.freq_inst.f_c[10]\ _02548_ VPWR VGND sg13g2_nand2_1
X_25589_ _02569_ \memory_i.datain_reg[10]\ _02550_ VPWR VGND sg13g2_nand2_1
X_25590_ _01244_ _02568_ _02569_ _02521_ VPWR VGND sg13g2_a21oi_1
X_25591_ _02570_ \memory_i.freq_inst.f_c[11]\ _02542_ VPWR VGND sg13g2_nand2_1
X_25592_ _02571_ \memory_i.datain_reg[11]\ _02546_ VPWR VGND sg13g2_nand2_1
X_25593_ _01245_ reset _02570_ _02571_ VPWR VGND sg13g2_nand3_1
X_25594_ _02572_ \memory_i.freq_inst.f_c[12]\ _02548_ VPWR VGND sg13g2_nand2_1
X_25595_ _02573_ \memory_i.datain_reg[12]\ _02550_ VPWR VGND sg13g2_nand2_1
X_25596_ _01246_ _02572_ _02573_ _02521_ VPWR VGND sg13g2_a21oi_1
X_25597_ _02574_ \memory_i.freq_inst.f_c[13]\ _02548_ VPWR VGND sg13g2_nand2_1
X_25598_ _02575_ \memory_i.datain_reg[13]\ _02550_ VPWR VGND sg13g2_nand2_1
X_25599_ _02576_ _02376_ VPWR VGND sg13g2_buf_1
X_25600_ _01247_ _02574_ _02575_ _02576_ VPWR VGND sg13g2_a21oi_1
X_25601_ _02577_ _02541_ VPWR VGND sg13g2_buf_1
X_25602_ _02578_ \memory_i.freq_inst.f_c[14]\ _02577_ VPWR VGND sg13g2_nand2_1
X_25603_ _02579_ _02545_ VPWR VGND sg13g2_buf_1
X_25604_ _02580_ \memory_i.datain_reg[14]\ _02579_ VPWR VGND sg13g2_nand2_1
X_25605_ _01248_ _02578_ _02580_ _02576_ VPWR VGND sg13g2_a21oi_1
X_25606_ _02581_ \memory_i.freq_inst.f_c[15]\ _02542_ VPWR VGND sg13g2_nand2_1
X_25607_ _02582_ \memory_i.datain_reg[15]\ _02546_ VPWR VGND sg13g2_nand2_1
X_25608_ _01249_ reset _02581_ _02582_ VPWR VGND sg13g2_nand3_1
X_25609_ _02583_ \memory_i.freq_inst.f_c[16]\ _02577_ VPWR VGND sg13g2_nand2_1
X_25610_ _02584_ \memory_i.datain_reg[16]\ _02579_ VPWR VGND sg13g2_nand2_1
X_25611_ _01250_ _02583_ _02584_ _02576_ VPWR VGND sg13g2_a21oi_1
X_25612_ _02585_ \memory_i.freq_inst.f_c[17]\ _02542_ VPWR VGND sg13g2_nand2_1
X_25613_ _02586_ \memory_i.datain_reg[17]\ _02546_ VPWR VGND sg13g2_nand2_1
X_25614_ _01251_ reset _02585_ _02586_ VPWR VGND sg13g2_nand3_1
X_25615_ _02587_ \memory_i.freq_inst.f_c[18]\ _02542_ VPWR VGND sg13g2_nand2_1
X_25616_ _02588_ \memory_i.datain_reg[18]\ _02546_ VPWR VGND sg13g2_nand2_1
X_25617_ _01252_ reset _02587_ _02588_ VPWR VGND sg13g2_nand3_1
X_25618_ _02589_ \memory_i.freq_inst.f_c[19]\ _02542_ VPWR VGND sg13g2_nand2_1
X_25619_ _02590_ \memory_i.datain_reg[19]\ _02546_ VPWR VGND sg13g2_nand2_1
X_25620_ _01253_ reset _02589_ _02590_ VPWR VGND sg13g2_nand3_1
X_25621_ _02591_ \memory_i.freq_inst.f_c[20]\ _02577_ VPWR VGND sg13g2_nand2_1
X_25622_ _02592_ \memory_i.datain_reg[20]\ _02579_ VPWR VGND sg13g2_nand2_1
X_25623_ _01254_ _02591_ _02592_ _02576_ VPWR VGND sg13g2_a21oi_1
X_25624_ _02593_ \memory_i.freq_inst.f_c[21]\ _02577_ VPWR VGND sg13g2_nand2_1
X_25625_ _02594_ \memory_i.datain_reg[21]\ _02579_ VPWR VGND sg13g2_nand2_1
X_25626_ _01255_ _02593_ _02594_ _02576_ VPWR VGND sg13g2_a21oi_1
X_25627_ _02595_ \memory_i.freq_inst.f_c[22]\ _02577_ VPWR VGND sg13g2_nand2_1
X_25628_ _02596_ \memory_i.datain_reg[22]\ _02579_ VPWR VGND sg13g2_nand2_1
X_25629_ _01256_ _02595_ _02596_ _02576_ VPWR VGND sg13g2_a21oi_1
X_25630_ _02597_ \memory_i.freq_inst.f_c[23]\ _02548_ VPWR VGND sg13g2_nand2_1
X_25631_ _02598_ \memory_i.datain_reg[23]\ _02550_ VPWR VGND sg13g2_nand2_1
X_25632_ _01257_ reset _02597_ _02598_ VPWR VGND sg13g2_nand3_1
X_25633_ _02599_ \memory_i.freq_inst.f_c[24]\ _02577_ VPWR VGND sg13g2_nand2_1
X_25634_ _02600_ \memory_i.datain_reg[24]\ _02579_ VPWR VGND sg13g2_nand2_1
X_25635_ _01258_ _02599_ _02600_ _02576_ VPWR VGND sg13g2_a21oi_1
X_25636_ _02601_ \memory_i.freq_inst.f_c[25]\ _02577_ VPWR VGND sg13g2_nand2_1
X_25637_ _02602_ \memory_i.datain_reg[25]\ _02579_ VPWR VGND sg13g2_nand2_1
X_25638_ _01259_ _02601_ _02602_ _02576_ VPWR VGND sg13g2_a21oi_1
X_25639_ _02603_ \memory_i.freq_inst.f_c[26]\ _02548_ VPWR VGND sg13g2_nand2_1
X_25640_ _02604_ \memory_i.datain_reg[26]\ _02550_ VPWR VGND sg13g2_nand2_1
X_25641_ _01260_ reset _02603_ _02604_ VPWR VGND sg13g2_nand3_1
X_25642_ _02605_ \memory_i.freq_inst.f_c[27]\ _02577_ VPWR VGND sg13g2_nand2_1
X_25643_ _02606_ \memory_i.datain_reg[27]\ _02579_ VPWR VGND sg13g2_nand2_1
X_25644_ _01261_ _02605_ _02606_ _02576_ VPWR VGND sg13g2_a21oi_1
X_25645_ _02607_ \memory_i.freq_inst.f_c[28]\ _02577_ VPWR VGND sg13g2_nand2_1
X_25646_ _02608_ \memory_i.datain_reg[28]\ _02579_ VPWR VGND sg13g2_nand2_1
X_25647_ _01262_ _02607_ _02608_ _02576_ VPWR VGND sg13g2_a21oi_1
X_25648_ _02609_ \memory_i.freq_inst.f_c[29]\ _02577_ VPWR VGND sg13g2_nand2_1
X_25649_ _02610_ \memory_i.datain_reg[29]\ _02579_ VPWR VGND sg13g2_nand2_1
X_25650_ _02611_ _02376_ VPWR VGND sg13g2_buf_1
X_25651_ _01263_ _02609_ _02610_ _02611_ VPWR VGND sg13g2_a21oi_1
X_25652_ _02612_ \memory_i.freq_inst.dsmod_cos.i_osr[0]\ _02541_ VPWR VGND sg13g2_nand2_1
X_25653_ _02613_ \memory_i.datain_reg[30]\ _02545_ VPWR VGND sg13g2_nand2_1
X_25654_ _01264_ _02612_ _02613_ _02611_ VPWR VGND sg13g2_a21oi_1
X_25655_ _02614_ \memory_i.freq_inst.dsmod_cos.i_osr[1]\ _02541_ VPWR VGND sg13g2_nand2_1
X_25656_ _02615_ \memory_i.datain_reg[31]\ _02545_ VPWR VGND sg13g2_nand2_1
X_25657_ _01265_ _02614_ _02615_ _02611_ VPWR VGND sg13g2_a21oi_1
X_25658_ _02616_ _16928_ VPWR VGND sg13g2_buf_1
X_25659_ _02617_ \memory_i.addr_reg[5]\ _13773_ _13801_ _02616_ VPWR
+ VGND
+ sg13g2_nand4_1
X_25660_ _02618_ _02617_ VPWR VGND sg13g2_buf_1
X_25661_ _02619_ \memory_i.ds_lo_conf[0]\ _02618_ VPWR VGND sg13g2_nand2_1
X_25662_ _02620_ \memory_i.datain_reg[0]\ _14215_ _02616_ VPWR VGND sg13g2_nand3_1
X_25663_ _01266_ _02619_ _02620_ _02611_ VPWR VGND sg13g2_a21oi_1
X_25664_ _02621_ \memory_i.ds_lo_conf[1]\ _02618_ VPWR VGND sg13g2_nand2_1
X_25665_ _02622_ \memory_i.datain_reg[1]\ _14215_ _02616_ VPWR VGND sg13g2_nand3_1
X_25666_ _01267_ _02621_ _02622_ _02611_ VPWR VGND sg13g2_a21oi_1
X_25667_ _02623_ \memory_i.ds_lo_conf[2]\ _02618_ VPWR VGND sg13g2_nand2_1
X_25668_ _02624_ \memory_i.datain_reg[2]\ _14215_ _02616_ VPWR VGND sg13g2_nand3_1
X_25669_ _01268_ _02623_ _02624_ _02611_ VPWR VGND sg13g2_a21oi_1
X_25670_ _02625_ \memory_i.ds_lo_conf[3]\ _02618_ VPWR VGND sg13g2_nand2_1
X_25671_ _02626_ \memory_i.datain_reg[3]\ _14215_ _02616_ VPWR VGND sg13g2_nand3_1
X_25672_ _01269_ _02625_ _02626_ _02611_ VPWR VGND sg13g2_a21oi_1
X_25673_ _02627_ \memory_i.ds_lo_conf[4]\ _02618_ VPWR VGND sg13g2_nand2_1
X_25674_ _02628_ \memory_i.datain_reg[4]\ _14215_ _02616_ VPWR VGND sg13g2_nand3_1
X_25675_ _01270_ _02627_ _02628_ _02611_ VPWR VGND sg13g2_a21oi_1
X_25676_ _02629_ \memory_i.ds_lo_conf[5]\ _02618_ VPWR VGND sg13g2_nand2_1
X_25677_ _02630_ \memory_i.datain_reg[5]\ _14215_ _02616_ VPWR VGND sg13g2_nand3_1
X_25678_ _01271_ _02629_ _02630_ _02611_ VPWR VGND sg13g2_a21oi_1
X_25679_ _02631_ \memory_i.ds_lo_conf[6]\ _02618_ VPWR VGND sg13g2_nand2_1
X_25680_ _02632_ \memory_i.datain_reg[6]\ _14215_ _02616_ VPWR VGND sg13g2_nand3_1
X_25681_ _01272_ _02631_ _02632_ _02611_ VPWR VGND sg13g2_a21oi_1
X_25682_ _02633_ \memory_i.ds_lo_conf[7]\ _02618_ VPWR VGND sg13g2_nand2_1
X_25683_ _02634_ \memory_i.datain_reg[7]\ _14215_ _02616_ VPWR VGND sg13g2_nand3_1
X_25684_ _02635_ _12948_ VPWR VGND sg13g2_buf_1
X_25685_ _02636_ _02635_ VPWR VGND sg13g2_buf_1
X_25686_ _01273_ _02633_ _02634_ _02636_ VPWR VGND sg13g2_a21oi_1
X_25687_ _02637_ _02442_ _13932_ _17224_ VPWR VGND sg13g2_nor3_1
X_25688_ _02638_ _02637_ VPWR VGND sg13g2_buf_1
X_25689_ _02639_ _02638_ VPWR VGND sg13g2_buf_1
X_25690_ _02640_ _02639_ \memory_i.ds_defaults[0]\ VPWR VGND sg13g2_nand2b_1
X_25691_ _02641_ \memory_i.datain_reg[0]\ _02639_ VPWR VGND sg13g2_nand2_1
X_25692_ _01274_ _02640_ _02641_ _02636_ VPWR VGND sg13g2_a21oi_1
X_25693_ _02642_ _02639_ \memory_i.ds_defaults[1]\ VPWR VGND sg13g2_nand2b_1
X_25694_ _02643_ \memory_i.datain_reg[1]\ _02639_ VPWR VGND sg13g2_nand2_1
X_25695_ _01275_ _02642_ _02643_ _02636_ VPWR VGND sg13g2_a21oi_1
X_25696_ _02644_ _02638_ \memory_i.ds_defaults[2]\ VPWR VGND sg13g2_nand2b_1
X_25697_ _02645_ \memory_i.datain_reg[2]\ _02639_ VPWR VGND sg13g2_nand2_1
X_25698_ _01276_ _02644_ _02645_ _02636_ VPWR VGND sg13g2_a21oi_1
X_25699_ _02646_ _02638_ \memory_i.ds_defaults[3]\ VPWR VGND sg13g2_nand2b_1
X_25700_ _02647_ \memory_i.datain_reg[3]\ _02639_ VPWR VGND sg13g2_nand2_1
X_25701_ _01277_ _02646_ _02647_ _02636_ VPWR VGND sg13g2_a21oi_1
X_25702_ _02648_ _02638_ \memory_i.ds_defaults[4]\ VPWR VGND sg13g2_nand2b_1
X_25703_ _02649_ \memory_i.datain_reg[4]\ _02639_ VPWR VGND sg13g2_nand2_1
X_25704_ _01278_ _02648_ _02649_ _02636_ VPWR VGND sg13g2_a21oi_1
X_25705_ _02650_ _02638_ \memory_i.ds_defaults[5]\ VPWR VGND sg13g2_nand2b_1
X_25706_ _02651_ \memory_i.datain_reg[5]\ _02639_ VPWR VGND sg13g2_nand2_1
X_25707_ _01279_ _02650_ _02651_ _02636_ VPWR VGND sg13g2_a21oi_1
X_25708_ _02652_ _02638_ \memory_i.ds_defaults[6]\ VPWR VGND sg13g2_nand2b_1
X_25709_ _02653_ \memory_i.datain_reg[6]\ _02639_ VPWR VGND sg13g2_nand2_1
X_25710_ _01280_ _02652_ _02653_ _02636_ VPWR VGND sg13g2_a21oi_1
X_25711_ _02654_ _02638_ \memory_i.ds_defaults[7]\ VPWR VGND sg13g2_nand2b_1
X_25712_ _02655_ \memory_i.datain_reg[7]\ _02639_ VPWR VGND sg13g2_nand2_1
X_25713_ _01281_ _02654_ _02655_ _02636_ VPWR VGND sg13g2_a21oi_1
X_25714_ _02656_ _13935_ _02616_ VPWR VGND sg13g2_nand2_1
X_25715_ _02657_ _02656_ VPWR VGND sg13g2_buf_1
X_25716_ _02658_ _02657_ VPWR VGND sg13g2_buf_1
X_25717_ _02659_ \memory_i.cordic_I[0]\ _02658_ VPWR VGND sg13g2_nand2_1
X_25718_ _02660_ _13935_ _16928_ VPWR VGND sg13g2_and2_1
X_25719_ _02661_ _02660_ VPWR VGND sg13g2_buf_1
X_25720_ _02662_ _02661_ VPWR VGND sg13g2_buf_1
X_25721_ _02663_ \memory_i.datain_reg[0]\ _02662_ VPWR VGND sg13g2_nand2_1
X_25722_ _01282_ _02659_ _02663_ _02636_ VPWR VGND sg13g2_a21oi_1
X_25723_ _02664_ _02657_ VPWR VGND sg13g2_buf_1
X_25724_ _02665_ \memory_i.cordic_I[1]\ _02664_ VPWR VGND sg13g2_nand2_1
X_25725_ _02666_ _02661_ VPWR VGND sg13g2_buf_1
X_25726_ _02667_ \memory_i.datain_reg[1]\ _02666_ VPWR VGND sg13g2_nand2_1
X_25727_ _01283_ reset _02665_ _02667_ VPWR VGND sg13g2_nand3_1
X_25728_ _02668_ \memory_i.cordic_I[2]\ _02664_ VPWR VGND sg13g2_nand2_1
X_25729_ _02669_ \memory_i.datain_reg[2]\ _02666_ VPWR VGND sg13g2_nand2_1
X_25730_ _01284_ reset _02668_ _02669_ VPWR VGND sg13g2_nand3_1
X_25731_ _02670_ \memory_i.cordic_I[3]\ _02658_ VPWR VGND sg13g2_nand2_1
X_25732_ _02671_ \memory_i.datain_reg[3]\ _02662_ VPWR VGND sg13g2_nand2_1
X_25733_ _02672_ _02635_ VPWR VGND sg13g2_buf_1
X_25734_ _01285_ _02670_ _02671_ _02672_ VPWR VGND sg13g2_a21oi_1
X_25735_ _02673_ \memory_i.cordic_I[4]\ _02658_ VPWR VGND sg13g2_nand2_1
X_25736_ _02674_ \memory_i.datain_reg[4]\ _02662_ VPWR VGND sg13g2_nand2_1
X_25737_ _01286_ _02673_ _02674_ _02672_ VPWR VGND sg13g2_a21oi_1
X_25738_ _02675_ \memory_i.cordic_I[5]\ _02658_ VPWR VGND sg13g2_nand2_1
X_25739_ _02676_ \memory_i.datain_reg[5]\ _02662_ VPWR VGND sg13g2_nand2_1
X_25740_ _01287_ _02675_ _02676_ _02672_ VPWR VGND sg13g2_a21oi_1
X_25741_ _02677_ \memory_i.cordic_I[6]\ _02664_ VPWR VGND sg13g2_nand2_1
X_25742_ _02678_ \memory_i.datain_reg[6]\ _02666_ VPWR VGND sg13g2_nand2_1
X_25743_ _01288_ reset _02677_ _02678_ VPWR VGND sg13g2_nand3_1
X_25744_ _02679_ \memory_i.cordic_I[7]\ _02664_ VPWR VGND sg13g2_nand2_1
X_25745_ _02680_ \memory_i.datain_reg[7]\ _02666_ VPWR VGND sg13g2_nand2_1
X_25746_ _01289_ reset _02679_ _02680_ VPWR VGND sg13g2_nand3_1
X_25747_ _02681_ \memory_i.cordic_I[8]\ _02664_ VPWR VGND sg13g2_nand2_1
X_25748_ _02682_ \memory_i.datain_reg[8]\ _02666_ VPWR VGND sg13g2_nand2_1
X_25749_ _01290_ reset _02681_ _02682_ VPWR VGND sg13g2_nand3_1
X_25750_ _02683_ \memory_i.cordic_I[9]\ _02664_ VPWR VGND sg13g2_nand2_1
X_25751_ _02684_ \memory_i.datain_reg[9]\ _02666_ VPWR VGND sg13g2_nand2_1
X_25752_ _01291_ reset _02683_ _02684_ VPWR VGND sg13g2_nand3_1
X_25753_ _02685_ _02657_ VPWR VGND sg13g2_buf_1
X_25754_ _02686_ \memory_i.cordic_I[10]\ _02685_ VPWR VGND sg13g2_nand2_1
X_25755_ _02687_ _02661_ VPWR VGND sg13g2_buf_1
X_25756_ _02688_ \memory_i.datain_reg[10]\ _02687_ VPWR VGND sg13g2_nand2_1
X_25757_ _01292_ _02686_ _02688_ _02672_ VPWR VGND sg13g2_a21oi_1
X_25758_ _02689_ \memory_i.cordic_I[11]\ _02664_ VPWR VGND sg13g2_nand2_1
X_25759_ _02690_ \memory_i.datain_reg[11]\ _02666_ VPWR VGND sg13g2_nand2_1
X_25760_ _01293_ reset _02689_ _02690_ VPWR VGND sg13g2_nand3_1
X_25761_ _02691_ \memory_i.cordic_I[12]\ _02685_ VPWR VGND sg13g2_nand2_1
X_25762_ _02692_ \memory_i.datain_reg[12]\ _02687_ VPWR VGND sg13g2_nand2_1
X_25763_ _01294_ _02691_ _02692_ _02672_ VPWR VGND sg13g2_a21oi_1
X_25764_ _02693_ \memory_i.cordic_I[13]\ _02685_ VPWR VGND sg13g2_nand2_1
X_25765_ _02694_ \memory_i.datain_reg[13]\ _02687_ VPWR VGND sg13g2_nand2_1
X_25766_ _01295_ _02693_ _02694_ _02672_ VPWR VGND sg13g2_a21oi_1
X_25767_ _02695_ \memory_i.cordic_I[14]\ _02664_ VPWR VGND sg13g2_nand2_1
X_25768_ _02696_ \memory_i.datain_reg[14]\ _02666_ VPWR VGND sg13g2_nand2_1
X_25769_ _01296_ reset _02695_ _02696_ VPWR VGND sg13g2_nand3_1
X_25770_ _02697_ \memory_i.cordic_I[15]\ _02685_ VPWR VGND sg13g2_nand2_1
X_25771_ _02698_ \memory_i.datain_reg[15]\ _02687_ VPWR VGND sg13g2_nand2_1
X_25772_ _01297_ _02697_ _02698_ _02672_ VPWR VGND sg13g2_a21oi_1
X_25773_ _02699_ \memory_i.cordic_I[16]\ _02664_ VPWR VGND sg13g2_nand2_1
X_25774_ _02700_ \memory_i.datain_reg[16]\ _02666_ VPWR VGND sg13g2_nand2_1
X_25775_ _01298_ reset _02699_ _02700_ VPWR VGND sg13g2_nand3_1
X_25776_ _02701_ \memory_i.cordic_I[17]\ _02664_ VPWR VGND sg13g2_nand2_1
X_25777_ _02702_ \memory_i.datain_reg[17]\ _02666_ VPWR VGND sg13g2_nand2_1
X_25778_ _01299_ reset _02701_ _02702_ VPWR VGND sg13g2_nand3_1
X_25779_ _02703_ \memory_i.cordic_I[18]\ _02658_ VPWR VGND sg13g2_nand2_1
X_25780_ _02704_ \memory_i.datain_reg[18]\ _02662_ VPWR VGND sg13g2_nand2_1
X_25781_ _01300_ reset _02703_ _02704_ VPWR VGND sg13g2_nand3_1
X_25782_ _02705_ \memory_i.cordic_I[19]\ _02685_ VPWR VGND sg13g2_nand2_1
X_25783_ _02706_ \memory_i.datain_reg[19]\ _02687_ VPWR VGND sg13g2_nand2_1
X_25784_ _01301_ _02705_ _02706_ _02672_ VPWR VGND sg13g2_a21oi_1
X_25785_ _02707_ \memory_i.cordic_I[20]\ _02658_ VPWR VGND sg13g2_nand2_1
X_25786_ _02708_ \memory_i.datain_reg[20]\ _02662_ VPWR VGND sg13g2_nand2_1
X_25787_ _01302_ reset _02707_ _02708_ VPWR VGND sg13g2_nand3_1
X_25788_ _02709_ \memory_i.cordic_I[21]\ _02658_ VPWR VGND sg13g2_nand2_1
X_25789_ _02710_ \memory_i.datain_reg[21]\ _02662_ VPWR VGND sg13g2_nand2_1
X_25790_ _01303_ reset _02709_ _02710_ VPWR VGND sg13g2_nand3_1
X_25791_ _02711_ \memory_i.cordic_I[22]\ _02685_ VPWR VGND sg13g2_nand2_1
X_25792_ _02712_ \memory_i.datain_reg[22]\ _02687_ VPWR VGND sg13g2_nand2_1
X_25793_ _01304_ _02711_ _02712_ _02672_ VPWR VGND sg13g2_a21oi_1
X_25794_ _02713_ \memory_i.cordic_I[23]\ _02658_ VPWR VGND sg13g2_nand2_1
X_25795_ _02714_ \memory_i.datain_reg[23]\ _02662_ VPWR VGND sg13g2_nand2_1
X_25796_ _01305_ reset _02713_ _02714_ VPWR VGND sg13g2_nand3_1
X_25797_ _02715_ \memory_i.cordic_I[24]\ _02658_ VPWR VGND sg13g2_nand2_1
X_25798_ _02716_ \memory_i.datain_reg[24]\ _02662_ VPWR VGND sg13g2_nand2_1
X_25799_ _01306_ reset _02715_ _02716_ VPWR VGND sg13g2_nand3_1
X_25800_ _02717_ \memory_i.cordic_I[25]\ _02685_ VPWR VGND sg13g2_nand2_1
X_25801_ _02718_ \memory_i.datain_reg[25]\ _02687_ VPWR VGND sg13g2_nand2_1
X_25802_ _01307_ _02717_ _02718_ _02672_ VPWR VGND sg13g2_a21oi_1
X_25803_ _02719_ \memory_i.cordic_I[26]\ _02685_ VPWR VGND sg13g2_nand2_1
X_25804_ _02720_ \memory_i.datain_reg[26]\ _02687_ VPWR VGND sg13g2_nand2_1
X_25805_ _02721_ _02635_ VPWR VGND sg13g2_buf_1
X_25806_ _01308_ _02719_ _02720_ _02721_ VPWR VGND sg13g2_a21oi_1
X_25807_ _02722_ \memory_i.cordic_I[27]\ _02658_ VPWR VGND sg13g2_nand2_1
X_25808_ _02723_ \memory_i.datain_reg[27]\ _02662_ VPWR VGND sg13g2_nand2_1
X_25809_ _01309_ reset _02722_ _02723_ VPWR VGND sg13g2_nand3_1
X_25810_ _02724_ \memory_i.cordic_I[28]\ _02685_ VPWR VGND sg13g2_nand2_1
X_25811_ _02725_ \memory_i.datain_reg[28]\ _02687_ VPWR VGND sg13g2_nand2_1
X_25812_ _01310_ _02724_ _02725_ _02721_ VPWR VGND sg13g2_a21oi_1
X_25813_ _02726_ \memory_i.cordic_I[29]\ _02685_ VPWR VGND sg13g2_nand2_1
X_25814_ _02727_ \memory_i.datain_reg[29]\ _02687_ VPWR VGND sg13g2_nand2_1
X_25815_ _01311_ _02726_ _02727_ _02721_ VPWR VGND sg13g2_a21oi_1
X_25816_ _02728_ \memory_i.freq_inst.reset_n\ _13178_ VPWR VGND sg13g2_nand2_1
X_25817_ _02729_ _02728_ VPWR VGND sg13g2_buf_1
X_25818_ _02730_ _02729_ VPWR VGND sg13g2_buf_1
X_25819_ _02731_ _13183_ VPWR VGND sg13g2_buf_1
X_25820_ _02732_ \memory_i.freq_inst.f_c[0]\ _02731_ VPWR VGND sg13g2_nand2_1
X_25821_ _02733_ \memory_i.freq_inst.cordic.Z_i[0]\ _02732_ VPWR VGND sg13g2_xor2_1
X_25822_ _01312_ _02730_ _02733_ VPWR VGND sg13g2_nor2_1
X_25823_ _02734_ \memory_i.freq_inst.cordic.Z_i[1]\ VPWR VGND sg13g2_inv_1
X_25824_ _02735_ \memory_i.freq_inst.cordic.Z_i[0]\ \memory_i.freq_inst.f_c[0]\ VPWR VGND sg13g2_nand2_1
X_25825_ _02736_ \memory_i.freq_inst.f_c[1]\ _02735_ VPWR VGND sg13g2_xnor2_1
X_25826_ _02737_ _13184_ _02736_ VPWR VGND sg13g2_nand2_1
X_25827_ _02738_ _02734_ _02737_ VPWR VGND sg13g2_xnor2_1
X_25828_ _01313_ _02730_ _02738_ VPWR VGND sg13g2_nor2_1
X_25829_ _02739_ _13175_ VPWR VGND sg13g2_buf_1
X_25830_ _02740_ \memory_i.freq_inst.cordic.Z_i[0]\ \memory_i.freq_inst.f_c[0]\ \memory_i.freq_inst.f_c[1]\ VPWR VGND sg13g2_a21oi_1
X_25831_ _02741_ \memory_i.freq_inst.cordic.Z_i[0]\ \memory_i.freq_inst.f_c[1]\ \memory_i.freq_inst.f_c[0]\ VPWR VGND sg13g2_nand3_1
X_25832_ _02742_ _02734_ _02740_ _02741_ VPWR VGND sg13g2_o21ai_1
X_25833_ _02743_ \memory_i.freq_inst.f_c[2]\ _02742_ VPWR VGND sg13g2_xnor2_1
X_25834_ _02744_ _02739_ _02743_ VPWR VGND sg13g2_nor2_1
X_25835_ _02745_ \memory_i.freq_inst.cordic.Z_i[2]\ _02744_ VPWR VGND sg13g2_xnor2_1
X_25836_ _01314_ _02730_ _02745_ VPWR VGND sg13g2_nor2_1
X_25837_ _02746_ \memory_i.freq_inst.cordic.Z_i[2]\ \memory_i.freq_inst.f_c[2]\ VPWR VGND sg13g2_or2_1
X_25838_ _02747_ \memory_i.freq_inst.cordic.Z_i[2]\ \memory_i.freq_inst.f_c[2]\ VPWR VGND sg13g2_and2_1
X_25839_ _02748_ _02742_ _02746_ _02747_ VPWR VGND sg13g2_a21o_1
X_25840_ _02749_ _02748_ VPWR VGND sg13g2_buf_1
X_25841_ _02750_ \memory_i.freq_inst.f_c[3]\ _02749_ VPWR VGND sg13g2_nor2_1
X_25842_ _02751_ \memory_i.freq_inst.f_c[3]\ _02749_ VPWR VGND sg13g2_and2_1
X_25843_ _02752_ _13175_ _02750_ _02751_ VPWR VGND sg13g2_nor3_1
X_25844_ _02753_ \memory_i.freq_inst.cordic.Z_i[3]\ _02752_ VPWR VGND sg13g2_xnor2_1
X_25845_ _01315_ _02730_ _02753_ VPWR VGND sg13g2_nor2_1
X_25846_ _02754_ \memory_i.freq_inst.f_c[3]\ _02749_ \memory_i.freq_inst.cordic.Z_i[3]\ VPWR VGND sg13g2_a21oi_1
X_25847_ _02755_ _02750_ _02754_ VPWR VGND sg13g2_nor2_1
X_25848_ _02756_ \memory_i.freq_inst.f_c[4]\ _02755_ VPWR VGND sg13g2_xor2_1
X_25849_ _02757_ _02731_ _02756_ VPWR VGND sg13g2_nand2_1
X_25850_ _02758_ \memory_i.freq_inst.cordic.Z_i[4]\ _02757_ VPWR VGND sg13g2_xor2_1
X_25851_ _01316_ _02730_ _02758_ VPWR VGND sg13g2_nor2_1
X_25852_ _02759_ _02729_ VPWR VGND sg13g2_buf_1
X_25853_ _02760_ \memory_i.freq_inst.cordic.Z_i[4]\ \memory_i.freq_inst.f_c[4]\ VPWR VGND sg13g2_nor2_1
X_25854_ _02761_ _02750_ _02754_ _02760_ VPWR VGND sg13g2_or3_1
X_25855_ _02762_ \memory_i.freq_inst.cordic.Z_i[4]\ \memory_i.freq_inst.f_c[4]\ VPWR VGND sg13g2_nand2_1
X_25856_ _02763_ \memory_i.freq_inst.f_c[5]\ VPWR VGND sg13g2_inv_1
X_25857_ _02764_ _02761_ _02762_ _02763_ VPWR VGND sg13g2_a21oi_1
X_25858_ _02765_ _02763_ _02761_ _02762_ VPWR VGND sg13g2_nand3_1
X_25859_ _02766_ _02764_ _13183_ _02765_ VPWR VGND sg13g2_nand3b_1
X_25860_ _02767_ \memory_i.freq_inst.cordic.Z_i[5]\ _02766_ VPWR VGND sg13g2_xnor2_1
X_25861_ _01317_ _02759_ _02767_ VPWR VGND sg13g2_nor2b_1
X_25862_ _02768_ \memory_i.freq_inst.cordic.Z_i[5]\ _02765_ _02764_ VPWR VGND sg13g2_a21oi_1
X_25863_ _02769_ \memory_i.freq_inst.f_c[6]\ _02768_ VPWR VGND sg13g2_xor2_1
X_25864_ _02770_ _02739_ _02769_ VPWR VGND sg13g2_nor2_1
X_25865_ _02771_ \memory_i.freq_inst.cordic.Z_i[6]\ _02770_ VPWR VGND sg13g2_xnor2_1
X_25866_ _01318_ _02730_ _02771_ VPWR VGND sg13g2_nor2_1
X_25867_ _02772_ \memory_i.freq_inst.cordic.Z_i[6]\ \memory_i.freq_inst.f_c[6]\ VPWR VGND sg13g2_nor2_1
X_25868_ _02773_ \memory_i.freq_inst.cordic.Z_i[6]\ \memory_i.freq_inst.f_c[6]\ VPWR VGND sg13g2_nand2_1
X_25869_ _02774_ _02768_ _02772_ _02773_ VPWR VGND sg13g2_o21ai_1
X_25870_ _02775_ \memory_i.freq_inst.f_c[7]\ _02774_ VPWR VGND sg13g2_or2_1
X_25871_ _02776_ \memory_i.freq_inst.f_c[7]\ _02774_ VPWR VGND sg13g2_nand2_1
X_25872_ _02777_ _13183_ _02775_ _02776_ VPWR VGND sg13g2_and3_1
X_25873_ _02778_ \memory_i.freq_inst.cordic.Z_i[7]\ _02777_ VPWR VGND sg13g2_xnor2_1
X_25874_ _01319_ _02730_ _02778_ VPWR VGND sg13g2_nor2_1
X_25875_ _02779_ \memory_i.freq_inst.f_c[8]\ VPWR VGND sg13g2_inv_1
X_25876_ _02780_ \memory_i.freq_inst.f_c[7]\ _02774_ \memory_i.freq_inst.cordic.Z_i[7]\ VPWR VGND sg13g2_o21ai_1
X_25877_ _02781_ _02779_ _02776_ _02780_ VPWR VGND sg13g2_and3_1
X_25878_ _02782_ _02776_ _02780_ _02779_ VPWR VGND sg13g2_a21oi_1
X_25879_ _02783_ _13175_ _02781_ _02782_ VPWR VGND sg13g2_nor3_1
X_25880_ _02784_ \memory_i.freq_inst.cordic.Z_i[8]\ _02783_ VPWR VGND sg13g2_xnor2_1
X_25881_ _01320_ _02730_ _02784_ VPWR VGND sg13g2_nor2_1
X_25882_ _02785_ _02779_ _02776_ _02780_ VPWR VGND sg13g2_nand3_1
X_25883_ _02786_ \memory_i.freq_inst.cordic.Z_i[8]\ _02785_ _02782_ VPWR VGND sg13g2_a21o_1
X_25884_ _02787_ _02786_ VPWR VGND sg13g2_buf_1
X_25885_ _02788_ \memory_i.freq_inst.f_c[9]\ _02787_ VPWR VGND sg13g2_or2_1
X_25886_ _02789_ \memory_i.freq_inst.f_c[9]\ _02787_ VPWR VGND sg13g2_nand2_1
X_25887_ _02790_ _13183_ _02788_ _02789_ VPWR VGND sg13g2_and3_1
X_25888_ _02791_ \memory_i.freq_inst.cordic.Z_i[9]\ _02790_ VPWR VGND sg13g2_xnor2_1
X_25889_ _01321_ _02730_ _02791_ VPWR VGND sg13g2_nor2_1
X_25890_ _02792_ \memory_i.freq_inst.f_c[9]\ _02787_ \memory_i.freq_inst.cordic.Z_i[9]\ VPWR VGND sg13g2_o21ai_1
X_25891_ _02793_ _02789_ _02792_ VPWR VGND sg13g2_nand2_1
X_25892_ _02794_ \memory_i.freq_inst.f_c[10]\ _02793_ VPWR VGND sg13g2_xnor2_1
X_25893_ _02795_ _02739_ _02794_ VPWR VGND sg13g2_nor2_1
X_25894_ _02796_ \memory_i.freq_inst.cordic.Z_i[10]\ _02795_ VPWR VGND sg13g2_xnor2_1
X_25895_ _01322_ _02730_ _02796_ VPWR VGND sg13g2_nor2_1
X_25896_ _02797_ _02729_ VPWR VGND sg13g2_buf_1
X_25897_ _02798_ \memory_i.freq_inst.f_c[11]\ \memory_i.freq_inst.f_c[10]\ VPWR VGND sg13g2_or2_1
X_25898_ _02799_ \memory_i.freq_inst.f_c[9]\ _02787_ _02798_ VPWR VGND sg13g2_a21oi_1
X_25899_ _02800_ \memory_i.freq_inst.cordic.Z_i[10]\ \memory_i.freq_inst.f_c[11]\ VPWR VGND sg13g2_or2_1
X_25900_ _02801_ \memory_i.freq_inst.f_c[9]\ _02787_ _02800_ VPWR VGND sg13g2_a21oi_1
X_25901_ _02802_ _02799_ _02801_ _02792_ VPWR VGND sg13g2_o21ai_1
X_25902_ _02803_ \memory_i.freq_inst.f_c[10]\ _02800_ VPWR VGND sg13g2_or2_1
X_25903_ _02804_ _02802_ _02803_ VPWR VGND sg13g2_nand2_1
X_25904_ _02805_ \memory_i.freq_inst.f_c[9]\ _02787_ \memory_i.freq_inst.f_c[10]\ VPWR VGND sg13g2_a21oi_1
X_25905_ _02806_ \memory_i.freq_inst.f_c[9]\ _02787_ \memory_i.freq_inst.cordic.Z_i[10]\ VPWR VGND sg13g2_a21oi_1
X_25906_ _02807_ _02805_ _02806_ _02792_ VPWR VGND sg13g2_o21ai_1
X_25907_ _02808_ \memory_i.freq_inst.cordic.Z_i[10]\ \memory_i.freq_inst.f_c[10]\ VPWR VGND sg13g2_or2_1
X_25908_ _02809_ \memory_i.freq_inst.f_c[11]\ _02807_ _02808_ VPWR VGND sg13g2_and3_1
X_25909_ _02810_ _13175_ _02804_ _02809_ VPWR VGND sg13g2_nor3_1
X_25910_ _02811_ \memory_i.freq_inst.cordic.Z_i[11]\ _02810_ VPWR VGND sg13g2_xnor2_1
X_25911_ _01323_ _02797_ _02811_ VPWR VGND sg13g2_nor2_1
X_25912_ _02812_ \memory_i.freq_inst.cordic.Z_i[11]\ _02809_ VPWR VGND sg13g2_nor2_1
X_25913_ _02813_ _02804_ _02812_ VPWR VGND sg13g2_or2_1
X_25914_ _02814_ \memory_i.freq_inst.f_c[12]\ _02813_ VPWR VGND sg13g2_xnor2_1
X_25915_ _02815_ _02731_ _02814_ VPWR VGND sg13g2_nand2_1
X_25916_ _02816_ \memory_i.freq_inst.cordic.Z_i[12]\ _02815_ VPWR VGND sg13g2_xor2_1
X_25917_ _01324_ _02797_ _02816_ VPWR VGND sg13g2_nor2_1
X_25918_ _02817_ \memory_i.freq_inst.cordic.Z_i[12]\ \memory_i.freq_inst.f_c[12]\ VPWR VGND sg13g2_nand2_1
X_25919_ _02818_ \memory_i.freq_inst.cordic.Z_i[12]\ \memory_i.freq_inst.f_c[12]\ VPWR VGND sg13g2_or2_1
X_25920_ _02819_ \memory_i.freq_inst.f_c[11]\ _02807_ _02808_ _02818_ VPWR
+ VGND
+ sg13g2_nand4_1
X_25921_ _02820_ \memory_i.freq_inst.cordic.Z_i[11]\ _02802_ _02803_ _02818_ VPWR
+ VGND
+ sg13g2_nand4_1
X_25922_ _02821_ _02817_ _02819_ _02820_ VPWR VGND sg13g2_nand3_1
X_25923_ _02822_ \memory_i.freq_inst.f_c[13]\ _02821_ VPWR VGND sg13g2_or2_1
X_25924_ _02823_ \memory_i.freq_inst.f_c[13]\ _02821_ VPWR VGND sg13g2_nand2_1
X_25925_ _02824_ _13183_ _02822_ _02823_ VPWR VGND sg13g2_nand3_1
X_25926_ _02825_ \memory_i.freq_inst.cordic.Z_i[13]\ _02824_ VPWR VGND sg13g2_xor2_1
X_25927_ _01325_ _02797_ _02825_ VPWR VGND sg13g2_nor2_1
X_25928_ _02826_ \memory_i.freq_inst.cordic.Z_i[14]\ VPWR VGND sg13g2_inv_1
X_25929_ _02827_ \memory_i.freq_inst.cordic.Z_i[13]\ \memory_i.freq_inst.f_c[13]\ VPWR VGND sg13g2_or2_1
X_25930_ _02828_ _02827_ VPWR VGND sg13g2_buf_1
X_25931_ _02829_ \memory_i.freq_inst.cordic.Z_i[13]\ \memory_i.freq_inst.f_c[13]\ VPWR VGND sg13g2_nand2_1
X_25932_ _02830_ _02817_ _02819_ _02820_ _02829_ VPWR
+ VGND
+ sg13g2_nand4_1
X_25933_ _02831_ _02830_ VPWR VGND sg13g2_buf_1
X_25934_ _02832_ _02828_ _02831_ \memory_i.freq_inst.f_c[14]\ VPWR VGND sg13g2_a21oi_1
X_25935_ _02833_ \memory_i.freq_inst.f_c[14]\ _02828_ _02831_ VPWR VGND sg13g2_nand3_1
X_25936_ _02834_ _02832_ _02833_ _13183_ VPWR VGND sg13g2_nand3b_1
X_25937_ _02835_ _02826_ _02834_ VPWR VGND sg13g2_xnor2_1
X_25938_ _01326_ _02797_ _02835_ VPWR VGND sg13g2_nor2_1
X_25939_ _02836_ _02826_ _02833_ _02832_ VPWR VGND sg13g2_a21o_1
X_25940_ _02837_ \memory_i.freq_inst.f_c[15]\ _02836_ VPWR VGND sg13g2_xnor2_1
X_25941_ _02838_ _02731_ _02837_ VPWR VGND sg13g2_nand2_1
X_25942_ _02839_ \memory_i.freq_inst.cordic.Z_i[15]\ _02838_ VPWR VGND sg13g2_xor2_1
X_25943_ _01327_ _02797_ _02839_ VPWR VGND sg13g2_nor2_1
X_25944_ _02840_ \memory_i.freq_inst.cordic.Z_i[15]\ \memory_i.freq_inst.f_c[15]\ VPWR VGND sg13g2_nand2_1
X_25945_ _02841_ \memory_i.freq_inst.cordic.Z_i[15]\ \memory_i.freq_inst.f_c[15]\ VPWR VGND sg13g2_nor2_1
X_25946_ _02842_ _02836_ _02840_ _02841_ VPWR VGND sg13g2_a21oi_1
X_25947_ _02843_ \memory_i.freq_inst.f_c[16]\ _02842_ VPWR VGND sg13g2_xor2_1
X_25948_ _02844_ _02731_ _02843_ VPWR VGND sg13g2_nand2_1
X_25949_ _02845_ \memory_i.freq_inst.cordic.Z_i[16]\ _02844_ VPWR VGND sg13g2_xor2_1
X_25950_ _01328_ _02797_ _02845_ VPWR VGND sg13g2_nor2_1
X_25951_ _02846_ \memory_i.freq_inst.f_c[16]\ \memory_i.freq_inst.f_c[15]\ VPWR VGND sg13g2_or2_1
X_25952_ _02847_ \memory_i.freq_inst.cordic.Z_i[15]\ \memory_i.freq_inst.f_c[16]\ VPWR VGND sg13g2_or2_1
X_25953_ _02848_ _02828_ _02831_ _02846_ _02847_ \memory_i.freq_inst.f_c[14]\
+ VPWR
+ VGND sg13g2_a221oi_1
X_25954_ _02849_ \memory_i.freq_inst.cordic.Z_i[14]\ \memory_i.freq_inst.f_c[16]\ \memory_i.freq_inst.f_c[15]\ VPWR VGND sg13g2_or3_1
X_25955_ _02850_ \memory_i.freq_inst.cordic.Z_i[15]\ \memory_i.freq_inst.cordic.Z_i[14]\ \memory_i.freq_inst.f_c[16]\ VPWR VGND sg13g2_or3_1
X_25956_ _02851_ _02828_ _02831_ _02849_ _02850_ VPWR
+ VGND
+ sg13g2_a22oi_1
X_25957_ _02852_ \memory_i.freq_inst.cordic.Z_i[14]\ \memory_i.freq_inst.f_c[16]\ \memory_i.freq_inst.f_c[15]\ \memory_i.freq_inst.f_c[14]\ VPWR
+ VGND
+ sg13g2_nor4_1
X_25958_ _02853_ \memory_i.freq_inst.cordic.Z_i[15]\ \memory_i.freq_inst.cordic.Z_i[14]\ \memory_i.freq_inst.f_c[16]\ \memory_i.freq_inst.f_c[14]\ VPWR
+ VGND
+ sg13g2_nor4_1
X_25959_ _02854_ _02852_ _02853_ VPWR VGND sg13g2_nor2_1
X_25960_ _02855_ \memory_i.freq_inst.f_c[15]\ _02847_ _02854_ VPWR VGND sg13g2_o21ai_1
X_25961_ _02856_ \memory_i.freq_inst.f_c[16]\ \memory_i.freq_inst.f_c[15]\ VPWR VGND sg13g2_nand2_1
X_25962_ _02857_ \memory_i.freq_inst.cordic.Z_i[15]\ \memory_i.freq_inst.f_c[16]\ VPWR VGND sg13g2_nand2_1
X_25963_ _02858_ _02826_ _02833_ _02856_ _02857_ _02832_
+ VPWR
+ VGND sg13g2_a221oi_1
X_25964_ _02859_ _02858_ VPWR VGND sg13g2_buf_1
X_25965_ _02860_ \memory_i.freq_inst.cordic.Z_i[15]\ \memory_i.freq_inst.f_c[16]\ \memory_i.freq_inst.f_c[15]\ VPWR VGND sg13g2_nand3_1
X_25966_ _02861_ \memory_i.freq_inst.cordic.Z_i[16]\ _02860_ VPWR VGND sg13g2_nand2b_1
X_25967_ _02862_ _02859_ _02861_ VPWR VGND sg13g2_nor2_1
X_25968_ _02863_ _02848_ _02851_ _02855_ _02862_ VPWR
+ VGND
+ sg13g2_nor4_1
X_25969_ _02864_ \memory_i.freq_inst.f_c[17]\ _02863_ VPWR VGND sg13g2_xnor2_1
X_25970_ _02865_ _02739_ _02864_ VPWR VGND sg13g2_nor2_1
X_25971_ _02866_ \memory_i.freq_inst.cordic.Z_i[17]\ _02865_ VPWR VGND sg13g2_xnor2_1
X_25972_ _01329_ _02797_ _02866_ VPWR VGND sg13g2_nor2_1
X_25973_ _02867_ \memory_i.freq_inst.cordic.Z_i[17]\ \memory_i.freq_inst.f_c[17]\ _02863_ VPWR VGND sg13g2_o21ai_1
X_25974_ _02868_ \memory_i.freq_inst.cordic.Z_i[17]\ \memory_i.freq_inst.f_c[17]\ VPWR VGND sg13g2_nand2_1
X_25975_ _02869_ _02867_ _02868_ VPWR VGND sg13g2_nand2_1
X_25976_ _02870_ \memory_i.freq_inst.f_c[18]\ _02869_ VPWR VGND sg13g2_xnor2_1
X_25977_ _02871_ _02739_ _02870_ VPWR VGND sg13g2_nor2_1
X_25978_ _02872_ \memory_i.freq_inst.cordic.Z_i[18]\ _02871_ VPWR VGND sg13g2_xnor2_1
X_25979_ _01330_ _02797_ _02872_ VPWR VGND sg13g2_nor2_1
X_25980_ _02873_ \memory_i.freq_inst.cordic.Z_i[18]\ \memory_i.freq_inst.f_c[18]\ \memory_i.freq_inst.f_c[17]\ VPWR VGND sg13g2_o21ai_1
X_25981_ _02874_ _02848_ _02851_ _02855_ _02873_ VPWR
+ VGND
+ sg13g2_nor4_1
X_25982_ _02875_ _02859_ _02861_ _02874_ VPWR VGND sg13g2_o21ai_1
X_25983_ _02876_ \memory_i.freq_inst.cordic.Z_i[18]\ \memory_i.freq_inst.f_c[18]\ \memory_i.freq_inst.cordic.Z_i[17]\ VPWR VGND sg13g2_o21ai_1
X_25984_ _02877_ _02848_ _02851_ _02855_ _02876_ VPWR
+ VGND
+ sg13g2_nor4_1
X_25985_ _02878_ _02859_ _02861_ _02877_ VPWR VGND sg13g2_o21ai_1
X_25986_ _02879_ \memory_i.freq_inst.cordic.Z_i[18]\ \memory_i.freq_inst.f_c[18]\ VPWR VGND sg13g2_nor2_1
X_25987_ _02880_ _02868_ _02879_ VPWR VGND sg13g2_nor2_1
X_25988_ _02881_ \memory_i.freq_inst.cordic.Z_i[18]\ \memory_i.freq_inst.f_c[18]\ _02880_ VPWR VGND sg13g2_a21oi_1
X_25989_ _02882_ _02875_ _02878_ _02881_ VPWR VGND sg13g2_nand3_1
X_25990_ _02883_ _02882_ VPWR VGND sg13g2_buf_1
X_25991_ _02884_ \memory_i.freq_inst.f_c[19]\ _02883_ VPWR VGND sg13g2_xnor2_1
X_25992_ _02885_ _02739_ _02884_ VPWR VGND sg13g2_nor2_1
X_25993_ _02886_ \memory_i.freq_inst.cordic.Z_i[19]\ _02885_ VPWR VGND sg13g2_xnor2_1
X_25994_ _01331_ _02797_ _02886_ VPWR VGND sg13g2_nor2_1
X_25995_ _02887_ \memory_i.freq_inst.cordic.Z_i[19]\ \memory_i.freq_inst.f_c[19]\ VPWR VGND sg13g2_or2_1
X_25996_ _02888_ \memory_i.freq_inst.cordic.Z_i[19]\ \memory_i.freq_inst.f_c[19]\ VPWR VGND sg13g2_and2_1
X_25997_ _02889_ _02883_ _02887_ _02888_ VPWR VGND sg13g2_a21oi_1
X_25998_ _02890_ \memory_i.freq_inst.f_c[20]\ _02889_ VPWR VGND sg13g2_xnor2_1
X_25999_ _02891_ _02731_ _02890_ VPWR VGND sg13g2_nand2_1
X_26000_ _02892_ \memory_i.freq_inst.cordic.Z_i[20]\ _02891_ VPWR VGND sg13g2_xor2_1
X_26001_ _01332_ _02797_ _02892_ VPWR VGND sg13g2_nor2_1
X_26002_ _02893_ \memory_i.freq_inst.cordic.Z_i[20]\ \memory_i.freq_inst.f_c[20]\ VPWR VGND sg13g2_nand2_1
X_26003_ _02894_ \memory_i.freq_inst.cordic.Z_i[20]\ \memory_i.freq_inst.f_c[20]\ VPWR VGND sg13g2_nor2_1
X_26004_ _02895_ _02889_ _02893_ _02894_ VPWR VGND sg13g2_a21oi_1
X_26005_ _02896_ \memory_i.freq_inst.f_c[21]\ _02895_ VPWR VGND sg13g2_xnor2_1
X_26006_ _02897_ _13175_ _02896_ VPWR VGND sg13g2_nor2_1
X_26007_ _02898_ \memory_i.freq_inst.cordic.Z_i[21]\ _02897_ VPWR VGND sg13g2_xnor2_1
X_26008_ _01333_ _02759_ _02898_ VPWR VGND sg13g2_nor2_1
X_26009_ _02899_ \memory_i.freq_inst.f_c[21]\ _02895_ \memory_i.freq_inst.cordic.Z_i[21]\ VPWR VGND sg13g2_a21o_1
X_26010_ _02900_ \memory_i.freq_inst.f_c[21]\ _02895_ _02899_ VPWR VGND sg13g2_o21ai_1
X_26011_ _02901_ \memory_i.freq_inst.f_c[22]\ _02900_ VPWR VGND sg13g2_xnor2_1
X_26012_ _02902_ _02731_ _02901_ VPWR VGND sg13g2_nand2_1
X_26013_ _02903_ \memory_i.freq_inst.cordic.Z_i[22]\ _02902_ VPWR VGND sg13g2_xor2_1
X_26014_ _01334_ _02759_ _02903_ VPWR VGND sg13g2_nor2_1
X_26015_ _02904_ \memory_i.freq_inst.cordic.Z_i[22]\ \memory_i.freq_inst.f_c[22]\ VPWR VGND sg13g2_nor2_1
X_26016_ _02905_ \memory_i.freq_inst.cordic.Z_i[22]\ \memory_i.freq_inst.f_c[22]\ VPWR VGND sg13g2_nand2_1
X_26017_ _02906_ _02900_ _02904_ _02905_ VPWR VGND sg13g2_o21ai_1
X_26018_ _02907_ \memory_i.freq_inst.f_c[23]\ _02906_ VPWR VGND sg13g2_xor2_1
X_26019_ _02908_ _02731_ _02907_ VPWR VGND sg13g2_nand2_1
X_26020_ _02909_ \memory_i.freq_inst.cordic.Z_i[23]\ _02908_ VPWR VGND sg13g2_xor2_1
X_26021_ _01335_ _02759_ _02909_ VPWR VGND sg13g2_nor2_1
X_26022_ _02910_ \memory_i.freq_inst.cordic.Z_i[23]\ \memory_i.freq_inst.f_c[23]\ VPWR VGND sg13g2_nand2_1
X_26023_ _02911_ \memory_i.freq_inst.cordic.Z_i[21]\ VPWR VGND sg13g2_inv_1
X_26024_ _02912_ \memory_i.freq_inst.cordic.Z_i[20]\ \memory_i.freq_inst.f_c[20]\ \memory_i.freq_inst.f_c[21]\ VPWR VGND sg13g2_a21oi_1
X_26025_ _02913_ \memory_i.freq_inst.cordic.Z_i[20]\ \memory_i.freq_inst.f_c[21]\ \memory_i.freq_inst.f_c[20]\ VPWR VGND sg13g2_nand3_1
X_26026_ _02914_ _02911_ _02912_ _02913_ VPWR VGND sg13g2_o21ai_1
X_26027_ _02915_ \memory_i.freq_inst.f_c[22]\ _02914_ \memory_i.freq_inst.cordic.Z_i[22]\ VPWR VGND sg13g2_a21o_1
X_26028_ _02916_ \memory_i.freq_inst.f_c[22]\ _02914_ _02915_ VPWR VGND sg13g2_o21ai_1
X_26029_ _02917_ \memory_i.freq_inst.cordic.Z_i[23]\ \memory_i.freq_inst.f_c[23]\ VPWR VGND sg13g2_nor2_1
X_26030_ _02918_ _02910_ _02916_ _02917_ VPWR VGND sg13g2_a21oi_1
X_26031_ _02919_ \memory_i.freq_inst.f_c[24]\ \memory_i.freq_inst.f_c[19]\ _02918_ VPWR VGND sg13g2_or3_1
X_26032_ _02920_ \memory_i.freq_inst.cordic.Z_i[19]\ \memory_i.freq_inst.f_c[24]\ _02918_ VPWR VGND sg13g2_or3_1
X_26033_ _02921_ _02919_ _02920_ _02883_ VPWR VGND sg13g2_a21oi_1
X_26034_ _02922_ \memory_i.freq_inst.cordic.Z_i[21]\ \memory_i.freq_inst.f_c[21]\ VPWR VGND sg13g2_xnor2_1
X_26035_ _02923_ \memory_i.freq_inst.cordic.Z_i[23]\ \memory_i.freq_inst.f_c[23]\ VPWR VGND sg13g2_xnor2_1
X_26036_ _02924_ _02904_ _02905_ VPWR VGND sg13g2_nand2b_1
X_26037_ _02925_ \memory_i.freq_inst.cordic.Z_i[20]\ \memory_i.freq_inst.f_c[20]\ VPWR VGND sg13g2_xnor2_1
X_26038_ _02926_ _02922_ _02923_ _02924_ _02925_ VPWR
+ VGND
+ sg13g2_nor4_1
X_26039_ _02927_ \memory_i.freq_inst.f_c[24]\ _02926_ VPWR VGND sg13g2_nor2_1
X_26040_ _02928_ \memory_i.freq_inst.cordic.Z_i[19]\ \memory_i.freq_inst.f_c[24]\ \memory_i.freq_inst.f_c[19]\ VPWR VGND sg13g2_nor3_1
X_26041_ _02929_ _02918_ VPWR VGND sg13g2_inv_1
X_26042_ _02930_ _02927_ _02928_ _02929_ VPWR VGND sg13g2_o21ai_1
X_26043_ _02931_ _02921_ _02930_ VPWR VGND sg13g2_nand2b_1
X_26044_ _02932_ _02875_ _02878_ VPWR VGND sg13g2_and2_1
X_26045_ _02933_ \memory_i.freq_inst.f_c[24]\ \memory_i.freq_inst.f_c[19]\ _02926_ VPWR VGND sg13g2_nand3_1
X_26046_ _02934_ \memory_i.freq_inst.cordic.Z_i[19]\ \memory_i.freq_inst.f_c[24]\ _02926_ VPWR VGND sg13g2_nand3_1
X_26047_ _02935_ _02932_ _02881_ _02933_ _02934_ VPWR
+ VGND
+ sg13g2_a22oi_1
X_26048_ _02936_ \memory_i.freq_inst.f_c[24]\ VPWR VGND sg13g2_inv_1
X_26049_ _02937_ \memory_i.freq_inst.cordic.Z_i[19]\ \memory_i.freq_inst.f_c[24]\ \memory_i.freq_inst.f_c[19]\ _02926_ VPWR
+ VGND
+ sg13g2_nand4_1
X_26050_ _02938_ _02936_ _02929_ _02937_ VPWR VGND sg13g2_o21ai_1
X_26051_ _02939_ _13175_ _02931_ _02935_ _02938_ VPWR
+ VGND
+ sg13g2_or4_1
X_26052_ _02940_ \memory_i.freq_inst.cordic.Z_i[24]\ _02939_ VPWR VGND sg13g2_xor2_1
X_26053_ _01336_ _02759_ _02940_ VPWR VGND sg13g2_nor2_1
X_26054_ _02941_ \memory_i.freq_inst.cordic.Z_i[24]\ _02935_ _02938_ VPWR VGND sg13g2_nor3_1
X_26055_ _02942_ _02931_ _02941_ VPWR VGND sg13g2_or2_1
X_26056_ _02943_ \memory_i.freq_inst.f_c[25]\ _02942_ VPWR VGND sg13g2_xor2_1
X_26057_ _02944_ _13175_ _02943_ VPWR VGND sg13g2_nor2_1
X_26058_ _02945_ \memory_i.freq_inst.cordic.Z_i[25]\ _02944_ VPWR VGND sg13g2_xnor2_1
X_26059_ _01337_ _02759_ _02945_ VPWR VGND sg13g2_nor2_1
X_26060_ _02946_ \memory_i.freq_inst.cordic.Z_i[25]\ \memory_i.freq_inst.f_c[25]\ VPWR VGND sg13g2_nor2_1
X_26061_ _02947_ \memory_i.freq_inst.cordic.Z_i[25]\ \memory_i.freq_inst.f_c[25]\ VPWR VGND sg13g2_nand2_1
X_26062_ _02948_ _02942_ _02946_ _02947_ VPWR VGND sg13g2_o21ai_1
X_26063_ _02949_ \memory_i.freq_inst.f_c[26]\ _02948_ VPWR VGND sg13g2_xor2_1
X_26064_ _02950_ _02731_ _02949_ VPWR VGND sg13g2_nand2_1
X_26065_ _02951_ \memory_i.freq_inst.cordic.Z_i[26]\ _02950_ VPWR VGND sg13g2_xor2_1
X_26066_ _01338_ _02759_ _02951_ VPWR VGND sg13g2_nor2_1
X_26067_ _02952_ \memory_i.freq_inst.cordic.Z_i[26]\ \memory_i.freq_inst.f_c[26]\ \memory_i.freq_inst.f_c[25]\ VPWR VGND sg13g2_o21ai_1
X_26068_ _02953_ _02952_ VPWR VGND sg13g2_inv_1
X_26069_ _02954_ _02921_ _02930_ _02953_ VPWR VGND sg13g2_nand3b_1
X_26070_ _02955_ \memory_i.freq_inst.cordic.Z_i[26]\ \memory_i.freq_inst.f_c[26]\ \memory_i.freq_inst.cordic.Z_i[25]\ VPWR VGND sg13g2_o21ai_1
X_26071_ _02956_ _02955_ VPWR VGND sg13g2_inv_1
X_26072_ _02957_ _02921_ _02930_ _02956_ VPWR VGND sg13g2_nand3b_1
X_26073_ _02958_ _02954_ _02957_ _02941_ VPWR VGND sg13g2_a21o_1
X_26074_ _02959_ \memory_i.freq_inst.cordic.Z_i[26]\ \memory_i.freq_inst.f_c[26]\ VPWR VGND sg13g2_nor2_1
X_26075_ _02960_ _02947_ _02959_ VPWR VGND sg13g2_nor2_1
X_26076_ _02961_ \memory_i.freq_inst.cordic.Z_i[26]\ \memory_i.freq_inst.f_c[26]\ _02960_ VPWR VGND sg13g2_a21oi_1
X_26077_ _02962_ \memory_i.freq_inst.f_c[27]\ VPWR VGND sg13g2_inv_1
X_26078_ _02963_ _02958_ _02961_ _02962_ VPWR VGND sg13g2_a21oi_1
X_26079_ _02964_ _02962_ _02958_ _02961_ VPWR VGND sg13g2_nand3_1
X_26080_ _02965_ _02963_ _02964_ _13183_ VPWR VGND sg13g2_nand3b_1
X_26081_ _02966_ \memory_i.freq_inst.cordic.Z_i[27]\ _02965_ VPWR VGND sg13g2_xor2_1
X_26082_ _01339_ _02759_ _02966_ VPWR VGND sg13g2_nor2_1
X_26083_ _02967_ \memory_i.freq_inst.cordic.Z_i[27]\ _02963_ _02964_ VPWR VGND sg13g2_o21ai_1
X_26084_ _02968_ \memory_i.freq_inst.f_c[28]\ _02967_ VPWR VGND sg13g2_xnor2_1
X_26085_ _02969_ _02731_ _02968_ VPWR VGND sg13g2_nand2_1
X_26086_ _02970_ \memory_i.freq_inst.cordic.Z_i[28]\ _02969_ VPWR VGND sg13g2_xor2_1
X_26087_ _01340_ _02759_ _02970_ VPWR VGND sg13g2_nor2_1
X_26088_ _02971_ \memory_i.freq_inst.f_c[29]\ _13183_ VPWR VGND sg13g2_nand2b_1
X_26089_ _02972_ \memory_i.freq_inst.f_c[29]\ _13183_ VPWR VGND sg13g2_nand2_1
X_26090_ _02973_ \memory_i.freq_inst.cordic.Z_i[28]\ \memory_i.freq_inst.f_c[28]\ VPWR VGND sg13g2_nand2_1
X_26091_ _02974_ \memory_i.freq_inst.cordic.Z_i[28]\ \memory_i.freq_inst.f_c[28]\ VPWR VGND sg13g2_nor2_1
X_26092_ _02975_ _02967_ _02973_ _02974_ VPWR VGND sg13g2_a21o_1
X_26093_ _02976_ _02971_ _02972_ _02975_ VPWR VGND sg13g2_mux2_1
X_26094_ _02977_ \memory_i.freq_inst.cordic.Z_i[29]\ _02976_ VPWR VGND sg13g2_xor2_1
X_26095_ _01341_ _02759_ _02977_ VPWR VGND sg13g2_nor2_1
X_26096_ _02978_ _13184_ VPWR VGND sg13g2_buf_1
X_26097_ _02979_ \memory_i.freq_inst.X_o[0]\ _02978_ VPWR VGND sg13g2_nand2_1
X_26098_ _02980_ _13175_ VPWR VGND sg13g2_buf_1
X_26099_ _02981_ _02980_ VPWR VGND sg13g2_buf_1
X_26100_ _02982_ \memory_i.freq_inst.cosine[0]\ _02981_ VPWR VGND sg13g2_nand2_1
X_26101_ _01342_ _02979_ _02982_ _13180_ VPWR VGND sg13g2_a21oi_1
X_26102_ _02983_ \memory_i.freq_inst.X_o[1]\ _02978_ VPWR VGND sg13g2_nand2_1
X_26103_ _02984_ \memory_i.freq_inst.cosine[1]\ _02981_ VPWR VGND sg13g2_nand2_1
X_26104_ _01343_ _02983_ _02984_ _13180_ VPWR VGND sg13g2_a21oi_1
X_26105_ _02985_ \memory_i.freq_inst.X_o[2]\ _02978_ VPWR VGND sg13g2_nand2_1
X_26106_ _02986_ \memory_i.freq_inst.cosine[2]\ _02981_ VPWR VGND sg13g2_nand2_1
X_26107_ _01344_ _02985_ _02986_ _13180_ VPWR VGND sg13g2_a21oi_1
X_26108_ _02987_ \memory_i.freq_inst.X_o[3]\ _02978_ VPWR VGND sg13g2_nand2_1
X_26109_ _02988_ \memory_i.freq_inst.cosine[3]\ _02981_ VPWR VGND sg13g2_nand2_1
X_26110_ _01345_ _02987_ _02988_ _13180_ VPWR VGND sg13g2_a21oi_1
X_26111_ _02989_ \memory_i.freq_inst.X_o[4]\ _02978_ VPWR VGND sg13g2_nand2_1
X_26112_ _02990_ \memory_i.freq_inst.cosine[4]\ _02981_ VPWR VGND sg13g2_nand2_1
X_26113_ _01346_ _02989_ _02990_ _13180_ VPWR VGND sg13g2_a21oi_1
X_26114_ _02991_ \memory_i.freq_inst.X_o[5]\ _02978_ VPWR VGND sg13g2_nand2_1
X_26115_ _02992_ \memory_i.freq_inst.cosine[5]\ _02981_ VPWR VGND sg13g2_nand2_1
X_26116_ _01347_ _02991_ _02992_ _13180_ VPWR VGND sg13g2_a21oi_1
X_26117_ _02993_ \memory_i.freq_inst.X_o[6]\ _02978_ VPWR VGND sg13g2_nand2_1
X_26118_ _02994_ \memory_i.freq_inst.cosine[6]\ _02981_ VPWR VGND sg13g2_nand2_1
X_26119_ _01348_ _02993_ _02994_ _13180_ VPWR VGND sg13g2_a21oi_1
X_26120_ _02995_ \memory_i.freq_inst.X_o[7]\ _02978_ VPWR VGND sg13g2_nand2_1
X_26121_ _02996_ \memory_i.freq_inst.cosine[7]\ _02981_ VPWR VGND sg13g2_nand2_1
X_26122_ _02997_ _13179_ VPWR VGND sg13g2_buf_1
X_26123_ _02998_ _02997_ VPWR VGND sg13g2_buf_1
X_26124_ _01349_ _02995_ _02996_ _02998_ VPWR VGND sg13g2_a21oi_1
X_26125_ _02999_ \memory_i.freq_inst.X_o[8]\ _02978_ VPWR VGND sg13g2_nand2_1
X_26126_ _03000_ \memory_i.freq_inst.cosine[8]\ _02981_ VPWR VGND sg13g2_nand2_1
X_26127_ _01350_ _02999_ _03000_ _02998_ VPWR VGND sg13g2_a21oi_1
X_26128_ _03001_ \memory_i.freq_inst.X_o[9]\ _02978_ VPWR VGND sg13g2_nand2_1
X_26129_ _03002_ \memory_i.freq_inst.cosine[9]\ _02981_ VPWR VGND sg13g2_nand2_1
X_26130_ _01351_ _03001_ _03002_ _02998_ VPWR VGND sg13g2_a21oi_1
X_26131_ _03003_ _13184_ VPWR VGND sg13g2_buf_1
X_26132_ _03004_ \memory_i.freq_inst.X_o[10]\ _03003_ VPWR VGND sg13g2_nand2_1
X_26133_ _03005_ _02739_ VPWR VGND sg13g2_buf_1
X_26134_ _03006_ \memory_i.freq_inst.cosine[10]\ _03005_ VPWR VGND sg13g2_nand2_1
X_26135_ _01352_ _03004_ _03006_ _02998_ VPWR VGND sg13g2_a21oi_1
X_26136_ _03007_ \memory_i.freq_inst.X_o[11]\ _03003_ VPWR VGND sg13g2_nand2_1
X_26137_ _03008_ \memory_i.freq_inst.cosine[11]\ _03005_ VPWR VGND sg13g2_nand2_1
X_26138_ _01353_ _03007_ _03008_ _02998_ VPWR VGND sg13g2_a21oi_1
X_26139_ _03009_ \memory_i.freq_inst.X_o[12]\ _03003_ VPWR VGND sg13g2_nand2_1
X_26140_ _03010_ \memory_i.freq_inst.cosine[12]\ _03005_ VPWR VGND sg13g2_nand2_1
X_26141_ _01354_ _03009_ _03010_ _02998_ VPWR VGND sg13g2_a21oi_1
X_26142_ _03011_ \memory_i.freq_inst.X_o[13]\ _03003_ VPWR VGND sg13g2_nand2_1
X_26143_ _03012_ \memory_i.freq_inst.cosine[13]\ _03005_ VPWR VGND sg13g2_nand2_1
X_26144_ _01355_ _03011_ _03012_ _02998_ VPWR VGND sg13g2_a21oi_1
X_26145_ _03013_ \memory_i.freq_inst.X_o[14]\ _03003_ VPWR VGND sg13g2_nand2_1
X_26146_ _03014_ \memory_i.freq_inst.cosine[14]\ _03005_ VPWR VGND sg13g2_nand2_1
X_26147_ _01356_ _03013_ _03014_ _02998_ VPWR VGND sg13g2_a21oi_1
X_26148_ _03015_ \memory_i.freq_inst.X_o[15]\ _03003_ VPWR VGND sg13g2_nand2_1
X_26149_ _03016_ \memory_i.freq_inst.cosine[15]\ _03005_ VPWR VGND sg13g2_nand2_1
X_26150_ _01357_ _03015_ _03016_ _02998_ VPWR VGND sg13g2_a21oi_1
X_26151_ _03017_ \memory_i.freq_inst.X_o[16]\ _03003_ VPWR VGND sg13g2_nand2_1
X_26152_ _03018_ \memory_i.freq_inst.cosine[16]\ _03005_ VPWR VGND sg13g2_nand2_1
X_26153_ _01358_ _03017_ _03018_ _02998_ VPWR VGND sg13g2_a21oi_1
X_26154_ _03019_ \memory_i.freq_inst.X_o[17]\ _03003_ VPWR VGND sg13g2_nand2_1
X_26155_ _03020_ \memory_i.freq_inst.cosine[17]\ _03005_ VPWR VGND sg13g2_nand2_1
X_26156_ _03021_ _02997_ VPWR VGND sg13g2_buf_1
X_26157_ _01359_ _03019_ _03020_ _03021_ VPWR VGND sg13g2_a21oi_1
X_26158_ _03022_ \memory_i.freq_inst.X_o[18]\ _03003_ VPWR VGND sg13g2_nand2_1
X_26159_ _03023_ \memory_i.freq_inst.cosine[18]\ _03005_ VPWR VGND sg13g2_nand2_1
X_26160_ _01360_ _03022_ _03023_ _03021_ VPWR VGND sg13g2_a21oi_1
X_26161_ _03024_ \memory_i.freq_inst.X_o[19]\ _03003_ VPWR VGND sg13g2_nand2_1
X_26162_ _03025_ \memory_i.freq_inst.cosine[19]\ _03005_ VPWR VGND sg13g2_nand2_1
X_26163_ _01361_ _03024_ _03025_ _03021_ VPWR VGND sg13g2_a21oi_1
X_26164_ _03026_ _13184_ VPWR VGND sg13g2_buf_1
X_26165_ _03027_ \memory_i.freq_inst.X_o[20]\ _03026_ VPWR VGND sg13g2_nand2_1
X_26166_ _03028_ _02739_ VPWR VGND sg13g2_buf_1
X_26167_ _03029_ \memory_i.freq_inst.cosine[20]\ _03028_ VPWR VGND sg13g2_nand2_1
X_26168_ _01362_ _03027_ _03029_ _03021_ VPWR VGND sg13g2_a21oi_1
X_26169_ _03030_ \memory_i.freq_inst.X_o[21]\ _03026_ VPWR VGND sg13g2_nand2_1
X_26170_ _03031_ \memory_i.freq_inst.cosine[21]\ _03028_ VPWR VGND sg13g2_nand2_1
X_26171_ _01363_ _03030_ _03031_ _03021_ VPWR VGND sg13g2_a21oi_1
X_26172_ _03032_ \memory_i.freq_inst.X_o[22]\ _03026_ VPWR VGND sg13g2_nand2_1
X_26173_ _03033_ \memory_i.freq_inst.cosine[22]\ _03028_ VPWR VGND sg13g2_nand2_1
X_26174_ _01364_ _03032_ _03033_ _03021_ VPWR VGND sg13g2_a21oi_1
X_26175_ _03034_ \memory_i.freq_inst.X_o[23]\ _03026_ VPWR VGND sg13g2_nand2_1
X_26176_ _03035_ \memory_i.freq_inst.cosine[23]\ _03028_ VPWR VGND sg13g2_nand2_1
X_26177_ _01365_ _03034_ _03035_ _03021_ VPWR VGND sg13g2_a21oi_1
X_26178_ _03036_ \memory_i.freq_inst.X_o[24]\ _03026_ VPWR VGND sg13g2_nand2_1
X_26179_ _03037_ \memory_i.freq_inst.cosine[24]\ _03028_ VPWR VGND sg13g2_nand2_1
X_26180_ _01366_ _03036_ _03037_ _03021_ VPWR VGND sg13g2_a21oi_1
X_26181_ _03038_ \memory_i.freq_inst.X_o[25]\ _03026_ VPWR VGND sg13g2_nand2_1
X_26182_ _03039_ \memory_i.freq_inst.cosine[25]\ _03028_ VPWR VGND sg13g2_nand2_1
X_26183_ _01367_ _03038_ _03039_ _03021_ VPWR VGND sg13g2_a21oi_1
X_26184_ _03040_ \memory_i.freq_inst.X_o[26]\ _03026_ VPWR VGND sg13g2_nand2_1
X_26185_ _03041_ \memory_i.freq_inst.cosine[26]\ _03028_ VPWR VGND sg13g2_nand2_1
X_26186_ _01368_ _03040_ _03041_ _03021_ VPWR VGND sg13g2_a21oi_1
X_26187_ _03042_ \memory_i.freq_inst.X_o[27]\ _03026_ VPWR VGND sg13g2_nand2_1
X_26188_ _03043_ \memory_i.freq_inst.cosine[27]\ _03028_ VPWR VGND sg13g2_nand2_1
X_26189_ _03044_ _02997_ VPWR VGND sg13g2_buf_1
X_26190_ _01369_ _03042_ _03043_ _03044_ VPWR VGND sg13g2_a21oi_1
X_26191_ _03045_ \memory_i.freq_inst.X_o[28]\ _03026_ VPWR VGND sg13g2_nand2_1
X_26192_ _03046_ \memory_i.freq_inst.cosine[28]\ _03028_ VPWR VGND sg13g2_nand2_1
X_26193_ _01370_ _03045_ _03046_ _03044_ VPWR VGND sg13g2_a21oi_1
X_26194_ _03047_ \memory_i.freq_inst.X_o[29]\ _03026_ VPWR VGND sg13g2_nand2_1
X_26195_ _03048_ \memory_i.freq_inst.cosine[29]\ _03028_ VPWR VGND sg13g2_nand2_1
X_26196_ _01371_ _03047_ _03048_ _03044_ VPWR VGND sg13g2_a21oi_1
X_26197_ _03049_ _13184_ VPWR VGND sg13g2_buf_1
X_26198_ _03050_ \memory_i.freq_inst.Y_o[0]\ _03049_ VPWR VGND sg13g2_nand2_1
X_26199_ _03051_ _02739_ VPWR VGND sg13g2_buf_1
X_26200_ _03052_ \memory_i.freq_inst.dsmod_sin.data_ext_w[8]\ _03051_ VPWR VGND sg13g2_nand2_1
X_26201_ _01372_ _03050_ _03052_ _03044_ VPWR VGND sg13g2_a21oi_1
X_26202_ _03053_ \memory_i.freq_inst.Y_o[1]\ _03049_ VPWR VGND sg13g2_nand2_1
X_26203_ _03054_ \memory_i.freq_inst.dsmod_sin.data_ext_w[9]\ _03051_ VPWR VGND sg13g2_nand2_1
X_26204_ _01373_ _03053_ _03054_ _03044_ VPWR VGND sg13g2_a21oi_1
X_26205_ _03055_ \memory_i.freq_inst.Y_o[2]\ _03049_ VPWR VGND sg13g2_nand2_1
X_26206_ _03056_ \memory_i.freq_inst.dsmod_sin.data_ext_w[10]\ _03051_ VPWR VGND sg13g2_nand2_1
X_26207_ _01374_ _03055_ _03056_ _03044_ VPWR VGND sg13g2_a21oi_1
X_26208_ _03057_ \memory_i.freq_inst.Y_o[3]\ _03049_ VPWR VGND sg13g2_nand2_1
X_26209_ _03058_ \memory_i.freq_inst.dsmod_sin.data_ext_w[11]\ _03051_ VPWR VGND sg13g2_nand2_1
X_26210_ _01375_ _03057_ _03058_ _03044_ VPWR VGND sg13g2_a21oi_1
X_26211_ _03059_ \memory_i.freq_inst.Y_o[4]\ _03049_ VPWR VGND sg13g2_nand2_1
X_26212_ _03060_ \memory_i.freq_inst.dsmod_sin.data_ext_w[12]\ _03051_ VPWR VGND sg13g2_nand2_1
X_26213_ _01376_ _03059_ _03060_ _03044_ VPWR VGND sg13g2_a21oi_1
X_26214_ _03061_ \memory_i.freq_inst.Y_o[5]\ _03049_ VPWR VGND sg13g2_nand2_1
X_26215_ _03062_ \memory_i.freq_inst.dsmod_sin.data_ext_w[13]\ _03051_ VPWR VGND sg13g2_nand2_1
X_26216_ _01377_ _03061_ _03062_ _03044_ VPWR VGND sg13g2_a21oi_1
X_26217_ _03063_ \memory_i.freq_inst.Y_o[6]\ _03049_ VPWR VGND sg13g2_nand2_1
X_26218_ _03064_ \memory_i.freq_inst.dsmod_sin.data_ext_w[14]\ _03051_ VPWR VGND sg13g2_nand2_1
X_26219_ _01378_ _03063_ _03064_ _03044_ VPWR VGND sg13g2_a21oi_1
X_26220_ _03065_ \memory_i.freq_inst.Y_o[7]\ _03049_ VPWR VGND sg13g2_nand2_1
X_26221_ _03066_ \memory_i.freq_inst.dsmod_sin.data_ext_w[15]\ _03051_ VPWR VGND sg13g2_nand2_1
X_26222_ _03067_ _02997_ VPWR VGND sg13g2_buf_1
X_26223_ _01379_ _03065_ _03066_ _03067_ VPWR VGND sg13g2_a21oi_1
X_26224_ _03068_ \memory_i.freq_inst.Y_o[8]\ _03049_ VPWR VGND sg13g2_nand2_1
X_26225_ _03069_ \memory_i.freq_inst.dsmod_sin.data_ext_w[16]\ _03051_ VPWR VGND sg13g2_nand2_1
X_26226_ _01380_ _03068_ _03069_ _03067_ VPWR VGND sg13g2_a21oi_1
X_26227_ _03070_ \memory_i.freq_inst.Y_o[9]\ _03049_ VPWR VGND sg13g2_nand2_1
X_26228_ _03071_ \memory_i.freq_inst.dsmod_sin.data_ext_w[17]\ _03051_ VPWR VGND sg13g2_nand2_1
X_26229_ _01381_ _03070_ _03071_ _03067_ VPWR VGND sg13g2_a21oi_1
X_26230_ _03072_ _13184_ VPWR VGND sg13g2_buf_1
X_26231_ _03073_ \memory_i.freq_inst.dsmod_sin.data_ext_w[18]\ VPWR VGND sg13g2_inv_1
X_26232_ _03074_ _03073_ _13184_ VPWR VGND sg13g2_nor2_1
X_26233_ _03075_ \memory_i.freq_inst.Y_o[10]\ _03072_ _03074_ VPWR VGND sg13g2_a21oi_1
X_26234_ _01382_ _13180_ _03075_ VPWR VGND sg13g2_nor2_1
X_26235_ _03076_ _13184_ VPWR VGND sg13g2_buf_1
X_26236_ _03077_ \memory_i.freq_inst.Y_o[11]\ _03076_ VPWR VGND sg13g2_nand2_1
X_26237_ _03078_ _02739_ VPWR VGND sg13g2_buf_1
X_26238_ _03079_ \memory_i.freq_inst.dsmod_sin.data_ext_w[19]\ _03078_ VPWR VGND sg13g2_nand2_1
X_26239_ _01383_ _03077_ _03079_ _03067_ VPWR VGND sg13g2_a21oi_1
X_26240_ _03080_ \memory_i.freq_inst.Y_o[12]\ _03076_ VPWR VGND sg13g2_nand2_1
X_26241_ _03081_ \memory_i.freq_inst.dsmod_sin.data_ext_w[20]\ _03078_ VPWR VGND sg13g2_nand2_1
X_26242_ _01384_ _03080_ _03081_ _03067_ VPWR VGND sg13g2_a21oi_1
X_26243_ _03082_ \memory_i.freq_inst.Y_o[13]\ _03076_ VPWR VGND sg13g2_nand2_1
X_26244_ _03083_ \memory_i.freq_inst.dsmod_sin.data_ext_w[21]\ _03078_ VPWR VGND sg13g2_nand2_1
X_26245_ _01385_ _03082_ _03083_ _03067_ VPWR VGND sg13g2_a21oi_1
X_26246_ _03084_ \memory_i.freq_inst.Y_o[14]\ _03076_ VPWR VGND sg13g2_nand2_1
X_26247_ _03085_ \memory_i.freq_inst.dsmod_sin.data_ext_w[22]\ _03078_ VPWR VGND sg13g2_nand2_1
X_26248_ _01386_ _03084_ _03085_ _03067_ VPWR VGND sg13g2_a21oi_1
X_26249_ _03086_ \memory_i.freq_inst.Y_o[15]\ _03076_ VPWR VGND sg13g2_nand2_1
X_26250_ _03087_ \memory_i.freq_inst.dsmod_sin.data_ext_w[23]\ _03078_ VPWR VGND sg13g2_nand2_1
X_26251_ _01387_ _03086_ _03087_ _03067_ VPWR VGND sg13g2_a21oi_1
X_26252_ _03088_ \memory_i.freq_inst.Y_o[16]\ _03076_ VPWR VGND sg13g2_nand2_1
X_26253_ _03089_ \memory_i.freq_inst.dsmod_sin.data_ext_w[24]\ _03078_ VPWR VGND sg13g2_nand2_1
X_26254_ _01388_ _03088_ _03089_ _03067_ VPWR VGND sg13g2_a21oi_1
X_26255_ _03090_ \memory_i.freq_inst.Y_o[17]\ _03076_ VPWR VGND sg13g2_nand2_1
X_26256_ _03091_ \memory_i.freq_inst.dsmod_sin.data_ext_w[25]\ _03078_ VPWR VGND sg13g2_nand2_1
X_26257_ _01389_ _03090_ _03091_ _03067_ VPWR VGND sg13g2_a21oi_1
X_26258_ _03092_ \memory_i.freq_inst.Y_o[18]\ _03076_ VPWR VGND sg13g2_nand2_1
X_26259_ _03093_ \memory_i.freq_inst.dsmod_sin.data_ext_w[26]\ _03078_ VPWR VGND sg13g2_nand2_1
X_26260_ _03094_ _02997_ VPWR VGND sg13g2_buf_1
X_26261_ _01390_ _03092_ _03093_ _03094_ VPWR VGND sg13g2_a21oi_1
X_26262_ _03095_ \memory_i.freq_inst.Y_o[19]\ _03076_ VPWR VGND sg13g2_nand2_1
X_26263_ _03096_ \memory_i.freq_inst.dsmod_sin.data_ext_w[27]\ _03078_ VPWR VGND sg13g2_nand2_1
X_26264_ _01391_ _03095_ _03096_ _03094_ VPWR VGND sg13g2_a21oi_1
X_26265_ _03097_ \memory_i.freq_inst.Y_o[20]\ _03076_ VPWR VGND sg13g2_nand2_1
X_26266_ _03098_ \memory_i.freq_inst.dsmod_sin.data_ext_w[28]\ _03078_ VPWR VGND sg13g2_nand2_1
X_26267_ _01392_ _03097_ _03098_ _03094_ VPWR VGND sg13g2_a21oi_1
X_26268_ _03099_ \memory_i.freq_inst.Y_o[21]\ _03072_ VPWR VGND sg13g2_nand2_1
X_26269_ _03100_ \memory_i.freq_inst.dsmod_sin.data_ext_w[29]\ _02980_ VPWR VGND sg13g2_nand2_1
X_26270_ _01393_ _03099_ _03100_ _03094_ VPWR VGND sg13g2_a21oi_1
X_26271_ _03101_ \memory_i.freq_inst.Y_o[22]\ _03072_ VPWR VGND sg13g2_nand2_1
X_26272_ _03102_ \memory_i.freq_inst.dsmod_sin.data_ext_w[30]\ _02980_ VPWR VGND sg13g2_nand2_1
X_26273_ _01394_ _03101_ _03102_ _03094_ VPWR VGND sg13g2_a21oi_1
X_26274_ _03103_ \memory_i.freq_inst.Y_o[23]\ _03072_ VPWR VGND sg13g2_nand2_1
X_26275_ _03104_ \memory_i.freq_inst.dsmod_sin.data_ext_w[31]\ _02980_ VPWR VGND sg13g2_nand2_1
X_26276_ _01395_ _03103_ _03104_ _03094_ VPWR VGND sg13g2_a21oi_1
X_26277_ _03105_ \memory_i.freq_inst.Y_o[24]\ _03072_ VPWR VGND sg13g2_nand2_1
X_26278_ _03106_ \memory_i.freq_inst.dsmod_sin.data_ext_w[32]\ _02980_ VPWR VGND sg13g2_nand2_1
X_26279_ _01396_ _03105_ _03106_ _03094_ VPWR VGND sg13g2_a21oi_1
X_26280_ _03107_ \memory_i.freq_inst.Y_o[25]\ _03072_ VPWR VGND sg13g2_nand2_1
X_26281_ _03108_ \memory_i.freq_inst.dsmod_sin.data_ext_w[33]\ _02980_ VPWR VGND sg13g2_nand2_1
X_26282_ _01397_ _03107_ _03108_ _03094_ VPWR VGND sg13g2_a21oi_1
X_26283_ _03109_ \memory_i.freq_inst.Y_o[26]\ _03072_ VPWR VGND sg13g2_nand2_1
X_26284_ _03110_ \memory_i.freq_inst.dsmod_sin.data_ext_w[34]\ _02980_ VPWR VGND sg13g2_nand2_1
X_26285_ _01398_ _03109_ _03110_ _03094_ VPWR VGND sg13g2_a21oi_1
X_26286_ _03111_ \memory_i.freq_inst.Y_o[27]\ _03072_ VPWR VGND sg13g2_nand2_1
X_26287_ _03112_ \memory_i.freq_inst.dsmod_sin.data_ext_w[35]\ _02980_ VPWR VGND sg13g2_nand2_1
X_26288_ _01399_ _03111_ _03112_ _03094_ VPWR VGND sg13g2_a21oi_1
X_26289_ _03113_ \memory_i.freq_inst.Y_o[28]\ _03072_ VPWR VGND sg13g2_nand2_1
X_26290_ _03114_ \memory_i.freq_inst.dsmod_sin.data_ext_w[36]\ _02980_ VPWR VGND sg13g2_nand2_1
X_26291_ _01400_ _03113_ _03114_ _02997_ VPWR VGND sg13g2_a21oi_1
X_26292_ _03115_ \memory_i.freq_inst.Y_o[29]\ _03072_ VPWR VGND sg13g2_nand2_1
X_26293_ _03116_ \memory_i.freq_inst.dsmod_sin.data_ext_w[37]\ _02980_ VPWR VGND sg13g2_nand2_1
X_26294_ _01401_ _03115_ _03116_ _02997_ VPWR VGND sg13g2_a21oi_1
X_26295_ _03117_ \memory_i.freq_inst.transmit_state[3]\ \memory_i.freq_inst.transmit_state[2]\ VPWR VGND sg13g2_nor2_1
X_26296_ _03118_ \memory_i.freq_inst.start\ _13187_ VPWR VGND sg13g2_nor2_1
X_26297_ _03119_ \memory_i.freq_inst.transmit_state[3]\ \memory_i.freq_inst.transmit_state[1]\ VPWR VGND sg13g2_or2_1
X_26298_ _03120_ _03119_ VPWR VGND sg13g2_buf_1
X_26299_ _03121_ \memory_i.freq_inst.transmit_state[0]\ \memory_i.freq_inst.transmit_state[2]\ _03120_ VPWR VGND sg13g2_nor3_1
X_26300_ _03122_ _13185_ _03118_ _03121_ VPWR VGND sg13g2_nor3_1
X_26301_ _03123_ \memory_i.freq_inst.cordic.strb_data_valid_i\ _03117_ _03122_ VPWR VGND sg13g2_mux2_1
X_26302_ _01402_ \memory_i.freq_inst.reset_n\ _03123_ VPWR VGND sg13g2_and2_1
X_26303_ _03124_ \memory_i.freq_inst.transmit_state[2]\ _13182_ VPWR VGND sg13g2_nand2_1
X_26304_ _01403_ _12941_ _03124_ _02997_ VPWR VGND sg13g2_a21oi_1
X_26305_ _03125_ \memory_i.freq_inst.transmit_state[2]\ _13152_ _03124_ VPWR VGND sg13g2_o21ai_1
X_26306_ _03126_ _03125_ VPWR VGND sg13g2_buf_1
X_26307_ _03127_ \memory_i.freq_inst.transmit_counter[0]\ _03120_ _13177_ VPWR VGND sg13g2_nand3_1
X_26308_ _03128_ \memory_i.freq_inst.transmit_counter[0]\ _03126_ _03127_ VPWR VGND sg13g2_o21ai_1
X_26309_ _01404_ \memory_i.freq_inst.reset_n\ _03128_ VPWR VGND sg13g2_nand2_1
X_26310_ _03129_ \memory_i.freq_inst.transmit_counter[0]\ _13177_ \memory_i.freq_inst.transmit_counter[1]\ VPWR VGND sg13g2_nand3b_1
X_26311_ _03130_ \memory_i.freq_inst.transmit_counter[1]\ \memory_i.freq_inst.transmit_counter[0]\ VPWR VGND sg13g2_nand2b_1
X_26312_ _03131_ _03129_ _03130_ _13152_ VPWR VGND sg13g2_a21oi_1
X_26313_ _03132_ \memory_i.freq_inst.transmit_counter[1]\ _03126_ VPWR VGND sg13g2_nor2_1
X_26314_ _01405_ _03131_ _03132_ \memory_i.freq_inst.reset_n\ VPWR VGND sg13g2_o21ai_1
X_26315_ _03133_ \memory_i.freq_inst.transmit_counter[1]\ \memory_i.freq_inst.transmit_counter[0]\ VPWR VGND sg13g2_nor2_1
X_26316_ _03134_ \memory_i.freq_inst.transmit_counter[2]\ _03133_ _13177_ VPWR VGND sg13g2_nand3_1
X_26317_ _03135_ \memory_i.freq_inst.transmit_counter[2]\ _03133_ _03134_ VPWR VGND sg13g2_o21ai_1
X_26318_ _03136_ _03120_ _03135_ VPWR VGND sg13g2_nand2_1
X_26319_ _03137_ \memory_i.freq_inst.transmit_counter[2]\ _03126_ _03136_ VPWR VGND sg13g2_o21ai_1
X_26320_ _01406_ \memory_i.freq_inst.reset_n\ _03137_ VPWR VGND sg13g2_nand2_1
X_26321_ _03138_ \memory_i.freq_inst.transmit_counter[3]\ _13153_ _13177_ VPWR VGND sg13g2_nand3_1
X_26322_ _03139_ \memory_i.freq_inst.transmit_counter[3]\ _13153_ _03138_ VPWR VGND sg13g2_o21ai_1
X_26323_ _03140_ _03120_ _03139_ VPWR VGND sg13g2_nand2_1
X_26324_ _03141_ \memory_i.freq_inst.transmit_counter[3]\ _03126_ _03140_ VPWR VGND sg13g2_o21ai_1
X_26325_ _01407_ \memory_i.freq_inst.reset_n\ _03141_ VPWR VGND sg13g2_nand2_1
X_26326_ _03142_ \memory_i.freq_inst.transmit_state[2]\ _13175_ _13155_ VPWR VGND sg13g2_a21oi_1
X_26327_ _03143_ _13155_ _03142_ \memory_i.freq_inst.transmit_counter[4]\ VPWR VGND sg13g2_mux2_1
X_26328_ _03144_ _03120_ _03143_ VPWR VGND sg13g2_nand2_1
X_26329_ _03145_ \memory_i.freq_inst.transmit_counter[4]\ _03126_ _03144_ VPWR VGND sg13g2_o21ai_1
X_26330_ _01408_ \memory_i.freq_inst.reset_n\ _03145_ VPWR VGND sg13g2_nand2_1
X_26331_ _03146_ \memory_i.freq_inst.dsmod_cos.i_osr[1]\ \memory_i.freq_inst.dsmod_cos.i_osr[0]\ VPWR VGND sg13g2_nor2_1
X_26332_ _03147_ _03146_ VPWR VGND sg13g2_buf_2
X_26333_ _03148_ \memory_i.freq_inst.transmit_counter[4]\ _13155_ \memory_i.freq_inst.transmit_counter[5]\ VPWR VGND sg13g2_o21ai_1
X_26334_ _03149_ _03120_ _03124_ _03148_ VPWR VGND sg13g2_o21ai_1
X_26335_ _03150_ _13156_ _03126_ _03149_ VPWR VGND sg13g2_a21oi_1
X_26336_ _03151_ _13160_ _03147_ _03150_ VPWR VGND sg13g2_a21oi_1
X_26337_ _03152_ \memory_i.freq_inst.transmit_state[2]\ _03120_ _13177_ VPWR VGND sg13g2_o21ai_1
X_26338_ _03153_ \memory_i.freq_inst.transmit_counter[5]\ _03152_ _02997_ VPWR VGND sg13g2_a21oi_1
X_26339_ _01409_ _03151_ _03153_ VPWR VGND sg13g2_nand2b_1
X_26340_ _03154_ \memory_i.freq_inst.dsmod_cos.i_osr[1]\ VPWR VGND sg13g2_inv_1
X_26341_ _03155_ _03154_ _13160_ VPWR VGND sg13g2_nand2_1
X_26342_ _03156_ \memory_i.freq_inst.transmit_counter[6]\ _03120_ _13156_ VPWR VGND sg13g2_nand3_1
X_26343_ _03157_ _03155_ _03156_ _03152_ VPWR VGND sg13g2_a21oi_1
X_26344_ _03158_ _03120_ _13157_ VPWR VGND sg13g2_nand2_1
X_26345_ _03159_ _03126_ _03158_ \memory_i.freq_inst.transmit_counter[6]\ VPWR VGND sg13g2_a21oi_1
X_26346_ _01410_ _03157_ _03159_ \memory_i.freq_inst.reset_n\ VPWR VGND sg13g2_o21ai_1
X_26347_ _03160_ _13159_ VPWR VGND sg13g2_inv_1
X_26348_ _03161_ \memory_i.freq_inst.transmit_counter[6]\ _13156_ VPWR VGND sg13g2_nand2b_1
X_26349_ _03162_ _03160_ _03126_ _03161_ \memory_i.freq_inst.transmit_counter[7]\ VPWR
+ VGND
+ sg13g2_a22oi_1
X_26350_ _03163_ \memory_i.freq_inst.dsmod_cos.i_osr[1]\ \memory_i.freq_inst.dsmod_cos.i_osr[0]\ VPWR VGND sg13g2_nand2_1
X_26351_ _03164_ _13160_ _03163_ VPWR VGND sg13g2_and2_1
X_26352_ _03165_ \memory_i.freq_inst.transmit_counter[7]\ _03152_ _02997_ VPWR VGND sg13g2_a21oi_1
X_26353_ _01411_ _03162_ _03164_ _03165_ VPWR VGND sg13g2_o21ai_1
X_26354_ _03166_ \memory_i.freq_inst.cordic.strb_data_valid_i\ \memory_i.freq_inst.cordic.rstn_i\ VPWR VGND sg13g2_nand2b_1
X_26355_ _03167_ _03166_ VPWR VGND sg13g2_buf_1
X_26356_ _01412_ \memory_i.freq_inst.cordic.shift_value[0]\ _13181_ _03167_ VPWR VGND sg13g2_a21oi_1
X_26357_ _03168_ \memory_i.freq_inst.cordic.shift_value[1]\ \memory_i.freq_inst.cordic.shift_value[0]\ VPWR VGND sg13g2_nor2_1
X_26358_ _03169_ _03168_ VPWR VGND sg13g2_buf_1
X_26359_ _03170_ \memory_i.freq_inst.cordic.shift_value[1]\ \memory_i.freq_inst.cordic.shift_value[0]\ VPWR VGND sg13g2_nand2_1
X_26360_ _03171_ _03170_ VPWR VGND sg13g2_buf_1
X_26361_ _03172_ \memory_i.freq_inst.cordic.shift_value[2]\ _13171_ _03171_ VPWR VGND sg13g2_a21oi_1
X_26362_ _01413_ _03167_ _03169_ _03172_ VPWR VGND sg13g2_nor3_1
X_26363_ _03173_ \memory_i.freq_inst.cordic.shift_value[1]\ VPWR VGND sg13g2_inv_1
X_26364_ _03174_ _03173_ VPWR VGND sg13g2_buf_2
X_26365_ _03175_ _03174_ VPWR VGND sg13g2_buf_4
X_26366_ _03176_ _03175_ VPWR VGND sg13g2_buf_4
X_26367_ _03177_ _03176_ VPWR VGND sg13g2_buf_2
X_26368_ _03178_ _03177_ VPWR VGND sg13g2_buf_2
X_26369_ _03179_ _03178_ _13168_ VPWR VGND sg13g2_nor2_1
X_26370_ _03180_ \memory_i.freq_inst.cordic.shift_value[2]\ _13170_ _03179_ VPWR VGND sg13g2_nand3_1
X_26371_ _03181_ \memory_i.freq_inst.cordic.shift_value[2]\ _03179_ _03180_ VPWR VGND sg13g2_o21ai_1
X_26372_ _01414_ _03167_ _03181_ VPWR VGND sg13g2_nor2_1
X_26373_ _03182_ \memory_i.freq_inst.cordic.shift_value[3]\ VPWR VGND sg13g2_inv_1
X_26374_ _03183_ _03182_ VPWR VGND sg13g2_buf_2
X_26375_ _03184_ _03183_ VPWR VGND sg13g2_buf_2
X_26376_ _03185_ _03184_ VPWR VGND sg13g2_buf_2
X_26377_ _03186_ _03185_ VPWR VGND sg13g2_buf_2
X_26378_ _03187_ _03186_ VPWR VGND sg13g2_buf_2
X_26379_ _03188_ _03187_ VPWR VGND sg13g2_buf_1
X_26380_ _03189_ _03188_ VPWR VGND sg13g2_buf_1
X_26381_ _03190_ \memory_i.freq_inst.cordic.shift_value[4]\ _03187_ VPWR VGND sg13g2_nor2_1
X_26382_ _03191_ \memory_i.freq_inst.cordic.shift_value[2]\ VPWR VGND sg13g2_inv_1
X_26383_ _03192_ _03191_ VPWR VGND sg13g2_buf_2
X_26384_ _03193_ _03192_ VPWR VGND sg13g2_buf_4
X_26385_ _03194_ _03193_ VPWR VGND sg13g2_buf_4
X_26386_ _03195_ _03194_ VPWR VGND sg13g2_buf_4
X_26387_ _03196_ _03195_ VPWR VGND sg13g2_buf_4
X_26388_ _03197_ _03196_ VPWR VGND sg13g2_buf_2
X_26389_ _03198_ _03197_ _03171_ VPWR VGND sg13g2_nor2_1
X_26390_ _03199_ _03189_ _03190_ _03198_ VPWR VGND sg13g2_mux2_1
X_26391_ _01415_ _03167_ _03199_ VPWR VGND sg13g2_nor2_1
X_26392_ _03200_ \memory_i.freq_inst.cordic.shift_value[3]\ _03198_ \memory_i.freq_inst.cordic.shift_value[4]\ VPWR VGND sg13g2_a21oi_1
X_26393_ _01416_ _03167_ _03200_ VPWR VGND sg13g2_nor2_1
X_26394_ _03201_ \memory_i.freq_inst.cordic.strb_data_valid_i\ \memory_i.cordic_I[0]\ VPWR VGND sg13g2_nand2_1
X_26395_ _03202_ \memory_i.freq_inst.cordic.strb_data_valid_i\ \memory_i.freq_inst.cordic.roc_in_X[0]\ VPWR VGND sg13g2_nand2b_1
X_26396_ _03203_ _15847_ VPWR VGND sg13g2_buf_1
X_26397_ _01417_ _03201_ _03202_ _03203_ VPWR VGND sg13g2_a21oi_1
X_26398_ _03204_ \memory_i.freq_inst.cordic.strb_data_valid_i\ \memory_i.cordic_I[1]\ VPWR VGND sg13g2_nand2_1
X_26399_ _03205_ \memory_i.freq_inst.cordic.strb_data_valid_i\ \memory_i.freq_inst.cordic.roc_in_X[1]\ VPWR VGND sg13g2_nand2b_1
X_26400_ _01418_ _03204_ _03205_ _03203_ VPWR VGND sg13g2_a21oi_1
X_26401_ _03206_ \memory_i.freq_inst.cordic.strb_data_valid_i\ \memory_i.cordic_I[2]\ VPWR VGND sg13g2_nand2_1
X_26402_ _03207_ \memory_i.freq_inst.cordic.strb_data_valid_i\ \memory_i.freq_inst.cordic.roc_in_X[2]\ VPWR VGND sg13g2_nand2b_1
X_26403_ _01419_ _03206_ _03207_ _03203_ VPWR VGND sg13g2_a21oi_1
X_26404_ _03208_ \memory_i.freq_inst.cordic.strb_data_valid_i\ \memory_i.cordic_I[3]\ VPWR VGND sg13g2_nand2_1
X_26405_ _03209_ \memory_i.freq_inst.cordic.strb_data_valid_i\ \memory_i.freq_inst.cordic.roc_in_X[3]\ VPWR VGND sg13g2_nand2b_1
X_26406_ _01420_ _03208_ _03209_ _03203_ VPWR VGND sg13g2_a21oi_1
X_26407_ _03210_ \memory_i.freq_inst.cordic.strb_data_valid_i\ \memory_i.cordic_I[4]\ VPWR VGND sg13g2_nand2_1
X_26408_ _03211_ \memory_i.freq_inst.cordic.strb_data_valid_i\ \memory_i.freq_inst.cordic.roc_in_X[4]\ VPWR VGND sg13g2_nand2b_1
X_26409_ _01421_ _03210_ _03211_ _03203_ VPWR VGND sg13g2_a21oi_1
X_26410_ _03212_ \memory_i.freq_inst.cordic.strb_data_valid_i\ \memory_i.cordic_I[5]\ VPWR VGND sg13g2_nand2_1
X_26411_ _03213_ \memory_i.freq_inst.cordic.strb_data_valid_i\ \memory_i.freq_inst.cordic.roc_in_X[5]\ VPWR VGND sg13g2_nand2b_1
X_26412_ _01422_ _03212_ _03213_ _03203_ VPWR VGND sg13g2_a21oi_1
X_26413_ _03214_ \memory_i.freq_inst.cordic.strb_data_valid_i\ \memory_i.cordic_I[6]\ VPWR VGND sg13g2_nand2_1
X_26414_ _03215_ \memory_i.freq_inst.cordic.strb_data_valid_i\ \memory_i.freq_inst.cordic.roc_in_X[6]\ VPWR VGND sg13g2_nand2b_1
X_26415_ _01423_ _03214_ _03215_ _03203_ VPWR VGND sg13g2_a21oi_1
X_26416_ _03216_ \memory_i.freq_inst.cordic.strb_data_valid_i\ \memory_i.cordic_I[7]\ VPWR VGND sg13g2_nand2_1
X_26417_ _03217_ \memory_i.freq_inst.cordic.strb_data_valid_i\ \memory_i.freq_inst.cordic.roc_in_X[7]\ VPWR VGND sg13g2_nand2b_1
X_26418_ _01424_ _03216_ _03217_ _03203_ VPWR VGND sg13g2_a21oi_1
X_26419_ _03218_ \memory_i.freq_inst.cordic.strb_data_valid_i\ \memory_i.cordic_I[8]\ VPWR VGND sg13g2_nand2_1
X_26420_ _03219_ \memory_i.freq_inst.cordic.strb_data_valid_i\ \memory_i.freq_inst.cordic.roc_in_X[8]\ VPWR VGND sg13g2_nand2b_1
X_26421_ _01425_ _03218_ _03219_ _03203_ VPWR VGND sg13g2_a21oi_1
X_26422_ _03220_ \memory_i.freq_inst.cordic.strb_data_valid_i\ \memory_i.cordic_I[9]\ VPWR VGND sg13g2_nand2_1
X_26423_ _03221_ \memory_i.freq_inst.cordic.strb_data_valid_i\ \memory_i.freq_inst.cordic.roc_in_X[9]\ VPWR VGND sg13g2_nand2b_1
X_26424_ _01426_ _03220_ _03221_ _03203_ VPWR VGND sg13g2_a21oi_1
X_26425_ _03222_ \memory_i.freq_inst.cordic.strb_data_valid_i\ \memory_i.cordic_I[10]\ VPWR VGND sg13g2_nand2_1
X_26426_ _03223_ \memory_i.freq_inst.cordic.strb_data_valid_i\ \memory_i.freq_inst.cordic.roc_in_X[10]\ VPWR VGND sg13g2_nand2b_1
X_26427_ _03224_ _15847_ VPWR VGND sg13g2_buf_1
X_26428_ _01427_ _03222_ _03223_ _03224_ VPWR VGND sg13g2_a21oi_1
X_26429_ _03225_ \memory_i.freq_inst.cordic.strb_data_valid_i\ \memory_i.cordic_I[11]\ VPWR VGND sg13g2_nand2_1
X_26430_ _03226_ \memory_i.freq_inst.cordic.strb_data_valid_i\ \memory_i.freq_inst.cordic.roc_in_X[11]\ VPWR VGND sg13g2_nand2b_1
X_26431_ _01428_ _03225_ _03226_ _03224_ VPWR VGND sg13g2_a21oi_1
X_26432_ _03227_ \memory_i.freq_inst.cordic.strb_data_valid_i\ \memory_i.cordic_I[12]\ VPWR VGND sg13g2_nand2_1
X_26433_ _03228_ \memory_i.freq_inst.cordic.strb_data_valid_i\ \memory_i.freq_inst.cordic.roc_in_X[12]\ VPWR VGND sg13g2_nand2b_1
X_26434_ _01429_ _03227_ _03228_ _03224_ VPWR VGND sg13g2_a21oi_1
X_26435_ _03229_ \memory_i.freq_inst.cordic.strb_data_valid_i\ \memory_i.cordic_I[13]\ VPWR VGND sg13g2_nand2_1
X_26436_ _03230_ \memory_i.freq_inst.cordic.strb_data_valid_i\ \memory_i.freq_inst.cordic.roc_in_X[13]\ VPWR VGND sg13g2_nand2b_1
X_26437_ _01430_ _03229_ _03230_ _03224_ VPWR VGND sg13g2_a21oi_1
X_26438_ _03231_ \memory_i.freq_inst.cordic.strb_data_valid_i\ \memory_i.cordic_I[14]\ VPWR VGND sg13g2_nand2_1
X_26439_ _03232_ \memory_i.freq_inst.cordic.strb_data_valid_i\ \memory_i.freq_inst.cordic.roc_in_X[14]\ VPWR VGND sg13g2_nand2b_1
X_26440_ _01431_ _03231_ _03232_ _03224_ VPWR VGND sg13g2_a21oi_1
X_26441_ _03233_ \memory_i.freq_inst.cordic.strb_data_valid_i\ \memory_i.cordic_I[15]\ VPWR VGND sg13g2_nand2_1
X_26442_ _03234_ \memory_i.freq_inst.cordic.strb_data_valid_i\ \memory_i.freq_inst.cordic.roc_in_X[15]\ VPWR VGND sg13g2_nand2b_1
X_26443_ _01432_ _03233_ _03234_ _03224_ VPWR VGND sg13g2_a21oi_1
X_26444_ _03235_ \memory_i.freq_inst.cordic.strb_data_valid_i\ \memory_i.cordic_I[16]\ VPWR VGND sg13g2_nand2_1
X_26445_ _03236_ \memory_i.freq_inst.cordic.strb_data_valid_i\ \memory_i.freq_inst.cordic.roc_in_X[16]\ VPWR VGND sg13g2_nand2b_1
X_26446_ _01433_ _03235_ _03236_ _03224_ VPWR VGND sg13g2_a21oi_1
X_26447_ _03237_ \memory_i.freq_inst.cordic.strb_data_valid_i\ \memory_i.cordic_I[17]\ VPWR VGND sg13g2_nand2_1
X_26448_ _03238_ \memory_i.freq_inst.cordic.strb_data_valid_i\ \memory_i.freq_inst.cordic.roc_in_X[17]\ VPWR VGND sg13g2_nand2b_1
X_26449_ _01434_ _03237_ _03238_ _03224_ VPWR VGND sg13g2_a21oi_1
X_26450_ _03239_ \memory_i.freq_inst.cordic.strb_data_valid_i\ \memory_i.cordic_I[18]\ VPWR VGND sg13g2_nand2_1
X_26451_ _03240_ \memory_i.freq_inst.cordic.strb_data_valid_i\ \memory_i.freq_inst.cordic.roc_in_X[18]\ VPWR VGND sg13g2_nand2b_1
X_26452_ _01435_ _03239_ _03240_ _03224_ VPWR VGND sg13g2_a21oi_1
X_26453_ _03241_ \memory_i.freq_inst.cordic.strb_data_valid_i\ \memory_i.cordic_I[19]\ VPWR VGND sg13g2_nand2_1
X_26454_ _03242_ \memory_i.freq_inst.cordic.strb_data_valid_i\ \memory_i.freq_inst.cordic.roc_in_X[19]\ VPWR VGND sg13g2_nand2b_1
X_26455_ _01436_ _03241_ _03242_ _03224_ VPWR VGND sg13g2_a21oi_1
X_26456_ _03243_ \memory_i.freq_inst.cordic.strb_data_valid_i\ \memory_i.cordic_I[20]\ VPWR VGND sg13g2_nand2_1
X_26457_ _03244_ \memory_i.freq_inst.cordic.strb_data_valid_i\ \memory_i.freq_inst.cordic.roc_in_X[20]\ VPWR VGND sg13g2_nand2b_1
X_26458_ _03245_ _12944_ VPWR VGND sg13g2_buf_1
X_26459_ _03246_ _03245_ VPWR VGND sg13g2_buf_1
X_26460_ _01437_ _03243_ _03244_ _03246_ VPWR VGND sg13g2_a21oi_1
X_26461_ _03247_ \memory_i.freq_inst.cordic.strb_data_valid_i\ \memory_i.cordic_I[21]\ VPWR VGND sg13g2_nand2_1
X_26462_ _03248_ \memory_i.freq_inst.cordic.strb_data_valid_i\ \memory_i.freq_inst.cordic.roc_in_X[21]\ VPWR VGND sg13g2_nand2b_1
X_26463_ _01438_ _03247_ _03248_ _03246_ VPWR VGND sg13g2_a21oi_1
X_26464_ _03249_ \memory_i.freq_inst.cordic.strb_data_valid_i\ \memory_i.cordic_I[22]\ VPWR VGND sg13g2_nand2_1
X_26465_ _03250_ \memory_i.freq_inst.cordic.strb_data_valid_i\ \memory_i.freq_inst.cordic.roc_in_X[22]\ VPWR VGND sg13g2_nand2b_1
X_26466_ _01439_ _03249_ _03250_ _03246_ VPWR VGND sg13g2_a21oi_1
X_26467_ _03251_ \memory_i.freq_inst.cordic.strb_data_valid_i\ \memory_i.cordic_I[23]\ VPWR VGND sg13g2_nand2_1
X_26468_ _03252_ \memory_i.freq_inst.cordic.strb_data_valid_i\ \memory_i.freq_inst.cordic.roc_in_X[23]\ VPWR VGND sg13g2_nand2b_1
X_26469_ _01440_ _03251_ _03252_ _03246_ VPWR VGND sg13g2_a21oi_1
X_26470_ _03253_ \memory_i.freq_inst.cordic.strb_data_valid_i\ \memory_i.cordic_I[24]\ VPWR VGND sg13g2_nand2_1
X_26471_ _03254_ \memory_i.freq_inst.cordic.strb_data_valid_i\ \memory_i.freq_inst.cordic.roc_in_X[24]\ VPWR VGND sg13g2_nand2b_1
X_26472_ _01441_ _03253_ _03254_ _03246_ VPWR VGND sg13g2_a21oi_1
X_26473_ _03255_ \memory_i.freq_inst.cordic.strb_data_valid_i\ \memory_i.cordic_I[25]\ VPWR VGND sg13g2_nand2_1
X_26474_ _03256_ \memory_i.freq_inst.cordic.strb_data_valid_i\ \memory_i.freq_inst.cordic.roc_in_X[25]\ VPWR VGND sg13g2_nand2b_1
X_26475_ _01442_ _03255_ _03256_ _03246_ VPWR VGND sg13g2_a21oi_1
X_26476_ _03257_ \memory_i.freq_inst.cordic.strb_data_valid_i\ \memory_i.cordic_I[26]\ VPWR VGND sg13g2_nand2_1
X_26477_ _03258_ \memory_i.freq_inst.cordic.strb_data_valid_i\ \memory_i.freq_inst.cordic.roc_in_X[26]\ VPWR VGND sg13g2_nand2b_1
X_26478_ _01443_ _03257_ _03258_ _03246_ VPWR VGND sg13g2_a21oi_1
X_26479_ _03259_ \memory_i.freq_inst.cordic.strb_data_valid_i\ \memory_i.cordic_I[27]\ VPWR VGND sg13g2_nand2_1
X_26480_ _03260_ \memory_i.freq_inst.cordic.strb_data_valid_i\ \memory_i.freq_inst.cordic.roc_in_X[27]\ VPWR VGND sg13g2_nand2b_1
X_26481_ _01444_ _03259_ _03260_ _03246_ VPWR VGND sg13g2_a21oi_1
X_26482_ _03261_ \memory_i.freq_inst.cordic.strb_data_valid_i\ \memory_i.cordic_I[28]\ VPWR VGND sg13g2_nand2_1
X_26483_ _03262_ \memory_i.freq_inst.cordic.strb_data_valid_i\ \memory_i.freq_inst.cordic.roc_in_X[28]\ VPWR VGND sg13g2_nand2b_1
X_26484_ _01445_ _03261_ _03262_ _03246_ VPWR VGND sg13g2_a21oi_1
X_26485_ _03263_ \memory_i.freq_inst.cordic.strb_data_valid_i\ \memory_i.cordic_I[29]\ VPWR VGND sg13g2_nand2_1
X_26486_ _03264_ \memory_i.freq_inst.cordic.strb_data_valid_i\ \memory_i.freq_inst.cordic.roc_in_X[29]\ VPWR VGND sg13g2_nand2b_1
X_26487_ _01446_ _03263_ _03264_ _03246_ VPWR VGND sg13g2_a21oi_1
X_26488_ _03265_ \memory_i.freq_inst.cordic.strb_data_valid_i\ \memory_i.freq_inst.cordic.Z_i[0]\ VPWR VGND sg13g2_nand2_1
X_26489_ _03266_ \memory_i.freq_inst.cordic.strb_data_valid_i\ \memory_i.freq_inst.cordic.roc_in_Z[0]\ VPWR VGND sg13g2_nand2b_1
X_26490_ _03267_ _03245_ VPWR VGND sg13g2_buf_1
X_26491_ _01447_ _03265_ _03266_ _03267_ VPWR VGND sg13g2_a21oi_1
X_26492_ _03268_ \memory_i.freq_inst.cordic.strb_data_valid_i\ \memory_i.freq_inst.cordic.Z_i[1]\ VPWR VGND sg13g2_nand2_1
X_26493_ _03269_ \memory_i.freq_inst.cordic.strb_data_valid_i\ \memory_i.freq_inst.cordic.roc_in_Z[1]\ VPWR VGND sg13g2_nand2b_1
X_26494_ _01448_ _03268_ _03269_ _03267_ VPWR VGND sg13g2_a21oi_1
X_26495_ _03270_ \memory_i.freq_inst.cordic.strb_data_valid_i\ \memory_i.freq_inst.cordic.Z_i[2]\ VPWR VGND sg13g2_nand2_1
X_26496_ _03271_ \memory_i.freq_inst.cordic.strb_data_valid_i\ \memory_i.freq_inst.cordic.roc_in_Z[2]\ VPWR VGND sg13g2_nand2b_1
X_26497_ _01449_ _03270_ _03271_ _03267_ VPWR VGND sg13g2_a21oi_1
X_26498_ _03272_ \memory_i.freq_inst.cordic.strb_data_valid_i\ \memory_i.freq_inst.cordic.Z_i[3]\ VPWR VGND sg13g2_nand2_1
X_26499_ _03273_ \memory_i.freq_inst.cordic.strb_data_valid_i\ \memory_i.freq_inst.cordic.roc_in_Z[3]\ VPWR VGND sg13g2_nand2b_1
X_26500_ _01450_ _03272_ _03273_ _03267_ VPWR VGND sg13g2_a21oi_1
X_26501_ _03274_ \memory_i.freq_inst.cordic.strb_data_valid_i\ \memory_i.freq_inst.cordic.Z_i[4]\ VPWR VGND sg13g2_nand2_1
X_26502_ _03275_ \memory_i.freq_inst.cordic.strb_data_valid_i\ \memory_i.freq_inst.cordic.roc_in_Z[4]\ VPWR VGND sg13g2_nand2b_1
X_26503_ _01451_ _03274_ _03275_ _03267_ VPWR VGND sg13g2_a21oi_1
X_26504_ _03276_ \memory_i.freq_inst.cordic.strb_data_valid_i\ \memory_i.freq_inst.cordic.Z_i[5]\ VPWR VGND sg13g2_nand2_1
X_26505_ _03277_ \memory_i.freq_inst.cordic.strb_data_valid_i\ \memory_i.freq_inst.cordic.roc_in_Z[5]\ VPWR VGND sg13g2_nand2b_1
X_26506_ _01452_ _03276_ _03277_ _03267_ VPWR VGND sg13g2_a21oi_1
X_26507_ _03278_ \memory_i.freq_inst.cordic.strb_data_valid_i\ \memory_i.freq_inst.cordic.Z_i[6]\ VPWR VGND sg13g2_nand2_1
X_26508_ _03279_ \memory_i.freq_inst.cordic.strb_data_valid_i\ \memory_i.freq_inst.cordic.roc_in_Z[6]\ VPWR VGND sg13g2_nand2b_1
X_26509_ _01453_ _03278_ _03279_ _03267_ VPWR VGND sg13g2_a21oi_1
X_26510_ _03280_ \memory_i.freq_inst.cordic.strb_data_valid_i\ \memory_i.freq_inst.cordic.Z_i[7]\ VPWR VGND sg13g2_nand2_1
X_26511_ _03281_ \memory_i.freq_inst.cordic.strb_data_valid_i\ \memory_i.freq_inst.cordic.roc_in_Z[7]\ VPWR VGND sg13g2_nand2b_1
X_26512_ _01454_ _03280_ _03281_ _03267_ VPWR VGND sg13g2_a21oi_1
X_26513_ _03282_ \memory_i.freq_inst.cordic.strb_data_valid_i\ \memory_i.freq_inst.cordic.Z_i[8]\ VPWR VGND sg13g2_nand2_1
X_26514_ _03283_ \memory_i.freq_inst.cordic.strb_data_valid_i\ \memory_i.freq_inst.cordic.roc_in_Z[8]\ VPWR VGND sg13g2_nand2b_1
X_26515_ _01455_ _03282_ _03283_ _03267_ VPWR VGND sg13g2_a21oi_1
X_26516_ _03284_ \memory_i.freq_inst.cordic.strb_data_valid_i\ \memory_i.freq_inst.cordic.Z_i[9]\ VPWR VGND sg13g2_nand2_1
X_26517_ _03285_ \memory_i.freq_inst.cordic.strb_data_valid_i\ \memory_i.freq_inst.cordic.roc_in_Z[9]\ VPWR VGND sg13g2_nand2b_1
X_26518_ _01456_ _03284_ _03285_ _03267_ VPWR VGND sg13g2_a21oi_1
X_26519_ _03286_ \memory_i.freq_inst.cordic.strb_data_valid_i\ \memory_i.freq_inst.cordic.Z_i[10]\ VPWR VGND sg13g2_nand2_1
X_26520_ _03287_ \memory_i.freq_inst.cordic.strb_data_valid_i\ \memory_i.freq_inst.cordic.roc_in_Z[10]\ VPWR VGND sg13g2_nand2b_1
X_26521_ _03288_ _03245_ VPWR VGND sg13g2_buf_1
X_26522_ _01457_ _03286_ _03287_ _03288_ VPWR VGND sg13g2_a21oi_1
X_26523_ _03289_ \memory_i.freq_inst.cordic.strb_data_valid_i\ \memory_i.freq_inst.cordic.Z_i[11]\ VPWR VGND sg13g2_nand2_1
X_26524_ _03290_ \memory_i.freq_inst.cordic.strb_data_valid_i\ \memory_i.freq_inst.cordic.roc_in_Z[11]\ VPWR VGND sg13g2_nand2b_1
X_26525_ _01458_ _03289_ _03290_ _03288_ VPWR VGND sg13g2_a21oi_1
X_26526_ _03291_ \memory_i.freq_inst.cordic.strb_data_valid_i\ \memory_i.freq_inst.cordic.Z_i[12]\ VPWR VGND sg13g2_nand2_1
X_26527_ _03292_ \memory_i.freq_inst.cordic.strb_data_valid_i\ \memory_i.freq_inst.cordic.roc_in_Z[12]\ VPWR VGND sg13g2_nand2b_1
X_26528_ _01459_ _03291_ _03292_ _03288_ VPWR VGND sg13g2_a21oi_1
X_26529_ _03293_ \memory_i.freq_inst.cordic.strb_data_valid_i\ \memory_i.freq_inst.cordic.Z_i[13]\ VPWR VGND sg13g2_nand2_1
X_26530_ _03294_ \memory_i.freq_inst.cordic.strb_data_valid_i\ \memory_i.freq_inst.cordic.roc_in_Z[13]\ VPWR VGND sg13g2_nand2b_1
X_26531_ _01460_ _03293_ _03294_ _03288_ VPWR VGND sg13g2_a21oi_1
X_26532_ _03295_ \memory_i.freq_inst.cordic.strb_data_valid_i\ \memory_i.freq_inst.cordic.Z_i[14]\ VPWR VGND sg13g2_nand2_1
X_26533_ _03296_ \memory_i.freq_inst.cordic.strb_data_valid_i\ \memory_i.freq_inst.cordic.roc_in_Z[14]\ VPWR VGND sg13g2_nand2b_1
X_26534_ _01461_ _03295_ _03296_ _03288_ VPWR VGND sg13g2_a21oi_1
X_26535_ _03297_ \memory_i.freq_inst.cordic.strb_data_valid_i\ \memory_i.freq_inst.cordic.Z_i[15]\ VPWR VGND sg13g2_nand2_1
X_26536_ _03298_ \memory_i.freq_inst.cordic.strb_data_valid_i\ \memory_i.freq_inst.cordic.roc_in_Z[15]\ VPWR VGND sg13g2_nand2b_1
X_26537_ _01462_ _03297_ _03298_ _03288_ VPWR VGND sg13g2_a21oi_1
X_26538_ _03299_ \memory_i.freq_inst.cordic.strb_data_valid_i\ \memory_i.freq_inst.cordic.Z_i[16]\ VPWR VGND sg13g2_nand2_1
X_26539_ _03300_ \memory_i.freq_inst.cordic.strb_data_valid_i\ \memory_i.freq_inst.cordic.roc_in_Z[16]\ VPWR VGND sg13g2_nand2b_1
X_26540_ _01463_ _03299_ _03300_ _03288_ VPWR VGND sg13g2_a21oi_1
X_26541_ _03301_ \memory_i.freq_inst.cordic.strb_data_valid_i\ \memory_i.freq_inst.cordic.Z_i[17]\ VPWR VGND sg13g2_nand2_1
X_26542_ _03302_ \memory_i.freq_inst.cordic.strb_data_valid_i\ \memory_i.freq_inst.cordic.roc_in_Z[17]\ VPWR VGND sg13g2_nand2b_1
X_26543_ _01464_ _03301_ _03302_ _03288_ VPWR VGND sg13g2_a21oi_1
X_26544_ _03303_ \memory_i.freq_inst.cordic.strb_data_valid_i\ \memory_i.freq_inst.cordic.Z_i[18]\ VPWR VGND sg13g2_nand2_1
X_26545_ _03304_ \memory_i.freq_inst.cordic.strb_data_valid_i\ \memory_i.freq_inst.cordic.roc_in_Z[18]\ VPWR VGND sg13g2_nand2b_1
X_26546_ _01465_ _03303_ _03304_ _03288_ VPWR VGND sg13g2_a21oi_1
X_26547_ _03305_ \memory_i.freq_inst.cordic.strb_data_valid_i\ \memory_i.freq_inst.cordic.Z_i[19]\ VPWR VGND sg13g2_nand2_1
X_26548_ _03306_ \memory_i.freq_inst.cordic.strb_data_valid_i\ \memory_i.freq_inst.cordic.roc_in_Z[19]\ VPWR VGND sg13g2_nand2b_1
X_26549_ _01466_ _03305_ _03306_ _03288_ VPWR VGND sg13g2_a21oi_1
X_26550_ _03307_ \memory_i.freq_inst.cordic.strb_data_valid_i\ \memory_i.freq_inst.cordic.Z_i[20]\ VPWR VGND sg13g2_nand2_1
X_26551_ _03308_ \memory_i.freq_inst.cordic.strb_data_valid_i\ \memory_i.freq_inst.cordic.roc_in_Z[20]\ VPWR VGND sg13g2_nand2b_1
X_26552_ _03309_ _03245_ VPWR VGND sg13g2_buf_1
X_26553_ _01467_ _03307_ _03308_ _03309_ VPWR VGND sg13g2_a21oi_1
X_26554_ _03310_ \memory_i.freq_inst.cordic.strb_data_valid_i\ \memory_i.freq_inst.cordic.Z_i[21]\ VPWR VGND sg13g2_nand2_1
X_26555_ _03311_ \memory_i.freq_inst.cordic.strb_data_valid_i\ \memory_i.freq_inst.cordic.roc_in_Z[21]\ VPWR VGND sg13g2_nand2b_1
X_26556_ _01468_ _03310_ _03311_ _03309_ VPWR VGND sg13g2_a21oi_1
X_26557_ _03312_ \memory_i.freq_inst.cordic.strb_data_valid_i\ \memory_i.freq_inst.cordic.Z_i[22]\ VPWR VGND sg13g2_nand2_1
X_26558_ _03313_ \memory_i.freq_inst.cordic.strb_data_valid_i\ \memory_i.freq_inst.cordic.roc_in_Z[22]\ VPWR VGND sg13g2_nand2b_1
X_26559_ _01469_ _03312_ _03313_ _03309_ VPWR VGND sg13g2_a21oi_1
X_26560_ _03314_ \memory_i.freq_inst.cordic.strb_data_valid_i\ \memory_i.freq_inst.cordic.Z_i[23]\ VPWR VGND sg13g2_nand2_1
X_26561_ _03315_ \memory_i.freq_inst.cordic.strb_data_valid_i\ \memory_i.freq_inst.cordic.roc_in_Z[23]\ VPWR VGND sg13g2_nand2b_1
X_26562_ _01470_ _03314_ _03315_ _03309_ VPWR VGND sg13g2_a21oi_1
X_26563_ _03316_ \memory_i.freq_inst.cordic.strb_data_valid_i\ \memory_i.freq_inst.cordic.Z_i[24]\ VPWR VGND sg13g2_nand2_1
X_26564_ _03317_ \memory_i.freq_inst.cordic.strb_data_valid_i\ \memory_i.freq_inst.cordic.roc_in_Z[24]\ VPWR VGND sg13g2_nand2b_1
X_26565_ _01471_ _03316_ _03317_ _03309_ VPWR VGND sg13g2_a21oi_1
X_26566_ _03318_ \memory_i.freq_inst.cordic.strb_data_valid_i\ \memory_i.freq_inst.cordic.Z_i[25]\ VPWR VGND sg13g2_nand2_1
X_26567_ _03319_ \memory_i.freq_inst.cordic.strb_data_valid_i\ \memory_i.freq_inst.cordic.roc_in_Z[25]\ VPWR VGND sg13g2_nand2b_1
X_26568_ _01472_ _03318_ _03319_ _03309_ VPWR VGND sg13g2_a21oi_1
X_26569_ _03320_ \memory_i.freq_inst.cordic.strb_data_valid_i\ \memory_i.freq_inst.cordic.Z_i[26]\ VPWR VGND sg13g2_nand2_1
X_26570_ _03321_ \memory_i.freq_inst.cordic.strb_data_valid_i\ \memory_i.freq_inst.cordic.roc_in_Z[26]\ VPWR VGND sg13g2_nand2b_1
X_26571_ _01473_ _03320_ _03321_ _03309_ VPWR VGND sg13g2_a21oi_1
X_26572_ _03322_ \memory_i.freq_inst.cordic.strb_data_valid_i\ \memory_i.freq_inst.cordic.Z_i[27]\ VPWR VGND sg13g2_nand2_1
X_26573_ _03323_ \memory_i.freq_inst.cordic.strb_data_valid_i\ \memory_i.freq_inst.cordic.roc_in_Z[27]\ VPWR VGND sg13g2_nand2b_1
X_26574_ _01474_ _03322_ _03323_ _03309_ VPWR VGND sg13g2_a21oi_1
X_26575_ _03324_ \memory_i.freq_inst.cordic.strb_data_valid_i\ \memory_i.freq_inst.cordic.Z_i[28]\ VPWR VGND sg13g2_nand2_1
X_26576_ _03325_ \memory_i.freq_inst.cordic.strb_data_valid_i\ \memory_i.freq_inst.cordic.roc_in_Z[28]\ VPWR VGND sg13g2_nand2b_1
X_26577_ _01475_ _03324_ _03325_ _03309_ VPWR VGND sg13g2_a21oi_1
X_26578_ _03326_ \memory_i.freq_inst.cordic.Z_i[29]\ \memory_i.freq_inst.cordic.strb_data_valid_i\ VPWR VGND sg13g2_nand2_1
X_26579_ _03327_ \memory_i.freq_inst.cordic.strb_data_valid_i\ \memory_i.freq_inst.cordic.roc_in_Z[29]\ VPWR VGND sg13g2_nand2b_1
X_26580_ _01476_ _03326_ _03327_ _03309_ VPWR VGND sg13g2_a21oi_1
X_26581_ _03328_ _12945_ VPWR VGND sg13g2_buf_1
X_26582_ _03329_ _03328_ VPWR VGND sg13g2_buf_1
X_26583_ _03330_ \memory_i.freq_inst.cordic.shift_value[4]\ VPWR VGND sg13g2_inv_1
X_26584_ _03331_ \memory_i.freq_inst.cordic.shift_value[2]\ \memory_i.freq_inst.cordic.shift_value[1]\ \memory_i.freq_inst.cordic.shift_value[0]\ VPWR VGND sg13g2_nor3_2
X_26585_ _03332_ \memory_i.freq_inst.cordic.shift_value[2]\ \memory_i.freq_inst.cordic.shift_value[0]\ VPWR VGND sg13g2_and2_1
X_26586_ _03333_ _03332_ VPWR VGND sg13g2_buf_1
X_26587_ _03334_ _03331_ _03333_ \memory_i.freq_inst.cordic.shift_value[3]\ VPWR VGND sg13g2_o21ai_1
X_26588_ _03335_ \memory_i.freq_inst.cordic.shift_value[1]\ \memory_i.freq_inst.cordic.shift_value[0]\ VPWR VGND sg13g2_or2_1
X_26589_ _03336_ _03335_ VPWR VGND sg13g2_buf_1
X_26590_ _03337_ _03182_ _03192_ _03336_ VPWR VGND sg13g2_nand3_1
X_26591_ _03338_ _03330_ _03171_ _03334_ _03337_ VPWR
+ VGND
+ sg13g2_nand4_1
X_26592_ _03339_ \memory_i.freq_inst.cordic.shift_value[1]\ \memory_i.freq_inst.cordic.shift_value[0]\ \memory_i.freq_inst.cordic.shift_value[3]\ VPWR VGND sg13g2_a21oi_1
X_26593_ _03340_ _03169_ _03339_ \memory_i.freq_inst.cordic.shift_value[2]\ VPWR VGND sg13g2_o21ai_1
X_26594_ _03341_ \memory_i.freq_inst.cordic.shift_value[3]\ _03193_ _03336_ VPWR VGND sg13g2_nand3_1
X_26595_ _03342_ \memory_i.freq_inst.cordic.shift_value[4]\ _03340_ _03341_ VPWR VGND sg13g2_nand3_1
X_26596_ _03343_ _03182_ \memory_i.freq_inst.cordic.shift_value[2]\ VPWR VGND sg13g2_nand2_1
X_26597_ _03344_ _03336_ _03343_ VPWR VGND sg13g2_nor2_1
X_26598_ _03345_ _03338_ _03342_ _03344_ VPWR VGND sg13g2_a21oi_1
X_26599_ _03346_ \memory_i.freq_inst.cordic.shift_value[4]\ \memory_i.freq_inst.cordic.shift_value[3]\ VPWR VGND sg13g2_nor2_1
X_26600_ _03347_ _03346_ VPWR VGND sg13g2_buf_4
X_26601_ _03348_ _03331_ _03347_ VPWR VGND sg13g2_nand2_1
X_26602_ _03349_ _03348_ VPWR VGND sg13g2_buf_4
X_26603_ _03350_ _03349_ VPWR VGND sg13g2_buf_4
X_26604_ _03351_ _03350_ VPWR VGND sg13g2_buf_4
X_26605_ _03352_ _03351_ VPWR VGND sg13g2_buf_4
X_26606_ _03353_ _03352_ VPWR VGND sg13g2_buf_4
X_26607_ _03354_ \memory_i.freq_inst.cordic.roc_in_Z[0]\ \memory_i.freq_inst.Z_o[0]\ _03353_ VPWR VGND sg13g2_mux2_1
X_26608_ _03355_ _03345_ _03354_ VPWR VGND sg13g2_xor2_1
X_26609_ _01477_ _03329_ _03355_ VPWR VGND sg13g2_nor2_1
X_26610_ _03356_ _13165_ VPWR VGND sg13g2_buf_2
X_26611_ _03357_ \memory_i.freq_inst.cordic.roc_in_Z[29]\ _03331_ _03347_ VPWR VGND sg13g2_nand3_1
X_26612_ _03358_ _03357_ VPWR VGND sg13g2_buf_1
X_26613_ _03359_ \memory_i.freq_inst.cordic.shift_value[2]\ \memory_i.freq_inst.cordic.shift_value[1]\ \memory_i.freq_inst.cordic.shift_value[0]\ VPWR VGND sg13g2_or3_1
X_26614_ _03360_ _03359_ VPWR VGND sg13g2_buf_2
X_26615_ _03361_ \memory_i.freq_inst.cordic.shift_value[4]\ \memory_i.freq_inst.cordic.shift_value[3]\ VPWR VGND sg13g2_or2_1
X_26616_ _03362_ _03361_ VPWR VGND sg13g2_buf_2
X_26617_ _03363_ _03360_ _03362_ \memory_i.freq_inst.Z_o[29]\ VPWR VGND sg13g2_o21ai_1
X_26618_ _03364_ _03363_ VPWR VGND sg13g2_buf_1
X_26619_ _03365_ _03356_ _03358_ _03364_ VPWR VGND sg13g2_and3_1
X_26620_ _03366_ _03365_ VPWR VGND sg13g2_buf_1
X_26621_ _03367_ \memory_i.freq_inst.cordic.shift_value[1]\ \memory_i.freq_inst.Z_o[29]\ \memory_i.freq_inst.cordic.shift_value[0]\ VPWR VGND sg13g2_o21ai_1
X_26622_ _03368_ _03177_ _03366_ _03367_ \memory_i.freq_inst.cordic.shift_value[3]\ VPWR
+ VGND
+ sg13g2_a22oi_1
X_26623_ _03369_ _03368_ \memory_i.freq_inst.cordic.shift_value[2]\ VPWR VGND sg13g2_nand2b_1
X_26624_ _03370_ \memory_i.freq_inst.cordic.shift_value[3]\ _13166_ VPWR VGND sg13g2_nor2_1
X_26625_ _03371_ _03370_ VPWR VGND sg13g2_buf_1
X_26626_ _03372_ \memory_i.freq_inst.cordic.shift_value[2]\ \memory_i.freq_inst.cordic.shift_value[1]\ VPWR VGND sg13g2_nor2_1
X_26627_ _03373_ _03372_ VPWR VGND sg13g2_buf_1
X_26628_ _03374_ _03358_ _03364_ VPWR VGND sg13g2_nand2_1
X_26629_ _03375_ \memory_i.freq_inst.cordic.shift_value[1]\ _03373_ _03374_ VPWR VGND sg13g2_mux2_1
X_26630_ _03376_ _03358_ _03364_ \memory_i.freq_inst.cordic.shift_value[0]\ VPWR VGND sg13g2_a21oi_1
X_26631_ _03377_ _03356_ \memory_i.freq_inst.Z_o[29]\ VPWR VGND sg13g2_nor2_1
X_26632_ _03378_ _03183_ _03377_ VPWR VGND sg13g2_nor2_1
X_26633_ _03379_ _03194_ _03376_ _03378_ VPWR VGND sg13g2_a21o_1
X_26634_ _03380_ _03371_ _03375_ _03379_ \memory_i.freq_inst.cordic.shift_value[1]\ VPWR
+ VGND
+ sg13g2_a22oi_1
X_26635_ _03381_ _03369_ _03380_ \memory_i.freq_inst.cordic.shift_value[4]\ VPWR VGND sg13g2_a21oi_1
X_26636_ _03382_ _03184_ \memory_i.freq_inst.cordic.shift_value[1]\ VPWR VGND sg13g2_nor2_1
X_26637_ _03383_ \memory_i.freq_inst.cordic.shift_value[2]\ _03176_ VPWR VGND sg13g2_nand2_1
X_26638_ _03384_ \memory_i.freq_inst.cordic.shift_value[3]\ _03192_ VPWR VGND sg13g2_nand2_1
X_26639_ _03385_ _03384_ VPWR VGND sg13g2_buf_1
X_26640_ _03386_ \memory_i.freq_inst.cordic.shift_value[3]\ _03383_ _03385_ VPWR VGND sg13g2_o21ai_1
X_26641_ _03387_ _03377_ _03376_ _03386_ VPWR VGND sg13g2_o21ai_1
X_26642_ _03388_ _03192_ VPWR VGND sg13g2_buf_1
X_26643_ _03389_ _03388_ \memory_i.freq_inst.cordic.shift_value[0]\ \memory_i.freq_inst.Z_o[29]\ VPWR VGND sg13g2_nor3_1
X_26644_ _03390_ \memory_i.freq_inst.cordic.shift_value[2]\ _03356_ VPWR VGND sg13g2_nor2_1
X_26645_ _03391_ _03390_ VPWR VGND sg13g2_buf_1
X_26646_ _03392_ \memory_i.freq_inst.cordic.shift_value[3]\ _03177_ VPWR VGND sg13g2_nor2_1
X_26647_ _03393_ _03389_ _03391_ _03392_ VPWR VGND sg13g2_o21ai_1
X_26648_ _03394_ _03330_ VPWR VGND sg13g2_buf_2
X_26649_ _03395_ _03394_ VPWR VGND sg13g2_buf_2
X_26650_ _03396_ _03387_ _03393_ _03395_ VPWR VGND sg13g2_a21oi_1
X_26651_ _03397_ _03366_ _03382_ _03396_ VPWR VGND sg13g2_a21o_1
X_26652_ _03398_ _03381_ _03397_ VPWR VGND sg13g2_or2_1
X_26653_ _03399_ \memory_i.freq_inst.cordic.roc_in_Z[1]\ \memory_i.freq_inst.Z_o[1]\ _03353_ VPWR VGND sg13g2_mux2_1
X_26654_ _03400_ _03345_ _03354_ VPWR VGND sg13g2_nand2b_1
X_26655_ _03401_ _03399_ _03400_ VPWR VGND sg13g2_nor2b_1
X_26656_ _03402_ _03400_ _03399_ VPWR VGND sg13g2_nor2b_1
X_26657_ _03403_ _03401_ _03402_ VPWR VGND sg13g2_nor2_1
X_26658_ _03404_ _03398_ _03403_ VPWR VGND sg13g2_xnor2_1
X_26659_ _01478_ _03329_ _03404_ VPWR VGND sg13g2_nor2_1
X_26660_ _03405_ _03381_ _03397_ _03402_ VPWR VGND sg13g2_nor3_1
X_26661_ _03406_ \memory_i.freq_inst.cordic.roc_in_Z[2]\ \memory_i.freq_inst.Z_o[2]\ _03353_ VPWR VGND sg13g2_mux2_1
X_26662_ _03407_ _03176_ \memory_i.freq_inst.cordic.shift_value[0]\ VPWR VGND sg13g2_nand2_1
X_26663_ _03408_ \memory_i.freq_inst.cordic.shift_value[4]\ \memory_i.freq_inst.cordic.shift_value[0]\ VPWR VGND sg13g2_nor2b_1
X_26664_ _03409_ \memory_i.freq_inst.cordic.shift_value[4]\ _03407_ _03408_ VPWR VGND sg13g2_a21o_1
X_26665_ _03410_ _03358_ _03364_ VPWR VGND sg13g2_and2_1
X_26666_ _03411_ _03410_ VPWR VGND sg13g2_buf_2
X_26667_ _03412_ _03394_ _03376_ _03409_ _03411_ VPWR
+ VGND
+ sg13g2_a22oi_1
X_26668_ _03413_ _03374_ VPWR VGND sg13g2_buf_1
X_26669_ _03414_ _03388_ _03169_ VPWR VGND sg13g2_nor2_1
X_26670_ _03415_ _03394_ _03413_ _03414_ VPWR VGND sg13g2_nand3_1
X_26671_ _03416_ \memory_i.freq_inst.cordic.shift_value[2]\ _03412_ _03415_ VPWR VGND sg13g2_o21ai_1
X_26672_ _03417_ \memory_i.freq_inst.cordic.shift_value[1]\ _03408_ _03388_ VPWR VGND sg13g2_o21ai_1
X_26673_ _03418_ _03171_ _03417_ VPWR VGND sg13g2_nand2_1
X_26674_ _03419_ \memory_i.freq_inst.cordic.shift_value[2]\ \memory_i.freq_inst.cordic.shift_value[1]\ VPWR VGND sg13g2_nor2b_1
X_26675_ _03420_ _03419_ VPWR VGND sg13g2_buf_1
X_26676_ _03421_ _03356_ _03420_ VPWR VGND sg13g2_nand2_1
X_26677_ _03422_ _03194_ \memory_i.freq_inst.Z_o[29]\ _03421_ VPWR VGND sg13g2_o21ai_1
X_26678_ _03423_ _03413_ _03418_ _03422_ \memory_i.freq_inst.cordic.shift_value[4]\ VPWR
+ VGND
+ sg13g2_a22oi_1
X_26679_ _03424_ _03356_ VPWR VGND sg13g2_buf_2
X_26680_ _03425_ \memory_i.freq_inst.Z_o[29]\ VPWR VGND sg13g2_inv_1
X_26681_ _03426_ _03424_ _03425_ _03385_ VPWR VGND sg13g2_nor3_1
X_26682_ _03427_ _03389_ _03426_ _03178_ VPWR VGND sg13g2_o21ai_1
X_26683_ _03428_ \memory_i.freq_inst.cordic.shift_value[3]\ _03423_ _03427_ VPWR VGND sg13g2_o21ai_1
X_26684_ _03429_ \memory_i.freq_inst.cordic.shift_value[3]\ _03416_ _03428_ VPWR VGND sg13g2_a21o_1
X_26685_ _03430_ _03429_ VPWR VGND sg13g2_buf_1
X_26686_ _03431_ _03406_ _03430_ VPWR VGND sg13g2_nor2_1
X_26687_ _03432_ _03406_ _03430_ VPWR VGND sg13g2_and2_1
X_26688_ _03433_ _03431_ _03432_ VPWR VGND sg13g2_nor2_1
X_26689_ _03434_ _03401_ _03405_ _03433_ VPWR VGND sg13g2_or3_1
X_26690_ _03435_ _03401_ _03405_ _03433_ VPWR VGND sg13g2_o21ai_1
X_26691_ _03436_ _03245_ VPWR VGND sg13g2_buf_1
X_26692_ _01479_ _03434_ _03435_ _03436_ VPWR VGND sg13g2_a21oi_1
X_26693_ _03437_ _03401_ _03405_ _03431_ VPWR VGND sg13g2_nor3_1
X_26694_ _03438_ _03432_ _03437_ VPWR VGND sg13g2_nor2_1
X_26695_ _03439_ \memory_i.freq_inst.cordic.roc_in_Z[3]\ \memory_i.freq_inst.Z_o[3]\ _03353_ VPWR VGND sg13g2_mux2_1
X_26696_ _03440_ _03185_ \memory_i.freq_inst.cordic.shift_value[1]\ _03413_ VPWR VGND sg13g2_nand3_1
X_26697_ _03441_ _03194_ VPWR VGND sg13g2_buf_1
X_26698_ _03442_ _03441_ \memory_i.freq_inst.cordic.shift_value[1]\ VPWR VGND sg13g2_nor2_1
X_26699_ _03443_ _03411_ _03442_ VPWR VGND sg13g2_nand2_1
X_26700_ _03444_ \memory_i.freq_inst.cordic.shift_value[4]\ _13167_ VPWR VGND sg13g2_nand2_1
X_26701_ _03445_ _03440_ _03443_ _03444_ VPWR VGND sg13g2_a21oi_1
X_26702_ _03446_ \memory_i.freq_inst.cordic.shift_value[0]\ _03425_ VPWR VGND sg13g2_nand2_1
X_26703_ _03447_ \memory_i.freq_inst.cordic.shift_value[3]\ _03446_ VPWR VGND sg13g2_nor2_1
X_26704_ _03448_ _03407_ VPWR VGND sg13g2_buf_1
X_26705_ _03449_ \memory_i.freq_inst.Z_o[29]\ _03448_ _03441_ VPWR VGND sg13g2_a21oi_1
X_26706_ _03450_ \memory_i.freq_inst.cordic.shift_value[2]\ _13167_ VPWR VGND sg13g2_nand2_1
X_26707_ _03451_ _03413_ _03450_ _03178_ VPWR VGND sg13g2_a21oi_1
X_26708_ _03452_ \memory_i.freq_inst.cordic.shift_value[3]\ _03449_ _03451_ VPWR VGND sg13g2_nor3_1
X_26709_ _03453_ _03441_ _03448_ VPWR VGND sg13g2_nand2_1
X_26710_ _03454_ _03196_ _03366_ _03453_ _03413_ _03185_
+ VPWR
+ VGND sg13g2_a221oi_1
X_26711_ _03455_ \memory_i.freq_inst.cordic.shift_value[4]\ _03452_ _03454_ VPWR VGND sg13g2_nor3_1
X_26712_ _03456_ \memory_i.freq_inst.cordic.shift_value[3]\ \memory_i.freq_inst.cordic.shift_value[1]\ VPWR VGND sg13g2_nor2_1
X_26713_ _03457_ _03395_ _13167_ VPWR VGND sg13g2_nor2_1
X_26714_ _03458_ _03411_ _03456_ _03457_ VPWR VGND sg13g2_o21ai_1
X_26715_ _03459_ _03178_ _03413_ VPWR VGND sg13g2_nor2_1
X_26716_ _03460_ \memory_i.freq_inst.cordic.shift_value[4]\ _03177_ VPWR VGND sg13g2_nand2_1
X_26717_ _03461_ \memory_i.freq_inst.cordic.shift_value[0]\ _03411_ _03460_ VPWR VGND sg13g2_nor3_1
X_26718_ _03462_ _03459_ _03461_ \memory_i.freq_inst.cordic.shift_value[3]\ VPWR VGND sg13g2_o21ai_1
X_26719_ _03463_ _03458_ _03462_ \memory_i.freq_inst.cordic.shift_value[2]\ VPWR VGND sg13g2_a21oi_1
X_26720_ _03464_ _03445_ _03447_ _03455_ _03463_ VPWR
+ VGND
+ sg13g2_or4_1
X_26721_ _03465_ _03464_ VPWR VGND sg13g2_buf_1
X_26722_ _03466_ _03439_ _03465_ VPWR VGND sg13g2_xnor2_1
X_26723_ _03467_ _03438_ _03466_ VPWR VGND sg13g2_xnor2_1
X_26724_ _01480_ _03329_ _03467_ VPWR VGND sg13g2_nor2_1
X_26725_ _03468_ _03439_ _03465_ VPWR VGND sg13g2_nor2_1
X_26726_ _03469_ _03406_ _03430_ _03439_ _03465_ _03437_
+ VPWR
+ VGND sg13g2_a221oi_1
X_26727_ _03470_ _03468_ _03469_ VPWR VGND sg13g2_nor2_1
X_26728_ _03471_ \memory_i.freq_inst.cordic.roc_in_Z[4]\ \memory_i.freq_inst.Z_o[4]\ _03353_ VPWR VGND sg13g2_mux2_1
X_26729_ _03472_ _03471_ VPWR VGND sg13g2_buf_1
X_26730_ _03473_ \memory_i.freq_inst.cordic.shift_value[2]\ _03169_ \memory_i.freq_inst.cordic.shift_value[3]\ VPWR VGND sg13g2_o21ai_1
X_26731_ _03474_ \memory_i.freq_inst.cordic.shift_value[3]\ \memory_i.freq_inst.cordic.shift_value[2]\ VPWR VGND sg13g2_nor2_1
X_26732_ _03475_ _03474_ VPWR VGND sg13g2_buf_1
X_26733_ _03476_ \memory_i.freq_inst.cordic.shift_value[0]\ _03475_ \memory_i.freq_inst.cordic.shift_value[1]\ VPWR VGND sg13g2_o21ai_1
X_26734_ _03477_ _03383_ _03473_ _03476_ VPWR VGND sg13g2_nand3_1
X_26735_ _03478_ _03373_ _03377_ _03477_ _03413_ VPWR
+ VGND
+ sg13g2_a22oi_1
X_26736_ _03479_ _03177_ \memory_i.freq_inst.cordic.shift_value[0]\ VPWR VGND sg13g2_nor2_1
X_26737_ _03480_ _03479_ VPWR VGND sg13g2_buf_1
X_26738_ _03481_ _03456_ VPWR VGND sg13g2_inv_1
X_26739_ _03482_ \memory_i.freq_inst.cordic.shift_value[3]\ _03480_ _03481_ \memory_i.freq_inst.cordic.shift_value[4]\ VPWR
+ VGND
+ sg13g2_a22oi_1
X_26740_ _03483_ \memory_i.freq_inst.cordic.shift_value[3]\ _13172_ _03460_ VPWR VGND sg13g2_o21ai_1
X_26741_ _03484_ _13168_ _03483_ VPWR VGND sg13g2_nand2_1
X_26742_ _03485_ \memory_i.freq_inst.cordic.shift_value[2]\ _03482_ _03484_ VPWR VGND sg13g2_o21ai_1
X_26743_ _03486_ _03185_ _03413_ VPWR VGND sg13g2_nand2_1
X_26744_ _03487_ \memory_i.freq_inst.cordic.shift_value[4]\ _03373_ _03333_ VPWR VGND sg13g2_a21oi_1
X_26745_ _03488_ _03486_ _03487_ VPWR VGND sg13g2_nor2_1
X_26746_ _03489_ _03411_ _03485_ _03488_ VPWR VGND sg13g2_a21oi_1
X_26747_ _03490_ \memory_i.freq_inst.cordic.shift_value[4]\ _03478_ _03489_ VPWR VGND sg13g2_o21ai_1
X_26748_ _03491_ _03490_ VPWR VGND sg13g2_buf_1
X_26749_ _03492_ _03472_ _03491_ VPWR VGND sg13g2_xor2_1
X_26750_ _03493_ _03470_ _03492_ VPWR VGND sg13g2_xnor2_1
X_26751_ _01481_ _03329_ _03493_ VPWR VGND sg13g2_nor2_1
X_26752_ _03494_ _03472_ _03491_ VPWR VGND sg13g2_nor2_1
X_26753_ _03495_ _03468_ _03469_ _03494_ VPWR VGND sg13g2_nor3_1
X_26754_ _03496_ _03472_ _03491_ _03495_ VPWR VGND sg13g2_a21oi_1
X_26755_ _03497_ _03413_ VPWR VGND sg13g2_buf_2
X_26756_ _03498_ _03196_ \memory_i.freq_inst.cordic.shift_value[1]\ VPWR VGND sg13g2_nand2_1
X_26757_ _03499_ _03383_ _03498_ VPWR VGND sg13g2_nand2_1
X_26758_ _03500_ _03498_ _03450_ VPWR VGND sg13g2_nand2_1
X_26759_ _03501_ \memory_i.freq_inst.cordic.shift_value[0]\ _03499_ _03500_ \memory_i.freq_inst.cordic.shift_value[3]\ VPWR
+ VGND
+ sg13g2_a22oi_1
X_26760_ _03502_ \memory_i.freq_inst.cordic.shift_value[3]\ \memory_i.freq_inst.cordic.shift_value[0]\ _03373_ VPWR VGND sg13g2_nor3_1
X_26761_ _03503_ _03198_ _03497_ _03502_ VPWR VGND sg13g2_nor3_1
X_26762_ _03504_ _03497_ _03501_ _03503_ VPWR VGND sg13g2_a21o_1
X_26763_ _03505_ _03411_ VPWR VGND sg13g2_buf_1
X_26764_ _03506_ \memory_i.freq_inst.cordic.shift_value[2]\ _03444_ _03186_ VPWR VGND sg13g2_a21oi_1
X_26765_ _03507_ _03391_ _03506_ _03178_ VPWR VGND sg13g2_o21ai_1
X_26766_ _03508_ _03371_ _03420_ \memory_i.freq_inst.cordic.shift_value[4]\ VPWR VGND sg13g2_o21ai_1
X_26767_ _03509_ _03507_ _03508_ VPWR VGND sg13g2_nand2_1
X_26768_ _03510_ _03420_ _03444_ _03486_ VPWR VGND sg13g2_nor3_1
X_26769_ _03511_ _03505_ _03509_ _03510_ VPWR VGND sg13g2_a21oi_1
X_26770_ _03512_ \memory_i.freq_inst.cordic.shift_value[4]\ _03504_ _03511_ VPWR VGND sg13g2_o21ai_1
X_26771_ _03513_ _03353_ VPWR VGND sg13g2_buf_1
X_26772_ _03514_ \memory_i.freq_inst.cordic.roc_in_Z[5]\ \memory_i.freq_inst.Z_o[5]\ _03513_ VPWR VGND sg13g2_mux2_1
X_26773_ _03515_ _03512_ _03514_ VPWR VGND sg13g2_xnor2_1
X_26774_ _03516_ _03496_ _03515_ VPWR VGND sg13g2_xnor2_1
X_26775_ _01482_ _03329_ _03516_ VPWR VGND sg13g2_nor2_1
X_26776_ _03517_ _03512_ _03514_ VPWR VGND sg13g2_nor2_1
X_26777_ _03518_ _03472_ _03491_ _03512_ _03514_ _03495_
+ VPWR
+ VGND sg13g2_a221oi_1
X_26778_ _03519_ _03517_ _03518_ VPWR VGND sg13g2_nor2_1
X_26779_ _03520_ _03497_ VPWR VGND sg13g2_buf_1
X_26780_ _03521_ _03395_ VPWR VGND sg13g2_buf_2
X_26781_ _03522_ _03521_ VPWR VGND sg13g2_buf_1
X_26782_ _03523_ _03197_ \memory_i.freq_inst.cordic.shift_value[0]\ VPWR VGND sg13g2_nor2_1
X_26783_ _03524_ _03522_ _03523_ VPWR VGND sg13g2_nand2_1
X_26784_ _03525_ \memory_i.freq_inst.cordic.shift_value[3]\ _03391_ _03524_ VPWR VGND sg13g2_o21ai_1
X_26785_ _03526_ \memory_i.freq_inst.cordic.shift_value[3]\ _03169_ VPWR VGND sg13g2_nand2_1
X_26786_ _03527_ _03187_ \memory_i.freq_inst.cordic.shift_value[1]\ VPWR VGND sg13g2_nand2_1
X_26787_ _03528_ \memory_i.freq_inst.cordic.shift_value[4]\ _03527_ VPWR VGND sg13g2_nand2_1
X_26788_ _03529_ _03526_ _03528_ \memory_i.freq_inst.cordic.shift_value[2]\ VPWR VGND sg13g2_a21oi_1
X_26789_ _03530_ \memory_i.freq_inst.cordic.shift_value[4]\ _03169_ _03525_ \memory_i.freq_inst.cordic.shift_value[1]\ _03529_
+ VPWR
+ VGND sg13g2_a221oi_1
X_26790_ _03531_ _03520_ _03530_ VPWR VGND sg13g2_nor2_1
X_26791_ _03532_ _03505_ VPWR VGND sg13g2_buf_2
X_26792_ _03533_ _03532_ VPWR VGND sg13g2_buf_8
X_26793_ _03534_ _13168_ _03498_ _03187_ VPWR VGND sg13g2_a21oi_1
X_26794_ _03535_ _03442_ _03391_ _03534_ VPWR VGND sg13g2_or3_1
X_26795_ _03536_ _03522_ VPWR VGND sg13g2_buf_1
X_26796_ _03537_ _03371_ _03499_ _03535_ _03536_ VPWR
+ VGND
+ sg13g2_a22oi_1
X_26797_ _03538_ _03533_ _03537_ VPWR VGND sg13g2_nor2_1
X_26798_ _03539_ \memory_i.freq_inst.cordic.roc_in_Z[6]\ \memory_i.freq_inst.Z_o[6]\ _03513_ VPWR VGND sg13g2_mux2_1
X_26799_ _03540_ _03531_ _03538_ _03539_ VPWR VGND sg13g2_nor3_1
X_26800_ _03541_ _03531_ _03538_ _03539_ VPWR VGND sg13g2_o21ai_1
X_26801_ _03542_ _03540_ _03541_ VPWR VGND sg13g2_nor2b_1
X_26802_ _03543_ _03519_ _03542_ VPWR VGND sg13g2_xnor2_1
X_26803_ _01483_ _03329_ _03543_ VPWR VGND sg13g2_nor2_1
X_26804_ _03544_ _03517_ _03518_ _03541_ VPWR VGND sg13g2_o21ai_1
X_26805_ _03545_ _03540_ _03544_ VPWR VGND sg13g2_nor2b_1
X_26806_ _03546_ \memory_i.freq_inst.cordic.roc_in_Z[7]\ \memory_i.freq_inst.Z_o[7]\ _03513_ VPWR VGND sg13g2_mux2_1
X_26807_ _03547_ _03520_ VPWR VGND sg13g2_buf_2
X_26808_ _03548_ _03188_ _03499_ VPWR VGND sg13g2_nand2_1
X_26809_ _03549_ _13172_ _03347_ _03548_ \memory_i.freq_inst.cordic.shift_value[4]\ VPWR
+ VGND
+ sg13g2_a22oi_1
X_26810_ _03550_ _03343_ _03448_ _03385_ VPWR VGND sg13g2_o21ai_1
X_26811_ _03551_ _13168_ _03549_ _03550_ _03536_ VPWR
+ VGND
+ sg13g2_a22oi_1
X_26812_ _03552_ \memory_i.freq_inst.cordic.shift_value[3]\ _13168_ VPWR VGND sg13g2_nand2_1
X_26813_ _03553_ \memory_i.freq_inst.cordic.shift_value[2]\ _03552_ VPWR VGND sg13g2_nand2_1
X_26814_ _03554_ _03347_ _03523_ _03553_ \memory_i.freq_inst.cordic.shift_value[4]\ VPWR
+ VGND
+ sg13g2_a22oi_1
X_26815_ _03555_ \memory_i.freq_inst.cordic.shift_value[1]\ _03554_ VPWR VGND sg13g2_nor2_1
X_26816_ _03556_ \memory_i.freq_inst.cordic.shift_value[3]\ _03498_ VPWR VGND sg13g2_nor2_1
X_26817_ _03557_ \memory_i.freq_inst.cordic.shift_value[3]\ _03333_ _03556_ VPWR VGND sg13g2_a21oi_1
X_26818_ _03558_ _13171_ _03371_ _03197_ VPWR VGND sg13g2_o21ai_1
X_26819_ _03559_ \memory_i.freq_inst.cordic.shift_value[4]\ _03557_ _03558_ VPWR VGND sg13g2_o21ai_1
X_26820_ _03560_ \memory_i.freq_inst.cordic.shift_value[0]\ _13173_ \memory_i.freq_inst.cordic.shift_value[4]\ VPWR VGND sg13g2_o21ai_1
X_26821_ _03561_ _03171_ _03560_ \memory_i.freq_inst.cordic.shift_value[3]\ VPWR VGND sg13g2_a21oi_1
X_26822_ _03562_ _03520_ _03555_ _03559_ _03561_ VPWR
+ VGND
+ sg13g2_nor4_1
X_26823_ _03563_ _03547_ _03551_ _03562_ VPWR VGND sg13g2_a21o_1
X_26824_ _03564_ _03546_ _03563_ VPWR VGND sg13g2_nand2b_1
X_26825_ _03565_ _03563_ _03546_ VPWR VGND sg13g2_nand2b_1
X_26826_ _03566_ _03564_ _03565_ VPWR VGND sg13g2_nand2_1
X_26827_ _03567_ _03545_ _03566_ VPWR VGND sg13g2_xnor2_1
X_26828_ _01484_ \memory_i.freq_inst.cordic.rstn_i\ _03567_ VPWR VGND sg13g2_and2_1
X_26829_ _03568_ _03540_ _03544_ _03564_ VPWR VGND sg13g2_nand3b_1
X_26830_ _03569_ _03565_ _03568_ VPWR VGND sg13g2_and2_1
X_26831_ _03570_ _03513_ VPWR VGND sg13g2_buf_1
X_26832_ _03571_ \memory_i.freq_inst.cordic.roc_in_Z[8]\ \memory_i.freq_inst.Z_o[8]\ _03570_ VPWR VGND sg13g2_mux2_1
X_26833_ _03572_ _03197_ VPWR VGND sg13g2_buf_1
X_26834_ _03573_ \memory_i.freq_inst.cordic.shift_value[4]\ _03391_ VPWR VGND sg13g2_nand2_1
X_26835_ _03574_ \memory_i.freq_inst.cordic.shift_value[4]\ _03572_ _03573_ VPWR VGND sg13g2_o21ai_1
X_26836_ _03575_ _03385_ _03448_ VPWR VGND sg13g2_nand2_1
X_26837_ _03576_ _03536_ VPWR VGND sg13g2_buf_1
X_26838_ _03577_ _03188_ _03574_ _03575_ _03576_ VPWR
+ VGND
+ sg13g2_a22oi_1
X_26839_ _03578_ \memory_i.freq_inst.cordic.shift_value[3]\ \memory_i.freq_inst.cordic.shift_value[1]\ _03444_ VPWR VGND sg13g2_a21oi_1
X_26840_ _03579_ _03521_ \memory_i.freq_inst.cordic.shift_value[3]\ VPWR VGND sg13g2_nor2_1
X_26841_ _03580_ _03190_ _03448_ _03579_ VPWR VGND sg13g2_a21oi_1
X_26842_ _03581_ \memory_i.freq_inst.cordic.shift_value[4]\ _03527_ _13170_ VPWR VGND sg13g2_o21ai_1
X_26843_ _03582_ _03572_ _03581_ VPWR VGND sg13g2_nand2_1
X_26844_ _03583_ _03572_ _03580_ _03582_ VPWR VGND sg13g2_o21ai_1
X_26845_ _03584_ _03578_ _03583_ _03533_ VPWR VGND sg13g2_o21ai_1
X_26846_ _03585_ _03533_ _03577_ _03584_ VPWR VGND sg13g2_o21ai_1
X_26847_ _03586_ _03571_ _03585_ VPWR VGND sg13g2_xnor2_1
X_26848_ _03587_ _03569_ _03586_ VPWR VGND sg13g2_xnor2_1
X_26849_ _01485_ _03329_ _03587_ VPWR VGND sg13g2_nor2_1
X_26850_ _03588_ _03571_ _03585_ VPWR VGND sg13g2_nor2_1
X_26851_ _03589_ _03571_ _03585_ VPWR VGND sg13g2_nand2_1
X_26852_ _03590_ _03569_ _03588_ _03589_ VPWR VGND sg13g2_o21ai_1
X_26853_ _03591_ _03533_ VPWR VGND sg13g2_buf_1
X_26854_ _03592_ \memory_i.freq_inst.cordic.shift_value[1]\ _13168_ VPWR VGND sg13g2_nor2_1
X_26855_ _03593_ _03592_ VPWR VGND sg13g2_buf_1
X_26856_ _03594_ _03188_ _03593_ VPWR VGND sg13g2_nand2_1
X_26857_ _03595_ \memory_i.freq_inst.cordic.shift_value[3]\ \memory_i.freq_inst.cordic.shift_value[0]\ VPWR VGND sg13g2_nand2_1
X_26858_ _03596_ \memory_i.freq_inst.cordic.shift_value[2]\ _03480_ VPWR VGND sg13g2_nand2_1
X_26859_ _03597_ _03595_ _03373_ _03596_ VPWR VGND sg13g2_o21ai_1
X_26860_ _03598_ _03343_ _03526_ _03536_ VPWR VGND sg13g2_a21oi_1
X_26861_ _03599_ _03576_ _03597_ _03598_ VPWR VGND sg13g2_a21oi_1
X_26862_ _03600_ _03591_ _03558_ _03594_ _03599_ VPWR
+ VGND
+ sg13g2_nand4_1
X_26863_ _03601_ _03547_ VPWR VGND sg13g2_buf_1
X_26864_ _03602_ \memory_i.freq_inst.cordic.shift_value[2]\ _03382_ _03480_ VPWR VGND sg13g2_nor3_1
X_26865_ _03603_ _03414_ _03602_ VPWR VGND sg13g2_nor2_1
X_26866_ _03604_ \memory_i.freq_inst.cordic.shift_value[2]\ \memory_i.freq_inst.cordic.shift_value[0]\ VPWR VGND sg13g2_nor2_1
X_26867_ _03605_ _03198_ _03604_ \memory_i.freq_inst.cordic.shift_value[4]\ VPWR VGND sg13g2_mux2_1
X_26868_ _03606_ _03576_ _03603_ _03605_ _03188_ VPWR
+ VGND
+ sg13g2_a22oi_1
X_26869_ _03607_ _03601_ _03606_ VPWR VGND sg13g2_nand2_1
X_26870_ _03608_ \memory_i.freq_inst.cordic.roc_in_Z[9]\ \memory_i.freq_inst.Z_o[9]\ _03570_ VPWR VGND sg13g2_mux2_1
X_26871_ _03609_ _03600_ _03607_ _03608_ VPWR VGND sg13g2_nand3_1
X_26872_ _03610_ _03600_ _03607_ _03608_ VPWR VGND sg13g2_a21o_1
X_26873_ _03611_ _03609_ _03610_ VPWR VGND sg13g2_nand2_1
X_26874_ _03612_ _03590_ _03611_ VPWR VGND sg13g2_xor2_1
X_26875_ _01486_ _03329_ _03612_ VPWR VGND sg13g2_nor2_1
X_26876_ _03613_ _03565_ _03568_ _03588_ VPWR VGND sg13g2_a21oi_1
X_26877_ _03614_ _03589_ _03609_ VPWR VGND sg13g2_nand2_1
X_26878_ _03615_ _03613_ _03614_ _03610_ VPWR VGND sg13g2_o21ai_1
X_26879_ _03616_ \memory_i.freq_inst.cordic.roc_in_Z[10]\ \memory_i.freq_inst.Z_o[10]\ _03570_ VPWR VGND sg13g2_mux2_1
X_26880_ _03617_ _03591_ VPWR VGND sg13g2_buf_1
X_26881_ _03618_ _03191_ _03174_ VPWR VGND sg13g2_nand2_1
X_26882_ _03619_ \memory_i.freq_inst.cordic.shift_value[4]\ _03371_ _03190_ VPWR VGND sg13g2_a21oi_1
X_26883_ _03620_ \memory_i.freq_inst.cordic.shift_value[1]\ _03333_ _03188_ VPWR VGND sg13g2_o21ai_1
X_26884_ _03621_ _03171_ _03620_ \memory_i.freq_inst.cordic.shift_value[4]\ VPWR VGND sg13g2_a21o_1
X_26885_ _03622_ _03618_ _03619_ _03621_ VPWR VGND sg13g2_o21ai_1
X_26886_ _03623_ _03362_ _03448_ _13170_ VPWR VGND sg13g2_o21ai_1
X_26887_ _03624_ _03572_ _03623_ VPWR VGND sg13g2_nand2_1
X_26888_ _03625_ _03442_ _03480_ _03190_ VPWR VGND sg13g2_o21ai_1
X_26889_ _03626_ _03576_ \memory_i.freq_inst.cordic.shift_value[3]\ _03336_ VPWR VGND sg13g2_o21ai_1
X_26890_ _03627_ _03448_ _03579_ _03626_ \memory_i.freq_inst.cordic.shift_value[2]\ VPWR
+ VGND
+ sg13g2_a22oi_1
X_26891_ _03628_ _03591_ _03624_ _03625_ _03627_ VPWR
+ VGND
+ sg13g2_nand4_1
X_26892_ _03629_ _03617_ _03622_ _03628_ VPWR VGND sg13g2_o21ai_1
X_26893_ _03630_ _03616_ _03629_ VPWR VGND sg13g2_xor2_1
X_26894_ _03631_ _03615_ _03630_ VPWR VGND sg13g2_xnor2_1
X_26895_ _01487_ _03329_ _03631_ VPWR VGND sg13g2_nor2_1
X_26896_ _03632_ _03629_ _03616_ VPWR VGND sg13g2_nand2b_1
X_26897_ _03633_ _03616_ _03629_ VPWR VGND sg13g2_nor2b_1
X_26898_ _03634_ _03615_ _03632_ _03633_ VPWR VGND sg13g2_a21oi_1
X_26899_ _03635_ \memory_i.freq_inst.cordic.roc_in_Z[11]\ \memory_i.freq_inst.Z_o[11]\ _03570_ VPWR VGND sg13g2_mux2_1
X_26900_ _03636_ _03635_ VPWR VGND sg13g2_inv_1
X_26901_ _03637_ \memory_i.freq_inst.cordic.shift_value[3]\ \memory_i.freq_inst.cordic.shift_value[2]\ VPWR VGND sg13g2_nand2_1
X_26902_ _03638_ _03169_ _03637_ VPWR VGND sg13g2_nor2_1
X_26903_ _03639_ \memory_i.freq_inst.cordic.shift_value[3]\ _03618_ VPWR VGND sg13g2_nor2_1
X_26904_ _03640_ _03639_ VPWR VGND sg13g2_buf_1
X_26905_ _03641_ _03638_ _03640_ \memory_i.freq_inst.cordic.shift_value[4]\ VPWR VGND sg13g2_o21ai_1
X_26906_ _03642_ _03576_ _03595_ _03383_ VPWR VGND sg13g2_nand3_1
X_26907_ _03643_ _03601_ VPWR VGND sg13g2_buf_2
X_26908_ _03644_ _03572_ \memory_i.freq_inst.cordic.shift_value[0]\ _03641_ _03642_ _03643_
+ VPWR
+ VGND sg13g2_a221oi_1
X_26909_ _03645_ _03644_ VPWR VGND sg13g2_buf_1
X_26910_ _03646_ \memory_i.freq_inst.cordic.shift_value[4]\ _03331_ VPWR VGND sg13g2_nand2_1
X_26911_ _03647_ \memory_i.freq_inst.cordic.shift_value[4]\ _13172_ _03646_ VPWR VGND sg13g2_o21ai_1
X_26912_ _03648_ \memory_i.freq_inst.cordic.shift_value[4]\ \memory_i.freq_inst.cordic.shift_value[0]\ VPWR VGND sg13g2_nor2_1
X_26913_ _03649_ _03178_ _03385_ VPWR VGND sg13g2_nand2_1
X_26914_ _03650_ _03617_ VPWR VGND sg13g2_buf_1
X_26915_ _03651_ _03189_ _03647_ _03648_ _03649_ _03650_
+ VPWR
+ VGND sg13g2_a221oi_1
X_26916_ _03652_ _03651_ VPWR VGND sg13g2_buf_1
X_26917_ _03653_ _03645_ _03652_ VPWR VGND sg13g2_nor2_1
X_26918_ _03654_ _03636_ _03653_ VPWR VGND sg13g2_xnor2_1
X_26919_ _03655_ _03634_ _03654_ VPWR VGND sg13g2_xnor2_1
X_26920_ _01488_ _03329_ _03655_ VPWR VGND sg13g2_nor2_1
X_26921_ _03656_ _12945_ VPWR VGND sg13g2_buf_1
X_26922_ _03657_ _03656_ VPWR VGND sg13g2_buf_1
X_26923_ _03658_ _03645_ _03652_ _03636_ VPWR VGND sg13g2_o21ai_1
X_26924_ _03659_ _03636_ _03645_ _03652_ VPWR VGND sg13g2_nor3_1
X_26925_ _03660_ _03634_ _03658_ _03659_ VPWR VGND sg13g2_a21oi_1
X_26926_ _03661_ \memory_i.freq_inst.cordic.shift_value[4]\ _03617_ VPWR VGND sg13g2_nor2_1
X_26927_ _03662_ \memory_i.freq_inst.cordic.shift_value[0]\ _03392_ \memory_i.freq_inst.cordic.shift_value[2]\ VPWR VGND sg13g2_o21ai_1
X_26928_ _03663_ _03189_ _03448_ _03662_ VPWR VGND sg13g2_o21ai_1
X_26929_ _03664_ \memory_i.freq_inst.cordic.shift_value[1]\ _03371_ _03572_ VPWR VGND sg13g2_o21ai_1
X_26930_ _03665_ \memory_i.freq_inst.cordic.shift_value[4]\ _03637_ VPWR VGND sg13g2_nand2_1
X_26931_ _03666_ _03190_ _03442_ _13168_ VPWR VGND sg13g2_o21ai_1
X_26932_ _03667_ _03664_ _03665_ _03666_ VPWR VGND sg13g2_nand3_1
X_26933_ _03668_ _03661_ _03663_ _03667_ _03650_ VPWR
+ VGND
+ sg13g2_a22oi_1
X_26934_ _03669_ _03570_ VPWR VGND sg13g2_buf_1
X_26935_ _03670_ \memory_i.freq_inst.cordic.roc_in_Z[12]\ \memory_i.freq_inst.Z_o[12]\ _03669_ VPWR VGND sg13g2_mux2_1
X_26936_ _03671_ _03668_ _03670_ VPWR VGND sg13g2_xor2_1
X_26937_ _03672_ _03660_ _03671_ VPWR VGND sg13g2_xnor2_1
X_26938_ _01489_ _03657_ _03672_ VPWR VGND sg13g2_nor2_1
X_26939_ _03673_ _03668_ VPWR VGND sg13g2_inv_1
X_26940_ _03674_ _03673_ _03670_ VPWR VGND sg13g2_nor2_1
X_26941_ _03675_ _03673_ _03670_ VPWR VGND sg13g2_nand2_1
X_26942_ _03676_ _03660_ _03674_ _03675_ VPWR VGND sg13g2_o21ai_1
X_26943_ _03677_ _03360_ _03362_ VPWR VGND sg13g2_nor2_1
X_26944_ _03678_ _03677_ VPWR VGND sg13g2_buf_1
X_26945_ _03679_ _03678_ VPWR VGND sg13g2_buf_2
X_26946_ _03680_ \memory_i.freq_inst.Z_o[13]\ _03669_ VPWR VGND sg13g2_and2_1
X_26947_ _03681_ \memory_i.freq_inst.cordic.roc_in_Z[13]\ _03679_ _03680_ VPWR VGND sg13g2_a21oi_1
X_26948_ _03682_ \memory_i.freq_inst.cordic.shift_value[3]\ _03448_ VPWR VGND sg13g2_nor2_1
X_26949_ _03683_ _03480_ _03682_ \memory_i.freq_inst.cordic.shift_value[2]\ VPWR VGND sg13g2_o21ai_1
X_26950_ _03684_ _03526_ _03683_ VPWR VGND sg13g2_nand2_1
X_26951_ _03685_ \memory_i.freq_inst.cordic.shift_value[4]\ _03456_ \memory_i.freq_inst.cordic.shift_value[2]\ VPWR VGND sg13g2_o21ai_1
X_26952_ _03686_ \memory_i.freq_inst.cordic.shift_value[0]\ _03685_ VPWR VGND sg13g2_nand2_1
X_26953_ _03687_ _03189_ _03169_ \memory_i.freq_inst.cordic.shift_value[4]\ VPWR VGND sg13g2_o21ai_1
X_26954_ _03688_ _03344_ _03420_ VPWR VGND sg13g2_nor2_1
X_26955_ _03689_ _03686_ _03687_ _03688_ VPWR VGND sg13g2_nand3_1
X_26956_ _03690_ _03661_ _03684_ _03689_ _03650_ VPWR
+ VGND
+ sg13g2_a22oi_1
X_26957_ _03691_ _03681_ _03690_ VPWR VGND sg13g2_nand2_1
X_26958_ _03692_ _03681_ _03690_ VPWR VGND sg13g2_nor2_1
X_26959_ _03693_ _03692_ VPWR VGND sg13g2_inv_1
X_26960_ _03694_ _03691_ _03693_ VPWR VGND sg13g2_nand2_1
X_26961_ _03695_ _03676_ _03694_ VPWR VGND sg13g2_xnor2_1
X_26962_ _01490_ \memory_i.freq_inst.cordic.rstn_i\ _03695_ VPWR VGND sg13g2_and2_1
X_26963_ _03696_ _03676_ _03691_ _03692_ VPWR VGND sg13g2_a21oi_1
X_26964_ _03697_ \memory_i.freq_inst.cordic.shift_value[4]\ _03593_ VPWR VGND sg13g2_nor2_1
X_26965_ _03698_ \memory_i.freq_inst.cordic.shift_value[2]\ _03697_ _03687_ VPWR VGND sg13g2_o21ai_1
X_26966_ _03699_ _03189_ _03333_ _03499_ _03552_ _03650_
+ VPWR
+ VGND sg13g2_a221oi_1
X_26967_ _03700_ \memory_i.freq_inst.cordic.shift_value[0]\ _13172_ VPWR VGND sg13g2_nand2_1
X_26968_ _03701_ \memory_i.freq_inst.cordic.shift_value[2]\ _03480_ _03700_ \memory_i.freq_inst.cordic.shift_value[3]\ _03643_
+ VPWR
+ VGND sg13g2_a221oi_1
X_26969_ _03702_ \memory_i.freq_inst.cordic.shift_value[4]\ _03699_ _03701_ VPWR VGND sg13g2_nor3_1
X_26970_ _03703_ _03650_ _03698_ _03702_ VPWR VGND sg13g2_a21o_1
X_26971_ _03704_ \memory_i.freq_inst.cordic.roc_in_Z[14]\ \memory_i.freq_inst.Z_o[14]\ _03570_ VPWR VGND sg13g2_mux2_1
X_26972_ _03705_ _03703_ _03704_ VPWR VGND sg13g2_and2_1
X_26973_ _03706_ _03703_ _03704_ VPWR VGND sg13g2_or2_1
X_26974_ _03707_ _03706_ VPWR VGND sg13g2_buf_1
X_26975_ _03708_ _03705_ _03707_ VPWR VGND sg13g2_nor2b_1
X_26976_ _03709_ _03696_ _03708_ VPWR VGND sg13g2_xnor2_1
X_26977_ _01491_ \memory_i.freq_inst.cordic.rstn_i\ _03709_ VPWR VGND sg13g2_and2_1
X_26978_ _03710_ _03691_ _03707_ VPWR VGND sg13g2_and2_1
X_26979_ _03711_ _03692_ _03707_ _03710_ _03676_ _03705_
+ VPWR
+ VGND sg13g2_a221oi_1
X_26980_ _03712_ _03711_ VPWR VGND sg13g2_buf_1
X_26981_ _03713_ \memory_i.freq_inst.cordic.roc_in_Z[15]\ \memory_i.freq_inst.Z_o[15]\ _03669_ VPWR VGND sg13g2_mux2_1
X_26982_ _03714_ _03650_ VPWR VGND sg13g2_buf_1
X_26983_ _03715_ _03576_ VPWR VGND sg13g2_buf_2
X_26984_ _03716_ _03715_ \memory_i.freq_inst.cordic.shift_value[1]\ _03366_ VPWR VGND sg13g2_nand3_1
X_26985_ _03717_ \memory_i.freq_inst.cordic.shift_value[1]\ _03714_ _03716_ VPWR VGND sg13g2_o21ai_1
X_26986_ _03718_ _03643_ VPWR VGND sg13g2_buf_1
X_26987_ _03719_ _03718_ VPWR VGND sg13g2_buf_1
X_26988_ _03720_ \memory_i.freq_inst.cordic.shift_value[4]\ _03336_ _03719_ \memory_i.freq_inst.cordic.shift_value[1]\ VPWR
+ VGND
+ sg13g2_a22oi_1
X_26989_ _03721_ _03648_ VPWR VGND sg13g2_inv_1
X_26990_ _03722_ \memory_i.freq_inst.cordic.shift_value[3]\ _03383_ _03721_ VPWR VGND sg13g2_a21oi_1
X_26991_ _03723_ _03650_ _03648_ VPWR VGND sg13g2_nor2_1
X_26992_ _03724_ _03714_ _03722_ _03723_ VPWR VGND sg13g2_a21oi_1
X_26993_ _03725_ _03637_ _03720_ _03724_ VPWR VGND sg13g2_o21ai_1
X_26994_ _03726_ _03572_ _03717_ _03725_ VPWR VGND sg13g2_a21oi_1
X_26995_ _03727_ _03713_ _03726_ VPWR VGND sg13g2_nand2_1
X_26996_ _03728_ _03727_ VPWR VGND sg13g2_inv_1
X_26997_ _03729_ _03713_ _03726_ VPWR VGND sg13g2_nor2_1
X_26998_ _03730_ _03728_ _03729_ VPWR VGND sg13g2_nor2_1
X_26999_ _03731_ _03712_ _03730_ VPWR VGND sg13g2_xnor2_1
X_27000_ _01492_ \memory_i.freq_inst.cordic.rstn_i\ _03731_ VPWR VGND sg13g2_and2_1
X_27001_ _03732_ _03712_ _03729_ _03727_ VPWR VGND sg13g2_o21ai_1
X_27002_ _03733_ \memory_i.freq_inst.cordic.roc_in_Z[16]\ \memory_i.freq_inst.Z_o[16]\ _03669_ VPWR VGND sg13g2_mux2_1
X_27003_ _03734_ _03572_ _13170_ _03486_ VPWR VGND sg13g2_o21ai_1
X_27004_ _03735_ _03377_ _03604_ _03456_ VPWR VGND sg13g2_o21ai_1
X_27005_ _03736_ _03385_ _03446_ _03735_ VPWR VGND sg13g2_o21ai_1
X_27006_ _03737_ \memory_i.freq_inst.cordic.shift_value[3]\ _03333_ _03718_ VPWR VGND sg13g2_a21oi_1
X_27007_ _03738_ \memory_i.freq_inst.cordic.shift_value[0]\ _03637_ _03650_ VPWR VGND sg13g2_a21o_1
X_27008_ _03739_ _03715_ _03737_ _03738_ VPWR VGND sg13g2_o21ai_1
X_27009_ _03740_ \memory_i.freq_inst.cordic.shift_value[1]\ _03734_ _03736_ _03715_ _03739_
+ VPWR
+ VGND sg13g2_a221oi_1
X_27010_ _03741_ _03740_ VPWR VGND sg13g2_buf_1
X_27011_ _03742_ _03733_ _03741_ VPWR VGND sg13g2_xor2_1
X_27012_ _03743_ _03732_ _03742_ VPWR VGND sg13g2_xnor2_1
X_27013_ _01493_ _03657_ _03743_ VPWR VGND sg13g2_nor2_1
X_27014_ _03744_ _03733_ _03741_ VPWR VGND sg13g2_nand2_1
X_27015_ _03745_ _03727_ _03744_ VPWR VGND sg13g2_and2_1
X_27016_ _03746_ _03729_ _03744_ VPWR VGND sg13g2_nand2_1
X_27017_ _03747_ _03733_ _03741_ _03746_ VPWR VGND sg13g2_o21ai_1
X_27018_ _03748_ _03712_ _03745_ _03747_ VPWR VGND sg13g2_a21o_1
X_27019_ _03749_ _03748_ VPWR VGND sg13g2_buf_1
X_27020_ _03750_ \memory_i.freq_inst.cordic.roc_in_Z[17]\ \memory_i.freq_inst.Z_o[17]\ _03669_ VPWR VGND sg13g2_mux2_1
X_27021_ _03751_ _03572_ _03425_ _03456_ VPWR VGND sg13g2_o21ai_1
X_27022_ _03752_ \memory_i.freq_inst.cordic.shift_value[2]\ _03719_ _03751_ VPWR VGND sg13g2_o21ai_1
X_27023_ _03753_ \memory_i.freq_inst.cordic.shift_value[4]\ _03336_ _03719_ VPWR VGND sg13g2_a21oi_1
X_27024_ _03754_ \memory_i.freq_inst.cordic.shift_value[1]\ _03719_ VPWR VGND sg13g2_nand2_1
X_27025_ _03755_ _03189_ _03753_ _03754_ VPWR VGND sg13g2_o21ai_1
X_27026_ _03756_ _03648_ _03752_ _03755_ \memory_i.freq_inst.cordic.shift_value[2]\ _03723_
+ VPWR
+ VGND sg13g2_a221oi_1
X_27027_ _03757_ _03750_ _03756_ VPWR VGND sg13g2_and2_1
X_27028_ _03758_ _03757_ VPWR VGND sg13g2_buf_1
X_27029_ _03759_ _03750_ _03756_ VPWR VGND sg13g2_nor2_1
X_27030_ _03760_ _03758_ _03759_ VPWR VGND sg13g2_nor2_1
X_27031_ _03761_ _03749_ _03760_ VPWR VGND sg13g2_xor2_1
X_27032_ _01494_ _03657_ _03761_ VPWR VGND sg13g2_nor2_1
X_27033_ _03762_ _03758_ VPWR VGND sg13g2_inv_1
X_27034_ _03763_ _03749_ _03762_ _03759_ VPWR VGND sg13g2_a21oi_1
X_27035_ _03764_ _03661_ VPWR VGND sg13g2_inv_1
X_27036_ _03765_ _03187_ \memory_i.freq_inst.cordic.shift_value[2]\ VPWR VGND sg13g2_nor2_1
X_27037_ _03766_ _03765_ _03593_ _03450_ _03392_ VPWR
+ VGND
+ sg13g2_a22oi_1
X_27038_ _03767_ _03189_ \memory_i.freq_inst.cordic.shift_value[0]\ VPWR VGND sg13g2_nand2_1
X_27039_ _03768_ \memory_i.freq_inst.cordic.shift_value[2]\ _03767_ _03448_ \memory_i.freq_inst.cordic.shift_value[3]\ VPWR
+ VGND
+ sg13g2_a22oi_1
X_27040_ _03769_ \memory_i.freq_inst.cordic.shift_value[4]\ _03768_ VPWR VGND sg13g2_nor2_1
X_27041_ _03770_ \memory_i.freq_inst.cordic.shift_value[2]\ _03336_ VPWR VGND sg13g2_nand2_1
X_27042_ _03771_ \memory_i.freq_inst.cordic.shift_value[4]\ _03770_ VPWR VGND sg13g2_nand2_1
X_27043_ _03772_ \memory_i.freq_inst.cordic.shift_value[3]\ _03697_ _03771_ VPWR VGND sg13g2_o21ai_1
X_27044_ _03773_ _03769_ _03772_ _03714_ VPWR VGND sg13g2_o21ai_1
X_27045_ _03774_ _03764_ _03766_ _03773_ VPWR VGND sg13g2_o21ai_1
X_27046_ _03775_ \memory_i.freq_inst.cordic.roc_in_Z[18]\ \memory_i.freq_inst.Z_o[18]\ _03669_ VPWR VGND sg13g2_mux2_1
X_27047_ _03776_ _03774_ _03775_ VPWR VGND sg13g2_and2_1
X_27048_ _03777_ _03776_ VPWR VGND sg13g2_buf_1
X_27049_ _03778_ _03774_ _03775_ VPWR VGND sg13g2_nor2_1
X_27050_ _03779_ _03777_ _03778_ VPWR VGND sg13g2_nor2_1
X_27051_ _03780_ _03763_ _03779_ VPWR VGND sg13g2_xnor2_1
X_27052_ _01495_ _03657_ _03780_ VPWR VGND sg13g2_nor2_1
X_27053_ _03781_ _03758_ _03777_ VPWR VGND sg13g2_nor2_1
X_27054_ _03782_ _03777_ _03759_ VPWR VGND sg13g2_nand2b_1
X_27055_ _03783_ _03778_ _03782_ VPWR VGND sg13g2_nand2b_1
X_27056_ _03784_ _03749_ _03781_ _03783_ VPWR VGND sg13g2_a21o_1
X_27057_ _03785_ _03784_ VPWR VGND sg13g2_buf_1
X_27058_ _03786_ _03572_ _03593_ _03480_ VPWR VGND sg13g2_a21oi_1
X_27059_ _03787_ _03169_ _03765_ VPWR VGND sg13g2_nand2_1
X_27060_ _03788_ \memory_i.freq_inst.cordic.shift_value[3]\ _03786_ _03787_ VPWR VGND sg13g2_o21ai_1
X_27061_ _03789_ \memory_i.freq_inst.cordic.shift_value[2]\ _03178_ _03336_ \memory_i.freq_inst.cordic.shift_value[3]\ _03179_
+ VPWR
+ VGND sg13g2_a221oi_1
X_27062_ _03790_ _13170_ _03770_ VPWR VGND sg13g2_nor2_1
X_27063_ _03791_ _03715_ _03789_ _03790_ VPWR VGND sg13g2_a21oi_1
X_27064_ _03792_ _03661_ _03788_ _03791_ _03714_ VPWR
+ VGND
+ sg13g2_a22oi_1
X_27065_ _03793_ \memory_i.freq_inst.cordic.roc_in_Z[19]\ \memory_i.freq_inst.Z_o[19]\ _03669_ VPWR VGND sg13g2_mux2_1
X_27066_ _03794_ _03792_ _03793_ VPWR VGND sg13g2_xor2_1
X_27067_ _03795_ _03785_ _03794_ VPWR VGND sg13g2_xnor2_1
X_27068_ _01496_ _03657_ _03795_ VPWR VGND sg13g2_nor2_1
X_27069_ _03796_ _03792_ VPWR VGND sg13g2_inv_1
X_27070_ _03797_ _03796_ _03793_ VPWR VGND sg13g2_nand2_1
X_27071_ _03798_ _03796_ _03793_ VPWR VGND sg13g2_nor2_1
X_27072_ _03799_ _03785_ _03797_ _03798_ VPWR VGND sg13g2_a21o_1
X_27073_ _03800_ \memory_i.freq_inst.Z_o[29]\ _03679_ VPWR VGND sg13g2_nor2_1
X_27074_ _03801_ _03790_ _03800_ VPWR VGND sg13g2_nand2b_1
X_27075_ _03802_ _03801_ VPWR VGND sg13g2_buf_1
X_27076_ _03803_ \memory_i.freq_inst.cordic.shift_value[0]\ _03498_ VPWR VGND sg13g2_nand2_1
X_27077_ _03804_ _03362_ VPWR VGND sg13g2_buf_1
X_27078_ _03805_ _03421_ _03803_ _03804_ VPWR VGND sg13g2_a21oi_1
X_27079_ _03806_ _03802_ _03805_ VPWR VGND sg13g2_xnor2_1
X_27080_ _03807_ \memory_i.freq_inst.cordic.roc_in_Z[20]\ \memory_i.freq_inst.Z_o[20]\ _03669_ VPWR VGND sg13g2_mux2_1
X_27081_ _03808_ _03806_ _03807_ VPWR VGND sg13g2_xnor2_1
X_27082_ _03809_ _03799_ _03808_ VPWR VGND sg13g2_xnor2_1
X_27083_ _01497_ _03657_ _03809_ VPWR VGND sg13g2_nor2_1
X_27084_ _03810_ _12945_ VPWR VGND sg13g2_buf_1
X_27085_ _03811_ _13168_ _03373_ VPWR VGND sg13g2_nor2_1
X_27086_ _03812_ _03331_ _03804_ _03811_ VPWR VGND sg13g2_nor3_1
X_27087_ _03813_ _03802_ _03812_ VPWR VGND sg13g2_xnor2_1
X_27088_ _03814_ \memory_i.freq_inst.cordic.roc_in_Z[21]\ \memory_i.freq_inst.Z_o[21]\ _03669_ VPWR VGND sg13g2_mux2_1
X_27089_ _03815_ _03813_ _03814_ VPWR VGND sg13g2_nand2_1
X_27090_ _03816_ _03813_ _03814_ VPWR VGND sg13g2_nor2_1
X_27091_ _03817_ _03816_ VPWR VGND sg13g2_inv_1
X_27092_ _03818_ _03806_ _03807_ VPWR VGND sg13g2_nand2_1
X_27093_ _03819_ _03806_ _03807_ VPWR VGND sg13g2_nor2_1
X_27094_ _03820_ _03799_ _03818_ _03819_ VPWR VGND sg13g2_a21oi_1
X_27095_ _03821_ _03815_ _03817_ _03820_ VPWR VGND sg13g2_a21oi_1
X_27096_ _03822_ _03820_ _03815_ _03817_ VPWR VGND sg13g2_and3_1
X_27097_ _01498_ _03810_ _03821_ _03822_ VPWR VGND sg13g2_nor3_1
X_27098_ _03823_ _03818_ _03815_ VPWR VGND sg13g2_and2_1
X_27099_ _03824_ _03797_ _03823_ VPWR VGND sg13g2_and2_1
X_27100_ _03825_ _03798_ _03823_ VPWR VGND sg13g2_and2_1
X_27101_ _03826_ _03819_ _03815_ _03824_ _03785_ _03825_
+ VPWR
+ VGND sg13g2_a221oi_1
X_27102_ _03827_ _03817_ _03826_ VPWR VGND sg13g2_nand2_1
X_27103_ _03828_ \memory_i.freq_inst.cordic.shift_value[2]\ _03593_ _03420_ VPWR VGND sg13g2_a21oi_1
X_27104_ _03829_ _03804_ _03828_ VPWR VGND sg13g2_nor2_1
X_27105_ _03830_ _03802_ _03829_ VPWR VGND sg13g2_xnor2_1
X_27106_ _03831_ _03669_ VPWR VGND sg13g2_buf_1
X_27107_ _03832_ \memory_i.freq_inst.cordic.roc_in_Z[22]\ \memory_i.freq_inst.Z_o[22]\ _03831_ VPWR VGND sg13g2_mux2_1
X_27108_ _03833_ _03832_ VPWR VGND sg13g2_buf_1
X_27109_ _03834_ _03830_ _03833_ VPWR VGND sg13g2_xnor2_1
X_27110_ _03835_ _03827_ _03834_ VPWR VGND sg13g2_xnor2_1
X_27111_ _01499_ _03657_ _03835_ VPWR VGND sg13g2_nor2_1
X_27112_ _03836_ _03830_ _03833_ VPWR VGND sg13g2_nor2_1
X_27113_ _03837_ _03816_ _03836_ VPWR VGND sg13g2_nor2_1
X_27114_ _03838_ _03830_ _03833_ _03837_ _03826_ VPWR
+ VGND
+ sg13g2_a22oi_1
X_27115_ _03839_ _03347_ VPWR VGND sg13g2_buf_1
X_27116_ _03840_ _03391_ _03523_ _03839_ VPWR VGND sg13g2_o21ai_1
X_27117_ _03841_ \memory_i.freq_inst.cordic.shift_value[1]\ _03840_ VPWR VGND sg13g2_nor2_1
X_27118_ _03842_ _03802_ _03841_ VPWR VGND sg13g2_xnor2_1
X_27119_ _03843_ \memory_i.freq_inst.cordic.roc_in_Z[23]\ \memory_i.freq_inst.Z_o[23]\ _03831_ VPWR VGND sg13g2_mux2_1
X_27120_ _03844_ _03842_ _03843_ VPWR VGND sg13g2_nand2_1
X_27121_ _03845_ _03842_ _03843_ VPWR VGND sg13g2_or2_1
X_27122_ _03846_ _03844_ _03845_ VPWR VGND sg13g2_nand2_1
X_27123_ _03847_ _03838_ _03846_ VPWR VGND sg13g2_xnor2_1
X_27124_ _01500_ _03657_ _03847_ VPWR VGND sg13g2_nor2_1
X_27125_ _03848_ _03845_ VPWR VGND sg13g2_inv_1
X_27126_ _03849_ _03838_ _03848_ _03844_ VPWR VGND sg13g2_o21ai_1
X_27127_ _03850_ \memory_i.freq_inst.Z_o[24]\ _03831_ VPWR VGND sg13g2_and2_1
X_27128_ _03851_ \memory_i.freq_inst.cordic.roc_in_Z[24]\ _03679_ _03850_ VPWR VGND sg13g2_a21oi_1
X_27129_ _03852_ _03714_ VPWR VGND sg13g2_buf_2
X_27130_ _03853_ \memory_i.freq_inst.cordic.shift_value[3]\ \memory_i.freq_inst.cordic.shift_value[2]\ _03593_ _03480_ VPWR
+ VGND
+ sg13g2_nor4_1
X_27131_ _03854_ \memory_i.freq_inst.cordic.shift_value[4]\ _03853_ _03771_ VPWR VGND sg13g2_o21ai_1
X_27132_ _03855_ \memory_i.freq_inst.cordic.shift_value[0]\ _03661_ _03420_ VPWR VGND sg13g2_nand3_1
X_27133_ _03856_ \memory_i.freq_inst.cordic.shift_value[4]\ _03425_ VPWR VGND sg13g2_nand2_1
X_27134_ _03857_ _03855_ _03856_ VPWR VGND sg13g2_nand2_1
X_27135_ _03858_ _03852_ _03854_ _03857_ _03189_ VPWR
+ VGND
+ sg13g2_a22oi_1
X_27136_ _03859_ _03858_ VPWR VGND sg13g2_buf_1
X_27137_ _03860_ _03851_ _03859_ VPWR VGND sg13g2_xor2_1
X_27138_ _03861_ _03849_ _03860_ VPWR VGND sg13g2_xnor2_1
X_27139_ _01501_ _03657_ _03861_ VPWR VGND sg13g2_nor2_1
X_27140_ _03862_ _03830_ _03833_ VPWR VGND sg13g2_nand2_1
X_27141_ _03863_ _03851_ _03859_ VPWR VGND sg13g2_or2_1
X_27142_ _03864_ _03862_ _03844_ _03863_ VPWR VGND sg13g2_nand3_1
X_27143_ _03865_ _03826_ _03837_ _03864_ VPWR VGND sg13g2_a21oi_1
X_27144_ _03866_ _03851_ _03859_ VPWR VGND sg13g2_and2_1
X_27145_ _03867_ _03848_ _03863_ _03866_ VPWR VGND sg13g2_a21oi_1
X_27146_ _03868_ _03865_ _03867_ VPWR VGND sg13g2_nand2b_1
X_27147_ _03869_ \memory_i.freq_inst.cordic.shift_value[4]\ _03414_ _03604_ _03839_ \memory_i.freq_inst.Z_o[29]\
+ VPWR
+ VGND sg13g2_a221oi_1
X_27148_ _03870_ \memory_i.freq_inst.Z_o[29]\ _03420_ _03648_ VPWR VGND sg13g2_nand3_1
X_27149_ _03871_ _03856_ _03870_ \memory_i.freq_inst.cordic.shift_value[3]\ VPWR VGND sg13g2_a21oi_1
X_27150_ _03872_ _03869_ _03871_ VPWR VGND sg13g2_nor2_1
X_27151_ _03873_ \memory_i.freq_inst.cordic.roc_in_Z[25]\ \memory_i.freq_inst.Z_o[25]\ _03831_ VPWR VGND sg13g2_mux2_1
X_27152_ _03874_ _03872_ _03873_ VPWR VGND sg13g2_nor2b_1
X_27153_ _03875_ _03869_ _03871_ _03873_ VPWR VGND sg13g2_or3_1
X_27154_ _03876_ _03875_ VPWR VGND sg13g2_inv_1
X_27155_ _03877_ _03874_ _03876_ VPWR VGND sg13g2_nor2_1
X_27156_ _03878_ _03868_ _03877_ VPWR VGND sg13g2_xor2_1
X_27157_ _01502_ _03657_ _03878_ VPWR VGND sg13g2_nor2_1
X_27158_ _03879_ _03656_ VPWR VGND sg13g2_buf_1
X_27159_ _03880_ _03874_ VPWR VGND sg13g2_inv_1
X_27160_ _03881_ _03868_ _03876_ _03880_ VPWR VGND sg13g2_o21ai_1
X_27161_ _03882_ _03881_ VPWR VGND sg13g2_buf_2
X_27162_ _03883_ _13168_ _03618_ _03804_ VPWR VGND sg13g2_nor3_1
X_27163_ _03884_ _03802_ _03883_ VPWR VGND sg13g2_xnor2_1
X_27164_ _03885_ \memory_i.freq_inst.cordic.roc_in_Z[26]\ \memory_i.freq_inst.Z_o[26]\ _03831_ VPWR VGND sg13g2_mux2_1
X_27165_ _03886_ _03885_ VPWR VGND sg13g2_buf_1
X_27166_ _03887_ _03884_ _03886_ VPWR VGND sg13g2_xor2_1
X_27167_ _03888_ _03882_ _03887_ VPWR VGND sg13g2_xnor2_1
X_27168_ _01503_ _03879_ _03888_ VPWR VGND sg13g2_nor2_1
X_27169_ _03889_ _03882_ _03884_ _03886_ VPWR VGND sg13g2_a21oi_1
X_27170_ _03890_ _03882_ _03884_ VPWR VGND sg13g2_nor2_1
X_27171_ _03891_ \memory_i.freq_inst.Z_o[27]\ _03802_ VPWR VGND sg13g2_xnor2_1
X_27172_ _03892_ _03831_ _03891_ VPWR VGND sg13g2_nand2_1
X_27173_ _03893_ \memory_i.freq_inst.cordic.roc_in_Z[27]\ _03831_ _03892_ VPWR VGND sg13g2_o21ai_1
X_27174_ _03894_ _03889_ _03890_ _03893_ VPWR VGND sg13g2_o21ai_1
X_27175_ _03895_ _03893_ _03889_ _03890_ VPWR VGND sg13g2_or3_1
X_27176_ _01504_ _03894_ _03895_ _03436_ VPWR VGND sg13g2_a21oi_1
X_27177_ _03896_ \memory_i.freq_inst.Z_o[27]\ VPWR VGND sg13g2_inv_1
X_27178_ _03897_ _03884_ _03886_ VPWR VGND sg13g2_nand2_1
X_27179_ _03898_ _03896_ _03802_ _03897_ VPWR VGND sg13g2_o21ai_1
X_27180_ _03899_ _03884_ _03886_ VPWR VGND sg13g2_nor2_1
X_27181_ _03900_ _03802_ _03899_ _03896_ VPWR VGND sg13g2_a21o_1
X_27182_ _03901_ _03802_ _03899_ _03900_ VPWR VGND sg13g2_o21ai_1
X_27183_ _03902_ _03882_ _03898_ _03901_ VPWR VGND sg13g2_o21ai_1
X_27184_ _03903_ \memory_i.freq_inst.Z_o[28]\ _03802_ VPWR VGND sg13g2_xor2_1
X_27185_ _03904_ _03831_ _03903_ VPWR VGND sg13g2_nand2_1
X_27186_ _03905_ _03902_ _03904_ VPWR VGND sg13g2_nand2b_1
X_27187_ _03906_ \memory_i.freq_inst.cordic.roc_in_Z[12]\ \memory_i.freq_inst.cordic.roc_in_Z[7]\ \memory_i.freq_inst.cordic.roc_in_Z[6]\ \memory_i.freq_inst.cordic.roc_in_Z[4]\ VPWR
+ VGND
+ sg13g2_nor4_1
X_27188_ _03907_ \memory_i.freq_inst.cordic.roc_in_Z[11]\ \memory_i.freq_inst.cordic.roc_in_Z[10]\ \memory_i.freq_inst.cordic.roc_in_Z[9]\ \memory_i.freq_inst.cordic.roc_in_Z[8]\ VPWR
+ VGND
+ sg13g2_nor4_1
X_27189_ _03908_ _03906_ _03907_ VPWR VGND sg13g2_nand2_1
X_27190_ _03909_ \memory_i.freq_inst.cordic.roc_in_Z[27]\ \memory_i.freq_inst.cordic.roc_in_Z[26]\ \memory_i.freq_inst.cordic.roc_in_Z[25]\ \memory_i.freq_inst.cordic.roc_in_Z[5]\ VPWR
+ VGND
+ sg13g2_nor4_1
X_27191_ _03910_ \memory_i.freq_inst.cordic.roc_in_Z[3]\ \memory_i.freq_inst.cordic.roc_in_Z[2]\ \memory_i.freq_inst.cordic.roc_in_Z[1]\ \memory_i.freq_inst.cordic.roc_in_Z[0]\ VPWR
+ VGND
+ sg13g2_nor4_1
X_27192_ _03911_ _03909_ _03910_ VPWR VGND sg13g2_nand2_1
X_27193_ _03912_ \memory_i.freq_inst.cordic.roc_in_Z[29]\ \memory_i.freq_inst.cordic.roc_in_Z[28]\ VPWR VGND sg13g2_nor2b_2
X_27194_ _03913_ _03912_ VPWR VGND sg13g2_buf_4
X_27195_ _03914_ \memory_i.freq_inst.cordic.roc_in_Z[19]\ \memory_i.freq_inst.cordic.roc_in_Z[18]\ \memory_i.freq_inst.cordic.roc_in_Z[17]\ \memory_i.freq_inst.cordic.roc_in_Z[13]\ VPWR
+ VGND
+ sg13g2_nor4_1
X_27196_ _03915_ \memory_i.freq_inst.cordic.roc_in_Z[24]\ \memory_i.freq_inst.cordic.roc_in_Z[23]\ \memory_i.freq_inst.cordic.roc_in_Z[22]\ \memory_i.freq_inst.cordic.roc_in_Z[21]\ VPWR
+ VGND
+ sg13g2_nor4_1
X_27197_ _03916_ \memory_i.freq_inst.cordic.roc_in_Z[20]\ \memory_i.freq_inst.cordic.roc_in_Z[16]\ \memory_i.freq_inst.cordic.roc_in_Z[15]\ \memory_i.freq_inst.cordic.roc_in_Z[14]\ VPWR
+ VGND
+ sg13g2_nor4_1
X_27198_ _03917_ _03913_ _03914_ _03915_ _03916_ VPWR
+ VGND
+ sg13g2_nand4_1
X_27199_ _03918_ _03908_ _03911_ _03917_ VPWR VGND sg13g2_nor3_2
X_27200_ _03919_ _03918_ VPWR VGND sg13g2_buf_2
X_27201_ _03920_ \memory_i.freq_inst.cordic.roc_in_Z[27]\ _03919_ _03679_ VPWR VGND sg13g2_o21ai_1
X_27202_ _03921_ _03904_ _03920_ VPWR VGND sg13g2_nand2_1
X_27203_ _03922_ _03902_ _03921_ VPWR VGND sg13g2_nand2_1
X_27204_ _01505_ \memory_i.freq_inst.cordic.rstn_i\ _03905_ _03922_ VPWR VGND sg13g2_and3_1
X_27205_ _03923_ \memory_i.freq_inst.Z_o[28]\ _03790_ _03800_ VPWR VGND sg13g2_o21ai_1
X_27206_ _01506_ \memory_i.freq_inst.cordic.rstn_i\ _03920_ _03905_ _03923_ VPWR
+ VGND
+ sg13g2_and4_1
X_27207_ _03924_ _03908_ _03911_ _03917_ VPWR VGND sg13g2_or3_1
X_27208_ _03925_ _03924_ VPWR VGND sg13g2_buf_4
X_27209_ _03926_ \memory_i.freq_inst.cordic.roc_in_Z[28]\ \memory_i.freq_inst.cordic.roc_in_Z[29]\ VPWR VGND sg13g2_nand2b_1
X_27210_ _03927_ _03926_ VPWR VGND sg13g2_buf_1
X_27211_ _03928_ _03677_ _03927_ VPWR VGND sg13g2_nand2_1
X_27212_ _03929_ _03913_ _03925_ _03928_ VPWR VGND sg13g2_a21oi_1
X_27213_ _03930_ _03929_ VPWR VGND sg13g2_buf_4
X_27214_ _03931_ \memory_i.freq_inst.X_o[29]\ _03349_ _03930_ \memory_i.freq_inst.cordic.roc_in_X[29]\ VPWR
+ VGND
+ sg13g2_a22oi_1
X_27215_ _03932_ _03931_ VPWR VGND sg13g2_buf_2
X_27216_ _03933_ \memory_i.freq_inst.X_o[28]\ _03349_ _03930_ \memory_i.freq_inst.cordic.roc_in_X[28]\ VPWR
+ VGND
+ sg13g2_a22oi_1
X_27217_ _03934_ _03933_ VPWR VGND sg13g2_buf_2
X_27218_ _03935_ _03932_ _03934_ _13163_ VPWR VGND sg13g2_mux2_1
X_27219_ _03936_ _03935_ VPWR VGND sg13g2_buf_2
X_27220_ _03937_ \memory_i.freq_inst.cordic.roc_in_X[29]\ VPWR VGND sg13g2_inv_1
X_27221_ _03938_ _03913_ _03925_ _03928_ VPWR VGND sg13g2_a21o_1
X_27222_ _03939_ _03938_ VPWR VGND sg13g2_buf_2
X_27223_ _03940_ _03349_ VPWR VGND sg13g2_buf_4
X_27224_ _03941_ \memory_i.freq_inst.X_o[29]\ _03940_ VPWR VGND sg13g2_nand2_1
X_27225_ _03942_ _03937_ _03939_ _03941_ VPWR VGND sg13g2_o21ai_1
X_27226_ _03943_ _03942_ VPWR VGND sg13g2_buf_2
X_27227_ _03944_ _03640_ _03943_ VPWR VGND sg13g2_nor2_1
X_27228_ _03945_ _03640_ _03936_ _03944_ VPWR VGND sg13g2_a21o_1
X_27229_ _03946_ _03945_ VPWR VGND sg13g2_buf_1
X_27230_ _03947_ _03719_ VPWR VGND sg13g2_buf_2
X_27231_ _03948_ _03947_ _03946_ VPWR VGND sg13g2_nand2_1
X_27232_ _03949_ _03349_ VPWR VGND sg13g2_buf_2
X_27233_ _03950_ _03930_ VPWR VGND sg13g2_buf_16
X_27234_ _03951_ \memory_i.freq_inst.X_o[27]\ _03949_ _03950_ \memory_i.freq_inst.cordic.roc_in_X[27]\ VPWR
+ VGND
+ sg13g2_a22oi_1
X_27235_ _03952_ _03951_ VPWR VGND sg13g2_buf_4
X_27236_ _03953_ _03934_ _03952_ _13164_ VPWR VGND sg13g2_mux2_1
X_27237_ _03954_ _03640_ _03953_ _03944_ VPWR VGND sg13g2_a21o_1
X_27238_ _03955_ _03954_ VPWR VGND sg13g2_buf_1
X_27239_ _03956_ _03932_ VPWR VGND sg13g2_buf_1
X_27240_ _03957_ _03956_ VPWR VGND sg13g2_buf_4
X_27241_ _03958_ _03804_ _03957_ VPWR VGND sg13g2_nand2_1
X_27242_ _03959_ \memory_i.freq_inst.X_o[26]\ _03349_ _03950_ \memory_i.freq_inst.cordic.roc_in_X[26]\ VPWR
+ VGND
+ sg13g2_a22oi_1
X_27243_ _03960_ _03959_ VPWR VGND sg13g2_buf_4
X_27244_ _03961_ _13163_ VPWR VGND sg13g2_buf_2
X_27245_ _03962_ _03961_ VPWR VGND sg13g2_buf_1
X_27246_ _03963_ _03932_ _03934_ _03952_ _03960_ _03962_
+ _03175_
+ VPWR VGND sg13g2_mux4_1
X_27247_ _03964_ _03956_ _03963_ _03193_ VPWR VGND sg13g2_mux2_1
X_27248_ _03965_ _03839_ _03964_ VPWR VGND sg13g2_nand2_1
X_27249_ _03966_ _03958_ _03965_ VPWR VGND sg13g2_nand2_1
X_27250_ _03967_ _03966_ VPWR VGND sg13g2_buf_2
X_27251_ _03968_ \memory_i.freq_inst.X_o[25]\ _03949_ _03950_ \memory_i.freq_inst.cordic.roc_in_X[25]\ VPWR
+ VGND
+ sg13g2_a22oi_1
X_27252_ _03969_ _03968_ VPWR VGND sg13g2_buf_2
X_27253_ _03970_ _03934_ _03952_ _03960_ _03969_ _03961_
+ _03174_
+ VPWR VGND sg13g2_mux4_1
X_27254_ _03971_ _03475_ _03943_ VPWR VGND sg13g2_nor2_1
X_27255_ _03972_ _03475_ _03970_ _03971_ VPWR VGND sg13g2_a21oi_1
X_27256_ _03973_ \memory_i.freq_inst.X_o[24]\ _03349_ _03950_ \memory_i.freq_inst.cordic.roc_in_X[24]\ VPWR
+ VGND
+ sg13g2_a22oi_1
X_27257_ _03974_ _03973_ VPWR VGND sg13g2_buf_2
X_27258_ _03975_ _03930_ VPWR VGND sg13g2_buf_8
X_27259_ _03976_ \memory_i.freq_inst.X_o[23]\ _03350_ _03975_ \memory_i.freq_inst.cordic.roc_in_X[23]\ VPWR
+ VGND
+ sg13g2_a22oi_1
X_27260_ _03977_ _03976_ VPWR VGND sg13g2_buf_4
X_27261_ _03978_ \memory_i.freq_inst.X_o[22]\ _03350_ _03975_ \memory_i.freq_inst.cordic.roc_in_X[22]\ VPWR
+ VGND
+ sg13g2_a22oi_1
X_27262_ _03979_ _03978_ VPWR VGND sg13g2_buf_4
X_27263_ _03980_ \memory_i.freq_inst.X_o[21]\ _03949_ _03975_ \memory_i.freq_inst.cordic.roc_in_X[21]\ VPWR
+ VGND
+ sg13g2_a22oi_1
X_27264_ _03981_ _03980_ VPWR VGND sg13g2_buf_4
X_27265_ _03982_ _03174_ VPWR VGND sg13g2_buf_2
X_27266_ _03983_ _03974_ _03977_ _03979_ _03981_ _03961_
+ _03982_
+ VPWR VGND sg13g2_mux4_1
X_27267_ _03984_ _03983_ _03970_ \memory_i.freq_inst.cordic.shift_value[2]\ VPWR VGND sg13g2_mux2_1
X_27268_ _03985_ _03984_ VPWR VGND sg13g2_buf_2
X_27269_ _03986_ _03184_ _03943_ VPWR VGND sg13g2_nor2_1
X_27270_ _03987_ _03188_ _03985_ _03986_ VPWR VGND sg13g2_a21o_1
X_27271_ _03988_ \memory_i.freq_inst.cordic.roc_in_X[27]\ VPWR VGND sg13g2_inv_1
X_27272_ _03989_ \memory_i.freq_inst.X_o[27]\ _03351_ VPWR VGND sg13g2_nand2_1
X_27273_ _03990_ _03988_ _03939_ _03989_ VPWR VGND sg13g2_o21ai_1
X_27274_ _03991_ _03990_ VPWR VGND sg13g2_buf_1
X_27275_ _03992_ \memory_i.freq_inst.cordic.roc_in_X[26]\ VPWR VGND sg13g2_inv_1
X_27276_ _03993_ \memory_i.freq_inst.X_o[26]\ _03352_ VPWR VGND sg13g2_nand2_1
X_27277_ _03994_ _03992_ _03939_ _03993_ VPWR VGND sg13g2_o21ai_1
X_27278_ _03995_ \memory_i.freq_inst.cordic.roc_in_X[25]\ VPWR VGND sg13g2_inv_1
X_27279_ _03996_ \memory_i.freq_inst.X_o[25]\ _03351_ VPWR VGND sg13g2_nand2_1
X_27280_ _03997_ _03995_ _03939_ _03996_ VPWR VGND sg13g2_o21ai_1
X_27281_ _03998_ \memory_i.freq_inst.cordic.roc_in_X[24]\ VPWR VGND sg13g2_inv_1
X_27282_ _03999_ _03351_ VPWR VGND sg13g2_buf_2
X_27283_ _04000_ \memory_i.freq_inst.X_o[24]\ _03999_ VPWR VGND sg13g2_nand2_1
X_27284_ _04001_ _03998_ _03939_ _04000_ VPWR VGND sg13g2_o21ai_1
X_27285_ _04002_ _03991_ _03994_ _03997_ _04001_ _13165_
+ _03176_
+ VPWR VGND sg13g2_mux4_1
X_27286_ _04003_ \memory_i.freq_inst.cordic.roc_in_X[23]\ VPWR VGND sg13g2_inv_1
X_27287_ _04004_ _03940_ VPWR VGND sg13g2_buf_2
X_27288_ _04005_ \memory_i.freq_inst.X_o[23]\ _04004_ VPWR VGND sg13g2_nand2_1
X_27289_ _04006_ _04003_ _03939_ _04005_ VPWR VGND sg13g2_o21ai_1
X_27290_ _04007_ \memory_i.freq_inst.cordic.roc_in_X[22]\ VPWR VGND sg13g2_inv_1
X_27291_ _04008_ _03939_ VPWR VGND sg13g2_buf_2
X_27292_ _04009_ \memory_i.freq_inst.X_o[22]\ _03999_ VPWR VGND sg13g2_nand2_1
X_27293_ _04010_ _04007_ _04008_ _04009_ VPWR VGND sg13g2_o21ai_1
X_27294_ _04011_ \memory_i.freq_inst.cordic.roc_in_X[21]\ VPWR VGND sg13g2_inv_1
X_27295_ _04012_ \memory_i.freq_inst.X_o[21]\ _03352_ VPWR VGND sg13g2_nand2_1
X_27296_ _04013_ _04011_ _03939_ _04012_ VPWR VGND sg13g2_o21ai_1
X_27297_ _04014_ \memory_i.freq_inst.cordic.roc_in_X[20]\ VPWR VGND sg13g2_inv_1
X_27298_ _04015_ \memory_i.freq_inst.X_o[20]\ _04004_ VPWR VGND sg13g2_nand2_1
X_27299_ _04016_ _04014_ _03939_ _04015_ VPWR VGND sg13g2_o21ai_1
X_27300_ _04017_ _04006_ _04010_ _04013_ _04016_ _13165_
+ _03176_
+ VPWR VGND sg13g2_mux4_1
X_27301_ _04018_ _04002_ _04017_ _03388_ VPWR VGND sg13g2_mux2_1
X_27302_ _04019_ _03372_ _03943_ VPWR VGND sg13g2_nor2_1
X_27303_ _04020_ _03373_ _03936_ _04019_ VPWR VGND sg13g2_a21oi_1
X_27304_ _04021_ _04018_ _04020_ \memory_i.freq_inst.cordic.shift_value[3]\ VPWR VGND sg13g2_mux2_1
X_27305_ _04022_ \memory_i.freq_inst.cordic.shift_value[4]\ _04021_ VPWR VGND sg13g2_nor2_1
X_27306_ _04023_ \memory_i.freq_inst.cordic.shift_value[4]\ _03957_ _03987_ _04022_ VPWR
+ VGND
+ sg13g2_a22oi_1
X_27307_ _04024_ _03982_ VPWR VGND sg13g2_buf_1
X_27308_ _04025_ _03960_ _03969_ _03974_ _03977_ _03962_
+ _04024_
+ VPWR VGND sg13g2_mux4_1
X_27309_ _04026_ \memory_i.freq_inst.X_o[20]\ _03949_ _03975_ \memory_i.freq_inst.cordic.roc_in_X[20]\ VPWR
+ VGND
+ sg13g2_a22oi_1
X_27310_ _04027_ _04026_ VPWR VGND sg13g2_buf_4
X_27311_ _04028_ \memory_i.freq_inst.X_o[19]\ _03949_ _03950_ \memory_i.freq_inst.cordic.roc_in_X[19]\ VPWR
+ VGND
+ sg13g2_a22oi_1
X_27312_ _04029_ _04028_ VPWR VGND sg13g2_buf_4
X_27313_ _04030_ _03979_ _03981_ _04027_ _04029_ _03962_
+ _03175_
+ VPWR VGND sg13g2_mux4_1
X_27314_ _04031_ _04025_ _04030_ _03193_ VPWR VGND sg13g2_mux2_1
X_27315_ _04032_ _03372_ _03953_ _04019_ VPWR VGND sg13g2_a21o_1
X_27316_ _04033_ _04031_ _04032_ \memory_i.freq_inst.cordic.shift_value[3]\ VPWR VGND sg13g2_mux2_1
X_27317_ _04034_ \memory_i.freq_inst.cordic.shift_value[4]\ _04033_ VPWR VGND sg13g2_nor2_1
X_27318_ _04035_ _03522_ _03956_ VPWR VGND sg13g2_nor2_1
X_27319_ _04036_ _04035_ VPWR VGND sg13g2_buf_1
X_27320_ _04037_ _03969_ _03974_ _03977_ _03979_ _13164_
+ _03175_
+ VPWR VGND sg13g2_mux4_1
X_27321_ _04038_ \memory_i.freq_inst.X_o[18]\ _03949_ _03950_ \memory_i.freq_inst.cordic.roc_in_X[18]\ VPWR
+ VGND
+ sg13g2_a22oi_1
X_27322_ _04039_ _04038_ VPWR VGND sg13g2_buf_4
X_27323_ _04040_ _03981_ _04027_ _04029_ _04039_ _03962_
+ _03175_
+ VPWR VGND sg13g2_mux4_1
X_27324_ _04041_ _03956_ _03963_ _04037_ _04040_ _03193_
+ _03183_
+ VPWR VGND sg13g2_mux4_1
X_27325_ _04042_ \memory_i.freq_inst.cordic.shift_value[4]\ _04041_ VPWR VGND sg13g2_nor2_1
X_27326_ _04043_ _04036_ _04042_ VPWR VGND sg13g2_nor2_1
X_27327_ _04044_ _04043_ VPWR VGND sg13g2_inv_1
X_27328_ _04045_ \memory_i.freq_inst.X_o[17]\ _03949_ _03975_ \memory_i.freq_inst.cordic.roc_in_X[17]\ VPWR
+ VGND
+ sg13g2_a22oi_1
X_27329_ _04046_ _04045_ VPWR VGND sg13g2_buf_4
X_27330_ _04047_ _04027_ _04029_ _04039_ _04046_ _03961_
+ _03174_
+ VPWR VGND sg13g2_mux4_1
X_27331_ _04048_ _03932_ _03983_ _03970_ _04047_ _03182_
+ _03193_
+ VPWR VGND sg13g2_mux4_1
X_27332_ _04049_ \memory_i.freq_inst.cordic.shift_value[4]\ _04048_ VPWR VGND sg13g2_nor2_1
X_27333_ _04050_ _04036_ _04049_ VPWR VGND sg13g2_nor2_1
X_27334_ _04051_ _04050_ VPWR VGND sg13g2_inv_1
X_27335_ _04052_ _03952_ _03960_ _13163_ VPWR VGND sg13g2_mux2_1
X_27336_ _04053_ _03969_ _03974_ _03961_ VPWR VGND sg13g2_mux2_1
X_27337_ _04054_ _03932_ _03936_ _04052_ _04053_ _03982_
+ _03192_
+ VPWR VGND sg13g2_mux4_1
X_27338_ _04055_ _04054_ VPWR VGND sg13g2_buf_2
X_27339_ _04056_ _03977_ _03979_ _03981_ _04027_ _03961_
+ _03174_
+ VPWR VGND sg13g2_mux4_1
X_27340_ _04057_ \memory_i.freq_inst.X_o[16]\ _03949_ _03950_ \memory_i.freq_inst.cordic.roc_in_X[16]\ VPWR
+ VGND
+ sg13g2_a22oi_1
X_27341_ _04058_ _04057_ VPWR VGND sg13g2_buf_4
X_27342_ _04059_ _04029_ _04039_ _04046_ _04058_ _03961_
+ _03174_
+ VPWR VGND sg13g2_mux4_1
X_27343_ _04060_ _04056_ _04059_ _03192_ VPWR VGND sg13g2_mux2_1
X_27344_ _04061_ _04055_ _04060_ _03186_ VPWR VGND sg13g2_mux2_1
X_27345_ _04062_ \memory_i.freq_inst.cordic.shift_value[4]\ _04061_ VPWR VGND sg13g2_nor2_1
X_27346_ _04063_ _04036_ _04062_ VPWR VGND sg13g2_nor2_1
X_27347_ _04064_ _03963_ _04037_ _03194_ VPWR VGND sg13g2_mux2_1
X_27348_ _04065_ _03950_ VPWR VGND sg13g2_buf_8
X_27349_ _04066_ \memory_i.freq_inst.X_o[15]\ _03350_ _04065_ \memory_i.freq_inst.cordic.roc_in_X[15]\ VPWR
+ VGND
+ sg13g2_a22oi_1
X_27350_ _04067_ _04066_ VPWR VGND sg13g2_buf_4
X_27351_ _04068_ \memory_i.freq_inst.X_o[14]\ _03350_ _03975_ \memory_i.freq_inst.cordic.roc_in_X[14]\ VPWR
+ VGND
+ sg13g2_a22oi_1
X_27352_ _04069_ _04068_ VPWR VGND sg13g2_buf_2
X_27353_ _04070_ _04046_ _04058_ _04067_ _04069_ _03962_
+ _03175_
+ VPWR VGND sg13g2_mux4_1
X_27354_ _04071_ _04040_ _04070_ _03194_ VPWR VGND sg13g2_mux2_1
X_27355_ _04072_ \memory_i.freq_inst.X_o[13]\ _03350_ _03975_ \memory_i.freq_inst.cordic.roc_in_X[13]\ VPWR
+ VGND
+ sg13g2_a22oi_1
X_27356_ _04073_ _04072_ VPWR VGND sg13g2_buf_4
X_27357_ _04074_ \memory_i.freq_inst.X_o[12]\ _03949_ _03950_ \memory_i.freq_inst.cordic.roc_in_X[12]\ VPWR
+ VGND
+ sg13g2_a22oi_1
X_27358_ _04075_ _04074_ VPWR VGND sg13g2_buf_2
X_27359_ _04076_ \memory_i.freq_inst.X_o[11]\ _03940_ _04065_ \memory_i.freq_inst.cordic.roc_in_X[11]\ VPWR
+ VGND
+ sg13g2_a22oi_1
X_27360_ _04077_ _04076_ VPWR VGND sg13g2_buf_2
X_27361_ _04078_ \memory_i.freq_inst.X_o[10]\ _03949_ _03975_ \memory_i.freq_inst.cordic.roc_in_X[10]\ VPWR
+ VGND
+ sg13g2_a22oi_1
X_27362_ _04079_ _04078_ VPWR VGND sg13g2_buf_2
X_27363_ _04080_ _04073_ _04075_ _04077_ _04079_ _03962_
+ _03175_
+ VPWR VGND sg13g2_mux4_1
X_27364_ _04081_ \memory_i.freq_inst.X_o[9]\ _03350_ _04065_ \memory_i.freq_inst.cordic.roc_in_X[9]\ VPWR
+ VGND
+ sg13g2_a22oi_1
X_27365_ _04082_ _04081_ VPWR VGND sg13g2_buf_4
X_27366_ _04083_ \memory_i.freq_inst.X_o[8]\ _03350_ _04065_ \memory_i.freq_inst.cordic.roc_in_X[8]\ VPWR
+ VGND
+ sg13g2_a22oi_1
X_27367_ _04084_ _04083_ VPWR VGND sg13g2_buf_4
X_27368_ _04085_ \memory_i.freq_inst.X_o[7]\ _03350_ _03975_ \memory_i.freq_inst.cordic.roc_in_X[7]\ VPWR
+ VGND
+ sg13g2_a22oi_1
X_27369_ _04086_ _04085_ VPWR VGND sg13g2_buf_4
X_27370_ _04087_ \memory_i.freq_inst.X_o[6]\ _03350_ _03975_ \memory_i.freq_inst.cordic.roc_in_X[6]\ VPWR
+ VGND
+ sg13g2_a22oi_1
X_27371_ _04088_ _04087_ VPWR VGND sg13g2_buf_4
X_27372_ _04089_ _04082_ _04084_ _04086_ _04088_ _03962_
+ _04024_
+ VPWR VGND sg13g2_mux4_1
X_27373_ _04090_ _04080_ _04089_ _03195_ VPWR VGND sg13g2_mux2_1
X_27374_ _04091_ _03956_ _04064_ _04071_ _04090_ _03185_
+ _03395_
+ VPWR VGND sg13g2_mux4_1
X_27375_ _04092_ _04091_ VPWR VGND sg13g2_buf_2
X_27376_ _04093_ _04079_ _04082_ _04084_ _04086_ _03962_
+ _04024_
+ VPWR VGND sg13g2_mux4_1
X_27377_ _04094_ \memory_i.freq_inst.X_o[5]\ _03349_ _03950_ \memory_i.freq_inst.cordic.roc_in_X[5]\ VPWR
+ VGND
+ sg13g2_a22oi_1
X_27378_ _04095_ _04094_ VPWR VGND sg13g2_buf_2
X_27379_ _04096_ _04095_ VPWR VGND sg13g2_buf_4
X_27380_ _04097_ \memory_i.freq_inst.X_o[4]\ _03940_ _04065_ \memory_i.freq_inst.cordic.roc_in_X[4]\ VPWR
+ VGND
+ sg13g2_a22oi_1
X_27381_ _04098_ _04097_ VPWR VGND sg13g2_buf_2
X_27382_ _04099_ \memory_i.freq_inst.X_o[3]\ _03940_ _04065_ \memory_i.freq_inst.cordic.roc_in_X[3]\ VPWR
+ VGND
+ sg13g2_a22oi_1
X_27383_ _04100_ _04099_ VPWR VGND sg13g2_buf_2
X_27384_ _04101_ _04088_ _04096_ _04098_ _04100_ _13165_
+ _04024_
+ VPWR VGND sg13g2_mux4_1
X_27385_ _04102_ _04093_ _04101_ _03388_ VPWR VGND sg13g2_mux2_1
X_27386_ _04103_ _04039_ _04046_ _04058_ _04067_ _03962_
+ _03175_
+ VPWR VGND sg13g2_mux4_1
X_27387_ _04104_ _04069_ _04073_ _04075_ _04077_ _03962_
+ _03175_
+ VPWR VGND sg13g2_mux4_1
X_27388_ _04105_ _04103_ _04104_ _03388_ VPWR VGND sg13g2_mux2_1
X_27389_ _04106_ _04031_ _04032_ _04102_ _04105_ \memory_i.freq_inst.cordic.shift_value[3]\
+ _03394_
+ VPWR VGND sg13g2_mux4_1
X_27390_ _04107_ \memory_i.freq_inst.X_o[2]\ _03940_ _04065_ \memory_i.freq_inst.cordic.roc_in_X[2]\ VPWR
+ VGND
+ sg13g2_a22oi_1
X_27391_ _04108_ _04107_ VPWR VGND sg13g2_buf_2
X_27392_ _04109_ _04096_ _04098_ _04100_ _04108_ _13165_
+ _04024_
+ VPWR VGND sg13g2_mux4_1
X_27393_ _04110_ _04070_ _04080_ _04089_ _04109_ _03193_
+ _03183_
+ VPWR VGND sg13g2_mux4_1
X_27394_ _04111_ _04041_ _04110_ _03394_ VPWR VGND sg13g2_mux2_1
X_27395_ _04112_ _04058_ _04067_ _04069_ _04073_ _03961_
+ _03982_
+ VPWR VGND sg13g2_mux4_1
X_27396_ _04113_ _04075_ _04077_ _04079_ _04082_ _13164_
+ _03982_
+ VPWR VGND sg13g2_mux4_1
X_27397_ _04114_ _04084_ _04086_ _04088_ _04096_ _13164_
+ _03982_
+ VPWR VGND sg13g2_mux4_1
X_27398_ _04115_ \memory_i.freq_inst.X_o[1]\ _03940_ _04065_ \memory_i.freq_inst.cordic.roc_in_X[1]\ VPWR
+ VGND
+ sg13g2_a22oi_1
X_27399_ _04116_ _04115_ VPWR VGND sg13g2_buf_1
X_27400_ _04117_ _04098_ _04100_ _04108_ _04116_ _13164_
+ _03982_
+ VPWR VGND sg13g2_mux4_1
X_27401_ _04118_ _04112_ _04113_ _04114_ _04117_ _03192_
+ _03182_
+ VPWR VGND sg13g2_mux4_1
X_27402_ _04119_ _04048_ _04118_ _03394_ VPWR VGND sg13g2_mux2_1
X_27403_ _04120_ _04119_ VPWR VGND sg13g2_buf_2
X_27404_ _04121_ _04067_ _04069_ _04073_ _04075_ _03961_
+ _03174_
+ VPWR VGND sg13g2_mux4_1
X_27405_ _04122_ _04077_ _04079_ _04082_ _04084_ _03961_
+ _03982_
+ VPWR VGND sg13g2_mux4_1
X_27406_ _04123_ _04121_ _04122_ _03192_ VPWR VGND sg13g2_mux2_1
X_27407_ _04124_ _04086_ _04088_ _04095_ _04098_ _13164_
+ _03982_
+ VPWR VGND sg13g2_mux4_1
X_27408_ _04125_ \memory_i.freq_inst.X_o[0]\ _03940_ _04065_ \memory_i.freq_inst.cordic.roc_in_X[0]\ VPWR
+ VGND
+ sg13g2_a22oi_1
X_27409_ _04126_ _04125_ VPWR VGND sg13g2_buf_1
X_27410_ _04127_ _04100_ _04108_ _04116_ _04126_ _13164_
+ _03982_
+ VPWR VGND sg13g2_mux4_1
X_27411_ _04128_ _04124_ _04127_ _03192_ VPWR VGND sg13g2_mux2_1
X_27412_ _04129_ _04055_ _04060_ _04123_ _04128_ _03182_
+ _03330_
+ VPWR VGND sg13g2_mux4_1
X_27413_ _04130_ _04129_ VPWR VGND sg13g2_buf_4
X_27414_ _04131_ _04106_ _04111_ _04120_ _04130_ VPWR
+ VGND
+ sg13g2_and4_1
X_27415_ _04132_ _04131_ VPWR VGND sg13g2_buf_4
X_27416_ _04133_ _04132_ VPWR VGND sg13g2_buf_8
X_27417_ _04134_ _04059_ _04121_ _04122_ _04124_ _03193_
+ _03183_
+ VPWR VGND sg13g2_mux4_1
X_27418_ _04135_ _03395_ _04134_ VPWR VGND sg13g2_nand2_1
X_27419_ _04136_ _04047_ _04112_ _04113_ _04114_ _03388_
+ _03183_
+ VPWR VGND sg13g2_mux4_1
X_27420_ _04137_ _03395_ _04134_ _04136_ VPWR VGND sg13g2_nand3_1
X_27421_ _04138_ _03395_ _04136_ _03985_ _03184_ _03986_
+ VPWR
+ VGND sg13g2_a221oi_1
X_27422_ _04139_ _04135_ _04021_ _04137_ _03395_ _04138_
+ VPWR
+ VGND sg13g2_a221oi_1
X_27423_ _04140_ _04139_ VPWR VGND sg13g2_buf_4
X_27424_ _04141_ _04092_ _04133_ _04140_ VPWR VGND sg13g2_and3_2
X_27425_ _04142_ _04141_ VPWR VGND sg13g2_buf_4
X_27426_ _04143_ _04064_ _04071_ _03184_ VPWR VGND sg13g2_mux2_1
X_27427_ _04144_ \memory_i.freq_inst.cordic.shift_value[4]\ _03943_ VPWR VGND sg13g2_nand2_1
X_27428_ _04145_ _04144_ VPWR VGND sg13g2_buf_1
X_27429_ _04146_ \memory_i.freq_inst.cordic.shift_value[4]\ _04143_ _04145_ VPWR VGND sg13g2_o21ai_1
X_27430_ _04147_ _04146_ VPWR VGND sg13g2_buf_1
X_27431_ _04148_ _04047_ _04112_ _03194_ VPWR VGND sg13g2_mux2_1
X_27432_ _04149_ _04148_ _03985_ \memory_i.freq_inst.cordic.shift_value[3]\ VPWR VGND sg13g2_mux2_1
X_27433_ _04150_ \memory_i.freq_inst.cordic.shift_value[4]\ _04149_ _04145_ VPWR VGND sg13g2_o21ai_1
X_27434_ _04151_ _04150_ VPWR VGND sg13g2_buf_1
X_27435_ _04152_ _04030_ _04103_ _03388_ VPWR VGND sg13g2_mux2_1
X_27436_ _04153_ _03960_ _03969_ _13164_ VPWR VGND sg13g2_mux2_1
X_27437_ _04154_ _03974_ _03977_ _13164_ VPWR VGND sg13g2_mux2_1
X_27438_ _04155_ _03932_ _03953_ _04153_ _04154_ _03175_
+ _03192_
+ VPWR VGND sg13g2_mux4_1
X_27439_ _04156_ _04155_ VPWR VGND sg13g2_buf_2
X_27440_ _04157_ _04104_ _04093_ _03388_ VPWR VGND sg13g2_mux2_1
X_27441_ _04158_ _03956_ _04152_ _04156_ _04157_ _03394_
+ _03184_
+ VPWR VGND sg13g2_mux4_1
X_27442_ _04159_ _04158_ VPWR VGND sg13g2_buf_4
X_27443_ _04160_ _03956_ _04055_ _04060_ _04123_ _03183_
+ _03394_
+ VPWR VGND sg13g2_mux4_1
X_27444_ _04161_ _04160_ VPWR VGND sg13g2_buf_1
X_27445_ _04162_ _03475_ _03970_ _03971_ VPWR VGND sg13g2_a21o_1
X_27446_ _04163_ _03983_ _04047_ _04112_ _04113_ _03388_
+ _03183_
+ VPWR VGND sg13g2_mux4_1
X_27447_ _04164_ _04162_ _04163_ _03394_ VPWR VGND sg13g2_mux2_1
X_27448_ _04165_ _04164_ VPWR VGND sg13g2_buf_2
X_27449_ _04166_ _04159_ _04161_ _04165_ VPWR VGND sg13g2_nand3_1
X_27450_ _04167_ _03952_ _03960_ _03969_ _03974_ _13165_
+ _03176_
+ VPWR VGND sg13g2_mux4_1
X_27451_ _04168_ _04167_ _04056_ _04059_ _04121_ _03194_
+ _03184_
+ VPWR VGND sg13g2_mux4_1
X_27452_ _04169_ _03946_ _04168_ _03395_ VPWR VGND sg13g2_mux2_1
X_27453_ _04170_ _04037_ _04040_ _03193_ VPWR VGND sg13g2_mux2_1
X_27454_ _04171_ _04070_ _04080_ _03193_ VPWR VGND sg13g2_mux2_1
X_27455_ _04172_ _03956_ _03964_ _04170_ _04171_ _03183_
+ _03394_
+ VPWR VGND sg13g2_mux4_1
X_27456_ _04173_ _04172_ VPWR VGND sg13g2_buf_2
X_27457_ _04174_ _04025_ _04030_ _04103_ _04104_ _03194_
+ _03183_
+ VPWR VGND sg13g2_mux4_1
X_27458_ _04175_ _03955_ _04174_ _03395_ VPWR VGND sg13g2_mux2_1
X_27459_ _04176_ _04169_ _04173_ _04175_ VPWR VGND sg13g2_nand3_1
X_27460_ _04177_ _04176_ VPWR VGND sg13g2_buf_1
X_27461_ _04178_ _04147_ _04151_ _04166_ _04177_ VPWR
+ VGND
+ sg13g2_nor4_1
X_27462_ _04179_ _04152_ _04156_ \memory_i.freq_inst.cordic.shift_value[3]\ VPWR VGND sg13g2_mux2_1
X_27463_ _04180_ \memory_i.freq_inst.cordic.shift_value[4]\ _04179_ _04145_ VPWR VGND sg13g2_o21ai_1
X_27464_ _04181_ _04180_ VPWR VGND sg13g2_buf_1
X_27465_ _04182_ _04181_ VPWR VGND sg13g2_inv_1
X_27466_ _04183_ _04063_ _04142_ _04178_ _04182_ VPWR
+ VGND
+ sg13g2_nand4_1
X_27467_ _04184_ _04034_ _04044_ _04051_ _04183_ VPWR
+ VGND
+ sg13g2_nor4_2
X_27468_ _04185_ _04023_ _04184_ VPWR VGND sg13g2_nand2b_1
X_27469_ _04186_ _03839_ _04064_ VPWR VGND sg13g2_nand2_1
X_27470_ _04187_ _03958_ _04186_ VPWR VGND sg13g2_nand2_1
X_27471_ _04188_ _04185_ _04187_ VPWR VGND sg13g2_nor2b_1
X_27472_ _04189_ _03839_ _04055_ _04156_ VPWR VGND sg13g2_nand3_1
X_27473_ _04190_ _03958_ _04189_ VPWR VGND sg13g2_nand2_1
X_27474_ _04191_ _04188_ _04190_ VPWR VGND sg13g2_nand2_1
X_27475_ _04192_ _03715_ _03972_ _04191_ VPWR VGND sg13g2_a21oi_1
X_27476_ _04193_ _03967_ _04192_ VPWR VGND sg13g2_and2_1
X_27477_ _04194_ _04193_ VPWR VGND sg13g2_buf_1
X_27478_ _04195_ _03955_ _04194_ VPWR VGND sg13g2_nand2_1
X_27479_ _04196_ _03946_ _03948_ _04195_ VPWR VGND sg13g2_mux2_1
X_27480_ _04197_ \memory_i.freq_inst.cordic.shift_value[4]\ _03946_ _04145_ VPWR VGND sg13g2_o21ai_1
X_27481_ _04198_ _03643_ _03957_ VPWR VGND sg13g2_nand2_1
X_27482_ _04199_ _03943_ _04194_ VPWR VGND sg13g2_nand2_1
X_27483_ _04200_ _04198_ _04194_ _04199_ VPWR VGND sg13g2_o21ai_1
X_27484_ _04201_ _03852_ _04197_ _04200_ \memory_i.freq_inst.cordic.shift_value[4]\ VPWR
+ VGND
+ sg13g2_a22oi_1
X_27485_ _04202_ \memory_i.freq_inst.cordic.shift_value[4]\ _04196_ _04201_ VPWR VGND sg13g2_o21ai_1
X_27486_ _04203_ _04202_ VPWR VGND sg13g2_inv_1
X_27487_ _04204_ \memory_i.freq_inst.cordic.roc_in_Z[29]\ VPWR VGND sg13g2_inv_1
X_27488_ _04205_ _04204_ \memory_i.freq_inst.cordic.roc_in_Z[28]\ VPWR VGND sg13g2_nor2_1
X_27489_ _04206_ _04205_ VPWR VGND sg13g2_buf_1
X_27490_ _04207_ _03677_ _04206_ VPWR VGND sg13g2_nand2_1
X_27491_ _04208_ _04207_ VPWR VGND sg13g2_buf_2
X_27492_ _04209_ \memory_i.freq_inst.cordic.roc_in_X[19]\ \memory_i.freq_inst.cordic.roc_in_X[18]\ VPWR VGND sg13g2_nor2_1
X_27493_ _04210_ \memory_i.freq_inst.cordic.roc_in_X[2]\ \memory_i.freq_inst.cordic.roc_in_X[1]\ \memory_i.freq_inst.cordic.roc_in_X[0]\ VPWR VGND sg13g2_or3_1
X_27494_ _04211_ _04210_ VPWR VGND sg13g2_buf_4
X_27495_ _04212_ \memory_i.freq_inst.cordic.roc_in_X[5]\ \memory_i.freq_inst.cordic.roc_in_X[4]\ \memory_i.freq_inst.cordic.roc_in_X[3]\ VPWR VGND sg13g2_or3_1
X_27496_ _04213_ _04212_ VPWR VGND sg13g2_buf_2
X_27497_ _04214_ \memory_i.freq_inst.cordic.roc_in_X[6]\ _04211_ _04213_ VPWR VGND sg13g2_nor3_2
X_27498_ _04215_ _04214_ VPWR VGND sg13g2_buf_8
X_27499_ _04216_ \memory_i.freq_inst.cordic.roc_in_X[9]\ \memory_i.freq_inst.cordic.roc_in_X[8]\ \memory_i.freq_inst.cordic.roc_in_X[7]\ VPWR VGND sg13g2_or3_1
X_27500_ _04217_ \memory_i.freq_inst.cordic.roc_in_X[12]\ \memory_i.freq_inst.cordic.roc_in_X[11]\ \memory_i.freq_inst.cordic.roc_in_X[10]\ _04216_ VPWR
+ VGND
+ sg13g2_nor4_2
X_27501_ _04218_ _04217_ VPWR VGND sg13g2_buf_4
X_27502_ _04219_ \memory_i.freq_inst.cordic.roc_in_X[14]\ \memory_i.freq_inst.cordic.roc_in_X[13]\ VPWR VGND sg13g2_nor2_1
X_27503_ _04220_ _04219_ VPWR VGND sg13g2_buf_2
X_27504_ _04221_ \memory_i.freq_inst.cordic.roc_in_X[17]\ \memory_i.freq_inst.cordic.roc_in_X[16]\ \memory_i.freq_inst.cordic.roc_in_X[15]\ VPWR VGND sg13g2_nor3_1
X_27505_ _04222_ _04215_ _04218_ _04220_ _04221_ VPWR
+ VGND
+ sg13g2_and4_1
X_27506_ _04223_ _04222_ VPWR VGND sg13g2_buf_8
X_27507_ _04224_ \memory_i.freq_inst.cordic.roc_in_X[22]\ \memory_i.freq_inst.cordic.roc_in_X[21]\ \memory_i.freq_inst.cordic.roc_in_X[20]\ VPWR VGND sg13g2_nor3_1
X_27508_ _04225_ _04003_ _04209_ _04223_ _04224_ VPWR
+ VGND
+ sg13g2_nand4_1
X_27509_ _04226_ _04225_ VPWR VGND sg13g2_buf_4
X_27510_ _04227_ \memory_i.freq_inst.cordic.roc_in_X[25]\ \memory_i.freq_inst.cordic.roc_in_X[24]\ _04226_ VPWR VGND sg13g2_nor3_2
X_27511_ _04228_ _03992_ _04227_ VPWR VGND sg13g2_xnor2_1
X_27512_ _04229_ _04204_ \memory_i.freq_inst.cordic.roc_in_Z[28]\ VPWR VGND sg13g2_nand2_1
X_27513_ _04230_ _03349_ _04229_ _03918_ VPWR VGND sg13g2_nor3_1
X_27514_ _04231_ _04230_ VPWR VGND sg13g2_buf_2
X_27515_ _04232_ \memory_i.freq_inst.cordic.roc_in_X[26]\ _04231_ VPWR VGND sg13g2_and2_1
X_27516_ _04233_ \memory_i.freq_inst.Y_o[26]\ _03351_ _04232_ VPWR VGND sg13g2_a21oi_1
X_27517_ _04234_ _04208_ _04228_ _04233_ VPWR VGND sg13g2_o21ai_1
X_27518_ _04235_ _04234_ VPWR VGND sg13g2_buf_4
X_27519_ _04236_ _04235_ VPWR VGND sg13g2_buf_8
X_27520_ _04237_ \memory_i.freq_inst.cordic.shift_value[4]\ _03955_ VPWR VGND sg13g2_nor2_1
X_27521_ _04238_ _04036_ _04237_ VPWR VGND sg13g2_nor2_1
X_27522_ _04239_ \memory_i.freq_inst.cordic.roc_in_X[19]\ \memory_i.freq_inst.cordic.roc_in_X[18]\ VPWR VGND sg13g2_or2_1
X_27523_ _04240_ _04239_ VPWR VGND sg13g2_buf_1
X_27524_ _04241_ _04215_ _04218_ _04220_ _04221_ VPWR
+ VGND
+ sg13g2_nand4_1
X_27525_ _04242_ _04241_ VPWR VGND sg13g2_buf_4
X_27526_ _04243_ _04007_ _04011_ _04014_ VPWR VGND sg13g2_nand3_1
X_27527_ _04244_ _04240_ _04242_ _04243_ VPWR VGND sg13g2_nor3_2
X_27528_ _04245_ \memory_i.freq_inst.cordic.roc_in_X[26]\ \memory_i.freq_inst.cordic.roc_in_X[25]\ \memory_i.freq_inst.cordic.roc_in_X[24]\ \memory_i.freq_inst.cordic.roc_in_X[23]\ VPWR
+ VGND
+ sg13g2_nor4_1
X_27529_ _04246_ _03927_ VPWR VGND sg13g2_buf_2
X_27530_ _04247_ _04246_ VPWR VGND sg13g2_buf_1
X_27531_ _04248_ _04244_ _04245_ _04247_ VPWR VGND sg13g2_a21o_1
X_27532_ _04249_ _04229_ _03918_ VPWR VGND sg13g2_nor2_1
X_27533_ _04250_ _04249_ VPWR VGND sg13g2_buf_2
X_27534_ _04251_ _03988_ _04250_ VPWR VGND sg13g2_nor2_1
X_27535_ _04252_ _04206_ VPWR VGND sg13g2_buf_2
X_27536_ _04253_ _04252_ VPWR VGND sg13g2_buf_2
X_27537_ _04254_ _04253_ _04244_ _04245_ VPWR VGND sg13g2_nand3_1
X_27538_ _04255_ _03988_ _04248_ _04251_ _04254_ VPWR
+ VGND
+ sg13g2_a22oi_1
X_27539_ _04256_ \memory_i.freq_inst.Y_o[27]\ VPWR VGND sg13g2_inv_1
X_27540_ _04257_ _04256_ _03678_ VPWR VGND sg13g2_nor2_1
X_27541_ _04258_ _03679_ _04255_ _04257_ VPWR VGND sg13g2_a21o_1
X_27542_ _04259_ _04258_ VPWR VGND sg13g2_buf_2
X_27543_ _04260_ _03947_ _04238_ _04259_ VPWR VGND sg13g2_a21o_1
X_27544_ _04261_ _03679_ _04255_ _04257_ VPWR VGND sg13g2_a21oi_1
X_27545_ _04262_ _04261_ _04238_ _03947_ VPWR VGND sg13g2_a21oi_1
X_27546_ _04263_ _04192_ _04260_ _04262_ VPWR VGND sg13g2_a21oi_1
X_27547_ _04264_ _03852_ _04192_ VPWR VGND sg13g2_nor2_1
X_27548_ _04265_ _04036_ _04237_ _04261_ VPWR VGND sg13g2_o21ai_1
X_27549_ _04266_ _03967_ _04264_ _04265_ VPWR VGND sg13g2_nand3_1
X_27550_ _04267_ _03967_ _04263_ _04266_ VPWR VGND sg13g2_o21ai_1
X_27551_ _04268_ _03852_ _04194_ VPWR VGND sg13g2_nor2_1
X_27552_ _04269_ _04238_ _04268_ VPWR VGND sg13g2_xnor2_1
X_27553_ _04270_ \memory_i.freq_inst.cordic.roc_in_X[24]\ _04226_ \memory_i.freq_inst.cordic.roc_in_X[25]\ VPWR VGND sg13g2_o21ai_1
X_27554_ _04271_ _04227_ _04270_ _04253_ VPWR VGND sg13g2_nand3b_1
X_27555_ _04272_ _04004_ VPWR VGND sg13g2_buf_2
X_27556_ _04273_ \memory_i.freq_inst.cordic.roc_in_X[25]\ _04250_ _04272_ VPWR VGND sg13g2_a21oi_1
X_27557_ _04274_ \memory_i.freq_inst.Y_o[25]\ _03678_ VPWR VGND sg13g2_nor2_1
X_27558_ _04275_ _04271_ _04273_ _04274_ VPWR VGND sg13g2_a21oi_1
X_27559_ _04276_ _03189_ _03943_ _03715_ VPWR VGND sg13g2_o21ai_1
X_27560_ _04277_ _03189_ _04156_ _04276_ VPWR VGND sg13g2_a21oi_1
X_27561_ _04278_ _04277_ _04188_ VPWR VGND sg13g2_nand2b_1
X_27562_ _04279_ _03719_ _04278_ VPWR VGND sg13g2_nand2_1
X_27563_ _04280_ _03839_ _04055_ VPWR VGND sg13g2_nand2_1
X_27564_ _04281_ _03958_ _04280_ VPWR VGND sg13g2_nand2_1
X_27565_ _04282_ _04279_ _04281_ VPWR VGND sg13g2_xor2_1
X_27566_ _04283_ _03913_ _03925_ VPWR VGND sg13g2_nand2_1
X_27567_ _04284_ _04246_ _04226_ _04283_ VPWR VGND sg13g2_o21ai_1
X_27568_ _04285_ \memory_i.freq_inst.cordic.roc_in_X[24]\ _04246_ VPWR VGND sg13g2_nor2_1
X_27569_ _04286_ \memory_i.freq_inst.cordic.roc_in_X[24]\ _04284_ _04285_ _04226_ VPWR
+ VGND
+ sg13g2_a22oi_1
X_27570_ _04287_ \memory_i.freq_inst.Y_o[24]\ _03678_ VPWR VGND sg13g2_nor2_1
X_27571_ _04288_ _03678_ _04286_ _04287_ VPWR VGND sg13g2_a21oi_2
X_27572_ _04289_ _03947_ _04191_ VPWR VGND sg13g2_nand2_1
X_27573_ _04290_ \memory_i.freq_inst.cordic.shift_value[4]\ _03957_ VPWR VGND sg13g2_nand2_1
X_27574_ _04291_ \memory_i.freq_inst.cordic.shift_value[4]\ _03972_ _04290_ VPWR VGND sg13g2_o21ai_1
X_27575_ _04292_ _04289_ _04291_ VPWR VGND sg13g2_xor2_1
X_27576_ _04293_ _04282_ _04288_ _04292_ VPWR VGND sg13g2_or3_1
X_27577_ _04294_ \memory_i.freq_inst.Y_o[23]\ VPWR VGND sg13g2_inv_1
X_27578_ _04295_ _04252_ _04209_ _04223_ _04224_ VPWR
+ VGND
+ sg13g2_nand4_1
X_27579_ _04296_ _04283_ _04295_ _04003_ VPWR VGND sg13g2_a21oi_1
X_27580_ _04297_ \memory_i.freq_inst.cordic.roc_in_X[23]\ _04247_ _04244_ VPWR VGND sg13g2_nor3_1
X_27581_ _04298_ _04296_ _04297_ _03678_ VPWR VGND sg13g2_o21ai_1
X_27582_ _04299_ _04294_ _03678_ _04298_ VPWR VGND sg13g2_o21ai_1
X_27583_ _04300_ _04299_ VPWR VGND sg13g2_buf_2
X_27584_ _04301_ _03650_ _04188_ VPWR VGND sg13g2_nor2_1
X_27585_ _04302_ _04156_ _04301_ VPWR VGND sg13g2_xor2_1
X_27586_ _04303_ _03601_ _03956_ VPWR VGND sg13g2_nor2_1
X_27587_ _04304_ _04198_ _04188_ VPWR VGND sg13g2_nor2_1
X_27588_ _04305_ _04303_ _04304_ _03804_ VPWR VGND sg13g2_o21ai_1
X_27589_ _04306_ _03804_ _04302_ _04305_ VPWR VGND sg13g2_o21ai_1
X_27590_ _04307_ _04300_ _04306_ VPWR VGND sg13g2_nand2_1
X_27591_ _04308_ \memory_i.freq_inst.Y_o[19]\ VPWR VGND sg13g2_inv_1
X_27592_ _04309_ \memory_i.freq_inst.cordic.roc_in_X[15]\ VPWR VGND sg13g2_inv_1
X_27593_ _04310_ _04309_ _04215_ _04218_ _04220_ VPWR
+ VGND
+ sg13g2_nand4_1
X_27594_ _04311_ _04310_ VPWR VGND sg13g2_buf_1
X_27595_ _04312_ \memory_i.freq_inst.cordic.roc_in_X[18]\ \memory_i.freq_inst.cordic.roc_in_X[17]\ \memory_i.freq_inst.cordic.roc_in_X[16]\ VPWR VGND sg13g2_or3_1
X_27596_ _04313_ _04246_ _04311_ _04312_ VPWR VGND sg13g2_nor3_1
X_27597_ _04314_ _04250_ _04313_ \memory_i.freq_inst.cordic.roc_in_X[19]\ VPWR VGND sg13g2_o21ai_1
X_27598_ _04315_ \memory_i.freq_inst.cordic.roc_in_X[19]\ _04246_ VPWR VGND sg13g2_nor2_1
X_27599_ _04316_ _04311_ _04312_ _04315_ VPWR VGND sg13g2_o21ai_1
X_27600_ _04317_ _03678_ _04316_ VPWR VGND sg13g2_and2_1
X_27601_ _04318_ _04308_ _03352_ _04314_ _04317_ VPWR
+ VGND
+ sg13g2_a22oi_1
X_27602_ _04319_ _04318_ VPWR VGND sg13g2_buf_1
X_27603_ _04320_ \memory_i.freq_inst.cordic.shift_value[4]\ _04033_ VPWR VGND sg13g2_or2_1
X_27604_ _04321_ _04320_ VPWR VGND sg13g2_buf_1
X_27605_ _04322_ _04321_ _04145_ VPWR VGND sg13g2_nand2_1
X_27606_ _04323_ _03591_ _04322_ VPWR VGND sg13g2_nand2_1
X_27607_ _04324_ _03547_ _04321_ _04145_ VPWR VGND sg13g2_nand3_1
X_27608_ _04325_ _04063_ _04142_ _04178_ _04182_ VPWR
+ VGND
+ sg13g2_and4_2
X_27609_ _04326_ _04043_ _04050_ _04325_ VPWR VGND sg13g2_nand3_1
X_27610_ _04327_ _04321_ _04324_ _04326_ VPWR VGND sg13g2_mux2_1
X_27611_ _04328_ _04319_ _04323_ _04327_ VPWR VGND sg13g2_nand3b_1
X_27612_ _04329_ _03591_ _04319_ _04322_ VPWR VGND sg13g2_nand3_1
X_27613_ _04330_ _04329_ VPWR VGND sg13g2_buf_1
X_27614_ _04331_ _04034_ _04319_ VPWR VGND sg13g2_nand2_1
X_27615_ _04332_ _03547_ _04321_ _04145_ _04319_ VPWR
+ VGND
+ sg13g2_nand4_1
X_27616_ _04333_ _04331_ _04332_ _04326_ VPWR VGND sg13g2_mux2_1
X_27617_ _04334_ _04333_ VPWR VGND sg13g2_buf_1
X_27618_ _04335_ _04328_ _04330_ _04334_ VPWR VGND sg13g2_nand3_1
X_27619_ _04336_ _04335_ VPWR VGND sg13g2_buf_1
X_27620_ _04337_ _04252_ _04311_ VPWR VGND sg13g2_nand2_1
X_27621_ _04338_ _04309_ _04215_ _04218_ _04220_ VPWR
+ VGND
+ sg13g2_and4_1
X_27622_ _04339_ _03913_ _03925_ _04252_ _04338_ VPWR
+ VGND
+ sg13g2_a22oi_1
X_27623_ _04340_ _04337_ _04339_ \memory_i.freq_inst.cordic.roc_in_X[16]\ VPWR VGND sg13g2_mux2_1
X_27624_ _04341_ \memory_i.freq_inst.Y_o[16]\ _03352_ VPWR VGND sg13g2_nand2_1
X_27625_ _04342_ _03999_ _04340_ _04341_ VPWR VGND sg13g2_o21ai_1
X_27626_ _04343_ _04342_ VPWR VGND sg13g2_buf_2
X_27627_ _04344_ _04092_ _04132_ _04140_ VPWR VGND sg13g2_nand3_1
X_27628_ _04345_ _04344_ VPWR VGND sg13g2_buf_4
X_27629_ _04346_ _04147_ _04151_ _04166_ _04177_ VPWR
+ VGND
+ sg13g2_or4_1
X_27630_ _04347_ _04346_ VPWR VGND sg13g2_buf_1
X_27631_ _04348_ _04345_ _04347_ _04181_ VPWR VGND sg13g2_nor3_1
X_27632_ _04349_ _03532_ _04348_ _04063_ VPWR VGND sg13g2_o21ai_1
X_27633_ _04350_ _03532_ _04063_ _04348_ VPWR VGND sg13g2_or3_1
X_27634_ _04351_ _04349_ _04350_ VPWR VGND sg13g2_and2_1
X_27635_ _04352_ _04351_ VPWR VGND sg13g2_buf_1
X_27636_ _04353_ _04343_ _04352_ VPWR VGND sg13g2_xor2_1
X_27637_ _04354_ \memory_i.freq_inst.Y_o[17]\ _03351_ VPWR VGND sg13g2_nand2_1
X_27638_ _04355_ \memory_i.freq_inst.cordic.roc_in_X[16]\ _04311_ _04208_ VPWR VGND sg13g2_nor3_1
X_27639_ _04356_ _04231_ _04355_ \memory_i.freq_inst.cordic.roc_in_X[17]\ VPWR VGND sg13g2_o21ai_1
X_27640_ _04357_ _03349_ _03927_ VPWR VGND sg13g2_nor2_1
X_27641_ _04358_ \memory_i.freq_inst.cordic.roc_in_X[16]\ _04311_ _04357_ VPWR VGND sg13g2_o21ai_1
X_27642_ _04359_ \memory_i.freq_inst.cordic.roc_in_X[17]\ _04358_ VPWR VGND sg13g2_or2_1
X_27643_ _04360_ _04354_ _04356_ _04359_ VPWR VGND sg13g2_and3_1
X_27644_ _04361_ _04360_ VPWR VGND sg13g2_buf_1
X_27645_ _04362_ _03520_ _04183_ VPWR VGND sg13g2_nand2_1
X_27646_ _04363_ _04051_ _04362_ VPWR VGND sg13g2_xnor2_1
X_27647_ _04364_ _04361_ _04363_ VPWR VGND sg13g2_xnor2_1
X_27648_ _04365_ _04050_ _04325_ _03533_ VPWR VGND sg13g2_a21oi_2
X_27649_ _04366_ _04044_ _04365_ VPWR VGND sg13g2_xnor2_1
X_27650_ _04367_ \memory_i.freq_inst.cordic.roc_in_X[18]\ VPWR VGND sg13g2_inv_1
X_27651_ _04368_ _04223_ _04357_ _04231_ VPWR VGND sg13g2_a21oi_1
X_27652_ _04369_ \memory_i.freq_inst.cordic.roc_in_X[18]\ _04208_ VPWR VGND sg13g2_nor2_1
X_27653_ _04370_ \memory_i.freq_inst.Y_o[18]\ _03351_ _04242_ _04369_ VPWR
+ VGND
+ sg13g2_a22oi_1
X_27654_ _04371_ _04367_ _04368_ _04370_ VPWR VGND sg13g2_o21ai_1
X_27655_ _04372_ _04371_ VPWR VGND sg13g2_buf_4
X_27656_ _04373_ _04366_ _04372_ VPWR VGND sg13g2_xnor2_1
X_27657_ _04374_ _04353_ _04364_ _04373_ VPWR VGND sg13g2_nand3_1
X_27658_ _04375_ _04336_ _04374_ VPWR VGND sg13g2_nor2_1
X_27659_ _04376_ _04229_ VPWR VGND sg13g2_buf_1
X_27660_ _04377_ \memory_i.freq_inst.cordic.roc_in_X[13]\ VPWR VGND sg13g2_inv_1
X_27661_ _04378_ _04215_ VPWR VGND sg13g2_buf_2
X_27662_ _04379_ _04377_ _04252_ _04378_ _04218_ VPWR
+ VGND
+ sg13g2_nand4_1
X_27663_ _04380_ _04376_ _03919_ _04379_ VPWR VGND sg13g2_o21ai_1
X_27664_ _04381_ _04377_ _04215_ _04218_ VPWR VGND sg13g2_and3_1
X_27665_ _04382_ \memory_i.freq_inst.cordic.roc_in_X[14]\ _04247_ _04381_ VPWR VGND sg13g2_nor3_1
X_27666_ _04383_ \memory_i.freq_inst.cordic.roc_in_X[14]\ _04380_ _04382_ VPWR VGND sg13g2_a21oi_1
X_27667_ _04384_ \memory_i.freq_inst.Y_o[14]\ _03352_ VPWR VGND sg13g2_nand2_1
X_27668_ _04385_ _03999_ _04383_ _04384_ VPWR VGND sg13g2_o21ai_1
X_27669_ _04386_ _04385_ VPWR VGND sg13g2_buf_1
X_27670_ _04387_ _04345_ _04347_ VPWR VGND sg13g2_nor2_1
X_27671_ _04388_ _04345_ _04151_ _04166_ _04177_ VPWR
+ VGND
+ sg13g2_nor4_1
X_27672_ _04389_ _03533_ _04388_ VPWR VGND sg13g2_or2_1
X_27673_ _04390_ _04389_ _04147_ VPWR VGND sg13g2_nor2b_1
X_27674_ _04391_ _04206_ _04378_ _04218_ _04220_ VPWR
+ VGND
+ sg13g2_nand4_1
X_27675_ _04392_ _04376_ _03918_ _04391_ VPWR VGND sg13g2_o21ai_1
X_27676_ _04393_ \memory_i.freq_inst.cordic.roc_in_X[15]\ _04246_ VPWR VGND sg13g2_nor2_1
X_27677_ _04394_ _04378_ _04218_ _04220_ VPWR VGND sg13g2_nand3_1
X_27678_ _04395_ \memory_i.freq_inst.cordic.roc_in_X[15]\ _04392_ _04393_ _04394_ VPWR
+ VGND
+ sg13g2_a22oi_1
X_27679_ _04396_ \memory_i.freq_inst.Y_o[15]\ _04004_ VPWR VGND sg13g2_nand2_1
X_27680_ _04397_ _03352_ _04395_ _04396_ VPWR VGND sg13g2_o21ai_1
X_27681_ _04398_ _04397_ VPWR VGND sg13g2_buf_1
X_27682_ _04399_ _04398_ _04181_ _03601_ VPWR VGND sg13g2_nand3b_1
X_27683_ _04400_ _03601_ _04147_ _04399_ VPWR VGND sg13g2_o21ai_1
X_27684_ _04401_ _03601_ _04181_ _04398_ VPWR VGND sg13g2_nor3_1
X_27685_ _04402_ _04387_ _04390_ _04400_ _04401_ VPWR
+ VGND
+ sg13g2_nor4_1
X_27686_ _04403_ _04345_ _04347_ _03547_ VPWR VGND sg13g2_o21ai_1
X_27687_ _04404_ _04181_ _04403_ VPWR VGND sg13g2_xnor2_1
X_27688_ _04405_ _04386_ _04402_ _04404_ _04398_ VPWR
+ VGND
+ sg13g2_a22oi_1
X_27689_ _04406_ _04405_ VPWR VGND sg13g2_inv_1
X_27690_ _04407_ \memory_i.freq_inst.cordic.roc_in_X[2]\ \memory_i.freq_inst.cordic.roc_in_X[1]\ \memory_i.freq_inst.cordic.roc_in_X[0]\ VPWR VGND sg13g2_nor3_1
X_27691_ _04408_ _04253_ _04407_ VPWR VGND sg13g2_nand2_1
X_27692_ _04409_ _04376_ _03919_ _04408_ VPWR VGND sg13g2_o21ai_1
X_27693_ _04410_ \memory_i.freq_inst.cordic.roc_in_X[3]\ _04247_ VPWR VGND sg13g2_nor2_1
X_27694_ _04411_ \memory_i.freq_inst.cordic.roc_in_X[3]\ _04409_ _04410_ _04211_ VPWR
+ VGND
+ sg13g2_a22oi_1
X_27695_ _04412_ \memory_i.freq_inst.Y_o[3]\ _04272_ VPWR VGND sg13g2_nand2_1
X_27696_ _04413_ _03353_ _04411_ _04412_ VPWR VGND sg13g2_o21ai_1
X_27697_ _04414_ _04413_ VPWR VGND sg13g2_buf_1
X_27698_ _04415_ _04111_ _04120_ _04130_ VPWR VGND sg13g2_nand3_1
X_27699_ _04416_ _03413_ _04415_ VPWR VGND sg13g2_nand2_1
X_27700_ _04417_ _04106_ _04416_ VPWR VGND sg13g2_xor2_1
X_27701_ _04418_ _04414_ _04417_ VPWR VGND sg13g2_nor2_1
X_27702_ _04419_ \memory_i.freq_inst.cordic.roc_in_X[1]\ \memory_i.freq_inst.cordic.roc_in_X[0]\ VPWR VGND sg13g2_nor2_1
X_27703_ _04420_ _04253_ _04419_ VPWR VGND sg13g2_nand2_1
X_27704_ _04421_ _04376_ _03919_ _04420_ VPWR VGND sg13g2_o21ai_1
X_27705_ _04422_ \memory_i.freq_inst.cordic.roc_in_X[2]\ _04247_ _04419_ VPWR VGND sg13g2_nor3_1
X_27706_ _04423_ \memory_i.freq_inst.cordic.roc_in_X[2]\ _04421_ _04422_ VPWR VGND sg13g2_a21oi_1
X_27707_ _04424_ \memory_i.freq_inst.Y_o[2]\ _03999_ VPWR VGND sg13g2_nand2_1
X_27708_ _04425_ _04272_ _04423_ _04424_ VPWR VGND sg13g2_o21ai_1
X_27709_ _04426_ _04425_ VPWR VGND sg13g2_buf_1
X_27710_ _04427_ _04120_ _04130_ _03411_ VPWR VGND sg13g2_a21oi_2
X_27711_ _04428_ _04111_ _04427_ VPWR VGND sg13g2_xor2_1
X_27712_ _04429_ \memory_i.freq_inst.cordic.roc_in_X[0]\ _04246_ VPWR VGND sg13g2_or2_1
X_27713_ _04430_ _04376_ _03919_ _04429_ VPWR VGND sg13g2_o21ai_1
X_27714_ _04431_ \memory_i.freq_inst.cordic.roc_in_X[1]\ \memory_i.freq_inst.cordic.roc_in_X[0]\ VPWR VGND sg13g2_nor2b_1
X_27715_ _04432_ \memory_i.freq_inst.cordic.roc_in_X[1]\ _04430_ _04431_ _04253_ VPWR
+ VGND
+ sg13g2_a22oi_1
X_27716_ _04433_ \memory_i.freq_inst.Y_o[1]\ _04272_ VPWR VGND sg13g2_nand2_1
X_27717_ _04434_ _03353_ _04432_ _04433_ VPWR VGND sg13g2_o21ai_1
X_27718_ _04435_ _04434_ VPWR VGND sg13g2_buf_1
X_27719_ _04436_ _04250_ _04253_ \memory_i.freq_inst.cordic.roc_in_X[0]\ VPWR VGND sg13g2_o21ai_1
X_27720_ _04437_ \memory_i.freq_inst.Y_o[0]\ _04272_ VPWR VGND sg13g2_nand2_1
X_27721_ _04438_ _03353_ _04436_ _04437_ VPWR VGND sg13g2_o21ai_1
X_27722_ _04439_ _04438_ VPWR VGND sg13g2_buf_1
X_27723_ _04440_ _04435_ _04439_ VPWR VGND sg13g2_nor2_1
X_27724_ _04441_ _04435_ _04130_ VPWR VGND sg13g2_nor2b_1
X_27725_ _04442_ _03411_ _04130_ VPWR VGND sg13g2_nor2_1
X_27726_ _04443_ _04120_ _04440_ _04441_ _04442_ VPWR
+ VGND
+ sg13g2_or4_1
X_27727_ _04444_ _04443_ VPWR VGND sg13g2_buf_1
X_27728_ _04445_ _03411_ _04440_ VPWR VGND sg13g2_nor2_1
X_27729_ _04446_ _04435_ _04439_ _04445_ _04120_ VPWR
+ VGND
+ sg13g2_a22oi_1
X_27730_ _04447_ _04130_ _04446_ VPWR VGND sg13g2_or2_1
X_27731_ _04448_ _04447_ VPWR VGND sg13g2_buf_1
X_27732_ _04449_ _04428_ _04444_ _04448_ VPWR VGND sg13g2_nand3_1
X_27733_ _04450_ _04444_ _04448_ _04428_ VPWR VGND sg13g2_a21oi_1
X_27734_ _04451_ _04414_ _04417_ _04426_ _04449_ _04450_
+ VPWR
+ VGND sg13g2_a221oi_1
X_27735_ _04452_ _03522_ _04021_ _04135_ VPWR VGND sg13g2_o21ai_1
X_27736_ _04453_ _04452_ VPWR VGND sg13g2_buf_1
X_27737_ _04454_ \memory_i.freq_inst.cordic.roc_in_X[4]\ VPWR VGND sg13g2_inv_1
X_27738_ _04455_ \memory_i.freq_inst.cordic.roc_in_X[3]\ _04211_ _04253_ VPWR VGND sg13g2_o21ai_1
X_27739_ _04456_ \memory_i.freq_inst.cordic.roc_in_X[3]\ _03927_ _04211_ VPWR VGND sg13g2_nor3_1
X_27740_ _04457_ _04454_ _04456_ VPWR VGND sg13g2_nor2_1
X_27741_ _04458_ _04454_ _04455_ _04457_ _04283_ _03352_
+ VPWR
+ VGND sg13g2_a221oi_1
X_27742_ _04459_ \memory_i.freq_inst.Y_o[4]\ _04272_ _04458_ VPWR VGND sg13g2_a21o_1
X_27743_ _04460_ _04459_ VPWR VGND sg13g2_buf_1
X_27744_ _04461_ _04453_ _04460_ VPWR VGND sg13g2_nand2_1
X_27745_ _04462_ _04113_ _04114_ _03441_ VPWR VGND sg13g2_mux2_1
X_27746_ _04463_ _03956_ _04148_ _03985_ _04462_ _03521_
+ _03185_
+ VPWR VGND sg13g2_mux4_1
X_27747_ _04464_ _04463_ VPWR VGND sg13g2_buf_1
X_27748_ _04465_ _04454_ _04456_ VPWR VGND sg13g2_nand2_1
X_27749_ _04466_ _04376_ _03919_ _04465_ VPWR VGND sg13g2_o21ai_1
X_27750_ _04467_ \memory_i.freq_inst.cordic.roc_in_X[4]\ \memory_i.freq_inst.cordic.roc_in_X[3]\ _04211_ VPWR VGND sg13g2_nor3_1
X_27751_ _04468_ \memory_i.freq_inst.cordic.roc_in_X[5]\ _04247_ _04467_ VPWR VGND sg13g2_nor3_1
X_27752_ _04469_ \memory_i.freq_inst.cordic.roc_in_X[5]\ _04466_ _04468_ VPWR VGND sg13g2_a21oi_1
X_27753_ _04470_ \memory_i.freq_inst.Y_o[5]\ _03999_ VPWR VGND sg13g2_nand2_1
X_27754_ _04471_ _04272_ _04469_ _04470_ VPWR VGND sg13g2_o21ai_1
X_27755_ _04472_ _04471_ VPWR VGND sg13g2_buf_1
X_27756_ _04473_ _04464_ _04472_ VPWR VGND sg13g2_nand2_1
X_27757_ _04474_ _04133_ _04453_ _04461_ _04473_ VPWR
+ VGND
+ sg13g2_a22oi_1
X_27758_ _04475_ _03411_ _04132_ VPWR VGND sg13g2_or2_1
X_27759_ _04476_ _04475_ VPWR VGND sg13g2_buf_1
X_27760_ _04477_ _04464_ _04472_ VPWR VGND sg13g2_nand2b_1
X_27761_ _04478_ _03505_ _04453_ VPWR VGND sg13g2_nor2_1
X_27762_ _04479_ _04167_ _04056_ _03196_ VPWR VGND sg13g2_mux2_1
X_27763_ _04480_ _03373_ _03936_ _04019_ VPWR VGND sg13g2_a21o_1
X_27764_ _04481_ _04479_ _04480_ \memory_i.freq_inst.cordic.shift_value[3]\ VPWR VGND sg13g2_mux2_1
X_27765_ _04482_ _03521_ _04134_ VPWR VGND sg13g2_and2_1
X_27766_ _04483_ \memory_i.freq_inst.cordic.shift_value[4]\ _04481_ _04482_ VPWR VGND sg13g2_a21oi_1
X_27767_ _04484_ _04483_ _04460_ VPWR VGND sg13g2_nand2_1
X_27768_ _04485_ _04477_ _04478_ _04484_ VPWR VGND sg13g2_o21ai_1
X_27769_ _04486_ _03520_ _04474_ _04476_ _04485_ VPWR
+ VGND
+ sg13g2_a22oi_1
X_27770_ _04487_ _04418_ _04451_ _04486_ VPWR VGND sg13g2_o21ai_1
X_27771_ _04488_ \memory_i.freq_inst.cordic.roc_in_X[6]\ VPWR VGND sg13g2_inv_1
X_27772_ _04489_ _04213_ _04488_ _04407_ VPWR VGND sg13g2_nand3b_1
X_27773_ _04490_ \memory_i.freq_inst.cordic.roc_in_X[7]\ _04247_ VPWR VGND sg13g2_nor2_1
X_27774_ _04491_ _04252_ _04378_ VPWR VGND sg13g2_nand2_1
X_27775_ _04492_ _04376_ _03919_ _04491_ VPWR VGND sg13g2_o21ai_1
X_27776_ _04493_ _04489_ _04490_ _04492_ \memory_i.freq_inst.cordic.roc_in_X[7]\ VPWR
+ VGND
+ sg13g2_a22oi_1
X_27777_ _04494_ \memory_i.freq_inst.Y_o[7]\ _03999_ VPWR VGND sg13g2_nand2_1
X_27778_ _04495_ _04272_ _04493_ _04494_ VPWR VGND sg13g2_o21ai_1
X_27779_ _04496_ _04495_ VPWR VGND sg13g2_buf_1
X_27780_ _04497_ _04159_ _04496_ VPWR VGND sg13g2_xnor2_1
X_27781_ _04498_ _04211_ _04213_ VPWR VGND sg13g2_nor2_1
X_27782_ _04499_ _03913_ _03925_ _04253_ _04498_ VPWR
+ VGND
+ sg13g2_a22oi_1
X_27783_ _04500_ _04211_ _04213_ _04253_ VPWR VGND sg13g2_o21ai_1
X_27784_ _04501_ _04499_ _04500_ _04488_ VPWR VGND sg13g2_mux2_1
X_27785_ _04502_ \memory_i.freq_inst.Y_o[6]\ _03999_ VPWR VGND sg13g2_nand2_1
X_27786_ _04503_ _04272_ _04501_ _04502_ VPWR VGND sg13g2_o21ai_1
X_27787_ _04504_ _04503_ VPWR VGND sg13g2_buf_1
X_27788_ _04505_ _04504_ VPWR VGND sg13g2_buf_1
X_27789_ _04506_ _04092_ _04505_ VPWR VGND sg13g2_xor2_1
X_27790_ _04507_ _03497_ _04506_ VPWR VGND sg13g2_nor2_1
X_27791_ _04508_ _04142_ _04505_ _04507_ VPWR VGND sg13g2_a21o_1
X_27792_ _04509_ _04505_ _04092_ VPWR VGND sg13g2_nand2b_1
X_27793_ _04510_ _04133_ _04140_ _04509_ VPWR VGND sg13g2_a21o_1
X_27794_ _04511_ _04092_ _04505_ VPWR VGND sg13g2_nor2_1
X_27795_ _04512_ _04133_ _04140_ _04511_ VPWR VGND sg13g2_nand3_1
X_27796_ _04513_ _04092_ _04505_ VPWR VGND sg13g2_nand2b_1
X_27797_ _04514_ _04133_ _04140_ _04513_ VPWR VGND sg13g2_a21o_1
X_27798_ _04515_ _04510_ _04512_ _04514_ VPWR VGND sg13g2_nand3_1
X_27799_ _04516_ _03532_ _04497_ VPWR VGND sg13g2_nor2_1
X_27800_ _04517_ _04497_ _04508_ _04515_ _04516_ VPWR
+ VGND
+ sg13g2_a22oi_1
X_27801_ _04518_ _03513_ _04469_ VPWR VGND sg13g2_nor2_1
X_27802_ _04519_ \memory_i.freq_inst.Y_o[5]\ _03513_ _04518_ VPWR VGND sg13g2_a21oi_1
X_27803_ _04520_ _04133_ _04453_ _03505_ VPWR VGND sg13g2_a21oi_1
X_27804_ _04521_ _04464_ _04520_ VPWR VGND sg13g2_xor2_1
X_27805_ _04522_ _04473_ _04483_ VPWR VGND sg13g2_and2_1
X_27806_ _04523_ _04453_ _04477_ VPWR VGND sg13g2_and2_1
X_27807_ _04524_ _04522_ _04523_ _04476_ VPWR VGND sg13g2_mux2_1
X_27808_ _04525_ _04460_ VPWR VGND sg13g2_inv_1
X_27809_ _04526_ _04519_ _04521_ _04524_ _04525_ VPWR
+ VGND
+ sg13g2_a22oi_1
X_27810_ _04527_ _04517_ _04526_ VPWR VGND sg13g2_nor2b_1
X_27811_ _04528_ \memory_i.freq_inst.cordic.roc_in_X[9]\ \memory_i.freq_inst.cordic.roc_in_X[8]\ \memory_i.freq_inst.cordic.roc_in_X[7]\ VPWR VGND sg13g2_nor3_1
X_27812_ _04529_ _04378_ _04528_ VPWR VGND sg13g2_nand2_1
X_27813_ _04530_ \memory_i.freq_inst.cordic.roc_in_X[10]\ _04247_ VPWR VGND sg13g2_nor2_1
X_27814_ _04531_ _04252_ _04378_ _04528_ VPWR VGND sg13g2_nand3_1
X_27815_ _04532_ _04376_ _03919_ _04531_ VPWR VGND sg13g2_o21ai_1
X_27816_ _04533_ _04529_ _04530_ _04532_ \memory_i.freq_inst.cordic.roc_in_X[10]\ VPWR
+ VGND
+ sg13g2_a22oi_1
X_27817_ _04534_ \memory_i.freq_inst.Y_o[10]\ _03999_ VPWR VGND sg13g2_nand2_1
X_27818_ _04535_ _04272_ _04533_ _04534_ VPWR VGND sg13g2_o21ai_1
X_27819_ _04536_ _04535_ VPWR VGND sg13g2_inv_1
X_27820_ _04537_ _04159_ _04496_ VPWR VGND sg13g2_nand2b_1
X_27821_ _04538_ _03497_ _04345_ _04537_ VPWR VGND sg13g2_a21oi_1
X_27822_ _04539_ _04133_ _04140_ _04092_ VPWR VGND sg13g2_a21oi_2
X_27823_ _04540_ _04159_ _04505_ VPWR VGND sg13g2_nand2_1
X_27824_ _04541_ _03505_ _04142_ _04539_ _04540_ VPWR
+ VGND
+ sg13g2_nor4_1
X_27825_ _04542_ _03497_ _04345_ _04159_ _04496_ VPWR
+ VGND
+ sg13g2_and4_1
X_27826_ _04543_ _04496_ _04504_ VPWR VGND sg13g2_and2_1
X_27827_ _04544_ _04159_ _04543_ VPWR VGND sg13g2_nand2b_1
X_27828_ _04545_ _04159_ _04505_ VPWR VGND sg13g2_nor2b_1
X_27829_ _04546_ _03497_ _04092_ VPWR VGND sg13g2_nor2_1
X_27830_ _04547_ _04543_ _04545_ _04546_ VPWR VGND sg13g2_o21ai_1
X_27831_ _04548_ _04539_ _04544_ _04547_ VPWR VGND sg13g2_o21ai_1
X_27832_ _04549_ _04538_ _04541_ _04542_ _04548_ VPWR
+ VGND
+ sg13g2_nor4_1
X_27833_ _04550_ _04536_ _04549_ VPWR VGND sg13g2_nand2_1
X_27834_ _04551_ _04159_ _04161_ _04165_ VPWR VGND sg13g2_and3_1
X_27835_ _04552_ _04092_ _04133_ _04140_ _04551_ VPWR
+ VGND
+ sg13g2_nand4_1
X_27836_ _04553_ _04552_ VPWR VGND sg13g2_buf_1
X_27837_ _04554_ _03520_ _04553_ VPWR VGND sg13g2_nand2_1
X_27838_ _04555_ _04173_ _04554_ VPWR VGND sg13g2_xnor2_1
X_27839_ _04556_ _04555_ _04549_ VPWR VGND sg13g2_nand2_1
X_27840_ _04557_ _04161_ VPWR VGND sg13g2_buf_2
X_27841_ _04558_ \memory_i.freq_inst.cordic.roc_in_X[8]\ \memory_i.freq_inst.cordic.roc_in_X[7]\ _04489_ VPWR VGND sg13g2_or3_1
X_27842_ _04559_ _04208_ _04558_ VPWR VGND sg13g2_nor2_1
X_27843_ _04560_ _04231_ _04559_ \memory_i.freq_inst.cordic.roc_in_X[9]\ VPWR VGND sg13g2_o21ai_1
X_27844_ _04561_ \memory_i.freq_inst.cordic.roc_in_X[9]\ _04208_ VPWR VGND sg13g2_nor2_1
X_27845_ _04562_ \memory_i.freq_inst.Y_o[9]\ _03351_ _04558_ _04561_ VPWR
+ VGND
+ sg13g2_a22oi_1
X_27846_ _04563_ _04560_ _04562_ VPWR VGND sg13g2_nand2_1
X_27847_ _04564_ _04563_ VPWR VGND sg13g2_buf_1
X_27848_ _04565_ _04557_ _04564_ VPWR VGND sg13g2_nor2_1
X_27849_ _04566_ _04091_ _04132_ _04140_ _04159_ VPWR
+ VGND
+ sg13g2_nand4_1
X_27850_ _04567_ _04566_ VPWR VGND sg13g2_buf_2
X_27851_ _04568_ _04557_ _04565_ _04567_ VPWR VGND sg13g2_mux2_1
X_27852_ _04569_ _04564_ VPWR VGND sg13g2_inv_1
X_27853_ _04570_ \memory_i.freq_inst.cordic.roc_in_X[7]\ _04378_ VPWR VGND sg13g2_nand2b_1
X_27854_ _04571_ \memory_i.freq_inst.cordic.roc_in_X[8]\ _04247_ VPWR VGND sg13g2_nor2_1
X_27855_ _04572_ \memory_i.freq_inst.cordic.roc_in_X[7]\ _04252_ _04378_ VPWR VGND sg13g2_nand3b_1
X_27856_ _04573_ _04376_ _03919_ _04572_ VPWR VGND sg13g2_o21ai_1
X_27857_ _04574_ _04570_ _04571_ _04573_ \memory_i.freq_inst.cordic.roc_in_X[8]\ VPWR
+ VGND
+ sg13g2_a22oi_1
X_27858_ _04575_ \memory_i.freq_inst.Y_o[8]\ _04004_ VPWR VGND sg13g2_nand2_1
X_27859_ _04576_ _03352_ _04574_ _04575_ VPWR VGND sg13g2_o21ai_1
X_27860_ _04577_ _04576_ VPWR VGND sg13g2_buf_2
X_27861_ _04578_ _04577_ VPWR VGND sg13g2_inv_1
X_27862_ _04579_ _04569_ _04578_ VPWR VGND sg13g2_nand2_1
X_27863_ _04580_ _03520_ _04165_ _04579_ VPWR VGND sg13g2_nand3_1
X_27864_ _04581_ _04568_ _04580_ VPWR VGND sg13g2_or2_1
X_27865_ _04582_ _04581_ VPWR VGND sg13g2_buf_1
X_27866_ _04583_ _04165_ _04569_ VPWR VGND sg13g2_nor2_1
X_27867_ _04584_ _04577_ _04583_ VPWR VGND sg13g2_nand2_1
X_27868_ _04585_ _04557_ _04583_ VPWR VGND sg13g2_nand2_1
X_27869_ _04586_ _04584_ _04585_ _04567_ VPWR VGND sg13g2_a21oi_1
X_27870_ _04587_ _04557_ _04577_ VPWR VGND sg13g2_nand2_1
X_27871_ _04588_ _04165_ _04564_ VPWR VGND sg13g2_nand2b_1
X_27872_ _04589_ _03520_ _04587_ _04588_ VPWR VGND sg13g2_a21oi_1
X_27873_ _04590_ _04165_ _04569_ VPWR VGND sg13g2_and2_1
X_27874_ _04591_ _03497_ _04557_ _04578_ _04590_ VPWR
+ VGND
+ sg13g2_nor4_1
X_27875_ _04592_ _04586_ _04589_ _04591_ VPWR VGND sg13g2_nor3_1
X_27876_ _04593_ _04582_ _04592_ VPWR VGND sg13g2_nand2_1
X_27877_ _04594_ _04487_ _04527_ _04550_ _04556_ _04593_
+ VPWR
+ VGND sg13g2_a221oi_1
X_27878_ _04595_ _04594_ VPWR VGND sg13g2_buf_2
X_27879_ _04596_ _04536_ _04555_ VPWR VGND sg13g2_nand2_1
X_27880_ _04597_ _04165_ _04564_ VPWR VGND sg13g2_xnor2_1
X_27881_ _04598_ _04161_ _04578_ VPWR VGND sg13g2_xnor2_1
X_27882_ _04599_ _04598_ _03532_ VPWR VGND sg13g2_nand2b_1
X_27883_ _04600_ _04567_ _04587_ _04599_ VPWR VGND sg13g2_o21ai_1
X_27884_ _04601_ _04557_ _04577_ VPWR VGND sg13g2_nor2_1
X_27885_ _04602_ _04601_ _04598_ _04567_ VPWR VGND sg13g2_mux2_1
X_27886_ _04603_ _03532_ _04597_ VPWR VGND sg13g2_nor2_1
X_27887_ _04604_ _04597_ _04600_ _04602_ _04603_ VPWR
+ VGND
+ sg13g2_a22oi_1
X_27888_ _04605_ _04536_ _04582_ _04592_ _04604_ VPWR
+ VGND
+ sg13g2_nand4_1
X_27889_ _04606_ _04555_ _04582_ _04592_ _04604_ VPWR
+ VGND
+ sg13g2_nand4_1
X_27890_ _04607_ _04596_ _04605_ _04606_ VPWR VGND sg13g2_nand3_1
X_27891_ _04608_ _04607_ VPWR VGND sg13g2_buf_1
X_27892_ _04609_ _04177_ _04553_ _03547_ VPWR VGND sg13g2_o21ai_1
X_27893_ _04610_ _04151_ _04609_ VPWR VGND sg13g2_xnor2_1
X_27894_ _04611_ _04610_ VPWR VGND sg13g2_buf_1
X_27895_ _04612_ _04215_ _04218_ _04377_ VPWR VGND sg13g2_a21oi_1
X_27896_ _04613_ _04246_ _04381_ _04612_ VPWR VGND sg13g2_nor3_1
X_27897_ _04614_ \memory_i.freq_inst.cordic.roc_in_X[13]\ _04250_ _04613_ VPWR VGND sg13g2_a21oi_1
X_27898_ _04615_ \memory_i.freq_inst.Y_o[13]\ _03351_ VPWR VGND sg13g2_nand2_1
X_27899_ _04616_ _04004_ _04614_ _04615_ VPWR VGND sg13g2_o21ai_1
X_27900_ _04617_ _04616_ VPWR VGND sg13g2_buf_2
X_27901_ _04618_ \memory_i.freq_inst.Y_o[11]\ _04004_ VPWR VGND sg13g2_nand2_1
X_27902_ _04619_ \memory_i.freq_inst.cordic.roc_in_X[11]\ _04208_ VPWR VGND sg13g2_nor2_1
X_27903_ _04620_ \memory_i.freq_inst.cordic.roc_in_X[10]\ _04529_ _04619_ VPWR VGND sg13g2_o21ai_1
X_27904_ _04621_ \memory_i.freq_inst.cordic.roc_in_X[10]\ _04208_ _04529_ VPWR VGND sg13g2_nor3_1
X_27905_ _04622_ _04231_ _04621_ \memory_i.freq_inst.cordic.roc_in_X[11]\ VPWR VGND sg13g2_o21ai_1
X_27906_ _04623_ _04618_ _04620_ _04622_ VPWR VGND sg13g2_nand3_1
X_27907_ _04624_ _04623_ VPWR VGND sg13g2_buf_2
X_27908_ _04625_ _04173_ VPWR VGND sg13g2_inv_1
X_27909_ _04626_ _04625_ _04553_ _03520_ VPWR VGND sg13g2_o21ai_1
X_27910_ _04627_ _04175_ _04626_ VPWR VGND sg13g2_xor2_1
X_27911_ _04628_ _04173_ _04175_ VPWR VGND sg13g2_nand2_1
X_27912_ _04629_ _04628_ _04553_ _03547_ VPWR VGND sg13g2_o21ai_1
X_27913_ _04630_ _04169_ _04629_ VPWR VGND sg13g2_xor2_1
X_27914_ _04631_ _04611_ _04617_ _04624_ _04627_ _04630_
+ VPWR
+ VGND sg13g2_a221oi_1
X_27915_ _04632_ _04595_ _04608_ _04631_ VPWR VGND sg13g2_o21ai_1
X_27916_ _04633_ \memory_i.freq_inst.cordic.roc_in_X[11]\ \memory_i.freq_inst.cordic.roc_in_X[10]\ _04216_ VPWR VGND sg13g2_nor3_1
X_27917_ _04634_ _04378_ _04633_ VPWR VGND sg13g2_nand2_1
X_27918_ _04635_ \memory_i.freq_inst.cordic.roc_in_X[12]\ _04246_ VPWR VGND sg13g2_nor2_1
X_27919_ _04636_ _04252_ _04378_ _04633_ VPWR VGND sg13g2_nand3_1
X_27920_ _04637_ _04376_ _03919_ _04636_ VPWR VGND sg13g2_o21ai_1
X_27921_ _04638_ _04634_ _04635_ _04637_ \memory_i.freq_inst.cordic.roc_in_X[12]\ VPWR
+ VGND
+ sg13g2_a22oi_1
X_27922_ _04639_ \memory_i.freq_inst.Y_o[12]\ _04004_ VPWR VGND sg13g2_nand2_1
X_27923_ _04640_ _03352_ _04638_ _04639_ VPWR VGND sg13g2_o21ai_1
X_27924_ _04641_ _04640_ VPWR VGND sg13g2_buf_1
X_27925_ _04642_ _04611_ _04617_ _04624_ _04627_ _04641_
+ VPWR
+ VGND sg13g2_a221oi_1
X_27926_ _04643_ _04595_ _04608_ _04642_ VPWR VGND sg13g2_o21ai_1
X_27927_ _04644_ _04611_ _04617_ VPWR VGND sg13g2_nand2_1
X_27928_ _04645_ _04641_ _04630_ VPWR VGND sg13g2_nor2_1
X_27929_ _04646_ _04624_ _04627_ VPWR VGND sg13g2_or2_1
X_27930_ _04647_ _04611_ _04617_ _04641_ _04630_ _04646_
+ VPWR
+ VGND sg13g2_a221oi_1
X_27931_ _04648_ _04644_ _04645_ _04647_ VPWR VGND sg13g2_a21oi_1
X_27932_ _04649_ _04632_ _04643_ _04648_ VPWR VGND sg13g2_and3_2
X_27933_ _04650_ _04181_ _04398_ VPWR VGND sg13g2_xor2_1
X_27934_ _04651_ _04403_ _04650_ VPWR VGND sg13g2_xnor2_1
X_27935_ _04652_ _04147_ _04389_ VPWR VGND sg13g2_xnor2_1
X_27936_ _04653_ _04386_ _04652_ VPWR VGND sg13g2_xor2_1
X_27937_ _04654_ _04651_ _04653_ VPWR VGND sg13g2_nand2_1
X_27938_ _04655_ _04611_ _04617_ VPWR VGND sg13g2_nor2_1
X_27939_ _04656_ _04336_ _04374_ _04654_ _04655_ VPWR
+ VGND
+ sg13g2_nor4_1
X_27940_ _04657_ _04050_ _04362_ VPWR VGND sg13g2_xnor2_1
X_27941_ _04658_ _04343_ _04349_ _04350_ VPWR VGND sg13g2_nand3_1
X_27942_ _04659_ _04657_ _04658_ _04361_ VPWR VGND sg13g2_o21ai_1
X_27943_ _04660_ _04657_ _04658_ VPWR VGND sg13g2_nand2_1
X_27944_ _04661_ _04372_ VPWR VGND sg13g2_inv_1
X_27945_ _04662_ _04330_ _04334_ _04661_ VPWR VGND sg13g2_nand3_1
X_27946_ _04663_ _04330_ _04334_ _04366_ VPWR VGND sg13g2_nand3_1
X_27947_ _04664_ _04659_ _04660_ _04662_ _04663_ VPWR
+ VGND
+ sg13g2_a22oi_1
X_27948_ _04665_ _04330_ _04334_ _04366_ _04661_ VPWR
+ VGND
+ sg13g2_nand4_1
X_27949_ _04666_ _04328_ _04665_ VPWR VGND sg13g2_nand2_1
X_27950_ _04667_ _04664_ _04666_ VPWR VGND sg13g2_nor2_1
X_27951_ _04668_ _04375_ _04406_ _04649_ _04656_ _04667_
+ VPWR
+ VGND sg13g2_a221oi_1
X_27952_ _04669_ _04668_ VPWR VGND sg13g2_buf_2
X_27953_ _04670_ _04240_ _04242_ _04206_ VPWR VGND sg13g2_o21ai_1
X_27954_ _04671_ _03913_ _03925_ _04014_ VPWR VGND sg13g2_a21oi_1
X_27955_ _04672_ _04206_ _04209_ _04223_ VPWR VGND sg13g2_nand3_1
X_27956_ _04673_ _04014_ _04670_ _04671_ _04672_ _03940_
+ VPWR
+ VGND sg13g2_a221oi_1
X_27957_ _04674_ \memory_i.freq_inst.Y_o[20]\ _04004_ _04673_ VPWR VGND sg13g2_a21o_1
X_27958_ _04675_ _04674_ VPWR VGND sg13g2_buf_1
X_27959_ _04676_ \memory_i.freq_inst.cordic.shift_value[4]\ _03957_ _04022_ VPWR VGND sg13g2_a21oi_1
X_27960_ _04677_ _03617_ _04184_ VPWR VGND sg13g2_nor2_1
X_27961_ _04678_ _04676_ _04677_ VPWR VGND sg13g2_xor2_1
X_27962_ _04679_ _04675_ _04678_ VPWR VGND sg13g2_or2_1
X_27963_ _04680_ \memory_i.freq_inst.cordic.roc_in_X[20]\ _04240_ _04242_ VPWR VGND sg13g2_nor3_1
X_27964_ _04681_ _04252_ _04680_ _04250_ VPWR VGND sg13g2_a21oi_1
X_27965_ _04682_ \memory_i.freq_inst.cordic.roc_in_X[21]\ _04246_ _04680_ VPWR VGND sg13g2_or3_1
X_27966_ _04683_ _04011_ _04681_ _04682_ VPWR VGND sg13g2_o21ai_1
X_27967_ _04684_ \memory_i.freq_inst.Y_o[21]\ _03351_ VPWR VGND sg13g2_and2_1
X_27968_ _04685_ _03679_ _04683_ _04684_ VPWR VGND sg13g2_a21oi_1
X_27969_ _04686_ _04481_ _04184_ _03591_ VPWR VGND sg13g2_a21oi_1
X_27970_ _04687_ _03987_ _04686_ VPWR VGND sg13g2_xnor2_1
X_27971_ _04688_ _03576_ _04303_ VPWR VGND sg13g2_nor2_1
X_27972_ _04689_ _04198_ _04184_ _04688_ VPWR VGND sg13g2_o21ai_1
X_27973_ _04690_ \memory_i.freq_inst.cordic.shift_value[4]\ _04687_ _04689_ VPWR VGND sg13g2_o21ai_1
X_27974_ _04691_ _04685_ _04690_ VPWR VGND sg13g2_nand2_1
X_27975_ _04692_ _04679_ _04691_ VPWR VGND sg13g2_nand2_1
X_27976_ _04693_ _03678_ _04683_ _04684_ VPWR VGND sg13g2_a21o_1
X_27977_ _04694_ _04693_ VPWR VGND sg13g2_buf_2
X_27978_ _04695_ _04675_ _04678_ VPWR VGND sg13g2_nand2_1
X_27979_ _04696_ _04695_ VPWR VGND sg13g2_inv_1
X_27980_ _04697_ _04685_ _04695_ _04690_ VPWR VGND sg13g2_o21ai_1
X_27981_ _04698_ _04694_ _04696_ _04697_ VPWR VGND sg13g2_o21ai_1
X_27982_ _04699_ _04669_ _04692_ _04698_ VPWR VGND sg13g2_o21ai_1
X_27983_ _04700_ _03718_ _04185_ VPWR VGND sg13g2_nand2_1
X_27984_ _04701_ _04187_ _04700_ VPWR VGND sg13g2_xnor2_1
X_27985_ _04702_ \memory_i.freq_inst.cordic.roc_in_X[21]\ \memory_i.freq_inst.cordic.roc_in_X[20]\ _04240_ _04242_ VPWR
+ VGND
+ sg13g2_nor4_1
X_27986_ _04703_ _04702_ _04357_ _04231_ VPWR VGND sg13g2_a21oi_1
X_27987_ _04704_ _04007_ _04703_ VPWR VGND sg13g2_nor2_1
X_27988_ _04705_ \memory_i.freq_inst.cordic.roc_in_X[22]\ _04702_ _04208_ VPWR VGND sg13g2_nor3_1
X_27989_ _04706_ \memory_i.freq_inst.Y_o[22]\ _03940_ _04705_ VPWR VGND sg13g2_a21oi_1
X_27990_ _04707_ _04704_ _04706_ VPWR VGND sg13g2_nor2b_1
X_27991_ _04708_ _04701_ _04707_ VPWR VGND sg13g2_nand2_1
X_27992_ _04709_ _04701_ _04707_ VPWR VGND sg13g2_nor2_1
X_27993_ _04710_ _04699_ _04708_ _04709_ VPWR VGND sg13g2_a21oi_1
X_27994_ _04711_ _04300_ _04306_ VPWR VGND sg13g2_nor2_1
X_27995_ _04712_ _04307_ _04710_ _04711_ VPWR VGND sg13g2_a21o_1
X_27996_ _04713_ _04712_ VPWR VGND sg13g2_buf_4
X_27997_ _04714_ _04282_ _04288_ VPWR VGND sg13g2_and2_1
X_27998_ _04715_ _04714_ VPWR VGND sg13g2_buf_1
X_27999_ _04716_ _04292_ _04715_ VPWR VGND sg13g2_nor2_1
X_28000_ _04717_ _04713_ _04716_ VPWR VGND sg13g2_nand2_1
X_28001_ _04718_ _04275_ _04293_ _04717_ VPWR VGND sg13g2_nand3_1
X_28002_ _04719_ _04282_ _04288_ VPWR VGND sg13g2_nor2_1
X_28003_ _04720_ _04713_ _04719_ VPWR VGND sg13g2_nor2_2
X_28004_ _04721_ _04720_ _04715_ _04292_ VPWR VGND sg13g2_o21ai_1
X_28005_ _04722_ _03967_ _04236_ VPWR VGND sg13g2_xnor2_1
X_28006_ _04723_ _04194_ _04236_ _04722_ _03852_ VPWR
+ VGND
+ sg13g2_a22oi_1
X_28007_ _04724_ _04259_ _04238_ VPWR VGND sg13g2_xnor2_1
X_28008_ _04725_ _04723_ _04724_ VPWR VGND sg13g2_nand2b_1
X_28009_ _04726_ _04192_ _04236_ VPWR VGND sg13g2_nor2_1
X_28010_ _04727_ _04192_ _04236_ VPWR VGND sg13g2_xnor2_1
X_28011_ _04728_ _03967_ _04727_ VPWR VGND sg13g2_nor2_1
X_28012_ _04729_ _03967_ _04726_ _04728_ VPWR VGND sg13g2_a21oi_1
X_28013_ _04730_ _03852_ _04724_ _04729_ VPWR VGND sg13g2_or3_1
X_28014_ _04731_ _04718_ _04721_ _04725_ _04730_ VPWR
+ VGND
+ sg13g2_a22oi_1
X_28015_ _04732_ _04236_ _04267_ _04269_ _04259_ _04731_
+ VPWR
+ VGND sg13g2_a221oi_1
X_28016_ _04733_ _04732_ VPWR VGND sg13g2_buf_2
X_28017_ _04734_ _04203_ _04733_ VPWR VGND sg13g2_or2_1
X_28018_ _04735_ _04734_ VPWR VGND sg13g2_buf_2
X_28019_ _04736_ _03677_ _04250_ VPWR VGND sg13g2_nand2_1
X_28020_ _04737_ _03988_ _04245_ VPWR VGND sg13g2_and2_1
X_28021_ _04738_ _04737_ VPWR VGND sg13g2_buf_1
X_28022_ _04739_ _04244_ _04738_ _04357_ VPWR VGND sg13g2_nand3_1
X_28023_ _04740_ \memory_i.freq_inst.cordic.roc_in_X[28]\ VPWR VGND sg13g2_inv_1
X_28024_ _04741_ _04736_ _04739_ _04740_ VPWR VGND sg13g2_a21o_1
X_28025_ _04742_ _04244_ _04738_ VPWR VGND sg13g2_nand2_1
X_28026_ _04743_ \memory_i.freq_inst.cordic.roc_in_X[28]\ _04208_ VPWR VGND sg13g2_nor2_1
X_28027_ _04744_ \memory_i.freq_inst.Y_o[28]\ _04004_ _04742_ _04743_ VPWR
+ VGND
+ sg13g2_a22oi_1
X_28028_ _04745_ _04741_ _04744_ VPWR VGND sg13g2_and2_1
X_28029_ _04746_ _04745_ VPWR VGND sg13g2_buf_8
X_28030_ _04747_ _04740_ _04738_ VPWR VGND sg13g2_nand2_1
X_28031_ _04748_ _04240_ _04242_ _04243_ _04747_ VPWR
+ VGND
+ sg13g2_nor4_1
X_28032_ _04749_ _04253_ _04748_ _04250_ VPWR VGND sg13g2_a21o_1
X_28033_ _04750_ \memory_i.freq_inst.cordic.roc_in_X[29]\ _04247_ _04748_ VPWR VGND sg13g2_nor3_1
X_28034_ _04751_ \memory_i.freq_inst.cordic.roc_in_X[29]\ _04749_ _04750_ VPWR VGND sg13g2_a21oi_1
X_28035_ _04752_ \memory_i.freq_inst.Y_o[29]\ _03678_ VPWR VGND sg13g2_nor2_1
X_28036_ _04753_ _03679_ _04751_ _04752_ VPWR VGND sg13g2_a21o_1
X_28037_ _04754_ _04753_ VPWR VGND sg13g2_buf_1
X_28038_ _04755_ _03946_ _03955_ _04198_ VPWR VGND sg13g2_a21o_1
X_28039_ _04756_ _03943_ _03946_ _03955_ _04194_ VPWR
+ VGND
+ sg13g2_nand4_1
X_28040_ _04757_ _04755_ _04756_ \memory_i.freq_inst.cordic.shift_value[4]\ VPWR VGND sg13g2_a21oi_1
X_28041_ _04758_ _04198_ _04194_ VPWR VGND sg13g2_nor2_1
X_28042_ _04759_ _04757_ _04303_ _04758_ VPWR VGND sg13g2_nor3_1
X_28043_ _04760_ _04754_ _04759_ VPWR VGND sg13g2_nor2_1
X_28044_ _04761_ _04735_ _04746_ _04760_ VPWR VGND sg13g2_nand3_1
X_28045_ _04762_ _04761_ VPWR VGND sg13g2_buf_4
X_28046_ _04763_ _04762_ VPWR VGND sg13g2_buf_4
X_28047_ _04764_ _04130_ _04439_ VPWR VGND sg13g2_xnor2_1
X_28048_ _04765_ _04754_ _04759_ VPWR VGND sg13g2_nand2_1
X_28049_ _04766_ _04203_ _04733_ VPWR VGND sg13g2_and2_1
X_28050_ _04767_ _04766_ VPWR VGND sg13g2_buf_2
X_28051_ _04768_ _04765_ _04767_ _04746_ VPWR VGND sg13g2_nor3_1
X_28052_ _04769_ _04768_ VPWR VGND sg13g2_buf_8
X_28053_ _04770_ _04769_ VPWR VGND sg13g2_buf_8
X_28054_ _04771_ _04763_ _04764_ _04770_ VPWR VGND sg13g2_a21oi_1
X_28055_ _01507_ _03879_ _04771_ VPWR VGND sg13g2_nor2_1
X_28056_ _04772_ _04769_ _04762_ VPWR VGND sg13g2_nor2b_2
X_28057_ _04773_ _04772_ VPWR VGND sg13g2_buf_4
X_28058_ _04774_ _04773_ VPWR VGND sg13g2_buf_8
X_28059_ _04775_ _03947_ VPWR VGND sg13g2_buf_1
X_28060_ _04776_ _04775_ _04439_ VPWR VGND sg13g2_xnor2_1
X_28061_ _04777_ _04130_ _04776_ VPWR VGND sg13g2_nor2_1
X_28062_ _04778_ _04120_ _04435_ VPWR VGND sg13g2_xnor2_1
X_28063_ _04779_ _04777_ _04778_ VPWR VGND sg13g2_xnor2_1
X_28064_ _04780_ \memory_i.freq_inst.cordic.rstn_i\ _04762_ VPWR VGND sg13g2_nand2_1
X_28065_ _04781_ _04780_ VPWR VGND sg13g2_buf_4
X_28066_ _04782_ _04781_ VPWR VGND sg13g2_buf_8
X_28067_ _01508_ _04774_ _04779_ _04782_ VPWR VGND sg13g2_a21oi_1
X_28068_ _04783_ _04444_ _04448_ VPWR VGND sg13g2_nand2_1
X_28069_ _04784_ _04426_ _04428_ VPWR VGND sg13g2_xnor2_1
X_28070_ _04785_ _04783_ _04784_ VPWR VGND sg13g2_xnor2_1
X_28071_ _01509_ _04774_ _04785_ _04782_ VPWR VGND sg13g2_a21oi_2
X_28072_ _04786_ _04426_ _04449_ _04450_ VPWR VGND sg13g2_a21o_1
X_28073_ _04787_ _04414_ _04417_ VPWR VGND sg13g2_xnor2_1
X_28074_ _04788_ _04786_ _04787_ VPWR VGND sg13g2_xor2_1
X_28075_ _01510_ _04774_ _04788_ _04782_ VPWR VGND sg13g2_a21oi_2
X_28076_ _04789_ _04418_ _04451_ VPWR VGND sg13g2_or2_1
X_28077_ _04790_ _04789_ VPWR VGND sg13g2_buf_1
X_28078_ _04791_ _04453_ _04525_ VPWR VGND sg13g2_xnor2_1
X_28079_ _04792_ _04476_ _04791_ VPWR VGND sg13g2_xnor2_1
X_28080_ _04793_ _04790_ _04792_ VPWR VGND sg13g2_xnor2_1
X_28081_ _01511_ _04774_ _04793_ _04782_ VPWR VGND sg13g2_a21oi_2
X_28082_ _04794_ _04453_ _04460_ VPWR VGND sg13g2_nor2_1
X_28083_ _04795_ _04790_ _04461_ _04794_ VPWR VGND sg13g2_a21oi_1
X_28084_ _04796_ _04133_ _04795_ VPWR VGND sg13g2_nor2_1
X_28085_ _04797_ _04790_ _04794_ _04796_ VPWR VGND sg13g2_a21oi_1
X_28086_ _04798_ _04483_ _04460_ VPWR VGND sg13g2_nor2_1
X_28087_ _04799_ _04790_ _04798_ _04484_ VPWR VGND sg13g2_o21ai_1
X_28088_ _04800_ _04775_ _04799_ VPWR VGND sg13g2_nor2_1
X_28089_ _04801_ _04775_ _04797_ _04800_ VPWR VGND sg13g2_a21oi_1
X_28090_ _04802_ _04464_ _04472_ VPWR VGND sg13g2_xnor2_1
X_28091_ _04803_ _04801_ _04802_ VPWR VGND sg13g2_xnor2_1
X_28092_ _01512_ _04774_ _04803_ _04782_ VPWR VGND sg13g2_a21oi_2
X_28093_ _04804_ _04487_ _04526_ VPWR VGND sg13g2_and2_1
X_28094_ _04805_ _04804_ VPWR VGND sg13g2_buf_1
X_28095_ _04806_ _03852_ VPWR VGND sg13g2_buf_1
X_28096_ _04807_ _04133_ _04140_ VPWR VGND sg13g2_and2_1
X_28097_ _04808_ _04806_ _04807_ VPWR VGND sg13g2_nor2_1
X_28098_ _04809_ _04506_ _04808_ VPWR VGND sg13g2_xor2_1
X_28099_ _04810_ _04805_ _04809_ VPWR VGND sg13g2_xnor2_1
X_28100_ _04811_ _04763_ _04810_ _04770_ VPWR VGND sg13g2_a21oi_1
X_28101_ _01513_ _03879_ _04811_ VPWR VGND sg13g2_nor2_1
X_28102_ _04812_ _04505_ _04805_ VPWR VGND sg13g2_nor2_1
X_28103_ _04813_ _04505_ _04805_ _04807_ VPWR VGND sg13g2_a21oi_1
X_28104_ _04814_ _04806_ _04813_ _04812_ VPWR VGND sg13g2_or3_1
X_28105_ _04815_ _04806_ _04812_ _04092_ VPWR VGND sg13g2_a21oi_1
X_28106_ _04816_ _04505_ _04805_ VPWR VGND sg13g2_nand2_1
X_28107_ _04817_ _04775_ _04345_ _04816_ VPWR VGND sg13g2_a21oi_1
X_28108_ _04818_ _04808_ _04812_ _04814_ _04815_ _04817_
+ VPWR
+ VGND sg13g2_a221oi_1
X_28109_ _04819_ _04497_ _04818_ VPWR VGND sg13g2_xnor2_1
X_28110_ _04820_ _04763_ _04819_ _04770_ VPWR VGND sg13g2_a21oi_1
X_28111_ _01514_ _03879_ _04820_ VPWR VGND sg13g2_nor2_1
X_28112_ _04821_ _04487_ _04527_ VPWR VGND sg13g2_nand2_1
X_28113_ _04822_ _04821_ _04549_ VPWR VGND sg13g2_and2_1
X_28114_ _04823_ _04822_ VPWR VGND sg13g2_buf_1
X_28115_ _04824_ _04775_ _04567_ VPWR VGND sg13g2_nand2_1
X_28116_ _04825_ _04598_ _04824_ VPWR VGND sg13g2_xnor2_1
X_28117_ _04826_ _04823_ _04825_ VPWR VGND sg13g2_xnor2_1
X_28118_ _01515_ _04774_ _04826_ _04782_ VPWR VGND sg13g2_a21oi_2
X_28119_ _04827_ _04557_ _04823_ VPWR VGND sg13g2_nor2_1
X_28120_ _04828_ _04775_ _04823_ _04827_ VPWR VGND sg13g2_a21oi_1
X_28121_ _04829_ _04567_ VPWR VGND sg13g2_inv_1
X_28122_ _04830_ _04829_ _04577_ VPWR VGND sg13g2_nand2_1
X_28123_ _04831_ _04830_ _04823_ _04557_ VPWR VGND sg13g2_mux2_1
X_28124_ _04832_ _03852_ _04557_ VPWR VGND sg13g2_nor2_1
X_28125_ _04833_ _04832_ _04557_ _04823_ VPWR VGND sg13g2_mux2_1
X_28126_ _04834_ _04829_ _04577_ _04833_ VPWR VGND sg13g2_o21ai_1
X_28127_ _04835_ _04806_ _04831_ _04834_ VPWR VGND sg13g2_o21ai_1
X_28128_ _04836_ _04578_ _04828_ _04835_ VPWR VGND sg13g2_a21oi_1
X_28129_ _04837_ _04597_ _04836_ VPWR VGND sg13g2_xor2_1
X_28130_ _04838_ _04763_ _04837_ _04770_ VPWR VGND sg13g2_a21oi_1
X_28131_ _01516_ _03879_ _04838_ VPWR VGND sg13g2_nor2_1
X_28132_ _04839_ _04593_ VPWR VGND sg13g2_inv_1
X_28133_ _04840_ _04604_ _04823_ _04839_ VPWR VGND sg13g2_o21ai_1
X_28134_ _04841_ _04536_ _04555_ VPWR VGND sg13g2_xnor2_1
X_28135_ _04842_ _04840_ _04841_ VPWR VGND sg13g2_xnor2_1
X_28136_ _04843_ _04763_ _04842_ _04770_ VPWR VGND sg13g2_a21oi_1
X_28137_ _01517_ _03879_ _04843_ VPWR VGND sg13g2_nor2_1
X_28138_ _04844_ _04595_ _04608_ VPWR VGND sg13g2_nor2_1
X_28139_ _04845_ _04624_ _04627_ VPWR VGND sg13g2_xor2_1
X_28140_ _04846_ _04844_ _04845_ VPWR VGND sg13g2_xnor2_1
X_28141_ _01518_ _04774_ _04846_ _04782_ VPWR VGND sg13g2_a21oi_2
X_28142_ _04847_ _04624_ _04627_ VPWR VGND sg13g2_and2_1
X_28143_ _04848_ _04844_ _04847_ _04646_ VPWR VGND sg13g2_o21ai_1
X_28144_ _04849_ _04641_ _04630_ VPWR VGND sg13g2_xnor2_1
X_28145_ _04850_ _04848_ _04849_ VPWR VGND sg13g2_xnor2_1
X_28146_ _01519_ _04774_ _04850_ _04782_ VPWR VGND sg13g2_a21oi_2
X_28147_ _04851_ _04641_ _04848_ VPWR VGND sg13g2_nand2b_1
X_28148_ _04852_ _04848_ _04641_ VPWR VGND sg13g2_nor2b_1
X_28149_ _04853_ _04851_ _04630_ _04852_ VPWR VGND sg13g2_a21oi_1
X_28150_ _04854_ _04611_ _04617_ VPWR VGND sg13g2_xnor2_1
X_28151_ _04855_ _04853_ _04854_ VPWR VGND sg13g2_xor2_1
X_28152_ _04856_ _04763_ _04855_ _04770_ VPWR VGND sg13g2_a21oi_1
X_28153_ _01520_ _03879_ _04856_ VPWR VGND sg13g2_nor2_1
X_28154_ _04857_ _04611_ _04617_ _04649_ VPWR VGND sg13g2_o21ai_1
X_28155_ _04858_ _04857_ VPWR VGND sg13g2_buf_1
X_28156_ _04859_ _04653_ _04858_ VPWR VGND sg13g2_xor2_1
X_28157_ _01521_ _04774_ _04859_ _04782_ VPWR VGND sg13g2_a21oi_1
X_28158_ _04860_ _04652_ VPWR VGND sg13g2_inv_1
X_28159_ _04861_ _04858_ VPWR VGND sg13g2_inv_1
X_28160_ _04862_ _04652_ _04861_ _04386_ VPWR VGND sg13g2_o21ai_1
X_28161_ _04863_ _04860_ _04858_ _04862_ VPWR VGND sg13g2_o21ai_1
X_28162_ _04864_ _04651_ _04863_ VPWR VGND sg13g2_xor2_1
X_28163_ _04865_ _04763_ _04864_ _04770_ VPWR VGND sg13g2_a21oi_1
X_28164_ _01522_ _03879_ _04865_ VPWR VGND sg13g2_nor2_1
X_28165_ _04866_ _04654_ _04858_ _04405_ VPWR VGND sg13g2_o21ai_1
X_28166_ _04867_ _04353_ _04866_ VPWR VGND sg13g2_xor2_1
X_28167_ _04868_ _04763_ _04867_ _04770_ VPWR VGND sg13g2_a21oi_1
X_28168_ _01523_ _03879_ _04868_ VPWR VGND sg13g2_nor2_1
X_28169_ _04869_ _04352_ _04866_ _04343_ VPWR VGND sg13g2_a21o_1
X_28170_ _04870_ _04352_ _04866_ _04869_ VPWR VGND sg13g2_o21ai_1
X_28171_ _04871_ _04364_ _04870_ VPWR VGND sg13g2_xnor2_1
X_28172_ _04872_ _04763_ _04871_ _04769_ VPWR VGND sg13g2_a21oi_1
X_28173_ _01524_ _03879_ _04872_ VPWR VGND sg13g2_nor2_1
X_28174_ _04873_ _03656_ VPWR VGND sg13g2_buf_1
X_28175_ _04874_ _04354_ _04356_ _04359_ VPWR VGND sg13g2_nand3_1
X_28176_ _04875_ _04874_ VPWR VGND sg13g2_buf_2
X_28177_ _04876_ _04361_ _04657_ _04870_ VPWR VGND sg13g2_o21ai_1
X_28178_ _04877_ _04875_ _04363_ _04876_ VPWR VGND sg13g2_o21ai_1
X_28179_ _04878_ _04373_ _04877_ VPWR VGND sg13g2_xnor2_1
X_28180_ _04879_ _04763_ _04878_ _04769_ VPWR VGND sg13g2_a21oi_1
X_28181_ _01525_ _04873_ _04879_ VPWR VGND sg13g2_nor2_1
X_28182_ _04880_ _04661_ _04877_ _04366_ VPWR VGND sg13g2_o21ai_1
X_28183_ _04881_ _04661_ _04877_ VPWR VGND sg13g2_nand2_1
X_28184_ _04882_ _04880_ _04881_ VPWR VGND sg13g2_nand2_1
X_28185_ _04883_ _04336_ _04882_ VPWR VGND sg13g2_xor2_1
X_28186_ _04884_ _04762_ _04883_ _04769_ VPWR VGND sg13g2_a21oi_1
X_28187_ _01526_ _04873_ _04884_ VPWR VGND sg13g2_nor2_1
X_28188_ _04885_ _04695_ _04679_ VPWR VGND sg13g2_nand2_1
X_28189_ _04886_ _04669_ _04885_ VPWR VGND sg13g2_xor2_1
X_28190_ _04887_ _04762_ _04886_ _04769_ VPWR VGND sg13g2_a21oi_1
X_28191_ _01527_ _04873_ _04887_ VPWR VGND sg13g2_nor2_1
X_28192_ _04888_ \memory_i.freq_inst.Y_o[20]\ _03831_ _04673_ VPWR VGND sg13g2_a21oi_1
X_28193_ _04889_ _04888_ _04669_ VPWR VGND sg13g2_nor2_1
X_28194_ _04890_ _04888_ _04669_ VPWR VGND sg13g2_nand2_1
X_28195_ _04891_ _04678_ _04889_ _04890_ VPWR VGND sg13g2_o21ai_1
X_28196_ _04892_ _04694_ _04690_ VPWR VGND sg13g2_xnor2_1
X_28197_ _04893_ _04891_ _04892_ VPWR VGND sg13g2_xnor2_1
X_28198_ _04894_ _04762_ _04893_ _04769_ VPWR VGND sg13g2_a21oi_1
X_28199_ _01528_ _04873_ _04894_ VPWR VGND sg13g2_nor2_1
X_28200_ _04895_ _04709_ _04708_ VPWR VGND sg13g2_nand2b_1
X_28201_ _04896_ _04699_ _04895_ VPWR VGND sg13g2_xnor2_1
X_28202_ _04897_ _04762_ _04896_ _04769_ VPWR VGND sg13g2_a21oi_1
X_28203_ _01529_ _04873_ _04897_ VPWR VGND sg13g2_nor2_1
X_28204_ _04898_ _04770_ VPWR VGND sg13g2_inv_1
X_28205_ _04899_ _04300_ _04306_ VPWR VGND sg13g2_xnor2_1
X_28206_ _04900_ _04710_ _04899_ VPWR VGND sg13g2_xnor2_1
X_28207_ _01530_ _04898_ _04900_ _04782_ VPWR VGND sg13g2_a21oi_1
X_28208_ _04901_ _04719_ _04715_ VPWR VGND sg13g2_or2_1
X_28209_ _04902_ _04713_ _04901_ VPWR VGND sg13g2_xnor2_1
X_28210_ _01531_ _04774_ _04902_ _04781_ VPWR VGND sg13g2_a21oi_2
X_28211_ _04903_ _04720_ _04715_ VPWR VGND sg13g2_nor2_1
X_28212_ _04904_ _04275_ _04292_ VPWR VGND sg13g2_xnor2_1
X_28213_ _04905_ _04903_ _04904_ VPWR VGND sg13g2_xnor2_1
X_28214_ _01532_ _04773_ _04905_ _04781_ VPWR VGND sg13g2_a21oi_1
X_28215_ _04906_ _04718_ _04721_ VPWR VGND sg13g2_and2_1
X_28216_ _04907_ _04906_ VPWR VGND sg13g2_buf_1
X_28217_ _04908_ _04722_ _04264_ VPWR VGND sg13g2_xnor2_1
X_28218_ _04909_ _04907_ _04908_ VPWR VGND sg13g2_xnor2_1
X_28219_ _01533_ _04773_ _04909_ _04781_ VPWR VGND sg13g2_a21oi_1
X_28220_ _04910_ \memory_i.freq_inst.cordic.roc_in_X[26]\ _04227_ VPWR VGND sg13g2_xnor2_1
X_28221_ _04911_ \memory_i.freq_inst.Y_o[26]\ _03999_ _04357_ _04910_ _04232_
+ VPWR
+ VGND sg13g2_a221oi_1
X_28222_ _04912_ _04911_ VPWR VGND sg13g2_buf_2
X_28223_ _04913_ _04806_ _03967_ VPWR VGND sg13g2_nor2_1
X_28224_ _04914_ _04907_ _04912_ _03967_ VPWR VGND sg13g2_a21o_1
X_28225_ _04915_ _04907_ _04912_ _04914_ VPWR VGND sg13g2_o21ai_1
X_28226_ _04916_ _04806_ VPWR VGND sg13g2_buf_1
X_28227_ _04917_ _04907_ _04264_ VPWR VGND sg13g2_nand2_1
X_28228_ _04918_ _03967_ _04236_ _04917_ VPWR VGND sg13g2_a21oi_1
X_28229_ _04919_ _04912_ _04913_ _04915_ _04916_ _04918_
+ VPWR
+ VGND sg13g2_a221oi_1
X_28230_ _04920_ _04724_ _04919_ VPWR VGND sg13g2_xor2_1
X_28231_ _04921_ \memory_i.freq_inst.cordic.rstn_i\ _04770_ VPWR VGND sg13g2_nand2_1
X_28232_ _01534_ _04781_ _04920_ _04921_ VPWR VGND sg13g2_o21ai_1
X_28233_ _04922_ _04202_ _04733_ VPWR VGND sg13g2_xnor2_1
X_28234_ _04923_ _04760_ _04922_ _04746_ VPWR VGND sg13g2_nand3b_1
X_28235_ _04924_ _04765_ _04735_ _04746_ VPWR VGND sg13g2_a21o_1
X_28236_ _04925_ _04746_ _04760_ VPWR VGND sg13g2_nor2_1
X_28237_ _04926_ _04765_ _04733_ VPWR VGND sg13g2_nor2_1
X_28238_ _04927_ _04767_ _04925_ _04926_ VPWR VGND sg13g2_a21oi_1
X_28239_ _04928_ _04923_ _04924_ _04927_ VPWR VGND sg13g2_nand3_1
X_28240_ _01535_ \memory_i.freq_inst.cordic.rstn_i\ _04928_ VPWR VGND sg13g2_and2_1
X_28241_ _04929_ _04735_ _04746_ _04767_ VPWR VGND sg13g2_a21o_1
X_28242_ _04930_ _04765_ _04929_ _04760_ VPWR VGND sg13g2_a21oi_1
X_28243_ _01536_ _04873_ _04930_ VPWR VGND sg13g2_nor2_1
X_28244_ _04931_ \memory_i.freq_inst.X_o[28]\ _03831_ VPWR VGND sg13g2_nand2_1
X_28245_ _04932_ _04740_ _04008_ _04931_ VPWR VGND sg13g2_o21ai_1
X_28246_ _04933_ \memory_i.freq_inst.Y_o[29]\ VPWR VGND sg13g2_inv_1
X_28247_ _04934_ _04024_ VPWR VGND sg13g2_buf_2
X_28248_ _04935_ _04933_ _04256_ _04746_ _04912_ _04934_
+ _03424_
+ VPWR VGND sg13g2_mux4_1
X_28249_ _04936_ \memory_i.freq_inst.cordic.shift_value[2]\ _03804_ VPWR VGND sg13g2_nor2_1
X_28250_ _04937_ _03679_ _04751_ _04752_ VPWR VGND sg13g2_a21oi_1
X_28251_ _04938_ _04937_ _04936_ VPWR VGND sg13g2_nor2_1
X_28252_ _04939_ _04935_ _04936_ _04938_ VPWR VGND sg13g2_a21oi_1
X_28253_ _04940_ _04741_ _04744_ VPWR VGND sg13g2_nand2_1
X_28254_ _04941_ _04275_ _04259_ _04236_ _04940_ \memory_i.freq_inst.cordic.shift_value[1]\
+ \memory_i.freq_inst.cordic.shift_value[0]\
+ VPWR VGND sg13g2_mux4_1
X_28255_ _04942_ _03475_ _04754_ VPWR VGND sg13g2_nor2_1
X_28256_ _04943_ _03475_ _04941_ _04942_ VPWR VGND sg13g2_a21oi_1
X_28257_ _04944_ \memory_i.freq_inst.cordic.shift_value[4]\ _04943_ VPWR VGND sg13g2_nor2_1
X_28258_ _04945_ \memory_i.freq_inst.Y_o[29]\ \memory_i.freq_inst.Y_o[27]\ _04940_ _04235_ _04024_
+ _03356_
+ VPWR VGND sg13g2_mux4_1
X_28259_ _04946_ _04704_ _04706_ VPWR VGND sg13g2_nand2b_1
X_28260_ _04947_ _04946_ VPWR VGND sg13g2_buf_2
X_28261_ _04948_ \memory_i.freq_inst.Y_o[25]\ \memory_i.freq_inst.Y_o[23]\ _04288_ _04947_ _04024_
+ _03356_
+ VPWR VGND sg13g2_mux4_1
X_28262_ _04949_ \memory_i.freq_inst.Y_o[21]\ \memory_i.freq_inst.Y_o[19]\ _04675_ _04372_ _04024_
+ _13165_
+ VPWR VGND sg13g2_mux4_1
X_28263_ _04950_ \memory_i.freq_inst.Y_o[29]\ _04945_ _04948_ _04949_ _03194_
+ _03184_
+ VPWR VGND sg13g2_mux4_1
X_28264_ _04951_ _04950_ VPWR VGND sg13g2_buf_2
X_28265_ _04952_ \memory_i.freq_inst.Y_o[24]\ _04300_ _04947_ _04694_ _13165_
+ _04934_
+ VPWR VGND sg13g2_mux4_1
X_28266_ _04953_ _04952_ VPWR VGND sg13g2_buf_2
X_28267_ _04954_ \memory_i.freq_inst.Y_o[20]\ _04319_ _04372_ _04875_ _13165_
+ _03176_
+ VPWR VGND sg13g2_mux4_1
X_28268_ _04955_ _04954_ VPWR VGND sg13g2_buf_1
X_28269_ _04956_ _04953_ _04955_ _03195_ VPWR VGND sg13g2_mux2_1
X_28270_ _04957_ _03188_ _04956_ _04941_ _03765_ VPWR
+ VGND
+ sg13g2_a22oi_1
X_28271_ _04958_ \memory_i.freq_inst.cordic.shift_value[4]\ _04957_ VPWR VGND sg13g2_nor2_1
X_28272_ _04959_ _03536_ _03637_ _04754_ VPWR VGND sg13g2_a21oi_1
X_28273_ _04960_ _04958_ _04959_ VPWR VGND sg13g2_nor2_1
X_28274_ _04961_ \memory_i.freq_inst.Y_o[24]\ _04300_ _04236_ _04275_ _03424_
+ \memory_i.freq_inst.cordic.shift_value[1]\
+ VPWR VGND sg13g2_mux4_1
X_28275_ _04962_ \memory_i.freq_inst.Y_o[20]\ _04947_ _04319_ _04694_ \memory_i.freq_inst.cordic.shift_value[1]\
+ _03424_
+ VPWR VGND sg13g2_mux4_1
X_28276_ _04963_ _04961_ _04962_ _03441_ VPWR VGND sg13g2_mux2_1
X_28277_ _04964_ _04261_ _04746_ \memory_i.freq_inst.cordic.shift_value[0]\ VPWR VGND sg13g2_mux2_1
X_28278_ _04965_ _04964_ VPWR VGND sg13g2_buf_2
X_28279_ _04966_ \memory_i.freq_inst.Y_o[29]\ _03373_ VPWR VGND sg13g2_nor2_1
X_28280_ _04967_ _03373_ _04965_ _04966_ VPWR VGND sg13g2_a21oi_1
X_28281_ _04968_ _04963_ _04967_ \memory_i.freq_inst.cordic.shift_value[3]\ VPWR VGND sg13g2_mux2_1
X_28282_ _04969_ _04968_ VPWR VGND sg13g2_buf_2
X_28283_ _04970_ \memory_i.freq_inst.Y_o[16]\ _04372_ _04398_ _04875_ \memory_i.freq_inst.cordic.shift_value[1]\
+ _03424_
+ VPWR VGND sg13g2_mux4_1
X_28284_ _04971_ \memory_i.freq_inst.Y_o[14]\ \memory_i.freq_inst.Y_o[12]\ _04617_ _04624_ _03177_
+ _03424_
+ VPWR VGND sg13g2_mux4_1
X_28285_ _04972_ _04970_ _04971_ _03441_ VPWR VGND sg13g2_mux2_1
X_28286_ _04973_ \memory_i.freq_inst.Y_o[10]\ \memory_i.freq_inst.Y_o[8]\ _04564_ _04496_ _03177_
+ _13167_
+ VPWR VGND sg13g2_mux4_1
X_28287_ _04974_ \memory_i.freq_inst.Y_o[6]\ \memory_i.freq_inst.Y_o[4]\ _04472_ _04414_ _03177_
+ _13167_
+ VPWR VGND sg13g2_mux4_1
X_28288_ _04975_ _04973_ _04974_ _03441_ VPWR VGND sg13g2_mux2_1
X_28289_ _04976_ _04972_ _04975_ _03185_ VPWR VGND sg13g2_mux2_1
X_28290_ _04977_ _03521_ _04976_ VPWR VGND sg13g2_and2_1
X_28291_ _04978_ \memory_i.freq_inst.cordic.shift_value[4]\ _04969_ _04977_ VPWR VGND sg13g2_a21o_1
X_28292_ _04979_ _04978_ VPWR VGND sg13g2_buf_2
X_28293_ _04980_ \memory_i.freq_inst.Y_o[15]\ \memory_i.freq_inst.Y_o[13]\ _04386_ _04641_ _04934_
+ _13166_
+ VPWR VGND sg13g2_mux4_1
X_28294_ _04981_ _04624_ _04535_ _04564_ _04577_ _13166_
+ _03177_
+ VPWR VGND sg13g2_mux4_1
X_28295_ _04982_ \memory_i.freq_inst.Y_o[7]\ \memory_i.freq_inst.Y_o[5]\ _04504_ _04460_ _04934_
+ _13166_
+ VPWR VGND sg13g2_mux4_1
X_28296_ _04983_ \memory_i.freq_inst.Y_o[3]\ \memory_i.freq_inst.Y_o[1]\ _04426_ _04439_ _04934_
+ _03424_
+ VPWR VGND sg13g2_mux4_1
X_28297_ _04984_ _04980_ _04981_ _04982_ _04983_ _03195_
+ _03185_
+ VPWR VGND sg13g2_mux4_1
X_28298_ _04985_ \memory_i.freq_inst.Y_o[15]\ _04875_ _04386_ _04343_ \memory_i.freq_inst.cordic.shift_value[1]\
+ _13166_
+ VPWR VGND sg13g2_mux4_1
X_28299_ _04986_ \memory_i.freq_inst.Y_o[13]\ _04641_ _04624_ _04535_ _03356_
+ _04934_
+ VPWR VGND sg13g2_mux4_1
X_28300_ _04987_ \memory_i.freq_inst.Y_o[7]\ _04564_ _04504_ _04577_ \memory_i.freq_inst.cordic.shift_value[1]\
+ _03424_
+ VPWR VGND sg13g2_mux4_1
X_28301_ _04988_ \memory_i.freq_inst.Y_o[5]\ \memory_i.freq_inst.Y_o[3]\ _04460_ _04426_ _04934_
+ _03424_
+ VPWR VGND sg13g2_mux4_1
X_28302_ _04989_ _04985_ _04986_ _04987_ _04988_ _03195_
+ _03185_
+ VPWR VGND sg13g2_mux4_1
X_28303_ _04990_ \memory_i.freq_inst.cordic.shift_value[4]\ _04984_ _04989_ VPWR VGND sg13g2_or3_1
X_28304_ _04991_ _04990_ VPWR VGND sg13g2_buf_1
X_28305_ _04992_ \memory_i.freq_inst.Y_o[27]\ \memory_i.freq_inst.Y_o[25]\ _04236_ _04288_ _03176_
+ _13166_
+ VPWR VGND sg13g2_mux4_1
X_28306_ _04993_ _04937_ _04940_ _03169_ VPWR VGND sg13g2_mux2_1
X_28307_ _04994_ \memory_i.freq_inst.Y_o[19]\ _04372_ _04875_ _04343_ _03356_
+ _04934_
+ VPWR VGND sg13g2_mux4_1
X_28308_ _04995_ \memory_i.freq_inst.Y_o[23]\ \memory_i.freq_inst.Y_o[21]\ _04947_ _04675_ _03176_
+ _13166_
+ VPWR VGND sg13g2_mux4_1
X_28309_ _04996_ _04992_ _04993_ _04994_ _04995_ \memory_i.freq_inst.cordic.shift_value[2]\
+ _03184_
+ VPWR VGND sg13g2_mux4_1
X_28310_ _04997_ _03521_ _04951_ _04996_ VPWR VGND sg13g2_or3_1
X_28311_ _04998_ _04997_ VPWR VGND sg13g2_buf_4
X_28312_ _04999_ _04271_ _04273_ _04274_ VPWR VGND sg13g2_a21o_1
X_28313_ _05000_ _04999_ _04261_ _04912_ _04746_ \memory_i.freq_inst.cordic.shift_value[1]\
+ \memory_i.freq_inst.cordic.shift_value[0]\
+ VPWR VGND sg13g2_mux4_1
X_28314_ _05001_ \memory_i.freq_inst.cordic.shift_value[2]\ \memory_i.freq_inst.Y_o[29]\ VPWR VGND sg13g2_nand2_1
X_28315_ _05002_ \memory_i.freq_inst.cordic.shift_value[2]\ _05000_ _05001_ VPWR VGND sg13g2_o21ai_1
X_28316_ _05003_ \memory_i.freq_inst.Y_o[8]\ \memory_i.freq_inst.Y_o[6]\ _04496_ _04472_ _04934_
+ _13166_
+ VPWR VGND sg13g2_mux4_1
X_28317_ _05004_ \memory_i.freq_inst.Y_o[4]\ \memory_i.freq_inst.Y_o[2]\ _04414_ _04435_ _04934_
+ _03424_
+ VPWR VGND sg13g2_mux4_1
X_28318_ _05005_ _05003_ _05004_ _03195_ VPWR VGND sg13g2_mux2_1
X_28319_ _05006_ \memory_i.freq_inst.Y_o[16]\ \memory_i.freq_inst.Y_o[14]\ _04398_ _04617_ _04024_
+ _03356_
+ VPWR VGND sg13g2_mux4_1
X_28320_ _05007_ _05006_ VPWR VGND sg13g2_buf_1
X_28321_ _05008_ \memory_i.freq_inst.Y_o[12]\ \memory_i.freq_inst.Y_o[10]\ _04624_ _04564_ _03176_
+ _13166_
+ VPWR VGND sg13g2_mux4_1
X_28322_ _05009_ _05007_ _05008_ _03195_ VPWR VGND sg13g2_mux2_1
X_28323_ _05010_ _04956_ _05002_ _05005_ _05009_ \memory_i.freq_inst.cordic.shift_value[3]\
+ _03521_
+ VPWR VGND sg13g2_mux4_1
X_28324_ _05011_ _05010_ VPWR VGND sg13g2_buf_2
X_28325_ _05012_ _04991_ _04998_ _05011_ VPWR VGND sg13g2_a21o_1
X_28326_ _05013_ _05012_ VPWR VGND sg13g2_buf_4
X_28327_ _05014_ \memory_i.freq_inst.Y_o[29]\ _03360_ VPWR VGND sg13g2_nand2_1
X_28328_ _05015_ _03360_ _04746_ _05014_ VPWR VGND sg13g2_o21ai_1
X_28329_ _05016_ _05015_ VPWR VGND sg13g2_buf_1
X_28330_ _05017_ _04992_ _04995_ _03441_ VPWR VGND sg13g2_mux2_2
X_28331_ _05018_ _04994_ _04980_ _03441_ VPWR VGND sg13g2_mux2_1
X_28332_ _05019_ _04981_ _04982_ _03196_ VPWR VGND sg13g2_mux2_1
X_28333_ _05020_ _05016_ _05017_ _05018_ _05019_ _03185_
+ _03521_
+ VPWR VGND sg13g2_mux4_1
X_28334_ _05021_ _05020_ VPWR VGND sg13g2_buf_4
X_28335_ _05022_ \memory_i.freq_inst.cordic.shift_value[0]\ \memory_i.freq_inst.Y_o[24]\ VPWR VGND sg13g2_and2_1
X_28336_ _05023_ _13167_ _04300_ _05022_ VPWR VGND sg13g2_a21oi_1
X_28337_ _05024_ _04707_ _04685_ _13167_ VPWR VGND sg13g2_mux2_1
X_28338_ _05025_ _04999_ _04912_ \memory_i.freq_inst.cordic.shift_value[0]\ VPWR VGND sg13g2_mux2_1
X_28339_ _05026_ _05023_ _05024_ _04965_ _05025_ _03178_
+ \memory_i.freq_inst.cordic.shift_value[2]\
+ VPWR VGND sg13g2_mux4_1
X_28340_ _05027_ _04955_ _05007_ _05008_ _05003_ _03195_
+ _03184_
+ VPWR VGND sg13g2_mux4_1
X_28341_ _05028_ \memory_i.freq_inst.cordic.shift_value[4]\ \memory_i.freq_inst.cordic.shift_value[3]\ _04933_ VPWR VGND sg13g2_nand3_1
X_28342_ _05029_ \memory_i.freq_inst.cordic.shift_value[4]\ _05027_ _05028_ VPWR VGND sg13g2_o21ai_1
X_28343_ _05030_ _03579_ _05026_ _05029_ VPWR VGND sg13g2_a21o_1
X_28344_ _05031_ _05030_ VPWR VGND sg13g2_buf_2
X_28345_ _05032_ _05021_ _05031_ VPWR VGND sg13g2_nand2b_1
X_28346_ _05033_ _04979_ _05013_ _05032_ VPWR VGND sg13g2_nor3_2
X_28347_ _05034_ _05033_ VPWR VGND sg13g2_buf_4
X_28348_ _05035_ _03640_ _04937_ VPWR VGND sg13g2_nor2_1
X_28349_ _05036_ _03640_ _04965_ _05035_ VPWR VGND sg13g2_a21oi_1
X_28350_ _05037_ _04963_ _04972_ _03186_ VPWR VGND sg13g2_mux2_1
X_28351_ _05038_ _05036_ _05037_ _03522_ VPWR VGND sg13g2_mux2_1
X_28352_ _05039_ _05038_ VPWR VGND sg13g2_buf_1
X_28353_ _05040_ _03475_ _04945_ _04942_ VPWR VGND sg13g2_a21oi_1
X_28354_ _05041_ _04948_ _04949_ _04985_ _04986_ _03197_
+ _03186_
+ VPWR VGND sg13g2_mux4_1
X_28355_ _05042_ \memory_i.freq_inst.cordic.shift_value[4]\ _05041_ VPWR VGND sg13g2_nor2_1
X_28356_ _05043_ \memory_i.freq_inst.cordic.shift_value[4]\ _05040_ _05042_ VPWR VGND sg13g2_a21oi_1
X_28357_ _05044_ _04992_ _04993_ \memory_i.freq_inst.cordic.shift_value[2]\ VPWR VGND sg13g2_mux2_1
X_28358_ _05045_ _03186_ _04933_ \memory_i.freq_inst.cordic.shift_value[4]\ VPWR VGND sg13g2_o21ai_1
X_28359_ _05046_ _03187_ _05044_ _05045_ VPWR VGND sg13g2_a21oi_1
X_28360_ _05047_ _04953_ _04955_ _05007_ _05008_ _03197_
+ _03186_
+ VPWR VGND sg13g2_mux4_1
X_28361_ _05048_ _04995_ _04994_ _04980_ _04981_ _03197_
+ _03186_
+ VPWR VGND sg13g2_mux4_1
X_28362_ _05049_ \memory_i.freq_inst.cordic.shift_value[4]\ _05047_ _05048_ VPWR VGND sg13g2_nor3_1
X_28363_ _05050_ _05046_ _04943_ _05049_ VPWR VGND sg13g2_a21oi_1
X_28364_ _05051_ _03195_ _04970_ VPWR VGND sg13g2_and2_1
X_28365_ _05052_ \memory_i.freq_inst.cordic.shift_value[2]\ _04962_ _05051_ VPWR VGND sg13g2_a21o_1
X_28366_ _05053_ _04259_ _04940_ \memory_i.freq_inst.cordic.shift_value[0]\ VPWR VGND sg13g2_mux2_1
X_28367_ _05054_ _04275_ _04236_ \memory_i.freq_inst.cordic.shift_value[0]\ VPWR VGND sg13g2_mux2_1
X_28368_ _05055_ _13167_ _04300_ _05022_ VPWR VGND sg13g2_a21o_1
X_28369_ _05056_ _04937_ _05053_ _05054_ _05055_ _03178_
+ _03196_
+ VPWR VGND sg13g2_mux4_1
X_28370_ _05057_ _04971_ _04973_ _03196_ VPWR VGND sg13g2_mux2_1
X_28371_ _05058_ \memory_i.freq_inst.Y_o[29]\ _05052_ _05056_ _05057_ _03521_
+ _03186_
+ VPWR VGND sg13g2_mux4_1
X_28372_ _05059_ _05058_ VPWR VGND sg13g2_buf_2
X_28373_ _05060_ \memory_i.freq_inst.cordic.shift_value[2]\ _04949_ VPWR VGND sg13g2_and2_1
X_28374_ _05061_ _03196_ _04985_ _05060_ VPWR VGND sg13g2_a21oi_1
X_28375_ _05062_ \memory_i.freq_inst.Y_o[25]\ VPWR VGND sg13g2_inv_1
X_28376_ _05063_ _03679_ _04286_ _04287_ VPWR VGND sg13g2_a21o_1
X_28377_ _05064_ _05062_ _04294_ _05063_ _04707_ _03177_
+ _13167_
+ VPWR VGND sg13g2_mux4_1
X_28378_ _05065_ _04935_ _05064_ _03195_ VPWR VGND sg13g2_mux2_1
X_28379_ _05066_ _05065_ VPWR VGND sg13g2_buf_2
X_28380_ _05067_ _03441_ _04987_ VPWR VGND sg13g2_and2_1
X_28381_ _05068_ \memory_i.freq_inst.cordic.shift_value[2]\ _04986_ _05067_ VPWR VGND sg13g2_a21oi_1
X_28382_ _05069_ _04933_ _05061_ _05066_ _05068_ _03521_
+ _03186_
+ VPWR VGND sg13g2_mux4_1
X_28383_ _05070_ _05069_ VPWR VGND sg13g2_buf_4
X_28384_ _05071_ _05059_ _05070_ VPWR VGND sg13g2_nand2b_1
X_28385_ _05072_ _05039_ _05043_ _05050_ _05071_ VPWR
+ VGND
+ sg13g2_nor4_2
X_28386_ _05073_ _03536_ _04996_ VPWR VGND sg13g2_nand2_1
X_28387_ _05074_ _04953_ _04941_ _05007_ _04955_ \memory_i.freq_inst.cordic.shift_value[2]\
+ _03187_
+ VPWR VGND sg13g2_mux4_1
X_28388_ _05075_ _03522_ _04933_ VPWR VGND sg13g2_nor2_1
X_28389_ _05076_ _05075_ VPWR VGND sg13g2_buf_1
X_28390_ _05077_ _03536_ _05074_ _05076_ VPWR VGND sg13g2_a21o_1
X_28391_ _05078_ _05077_ VPWR VGND sg13g2_buf_1
X_28392_ _05079_ \memory_i.freq_inst.Y_o[29]\ _05016_ _05017_ _05018_ _03187_
+ _03522_
+ VPWR VGND sg13g2_mux4_1
X_28393_ _05080_ _05079_ VPWR VGND sg13g2_buf_1
X_28394_ _05081_ _05078_ _05080_ VPWR VGND sg13g2_nor2_1
X_28395_ _05082_ _04949_ _04985_ _03197_ VPWR VGND sg13g2_mux2_1
X_28396_ _05083_ _03187_ _05082_ VPWR VGND sg13g2_nand2_1
X_28397_ _05084_ _03187_ _05066_ _05083_ VPWR VGND sg13g2_o21ai_1
X_28398_ _05085_ _03536_ _05084_ _05076_ VPWR VGND sg13g2_a21oi_1
X_28399_ _05086_ _05085_ VPWR VGND sg13g2_buf_1
X_28400_ _05087_ \memory_i.freq_inst.cordic.shift_value[2]\ _04962_ _05051_ VPWR VGND sg13g2_a21oi_1
X_28401_ _05088_ _04754_ _04965_ _05025_ _05023_ _03178_
+ _03197_
+ VPWR VGND sg13g2_mux4_1
X_28402_ _05089_ _05087_ _05088_ \memory_i.freq_inst.cordic.shift_value[3]\ VPWR VGND sg13g2_mux2_1
X_28403_ _05090_ _04933_ _05089_ _03536_ VPWR VGND sg13g2_mux2_1
X_28404_ _05091_ _05090_ VPWR VGND sg13g2_buf_1
X_28405_ _05092_ _05073_ _05081_ _05086_ _05091_ VPWR
+ VGND
+ sg13g2_and4_1
X_28406_ _05093_ _04960_ _05034_ _05072_ _05092_ VPWR
+ VGND
+ sg13g2_nand4_1
X_28407_ _05094_ _05093_ VPWR VGND sg13g2_buf_2
X_28408_ _05095_ _03576_ _04969_ VPWR VGND sg13g2_and2_1
X_28409_ _05096_ _05095_ VPWR VGND sg13g2_buf_1
X_28410_ _05097_ _05016_ _05017_ _03188_ VPWR VGND sg13g2_mux2_1
X_28411_ _05098_ _03576_ _05097_ VPWR VGND sg13g2_nand2_1
X_28412_ _05099_ _05098_ VPWR VGND sg13g2_inv_1
X_28413_ _05100_ _04951_ _05094_ _05096_ _05099_ VPWR
+ VGND
+ sg13g2_or4_1
X_28414_ _05101_ \memory_i.freq_inst.cordic.shift_value[2]\ _04953_ VPWR VGND sg13g2_nor2_1
X_28415_ _05102_ \memory_i.freq_inst.cordic.shift_value[2]\ _05000_ _05101_ VPWR VGND sg13g2_a21oi_1
X_28416_ _05103_ _03362_ _05102_ VPWR VGND sg13g2_nor2_1
X_28417_ _05104_ \memory_i.freq_inst.Y_o[29]\ _03347_ VPWR VGND sg13g2_nor2_1
X_28418_ _05105_ _05066_ _05103_ _05104_ VPWR VGND sg13g2_a21oi_1
X_28419_ _05106_ \memory_i.freq_inst.Y_o[29]\ _03362_ VPWR VGND sg13g2_nand2_1
X_28420_ _05107_ _03804_ _05088_ _05106_ VPWR VGND sg13g2_o21ai_1
X_28421_ _05108_ _05106_ VPWR VGND sg13g2_inv_1
X_28422_ _05109_ _03839_ _05044_ _05108_ VPWR VGND sg13g2_a21o_1
X_28423_ _05110_ _05100_ _05105_ _05107_ _05109_ VPWR
+ VGND
+ sg13g2_or4_1
X_28424_ _05111_ _05110_ VPWR VGND sg13g2_buf_1
X_28425_ _05112_ \memory_i.freq_inst.cordic.shift_value[4]\ \memory_i.freq_inst.Y_o[29]\ VPWR VGND sg13g2_nand2_1
X_28426_ _05113_ _04944_ VPWR VGND sg13g2_inv_1
X_28427_ _05114_ _05112_ _05113_ _03650_ VPWR VGND sg13g2_a21oi_1
X_28428_ _05115_ _04944_ _05111_ _05114_ VPWR VGND sg13g2_nor3_1
X_28429_ _05116_ _04939_ _05115_ VPWR VGND sg13g2_nor2b_1
X_28430_ _05117_ _03715_ _05036_ VPWR VGND sg13g2_nand2_1
X_28431_ _05118_ _05116_ _05117_ VPWR VGND sg13g2_nand2_1
X_28432_ _05119_ _03852_ _05118_ VPWR VGND sg13g2_nand2_1
X_28433_ _05120_ _03839_ _05016_ _05108_ VPWR VGND sg13g2_a21oi_1
X_28434_ _05121_ _05119_ _05120_ VPWR VGND sg13g2_xnor2_1
X_28435_ _05122_ _03947_ _05116_ VPWR VGND sg13g2_nor2_1
X_28436_ _05123_ _05036_ _05122_ VPWR VGND sg13g2_xnor2_1
X_28437_ _05124_ \memory_i.freq_inst.Y_o[29]\ \memory_i.freq_inst.Z_o[29]\ _03715_ VPWR VGND sg13g2_a21oi_1
X_28438_ _05125_ _04933_ _05122_ VPWR VGND sg13g2_nand2_1
X_28439_ _05126_ _03715_ _05123_ _05124_ _05125_ VPWR
+ VGND
+ sg13g2_a22oi_1
X_28440_ _05127_ _05126_ VPWR VGND sg13g2_buf_2
X_28441_ _05128_ _05034_ _05072_ VPWR VGND sg13g2_nand2_1
X_28442_ _05129_ _05128_ VPWR VGND sg13g2_buf_4
X_28443_ _05130_ _05092_ VPWR VGND sg13g2_inv_1
X_28444_ _05131_ _05129_ _05130_ _03617_ VPWR VGND sg13g2_o21ai_1
X_28445_ _05132_ _04960_ _05131_ VPWR VGND sg13g2_xnor2_1
X_28446_ _05133_ _05132_ VPWR VGND sg13g2_buf_1
X_28447_ _05134_ _05081_ _05086_ _05091_ VPWR VGND sg13g2_nand3_1
X_28448_ _05135_ _05129_ _05134_ _03617_ VPWR VGND sg13g2_o21ai_1
X_28449_ _05136_ _05073_ _05112_ VPWR VGND sg13g2_nand2_1
X_28450_ _05137_ _05135_ _05136_ VPWR VGND sg13g2_xor2_1
X_28451_ _05138_ _05133_ _05137_ VPWR VGND sg13g2_and2_1
X_28452_ _05139_ \memory_i.freq_inst.cordic.shift_value[4]\ _05089_ _05112_ VPWR VGND sg13g2_o21ai_1
X_28453_ _05140_ \memory_i.freq_inst.X_o[15]\ _03570_ VPWR VGND sg13g2_nand2_1
X_28454_ _05141_ _04309_ _04008_ _05140_ VPWR VGND sg13g2_o21ai_1
X_28455_ _05142_ _03576_ _05084_ _05076_ VPWR VGND sg13g2_a21o_1
X_28456_ _05143_ _05142_ VPWR VGND sg13g2_buf_1
X_28457_ _05144_ _05034_ _05072_ _05081_ VPWR VGND sg13g2_nand3_1
X_28458_ _05145_ _05144_ VPWR VGND sg13g2_buf_2
X_28459_ _05146_ _05143_ _05145_ VPWR VGND sg13g2_or2_1
X_28460_ _05147_ _05086_ _05145_ VPWR VGND sg13g2_xnor2_1
X_28461_ _05148_ \memory_i.freq_inst.cordic.roc_in_X[14]\ VPWR VGND sg13g2_inv_1
X_28462_ _05149_ \memory_i.freq_inst.X_o[14]\ _03570_ VPWR VGND sg13g2_nand2_1
X_28463_ _05150_ _05148_ _04008_ _05149_ VPWR VGND sg13g2_o21ai_1
X_28464_ _05151_ _05150_ VPWR VGND sg13g2_buf_1
X_28465_ _05152_ _05141_ _05146_ _05147_ _05151_ VPWR
+ VGND
+ sg13g2_a22oi_1
X_28466_ _05153_ _03718_ _05139_ _05152_ VPWR VGND sg13g2_nor3_1
X_28467_ _05154_ _05143_ _05091_ VPWR VGND sg13g2_nor2_1
X_28468_ _05155_ _05154_ VPWR VGND sg13g2_inv_1
X_28469_ _05156_ _05151_ _05143_ VPWR VGND sg13g2_nand2_1
X_28470_ _05157_ _05155_ _05156_ _05145_ VPWR VGND sg13g2_a21o_1
X_28471_ _05158_ _05091_ _05156_ VPWR VGND sg13g2_nand2_1
X_28472_ _05159_ _05151_ _05154_ _05158_ _03643_ VPWR
+ VGND
+ sg13g2_a22oi_1
X_28473_ _05160_ _05157_ _05159_ _04067_ VPWR VGND sg13g2_a21oi_1
X_28474_ _05161_ _03718_ _05151_ _05143_ _05139_ VPWR
+ VGND
+ sg13g2_nand4_1
X_28475_ _05162_ _05160_ _05161_ VPWR VGND sg13g2_nor2b_1
X_28476_ _05163_ _05153_ _05162_ VPWR VGND sg13g2_nor2b_1
X_28477_ _05164_ _04058_ _05137_ VPWR VGND sg13g2_or2_1
X_28478_ _05165_ _05164_ VPWR VGND sg13g2_buf_1
X_28479_ _05166_ _05163_ _05133_ _05165_ VPWR VGND sg13g2_and3_1
X_28480_ _05167_ _04073_ _05078_ VPWR VGND sg13g2_xnor2_1
X_28481_ _05168_ _05080_ VPWR VGND sg13g2_buf_1
X_28482_ _05169_ _05129_ _05168_ VPWR VGND sg13g2_or2_1
X_28483_ _05170_ _04075_ _05080_ VPWR VGND sg13g2_xnor2_1
X_28484_ _05171_ _03643_ _05170_ VPWR VGND sg13g2_nand2_1
X_28485_ _05172_ _04075_ _05169_ _05171_ VPWR VGND sg13g2_o21ai_1
X_28486_ _05173_ \memory_i.freq_inst.cordic.roc_in_X[12]\ VPWR VGND sg13g2_inv_1
X_28487_ _05174_ \memory_i.freq_inst.X_o[12]\ _03570_ VPWR VGND sg13g2_nand2_1
X_28488_ _05175_ _05173_ _04008_ _05174_ VPWR VGND sg13g2_o21ai_1
X_28489_ _05176_ _05129_ _05168_ VPWR VGND sg13g2_xnor2_1
X_28490_ _05177_ _05175_ _05129_ _05168_ VPWR VGND sg13g2_nand3_1
X_28491_ _05178_ _05175_ _05176_ _05177_ VPWR VGND sg13g2_o21ai_1
X_28492_ _05179_ _03643_ _05167_ VPWR VGND sg13g2_nor2_1
X_28493_ _05180_ _05167_ _05172_ _05178_ _05179_ VPWR
+ VGND
+ sg13g2_a22oi_1
X_28494_ _05181_ _03643_ _05039_ VPWR VGND sg13g2_nor2_1
X_28495_ _05182_ _05043_ VPWR VGND sg13g2_buf_1
X_28496_ _05183_ \memory_i.freq_inst.cordic.shift_value[4]\ _04969_ _04977_ VPWR VGND sg13g2_a21oi_1
X_28497_ _05184_ _04991_ _04998_ _05011_ VPWR VGND sg13g2_a21oi_2
X_28498_ _05185_ _03579_ _05026_ _05029_ VPWR VGND sg13g2_a21oi_2
X_28499_ _05186_ _05185_ _05021_ VPWR VGND sg13g2_nor2_2
X_28500_ _05187_ _05183_ _05184_ _05186_ VPWR VGND sg13g2_nand3_1
X_28501_ _05188_ _05187_ VPWR VGND sg13g2_buf_2
X_28502_ _05189_ _05188_ _05050_ _05071_ VPWR VGND sg13g2_or3_1
X_28503_ _05190_ _05189_ VPWR VGND sg13g2_buf_4
X_28504_ _05191_ _05182_ _05190_ VPWR VGND sg13g2_xnor2_1
X_28505_ _05192_ \memory_i.freq_inst.cordic.roc_in_X[11]\ VPWR VGND sg13g2_inv_1
X_28506_ _05193_ \memory_i.freq_inst.X_o[11]\ _03513_ VPWR VGND sg13g2_nand2_1
X_28507_ _05194_ _05192_ _04008_ _05193_ VPWR VGND sg13g2_o21ai_1
X_28508_ _05195_ _05182_ _05190_ _05194_ VPWR VGND sg13g2_o21ai_1
X_28509_ _05196_ _04079_ _05191_ _05195_ VPWR VGND sg13g2_o21ai_1
X_28510_ _05197_ _05194_ _05039_ VPWR VGND sg13g2_nand2_1
X_28511_ _05198_ _05182_ _05190_ VPWR VGND sg13g2_and2_1
X_28512_ _05199_ _05194_ _05039_ VPWR VGND sg13g2_or2_1
X_28513_ _05200_ _03601_ _05182_ _05199_ VPWR VGND sg13g2_nand3_1
X_28514_ _05201_ _05197_ _05198_ _05200_ VPWR VGND sg13g2_o21ai_1
X_28515_ _05202_ \memory_i.freq_inst.cordic.roc_in_X[10]\ VPWR VGND sg13g2_inv_1
X_28516_ _05203_ \memory_i.freq_inst.X_o[10]\ _03570_ VPWR VGND sg13g2_nand2_1
X_28517_ _05204_ _05202_ _04008_ _05203_ VPWR VGND sg13g2_o21ai_1
X_28518_ _05205_ _05182_ _05190_ VPWR VGND sg13g2_or2_1
X_28519_ _05206_ _03617_ _05205_ _05197_ VPWR VGND sg13g2_a21oi_1
X_28520_ _05207_ _05181_ _05196_ _05201_ _05204_ _05206_
+ VPWR
+ VGND sg13g2_a221oi_1
X_28521_ _05208_ _03643_ _05078_ VPWR VGND sg13g2_nor2_1
X_28522_ _05209_ \memory_i.freq_inst.X_o[13]\ _03513_ VPWR VGND sg13g2_nand2_1
X_28523_ _05210_ _04377_ _04008_ _05209_ VPWR VGND sg13g2_o21ai_1
X_28524_ _05211_ _05129_ _05168_ _05210_ VPWR VGND sg13g2_o21ai_1
X_28525_ _05212_ _04075_ _05176_ _05211_ VPWR VGND sg13g2_o21ai_1
X_28526_ _05213_ _05210_ _05078_ _05168_ VPWR VGND sg13g2_o21ai_1
X_28527_ _05214_ _03617_ _05213_ VPWR VGND sg13g2_nor2_1
X_28528_ _05215_ _05210_ _05078_ VPWR VGND sg13g2_nand2_1
X_28529_ _05216_ _05129_ _05168_ _05215_ VPWR VGND sg13g2_a21oi_1
X_28530_ _05217_ _05214_ _05216_ VPWR VGND sg13g2_or2_1
X_28531_ _05218_ _03617_ _05169_ _05215_ VPWR VGND sg13g2_a21oi_1
X_28532_ _05219_ _05208_ _05212_ _05217_ _05175_ _05218_
+ VPWR
+ VGND sg13g2_a221oi_1
X_28533_ _05220_ _05180_ _05207_ _05219_ VPWR VGND sg13g2_o21ai_1
X_28534_ _05221_ _04979_ _05013_ _05032_ _05071_ VPWR
+ VGND
+ sg13g2_nor4_2
X_28535_ _05222_ _05221_ VPWR VGND sg13g2_buf_8
X_28536_ _05223_ \memory_i.freq_inst.cordic.shift_value[4]\ _05048_ VPWR VGND sg13g2_nor2_1
X_28537_ _05224_ _05046_ _05223_ VPWR VGND sg13g2_nor2_1
X_28538_ _05225_ _05224_ VPWR VGND sg13g2_buf_1
X_28539_ _05226_ _05222_ _05225_ VPWR VGND sg13g2_nand2b_1
X_28540_ _05227_ _05225_ VPWR VGND sg13g2_inv_1
X_28541_ _05228_ _05227_ _05222_ VPWR VGND sg13g2_xnor2_1
X_28542_ _05229_ _05226_ _05228_ _04084_ VPWR VGND sg13g2_mux2_1
X_28543_ _05230_ \memory_i.freq_inst.cordic.shift_value[4]\ _05047_ VPWR VGND sg13g2_nor2_1
X_28544_ _05231_ \memory_i.freq_inst.cordic.shift_value[4]\ _04943_ _05230_ VPWR VGND sg13g2_a21oi_1
X_28545_ _05232_ _04082_ _05231_ VPWR VGND sg13g2_xnor2_1
X_28546_ _05233_ _05232_ _03591_ VPWR VGND sg13g2_nand2b_1
X_28547_ _05234_ \memory_i.freq_inst.cordic.roc_in_X[8]\ VPWR VGND sg13g2_inv_1
X_28548_ _05235_ \memory_i.freq_inst.X_o[8]\ _03513_ VPWR VGND sg13g2_nand2_1
X_28549_ _05236_ _05234_ _04008_ _05235_ VPWR VGND sg13g2_o21ai_1
X_28550_ _05237_ _05236_ VPWR VGND sg13g2_buf_1
X_28551_ _05238_ _05237_ _05225_ VPWR VGND sg13g2_xnor2_1
X_28552_ _05239_ _03591_ _05238_ VPWR VGND sg13g2_nor2_1
X_28553_ _05240_ _05237_ _05227_ _05222_ VPWR VGND sg13g2_and3_1
X_28554_ _05241_ _05239_ _05240_ _05232_ VPWR VGND sg13g2_o21ai_1
X_28555_ _05242_ _05229_ _05233_ _05241_ VPWR VGND sg13g2_o21ai_1
X_28556_ _05243_ _03497_ _04098_ VPWR VGND sg13g2_nor2_1
X_28557_ _05244_ _05186_ _05243_ VPWR VGND sg13g2_and2_1
X_28558_ _05245_ _05021_ VPWR VGND sg13g2_buf_2
X_28559_ _05246_ _04096_ _05031_ _05245_ VPWR VGND sg13g2_nor3_1
X_28560_ _05247_ _04979_ _05013_ VPWR VGND sg13g2_nor2_1
X_28561_ _05248_ _05247_ VPWR VGND sg13g2_buf_4
X_28562_ _05249_ _05244_ _05246_ _05248_ VPWR VGND sg13g2_mux2_1
X_28563_ _05250_ _04098_ VPWR VGND sg13g2_buf_1
X_28564_ _05251_ _03520_ _04096_ _05250_ _05021_ VPWR
+ VGND
+ sg13g2_nor4_1
X_28565_ _05252_ _05031_ _05021_ _05243_ VPWR VGND sg13g2_and3_1
X_28566_ _05253_ _05251_ _05252_ _05248_ VPWR VGND sg13g2_mux2_1
X_28567_ _05254_ _04096_ _05250_ _05031_ VPWR VGND sg13g2_nor3_1
X_28568_ _05255_ _05183_ _05184_ _05254_ VPWR VGND sg13g2_nand3_1
X_28569_ _05256_ _03497_ _04096_ VPWR VGND sg13g2_nor2_1
X_28570_ _05257_ _05031_ _05256_ VPWR VGND sg13g2_and2_1
X_28571_ _05258_ _04979_ _05013_ _05257_ VPWR VGND sg13g2_o21ai_1
X_28572_ _05259_ _03532_ _05250_ VPWR VGND sg13g2_nor2_1
X_28573_ _05260_ _05185_ _05021_ _05259_ VPWR VGND sg13g2_nand3_1
X_28574_ _05261_ _05031_ _05021_ _05256_ VPWR VGND sg13g2_nand3_1
X_28575_ _05262_ _05260_ _05261_ VPWR VGND sg13g2_and2_1
X_28576_ _05263_ _03532_ _04096_ _05250_ VPWR VGND sg13g2_nor3_1
X_28577_ _05264_ _03532_ _04096_ VPWR VGND sg13g2_nor2_1
X_28578_ _05265_ _05245_ _05263_ _05264_ _05185_ VPWR
+ VGND
+ sg13g2_a22oi_1
X_28579_ _05266_ _05255_ _05258_ _05262_ _05265_ VPWR
+ VGND
+ sg13g2_nand4_1
X_28580_ _05267_ _05249_ _05253_ _05266_ VPWR VGND sg13g2_nor3_1
X_28581_ _05268_ _03505_ _04991_ VPWR VGND sg13g2_and2_1
X_28582_ _05269_ _03532_ _05011_ _05268_ _04998_ VPWR
+ VGND
+ sg13g2_a22oi_1
X_28583_ _05270_ _04979_ _05269_ VPWR VGND sg13g2_xnor2_1
X_28584_ _05271_ _05270_ _04100_ VPWR VGND sg13g2_nand2b_1
X_28585_ _05272_ _04996_ _04984_ _03522_ VPWR VGND sg13g2_mux2_1
X_28586_ _05273_ _05272_ VPWR VGND sg13g2_buf_2
X_28587_ _05274_ _05011_ _05273_ _03505_ VPWR VGND sg13g2_o21ai_1
X_28588_ _05275_ _03522_ _04989_ VPWR VGND sg13g2_and2_1
X_28589_ _05276_ \memory_i.freq_inst.cordic.shift_value[4]\ _04951_ _05275_ VPWR VGND sg13g2_a21oi_1
X_28590_ _05277_ _05274_ _05276_ VPWR VGND sg13g2_xnor2_1
X_28591_ _05278_ _03505_ _05273_ VPWR VGND sg13g2_and2_1
X_28592_ _05279_ _04116_ _04126_ _05011_ VPWR VGND sg13g2_a21oi_1
X_28593_ _05280_ _04126_ _05273_ VPWR VGND sg13g2_nor2b_1
X_28594_ _05281_ _04955_ _03196_ VPWR VGND sg13g2_nand2b_1
X_28595_ _05282_ _03197_ _04953_ _05281_ VPWR VGND sg13g2_o21ai_1
X_28596_ _05283_ _04933_ _05000_ _03196_ VPWR VGND sg13g2_mux2_1
X_28597_ _05284_ _05005_ VPWR VGND sg13g2_inv_1
X_28598_ _05285_ _05007_ \memory_i.freq_inst.cordic.shift_value[2]\ VPWR VGND sg13g2_nand2b_1
X_28599_ _05286_ \memory_i.freq_inst.cordic.shift_value[2]\ _05008_ _05285_ VPWR VGND sg13g2_o21ai_1
X_28600_ _05287_ _05282_ _05283_ _05284_ _05286_ \memory_i.freq_inst.cordic.shift_value[3]\
+ _03522_
+ VPWR VGND sg13g2_mux4_1
X_28601_ _05288_ _03505_ _05287_ _04116_ VPWR VGND sg13g2_o21ai_1
X_28602_ _05289_ \memory_i.freq_inst.cordic.roc_in_X[1]\ _04065_ VPWR VGND sg13g2_nand2_1
X_28603_ _05290_ \memory_i.freq_inst.X_o[1]\ _03353_ VPWR VGND sg13g2_nand2_1
X_28604_ _05291_ _05289_ _05290_ _05273_ _03505_ _05287_
+ VPWR
+ VGND sg13g2_a221oi_1
X_28605_ _05292_ _05278_ _05279_ _05280_ _05288_ _05291_
+ VPWR
+ VGND sg13g2_a221oi_1
X_28606_ _05293_ _05292_ VPWR VGND sg13g2_buf_1
X_28607_ _05294_ _05277_ _05293_ VPWR VGND sg13g2_nand2_1
X_28608_ _05295_ _05277_ _05293_ _04108_ VPWR VGND sg13g2_o21ai_1
X_28609_ _05296_ _05271_ _05294_ _05295_ VPWR VGND sg13g2_nand3_1
X_28610_ _05297_ _04100_ _05270_ VPWR VGND sg13g2_nand2b_1
X_28611_ _05298_ _05267_ _05296_ _05297_ VPWR VGND sg13g2_nand3_1
X_28612_ _05299_ _04088_ _05070_ VPWR VGND sg13g2_nor2_1
X_28613_ _05300_ \memory_i.freq_inst.X_o[6]\ _03513_ VPWR VGND sg13g2_nand2_1
X_28614_ _05301_ _04488_ _04008_ _05300_ VPWR VGND sg13g2_o21ai_1
X_28615_ _05302_ _05301_ VPWR VGND sg13g2_buf_1
X_28616_ _05303_ \memory_i.freq_inst.cordic.shift_value[2]\ _04948_ VPWR VGND sg13g2_nor2_1
X_28617_ _05304_ \memory_i.freq_inst.cordic.shift_value[2]\ _04935_ _05303_ VPWR VGND sg13g2_a21oi_1
X_28618_ _05305_ \memory_i.freq_inst.cordic.shift_value[2]\ _04986_ _05067_ VPWR VGND sg13g2_a21o_1
X_28619_ _05306_ \memory_i.freq_inst.Y_o[29]\ _05082_ _05304_ _05305_ _03536_
+ _03188_
+ VPWR VGND sg13g2_mux4_1
X_28620_ _05307_ _05306_ VPWR VGND sg13g2_buf_1
X_28621_ _05308_ _05302_ _05307_ VPWR VGND sg13g2_nor2_1
X_28622_ _05309_ _04086_ _05059_ VPWR VGND sg13g2_xor2_1
X_28623_ _05310_ _03533_ _05309_ VPWR VGND sg13g2_nand2_1
X_28624_ _05311_ _05034_ _05310_ VPWR VGND sg13g2_nor2_1
X_28625_ _05312_ _05299_ _05308_ _05311_ VPWR VGND sg13g2_o21ai_1
X_28626_ _05313_ _04088_ _05307_ _05309_ VPWR VGND sg13g2_nor3_1
X_28627_ _05314_ _05188_ _05310_ VPWR VGND sg13g2_nor2_1
X_28628_ _05315_ _05302_ _05070_ VPWR VGND sg13g2_nor2_1
X_28629_ _05316_ _04088_ _05070_ VPWR VGND sg13g2_xnor2_1
X_28630_ _05317_ _03591_ _05309_ _05316_ VPWR VGND sg13g2_nor3_1
X_28631_ _05318_ _05034_ _05313_ _05314_ _05315_ _05317_
+ VPWR
+ VGND sg13g2_a221oi_1
X_28632_ _05319_ _04096_ _05185_ VPWR VGND sg13g2_xnor2_1
X_28633_ _05320_ _05250_ _05021_ VPWR VGND sg13g2_xnor2_1
X_28634_ _05321_ _05250_ _04979_ _05013_ _05245_ VPWR
+ VGND
+ sg13g2_nor4_1
X_28635_ _05322_ _03547_ _05320_ _05321_ VPWR VGND sg13g2_a21o_1
X_28636_ _05323_ _03533_ _05250_ _05245_ VPWR VGND sg13g2_nand3_1
X_28637_ _05324_ _05319_ _05323_ VPWR VGND sg13g2_nor2_1
X_28638_ _05325_ _05245_ _05250_ _03533_ VPWR VGND sg13g2_nand3b_1
X_28639_ _05326_ _05245_ _05243_ VPWR VGND sg13g2_nand2_1
X_28640_ _05327_ _05183_ _05184_ _05325_ _05326_ _05319_
+ VPWR
+ VGND sg13g2_a221oi_1
X_28641_ _05328_ _05319_ _05322_ _05324_ _05248_ _05327_
+ VPWR
+ VGND sg13g2_a221oi_1
X_28642_ _05329_ _05312_ _05318_ _05267_ _05328_ VPWR
+ VGND
+ sg13g2_a22oi_1
X_28643_ _05330_ _05242_ _05298_ _05329_ VPWR VGND sg13g2_nand3_1
X_28644_ _05331_ _05231_ VPWR VGND sg13g2_inv_1
X_28645_ _05332_ _03591_ _05331_ VPWR VGND sg13g2_nand2_1
X_28646_ _05333_ _03601_ _05231_ _05225_ VPWR VGND sg13g2_nand3_1
X_28647_ _05334_ _05332_ _05228_ _05333_ VPWR VGND sg13g2_o21ai_1
X_28648_ _05335_ _05186_ _05059_ _05070_ VPWR VGND sg13g2_and3_2
X_28649_ _05336_ _05302_ _05186_ _05059_ VPWR VGND sg13g2_and3_2
X_28650_ _05337_ _05335_ _05336_ _05248_ VPWR VGND sg13g2_o21ai_1
X_28651_ _05338_ _05059_ _05299_ _03547_ VPWR VGND sg13g2_o21ai_1
X_28652_ _05339_ _05302_ _05059_ _05070_ VPWR VGND sg13g2_nand3_1
X_28653_ _05340_ _05338_ _05339_ VPWR VGND sg13g2_and2_1
X_28654_ _05341_ _05337_ _05340_ _04086_ VPWR VGND sg13g2_a21oi_1
X_28655_ _05342_ _04086_ _05188_ _05307_ VPWR VGND sg13g2_nand3_1
X_28656_ _05343_ _05059_ _03533_ VPWR VGND sg13g2_nand2b_1
X_28657_ _05344_ _04086_ _04088_ _05034_ _05070_ _05343_
+ VPWR
+ VGND sg13g2_a221oi_1
X_28658_ _05345_ _03547_ _05059_ VPWR VGND sg13g2_and2_1
X_28659_ _05346_ _05342_ _05344_ _05345_ _05299_ VPWR
+ VGND
+ sg13g2_a22oi_1
X_28660_ _05347_ _05341_ _05346_ VPWR VGND sg13g2_nand2b_1
X_28661_ _05348_ _05227_ _05222_ VPWR VGND sg13g2_and2_1
X_28662_ _05349_ _05237_ _05348_ _05226_ VPWR VGND sg13g2_o21ai_1
X_28663_ _05350_ _03601_ _05331_ VPWR VGND sg13g2_nor2_1
X_28664_ _05351_ _04084_ _05227_ _03601_ VPWR VGND sg13g2_o21ai_1
X_28665_ _05352_ _05348_ _05351_ VPWR VGND sg13g2_nand2b_1
X_28666_ _05353_ _05349_ _05350_ _05352_ _05331_ _04082_
+ VPWR
+ VGND sg13g2_a221oi_1
X_28667_ _05354_ _05237_ _05334_ _05242_ _05347_ _05353_
+ VPWR
+ VGND sg13g2_a221oi_1
X_28668_ _05355_ _05197_ _05199_ VPWR VGND sg13g2_nand2_1
X_28669_ _05356_ _04079_ _05043_ VPWR VGND sg13g2_xnor2_1
X_28670_ _05357_ _03643_ _05356_ VPWR VGND sg13g2_nand2_1
X_28671_ _05358_ _04079_ _05205_ _05357_ VPWR VGND sg13g2_o21ai_1
X_28672_ _05359_ _05355_ _05358_ VPWR VGND sg13g2_nand2b_1
X_28673_ _05360_ _05182_ _05190_ VPWR VGND sg13g2_nand2_1
X_28674_ _05361_ _05191_ _05360_ _05204_ VPWR VGND sg13g2_mux2_1
X_28675_ _05362_ _05361_ _03617_ _05355_ VPWR VGND sg13g2_nand3b_1
X_28676_ _05363_ _05330_ _05354_ _05359_ _05362_ _05180_
+ VPWR
+ VGND sg13g2_a221oi_1
X_28677_ _05364_ _05363_ VPWR VGND sg13g2_buf_4
X_28678_ _05365_ _05220_ _05364_ VPWR VGND sg13g2_nor2_2
X_28679_ _05366_ _05365_ VPWR VGND sg13g2_buf_4
X_28680_ _05367_ _04067_ _05139_ VPWR VGND sg13g2_xnor2_1
X_28681_ _05368_ _05151_ _05086_ VPWR VGND sg13g2_xnor2_1
X_28682_ _05369_ _03718_ _05368_ VPWR VGND sg13g2_nand2_1
X_28683_ _05370_ _04069_ _05146_ _05369_ VPWR VGND sg13g2_o21ai_1
X_28684_ _05371_ _05151_ _05143_ _05145_ VPWR VGND sg13g2_and3_1
X_28685_ _05372_ _04069_ _05147_ _05371_ VPWR VGND sg13g2_a21o_1
X_28686_ _05373_ _03718_ _05367_ VPWR VGND sg13g2_nor2_1
X_28687_ _05374_ _05367_ _05370_ _05372_ _05373_ VPWR
+ VGND
+ sg13g2_a22oi_1
X_28688_ _05375_ _05374_ VPWR VGND sg13g2_buf_1
X_28689_ _05376_ _05138_ _05375_ VPWR VGND sg13g2_nand2_1
X_28690_ _05377_ _04058_ _05133_ _05375_ VPWR VGND sg13g2_nand3_1
X_28691_ _05378_ _05153_ _05162_ VPWR VGND sg13g2_nand2b_1
X_28692_ _05379_ _05376_ _05377_ _05378_ VPWR VGND sg13g2_a21oi_1
X_28693_ _05380_ _04058_ _05138_ _05166_ _05366_ _05379_
+ VPWR
+ VGND sg13g2_a221oi_1
X_28694_ _05381_ _05380_ VPWR VGND sg13g2_buf_1
X_28695_ _05382_ \memory_i.freq_inst.cordic.shift_value[4]\ _04951_ VPWR VGND sg13g2_nor2_1
X_28696_ _05383_ \memory_i.freq_inst.cordic.shift_value[4]\ _04933_ _05382_ VPWR VGND sg13g2_a21oi_1
X_28697_ _05384_ _03714_ _05094_ VPWR VGND sg13g2_nand2_1
X_28698_ _05385_ _05383_ _05384_ VPWR VGND sg13g2_xor2_1
X_28699_ _05386_ _04039_ _05385_ _04046_ VPWR VGND sg13g2_a21oi_1
X_28700_ _05387_ _04039_ _05385_ _05133_ VPWR VGND sg13g2_a21oi_1
X_28701_ _05388_ _04058_ _05137_ _05163_ VPWR VGND sg13g2_a21o_1
X_28702_ _05389_ _05137_ _05375_ VPWR VGND sg13g2_nor2_1
X_28703_ _05390_ _05220_ _05364_ _05389_ VPWR VGND sg13g2_o21ai_1
X_28704_ _05391_ _04058_ _05375_ VPWR VGND sg13g2_nor2_1
X_28705_ _05392_ _05220_ _05364_ _05391_ VPWR VGND sg13g2_o21ai_1
X_28706_ _05393_ _05165_ _05388_ _05390_ _05392_ VPWR
+ VGND
+ sg13g2_nand4_1
X_28707_ _05394_ _04039_ _05385_ VPWR VGND sg13g2_nor2_1
X_28708_ _05395_ _05381_ _05386_ _05387_ _05393_ _05394_
+ VPWR
+ VGND sg13g2_a221oi_1
X_28709_ _05396_ _05395_ VPWR VGND sg13g2_buf_2
X_28710_ _05397_ _03839_ _05304_ VPWR VGND sg13g2_nand2_1
X_28711_ _05398_ _05106_ _05397_ VPWR VGND sg13g2_nand2_1
X_28712_ _05399_ _04951_ _05094_ _05096_ _05099_ VPWR
+ VGND
+ sg13g2_nor4_2
X_28713_ _05400_ _05102_ _05066_ VPWR VGND sg13g2_nor2_1
X_28714_ _05401_ _05026_ _05304_ VPWR VGND sg13g2_nor2_1
X_28715_ _05402_ _05399_ _05400_ _05401_ _03714_ VPWR
+ VGND
+ sg13g2_a22oi_1
X_28716_ _05403_ _03714_ _05100_ _05397_ VPWR VGND sg13g2_nand3_1
X_28717_ _05404_ _03804_ _05402_ _05403_ VPWR VGND sg13g2_o21ai_1
X_28718_ _05405_ _03719_ _05398_ _05404_ _05106_ VPWR
+ VGND
+ sg13g2_a22oi_1
X_28719_ _05406_ _05405_ VPWR VGND sg13g2_buf_1
X_28720_ _05407_ _03979_ _05406_ VPWR VGND sg13g2_xnor2_1
X_28721_ _05408_ _05105_ _05399_ VPWR VGND sg13g2_nand2b_1
X_28722_ _05409_ _03714_ _05408_ VPWR VGND sg13g2_nand2_1
X_28723_ _05410_ _05107_ _05409_ VPWR VGND sg13g2_xor2_1
X_28724_ _05411_ _04006_ _05410_ VPWR VGND sg13g2_xnor2_1
X_28725_ _05412_ _04951_ _05094_ VPWR VGND sg13g2_nor2_1
X_28726_ _05413_ _03715_ _04969_ VPWR VGND sg13g2_nand2_1
X_28727_ _05414_ _05112_ _05413_ VPWR VGND sg13g2_nand2_1
X_28728_ _05415_ _03719_ _05076_ _05096_ _05412_ VPWR
+ VGND
+ sg13g2_nor4_1
X_28729_ _05416_ _05096_ _05412_ _05414_ _03719_ _05415_
+ VPWR
+ VGND sg13g2_a221oi_1
X_28730_ _05417_ _05416_ VPWR VGND sg13g2_buf_1
X_28731_ _05418_ _04029_ _05417_ VPWR VGND sg13g2_nand2_1
X_28732_ _05419_ _05413_ _05412_ _03718_ VPWR VGND sg13g2_a21oi_1
X_28733_ _05420_ _05076_ _05099_ VPWR VGND sg13g2_nor2_1
X_28734_ _05421_ _05419_ _05420_ VPWR VGND sg13g2_xnor2_1
X_28735_ _05422_ _04027_ _05421_ VPWR VGND sg13g2_xnor2_1
X_28736_ _05423_ _05104_ _05103_ VPWR VGND sg13g2_nor2_1
X_28737_ _05424_ _03718_ _05399_ _05423_ VPWR VGND sg13g2_o21ai_1
X_28738_ _05425_ _03718_ _05399_ _05423_ VPWR VGND sg13g2_or3_1
X_28739_ _05426_ _05425_ VPWR VGND sg13g2_buf_2
X_28740_ _05427_ _05424_ _05426_ VPWR VGND sg13g2_nand2_1
X_28741_ _05428_ _03981_ _05427_ VPWR VGND sg13g2_xnor2_1
X_28742_ _05429_ _05411_ _05418_ _05422_ _05428_ VPWR
+ VGND
+ sg13g2_nand4_1
X_28743_ _05430_ _05407_ _05429_ VPWR VGND sg13g2_nor2_1
X_28744_ _05431_ _05396_ _05430_ VPWR VGND sg13g2_nand2b_1
X_28745_ _05432_ _04029_ _05417_ VPWR VGND sg13g2_nor2_1
X_28746_ _05433_ _04016_ _05421_ _05427_ VPWR VGND sg13g2_a21o_1
X_28747_ _05434_ _04016_ _05421_ _05427_ VPWR VGND sg13g2_and3_1
X_28748_ _05435_ _04013_ _05433_ _05434_ VPWR VGND sg13g2_a21oi_1
X_28749_ _05436_ _05406_ _05435_ _03979_ VPWR VGND sg13g2_a21o_1
X_28750_ _05437_ _05406_ _05435_ _05436_ VPWR VGND sg13g2_o21ai_1
X_28751_ _05438_ _03977_ _05410_ VPWR VGND sg13g2_nand2_1
X_28752_ _05439_ _03977_ _05410_ VPWR VGND sg13g2_nor2_1
X_28753_ _05440_ _05430_ _05432_ _05437_ _05438_ _05439_
+ VPWR
+ VGND sg13g2_a221oi_1
X_28754_ _05441_ _05431_ _05440_ VPWR VGND sg13g2_nand2_2
X_28755_ _05442_ _03947_ _05115_ VPWR VGND sg13g2_nor2_1
X_28756_ _05443_ _04939_ _05442_ VPWR VGND sg13g2_xnor2_1
X_28757_ _05444_ _05443_ VPWR VGND sg13g2_buf_1
X_28758_ _05445_ _03960_ _05444_ VPWR VGND sg13g2_nand2_1
X_28759_ _05446_ _05127_ _05445_ _03991_ VPWR VGND sg13g2_a21oi_1
X_28760_ _05447_ _05408_ _05107_ _03714_ VPWR VGND sg13g2_o21ai_1
X_28761_ _05448_ _05109_ _05447_ VPWR VGND sg13g2_xor2_1
X_28762_ _05449_ _03974_ _05448_ VPWR VGND sg13g2_nor2_1
X_28763_ _05450_ _03974_ _05448_ VPWR VGND sg13g2_nand2_1
X_28764_ _05451_ _05449_ _05450_ VPWR VGND sg13g2_nand2b_1
X_28765_ _05452_ _03719_ _05076_ _04944_ VPWR VGND sg13g2_nor3_1
X_28766_ _05453_ _05114_ _05452_ VPWR VGND sg13g2_nor2_1
X_28767_ _05454_ _05111_ _05453_ _05115_ VPWR VGND sg13g2_a21oi_1
X_28768_ _05455_ _03997_ _05454_ VPWR VGND sg13g2_xnor2_1
X_28769_ _05456_ _05451_ _05455_ VPWR VGND sg13g2_nor2_1
X_28770_ _05457_ _05127_ _05445_ _05456_ VPWR VGND sg13g2_o21ai_1
X_28771_ _05458_ _05446_ _05457_ VPWR VGND sg13g2_nor2_1
X_28772_ _05459_ _05449_ _05454_ _03997_ VPWR VGND sg13g2_o21ai_1
X_28773_ _05460_ _05449_ _05454_ VPWR VGND sg13g2_nand2_1
X_28774_ _05461_ _05444_ _05459_ _05460_ VPWR VGND sg13g2_nand3_1
X_28775_ _05462_ _05459_ _05460_ _05444_ VPWR VGND sg13g2_a21oi_1
X_28776_ _05463_ _03994_ _05461_ _05462_ VPWR VGND sg13g2_a21oi_1
X_28777_ _05464_ _03991_ _05127_ VPWR VGND sg13g2_nor2_1
X_28778_ _05465_ _05463_ _05464_ VPWR VGND sg13g2_nor2_1
X_28779_ _05466_ _03991_ _05127_ _05441_ _05458_ _05465_
+ VPWR
+ VGND sg13g2_a221oi_1
X_28780_ _05467_ _05121_ _05466_ VPWR VGND sg13g2_nor2_1
X_28781_ _05468_ _05121_ _05466_ VPWR VGND sg13g2_nand2_1
X_28782_ _05469_ _04932_ _05467_ _05468_ VPWR VGND sg13g2_o21ai_1
X_28783_ _05470_ _05469_ VPWR VGND sg13g2_buf_2
X_28784_ _05471_ _03947_ _04937_ VPWR VGND sg13g2_nor2_1
X_28785_ _05472_ _04754_ _05016_ _05118_ VPWR VGND sg13g2_nor3_1
X_28786_ _05473_ _05016_ _05471_ _05472_ VPWR VGND sg13g2_a21o_1
X_28787_ _05474_ _03852_ _04754_ VPWR VGND sg13g2_nor2_1
X_28788_ _05475_ _05118_ _05471_ _05473_ _03839_ _05474_
+ VPWR
+ VGND sg13g2_a221oi_1
X_28789_ _05476_ _05475_ VPWR VGND sg13g2_buf_2
X_28790_ _05477_ _03957_ _05476_ VPWR VGND sg13g2_nor2_1
X_28791_ _05478_ _05470_ _05477_ VPWR VGND sg13g2_nand2_2
X_28792_ _05479_ _05478_ VPWR VGND sg13g2_buf_4
X_28793_ _05480_ \memory_i.freq_inst.cordic.rstn_i\ _05479_ VPWR VGND sg13g2_nand2_1
X_28794_ _05481_ _05480_ VPWR VGND sg13g2_buf_4
X_28795_ _05482_ _05481_ VPWR VGND sg13g2_buf_8
X_28796_ _05483_ _04126_ _05273_ VPWR VGND sg13g2_xor2_1
X_28797_ _05484_ _05470_ _05476_ _03957_ VPWR VGND sg13g2_nand3b_1
X_28798_ _05485_ _05484_ VPWR VGND sg13g2_buf_2
X_28799_ _05486_ _12943_ _05485_ VPWR VGND sg13g2_or2_2
X_28800_ _05487_ _05486_ VPWR VGND sg13g2_buf_8
X_28801_ _05488_ _05487_ VPWR VGND sg13g2_buf_16
X_28802_ _01537_ _05482_ _05483_ _05488_ VPWR VGND sg13g2_o21ai_1
X_28803_ _05489_ _04916_ _04126_ VPWR VGND sg13g2_xnor2_1
X_28804_ _05490_ _05273_ _05489_ VPWR VGND sg13g2_nand2_1
X_28805_ _05491_ _04116_ _05287_ VPWR VGND sg13g2_xnor2_1
X_28806_ _05492_ _05490_ _05491_ VPWR VGND sg13g2_xnor2_1
X_28807_ _01538_ _05482_ _05492_ _05488_ VPWR VGND sg13g2_o21ai_1
X_28808_ _05493_ _04108_ _05293_ VPWR VGND sg13g2_xnor2_1
X_28809_ _05494_ _05277_ _05493_ VPWR VGND sg13g2_xnor2_1
X_28810_ _05495_ _05481_ VPWR VGND sg13g2_buf_8
X_28811_ _01539_ _05487_ _05494_ _05495_ VPWR VGND sg13g2_a21oi_1
X_28812_ _05496_ _05294_ _05295_ VPWR VGND sg13g2_nand2_1
X_28813_ _05497_ _05271_ _05297_ VPWR VGND sg13g2_and2_1
X_28814_ _05498_ _05496_ _05497_ VPWR VGND sg13g2_xor2_1
X_28815_ _01540_ _05487_ _05498_ _05495_ VPWR VGND sg13g2_a21oi_1
X_28816_ _05499_ _05485_ VPWR VGND sg13g2_buf_4
X_28817_ _05500_ _05296_ _05297_ VPWR VGND sg13g2_nand2_1
X_28818_ _05501_ _03947_ _05248_ VPWR VGND sg13g2_nor2_1
X_28819_ _05502_ _05501_ _05320_ VPWR VGND sg13g2_xnor2_1
X_28820_ _05503_ _05500_ _05502_ VPWR VGND sg13g2_xnor2_1
X_28821_ _05504_ _05479_ _05503_ VPWR VGND sg13g2_nand2_1
X_28822_ _01541_ _05499_ _05504_ _03436_ VPWR VGND sg13g2_a21oi_1
X_28823_ _05505_ _05500_ VPWR VGND sg13g2_inv_1
X_28824_ _05506_ _05245_ _05505_ VPWR VGND sg13g2_nand2_1
X_28825_ _05507_ _05245_ _05505_ VPWR VGND sg13g2_nor2_1
X_28826_ _05508_ _05248_ _05507_ _05506_ VPWR VGND sg13g2_o21ai_1
X_28827_ _05509_ _05250_ _05508_ VPWR VGND sg13g2_nand2_1
X_28828_ _05510_ _05248_ _05506_ _05509_ VPWR VGND sg13g2_o21ai_1
X_28829_ _05511_ _05245_ _05500_ VPWR VGND sg13g2_nor2_1
X_28830_ _05512_ _05250_ _05511_ VPWR VGND sg13g2_nor2_1
X_28831_ _05513_ _05245_ _05500_ _05512_ VPWR VGND sg13g2_a21oi_1
X_28832_ _05514_ _04916_ _05513_ VPWR VGND sg13g2_nor2_1
X_28833_ _05515_ _04916_ _05510_ _05514_ VPWR VGND sg13g2_a21oi_1
X_28834_ _05516_ _05319_ _05515_ VPWR VGND sg13g2_xor2_1
X_28835_ _01542_ _05482_ _05516_ _05488_ VPWR VGND sg13g2_o21ai_1
X_28836_ _05517_ _05328_ _05505_ VPWR VGND sg13g2_nor2_1
X_28837_ _05518_ _05517_ _05267_ VPWR VGND sg13g2_nor2b_1
X_28838_ _05519_ _05518_ VPWR VGND sg13g2_buf_1
X_28839_ _05520_ _03947_ _05034_ VPWR VGND sg13g2_nor2_1
X_28840_ _05521_ _05316_ _05520_ VPWR VGND sg13g2_xnor2_1
X_28841_ _05522_ _05519_ _05521_ VPWR VGND sg13g2_xnor2_1
X_28842_ _05523_ _05479_ _05522_ VPWR VGND sg13g2_nand2_1
X_28843_ _01543_ _05499_ _05523_ _03436_ VPWR VGND sg13g2_a21oi_1
X_28844_ _05524_ _05034_ _05070_ VPWR VGND sg13g2_nor2_1
X_28845_ _05525_ _05307_ _05519_ _05188_ VPWR VGND sg13g2_o21ai_1
X_28846_ _05526_ _05307_ _05519_ VPWR VGND sg13g2_nand2_1
X_28847_ _05527_ _05525_ _05526_ VPWR VGND sg13g2_nand2_1
X_28848_ _05528_ _05524_ _05519_ _05527_ _04088_ VPWR
+ VGND
+ sg13g2_a22oi_1
X_28849_ _05529_ _05070_ _05519_ _04088_ VPWR VGND sg13g2_a21oi_1
X_28850_ _05530_ _05070_ _05519_ VPWR VGND sg13g2_nor2_1
X_28851_ _05531_ _04806_ _05529_ _05530_ VPWR VGND sg13g2_nor3_1
X_28852_ _05532_ _04916_ _05528_ _05531_ VPWR VGND sg13g2_a21oi_1
X_28853_ _05533_ _05309_ _05532_ VPWR VGND sg13g2_xnor2_1
X_28854_ _05534_ _05479_ _05533_ VPWR VGND sg13g2_nand2_1
X_28855_ _01544_ _05499_ _05534_ _03436_ VPWR VGND sg13g2_a21oi_1
X_28856_ _05535_ _05298_ _05329_ _05347_ VPWR VGND sg13g2_a21o_1
X_28857_ _05536_ _05535_ VPWR VGND sg13g2_buf_1
X_28858_ _05537_ _04775_ _05222_ VPWR VGND sg13g2_nor2_1
X_28859_ _05538_ _05537_ _05238_ VPWR VGND sg13g2_xnor2_1
X_28860_ _05539_ _05536_ _05538_ VPWR VGND sg13g2_xnor2_1
X_28861_ _01545_ _05487_ _05539_ _05495_ VPWR VGND sg13g2_a21oi_1
X_28862_ _05540_ _05222_ _05536_ VPWR VGND sg13g2_nor2_1
X_28863_ _05541_ _05225_ _05540_ _04084_ VPWR VGND sg13g2_o21ai_1
X_28864_ _05542_ _05225_ _05540_ VPWR VGND sg13g2_nand2_1
X_28865_ _05543_ _05541_ _05542_ VPWR VGND sg13g2_nand2_1
X_28866_ _05544_ _05225_ _05536_ _05237_ VPWR VGND sg13g2_o21ai_1
X_28867_ _05545_ _05225_ _05536_ VPWR VGND sg13g2_nand2_1
X_28868_ _05546_ _05544_ _05545_ _04916_ VPWR VGND sg13g2_a21oi_1
X_28869_ _05547_ _04916_ _05543_ _05546_ VPWR VGND sg13g2_a21oi_1
X_28870_ _05548_ _05232_ _05547_ VPWR VGND sg13g2_xor2_1
X_28871_ _01546_ _05487_ _05548_ _05495_ VPWR VGND sg13g2_a21oi_1
X_28872_ _05549_ _05330_ _05354_ VPWR VGND sg13g2_nand2_1
X_28873_ _05550_ _04806_ _05190_ VPWR VGND sg13g2_nand2_1
X_28874_ _05551_ _05356_ _05550_ VPWR VGND sg13g2_xor2_1
X_28875_ _05552_ _05549_ _05551_ VPWR VGND sg13g2_xnor2_1
X_28876_ _05553_ _05479_ _05552_ VPWR VGND sg13g2_nand2_1
X_28877_ _01547_ _05499_ _05553_ _03436_ VPWR VGND sg13g2_a21oi_1
X_28878_ _05554_ _05549_ _05190_ VPWR VGND sg13g2_nor2b_1
X_28879_ _05555_ _05182_ _05554_ _04079_ VPWR VGND sg13g2_o21ai_1
X_28880_ _05556_ _05182_ _05554_ VPWR VGND sg13g2_nand2_1
X_28881_ _05557_ _04916_ _05555_ _05556_ VPWR VGND sg13g2_nand3_1
X_28882_ _05558_ _05182_ _05549_ _05204_ VPWR VGND sg13g2_o21ai_1
X_28883_ _05559_ _05182_ _05549_ VPWR VGND sg13g2_nand2_1
X_28884_ _05560_ _04775_ _05558_ _05559_ VPWR VGND sg13g2_nand3_1
X_28885_ _05561_ _05557_ _05560_ VPWR VGND sg13g2_nand2_1
X_28886_ _05562_ _05355_ _05561_ VPWR VGND sg13g2_xnor2_1
X_28887_ _01548_ _05499_ _05562_ _05495_ VPWR VGND sg13g2_a21oi_1
X_28888_ _05563_ _05359_ _05362_ VPWR VGND sg13g2_nand2_1
X_28889_ _05564_ _05549_ _05563_ VPWR VGND sg13g2_nand2_1
X_28890_ _05565_ _05207_ _05564_ VPWR VGND sg13g2_and2_1
X_28891_ _05566_ _05565_ VPWR VGND sg13g2_buf_1
X_28892_ _05567_ _04916_ _05129_ VPWR VGND sg13g2_nand2_1
X_28893_ _05568_ _05567_ _05170_ VPWR VGND sg13g2_xor2_1
X_28894_ _05569_ _05566_ _05568_ VPWR VGND sg13g2_xnor2_1
X_28895_ _01549_ _05499_ _05569_ _05495_ VPWR VGND sg13g2_a21oi_1
X_28896_ _05570_ _05566_ VPWR VGND sg13g2_inv_1
X_28897_ _05571_ _05168_ _05570_ VPWR VGND sg13g2_nor2_1
X_28898_ _05572_ _05168_ _05570_ VPWR VGND sg13g2_nand2_1
X_28899_ _05573_ _04075_ _05571_ _05572_ VPWR VGND sg13g2_o21ai_1
X_28900_ _05574_ _05129_ _05566_ VPWR VGND sg13g2_and2_1
X_28901_ _05575_ _05168_ _05574_ _04075_ VPWR VGND sg13g2_o21ai_1
X_28902_ _05576_ _05168_ _05574_ VPWR VGND sg13g2_nand2_1
X_28903_ _05577_ _04806_ _05575_ _05576_ VPWR VGND sg13g2_nand3_1
X_28904_ _05578_ _04916_ _05573_ _05577_ VPWR VGND sg13g2_o21ai_1
X_28905_ _05579_ _05167_ _05578_ VPWR VGND sg13g2_xnor2_1
X_28906_ _05580_ _05479_ _05579_ VPWR VGND sg13g2_nand2_1
X_28907_ _01550_ _05499_ _05580_ _03436_ VPWR VGND sg13g2_a21oi_1
X_28908_ _05581_ _04806_ _05145_ VPWR VGND sg13g2_nand2_1
X_28909_ _05582_ _05368_ _05581_ VPWR VGND sg13g2_xor2_1
X_28910_ _05583_ _05366_ _05582_ VPWR VGND sg13g2_xnor2_1
X_28911_ _01551_ _05482_ _05583_ _05488_ VPWR VGND sg13g2_o21ai_1
X_28912_ _05584_ _05086_ _05366_ _04069_ VPWR VGND sg13g2_a21oi_1
X_28913_ _05585_ _05086_ _05366_ VPWR VGND sg13g2_nor2_1
X_28914_ _05586_ _05584_ _05585_ VPWR VGND sg13g2_nor2_1
X_28915_ _05587_ _05366_ _05145_ _05143_ VPWR VGND sg13g2_a21oi_1
X_28916_ _05588_ _05143_ _05366_ _05145_ VPWR VGND sg13g2_nand3_1
X_28917_ _05589_ _05151_ _05587_ _05588_ VPWR VGND sg13g2_o21ai_1
X_28918_ _05590_ _04775_ _05589_ VPWR VGND sg13g2_nor2_1
X_28919_ _05591_ _04775_ _05586_ _05590_ VPWR VGND sg13g2_a21oi_1
X_28920_ _05592_ _05367_ _05591_ VPWR VGND sg13g2_xnor2_1
X_28921_ _01552_ _05482_ _05592_ _05488_ VPWR VGND sg13g2_o21ai_1
X_28922_ _05593_ _05366_ _05375_ _05163_ VPWR VGND sg13g2_o21ai_1
X_28923_ _05594_ _04058_ _05137_ VPWR VGND sg13g2_xor2_1
X_28924_ _05595_ _05593_ _05594_ VPWR VGND sg13g2_xnor2_1
X_28925_ _01553_ _05482_ _05595_ _05488_ VPWR VGND sg13g2_o21ai_1
X_28926_ _05596_ _05165_ _05388_ _05390_ _05392_ VPWR
+ VGND
+ sg13g2_and4_1
X_28927_ _05597_ _04046_ _05133_ VPWR VGND sg13g2_xnor2_1
X_28928_ _05598_ _05596_ _05597_ VPWR VGND sg13g2_xnor2_1
X_28929_ _01554_ _05482_ _05598_ _05488_ VPWR VGND sg13g2_o21ai_1
X_28930_ _05599_ _04046_ _05381_ VPWR VGND sg13g2_nand2b_1
X_28931_ _05600_ _05133_ _05596_ _05599_ VPWR VGND sg13g2_o21ai_1
X_28932_ _05601_ _04039_ _05385_ VPWR VGND sg13g2_xor2_1
X_28933_ _05602_ _05600_ _05601_ VPWR VGND sg13g2_xnor2_1
X_28934_ _01555_ _05482_ _05602_ _05488_ VPWR VGND sg13g2_o21ai_1
X_28935_ _05603_ _04029_ _05417_ VPWR VGND sg13g2_xnor2_1
X_28936_ _05604_ _05396_ _05603_ VPWR VGND sg13g2_xnor2_1
X_28937_ _01556_ _05499_ _05604_ _05495_ VPWR VGND sg13g2_a21oi_1
X_28938_ _05605_ _05417_ _05396_ VPWR VGND sg13g2_nand2_1
X_28939_ _05606_ _05381_ _05386_ _05387_ _05393_ VPWR
+ VGND
+ sg13g2_a22oi_1
X_28940_ _05607_ _05394_ _04029_ VPWR VGND sg13g2_nor2b_1
X_28941_ _05608_ _04029_ _05417_ _05606_ _05607_ VPWR
+ VGND
+ sg13g2_a22oi_1
X_28942_ _05609_ _05605_ _05608_ VPWR VGND sg13g2_nand2_1
X_28943_ _05610_ _05422_ _05609_ VPWR VGND sg13g2_xor2_1
X_28944_ _01557_ _05499_ _05610_ _05495_ VPWR VGND sg13g2_a21oi_1
X_28945_ _05611_ _05421_ _05605_ _05608_ VPWR VGND sg13g2_nand3_1
X_28946_ _05612_ _05605_ _05608_ _05421_ VPWR VGND sg13g2_a21oi_1
X_28947_ _05613_ _04027_ _05611_ _05612_ VPWR VGND sg13g2_a21oi_1
X_28948_ _05614_ _05428_ _05613_ VPWR VGND sg13g2_xnor2_1
X_28949_ _01558_ _05487_ _05614_ _05495_ VPWR VGND sg13g2_a21oi_1
X_28950_ _05615_ _03981_ _05424_ _05426_ VPWR VGND sg13g2_nand3_1
X_28951_ _05616_ _05424_ _05426_ _03981_ VPWR VGND sg13g2_a21oi_1
X_28952_ _05617_ _05613_ _05615_ _05616_ VPWR VGND sg13g2_a21oi_1
X_28953_ _05618_ _05407_ _05617_ VPWR VGND sg13g2_xnor2_1
X_28954_ _01559_ _05482_ _05618_ _05488_ VPWR VGND sg13g2_o21ai_1
X_28955_ _05619_ _05406_ _05617_ _03979_ VPWR VGND sg13g2_o21ai_1
X_28956_ _05620_ _05406_ _05617_ VPWR VGND sg13g2_nand2_1
X_28957_ _05621_ _05619_ _05620_ VPWR VGND sg13g2_nand2_1
X_28958_ _05622_ _05411_ _05621_ VPWR VGND sg13g2_xor2_1
X_28959_ _01560_ _05499_ _05622_ _05495_ VPWR VGND sg13g2_a21oi_1
X_28960_ _05623_ _05441_ _05451_ VPWR VGND sg13g2_xnor2_1
X_28961_ _05624_ _03957_ _05476_ _05623_ VPWR VGND sg13g2_a21oi_1
X_28962_ _05625_ _05477_ _05623_ VPWR VGND sg13g2_nand2b_1
X_28963_ _05626_ _05470_ _05624_ _05625_ VPWR VGND sg13g2_o21ai_1
X_28964_ _01561_ \memory_i.freq_inst.cordic.rstn_i\ _05626_ VPWR VGND sg13g2_and2_1
X_28965_ _05627_ _05441_ _05449_ _05450_ VPWR VGND sg13g2_o21ai_1
X_28966_ _05628_ _05455_ _05627_ VPWR VGND sg13g2_xor2_1
X_28967_ _05629_ _05479_ _05628_ VPWR VGND sg13g2_nand2_1
X_28968_ _01562_ _05485_ _05629_ _03436_ VPWR VGND sg13g2_a21oi_1
X_28969_ _05630_ _05459_ _05460_ VPWR VGND sg13g2_nand2_1
X_28970_ _05631_ _05441_ _05456_ _05630_ VPWR VGND sg13g2_a21oi_1
X_28971_ _05632_ _03960_ _05444_ VPWR VGND sg13g2_xnor2_1
X_28972_ _05633_ _05631_ _05632_ VPWR VGND sg13g2_xnor2_1
X_28973_ _01563_ _05487_ _05633_ _05482_ VPWR VGND sg13g2_a21oi_1
X_28974_ _05634_ _03952_ _05127_ VPWR VGND sg13g2_xnor2_1
X_28975_ _05635_ _05444_ _05631_ _03960_ VPWR VGND sg13g2_a21o_1
X_28976_ _05636_ _05444_ _05631_ _05635_ VPWR VGND sg13g2_o21ai_1
X_28977_ _05637_ _05634_ _05636_ VPWR VGND sg13g2_xnor2_1
X_28978_ _01564_ _05481_ _05637_ _05488_ VPWR VGND sg13g2_o21ai_1
X_28979_ _05638_ _05467_ _05468_ VPWR VGND sg13g2_nand2b_1
X_28980_ _05639_ _04932_ _05638_ VPWR VGND sg13g2_nor2_1
X_28981_ _05640_ _03943_ _03934_ VPWR VGND sg13g2_nor2_1
X_28982_ _05641_ _05639_ _05640_ _05476_ VPWR VGND sg13g2_o21ai_1
X_28983_ _05642_ _04932_ _05638_ VPWR VGND sg13g2_and2_1
X_28984_ _05643_ _03957_ _05639_ _05642_ VPWR VGND sg13g2_a21oi_1
X_28985_ _01565_ _05641_ _05643_ _03436_ VPWR VGND sg13g2_a21oi_1
X_28986_ _05644_ _03957_ _05476_ VPWR VGND sg13g2_nand2_1
X_28987_ _05645_ _05470_ _05644_ _05477_ VPWR VGND sg13g2_a21oi_1
X_28988_ _01566_ _04873_ _05645_ VPWR VGND sg13g2_nor2_1
X_28989_ _05646_ _15902_ VPWR VGND sg13g2_buf_1
X_28990_ _05647_ \memory_i.freq_inst.dsmod_cos.i_ena_mod\ \memory_i.freq_inst.dsmod_cos.data_step_r[0]\ VPWR VGND sg13g2_nand2_1
X_28991_ _05648_ \memory_i.freq_inst.dsmod_cos.data_interp_r[0]\ _05647_ VPWR VGND sg13g2_xor2_1
X_28992_ _01567_ _03810_ _05646_ _05648_ VPWR VGND sg13g2_nor3_1
X_28993_ _05649_ _12938_ VPWR VGND sg13g2_buf_1
X_28994_ _05650_ _05649_ VPWR VGND sg13g2_buf_1
X_28995_ _05651_ _05650_ VPWR VGND sg13g2_buf_1
X_28996_ _05652_ \memory_i.freq_inst.dsmod_cos.fetch_ctr_r[3]\ \memory_i.freq_inst.dsmod_cos.fetch_ctr_r[2]\ \memory_i.freq_inst.dsmod_cos.fetch_ctr_r[1]\ \memory_i.freq_inst.dsmod_cos.fetch_ctr_r[0]\ VPWR
+ VGND
+ sg13g2_nor4_1
X_28997_ _05653_ \memory_i.freq_inst.dsmod_cos.fetch_ctr_r[7]\ \memory_i.freq_inst.dsmod_cos.fetch_ctr_r[6]\ \memory_i.freq_inst.dsmod_cos.fetch_ctr_r[5]\ VPWR VGND sg13g2_nor3_1
X_28998_ _05654_ \memory_i.freq_inst.dsmod_cos.fetch_ctr_r[4]\ _05652_ _05653_ VPWR VGND sg13g2_nand3b_1
X_28999_ _05655_ \memory_i.freq_inst.dsmod_cos.i_ena_mod\ _05654_ VPWR VGND sg13g2_and2_1
X_29000_ _05656_ _05655_ VPWR VGND sg13g2_buf_1
X_29001_ _05657_ _05656_ VPWR VGND sg13g2_buf_1
X_29002_ _05658_ \memory_i.freq_inst.dsmod_cos.data_step_r[0]\ \memory_i.freq_inst.dsmod_cos.data_interp_r[0]\ VPWR VGND sg13g2_nand2_1
X_29003_ _05659_ \memory_i.freq_inst.dsmod_cos.data_step_r[1]\ \memory_i.freq_inst.dsmod_cos.data_interp_r[1]\ VPWR VGND sg13g2_xor2_1
X_29004_ _05660_ _05658_ _05659_ VPWR VGND sg13g2_xnor2_1
X_29005_ _05661_ _05651_ \memory_i.freq_inst.dsmod_cos.data_interp_r[1]\ _05657_ _05660_ VPWR
+ VGND
+ sg13g2_a22oi_1
X_29006_ _01568_ _04873_ _05661_ VPWR VGND sg13g2_nor2_1
X_29007_ _05662_ _05650_ VPWR VGND sg13g2_buf_1
X_29008_ _05663_ \memory_i.freq_inst.dsmod_cos.data_step_r[0]\ \memory_i.freq_inst.dsmod_cos.data_interp_r[0]\ \memory_i.freq_inst.dsmod_cos.data_interp_r[1]\ VPWR VGND sg13g2_a21o_1
X_29009_ _05664_ \memory_i.freq_inst.dsmod_cos.data_step_r[0]\ \memory_i.freq_inst.dsmod_cos.data_interp_r[1]\ \memory_i.freq_inst.dsmod_cos.data_interp_r[0]\ VPWR VGND sg13g2_and3_1
X_29010_ _05665_ \memory_i.freq_inst.dsmod_cos.data_step_r[1]\ _05663_ _05664_ VPWR VGND sg13g2_a21oi_1
X_29011_ _05666_ \memory_i.freq_inst.dsmod_cos.data_step_r[2]\ \memory_i.freq_inst.dsmod_cos.data_interp_r[2]\ VPWR VGND sg13g2_xor2_1
X_29012_ _05667_ _05665_ _05666_ VPWR VGND sg13g2_xnor2_1
X_29013_ _05668_ _05662_ \memory_i.freq_inst.dsmod_cos.data_interp_r[2]\ _05657_ _05667_ VPWR
+ VGND
+ sg13g2_a22oi_1
X_29014_ _01569_ _04873_ _05668_ VPWR VGND sg13g2_nor2_1
X_29015_ _05669_ \memory_i.freq_inst.dsmod_cos.data_step_r[2]\ \memory_i.freq_inst.dsmod_cos.data_interp_r[2]\ VPWR VGND sg13g2_nor2_1
X_29016_ _05670_ \memory_i.freq_inst.dsmod_cos.data_step_r[2]\ \memory_i.freq_inst.dsmod_cos.data_interp_r[2]\ _05663_ \memory_i.freq_inst.dsmod_cos.data_step_r[1]\ _05664_
+ VPWR
+ VGND sg13g2_a221oi_1
X_29017_ _05671_ _05670_ VPWR VGND sg13g2_buf_1
X_29018_ _05672_ _05669_ _05671_ VPWR VGND sg13g2_nor2_1
X_29019_ _05673_ \memory_i.freq_inst.dsmod_cos.data_step_r[3]\ \memory_i.freq_inst.dsmod_cos.data_interp_r[3]\ VPWR VGND sg13g2_xnor2_1
X_29020_ _05674_ _05672_ _05673_ VPWR VGND sg13g2_xnor2_1
X_29021_ _05675_ _05662_ \memory_i.freq_inst.dsmod_cos.data_interp_r[3]\ _05656_ _05674_ VPWR
+ VGND
+ sg13g2_a22oi_1
X_29022_ _01570_ _04873_ _05675_ VPWR VGND sg13g2_nor2_1
X_29023_ _05676_ _03656_ VPWR VGND sg13g2_buf_1
X_29024_ _05677_ \memory_i.freq_inst.dsmod_cos.data_interp_r[3]\ VPWR VGND sg13g2_inv_1
X_29025_ _05678_ _05669_ _05671_ _05677_ VPWR VGND sg13g2_o21ai_1
X_29026_ _05679_ _05677_ _05669_ _05671_ VPWR VGND sg13g2_nor3_1
X_29027_ _05680_ \memory_i.freq_inst.dsmod_cos.data_step_r[3]\ _05678_ _05679_ VPWR VGND sg13g2_a21oi_1
X_29028_ _05681_ \memory_i.freq_inst.dsmod_cos.data_step_r[4]\ \memory_i.freq_inst.dsmod_cos.data_interp_r[4]\ VPWR VGND sg13g2_xor2_1
X_29029_ _05682_ _05680_ _05681_ VPWR VGND sg13g2_xnor2_1
X_29030_ _05683_ _05662_ \memory_i.freq_inst.dsmod_cos.data_interp_r[4]\ _05656_ _05682_ VPWR
+ VGND
+ sg13g2_a22oi_1
X_29031_ _01571_ _05676_ _05683_ VPWR VGND sg13g2_nor2_1
X_29032_ _05684_ \memory_i.freq_inst.dsmod_cos.data_step_r[4]\ \memory_i.freq_inst.dsmod_cos.data_interp_r[4]\ VPWR VGND sg13g2_nor2_1
X_29033_ _05685_ \memory_i.freq_inst.dsmod_cos.data_step_r[4]\ \memory_i.freq_inst.dsmod_cos.data_interp_r[4]\ _05678_ \memory_i.freq_inst.dsmod_cos.data_step_r[3]\ _05679_
+ VPWR
+ VGND sg13g2_a221oi_1
X_29034_ _05686_ _05685_ VPWR VGND sg13g2_buf_1
X_29035_ _05687_ _05684_ _05686_ VPWR VGND sg13g2_nor2_1
X_29036_ _05688_ \memory_i.freq_inst.dsmod_cos.data_step_r[5]\ \memory_i.freq_inst.dsmod_cos.data_interp_r[5]\ VPWR VGND sg13g2_xnor2_1
X_29037_ _05689_ _05687_ _05688_ VPWR VGND sg13g2_xnor2_1
X_29038_ _05690_ _05662_ \memory_i.freq_inst.dsmod_cos.data_interp_r[5]\ _05656_ _05689_ VPWR
+ VGND
+ sg13g2_a22oi_1
X_29039_ _01572_ _05676_ _05690_ VPWR VGND sg13g2_nor2_1
X_29040_ _05691_ \memory_i.freq_inst.dsmod_cos.data_interp_r[5]\ VPWR VGND sg13g2_inv_1
X_29041_ _05692_ _05684_ _05686_ _05691_ VPWR VGND sg13g2_o21ai_1
X_29042_ _05693_ _05691_ _05684_ _05686_ VPWR VGND sg13g2_nor3_1
X_29043_ _05694_ \memory_i.freq_inst.dsmod_cos.data_step_r[5]\ _05692_ _05693_ VPWR VGND sg13g2_a21oi_1
X_29044_ _05695_ \memory_i.freq_inst.dsmod_cos.data_step_r[6]\ \memory_i.freq_inst.dsmod_cos.data_interp_r[6]\ VPWR VGND sg13g2_xor2_1
X_29045_ _05696_ _05694_ _05695_ VPWR VGND sg13g2_xnor2_1
X_29046_ _05697_ _05662_ \memory_i.freq_inst.dsmod_cos.data_interp_r[6]\ _05656_ _05696_ VPWR
+ VGND
+ sg13g2_a22oi_1
X_29047_ _01573_ _05676_ _05697_ VPWR VGND sg13g2_nor2_1
X_29048_ _05698_ \memory_i.freq_inst.dsmod_cos.data_step_r[6]\ \memory_i.freq_inst.dsmod_cos.data_interp_r[6]\ VPWR VGND sg13g2_nor2_1
X_29049_ _05699_ \memory_i.freq_inst.dsmod_cos.data_step_r[6]\ \memory_i.freq_inst.dsmod_cos.data_interp_r[6]\ VPWR VGND sg13g2_nand2_1
X_29050_ _05700_ _05694_ _05698_ _05699_ VPWR VGND sg13g2_o21ai_1
X_29051_ _05701_ _05700_ VPWR VGND sg13g2_buf_1
X_29052_ _05702_ \memory_i.freq_inst.dsmod_cos.data_step_r[7]\ \memory_i.freq_inst.dsmod_cos.data_interp_r[7]\ VPWR VGND sg13g2_xnor2_1
X_29053_ _05703_ _05701_ _05702_ VPWR VGND sg13g2_xnor2_1
X_29054_ _05704_ _05662_ \memory_i.freq_inst.dsmod_cos.data_interp_r[7]\ _05656_ _05703_ VPWR
+ VGND
+ sg13g2_a22oi_1
X_29055_ _01574_ _05676_ _05704_ VPWR VGND sg13g2_nor2_1
X_29056_ _05705_ _12939_ VPWR VGND sg13g2_buf_1
X_29057_ _05706_ _15965_ VPWR VGND sg13g2_buf_1
X_29058_ _05707_ \memory_i.freq_inst.dsmod_cos.i_ena_mod\ _05654_ VPWR VGND sg13g2_nand2_1
X_29059_ _05708_ _05707_ VPWR VGND sg13g2_buf_1
X_29060_ _05709_ _05708_ VPWR VGND sg13g2_buf_1
X_29061_ _05710_ \memory_i.freq_inst.dsmod_cos.data_interp_r[7]\ _05701_ VPWR VGND sg13g2_nand2_1
X_29062_ _05711_ \memory_i.freq_inst.dsmod_cos.data_interp_r[7]\ _05701_ \memory_i.freq_inst.dsmod_cos.data_step_r[7]\ VPWR VGND sg13g2_o21ai_1
X_29063_ _05712_ _05711_ VPWR VGND sg13g2_buf_1
X_29064_ _05713_ \memory_i.freq_inst.dsmod_cos.data_step_r[8]\ \memory_i.freq_inst.dsmod_cos.data_interp_r[8]\ VPWR VGND sg13g2_xnor2_1
X_29065_ _05714_ _05710_ _05712_ _05713_ VPWR VGND sg13g2_and3_1
X_29066_ _05715_ _05710_ _05712_ _05713_ VPWR VGND sg13g2_a21oi_1
X_29067_ _05716_ _05709_ _05714_ _05715_ VPWR VGND sg13g2_nor3_1
X_29068_ _05717_ _05705_ \memory_i.freq_inst.dsmod_cos.data_interp_r[8]\ \memory_i.freq_inst.dsmod_cos.data_pre_r[8]\ _05706_ _05716_
+ VPWR
+ VGND sg13g2_a221oi_1
X_29069_ _01575_ _05676_ _05717_ VPWR VGND sg13g2_nor2_1
X_29070_ _05718_ \memory_i.freq_inst.dsmod_cos.data_interp_r[8]\ VPWR VGND sg13g2_inv_1
X_29071_ _05719_ _05718_ _05710_ _05712_ VPWR VGND sg13g2_nand3_1
X_29072_ _05720_ _05710_ _05712_ _05718_ VPWR VGND sg13g2_a21oi_1
X_29073_ _05721_ \memory_i.freq_inst.dsmod_cos.data_step_r[8]\ _05719_ _05720_ VPWR VGND sg13g2_a21oi_1
X_29074_ _05722_ \memory_i.freq_inst.dsmod_cos.data_step_r[9]\ \memory_i.freq_inst.dsmod_cos.data_interp_r[9]\ VPWR VGND sg13g2_xnor2_1
X_29075_ _05723_ _05721_ _05722_ VPWR VGND sg13g2_xnor2_1
X_29076_ _05724_ _05649_ VPWR VGND sg13g2_buf_1
X_29077_ _05725_ _05724_ \memory_i.freq_inst.dsmod_cos.data_interp_r[9]\ \memory_i.freq_inst.dsmod_cos.data_pre_r[9]\ _15902_ VPWR
+ VGND
+ sg13g2_a22oi_1
X_29078_ _05726_ _05709_ _05723_ _05725_ VPWR VGND sg13g2_o21ai_1
X_29079_ _01576_ \memory_i.freq_inst.cordic.rstn_i\ _05726_ VPWR VGND sg13g2_and2_1
X_29080_ _05727_ \memory_i.freq_inst.dsmod_cos.data_interp_r[9]\ VPWR VGND sg13g2_inv_1
X_29081_ _05728_ _05727_ _05721_ VPWR VGND sg13g2_or2_1
X_29082_ _05729_ _05728_ VPWR VGND sg13g2_buf_1
X_29083_ _05730_ \memory_i.freq_inst.dsmod_cos.data_step_r[9]\ VPWR VGND sg13g2_inv_1
X_29084_ _05731_ _05727_ _05721_ _05730_ VPWR VGND sg13g2_a21o_1
X_29085_ _05732_ _05731_ VPWR VGND sg13g2_buf_1
X_29086_ _05733_ \memory_i.freq_inst.dsmod_cos.data_step_r[10]\ \memory_i.freq_inst.dsmod_cos.data_interp_r[10]\ VPWR VGND sg13g2_xnor2_1
X_29087_ _05734_ _05729_ _05732_ _05733_ VPWR VGND sg13g2_nand3_1
X_29088_ _05735_ _05729_ _05732_ _05733_ VPWR VGND sg13g2_a21o_1
X_29089_ _05736_ _05656_ _05734_ _05735_ VPWR VGND sg13g2_nand3_1
X_29090_ _05737_ _05649_ VPWR VGND sg13g2_buf_1
X_29091_ _05738_ _05737_ VPWR VGND sg13g2_buf_1
X_29092_ _05739_ _15965_ VPWR VGND sg13g2_buf_1
X_29093_ _05740_ _05738_ \memory_i.freq_inst.dsmod_cos.data_interp_r[10]\ \memory_i.freq_inst.dsmod_cos.data_pre_r[10]\ _05739_ VPWR
+ VGND
+ sg13g2_a22oi_1
X_29094_ _01577_ _05736_ _05740_ _03436_ VPWR VGND sg13g2_a21oi_1
X_29095_ _05741_ _05656_ VPWR VGND sg13g2_buf_1
X_29096_ _05742_ \memory_i.freq_inst.dsmod_cos.data_interp_r[10]\ VPWR VGND sg13g2_inv_1
X_29097_ _05743_ _05742_ _05729_ _05732_ VPWR VGND sg13g2_nand3_1
X_29098_ _05744_ _05729_ _05732_ _05742_ VPWR VGND sg13g2_a21oi_1
X_29099_ _05745_ \memory_i.freq_inst.dsmod_cos.data_step_r[10]\ _05743_ _05744_ VPWR VGND sg13g2_a21oi_1
X_29100_ _05746_ \memory_i.freq_inst.dsmod_cos.data_step_r[11]\ \memory_i.freq_inst.dsmod_cos.data_interp_r[11]\ VPWR VGND sg13g2_xor2_1
X_29101_ _05747_ _05745_ _05746_ VPWR VGND sg13g2_xnor2_1
X_29102_ _05748_ _05741_ _05747_ VPWR VGND sg13g2_nand2_1
X_29103_ _05749_ _05738_ \memory_i.freq_inst.dsmod_cos.data_interp_r[11]\ \memory_i.freq_inst.dsmod_cos.data_pre_r[11]\ _05739_ VPWR
+ VGND
+ sg13g2_a22oi_1
X_29104_ _05750_ _03245_ VPWR VGND sg13g2_buf_1
X_29105_ _01578_ _05748_ _05749_ _05750_ VPWR VGND sg13g2_a21oi_1
X_29106_ _05751_ _05737_ VPWR VGND sg13g2_buf_1
X_29107_ _05752_ _15965_ VPWR VGND sg13g2_buf_1
X_29108_ _05753_ _05751_ \memory_i.freq_inst.dsmod_cos.data_interp_r[12]\ \memory_i.freq_inst.dsmod_cos.data_pre_r[12]\ _05752_ VPWR
+ VGND
+ sg13g2_a22oi_1
X_29109_ _05754_ \memory_i.freq_inst.dsmod_cos.data_interp_r[11]\ VPWR VGND sg13g2_inv_1
X_29110_ _05755_ _05754_ _05745_ VPWR VGND sg13g2_nand2_1
X_29111_ _05756_ \memory_i.freq_inst.dsmod_cos.data_step_r[11]\ VPWR VGND sg13g2_inv_1
X_29112_ _05757_ _05754_ _05745_ _05756_ VPWR VGND sg13g2_o21ai_1
X_29113_ _05758_ _05755_ _05757_ VPWR VGND sg13g2_and2_1
X_29114_ _05759_ _05758_ VPWR VGND sg13g2_buf_1
X_29115_ _05760_ \memory_i.freq_inst.dsmod_cos.data_step_r[12]\ \memory_i.freq_inst.dsmod_cos.data_interp_r[12]\ VPWR VGND sg13g2_xnor2_1
X_29116_ _05761_ _05759_ _05760_ VPWR VGND sg13g2_xnor2_1
X_29117_ _05762_ _05741_ _05761_ VPWR VGND sg13g2_nand2_1
X_29118_ _01579_ _05753_ _05762_ _05750_ VPWR VGND sg13g2_a21oi_1
X_29119_ _05763_ _05751_ \memory_i.freq_inst.dsmod_cos.data_interp_r[13]\ \memory_i.freq_inst.dsmod_cos.data_pre_r[13]\ _05752_ VPWR
+ VGND
+ sg13g2_a22oi_1
X_29120_ _05764_ \memory_i.freq_inst.dsmod_cos.data_interp_r[12]\ _05759_ \memory_i.freq_inst.dsmod_cos.data_step_r[12]\ VPWR VGND sg13g2_a21o_1
X_29121_ _05765_ \memory_i.freq_inst.dsmod_cos.data_interp_r[12]\ _05759_ _05764_ VPWR VGND sg13g2_o21ai_1
X_29122_ _05766_ \memory_i.freq_inst.dsmod_cos.data_step_r[13]\ \memory_i.freq_inst.dsmod_cos.data_interp_r[13]\ VPWR VGND sg13g2_xor2_1
X_29123_ _05767_ _05765_ _05766_ VPWR VGND sg13g2_xnor2_1
X_29124_ _05768_ _05741_ _05767_ VPWR VGND sg13g2_nand2_1
X_29125_ _01580_ _05763_ _05768_ _05750_ VPWR VGND sg13g2_a21oi_1
X_29126_ _05769_ _05751_ \memory_i.freq_inst.dsmod_cos.data_interp_r[14]\ \memory_i.freq_inst.dsmod_cos.data_pre_r[14]\ _05752_ VPWR
+ VGND
+ sg13g2_a22oi_1
X_29127_ _05770_ \memory_i.freq_inst.dsmod_cos.data_interp_r[13]\ VPWR VGND sg13g2_inv_1
X_29128_ _05771_ \memory_i.freq_inst.dsmod_cos.data_step_r[13]\ VPWR VGND sg13g2_inv_1
X_29129_ _05772_ _05770_ _05765_ _05771_ VPWR VGND sg13g2_a21o_1
X_29130_ _05773_ _05770_ _05765_ _05772_ VPWR VGND sg13g2_o21ai_1
X_29131_ _05774_ \memory_i.freq_inst.dsmod_cos.data_step_r[14]\ \memory_i.freq_inst.dsmod_cos.data_interp_r[14]\ VPWR VGND sg13g2_xnor2_1
X_29132_ _05775_ _05773_ _05774_ VPWR VGND sg13g2_xnor2_1
X_29133_ _05776_ _05741_ _05775_ VPWR VGND sg13g2_nand2_1
X_29134_ _01581_ _05769_ _05776_ _05750_ VPWR VGND sg13g2_a21oi_1
X_29135_ _05777_ \memory_i.freq_inst.dsmod_cos.data_step_r[15]\ \memory_i.freq_inst.dsmod_cos.data_interp_r[15]\ VPWR VGND sg13g2_xor2_1
X_29136_ _05778_ \memory_i.freq_inst.dsmod_cos.data_step_r[14]\ _05773_ \memory_i.freq_inst.dsmod_cos.data_interp_r[14]\ VPWR VGND sg13g2_o21ai_1
X_29137_ _05779_ _05778_ VPWR VGND sg13g2_inv_1
X_29138_ _05780_ \memory_i.freq_inst.dsmod_cos.data_step_r[14]\ _05773_ _05779_ VPWR VGND sg13g2_a21oi_1
X_29139_ _05781_ _05777_ _05780_ VPWR VGND sg13g2_xnor2_1
X_29140_ _05782_ _05741_ _05781_ VPWR VGND sg13g2_nand2_1
X_29141_ _05783_ _12938_ VPWR VGND sg13g2_buf_1
X_29142_ _05784_ _05783_ VPWR VGND sg13g2_buf_1
X_29143_ _05785_ _05784_ \memory_i.freq_inst.dsmod_cos.data_interp_r[15]\ \memory_i.freq_inst.dsmod_cos.data_pre_r[15]\ _05706_ VPWR
+ VGND
+ sg13g2_a22oi_1
X_29144_ _01582_ _05782_ _05785_ _05750_ VPWR VGND sg13g2_a21oi_1
X_29145_ _05786_ _05751_ \memory_i.freq_inst.dsmod_cos.data_interp_r[16]\ \memory_i.freq_inst.dsmod_cos.data_pre_r[16]\ _05739_ VPWR
+ VGND
+ sg13g2_a22oi_1
X_29146_ _05787_ _05774_ _05777_ VPWR VGND sg13g2_nor2b_1
X_29147_ _05788_ _05760_ _05766_ VPWR VGND sg13g2_nor2b_1
X_29148_ _05789_ _05755_ _05757_ _05787_ _05788_ VPWR
+ VGND
+ sg13g2_nand4_1
X_29149_ _05790_ _05789_ VPWR VGND sg13g2_buf_1
X_29150_ _05791_ \memory_i.freq_inst.dsmod_cos.data_step_r[12]\ \memory_i.freq_inst.dsmod_cos.data_interp_r[12]\ \memory_i.freq_inst.dsmod_cos.data_interp_r[13]\ VPWR VGND sg13g2_a21oi_1
X_29151_ _05792_ \memory_i.freq_inst.dsmod_cos.data_step_r[12]\ \memory_i.freq_inst.dsmod_cos.data_interp_r[13]\ \memory_i.freq_inst.dsmod_cos.data_interp_r[12]\ VPWR VGND sg13g2_nand3_1
X_29152_ _05793_ _05771_ _05791_ _05792_ VPWR VGND sg13g2_o21ai_1
X_29153_ _05794_ \memory_i.freq_inst.dsmod_cos.data_interp_r[14]\ _05793_ \memory_i.freq_inst.dsmod_cos.data_step_r[14]\ VPWR VGND sg13g2_a21oi_1
X_29154_ _05795_ \memory_i.freq_inst.dsmod_cos.data_interp_r[14]\ _05793_ VPWR VGND sg13g2_nor2_1
X_29155_ _05796_ \memory_i.freq_inst.dsmod_cos.data_step_r[15]\ \memory_i.freq_inst.dsmod_cos.data_interp_r[15]\ VPWR VGND sg13g2_nand2_1
X_29156_ _05797_ _05794_ _05795_ _05796_ VPWR VGND sg13g2_o21ai_1
X_29157_ _05798_ \memory_i.freq_inst.dsmod_cos.data_step_r[15]\ \memory_i.freq_inst.dsmod_cos.data_interp_r[15]\ _05797_ VPWR VGND sg13g2_o21ai_1
X_29158_ _05799_ _05790_ _05798_ VPWR VGND sg13g2_nand2_1
X_29159_ _05800_ \memory_i.freq_inst.dsmod_cos.data_step_r[16]\ \memory_i.freq_inst.dsmod_cos.data_interp_r[16]\ VPWR VGND sg13g2_xnor2_1
X_29160_ _05801_ _05799_ _05800_ VPWR VGND sg13g2_xnor2_1
X_29161_ _05802_ _05657_ _05801_ VPWR VGND sg13g2_nand2_1
X_29162_ _01583_ _05786_ _05802_ _05750_ VPWR VGND sg13g2_a21oi_1
X_29163_ _05803_ _05751_ \memory_i.freq_inst.dsmod_cos.data_interp_r[17]\ \memory_i.freq_inst.dsmod_cos.data_pre_r[17]\ _05739_ VPWR
+ VGND
+ sg13g2_a22oi_1
X_29164_ _05804_ \memory_i.freq_inst.dsmod_cos.data_interp_r[16]\ VPWR VGND sg13g2_inv_1
X_29165_ _05805_ _05804_ _05790_ _05798_ VPWR VGND sg13g2_nand3_1
X_29166_ _05806_ _05790_ _05798_ _05804_ VPWR VGND sg13g2_a21oi_1
X_29167_ _05807_ \memory_i.freq_inst.dsmod_cos.data_step_r[16]\ _05805_ _05806_ VPWR VGND sg13g2_a21o_1
X_29168_ _05808_ _05807_ VPWR VGND sg13g2_buf_1
X_29169_ _05809_ \memory_i.freq_inst.dsmod_cos.data_step_r[17]\ \memory_i.freq_inst.dsmod_cos.data_interp_r[17]\ VPWR VGND sg13g2_xor2_1
X_29170_ _05810_ _05808_ _05809_ VPWR VGND sg13g2_xor2_1
X_29171_ _05811_ _05657_ _05810_ VPWR VGND sg13g2_nand2_1
X_29172_ _01584_ _05803_ _05811_ _05750_ VPWR VGND sg13g2_a21oi_1
X_29173_ _05812_ \memory_i.freq_inst.dsmod_cos.data_interp_r[17]\ _05808_ VPWR VGND sg13g2_nand2_1
X_29174_ _05813_ \memory_i.freq_inst.dsmod_cos.data_interp_r[17]\ _05808_ \memory_i.freq_inst.dsmod_cos.data_step_r[17]\ VPWR VGND sg13g2_o21ai_1
X_29175_ _05814_ _05813_ VPWR VGND sg13g2_buf_1
X_29176_ _05815_ \memory_i.freq_inst.dsmod_cos.data_step_r[18]\ \memory_i.freq_inst.dsmod_cos.data_interp_r[18]\ VPWR VGND sg13g2_xnor2_1
X_29177_ _05816_ _05812_ _05814_ _05815_ VPWR VGND sg13g2_and3_1
X_29178_ _05817_ _05812_ _05814_ _05815_ VPWR VGND sg13g2_a21oi_1
X_29179_ _05818_ _05709_ _05816_ _05817_ VPWR VGND sg13g2_nor3_1
X_29180_ _05819_ _12940_ \memory_i.freq_inst.dsmod_cos.data_interp_r[18]\ \memory_i.freq_inst.dsmod_cos.data_pre_r[18]\ _15902_ _05818_
+ VPWR
+ VGND sg13g2_a221oi_1
X_29181_ _01585_ _05676_ _05819_ VPWR VGND sg13g2_nor2_1
X_29182_ _05820_ \memory_i.freq_inst.dsmod_cos.data_interp_r[18]\ VPWR VGND sg13g2_inv_1
X_29183_ _05821_ _05820_ _05812_ _05814_ VPWR VGND sg13g2_nand3_1
X_29184_ _05822_ _05812_ _05814_ _05820_ VPWR VGND sg13g2_a21oi_1
X_29185_ _05823_ \memory_i.freq_inst.dsmod_cos.data_step_r[18]\ _05821_ _05822_ VPWR VGND sg13g2_a21oi_1
X_29186_ _05824_ \memory_i.freq_inst.dsmod_cos.data_step_r[19]\ \memory_i.freq_inst.dsmod_cos.data_interp_r[19]\ VPWR VGND sg13g2_xnor2_1
X_29187_ _05825_ _05823_ _05824_ VPWR VGND sg13g2_xnor2_1
X_29188_ _05826_ _05724_ \memory_i.freq_inst.dsmod_cos.data_interp_r[19]\ \memory_i.freq_inst.dsmod_cos.data_pre_r[19]\ _15965_ VPWR
+ VGND
+ sg13g2_a22oi_1
X_29189_ _05827_ _05709_ _05825_ _05826_ VPWR VGND sg13g2_o21ai_1
X_29190_ _01586_ \memory_i.freq_inst.cordic.rstn_i\ _05827_ VPWR VGND sg13g2_and2_1
X_29191_ _05828_ _05751_ \memory_i.freq_inst.dsmod_cos.data_interp_r[20]\ \memory_i.freq_inst.dsmod_cos.data_pre_r[20]\ _05739_ VPWR
+ VGND
+ sg13g2_a22oi_1
X_29192_ _05829_ \memory_i.freq_inst.dsmod_cos.data_interp_r[19]\ VPWR VGND sg13g2_inv_1
X_29193_ _05830_ _05829_ _05823_ VPWR VGND sg13g2_nand2_1
X_29194_ _05831_ _05829_ _05823_ VPWR VGND sg13g2_nor2_1
X_29195_ _05832_ \memory_i.freq_inst.dsmod_cos.data_step_r[19]\ _05830_ _05831_ VPWR VGND sg13g2_a21o_1
X_29196_ _05833_ _05832_ VPWR VGND sg13g2_buf_1
X_29197_ _05834_ \memory_i.freq_inst.dsmod_cos.data_step_r[20]\ \memory_i.freq_inst.dsmod_cos.data_interp_r[20]\ VPWR VGND sg13g2_xnor2_1
X_29198_ _05835_ _05833_ _05834_ VPWR VGND sg13g2_xnor2_1
X_29199_ _05836_ _05657_ _05835_ VPWR VGND sg13g2_nand2_1
X_29200_ _01587_ _05828_ _05836_ _05750_ VPWR VGND sg13g2_a21oi_1
X_29201_ _05837_ _05751_ \memory_i.freq_inst.dsmod_cos.data_interp_r[21]\ \memory_i.freq_inst.dsmod_cos.data_pre_r[21]\ _05739_ VPWR
+ VGND
+ sg13g2_a22oi_1
X_29202_ _05838_ \memory_i.freq_inst.dsmod_cos.data_interp_r[20]\ _05833_ VPWR VGND sg13g2_nand2_1
X_29203_ _05839_ \memory_i.freq_inst.dsmod_cos.data_interp_r[20]\ _05833_ \memory_i.freq_inst.dsmod_cos.data_step_r[20]\ VPWR VGND sg13g2_o21ai_1
X_29204_ _05840_ _05838_ _05839_ VPWR VGND sg13g2_nand2_1
X_29205_ _05841_ \memory_i.freq_inst.dsmod_cos.data_step_r[21]\ \memory_i.freq_inst.dsmod_cos.data_interp_r[21]\ VPWR VGND sg13g2_xor2_1
X_29206_ _05842_ _05840_ _05841_ VPWR VGND sg13g2_xor2_1
X_29207_ _05843_ _05657_ _05842_ VPWR VGND sg13g2_nand2_1
X_29208_ _01588_ _05837_ _05843_ _05750_ VPWR VGND sg13g2_a21oi_1
X_29209_ _05844_ _05738_ \memory_i.freq_inst.dsmod_cos.data_interp_r[22]\ \memory_i.freq_inst.dsmod_cos.data_pre_r[22]\ _05739_ VPWR
+ VGND
+ sg13g2_a22oi_1
X_29210_ _05845_ \memory_i.freq_inst.dsmod_cos.data_step_r[21]\ VPWR VGND sg13g2_inv_1
X_29211_ _05846_ _05845_ _05838_ _05839_ VPWR VGND sg13g2_nand3_1
X_29212_ _05847_ _05838_ _05839_ _05845_ VPWR VGND sg13g2_a21oi_1
X_29213_ _05848_ \memory_i.freq_inst.dsmod_cos.data_interp_r[21]\ _05846_ _05847_ VPWR VGND sg13g2_a21oi_1
X_29214_ _05849_ \memory_i.freq_inst.dsmod_cos.data_step_r[22]\ \memory_i.freq_inst.dsmod_cos.data_interp_r[22]\ VPWR VGND sg13g2_xor2_1
X_29215_ _05850_ _05848_ _05849_ VPWR VGND sg13g2_xnor2_1
X_29216_ _05851_ _05657_ _05850_ VPWR VGND sg13g2_nand2_1
X_29217_ _01589_ _05844_ _05851_ _05750_ VPWR VGND sg13g2_a21oi_1
X_29218_ _05852_ \memory_i.freq_inst.cordic.rstn_i\ _05656_ VPWR VGND sg13g2_nand2_1
X_29219_ _05853_ \memory_i.freq_inst.dsmod_cos.data_step_r[22]\ \memory_i.freq_inst.dsmod_cos.data_interp_r[22]\ VPWR VGND sg13g2_nand2_1
X_29220_ _05854_ \memory_i.freq_inst.dsmod_cos.data_step_r[22]\ \memory_i.freq_inst.dsmod_cos.data_interp_r[22]\ VPWR VGND sg13g2_nor2_1
X_29221_ _05855_ _05848_ _05853_ _05854_ VPWR VGND sg13g2_a21oi_1
X_29222_ _05856_ \memory_i.freq_inst.dsmod_cos.data_step_r[23]\ \memory_i.freq_inst.dsmod_cos.data_interp_r[23]\ VPWR VGND sg13g2_xor2_1
X_29223_ _05857_ _05855_ _05856_ VPWR VGND sg13g2_xnor2_1
X_29224_ _05858_ _05724_ \memory_i.freq_inst.dsmod_cos.data_interp_r[23]\ \memory_i.freq_inst.dsmod_cos.data_pre_r[23]\ _15902_ VPWR
+ VGND
+ sg13g2_a22oi_1
X_29225_ _05859_ _05858_ \memory_i.freq_inst.cordic.rstn_i\ VPWR VGND sg13g2_nand2b_1
X_29226_ _01590_ _05852_ _05857_ _05859_ VPWR VGND sg13g2_o21ai_1
X_29227_ _05860_ _05834_ _05841_ VPWR VGND sg13g2_nor2b_1
X_29228_ _05861_ _05849_ _05856_ _05860_ VPWR VGND sg13g2_nand3_1
X_29229_ _05862_ _05800_ _05809_ VPWR VGND sg13g2_nand2b_1
X_29230_ _05863_ _05815_ _05824_ _05861_ _05862_ VPWR
+ VGND
+ sg13g2_nor4_1
X_29231_ _05864_ \memory_i.freq_inst.dsmod_cos.data_step_r[20]\ \memory_i.freq_inst.dsmod_cos.data_interp_r[20]\ VPWR VGND sg13g2_nor2_1
X_29232_ _05865_ \memory_i.freq_inst.dsmod_cos.data_step_r[18]\ \memory_i.freq_inst.dsmod_cos.data_interp_r[18]\ VPWR VGND sg13g2_nor2_1
X_29233_ _05866_ \memory_i.freq_inst.dsmod_cos.data_step_r[16]\ \memory_i.freq_inst.dsmod_cos.data_interp_r[16]\ \memory_i.freq_inst.dsmod_cos.data_interp_r[17]\ VPWR VGND sg13g2_a21o_1
X_29234_ _05867_ \memory_i.freq_inst.dsmod_cos.data_step_r[16]\ \memory_i.freq_inst.dsmod_cos.data_interp_r[17]\ \memory_i.freq_inst.dsmod_cos.data_interp_r[16]\ VPWR VGND sg13g2_and3_1
X_29235_ _05868_ \memory_i.freq_inst.dsmod_cos.data_step_r[18]\ \memory_i.freq_inst.dsmod_cos.data_interp_r[18]\ _05866_ \memory_i.freq_inst.dsmod_cos.data_step_r[17]\ _05867_
+ VPWR
+ VGND sg13g2_a221oi_1
X_29236_ _05869_ _05865_ _05868_ _05829_ VPWR VGND sg13g2_o21ai_1
X_29237_ _05870_ _05829_ _05865_ _05868_ VPWR VGND sg13g2_nor3_1
X_29238_ _05871_ \memory_i.freq_inst.dsmod_cos.data_step_r[20]\ \memory_i.freq_inst.dsmod_cos.data_interp_r[20]\ _05869_ \memory_i.freq_inst.dsmod_cos.data_step_r[19]\ _05870_
+ VPWR
+ VGND sg13g2_a221oi_1
X_29239_ _05872_ _05864_ _05871_ VPWR VGND sg13g2_nor2_1
X_29240_ _05873_ \memory_i.freq_inst.dsmod_cos.data_interp_r[21]\ _05872_ \memory_i.freq_inst.dsmod_cos.data_step_r[21]\ VPWR VGND sg13g2_o21ai_1
X_29241_ _05874_ _05873_ VPWR VGND sg13g2_inv_1
X_29242_ _05875_ \memory_i.freq_inst.dsmod_cos.data_step_r[22]\ \memory_i.freq_inst.dsmod_cos.data_interp_r[22]\ \memory_i.freq_inst.dsmod_cos.data_interp_r[21]\ _05872_ _05874_
+ VPWR
+ VGND sg13g2_a221oi_1
X_29243_ _05876_ _05854_ _05875_ VPWR VGND sg13g2_nor2_1
X_29244_ _05877_ \memory_i.freq_inst.dsmod_cos.data_interp_r[23]\ _05876_ \memory_i.freq_inst.dsmod_cos.data_step_r[23]\ VPWR VGND sg13g2_a21oi_1
X_29245_ _05878_ \memory_i.freq_inst.dsmod_cos.data_interp_r[23]\ _05876_ VPWR VGND sg13g2_nor2_1
X_29246_ _05879_ _05877_ _05878_ VPWR VGND sg13g2_nor2_1
X_29247_ _05880_ _05799_ _05863_ _05879_ VPWR VGND sg13g2_a21oi_1
X_29248_ _05881_ \memory_i.freq_inst.dsmod_cos.data_step_r[24]\ \memory_i.freq_inst.dsmod_cos.data_interp_r[24]\ VPWR VGND sg13g2_xor2_1
X_29249_ _05882_ _05880_ _05881_ VPWR VGND sg13g2_xnor2_1
X_29250_ _05883_ _05741_ _05882_ VPWR VGND sg13g2_nand2_1
X_29251_ _05884_ _05784_ \memory_i.freq_inst.dsmod_cos.data_interp_r[24]\ \memory_i.freq_inst.dsmod_cos.data_pre_r[24]\ _05706_ VPWR
+ VGND
+ sg13g2_a22oi_1
X_29252_ _05885_ _03245_ VPWR VGND sg13g2_buf_1
X_29253_ _01591_ _05883_ _05884_ _05885_ VPWR VGND sg13g2_a21oi_1
X_29254_ _05886_ \memory_i.freq_inst.dsmod_cos.data_step_r[25]\ \memory_i.freq_inst.dsmod_cos.data_interp_r[25]\ VPWR VGND sg13g2_nand2_1
X_29255_ _05887_ \memory_i.freq_inst.dsmod_cos.data_step_r[25]\ \memory_i.freq_inst.dsmod_cos.data_interp_r[25]\ VPWR VGND sg13g2_or2_1
X_29256_ _05888_ _05886_ _05887_ VPWR VGND sg13g2_nand2_1
X_29257_ _05889_ \memory_i.freq_inst.dsmod_cos.data_step_r[24]\ _05880_ VPWR VGND sg13g2_nand2b_1
X_29258_ _05890_ _05880_ \memory_i.freq_inst.dsmod_cos.data_step_r[24]\ VPWR VGND sg13g2_nor2b_1
X_29259_ _05891_ \memory_i.freq_inst.dsmod_cos.data_interp_r[24]\ _05889_ _05890_ VPWR VGND sg13g2_a21oi_1
X_29260_ _05892_ _05888_ _05891_ VPWR VGND sg13g2_xnor2_1
X_29261_ _05893_ _05724_ \memory_i.freq_inst.dsmod_cos.data_interp_r[25]\ \memory_i.freq_inst.dsmod_cos.data_pre_r[25]\ _15965_ VPWR
+ VGND
+ sg13g2_a22oi_1
X_29262_ _05894_ _05709_ _05892_ _05893_ VPWR VGND sg13g2_o21ai_1
X_29263_ _01592_ \memory_i.freq_inst.cordic.rstn_i\ _05894_ VPWR VGND sg13g2_and2_1
X_29264_ _05895_ \memory_i.freq_inst.dsmod_cos.data_step_r[24]\ \memory_i.freq_inst.dsmod_cos.data_interp_r[24]\ _05799_ _05863_ _05879_
+ VPWR
+ VGND sg13g2_a221oi_1
X_29265_ _05896_ \memory_i.freq_inst.dsmod_cos.data_step_r[24]\ \memory_i.freq_inst.dsmod_cos.data_interp_r[24]\ _05887_ VPWR VGND sg13g2_o21ai_1
X_29266_ _05897_ _05895_ _05896_ _05886_ VPWR VGND sg13g2_o21ai_1
X_29267_ _05898_ _05897_ VPWR VGND sg13g2_buf_1
X_29268_ _05899_ \memory_i.freq_inst.dsmod_cos.data_step_r[26]\ \memory_i.freq_inst.dsmod_cos.data_interp_r[26]\ VPWR VGND sg13g2_xor2_1
X_29269_ _05900_ _05898_ _05899_ VPWR VGND sg13g2_xnor2_1
X_29270_ _05901_ _05724_ \memory_i.freq_inst.dsmod_cos.data_interp_r[26]\ \memory_i.freq_inst.dsmod_cos.data_pre_r[26]\ _15965_ VPWR
+ VGND
+ sg13g2_a22oi_1
X_29271_ _05902_ _05709_ _05900_ _05901_ VPWR VGND sg13g2_o21ai_1
X_29272_ _01593_ \memory_i.freq_inst.cordic.rstn_i\ _05902_ VPWR VGND sg13g2_and2_1
X_29273_ _05903_ \memory_i.freq_inst.dsmod_cos.data_interp_r[26]\ _05898_ \memory_i.freq_inst.dsmod_cos.data_step_r[26]\ VPWR VGND sg13g2_a21o_1
X_29274_ _05904_ \memory_i.freq_inst.dsmod_cos.data_interp_r[26]\ _05898_ _05903_ VPWR VGND sg13g2_o21ai_1
X_29275_ _05905_ \memory_i.freq_inst.dsmod_cos.data_step_r[27]\ \memory_i.freq_inst.dsmod_cos.data_interp_r[27]\ VPWR VGND sg13g2_xor2_1
X_29276_ _05906_ _05904_ _05905_ VPWR VGND sg13g2_xnor2_1
X_29277_ _05907_ _05741_ _05906_ VPWR VGND sg13g2_nand2_1
X_29278_ _05908_ _05784_ \memory_i.freq_inst.dsmod_cos.data_interp_r[27]\ \memory_i.freq_inst.dsmod_cos.data_pre_r[27]\ _05706_ VPWR
+ VGND
+ sg13g2_a22oi_1
X_29279_ _01594_ _05907_ _05908_ _05885_ VPWR VGND sg13g2_a21oi_1
X_29280_ _05909_ \memory_i.freq_inst.dsmod_cos.data_step_r[28]\ \memory_i.freq_inst.dsmod_cos.data_interp_r[28]\ VPWR VGND sg13g2_and2_1
X_29281_ _05910_ _05909_ VPWR VGND sg13g2_buf_1
X_29282_ _05911_ \memory_i.freq_inst.dsmod_cos.data_step_r[28]\ \memory_i.freq_inst.dsmod_cos.data_interp_r[28]\ VPWR VGND sg13g2_or2_1
X_29283_ _05912_ _05911_ VPWR VGND sg13g2_buf_1
X_29284_ _05913_ _05910_ _05912_ VPWR VGND sg13g2_nand2b_1
X_29285_ _05914_ \memory_i.freq_inst.dsmod_cos.data_step_r[27]\ \memory_i.freq_inst.dsmod_cos.data_interp_r[27]\ VPWR VGND sg13g2_nor2_1
X_29286_ _05915_ \memory_i.freq_inst.dsmod_cos.data_step_r[27]\ \memory_i.freq_inst.dsmod_cos.data_interp_r[27]\ VPWR VGND sg13g2_nand2_1
X_29287_ _05916_ _05904_ _05914_ _05915_ VPWR VGND sg13g2_o21ai_1
X_29288_ _05917_ _05913_ _05916_ VPWR VGND sg13g2_xnor2_1
X_29289_ _05918_ _05741_ _05917_ VPWR VGND sg13g2_nand2_1
X_29290_ _05919_ _05784_ \memory_i.freq_inst.dsmod_cos.data_interp_r[28]\ \memory_i.freq_inst.dsmod_cos.data_pre_r[28]\ _05706_ VPWR
+ VGND
+ sg13g2_a22oi_1
X_29291_ _01595_ _05918_ _05919_ _05885_ VPWR VGND sg13g2_a21oi_1
X_29292_ _05920_ \memory_i.freq_inst.dsmod_cos.data_interp_r[27]\ \memory_i.freq_inst.dsmod_cos.data_interp_r[26]\ _05898_ _05912_ VPWR
+ VGND
+ sg13g2_nand4_1
X_29293_ _05921_ \memory_i.freq_inst.dsmod_cos.data_step_r[27]\ \memory_i.freq_inst.dsmod_cos.data_interp_r[26]\ _05898_ _05912_ VPWR
+ VGND
+ sg13g2_nand4_1
X_29294_ _05922_ \memory_i.freq_inst.dsmod_cos.data_step_r[26]\ \memory_i.freq_inst.dsmod_cos.data_interp_r[27]\ _05912_ VPWR VGND sg13g2_and3_1
X_29295_ _05923_ \memory_i.freq_inst.dsmod_cos.data_step_r[27]\ \memory_i.freq_inst.dsmod_cos.data_step_r[26]\ _05912_ VPWR VGND sg13g2_and3_1
X_29296_ _05924_ _05922_ _05923_ _05898_ VPWR VGND sg13g2_o21ai_1
X_29297_ _05925_ _05922_ _05923_ \memory_i.freq_inst.dsmod_cos.data_interp_r[26]\ VPWR VGND sg13g2_o21ai_1
X_29298_ _05926_ _05915_ _05912_ VPWR VGND sg13g2_nand2b_1
X_29299_ _05927_ _05925_ _05926_ VPWR VGND sg13g2_and2_1
X_29300_ _05928_ _05920_ _05921_ _05924_ _05927_ VPWR
+ VGND
+ sg13g2_nand4_1
X_29301_ _05929_ _05928_ VPWR VGND sg13g2_buf_1
X_29302_ _05930_ _05910_ _05929_ VPWR VGND sg13g2_nor2_1
X_29303_ _05931_ \memory_i.freq_inst.dsmod_cos.data_step_r[29]\ \memory_i.freq_inst.dsmod_cos.data_interp_r[29]\ VPWR VGND sg13g2_xor2_1
X_29304_ _05932_ _05930_ _05931_ VPWR VGND sg13g2_xnor2_1
X_29305_ _05933_ _05741_ _05932_ VPWR VGND sg13g2_nand2_1
X_29306_ _05934_ _05784_ \memory_i.freq_inst.dsmod_cos.data_interp_r[29]\ \memory_i.freq_inst.dsmod_cos.data_pre_r[29]\ _05706_ VPWR
+ VGND
+ sg13g2_a22oi_1
X_29307_ _01596_ _05933_ _05934_ _05885_ VPWR VGND sg13g2_a21oi_1
X_29308_ _05935_ \memory_i.freq_inst.dsmod_cos.data_interp_r[29]\ VPWR VGND sg13g2_inv_1
X_29309_ _05936_ _05910_ _05929_ \memory_i.freq_inst.dsmod_cos.data_interp_r[29]\ VPWR VGND sg13g2_o21ai_1
X_29310_ _05937_ \memory_i.freq_inst.dsmod_cos.data_step_r[29]\ _05936_ VPWR VGND sg13g2_nor2b_1
X_29311_ _05938_ _05935_ _05930_ _05937_ VPWR VGND sg13g2_a21oi_1
X_29312_ _05939_ \memory_i.freq_inst.dsmod_cos.data_step_r[30]\ \memory_i.freq_inst.dsmod_cos.data_interp_r[30]\ VPWR VGND sg13g2_xnor2_1
X_29313_ _05940_ _05938_ _05939_ VPWR VGND sg13g2_xnor2_1
X_29314_ _05941_ _05741_ _05940_ VPWR VGND sg13g2_nand2_1
X_29315_ _05942_ _05784_ \memory_i.freq_inst.dsmod_cos.data_interp_r[30]\ \memory_i.freq_inst.dsmod_cos.data_pre_r[30]\ _05706_ VPWR
+ VGND
+ sg13g2_a22oi_1
X_29316_ _01597_ _05941_ _05942_ _05885_ VPWR VGND sg13g2_a21oi_1
X_29317_ _05943_ _05738_ \memory_i.freq_inst.dsmod_cos.data_interp_r[31]\ \memory_i.freq_inst.dsmod_cos.data_pre_r[31]\ _05739_ VPWR
+ VGND
+ sg13g2_a22oi_1
X_29318_ _05944_ \memory_i.freq_inst.dsmod_cos.data_step_r[31]\ \memory_i.freq_inst.dsmod_cos.data_interp_r[31]\ VPWR VGND sg13g2_xnor2_1
X_29319_ _05945_ \memory_i.freq_inst.dsmod_cos.data_step_r[30]\ \memory_i.freq_inst.dsmod_cos.data_interp_r[30]\ VPWR VGND sg13g2_nor2_1
X_29320_ _05946_ \memory_i.freq_inst.dsmod_cos.data_interp_r[30]\ \memory_i.freq_inst.dsmod_cos.data_interp_r[29]\ VPWR VGND sg13g2_or2_1
X_29321_ _05947_ \memory_i.freq_inst.dsmod_cos.data_step_r[30]\ \memory_i.freq_inst.dsmod_cos.data_interp_r[29]\ VPWR VGND sg13g2_or2_1
X_29322_ _05948_ \memory_i.freq_inst.dsmod_cos.data_step_r[28]\ \memory_i.freq_inst.dsmod_cos.data_interp_r[28]\ _05946_ _05947_ _05929_
+ VPWR
+ VGND sg13g2_a221oi_1
X_29323_ _05949_ \memory_i.freq_inst.dsmod_cos.data_step_r[29]\ \memory_i.freq_inst.dsmod_cos.data_interp_r[30]\ VPWR VGND sg13g2_or2_1
X_29324_ _05950_ \memory_i.freq_inst.dsmod_cos.data_step_r[30]\ \memory_i.freq_inst.dsmod_cos.data_step_r[29]\ VPWR VGND sg13g2_or2_1
X_29325_ _05951_ \memory_i.freq_inst.dsmod_cos.data_step_r[28]\ \memory_i.freq_inst.dsmod_cos.data_interp_r[28]\ _05949_ _05950_ _05929_
+ VPWR
+ VGND sg13g2_a221oi_1
X_29326_ _05952_ _05949_ _05950_ \memory_i.freq_inst.dsmod_cos.data_interp_r[29]\ VPWR VGND sg13g2_a21oi_1
X_29327_ _05953_ _05945_ _05948_ _05951_ _05952_ VPWR
+ VGND
+ sg13g2_nor4_1
X_29328_ _05954_ _05944_ _05953_ VPWR VGND sg13g2_xnor2_1
X_29329_ _05955_ _05657_ _05954_ VPWR VGND sg13g2_nand2_1
X_29330_ _01598_ _05943_ _05955_ _05885_ VPWR VGND sg13g2_a21oi_1
X_29331_ _05956_ \memory_i.freq_inst.dsmod_cos.data_step_r[31]\ \memory_i.freq_inst.dsmod_cos.data_interp_r[31]\ VPWR VGND sg13g2_or2_1
X_29332_ _05957_ \memory_i.freq_inst.dsmod_cos.data_step_r[31]\ \memory_i.freq_inst.dsmod_cos.data_interp_r[31]\ VPWR VGND sg13g2_and2_1
X_29333_ _05958_ _05953_ _05956_ _05957_ VPWR VGND sg13g2_a21oi_1
X_29334_ _05959_ \memory_i.freq_inst.dsmod_cos.data_step_r[32]\ VPWR VGND sg13g2_inv_1
X_29335_ _05960_ _05959_ \memory_i.freq_inst.dsmod_cos.data_interp_r[32]\ VPWR VGND sg13g2_nand2_1
X_29336_ _05961_ \memory_i.freq_inst.dsmod_cos.data_interp_r[32]\ \memory_i.freq_inst.dsmod_cos.data_step_r[32]\ VPWR VGND sg13g2_nand2b_1
X_29337_ _05962_ _05960_ _05961_ VPWR VGND sg13g2_and2_1
X_29338_ _05963_ _05958_ _05962_ VPWR VGND sg13g2_xnor2_1
X_29339_ _05964_ _05724_ \memory_i.freq_inst.dsmod_cos.data_interp_r[32]\ \memory_i.freq_inst.dsmod_cos.data_pre_r[32]\ _15965_ VPWR
+ VGND
+ sg13g2_a22oi_1
X_29340_ _05965_ _05709_ _05963_ _05964_ VPWR VGND sg13g2_o21ai_1
X_29341_ _01599_ \memory_i.freq_inst.cordic.rstn_i\ _05965_ VPWR VGND sg13g2_and2_1
X_29342_ _05966_ _05738_ \memory_i.freq_inst.dsmod_cos.data_interp_r[33]\ \memory_i.freq_inst.dsmod_cos.data_pre_r[33]\ _05739_ VPWR
+ VGND
+ sg13g2_a22oi_1
X_29343_ _05967_ _05960_ _05961_ _05958_ VPWR VGND sg13g2_mux2_1
X_29344_ _05968_ \memory_i.freq_inst.dsmod_cos.data_interp_r[33]\ _05967_ VPWR VGND sg13g2_xnor2_1
X_29345_ _05969_ _05657_ _05968_ VPWR VGND sg13g2_nand2_1
X_29346_ _01600_ _05966_ _05969_ _05885_ VPWR VGND sg13g2_a21oi_1
X_29347_ _05970_ _05738_ \memory_i.freq_inst.dsmod_cos.data_interp_r[34]\ \memory_i.freq_inst.dsmod_cos.data_pre_r[34]\ _05739_ VPWR
+ VGND
+ sg13g2_a22oi_1
X_29348_ _05971_ \memory_i.freq_inst.dsmod_cos.data_interp_r[34]\ VPWR VGND sg13g2_inv_1
X_29349_ _05972_ \memory_i.freq_inst.dsmod_cos.data_interp_r[33]\ VPWR VGND sg13g2_inv_1
X_29350_ _05973_ \memory_i.freq_inst.dsmod_cos.data_step_r[32]\ _05972_ VPWR VGND sg13g2_nor2_1
X_29351_ _05974_ \memory_i.freq_inst.dsmod_cos.data_interp_r[32]\ _05973_ VPWR VGND sg13g2_nand2_1
X_29352_ _05975_ _05959_ \memory_i.freq_inst.dsmod_cos.data_interp_r[33]\ \memory_i.freq_inst.dsmod_cos.data_interp_r[32]\ VPWR VGND sg13g2_nor3_1
X_29353_ _05976_ _05958_ _05975_ VPWR VGND sg13g2_nand2_1
X_29354_ _05977_ _05958_ _05974_ _05976_ VPWR VGND sg13g2_o21ai_1
X_29355_ _05978_ _05971_ _05977_ VPWR VGND sg13g2_xnor2_1
X_29356_ _05979_ _05657_ _05978_ VPWR VGND sg13g2_nand2_1
X_29357_ _01601_ _05970_ _05979_ _05885_ VPWR VGND sg13g2_a21oi_1
X_29358_ _05980_ \memory_i.freq_inst.dsmod_cos.data_interp_r[34]\ \memory_i.freq_inst.dsmod_cos.data_interp_r[32]\ _05956_ _05973_ VPWR
+ VGND
+ sg13g2_and4_1
X_29359_ _05981_ \memory_i.freq_inst.dsmod_cos.data_interp_r[34]\ \memory_i.freq_inst.dsmod_cos.data_interp_r[32]\ _05957_ _05973_ VPWR
+ VGND
+ sg13g2_and4_1
X_29360_ _05982_ _05953_ _05980_ _05981_ VPWR VGND sg13g2_a21oi_1
X_29361_ _05983_ \memory_i.freq_inst.dsmod_cos.data_interp_r[34]\ _05976_ _05982_ VPWR VGND sg13g2_o21ai_1
X_29362_ _05984_ _05709_ _05983_ \memory_i.freq_inst.dsmod_cos.i_ena_mod\ VPWR VGND sg13g2_o21ai_1
X_29363_ _05985_ \memory_i.freq_inst.dsmod_cos.data_interp_r[35]\ _05984_ VPWR VGND sg13g2_nand2_1
X_29364_ _05986_ \memory_i.freq_inst.dsmod_cos.data_interp_r[35]\ _05709_ VPWR VGND sg13g2_nor2_1
X_29365_ _05987_ \memory_i.freq_inst.dsmod_cos.data_pre_r[35]\ _05706_ _05983_ _05986_ VPWR
+ VGND
+ sg13g2_a22oi_1
X_29366_ _01602_ _05985_ _05987_ _05885_ VPWR VGND sg13g2_a21oi_1
X_29367_ _05988_ \memory_i.freq_inst.dsmod_cos.data_interp_r[35]\ VPWR VGND sg13g2_inv_1
X_29368_ _05989_ _05988_ _05971_ _05958_ _05975_ VPWR
+ VGND
+ sg13g2_nand4_1
X_29369_ _05990_ _05988_ _05982_ _05989_ VPWR VGND sg13g2_o21ai_1
X_29370_ _05991_ \memory_i.freq_inst.dsmod_cos.data_interp_r[36]\ _05709_ VPWR VGND sg13g2_nor2_1
X_29371_ _05992_ \memory_i.freq_inst.dsmod_cos.data_pre_r[36]\ _05706_ _05990_ _05991_ VPWR
+ VGND
+ sg13g2_a22oi_1
X_29372_ _05993_ _05708_ _05990_ \memory_i.freq_inst.dsmod_cos.i_ena_mod\ VPWR VGND sg13g2_o21ai_1
X_29373_ _05994_ \memory_i.freq_inst.dsmod_cos.data_interp_r[36]\ _05993_ VPWR VGND sg13g2_nand2_1
X_29374_ _01603_ _05992_ _05994_ _05885_ VPWR VGND sg13g2_a21oi_1
X_29375_ _05995_ \memory_i.freq_inst.dsmod_cos.data_interp_r[36]\ \memory_i.freq_inst.dsmod_cos.data_interp_r[35]\ VPWR VGND sg13g2_nand2_1
X_29376_ _05996_ _05982_ _05995_ VPWR VGND sg13g2_or2_1
X_29377_ _05997_ \memory_i.freq_inst.dsmod_cos.data_interp_r[36]\ _05989_ _05996_ VPWR VGND sg13g2_o21ai_1
X_29378_ _05998_ \memory_i.freq_inst.dsmod_cos.data_interp_r[37]\ _05708_ VPWR VGND sg13g2_nor2_1
X_29379_ _05999_ _05708_ _05997_ \memory_i.freq_inst.dsmod_cos.i_ena_mod\ VPWR VGND sg13g2_o21ai_1
X_29380_ _06000_ \memory_i.freq_inst.dsmod_cos.data_pre_r[37]\ _15965_ VPWR VGND sg13g2_and2_1
X_29381_ _06001_ _05997_ _05998_ _05999_ \memory_i.freq_inst.dsmod_cos.data_interp_r[37]\ _06000_
+ VPWR
+ VGND sg13g2_a221oi_1
X_29382_ _01604_ _05676_ _06001_ VPWR VGND sg13g2_nor2_1
X_29383_ _06002_ _15907_ VPWR VGND sg13g2_buf_1
X_29384_ _06003_ \memory_i.freq_inst.dsmod_cos.data_step_r[0]\ _06002_ VPWR VGND sg13g2_nand2_1
X_29385_ _06004_ \memory_i.freq_inst.cosine[0]\ \memory_i.freq_inst.dsmod_cos.data_pre_r[8]\ VPWR VGND sg13g2_xor2_1
X_29386_ _06005_ \memory_i.freq_inst.dsmod_cos.i_osr[1]\ \memory_i.freq_inst.dsmod_cos.i_osr[0]\ _05706_ _06004_ VPWR
+ VGND
+ sg13g2_nand4_1
X_29387_ _06006_ _12944_ VPWR VGND sg13g2_buf_1
X_29388_ _06007_ _06006_ VPWR VGND sg13g2_buf_1
X_29389_ _01605_ _06003_ _06005_ _06007_ VPWR VGND sg13g2_a21oi_1
X_29390_ _06008_ \memory_i.freq_inst.dsmod_cos.data_step_r[1]\ _06002_ VPWR VGND sg13g2_nand2_1
X_29391_ _06009_ \memory_i.freq_inst.cosine[0]\ \memory_i.freq_inst.dsmod_cos.data_pre_r[8]\ VPWR VGND sg13g2_nor2b_1
X_29392_ _06010_ _06009_ VPWR VGND sg13g2_buf_2
X_29393_ _06011_ \memory_i.freq_inst.cosine[1]\ \memory_i.freq_inst.dsmod_cos.data_pre_r[9]\ VPWR VGND sg13g2_xor2_1
X_29394_ _06012_ \memory_i.freq_inst.dsmod_cos.i_osr[0]\ _06011_ VPWR VGND sg13g2_nand2_1
X_29395_ _06013_ \memory_i.freq_inst.dsmod_cos.i_osr[0]\ \memory_i.freq_inst.dsmod_cos.data_pre_r[8]\ VPWR VGND sg13g2_nor2_1
X_29396_ _06014_ \memory_i.freq_inst.cosine[0]\ _06013_ _06012_ _06010_ VPWR
+ VGND
+ sg13g2_a22oi_1
X_29397_ _06015_ _06010_ _06012_ _06014_ VPWR VGND sg13g2_o21ai_1
X_29398_ _06016_ \memory_i.freq_inst.dsmod_cos.i_osr[1]\ _05752_ _06015_ VPWR VGND sg13g2_nand3_1
X_29399_ _01606_ _06008_ _06016_ _06007_ VPWR VGND sg13g2_a21oi_1
X_29400_ _06017_ \memory_i.freq_inst.dsmod_cos.data_step_r[2]\ _15966_ VPWR VGND sg13g2_nor2_1
X_29401_ _06018_ \memory_i.freq_inst.cosine[1]\ VPWR VGND sg13g2_inv_1
X_29402_ _06019_ \memory_i.freq_inst.dsmod_cos.i_osr[0]\ VPWR VGND sg13g2_inv_1
X_29403_ _06020_ _06019_ VPWR VGND sg13g2_buf_1
X_29404_ _06021_ _06020_ VPWR VGND sg13g2_buf_1
X_29405_ _06022_ _06021_ VPWR VGND sg13g2_buf_1
X_29406_ _06023_ \memory_i.freq_inst.dsmod_cos.data_pre_r[9]\ _06010_ VPWR VGND sg13g2_xnor2_1
X_29407_ _06024_ \memory_i.freq_inst.dsmod_cos.data_pre_r[9]\ _06010_ VPWR VGND sg13g2_nand2_1
X_29408_ _06025_ \memory_i.freq_inst.cosine[2]\ \memory_i.freq_inst.dsmod_cos.data_pre_r[10]\ VPWR VGND sg13g2_xor2_1
X_29409_ _06026_ \memory_i.freq_inst.dsmod_cos.i_osr[0]\ _06025_ VPWR VGND sg13g2_and2_1
X_29410_ _06027_ _06025_ _06024_ VPWR VGND sg13g2_nor2_1
X_29411_ _06028_ _06022_ _06023_ _06024_ _06026_ _06027_
+ VPWR
+ VGND sg13g2_a221oi_1
X_29412_ _06029_ \memory_i.freq_inst.dsmod_cos.data_pre_r[9]\ _06010_ VPWR VGND sg13g2_nor2_1
X_29413_ _06030_ _06020_ VPWR VGND sg13g2_buf_1
X_29414_ _06031_ _06030_ _06025_ _06029_ VPWR VGND sg13g2_or3_1
X_29415_ _06032_ \memory_i.freq_inst.dsmod_cos.i_osr[0]\ _06023_ _06031_ VPWR VGND sg13g2_o21ai_1
X_29416_ _06033_ _06026_ _06029_ _06032_ _06018_ VPWR
+ VGND
+ sg13g2_a22oi_1
X_29417_ _06034_ _06018_ _06028_ _06033_ VPWR VGND sg13g2_o21ai_1
X_29418_ _06035_ _06022_ VPWR VGND sg13g2_buf_1
X_29419_ _06036_ \memory_i.freq_inst.dsmod_cos.i_osr[1]\ _06035_ VPWR VGND sg13g2_nor2_1
X_29420_ _06037_ _15906_ VPWR VGND sg13g2_buf_1
X_29421_ _06038_ \memory_i.freq_inst.dsmod_cos.i_osr[1]\ _06034_ _06036_ _06004_ _06037_
+ VPWR
+ VGND sg13g2_a221oi_1
X_29422_ _01607_ _03810_ _06017_ _06038_ VPWR VGND sg13g2_nor3_1
X_29423_ _06039_ \memory_i.freq_inst.dsmod_cos.data_step_r[3]\ _06002_ VPWR VGND sg13g2_nand2_1
X_29424_ _06040_ \memory_i.freq_inst.dsmod_cos.data_pre_r[9]\ _06010_ _06018_ VPWR VGND sg13g2_o21ai_1
X_29425_ _06041_ _06024_ _06040_ VPWR VGND sg13g2_nand2_1
X_29426_ _06042_ \memory_i.freq_inst.dsmod_cos.data_pre_r[10]\ _06041_ VPWR VGND sg13g2_nor2_1
X_29427_ _06043_ _06042_ VPWR VGND sg13g2_inv_1
X_29428_ _06044_ \memory_i.freq_inst.dsmod_cos.data_pre_r[10]\ _06041_ VPWR VGND sg13g2_nand2_1
X_29429_ _06045_ _06043_ _06044_ \memory_i.freq_inst.dsmod_cos.i_osr[0]\ VPWR VGND sg13g2_a21oi_1
X_29430_ _06046_ \memory_i.freq_inst.cosine[3]\ \memory_i.freq_inst.dsmod_cos.data_pre_r[11]\ VPWR VGND sg13g2_xor2_1
X_29431_ _06047_ _06042_ _06046_ \memory_i.freq_inst.dsmod_cos.i_osr[0]\ VPWR VGND sg13g2_o21ai_1
X_29432_ _06048_ _06045_ _06047_ VPWR VGND sg13g2_nand2b_1
X_29433_ _06049_ \memory_i.freq_inst.dsmod_cos.i_osr[0]\ _06042_ _06046_ VPWR VGND sg13g2_nand3_1
X_29434_ _06050_ \memory_i.freq_inst.cosine[2]\ _06048_ _06049_ VPWR VGND sg13g2_o21ai_1
X_29435_ _06051_ \memory_i.freq_inst.dsmod_cos.i_osr[0]\ _06046_ _06044_ VPWR VGND sg13g2_nand3_1
X_29436_ _06052_ _06046_ _06044_ _06051_ VPWR VGND sg13g2_o21ai_1
X_29437_ _06053_ _06045_ _06052_ \memory_i.freq_inst.cosine[2]\ VPWR VGND sg13g2_o21ai_1
X_29438_ _06054_ _06050_ _06053_ VPWR VGND sg13g2_nor2b_1
X_29439_ _06055_ \memory_i.freq_inst.dsmod_cos.i_osr[1]\ _06015_ VPWR VGND sg13g2_nor2_1
X_29440_ _06056_ \memory_i.freq_inst.dsmod_cos.i_osr[1]\ _06054_ _06055_ VPWR VGND sg13g2_a21oi_1
X_29441_ _06057_ _05646_ _06056_ VPWR VGND sg13g2_nand2_1
X_29442_ _01608_ _06039_ _06057_ _06007_ VPWR VGND sg13g2_a21oi_1
X_29443_ _06058_ \memory_i.freq_inst.dsmod_cos.data_pre_r[10]\ VPWR VGND sg13g2_inv_1
X_29444_ _06059_ \memory_i.freq_inst.cosine[2]\ _06058_ VPWR VGND sg13g2_nor2_1
X_29445_ _06060_ \memory_i.freq_inst.cosine[2]\ _06058_ _06024_ _06040_ VPWR
+ VGND
+ sg13g2_a22oi_1
X_29446_ _06061_ \memory_i.freq_inst.dsmod_cos.data_pre_r[11]\ _06059_ _06060_ VPWR VGND sg13g2_nor3_1
X_29447_ _06062_ _06059_ _06060_ \memory_i.freq_inst.dsmod_cos.data_pre_r[11]\ VPWR VGND sg13g2_o21ai_1
X_29448_ _06063_ _06061_ _06062_ VPWR VGND sg13g2_nor2b_1
X_29449_ _06064_ \memory_i.freq_inst.cosine[4]\ \memory_i.freq_inst.dsmod_cos.data_pre_r[12]\ VPWR VGND sg13g2_xor2_1
X_29450_ _06065_ \memory_i.freq_inst.dsmod_cos.i_osr[0]\ _06064_ VPWR VGND sg13g2_nand2_1
X_29451_ _06066_ _06064_ _06065_ _06062_ VPWR VGND sg13g2_mux2_1
X_29452_ _06067_ \memory_i.freq_inst.dsmod_cos.i_osr[0]\ _06063_ _06066_ VPWR VGND sg13g2_o21ai_1
X_29453_ _06068_ _06064_ _06061_ \memory_i.freq_inst.dsmod_cos.i_osr[0]\ VPWR VGND sg13g2_o21ai_1
X_29454_ _06069_ \memory_i.freq_inst.dsmod_cos.i_osr[0]\ _06063_ _06068_ VPWR VGND sg13g2_o21ai_1
X_29455_ _06070_ _06065_ _06061_ VPWR VGND sg13g2_nand2b_1
X_29456_ _06071_ \memory_i.freq_inst.cosine[3]\ _06069_ _06070_ VPWR VGND sg13g2_o21ai_1
X_29457_ _06072_ \memory_i.freq_inst.cosine[3]\ _06067_ _06071_ VPWR VGND sg13g2_a21o_1
X_29458_ _06073_ _06034_ _06072_ \memory_i.freq_inst.dsmod_cos.i_osr[1]\ VPWR VGND sg13g2_mux2_1
X_29459_ _06074_ \memory_i.freq_inst.dsmod_cos.data_step_r[4]\ _06073_ _15902_ VPWR VGND sg13g2_mux2_1
X_29460_ _01609_ \memory_i.freq_inst.cordic.rstn_i\ _06074_ VPWR VGND sg13g2_and2_1
X_29461_ _06075_ \memory_i.freq_inst.cosine[3]\ _06061_ _06062_ VPWR VGND sg13g2_o21ai_1
X_29462_ _06076_ _06075_ VPWR VGND sg13g2_buf_1
X_29463_ _06077_ \memory_i.freq_inst.dsmod_cos.data_pre_r[12]\ _06076_ VPWR VGND sg13g2_nor2_1
X_29464_ _06078_ \memory_i.freq_inst.cosine[5]\ \memory_i.freq_inst.dsmod_cos.data_pre_r[13]\ VPWR VGND sg13g2_xor2_1
X_29465_ _06079_ \memory_i.freq_inst.dsmod_cos.i_osr[0]\ _06077_ _06078_ VPWR VGND sg13g2_nand3_1
X_29466_ _06080_ \memory_i.freq_inst.dsmod_cos.data_pre_r[12]\ _06076_ VPWR VGND sg13g2_nand2_1
X_29467_ _06081_ _06077_ _06080_ VPWR VGND sg13g2_nor2b_1
X_29468_ _06082_ \memory_i.freq_inst.dsmod_cos.i_osr[0]\ _06081_ VPWR VGND sg13g2_nor2_1
X_29469_ _06083_ \memory_i.freq_inst.dsmod_cos.i_osr[0]\ _06078_ _06080_ VPWR VGND sg13g2_nand3_1
X_29470_ _06084_ _06078_ _06080_ _06083_ VPWR VGND sg13g2_o21ai_1
X_29471_ _06085_ _06082_ _06084_ \memory_i.freq_inst.cosine[4]\ VPWR VGND sg13g2_o21ai_1
X_29472_ _06086_ _06020_ VPWR VGND sg13g2_buf_1
X_29473_ _06087_ _06086_ _06078_ VPWR VGND sg13g2_nor2_1
X_29474_ _06088_ _06022_ _06080_ _06087_ VPWR VGND sg13g2_a21oi_1
X_29475_ _06089_ \memory_i.freq_inst.cosine[4]\ _06077_ _06088_ VPWR VGND sg13g2_or3_1
X_29476_ _06090_ _06079_ _06085_ _06089_ VPWR VGND sg13g2_nand3_1
X_29477_ _06091_ \memory_i.freq_inst.dsmod_cos.i_osr[1]\ _06054_ VPWR VGND sg13g2_nor2_1
X_29478_ _06092_ \memory_i.freq_inst.dsmod_cos.i_osr[1]\ _06090_ _06091_ VPWR VGND sg13g2_a21oi_1
X_29479_ _06093_ _06037_ _06092_ VPWR VGND sg13g2_nor2_1
X_29480_ _06094_ \memory_i.freq_inst.dsmod_cos.data_step_r[5]\ _15970_ _06093_ VPWR VGND sg13g2_a21oi_1
X_29481_ _01610_ _05676_ _06094_ VPWR VGND sg13g2_nor2_1
X_29482_ _06095_ \memory_i.freq_inst.dsmod_cos.data_step_r[6]\ _06002_ VPWR VGND sg13g2_nand2_1
X_29483_ _06096_ \memory_i.freq_inst.dsmod_cos.data_pre_r[14]\ \memory_i.freq_inst.cosine[6]\ VPWR VGND sg13g2_nor2b_1
X_29484_ _06097_ \memory_i.freq_inst.dsmod_cos.data_pre_r[14]\ VPWR VGND sg13g2_inv_1
X_29485_ _06098_ \memory_i.freq_inst.cosine[6]\ _06097_ VPWR VGND sg13g2_nor2_1
X_29486_ _06099_ _06096_ _06098_ VPWR VGND sg13g2_nor2_1
X_29487_ _06100_ _06030_ _06099_ VPWR VGND sg13g2_nor2_1
X_29488_ _06101_ \memory_i.freq_inst.dsmod_cos.data_pre_r[12]\ \memory_i.freq_inst.cosine[4]\ VPWR VGND sg13g2_nand2b_1
X_29489_ _06102_ \memory_i.freq_inst.cosine[4]\ \memory_i.freq_inst.dsmod_cos.data_pre_r[12]\ VPWR VGND sg13g2_nor2b_1
X_29490_ _06103_ _06101_ _06076_ _06102_ VPWR VGND sg13g2_a21oi_1
X_29491_ _06104_ _06103_ \memory_i.freq_inst.dsmod_cos.data_pre_r[13]\ VPWR VGND sg13g2_nand2b_1
X_29492_ _06105_ _06104_ VPWR VGND sg13g2_buf_2
X_29493_ _06106_ _06099_ _06100_ _06105_ VPWR VGND sg13g2_mux2_1
X_29494_ _06107_ \memory_i.freq_inst.dsmod_cos.data_pre_r[13]\ VPWR VGND sg13g2_inv_1
X_29495_ _06108_ _06107_ _06103_ VPWR VGND sg13g2_nand2_1
X_29496_ _06109_ _06105_ _06108_ \memory_i.freq_inst.dsmod_cos.i_osr[0]\ VPWR VGND sg13g2_a21oi_1
X_29497_ _06110_ _06106_ _06109_ \memory_i.freq_inst.cosine[5]\ VPWR VGND sg13g2_o21ai_1
X_29498_ _06111_ _06030_ _06096_ _06098_ VPWR VGND sg13g2_nor3_1
X_29499_ _06112_ _06022_ _06105_ _06111_ VPWR VGND sg13g2_a21oi_1
X_29500_ _06113_ \memory_i.freq_inst.cosine[5]\ _06112_ _06108_ VPWR VGND sg13g2_o21ai_1
X_29501_ _06114_ _06100_ _06108_ _06113_ VPWR VGND sg13g2_o21ai_1
X_29502_ _06115_ _06110_ _06114_ VPWR VGND sg13g2_nand2_1
X_29503_ _06116_ _06072_ _06115_ \memory_i.freq_inst.dsmod_cos.i_osr[1]\ VPWR VGND sg13g2_mux2_1
X_29504_ _06117_ _05646_ _06116_ VPWR VGND sg13g2_nand2_1
X_29505_ _01611_ _06095_ _06117_ _06007_ VPWR VGND sg13g2_a21oi_1
X_29506_ _06118_ \memory_i.freq_inst.dsmod_cos.data_step_r[7]\ _06002_ VPWR VGND sg13g2_nand2_1
X_29507_ _06119_ _06107_ _06103_ \memory_i.freq_inst.cosine[5]\ VPWR VGND sg13g2_a21o_1
X_29508_ _06120_ _06119_ VPWR VGND sg13g2_buf_1
X_29509_ _06121_ _06105_ _06120_ VPWR VGND sg13g2_and2_1
X_29510_ _06122_ _06097_ _06121_ VPWR VGND sg13g2_and2_1
X_29511_ _06123_ _06122_ VPWR VGND sg13g2_buf_1
X_29512_ _06124_ \memory_i.freq_inst.cosine[7]\ \memory_i.freq_inst.dsmod_cos.data_pre_r[15]\ VPWR VGND sg13g2_xor2_1
X_29513_ _06125_ \memory_i.freq_inst.dsmod_cos.i_osr[0]\ _06124_ VPWR VGND sg13g2_nand2_1
X_29514_ _06126_ _06125_ VPWR VGND sg13g2_inv_1
X_29515_ _06127_ _06121_ \memory_i.freq_inst.dsmod_cos.data_pre_r[14]\ VPWR VGND sg13g2_nand2b_1
X_29516_ _06128_ _06127_ VPWR VGND sg13g2_buf_1
X_29517_ _06129_ _06123_ _06128_ VPWR VGND sg13g2_nor2b_1
X_29518_ _06130_ _06124_ _06128_ VPWR VGND sg13g2_nor2_1
X_29519_ _06131_ _06126_ _06128_ _06130_ VPWR VGND sg13g2_a21oi_1
X_29520_ _06132_ \memory_i.freq_inst.dsmod_cos.i_osr[0]\ _06129_ _06131_ VPWR VGND sg13g2_o21ai_1
X_29521_ _06133_ _06021_ _06124_ VPWR VGND sg13g2_nor2_1
X_29522_ _06134_ _06086_ _06128_ _06133_ VPWR VGND sg13g2_a21oi_1
X_29523_ _06135_ \memory_i.freq_inst.cosine[6]\ _06123_ _06134_ VPWR VGND sg13g2_nor3_1
X_29524_ _06136_ _06123_ _06126_ _06132_ \memory_i.freq_inst.cosine[6]\ _06135_
+ VPWR
+ VGND sg13g2_a221oi_1
X_29525_ _06137_ \memory_i.freq_inst.dsmod_cos.i_osr[1]\ _06090_ VPWR VGND sg13g2_nor2_1
X_29526_ _06138_ \memory_i.freq_inst.dsmod_cos.i_osr[1]\ _06136_ _06137_ VPWR VGND sg13g2_a21oi_1
X_29527_ _06139_ _05646_ _06138_ VPWR VGND sg13g2_nand2_1
X_29528_ _01612_ _06118_ _06139_ _06007_ VPWR VGND sg13g2_a21oi_1
X_29529_ _06140_ \memory_i.freq_inst.dsmod_cos.data_step_r[8]\ _06002_ VPWR VGND sg13g2_nand2_1
X_29530_ _06141_ \memory_i.freq_inst.cosine[8]\ \memory_i.freq_inst.dsmod_cos.data_pre_r[16]\ VPWR VGND sg13g2_xor2_1
X_29531_ _06142_ \memory_i.freq_inst.dsmod_cos.i_osr[0]\ _06141_ VPWR VGND sg13g2_nand2_1
X_29532_ _06143_ _06021_ VPWR VGND sg13g2_buf_1
X_29533_ _06144_ _06105_ _06120_ _06096_ VPWR VGND sg13g2_a21oi_1
X_29534_ _06145_ _06098_ _06144_ \memory_i.freq_inst.dsmod_cos.data_pre_r[15]\ VPWR VGND sg13g2_o21ai_1
X_29535_ _06146_ _06145_ VPWR VGND sg13g2_buf_4
X_29536_ _06147_ _06086_ _06146_ VPWR VGND sg13g2_nand2_1
X_29537_ _06148_ _06143_ _06141_ _06147_ VPWR VGND sg13g2_o21ai_1
X_29538_ _06149_ \memory_i.freq_inst.cosine[7]\ _06148_ VPWR VGND sg13g2_nand2b_1
X_29539_ _06150_ \memory_i.freq_inst.dsmod_cos.data_pre_r[15]\ VPWR VGND sg13g2_inv_1
X_29540_ _06151_ \memory_i.freq_inst.cosine[6]\ \memory_i.freq_inst.dsmod_cos.data_pre_r[14]\ VPWR VGND sg13g2_nand2b_1
X_29541_ _06152_ _06105_ _06120_ _06096_ VPWR VGND sg13g2_a21o_1
X_29542_ _06153_ _06150_ _06151_ _06152_ VPWR VGND sg13g2_nand3_1
X_29543_ _06154_ _06142_ _06149_ _06153_ VPWR VGND sg13g2_mux2_1
X_29544_ _06155_ _06153_ _06146_ \memory_i.freq_inst.dsmod_cos.i_osr[0]\ VPWR VGND sg13g2_a21oi_1
X_29545_ _06156_ _06142_ _06146_ VPWR VGND sg13g2_nand2b_1
X_29546_ _06157_ _06141_ _06146_ _06156_ VPWR VGND sg13g2_o21ai_1
X_29547_ _06158_ _06155_ _06157_ \memory_i.freq_inst.cosine[7]\ VPWR VGND sg13g2_o21ai_1
X_29548_ _06159_ _06154_ _06158_ VPWR VGND sg13g2_nand2_1
X_29549_ _06160_ _06115_ _06159_ \memory_i.freq_inst.dsmod_cos.i_osr[1]\ VPWR VGND sg13g2_mux2_1
X_29550_ _06161_ _05646_ _06160_ VPWR VGND sg13g2_nand2_1
X_29551_ _01613_ _06140_ _06161_ _06007_ VPWR VGND sg13g2_a21oi_1
X_29552_ _06162_ \memory_i.freq_inst.cosine[9]\ \memory_i.freq_inst.dsmod_cos.data_pre_r[17]\ VPWR VGND sg13g2_xor2_1
X_29553_ _06163_ \memory_i.freq_inst.dsmod_cos.data_pre_r[16]\ \memory_i.freq_inst.cosine[7]\ VPWR VGND sg13g2_nor2b_1
X_29554_ _06164_ \memory_i.freq_inst.dsmod_cos.data_pre_r[16]\ \memory_i.freq_inst.dsmod_cos.data_pre_r[15]\ _06098_ _06144_ VPWR
+ VGND
+ sg13g2_nor4_1
X_29555_ _06165_ _06146_ _06163_ _06164_ VPWR VGND sg13g2_a21o_1
X_29556_ _06166_ _06165_ VPWR VGND sg13g2_buf_2
X_29557_ _06167_ _06166_ \memory_i.freq_inst.dsmod_cos.i_osr[0]\ VPWR VGND sg13g2_nand2b_1
X_29558_ _06168_ \memory_i.freq_inst.dsmod_cos.data_pre_r[15]\ _06098_ _06144_ VPWR VGND sg13g2_nor3_1
X_29559_ _06169_ \memory_i.freq_inst.cosine[7]\ _06146_ _06168_ VPWR VGND sg13g2_a21oi_1
X_29560_ _06170_ \memory_i.freq_inst.dsmod_cos.data_pre_r[16]\ _06169_ VPWR VGND sg13g2_nand2_1
X_29561_ _06171_ _06167_ _06170_ \memory_i.freq_inst.cosine[8]\ VPWR VGND sg13g2_mux2_1
X_29562_ _06172_ _06141_ _06169_ VPWR VGND sg13g2_xnor2_1
X_29563_ _06173_ \memory_i.freq_inst.dsmod_cos.data_pre_r[16]\ VPWR VGND sg13g2_inv_1
X_29564_ _06174_ \memory_i.freq_inst.cosine[7]\ _06150_ _06151_ _06152_ _06173_
+ VPWR
+ VGND sg13g2_a221oi_1
X_29565_ _06175_ \memory_i.freq_inst.cosine[7]\ \memory_i.freq_inst.dsmod_cos.data_pre_r[16]\ VPWR VGND sg13g2_nand2b_1
X_29566_ _06176_ _06150_ _06175_ \memory_i.freq_inst.cosine[8]\ VPWR VGND sg13g2_o21ai_1
X_29567_ _06177_ _06174_ _06176_ VPWR VGND sg13g2_nor2_1
X_29568_ _06178_ _06166_ _06177_ VPWR VGND sg13g2_nor2_1
X_29569_ _06179_ _06178_ \memory_i.freq_inst.dsmod_cos.i_osr[0]\ _06162_ VPWR VGND sg13g2_nand3b_1
X_29570_ _06180_ \memory_i.freq_inst.dsmod_cos.i_osr[0]\ _06172_ _06179_ VPWR VGND sg13g2_o21ai_1
X_29571_ _06181_ _06180_ VPWR VGND sg13g2_inv_1
X_29572_ _06182_ _06162_ _06171_ _06181_ VPWR VGND sg13g2_o21ai_1
X_29573_ _06183_ \memory_i.freq_inst.dsmod_cos.i_osr[1]\ _06136_ VPWR VGND sg13g2_nor2_1
X_29574_ _06184_ \memory_i.freq_inst.dsmod_cos.i_osr[1]\ _06182_ _06183_ VPWR VGND sg13g2_a21oi_1
X_29575_ _06185_ _15907_ _06184_ VPWR VGND sg13g2_nor2_1
X_29576_ _06186_ \memory_i.freq_inst.dsmod_cos.data_step_r[9]\ _15970_ _06185_ VPWR VGND sg13g2_a21oi_1
X_29577_ _01614_ _05676_ _06186_ VPWR VGND sg13g2_nor2_1
X_29578_ _06187_ \memory_i.freq_inst.dsmod_cos.data_step_r[10]\ _06002_ VPWR VGND sg13g2_nand2_1
X_29579_ _06188_ \memory_i.freq_inst.dsmod_cos.data_pre_r[17]\ _06178_ VPWR VGND sg13g2_nor2_1
X_29580_ _06189_ \memory_i.freq_inst.cosine[9]\ _06188_ VPWR VGND sg13g2_nor2_1
X_29581_ _06190_ \memory_i.freq_inst.dsmod_cos.data_pre_r[17]\ _06178_ _06189_ VPWR VGND sg13g2_a21oi_1
X_29582_ _06191_ \memory_i.freq_inst.cosine[10]\ \memory_i.freq_inst.dsmod_cos.data_pre_r[18]\ VPWR VGND sg13g2_xnor2_1
X_29583_ _06192_ _06190_ _06189_ _06191_ VPWR VGND sg13g2_mux2_1
X_29584_ _06193_ _06162_ _06178_ VPWR VGND sg13g2_xnor2_1
X_29585_ _06194_ \memory_i.freq_inst.cosine[9]\ \memory_i.freq_inst.dsmod_cos.data_pre_r[17]\ _06178_ _06191_ VPWR
+ VGND
+ sg13g2_nand4_1
X_29586_ _06195_ \memory_i.freq_inst.dsmod_cos.i_osr[0]\ _06193_ _06194_ VPWR VGND sg13g2_o21ai_1
X_29587_ _06196_ \memory_i.freq_inst.dsmod_cos.i_osr[0]\ _06192_ _06195_ VPWR VGND sg13g2_a21o_1
X_29588_ _06197_ _06159_ _06196_ \memory_i.freq_inst.dsmod_cos.i_osr[1]\ VPWR VGND sg13g2_mux2_1
X_29589_ _06198_ _05646_ _06197_ VPWR VGND sg13g2_nand2_1
X_29590_ _01615_ _06187_ _06198_ _06007_ VPWR VGND sg13g2_a21oi_1
X_29591_ _06199_ \memory_i.freq_inst.dsmod_cos.data_step_r[11]\ _15966_ VPWR VGND sg13g2_nor2_1
X_29592_ _06200_ \memory_i.freq_inst.cosine[11]\ \memory_i.freq_inst.dsmod_cos.data_pre_r[19]\ VPWR VGND sg13g2_xor2_1
X_29593_ _06201_ \memory_i.freq_inst.dsmod_cos.i_osr[0]\ _06200_ VPWR VGND sg13g2_nand2_1
X_29594_ _06202_ \memory_i.freq_inst.dsmod_cos.data_pre_r[18]\ VPWR VGND sg13g2_inv_1
X_29595_ _06203_ _06202_ _06190_ VPWR VGND sg13g2_or2_1
X_29596_ _06204_ _06203_ VPWR VGND sg13g2_buf_1
X_29597_ _06205_ _06200_ _06204_ VPWR VGND sg13g2_nand2b_1
X_29598_ _06206_ \memory_i.freq_inst.dsmod_cos.data_pre_r[18]\ _06190_ VPWR VGND sg13g2_xnor2_1
X_29599_ _06207_ \memory_i.freq_inst.dsmod_cos.i_osr[0]\ _06206_ VPWR VGND sg13g2_nor2_1
X_29600_ _06208_ \memory_i.freq_inst.dsmod_cos.i_osr[0]\ _06205_ _06207_ VPWR VGND sg13g2_a21oi_1
X_29601_ _06209_ _06207_ VPWR VGND sg13g2_inv_1
X_29602_ _06210_ _06202_ _06190_ VPWR VGND sg13g2_and2_1
X_29603_ _06211_ _06201_ _06200_ _06210_ VPWR VGND sg13g2_mux2_1
X_29604_ _06212_ _06209_ _06211_ \memory_i.freq_inst.cosine[10]\ VPWR VGND sg13g2_a21oi_1
X_29605_ _06213_ \memory_i.freq_inst.cosine[10]\ _06208_ _06212_ VPWR VGND sg13g2_a21oi_1
X_29606_ _06214_ _06201_ _06204_ _06213_ VPWR VGND sg13g2_o21ai_1
X_29607_ _06215_ \memory_i.freq_inst.dsmod_cos.i_osr[1]\ _06182_ VPWR VGND sg13g2_nor2_1
X_29608_ _06216_ \memory_i.freq_inst.dsmod_cos.i_osr[1]\ _06214_ _06215_ VPWR VGND sg13g2_a21oi_1
X_29609_ _06217_ _06037_ _06216_ VPWR VGND sg13g2_nor2_1
X_29610_ _01616_ _03810_ _06199_ _06217_ VPWR VGND sg13g2_nor3_1
X_29611_ _06218_ \memory_i.freq_inst.dsmod_cos.data_step_r[12]\ _15966_ VPWR VGND sg13g2_nor2_1
X_29612_ _06219_ \memory_i.freq_inst.cosine[12]\ \memory_i.freq_inst.dsmod_cos.data_pre_r[20]\ VPWR VGND sg13g2_nand2b_1
X_29613_ _06220_ _06219_ VPWR VGND sg13g2_buf_1
X_29614_ _06221_ \memory_i.freq_inst.dsmod_cos.data_pre_r[20]\ VPWR VGND sg13g2_inv_1
X_29615_ _06222_ \memory_i.freq_inst.cosine[12]\ _06221_ VPWR VGND sg13g2_nand2_1
X_29616_ _06223_ _06220_ _06222_ VPWR VGND sg13g2_nand2_1
X_29617_ _06224_ \memory_i.freq_inst.dsmod_cos.data_pre_r[19]\ \memory_i.freq_inst.dsmod_cos.data_pre_r[18]\ \memory_i.freq_inst.dsmod_cos.data_pre_r[17]\ VPWR VGND sg13g2_nand3_1
X_29618_ _06225_ _06166_ _06177_ _06224_ VPWR VGND sg13g2_nor3_1
X_29619_ _06226_ \memory_i.freq_inst.cosine[10]\ \memory_i.freq_inst.dsmod_cos.data_pre_r[19]\ \memory_i.freq_inst.dsmod_cos.data_pre_r[17]\ VPWR VGND sg13g2_nand3b_1
X_29620_ _06227_ _06166_ _06177_ _06226_ VPWR VGND sg13g2_nor3_1
X_29621_ _06228_ \memory_i.freq_inst.cosine[9]\ \memory_i.freq_inst.dsmod_cos.data_pre_r[19]\ VPWR VGND sg13g2_nor2b_1
X_29622_ _06229_ \memory_i.freq_inst.dsmod_cos.data_pre_r[18]\ _06228_ VPWR VGND sg13g2_nand2_1
X_29623_ _06230_ _06166_ _06177_ _06229_ VPWR VGND sg13g2_nor3_1
X_29624_ _06231_ \memory_i.freq_inst.cosine[10]\ \memory_i.freq_inst.cosine[9]\ VPWR VGND sg13g2_nor2_1
X_29625_ _06232_ \memory_i.freq_inst.dsmod_cos.data_pre_r[19]\ _06231_ VPWR VGND sg13g2_nand2_1
X_29626_ _06233_ _06166_ _06177_ _06232_ VPWR VGND sg13g2_nor3_1
X_29627_ _06234_ _06225_ _06227_ _06230_ _06233_ VPWR
+ VGND
+ sg13g2_or4_1
X_29628_ _06235_ _06234_ VPWR VGND sg13g2_buf_1
X_29629_ _06236_ \memory_i.freq_inst.dsmod_cos.data_pre_r[18]\ \memory_i.freq_inst.dsmod_cos.data_pre_r[17]\ _06228_ VPWR VGND sg13g2_nand3_1
X_29630_ _06237_ \memory_i.freq_inst.dsmod_cos.data_pre_r[19]\ \memory_i.freq_inst.dsmod_cos.data_pre_r[17]\ _06231_ VPWR VGND sg13g2_nand3_1
X_29631_ _06238_ \memory_i.freq_inst.cosine[10]\ \memory_i.freq_inst.dsmod_cos.data_pre_r[19]\ \memory_i.freq_inst.dsmod_cos.data_pre_r[18]\ VPWR VGND sg13g2_nand3b_1
X_29632_ _06239_ _06236_ _06237_ _06238_ VPWR VGND sg13g2_nand3_1
X_29633_ _06240_ _06239_ VPWR VGND sg13g2_buf_1
X_29634_ _06241_ _06235_ _06240_ VPWR VGND sg13g2_nor2_1
X_29635_ _06242_ _06223_ _06241_ VPWR VGND sg13g2_nand2b_1
X_29636_ _06243_ \memory_i.freq_inst.cosine[10]\ _06204_ _06210_ VPWR VGND sg13g2_a21oi_1
X_29637_ _06244_ \memory_i.freq_inst.dsmod_cos.data_pre_r[19]\ _06243_ VPWR VGND sg13g2_xor2_1
X_29638_ _06245_ \memory_i.freq_inst.dsmod_cos.i_osr[0]\ _06244_ VPWR VGND sg13g2_nor2_1
X_29639_ _06246_ \memory_i.freq_inst.dsmod_cos.i_osr[0]\ _06242_ _06245_ VPWR VGND sg13g2_a21oi_1
X_29640_ _06247_ \memory_i.freq_inst.dsmod_cos.data_pre_r[17]\ \memory_i.freq_inst.dsmod_cos.data_pre_r[16]\ VPWR VGND sg13g2_nand2_1
X_29641_ _06248_ \memory_i.freq_inst.cosine[8]\ \memory_i.freq_inst.dsmod_cos.data_pre_r[17]\ VPWR VGND sg13g2_nand2b_1
X_29642_ _06249_ \memory_i.freq_inst.cosine[7]\ _06146_ _06247_ _06248_ _06168_
+ VPWR
+ VGND sg13g2_a221oi_1
X_29643_ _06250_ _06173_ _06248_ \memory_i.freq_inst.cosine[9]\ VPWR VGND sg13g2_o21ai_1
X_29644_ _06251_ \memory_i.freq_inst.dsmod_cos.data_pre_r[19]\ \memory_i.freq_inst.dsmod_cos.data_pre_r[18]\ _06249_ _06250_ VPWR
+ VGND
+ sg13g2_nor4_1
X_29645_ _06252_ \memory_i.freq_inst.dsmod_cos.data_pre_r[19]\ \memory_i.freq_inst.cosine[10]\ VPWR VGND sg13g2_nand2b_1
X_29646_ _06253_ _06249_ _06250_ _06252_ VPWR VGND sg13g2_nor3_1
X_29647_ _06254_ \memory_i.freq_inst.cosine[8]\ _06173_ VPWR VGND sg13g2_nand2_1
X_29648_ _06255_ \memory_i.freq_inst.dsmod_cos.data_pre_r[19]\ \memory_i.freq_inst.dsmod_cos.data_pre_r[18]\ \memory_i.freq_inst.dsmod_cos.data_pre_r[17]\ VPWR VGND sg13g2_or3_1
X_29649_ _06256_ \memory_i.freq_inst.dsmod_cos.data_pre_r[17]\ _06252_ VPWR VGND sg13g2_or2_1
X_29650_ _06257_ \memory_i.freq_inst.cosine[8]\ _06173_ VPWR VGND sg13g2_nor2_1
X_29651_ _06258_ _06254_ _06169_ _06255_ _06256_ _06257_
+ VPWR
+ VGND sg13g2_a221oi_1
X_29652_ _06259_ \memory_i.freq_inst.dsmod_cos.data_pre_r[18]\ _06252_ VPWR VGND sg13g2_nor2_1
X_29653_ _06260_ _06251_ _06253_ _06258_ _06259_ VPWR
+ VGND
+ sg13g2_nor4_1
X_29654_ _06261_ _06223_ _06260_ VPWR VGND sg13g2_nor2_1
X_29655_ _06262_ _06245_ _06261_ VPWR VGND sg13g2_nor2_1
X_29656_ _06263_ \memory_i.freq_inst.cosine[11]\ _06260_ VPWR VGND sg13g2_nand2b_1
X_29657_ _06264_ _06241_ _06263_ VPWR VGND sg13g2_and2_1
X_29658_ _06265_ _06264_ VPWR VGND sg13g2_buf_1
X_29659_ _06266_ _06265_ \memory_i.freq_inst.dsmod_cos.i_osr[0]\ _06223_ VPWR VGND sg13g2_nand3b_1
X_29660_ _06267_ \memory_i.freq_inst.cosine[11]\ _06262_ _06266_ VPWR VGND sg13g2_o21ai_1
X_29661_ _06268_ \memory_i.freq_inst.cosine[11]\ _06246_ _06267_ VPWR VGND sg13g2_a21oi_1
X_29662_ _06269_ _06196_ _06268_ \memory_i.freq_inst.dsmod_cos.i_osr[1]\ VPWR VGND sg13g2_mux2_1
X_29663_ _06270_ _06037_ _06269_ VPWR VGND sg13g2_nor2_1
X_29664_ _01617_ _03810_ _06218_ _06270_ VPWR VGND sg13g2_nor3_1
X_29665_ _06271_ _06221_ _06265_ VPWR VGND sg13g2_nor2_1
X_29666_ _06272_ \memory_i.freq_inst.cosine[13]\ \memory_i.freq_inst.dsmod_cos.data_pre_r[21]\ VPWR VGND sg13g2_xnor2_1
X_29667_ _06273_ _06020_ _06272_ VPWR VGND sg13g2_nor2_1
X_29668_ _06274_ _06221_ _06265_ _06272_ VPWR VGND sg13g2_o21ai_1
X_29669_ _06275_ \memory_i.freq_inst.dsmod_cos.data_pre_r[20]\ _06265_ VPWR VGND sg13g2_xnor2_1
X_29670_ _06276_ \memory_i.freq_inst.dsmod_cos.i_osr[0]\ _06275_ VPWR VGND sg13g2_nor2_1
X_29671_ _06277_ \memory_i.freq_inst.dsmod_cos.i_osr[0]\ _06274_ _06276_ VPWR VGND sg13g2_a21oi_1
X_29672_ _06278_ _06221_ _06265_ VPWR VGND sg13g2_nand2_1
X_29673_ _06279_ _06272_ _06273_ _06278_ VPWR VGND sg13g2_mux2_1
X_29674_ _06280_ _06276_ _06279_ VPWR VGND sg13g2_nor2_1
X_29675_ _06281_ \memory_i.freq_inst.cosine[12]\ _06280_ VPWR VGND sg13g2_nor2_1
X_29676_ _06282_ _06271_ _06273_ _06277_ \memory_i.freq_inst.cosine[12]\ _06281_
+ VPWR
+ VGND sg13g2_a221oi_1
X_29677_ _06283_ \memory_i.freq_inst.dsmod_cos.i_osr[1]\ _06214_ VPWR VGND sg13g2_nor2_1
X_29678_ _06284_ \memory_i.freq_inst.dsmod_cos.i_osr[1]\ _06282_ _06283_ VPWR VGND sg13g2_a21oi_1
X_29679_ _06285_ _15907_ _06284_ VPWR VGND sg13g2_nor2_1
X_29680_ _06286_ \memory_i.freq_inst.dsmod_cos.data_step_r[13]\ _15970_ _06285_ VPWR VGND sg13g2_a21oi_1
X_29681_ _01618_ _05676_ _06286_ VPWR VGND sg13g2_nor2_1
X_29682_ _06287_ _03656_ VPWR VGND sg13g2_buf_1
X_29683_ _06288_ \memory_i.freq_inst.cosine[14]\ \memory_i.freq_inst.dsmod_cos.data_pre_r[22]\ VPWR VGND sg13g2_xor2_1
X_29684_ _06289_ \memory_i.freq_inst.dsmod_cos.i_osr[0]\ _06288_ VPWR VGND sg13g2_nand2_1
X_29685_ _06290_ _06235_ _06240_ _06222_ VPWR VGND sg13g2_o21ai_1
X_29686_ _06291_ \memory_i.freq_inst.cosine[11]\ _06222_ _06260_ VPWR VGND sg13g2_nand3b_1
X_29687_ _06292_ _06290_ _06291_ VPWR VGND sg13g2_and2_1
X_29688_ _06293_ \memory_i.freq_inst.dsmod_cos.data_pre_r[21]\ VPWR VGND sg13g2_inv_1
X_29689_ _06294_ _06220_ _06292_ _06293_ VPWR VGND sg13g2_a21oi_1
X_29690_ _06295_ _06289_ _06288_ _06294_ VPWR VGND sg13g2_mux2_1
X_29691_ _06296_ _06293_ _06220_ VPWR VGND sg13g2_and2_1
X_29692_ _06297_ _06292_ _06296_ VPWR VGND sg13g2_and2_1
X_29693_ _06298_ _06294_ _06297_ _06143_ VPWR VGND sg13g2_o21ai_1
X_29694_ _06299_ _06295_ _06298_ VPWR VGND sg13g2_nand2_1
X_29695_ _06300_ _06289_ _06297_ VPWR VGND sg13g2_nand2_1
X_29696_ _06301_ _06288_ _06294_ _06021_ VPWR VGND sg13g2_mux2_1
X_29697_ _06302_ _06290_ _06291_ _06296_ VPWR VGND sg13g2_nand3_1
X_29698_ _06303_ \memory_i.freq_inst.cosine[13]\ _06301_ _06302_ VPWR VGND sg13g2_o21ai_1
X_29699_ _06304_ \memory_i.freq_inst.cosine[13]\ _06299_ _06300_ _06303_ VPWR
+ VGND
+ sg13g2_a22oi_1
X_29700_ _06305_ \memory_i.freq_inst.dsmod_cos.i_osr[1]\ _06304_ VPWR VGND sg13g2_nand2_1
X_29701_ _06306_ \memory_i.freq_inst.dsmod_cos.i_osr[1]\ _06268_ _06305_ VPWR VGND sg13g2_o21ai_1
X_29702_ _06307_ _15907_ _06306_ VPWR VGND sg13g2_nor2_1
X_29703_ _06308_ \memory_i.freq_inst.dsmod_cos.data_step_r[14]\ _15970_ _06307_ VPWR VGND sg13g2_a21oi_1
X_29704_ _01619_ _06287_ _06308_ VPWR VGND sg13g2_nor2_1
X_29705_ _06309_ \memory_i.freq_inst.dsmod_cos.data_step_r[15]\ _06002_ VPWR VGND sg13g2_nand2_1
X_29706_ _06310_ \memory_i.freq_inst.cosine[15]\ \memory_i.freq_inst.dsmod_cos.data_pre_r[23]\ VPWR VGND sg13g2_xnor2_1
X_29707_ _06311_ \memory_i.freq_inst.cosine[14]\ \memory_i.freq_inst.dsmod_cos.data_pre_r[22]\ VPWR VGND sg13g2_nor2b_1
X_29708_ _06312_ \memory_i.freq_inst.cosine[13]\ _06220_ VPWR VGND sg13g2_nand2_1
X_29709_ _06313_ _06235_ _06240_ _06312_ VPWR VGND sg13g2_nor3_1
X_29710_ _06314_ \memory_i.freq_inst.cosine[13]\ VPWR VGND sg13g2_inv_1
X_29711_ _06315_ \memory_i.freq_inst.dsmod_cos.data_pre_r[21]\ _06222_ _06314_ VPWR VGND sg13g2_a21oi_1
X_29712_ _06316_ _06263_ _06313_ _06315_ VPWR VGND sg13g2_a21oi_1
X_29713_ _06317_ _06302_ _06316_ VPWR VGND sg13g2_and2_1
X_29714_ _06318_ _06317_ VPWR VGND sg13g2_buf_1
X_29715_ _06319_ \memory_i.freq_inst.dsmod_cos.data_pre_r[22]\ \memory_i.freq_inst.cosine[14]\ VPWR VGND sg13g2_nand2b_1
X_29716_ _06320_ _06311_ _06318_ _06319_ VPWR VGND sg13g2_o21ai_1
X_29717_ _06321_ _06320_ VPWR VGND sg13g2_buf_1
X_29718_ _06322_ \memory_i.freq_inst.dsmod_cos.data_pre_r[22]\ _06318_ VPWR VGND sg13g2_nand2_1
X_29719_ _06323_ \memory_i.freq_inst.cosine[14]\ _06310_ _06322_ VPWR VGND sg13g2_nand3_1
X_29720_ _06324_ _06310_ _06321_ _06323_ VPWR VGND sg13g2_o21ai_1
X_29721_ _06325_ _06288_ _06318_ VPWR VGND sg13g2_xor2_1
X_29722_ _06326_ \memory_i.freq_inst.dsmod_cos.data_pre_r[22]\ _06318_ VPWR VGND sg13g2_nor2_1
X_29723_ _06327_ \memory_i.freq_inst.cosine[14]\ _06326_ _06310_ VPWR VGND sg13g2_nand3b_1
X_29724_ _06328_ \memory_i.freq_inst.dsmod_cos.i_osr[0]\ _06325_ _06327_ VPWR VGND sg13g2_o21ai_1
X_29725_ _06329_ \memory_i.freq_inst.dsmod_cos.i_osr[0]\ _06324_ _06328_ VPWR VGND sg13g2_a21oi_1
X_29726_ _06330_ _06282_ _06329_ \memory_i.freq_inst.dsmod_cos.i_osr[1]\ VPWR VGND sg13g2_mux2_1
X_29727_ _06331_ _05646_ _06330_ VPWR VGND sg13g2_nand2_1
X_29728_ _01620_ _06309_ _06331_ _06007_ VPWR VGND sg13g2_a21oi_1
X_29729_ _06332_ \memory_i.freq_inst.cosine[16]\ \memory_i.freq_inst.dsmod_cos.data_pre_r[24]\ VPWR VGND sg13g2_nor2b_1
X_29730_ _06333_ \memory_i.freq_inst.dsmod_cos.data_pre_r[24]\ \memory_i.freq_inst.cosine[16]\ VPWR VGND sg13g2_nor2b_1
X_29731_ _06334_ _06332_ _06333_ VPWR VGND sg13g2_or2_1
X_29732_ _06335_ _06334_ VPWR VGND sg13g2_buf_1
X_29733_ _06336_ \memory_i.freq_inst.dsmod_cos.i_osr[0]\ _06335_ VPWR VGND sg13g2_nand2_1
X_29734_ _06337_ _06321_ \memory_i.freq_inst.dsmod_cos.data_pre_r[23]\ VPWR VGND sg13g2_nand2b_1
X_29735_ _06338_ _06337_ VPWR VGND sg13g2_buf_1
X_29736_ _06339_ \memory_i.freq_inst.dsmod_cos.data_pre_r[23]\ VPWR VGND sg13g2_inv_1
X_29737_ _06340_ _06339_ _06321_ VPWR VGND sg13g2_and2_1
X_29738_ _06341_ _06335_ _06340_ _06030_ VPWR VGND sg13g2_mux2_1
X_29739_ _06342_ _06341_ \memory_i.freq_inst.cosine[15]\ _06338_ VPWR VGND sg13g2_nand3b_1
X_29740_ _06343_ _06336_ _06338_ _06342_ VPWR VGND sg13g2_o21ai_1
X_29741_ _06344_ _06339_ _06321_ VPWR VGND sg13g2_nand2_1
X_29742_ _06345_ _06338_ _06344_ \memory_i.freq_inst.dsmod_cos.i_osr[0]\ VPWR VGND sg13g2_a21o_1
X_29743_ _06346_ _06335_ _06336_ _06344_ VPWR VGND sg13g2_mux2_1
X_29744_ _06347_ _06345_ _06346_ \memory_i.freq_inst.cosine[15]\ VPWR VGND sg13g2_a21oi_1
X_29745_ _06348_ _06343_ _06347_ VPWR VGND sg13g2_nor2_1
X_29746_ _06349_ \memory_i.freq_inst.dsmod_cos.i_osr[1]\ _06304_ VPWR VGND sg13g2_nor2_1
X_29747_ _06350_ \memory_i.freq_inst.dsmod_cos.i_osr[1]\ _06348_ _06349_ VPWR VGND sg13g2_a21oi_1
X_29748_ _06351_ _15907_ _06350_ VPWR VGND sg13g2_nor2_1
X_29749_ _06352_ \memory_i.freq_inst.dsmod_cos.data_step_r[16]\ _15970_ _06351_ VPWR VGND sg13g2_a21oi_1
X_29750_ _01621_ _06287_ _06352_ VPWR VGND sg13g2_nor2_1
X_29751_ _06353_ \memory_i.freq_inst.dsmod_cos.data_step_r[17]\ _15966_ VPWR VGND sg13g2_nor2_1
X_29752_ _06354_ \memory_i.freq_inst.cosine[17]\ \memory_i.freq_inst.dsmod_cos.data_pre_r[25]\ VPWR VGND sg13g2_xnor2_1
X_29753_ _06355_ _06020_ _06354_ VPWR VGND sg13g2_nor2_1
X_29754_ _06356_ \memory_i.freq_inst.cosine[15]\ _06338_ _06340_ VPWR VGND sg13g2_a21oi_1
X_29755_ _06357_ \memory_i.freq_inst.dsmod_cos.data_pre_r[24]\ _06356_ VPWR VGND sg13g2_and2_1
X_29756_ _06358_ \memory_i.freq_inst.dsmod_cos.data_pre_r[24]\ _06356_ VPWR VGND sg13g2_xnor2_1
X_29757_ _06359_ _06357_ _06354_ \memory_i.freq_inst.dsmod_cos.i_osr[0]\ VPWR VGND sg13g2_nand3b_1
X_29758_ _06360_ \memory_i.freq_inst.dsmod_cos.i_osr[0]\ _06358_ _06359_ VPWR VGND sg13g2_o21ai_1
X_29759_ _06361_ _06143_ VPWR VGND sg13g2_buf_1
X_29760_ _06362_ \memory_i.freq_inst.dsmod_cos.data_pre_r[24]\ _06356_ VPWR VGND sg13g2_nor2_1
X_29761_ _06363_ _06355_ _06354_ _06362_ VPWR VGND sg13g2_mux2_1
X_29762_ _06364_ _06361_ _06358_ _06363_ VPWR VGND sg13g2_a21oi_1
X_29763_ _06365_ \memory_i.freq_inst.cosine[16]\ _06364_ VPWR VGND sg13g2_nor2_1
X_29764_ _06366_ _06355_ _06357_ _06360_ \memory_i.freq_inst.cosine[16]\ _06365_
+ VPWR
+ VGND sg13g2_a221oi_1
X_29765_ _06367_ _06329_ _06366_ \memory_i.freq_inst.dsmod_cos.i_osr[1]\ VPWR VGND sg13g2_mux2_1
X_29766_ _06368_ _06037_ _06367_ VPWR VGND sg13g2_nor2_1
X_29767_ _01622_ _03810_ _06353_ _06368_ VPWR VGND sg13g2_nor3_1
X_29768_ _06369_ \memory_i.freq_inst.dsmod_cos.data_step_r[18]\ _06002_ VPWR VGND sg13g2_nand2_1
X_29769_ _06370_ \memory_i.freq_inst.dsmod_cos.data_pre_r[26]\ VPWR VGND sg13g2_inv_1
X_29770_ _06371_ \memory_i.freq_inst.cosine[18]\ _06370_ VPWR VGND sg13g2_nand2_1
X_29771_ _06372_ \memory_i.freq_inst.cosine[18]\ VPWR VGND sg13g2_inv_1
X_29772_ _06373_ _06372_ \memory_i.freq_inst.dsmod_cos.data_pre_r[26]\ VPWR VGND sg13g2_nand2_1
X_29773_ _06374_ _06371_ _06373_ VPWR VGND sg13g2_nand2_1
X_29774_ _06375_ \memory_i.freq_inst.cosine[15]\ VPWR VGND sg13g2_inv_1
X_29775_ _06376_ _06311_ _06332_ VPWR VGND sg13g2_or2_1
X_29776_ _06377_ _06375_ \memory_i.freq_inst.dsmod_cos.data_pre_r[23]\ _06302_ _06316_ _06376_
+ VPWR
+ VGND sg13g2_a221oi_1
X_29777_ _06378_ \memory_i.freq_inst.cosine[15]\ _06339_ VPWR VGND sg13g2_nand2_1
X_29778_ _06379_ _06319_ _06332_ VPWR VGND sg13g2_nor2_1
X_29779_ _06380_ \memory_i.freq_inst.cosine[15]\ _06339_ _06379_ VPWR VGND sg13g2_o21ai_1
X_29780_ _06381_ _06378_ _06332_ _06380_ VPWR VGND sg13g2_o21ai_1
X_29781_ _06382_ _06333_ _06377_ _06381_ VPWR VGND sg13g2_nor3_1
X_29782_ _06383_ \memory_i.freq_inst.dsmod_cos.data_pre_r[25]\ _06382_ VPWR VGND sg13g2_and2_1
X_29783_ _06384_ \memory_i.freq_inst.dsmod_cos.data_pre_r[25]\ _06382_ \memory_i.freq_inst.dsmod_cos.i_osr[0]\ VPWR VGND sg13g2_o21ai_1
X_29784_ _06385_ \memory_i.freq_inst.cosine[17]\ _06384_ VPWR VGND sg13g2_nor2_1
X_29785_ _06386_ \memory_i.freq_inst.cosine[17]\ _06383_ _06385_ VPWR VGND sg13g2_a21oi_1
X_29786_ _06387_ _06354_ _06382_ VPWR VGND sg13g2_xor2_1
X_29787_ _06388_ \memory_i.freq_inst.cosine[17]\ \memory_i.freq_inst.dsmod_cos.data_pre_r[25]\ VPWR VGND sg13g2_nand2b_1
X_29788_ _06389_ \memory_i.freq_inst.dsmod_cos.data_pre_r[25]\ \memory_i.freq_inst.cosine[17]\ VPWR VGND sg13g2_nor2b_1
X_29789_ _06390_ _06333_ _06389_ _06377_ _06381_ VPWR
+ VGND
+ sg13g2_or4_1
X_29790_ _06391_ _06388_ _06390_ VPWR VGND sg13g2_and2_1
X_29791_ _06392_ _06391_ VPWR VGND sg13g2_buf_1
X_29792_ _06393_ \memory_i.freq_inst.dsmod_cos.i_osr[0]\ _06374_ _06392_ VPWR VGND sg13g2_nand3_1
X_29793_ _06394_ \memory_i.freq_inst.dsmod_cos.i_osr[0]\ _06387_ _06393_ VPWR VGND sg13g2_o21ai_1
X_29794_ _06395_ _06394_ VPWR VGND sg13g2_inv_1
X_29795_ _06396_ _06374_ _06386_ _06395_ VPWR VGND sg13g2_o21ai_1
X_29796_ _06397_ _06348_ _06396_ \memory_i.freq_inst.dsmod_cos.i_osr[1]\ VPWR VGND sg13g2_mux2_1
X_29797_ _06398_ _15903_ _06397_ VPWR VGND sg13g2_nand2_1
X_29798_ _01623_ _06369_ _06398_ _06007_ VPWR VGND sg13g2_a21oi_1
X_29799_ _06399_ \memory_i.freq_inst.dsmod_cos.data_step_r[19]\ _15908_ VPWR VGND sg13g2_nand2_1
X_29800_ _06400_ _06370_ _06392_ VPWR VGND sg13g2_xnor2_1
X_29801_ _06401_ \memory_i.freq_inst.cosine[19]\ \memory_i.freq_inst.dsmod_cos.data_pre_r[27]\ VPWR VGND sg13g2_nand2b_1
X_29802_ _06402_ \memory_i.freq_inst.dsmod_cos.data_pre_r[27]\ \memory_i.freq_inst.cosine[19]\ VPWR VGND sg13g2_nand2b_1
X_29803_ _06403_ _06402_ VPWR VGND sg13g2_buf_1
X_29804_ _06404_ _06401_ _06403_ VPWR VGND sg13g2_and2_1
X_29805_ _06405_ _06404_ VPWR VGND sg13g2_buf_1
X_29806_ _06406_ _06030_ _06405_ VPWR VGND sg13g2_nor2_1
X_29807_ _06407_ _06370_ _06392_ VPWR VGND sg13g2_nor2_1
X_29808_ _06408_ _06406_ _06405_ _06407_ VPWR VGND sg13g2_mux2_1
X_29809_ _06409_ _06361_ _06400_ _06408_ VPWR VGND sg13g2_a21oi_1
X_29810_ _06410_ _06370_ _06392_ VPWR VGND sg13g2_nand2_1
X_29811_ _06411_ \memory_i.freq_inst.dsmod_cos.i_osr[0]\ _06407_ VPWR VGND sg13g2_nor2_1
X_29812_ _06412_ \memory_i.freq_inst.dsmod_cos.i_osr[0]\ _06405_ _06411_ VPWR VGND sg13g2_a21oi_1
X_29813_ _06413_ \memory_i.freq_inst.cosine[18]\ _06412_ _06410_ VPWR VGND sg13g2_o21ai_1
X_29814_ _06414_ _06410_ _06406_ _06413_ VPWR VGND sg13g2_o21ai_1
X_29815_ _06415_ _06372_ _06409_ _06414_ VPWR VGND sg13g2_o21ai_1
X_29816_ _06416_ _06366_ _06415_ \memory_i.freq_inst.dsmod_cos.i_osr[1]\ VPWR VGND sg13g2_mux2_1
X_29817_ _06417_ _15903_ _06416_ VPWR VGND sg13g2_nand2_1
X_29818_ _01624_ _06399_ _06417_ _06007_ VPWR VGND sg13g2_a21oi_1
X_29819_ _06418_ \memory_i.freq_inst.dsmod_cos.data_step_r[20]\ _15966_ VPWR VGND sg13g2_nor2_1
X_29820_ _06419_ \memory_i.freq_inst.cosine[20]\ \memory_i.freq_inst.dsmod_cos.data_pre_r[28]\ VPWR VGND sg13g2_xnor2_1
X_29821_ _06420_ \memory_i.freq_inst.cosine[19]\ \memory_i.freq_inst.dsmod_cos.data_pre_r[27]\ VPWR VGND sg13g2_nor2b_1
X_29822_ _06421_ _06388_ _06373_ _06390_ VPWR VGND sg13g2_nand3_1
X_29823_ _06422_ _06371_ _06421_ VPWR VGND sg13g2_and2_1
X_29824_ _06423_ _06422_ VPWR VGND sg13g2_buf_1
X_29825_ _06424_ _06420_ _06423_ _06403_ VPWR VGND sg13g2_o21ai_1
X_29826_ _06425_ \memory_i.freq_inst.dsmod_cos.data_pre_r[27]\ _06423_ VPWR VGND sg13g2_nand2_1
X_29827_ _06426_ \memory_i.freq_inst.cosine[19]\ _06425_ _06419_ VPWR VGND sg13g2_nand3_1
X_29828_ _06427_ _06419_ _06424_ _06426_ VPWR VGND sg13g2_o21ai_1
X_29829_ _06428_ _06405_ _06423_ VPWR VGND sg13g2_xnor2_1
X_29830_ _06429_ \memory_i.freq_inst.dsmod_cos.data_pre_r[27]\ _06423_ VPWR VGND sg13g2_nor2_1
X_29831_ _06430_ \memory_i.freq_inst.cosine[19]\ _06419_ _06429_ VPWR VGND sg13g2_nand3b_1
X_29832_ _06431_ \memory_i.freq_inst.dsmod_cos.i_osr[0]\ _06428_ _06430_ VPWR VGND sg13g2_o21ai_1
X_29833_ _06432_ \memory_i.freq_inst.dsmod_cos.i_osr[0]\ _06427_ _06431_ VPWR VGND sg13g2_a21oi_1
X_29834_ _06433_ _06396_ _06432_ \memory_i.freq_inst.dsmod_cos.i_osr[1]\ VPWR VGND sg13g2_mux2_1
X_29835_ _06434_ _06037_ _06433_ VPWR VGND sg13g2_nor2_1
X_29836_ _01625_ _03810_ _06418_ _06434_ VPWR VGND sg13g2_nor3_1
X_29837_ _06435_ \memory_i.freq_inst.dsmod_cos.data_step_r[21]\ _05752_ VPWR VGND sg13g2_nor2_1
X_29838_ _06436_ \memory_i.freq_inst.cosine[21]\ VPWR VGND sg13g2_inv_1
X_29839_ _06437_ _06436_ \memory_i.freq_inst.dsmod_cos.data_pre_r[29]\ VPWR VGND sg13g2_nand2_1
X_29840_ _06438_ \memory_i.freq_inst.dsmod_cos.data_pre_r[29]\ VPWR VGND sg13g2_inv_1
X_29841_ _06439_ \memory_i.freq_inst.cosine[21]\ _06438_ VPWR VGND sg13g2_nand2_1
X_29842_ _06440_ _06437_ _06439_ VPWR VGND sg13g2_nand2_1
X_29843_ _06441_ \memory_i.freq_inst.dsmod_cos.i_osr[0]\ _06440_ VPWR VGND sg13g2_nand2_1
X_29844_ _06442_ \memory_i.freq_inst.dsmod_cos.data_pre_r[28]\ _06403_ VPWR VGND sg13g2_and2_1
X_29845_ _06443_ _06420_ _06423_ _06442_ VPWR VGND sg13g2_o21ai_1
X_29846_ _06444_ _06443_ VPWR VGND sg13g2_buf_1
X_29847_ _06445_ \memory_i.freq_inst.dsmod_cos.data_pre_r[28]\ _06424_ VPWR VGND sg13g2_nand2b_1
X_29848_ _06446_ _06445_ VPWR VGND sg13g2_buf_1
X_29849_ _06447_ _06086_ _06440_ VPWR VGND sg13g2_nor2_1
X_29850_ _06448_ _06143_ _06446_ _06447_ VPWR VGND sg13g2_a21oi_1
X_29851_ _06449_ _06448_ \memory_i.freq_inst.cosine[20]\ _06444_ VPWR VGND sg13g2_nand3b_1
X_29852_ _06450_ _06441_ _06444_ _06449_ VPWR VGND sg13g2_o21ai_1
X_29853_ _06451_ _06444_ _06446_ \memory_i.freq_inst.dsmod_cos.i_osr[0]\ VPWR VGND sg13g2_a21o_1
X_29854_ _06452_ _06440_ _06441_ _06446_ VPWR VGND sg13g2_mux2_1
X_29855_ _06453_ _06451_ _06452_ \memory_i.freq_inst.cosine[20]\ VPWR VGND sg13g2_a21oi_1
X_29856_ _06454_ _06450_ _06453_ VPWR VGND sg13g2_nor2_1
X_29857_ _06455_ _06415_ _06454_ \memory_i.freq_inst.dsmod_cos.i_osr[1]\ VPWR VGND sg13g2_mux2_1
X_29858_ _06456_ _06037_ _06455_ VPWR VGND sg13g2_nor2_1
X_29859_ _01626_ _03810_ _06435_ _06456_ VPWR VGND sg13g2_nor3_1
X_29860_ _06457_ \memory_i.freq_inst.dsmod_cos.data_step_r[22]\ _15908_ VPWR VGND sg13g2_nand2_1
X_29861_ _06458_ \memory_i.freq_inst.dsmod_cos.data_pre_r[30]\ \memory_i.freq_inst.cosine[22]\ VPWR VGND sg13g2_nor2b_1
X_29862_ _06459_ \memory_i.freq_inst.cosine[22]\ \memory_i.freq_inst.dsmod_cos.data_pre_r[30]\ VPWR VGND sg13g2_nand2b_1
X_29863_ _06460_ _06458_ _06459_ VPWR VGND sg13g2_nor2b_1
X_29864_ _06461_ _06460_ VPWR VGND sg13g2_buf_1
X_29865_ _06462_ \memory_i.freq_inst.dsmod_cos.data_pre_r[28]\ _06401_ _06437_ VPWR VGND sg13g2_nand3b_1
X_29866_ _06463_ \memory_i.freq_inst.cosine[20]\ _06401_ _06437_ VPWR VGND sg13g2_nand3_1
X_29867_ _06464_ _06371_ _06421_ _06462_ _06463_ VPWR
+ VGND
+ sg13g2_a22oi_1
X_29868_ _06465_ _06464_ VPWR VGND sg13g2_buf_2
X_29869_ _06466_ \memory_i.freq_inst.cosine[20]\ VPWR VGND sg13g2_inv_1
X_29870_ _06467_ _06466_ \memory_i.freq_inst.dsmod_cos.data_pre_r[28]\ VPWR VGND sg13g2_nor2_1
X_29871_ _06468_ _06436_ \memory_i.freq_inst.dsmod_cos.data_pre_r[29]\ \memory_i.freq_inst.dsmod_cos.data_pre_r[28]\ _06466_ _06403_
+ VPWR
+ VGND sg13g2_a221oi_1
X_29872_ _06469_ _06467_ _06437_ _06468_ VPWR VGND sg13g2_a21oi_1
X_29873_ _06470_ _06465_ _06469_ _06439_ VPWR VGND sg13g2_nand3b_1
X_29874_ _06471_ _06470_ VPWR VGND sg13g2_buf_2
X_29875_ _06472_ \memory_i.freq_inst.cosine[20]\ _06444_ VPWR VGND sg13g2_nand2_1
X_29876_ _06473_ _06446_ _06472_ VPWR VGND sg13g2_nand2_1
X_29877_ _06474_ \memory_i.freq_inst.cosine[21]\ _06461_ VPWR VGND sg13g2_and2_1
X_29878_ _06475_ _06438_ _06473_ _06474_ VPWR VGND sg13g2_o21ai_1
X_29879_ _06476_ _06461_ _06471_ _06475_ VPWR VGND sg13g2_o21ai_1
X_29880_ _06477_ _06440_ _06473_ VPWR VGND sg13g2_xnor2_1
X_29881_ _06478_ \memory_i.freq_inst.cosine[21]\ \memory_i.freq_inst.dsmod_cos.data_pre_r[29]\ VPWR VGND sg13g2_nor2_1
X_29882_ _06479_ _06473_ _06461_ _06478_ VPWR VGND sg13g2_nand3_1
X_29883_ _06480_ \memory_i.freq_inst.dsmod_cos.i_osr[0]\ _06477_ _06479_ VPWR VGND sg13g2_o21ai_1
X_29884_ _06481_ \memory_i.freq_inst.dsmod_cos.i_osr[0]\ _06476_ _06480_ VPWR VGND sg13g2_a21oi_1
X_29885_ _06482_ _06432_ _06481_ \memory_i.freq_inst.dsmod_cos.i_osr[1]\ VPWR VGND sg13g2_mux2_1
X_29886_ _06483_ _15903_ _06482_ VPWR VGND sg13g2_nand2_1
X_29887_ _06484_ _06006_ VPWR VGND sg13g2_buf_1
X_29888_ _01627_ _06457_ _06483_ _06484_ VPWR VGND sg13g2_a21oi_1
X_29889_ _06485_ \memory_i.freq_inst.dsmod_cos.data_step_r[23]\ _15908_ VPWR VGND sg13g2_nand2_1
X_29890_ _06486_ _06461_ _06471_ VPWR VGND sg13g2_xnor2_1
X_29891_ _06487_ _06459_ _06471_ _06458_ VPWR VGND sg13g2_a21oi_1
X_29892_ _06488_ _06487_ VPWR VGND sg13g2_buf_2
X_29893_ _06489_ \memory_i.freq_inst.cosine[23]\ \memory_i.freq_inst.dsmod_cos.data_pre_r[31]\ VPWR VGND sg13g2_xor2_1
X_29894_ _06490_ _06488_ \memory_i.freq_inst.dsmod_cos.i_osr[0]\ _06489_ VPWR VGND sg13g2_nand3b_1
X_29895_ _06491_ \memory_i.freq_inst.dsmod_cos.i_osr[0]\ _06486_ _06490_ VPWR VGND sg13g2_o21ai_1
X_29896_ _06492_ _06436_ \memory_i.freq_inst.dsmod_cos.data_pre_r[29]\ VPWR VGND sg13g2_nor2_1
X_29897_ _06493_ _06469_ VPWR VGND sg13g2_inv_1
X_29898_ _06494_ _06492_ _06465_ _06493_ VPWR VGND sg13g2_nor3_1
X_29899_ _06495_ \memory_i.freq_inst.dsmod_cos.data_pre_r[30]\ _06494_ \memory_i.freq_inst.dsmod_cos.i_osr[0]\ VPWR VGND sg13g2_o21ai_1
X_29900_ _06496_ \memory_i.freq_inst.cosine[22]\ \memory_i.freq_inst.dsmod_cos.data_pre_r[30]\ _06494_ VPWR VGND sg13g2_nand3_1
X_29901_ _06497_ \memory_i.freq_inst.cosine[22]\ _06495_ _06496_ VPWR VGND sg13g2_o21ai_1
X_29902_ _06498_ _06489_ _06497_ VPWR VGND sg13g2_nand2b_1
X_29903_ _06499_ _06491_ _06498_ VPWR VGND sg13g2_nand2b_1
X_29904_ _06500_ _06454_ _06499_ \memory_i.freq_inst.dsmod_cos.i_osr[1]\ VPWR VGND sg13g2_mux2_1
X_29905_ _06501_ _15903_ _06500_ VPWR VGND sg13g2_nand2_1
X_29906_ _01628_ _06485_ _06501_ _06484_ VPWR VGND sg13g2_a21oi_1
X_29907_ _06502_ \memory_i.freq_inst.dsmod_cos.data_pre_r[31]\ _06488_ VPWR VGND sg13g2_xor2_1
X_29908_ _06503_ \memory_i.freq_inst.dsmod_cos.i_osr[0]\ _06502_ VPWR VGND sg13g2_nor2_1
X_29909_ _06504_ \memory_i.freq_inst.dsmod_cos.data_pre_r[32]\ VPWR VGND sg13g2_inv_1
X_29910_ _06505_ \memory_i.freq_inst.cosine[24]\ _06504_ VPWR VGND sg13g2_nand2_1
X_29911_ _06506_ \memory_i.freq_inst.cosine[24]\ \memory_i.freq_inst.dsmod_cos.data_pre_r[32]\ VPWR VGND sg13g2_nand2b_1
X_29912_ _06507_ _06505_ _06506_ VPWR VGND sg13g2_nand2_1
X_29913_ _06508_ \memory_i.freq_inst.dsmod_cos.data_pre_r[31]\ _06488_ VPWR VGND sg13g2_or2_1
X_29914_ _06509_ _06507_ _06508_ VPWR VGND sg13g2_nor2_1
X_29915_ _06510_ \memory_i.freq_inst.dsmod_cos.i_osr[0]\ _06507_ _06508_ VPWR VGND sg13g2_and3_1
X_29916_ _06511_ _06503_ _06509_ _06510_ VPWR VGND sg13g2_nor3_1
X_29917_ _06512_ \memory_i.freq_inst.dsmod_cos.data_pre_r[31]\ _06488_ _06507_ VPWR VGND sg13g2_a21o_1
X_29918_ _06513_ \memory_i.freq_inst.dsmod_cos.i_osr[0]\ _06512_ _06503_ VPWR VGND sg13g2_a21oi_1
X_29919_ _06514_ \memory_i.freq_inst.dsmod_cos.i_osr[0]\ \memory_i.freq_inst.dsmod_cos.data_pre_r[31]\ _06488_ _06507_ VPWR
+ VGND
+ sg13g2_and4_1
X_29920_ _06515_ \memory_i.freq_inst.cosine[23]\ _06513_ _06514_ VPWR VGND sg13g2_a21oi_1
X_29921_ _06516_ \memory_i.freq_inst.cosine[23]\ _06511_ _06515_ VPWR VGND sg13g2_o21ai_1
X_29922_ _06517_ \memory_i.freq_inst.dsmod_cos.i_osr[1]\ _06481_ _15965_ VPWR VGND sg13g2_o21ai_1
X_29923_ _06518_ \memory_i.freq_inst.dsmod_cos.i_osr[1]\ _06516_ _06517_ VPWR VGND sg13g2_a21oi_1
X_29924_ _06519_ \memory_i.freq_inst.dsmod_cos.data_step_r[24]\ _06037_ _06518_ VPWR VGND sg13g2_a21oi_1
X_29925_ _01629_ _06287_ _06519_ VPWR VGND sg13g2_nor2_1
X_29926_ _06520_ \memory_i.freq_inst.dsmod_cos.data_step_r[25]\ _15908_ VPWR VGND sg13g2_nand2_1
X_29927_ _06521_ \memory_i.freq_inst.dsmod_cos.data_pre_r[30]\ VPWR VGND sg13g2_inv_1
X_29928_ _06522_ \memory_i.freq_inst.cosine[23]\ _06521_ _06492_ VPWR VGND sg13g2_nor3_1
X_29929_ _06523_ _06465_ _06469_ _06522_ VPWR VGND sg13g2_nand3b_1
X_29930_ _06524_ \memory_i.freq_inst.cosine[23]\ \memory_i.freq_inst.cosine[22]\ VPWR VGND sg13g2_nor2_1
X_29931_ _06525_ _06439_ _06524_ VPWR VGND sg13g2_nand2_1
X_29932_ _06526_ _06465_ _06493_ _06525_ VPWR VGND sg13g2_or3_1
X_29933_ _06527_ \memory_i.freq_inst.cosine[23]\ VPWR VGND sg13g2_inv_1
X_29934_ _06528_ _06527_ \memory_i.freq_inst.dsmod_cos.data_pre_r[31]\ \memory_i.freq_inst.dsmod_cos.data_pre_r[30]\ _06524_ VPWR
+ VGND
+ sg13g2_a22oi_1
X_29935_ _06529_ _06523_ _06526_ _06528_ VPWR VGND sg13g2_nand3_1
X_29936_ _06530_ _06529_ VPWR VGND sg13g2_buf_1
X_29937_ _06531_ \memory_i.freq_inst.dsmod_cos.data_pre_r[31]\ _06488_ _06530_ VPWR VGND sg13g2_a21oi_1
X_29938_ _06532_ \memory_i.freq_inst.cosine[25]\ \memory_i.freq_inst.dsmod_cos.data_pre_r[33]\ VPWR VGND sg13g2_xnor2_1
X_29939_ _06533_ _06030_ _06532_ VPWR VGND sg13g2_nor2_1
X_29940_ _06534_ _06504_ _06531_ _06533_ VPWR VGND sg13g2_nand3_1
X_29941_ _06535_ \memory_i.freq_inst.dsmod_cos.data_pre_r[32]\ _06531_ VPWR VGND sg13g2_xnor2_1
X_29942_ _06536_ \memory_i.freq_inst.dsmod_cos.i_osr[0]\ _06532_ VPWR VGND sg13g2_nand2_1
X_29943_ _06537_ _06504_ _06531_ _06536_ VPWR VGND sg13g2_a21oi_1
X_29944_ _06538_ _06022_ _06535_ _06537_ VPWR VGND sg13g2_a21oi_1
X_29945_ _06539_ \memory_i.freq_inst.cosine[24]\ _06538_ VPWR VGND sg13g2_or2_1
X_29946_ _06540_ _06504_ _06531_ VPWR VGND sg13g2_nor2_1
X_29947_ _06541_ _06533_ _06532_ _06540_ VPWR VGND sg13g2_mux2_1
X_29948_ _06542_ \memory_i.freq_inst.dsmod_cos.i_osr[0]\ _06535_ VPWR VGND sg13g2_nor2_1
X_29949_ _06543_ _06541_ _06542_ \memory_i.freq_inst.cosine[24]\ VPWR VGND sg13g2_o21ai_1
X_29950_ _06544_ _06534_ _06539_ _06543_ VPWR VGND sg13g2_nand3_1
X_29951_ _06545_ _06499_ _06544_ \memory_i.freq_inst.dsmod_cos.i_osr[1]\ VPWR VGND sg13g2_mux2_1
X_29952_ _06546_ _15903_ _06545_ VPWR VGND sg13g2_nand2_1
X_29953_ _01630_ _06520_ _06546_ _06484_ VPWR VGND sg13g2_a21oi_1
X_29954_ _06547_ \memory_i.freq_inst.cosine[25]\ VPWR VGND sg13g2_inv_1
X_29955_ _06548_ \memory_i.freq_inst.dsmod_cos.data_pre_r[31]\ _06505_ VPWR VGND sg13g2_nand2_1
X_29956_ _06549_ _06521_ _06471_ _06548_ VPWR VGND sg13g2_a21oi_1
X_29957_ _06550_ _06521_ _06471_ \memory_i.freq_inst.cosine[22]\ VPWR VGND sg13g2_o21ai_1
X_29958_ _06551_ \memory_i.freq_inst.cosine[24]\ _06504_ VPWR VGND sg13g2_nor2_1
X_29959_ _06552_ _06505_ _06530_ _06549_ _06550_ _06551_
+ VPWR
+ VGND sg13g2_a221oi_1
X_29960_ _06553_ _06552_ VPWR VGND sg13g2_buf_1
X_29961_ _06554_ \memory_i.freq_inst.dsmod_cos.data_pre_r[33]\ _06553_ VPWR VGND sg13g2_nand2b_1
X_29962_ _06555_ _06553_ \memory_i.freq_inst.dsmod_cos.data_pre_r[33]\ VPWR VGND sg13g2_nand2b_1
X_29963_ _06556_ _06554_ _06555_ VPWR VGND sg13g2_and2_1
X_29964_ _06557_ \memory_i.freq_inst.cosine[26]\ \memory_i.freq_inst.dsmod_cos.data_pre_r[34]\ VPWR VGND sg13g2_xor2_1
X_29965_ _06558_ \memory_i.freq_inst.dsmod_cos.i_osr[0]\ _06557_ VPWR VGND sg13g2_nand2_1
X_29966_ _06559_ _06557_ _06558_ _06554_ VPWR VGND sg13g2_mux2_1
X_29967_ _06560_ \memory_i.freq_inst.dsmod_cos.i_osr[0]\ _06556_ _06559_ VPWR VGND sg13g2_o21ai_1
X_29968_ _06561_ _06547_ \memory_i.freq_inst.dsmod_cos.i_osr[0]\ VPWR VGND sg13g2_nor2_1
X_29969_ _06562_ _06547_ _06022_ VPWR VGND sg13g2_nor2_1
X_29970_ _06563_ _06557_ _06555_ _06562_ VPWR VGND sg13g2_nand3b_1
X_29971_ _06564_ _06558_ _06555_ _06563_ VPWR VGND sg13g2_o21ai_1
X_29972_ _06565_ _06547_ _06560_ _06561_ _06556_ _06564_
+ VPWR
+ VGND sg13g2_a221oi_1
X_29973_ _06566_ \memory_i.freq_inst.dsmod_cos.i_osr[1]\ _06516_ _15902_ VPWR VGND sg13g2_o21ai_1
X_29974_ _06567_ \memory_i.freq_inst.dsmod_cos.i_osr[1]\ _06565_ _06566_ VPWR VGND sg13g2_a21oi_1
X_29975_ _06568_ \memory_i.freq_inst.dsmod_cos.data_step_r[26]\ _05752_ \memory_i.freq_inst.cordic.rstn_i\ VPWR VGND sg13g2_o21ai_1
X_29976_ _01631_ _06567_ _06568_ VPWR VGND sg13g2_nor2_1
X_29977_ _06569_ _06547_ \memory_i.freq_inst.dsmod_cos.data_pre_r[33]\ VPWR VGND sg13g2_nand2_1
X_29978_ _06570_ _06547_ \memory_i.freq_inst.dsmod_cos.data_pre_r[33]\ VPWR VGND sg13g2_nor2_1
X_29979_ _06571_ _06569_ _06553_ _06570_ VPWR VGND sg13g2_a21oi_1
X_29980_ _06572_ \memory_i.freq_inst.dsmod_cos.i_osr[0]\ \memory_i.freq_inst.dsmod_cos.data_pre_r[34]\ VPWR VGND sg13g2_nor2b_1
X_29981_ _06573_ \memory_i.freq_inst.dsmod_cos.data_pre_r[34]\ _06571_ VPWR VGND sg13g2_nor2_1
X_29982_ _06574_ _06571_ _06572_ _06573_ VPWR VGND sg13g2_a21oi_1
X_29983_ _06575_ \memory_i.freq_inst.dsmod_cos.data_pre_r[35]\ \memory_i.freq_inst.cosine[27]\ VPWR VGND sg13g2_nor2b_1
X_29984_ _06576_ _06575_ VPWR VGND sg13g2_buf_1
X_29985_ _06577_ \memory_i.freq_inst.cosine[27]\ \memory_i.freq_inst.dsmod_cos.data_pre_r[35]\ VPWR VGND sg13g2_nor2b_1
X_29986_ _06578_ _06577_ VPWR VGND sg13g2_buf_1
X_29987_ _06579_ _06576_ _06578_ VPWR VGND sg13g2_or2_1
X_29988_ _06580_ \memory_i.freq_inst.dsmod_cos.i_osr[0]\ _06579_ \memory_i.freq_inst.cosine[26]\ VPWR VGND sg13g2_a21oi_1
X_29989_ _06581_ _06576_ _06578_ VPWR VGND sg13g2_nor2_1
X_29990_ _06582_ _06361_ \memory_i.freq_inst.dsmod_cos.data_pre_r[34]\ _06571_ _06581_ VPWR
+ VGND
+ sg13g2_nor4_1
X_29991_ _06583_ _06574_ _06580_ _06582_ VPWR VGND sg13g2_a21oi_1
X_29992_ _06584_ \memory_i.freq_inst.dsmod_cos.data_pre_r[34]\ _06571_ VPWR VGND sg13g2_nand2_1
X_29993_ _06585_ _06573_ _06584_ VPWR VGND sg13g2_nand2b_1
X_29994_ _06586_ \memory_i.freq_inst.cosine[26]\ _06035_ _06585_ VPWR VGND sg13g2_nand3_1
X_29995_ _06587_ \memory_i.freq_inst.cosine[26]\ VPWR VGND sg13g2_inv_1
X_29996_ _06588_ _06587_ _06361_ _06581_ VPWR VGND sg13g2_nor3_1
X_29997_ _06589_ _06587_ _06584_ _06579_ VPWR VGND sg13g2_nor3_1
X_29998_ _06590_ _06584_ _06588_ _06589_ VPWR VGND sg13g2_a21oi_1
X_29999_ _06591_ \memory_i.freq_inst.dsmod_cos.i_osr[1]\ _06583_ _06586_ _06590_ VPWR
+ VGND
+ sg13g2_nand4_1
X_30000_ _06592_ \memory_i.freq_inst.dsmod_cos.i_osr[1]\ _06544_ _06591_ VPWR VGND sg13g2_o21ai_1
X_30001_ _06593_ \memory_i.freq_inst.dsmod_cos.data_step_r[27]\ _05752_ \memory_i.freq_inst.cordic.rstn_i\ VPWR VGND sg13g2_o21ai_1
X_30002_ _01632_ _05646_ _06592_ _06593_ VPWR VGND sg13g2_a21oi_1
X_30003_ _06594_ \memory_i.freq_inst.dsmod_cos.data_step_r[28]\ _05752_ VPWR VGND sg13g2_nor2_1
X_30004_ _06595_ _06587_ \memory_i.freq_inst.dsmod_cos.data_pre_r[34]\ VPWR VGND sg13g2_nor2_1
X_30005_ _06596_ _06587_ \memory_i.freq_inst.dsmod_cos.data_pre_r[34]\ VPWR VGND sg13g2_nand2_1
X_30006_ _06597_ \memory_i.freq_inst.dsmod_cos.data_pre_r[33]\ _06506_ _06596_ VPWR VGND sg13g2_nand3b_1
X_30007_ _06598_ \memory_i.freq_inst.cosine[25]\ _06506_ _06596_ VPWR VGND sg13g2_nand3_1
X_30008_ _06599_ \memory_i.freq_inst.dsmod_cos.data_pre_r[31]\ _06488_ _06597_ _06598_ _06530_
+ VPWR
+ VGND sg13g2_a221oi_1
X_30009_ _06600_ _06587_ \memory_i.freq_inst.dsmod_cos.data_pre_r[34]\ \memory_i.freq_inst.dsmod_cos.data_pre_r[33]\ _06547_ _06505_
+ VPWR
+ VGND sg13g2_a221oi_1
X_30010_ _06601_ _06570_ _06596_ _06600_ VPWR VGND sg13g2_a21oi_1
X_30011_ _06602_ _06601_ VPWR VGND sg13g2_inv_1
X_30012_ _06603_ _06595_ _06599_ _06602_ VPWR VGND sg13g2_nor3_1
X_30013_ _06604_ _06581_ _06603_ VPWR VGND sg13g2_xnor2_1
X_30014_ _06605_ _06599_ _06602_ VPWR VGND sg13g2_nor2_1
X_30015_ _06606_ \memory_i.freq_inst.cosine[28]\ \memory_i.freq_inst.dsmod_cos.data_pre_r[36]\ VPWR VGND sg13g2_xnor2_1
X_30016_ _06607_ _06578_ _06605_ _06606_ VPWR VGND sg13g2_or3_1
X_30017_ _06608_ _06595_ _06576_ VPWR VGND sg13g2_nor2_1
X_30018_ _06609_ _06605_ _06606_ _06608_ VPWR VGND sg13g2_nand3_1
X_30019_ _06610_ _06587_ \memory_i.freq_inst.dsmod_cos.data_pre_r[34]\ _06578_ VPWR VGND sg13g2_nor3_1
X_30020_ _06611_ _06606_ VPWR VGND sg13g2_inv_1
X_30021_ _06612_ _06576_ _06610_ _06611_ VPWR VGND sg13g2_o21ai_1
X_30022_ _06613_ _06578_ _06606_ VPWR VGND sg13g2_nand2_1
X_30023_ _06614_ _06607_ _06609_ _06612_ _06613_ VPWR
+ VGND
+ sg13g2_nand4_1
X_30024_ _06615_ _06604_ _06614_ \memory_i.freq_inst.dsmod_cos.i_osr[0]\ VPWR VGND sg13g2_mux2_1
X_30025_ _06616_ _06565_ _06615_ \memory_i.freq_inst.dsmod_cos.i_osr[1]\ VPWR VGND sg13g2_mux2_1
X_30026_ _06617_ _06037_ _06616_ VPWR VGND sg13g2_nor2_1
X_30027_ _01633_ _03810_ _06594_ _06617_ VPWR VGND sg13g2_nor3_1
X_30028_ _06618_ \memory_i.freq_inst.dsmod_cos.data_pre_r[36]\ \memory_i.freq_inst.cosine[28]\ VPWR VGND sg13g2_nand2b_1
X_30029_ _06619_ _06618_ _06608_ VPWR VGND sg13g2_and2_1
X_30030_ _06620_ \memory_i.freq_inst.cosine[28]\ \memory_i.freq_inst.dsmod_cos.data_pre_r[36]\ VPWR VGND sg13g2_nor2b_1
X_30031_ _06621_ _06578_ _06618_ _06619_ _06605_ _06620_
+ VPWR
+ VGND sg13g2_a221oi_1
X_30032_ _06622_ \memory_i.freq_inst.cosine[29]\ \memory_i.freq_inst.dsmod_cos.data_pre_r[37]\ VPWR VGND sg13g2_xor2_1
X_30033_ _06623_ _06621_ _06622_ VPWR VGND sg13g2_xnor2_1
X_30034_ _06624_ _03163_ _06623_ VPWR VGND sg13g2_nor2_1
X_30035_ _06625_ _03154_ _06583_ _06586_ _06590_ VPWR
+ VGND
+ sg13g2_nand4_1
X_30036_ _06626_ _03154_ \memory_i.freq_inst.dsmod_cos.i_osr[0]\ _06614_ VPWR VGND sg13g2_or3_1
X_30037_ _06627_ \memory_i.freq_inst.cordic.rstn_i\ _15902_ _06625_ _06626_ VPWR
+ VGND
+ sg13g2_nand4_1
X_30038_ _06628_ \memory_i.freq_inst.cordic.rstn_i\ \memory_i.freq_inst.dsmod_cos.data_step_r[29]\ _06002_ VPWR VGND sg13g2_nand3_1
X_30039_ _01634_ _06624_ _06627_ _06628_ VPWR VGND sg13g2_o21ai_1
X_30040_ _06629_ _03154_ VPWR VGND sg13g2_buf_1
X_30041_ _06630_ _06629_ _06615_ VPWR VGND sg13g2_nand2_1
X_30042_ _06631_ \memory_i.freq_inst.dsmod_cos.i_osr[1]\ _06623_ _06037_ VPWR VGND sg13g2_a21oi_1
X_30043_ _06632_ \memory_i.freq_inst.dsmod_cos.data_step_r[30]\ _05752_ \memory_i.freq_inst.cordic.rstn_i\ VPWR VGND sg13g2_o21ai_1
X_30044_ _01635_ _06630_ _06631_ _06632_ VPWR VGND sg13g2_a21oi_1
X_30045_ _06633_ _03147_ _06623_ VPWR VGND sg13g2_nor2b_1
X_30046_ _06634_ _03147_ _06614_ _06633_ VPWR VGND sg13g2_a21oi_1
X_30047_ _06635_ \memory_i.freq_inst.dsmod_cos.data_step_r[31]\ _05752_ \memory_i.freq_inst.cordic.rstn_i\ VPWR VGND sg13g2_o21ai_1
X_30048_ _01636_ _05646_ _06634_ _06635_ VPWR VGND sg13g2_a21oi_1
X_30049_ _06636_ _05646_ _06623_ VPWR VGND sg13g2_nand2_1
X_30050_ _06637_ \memory_i.freq_inst.dsmod_cos.data_step_r[32]\ _15970_ VPWR VGND sg13g2_nand2_1
X_30051_ _01637_ _06636_ _06637_ _06484_ VPWR VGND sg13g2_a21oi_1
X_30052_ _06638_ \memory_i.freq_inst.dsmod_cos.i_ena_mod\ \memory_i.freq_inst.dsmod_cos.data_interp_r[0]\ VPWR VGND sg13g2_nand2_1
X_30053_ _06639_ \memory_i.freq_inst.dsmod_cos.accu1_r[0]\ _06638_ VPWR VGND sg13g2_xor2_1
X_30054_ _01638_ _06287_ _06639_ VPWR VGND sg13g2_nor2_1
X_30055_ _06640_ \memory_i.freq_inst.dsmod_cos.accu1_r[0]\ \memory_i.freq_inst.dsmod_cos.data_interp_r[0]\ VPWR VGND sg13g2_nand2_1
X_30056_ _06641_ \memory_i.freq_inst.dsmod_cos.data_interp_r[1]\ _06640_ VPWR VGND sg13g2_xnor2_1
X_30057_ _06642_ \memory_i.freq_inst.dsmod_cos.i_ena_mod\ _06641_ VPWR VGND sg13g2_nand2_1
X_30058_ _06643_ \memory_i.freq_inst.dsmod_cos.accu1_r[1]\ _06642_ VPWR VGND sg13g2_xor2_1
X_30059_ _01639_ _06287_ _06643_ VPWR VGND sg13g2_nor2_1
X_30060_ _06644_ \memory_i.freq_inst.dsmod_cos.accu1_r[0]\ \memory_i.freq_inst.dsmod_cos.data_interp_r[0]\ \memory_i.freq_inst.dsmod_cos.data_interp_r[1]\ VPWR VGND sg13g2_a21o_1
X_30061_ _06645_ \memory_i.freq_inst.dsmod_cos.accu1_r[0]\ \memory_i.freq_inst.dsmod_cos.data_interp_r[1]\ \memory_i.freq_inst.dsmod_cos.data_interp_r[0]\ VPWR VGND sg13g2_and3_1
X_30062_ _06646_ \memory_i.freq_inst.dsmod_cos.accu1_r[1]\ _06644_ _06645_ VPWR VGND sg13g2_a21oi_1
X_30063_ _06647_ \memory_i.freq_inst.dsmod_cos.data_interp_r[2]\ _06646_ VPWR VGND sg13g2_xnor2_1
X_30064_ _06648_ \memory_i.freq_inst.dsmod_cos.i_ena_mod\ _06647_ VPWR VGND sg13g2_nand2_1
X_30065_ _06649_ \memory_i.freq_inst.dsmod_cos.accu1_r[2]\ _06648_ VPWR VGND sg13g2_xor2_1
X_30066_ _01640_ _06287_ _06649_ VPWR VGND sg13g2_nor2_1
X_30067_ _06650_ \memory_i.freq_inst.dsmod_cos.accu1_r[2]\ \memory_i.freq_inst.dsmod_cos.data_interp_r[2]\ VPWR VGND sg13g2_nor2_1
X_30068_ _06651_ \memory_i.freq_inst.dsmod_cos.accu1_r[2]\ \memory_i.freq_inst.dsmod_cos.data_interp_r[2]\ VPWR VGND sg13g2_nand2_1
X_30069_ _06652_ _06646_ _06650_ _06651_ VPWR VGND sg13g2_o21ai_1
X_30070_ _06653_ \memory_i.freq_inst.dsmod_cos.data_interp_r[3]\ _06652_ VPWR VGND sg13g2_or2_1
X_30071_ _06654_ \memory_i.freq_inst.dsmod_cos.data_interp_r[3]\ _06652_ VPWR VGND sg13g2_nand2_1
X_30072_ _06655_ \memory_i.freq_inst.dsmod_cos.i_ena_mod\ _06653_ _06654_ VPWR VGND sg13g2_and3_1
X_30073_ _06656_ \memory_i.freq_inst.dsmod_cos.accu1_r[3]\ _06655_ VPWR VGND sg13g2_xnor2_1
X_30074_ _01641_ _06287_ _06656_ VPWR VGND sg13g2_nor2_1
X_30075_ _06657_ \memory_i.freq_inst.dsmod_cos.data_interp_r[3]\ _06652_ \memory_i.freq_inst.dsmod_cos.accu1_r[3]\ VPWR VGND sg13g2_o21ai_1
X_30076_ _06658_ _06654_ _06657_ VPWR VGND sg13g2_nand2_1
X_30077_ _06659_ \memory_i.freq_inst.dsmod_cos.data_interp_r[4]\ _06658_ VPWR VGND sg13g2_xnor2_1
X_30078_ _06660_ _05650_ _06659_ VPWR VGND sg13g2_nor2_1
X_30079_ _06661_ \memory_i.freq_inst.dsmod_cos.accu1_r[4]\ _06660_ VPWR VGND sg13g2_xnor2_1
X_30080_ _01642_ _06287_ _06661_ VPWR VGND sg13g2_nor2_1
X_30081_ _06662_ \memory_i.freq_inst.dsmod_cos.data_interp_r[4]\ _06658_ \memory_i.freq_inst.dsmod_cos.accu1_r[4]\ VPWR VGND sg13g2_a21o_1
X_30082_ _06663_ \memory_i.freq_inst.dsmod_cos.data_interp_r[4]\ _06658_ _06662_ VPWR VGND sg13g2_o21ai_1
X_30083_ _06664_ _05691_ _06663_ VPWR VGND sg13g2_xnor2_1
X_30084_ _06665_ _05650_ _06664_ VPWR VGND sg13g2_nor2_1
X_30085_ _06666_ \memory_i.freq_inst.dsmod_cos.accu1_r[5]\ _06665_ VPWR VGND sg13g2_xnor2_1
X_30086_ _01643_ _06287_ _06666_ VPWR VGND sg13g2_nor2_1
X_30087_ _06667_ \memory_i.freq_inst.dsmod_cos.accu1_r[4]\ \memory_i.freq_inst.dsmod_cos.data_interp_r[4]\ VPWR VGND sg13g2_nor2_1
X_30088_ _06668_ \memory_i.freq_inst.dsmod_cos.accu1_r[5]\ \memory_i.freq_inst.dsmod_cos.data_interp_r[5]\ VPWR VGND sg13g2_nor2_1
X_30089_ _06669_ _06667_ _06668_ VPWR VGND sg13g2_nor2_1
X_30090_ _06670_ \memory_i.freq_inst.dsmod_cos.accu1_r[5]\ VPWR VGND sg13g2_inv_1
X_30091_ _06671_ \memory_i.freq_inst.dsmod_cos.accu1_r[4]\ \memory_i.freq_inst.dsmod_cos.data_interp_r[5]\ \memory_i.freq_inst.dsmod_cos.data_interp_r[4]\ VPWR VGND sg13g2_nand3_1
X_30092_ _06672_ \memory_i.freq_inst.dsmod_cos.accu1_r[4]\ \memory_i.freq_inst.dsmod_cos.data_interp_r[4]\ \memory_i.freq_inst.dsmod_cos.data_interp_r[5]\ VPWR VGND sg13g2_a21oi_1
X_30093_ _06673_ _06670_ _06671_ _06672_ VPWR VGND sg13g2_a21oi_1
X_30094_ _06674_ _06658_ _06669_ _06673_ VPWR VGND sg13g2_a21oi_1
X_30095_ _06675_ \memory_i.freq_inst.dsmod_cos.data_interp_r[6]\ _06674_ VPWR VGND sg13g2_xnor2_1
X_30096_ _06676_ \memory_i.freq_inst.dsmod_cos.i_ena_mod\ _06675_ VPWR VGND sg13g2_nand2_1
X_30097_ _06677_ \memory_i.freq_inst.dsmod_cos.accu1_r[6]\ _06676_ VPWR VGND sg13g2_xor2_1
X_30098_ _01644_ _06287_ _06677_ VPWR VGND sg13g2_nor2_1
X_30099_ _06678_ _03656_ VPWR VGND sg13g2_buf_1
X_30100_ _06679_ \memory_i.freq_inst.dsmod_cos.data_interp_r[7]\ VPWR VGND sg13g2_inv_1
X_30101_ _06680_ \memory_i.freq_inst.dsmod_cos.accu1_r[6]\ \memory_i.freq_inst.dsmod_cos.data_interp_r[6]\ VPWR VGND sg13g2_nor2_1
X_30102_ _06681_ _06667_ _06668_ _06680_ VPWR VGND sg13g2_or3_1
X_30103_ _06682_ _06654_ _06657_ _06681_ VPWR VGND sg13g2_a21oi_1
X_30104_ _06683_ \memory_i.freq_inst.dsmod_cos.accu1_r[6]\ \memory_i.freq_inst.dsmod_cos.data_interp_r[6]\ _06673_ VPWR VGND sg13g2_a21oi_1
X_30105_ _06684_ _06680_ _06683_ VPWR VGND sg13g2_nor2_1
X_30106_ _06685_ _06682_ _06684_ VPWR VGND sg13g2_nor2_1
X_30107_ _06686_ _06679_ _06685_ VPWR VGND sg13g2_xnor2_1
X_30108_ _06687_ _05650_ _06686_ VPWR VGND sg13g2_nor2_1
X_30109_ _06688_ \memory_i.freq_inst.dsmod_cos.accu1_r[7]\ _06687_ VPWR VGND sg13g2_xnor2_1
X_30110_ _01645_ _06678_ _06688_ VPWR VGND sg13g2_nor2_1
X_30111_ _06689_ \memory_i.freq_inst.dsmod_cos.accu1_r[8]\ VPWR VGND sg13g2_inv_1
X_30112_ _06690_ _06685_ VPWR VGND sg13g2_inv_1
X_30113_ _06691_ \memory_i.freq_inst.dsmod_cos.data_interp_r[7]\ _06690_ \memory_i.freq_inst.dsmod_cos.accu1_r[7]\ VPWR VGND sg13g2_a21oi_1
X_30114_ _06692_ _06679_ _06685_ _06691_ VPWR VGND sg13g2_a21oi_1
X_30115_ _06693_ _05718_ _06692_ VPWR VGND sg13g2_xnor2_1
X_30116_ _06694_ \memory_i.freq_inst.dsmod_cos.i_ena_mod\ _06693_ VPWR VGND sg13g2_nand2_1
X_30117_ _06695_ _06689_ _06694_ VPWR VGND sg13g2_xnor2_1
X_30118_ _01646_ _06678_ _06695_ VPWR VGND sg13g2_nor2_1
X_30119_ _06696_ _06684_ VPWR VGND sg13g2_inv_1
X_30120_ _06697_ \memory_i.freq_inst.dsmod_cos.accu1_r[8]\ \memory_i.freq_inst.dsmod_cos.data_interp_r[8]\ \memory_i.freq_inst.dsmod_cos.data_interp_r[7]\ \memory_i.freq_inst.dsmod_cos.accu1_r[7]\ VPWR
+ VGND
+ sg13g2_a22oi_1
X_30121_ _06698_ _06682_ _06696_ _06697_ VPWR VGND sg13g2_nand3b_1
X_30122_ _06699_ _06698_ VPWR VGND sg13g2_buf_1
X_30123_ _06700_ \memory_i.freq_inst.dsmod_cos.accu1_r[7]\ \memory_i.freq_inst.dsmod_cos.data_interp_r[7]\ \memory_i.freq_inst.dsmod_cos.data_interp_r[8]\ VPWR VGND sg13g2_o21ai_1
X_30124_ _06701_ \memory_i.freq_inst.dsmod_cos.accu1_r[7]\ \memory_i.freq_inst.dsmod_cos.data_interp_r[8]\ \memory_i.freq_inst.dsmod_cos.data_interp_r[7]\ VPWR VGND sg13g2_nor3_1
X_30125_ _06702_ _06689_ _06700_ _06701_ VPWR VGND sg13g2_a21oi_1
X_30126_ _06703_ _06699_ _06702_ VPWR VGND sg13g2_and2_1
X_30127_ _06704_ _06703_ VPWR VGND sg13g2_buf_1
X_30128_ _06705_ \memory_i.freq_inst.dsmod_cos.data_interp_r[9]\ _06704_ VPWR VGND sg13g2_xnor2_1
X_30129_ _06706_ _05650_ _06705_ VPWR VGND sg13g2_nor2_1
X_30130_ _06707_ \memory_i.freq_inst.dsmod_cos.accu1_r[9]\ _06706_ VPWR VGND sg13g2_xnor2_1
X_30131_ _01647_ _06678_ _06707_ VPWR VGND sg13g2_nor2_1
X_30132_ _06708_ \memory_i.freq_inst.dsmod_cos.data_interp_r[9]\ _06704_ \memory_i.freq_inst.dsmod_cos.accu1_r[9]\ VPWR VGND sg13g2_a21o_1
X_30133_ _06709_ \memory_i.freq_inst.dsmod_cos.data_interp_r[9]\ _06704_ _06708_ VPWR VGND sg13g2_o21ai_1
X_30134_ _06710_ \memory_i.freq_inst.dsmod_cos.data_interp_r[10]\ _06709_ VPWR VGND sg13g2_xnor2_1
X_30135_ _06711_ \memory_i.freq_inst.dsmod_cos.i_ena_mod\ _06710_ VPWR VGND sg13g2_nand2_1
X_30136_ _06712_ \memory_i.freq_inst.dsmod_cos.accu1_r[10]\ _06711_ VPWR VGND sg13g2_xor2_1
X_30137_ _01648_ _06678_ _06712_ VPWR VGND sg13g2_nor2_1
X_30138_ _06713_ \memory_i.freq_inst.dsmod_cos.accu1_r[10]\ \memory_i.freq_inst.dsmod_cos.data_interp_r[10]\ VPWR VGND sg13g2_nor2_1
X_30139_ _06714_ \memory_i.freq_inst.dsmod_cos.accu1_r[10]\ \memory_i.freq_inst.dsmod_cos.data_interp_r[10]\ VPWR VGND sg13g2_nand2_1
X_30140_ _06715_ _06709_ _06713_ _06714_ VPWR VGND sg13g2_o21ai_1
X_30141_ _06716_ _05754_ _06715_ VPWR VGND sg13g2_xnor2_1
X_30142_ _06717_ \memory_i.freq_inst.dsmod_cos.i_ena_mod\ _06716_ VPWR VGND sg13g2_nand2_1
X_30143_ _06718_ \memory_i.freq_inst.dsmod_cos.accu1_r[11]\ _06717_ VPWR VGND sg13g2_xor2_1
X_30144_ _01649_ _06678_ _06718_ VPWR VGND sg13g2_nor2_1
X_30145_ _06719_ \memory_i.freq_inst.dsmod_cos.data_interp_r[12]\ VPWR VGND sg13g2_inv_1
X_30146_ _06720_ _05754_ _05727_ _06714_ VPWR VGND sg13g2_nand3_1
X_30147_ _06721_ \memory_i.freq_inst.dsmod_cos.accu1_r[9]\ _05754_ _06714_ VPWR VGND sg13g2_nand3b_1
X_30148_ _06722_ _06699_ _06702_ _06720_ _06721_ VPWR
+ VGND
+ sg13g2_a22oi_1
X_30149_ _06723_ \memory_i.freq_inst.dsmod_cos.data_interp_r[9]\ _06721_ VPWR VGND sg13g2_nor2_1
X_30150_ _06724_ \memory_i.freq_inst.dsmod_cos.accu1_r[10]\ \memory_i.freq_inst.dsmod_cos.data_interp_r[10]\ VPWR VGND sg13g2_or2_1
X_30151_ _06725_ _06724_ VPWR VGND sg13g2_buf_1
X_30152_ _06726_ \memory_i.freq_inst.dsmod_cos.data_interp_r[11]\ _06725_ VPWR VGND sg13g2_nor2_1
X_30153_ _06727_ _06722_ _06723_ _06726_ VPWR VGND sg13g2_nor3_1
X_30154_ _06728_ _05754_ _05727_ VPWR VGND sg13g2_nor2_1
X_30155_ _06729_ _06699_ _06702_ _06725_ _06728_ VPWR
+ VGND
+ sg13g2_nand4_1
X_30156_ _06730_ \memory_i.freq_inst.dsmod_cos.accu1_r[9]\ \memory_i.freq_inst.dsmod_cos.data_interp_r[11]\ _06725_ VPWR VGND sg13g2_and3_1
X_30157_ _06731_ _06699_ _06702_ _06730_ VPWR VGND sg13g2_nand3_1
X_30158_ _06732_ \memory_i.freq_inst.dsmod_cos.accu1_r[10]\ \memory_i.freq_inst.dsmod_cos.data_interp_r[10]\ VPWR VGND sg13g2_and2_1
X_30159_ _06733_ \memory_i.freq_inst.dsmod_cos.data_interp_r[11]\ _06732_ _06730_ \memory_i.freq_inst.dsmod_cos.data_interp_r[9]\ VPWR
+ VGND
+ sg13g2_a22oi_1
X_30160_ _06734_ _06729_ _06731_ _06733_ VPWR VGND sg13g2_nand3_1
X_30161_ _06735_ \memory_i.freq_inst.dsmod_cos.accu1_r[11]\ _06727_ _06734_ VPWR VGND sg13g2_a21o_1
X_30162_ _06736_ _06735_ VPWR VGND sg13g2_buf_1
X_30163_ _06737_ _06719_ _06736_ VPWR VGND sg13g2_xnor2_1
X_30164_ _06738_ \memory_i.freq_inst.dsmod_cos.i_ena_mod\ _06737_ VPWR VGND sg13g2_nand2_1
X_30165_ _06739_ \memory_i.freq_inst.dsmod_cos.accu1_r[12]\ _06738_ VPWR VGND sg13g2_xor2_1
X_30166_ _01650_ _06678_ _06739_ VPWR VGND sg13g2_nor2_1
X_30167_ _06740_ \memory_i.freq_inst.dsmod_cos.data_interp_r[12]\ _06736_ VPWR VGND sg13g2_nor2_1
X_30168_ _06741_ \memory_i.freq_inst.dsmod_cos.data_interp_r[12]\ _06736_ \memory_i.freq_inst.dsmod_cos.accu1_r[12]\ VPWR VGND sg13g2_a21oi_1
X_30169_ _06742_ _06740_ _06741_ _05770_ VPWR VGND sg13g2_o21ai_1
X_30170_ _06743_ _05770_ _06740_ _06741_ VPWR VGND sg13g2_or3_1
X_30171_ _06744_ \memory_i.freq_inst.dsmod_cos.i_ena_mod\ _06742_ _06743_ VPWR VGND sg13g2_nand3_1
X_30172_ _06745_ \memory_i.freq_inst.dsmod_cos.accu1_r[13]\ _06744_ VPWR VGND sg13g2_xor2_1
X_30173_ _01651_ _06678_ _06745_ VPWR VGND sg13g2_nor2_1
X_30174_ _06746_ \memory_i.freq_inst.dsmod_cos.accu1_r[13]\ _06742_ VPWR VGND sg13g2_nand2_1
X_30175_ _06747_ _06743_ _06746_ VPWR VGND sg13g2_nand2_1
X_30176_ _06748_ \memory_i.freq_inst.dsmod_cos.data_interp_r[14]\ _06747_ VPWR VGND sg13g2_xnor2_1
X_30177_ _06749_ _05650_ _06748_ VPWR VGND sg13g2_nor2_1
X_30178_ _06750_ \memory_i.freq_inst.dsmod_cos.accu1_r[14]\ _06749_ VPWR VGND sg13g2_xnor2_1
X_30179_ _01652_ _06678_ _06750_ VPWR VGND sg13g2_nor2_1
X_30180_ _06751_ \memory_i.freq_inst.dsmod_cos.accu1_r[14]\ _06747_ \memory_i.freq_inst.dsmod_cos.data_interp_r[14]\ VPWR VGND sg13g2_o21ai_1
X_30181_ _06752_ _06751_ VPWR VGND sg13g2_inv_1
X_30182_ _06753_ \memory_i.freq_inst.dsmod_cos.accu1_r[14]\ _06747_ _06752_ VPWR VGND sg13g2_a21oi_1
X_30183_ _06754_ \memory_i.freq_inst.dsmod_cos.data_interp_r[15]\ _06753_ VPWR VGND sg13g2_xnor2_1
X_30184_ _06755_ \memory_i.freq_inst.dsmod_cos.i_ena_mod\ _06754_ VPWR VGND sg13g2_nand2_1
X_30185_ _06756_ \memory_i.freq_inst.dsmod_cos.accu1_r[15]\ _06755_ VPWR VGND sg13g2_xor2_1
X_30186_ _01653_ _06678_ _06756_ VPWR VGND sg13g2_nor2_1
X_30187_ _06757_ \memory_i.freq_inst.dsmod_cos.accu1_r[16]\ VPWR VGND sg13g2_inv_1
X_30188_ _06758_ \memory_i.freq_inst.dsmod_cos.accu1_r[12]\ \memory_i.freq_inst.dsmod_cos.data_interp_r[12]\ VPWR VGND sg13g2_xnor2_1
X_30189_ _06759_ \memory_i.freq_inst.dsmod_cos.accu1_r[15]\ \memory_i.freq_inst.dsmod_cos.data_interp_r[15]\ VPWR VGND sg13g2_xnor2_1
X_30190_ _06760_ \memory_i.freq_inst.dsmod_cos.accu1_r[14]\ \memory_i.freq_inst.dsmod_cos.data_interp_r[14]\ VPWR VGND sg13g2_xnor2_1
X_30191_ _06761_ \memory_i.freq_inst.dsmod_cos.accu1_r[13]\ \memory_i.freq_inst.dsmod_cos.data_interp_r[13]\ VPWR VGND sg13g2_xnor2_1
X_30192_ _06762_ _06758_ _06759_ _06760_ _06761_ VPWR
+ VGND
+ sg13g2_nor4_1
X_30193_ _06763_ \memory_i.freq_inst.dsmod_cos.accu1_r[11]\ _06762_ VPWR VGND sg13g2_and2_1
X_30194_ _06764_ \memory_i.freq_inst.dsmod_cos.accu1_r[14]\ \memory_i.freq_inst.dsmod_cos.data_interp_r[14]\ VPWR VGND sg13g2_nor2_1
X_30195_ _06765_ \memory_i.freq_inst.dsmod_cos.accu1_r[12]\ \memory_i.freq_inst.dsmod_cos.data_interp_r[12]\ \memory_i.freq_inst.dsmod_cos.data_interp_r[13]\ VPWR VGND sg13g2_a21o_1
X_30196_ _06766_ \memory_i.freq_inst.dsmod_cos.accu1_r[12]\ \memory_i.freq_inst.dsmod_cos.data_interp_r[13]\ \memory_i.freq_inst.dsmod_cos.data_interp_r[12]\ VPWR VGND sg13g2_and3_1
X_30197_ _06767_ \memory_i.freq_inst.dsmod_cos.accu1_r[14]\ \memory_i.freq_inst.dsmod_cos.data_interp_r[14]\ _06765_ \memory_i.freq_inst.dsmod_cos.accu1_r[13]\ _06766_
+ VPWR
+ VGND sg13g2_a221oi_1
X_30198_ _06768_ _06764_ _06767_ VPWR VGND sg13g2_nor2_1
X_30199_ _06769_ \memory_i.freq_inst.dsmod_cos.data_interp_r[15]\ _06768_ VPWR VGND sg13g2_nor2_1
X_30200_ _06770_ \memory_i.freq_inst.dsmod_cos.data_interp_r[15]\ _06768_ \memory_i.freq_inst.dsmod_cos.accu1_r[15]\ VPWR VGND sg13g2_a21oi_1
X_30201_ _06771_ _06769_ _06770_ VPWR VGND sg13g2_nor2_1
X_30202_ _06772_ _06734_ _06762_ _06763_ _06727_ _06771_
+ VPWR
+ VGND sg13g2_a221oi_1
X_30203_ _06773_ _05804_ _06772_ VPWR VGND sg13g2_nand2_1
X_30204_ _06774_ _06772_ \memory_i.freq_inst.dsmod_cos.data_interp_r[16]\ VPWR VGND sg13g2_nand2b_1
X_30205_ _06775_ \memory_i.freq_inst.dsmod_cos.i_ena_mod\ _06773_ _06774_ VPWR VGND sg13g2_nand3_1
X_30206_ _06776_ _06757_ _06775_ VPWR VGND sg13g2_xnor2_1
X_30207_ _01654_ _06678_ _06776_ VPWR VGND sg13g2_nor2_1
X_30208_ _06777_ _03656_ VPWR VGND sg13g2_buf_1
X_30209_ _06778_ \memory_i.freq_inst.dsmod_cos.data_interp_r[17]\ VPWR VGND sg13g2_inv_1
X_30210_ _06779_ _06757_ _06774_ VPWR VGND sg13g2_nand2_1
X_30211_ _06780_ _06773_ _06779_ VPWR VGND sg13g2_nand2_1
X_30212_ _06781_ _06778_ _06780_ VPWR VGND sg13g2_xnor2_1
X_30213_ _06782_ _05650_ _06781_ VPWR VGND sg13g2_nor2_1
X_30214_ _06783_ \memory_i.freq_inst.dsmod_cos.accu1_r[17]\ _06782_ VPWR VGND sg13g2_xnor2_1
X_30215_ _01655_ _06777_ _06783_ VPWR VGND sg13g2_nor2_1
X_30216_ _06784_ \memory_i.freq_inst.dsmod_cos.accu1_r[17]\ VPWR VGND sg13g2_inv_1
X_30217_ _06785_ _06784_ _06778_ _05804_ _06757_ _06772_
+ VPWR
+ VGND sg13g2_a221oi_1
X_30218_ _06786_ _06757_ _05804_ VPWR VGND sg13g2_nor2_1
X_30219_ _06787_ \memory_i.freq_inst.dsmod_cos.accu1_r[17]\ \memory_i.freq_inst.dsmod_cos.data_interp_r[17]\ _06786_ VPWR VGND sg13g2_o21ai_1
X_30220_ _06788_ _06784_ _06778_ _06787_ VPWR VGND sg13g2_o21ai_1
X_30221_ _06789_ _06785_ _06788_ VPWR VGND sg13g2_nor2_1
X_30222_ _06790_ _05820_ _06789_ VPWR VGND sg13g2_xnor2_1
X_30223_ _06791_ _05650_ _06790_ VPWR VGND sg13g2_nor2_1
X_30224_ _06792_ \memory_i.freq_inst.dsmod_cos.accu1_r[18]\ _06791_ VPWR VGND sg13g2_xnor2_1
X_30225_ _01656_ _06777_ _06792_ VPWR VGND sg13g2_nor2_1
X_30226_ _06793_ _05649_ VPWR VGND sg13g2_buf_1
X_30227_ _06794_ _06785_ _06788_ VPWR VGND sg13g2_or2_1
X_30228_ _06795_ _06794_ VPWR VGND sg13g2_buf_1
X_30229_ _06796_ \memory_i.freq_inst.dsmod_cos.data_interp_r[18]\ _06795_ \memory_i.freq_inst.dsmod_cos.accu1_r[18]\ VPWR VGND sg13g2_o21ai_1
X_30230_ _06797_ _05820_ _06789_ _06796_ VPWR VGND sg13g2_o21ai_1
X_30231_ _06798_ \memory_i.freq_inst.dsmod_cos.data_interp_r[19]\ _06797_ VPWR VGND sg13g2_xnor2_1
X_30232_ _06799_ _06793_ _06798_ VPWR VGND sg13g2_nor2_1
X_30233_ _06800_ \memory_i.freq_inst.dsmod_cos.accu1_r[19]\ _06799_ VPWR VGND sg13g2_xnor2_1
X_30234_ _01657_ _06777_ _06800_ VPWR VGND sg13g2_nor2_1
X_30235_ _06801_ \memory_i.freq_inst.dsmod_cos.data_interp_r[20]\ \memory_i.freq_inst.dsmod_cos.data_interp_r[19]\ \memory_i.freq_inst.dsmod_cos.data_interp_r[18]\ VPWR VGND sg13g2_or3_1
X_30236_ _06802_ \memory_i.freq_inst.dsmod_cos.accu1_r[19]\ \memory_i.freq_inst.dsmod_cos.data_interp_r[20]\ \memory_i.freq_inst.dsmod_cos.data_interp_r[18]\ VPWR VGND sg13g2_or3_1
X_30237_ _06803_ _06801_ _06802_ _06795_ VPWR VGND sg13g2_a21oi_1
X_30238_ _06804_ \memory_i.freq_inst.dsmod_cos.accu1_r[18]\ \memory_i.freq_inst.dsmod_cos.data_interp_r[20]\ \memory_i.freq_inst.dsmod_cos.data_interp_r[19]\ VPWR VGND sg13g2_or3_1
X_30239_ _06805_ \memory_i.freq_inst.dsmod_cos.accu1_r[19]\ \memory_i.freq_inst.dsmod_cos.accu1_r[18]\ \memory_i.freq_inst.dsmod_cos.data_interp_r[20]\ VPWR VGND sg13g2_or3_1
X_30240_ _06806_ _06804_ _06805_ _06795_ VPWR VGND sg13g2_a21oi_1
X_30241_ _06807_ \memory_i.freq_inst.dsmod_cos.accu1_r[18]\ \memory_i.freq_inst.dsmod_cos.data_interp_r[20]\ \memory_i.freq_inst.dsmod_cos.data_interp_r[19]\ \memory_i.freq_inst.dsmod_cos.data_interp_r[18]\ VPWR
+ VGND
+ sg13g2_nor4_1
X_30242_ _06808_ \memory_i.freq_inst.dsmod_cos.accu1_r[19]\ \memory_i.freq_inst.dsmod_cos.accu1_r[18]\ \memory_i.freq_inst.dsmod_cos.data_interp_r[20]\ \memory_i.freq_inst.dsmod_cos.data_interp_r[18]\ VPWR
+ VGND
+ sg13g2_nor4_1
X_30243_ _06809_ \memory_i.freq_inst.dsmod_cos.accu1_r[19]\ \memory_i.freq_inst.dsmod_cos.data_interp_r[20]\ \memory_i.freq_inst.dsmod_cos.data_interp_r[19]\ VPWR VGND sg13g2_nor3_1
X_30244_ _06810_ _06807_ _06808_ _06809_ VPWR VGND sg13g2_or3_1
X_30245_ _06811_ _06810_ VPWR VGND sg13g2_buf_1
X_30246_ _06812_ _06803_ _06806_ _06811_ VPWR VGND sg13g2_or3_1
X_30247_ _06813_ \memory_i.freq_inst.dsmod_cos.data_interp_r[20]\ \memory_i.freq_inst.dsmod_cos.data_interp_r[19]\ \memory_i.freq_inst.dsmod_cos.data_interp_r[18]\ VPWR VGND sg13g2_nand3_1
X_30248_ _06814_ \memory_i.freq_inst.dsmod_cos.accu1_r[19]\ \memory_i.freq_inst.dsmod_cos.data_interp_r[20]\ \memory_i.freq_inst.dsmod_cos.data_interp_r[18]\ VPWR VGND sg13g2_nand3_1
X_30249_ _06815_ _06813_ _06814_ _06789_ VPWR VGND sg13g2_a21oi_1
X_30250_ _06816_ \memory_i.freq_inst.dsmod_cos.accu1_r[18]\ \memory_i.freq_inst.dsmod_cos.data_interp_r[20]\ \memory_i.freq_inst.dsmod_cos.data_interp_r[19]\ VPWR VGND sg13g2_nand3_1
X_30251_ _06817_ \memory_i.freq_inst.dsmod_cos.accu1_r[19]\ \memory_i.freq_inst.dsmod_cos.accu1_r[18]\ \memory_i.freq_inst.dsmod_cos.data_interp_r[20]\ VPWR VGND sg13g2_nand3_1
X_30252_ _06818_ _06816_ _06817_ _06789_ VPWR VGND sg13g2_a21oi_1
X_30253_ _06819_ \memory_i.freq_inst.dsmod_cos.accu1_r[18]\ \memory_i.freq_inst.dsmod_cos.data_interp_r[20]\ \memory_i.freq_inst.dsmod_cos.data_interp_r[19]\ \memory_i.freq_inst.dsmod_cos.data_interp_r[18]\ VPWR
+ VGND
+ sg13g2_nand4_1
X_30254_ _06820_ \memory_i.freq_inst.dsmod_cos.accu1_r[19]\ \memory_i.freq_inst.dsmod_cos.accu1_r[18]\ \memory_i.freq_inst.dsmod_cos.data_interp_r[20]\ \memory_i.freq_inst.dsmod_cos.data_interp_r[18]\ VPWR
+ VGND
+ sg13g2_nand4_1
X_30255_ _06821_ \memory_i.freq_inst.dsmod_cos.accu1_r[19]\ \memory_i.freq_inst.dsmod_cos.data_interp_r[20]\ \memory_i.freq_inst.dsmod_cos.data_interp_r[19]\ VPWR VGND sg13g2_nand3_1
X_30256_ _06822_ _06819_ _06820_ _06821_ VPWR VGND sg13g2_nand3_1
X_30257_ _06823_ _06812_ _06815_ _06818_ _06822_ VPWR
+ VGND
+ sg13g2_nor4_1
X_30258_ _06824_ \memory_i.freq_inst.dsmod_cos.i_ena_mod\ _06823_ VPWR VGND sg13g2_nand2_1
X_30259_ _06825_ \memory_i.freq_inst.dsmod_cos.accu1_r[20]\ _06824_ VPWR VGND sg13g2_xor2_1
X_30260_ _01658_ _06777_ _06825_ VPWR VGND sg13g2_nor2_1
X_30261_ _06826_ \memory_i.freq_inst.dsmod_cos.accu1_r[20]\ _06815_ _06818_ _06822_ VPWR
+ VGND
+ sg13g2_or4_1
X_30262_ _06827_ _06812_ _06826_ VPWR VGND sg13g2_nor2b_1
X_30263_ _06828_ \memory_i.freq_inst.dsmod_cos.data_interp_r[21]\ _06827_ VPWR VGND sg13g2_xnor2_1
X_30264_ _06829_ _06793_ _06828_ VPWR VGND sg13g2_nor2_1
X_30265_ _06830_ \memory_i.freq_inst.dsmod_cos.accu1_r[21]\ _06829_ VPWR VGND sg13g2_xnor2_1
X_30266_ _01659_ _06777_ _06830_ VPWR VGND sg13g2_nor2_1
X_30267_ _06831_ \memory_i.freq_inst.dsmod_cos.data_interp_r[22]\ VPWR VGND sg13g2_inv_1
X_30268_ _06832_ \memory_i.freq_inst.dsmod_cos.data_interp_r[21]\ _06827_ \memory_i.freq_inst.dsmod_cos.accu1_r[21]\ VPWR VGND sg13g2_a21o_1
X_30269_ _06833_ \memory_i.freq_inst.dsmod_cos.data_interp_r[21]\ _06827_ _06832_ VPWR VGND sg13g2_o21ai_1
X_30270_ _06834_ _06831_ _06833_ VPWR VGND sg13g2_xnor2_1
X_30271_ _06835_ _06793_ _06834_ VPWR VGND sg13g2_nor2_1
X_30272_ _06836_ \memory_i.freq_inst.dsmod_cos.accu1_r[22]\ _06835_ VPWR VGND sg13g2_xnor2_1
X_30273_ _01660_ _06777_ _06836_ VPWR VGND sg13g2_nor2_1
X_30274_ _06837_ \memory_i.freq_inst.dsmod_cos.data_interp_r[23]\ VPWR VGND sg13g2_inv_1
X_30275_ _06838_ \memory_i.freq_inst.dsmod_cos.accu1_r[22]\ \memory_i.freq_inst.dsmod_cos.data_interp_r[22]\ VPWR VGND sg13g2_or2_1
X_30276_ _06839_ _06838_ VPWR VGND sg13g2_buf_1
X_30277_ _06840_ \memory_i.freq_inst.dsmod_cos.data_interp_r[21]\ _06839_ VPWR VGND sg13g2_nand2_1
X_30278_ _06841_ _06803_ _06806_ _06811_ _06840_ VPWR
+ VGND
+ sg13g2_nor4_1
X_30279_ _06842_ \memory_i.freq_inst.dsmod_cos.accu1_r[21]\ _06839_ VPWR VGND sg13g2_nand2_1
X_30280_ _06843_ _06803_ _06806_ _06811_ _06842_ VPWR
+ VGND
+ sg13g2_nor4_1
X_30281_ _06844_ _06841_ _06843_ _06826_ VPWR VGND sg13g2_o21ai_1
X_30282_ _06845_ \memory_i.freq_inst.dsmod_cos.accu1_r[21]\ \memory_i.freq_inst.dsmod_cos.data_interp_r[21]\ _06839_ VPWR VGND sg13g2_and3_1
X_30283_ _06846_ \memory_i.freq_inst.dsmod_cos.accu1_r[22]\ \memory_i.freq_inst.dsmod_cos.data_interp_r[22]\ _06845_ VPWR VGND sg13g2_a21oi_1
X_30284_ _06847_ _06837_ _06844_ _06846_ VPWR VGND sg13g2_and3_1
X_30285_ _06848_ _06844_ _06846_ _06837_ VPWR VGND sg13g2_a21oi_1
X_30286_ _06849_ _05783_ _06847_ _06848_ VPWR VGND sg13g2_nor3_1
X_30287_ _06850_ \memory_i.freq_inst.dsmod_cos.accu1_r[23]\ _06849_ VPWR VGND sg13g2_xnor2_1
X_30288_ _01661_ _06777_ _06850_ VPWR VGND sg13g2_nor2_1
X_30289_ _06851_ \memory_i.freq_inst.dsmod_cos.accu1_r[23]\ _06848_ VPWR VGND sg13g2_nor2_1
X_30290_ _06852_ _06847_ _06851_ VPWR VGND sg13g2_nor2_1
X_30291_ _06853_ \memory_i.freq_inst.dsmod_cos.data_interp_r[24]\ _06852_ VPWR VGND sg13g2_xor2_1
X_30292_ _06854_ \memory_i.freq_inst.dsmod_cos.i_ena_mod\ _06853_ VPWR VGND sg13g2_nand2_1
X_30293_ _06855_ \memory_i.freq_inst.dsmod_cos.accu1_r[24]\ _06854_ VPWR VGND sg13g2_xor2_1
X_30294_ _01662_ _06777_ _06855_ VPWR VGND sg13g2_nor2_1
X_30295_ _06856_ \memory_i.freq_inst.dsmod_cos.data_interp_r[24]\ _06852_ VPWR VGND sg13g2_nor2_1
X_30296_ _06857_ \memory_i.freq_inst.dsmod_cos.data_interp_r[24]\ _06852_ \memory_i.freq_inst.dsmod_cos.accu1_r[24]\ VPWR VGND sg13g2_a21oi_1
X_30297_ _06858_ _06856_ _06857_ VPWR VGND sg13g2_nor2_1
X_30298_ _06859_ \memory_i.freq_inst.dsmod_cos.data_interp_r[25]\ _06858_ VPWR VGND sg13g2_nor2_1
X_30299_ _06860_ \memory_i.freq_inst.dsmod_cos.data_interp_r[25]\ VPWR VGND sg13g2_inv_1
X_30300_ _06861_ _06860_ _06856_ _06857_ VPWR VGND sg13g2_nor3_1
X_30301_ _06862_ _05783_ _06859_ _06861_ VPWR VGND sg13g2_nor3_1
X_30302_ _06863_ \memory_i.freq_inst.dsmod_cos.accu1_r[25]\ _06862_ VPWR VGND sg13g2_xnor2_1
X_30303_ _01663_ _06777_ _06863_ VPWR VGND sg13g2_nor2_1
X_30304_ _06864_ \memory_i.freq_inst.dsmod_cos.accu1_r[26]\ VPWR VGND sg13g2_inv_1
X_30305_ _06865_ _06856_ _06857_ _06860_ VPWR VGND sg13g2_o21ai_1
X_30306_ _06866_ \memory_i.freq_inst.dsmod_cos.accu1_r[25]\ _06865_ _06861_ VPWR VGND sg13g2_a21oi_1
X_30307_ _06867_ \memory_i.freq_inst.dsmod_cos.data_interp_r[26]\ _06866_ VPWR VGND sg13g2_xnor2_1
X_30308_ _06868_ \memory_i.freq_inst.dsmod_cos.i_ena_mod\ _06867_ VPWR VGND sg13g2_nand2_1
X_30309_ _06869_ _06864_ _06868_ VPWR VGND sg13g2_xnor2_1
X_30310_ _01664_ _06777_ _06869_ VPWR VGND sg13g2_nor2_1
X_30311_ _06870_ _12944_ VPWR VGND sg13g2_buf_1
X_30312_ _06871_ _06870_ VPWR VGND sg13g2_buf_1
X_30313_ _06872_ \memory_i.freq_inst.dsmod_cos.data_interp_r[26]\ VPWR VGND sg13g2_inv_1
X_30314_ _06873_ _06864_ _06866_ _06872_ VPWR VGND sg13g2_a21oi_1
X_30315_ _06874_ _06864_ _06866_ VPWR VGND sg13g2_nor2_1
X_30316_ _06875_ _06873_ _06874_ VPWR VGND sg13g2_nor2_1
X_30317_ _06876_ \memory_i.freq_inst.dsmod_cos.data_interp_r[27]\ _06875_ VPWR VGND sg13g2_xnor2_1
X_30318_ _06877_ \memory_i.freq_inst.dsmod_cos.i_ena_mod\ _06876_ VPWR VGND sg13g2_nand2_1
X_30319_ _06878_ \memory_i.freq_inst.dsmod_cos.accu1_r[27]\ _06877_ VPWR VGND sg13g2_xor2_1
X_30320_ _01665_ _06871_ _06878_ VPWR VGND sg13g2_nor2_1
X_30321_ _06879_ \memory_i.freq_inst.dsmod_cos.accu1_r[24]\ \memory_i.freq_inst.dsmod_cos.data_interp_r[24]\ VPWR VGND sg13g2_xnor2_1
X_30322_ _06880_ \memory_i.freq_inst.dsmod_cos.accu1_r[26]\ \memory_i.freq_inst.dsmod_cos.data_interp_r[26]\ VPWR VGND sg13g2_xnor2_1
X_30323_ _06881_ \memory_i.freq_inst.dsmod_cos.accu1_r[27]\ \memory_i.freq_inst.dsmod_cos.data_interp_r[27]\ VPWR VGND sg13g2_xnor2_1
X_30324_ _06882_ \memory_i.freq_inst.dsmod_cos.accu1_r[25]\ \memory_i.freq_inst.dsmod_cos.data_interp_r[25]\ VPWR VGND sg13g2_xnor2_1
X_30325_ _06883_ _06879_ _06880_ _06881_ _06882_ VPWR
+ VGND
+ sg13g2_nor4_1
X_30326_ _06884_ \memory_i.freq_inst.dsmod_cos.data_interp_r[23]\ _06883_ VPWR VGND sg13g2_nand2_1
X_30327_ _06885_ \memory_i.freq_inst.dsmod_cos.accu1_r[23]\ _06883_ VPWR VGND sg13g2_nand2_1
X_30328_ _06886_ _06844_ _06846_ _06884_ _06885_ VPWR
+ VGND
+ sg13g2_a22oi_1
X_30329_ _06887_ _06886_ VPWR VGND sg13g2_buf_1
X_30330_ _06888_ \memory_i.freq_inst.dsmod_cos.accu1_r[24]\ \memory_i.freq_inst.dsmod_cos.data_interp_r[24]\ \memory_i.freq_inst.dsmod_cos.data_interp_r[25]\ VPWR VGND sg13g2_a21o_1
X_30331_ _06889_ \memory_i.freq_inst.dsmod_cos.accu1_r[24]\ \memory_i.freq_inst.dsmod_cos.data_interp_r[25]\ \memory_i.freq_inst.dsmod_cos.data_interp_r[24]\ VPWR VGND sg13g2_and3_1
X_30332_ _06890_ \memory_i.freq_inst.dsmod_cos.accu1_r[26]\ \memory_i.freq_inst.dsmod_cos.data_interp_r[26]\ _06888_ \memory_i.freq_inst.dsmod_cos.accu1_r[25]\ _06889_
+ VPWR
+ VGND sg13g2_a221oi_1
X_30333_ _06891_ _06864_ _06872_ _06890_ VPWR VGND sg13g2_a21oi_1
X_30334_ _06892_ \memory_i.freq_inst.dsmod_cos.data_interp_r[27]\ _06891_ \memory_i.freq_inst.dsmod_cos.accu1_r[27]\ VPWR VGND sg13g2_o21ai_1
X_30335_ _06893_ \memory_i.freq_inst.dsmod_cos.data_interp_r[27]\ _06891_ VPWR VGND sg13g2_nand2_1
X_30336_ _06894_ \memory_i.freq_inst.dsmod_cos.accu1_r[23]\ \memory_i.freq_inst.dsmod_cos.data_interp_r[23]\ _06883_ VPWR VGND sg13g2_nand3_1
X_30337_ _06895_ _06892_ _06893_ _06894_ VPWR VGND sg13g2_nand3_1
X_30338_ _06896_ _06895_ VPWR VGND sg13g2_buf_1
X_30339_ _06897_ \memory_i.freq_inst.dsmod_cos.data_interp_r[28]\ _06887_ _06896_ VPWR VGND sg13g2_nor3_1
X_30340_ _06898_ _06887_ _06896_ VPWR VGND sg13g2_nor2_1
X_30341_ _06899_ _06898_ \memory_i.freq_inst.dsmod_cos.data_interp_r[28]\ VPWR VGND sg13g2_nor2b_1
X_30342_ _06900_ _05783_ _06897_ _06899_ VPWR VGND sg13g2_nor3_1
X_30343_ _06901_ \memory_i.freq_inst.dsmod_cos.accu1_r[28]\ _06900_ VPWR VGND sg13g2_xnor2_1
X_30344_ _01666_ _06871_ _06901_ VPWR VGND sg13g2_nor2_1
X_30345_ _06902_ \memory_i.freq_inst.dsmod_cos.accu1_r[29]\ VPWR VGND sg13g2_inv_1
X_30346_ _06903_ \memory_i.freq_inst.dsmod_cos.accu1_r[28]\ VPWR VGND sg13g2_inv_1
X_30347_ _06904_ _06887_ _06896_ \memory_i.freq_inst.dsmod_cos.data_interp_r[28]\ VPWR VGND sg13g2_o21ai_1
X_30348_ _06905_ _06903_ _06904_ _06897_ VPWR VGND sg13g2_a21oi_1
X_30349_ _06906_ _05935_ _06905_ VPWR VGND sg13g2_xnor2_1
X_30350_ _06907_ \memory_i.freq_inst.dsmod_cos.i_ena_mod\ _06906_ VPWR VGND sg13g2_nand2_1
X_30351_ _06908_ _06902_ _06907_ VPWR VGND sg13g2_xnor2_1
X_30352_ _01667_ _06871_ _06908_ VPWR VGND sg13g2_nor2_1
X_30353_ _06909_ \memory_i.freq_inst.dsmod_cos.accu1_r[29]\ \memory_i.freq_inst.dsmod_cos.data_interp_r[29]\ _06905_ VPWR VGND sg13g2_a21oi_1
X_30354_ _06910_ _06902_ _05935_ _06909_ VPWR VGND sg13g2_a21oi_1
X_30355_ _06911_ \memory_i.freq_inst.dsmod_cos.data_interp_r[30]\ _06910_ VPWR VGND sg13g2_xor2_1
X_30356_ _06912_ \memory_i.freq_inst.dsmod_cos.i_ena_mod\ _06911_ VPWR VGND sg13g2_nand2_1
X_30357_ _06913_ \memory_i.freq_inst.dsmod_cos.accu1_r[30]\ _06912_ VPWR VGND sg13g2_xor2_1
X_30358_ _01668_ _06871_ _06913_ VPWR VGND sg13g2_nor2_1
X_30359_ _06914_ \memory_i.freq_inst.dsmod_cos.accu1_r[30]\ \memory_i.freq_inst.dsmod_cos.data_interp_r[30]\ VPWR VGND sg13g2_and2_1
X_30360_ _06915_ \memory_i.freq_inst.dsmod_cos.data_interp_r[30]\ \memory_i.freq_inst.dsmod_cos.data_interp_r[29]\ VPWR VGND sg13g2_nand2_1
X_30361_ _06916_ \memory_i.freq_inst.dsmod_cos.accu1_r[30]\ \memory_i.freq_inst.dsmod_cos.data_interp_r[29]\ VPWR VGND sg13g2_nand2_1
X_30362_ _06917_ _06903_ _06904_ _06915_ _06916_ _06897_
+ VPWR
+ VGND sg13g2_a221oi_1
X_30363_ _06918_ \memory_i.freq_inst.dsmod_cos.accu1_r[29]\ \memory_i.freq_inst.dsmod_cos.data_interp_r[30]\ VPWR VGND sg13g2_nand2_1
X_30364_ _06919_ \memory_i.freq_inst.dsmod_cos.accu1_r[30]\ \memory_i.freq_inst.dsmod_cos.accu1_r[29]\ VPWR VGND sg13g2_nand2_1
X_30365_ _06920_ _06903_ _06904_ _06918_ _06919_ _06897_
+ VPWR
+ VGND sg13g2_a221oi_1
X_30366_ _06921_ _06918_ _06919_ _05935_ VPWR VGND sg13g2_a21oi_1
X_30367_ _06922_ _06914_ _06917_ _06920_ _06921_ VPWR
+ VGND
+ sg13g2_nor4_1
X_30368_ _06923_ \memory_i.freq_inst.dsmod_cos.data_interp_r[31]\ _06922_ VPWR VGND sg13g2_xnor2_1
X_30369_ _06924_ \memory_i.freq_inst.dsmod_cos.i_ena_mod\ _06923_ VPWR VGND sg13g2_nand2_1
X_30370_ _06925_ \memory_i.freq_inst.dsmod_cos.accu1_r[31]\ _06924_ VPWR VGND sg13g2_xor2_1
X_30371_ _01669_ _06871_ _06925_ VPWR VGND sg13g2_nor2_1
X_30372_ _06926_ \memory_i.freq_inst.dsmod_cos.accu1_r[31]\ \memory_i.freq_inst.dsmod_cos.data_interp_r[31]\ VPWR VGND sg13g2_nand2_1
X_30373_ _06927_ \memory_i.freq_inst.dsmod_cos.accu1_r[31]\ \memory_i.freq_inst.dsmod_cos.data_interp_r[31]\ VPWR VGND sg13g2_nor2_1
X_30374_ _06928_ _06922_ _06926_ _06927_ VPWR VGND sg13g2_a21oi_1
X_30375_ _06929_ \memory_i.freq_inst.dsmod_cos.data_interp_r[32]\ _06928_ VPWR VGND sg13g2_xnor2_1
X_30376_ _06930_ _06793_ _06929_ VPWR VGND sg13g2_nor2_1
X_30377_ _06931_ \memory_i.freq_inst.dsmod_cos.accu1_r[32]\ _06930_ VPWR VGND sg13g2_xnor2_1
X_30378_ _01670_ _06871_ _06931_ VPWR VGND sg13g2_nor2_1
X_30379_ _06932_ \memory_i.freq_inst.dsmod_cos.accu1_r[31]\ \memory_i.freq_inst.dsmod_cos.data_interp_r[31]\ \memory_i.freq_inst.dsmod_cos.data_interp_r[32]\ VPWR VGND sg13g2_a21oi_1
X_30380_ _06933_ \memory_i.freq_inst.dsmod_cos.accu1_r[31]\ \memory_i.freq_inst.dsmod_cos.data_interp_r[31]\ \memory_i.freq_inst.dsmod_cos.accu1_r[32]\ VPWR VGND sg13g2_a21oi_1
X_30381_ _06934_ _06932_ _06933_ _06922_ VPWR VGND sg13g2_o21ai_1
X_30382_ _06935_ \memory_i.freq_inst.dsmod_cos.accu1_r[31]\ \memory_i.freq_inst.dsmod_cos.data_interp_r[31]\ VPWR VGND sg13g2_or2_1
X_30383_ _06936_ \memory_i.freq_inst.dsmod_cos.accu1_r[32]\ \memory_i.freq_inst.dsmod_cos.data_interp_r[32]\ _06935_ VPWR VGND sg13g2_a21oi_1
X_30384_ _06937_ \memory_i.freq_inst.dsmod_cos.accu1_r[32]\ \memory_i.freq_inst.dsmod_cos.data_interp_r[32]\ VPWR VGND sg13g2_nor2_1
X_30385_ _06938_ _06936_ _06937_ VPWR VGND sg13g2_nor2_1
X_30386_ _06939_ _06934_ _06938_ VPWR VGND sg13g2_nand2_1
X_30387_ _06940_ \memory_i.freq_inst.dsmod_cos.data_interp_r[33]\ _06939_ VPWR VGND sg13g2_xnor2_1
X_30388_ _06941_ \memory_i.freq_inst.dsmod_cos.i_ena_mod\ _06940_ VPWR VGND sg13g2_nand2_1
X_30389_ _06942_ \memory_i.freq_inst.dsmod_cos.accu1_r[33]\ _06941_ VPWR VGND sg13g2_xor2_1
X_30390_ _01671_ _06871_ _06942_ VPWR VGND sg13g2_nor2_1
X_30391_ _06943_ _05972_ _06939_ VPWR VGND sg13g2_nand2_1
X_30392_ _06944_ _05972_ _06939_ VPWR VGND sg13g2_nor2_1
X_30393_ _06945_ \memory_i.freq_inst.dsmod_cos.accu1_r[33]\ _06943_ _06944_ VPWR VGND sg13g2_a21oi_1
X_30394_ _06946_ _05971_ _06945_ VPWR VGND sg13g2_xnor2_1
X_30395_ _06947_ _06793_ _06946_ VPWR VGND sg13g2_nor2_1
X_30396_ _06948_ \memory_i.freq_inst.dsmod_cos.accu1_r[34]\ _06947_ VPWR VGND sg13g2_xnor2_1
X_30397_ _01672_ _06871_ _06948_ VPWR VGND sg13g2_nor2_1
X_30398_ _06949_ \memory_i.freq_inst.dsmod_cos.accu1_r[35]\ VPWR VGND sg13g2_inv_1
X_30399_ _06950_ \memory_i.freq_inst.dsmod_cos.accu1_r[34]\ \memory_i.freq_inst.dsmod_cos.data_interp_r[34]\ VPWR VGND sg13g2_and2_1
X_30400_ _06951_ _06950_ VPWR VGND sg13g2_buf_1
X_30401_ _06952_ \memory_i.freq_inst.dsmod_cos.accu1_r[34]\ \memory_i.freq_inst.dsmod_cos.data_interp_r[34]\ VPWR VGND sg13g2_or2_1
X_30402_ _06953_ _06952_ VPWR VGND sg13g2_buf_1
X_30403_ _06954_ _06945_ _06953_ VPWR VGND sg13g2_nor2b_1
X_30404_ _06955_ _06951_ _06954_ VPWR VGND sg13g2_nor2_1
X_30405_ _06956_ \memory_i.freq_inst.dsmod_cos.data_interp_r[35]\ _06955_ VPWR VGND sg13g2_xnor2_1
X_30406_ _06957_ \memory_i.freq_inst.dsmod_cos.i_ena_mod\ _06956_ VPWR VGND sg13g2_nand2_1
X_30407_ _06958_ _06949_ _06957_ VPWR VGND sg13g2_xnor2_1
X_30408_ _01673_ _06871_ _06958_ VPWR VGND sg13g2_nor2_1
X_30409_ _06959_ \memory_i.freq_inst.dsmod_cos.data_interp_r[35]\ \memory_i.freq_inst.dsmod_cos.data_interp_r[33]\ _06953_ VPWR VGND sg13g2_nand3_1
X_30410_ _06960_ \memory_i.freq_inst.dsmod_cos.accu1_r[33]\ \memory_i.freq_inst.dsmod_cos.data_interp_r[35]\ _06953_ VPWR VGND sg13g2_nand3_1
X_30411_ _06961_ _06959_ _06960_ _06939_ VPWR VGND sg13g2_a21o_1
X_30412_ _06962_ \memory_i.freq_inst.dsmod_cos.data_interp_r[35]\ _06951_ VPWR VGND sg13g2_nand2_1
X_30413_ _06963_ _05972_ _06960_ VPWR VGND sg13g2_or2_1
X_30414_ _06964_ \memory_i.freq_inst.dsmod_cos.data_interp_r[35]\ \memory_i.freq_inst.dsmod_cos.data_interp_r[33]\ _06951_ VPWR VGND sg13g2_or3_1
X_30415_ _06965_ \memory_i.freq_inst.dsmod_cos.accu1_r[33]\ \memory_i.freq_inst.dsmod_cos.data_interp_r[35]\ _06951_ VPWR VGND sg13g2_or3_1
X_30416_ _06966_ _06934_ _06938_ _06964_ _06965_ VPWR
+ VGND
+ sg13g2_a22oi_1
X_30417_ _06967_ _06953_ _05988_ VPWR VGND sg13g2_nand2b_1
X_30418_ _06968_ \memory_i.freq_inst.dsmod_cos.data_interp_r[33]\ _06965_ _06967_ VPWR VGND sg13g2_o21ai_1
X_30419_ _06969_ _06949_ _06966_ _06968_ VPWR VGND sg13g2_or3_1
X_30420_ _06970_ _06961_ _06962_ _06963_ _06969_ VPWR
+ VGND
+ sg13g2_nand4_1
X_30421_ _06971_ \memory_i.freq_inst.dsmod_cos.data_interp_r[36]\ _06970_ VPWR VGND sg13g2_xnor2_1
X_30422_ _06972_ _06793_ _06971_ VPWR VGND sg13g2_nor2_1
X_30423_ _06973_ \memory_i.freq_inst.dsmod_cos.accu1_r[36]\ _06972_ VPWR VGND sg13g2_xnor2_1
X_30424_ _01674_ _06871_ _06973_ VPWR VGND sg13g2_nor2_1
X_30425_ _06974_ _06870_ VPWR VGND sg13g2_buf_1
X_30426_ _06975_ \memory_i.freq_inst.dsmod_cos.data_interp_r[37]\ VPWR VGND sg13g2_inv_1
X_30427_ _06976_ \memory_i.freq_inst.dsmod_cos.accu1_r[36]\ \memory_i.freq_inst.dsmod_cos.data_interp_r[36]\ VPWR VGND sg13g2_or2_1
X_30428_ _06977_ \memory_i.freq_inst.dsmod_cos.accu1_r[36]\ \memory_i.freq_inst.dsmod_cos.data_interp_r[36]\ VPWR VGND sg13g2_and2_1
X_30429_ _06978_ _06970_ _06976_ _06977_ VPWR VGND sg13g2_a21oi_1
X_30430_ _06979_ _06975_ _06978_ VPWR VGND sg13g2_xnor2_1
X_30431_ _06980_ \memory_i.freq_inst.dsmod_cos.i_ena_mod\ _06979_ VPWR VGND sg13g2_nand2_1
X_30432_ _06981_ \memory_i.freq_inst.dsmod_cos.accu1_r[37]\ _06980_ VPWR VGND sg13g2_xor2_1
X_30433_ _01675_ _06974_ _06981_ VPWR VGND sg13g2_nor2_1
X_30434_ _06982_ \memory_i.freq_inst.dsmod_cos.accu1_r[37]\ _06975_ VPWR VGND sg13g2_nand2_1
X_30435_ _06983_ \memory_i.freq_inst.dsmod_cos.accu1_r[37]\ _06975_ VPWR VGND sg13g2_nor2_1
X_30436_ _06984_ _06978_ _06982_ _06983_ VPWR VGND sg13g2_a21o_1
X_30437_ _06985_ _06984_ VPWR VGND sg13g2_buf_1
X_30438_ _06986_ _13397_ _06985_ VPWR VGND sg13g2_xnor2_1
X_30439_ _06987_ _06793_ _06986_ VPWR VGND sg13g2_nor2_1
X_30440_ _06988_ \memory_i.freq_inst.dsmod_cos.accu1_r[38]\ _06987_ VPWR VGND sg13g2_xnor2_1
X_30441_ _01676_ _06974_ _06988_ VPWR VGND sg13g2_nor2_1
X_30442_ _06989_ \memory_i.freq_inst.dsmod_cos.accu3_r[41]\ VPWR VGND sg13g2_inv_1
X_30443_ _06990_ \memory_i.freq_inst.dsmod_cos.accu1_r[38]\ VPWR VGND sg13g2_inv_1
X_30444_ _06991_ _06989_ \memory_i.freq_inst.dsmod_cos.accu1_r[39]\ _06990_ \memory_i.ds_lo_conf[5]\ VPWR
+ VGND
+ sg13g2_and4_1
X_30445_ _06992_ _06990_ \memory_i.ds_lo_conf[5]\ _06985_ VPWR VGND sg13g2_nor3_1
X_30446_ _06993_ _06985_ _06991_ _06992_ VPWR VGND sg13g2_a21oi_1
X_30447_ _06994_ _05705_ _06993_ VPWR VGND sg13g2_nor2_1
X_30448_ _06995_ \memory_i.freq_inst.dsmod_cos.accu1_r[39]\ \memory_i.freq_inst.dsmod_cos.accu1_r[38]\ VPWR VGND sg13g2_or2_1
X_30449_ _06996_ _13379_ _06995_ \memory_i.freq_inst.cordic.rstn_i\ VPWR VGND sg13g2_o21ai_1
X_30450_ _06997_ \memory_i.freq_inst.dsmod_cos.i_ena_mod\ \memory_i.freq_inst.dsmod_cos.accu3_r[41]\ \memory_i.freq_inst.dsmod_cos.accu1_r[39]\ \memory_i.freq_inst.dsmod_cos.accu1_r[38]\ VPWR
+ VGND
+ sg13g2_nand4_1
X_30451_ _06998_ _06995_ _06997_ _06985_ VPWR VGND sg13g2_a21oi_1
X_30452_ _06999_ _06989_ _06985_ \memory_i.freq_inst.dsmod_cos.accu1_r[38]\ VPWR VGND sg13g2_o21ai_1
X_30453_ _07000_ \memory_i.freq_inst.dsmod_cos.i_ena_mod\ _06999_ \memory_i.freq_inst.dsmod_cos.accu1_r[39]\ VPWR VGND sg13g2_a21oi_1
X_30454_ _01677_ _06994_ _06996_ _06998_ _07000_ VPWR
+ VGND
+ sg13g2_nor4_1
X_30455_ _07001_ \memory_i.freq_inst.dsmod_cos.accu2_r[0]\ _06638_ VPWR VGND sg13g2_xor2_1
X_30456_ _01678_ _06974_ _07001_ VPWR VGND sg13g2_nor2_1
X_30457_ _07002_ \memory_i.freq_inst.dsmod_cos.accu2_r[0]\ \memory_i.freq_inst.dsmod_cos.data_interp_r[0]\ VPWR VGND sg13g2_and2_1
X_30458_ _07003_ _07002_ VPWR VGND sg13g2_buf_4
X_30459_ _07004_ \memory_i.freq_inst.dsmod_cos.data_interp_r[1]\ _07003_ VPWR VGND sg13g2_xnor2_1
X_30460_ _07005_ _06793_ _07004_ VPWR VGND sg13g2_nor2_1
X_30461_ _07006_ \memory_i.freq_inst.dsmod_cos.accu2_r[1]\ _07005_ VPWR VGND sg13g2_xnor2_1
X_30462_ _01679_ _06974_ _07006_ VPWR VGND sg13g2_nor2_1
X_30463_ _07007_ \memory_i.freq_inst.dsmod_cos.accu2_r[2]\ \memory_i.freq_inst.dsmod_cos.data_interp_r[2]\ VPWR VGND sg13g2_or2_1
X_30464_ _07008_ \memory_i.freq_inst.dsmod_cos.accu2_r[2]\ \memory_i.freq_inst.dsmod_cos.data_interp_r[2]\ VPWR VGND sg13g2_nand2_1
X_30465_ _07009_ _07007_ _07008_ VPWR VGND sg13g2_nand2_1
X_30466_ _07010_ \memory_i.freq_inst.dsmod_cos.accu2_r[1]\ VPWR VGND sg13g2_inv_1
X_30467_ _07011_ \memory_i.freq_inst.dsmod_cos.accu2_r[0]\ \memory_i.freq_inst.dsmod_cos.data_interp_r[0]\ \memory_i.freq_inst.dsmod_cos.data_interp_r[1]\ VPWR VGND sg13g2_a21oi_1
X_30468_ _07012_ \memory_i.freq_inst.dsmod_cos.accu2_r[0]\ \memory_i.freq_inst.dsmod_cos.data_interp_r[1]\ \memory_i.freq_inst.dsmod_cos.data_interp_r[0]\ VPWR VGND sg13g2_nand3_1
X_30469_ _07013_ _07010_ _07011_ _07012_ VPWR VGND sg13g2_o21ai_1
X_30470_ _07014_ _07009_ _07013_ VPWR VGND sg13g2_xnor2_1
X_30471_ _07015_ \memory_i.freq_inst.dsmod_cos.i_ena_mod\ _07014_ VPWR VGND sg13g2_nand2_1
X_30472_ _07016_ _12941_ \memory_i.freq_inst.dsmod_cos.accu2_r[2]\ VPWR VGND sg13g2_nand2_1
X_30473_ _01680_ _07015_ _07016_ _06484_ VPWR VGND sg13g2_a21oi_1
X_30474_ _07017_ \memory_i.freq_inst.dsmod_cos.accu2_r[2]\ VPWR VGND sg13g2_inv_1
X_30475_ _07018_ \memory_i.freq_inst.dsmod_cos.data_interp_r[2]\ VPWR VGND sg13g2_inv_1
X_30476_ _07019_ _07017_ _07018_ _07012_ _07010_ _07011_
+ VPWR
+ VGND sg13g2_a221oi_1
X_30477_ _07020_ _07019_ VPWR VGND sg13g2_buf_2
X_30478_ _07021_ _05677_ _07008_ VPWR VGND sg13g2_nand2_1
X_30479_ _07022_ _07020_ _07021_ VPWR VGND sg13g2_or2_1
X_30480_ _07023_ _07022_ VPWR VGND sg13g2_buf_1
X_30481_ _07024_ _07023_ VPWR VGND sg13g2_buf_4
X_30482_ _07025_ _07017_ _07018_ VPWR VGND sg13g2_nor2_1
X_30483_ _07026_ _07025_ _07020_ \memory_i.freq_inst.dsmod_cos.data_interp_r[3]\ VPWR VGND sg13g2_o21ai_1
X_30484_ _07027_ \memory_i.freq_inst.dsmod_cos.i_ena_mod\ _07024_ _07026_ VPWR VGND sg13g2_nand3_1
X_30485_ _07028_ \memory_i.freq_inst.dsmod_cos.accu2_r[3]\ _07027_ VPWR VGND sg13g2_xor2_1
X_30486_ _01681_ _06974_ _07028_ VPWR VGND sg13g2_nor2_1
X_30487_ _07029_ _07020_ _07021_ \memory_i.freq_inst.dsmod_cos.accu2_r[3]\ VPWR VGND sg13g2_o21ai_1
X_30488_ _07030_ _07026_ _07029_ VPWR VGND sg13g2_nand2_1
X_30489_ _07031_ \memory_i.freq_inst.dsmod_cos.data_interp_r[4]\ _07030_ VPWR VGND sg13g2_xnor2_1
X_30490_ _07032_ _06793_ _07031_ VPWR VGND sg13g2_nor2_1
X_30491_ _07033_ \memory_i.freq_inst.dsmod_cos.accu2_r[4]\ _07032_ VPWR VGND sg13g2_xnor2_1
X_30492_ _01682_ _06974_ _07033_ VPWR VGND sg13g2_nor2_1
X_30493_ _07034_ _07011_ \memory_i.freq_inst.dsmod_cos.accu2_r[1]\ VPWR VGND sg13g2_nand2b_1
X_30494_ _07035_ \memory_i.freq_inst.dsmod_cos.accu2_r[2]\ \memory_i.freq_inst.dsmod_cos.data_interp_r[2]\ \memory_i.freq_inst.dsmod_cos.data_interp_r[1]\ _07003_ \memory_i.freq_inst.dsmod_cos.accu2_r[3]\
+ VPWR
+ VGND sg13g2_a221oi_1
X_30495_ _07036_ _07035_ VPWR VGND sg13g2_buf_2
X_30496_ _07037_ \memory_i.freq_inst.dsmod_cos.data_interp_r[3]\ _07007_ \memory_i.freq_inst.dsmod_cos.accu2_r[3]\ VPWR VGND sg13g2_a21oi_1
X_30497_ _07038_ _07034_ _07036_ _07037_ VPWR VGND sg13g2_a21o_1
X_30498_ _07039_ \memory_i.freq_inst.dsmod_cos.accu2_r[4]\ \memory_i.freq_inst.dsmod_cos.data_interp_r[4]\ VPWR VGND sg13g2_nand2_1
X_30499_ _07040_ _05677_ _07008_ _07039_ VPWR VGND sg13g2_nand3_1
X_30500_ _07041_ \memory_i.freq_inst.dsmod_cos.accu2_r[4]\ \memory_i.freq_inst.dsmod_cos.data_interp_r[4]\ VPWR VGND sg13g2_or2_1
X_30501_ _07042_ _07041_ VPWR VGND sg13g2_buf_2
X_30502_ _07043_ _07020_ _07040_ _07042_ VPWR VGND sg13g2_o21ai_1
X_30503_ _07044_ _07038_ _07039_ _07043_ VPWR VGND sg13g2_a21oi_1
X_30504_ _07045_ \memory_i.freq_inst.dsmod_cos.accu2_r[5]\ \memory_i.freq_inst.dsmod_cos.data_interp_r[5]\ VPWR VGND sg13g2_xnor2_1
X_30505_ _07046_ _07044_ _07045_ VPWR VGND sg13g2_xnor2_1
X_30506_ _07047_ \memory_i.freq_inst.dsmod_cos.i_ena_mod\ _07046_ VPWR VGND sg13g2_nand2_1
X_30507_ _07048_ _12941_ \memory_i.freq_inst.dsmod_cos.accu2_r[5]\ VPWR VGND sg13g2_nand2_1
X_30508_ _01683_ _07047_ _07048_ _06484_ VPWR VGND sg13g2_a21oi_1
X_30509_ _07049_ _12945_ VPWR VGND sg13g2_buf_1
X_30510_ _07050_ \memory_i.freq_inst.dsmod_cos.i_ena_mod\ \memory_i.freq_inst.dsmod_cos.accu2_r[6]\ VPWR VGND sg13g2_nor2_1
X_30511_ _07051_ _05650_ VPWR VGND sg13g2_buf_1
X_30512_ _07052_ \memory_i.freq_inst.dsmod_cos.accu2_r[6]\ \memory_i.freq_inst.dsmod_cos.data_interp_r[6]\ VPWR VGND sg13g2_xor2_1
X_30513_ _07053_ \memory_i.freq_inst.dsmod_cos.data_interp_r[5]\ _07042_ _07052_ VPWR VGND sg13g2_nand3_1
X_30514_ _07054_ \memory_i.freq_inst.dsmod_cos.accu2_r[5]\ _07042_ _07052_ VPWR VGND sg13g2_nand3_1
X_30515_ _07055_ _07026_ _07029_ _07053_ _07054_ VPWR
+ VGND
+ sg13g2_a22oi_1
X_30516_ _07056_ _07034_ _07036_ _07037_ VPWR VGND sg13g2_a21oi_1
X_30517_ _07057_ \memory_i.freq_inst.dsmod_cos.accu2_r[6]\ \memory_i.freq_inst.dsmod_cos.data_interp_r[6]\ VPWR VGND sg13g2_xnor2_1
X_30518_ _07058_ \memory_i.freq_inst.dsmod_cos.accu2_r[4]\ \memory_i.freq_inst.dsmod_cos.data_interp_r[4]\ \memory_i.freq_inst.dsmod_cos.data_interp_r[5]\ VPWR VGND sg13g2_a21oi_2
X_30519_ _07059_ _07057_ _07058_ VPWR VGND sg13g2_nand2_1
X_30520_ _07060_ \memory_i.freq_inst.dsmod_cos.accu2_r[5]\ _07039_ _07057_ VPWR VGND sg13g2_nand3b_1
X_30521_ _07061_ _07024_ _07056_ _07059_ _07060_ VPWR
+ VGND
+ sg13g2_a22oi_1
X_30522_ _07062_ _07039_ _07057_ VPWR VGND sg13g2_nor2_1
X_30523_ _07063_ \memory_i.freq_inst.dsmod_cos.accu2_r[5]\ \memory_i.freq_inst.dsmod_cos.data_interp_r[5]\ _07062_ VPWR VGND sg13g2_o21ai_1
X_30524_ _07064_ \memory_i.freq_inst.dsmod_cos.accu2_r[5]\ \memory_i.freq_inst.dsmod_cos.data_interp_r[5]\ _07052_ VPWR VGND sg13g2_nand3_1
X_30525_ _07065_ _07042_ _07057_ _05691_ VPWR VGND sg13g2_nand3b_1
X_30526_ _07066_ \memory_i.freq_inst.dsmod_cos.accu2_r[5]\ \memory_i.freq_inst.dsmod_cos.data_interp_r[5]\ VPWR VGND sg13g2_nor2_1
X_30527_ _07067_ \memory_i.freq_inst.dsmod_cos.accu2_r[5]\ _07042_ VPWR VGND sg13g2_nor2_1
X_30528_ _07068_ _07066_ _07067_ _07057_ VPWR VGND sg13g2_o21ai_1
X_30529_ _07069_ _07063_ _07064_ _07065_ _07068_ VPWR
+ VGND
+ sg13g2_nand4_1
X_30530_ _07070_ _07055_ _07061_ _07069_ VPWR VGND sg13g2_nor3_1
X_30531_ _07071_ _07070_ VPWR VGND sg13g2_buf_1
X_30532_ _07072_ _07051_ _07071_ VPWR VGND sg13g2_nor2_1
X_30533_ _01684_ _07049_ _07050_ _07072_ VPWR VGND sg13g2_nor3_1
X_30534_ _07073_ \memory_i.freq_inst.dsmod_cos.accu2_r[3]\ \memory_i.freq_inst.dsmod_cos.data_interp_r[2]\ VPWR VGND sg13g2_nor2_1
X_30535_ _07074_ \memory_i.freq_inst.dsmod_cos.accu2_r[3]\ \memory_i.freq_inst.dsmod_cos.data_interp_r[3]\ VPWR VGND sg13g2_or2_1
X_30536_ _07075_ \memory_i.freq_inst.dsmod_cos.accu2_r[5]\ \memory_i.freq_inst.dsmod_cos.data_interp_r[5]\ VPWR VGND sg13g2_or2_1
X_30537_ _07076_ \memory_i.freq_inst.dsmod_cos.accu2_r[6]\ \memory_i.freq_inst.dsmod_cos.data_interp_r[6]\ VPWR VGND sg13g2_or2_1
X_30538_ _07077_ _07076_ VPWR VGND sg13g2_buf_4
X_30539_ _07078_ _07074_ _07042_ _07075_ _07077_ VPWR
+ VGND
+ sg13g2_nand4_1
X_30540_ _07079_ _07017_ _07073_ _07036_ _07034_ _07078_
+ VPWR
+ VGND sg13g2_a221oi_1
X_30541_ _07080_ _07079_ VPWR VGND sg13g2_buf_4
X_30542_ _07081_ \memory_i.freq_inst.dsmod_cos.accu2_r[6]\ \memory_i.freq_inst.dsmod_cos.data_interp_r[6]\ VPWR VGND sg13g2_nand2_1
X_30543_ _07082_ \memory_i.freq_inst.dsmod_cos.accu2_r[4]\ \memory_i.freq_inst.dsmod_cos.data_interp_r[4]\ VPWR VGND sg13g2_and2_1
X_30544_ _07083_ \memory_i.freq_inst.dsmod_cos.data_interp_r[5]\ _07082_ _07077_ VPWR VGND sg13g2_nand3_1
X_30545_ _07084_ _07083_ VPWR VGND sg13g2_buf_8
X_30546_ _07085_ _07058_ _07077_ \memory_i.freq_inst.dsmod_cos.accu2_r[5]\ VPWR VGND sg13g2_nand3b_1
X_30547_ _07086_ _07085_ VPWR VGND sg13g2_buf_8
X_30548_ _07087_ _07081_ _07084_ _07086_ VPWR VGND sg13g2_nand3_1
X_30549_ _07088_ _07024_ _07080_ _07087_ VPWR VGND sg13g2_a21oi_1
X_30550_ _07089_ _06679_ _07088_ VPWR VGND sg13g2_xnor2_1
X_30551_ _07090_ _06793_ _07089_ VPWR VGND sg13g2_nor2_1
X_30552_ _07091_ \memory_i.freq_inst.dsmod_cos.accu2_r[7]\ _07090_ VPWR VGND sg13g2_xnor2_1
X_30553_ _01685_ _06974_ _07091_ VPWR VGND sg13g2_nor2_1
X_30554_ _07092_ \memory_i.freq_inst.dsmod_cos.accu2_r[8]\ \memory_i.freq_inst.dsmod_cos.data_interp_r[8]\ VPWR VGND sg13g2_xor2_1
X_30555_ _07093_ \memory_i.freq_inst.dsmod_cos.accu2_r[7]\ \memory_i.freq_inst.dsmod_cos.data_interp_r[7]\ VPWR VGND sg13g2_nor2_1
X_30556_ _07094_ _07093_ VPWR VGND sg13g2_buf_1
X_30557_ _07095_ \memory_i.freq_inst.dsmod_cos.accu2_r[7]\ \memory_i.freq_inst.dsmod_cos.data_interp_r[7]\ _07024_ _07080_ _07087_
+ VPWR
+ VGND sg13g2_a221oi_1
X_30558_ _07096_ _07094_ _07095_ VPWR VGND sg13g2_nor2_1
X_30559_ _07097_ _07092_ _07096_ VPWR VGND sg13g2_xor2_1
X_30560_ _07098_ \memory_i.freq_inst.dsmod_cos.i_ena_mod\ _07097_ VPWR VGND sg13g2_nand2_1
X_30561_ _07099_ _12941_ \memory_i.freq_inst.dsmod_cos.accu2_r[8]\ VPWR VGND sg13g2_nand2_1
X_30562_ _01686_ _07098_ _07099_ _06484_ VPWR VGND sg13g2_a21oi_1
X_30563_ _07100_ \memory_i.freq_inst.dsmod_cos.i_ena_mod\ \memory_i.freq_inst.dsmod_cos.accu2_r[9]\ VPWR VGND sg13g2_nor2_1
X_30564_ _07101_ \memory_i.freq_inst.dsmod_cos.accu2_r[9]\ \memory_i.freq_inst.dsmod_cos.data_interp_r[9]\ VPWR VGND sg13g2_xor2_1
X_30565_ _07102_ \memory_i.freq_inst.dsmod_cos.accu2_r[8]\ \memory_i.freq_inst.dsmod_cos.data_interp_r[8]\ VPWR VGND sg13g2_and2_1
X_30566_ _07103_ _07102_ VPWR VGND sg13g2_buf_2
X_30567_ _07104_ \memory_i.freq_inst.dsmod_cos.accu2_r[8]\ \memory_i.freq_inst.dsmod_cos.data_interp_r[8]\ VPWR VGND sg13g2_nor2_1
X_30568_ _07105_ _07094_ _07104_ VPWR VGND sg13g2_or2_1
X_30569_ _07106_ _07103_ _07105_ VPWR VGND sg13g2_nor2b_1
X_30570_ _07107_ _07106_ VPWR VGND sg13g2_buf_1
X_30571_ _07108_ \memory_i.freq_inst.dsmod_cos.data_interp_r[5]\ _07082_ \memory_i.freq_inst.dsmod_cos.accu2_r[5]\ VPWR VGND sg13g2_a21oi_1
X_30572_ _07109_ _07058_ _07108_ _07081_ VPWR VGND sg13g2_o21ai_1
X_30573_ _07110_ \memory_i.freq_inst.dsmod_cos.accu2_r[7]\ VPWR VGND sg13g2_inv_1
X_30574_ _07111_ _07110_ _06679_ VPWR VGND sg13g2_nor2_1
X_30575_ _07112_ _07111_ _07103_ VPWR VGND sg13g2_or2_1
X_30576_ _07113_ _07077_ _07109_ _07080_ _07024_ _07112_
+ VPWR
+ VGND sg13g2_a221oi_1
X_30577_ _07114_ _07113_ VPWR VGND sg13g2_buf_1
X_30578_ _07115_ _07114_ VPWR VGND sg13g2_buf_4
X_30579_ _07116_ _07101_ _07107_ _07115_ VPWR VGND sg13g2_or3_1
X_30580_ _07117_ _07107_ _07115_ _07101_ VPWR VGND sg13g2_o21ai_1
X_30581_ _07118_ _07116_ _07117_ VPWR VGND sg13g2_nand2_1
X_30582_ _07119_ _07051_ _07118_ VPWR VGND sg13g2_nor2_1
X_30583_ _01687_ _07049_ _07100_ _07119_ VPWR VGND sg13g2_nor3_1
X_30584_ _07120_ _07107_ _07115_ VPWR VGND sg13g2_nor2_1
X_30585_ _07121_ \memory_i.freq_inst.dsmod_cos.data_interp_r[9]\ _07120_ \memory_i.freq_inst.dsmod_cos.accu2_r[9]\ VPWR VGND sg13g2_a21o_1
X_30586_ _07122_ \memory_i.freq_inst.dsmod_cos.data_interp_r[9]\ _07120_ _07121_ VPWR VGND sg13g2_o21ai_1
X_30587_ _07123_ \memory_i.freq_inst.dsmod_cos.accu2_r[10]\ \memory_i.freq_inst.dsmod_cos.data_interp_r[10]\ VPWR VGND sg13g2_xor2_1
X_30588_ _07124_ _07123_ VPWR VGND sg13g2_buf_2
X_30589_ _07125_ _07122_ _07124_ VPWR VGND sg13g2_xnor2_1
X_30590_ _07126_ \memory_i.freq_inst.dsmod_cos.i_ena_mod\ \memory_i.freq_inst.dsmod_cos.accu2_r[10]\ VPWR VGND sg13g2_nor2b_1
X_30591_ _07127_ \memory_i.freq_inst.dsmod_cos.i_ena_mod\ _07125_ _07126_ VPWR VGND sg13g2_a21oi_1
X_30592_ _01688_ _06974_ _07127_ VPWR VGND sg13g2_nor2_1
X_30593_ _07128_ \memory_i.freq_inst.dsmod_cos.accu2_r[11]\ \memory_i.freq_inst.dsmod_cos.data_interp_r[11]\ VPWR VGND sg13g2_xor2_1
X_30594_ _07129_ _07128_ VPWR VGND sg13g2_buf_2
X_30595_ _07130_ \memory_i.freq_inst.dsmod_cos.accu2_r[10]\ \memory_i.freq_inst.dsmod_cos.data_interp_r[10]\ VPWR VGND sg13g2_or2_1
X_30596_ _07131_ _07130_ VPWR VGND sg13g2_buf_1
X_30597_ _07132_ \memory_i.freq_inst.dsmod_cos.data_interp_r[9]\ _07129_ _07131_ VPWR VGND sg13g2_nand3_1
X_30598_ _07133_ _07107_ _07115_ _07132_ VPWR VGND sg13g2_or3_1
X_30599_ _07134_ \memory_i.freq_inst.dsmod_cos.accu2_r[9]\ _07129_ _07131_ VPWR VGND sg13g2_nand3_1
X_30600_ _07135_ _07107_ _07115_ _07134_ VPWR VGND sg13g2_or3_1
X_30601_ _07136_ \memory_i.freq_inst.dsmod_cos.accu2_r[10]\ \memory_i.freq_inst.dsmod_cos.data_interp_r[10]\ VPWR VGND sg13g2_and2_1
X_30602_ _07137_ \memory_i.freq_inst.dsmod_cos.data_interp_r[9]\ _07129_ _07136_ VPWR VGND sg13g2_nor3_1
X_30603_ _07138_ _07107_ _07115_ _07137_ VPWR VGND sg13g2_o21ai_1
X_30604_ _07139_ \memory_i.freq_inst.dsmod_cos.accu2_r[9]\ _07129_ _07136_ VPWR VGND sg13g2_nor3_1
X_30605_ _07140_ _07107_ _07115_ _07139_ VPWR VGND sg13g2_o21ai_1
X_30606_ _07141_ _07133_ _07135_ _07138_ _07140_ VPWR
+ VGND
+ sg13g2_and4_1
X_30607_ _07142_ _07141_ VPWR VGND sg13g2_buf_1
X_30608_ _07143_ \memory_i.freq_inst.dsmod_cos.accu2_r[10]\ \memory_i.freq_inst.dsmod_cos.data_interp_r[10]\ VPWR VGND sg13g2_nand2_1
X_30609_ _07144_ \memory_i.freq_inst.dsmod_cos.accu2_r[9]\ \memory_i.freq_inst.dsmod_cos.data_interp_r[9]\ VPWR VGND sg13g2_nand2_1
X_30610_ _07145_ _07144_ _07131_ VPWR VGND sg13g2_nand2b_1
X_30611_ _07146_ _07129_ VPWR VGND sg13g2_inv_1
X_30612_ _07147_ _07143_ _07145_ _07146_ VPWR VGND sg13g2_a21oi_1
X_30613_ _07148_ \memory_i.freq_inst.dsmod_cos.accu2_r[9]\ \memory_i.freq_inst.dsmod_cos.data_interp_r[9]\ VPWR VGND sg13g2_nor2_1
X_30614_ _07149_ _07148_ _07143_ VPWR VGND sg13g2_nand2_1
X_30615_ _07150_ _07131_ _07149_ _07129_ VPWR VGND sg13g2_a21oi_1
X_30616_ _07151_ _07147_ _07150_ VPWR VGND sg13g2_nor2_1
X_30617_ _07152_ _07142_ _07151_ VPWR VGND sg13g2_nand2_1
X_30618_ _07153_ \memory_i.freq_inst.dsmod_cos.i_ena_mod\ _07152_ VPWR VGND sg13g2_nand2_1
X_30619_ _07154_ \memory_i.freq_inst.dsmod_cos.i_ena_mod\ \memory_i.freq_inst.dsmod_cos.accu2_r[11]\ _07153_ VPWR VGND sg13g2_o21ai_1
X_30620_ _01689_ _06974_ _07154_ VPWR VGND sg13g2_nor2_1
X_30621_ _07155_ _06679_ _07081_ _07084_ _07086_ VPWR
+ VGND
+ sg13g2_nand4_1
X_30622_ _07156_ _07092_ _07101_ _07124_ _07129_ VPWR
+ VGND
+ sg13g2_nand4_1
X_30623_ _07157_ _07156_ VPWR VGND sg13g2_buf_2
X_30624_ _07158_ _07094_ _07157_ VPWR VGND sg13g2_nor2_2
X_30625_ _07159_ _07110_ _07081_ _07084_ _07086_ VPWR
+ VGND
+ sg13g2_nand4_1
X_30626_ _07160_ \memory_i.freq_inst.dsmod_cos.data_interp_r[12]\ _07155_ _07158_ _07159_ VPWR
+ VGND
+ sg13g2_nand4_1
X_30627_ _07161_ \memory_i.freq_inst.dsmod_cos.accu2_r[11]\ \memory_i.freq_inst.dsmod_cos.data_interp_r[11]\ \memory_i.freq_inst.dsmod_cos.data_interp_r[9]\ _07103_ \memory_i.freq_inst.dsmod_cos.data_interp_r[10]\
+ VPWR
+ VGND sg13g2_a221oi_1
X_30628_ _07162_ \memory_i.freq_inst.dsmod_cos.accu2_r[11]\ \memory_i.freq_inst.dsmod_cos.data_interp_r[11]\ \memory_i.freq_inst.dsmod_cos.data_interp_r[9]\ _07103_ \memory_i.freq_inst.dsmod_cos.accu2_r[10]\
+ VPWR
+ VGND sg13g2_a221oi_1
X_30629_ _07163_ \memory_i.freq_inst.dsmod_cos.data_interp_r[9]\ _07103_ \memory_i.freq_inst.dsmod_cos.accu2_r[9]\ VPWR VGND sg13g2_o21ai_1
X_30630_ _07164_ _07161_ _07162_ _07163_ VPWR VGND sg13g2_o21ai_1
X_30631_ _07165_ \memory_i.freq_inst.dsmod_cos.accu2_r[11]\ VPWR VGND sg13g2_inv_1
X_30632_ _07166_ \memory_i.freq_inst.dsmod_cos.accu2_r[11]\ \memory_i.freq_inst.dsmod_cos.data_interp_r[11]\ _07131_ VPWR VGND sg13g2_a21oi_1
X_30633_ _07167_ _07165_ _05754_ _07166_ VPWR VGND sg13g2_a21oi_1
X_30634_ _07168_ \memory_i.freq_inst.dsmod_cos.data_interp_r[12]\ _07164_ _07167_ VPWR VGND sg13g2_nand3_1
X_30635_ _07169_ _06719_ _07094_ _07157_ VPWR VGND sg13g2_nor3_1
X_30636_ _07170_ _07024_ _07080_ _07169_ VPWR VGND sg13g2_nand3_1
X_30637_ _07171_ _07160_ _07168_ _07170_ VPWR VGND sg13g2_nand3_1
X_30638_ _07172_ _07155_ _07158_ _07159_ VPWR VGND sg13g2_and3_2
X_30639_ _07173_ _07172_ VPWR VGND sg13g2_buf_8
X_30640_ _07174_ _07164_ _07167_ VPWR VGND sg13g2_and2_1
X_30641_ _07175_ _07174_ VPWR VGND sg13g2_buf_1
X_30642_ _07176_ _07023_ _07080_ _07158_ VPWR VGND sg13g2_and3_2
X_30643_ _07177_ _07176_ VPWR VGND sg13g2_buf_4
X_30644_ _07178_ \memory_i.freq_inst.dsmod_cos.data_interp_r[12]\ _07173_ _07175_ _07177_ VPWR
+ VGND
+ sg13g2_nor4_1
X_30645_ _07179_ _07171_ _07178_ VPWR VGND sg13g2_nor2_1
X_30646_ _07180_ \memory_i.freq_inst.dsmod_cos.i_ena_mod\ _07179_ VPWR VGND sg13g2_nand2_1
X_30647_ _07181_ \memory_i.freq_inst.dsmod_cos.accu2_r[12]\ _07180_ VPWR VGND sg13g2_xor2_1
X_30648_ _01690_ _06974_ _07181_ VPWR VGND sg13g2_nor2_1
X_30649_ _07182_ _06870_ VPWR VGND sg13g2_buf_1
X_30650_ _07183_ _05649_ VPWR VGND sg13g2_buf_1
X_30651_ _07184_ \memory_i.freq_inst.dsmod_cos.accu2_r[12]\ \memory_i.freq_inst.dsmod_cos.data_interp_r[12]\ VPWR VGND sg13g2_nand2_1
X_30652_ _07185_ \memory_i.freq_inst.dsmod_cos.accu2_r[12]\ \memory_i.freq_inst.dsmod_cos.data_interp_r[12]\ VPWR VGND sg13g2_xor2_1
X_30653_ _07186_ _07155_ _07158_ _07159_ _07185_ VPWR
+ VGND
+ sg13g2_nand4_1
X_30654_ _07187_ _07164_ _07167_ _07185_ VPWR VGND sg13g2_nand3_1
X_30655_ _07188_ \memory_i.freq_inst.dsmod_cos.accu2_r[12]\ \memory_i.freq_inst.dsmod_cos.data_interp_r[12]\ VPWR VGND sg13g2_xnor2_1
X_30656_ _07189_ _07094_ _07157_ _07188_ VPWR VGND sg13g2_nor3_1
X_30657_ _07190_ _07024_ _07080_ _07189_ VPWR VGND sg13g2_nand3_1
X_30658_ _07191_ _07184_ _07186_ _07187_ _07190_ VPWR
+ VGND
+ sg13g2_nand4_1
X_30659_ _07192_ _07191_ VPWR VGND sg13g2_buf_1
X_30660_ _07193_ \memory_i.freq_inst.dsmod_cos.data_interp_r[13]\ _07192_ VPWR VGND sg13g2_xnor2_1
X_30661_ _07194_ _07183_ _07193_ VPWR VGND sg13g2_nor2_1
X_30662_ _07195_ \memory_i.freq_inst.dsmod_cos.accu2_r[13]\ _07194_ VPWR VGND sg13g2_xnor2_1
X_30663_ _01691_ _07182_ _07195_ VPWR VGND sg13g2_nor2_1
X_30664_ _07196_ \memory_i.freq_inst.dsmod_cos.i_ena_mod\ \memory_i.freq_inst.dsmod_cos.accu2_r[14]\ VPWR VGND sg13g2_nor2_1
X_30665_ _07197_ \memory_i.freq_inst.dsmod_cos.accu2_r[14]\ \memory_i.freq_inst.dsmod_cos.data_interp_r[14]\ VPWR VGND sg13g2_xnor2_1
X_30666_ _07198_ \memory_i.freq_inst.dsmod_cos.accu2_r[13]\ \memory_i.freq_inst.dsmod_cos.data_interp_r[13]\ VPWR VGND sg13g2_or2_1
X_30667_ _07199_ \memory_i.freq_inst.dsmod_cos.accu2_r[13]\ \memory_i.freq_inst.dsmod_cos.data_interp_r[13]\ VPWR VGND sg13g2_and2_1
X_30668_ _07200_ _07192_ _07198_ _07199_ VPWR VGND sg13g2_a21o_1
X_30669_ _07201_ _07197_ _07200_ VPWR VGND sg13g2_xnor2_1
X_30670_ _07202_ _07051_ _07201_ VPWR VGND sg13g2_nor2_1
X_30671_ _01692_ _07049_ _07196_ _07202_ VPWR VGND sg13g2_nor3_1
X_30672_ _07203_ \memory_i.freq_inst.dsmod_cos.accu2_r[15]\ \memory_i.freq_inst.dsmod_cos.data_interp_r[15]\ VPWR VGND sg13g2_xnor2_1
X_30673_ _07204_ _07203_ VPWR VGND sg13g2_buf_1
X_30674_ _07205_ \memory_i.freq_inst.dsmod_cos.accu2_r[14]\ \memory_i.freq_inst.dsmod_cos.data_interp_r[14]\ VPWR VGND sg13g2_nor2_1
X_30675_ _07206_ \memory_i.freq_inst.dsmod_cos.accu2_r[14]\ \memory_i.freq_inst.dsmod_cos.data_interp_r[14]\ _07192_ _07198_ _07199_
+ VPWR
+ VGND sg13g2_a221oi_1
X_30676_ _07207_ _07206_ VPWR VGND sg13g2_buf_1
X_30677_ _07208_ _07205_ _07207_ VPWR VGND sg13g2_nor2_1
X_30678_ _07209_ _07204_ _07208_ VPWR VGND sg13g2_xnor2_1
X_30679_ _07210_ \memory_i.freq_inst.dsmod_cos.i_ena_mod\ \memory_i.freq_inst.dsmod_cos.accu2_r[15]\ VPWR VGND sg13g2_nor2b_1
X_30680_ _07211_ \memory_i.freq_inst.dsmod_cos.i_ena_mod\ _07209_ _07210_ VPWR VGND sg13g2_a21oi_1
X_30681_ _01693_ _07182_ _07211_ VPWR VGND sg13g2_nor2_1
X_30682_ _07212_ \memory_i.freq_inst.dsmod_cos.accu2_r[15]\ \memory_i.freq_inst.dsmod_cos.data_interp_r[15]\ \memory_i.freq_inst.dsmod_cos.data_interp_r[14]\ VPWR VGND sg13g2_o21ai_1
X_30683_ _07213_ \memory_i.freq_inst.dsmod_cos.accu2_r[15]\ \memory_i.freq_inst.dsmod_cos.data_interp_r[15]\ \memory_i.freq_inst.dsmod_cos.accu2_r[14]\ VPWR VGND sg13g2_o21ai_1
X_30684_ _07214_ \memory_i.freq_inst.dsmod_cos.accu2_r[12]\ \memory_i.freq_inst.dsmod_cos.data_interp_r[12]\ \memory_i.freq_inst.dsmod_cos.data_interp_r[13]\ VPWR VGND sg13g2_a21o_1
X_30685_ _07215_ \memory_i.freq_inst.dsmod_cos.accu2_r[12]\ \memory_i.freq_inst.dsmod_cos.data_interp_r[13]\ \memory_i.freq_inst.dsmod_cos.data_interp_r[12]\ VPWR VGND sg13g2_and3_1
X_30686_ _07216_ \memory_i.freq_inst.dsmod_cos.accu2_r[13]\ _07214_ _07215_ VPWR VGND sg13g2_a21oi_1
X_30687_ _07217_ _07212_ _07213_ _07216_ VPWR VGND sg13g2_a21o_1
X_30688_ _07218_ _07217_ VPWR VGND sg13g2_buf_1
X_30689_ _07219_ \memory_i.freq_inst.dsmod_cos.accu2_r[14]\ \memory_i.freq_inst.dsmod_cos.data_interp_r[14]\ VPWR VGND sg13g2_nand2_1
X_30690_ _07220_ \memory_i.freq_inst.dsmod_cos.accu2_r[15]\ \memory_i.freq_inst.dsmod_cos.data_interp_r[15]\ VPWR VGND sg13g2_nor2_1
X_30691_ _07221_ \memory_i.freq_inst.dsmod_cos.accu2_r[15]\ \memory_i.freq_inst.dsmod_cos.data_interp_r[15]\ VPWR VGND sg13g2_nand2_1
X_30692_ _07222_ _07219_ _07220_ _07221_ VPWR VGND sg13g2_o21ai_1
X_30693_ _07223_ _07222_ VPWR VGND sg13g2_inv_1
X_30694_ _07224_ _07218_ _07223_ VPWR VGND sg13g2_nand2_1
X_30695_ _07225_ _07173_ _07175_ _07177_ _07224_ VPWR
+ VGND
+ sg13g2_or4_1
X_30696_ _07226_ _07225_ VPWR VGND sg13g2_buf_1
X_30697_ _07227_ \memory_i.freq_inst.dsmod_cos.accu2_r[13]\ \memory_i.freq_inst.dsmod_cos.data_interp_r[13]\ VPWR VGND sg13g2_xnor2_1
X_30698_ _07228_ _07188_ _07197_ _07204_ _07227_ VPWR
+ VGND
+ sg13g2_or4_1
X_30699_ _07229_ _07218_ _07223_ _07228_ VPWR VGND sg13g2_nand3_1
X_30700_ _07230_ _07229_ VPWR VGND sg13g2_buf_1
X_30701_ _07231_ _07226_ _07230_ VPWR VGND sg13g2_nand2_1
X_30702_ _07232_ \memory_i.freq_inst.dsmod_cos.accu2_r[16]\ \memory_i.freq_inst.dsmod_cos.data_interp_r[16]\ VPWR VGND sg13g2_xor2_1
X_30703_ _07233_ _07231_ _07232_ VPWR VGND sg13g2_xnor2_1
X_30704_ _07234_ _07233_ VPWR VGND sg13g2_buf_1
X_30705_ _07235_ \memory_i.freq_inst.dsmod_cos.i_ena_mod\ _07234_ VPWR VGND sg13g2_nand2_1
X_30706_ _07236_ _12941_ \memory_i.freq_inst.dsmod_cos.accu2_r[16]\ VPWR VGND sg13g2_nand2_1
X_30707_ _01694_ _07235_ _07236_ _06484_ VPWR VGND sg13g2_a21oi_1
X_30708_ _07237_ \memory_i.freq_inst.dsmod_cos.accu2_r[16]\ VPWR VGND sg13g2_inv_1
X_30709_ _07238_ \memory_i.freq_inst.dsmod_cos.data_interp_r[16]\ _07226_ _07230_ VPWR VGND sg13g2_nand3_1
X_30710_ _07239_ _07226_ _07230_ \memory_i.freq_inst.dsmod_cos.data_interp_r[16]\ VPWR VGND sg13g2_a21oi_1
X_30711_ _07240_ _07237_ _07238_ _07239_ VPWR VGND sg13g2_a21oi_1
X_30712_ _07241_ \memory_i.freq_inst.dsmod_cos.accu2_r[17]\ \memory_i.freq_inst.dsmod_cos.data_interp_r[17]\ VPWR VGND sg13g2_xor2_1
X_30713_ _07242_ _07240_ _07241_ VPWR VGND sg13g2_xnor2_1
X_30714_ _07243_ _07242_ VPWR VGND sg13g2_buf_2
X_30715_ _07244_ _12940_ \memory_i.freq_inst.dsmod_cos.accu2_r[17]\ VPWR VGND sg13g2_nand2_1
X_30716_ _07245_ _05705_ _07243_ _07244_ VPWR VGND sg13g2_o21ai_1
X_30717_ _01695_ \memory_i.freq_inst.cordic.rstn_i\ _07245_ VPWR VGND sg13g2_and2_1
X_30718_ _07246_ \memory_i.freq_inst.dsmod_cos.i_ena_mod\ \memory_i.freq_inst.dsmod_cos.accu2_r[18]\ VPWR VGND sg13g2_nor2_1
X_30719_ _07247_ \memory_i.freq_inst.dsmod_cos.accu2_r[18]\ \memory_i.freq_inst.dsmod_cos.data_interp_r[18]\ VPWR VGND sg13g2_xnor2_1
X_30720_ _07248_ _07247_ VPWR VGND sg13g2_buf_2
X_30721_ _07249_ \memory_i.freq_inst.dsmod_cos.data_interp_r[17]\ _07248_ VPWR VGND sg13g2_or2_1
X_30722_ _07250_ \memory_i.freq_inst.dsmod_cos.accu2_r[17]\ _07248_ VPWR VGND sg13g2_or2_1
X_30723_ _07251_ _07249_ _07250_ _07240_ VPWR VGND sg13g2_a21o_1
X_30724_ _07252_ _07251_ VPWR VGND sg13g2_buf_1
X_30725_ _07253_ \memory_i.freq_inst.dsmod_cos.data_interp_r[17]\ _07248_ VPWR VGND sg13g2_nand2_1
X_30726_ _07254_ \memory_i.freq_inst.dsmod_cos.accu2_r[17]\ _07248_ VPWR VGND sg13g2_nand2_1
X_30727_ _07255_ _07237_ _07238_ _07253_ _07254_ _07239_
+ VPWR
+ VGND sg13g2_a221oi_1
X_30728_ _07256_ \memory_i.freq_inst.dsmod_cos.accu2_r[17]\ \memory_i.freq_inst.dsmod_cos.data_interp_r[17]\ VPWR VGND sg13g2_nor2_1
X_30729_ _07257_ _07248_ _07256_ VPWR VGND sg13g2_nor2b_1
X_30730_ _07258_ \memory_i.freq_inst.dsmod_cos.accu2_r[17]\ \memory_i.freq_inst.dsmod_cos.data_interp_r[17]\ _07248_ VPWR VGND sg13g2_and3_1
X_30731_ _07259_ _07255_ _07257_ _07258_ VPWR VGND sg13g2_nor3_1
X_30732_ _07260_ _07252_ _07259_ VPWR VGND sg13g2_nand2_1
X_30733_ _07261_ _07051_ _07260_ VPWR VGND sg13g2_nor2_1
X_30734_ _01696_ _07049_ _07246_ _07261_ VPWR VGND sg13g2_nor3_1
X_30735_ _07262_ \memory_i.freq_inst.dsmod_cos.accu2_r[19]\ \memory_i.freq_inst.dsmod_cos.data_interp_r[19]\ VPWR VGND sg13g2_xnor2_1
X_30736_ _07263_ \memory_i.freq_inst.dsmod_cos.accu2_r[18]\ \memory_i.freq_inst.dsmod_cos.data_interp_r[18]\ VPWR VGND sg13g2_or2_1
X_30737_ _07264_ \memory_i.freq_inst.dsmod_cos.data_interp_r[17]\ _07240_ VPWR VGND sg13g2_nor2_1
X_30738_ _07265_ \memory_i.freq_inst.dsmod_cos.data_interp_r[17]\ _07240_ \memory_i.freq_inst.dsmod_cos.accu2_r[17]\ VPWR VGND sg13g2_a21oi_1
X_30739_ _07266_ \memory_i.freq_inst.dsmod_cos.accu2_r[18]\ \memory_i.freq_inst.dsmod_cos.data_interp_r[18]\ VPWR VGND sg13g2_nand2_1
X_30740_ _07267_ _07264_ _07265_ _07266_ VPWR VGND sg13g2_o21ai_1
X_30741_ _07268_ _07262_ _07263_ _07267_ VPWR VGND sg13g2_nand3_1
X_30742_ _07269_ _07263_ _07267_ _07262_ VPWR VGND sg13g2_a21o_1
X_30743_ _07270_ _07268_ _07269_ VPWR VGND sg13g2_and2_1
X_30744_ _07271_ _07270_ VPWR VGND sg13g2_buf_1
X_30745_ _07272_ \memory_i.freq_inst.dsmod_cos.i_ena_mod\ _07271_ VPWR VGND sg13g2_nand2_1
X_30746_ _07273_ \memory_i.freq_inst.dsmod_cos.i_ena_mod\ \memory_i.freq_inst.dsmod_cos.accu2_r[19]\ _07272_ VPWR VGND sg13g2_o21ai_1
X_30747_ _01697_ _07182_ _07273_ VPWR VGND sg13g2_nor2_1
X_30748_ _07274_ \memory_i.freq_inst.dsmod_cos.accu2_r[20]\ VPWR VGND sg13g2_inv_1
X_30749_ _07275_ _07173_ _07175_ _07177_ VPWR VGND sg13g2_nor3_2
X_30750_ _07276_ _07248_ _07256_ _07262_ VPWR VGND sg13g2_nor3_1
X_30751_ _07277_ _07276_ VPWR VGND sg13g2_buf_2
X_30752_ _07278_ \memory_i.freq_inst.dsmod_cos.data_interp_r[16]\ _07277_ VPWR VGND sg13g2_nand2_1
X_30753_ _07279_ \memory_i.freq_inst.dsmod_cos.accu2_r[16]\ _07277_ VPWR VGND sg13g2_nand2_1
X_30754_ _07280_ _07278_ _07279_ _07228_ VPWR VGND sg13g2_a21oi_1
X_30755_ _07281_ _07280_ VPWR VGND sg13g2_inv_1
X_30756_ _07282_ \memory_i.freq_inst.dsmod_cos.accu2_r[19]\ VPWR VGND sg13g2_inv_1
X_30757_ _07283_ \memory_i.freq_inst.dsmod_cos.accu2_r[17]\ \memory_i.freq_inst.dsmod_cos.data_interp_r[17]\ \memory_i.freq_inst.dsmod_cos.data_interp_r[18]\ VPWR VGND sg13g2_a21o_1
X_30758_ _07284_ \memory_i.freq_inst.dsmod_cos.accu2_r[17]\ \memory_i.freq_inst.dsmod_cos.data_interp_r[18]\ \memory_i.freq_inst.dsmod_cos.data_interp_r[17]\ VPWR VGND sg13g2_and3_1
X_30759_ _07285_ \memory_i.freq_inst.dsmod_cos.accu2_r[19]\ \memory_i.freq_inst.dsmod_cos.data_interp_r[19]\ _07283_ \memory_i.freq_inst.dsmod_cos.accu2_r[18]\ _07284_
+ VPWR
+ VGND sg13g2_a221oi_1
X_30760_ _07286_ _07282_ _05829_ _07285_ VPWR VGND sg13g2_a21oi_1
X_30761_ _07287_ _07218_ _07223_ _07278_ _07279_ VPWR
+ VGND
+ sg13g2_a22oi_1
X_30762_ _07288_ \memory_i.freq_inst.dsmod_cos.accu2_r[16]\ \memory_i.freq_inst.dsmod_cos.data_interp_r[16]\ _07277_ VPWR VGND sg13g2_and3_1
X_30763_ _07289_ _07286_ _07287_ _07288_ VPWR VGND sg13g2_nor3_1
X_30764_ _07290_ _07275_ _07281_ _07289_ VPWR VGND sg13g2_o21ai_1
X_30765_ _07291_ _07290_ VPWR VGND sg13g2_buf_8
X_30766_ _07292_ \memory_i.freq_inst.dsmod_cos.data_interp_r[20]\ _07291_ VPWR VGND sg13g2_nor2_1
X_30767_ _07293_ _07292_ VPWR VGND sg13g2_buf_4
X_30768_ _07294_ \memory_i.freq_inst.dsmod_cos.data_interp_r[20]\ _07291_ VPWR VGND sg13g2_nand2_1
X_30769_ _07295_ _07293_ \memory_i.freq_inst.dsmod_cos.i_ena_mod\ _07294_ VPWR VGND sg13g2_nand3b_1
X_30770_ _07296_ _07274_ _07295_ VPWR VGND sg13g2_xnor2_1
X_30771_ _01698_ _07182_ _07296_ VPWR VGND sg13g2_nor2_1
X_30772_ _07297_ \memory_i.freq_inst.dsmod_cos.data_interp_r[20]\ _07291_ \memory_i.freq_inst.dsmod_cos.accu2_r[20]\ VPWR VGND sg13g2_a21oi_2
X_30773_ _07298_ _07293_ _07297_ VPWR VGND sg13g2_or2_1
X_30774_ _07299_ \memory_i.freq_inst.dsmod_cos.data_interp_r[21]\ _07298_ VPWR VGND sg13g2_xnor2_1
X_30775_ _07300_ \memory_i.freq_inst.dsmod_cos.i_ena_mod\ _07299_ VPWR VGND sg13g2_nand2_1
X_30776_ _07301_ \memory_i.freq_inst.dsmod_cos.accu2_r[21]\ _07300_ VPWR VGND sg13g2_xor2_1
X_30777_ _01699_ _07182_ _07301_ VPWR VGND sg13g2_nor2_1
X_30778_ _07302_ \memory_i.freq_inst.dsmod_cos.accu2_r[22]\ VPWR VGND sg13g2_inv_1
X_30779_ _07303_ \memory_i.freq_inst.dsmod_cos.accu2_r[21]\ \memory_i.freq_inst.dsmod_cos.data_interp_r[21]\ \memory_i.freq_inst.dsmod_cos.data_interp_r[20]\ _07291_ \memory_i.freq_inst.dsmod_cos.accu2_r[20]\
+ VPWR
+ VGND sg13g2_a221oi_1
X_30780_ _07304_ _07303_ VPWR VGND sg13g2_buf_8
X_30781_ _07305_ _07173_ _07175_ _07177_ VPWR VGND sg13g2_or3_1
X_30782_ _07306_ _07305_ VPWR VGND sg13g2_buf_4
X_30783_ _07307_ _07212_ _07213_ _07216_ VPWR VGND sg13g2_a21oi_1
X_30784_ _07308_ \memory_i.freq_inst.dsmod_cos.data_interp_r[16]\ _07307_ _07222_ VPWR VGND sg13g2_nor3_1
X_30785_ _07309_ _07307_ _07222_ \memory_i.freq_inst.dsmod_cos.data_interp_r[16]\ VPWR VGND sg13g2_o21ai_1
X_30786_ _07310_ _07237_ _07308_ _07309_ VPWR VGND sg13g2_o21ai_1
X_30787_ _07311_ \memory_i.freq_inst.dsmod_cos.data_interp_r[21]\ \memory_i.freq_inst.dsmod_cos.data_interp_r[20]\ _07286_ VPWR VGND sg13g2_or3_1
X_30788_ _07312_ _07306_ _07280_ _07310_ _07277_ _07311_
+ VPWR
+ VGND sg13g2_a221oi_1
X_30789_ _07313_ \memory_i.freq_inst.dsmod_cos.accu2_r[21]\ \memory_i.freq_inst.dsmod_cos.data_interp_r[20]\ _07286_ VPWR VGND sg13g2_or3_1
X_30790_ _07314_ _07306_ _07280_ _07310_ _07277_ _07313_
+ VPWR
+ VGND sg13g2_a221oi_1
X_30791_ _07315_ \memory_i.freq_inst.dsmod_cos.accu2_r[21]\ \memory_i.freq_inst.dsmod_cos.data_interp_r[21]\ VPWR VGND sg13g2_nor2_1
X_30792_ _07316_ _07312_ _07314_ _07315_ VPWR VGND sg13g2_or3_1
X_30793_ _07317_ _07316_ VPWR VGND sg13g2_buf_4
X_30794_ _07318_ _07304_ _07317_ VPWR VGND sg13g2_nor2_1
X_30795_ _07319_ _06831_ _07318_ VPWR VGND sg13g2_xnor2_1
X_30796_ _07320_ \memory_i.freq_inst.dsmod_cos.i_ena_mod\ _07319_ VPWR VGND sg13g2_nand2_1
X_30797_ _07321_ _07302_ _07320_ VPWR VGND sg13g2_xnor2_1
X_30798_ _01700_ _07182_ _07321_ VPWR VGND sg13g2_nor2_1
X_30799_ _07322_ \memory_i.freq_inst.dsmod_cos.accu2_r[22]\ \memory_i.freq_inst.dsmod_cos.data_interp_r[22]\ VPWR VGND sg13g2_nand2_1
X_30800_ _07323_ _07304_ _07317_ _07322_ VPWR VGND sg13g2_o21ai_1
X_30801_ _07324_ _07302_ _06831_ VPWR VGND sg13g2_nand2_1
X_30802_ _07325_ _07323_ _07324_ VPWR VGND sg13g2_nand2_1
X_30803_ _07326_ \memory_i.freq_inst.dsmod_cos.accu2_r[23]\ \memory_i.freq_inst.dsmod_cos.data_interp_r[23]\ VPWR VGND sg13g2_xnor2_1
X_30804_ _07327_ _07325_ _07326_ VPWR VGND sg13g2_xor2_1
X_30805_ _07328_ \memory_i.freq_inst.dsmod_cos.accu2_r[23]\ VPWR VGND sg13g2_inv_1
X_30806_ _07329_ \memory_i.freq_inst.dsmod_cos.i_ena_mod\ _07328_ VPWR VGND sg13g2_nor2_1
X_30807_ _07330_ \memory_i.freq_inst.dsmod_cos.i_ena_mod\ _07327_ _07329_ VPWR VGND sg13g2_a21oi_1
X_30808_ _01701_ _07182_ _07330_ VPWR VGND sg13g2_nor2_1
X_30809_ _07331_ \memory_i.freq_inst.dsmod_cos.accu2_r[24]\ \memory_i.freq_inst.dsmod_cos.data_interp_r[24]\ VPWR VGND sg13g2_xor2_1
X_30810_ _07332_ _07328_ _06837_ VPWR VGND sg13g2_nor2_1
X_30811_ _07333_ _07331_ _07332_ VPWR VGND sg13g2_nand2b_1
X_30812_ _07334_ \memory_i.freq_inst.dsmod_cos.accu2_r[23]\ \memory_i.freq_inst.dsmod_cos.data_interp_r[23]\ VPWR VGND sg13g2_nor2_1
X_30813_ _07335_ _07331_ _07334_ VPWR VGND sg13g2_nand2_1
X_30814_ _07336_ _07331_ _07334_ VPWR VGND sg13g2_nor2_1
X_30815_ _07337_ _07323_ _07324_ _07336_ VPWR VGND sg13g2_nand3_1
X_30816_ _07338_ _07328_ _06837_ _07331_ VPWR VGND sg13g2_o21ai_1
X_30817_ _07339_ _07323_ _07324_ _07338_ VPWR VGND sg13g2_a21o_1
X_30818_ _07340_ _07333_ _07335_ _07337_ _07339_ VPWR
+ VGND
+ sg13g2_nand4_1
X_30819_ _07341_ _07340_ VPWR VGND sg13g2_buf_1
X_30820_ _07342_ \memory_i.freq_inst.dsmod_cos.i_ena_mod\ \memory_i.freq_inst.dsmod_cos.accu2_r[24]\ VPWR VGND sg13g2_nor2b_1
X_30821_ _07343_ \memory_i.freq_inst.dsmod_cos.i_ena_mod\ _07341_ _07342_ VPWR VGND sg13g2_a21oi_1
X_30822_ _01702_ _07182_ _07343_ VPWR VGND sg13g2_nor2_1
X_30823_ _07344_ \memory_i.freq_inst.dsmod_cos.i_ena_mod\ \memory_i.freq_inst.dsmod_cos.accu2_r[25]\ VPWR VGND sg13g2_nor2_1
X_30824_ _07345_ \memory_i.freq_inst.dsmod_cos.accu2_r[24]\ \memory_i.freq_inst.dsmod_cos.data_interp_r[24]\ VPWR VGND sg13g2_nor2_1
X_30825_ _07346_ _07345_ \memory_i.freq_inst.dsmod_cos.accu2_r[23]\ VPWR VGND sg13g2_nor2b_1
X_30826_ _07347_ \memory_i.freq_inst.dsmod_cos.data_interp_r[22]\ _07346_ VPWR VGND sg13g2_nand2_1
X_30827_ _07348_ _07304_ _07317_ _07347_ VPWR VGND sg13g2_nor3_2
X_30828_ _07349_ \memory_i.freq_inst.dsmod_cos.data_interp_r[24]\ _07332_ \memory_i.freq_inst.dsmod_cos.accu2_r[24]\ VPWR VGND sg13g2_a21o_1
X_30829_ _07350_ \memory_i.freq_inst.dsmod_cos.data_interp_r[24]\ _07332_ _07349_ VPWR VGND sg13g2_o21ai_1
X_30830_ _07351_ _07350_ VPWR VGND sg13g2_buf_1
X_30831_ _07352_ _07348_ _07351_ VPWR VGND sg13g2_nor2b_2
X_30832_ _07353_ \memory_i.freq_inst.dsmod_cos.accu2_r[21]\ \memory_i.freq_inst.dsmod_cos.data_interp_r[21]\ VPWR VGND sg13g2_or2_1
X_30833_ _07354_ \memory_i.freq_inst.dsmod_cos.data_interp_r[22]\ _07353_ \memory_i.freq_inst.dsmod_cos.accu2_r[22]\ VPWR VGND sg13g2_o21ai_1
X_30834_ _07355_ \memory_i.freq_inst.dsmod_cos.accu2_r[24]\ \memory_i.freq_inst.dsmod_cos.data_interp_r[24]\ \memory_i.freq_inst.dsmod_cos.data_interp_r[23]\ VPWR VGND sg13g2_o21ai_1
X_30835_ _07356_ _06831_ _07354_ _07355_ VPWR VGND sg13g2_a21oi_1
X_30836_ _07357_ _07353_ _07356_ VPWR VGND sg13g2_nand2_1
X_30837_ _07358_ _07293_ _07297_ _07357_ VPWR VGND sg13g2_nor3_1
X_30838_ _07359_ _07354_ VPWR VGND sg13g2_inv_1
X_30839_ _07360_ \memory_i.freq_inst.dsmod_cos.accu2_r[21]\ \memory_i.freq_inst.dsmod_cos.data_interp_r[21]\ _07359_ VPWR VGND sg13g2_a21o_1
X_30840_ _07361_ _07359_ _07346_ _07356_ _07360_ VPWR
+ VGND
+ sg13g2_a22oi_1
X_30841_ _07362_ _07361_ VPWR VGND sg13g2_inv_1
X_30842_ _07363_ \memory_i.freq_inst.dsmod_cos.accu2_r[21]\ \memory_i.freq_inst.dsmod_cos.data_interp_r[21]\ \memory_i.freq_inst.dsmod_cos.data_interp_r[22]\ VPWR VGND sg13g2_a21oi_1
X_30843_ _07364_ _07293_ _07297_ _07363_ VPWR VGND sg13g2_o21ai_1
X_30844_ _07365_ _07358_ _07362_ _07364_ VPWR VGND sg13g2_o21ai_1
X_30845_ _07366_ _07365_ VPWR VGND sg13g2_buf_2
X_30846_ _07367_ \memory_i.freq_inst.dsmod_cos.accu2_r[25]\ \memory_i.freq_inst.dsmod_cos.data_interp_r[25]\ VPWR VGND sg13g2_xnor2_1
X_30847_ _07368_ _07352_ _07366_ _07367_ VPWR VGND sg13g2_a21o_1
X_30848_ _07369_ _07368_ VPWR VGND sg13g2_buf_1
X_30849_ _07370_ _07367_ _07352_ _07366_ VPWR VGND sg13g2_nand3_1
X_30850_ _07371_ _07369_ _07370_ VPWR VGND sg13g2_and2_1
X_30851_ _07372_ _07371_ VPWR VGND sg13g2_buf_1
X_30852_ _07373_ _07051_ _07372_ VPWR VGND sg13g2_nor2_1
X_30853_ _01703_ _07049_ _07344_ _07373_ VPWR VGND sg13g2_nor3_1
X_30854_ _07374_ \memory_i.freq_inst.dsmod_cos.accu2_r[26]\ \memory_i.freq_inst.dsmod_cos.data_interp_r[26]\ VPWR VGND sg13g2_xor2_1
X_30855_ _07375_ \memory_i.freq_inst.dsmod_cos.accu2_r[25]\ \memory_i.freq_inst.dsmod_cos.data_interp_r[25]\ VPWR VGND sg13g2_or2_1
X_30856_ _07376_ _07375_ VPWR VGND sg13g2_buf_1
X_30857_ _07377_ \memory_i.freq_inst.dsmod_cos.accu2_r[25]\ \memory_i.freq_inst.dsmod_cos.data_interp_r[25]\ VPWR VGND sg13g2_nand2_1
X_30858_ _07378_ _07352_ _07366_ _07377_ VPWR VGND sg13g2_nand3_1
X_30859_ _07379_ _07374_ _07376_ _07378_ VPWR VGND sg13g2_and3_1
X_30860_ _07380_ _07379_ VPWR VGND sg13g2_buf_1
X_30861_ _07381_ _07376_ _07378_ _07374_ VPWR VGND sg13g2_a21oi_2
X_30862_ _07382_ _07380_ _07381_ VPWR VGND sg13g2_or2_1
X_30863_ _07383_ _07382_ VPWR VGND sg13g2_buf_1
X_30864_ _07384_ \memory_i.freq_inst.dsmod_cos.i_ena_mod\ _07383_ VPWR VGND sg13g2_nand2_1
X_30865_ _07385_ \memory_i.freq_inst.dsmod_cos.i_ena_mod\ \memory_i.freq_inst.dsmod_cos.accu2_r[26]\ _07384_ VPWR VGND sg13g2_o21ai_1
X_30866_ _01704_ _07182_ _07385_ VPWR VGND sg13g2_nor2_1
X_30867_ _07386_ \memory_i.freq_inst.dsmod_cos.accu2_r[26]\ \memory_i.freq_inst.dsmod_cos.data_interp_r[26]\ VPWR VGND sg13g2_and2_1
X_30868_ _07387_ _07386_ VPWR VGND sg13g2_buf_1
X_30869_ _07388_ \memory_i.freq_inst.dsmod_cos.data_interp_r[25]\ _07348_ _07387_ VPWR VGND sg13g2_nor3_1
X_30870_ _07389_ _07351_ _07366_ _07388_ VPWR VGND sg13g2_nand3_1
X_30871_ _07390_ \memory_i.freq_inst.dsmod_cos.accu2_r[25]\ _07348_ _07387_ VPWR VGND sg13g2_nor3_1
X_30872_ _07391_ _07351_ _07366_ _07390_ VPWR VGND sg13g2_nand3_1
X_30873_ _07392_ \memory_i.freq_inst.dsmod_cos.accu2_r[26]\ \memory_i.freq_inst.dsmod_cos.data_interp_r[26]\ VPWR VGND sg13g2_nor2_1
X_30874_ _07393_ _07376_ _07387_ VPWR VGND sg13g2_nor2_1
X_30875_ _07394_ _07392_ _07393_ VPWR VGND sg13g2_nor2_1
X_30876_ _07395_ _07389_ _07391_ _07394_ VPWR VGND sg13g2_nand3_1
X_30877_ _07396_ \memory_i.freq_inst.dsmod_cos.accu2_r[27]\ \memory_i.freq_inst.dsmod_cos.data_interp_r[27]\ VPWR VGND sg13g2_xor2_1
X_30878_ _07397_ _07395_ _07396_ VPWR VGND sg13g2_xnor2_1
X_30879_ _07398_ \memory_i.freq_inst.dsmod_cos.i_ena_mod\ \memory_i.freq_inst.dsmod_cos.accu2_r[27]\ VPWR VGND sg13g2_nor2b_1
X_30880_ _07399_ \memory_i.freq_inst.dsmod_cos.i_ena_mod\ _07397_ _07398_ VPWR VGND sg13g2_a21oi_1
X_30881_ _01705_ _07182_ _07399_ VPWR VGND sg13g2_nor2_1
X_30882_ _07400_ _06870_ VPWR VGND sg13g2_buf_1
X_30883_ _07401_ \memory_i.freq_inst.dsmod_cos.accu2_r[28]\ \memory_i.freq_inst.dsmod_cos.data_interp_r[28]\ VPWR VGND sg13g2_xor2_1
X_30884_ _07402_ \memory_i.freq_inst.dsmod_cos.data_interp_r[27]\ _07401_ VPWR VGND sg13g2_nand2_1
X_30885_ _07403_ \memory_i.freq_inst.dsmod_cos.accu2_r[27]\ _07401_ VPWR VGND sg13g2_nand2_1
X_30886_ _07404_ _07402_ _07403_ _07395_ VPWR VGND sg13g2_a21oi_1
X_30887_ _07405_ \memory_i.freq_inst.dsmod_cos.accu2_r[26]\ \memory_i.freq_inst.dsmod_cos.data_interp_r[26]\ VPWR VGND sg13g2_or2_1
X_30888_ _07406_ _07376_ _07378_ _07387_ VPWR VGND sg13g2_a21o_1
X_30889_ _07407_ _07406_ VPWR VGND sg13g2_buf_4
X_30890_ _07408_ \memory_i.freq_inst.dsmod_cos.accu2_r[27]\ \memory_i.freq_inst.dsmod_cos.data_interp_r[27]\ _07405_ _07407_ _07401_
+ VPWR
+ VGND sg13g2_a221oi_1
X_30891_ _07409_ \memory_i.freq_inst.dsmod_cos.accu2_r[27]\ \memory_i.freq_inst.dsmod_cos.data_interp_r[27]\ VPWR VGND sg13g2_and2_1
X_30892_ _07410_ _07409_ VPWR VGND sg13g2_buf_1
X_30893_ _07411_ _07401_ _07410_ VPWR VGND sg13g2_and2_1
X_30894_ _07412_ \memory_i.freq_inst.dsmod_cos.accu2_r[27]\ \memory_i.freq_inst.dsmod_cos.data_interp_r[27]\ _07401_ VPWR VGND sg13g2_nor3_1
X_30895_ _07413_ _07404_ _07408_ _07411_ _07412_ VPWR
+ VGND
+ sg13g2_nor4_1
X_30896_ _07414_ _07413_ VPWR VGND sg13g2_buf_2
X_30897_ _07415_ \memory_i.freq_inst.dsmod_cos.i_ena_mod\ \memory_i.freq_inst.dsmod_cos.accu2_r[28]\ VPWR VGND sg13g2_nor2b_1
X_30898_ _07416_ \memory_i.freq_inst.dsmod_cos.i_ena_mod\ _07414_ _07415_ VPWR VGND sg13g2_a21oi_1
X_30899_ _01706_ _07400_ _07416_ VPWR VGND sg13g2_nor2_1
X_30900_ _07417_ \memory_i.freq_inst.dsmod_cos.i_ena_mod\ \memory_i.freq_inst.dsmod_cos.accu2_r[29]\ VPWR VGND sg13g2_nor2_1
X_30901_ _07418_ \memory_i.freq_inst.dsmod_cos.accu2_r[28]\ \memory_i.freq_inst.dsmod_cos.data_interp_r[28]\ \memory_i.freq_inst.dsmod_cos.accu2_r[27]\ VPWR VGND sg13g2_o21ai_1
X_30902_ _07419_ _07392_ _07418_ VPWR VGND sg13g2_nor2_1
X_30903_ _07420_ \memory_i.freq_inst.dsmod_cos.accu2_r[28]\ \memory_i.freq_inst.dsmod_cos.data_interp_r[28]\ \memory_i.freq_inst.dsmod_cos.data_interp_r[27]\ VPWR VGND sg13g2_o21ai_1
X_30904_ _07421_ \memory_i.freq_inst.dsmod_cos.data_interp_r[28]\ _07410_ \memory_i.freq_inst.dsmod_cos.accu2_r[28]\ VPWR VGND sg13g2_a21o_1
X_30905_ _07422_ \memory_i.freq_inst.dsmod_cos.data_interp_r[28]\ _07410_ _07421_ VPWR VGND sg13g2_o21ai_1
X_30906_ _07423_ _07392_ _07420_ _07422_ VPWR VGND sg13g2_o21ai_1
X_30907_ _07424_ _06860_ _07352_ _07366_ VPWR VGND sg13g2_nand3_1
X_30908_ _07425_ \memory_i.freq_inst.dsmod_cos.data_interp_r[25]\ _07348_ VPWR VGND sg13g2_and2_1
X_30909_ _07426_ _06860_ _07351_ VPWR VGND sg13g2_nor2_1
X_30910_ _07427_ _07293_ _07297_ _07357_ VPWR VGND sg13g2_or3_1
X_30911_ _07428_ _07298_ _07363_ _07427_ _07361_ _06860_
+ VPWR
+ VGND sg13g2_a221oi_1
X_30912_ _07429_ _07387_ _07422_ VPWR VGND sg13g2_nand2b_1
X_30913_ _07430_ _07425_ _07426_ _07428_ _07429_ VPWR
+ VGND
+ sg13g2_or4_1
X_30914_ _07431_ \memory_i.freq_inst.dsmod_cos.accu2_r[25]\ _07424_ _07430_ VPWR VGND sg13g2_a21o_1
X_30915_ _07432_ _07431_ VPWR VGND sg13g2_buf_1
X_30916_ _07433_ _07407_ _07419_ _07423_ _07432_ VPWR
+ VGND
+ sg13g2_a22oi_1
X_30917_ _07434_ \memory_i.freq_inst.dsmod_cos.accu2_r[29]\ \memory_i.freq_inst.dsmod_cos.data_interp_r[29]\ VPWR VGND sg13g2_xor2_1
X_30918_ _07435_ _07433_ _07434_ VPWR VGND sg13g2_xnor2_1
X_30919_ _07436_ _07435_ VPWR VGND sg13g2_buf_1
X_30920_ _07437_ _07051_ _07436_ VPWR VGND sg13g2_nor2_1
X_30921_ _01707_ _07049_ _07417_ _07437_ VPWR VGND sg13g2_nor3_1
X_30922_ _07438_ \memory_i.freq_inst.dsmod_cos.accu2_r[30]\ \memory_i.freq_inst.dsmod_cos.data_interp_r[30]\ VPWR VGND sg13g2_xnor2_1
X_30923_ _07439_ \memory_i.freq_inst.dsmod_cos.accu2_r[29]\ \memory_i.freq_inst.dsmod_cos.data_interp_r[29]\ VPWR VGND sg13g2_nor2_1
X_30924_ _07440_ \memory_i.freq_inst.dsmod_cos.accu2_r[29]\ \memory_i.freq_inst.dsmod_cos.data_interp_r[29]\ VPWR VGND sg13g2_nand2_1
X_30925_ _07441_ _07433_ _07439_ _07440_ VPWR VGND sg13g2_o21ai_1
X_30926_ _07442_ _07438_ _07441_ VPWR VGND sg13g2_xnor2_1
X_30927_ _07443_ \memory_i.freq_inst.dsmod_cos.i_ena_mod\ _07442_ VPWR VGND sg13g2_nand2_1
X_30928_ _07444_ _12941_ \memory_i.freq_inst.dsmod_cos.accu2_r[30]\ VPWR VGND sg13g2_nand2_1
X_30929_ _01708_ _07443_ _07444_ _06484_ VPWR VGND sg13g2_a21oi_1
X_30930_ _07445_ \memory_i.freq_inst.dsmod_cos.accu2_r[30]\ \memory_i.freq_inst.dsmod_cos.data_interp_r[30]\ VPWR VGND sg13g2_nand2_1
X_30931_ _07446_ _05935_ _07445_ VPWR VGND sg13g2_nand2_1
X_30932_ _07447_ _07407_ _07419_ _07423_ _07432_ _07446_
+ VPWR
+ VGND sg13g2_a221oi_1
X_30933_ _07448_ _07447_ VPWR VGND sg13g2_buf_2
X_30934_ _07449_ \memory_i.freq_inst.dsmod_cos.accu2_r[29]\ _07445_ VPWR VGND sg13g2_nand2b_1
X_30935_ _07450_ _07407_ _07419_ _07423_ _07432_ _07449_
+ VPWR
+ VGND sg13g2_a221oi_1
X_30936_ _07451_ _07450_ VPWR VGND sg13g2_buf_2
X_30937_ _07452_ _07439_ _07445_ VPWR VGND sg13g2_nand2_1
X_30938_ _07453_ \memory_i.freq_inst.dsmod_cos.accu2_r[30]\ \memory_i.freq_inst.dsmod_cos.data_interp_r[30]\ _07452_ VPWR VGND sg13g2_o21ai_1
X_30939_ _07454_ _07453_ VPWR VGND sg13g2_buf_1
X_30940_ _07455_ _07448_ _07451_ _07454_ VPWR VGND sg13g2_or3_1
X_30941_ _07456_ \memory_i.freq_inst.dsmod_cos.data_interp_r[31]\ _07455_ VPWR VGND sg13g2_xnor2_1
X_30942_ _07457_ \memory_i.freq_inst.dsmod_cos.i_ena_mod\ _07456_ VPWR VGND sg13g2_nand2_1
X_30943_ _07458_ \memory_i.freq_inst.dsmod_cos.accu2_r[31]\ _07457_ VPWR VGND sg13g2_xor2_1
X_30944_ _01709_ _07400_ _07458_ VPWR VGND sg13g2_nor2_1
X_30945_ _07459_ _07448_ _07451_ _07454_ VPWR VGND sg13g2_nor3_2
X_30946_ _07460_ \memory_i.freq_inst.dsmod_cos.data_interp_r[31]\ _07459_ VPWR VGND sg13g2_nor2_1
X_30947_ _07461_ \memory_i.freq_inst.dsmod_cos.data_interp_r[31]\ _07459_ \memory_i.freq_inst.dsmod_cos.accu2_r[31]\ VPWR VGND sg13g2_a21oi_1
X_30948_ _07462_ \memory_i.freq_inst.dsmod_cos.accu2_r[32]\ \memory_i.freq_inst.dsmod_cos.data_interp_r[32]\ VPWR VGND sg13g2_xor2_1
X_30949_ _07463_ _07462_ VPWR VGND sg13g2_inv_1
X_30950_ _07464_ _07460_ _07461_ _07463_ VPWR VGND sg13g2_o21ai_1
X_30951_ _07465_ _07460_ _07463_ _07461_ VPWR VGND sg13g2_or3_1
X_30952_ _07466_ _07465_ VPWR VGND sg13g2_buf_1
X_30953_ _07467_ \memory_i.freq_inst.dsmod_cos.i_ena_mod\ _07464_ _07466_ VPWR VGND sg13g2_nand3_1
X_30954_ _07468_ _12941_ \memory_i.freq_inst.dsmod_cos.accu2_r[32]\ VPWR VGND sg13g2_nand2_1
X_30955_ _01710_ _07467_ _07468_ _06484_ VPWR VGND sg13g2_a21oi_1
X_30956_ _07469_ \memory_i.freq_inst.dsmod_cos.accu2_r[32]\ \memory_i.freq_inst.dsmod_cos.data_interp_r[32]\ VPWR VGND sg13g2_nor2_1
X_30957_ _07470_ \memory_i.freq_inst.dsmod_cos.accu2_r[32]\ \memory_i.freq_inst.dsmod_cos.data_interp_r[32]\ \memory_i.freq_inst.dsmod_cos.data_interp_r[31]\ \memory_i.freq_inst.dsmod_cos.accu2_r[31]\ _07459_
+ VPWR
+ VGND sg13g2_a221oi_1
X_30958_ _07471_ \memory_i.freq_inst.dsmod_cos.accu2_r[32]\ \memory_i.freq_inst.dsmod_cos.data_interp_r[32]\ VPWR VGND sg13g2_and2_1
X_30959_ _07472_ _07471_ VPWR VGND sg13g2_buf_1
X_30960_ _07473_ \memory_i.freq_inst.dsmod_cos.accu2_r[31]\ \memory_i.freq_inst.dsmod_cos.data_interp_r[31]\ _07472_ VPWR VGND sg13g2_nor3_1
X_30961_ _07474_ _07469_ _07470_ _07473_ VPWR VGND sg13g2_nor3_1
X_30962_ _07475_ \memory_i.freq_inst.dsmod_cos.data_interp_r[33]\ _07474_ VPWR VGND sg13g2_xnor2_1
X_30963_ _07476_ _07183_ _07475_ VPWR VGND sg13g2_nor2_1
X_30964_ _07477_ \memory_i.freq_inst.dsmod_cos.accu2_r[33]\ _07476_ VPWR VGND sg13g2_xnor2_1
X_30965_ _01711_ _07400_ _07477_ VPWR VGND sg13g2_nor2_1
X_30966_ _07478_ \memory_i.freq_inst.dsmod_cos.i_ena_mod\ \memory_i.freq_inst.dsmod_cos.accu2_r[34]\ VPWR VGND sg13g2_nor2_1
X_30967_ _07479_ \memory_i.freq_inst.dsmod_cos.data_interp_r[33]\ \memory_i.freq_inst.dsmod_cos.data_interp_r[31]\ _07472_ VPWR VGND sg13g2_or3_1
X_30968_ _07480_ \memory_i.freq_inst.dsmod_cos.accu2_r[31]\ \memory_i.freq_inst.dsmod_cos.data_interp_r[33]\ _07472_ VPWR VGND sg13g2_or3_1
X_30969_ _07481_ _07479_ _07480_ _07459_ VPWR VGND sg13g2_a21o_1
X_30970_ _07482_ \memory_i.freq_inst.dsmod_cos.data_interp_r[31]\ _07480_ VPWR VGND sg13g2_nor2_1
X_30971_ _07483_ _05972_ _07469_ _07482_ VPWR VGND sg13g2_a21oi_1
X_30972_ _07484_ \memory_i.freq_inst.dsmod_cos.accu2_r[33]\ _07481_ _07483_ VPWR VGND sg13g2_nand3_1
X_30973_ _07485_ _07484_ VPWR VGND sg13g2_buf_8
X_30974_ _07486_ \memory_i.freq_inst.dsmod_cos.accu2_r[32]\ \memory_i.freq_inst.dsmod_cos.data_interp_r[32]\ VPWR VGND sg13g2_or2_1
X_30975_ _07487_ \memory_i.freq_inst.dsmod_cos.data_interp_r[33]\ \memory_i.freq_inst.dsmod_cos.data_interp_r[31]\ _07486_ VPWR VGND sg13g2_nand3_1
X_30976_ _07488_ _07448_ _07451_ _07454_ _07487_ VPWR
+ VGND
+ sg13g2_nor4_1
X_30977_ _07489_ \memory_i.freq_inst.dsmod_cos.accu2_r[31]\ \memory_i.freq_inst.dsmod_cos.data_interp_r[33]\ _07486_ VPWR VGND sg13g2_nand3_1
X_30978_ _07490_ _07448_ _07451_ _07454_ _07489_ VPWR
+ VGND
+ sg13g2_nor4_1
X_30979_ _07491_ \memory_i.freq_inst.dsmod_cos.data_interp_r[31]\ VPWR VGND sg13g2_inv_1
X_30980_ _07492_ \memory_i.freq_inst.dsmod_cos.data_interp_r[33]\ _07472_ VPWR VGND sg13g2_nand2_1
X_30981_ _07493_ _07491_ _07489_ _07492_ VPWR VGND sg13g2_o21ai_1
X_30982_ _07494_ _07488_ _07490_ _07493_ VPWR VGND sg13g2_nor3_2
X_30983_ _07495_ _07494_ VPWR VGND sg13g2_buf_8
X_30984_ _07496_ _07485_ _07495_ VPWR VGND sg13g2_nand2_1
X_30985_ _07497_ \memory_i.freq_inst.dsmod_cos.accu2_r[34]\ \memory_i.freq_inst.dsmod_cos.data_interp_r[34]\ VPWR VGND sg13g2_xnor2_1
X_30986_ _07498_ _07496_ _07497_ VPWR VGND sg13g2_xnor2_1
X_30987_ _07499_ _07498_ VPWR VGND sg13g2_buf_1
X_30988_ _07500_ _07051_ _07499_ VPWR VGND sg13g2_nor2_1
X_30989_ _01712_ _07049_ _07478_ _07500_ VPWR VGND sg13g2_nor3_1
X_30990_ _07501_ \memory_i.freq_inst.dsmod_cos.data_interp_r[35]\ _05971_ _07485_ _07495_ VPWR
+ VGND
+ sg13g2_nand4_1
X_30991_ _07502_ \memory_i.freq_inst.dsmod_cos.accu2_r[34]\ VPWR VGND sg13g2_inv_1
X_30992_ _07503_ _07502_ \memory_i.freq_inst.dsmod_cos.data_interp_r[35]\ _07485_ _07495_ VPWR
+ VGND
+ sg13g2_nand4_1
X_30993_ _07504_ _07501_ _07503_ VPWR VGND sg13g2_and2_1
X_30994_ _07505_ _05988_ \memory_i.freq_inst.dsmod_cos.data_interp_r[34]\ VPWR VGND sg13g2_nand2_1
X_30995_ _07506_ \memory_i.freq_inst.dsmod_cos.accu2_r[34]\ _05988_ VPWR VGND sg13g2_nand2_1
X_30996_ _07507_ _07505_ _07506_ _07495_ VPWR VGND sg13g2_a21oi_1
X_30997_ _07508_ _07485_ _07505_ VPWR VGND sg13g2_nor2_1
X_30998_ _07509_ _07507_ _07508_ VPWR VGND sg13g2_nor2_1
X_30999_ _07510_ _07485_ _07506_ VPWR VGND sg13g2_nor2_1
X_31000_ _07511_ \memory_i.freq_inst.dsmod_cos.accu2_r[34]\ \memory_i.freq_inst.dsmod_cos.data_interp_r[35]\ _05971_ VPWR VGND sg13g2_nand3b_1
X_31001_ _07512_ _05971_ _07506_ _07511_ VPWR VGND sg13g2_o21ai_1
X_31002_ _07513_ _07510_ _07512_ VPWR VGND sg13g2_nor2_1
X_31003_ _07514_ _07504_ _07509_ _07513_ VPWR VGND sg13g2_nand3_1
X_31004_ _07515_ _07514_ VPWR VGND sg13g2_buf_1
X_31005_ _07516_ \memory_i.freq_inst.dsmod_cos.i_ena_mod\ _07515_ VPWR VGND sg13g2_nand2_1
X_31006_ _07517_ \memory_i.freq_inst.dsmod_cos.accu2_r[35]\ _07516_ VPWR VGND sg13g2_xor2_1
X_31007_ _01713_ _07400_ _07517_ VPWR VGND sg13g2_nor2_1
X_31008_ _07518_ \memory_i.freq_inst.dsmod_cos.accu2_r[35]\ \memory_i.freq_inst.dsmod_cos.data_interp_r[35]\ VPWR VGND sg13g2_nand2_1
X_31009_ _07519_ _05971_ _07495_ _07518_ VPWR VGND sg13g2_and3_1
X_31010_ _07520_ _07518_ VPWR VGND sg13g2_inv_1
X_31011_ _07521_ \memory_i.freq_inst.dsmod_cos.accu2_r[34]\ _07520_ VPWR VGND sg13g2_nor2_1
X_31012_ _07522_ _07495_ _07521_ VPWR VGND sg13g2_and2_1
X_31013_ _07523_ _07519_ _07522_ _07485_ VPWR VGND sg13g2_o21ai_1
X_31014_ _07524_ \memory_i.freq_inst.dsmod_cos.accu2_r[34]\ \memory_i.freq_inst.dsmod_cos.data_interp_r[34]\ VPWR VGND sg13g2_nor2_1
X_31015_ _07525_ _07524_ _07518_ VPWR VGND sg13g2_nand2_1
X_31016_ _07526_ \memory_i.freq_inst.dsmod_cos.accu2_r[35]\ \memory_i.freq_inst.dsmod_cos.data_interp_r[35]\ _07525_ VPWR VGND sg13g2_o21ai_1
X_31017_ _07527_ _07526_ VPWR VGND sg13g2_inv_1
X_31018_ _07528_ _07523_ _07527_ VPWR VGND sg13g2_and2_1
X_31019_ _07529_ _07528_ VPWR VGND sg13g2_buf_1
X_31020_ _07530_ \memory_i.freq_inst.dsmod_cos.accu2_r[36]\ \memory_i.freq_inst.dsmod_cos.data_interp_r[36]\ VPWR VGND sg13g2_xor2_1
X_31021_ _07531_ _07529_ _07530_ VPWR VGND sg13g2_xor2_1
X_31022_ _07532_ \memory_i.freq_inst.dsmod_cos.i_ena_mod\ \memory_i.freq_inst.dsmod_cos.accu2_r[36]\ VPWR VGND sg13g2_nor2b_1
X_31023_ _07533_ \memory_i.freq_inst.dsmod_cos.i_ena_mod\ _07531_ _07532_ VPWR VGND sg13g2_a21oi_1
X_31024_ _01714_ _07400_ _07533_ VPWR VGND sg13g2_nor2_1
X_31025_ _07534_ _07502_ _07495_ VPWR VGND sg13g2_and2_1
X_31026_ _07535_ _07485_ _07534_ _07524_ VPWR VGND sg13g2_a21oi_1
X_31027_ _07536_ _05971_ _07495_ VPWR VGND sg13g2_and2_1
X_31028_ _07537_ \memory_i.freq_inst.dsmod_cos.accu2_r[35]\ \memory_i.freq_inst.dsmod_cos.data_interp_r[35]\ \memory_i.freq_inst.dsmod_cos.accu2_r[36]\ VPWR VGND sg13g2_o21ai_1
X_31029_ _07538_ _07485_ _07536_ _07537_ VPWR VGND sg13g2_a21oi_1
X_31030_ _07539_ \memory_i.freq_inst.dsmod_cos.data_interp_r[36]\ _07520_ \memory_i.freq_inst.dsmod_cos.accu2_r[36]\ VPWR VGND sg13g2_o21ai_1
X_31031_ _07540_ _07539_ VPWR VGND sg13g2_inv_1
X_31032_ _07541_ _07535_ _07538_ _07540_ VPWR VGND sg13g2_a21o_1
X_31033_ _07542_ _07541_ VPWR VGND sg13g2_buf_8
X_31034_ _07543_ \memory_i.freq_inst.dsmod_cos.data_interp_r[36]\ _07523_ _07527_ VPWR VGND sg13g2_and3_1
X_31035_ _07544_ _07543_ VPWR VGND sg13g2_buf_8
X_31036_ _07545_ _07542_ _07544_ \memory_i.freq_inst.dsmod_cos.data_interp_r[37]\ VPWR VGND sg13g2_o21ai_1
X_31037_ _07546_ _07535_ _07538_ _07540_ VPWR VGND sg13g2_a21oi_1
X_31038_ _07547_ \memory_i.freq_inst.dsmod_cos.data_interp_r[36]\ _07523_ _07527_ VPWR VGND sg13g2_nand3_1
X_31039_ _07548_ _07547_ VPWR VGND sg13g2_buf_1
X_31040_ _07549_ _06975_ _07546_ _07548_ VPWR VGND sg13g2_nand3_1
X_31041_ _07550_ _07545_ _07549_ _05737_ VPWR VGND sg13g2_a21oi_1
X_31042_ _07551_ \memory_i.freq_inst.dsmod_cos.accu2_r[37]\ _07550_ VPWR VGND sg13g2_xnor2_1
X_31043_ _01715_ _07400_ _07551_ VPWR VGND sg13g2_nor2_1
X_31044_ _07552_ \memory_i.freq_inst.dsmod_cos.accu2_r[38]\ _13397_ VPWR VGND sg13g2_nor2_1
X_31045_ _07553_ \memory_i.freq_inst.dsmod_cos.accu2_r[38]\ _13397_ VPWR VGND sg13g2_nand2_1
X_31046_ _07554_ _07552_ _07553_ VPWR VGND sg13g2_nand2b_1
X_31047_ _07555_ \memory_i.freq_inst.dsmod_cos.accu2_r[37]\ _06975_ VPWR VGND sg13g2_nand2_1
X_31048_ _07556_ \memory_i.freq_inst.dsmod_cos.accu2_r[37]\ VPWR VGND sg13g2_inv_1
X_31049_ _07557_ _07556_ \memory_i.freq_inst.dsmod_cos.data_interp_r[37]\ VPWR VGND sg13g2_nand2_1
X_31050_ _07558_ _07542_ _07544_ _07557_ VPWR VGND sg13g2_o21ai_1
X_31051_ _07559_ _07558_ VPWR VGND sg13g2_buf_2
X_31052_ _07560_ _07555_ _07559_ VPWR VGND sg13g2_nand2_2
X_31053_ _07561_ _07554_ _07560_ VPWR VGND sg13g2_xor2_1
X_31054_ _07562_ _07561_ VPWR VGND sg13g2_buf_1
X_31055_ _07563_ \memory_i.freq_inst.dsmod_cos.i_ena_mod\ \memory_i.freq_inst.dsmod_cos.accu2_r[38]\ VPWR VGND sg13g2_nor2b_1
X_31056_ _07564_ \memory_i.freq_inst.dsmod_cos.i_ena_mod\ _07562_ _07563_ VPWR VGND sg13g2_a21oi_1
X_31057_ _01716_ _07400_ _07564_ VPWR VGND sg13g2_nor2_1
X_31058_ _07565_ _07555_ _07559_ _07553_ VPWR VGND sg13g2_a21oi_1
X_31059_ _07566_ _07552_ _07555_ _07559_ VPWR VGND sg13g2_and3_2
X_31060_ _07567_ _07566_ VPWR VGND sg13g2_buf_2
X_31061_ _07568_ _07565_ _07567_ VPWR VGND sg13g2_nor2_1
X_31062_ _07569_ _07183_ _07568_ VPWR VGND sg13g2_nor2_1
X_31063_ _07570_ \memory_i.freq_inst.dsmod_cos.accu2_r[39]\ _07569_ VPWR VGND sg13g2_xnor2_1
X_31064_ _01717_ _07400_ _07570_ VPWR VGND sg13g2_nor2_1
X_31065_ _07571_ \memory_i.freq_inst.dsmod_cos.accu2_r[38]\ _07556_ _06975_ VPWR VGND sg13g2_nand3_1
X_31066_ _07572_ \memory_i.freq_inst.dsmod_cos.accu2_r[38]\ \memory_i.freq_inst.dsmod_cos.accu2_r[37]\ \memory_i.freq_inst.dsmod_cos.data_interp_r[37]\ VPWR VGND sg13g2_nand3_1
X_31067_ _07573_ _07546_ _07548_ _07571_ _07572_ VPWR
+ VGND
+ sg13g2_a22oi_1
X_31068_ _07574_ \memory_i.freq_inst.dsmod_cos.accu2_r[38]\ \memory_i.freq_inst.dsmod_cos.accu2_r[37]\ VPWR VGND sg13g2_nand2_1
X_31069_ _07575_ \memory_i.freq_inst.dsmod_cos.data_interp_r[37]\ _07542_ _07544_ _07574_ VPWR
+ VGND
+ sg13g2_or4_1
X_31070_ _07576_ _13383_ _07555_ VPWR VGND sg13g2_nand2_1
X_31071_ _07577_ _07573_ _07575_ _07576_ VPWR VGND sg13g2_nand3b_1
X_31072_ _07578_ \memory_i.freq_inst.dsmod_cos.accu2_r[39]\ _13397_ VPWR VGND sg13g2_nor2_1
X_31073_ _07579_ \memory_i.freq_inst.dsmod_cos.accu2_r[39]\ _07542_ _07544_ _07557_ VPWR
+ VGND
+ sg13g2_or4_1
X_31074_ _07580_ \memory_i.freq_inst.dsmod_cos.accu2_r[38]\ \memory_i.freq_inst.dsmod_cos.accu2_r[39]\ VPWR VGND sg13g2_nor2b_1
X_31075_ _07581_ \memory_i.freq_inst.dsmod_cos.accu2_r[39]\ \memory_i.freq_inst.dsmod_cos.accu2_r[38]\ VPWR VGND sg13g2_nor2b_1
X_31076_ _07582_ _07580_ _07581_ _13383_ VPWR VGND sg13g2_o21ai_1
X_31077_ _07583_ \memory_i.freq_inst.dsmod_cos.accu2_r[38]\ _07579_ _07582_ VPWR VGND sg13g2_o21ai_1
X_31078_ _07584_ \memory_i.freq_inst.dsmod_cos.accu2_r[39]\ _07577_ _07578_ _07560_ _07583_
+ VPWR
+ VGND sg13g2_a221oi_1
X_31079_ _07585_ \memory_i.freq_inst.dsmod_cos.accu2_r[40]\ \memory_i.freq_inst.dsmod_cos.data_interp_r[37]\ VPWR VGND sg13g2_xnor2_1
X_31080_ _07586_ _13396_ _07585_ VPWR VGND sg13g2_xnor2_1
X_31081_ _07587_ _07586_ VPWR VGND sg13g2_buf_1
X_31082_ _07588_ \memory_i.freq_inst.dsmod_cos.accu2_r[39]\ _07587_ VPWR VGND sg13g2_nor2_1
X_31083_ _07589_ \memory_i.freq_inst.dsmod_cos.data_interp_r[37]\ _07587_ VPWR VGND sg13g2_and2_1
X_31084_ _07590_ \memory_i.freq_inst.dsmod_cos.accu2_r[38]\ \memory_i.freq_inst.dsmod_cos.accu2_r[37]\ _07542_ _07544_ VPWR
+ VGND
+ sg13g2_or4_1
X_31085_ _07591_ _07588_ _07589_ _07590_ VPWR VGND sg13g2_mux2_1
X_31086_ _07592_ \memory_i.freq_inst.dsmod_cos.accu2_r[39]\ \memory_i.freq_inst.dsmod_cos.accu2_r[38]\ \memory_i.freq_inst.dsmod_cos.accu2_r[37]\ _07587_ VPWR
+ VGND
+ sg13g2_nand4_1
X_31087_ _07593_ _07546_ _07548_ _07592_ VPWR VGND sg13g2_a21oi_1
X_31088_ _07594_ \memory_i.freq_inst.dsmod_cos.data_interp_r[37]\ _07542_ _07544_ _07587_ VPWR
+ VGND
+ sg13g2_nor4_1
X_31089_ _07595_ _06975_ _07574_ VPWR VGND sg13g2_nand2_1
X_31090_ _07596_ \memory_i.freq_inst.dsmod_cos.accu2_r[39]\ \memory_i.freq_inst.dsmod_cos.data_interp_r[37]\ _07587_ VPWR VGND sg13g2_nand3_1
X_31091_ _07597_ _07587_ _07595_ _07596_ VPWR VGND sg13g2_o21ai_1
X_31092_ _07598_ \memory_i.freq_inst.dsmod_cos.accu2_r[39]\ \memory_i.freq_inst.dsmod_cos.data_interp_r[37]\ _07587_ VPWR VGND sg13g2_nor3_1
X_31093_ _07599_ _07597_ _07598_ VPWR VGND sg13g2_or2_1
X_31094_ _07600_ _07591_ _07593_ _07594_ _07599_ VPWR
+ VGND
+ sg13g2_nor4_1
X_31095_ _07601_ _07584_ _07600_ VPWR VGND sg13g2_xnor2_1
X_31096_ _07602_ _12940_ \memory_i.freq_inst.dsmod_cos.accu2_r[40]\ VPWR VGND sg13g2_nand2_1
X_31097_ _07603_ _05705_ _07601_ _07602_ VPWR VGND sg13g2_o21ai_1
X_31098_ _01718_ \memory_i.freq_inst.cordic.rstn_i\ _07603_ VPWR VGND sg13g2_and2_1
X_31099_ _07604_ \memory_i.freq_inst.dsmod_cos.accu2_r[40]\ \memory_i.freq_inst.dsmod_cos.accu2_r[39]\ VPWR VGND sg13g2_nor2_1
X_31100_ _07605_ _07567_ _07604_ VPWR VGND sg13g2_nand2_1
X_31101_ _07606_ \memory_i.freq_inst.dsmod_cos.accu2_r[40]\ \memory_i.freq_inst.dsmod_cos.accu2_r[39]\ _07565_ VPWR VGND sg13g2_nand3_1
X_31102_ _07607_ _07605_ _07606_ VPWR VGND sg13g2_nand2_1
X_31103_ _07608_ \memory_i.freq_inst.dsmod_cos.i_ena_mod\ _07607_ VPWR VGND sg13g2_nand2_1
X_31104_ _07609_ \memory_i.freq_inst.dsmod_cos.accu2_r[41]\ _07608_ VPWR VGND sg13g2_xor2_1
X_31105_ _01719_ _07400_ _07609_ VPWR VGND sg13g2_nor2_1
X_31106_ _07610_ \memory_i.freq_inst.dsmod_cos.accu2_r[0]\ \memory_i.freq_inst.dsmod_cos.data_interp_r[0]\ VPWR VGND sg13g2_xnor2_1
X_31107_ _07611_ _07183_ _07610_ VPWR VGND sg13g2_nor2_1
X_31108_ _07612_ \memory_i.freq_inst.dsmod_cos.accu3_r[0]\ _07611_ VPWR VGND sg13g2_xnor2_1
X_31109_ _01720_ _07400_ _07612_ VPWR VGND sg13g2_nor2_1
X_31110_ _07613_ _06870_ VPWR VGND sg13g2_buf_1
X_31111_ _07614_ \memory_i.freq_inst.dsmod_cos.accu3_r[1]\ VPWR VGND sg13g2_inv_1
X_31112_ _07615_ \memory_i.freq_inst.dsmod_cos.accu2_r[0]\ \memory_i.freq_inst.dsmod_cos.data_interp_r[0]\ VPWR VGND sg13g2_or2_1
X_31113_ _07616_ \memory_i.freq_inst.dsmod_cos.accu3_r[0]\ _07003_ _07615_ VPWR VGND sg13g2_o21ai_1
X_31114_ _07617_ \memory_i.freq_inst.dsmod_cos.accu2_r[1]\ \memory_i.freq_inst.dsmod_cos.data_interp_r[1]\ VPWR VGND sg13g2_xnor2_1
X_31115_ _07618_ _07616_ _07617_ VPWR VGND sg13g2_xor2_1
X_31116_ _07619_ \memory_i.freq_inst.dsmod_cos.i_ena_mod\ _07618_ VPWR VGND sg13g2_nand2_1
X_31117_ _07620_ _07614_ _07619_ VPWR VGND sg13g2_xnor2_1
X_31118_ _01721_ _07613_ _07620_ VPWR VGND sg13g2_nor2_1
X_31119_ _07621_ _07617_ \memory_i.freq_inst.dsmod_cos.accu3_r[0]\ _07615_ VPWR VGND sg13g2_nand3b_1
X_31120_ _07622_ _07617_ _07003_ VPWR VGND sg13g2_nor2b_1
X_31121_ _07623_ _07616_ _07617_ _07621_ _07614_ _07622_
+ VPWR
+ VGND sg13g2_a221oi_1
X_31122_ _07624_ _07623_ VPWR VGND sg13g2_buf_1
X_31123_ _07625_ _07014_ _07624_ VPWR VGND sg13g2_xnor2_1
X_31124_ _07626_ _07183_ _07625_ VPWR VGND sg13g2_nor2_1
X_31125_ _07627_ \memory_i.freq_inst.dsmod_cos.accu3_r[2]\ _07626_ VPWR VGND sg13g2_xnor2_1
X_31126_ _01722_ _07613_ _07627_ VPWR VGND sg13g2_nor2_1
X_31127_ _07628_ \memory_i.freq_inst.dsmod_cos.accu2_r[3]\ \memory_i.freq_inst.dsmod_cos.data_interp_r[3]\ VPWR VGND sg13g2_xor2_1
X_31128_ _07629_ _07025_ _07020_ _07628_ VPWR VGND sg13g2_or3_1
X_31129_ _07630_ _07025_ _07020_ _07628_ VPWR VGND sg13g2_o21ai_1
X_31130_ _07631_ _07629_ _07630_ VPWR VGND sg13g2_nand2_1
X_31131_ _07632_ _07014_ _07624_ \memory_i.freq_inst.dsmod_cos.accu3_r[2]\ VPWR VGND sg13g2_a21oi_1
X_31132_ _07633_ _07014_ _07624_ VPWR VGND sg13g2_nor2_1
X_31133_ _07634_ _07632_ _07633_ VPWR VGND sg13g2_nor2_1
X_31134_ _07635_ _07631_ _07634_ VPWR VGND sg13g2_xnor2_1
X_31135_ _07636_ \memory_i.freq_inst.dsmod_cos.i_ena_mod\ _07635_ VPWR VGND sg13g2_nand2_1
X_31136_ _07637_ \memory_i.freq_inst.dsmod_cos.accu3_r[3]\ _07636_ VPWR VGND sg13g2_xor2_1
X_31137_ _01723_ _07613_ _07637_ VPWR VGND sg13g2_nor2_1
X_31138_ _07638_ \memory_i.freq_inst.dsmod_cos.accu3_r[3]\ _07629_ _07630_ VPWR VGND sg13g2_nand3_1
X_31139_ _07639_ _07632_ _07633_ _07638_ VPWR VGND sg13g2_o21ai_1
X_31140_ _07640_ \memory_i.freq_inst.dsmod_cos.accu3_r[3]\ _07631_ VPWR VGND sg13g2_nand2b_1
X_31141_ _07641_ _07639_ _07640_ VPWR VGND sg13g2_and2_1
X_31142_ _07642_ \memory_i.freq_inst.dsmod_cos.accu2_r[4]\ \memory_i.freq_inst.dsmod_cos.data_interp_r[4]\ VPWR VGND sg13g2_xnor2_1
X_31143_ _07643_ _07024_ _07056_ _07642_ VPWR VGND sg13g2_nand3_1
X_31144_ _07644_ _07024_ _07056_ _07642_ VPWR VGND sg13g2_a21o_1
X_31145_ _07645_ _07643_ _07644_ VPWR VGND sg13g2_nand2_1
X_31146_ _07646_ _07641_ _07645_ VPWR VGND sg13g2_xnor2_1
X_31147_ _07647_ _07183_ _07646_ VPWR VGND sg13g2_nor2_1
X_31148_ _07648_ \memory_i.freq_inst.dsmod_cos.accu3_r[4]\ _07647_ VPWR VGND sg13g2_xnor2_1
X_31149_ _01724_ _07613_ _07648_ VPWR VGND sg13g2_nor2_1
X_31150_ _07649_ \memory_i.freq_inst.dsmod_cos.accu3_r[4]\ _07643_ _07644_ VPWR VGND sg13g2_nand3b_1
X_31151_ _07650_ _07642_ \memory_i.freq_inst.dsmod_cos.accu3_r[4]\ VPWR VGND sg13g2_nand2b_1
X_31152_ _07651_ \memory_i.freq_inst.dsmod_cos.accu3_r[4]\ _07024_ _07056_ _07642_ VPWR
+ VGND
+ sg13g2_nand4_1
X_31153_ _07652_ _07030_ _07650_ _07651_ VPWR VGND sg13g2_o21ai_1
X_31154_ _07653_ _07641_ _07649_ _07652_ VPWR VGND sg13g2_a21o_1
X_31155_ _07654_ _07046_ _07653_ VPWR VGND sg13g2_xor2_1
X_31156_ _07655_ \memory_i.freq_inst.dsmod_cos.i_ena_mod\ _07654_ VPWR VGND sg13g2_nand2_1
X_31157_ _07656_ \memory_i.freq_inst.dsmod_cos.accu3_r[5]\ _07655_ VPWR VGND sg13g2_xor2_1
X_31158_ _01725_ _07613_ _07656_ VPWR VGND sg13g2_nor2_1
X_31159_ _07657_ \memory_i.freq_inst.dsmod_cos.accu3_r[5]\ _07045_ VPWR VGND sg13g2_nand2b_1
X_31160_ _07658_ \memory_i.freq_inst.dsmod_cos.accu3_r[5]\ _07045_ VPWR VGND sg13g2_or2_1
X_31161_ _07659_ _07657_ _07658_ _07044_ VPWR VGND sg13g2_mux2_1
X_31162_ _07660_ _07639_ _07640_ _07649_ _07659_ VPWR
+ VGND
+ sg13g2_nand4_1
X_31163_ _07661_ \memory_i.freq_inst.dsmod_cos.accu3_r[5]\ _07046_ _07652_ _07659_ VPWR
+ VGND
+ sg13g2_a22oi_1
X_31164_ _07662_ _07660_ _07661_ VPWR VGND sg13g2_nand2_1
X_31165_ _07663_ _07071_ _07662_ VPWR VGND sg13g2_xnor2_1
X_31166_ _07664_ _07183_ _07663_ VPWR VGND sg13g2_nor2_1
X_31167_ _07665_ \memory_i.freq_inst.dsmod_cos.accu3_r[6]\ _07664_ VPWR VGND sg13g2_xnor2_1
X_31168_ _01726_ _07613_ _07665_ VPWR VGND sg13g2_nor2_1
X_31169_ _07666_ \memory_i.freq_inst.dsmod_cos.accu3_r[7]\ VPWR VGND sg13g2_inv_1
X_31170_ _07667_ \memory_i.freq_inst.dsmod_cos.accu2_r[7]\ _06679_ VPWR VGND sg13g2_nand2_1
X_31171_ _07668_ _07110_ \memory_i.freq_inst.dsmod_cos.data_interp_r[7]\ VPWR VGND sg13g2_nand2_1
X_31172_ _07669_ _07667_ _07668_ _07088_ VPWR VGND sg13g2_a21o_1
X_31173_ _07670_ _07669_ VPWR VGND sg13g2_buf_1
X_31174_ _07671_ _07094_ _07111_ _07088_ VPWR VGND sg13g2_o21ai_1
X_31175_ _07672_ _07670_ _07671_ VPWR VGND sg13g2_nand2_1
X_31176_ _07673_ \memory_i.freq_inst.dsmod_cos.accu3_r[6]\ _07071_ VPWR VGND sg13g2_nor2_1
X_31177_ _07674_ _07660_ _07661_ _07673_ VPWR VGND sg13g2_a21oi_1
X_31178_ _07675_ \memory_i.freq_inst.dsmod_cos.accu3_r[6]\ _07071_ _07674_ VPWR VGND sg13g2_a21oi_1
X_31179_ _07676_ _07672_ _07675_ VPWR VGND sg13g2_xor2_1
X_31180_ _07677_ \memory_i.freq_inst.dsmod_cos.i_ena_mod\ _07676_ VPWR VGND sg13g2_nand2_1
X_31181_ _07678_ _07666_ _07677_ VPWR VGND sg13g2_xnor2_1
X_31182_ _01727_ _07613_ _07678_ VPWR VGND sg13g2_nor2_1
X_31183_ _07679_ \memory_i.freq_inst.dsmod_cos.accu3_r[8]\ VPWR VGND sg13g2_inv_1
X_31184_ _07680_ _07660_ _07661_ _07672_ _07666_ _07673_
+ VPWR
+ VGND sg13g2_a221oi_1
X_31185_ _07681_ _07680_ VPWR VGND sg13g2_buf_1
X_31186_ _07682_ \memory_i.freq_inst.dsmod_cos.accu3_r[7]\ _07670_ _07671_ VPWR VGND sg13g2_nand3_1
X_31187_ _07683_ \memory_i.freq_inst.dsmod_cos.accu3_r[7]\ \memory_i.freq_inst.dsmod_cos.accu3_r[6]\ _07071_ VPWR VGND sg13g2_nand3_1
X_31188_ _07684_ \memory_i.freq_inst.dsmod_cos.accu3_r[6]\ _07071_ _07670_ _07671_ VPWR
+ VGND
+ sg13g2_nand4_1
X_31189_ _07685_ _07682_ _07683_ _07684_ VPWR VGND sg13g2_nand3_1
X_31190_ _07686_ _07685_ VPWR VGND sg13g2_buf_1
X_31191_ _07687_ _07097_ _07681_ _07686_ VPWR VGND sg13g2_nor3_1
X_31192_ _07688_ _07681_ _07686_ _07097_ VPWR VGND sg13g2_o21ai_1
X_31193_ _07689_ _07687_ _07688_ \memory_i.freq_inst.dsmod_cos.i_ena_mod\ VPWR VGND sg13g2_nand3b_1
X_31194_ _07690_ _07679_ _07689_ VPWR VGND sg13g2_xnor2_1
X_31195_ _01728_ _07613_ _07690_ VPWR VGND sg13g2_nor2_1
X_31196_ _07691_ _07679_ _07688_ _07687_ VPWR VGND sg13g2_a21oi_1
X_31197_ _07692_ _07118_ _07691_ VPWR VGND sg13g2_xnor2_1
X_31198_ _07693_ _07183_ _07692_ VPWR VGND sg13g2_nor2_1
X_31199_ _07694_ \memory_i.freq_inst.dsmod_cos.accu3_r[9]\ _07693_ VPWR VGND sg13g2_xnor2_1
X_31200_ _01729_ _07613_ _07694_ VPWR VGND sg13g2_nor2_1
X_31201_ _07695_ \memory_i.freq_inst.dsmod_cos.accu3_r[10]\ VPWR VGND sg13g2_inv_1
X_31202_ _07696_ \memory_i.freq_inst.dsmod_cos.accu3_r[9]\ _07691_ _07118_ VPWR VGND sg13g2_o21ai_1
X_31203_ _07697_ _07696_ VPWR VGND sg13g2_inv_1
X_31204_ _07698_ \memory_i.freq_inst.dsmod_cos.accu3_r[9]\ _07691_ _07697_ VPWR VGND sg13g2_a21oi_1
X_31205_ _07699_ _07125_ _07698_ VPWR VGND sg13g2_xnor2_1
X_31206_ _07700_ \memory_i.freq_inst.dsmod_cos.i_ena_mod\ _07699_ VPWR VGND sg13g2_nand2_1
X_31207_ _07701_ _07695_ _07700_ VPWR VGND sg13g2_xnor2_1
X_31208_ _01730_ _07613_ _07701_ VPWR VGND sg13g2_nor2_1
X_31209_ _07702_ _06870_ VPWR VGND sg13g2_buf_1
X_31210_ _07703_ _07101_ VPWR VGND sg13g2_inv_1
X_31211_ _07704_ \memory_i.freq_inst.dsmod_cos.accu2_r[10]\ \memory_i.freq_inst.dsmod_cos.data_interp_r[10]\ VPWR VGND sg13g2_xnor2_1
X_31212_ _07705_ _07703_ _07704_ VPWR VGND sg13g2_nor2_1
X_31213_ _07706_ \memory_i.freq_inst.dsmod_cos.accu3_r[10]\ \memory_i.freq_inst.dsmod_cos.accu3_r[9]\ _07120_ VPWR VGND sg13g2_nand3_1
X_31214_ _07707_ _07144_ _07704_ VPWR VGND sg13g2_nor2_1
X_31215_ _07708_ _07120_ _07705_ _07706_ _07707_ VPWR
+ VGND
+ sg13g2_a22oi_1
X_31216_ _07709_ \memory_i.freq_inst.dsmod_cos.accu3_r[9]\ _07120_ \memory_i.freq_inst.dsmod_cos.accu3_r[10]\ VPWR VGND sg13g2_o21ai_1
X_31217_ _07710_ _07144_ _07704_ _07709_ VPWR VGND sg13g2_nand3_1
X_31218_ _07711_ \memory_i.freq_inst.dsmod_cos.accu2_r[9]\ \memory_i.freq_inst.dsmod_cos.data_interp_r[9]\ _07105_ VPWR VGND sg13g2_or3_1
X_31219_ _07712_ \memory_i.freq_inst.dsmod_cos.accu3_r[10]\ _07103_ _07148_ VPWR VGND sg13g2_o21ai_1
X_31220_ _07713_ _07095_ _07711_ _07712_ VPWR VGND sg13g2_o21ai_1
X_31221_ _07714_ _07695_ _07144_ _07124_ VPWR VGND sg13g2_nor3_1
X_31222_ _07715_ _07124_ _07713_ _07714_ VPWR VGND sg13g2_a21oi_1
X_31223_ _07716_ _07107_ _07114_ VPWR VGND sg13g2_or2_1
X_31224_ _07717_ _07695_ _07148_ VPWR VGND sg13g2_nor2_1
X_31225_ _07718_ \memory_i.freq_inst.dsmod_cos.accu2_r[9]\ \memory_i.freq_inst.dsmod_cos.data_interp_r[9]\ _07717_ VPWR VGND sg13g2_a21oi_1
X_31226_ _07719_ _07107_ _07115_ _07124_ _07718_ VPWR
+ VGND
+ sg13g2_nor4_1
X_31227_ _07720_ \memory_i.freq_inst.dsmod_cos.accu3_r[10]\ \memory_i.freq_inst.dsmod_cos.accu3_r[9]\ _07716_ _07705_ _07719_
+ VPWR
+ VGND sg13g2_a221oi_1
X_31228_ _07721_ _07720_ VPWR VGND sg13g2_buf_1
X_31229_ _07722_ _07715_ _07721_ VPWR VGND sg13g2_nand2_1
X_31230_ _07723_ _07703_ _07716_ VPWR VGND sg13g2_nand2_1
X_31231_ _07724_ _07148_ _07704_ _07695_ VPWR VGND sg13g2_a21oi_1
X_31232_ _07725_ \memory_i.freq_inst.dsmod_cos.accu3_r[9]\ _07723_ _07724_ VPWR VGND sg13g2_a21o_1
X_31233_ _07726_ _07708_ _07710_ _07722_ _07725_ VPWR
+ VGND
+ sg13g2_nand4_1
X_31234_ _07727_ _07092_ _07096_ VPWR VGND sg13g2_xnor2_1
X_31235_ _07728_ _07715_ _07721_ _07727_ VPWR VGND sg13g2_a21oi_1
X_31236_ _07729_ _07681_ _07686_ _07728_ VPWR VGND sg13g2_o21ai_1
X_31237_ _07730_ _07715_ _07721_ _07679_ VPWR VGND sg13g2_a21oi_1
X_31238_ _07731_ _07681_ _07686_ _07730_ VPWR VGND sg13g2_o21ai_1
X_31239_ _07732_ \memory_i.freq_inst.dsmod_cos.accu3_r[9]\ _07144_ _07124_ VPWR VGND sg13g2_and3_1
X_31240_ _07733_ _07107_ _07115_ _07732_ VPWR VGND sg13g2_o21ai_1
X_31241_ _07734_ \memory_i.freq_inst.dsmod_cos.accu2_r[9]\ \memory_i.freq_inst.dsmod_cos.data_interp_r[9]\ \memory_i.freq_inst.dsmod_cos.accu3_r[9]\ VPWR VGND sg13g2_o21ai_1
X_31242_ _07735_ _07106_ _07115_ _07124_ _07734_ VPWR
+ VGND
+ sg13g2_or4_1
X_31243_ _07736_ \memory_i.freq_inst.dsmod_cos.accu3_r[9]\ \memory_i.freq_inst.dsmod_cos.accu2_r[9]\ \memory_i.freq_inst.dsmod_cos.data_interp_r[9]\ _07704_ VPWR
+ VGND
+ sg13g2_nand4_1
X_31244_ _07737_ \memory_i.freq_inst.dsmod_cos.accu3_r[9]\ _07148_ _07124_ VPWR VGND sg13g2_nand3_1
X_31245_ _07738_ _07733_ _07735_ _07736_ _07737_ VPWR
+ VGND
+ sg13g2_and4_1
X_31246_ _07739_ _07738_ VPWR VGND sg13g2_buf_1
X_31247_ _07740_ _07116_ _07117_ _07695_ VPWR VGND sg13g2_a21o_1
X_31248_ _07741_ _07740_ VPWR VGND sg13g2_buf_1
X_31249_ _07742_ _07739_ _07741_ _07727_ VPWR VGND sg13g2_a21oi_1
X_31250_ _07743_ _07681_ _07686_ _07742_ VPWR VGND sg13g2_o21ai_1
X_31251_ _07744_ _07726_ _07729_ _07731_ _07743_ VPWR
+ VGND
+ sg13g2_and4_1
X_31252_ _07745_ _07744_ VPWR VGND sg13g2_buf_1
X_31253_ _07746_ _07739_ _07741_ _07679_ VPWR VGND sg13g2_a21oi_1
X_31254_ _07747_ _07681_ _07686_ _07746_ VPWR VGND sg13g2_o21ai_1
X_31255_ _07748_ _07739_ _07741_ VPWR VGND sg13g2_nand2_1
X_31256_ _07749_ _07679_ _07727_ VPWR VGND sg13g2_nor2_1
X_31257_ _07750_ _07722_ _07748_ _07749_ VPWR VGND sg13g2_o21ai_1
X_31258_ _07751_ _07747_ _07750_ VPWR VGND sg13g2_and2_1
X_31259_ _07752_ _07751_ VPWR VGND sg13g2_buf_1
X_31260_ _07753_ _07745_ _07752_ VPWR VGND sg13g2_and2_1
X_31261_ _07754_ _07753_ VPWR VGND sg13g2_buf_1
X_31262_ _07755_ _07152_ _07754_ VPWR VGND sg13g2_nor2_1
X_31263_ _07756_ _07152_ _07754_ VPWR VGND sg13g2_nand2_1
X_31264_ _07757_ _07755_ _07756_ \memory_i.freq_inst.dsmod_cos.i_ena_mod\ VPWR VGND sg13g2_nand3b_1
X_31265_ _07758_ \memory_i.freq_inst.dsmod_cos.accu3_r[11]\ _07757_ VPWR VGND sg13g2_xor2_1
X_31266_ _01731_ _07702_ _07758_ VPWR VGND sg13g2_nor2_1
X_31267_ _07759_ \memory_i.freq_inst.dsmod_cos.accu3_r[11]\ _07755_ _07756_ VPWR VGND sg13g2_o21ai_1
X_31268_ _07760_ _07759_ VPWR VGND sg13g2_buf_1
X_31269_ _07761_ _07306_ _07188_ VPWR VGND sg13g2_xnor2_1
X_31270_ _07762_ _07760_ _07761_ VPWR VGND sg13g2_xnor2_1
X_31271_ _07763_ \memory_i.freq_inst.dsmod_cos.i_ena_mod\ _07762_ VPWR VGND sg13g2_nand2_1
X_31272_ _07764_ \memory_i.freq_inst.dsmod_cos.accu3_r[12]\ _07763_ VPWR VGND sg13g2_xor2_1
X_31273_ _01732_ _07702_ _07764_ VPWR VGND sg13g2_nor2_1
X_31274_ _07765_ _07227_ VPWR VGND sg13g2_inv_1
X_31275_ _07766_ _07275_ _07760_ VPWR VGND sg13g2_nor2_1
X_31276_ _07767_ \memory_i.freq_inst.dsmod_cos.data_interp_r[12]\ _07766_ VPWR VGND sg13g2_nor2_1
X_31277_ _07768_ _07275_ _07760_ _07767_ VPWR VGND sg13g2_a21oi_1
X_31278_ _07769_ \memory_i.freq_inst.dsmod_cos.data_interp_r[12]\ _07766_ _07768_ \memory_i.freq_inst.dsmod_cos.accu2_r[12]\ VPWR
+ VGND
+ sg13g2_a22oi_1
X_31279_ _07770_ _07769_ \memory_i.freq_inst.dsmod_cos.accu3_r[12]\ VPWR VGND sg13g2_nor2b_1
X_31280_ _07771_ _07275_ _07184_ _07760_ VPWR VGND sg13g2_nor3_1
X_31281_ _07772_ _06719_ _07275_ _07760_ VPWR VGND sg13g2_nand3_1
X_31282_ _07773_ \memory_i.freq_inst.dsmod_cos.accu3_r[12]\ \memory_i.freq_inst.dsmod_cos.accu2_r[12]\ _07772_ VPWR VGND sg13g2_a21oi_1
X_31283_ _07774_ \memory_i.freq_inst.dsmod_cos.accu3_r[12]\ \memory_i.freq_inst.dsmod_cos.accu2_r[12]\ VPWR VGND sg13g2_nor2_1
X_31284_ _07775_ _07768_ _07774_ VPWR VGND sg13g2_nor2b_1
X_31285_ _07776_ _07770_ _07771_ _07773_ _07775_ VPWR
+ VGND
+ sg13g2_nor4_1
X_31286_ _07777_ _07765_ _07776_ VPWR VGND sg13g2_xnor2_1
X_31287_ _07778_ _07183_ _07777_ VPWR VGND sg13g2_nor2_1
X_31288_ _07779_ \memory_i.freq_inst.dsmod_cos.accu3_r[13]\ _07778_ VPWR VGND sg13g2_xnor2_1
X_31289_ _01733_ _07702_ _07779_ VPWR VGND sg13g2_nor2_1
X_31290_ _07780_ \memory_i.freq_inst.dsmod_cos.accu3_r[14]\ VPWR VGND sg13g2_inv_1
X_31291_ _07781_ _07197_ _07200_ VPWR VGND sg13g2_xor2_1
X_31292_ _07782_ _07781_ VPWR VGND sg13g2_buf_2
X_31293_ _07783_ \memory_i.freq_inst.dsmod_cos.accu3_r[12]\ _07306_ \memory_i.freq_inst.dsmod_cos.accu3_r[13]\ VPWR VGND sg13g2_o21ai_1
X_31294_ _07784_ \memory_i.freq_inst.dsmod_cos.accu3_r[12]\ _07306_ VPWR VGND sg13g2_nand2_1
X_31295_ _07785_ \memory_i.freq_inst.dsmod_cos.accu2_r[12]\ \memory_i.freq_inst.dsmod_cos.data_interp_r[12]\ VPWR VGND sg13g2_nor2_1
X_31296_ _07786_ _07184_ _07783_ _07784_ _07785_ _07765_
+ VPWR
+ VGND sg13g2_a221oi_1
X_31297_ _07787_ \memory_i.freq_inst.dsmod_cos.accu3_r[13]\ \memory_i.freq_inst.dsmod_cos.accu3_r[12]\ _07306_ _07188_ VPWR
+ VGND
+ sg13g2_nand4_1
X_31298_ _07788_ _07192_ _07787_ _07227_ VPWR VGND sg13g2_a21oi_1
X_31299_ _07789_ _07306_ _07185_ \memory_i.freq_inst.dsmod_cos.accu3_r[12]\ VPWR VGND sg13g2_o21ai_1
X_31300_ _07790_ \memory_i.freq_inst.dsmod_cos.accu3_r[13]\ _07789_ VPWR VGND sg13g2_nand2b_1
X_31301_ _07791_ _07786_ _07788_ _07790_ VPWR VGND sg13g2_o21ai_1
X_31302_ _07792_ \memory_i.freq_inst.dsmod_cos.accu3_r[11]\ _07142_ _07151_ VPWR VGND sg13g2_nand3_1
X_31303_ _07793_ _07791_ _07792_ VPWR VGND sg13g2_and2_1
X_31304_ _07794_ _07793_ VPWR VGND sg13g2_buf_1
X_31305_ _07795_ \memory_i.freq_inst.dsmod_cos.accu3_r[12]\ \memory_i.freq_inst.dsmod_cos.accu2_r[12]\ VPWR VGND sg13g2_xor2_1
X_31306_ _07796_ \memory_i.freq_inst.dsmod_cos.accu3_r[13]\ _07227_ VPWR VGND sg13g2_xnor2_1
X_31307_ _07797_ _07171_ _07178_ _07796_ VPWR VGND sg13g2_mux2_1
X_31308_ _07798_ \memory_i.freq_inst.dsmod_cos.accu3_r[12]\ \memory_i.freq_inst.dsmod_cos.accu2_r[12]\ VPWR VGND sg13g2_nand2_1
X_31309_ _07799_ _07774_ _07796_ VPWR VGND sg13g2_nand2_1
X_31310_ _07800_ _07796_ _07798_ _07799_ VPWR VGND sg13g2_o21ai_1
X_31311_ _07801_ _07795_ _07797_ _07800_ _07179_ VPWR
+ VGND
+ sg13g2_a22oi_1
X_31312_ _07802_ _07142_ _07151_ \memory_i.freq_inst.dsmod_cos.accu3_r[11]\ VPWR VGND sg13g2_a21oi_1
X_31313_ _07803_ _07801_ _07802_ VPWR VGND sg13g2_or2_1
X_31314_ _07804_ _07791_ _07803_ VPWR VGND sg13g2_and2_1
X_31315_ _07805_ _07754_ _07794_ _07804_ VPWR VGND sg13g2_a21o_1
X_31316_ _07806_ _07782_ _07805_ VPWR VGND sg13g2_nor2_1
X_31317_ _07807_ _07782_ _07805_ VPWR VGND sg13g2_nand2_1
X_31318_ _07808_ _07806_ _07807_ \memory_i.freq_inst.dsmod_cos.i_ena_mod\ VPWR VGND sg13g2_nand3b_1
X_31319_ _07809_ _07780_ _07808_ VPWR VGND sg13g2_xnor2_1
X_31320_ _01734_ _07702_ _07809_ VPWR VGND sg13g2_nor2_1
X_31321_ _07810_ \memory_i.freq_inst.dsmod_cos.accu3_r[14]\ _07807_ _07806_ VPWR VGND sg13g2_a21o_1
X_31322_ _07811_ _07810_ VPWR VGND sg13g2_buf_1
X_31323_ _07812_ _07209_ _07811_ VPWR VGND sg13g2_xnor2_1
X_31324_ _07813_ _07183_ _07812_ VPWR VGND sg13g2_nor2_1
X_31325_ _07814_ \memory_i.freq_inst.dsmod_cos.accu3_r[15]\ _07813_ VPWR VGND sg13g2_xnor2_1
X_31326_ _01735_ _07702_ _07814_ VPWR VGND sg13g2_nor2_1
X_31327_ _07815_ \memory_i.freq_inst.dsmod_cos.accu3_r[16]\ VPWR VGND sg13g2_inv_1
X_31328_ _07816_ \memory_i.freq_inst.dsmod_cos.accu3_r[15]\ _07811_ _07209_ VPWR VGND sg13g2_a21o_1
X_31329_ _07817_ \memory_i.freq_inst.dsmod_cos.accu3_r[15]\ _07811_ _07816_ VPWR VGND sg13g2_o21ai_1
X_31330_ _07818_ _07234_ _07817_ VPWR VGND sg13g2_xnor2_1
X_31331_ _07819_ \memory_i.freq_inst.dsmod_cos.i_ena_mod\ _07818_ VPWR VGND sg13g2_nand2_1
X_31332_ _07820_ _07815_ _07819_ VPWR VGND sg13g2_xnor2_1
X_31333_ _01736_ _07702_ _07820_ VPWR VGND sg13g2_nor2_1
X_31334_ _07821_ _05649_ VPWR VGND sg13g2_buf_1
X_31335_ _07822_ _07204_ \memory_i.freq_inst.dsmod_cos.accu3_r[15]\ VPWR VGND sg13g2_nor2b_1
X_31336_ _07823_ _07205_ _07207_ _07822_ VPWR VGND sg13g2_o21ai_1
X_31337_ _07824_ \memory_i.freq_inst.dsmod_cos.accu3_r[15]\ _07204_ VPWR VGND sg13g2_nand2_1
X_31338_ _07825_ _07205_ _07207_ _07824_ VPWR VGND sg13g2_or3_1
X_31339_ _07826_ _07234_ _07823_ _07825_ VPWR VGND sg13g2_nand3b_1
X_31340_ _07827_ _07826_ VPWR VGND sg13g2_buf_1
X_31341_ _07828_ _07827_ _07803_ _07791_ VPWR VGND sg13g2_nand3b_1
X_31342_ _07829_ \memory_i.freq_inst.dsmod_cos.accu3_r[14]\ _07201_ _07828_ VPWR VGND sg13g2_a21oi_1
X_31343_ _07830_ _07780_ _07782_ VPWR VGND sg13g2_nand2_1
X_31344_ _07831_ _07827_ _07830_ VPWR VGND sg13g2_nor2_1
X_31345_ _07832_ \memory_i.freq_inst.dsmod_cos.accu3_r[14]\ _07201_ _07827_ VPWR VGND sg13g2_a21oi_1
X_31346_ _07833_ _07745_ _07752_ _07794_ _07832_ VPWR
+ VGND
+ sg13g2_and4_1
X_31347_ _07834_ \memory_i.freq_inst.dsmod_cos.accu3_r[15]\ _07209_ _07234_ VPWR VGND sg13g2_or3_1
X_31348_ _07835_ _07823_ _07825_ VPWR VGND sg13g2_nand2_1
X_31349_ _07836_ _07780_ _07782_ _07204_ _07208_ VPWR
+ VGND
+ sg13g2_nor4_1
X_31350_ _07837_ \memory_i.freq_inst.dsmod_cos.accu3_r[14]\ _07201_ _07204_ _07208_ VPWR
+ VGND
+ sg13g2_and4_1
X_31351_ _07838_ \memory_i.freq_inst.dsmod_cos.accu3_r[15]\ \memory_i.freq_inst.dsmod_cos.accu3_r[14]\ VPWR VGND sg13g2_nand2_1
X_31352_ _07839_ _07782_ _07838_ _07815_ VPWR VGND sg13g2_o21ai_1
X_31353_ _07840_ _07835_ _07836_ _07837_ _07839_ VPWR
+ VGND
+ sg13g2_nor4_1
X_31354_ _07841_ _07745_ _07752_ _07794_ _07840_ VPWR
+ VGND
+ sg13g2_nand4_1
X_31355_ _07842_ \memory_i.freq_inst.dsmod_cos.accu3_r[15]\ _07780_ _07782_ VPWR VGND sg13g2_nand3b_1
X_31356_ _07843_ _07209_ _07234_ _07842_ VPWR VGND sg13g2_nand3_1
X_31357_ _07844_ \memory_i.freq_inst.dsmod_cos.accu3_r[15]\ _07234_ VPWR VGND sg13g2_and2_1
X_31358_ _07845_ _07830_ _07844_ \memory_i.freq_inst.dsmod_cos.accu3_r[16]\ VPWR VGND sg13g2_a21oi_1
X_31359_ _07846_ _07804_ _07840_ _07843_ _07845_ VPWR
+ VGND
+ sg13g2_a22oi_1
X_31360_ _07847_ _07834_ _07841_ _07846_ VPWR VGND sg13g2_nand3_1
X_31361_ _07848_ _07829_ _07831_ _07833_ _07847_ VPWR
+ VGND
+ sg13g2_or4_1
X_31362_ _07849_ _07848_ VPWR VGND sg13g2_buf_1
X_31363_ _07850_ _07243_ _07849_ VPWR VGND sg13g2_xnor2_1
X_31364_ _07851_ _07821_ _07850_ VPWR VGND sg13g2_nor2_1
X_31365_ _07852_ \memory_i.freq_inst.dsmod_cos.accu3_r[17]\ _07851_ VPWR VGND sg13g2_xnor2_1
X_31366_ _01737_ _07702_ _07852_ VPWR VGND sg13g2_nor2_1
X_31367_ _07853_ _07849_ VPWR VGND sg13g2_inv_1
X_31368_ _07854_ \memory_i.freq_inst.dsmod_cos.accu3_r[17]\ VPWR VGND sg13g2_inv_1
X_31369_ _07855_ _07854_ _07849_ _07243_ VPWR VGND sg13g2_o21ai_1
X_31370_ _07856_ \memory_i.freq_inst.dsmod_cos.accu3_r[17]\ _07853_ _07855_ VPWR VGND sg13g2_o21ai_1
X_31371_ _07857_ _07260_ _07856_ VPWR VGND sg13g2_xnor2_1
X_31372_ _07858_ \memory_i.freq_inst.dsmod_cos.i_ena_mod\ _07857_ VPWR VGND sg13g2_nand2_1
X_31373_ _07859_ \memory_i.freq_inst.dsmod_cos.accu3_r[18]\ _07858_ VPWR VGND sg13g2_xor2_1
X_31374_ _01738_ _07702_ _07859_ VPWR VGND sg13g2_nor2_1
X_31375_ _07860_ \memory_i.freq_inst.dsmod_cos.accu3_r[19]\ VPWR VGND sg13g2_inv_1
X_31376_ _07861_ _07854_ _07243_ _07252_ _07259_ VPWR
+ VGND
+ sg13g2_a22oi_1
X_31377_ _07862_ _07854_ _07243_ _07252_ _07259_ VPWR
+ VGND
+ sg13g2_nand4_1
X_31378_ _07863_ \memory_i.freq_inst.dsmod_cos.accu3_r[18]\ _07861_ _07862_ VPWR VGND sg13g2_o21ai_1
X_31379_ _07864_ _07829_ _07831_ _07833_ _07863_ VPWR
+ VGND
+ sg13g2_or4_1
X_31380_ _07865_ _07854_ _07243_ VPWR VGND sg13g2_nor2_1
X_31381_ _07866_ _07260_ _07865_ \memory_i.freq_inst.dsmod_cos.accu3_r[18]\ VPWR VGND sg13g2_a21o_1
X_31382_ _07867_ _07260_ _07865_ _07866_ VPWR VGND sg13g2_o21ai_1
X_31383_ _07868_ _07847_ _07864_ _07867_ VPWR VGND sg13g2_o21ai_1
X_31384_ _07869_ _07271_ _07868_ VPWR VGND sg13g2_xnor2_1
X_31385_ _07870_ \memory_i.freq_inst.dsmod_cos.i_ena_mod\ _07869_ VPWR VGND sg13g2_nand2_1
X_31386_ _07871_ _07860_ _07870_ VPWR VGND sg13g2_xnor2_1
X_31387_ _01739_ _07702_ _07871_ VPWR VGND sg13g2_nor2_1
X_31388_ _07872_ \memory_i.freq_inst.dsmod_cos.accu3_r[20]\ VPWR VGND sg13g2_inv_1
X_31389_ _07873_ _07847_ _07864_ VPWR VGND sg13g2_nor2_1
X_31390_ _07874_ _07873_ _07867_ VPWR VGND sg13g2_nor2b_1
X_31391_ _07875_ _07271_ _07874_ VPWR VGND sg13g2_nor2_1
X_31392_ _07876_ \memory_i.freq_inst.dsmod_cos.accu3_r[19]\ _07875_ VPWR VGND sg13g2_nor2_1
X_31393_ _07877_ _07271_ _07874_ _07876_ VPWR VGND sg13g2_a21oi_1
X_31394_ _07878_ \memory_i.freq_inst.dsmod_cos.accu2_r[20]\ \memory_i.freq_inst.dsmod_cos.data_interp_r[20]\ VPWR VGND sg13g2_xor2_1
X_31395_ _07879_ _07291_ _07878_ VPWR VGND sg13g2_xnor2_1
X_31396_ _07880_ _07877_ _07879_ VPWR VGND sg13g2_xnor2_1
X_31397_ _07881_ \memory_i.freq_inst.dsmod_cos.i_ena_mod\ _07880_ VPWR VGND sg13g2_nand2_1
X_31398_ _07882_ _07872_ _07881_ VPWR VGND sg13g2_xnor2_1
X_31399_ _01740_ _07702_ _07882_ VPWR VGND sg13g2_nor2_1
X_31400_ _07883_ _06870_ VPWR VGND sg13g2_buf_1
X_31401_ _07884_ \memory_i.freq_inst.dsmod_cos.accu2_r[21]\ \memory_i.freq_inst.dsmod_cos.data_interp_r[21]\ VPWR VGND sg13g2_xor2_1
X_31402_ _07885_ _07884_ VPWR VGND sg13g2_buf_1
X_31403_ _07886_ _07291_ _07877_ VPWR VGND sg13g2_and2_1
X_31404_ _07887_ _07886_ VPWR VGND sg13g2_buf_1
X_31405_ _07888_ _07291_ _07877_ \memory_i.freq_inst.dsmod_cos.data_interp_r[20]\ VPWR VGND sg13g2_o21ai_1
X_31406_ _07889_ _07887_ _07888_ VPWR VGND sg13g2_nand2b_1
X_31407_ _07890_ \memory_i.freq_inst.dsmod_cos.data_interp_r[20]\ _07887_ _07889_ \memory_i.freq_inst.dsmod_cos.accu2_r[20]\ VPWR
+ VGND
+ sg13g2_a22oi_1
X_31408_ _07891_ \memory_i.freq_inst.dsmod_cos.data_interp_r[20]\ _07291_ _07877_ VPWR VGND sg13g2_or3_1
X_31409_ _07892_ \memory_i.freq_inst.dsmod_cos.accu2_r[20]\ _07889_ _07891_ VPWR VGND sg13g2_o21ai_1
X_31410_ _07893_ \memory_i.freq_inst.dsmod_cos.accu2_r[20]\ \memory_i.freq_inst.dsmod_cos.data_interp_r[20]\ _07887_ VPWR VGND sg13g2_nand3_1
X_31411_ _07894_ \memory_i.freq_inst.dsmod_cos.accu2_r[20]\ _07891_ _07893_ VPWR VGND sg13g2_o21ai_1
X_31412_ _07895_ _07872_ _07892_ _07894_ VPWR VGND sg13g2_a21oi_1
X_31413_ _07896_ _07872_ _07890_ _07895_ VPWR VGND sg13g2_o21ai_1
X_31414_ _07897_ _07885_ _07896_ VPWR VGND sg13g2_xnor2_1
X_31415_ _07898_ \memory_i.freq_inst.dsmod_cos.i_ena_mod\ _07897_ VPWR VGND sg13g2_nand2_1
X_31416_ _07899_ \memory_i.freq_inst.dsmod_cos.accu3_r[21]\ _07898_ VPWR VGND sg13g2_xor2_1
X_31417_ _01741_ _07883_ _07899_ VPWR VGND sg13g2_nor2_1
X_31418_ _07900_ \memory_i.freq_inst.dsmod_cos.accu3_r[22]\ VPWR VGND sg13g2_inv_1
X_31419_ _07901_ _07302_ \memory_i.freq_inst.dsmod_cos.data_interp_r[22]\ VPWR VGND sg13g2_nor2_1
X_31420_ _07902_ _07304_ _07317_ _07901_ VPWR VGND sg13g2_o21ai_1
X_31421_ _07903_ \memory_i.freq_inst.dsmod_cos.accu2_r[22]\ _06831_ VPWR VGND sg13g2_nor2_1
X_31422_ _07904_ _07304_ _07317_ _07903_ VPWR VGND sg13g2_o21ai_1
X_31423_ _07905_ _07304_ _07317_ _07324_ VPWR VGND sg13g2_or3_1
X_31424_ _07906_ _07304_ _07317_ _07322_ VPWR VGND sg13g2_or3_1
X_31425_ _07907_ _07902_ _07904_ _07905_ _07906_ VPWR
+ VGND
+ sg13g2_nand4_1
X_31426_ _07908_ _07907_ VPWR VGND sg13g2_buf_1
X_31427_ _07909_ \memory_i.freq_inst.dsmod_cos.accu3_r[21]\ \memory_i.freq_inst.dsmod_cos.accu3_r[20]\ _07291_ VPWR VGND sg13g2_and3_1
X_31428_ _07910_ \memory_i.freq_inst.dsmod_cos.accu2_r[20]\ \memory_i.freq_inst.dsmod_cos.data_interp_r[20]\ _07885_ VPWR VGND sg13g2_nand3_1
X_31429_ _07911_ _07291_ _07878_ _07885_ VPWR VGND sg13g2_nand3_1
X_31430_ _07912_ _07909_ _07910_ _07911_ VPWR VGND sg13g2_o21ai_1
X_31431_ _07913_ \memory_i.freq_inst.dsmod_cos.accu2_r[20]\ \memory_i.freq_inst.dsmod_cos.data_interp_r[20]\ _07885_ VPWR VGND sg13g2_a21o_1
X_31432_ _07914_ \memory_i.freq_inst.dsmod_cos.accu3_r[20]\ _07913_ VPWR VGND sg13g2_nor2_1
X_31433_ _07915_ \memory_i.freq_inst.dsmod_cos.accu2_r[20]\ \memory_i.freq_inst.dsmod_cos.data_interp_r[20]\ _07885_ VPWR VGND sg13g2_nor3_1
X_31434_ _07916_ _07306_ _07280_ _07310_ _07277_ _07286_
+ VPWR
+ VGND sg13g2_a221oi_1
X_31435_ _07917_ _07914_ _07915_ _07916_ VPWR VGND sg13g2_o21ai_1
X_31436_ _07918_ \memory_i.freq_inst.dsmod_cos.accu3_r[21]\ _07878_ VPWR VGND sg13g2_nor2_1
X_31437_ _07919_ \memory_i.freq_inst.dsmod_cos.accu3_r[21]\ _07913_ VPWR VGND sg13g2_nor2_1
X_31438_ _07920_ _07872_ _07915_ _07919_ VPWR VGND sg13g2_a21oi_1
X_31439_ _07921_ \memory_i.freq_inst.dsmod_cos.accu3_r[21]\ \memory_i.freq_inst.dsmod_cos.accu3_r[20]\ _07920_ VPWR VGND sg13g2_o21ai_1
X_31440_ _07922_ _07916_ _07918_ _07921_ VPWR VGND sg13g2_a21oi_1
X_31441_ _07923_ _07917_ _07922_ VPWR VGND sg13g2_nand2_1
X_31442_ _07924_ _07912_ _07923_ VPWR VGND sg13g2_or2_1
X_31443_ _07925_ \memory_i.freq_inst.dsmod_cos.accu3_r[21]\ _07885_ VPWR VGND sg13g2_xor2_1
X_31444_ _07926_ _07925_ \memory_i.freq_inst.dsmod_cos.accu2_r[20]\ \memory_i.freq_inst.dsmod_cos.accu3_r[20]\ VPWR VGND sg13g2_nand3b_1
X_31445_ _07927_ _07872_ _07274_ _07925_ VPWR VGND sg13g2_nand3_1
X_31446_ _07928_ _07926_ _07927_ _07293_ VPWR VGND sg13g2_a21oi_1
X_31447_ _07929_ \memory_i.freq_inst.dsmod_cos.accu3_r[20]\ \memory_i.freq_inst.dsmod_cos.accu2_r[20]\ VPWR VGND sg13g2_xor2_1
X_31448_ _07930_ _07293_ _07925_ VPWR VGND sg13g2_nand2_1
X_31449_ _07931_ _07294_ _07925_ _07930_ VPWR VGND sg13g2_o21ai_1
X_31450_ _07932_ _07294_ _07928_ _07929_ _07931_ VPWR
+ VGND
+ sg13g2_a22oi_1
X_31451_ _07933_ _07932_ _07877_ VPWR VGND sg13g2_nand2b_1
X_31452_ _07934_ _07924_ _07933_ VPWR VGND sg13g2_nand2_1
X_31453_ _07935_ _07908_ _07934_ VPWR VGND sg13g2_xnor2_1
X_31454_ _07936_ _07935_ \memory_i.freq_inst.dsmod_cos.i_ena_mod\ VPWR VGND sg13g2_nand2b_1
X_31455_ _07937_ _07900_ _07936_ VPWR VGND sg13g2_xnor2_1
X_31456_ _01742_ _07883_ _07937_ VPWR VGND sg13g2_nor2_1
X_31457_ _07938_ \memory_i.freq_inst.dsmod_cos.accu3_r[23]\ VPWR VGND sg13g2_inv_1
X_31458_ _07939_ _07908_ _07934_ \memory_i.freq_inst.dsmod_cos.accu3_r[22]\ VPWR VGND sg13g2_a21o_1
X_31459_ _07940_ _07908_ _07934_ _07939_ VPWR VGND sg13g2_o21ai_1
X_31460_ _07941_ _07327_ _07940_ VPWR VGND sg13g2_xnor2_1
X_31461_ _07942_ \memory_i.freq_inst.dsmod_cos.i_ena_mod\ _07941_ VPWR VGND sg13g2_nand2_1
X_31462_ _07943_ _07938_ _07942_ VPWR VGND sg13g2_xnor2_1
X_31463_ _01743_ _07883_ _07943_ VPWR VGND sg13g2_nor2_1
X_31464_ _07944_ \memory_i.freq_inst.dsmod_cos.accu3_r[24]\ VPWR VGND sg13g2_inv_1
X_31465_ _07945_ _07912_ _07923_ VPWR VGND sg13g2_nor2_1
X_31466_ _07946_ _07908_ _07945_ \memory_i.freq_inst.dsmod_cos.accu3_r[22]\ VPWR VGND sg13g2_a21o_1
X_31467_ _07947_ _07908_ _07924_ VPWR VGND sg13g2_nand2b_1
X_31468_ _07948_ _07327_ _07946_ _07947_ VPWR VGND sg13g2_nand3_1
X_31469_ _07949_ _07938_ _07948_ VPWR VGND sg13g2_nand2_1
X_31470_ _07950_ _07946_ _07947_ _07327_ VPWR VGND sg13g2_a21o_1
X_31471_ _07951_ _07938_ _07326_ VPWR VGND sg13g2_xnor2_1
X_31472_ _07952_ \memory_i.freq_inst.dsmod_cos.data_interp_r[22]\ _07951_ VPWR VGND sg13g2_nor2_1
X_31473_ _07953_ \memory_i.freq_inst.dsmod_cos.data_interp_r[22]\ _07951_ VPWR VGND sg13g2_and2_1
X_31474_ _07954_ _07952_ _07953_ _07318_ VPWR VGND sg13g2_mux2_1
X_31475_ _07955_ \memory_i.freq_inst.dsmod_cos.accu2_r[22]\ _07951_ VPWR VGND sg13g2_nor2_1
X_31476_ _07956_ \memory_i.freq_inst.dsmod_cos.accu2_r[22]\ _07954_ _07955_ _07319_ VPWR
+ VGND
+ sg13g2_a22oi_1
X_31477_ _07957_ \memory_i.freq_inst.dsmod_cos.accu3_r[22]\ _07932_ _07956_ VPWR VGND sg13g2_or3_1
X_31478_ _07958_ \memory_i.freq_inst.dsmod_cos.accu2_r[22]\ _07954_ VPWR VGND sg13g2_nor2_1
X_31479_ _07959_ _07319_ _07951_ _07302_ VPWR VGND sg13g2_a21oi_1
X_31480_ _07960_ _07900_ _07932_ _07958_ _07959_ VPWR
+ VGND
+ sg13g2_or4_1
X_31481_ _07961_ _07268_ _07269_ _07957_ _07960_ _07860_
+ VPWR
+ VGND sg13g2_a221oi_1
X_31482_ _07962_ _07949_ _07950_ _07961_ VPWR VGND sg13g2_a21oi_1
X_31483_ _07963_ _07860_ _07271_ _07957_ _07960_ VPWR
+ VGND
+ sg13g2_a22oi_1
X_31484_ _07964_ _07868_ _07963_ VPWR VGND sg13g2_nand2_1
X_31485_ _07965_ _07962_ _07964_ VPWR VGND sg13g2_nand2_1
X_31486_ _07966_ _07341_ _07965_ VPWR VGND sg13g2_nor2_1
X_31487_ _07967_ _07341_ _07965_ VPWR VGND sg13g2_nand2_1
X_31488_ _07968_ _07966_ _07967_ \memory_i.freq_inst.dsmod_cos.i_ena_mod\ VPWR VGND sg13g2_nand3b_1
X_31489_ _07969_ _07944_ _07968_ VPWR VGND sg13g2_xnor2_1
X_31490_ _01744_ _07883_ _07969_ VPWR VGND sg13g2_nor2_1
X_31491_ _07970_ \memory_i.freq_inst.dsmod_cos.accu3_r[25]\ VPWR VGND sg13g2_inv_1
X_31492_ _07971_ _07944_ _07967_ _07966_ VPWR VGND sg13g2_a21oi_1
X_31493_ _07972_ _07372_ _07971_ VPWR VGND sg13g2_and2_1
X_31494_ _07973_ _07372_ _07971_ VPWR VGND sg13g2_or2_1
X_31495_ _07974_ _07972_ _07973_ \memory_i.freq_inst.dsmod_cos.i_ena_mod\ VPWR VGND sg13g2_nand3b_1
X_31496_ _07975_ _07970_ _07974_ VPWR VGND sg13g2_xnor2_1
X_31497_ _01745_ _07883_ _07975_ VPWR VGND sg13g2_nor2_1
X_31498_ _07976_ \memory_i.freq_inst.dsmod_cos.accu3_r[25]\ _07973_ _07972_ VPWR VGND sg13g2_a21oi_1
X_31499_ _07977_ _07383_ _07976_ VPWR VGND sg13g2_xnor2_1
X_31500_ _07978_ _07821_ _07977_ VPWR VGND sg13g2_nor2_1
X_31501_ _07979_ \memory_i.freq_inst.dsmod_cos.accu3_r[26]\ _07978_ VPWR VGND sg13g2_xnor2_1
X_31502_ _01746_ _07883_ _07979_ VPWR VGND sg13g2_nor2_1
X_31503_ _07980_ _07976_ VPWR VGND sg13g2_inv_1
X_31504_ _07981_ \memory_i.freq_inst.dsmod_cos.accu3_r[26]\ VPWR VGND sg13g2_inv_1
X_31505_ _07982_ _07981_ _07976_ _07383_ VPWR VGND sg13g2_o21ai_1
X_31506_ _07983_ \memory_i.freq_inst.dsmod_cos.accu3_r[26]\ _07980_ _07982_ VPWR VGND sg13g2_o21ai_1
X_31507_ _07984_ _07397_ _07983_ VPWR VGND sg13g2_xnor2_1
X_31508_ _07985_ \memory_i.freq_inst.dsmod_cos.i_ena_mod\ _07984_ VPWR VGND sg13g2_nand2_1
X_31509_ _07986_ \memory_i.freq_inst.dsmod_cos.accu3_r[27]\ _07985_ VPWR VGND sg13g2_xor2_1
X_31510_ _01747_ _07883_ _07986_ VPWR VGND sg13g2_nor2_1
X_31511_ _07987_ \memory_i.freq_inst.dsmod_cos.accu3_r[28]\ VPWR VGND sg13g2_inv_1
X_31512_ _07988_ \memory_i.freq_inst.dsmod_cos.accu3_r[27]\ _07397_ VPWR VGND sg13g2_or2_1
X_31513_ _07989_ _07949_ _07950_ _07963_ _07868_ _07961_
+ VPWR
+ VGND sg13g2_a221oi_1
X_31514_ _07990_ _07380_ _07381_ _07981_ VPWR VGND sg13g2_o21ai_1
X_31515_ _07991_ _07970_ _07372_ VPWR VGND sg13g2_xnor2_1
X_31516_ _07992_ _07944_ _07341_ VPWR VGND sg13g2_xnor2_1
X_31517_ _07993_ _07990_ _07991_ _07992_ VPWR VGND sg13g2_nand3_1
X_31518_ _07994_ \memory_i.freq_inst.dsmod_cos.accu3_r[24]\ _07341_ _07369_ _07370_ VPWR
+ VGND
+ sg13g2_a22oi_1
X_31519_ _07995_ \memory_i.freq_inst.dsmod_cos.accu3_r[24]\ _07341_ _07369_ _07370_ VPWR
+ VGND
+ sg13g2_nand4_1
X_31520_ _07996_ _07970_ _07994_ _07995_ VPWR VGND sg13g2_o21ai_1
X_31521_ _07997_ _07981_ _07380_ _07381_ VPWR VGND sg13g2_nor3_1
X_31522_ _07998_ \memory_i.freq_inst.dsmod_cos.accu3_r[27]\ _07397_ _07990_ _07996_ _07997_
+ VPWR
+ VGND sg13g2_a221oi_1
X_31523_ _07999_ _07989_ _07993_ _07998_ VPWR VGND sg13g2_o21ai_1
X_31524_ _08000_ _07988_ _07999_ VPWR VGND sg13g2_and2_1
X_31525_ _08001_ _08000_ VPWR VGND sg13g2_buf_1
X_31526_ _08002_ _07414_ _08001_ VPWR VGND sg13g2_xor2_1
X_31527_ _08003_ \memory_i.freq_inst.dsmod_cos.i_ena_mod\ _08002_ VPWR VGND sg13g2_nand2_1
X_31528_ _08004_ _07987_ _08003_ VPWR VGND sg13g2_xnor2_1
X_31529_ _01748_ _07883_ _08004_ VPWR VGND sg13g2_nor2_1
X_31530_ _08005_ _07414_ _08001_ \memory_i.freq_inst.dsmod_cos.accu3_r[28]\ VPWR VGND sg13g2_a21o_1
X_31531_ _08006_ _07414_ _08001_ _08005_ VPWR VGND sg13g2_o21ai_1
X_31532_ _08007_ _07436_ _08006_ VPWR VGND sg13g2_xnor2_1
X_31533_ _08008_ \memory_i.freq_inst.dsmod_cos.i_ena_mod\ _08007_ VPWR VGND sg13g2_nand2_1
X_31534_ _08009_ \memory_i.freq_inst.dsmod_cos.accu3_r[29]\ _08008_ VPWR VGND sg13g2_xor2_1
X_31535_ _01749_ _07883_ _08009_ VPWR VGND sg13g2_nor2_1
X_31536_ _08010_ \memory_i.freq_inst.dsmod_cos.accu3_r[30]\ VPWR VGND sg13g2_inv_1
X_31537_ _08011_ \memory_i.freq_inst.dsmod_cos.accu3_r[29]\ _07436_ _07414_ VPWR VGND sg13g2_a21o_1
X_31538_ _08012_ \memory_i.freq_inst.dsmod_cos.accu3_r[29]\ _07436_ \memory_i.freq_inst.dsmod_cos.accu3_r[28]\ VPWR VGND sg13g2_a21o_1
X_31539_ _08013_ _07988_ _07999_ _08011_ _08012_ VPWR
+ VGND
+ sg13g2_a22oi_1
X_31540_ _08014_ \memory_i.freq_inst.dsmod_cos.accu3_r[29]\ _07436_ _07414_ VPWR VGND sg13g2_a21oi_1
X_31541_ _08015_ \memory_i.freq_inst.dsmod_cos.accu3_r[29]\ _07436_ VPWR VGND sg13g2_nor2_1
X_31542_ _08016_ _07987_ _08014_ _08015_ VPWR VGND sg13g2_a21oi_1
X_31543_ _08017_ _08013_ _08016_ VPWR VGND sg13g2_nand2b_1
X_31544_ _08018_ _07442_ _08017_ VPWR VGND sg13g2_xnor2_1
X_31545_ _08019_ \memory_i.freq_inst.dsmod_cos.i_ena_mod\ _08018_ VPWR VGND sg13g2_nand2_1
X_31546_ _08020_ _08010_ _08019_ VPWR VGND sg13g2_xnor2_1
X_31547_ _01750_ _07883_ _08020_ VPWR VGND sg13g2_nor2_1
X_31548_ _08021_ _12944_ VPWR VGND sg13g2_buf_1
X_31549_ _08022_ _08021_ VPWR VGND sg13g2_buf_1
X_31550_ _08023_ \memory_i.freq_inst.dsmod_cos.accu2_r[31]\ _07456_ VPWR VGND sg13g2_xor2_1
X_31551_ _08024_ _07438_ _07441_ VPWR VGND sg13g2_xor2_1
X_31552_ _08025_ _08024_ _08017_ _08010_ VPWR VGND sg13g2_a21o_1
X_31553_ _08026_ _08024_ _08017_ _08025_ VPWR VGND sg13g2_o21ai_1
X_31554_ _08027_ _08023_ _08026_ VPWR VGND sg13g2_xor2_1
X_31555_ _08028_ \memory_i.freq_inst.dsmod_cos.i_ena_mod\ _08027_ VPWR VGND sg13g2_nand2_1
X_31556_ _08029_ \memory_i.freq_inst.dsmod_cos.accu3_r[31]\ _08028_ VPWR VGND sg13g2_xor2_1
X_31557_ _01751_ _08022_ _08029_ VPWR VGND sg13g2_nor2_1
X_31558_ _08030_ _07464_ _07466_ VPWR VGND sg13g2_nand2_1
X_31559_ _08031_ \memory_i.freq_inst.dsmod_cos.accu3_r[31]\ \memory_i.freq_inst.dsmod_cos.accu2_r[31]\ VPWR VGND sg13g2_nor2b_1
X_31560_ _08032_ _07491_ _08031_ VPWR VGND sg13g2_nand2_1
X_31561_ _08033_ \memory_i.freq_inst.dsmod_cos.accu3_r[31]\ \memory_i.freq_inst.dsmod_cos.accu2_r[31]\ VPWR VGND sg13g2_nor2_1
X_31562_ _08034_ \memory_i.freq_inst.dsmod_cos.data_interp_r[31]\ _08033_ VPWR VGND sg13g2_nand2_1
X_31563_ _08035_ _08032_ _08034_ _07455_ VPWR VGND sg13g2_a21oi_1
X_31564_ _08036_ _07491_ _08033_ VPWR VGND sg13g2_nand2_1
X_31565_ _08037_ \memory_i.freq_inst.dsmod_cos.data_interp_r[31]\ _08031_ VPWR VGND sg13g2_nand2_1
X_31566_ _08038_ _08036_ _08037_ _07459_ VPWR VGND sg13g2_a21oi_2
X_31567_ _08039_ _08024_ _08035_ _08038_ VPWR VGND sg13g2_nor3_1
X_31568_ _08040_ _08013_ _08016_ _08039_ VPWR VGND sg13g2_nand3b_1
X_31569_ _08041_ _08010_ _08035_ _08038_ VPWR VGND sg13g2_nor3_1
X_31570_ _08042_ _08013_ _08016_ _08041_ VPWR VGND sg13g2_nand3b_1
X_31571_ _08043_ _08010_ _08024_ _08035_ _08038_ VPWR
+ VGND
+ sg13g2_nor4_1
X_31572_ _08044_ \memory_i.freq_inst.dsmod_cos.accu3_r[31]\ _08023_ _08043_ VPWR VGND sg13g2_a21oi_1
X_31573_ _08045_ _08040_ _08042_ _08044_ VPWR VGND sg13g2_nand3_1
X_31574_ _08046_ _08030_ _08045_ VPWR VGND sg13g2_xor2_1
X_31575_ _08047_ _07821_ _08046_ VPWR VGND sg13g2_nor2_1
X_31576_ _08048_ \memory_i.freq_inst.dsmod_cos.accu3_r[32]\ _08047_ VPWR VGND sg13g2_xnor2_1
X_31577_ _01752_ _08022_ _08048_ VPWR VGND sg13g2_nor2_1
X_31578_ _08049_ \memory_i.freq_inst.dsmod_cos.accu3_r[32]\ _08030_ VPWR VGND sg13g2_nand2b_1
X_31579_ _08050_ \memory_i.freq_inst.dsmod_cos.accu3_r[32]\ _07464_ _07466_ VPWR VGND sg13g2_nand3_1
X_31580_ _08051_ _08040_ _08042_ _08044_ _08050_ VPWR
+ VGND
+ sg13g2_nand4_1
X_31581_ _08052_ \memory_i.freq_inst.dsmod_cos.accu2_r[33]\ _07475_ VPWR VGND sg13g2_xnor2_1
X_31582_ _08053_ _08049_ _08051_ _08052_ VPWR VGND sg13g2_a21oi_1
X_31583_ _08054_ _08052_ _08049_ _08051_ VPWR VGND sg13g2_and3_1
X_31584_ _08055_ _05783_ _08053_ _08054_ VPWR VGND sg13g2_nor3_1
X_31585_ _08056_ \memory_i.freq_inst.dsmod_cos.accu3_r[33]\ _08055_ VPWR VGND sg13g2_xnor2_1
X_31586_ _01753_ _08022_ _08056_ VPWR VGND sg13g2_nor2_1
X_31587_ _08057_ \memory_i.freq_inst.dsmod_cos.accu3_r[33]\ _08052_ VPWR VGND sg13g2_nor2_2
X_31588_ _08058_ \memory_i.freq_inst.dsmod_cos.accu3_r[33]\ _08052_ _08049_ _08051_ VPWR
+ VGND
+ sg13g2_a22oi_1
X_31589_ _08059_ _08058_ VPWR VGND sg13g2_buf_2
X_31590_ _08060_ _08057_ _08059_ VPWR VGND sg13g2_nor2_1
X_31591_ _08061_ _07499_ _08060_ VPWR VGND sg13g2_nor2_1
X_31592_ _08062_ _07499_ _08060_ VPWR VGND sg13g2_nand2_1
X_31593_ _08063_ _08061_ _08062_ \memory_i.freq_inst.dsmod_cos.i_ena_mod\ VPWR VGND sg13g2_nand3b_1
X_31594_ _08064_ \memory_i.freq_inst.dsmod_cos.accu3_r[34]\ _08063_ VPWR VGND sg13g2_xor2_1
X_31595_ _01754_ _08022_ _08064_ VPWR VGND sg13g2_nor2_1
X_31596_ _08065_ \memory_i.freq_inst.dsmod_cos.accu2_r[35]\ _07515_ VPWR VGND sg13g2_xnor2_1
X_31597_ _08066_ _07499_ _08060_ \memory_i.freq_inst.dsmod_cos.accu3_r[34]\ VPWR VGND sg13g2_a21oi_1
X_31598_ _08067_ _08061_ _08066_ VPWR VGND sg13g2_or2_1
X_31599_ _08068_ _08065_ _08067_ VPWR VGND sg13g2_xnor2_1
X_31600_ _08069_ _07821_ _08068_ VPWR VGND sg13g2_nor2_1
X_31601_ _08070_ \memory_i.freq_inst.dsmod_cos.accu3_r[35]\ _08069_ VPWR VGND sg13g2_xnor2_1
X_31602_ _01755_ _08022_ _08070_ VPWR VGND sg13g2_nor2_1
X_31603_ _08071_ _07504_ _07509_ _07513_ VPWR VGND sg13g2_and3_1
X_31604_ _08072_ _08071_ VPWR VGND sg13g2_buf_1
X_31605_ _08073_ \memory_i.freq_inst.dsmod_cos.accu2_r[35]\ _07499_ VPWR VGND sg13g2_nand2b_1
X_31606_ _08074_ _08072_ _08057_ _08059_ _08073_ VPWR
+ VGND
+ sg13g2_nor4_1
X_31607_ _08075_ \memory_i.freq_inst.dsmod_cos.accu2_r[35]\ \memory_i.freq_inst.dsmod_cos.accu3_r[34]\ VPWR VGND sg13g2_nand2b_1
X_31608_ _08076_ _08072_ _08057_ _08059_ _08075_ VPWR
+ VGND
+ sg13g2_nor4_1
X_31609_ _08077_ \memory_i.freq_inst.dsmod_cos.accu2_r[35]\ _07499_ VPWR VGND sg13g2_nand2_1
X_31610_ _08078_ _07515_ _08057_ _08059_ _08077_ VPWR
+ VGND
+ sg13g2_nor4_1
X_31611_ _08079_ \memory_i.freq_inst.dsmod_cos.accu3_r[34]\ \memory_i.freq_inst.dsmod_cos.accu2_r[35]\ VPWR VGND sg13g2_nand2_1
X_31612_ _08080_ _07515_ _08057_ _08059_ _08079_ VPWR
+ VGND
+ sg13g2_nor4_1
X_31613_ _08081_ _08074_ _08076_ _08078_ _08080_ VPWR
+ VGND
+ sg13g2_nor4_2
X_31614_ _08082_ \memory_i.freq_inst.dsmod_cos.accu3_r[33]\ VPWR VGND sg13g2_inv_1
X_31615_ _08083_ _08052_ VPWR VGND sg13g2_inv_1
X_31616_ _08084_ \memory_i.freq_inst.dsmod_cos.accu3_r[35]\ _07499_ VPWR VGND sg13g2_nand2_1
X_31617_ _08085_ \memory_i.freq_inst.dsmod_cos.accu3_r[35]\ \memory_i.freq_inst.dsmod_cos.accu3_r[34]\ VPWR VGND sg13g2_nand2_1
X_31618_ _08086_ _08082_ _08083_ _08084_ _08085_ _08059_
+ VPWR
+ VGND sg13g2_a221oi_1
X_31619_ _08087_ \memory_i.freq_inst.dsmod_cos.accu2_r[35]\ _07499_ \memory_i.freq_inst.dsmod_cos.accu3_r[34]\ VPWR VGND sg13g2_nand3b_1
X_31620_ _08088_ \memory_i.freq_inst.dsmod_cos.accu2_r[35]\ \memory_i.freq_inst.dsmod_cos.accu3_r[35]\ VPWR VGND sg13g2_nand2b_1
X_31621_ _08089_ _08087_ _08088_ _08072_ VPWR VGND sg13g2_a21oi_1
X_31622_ _08090_ \memory_i.freq_inst.dsmod_cos.accu3_r[34]\ \memory_i.freq_inst.dsmod_cos.accu2_r[35]\ _07499_ VPWR VGND sg13g2_nand3_1
X_31623_ _08091_ \memory_i.freq_inst.dsmod_cos.accu3_r[35]\ \memory_i.freq_inst.dsmod_cos.accu2_r[35]\ VPWR VGND sg13g2_nand2_1
X_31624_ _08092_ _08090_ _08091_ _07515_ VPWR VGND sg13g2_a21oi_1
X_31625_ _08093_ \memory_i.freq_inst.dsmod_cos.accu3_r[35]\ \memory_i.freq_inst.dsmod_cos.accu3_r[34]\ _07499_ VPWR VGND sg13g2_and3_1
X_31626_ _08094_ _08086_ _08089_ _08092_ _08093_ VPWR
+ VGND
+ sg13g2_nor4_2
X_31627_ _08095_ _08081_ _08094_ VPWR VGND sg13g2_nand2_1
X_31628_ _08096_ _07531_ _08095_ VPWR VGND sg13g2_xnor2_1
X_31629_ _08097_ _07821_ _08096_ VPWR VGND sg13g2_nor2_1
X_31630_ _08098_ \memory_i.freq_inst.dsmod_cos.accu3_r[36]\ _08097_ VPWR VGND sg13g2_xnor2_1
X_31631_ _01756_ _08022_ _08098_ VPWR VGND sg13g2_nor2_1
X_31632_ _08099_ \memory_i.freq_inst.dsmod_cos.i_ena_mod\ \memory_i.freq_inst.dsmod_cos.accu3_r[37]\ VPWR VGND sg13g2_nor2_1
X_31633_ _08100_ \memory_i.freq_inst.dsmod_cos.accu3_r[36]\ _07531_ VPWR VGND sg13g2_and2_1
X_31634_ _08101_ _07529_ _07530_ VPWR VGND sg13g2_xnor2_1
X_31635_ _08102_ \memory_i.freq_inst.dsmod_cos.accu3_r[36]\ _08101_ VPWR VGND sg13g2_nand2b_1
X_31636_ _08103_ _08095_ _08100_ _08102_ VPWR VGND sg13g2_o21ai_1
X_31637_ _08104_ _07546_ _07548_ _07557_ _07555_ VPWR
+ VGND
+ sg13g2_a22oi_1
X_31638_ _08105_ _07556_ _06975_ VPWR VGND sg13g2_nand2_1
X_31639_ _08106_ \memory_i.freq_inst.dsmod_cos.accu2_r[37]\ \memory_i.freq_inst.dsmod_cos.data_interp_r[37]\ VPWR VGND sg13g2_nand2_1
X_31640_ _08107_ \memory_i.freq_inst.dsmod_cos.data_interp_r[36]\ _07529_ _08105_ _08106_ _07542_
+ VPWR
+ VGND sg13g2_a221oi_1
X_31641_ _08108_ _08104_ _08107_ VPWR VGND sg13g2_or2_1
X_31642_ _08109_ _08108_ VPWR VGND sg13g2_buf_1
X_31643_ _08110_ \memory_i.freq_inst.dsmod_cos.accu3_r[37]\ _08109_ VPWR VGND sg13g2_xnor2_1
X_31644_ _08111_ _08103_ _08110_ VPWR VGND sg13g2_xnor2_1
X_31645_ _08112_ _05651_ _08111_ VPWR VGND sg13g2_nor2_1
X_31646_ _01757_ _07049_ _08099_ _08112_ VPWR VGND sg13g2_nor3_1
X_31647_ _08113_ _07531_ _08109_ VPWR VGND sg13g2_nand2_1
X_31648_ _08114_ \memory_i.freq_inst.dsmod_cos.accu3_r[36]\ _08109_ VPWR VGND sg13g2_nand2_1
X_31649_ _08115_ _08081_ _08094_ _08113_ _08114_ VPWR
+ VGND
+ sg13g2_a22oi_1
X_31650_ _08116_ \memory_i.freq_inst.dsmod_cos.accu3_r[37]\ _07531_ VPWR VGND sg13g2_nand2_1
X_31651_ _08117_ \memory_i.freq_inst.dsmod_cos.accu3_r[37]\ \memory_i.freq_inst.dsmod_cos.accu3_r[36]\ VPWR VGND sg13g2_nand2_1
X_31652_ _08118_ _08081_ _08094_ _08116_ _08117_ VPWR
+ VGND
+ sg13g2_a22oi_1
X_31653_ _08119_ \memory_i.freq_inst.dsmod_cos.accu3_r[37]\ _08100_ _08109_ VPWR VGND sg13g2_o21ai_1
X_31654_ _08120_ _08101_ _08117_ _08119_ VPWR VGND sg13g2_o21ai_1
X_31655_ _08121_ _08115_ _08118_ _08120_ VPWR VGND sg13g2_nor3_2
X_31656_ _08122_ _08121_ VPWR VGND sg13g2_buf_4
X_31657_ _08123_ \memory_i.freq_inst.dsmod_cos.accu2_r[38]\ _07560_ VPWR VGND sg13g2_xnor2_1
X_31658_ _08124_ _08111_ _08123_ VPWR VGND sg13g2_xnor2_1
X_31659_ _08125_ _08122_ _08124_ VPWR VGND sg13g2_and2_1
X_31660_ _08126_ _08122_ _08124_ VPWR VGND sg13g2_nor2_1
X_31661_ _08127_ _05783_ _08125_ _08126_ VPWR VGND sg13g2_nor3_1
X_31662_ _08128_ \memory_i.freq_inst.dsmod_cos.accu3_r[38]\ _08127_ VPWR VGND sg13g2_xnor2_1
X_31663_ _01758_ _08022_ _08128_ VPWR VGND sg13g2_nor2_1
X_31664_ _08129_ _07565_ _07567_ \memory_i.freq_inst.dsmod_cos.accu2_r[39]\ VPWR VGND sg13g2_o21ai_1
X_31665_ _08130_ _08129_ VPWR VGND sg13g2_buf_2
X_31666_ _08131_ \memory_i.freq_inst.dsmod_cos.accu2_r[39]\ _07565_ _07567_ VPWR VGND sg13g2_or3_1
X_31667_ _08132_ _08131_ VPWR VGND sg13g2_buf_4
X_31668_ _08133_ _08130_ _08132_ VPWR VGND sg13g2_and2_1
X_31669_ _08134_ _08133_ VPWR VGND sg13g2_buf_2
X_31670_ _08135_ _08103_ _08110_ VPWR VGND sg13g2_xor2_1
X_31671_ _08136_ _08115_ _08118_ _08120_ VPWR VGND sg13g2_or3_1
X_31672_ _08137_ _08136_ VPWR VGND sg13g2_buf_2
X_31673_ _08138_ _13397_ _07562_ \memory_i.freq_inst.dsmod_cos.accu3_r[38]\ VPWR VGND sg13g2_o21ai_1
X_31674_ _08139_ \memory_i.freq_inst.dsmod_cos.accu3_r[38]\ _08123_ _08138_ VPWR VGND sg13g2_o21ai_1
X_31675_ _08140_ _08135_ _08137_ _08139_ VPWR VGND sg13g2_a21o_1
X_31676_ _08141_ \memory_i.freq_inst.dsmod_cos.accu3_r[38]\ VPWR VGND sg13g2_inv_1
X_31677_ _08142_ _08141_ _13383_ VPWR VGND sg13g2_nand2_1
X_31678_ _08143_ _07562_ _08142_ VPWR VGND sg13g2_nor2_1
X_31679_ _08144_ _07554_ _07560_ VPWR VGND sg13g2_xnor2_1
X_31680_ _08145_ _08144_ VPWR VGND sg13g2_buf_1
X_31681_ _08146_ \memory_i.freq_inst.dsmod_cos.accu3_r[38]\ _13397_ VPWR VGND sg13g2_nand2_1
X_31682_ _08147_ _08145_ _08122_ _08146_ VPWR VGND sg13g2_nor3_1
X_31683_ _08148_ _08143_ _08147_ _08135_ VPWR VGND sg13g2_o21ai_1
X_31684_ _08149_ _08146_ _07562_ VPWR VGND sg13g2_nand2b_1
X_31685_ _08150_ _08111_ _08122_ _08142_ _08149_ VPWR
+ VGND
+ sg13g2_nand4_1
X_31686_ _08151_ _08137_ _08143_ VPWR VGND sg13g2_nand2_1
X_31687_ _08152_ _08140_ _08148_ _08150_ _08151_ VPWR
+ VGND
+ sg13g2_and4_1
X_31688_ _08153_ _08134_ _08152_ VPWR VGND sg13g2_xor2_1
X_31689_ _08154_ \memory_i.freq_inst.cordic.rstn_i\ \memory_i.freq_inst.dsmod_cos.accu3_r[39]\ VPWR VGND sg13g2_nand2_1
X_31690_ _08155_ \memory_i.freq_inst.dsmod_cos.i_ena_mod\ _08153_ _08154_ VPWR VGND sg13g2_a21oi_1
X_31691_ _08156_ \memory_i.freq_inst.dsmod_cos.accu3_r[39]\ VPWR VGND sg13g2_inv_1
X_31692_ _08157_ \memory_i.freq_inst.dsmod_cos.i_ena_mod\ \memory_i.freq_inst.cordic.rstn_i\ _08156_ _08153_ VPWR
+ VGND
+ sg13g2_nand4_1
X_31693_ _01759_ _08155_ _08157_ VPWR VGND sg13g2_nand2b_1
X_31694_ _08158_ _12941_ \memory_i.freq_inst.dsmod_cos.accu3_r[40]\ VPWR VGND sg13g2_nand2_1
X_31695_ _08159_ _08130_ _08132_ _08156_ VPWR VGND sg13g2_a21oi_1
X_31696_ _08160_ _08156_ _08130_ _08132_ VPWR VGND sg13g2_and3_2
X_31697_ _08161_ _08160_ VPWR VGND sg13g2_buf_1
X_31698_ _08162_ _08141_ _07562_ VPWR VGND sg13g2_nor2_1
X_31699_ _08163_ _08159_ _08161_ _08162_ VPWR VGND sg13g2_o21ai_1
X_31700_ _08164_ _08130_ _08132_ _08156_ VPWR VGND sg13g2_a21o_1
X_31701_ _08165_ _08156_ _08130_ _08132_ VPWR VGND sg13g2_nand3_1
X_31702_ _08166_ _08141_ _08145_ VPWR VGND sg13g2_nor2_1
X_31703_ _08167_ _08164_ _08165_ _08166_ VPWR VGND sg13g2_nand3_1
X_31704_ _08168_ _08163_ _08167_ _08137_ VPWR VGND sg13g2_mux2_1
X_31705_ _08169_ \memory_i.freq_inst.dsmod_cos.accu3_r[38]\ _07562_ VPWR VGND sg13g2_nor2_1
X_31706_ _08170_ _08159_ _08161_ _08169_ VPWR VGND sg13g2_o21ai_1
X_31707_ _08171_ \memory_i.freq_inst.dsmod_cos.accu3_r[38]\ _08145_ VPWR VGND sg13g2_nor2_1
X_31708_ _08172_ _08159_ _08161_ _08171_ VPWR VGND sg13g2_o21ai_1
X_31709_ _08173_ _08170_ _08172_ _08122_ VPWR VGND sg13g2_mux2_1
X_31710_ _08174_ _08168_ _08173_ _08111_ VPWR VGND sg13g2_a21oi_1
X_31711_ _08175_ _08163_ _08172_ _08122_ VPWR VGND sg13g2_a21oi_1
X_31712_ _08176_ _08164_ _08165_ _08169_ VPWR VGND sg13g2_nand3_1
X_31713_ _08177_ _08159_ _08161_ _08166_ VPWR VGND sg13g2_o21ai_1
X_31714_ _08178_ _08176_ _08177_ _08137_ VPWR VGND sg13g2_a21oi_1
X_31715_ _08179_ _08175_ _08178_ VPWR VGND sg13g2_or2_1
X_31716_ _08180_ _13397_ _08135_ VPWR VGND sg13g2_nor2_1
X_31717_ _08181_ _13397_ _08174_ _08179_ _08180_ VPWR
+ VGND
+ sg13g2_a22oi_1
X_31718_ _08182_ _07562_ _08137_ VPWR VGND sg13g2_nand2_1
X_31719_ _08183_ \memory_i.freq_inst.dsmod_cos.accu3_r[40]\ _07601_ VPWR VGND sg13g2_xnor2_1
X_31720_ _08184_ _08183_ VPWR VGND sg13g2_buf_4
X_31721_ _08185_ \memory_i.freq_inst.dsmod_cos.accu3_r[39]\ _08134_ VPWR VGND sg13g2_nor2_1
X_31722_ _08186_ _08182_ _08184_ _08185_ VPWR VGND sg13g2_or3_1
X_31723_ _08187_ _08141_ _08184_ _08185_ VPWR VGND sg13g2_nor3_2
X_31724_ _08188_ _08145_ _08122_ VPWR VGND sg13g2_nand2_1
X_31725_ _08189_ \memory_i.freq_inst.dsmod_cos.accu3_r[39]\ _08134_ VPWR VGND sg13g2_nand2_1
X_31726_ _08190_ _08184_ _08189_ VPWR VGND sg13g2_nor2_1
X_31727_ _08191_ _08184_ _08185_ _08187_ _08188_ _08190_
+ VPWR
+ VGND sg13g2_a221oi_1
X_31728_ _08192_ \memory_i.freq_inst.dsmod_cos.accu3_r[39]\ _08134_ \memory_i.freq_inst.dsmod_cos.accu3_r[38]\ VPWR VGND sg13g2_a21o_1
X_31729_ _08193_ _08192_ _08184_ VPWR VGND sg13g2_nor2b_1
X_31730_ _08194_ _08145_ _08122_ _08184_ _08189_ VPWR
+ VGND
+ sg13g2_and4_1
X_31731_ _08195_ _08182_ _08193_ _08194_ VPWR VGND sg13g2_a21oi_1
X_31732_ _08196_ _08186_ _08191_ _08195_ VPWR VGND sg13g2_nand3_1
X_31733_ _08197_ _08181_ _08196_ VPWR VGND sg13g2_xnor2_1
X_31734_ _08198_ \memory_i.freq_inst.dsmod_cos.i_ena_mod\ _08197_ VPWR VGND sg13g2_nand2_1
X_31735_ _08199_ _06006_ VPWR VGND sg13g2_buf_1
X_31736_ _01760_ _08158_ _08198_ _08199_ VPWR VGND sg13g2_a21oi_1
X_31737_ _08200_ _08179_ _08186_ _08191_ _08195_ VPWR
+ VGND
+ sg13g2_nand4_1
X_31738_ _08201_ _13397_ _08111_ VPWR VGND sg13g2_nor2_1
X_31739_ _08202_ _08174_ _08196_ _08200_ _13383_ _08201_
+ VPWR
+ VGND sg13g2_a221oi_1
X_31740_ _08203_ \memory_i.freq_inst.dsmod_cos.accu3_r[41]\ \memory_i.freq_inst.dsmod_cos.accu1_r[39]\ VPWR VGND sg13g2_xnor2_1
X_31741_ _08204_ \memory_i.ds_lo_conf[5]\ _08203_ VPWR VGND sg13g2_nor2_1
X_31742_ _08205_ \memory_i.freq_inst.dsmod_cos.accu2_r[41]\ _08204_ VPWR VGND sg13g2_xor2_1
X_31743_ _08206_ _07607_ _08205_ VPWR VGND sg13g2_xnor2_1
X_31744_ _08207_ \memory_i.freq_inst.dsmod_cos.accu3_r[40]\ VPWR VGND sg13g2_inv_1
X_31745_ _08208_ _08207_ _07601_ VPWR VGND sg13g2_nor2_1
X_31746_ _08209_ _08145_ _08122_ _08189_ VPWR VGND sg13g2_and3_2
X_31747_ _08210_ _07562_ _08137_ _08192_ VPWR VGND sg13g2_a21oi_1
X_31748_ _08211_ _07601_ _08185_ _08209_ _08210_ VPWR
+ VGND
+ sg13g2_nor4_1
X_31749_ _08212_ _08207_ _08185_ _08209_ _08210_ VPWR
+ VGND
+ sg13g2_nor4_1
X_31750_ _08213_ _08208_ _08211_ _08212_ VPWR VGND sg13g2_nor3_1
X_31751_ _08214_ _08206_ _08213_ VPWR VGND sg13g2_xnor2_1
X_31752_ _08215_ \memory_i.freq_inst.dsmod_cos.i_ena_mod\ \memory_i.freq_inst.cordic.rstn_i\ _08202_ _08214_ VPWR
+ VGND
+ sg13g2_nand4_1
X_31753_ _08216_ \memory_i.freq_inst.dsmod_cos.i_ena_mod\ \memory_i.freq_inst.cordic.rstn_i\ VPWR VGND sg13g2_nand2_1
X_31754_ _08217_ _08202_ _08214_ _08216_ VPWR VGND sg13g2_or3_1
X_31755_ _08218_ _07051_ \memory_i.freq_inst.cordic.rstn_i\ \memory_i.freq_inst.dsmod_cos.accu3_r[41]\ VPWR VGND sg13g2_nand3_1
X_31756_ _01761_ _08215_ _08217_ _08218_ VPWR VGND sg13g2_nand3_1
X_31757_ _08219_ _05724_ VPWR VGND sg13g2_buf_1
X_31758_ _08220_ _08219_ \memory_i.freq_inst.dsmod_cos.fetch_ctr_r[0]\ VPWR VGND sg13g2_nand2_1
X_31759_ _01762_ _15893_ _08220_ _08199_ VPWR VGND sg13g2_a21oi_1
X_31760_ _08221_ \memory_i.freq_inst.dsmod_cos.fetch_ctr_r[1]\ _15893_ VPWR VGND sg13g2_xor2_1
X_31761_ _01763_ _08022_ _08221_ VPWR VGND sg13g2_nor2_1
X_31762_ _08222_ \memory_i.freq_inst.dsmod_cos.fetch_ctr_r[1]\ _15893_ \memory_i.freq_inst.dsmod_cos.fetch_ctr_r[2]\ VPWR VGND sg13g2_o21ai_1
X_31763_ _01764_ _15895_ _08222_ _08199_ VPWR VGND sg13g2_a21oi_1
X_31764_ _08223_ \memory_i.freq_inst.dsmod_cos.fetch_ctr_r[3]\ _15895_ VPWR VGND sg13g2_xor2_1
X_31765_ _01765_ _08022_ _08223_ VPWR VGND sg13g2_nor2_1
X_31766_ _08224_ _15896_ VPWR VGND sg13g2_inv_1
X_31767_ _08225_ \memory_i.freq_inst.dsmod_cos.fetch_ctr_r[3]\ _15895_ \memory_i.freq_inst.dsmod_cos.fetch_ctr_r[4]\ VPWR VGND sg13g2_o21ai_1
X_31768_ _01766_ _08224_ _08225_ _08199_ VPWR VGND sg13g2_a21oi_1
X_31769_ _08226_ _15899_ _03147_ _15898_ VPWR VGND sg13g2_a21o_1
X_31770_ _08227_ _15896_ \memory_i.freq_inst.dsmod_cos.fetch_ctr_r[5]\ VPWR VGND sg13g2_nand2b_1
X_31771_ _01767_ _08226_ _08227_ _08199_ VPWR VGND sg13g2_a21oi_1
X_31772_ _08228_ \memory_i.freq_inst.dsmod_cos.fetch_ctr_r[7]\ \memory_i.freq_inst.dsmod_cos.i_osr[1]\ VPWR VGND sg13g2_nor2_1
X_31773_ _08229_ \memory_i.freq_inst.dsmod_cos.fetch_ctr_r[6]\ _15898_ _08228_ VPWR VGND sg13g2_nor3_1
X_31774_ _08230_ \memory_i.freq_inst.dsmod_cos.fetch_ctr_r[6]\ _15898_ _08229_ VPWR VGND sg13g2_a21oi_1
X_31775_ _01768_ _08022_ _08230_ VPWR VGND sg13g2_nor2_1
X_31776_ _08231_ \memory_i.freq_inst.dsmod_cos.fetch_ctr_r[6]\ _15898_ \memory_i.freq_inst.dsmod_cos.fetch_ctr_r[7]\ VPWR VGND sg13g2_o21ai_1
X_31777_ _08232_ \memory_i.freq_inst.dsmod_cos.fetch_ctr_r[7]\ \memory_i.freq_inst.dsmod_cos.fetch_ctr_r[6]\ _15898_ _03163_ VPWR
+ VGND
+ sg13g2_or4_1
X_31778_ _01769_ _08231_ _08232_ _08199_ VPWR VGND sg13g2_a21oi_1
X_31779_ _08233_ _15815_ VPWR VGND sg13g2_buf_1
X_31780_ _08234_ _08233_ VPWR VGND sg13g2_buf_1
X_31781_ _08235_ \memory_i.freq_inst.dsmod_cos.i_ena_mod\ \memory_i.freq_inst.dsmod_sin.data_step_r[0]\ VPWR VGND sg13g2_nand2_1
X_31782_ _08236_ \memory_i.freq_inst.dsmod_sin.data_interp_r[0]\ _08235_ VPWR VGND sg13g2_xor2_1
X_31783_ _01770_ _07049_ _08234_ _08236_ VPWR VGND sg13g2_nor3_1
X_31784_ _08237_ _08021_ VPWR VGND sg13g2_buf_1
X_31785_ _08238_ \memory_i.freq_inst.dsmod_sin.fetch_ctr_r[4]\ _15809_ VPWR VGND sg13g2_nor2_1
X_31786_ _08239_ \memory_i.freq_inst.dsmod_sin.fetch_ctr_r[7]\ \memory_i.freq_inst.dsmod_sin.fetch_ctr_r[6]\ \memory_i.freq_inst.dsmod_sin.fetch_ctr_r[5]\ VPWR VGND sg13g2_nor3_1
X_31787_ _08240_ _08238_ _08239_ _12938_ VPWR VGND sg13g2_a21oi_1
X_31788_ _08241_ _08240_ VPWR VGND sg13g2_buf_1
X_31789_ _08242_ _08241_ VPWR VGND sg13g2_buf_1
X_31790_ _08243_ \memory_i.freq_inst.dsmod_sin.data_step_r[0]\ \memory_i.freq_inst.dsmod_sin.data_interp_r[0]\ VPWR VGND sg13g2_nand2_1
X_31791_ _08244_ \memory_i.freq_inst.dsmod_sin.data_step_r[1]\ \memory_i.freq_inst.dsmod_sin.data_interp_r[1]\ VPWR VGND sg13g2_xor2_1
X_31792_ _08245_ _08243_ _08244_ VPWR VGND sg13g2_xnor2_1
X_31793_ _08246_ _05662_ \memory_i.freq_inst.dsmod_sin.data_interp_r[1]\ _08242_ _08245_ VPWR
+ VGND
+ sg13g2_a22oi_1
X_31794_ _01771_ _08237_ _08246_ VPWR VGND sg13g2_nor2_1
X_31795_ _08247_ \memory_i.freq_inst.dsmod_sin.data_step_r[0]\ \memory_i.freq_inst.dsmod_sin.data_interp_r[0]\ \memory_i.freq_inst.dsmod_sin.data_interp_r[1]\ VPWR VGND sg13g2_a21o_1
X_31796_ _08248_ \memory_i.freq_inst.dsmod_sin.data_step_r[0]\ \memory_i.freq_inst.dsmod_sin.data_interp_r[1]\ \memory_i.freq_inst.dsmod_sin.data_interp_r[0]\ VPWR VGND sg13g2_and3_1
X_31797_ _08249_ \memory_i.freq_inst.dsmod_sin.data_step_r[1]\ _08247_ _08248_ VPWR VGND sg13g2_a21oi_1
X_31798_ _08250_ \memory_i.freq_inst.dsmod_sin.data_step_r[2]\ \memory_i.freq_inst.dsmod_sin.data_interp_r[2]\ VPWR VGND sg13g2_xor2_1
X_31799_ _08251_ _08249_ _08250_ VPWR VGND sg13g2_xnor2_1
X_31800_ _08252_ _05662_ \memory_i.freq_inst.dsmod_sin.data_interp_r[2]\ _08242_ _08251_ VPWR
+ VGND
+ sg13g2_a22oi_1
X_31801_ _01772_ _08237_ _08252_ VPWR VGND sg13g2_nor2_1
X_31802_ _08253_ \memory_i.freq_inst.dsmod_sin.data_step_r[2]\ \memory_i.freq_inst.dsmod_sin.data_interp_r[2]\ VPWR VGND sg13g2_nor2_1
X_31803_ _08254_ \memory_i.freq_inst.dsmod_sin.data_step_r[2]\ \memory_i.freq_inst.dsmod_sin.data_interp_r[2]\ _08247_ \memory_i.freq_inst.dsmod_sin.data_step_r[1]\ _08248_
+ VPWR
+ VGND sg13g2_a221oi_1
X_31804_ _08255_ _08254_ VPWR VGND sg13g2_buf_1
X_31805_ _08256_ _08253_ _08255_ VPWR VGND sg13g2_nor2_1
X_31806_ _08257_ \memory_i.freq_inst.dsmod_sin.data_step_r[3]\ \memory_i.freq_inst.dsmod_sin.data_interp_r[3]\ VPWR VGND sg13g2_xnor2_1
X_31807_ _08258_ _08256_ _08257_ VPWR VGND sg13g2_xnor2_1
X_31808_ _08259_ _05662_ \memory_i.freq_inst.dsmod_sin.data_interp_r[3]\ _08242_ _08258_ VPWR
+ VGND
+ sg13g2_a22oi_1
X_31809_ _01773_ _08237_ _08259_ VPWR VGND sg13g2_nor2_1
X_31810_ _08260_ \memory_i.freq_inst.dsmod_sin.data_interp_r[3]\ VPWR VGND sg13g2_inv_1
X_31811_ _08261_ _08253_ _08255_ _08260_ VPWR VGND sg13g2_o21ai_1
X_31812_ _08262_ _08260_ _08253_ _08255_ VPWR VGND sg13g2_nor3_1
X_31813_ _08263_ \memory_i.freq_inst.dsmod_sin.data_step_r[3]\ _08261_ _08262_ VPWR VGND sg13g2_a21oi_1
X_31814_ _08264_ \memory_i.freq_inst.dsmod_sin.data_step_r[4]\ \memory_i.freq_inst.dsmod_sin.data_interp_r[4]\ VPWR VGND sg13g2_xor2_1
X_31815_ _08265_ _08263_ _08264_ VPWR VGND sg13g2_xnor2_1
X_31816_ _08266_ _05662_ \memory_i.freq_inst.dsmod_sin.data_interp_r[4]\ _08242_ _08265_ VPWR
+ VGND
+ sg13g2_a22oi_1
X_31817_ _01774_ _08237_ _08266_ VPWR VGND sg13g2_nor2_1
X_31818_ _08267_ \memory_i.freq_inst.dsmod_sin.data_step_r[4]\ \memory_i.freq_inst.dsmod_sin.data_interp_r[4]\ VPWR VGND sg13g2_nor2_1
X_31819_ _08268_ \memory_i.freq_inst.dsmod_sin.data_step_r[4]\ \memory_i.freq_inst.dsmod_sin.data_interp_r[4]\ _08261_ \memory_i.freq_inst.dsmod_sin.data_step_r[3]\ _08262_
+ VPWR
+ VGND sg13g2_a221oi_1
X_31820_ _08269_ _08268_ VPWR VGND sg13g2_buf_1
X_31821_ _08270_ _08267_ _08269_ VPWR VGND sg13g2_nor2_1
X_31822_ _08271_ \memory_i.freq_inst.dsmod_sin.data_step_r[5]\ \memory_i.freq_inst.dsmod_sin.data_interp_r[5]\ VPWR VGND sg13g2_xnor2_1
X_31823_ _08272_ _08270_ _08271_ VPWR VGND sg13g2_xnor2_1
X_31824_ _08273_ _05751_ \memory_i.freq_inst.dsmod_sin.data_interp_r[5]\ _08242_ _08272_ VPWR
+ VGND
+ sg13g2_a22oi_1
X_31825_ _01775_ _08237_ _08273_ VPWR VGND sg13g2_nor2_1
X_31826_ _08274_ \memory_i.freq_inst.dsmod_sin.data_interp_r[5]\ VPWR VGND sg13g2_inv_1
X_31827_ _08275_ _08267_ _08269_ _08274_ VPWR VGND sg13g2_o21ai_1
X_31828_ _08276_ _08274_ _08267_ _08269_ VPWR VGND sg13g2_nor3_1
X_31829_ _08277_ \memory_i.freq_inst.dsmod_sin.data_step_r[5]\ _08275_ _08276_ VPWR VGND sg13g2_a21oi_1
X_31830_ _08278_ \memory_i.freq_inst.dsmod_sin.data_step_r[6]\ \memory_i.freq_inst.dsmod_sin.data_interp_r[6]\ VPWR VGND sg13g2_xor2_1
X_31831_ _08279_ _08277_ _08278_ VPWR VGND sg13g2_xnor2_1
X_31832_ _08280_ _05751_ \memory_i.freq_inst.dsmod_sin.data_interp_r[6]\ _08242_ _08279_ VPWR
+ VGND
+ sg13g2_a22oi_1
X_31833_ _01776_ _08237_ _08280_ VPWR VGND sg13g2_nor2_1
X_31834_ _08281_ \memory_i.freq_inst.dsmod_sin.data_step_r[6]\ \memory_i.freq_inst.dsmod_sin.data_interp_r[6]\ VPWR VGND sg13g2_nor2_1
X_31835_ _08282_ \memory_i.freq_inst.dsmod_sin.data_step_r[6]\ \memory_i.freq_inst.dsmod_sin.data_interp_r[6]\ VPWR VGND sg13g2_nand2_1
X_31836_ _08283_ _08277_ _08281_ _08282_ VPWR VGND sg13g2_o21ai_1
X_31837_ _08284_ \memory_i.freq_inst.dsmod_sin.data_step_r[7]\ \memory_i.freq_inst.dsmod_sin.data_interp_r[7]\ VPWR VGND sg13g2_xnor2_1
X_31838_ _08285_ _08283_ _08284_ VPWR VGND sg13g2_xnor2_1
X_31839_ _08286_ _05751_ \memory_i.freq_inst.dsmod_sin.data_interp_r[7]\ _08241_ _08285_ VPWR
+ VGND
+ sg13g2_a22oi_1
X_31840_ _01777_ _08237_ _08286_ VPWR VGND sg13g2_nor2_1
X_31841_ _08287_ _15815_ VPWR VGND sg13g2_buf_1
X_31842_ _08288_ _05738_ \memory_i.freq_inst.dsmod_sin.data_interp_r[8]\ \memory_i.freq_inst.dsmod_sin.data_pre_r[8]\ _08287_ VPWR
+ VGND
+ sg13g2_a22oi_1
X_31843_ _08289_ \memory_i.freq_inst.dsmod_sin.data_interp_r[7]\ _08283_ VPWR VGND sg13g2_nand2_1
X_31844_ _08290_ \memory_i.freq_inst.dsmod_sin.data_interp_r[7]\ _08283_ \memory_i.freq_inst.dsmod_sin.data_step_r[7]\ VPWR VGND sg13g2_o21ai_1
X_31845_ _08291_ _08289_ _08290_ VPWR VGND sg13g2_nand2_1
X_31846_ _08292_ \memory_i.freq_inst.dsmod_sin.data_step_r[8]\ \memory_i.freq_inst.dsmod_sin.data_interp_r[8]\ VPWR VGND sg13g2_xnor2_1
X_31847_ _08293_ _08291_ _08292_ VPWR VGND sg13g2_xnor2_1
X_31848_ _08294_ _08242_ _08293_ VPWR VGND sg13g2_nand2_1
X_31849_ _01778_ _08288_ _08294_ _08199_ VPWR VGND sg13g2_a21oi_1
X_31850_ _08295_ _08241_ VPWR VGND sg13g2_inv_1
X_31851_ _08296_ \memory_i.freq_inst.dsmod_sin.data_interp_r[8]\ _08291_ \memory_i.freq_inst.dsmod_sin.data_step_r[8]\ VPWR VGND sg13g2_a21o_1
X_31852_ _08297_ \memory_i.freq_inst.dsmod_sin.data_interp_r[8]\ _08291_ _08296_ VPWR VGND sg13g2_o21ai_1
X_31853_ _08298_ \memory_i.freq_inst.dsmod_sin.data_step_r[9]\ \memory_i.freq_inst.dsmod_sin.data_interp_r[9]\ VPWR VGND sg13g2_xnor2_1
X_31854_ _08299_ _08297_ _08298_ VPWR VGND sg13g2_xnor2_1
X_31855_ _08300_ _05724_ \memory_i.freq_inst.dsmod_sin.data_interp_r[9]\ \memory_i.freq_inst.dsmod_sin.data_pre_r[9]\ _15816_ VPWR
+ VGND
+ sg13g2_a22oi_1
X_31856_ _08301_ _08295_ _08299_ _08300_ VPWR VGND sg13g2_o21ai_1
X_31857_ _01779_ \memory_i.freq_inst.cordic.rstn_i\ _08301_ VPWR VGND sg13g2_and2_1
X_31858_ _08302_ _05738_ \memory_i.freq_inst.dsmod_sin.data_interp_r[10]\ \memory_i.freq_inst.dsmod_sin.data_pre_r[10]\ _08287_ VPWR
+ VGND
+ sg13g2_a22oi_1
X_31859_ _08303_ \memory_i.freq_inst.dsmod_sin.data_interp_r[9]\ VPWR VGND sg13g2_inv_1
X_31860_ _08304_ \memory_i.freq_inst.dsmod_sin.data_step_r[9]\ VPWR VGND sg13g2_inv_1
X_31861_ _08305_ _08303_ _08297_ _08304_ VPWR VGND sg13g2_a21o_1
X_31862_ _08306_ _08303_ _08297_ _08305_ VPWR VGND sg13g2_o21ai_1
X_31863_ _08307_ \memory_i.freq_inst.dsmod_sin.data_step_r[10]\ \memory_i.freq_inst.dsmod_sin.data_interp_r[10]\ VPWR VGND sg13g2_xnor2_1
X_31864_ _08308_ _08306_ _08307_ VPWR VGND sg13g2_xnor2_1
X_31865_ _08309_ _08242_ _08308_ VPWR VGND sg13g2_nand2_1
X_31866_ _01780_ _08302_ _08309_ _08199_ VPWR VGND sg13g2_a21oi_1
X_31867_ _08310_ _08241_ VPWR VGND sg13g2_buf_1
X_31868_ _08311_ \memory_i.freq_inst.dsmod_sin.data_step_r[11]\ \memory_i.freq_inst.dsmod_sin.data_interp_r[11]\ VPWR VGND sg13g2_xnor2_1
X_31869_ _08312_ \memory_i.freq_inst.dsmod_sin.data_step_r[10]\ _08306_ \memory_i.freq_inst.dsmod_sin.data_interp_r[10]\ VPWR VGND sg13g2_o21ai_1
X_31870_ _08313_ \memory_i.freq_inst.dsmod_sin.data_step_r[10]\ _08306_ VPWR VGND sg13g2_nand2_1
X_31871_ _08314_ _08312_ _08313_ VPWR VGND sg13g2_nand2_1
X_31872_ _08315_ _08311_ _08314_ VPWR VGND sg13g2_xnor2_1
X_31873_ _08316_ _08310_ _08315_ VPWR VGND sg13g2_nand2_1
X_31874_ _08317_ _05784_ \memory_i.freq_inst.dsmod_sin.data_interp_r[11]\ \memory_i.freq_inst.dsmod_sin.data_pre_r[11]\ _08287_ VPWR
+ VGND
+ sg13g2_a22oi_1
X_31875_ _01781_ _08316_ _08317_ _08199_ VPWR VGND sg13g2_a21oi_1
X_31876_ _08318_ _08292_ _08298_ _08307_ _08311_ VPWR
+ VGND
+ sg13g2_or4_1
X_31877_ _08319_ _08289_ _08290_ _08318_ VPWR VGND sg13g2_a21o_1
X_31878_ _08320_ \memory_i.freq_inst.dsmod_sin.data_step_r[11]\ \memory_i.freq_inst.dsmod_sin.data_interp_r[11]\ VPWR VGND sg13g2_nand2_1
X_31879_ _08321_ \memory_i.freq_inst.dsmod_sin.data_step_r[8]\ \memory_i.freq_inst.dsmod_sin.data_interp_r[8]\ \memory_i.freq_inst.dsmod_sin.data_interp_r[9]\ VPWR VGND sg13g2_a21oi_1
X_31880_ _08322_ \memory_i.freq_inst.dsmod_sin.data_step_r[8]\ \memory_i.freq_inst.dsmod_sin.data_interp_r[9]\ \memory_i.freq_inst.dsmod_sin.data_interp_r[8]\ VPWR VGND sg13g2_nand3_1
X_31881_ _08323_ _08304_ _08321_ _08322_ VPWR VGND sg13g2_o21ai_1
X_31882_ _08324_ \memory_i.freq_inst.dsmod_sin.data_interp_r[10]\ _08323_ VPWR VGND sg13g2_nand2_1
X_31883_ _08325_ \memory_i.freq_inst.dsmod_sin.data_interp_r[10]\ _08323_ \memory_i.freq_inst.dsmod_sin.data_step_r[10]\ VPWR VGND sg13g2_o21ai_1
X_31884_ _08326_ _08320_ _08324_ _08325_ VPWR VGND sg13g2_nand3_1
X_31885_ _08327_ \memory_i.freq_inst.dsmod_sin.data_step_r[11]\ \memory_i.freq_inst.dsmod_sin.data_interp_r[11]\ _08326_ VPWR VGND sg13g2_o21ai_1
X_31886_ _08328_ _08319_ _08327_ VPWR VGND sg13g2_nand2_1
X_31887_ _08329_ \memory_i.freq_inst.dsmod_sin.data_step_r[12]\ \memory_i.freq_inst.dsmod_sin.data_interp_r[12]\ VPWR VGND sg13g2_xnor2_1
X_31888_ _08330_ _08328_ _08329_ VPWR VGND sg13g2_xnor2_1
X_31889_ _08331_ _08310_ _08330_ VPWR VGND sg13g2_nand2_1
X_31890_ _08332_ _05784_ \memory_i.freq_inst.dsmod_sin.data_interp_r[12]\ \memory_i.freq_inst.dsmod_sin.data_pre_r[12]\ _08287_ VPWR
+ VGND
+ sg13g2_a22oi_1
X_31891_ _01782_ _08331_ _08332_ _08199_ VPWR VGND sg13g2_a21oi_1
X_31892_ _08333_ \memory_i.freq_inst.dsmod_sin.data_step_r[13]\ \memory_i.freq_inst.dsmod_sin.data_interp_r[13]\ VPWR VGND sg13g2_and2_1
X_31893_ _08334_ \memory_i.freq_inst.dsmod_sin.data_step_r[13]\ \memory_i.freq_inst.dsmod_sin.data_interp_r[13]\ VPWR VGND sg13g2_nor2_1
X_31894_ _08335_ _08333_ _08334_ VPWR VGND sg13g2_nor2_1
X_31895_ _08336_ \memory_i.freq_inst.dsmod_sin.data_interp_r[12]\ _08328_ \memory_i.freq_inst.dsmod_sin.data_step_r[12]\ VPWR VGND sg13g2_a21o_1
X_31896_ _08337_ \memory_i.freq_inst.dsmod_sin.data_interp_r[12]\ _08328_ _08336_ VPWR VGND sg13g2_o21ai_1
X_31897_ _08338_ _08335_ _08337_ VPWR VGND sg13g2_xnor2_1
X_31898_ _08339_ _08310_ _08338_ VPWR VGND sg13g2_nand2_1
X_31899_ _08340_ _05784_ \memory_i.freq_inst.dsmod_sin.data_interp_r[13]\ \memory_i.freq_inst.dsmod_sin.data_pre_r[13]\ _08287_ VPWR
+ VGND
+ sg13g2_a22oi_1
X_31900_ _08341_ _06006_ VPWR VGND sg13g2_buf_1
X_31901_ _01783_ _08339_ _08340_ _08341_ VPWR VGND sg13g2_a21oi_1
X_31902_ _08342_ \memory_i.freq_inst.dsmod_sin.data_step_r[14]\ \memory_i.freq_inst.dsmod_sin.data_interp_r[14]\ VPWR VGND sg13g2_xnor2_1
X_31903_ _08343_ \memory_i.freq_inst.dsmod_sin.data_step_r[13]\ \memory_i.freq_inst.dsmod_sin.data_interp_r[13]\ VPWR VGND sg13g2_nand2_1
X_31904_ _08344_ _08334_ _08337_ _08343_ VPWR VGND sg13g2_o21ai_1
X_31905_ _08345_ _08342_ _08344_ VPWR VGND sg13g2_xnor2_1
X_31906_ _08346_ _08310_ _08345_ VPWR VGND sg13g2_nand2_1
X_31907_ _08347_ _05784_ \memory_i.freq_inst.dsmod_sin.data_interp_r[14]\ \memory_i.freq_inst.dsmod_sin.data_pre_r[14]\ _08287_ VPWR
+ VGND
+ sg13g2_a22oi_1
X_31908_ _01784_ _08346_ _08347_ _08341_ VPWR VGND sg13g2_a21oi_1
X_31909_ _08348_ \memory_i.freq_inst.dsmod_sin.data_step_r[13]\ \memory_i.freq_inst.dsmod_sin.data_interp_r[13]\ VPWR VGND sg13g2_or2_1
X_31910_ _08349_ _08348_ VPWR VGND sg13g2_buf_1
X_31911_ _08350_ \memory_i.freq_inst.dsmod_sin.data_interp_r[14]\ \memory_i.freq_inst.dsmod_sin.data_interp_r[12]\ _08349_ VPWR VGND sg13g2_nand3_1
X_31912_ _08351_ \memory_i.freq_inst.dsmod_sin.data_step_r[12]\ \memory_i.freq_inst.dsmod_sin.data_interp_r[14]\ _08349_ VPWR VGND sg13g2_nand3_1
X_31913_ _08352_ _08319_ _08327_ _08350_ _08351_ VPWR
+ VGND
+ sg13g2_a22oi_1
X_31914_ _08353_ \memory_i.freq_inst.dsmod_sin.data_interp_r[12]\ VPWR VGND sg13g2_inv_1
X_31915_ _08354_ \memory_i.freq_inst.dsmod_sin.data_interp_r[14]\ _08333_ VPWR VGND sg13g2_nand2_1
X_31916_ _08355_ _08353_ _08351_ _08354_ VPWR VGND sg13g2_o21ai_1
X_31917_ _08356_ \memory_i.freq_inst.dsmod_sin.data_step_r[14]\ VPWR VGND sg13g2_inv_1
X_31918_ _08357_ _08292_ _08298_ _08307_ _08311_ VPWR
+ VGND
+ sg13g2_nor4_1
X_31919_ _08358_ \memory_i.freq_inst.dsmod_sin.data_interp_r[14]\ VPWR VGND sg13g2_inv_1
X_31920_ _08359_ _08358_ _08353_ _08343_ VPWR VGND sg13g2_nand3_1
X_31921_ _08360_ \memory_i.freq_inst.dsmod_sin.data_step_r[12]\ _08358_ _08343_ VPWR VGND sg13g2_nand3b_1
X_31922_ _08361_ _08327_ VPWR VGND sg13g2_inv_1
X_31923_ _08362_ _08291_ _08357_ _08359_ _08360_ _08361_
+ VPWR
+ VGND sg13g2_a221oi_1
X_31924_ _08363_ \memory_i.freq_inst.dsmod_sin.data_interp_r[14]\ _08349_ VPWR VGND sg13g2_nor2_1
X_31925_ _08364_ \memory_i.freq_inst.dsmod_sin.data_interp_r[12]\ _08360_ VPWR VGND sg13g2_nor2_1
X_31926_ _08365_ _08356_ _08362_ _08363_ _08364_ VPWR
+ VGND
+ sg13g2_nor4_1
X_31927_ _08366_ _08352_ _08355_ _08365_ VPWR VGND sg13g2_or3_1
X_31928_ _08367_ _08366_ VPWR VGND sg13g2_buf_1
X_31929_ _08368_ \memory_i.freq_inst.dsmod_sin.data_step_r[15]\ \memory_i.freq_inst.dsmod_sin.data_interp_r[15]\ VPWR VGND sg13g2_xor2_1
X_31930_ _08369_ _08367_ _08368_ VPWR VGND sg13g2_xnor2_1
X_31931_ _08370_ _05724_ \memory_i.freq_inst.dsmod_sin.data_interp_r[15]\ \memory_i.freq_inst.dsmod_sin.data_pre_r[15]\ _15816_ VPWR
+ VGND
+ sg13g2_a22oi_1
X_31932_ _08371_ _08295_ _08369_ _08370_ VPWR VGND sg13g2_o21ai_1
X_31933_ _01785_ \memory_i.freq_inst.cordic.rstn_i\ _08371_ VPWR VGND sg13g2_and2_1
X_31934_ _08372_ \memory_i.freq_inst.dsmod_sin.data_step_r[16]\ \memory_i.freq_inst.dsmod_sin.data_interp_r[16]\ VPWR VGND sg13g2_nand2_1
X_31935_ _08373_ _08372_ VPWR VGND sg13g2_inv_1
X_31936_ _08374_ \memory_i.freq_inst.dsmod_sin.data_step_r[16]\ \memory_i.freq_inst.dsmod_sin.data_interp_r[16]\ VPWR VGND sg13g2_nor2_1
X_31937_ _08375_ _08373_ _08374_ VPWR VGND sg13g2_or2_1
X_31938_ _08376_ \memory_i.freq_inst.dsmod_sin.data_interp_r[15]\ _08367_ \memory_i.freq_inst.dsmod_sin.data_step_r[15]\ VPWR VGND sg13g2_a21o_1
X_31939_ _08377_ \memory_i.freq_inst.dsmod_sin.data_interp_r[15]\ _08367_ _08376_ VPWR VGND sg13g2_o21ai_1
X_31940_ _08378_ _08375_ _08377_ VPWR VGND sg13g2_xor2_1
X_31941_ _08379_ _08310_ _08378_ VPWR VGND sg13g2_nand2_1
X_31942_ _08380_ _05783_ VPWR VGND sg13g2_buf_1
X_31943_ _08381_ _15816_ VPWR VGND sg13g2_buf_1
X_31944_ _08382_ _08380_ \memory_i.freq_inst.dsmod_sin.data_interp_r[16]\ \memory_i.freq_inst.dsmod_sin.data_pre_r[16]\ _08381_ VPWR
+ VGND
+ sg13g2_a22oi_1
X_31945_ _01786_ _08379_ _08382_ _08341_ VPWR VGND sg13g2_a21oi_1
X_31946_ _08383_ \memory_i.freq_inst.dsmod_sin.data_interp_r[15]\ _08352_ _08355_ _08373_ VPWR
+ VGND
+ sg13g2_or4_1
X_31947_ _08384_ \memory_i.freq_inst.dsmod_sin.data_step_r[15]\ _08352_ _08355_ _08373_ VPWR
+ VGND
+ sg13g2_or4_1
X_31948_ _08385_ _08383_ _08384_ _08365_ VPWR VGND sg13g2_a21o_1
X_31949_ _08386_ _08385_ VPWR VGND sg13g2_buf_1
X_31950_ _08387_ \memory_i.freq_inst.dsmod_sin.data_step_r[15]\ \memory_i.freq_inst.dsmod_sin.data_interp_r[15]\ VPWR VGND sg13g2_nor2_1
X_31951_ _08388_ _08387_ _08372_ _08374_ VPWR VGND sg13g2_a21oi_1
X_31952_ _08389_ _08386_ _08388_ VPWR VGND sg13g2_nand2_1
X_31953_ _08390_ \memory_i.freq_inst.dsmod_sin.data_step_r[17]\ \memory_i.freq_inst.dsmod_sin.data_interp_r[17]\ VPWR VGND sg13g2_xor2_1
X_31954_ _08391_ _08389_ _08390_ VPWR VGND sg13g2_xnor2_1
X_31955_ _08392_ _08310_ _08391_ VPWR VGND sg13g2_nand2_1
X_31956_ _08393_ _08380_ \memory_i.freq_inst.dsmod_sin.data_interp_r[17]\ \memory_i.freq_inst.dsmod_sin.data_pre_r[17]\ _08381_ VPWR
+ VGND
+ sg13g2_a22oi_1
X_31957_ _01787_ _08392_ _08393_ _08341_ VPWR VGND sg13g2_a21oi_1
X_31958_ _08394_ \memory_i.freq_inst.dsmod_sin.data_interp_r[17]\ VPWR VGND sg13g2_inv_1
X_31959_ _08395_ _08394_ _08389_ VPWR VGND sg13g2_nand2_1
X_31960_ _08396_ \memory_i.freq_inst.dsmod_sin.data_step_r[17]\ _08395_ VPWR VGND sg13g2_nand2_1
X_31961_ _08397_ _08394_ _08389_ _08396_ VPWR VGND sg13g2_o21ai_1
X_31962_ _08398_ \memory_i.freq_inst.dsmod_sin.data_step_r[18]\ \memory_i.freq_inst.dsmod_sin.data_interp_r[18]\ VPWR VGND sg13g2_xnor2_1
X_31963_ _08399_ _08397_ _08398_ VPWR VGND sg13g2_xnor2_1
X_31964_ _08400_ _08310_ _08399_ VPWR VGND sg13g2_nand2_1
X_31965_ _08401_ _08380_ \memory_i.freq_inst.dsmod_sin.data_interp_r[18]\ \memory_i.freq_inst.dsmod_sin.data_pre_r[18]\ _08381_ VPWR
+ VGND
+ sg13g2_a22oi_1
X_31966_ _01788_ _08400_ _08401_ _08341_ VPWR VGND sg13g2_a21oi_1
X_31967_ _08402_ \memory_i.freq_inst.dsmod_sin.data_step_r[19]\ \memory_i.freq_inst.dsmod_sin.data_interp_r[19]\ VPWR VGND sg13g2_and2_1
X_31968_ _08403_ _08402_ VPWR VGND sg13g2_buf_1
X_31969_ _08404_ \memory_i.freq_inst.dsmod_sin.data_step_r[19]\ \memory_i.freq_inst.dsmod_sin.data_interp_r[19]\ VPWR VGND sg13g2_nor2_1
X_31970_ _08405_ _08403_ _08404_ VPWR VGND sg13g2_nor2_1
X_31971_ _08406_ \memory_i.freq_inst.dsmod_sin.data_step_r[18]\ \memory_i.freq_inst.dsmod_sin.data_interp_r[18]\ VPWR VGND sg13g2_and2_1
X_31972_ _08407_ \memory_i.freq_inst.dsmod_sin.data_step_r[18]\ \memory_i.freq_inst.dsmod_sin.data_interp_r[18]\ VPWR VGND sg13g2_or2_1
X_31973_ _08408_ _08397_ _08406_ _08407_ VPWR VGND sg13g2_o21ai_1
X_31974_ _08409_ _08405_ _08408_ VPWR VGND sg13g2_xnor2_1
X_31975_ _08410_ _08310_ _08409_ VPWR VGND sg13g2_nand2_1
X_31976_ _08411_ _08380_ \memory_i.freq_inst.dsmod_sin.data_interp_r[19]\ \memory_i.freq_inst.dsmod_sin.data_pre_r[19]\ _08381_ VPWR
+ VGND
+ sg13g2_a22oi_1
X_31977_ _01789_ _08410_ _08411_ _08341_ VPWR VGND sg13g2_a21oi_1
X_31978_ _08412_ \memory_i.freq_inst.dsmod_sin.data_interp_r[18]\ \memory_i.freq_inst.dsmod_sin.data_interp_r[17]\ _08403_ VPWR VGND sg13g2_or3_1
X_31979_ _08413_ \memory_i.freq_inst.dsmod_sin.data_step_r[18]\ \memory_i.freq_inst.dsmod_sin.data_interp_r[17]\ _08403_ VPWR VGND sg13g2_or3_1
X_31980_ _08414_ _08386_ _08388_ _08412_ _08413_ VPWR
+ VGND
+ sg13g2_a22oi_1
X_31981_ _08415_ _08414_ VPWR VGND sg13g2_buf_1
X_31982_ _08416_ \memory_i.freq_inst.dsmod_sin.data_step_r[17]\ \memory_i.freq_inst.dsmod_sin.data_interp_r[18]\ _08403_ VPWR VGND sg13g2_or3_1
X_31983_ _08417_ \memory_i.freq_inst.dsmod_sin.data_step_r[18]\ \memory_i.freq_inst.dsmod_sin.data_step_r[17]\ _08403_ VPWR VGND sg13g2_or3_1
X_31984_ _08418_ _08386_ _08388_ _08416_ _08417_ VPWR
+ VGND
+ sg13g2_a22oi_1
X_31985_ _08419_ _08418_ VPWR VGND sg13g2_buf_1
X_31986_ _08420_ _08416_ _08417_ \memory_i.freq_inst.dsmod_sin.data_interp_r[17]\ VPWR VGND sg13g2_a21o_1
X_31987_ _08421_ _08403_ _08407_ _08420_ VPWR VGND sg13g2_o21ai_1
X_31988_ _08422_ _08421_ VPWR VGND sg13g2_buf_1
X_31989_ _08423_ _08404_ _08415_ _08419_ _08422_ VPWR
+ VGND
+ sg13g2_nor4_1
X_31990_ _08424_ \memory_i.freq_inst.dsmod_sin.data_step_r[20]\ \memory_i.freq_inst.dsmod_sin.data_interp_r[20]\ VPWR VGND sg13g2_xor2_1
X_31991_ _08425_ _08423_ _08424_ VPWR VGND sg13g2_xnor2_1
X_31992_ _08426_ _05724_ \memory_i.freq_inst.dsmod_sin.data_interp_r[20]\ \memory_i.freq_inst.dsmod_sin.data_pre_r[20]\ _15816_ VPWR
+ VGND
+ sg13g2_a22oi_1
X_31993_ _08427_ _08295_ _08425_ _08426_ VPWR VGND sg13g2_o21ai_1
X_31994_ _01790_ \memory_i.freq_inst.cordic.rstn_i\ _08427_ VPWR VGND sg13g2_and2_1
X_31995_ _08428_ \memory_i.freq_inst.dsmod_sin.data_step_r[19]\ \memory_i.freq_inst.dsmod_sin.data_interp_r[19]\ \memory_i.freq_inst.dsmod_sin.data_interp_r[20]\ VPWR VGND sg13g2_o21ai_1
X_31996_ _08429_ _08415_ _08419_ _08422_ _08428_ VPWR
+ VGND
+ sg13g2_nor4_1
X_31997_ _08430_ \memory_i.freq_inst.dsmod_sin.data_step_r[19]\ \memory_i.freq_inst.dsmod_sin.data_interp_r[19]\ \memory_i.freq_inst.dsmod_sin.data_step_r[20]\ VPWR VGND sg13g2_o21ai_1
X_31998_ _08431_ _08415_ _08419_ _08422_ _08430_ VPWR
+ VGND
+ sg13g2_nor4_1
X_31999_ _08432_ \memory_i.freq_inst.dsmod_sin.data_step_r[20]\ \memory_i.freq_inst.dsmod_sin.data_interp_r[20]\ VPWR VGND sg13g2_and2_1
X_32000_ _08433_ _08432_ VPWR VGND sg13g2_buf_1
X_32001_ _08434_ _08429_ _08431_ _08433_ VPWR VGND sg13g2_nor3_1
X_32002_ _08435_ \memory_i.freq_inst.dsmod_sin.data_step_r[21]\ \memory_i.freq_inst.dsmod_sin.data_interp_r[21]\ VPWR VGND sg13g2_xor2_1
X_32003_ _08436_ _08434_ _08435_ VPWR VGND sg13g2_xnor2_1
X_32004_ _08437_ _08310_ _08436_ VPWR VGND sg13g2_nand2_1
X_32005_ _08438_ _08380_ \memory_i.freq_inst.dsmod_sin.data_interp_r[21]\ \memory_i.freq_inst.dsmod_sin.data_pre_r[21]\ _08381_ VPWR
+ VGND
+ sg13g2_a22oi_1
X_32006_ _01791_ _08437_ _08438_ _08341_ VPWR VGND sg13g2_a21oi_1
X_32007_ _08439_ \memory_i.freq_inst.dsmod_sin.data_step_r[22]\ \memory_i.freq_inst.dsmod_sin.data_interp_r[22]\ VPWR VGND sg13g2_nand2_1
X_32008_ _08440_ \memory_i.freq_inst.dsmod_sin.data_step_r[22]\ \memory_i.freq_inst.dsmod_sin.data_interp_r[22]\ VPWR VGND sg13g2_or2_1
X_32009_ _08441_ _08439_ _08440_ VPWR VGND sg13g2_nand2_1
X_32010_ _08442_ \memory_i.freq_inst.dsmod_sin.data_step_r[21]\ \memory_i.freq_inst.dsmod_sin.data_interp_r[21]\ VPWR VGND sg13g2_nand2_1
X_32011_ _08443_ \memory_i.freq_inst.dsmod_sin.data_step_r[21]\ \memory_i.freq_inst.dsmod_sin.data_interp_r[21]\ VPWR VGND sg13g2_nor2_1
X_32012_ _08444_ _08434_ _08442_ _08443_ VPWR VGND sg13g2_a21oi_1
X_32013_ _08445_ _08441_ _08444_ VPWR VGND sg13g2_xnor2_1
X_32014_ _08446_ _08310_ _08445_ VPWR VGND sg13g2_nand2_1
X_32015_ _08447_ _08380_ \memory_i.freq_inst.dsmod_sin.data_interp_r[22]\ \memory_i.freq_inst.dsmod_sin.data_pre_r[22]\ _08381_ VPWR
+ VGND
+ sg13g2_a22oi_1
X_32016_ _01792_ _08446_ _08447_ _08341_ VPWR VGND sg13g2_a21oi_1
X_32017_ _08448_ _08241_ VPWR VGND sg13g2_buf_1
X_32018_ _08449_ \memory_i.freq_inst.dsmod_sin.data_interp_r[21]\ _08439_ VPWR VGND sg13g2_nand2b_1
X_32019_ _08450_ _08429_ _08431_ _08433_ _08449_ VPWR
+ VGND
+ sg13g2_nor4_1
X_32020_ _08451_ \memory_i.freq_inst.dsmod_sin.data_step_r[21]\ _08439_ VPWR VGND sg13g2_nand2b_1
X_32021_ _08452_ _08429_ _08431_ _08433_ _08451_ VPWR
+ VGND
+ sg13g2_nor4_1
X_32022_ _08453_ _08439_ _08443_ VPWR VGND sg13g2_nand2_1
X_32023_ _08454_ _08440_ _08453_ VPWR VGND sg13g2_nand2_1
X_32024_ _08455_ _08450_ _08452_ _08454_ VPWR VGND sg13g2_nor3_1
X_32025_ _08456_ \memory_i.freq_inst.dsmod_sin.data_step_r[23]\ \memory_i.freq_inst.dsmod_sin.data_interp_r[23]\ VPWR VGND sg13g2_xnor2_1
X_32026_ _08457_ _08455_ _08456_ VPWR VGND sg13g2_xnor2_1
X_32027_ _08458_ _08448_ _08457_ VPWR VGND sg13g2_nand2_1
X_32028_ _08459_ _08380_ \memory_i.freq_inst.dsmod_sin.data_interp_r[23]\ \memory_i.freq_inst.dsmod_sin.data_pre_r[23]\ _08381_ VPWR
+ VGND
+ sg13g2_a22oi_1
X_32029_ _01793_ _08458_ _08459_ _08341_ VPWR VGND sg13g2_a21oi_1
X_32030_ _08460_ \memory_i.freq_inst.dsmod_sin.data_step_r[24]\ \memory_i.freq_inst.dsmod_sin.data_interp_r[24]\ VPWR VGND sg13g2_xor2_1
X_32031_ _08461_ \memory_i.freq_inst.dsmod_sin.data_step_r[23]\ \memory_i.freq_inst.dsmod_sin.data_interp_r[23]\ VPWR VGND sg13g2_and2_1
X_32032_ _08462_ \memory_i.freq_inst.dsmod_sin.data_step_r[23]\ \memory_i.freq_inst.dsmod_sin.data_interp_r[23]\ VPWR VGND sg13g2_or2_1
X_32033_ _08463_ _08455_ _08461_ _08462_ VPWR VGND sg13g2_o21ai_1
X_32034_ _08464_ _08460_ _08463_ VPWR VGND sg13g2_xnor2_1
X_32035_ _08465_ _08448_ _08464_ VPWR VGND sg13g2_nand2_1
X_32036_ _08466_ _08380_ \memory_i.freq_inst.dsmod_sin.data_interp_r[24]\ \memory_i.freq_inst.dsmod_sin.data_pre_r[24]\ _08381_ VPWR
+ VGND
+ sg13g2_a22oi_1
X_32037_ _01794_ _08465_ _08466_ _08341_ VPWR VGND sg13g2_a21oi_1
X_32038_ _08467_ \memory_i.freq_inst.dsmod_sin.data_interp_r[24]\ VPWR VGND sg13g2_inv_1
X_32039_ _08468_ \memory_i.freq_inst.dsmod_sin.data_interp_r[24]\ \memory_i.freq_inst.dsmod_sin.data_interp_r[23]\ VPWR VGND sg13g2_and2_1
X_32040_ _08469_ \memory_i.freq_inst.dsmod_sin.data_step_r[23]\ \memory_i.freq_inst.dsmod_sin.data_interp_r[24]\ VPWR VGND sg13g2_and2_1
X_32041_ _08470_ _08468_ _08469_ _08455_ VPWR VGND sg13g2_o21ai_1
X_32042_ _08471_ \memory_i.freq_inst.dsmod_sin.data_interp_r[23]\ _08469_ \memory_i.freq_inst.dsmod_sin.data_step_r[24]\ VPWR VGND sg13g2_a21oi_1
X_32043_ _08472_ _08467_ _08463_ _08470_ _08471_ VPWR
+ VGND
+ sg13g2_a22oi_1
X_32044_ _08473_ \memory_i.freq_inst.dsmod_sin.data_step_r[25]\ \memory_i.freq_inst.dsmod_sin.data_interp_r[25]\ VPWR VGND sg13g2_xnor2_1
X_32045_ _08474_ _08472_ _08473_ VPWR VGND sg13g2_xnor2_1
X_32046_ _08475_ _08448_ _08474_ VPWR VGND sg13g2_nand2_1
X_32047_ _08476_ _08380_ \memory_i.freq_inst.dsmod_sin.data_interp_r[25]\ \memory_i.freq_inst.dsmod_sin.data_pre_r[25]\ _08381_ VPWR
+ VGND
+ sg13g2_a22oi_1
X_32048_ _08477_ _06006_ VPWR VGND sg13g2_buf_1
X_32049_ _01795_ _08475_ _08476_ _08477_ VPWR VGND sg13g2_a21oi_1
X_32050_ _08478_ \memory_i.freq_inst.dsmod_sin.data_interp_r[25]\ VPWR VGND sg13g2_inv_1
X_32051_ _08479_ \memory_i.freq_inst.dsmod_sin.data_step_r[24]\ \memory_i.freq_inst.dsmod_sin.data_interp_r[24]\ \memory_i.freq_inst.dsmod_sin.data_interp_r[23]\ \memory_i.freq_inst.dsmod_sin.data_step_r[23]\ _08455_
+ VPWR
+ VGND sg13g2_a221oi_1
X_32052_ _08480_ \memory_i.freq_inst.dsmod_sin.data_step_r[24]\ \memory_i.freq_inst.dsmod_sin.data_interp_r[24]\ VPWR VGND sg13g2_nand2_1
X_32053_ _08481_ \memory_i.freq_inst.dsmod_sin.data_step_r[23]\ \memory_i.freq_inst.dsmod_sin.data_interp_r[23]\ VPWR VGND sg13g2_nor2_1
X_32054_ _08482_ \memory_i.freq_inst.dsmod_sin.data_step_r[24]\ \memory_i.freq_inst.dsmod_sin.data_interp_r[24]\ VPWR VGND sg13g2_nor2_1
X_32055_ _08483_ _08480_ _08481_ _08482_ VPWR VGND sg13g2_a21oi_1
X_32056_ _08484_ \memory_i.freq_inst.dsmod_sin.data_interp_r[25]\ _08483_ \memory_i.freq_inst.dsmod_sin.data_step_r[25]\ VPWR VGND sg13g2_o21ai_1
X_32057_ _08485_ _08478_ _08479_ _08484_ VPWR VGND sg13g2_a21oi_1
X_32058_ _08486_ \memory_i.freq_inst.dsmod_sin.data_interp_r[25]\ _08472_ _08485_ VPWR VGND sg13g2_a21oi_1
X_32059_ _08487_ \memory_i.freq_inst.dsmod_sin.data_step_r[26]\ \memory_i.freq_inst.dsmod_sin.data_interp_r[26]\ VPWR VGND sg13g2_xor2_1
X_32060_ _08488_ _08486_ _08487_ VPWR VGND sg13g2_xnor2_1
X_32061_ _08489_ _08448_ _08488_ VPWR VGND sg13g2_nand2_1
X_32062_ _08490_ _08380_ \memory_i.freq_inst.dsmod_sin.data_interp_r[26]\ \memory_i.freq_inst.dsmod_sin.data_pre_r[26]\ _08381_ VPWR
+ VGND
+ sg13g2_a22oi_1
X_32063_ _01796_ _08489_ _08490_ _08477_ VPWR VGND sg13g2_a21oi_1
X_32064_ _08491_ \memory_i.freq_inst.dsmod_sin.data_step_r[27]\ \memory_i.freq_inst.dsmod_sin.data_interp_r[27]\ VPWR VGND sg13g2_xor2_1
X_32065_ _08492_ \memory_i.freq_inst.dsmod_sin.data_step_r[26]\ \memory_i.freq_inst.dsmod_sin.data_interp_r[26]\ VPWR VGND sg13g2_nand2_1
X_32066_ _08493_ \memory_i.freq_inst.dsmod_sin.data_step_r[26]\ \memory_i.freq_inst.dsmod_sin.data_interp_r[26]\ VPWR VGND sg13g2_nor2_1
X_32067_ _08494_ _08486_ _08492_ _08493_ VPWR VGND sg13g2_a21o_1
X_32068_ _08495_ _08491_ _08494_ VPWR VGND sg13g2_xnor2_1
X_32069_ _08496_ _08448_ _08495_ VPWR VGND sg13g2_nand2_1
X_32070_ _08497_ _05705_ \memory_i.freq_inst.dsmod_sin.data_interp_r[27]\ \memory_i.freq_inst.dsmod_sin.data_pre_r[27]\ _08233_ VPWR
+ VGND
+ sg13g2_a22oi_1
X_32071_ _01797_ _08496_ _08497_ _08477_ VPWR VGND sg13g2_a21oi_1
X_32072_ _08498_ _05738_ \memory_i.freq_inst.dsmod_sin.data_interp_r[28]\ \memory_i.freq_inst.dsmod_sin.data_pre_r[28]\ _08287_ VPWR
+ VGND
+ sg13g2_a22oi_1
X_32073_ _08499_ \memory_i.freq_inst.dsmod_sin.data_step_r[27]\ \memory_i.freq_inst.dsmod_sin.data_interp_r[27]\ VPWR VGND sg13g2_nand2_1
X_32074_ _08500_ \memory_i.freq_inst.dsmod_sin.data_step_r[27]\ \memory_i.freq_inst.dsmod_sin.data_interp_r[27]\ VPWR VGND sg13g2_nor2_1
X_32075_ _08501_ _08499_ _08494_ _08500_ VPWR VGND sg13g2_a21oi_1
X_32076_ _08502_ \memory_i.freq_inst.dsmod_sin.data_step_r[28]\ \memory_i.freq_inst.dsmod_sin.data_interp_r[28]\ VPWR VGND sg13g2_xnor2_1
X_32077_ _08503_ _08501_ _08502_ VPWR VGND sg13g2_xnor2_1
X_32078_ _08504_ _08242_ _08503_ VPWR VGND sg13g2_nand2_1
X_32079_ _01798_ _08498_ _08504_ _08477_ VPWR VGND sg13g2_a21oi_1
X_32080_ _08505_ \memory_i.freq_inst.dsmod_sin.data_step_r[29]\ \memory_i.freq_inst.dsmod_sin.data_interp_r[29]\ VPWR VGND sg13g2_xor2_1
X_32081_ _08506_ \memory_i.freq_inst.dsmod_sin.data_interp_r[28]\ _08501_ \memory_i.freq_inst.dsmod_sin.data_step_r[28]\ VPWR VGND sg13g2_a21o_1
X_32082_ _08507_ \memory_i.freq_inst.dsmod_sin.data_interp_r[28]\ _08501_ _08506_ VPWR VGND sg13g2_o21ai_1
X_32083_ _08508_ _08505_ _08507_ VPWR VGND sg13g2_xnor2_1
X_32084_ _08509_ _08448_ _08508_ VPWR VGND sg13g2_nand2_1
X_32085_ _08510_ _05705_ \memory_i.freq_inst.dsmod_sin.data_interp_r[29]\ \memory_i.freq_inst.dsmod_sin.data_pre_r[29]\ _08233_ VPWR
+ VGND
+ sg13g2_a22oi_1
X_32086_ _01799_ _08509_ _08510_ _08477_ VPWR VGND sg13g2_a21oi_1
X_32087_ _08511_ \memory_i.freq_inst.dsmod_sin.data_step_r[30]\ \memory_i.freq_inst.dsmod_sin.data_interp_r[30]\ VPWR VGND sg13g2_xor2_1
X_32088_ _08512_ \memory_i.freq_inst.dsmod_sin.data_step_r[29]\ \memory_i.freq_inst.dsmod_sin.data_interp_r[29]\ VPWR VGND sg13g2_nand2_1
X_32089_ _08513_ \memory_i.freq_inst.dsmod_sin.data_step_r[29]\ \memory_i.freq_inst.dsmod_sin.data_interp_r[29]\ VPWR VGND sg13g2_nor2_1
X_32090_ _08514_ _08507_ _08512_ _08513_ VPWR VGND sg13g2_a21oi_1
X_32091_ _08515_ _08511_ _08514_ VPWR VGND sg13g2_xor2_1
X_32092_ _08516_ \memory_i.freq_inst.dsmod_sin.data_pre_r[30]\ _15816_ VPWR VGND sg13g2_and2_1
X_32093_ _08517_ _12940_ \memory_i.freq_inst.dsmod_sin.data_interp_r[30]\ _08241_ _08515_ _08516_
+ VPWR
+ VGND sg13g2_a221oi_1
X_32094_ _01800_ _08237_ _08517_ VPWR VGND sg13g2_nor2_1
X_32095_ _08518_ _05738_ \memory_i.freq_inst.dsmod_sin.data_interp_r[31]\ \memory_i.freq_inst.dsmod_sin.data_pre_r[31]\ _08287_ VPWR
+ VGND
+ sg13g2_a22oi_1
X_32096_ _08519_ \memory_i.freq_inst.dsmod_sin.data_step_r[30]\ _08507_ _08512_ VPWR VGND sg13g2_nand3b_1
X_32097_ _08520_ \memory_i.freq_inst.dsmod_sin.data_step_r[30]\ \memory_i.freq_inst.dsmod_sin.data_step_r[29]\ \memory_i.freq_inst.dsmod_sin.data_interp_r[29]\ VPWR VGND sg13g2_nor3_1
X_32098_ _08521_ _08520_ \memory_i.freq_inst.dsmod_sin.data_interp_r[30]\ VPWR VGND sg13g2_nor2b_1
X_32099_ _08522_ \memory_i.freq_inst.dsmod_sin.data_step_r[30]\ _08514_ _08519_ _08521_ VPWR
+ VGND
+ sg13g2_a22oi_1
X_32100_ _08523_ \memory_i.freq_inst.dsmod_sin.data_step_r[31]\ \memory_i.freq_inst.dsmod_sin.data_interp_r[31]\ VPWR VGND sg13g2_xnor2_1
X_32101_ _08524_ _08522_ _08523_ VPWR VGND sg13g2_xor2_1
X_32102_ _08525_ _08242_ _08524_ VPWR VGND sg13g2_nand2_1
X_32103_ _01801_ _08518_ _08525_ _08477_ VPWR VGND sg13g2_a21oi_1
X_32104_ _08526_ _08505_ _08511_ VPWR VGND sg13g2_nand2_1
X_32105_ _08527_ _08502_ _08523_ _08526_ VPWR VGND sg13g2_nor3_1
X_32106_ _08528_ \memory_i.freq_inst.dsmod_sin.data_step_r[31]\ \memory_i.freq_inst.dsmod_sin.data_interp_r[31]\ VPWR VGND sg13g2_nand2_1
X_32107_ _08529_ \memory_i.freq_inst.dsmod_sin.data_step_r[28]\ \memory_i.freq_inst.dsmod_sin.data_interp_r[29]\ \memory_i.freq_inst.dsmod_sin.data_interp_r[28]\ VPWR VGND sg13g2_nand3_1
X_32108_ _08530_ \memory_i.freq_inst.dsmod_sin.data_step_r[29]\ \memory_i.freq_inst.dsmod_sin.data_step_r[28]\ \memory_i.freq_inst.dsmod_sin.data_interp_r[28]\ VPWR VGND sg13g2_nand3_1
X_32109_ _08531_ _08512_ _08529_ _08530_ VPWR VGND sg13g2_nand3_1
X_32110_ _08532_ \memory_i.freq_inst.dsmod_sin.data_interp_r[30]\ _08531_ \memory_i.freq_inst.dsmod_sin.data_step_r[30]\ VPWR VGND sg13g2_a21o_1
X_32111_ _08533_ \memory_i.freq_inst.dsmod_sin.data_interp_r[30]\ _08531_ _08532_ VPWR VGND sg13g2_o21ai_1
X_32112_ _08534_ \memory_i.freq_inst.dsmod_sin.data_step_r[31]\ \memory_i.freq_inst.dsmod_sin.data_interp_r[31]\ VPWR VGND sg13g2_nor2_1
X_32113_ _08535_ _08528_ _08533_ _08534_ VPWR VGND sg13g2_a21oi_1
X_32114_ _08536_ _08501_ _08527_ _08535_ VPWR VGND sg13g2_a21o_1
X_32115_ _08537_ _08536_ VPWR VGND sg13g2_buf_1
X_32116_ _08538_ \memory_i.freq_inst.dsmod_sin.data_step_r[32]\ \memory_i.freq_inst.dsmod_sin.data_interp_r[32]\ VPWR VGND sg13g2_xnor2_1
X_32117_ _08539_ _08537_ _08538_ VPWR VGND sg13g2_xnor2_1
X_32118_ _08540_ _08448_ _08539_ VPWR VGND sg13g2_nand2_1
X_32119_ _08541_ _05705_ \memory_i.freq_inst.dsmod_sin.data_interp_r[32]\ \memory_i.freq_inst.dsmod_sin.data_pre_r[32]\ _08233_ VPWR
+ VGND
+ sg13g2_a22oi_1
X_32120_ _01802_ _08540_ _08541_ _08477_ VPWR VGND sg13g2_a21oi_1
X_32121_ _08542_ \memory_i.freq_inst.dsmod_sin.data_interp_r[32]\ _08537_ VPWR VGND sg13g2_nor2_1
X_32122_ _08543_ \memory_i.freq_inst.dsmod_sin.data_interp_r[32]\ _08537_ VPWR VGND sg13g2_nand2_1
X_32123_ _08544_ \memory_i.freq_inst.dsmod_sin.data_step_r[32]\ _08543_ VPWR VGND sg13g2_nor2_1
X_32124_ _08545_ \memory_i.freq_inst.dsmod_sin.data_step_r[32]\ _08542_ _08544_ VPWR VGND sg13g2_a21oi_1
X_32125_ _08546_ \memory_i.freq_inst.dsmod_sin.data_interp_r[33]\ _08545_ VPWR VGND sg13g2_xnor2_1
X_32126_ _08547_ _08448_ _08546_ VPWR VGND sg13g2_nand2_1
X_32127_ _08548_ _05705_ \memory_i.freq_inst.dsmod_sin.data_interp_r[33]\ \memory_i.freq_inst.dsmod_sin.data_pre_r[33]\ _08233_ VPWR
+ VGND
+ sg13g2_a22oi_1
X_32128_ _01803_ _08547_ _08548_ _08477_ VPWR VGND sg13g2_a21oi_1
X_32129_ _08549_ \memory_i.freq_inst.dsmod_sin.data_interp_r[33]\ VPWR VGND sg13g2_inv_1
X_32130_ _08550_ \memory_i.freq_inst.dsmod_sin.data_step_r[32]\ _08549_ _08543_ VPWR VGND sg13g2_nor3_2
X_32131_ _08551_ \memory_i.freq_inst.dsmod_sin.data_step_r[32]\ _08549_ _08542_ VPWR VGND sg13g2_and3_1
X_32132_ _08552_ _08551_ VPWR VGND sg13g2_buf_1
X_32133_ _08553_ _08550_ _08552_ VPWR VGND sg13g2_nor2_1
X_32134_ _08554_ \memory_i.freq_inst.dsmod_sin.data_interp_r[34]\ _08553_ VPWR VGND sg13g2_xnor2_1
X_32135_ _08555_ _08448_ _08554_ VPWR VGND sg13g2_nand2_1
X_32136_ _08556_ _05705_ \memory_i.freq_inst.dsmod_sin.data_interp_r[34]\ \memory_i.freq_inst.dsmod_sin.data_pre_r[34]\ _08233_ VPWR
+ VGND
+ sg13g2_a22oi_1
X_32137_ _01804_ _08555_ _08556_ _08477_ VPWR VGND sg13g2_a21oi_1
X_32138_ _08557_ \memory_i.freq_inst.dsmod_sin.data_interp_r[34]\ VPWR VGND sg13g2_inv_1
X_32139_ _08558_ _08550_ _08552_ _08557_ VPWR VGND sg13g2_mux2_1
X_32140_ _08559_ \memory_i.freq_inst.dsmod_sin.data_interp_r[35]\ _08295_ VPWR VGND sg13g2_nor2_1
X_32141_ _08560_ \memory_i.freq_inst.dsmod_sin.data_pre_r[35]\ _08233_ _08558_ _08559_ VPWR
+ VGND
+ sg13g2_a22oi_1
X_32142_ _08561_ _08295_ _08558_ \memory_i.freq_inst.dsmod_cos.i_ena_mod\ VPWR VGND sg13g2_o21ai_1
X_32143_ _08562_ \memory_i.freq_inst.dsmod_sin.data_interp_r[35]\ _08561_ VPWR VGND sg13g2_nand2_1
X_32144_ _01805_ _08560_ _08562_ _08477_ VPWR VGND sg13g2_a21oi_1
X_32145_ _08563_ \memory_i.freq_inst.dsmod_sin.data_interp_r[35]\ \memory_i.freq_inst.dsmod_sin.data_interp_r[34]\ VPWR VGND sg13g2_nor2_1
X_32146_ _08564_ \memory_i.freq_inst.dsmod_sin.data_interp_r[35]\ \memory_i.freq_inst.dsmod_sin.data_interp_r[34]\ VPWR VGND sg13g2_and2_1
X_32147_ _08565_ _08552_ _08563_ _08564_ _08550_ VPWR
+ VGND
+ sg13g2_a22oi_1
X_32148_ _08566_ _08241_ _08565_ _12939_ VPWR VGND sg13g2_a21o_1
X_32149_ _08567_ \memory_i.freq_inst.dsmod_sin.data_interp_r[36]\ _08295_ _08565_ VPWR VGND sg13g2_nor3_1
X_32150_ _08568_ \memory_i.freq_inst.dsmod_sin.data_pre_r[36]\ _08233_ _08566_ \memory_i.freq_inst.dsmod_sin.data_interp_r[36]\ _08567_
+ VPWR
+ VGND sg13g2_a221oi_1
X_32151_ _01806_ _08237_ _08568_ VPWR VGND sg13g2_nor2_1
X_32152_ _08569_ \memory_i.freq_inst.dsmod_sin.data_interp_r[36]\ \memory_i.freq_inst.dsmod_sin.data_interp_r[35]\ VPWR VGND sg13g2_or2_1
X_32153_ _08570_ \memory_i.freq_inst.dsmod_sin.data_interp_r[34]\ _08569_ VPWR VGND sg13g2_nor2_1
X_32154_ _08571_ \memory_i.freq_inst.dsmod_sin.data_interp_r[36]\ _08564_ VPWR VGND sg13g2_and2_1
X_32155_ _08572_ _08552_ _08570_ _08571_ _08550_ VPWR
+ VGND
+ sg13g2_a22oi_1
X_32156_ _08573_ \memory_i.freq_inst.dsmod_sin.data_interp_r[37]\ _08572_ VPWR VGND sg13g2_xnor2_1
X_32157_ _08574_ _08448_ _08573_ VPWR VGND sg13g2_nand2_1
X_32158_ _08575_ _05705_ \memory_i.freq_inst.dsmod_sin.data_interp_r[37]\ \memory_i.freq_inst.dsmod_sin.data_pre_r[37]\ _08233_ VPWR
+ VGND
+ sg13g2_a22oi_1
X_32159_ _08576_ _06006_ VPWR VGND sg13g2_buf_1
X_32160_ _01807_ _08574_ _08575_ _08576_ VPWR VGND sg13g2_a21oi_1
X_32161_ _08577_ _15820_ VPWR VGND sg13g2_buf_1
X_32162_ _08578_ \memory_i.freq_inst.dsmod_sin.data_step_r[0]\ _08577_ VPWR VGND sg13g2_nand2_1
X_32163_ _08579_ \memory_i.freq_inst.dsmod_sin.data_ext_w[8]\ \memory_i.freq_inst.dsmod_sin.data_pre_r[8]\ VPWR VGND sg13g2_xor2_1
X_32164_ _08580_ \memory_i.freq_inst.dsmod_cos.i_osr[1]\ \memory_i.freq_inst.dsmod_cos.i_osr[0]\ _08233_ _08579_ VPWR
+ VGND
+ sg13g2_nand4_1
X_32165_ _01808_ _08578_ _08580_ _08576_ VPWR VGND sg13g2_a21oi_1
X_32166_ _08581_ \memory_i.freq_inst.dsmod_sin.data_step_r[1]\ _08577_ VPWR VGND sg13g2_nand2_1
X_32167_ _08582_ \memory_i.freq_inst.dsmod_sin.data_ext_w[8]\ \memory_i.freq_inst.dsmod_sin.data_pre_r[8]\ VPWR VGND sg13g2_nor2b_1
X_32168_ _08583_ _08582_ VPWR VGND sg13g2_buf_1
X_32169_ _08584_ \memory_i.freq_inst.dsmod_sin.data_ext_w[9]\ \memory_i.freq_inst.dsmod_sin.data_pre_r[9]\ VPWR VGND sg13g2_xor2_1
X_32170_ _08585_ \memory_i.freq_inst.dsmod_cos.i_osr[0]\ _08584_ VPWR VGND sg13g2_nand2_1
X_32171_ _08586_ \memory_i.freq_inst.dsmod_cos.i_osr[0]\ \memory_i.freq_inst.dsmod_sin.data_pre_r[8]\ VPWR VGND sg13g2_nor2_1
X_32172_ _08587_ \memory_i.freq_inst.dsmod_sin.data_ext_w[8]\ _08586_ _08585_ _08583_ VPWR
+ VGND
+ sg13g2_a22oi_1
X_32173_ _08588_ _08583_ _08585_ _08587_ VPWR VGND sg13g2_o21ai_1
X_32174_ _08589_ \memory_i.freq_inst.dsmod_cos.i_osr[1]\ _15889_ _08588_ VPWR VGND sg13g2_nand3_1
X_32175_ _01809_ _08581_ _08589_ _08576_ VPWR VGND sg13g2_a21oi_1
X_32176_ _08590_ \memory_i.freq_inst.dsmod_sin.data_step_r[2]\ _15889_ VPWR VGND sg13g2_nor2_1
X_32177_ _08591_ \memory_i.freq_inst.dsmod_sin.data_pre_r[9]\ VPWR VGND sg13g2_inv_1
X_32178_ _08592_ \memory_i.freq_inst.dsmod_sin.data_ext_w[8]\ \memory_i.freq_inst.dsmod_sin.data_pre_r[8]\ VPWR VGND sg13g2_nand2b_1
X_32179_ _08593_ _08591_ _08592_ VPWR VGND sg13g2_nor2_1
X_32180_ _08594_ \memory_i.freq_inst.dsmod_sin.data_ext_w[10]\ \memory_i.freq_inst.dsmod_sin.data_pre_r[10]\ VPWR VGND sg13g2_xnor2_1
X_32181_ _08595_ _06020_ _08594_ VPWR VGND sg13g2_nor2_1
X_32182_ _08596_ \memory_i.freq_inst.dsmod_cos.i_osr[0]\ _08591_ VPWR VGND sg13g2_nor2_1
X_32183_ _08597_ \memory_i.freq_inst.dsmod_cos.i_osr[0]\ _08594_ _08596_ VPWR VGND sg13g2_a21oi_1
X_32184_ _08598_ \memory_i.freq_inst.dsmod_sin.data_pre_r[9]\ _08595_ VPWR VGND sg13g2_nor2_1
X_32185_ _08599_ _08583_ _08598_ VPWR VGND sg13g2_nand2_1
X_32186_ _08600_ _08583_ _08597_ _08599_ VPWR VGND sg13g2_o21ai_1
X_32187_ _08601_ _08595_ _08596_ _08583_ VPWR VGND sg13g2_o21ai_1
X_32188_ _08602_ _06086_ _08591_ _08594_ VPWR VGND sg13g2_nor3_1
X_32189_ _08603_ _08592_ _08598_ _08602_ VPWR VGND sg13g2_a21oi_1
X_32190_ _08604_ _08601_ _08603_ \memory_i.freq_inst.dsmod_sin.data_ext_w[9]\ VPWR VGND sg13g2_a21oi_1
X_32191_ _08605_ _08593_ _08595_ _08600_ \memory_i.freq_inst.dsmod_sin.data_ext_w[9]\ _08604_
+ VPWR
+ VGND sg13g2_a221oi_1
X_32192_ _08606_ _15820_ VPWR VGND sg13g2_buf_1
X_32193_ _08607_ _06036_ _08579_ _08605_ \memory_i.freq_inst.dsmod_cos.i_osr[1]\ _08606_
+ VPWR
+ VGND sg13g2_a221oi_1
X_32194_ _01810_ _07049_ _08590_ _08607_ VPWR VGND sg13g2_nor3_1
X_32195_ _08608_ \memory_i.freq_inst.dsmod_sin.data_step_r[3]\ _08577_ VPWR VGND sg13g2_nand2_1
X_32196_ _08609_ _08591_ _08592_ \memory_i.freq_inst.dsmod_sin.data_ext_w[9]\ VPWR VGND sg13g2_a21oi_1
X_32197_ _08610_ \memory_i.freq_inst.dsmod_sin.data_pre_r[10]\ _08593_ _08609_ VPWR VGND sg13g2_nor3_1
X_32198_ _08611_ _08593_ _08609_ \memory_i.freq_inst.dsmod_sin.data_pre_r[10]\ VPWR VGND sg13g2_o21ai_1
X_32199_ _08612_ _08610_ _08611_ VPWR VGND sg13g2_nor2b_1
X_32200_ _08613_ \memory_i.freq_inst.dsmod_cos.i_osr[0]\ _08612_ VPWR VGND sg13g2_nor2_1
X_32201_ _08614_ \memory_i.freq_inst.dsmod_sin.data_ext_w[11]\ \memory_i.freq_inst.dsmod_sin.data_pre_r[11]\ VPWR VGND sg13g2_xnor2_1
X_32202_ _08615_ _06030_ _08614_ VPWR VGND sg13g2_nor2_1
X_32203_ _08616_ _08614_ _08615_ _08611_ VPWR VGND sg13g2_mux2_1
X_32204_ _08617_ _08613_ _08616_ \memory_i.freq_inst.dsmod_sin.data_ext_w[10]\ VPWR VGND sg13g2_o21ai_1
X_32205_ _08618_ _08610_ _08614_ VPWR VGND sg13g2_nand2b_1
X_32206_ _08619_ \memory_i.freq_inst.dsmod_cos.i_osr[0]\ _08618_ _08613_ VPWR VGND sg13g2_a21oi_1
X_32207_ _08620_ \memory_i.freq_inst.dsmod_sin.data_ext_w[10]\ VPWR VGND sg13g2_inv_1
X_32208_ _08621_ _08610_ _08615_ _08619_ _08620_ VPWR
+ VGND
+ sg13g2_a22oi_1
X_32209_ _08622_ _08617_ _08621_ VPWR VGND sg13g2_nand2_1
X_32210_ _08623_ _08588_ _08622_ \memory_i.freq_inst.dsmod_cos.i_osr[1]\ VPWR VGND sg13g2_mux2_1
X_32211_ _08624_ _08234_ _08623_ VPWR VGND sg13g2_nand2_1
X_32212_ _01811_ _08608_ _08624_ _08576_ VPWR VGND sg13g2_a21oi_1
X_32213_ _08625_ \memory_i.freq_inst.dsmod_sin.data_step_r[4]\ _08577_ VPWR VGND sg13g2_nand2_1
X_32214_ _08626_ \memory_i.freq_inst.dsmod_sin.data_ext_w[10]\ _08610_ _08611_ VPWR VGND sg13g2_o21ai_1
X_32215_ _08627_ \memory_i.freq_inst.dsmod_sin.data_pre_r[11]\ _08626_ VPWR VGND sg13g2_nor2_2
X_32216_ _08628_ \memory_i.freq_inst.dsmod_sin.data_pre_r[11]\ _08626_ VPWR VGND sg13g2_nand2_2
X_32217_ _08629_ _08627_ _08628_ VPWR VGND sg13g2_nor2b_1
X_32218_ _08630_ \memory_i.freq_inst.dsmod_sin.data_ext_w[12]\ \memory_i.freq_inst.dsmod_sin.data_pre_r[12]\ VPWR VGND sg13g2_xor2_1
X_32219_ _08631_ \memory_i.freq_inst.dsmod_cos.i_osr[0]\ _08630_ VPWR VGND sg13g2_nand2_1
X_32220_ _08632_ _08630_ _08631_ _08628_ VPWR VGND sg13g2_mux2_1
X_32221_ _08633_ \memory_i.freq_inst.dsmod_cos.i_osr[0]\ _08629_ _08632_ VPWR VGND sg13g2_o21ai_1
X_32222_ _08634_ _06021_ _08627_ _08630_ VPWR VGND sg13g2_nor3_1
X_32223_ _08635_ _06143_ _08629_ _08634_ VPWR VGND sg13g2_a21oi_1
X_32224_ _08636_ \memory_i.freq_inst.dsmod_cos.i_osr[0]\ _08627_ _08630_ VPWR VGND sg13g2_nand3_1
X_32225_ _08637_ \memory_i.freq_inst.dsmod_sin.data_ext_w[11]\ _08635_ _08636_ VPWR VGND sg13g2_o21ai_1
X_32226_ _08638_ \memory_i.freq_inst.dsmod_sin.data_ext_w[11]\ _08633_ _08637_ VPWR VGND sg13g2_a21oi_1
X_32227_ _08639_ \memory_i.freq_inst.dsmod_cos.i_osr[1]\ _08605_ VPWR VGND sg13g2_nor2_1
X_32228_ _08640_ \memory_i.freq_inst.dsmod_cos.i_osr[1]\ _08638_ _08639_ VPWR VGND sg13g2_a21oi_1
X_32229_ _08641_ _08234_ _08640_ VPWR VGND sg13g2_nand2_1
X_32230_ _01812_ _08625_ _08641_ _08576_ VPWR VGND sg13g2_a21oi_1
X_32231_ _08642_ \memory_i.freq_inst.dsmod_sin.data_step_r[5]\ _15889_ VPWR VGND sg13g2_nor2_1
X_32232_ _08643_ \memory_i.freq_inst.dsmod_sin.data_ext_w[13]\ \memory_i.freq_inst.dsmod_sin.data_pre_r[13]\ VPWR VGND sg13g2_xnor2_1
X_32233_ _08644_ _06021_ _08643_ VPWR VGND sg13g2_nor2_1
X_32234_ _08645_ \memory_i.freq_inst.dsmod_sin.data_ext_w[11]\ _08628_ _08627_ VPWR VGND sg13g2_a21oi_1
X_32235_ _08646_ \memory_i.freq_inst.dsmod_sin.data_pre_r[12]\ _08645_ VPWR VGND sg13g2_and2_1
X_32236_ _08647_ _08646_ VPWR VGND sg13g2_buf_1
X_32237_ _08648_ \memory_i.freq_inst.dsmod_sin.data_pre_r[12]\ _08645_ VPWR VGND sg13g2_nor2_1
X_32238_ _08649_ _08647_ _08648_ _06022_ VPWR VGND sg13g2_o21ai_1
X_32239_ _08650_ \memory_i.freq_inst.dsmod_sin.data_pre_r[12]\ _08645_ _08644_ VPWR VGND sg13g2_o21ai_1
X_32240_ _08651_ _08643_ _08648_ VPWR VGND sg13g2_nand2_1
X_32241_ _08652_ _08649_ _08650_ _08651_ VPWR VGND sg13g2_nand3_1
X_32242_ _08653_ \memory_i.freq_inst.dsmod_sin.data_ext_w[12]\ VPWR VGND sg13g2_inv_1
X_32243_ _08654_ \memory_i.freq_inst.dsmod_cos.i_osr[0]\ _08648_ VPWR VGND sg13g2_nor2_1
X_32244_ _08655_ \memory_i.freq_inst.dsmod_cos.i_osr[0]\ _08643_ _08654_ VPWR VGND sg13g2_a21oi_1
X_32245_ _08656_ _08653_ _08647_ _08655_ VPWR VGND sg13g2_nor3_1
X_32246_ _08657_ _08644_ _08647_ _08652_ _08653_ _08656_
+ VPWR
+ VGND sg13g2_a221oi_1
X_32247_ _08658_ _08622_ _08657_ \memory_i.freq_inst.dsmod_cos.i_osr[1]\ VPWR VGND sg13g2_mux2_1
X_32248_ _08659_ _15883_ _08658_ VPWR VGND sg13g2_nor2_1
X_32249_ _01813_ _03328_ _08642_ _08659_ VPWR VGND sg13g2_nor3_1
X_32250_ _08660_ _15820_ VPWR VGND sg13g2_buf_1
X_32251_ _08661_ \memory_i.freq_inst.dsmod_sin.data_ext_w[14]\ \memory_i.freq_inst.dsmod_sin.data_pre_r[14]\ VPWR VGND sg13g2_xnor2_1
X_32252_ _08662_ _06021_ _08661_ VPWR VGND sg13g2_nor2_1
X_32253_ _08663_ \memory_i.freq_inst.dsmod_sin.data_pre_r[12]\ VPWR VGND sg13g2_inv_1
X_32254_ _08664_ \memory_i.freq_inst.dsmod_sin.data_ext_w[12]\ _08663_ VPWR VGND sg13g2_nor2_1
X_32255_ _08665_ \memory_i.freq_inst.dsmod_sin.data_ext_w[12]\ _08663_ _08628_ \memory_i.freq_inst.dsmod_sin.data_ext_w[11]\ _08627_
+ VPWR
+ VGND sg13g2_a221oi_1
X_32256_ _08666_ _08664_ _08665_ \memory_i.freq_inst.dsmod_sin.data_pre_r[13]\ VPWR VGND sg13g2_o21ai_1
X_32257_ _08667_ _08666_ VPWR VGND sg13g2_buf_2
X_32258_ _08668_ _08661_ _08662_ _08667_ VPWR VGND sg13g2_mux2_1
X_32259_ _08669_ \memory_i.freq_inst.dsmod_sin.data_pre_r[13]\ _08664_ _08665_ VPWR VGND sg13g2_or3_1
X_32260_ _08670_ _08669_ VPWR VGND sg13g2_buf_1
X_32261_ _08671_ _08667_ _08670_ \memory_i.freq_inst.dsmod_cos.i_osr[0]\ VPWR VGND sg13g2_a21oi_1
X_32262_ _08672_ _08668_ _08671_ \memory_i.freq_inst.dsmod_sin.data_ext_w[13]\ VPWR VGND sg13g2_o21ai_1
X_32263_ _08673_ \memory_i.freq_inst.dsmod_cos.i_osr[0]\ _08661_ VPWR VGND sg13g2_and2_1
X_32264_ _08674_ _06143_ _08667_ _08673_ VPWR VGND sg13g2_a21oi_1
X_32265_ _08675_ \memory_i.freq_inst.dsmod_sin.data_ext_w[13]\ _08674_ _08670_ VPWR VGND sg13g2_o21ai_1
X_32266_ _08676_ _08662_ _08670_ _08675_ VPWR VGND sg13g2_o21ai_1
X_32267_ _08677_ _08672_ _08676_ VPWR VGND sg13g2_nand2_1
X_32268_ _08678_ \memory_i.freq_inst.dsmod_cos.i_osr[1]\ _08638_ VPWR VGND sg13g2_nor2_1
X_32269_ _08679_ \memory_i.freq_inst.dsmod_cos.i_osr[1]\ _08677_ _08678_ VPWR VGND sg13g2_a21oi_1
X_32270_ _08680_ _08660_ _08679_ VPWR VGND sg13g2_nor2_1
X_32271_ _08681_ \memory_i.freq_inst.dsmod_sin.data_step_r[6]\ _15883_ _08680_ VPWR VGND sg13g2_a21oi_1
X_32272_ _01814_ _08237_ _08681_ VPWR VGND sg13g2_nor2_1
X_32273_ _08682_ \memory_i.freq_inst.dsmod_sin.data_step_r[7]\ _08577_ VPWR VGND sg13g2_nand2_1
X_32274_ _08683_ \memory_i.freq_inst.dsmod_sin.data_ext_w[15]\ \memory_i.freq_inst.dsmod_sin.data_pre_r[15]\ VPWR VGND sg13g2_xnor2_1
X_32275_ _08684_ _06021_ _08683_ VPWR VGND sg13g2_nor2_1
X_32276_ _08685_ \memory_i.freq_inst.dsmod_sin.data_pre_r[13]\ _08664_ _08665_ VPWR VGND sg13g2_nor3_1
X_32277_ _08686_ \memory_i.freq_inst.dsmod_sin.data_ext_w[13]\ _08685_ _08667_ VPWR VGND sg13g2_o21ai_1
X_32278_ _08687_ _08686_ VPWR VGND sg13g2_buf_2
X_32279_ _08688_ \memory_i.freq_inst.dsmod_sin.data_pre_r[14]\ _08687_ VPWR VGND sg13g2_nand2_1
X_32280_ _08689_ _08683_ _08684_ _08688_ VPWR VGND sg13g2_mux2_1
X_32281_ _08690_ \memory_i.freq_inst.dsmod_sin.data_pre_r[14]\ _08687_ VPWR VGND sg13g2_or2_1
X_32282_ _08691_ _08690_ VPWR VGND sg13g2_buf_1
X_32283_ _08692_ _08688_ _08691_ \memory_i.freq_inst.dsmod_cos.i_osr[0]\ VPWR VGND sg13g2_a21oi_1
X_32284_ _08693_ _08689_ _08692_ \memory_i.freq_inst.dsmod_sin.data_ext_w[14]\ VPWR VGND sg13g2_o21ai_1
X_32285_ _08694_ \memory_i.freq_inst.dsmod_cos.i_osr[0]\ _08683_ VPWR VGND sg13g2_and2_1
X_32286_ _08695_ _06086_ _08688_ _08694_ VPWR VGND sg13g2_a21oi_1
X_32287_ _08696_ \memory_i.freq_inst.dsmod_sin.data_ext_w[14]\ _08695_ _08691_ VPWR VGND sg13g2_o21ai_1
X_32288_ _08697_ _08684_ _08691_ _08696_ VPWR VGND sg13g2_o21ai_1
X_32289_ _08698_ _08693_ _08697_ VPWR VGND sg13g2_and2_1
X_32290_ _08699_ \memory_i.freq_inst.dsmod_cos.i_osr[1]\ _08657_ VPWR VGND sg13g2_nor2_1
X_32291_ _08700_ \memory_i.freq_inst.dsmod_cos.i_osr[1]\ _08698_ _08699_ VPWR VGND sg13g2_a21oi_1
X_32292_ _08701_ _08234_ _08700_ VPWR VGND sg13g2_nand2_1
X_32293_ _01815_ _08682_ _08701_ _08576_ VPWR VGND sg13g2_a21oi_1
X_32294_ _08702_ \memory_i.freq_inst.dsmod_sin.data_step_r[8]\ _08577_ VPWR VGND sg13g2_nand2_1
X_32295_ _08703_ \memory_i.freq_inst.dsmod_sin.data_ext_w[16]\ \memory_i.freq_inst.dsmod_sin.data_pre_r[16]\ VPWR VGND sg13g2_xnor2_1
X_32296_ _08704_ \memory_i.freq_inst.dsmod_sin.data_pre_r[15]\ VPWR VGND sg13g2_inv_1
X_32297_ _08705_ \memory_i.freq_inst.dsmod_sin.data_pre_r[14]\ \memory_i.freq_inst.dsmod_sin.data_ext_w[14]\ VPWR VGND sg13g2_nand2b_1
X_32298_ _08706_ \memory_i.freq_inst.dsmod_sin.data_ext_w[14]\ \memory_i.freq_inst.dsmod_sin.data_pre_r[14]\ VPWR VGND sg13g2_nor2b_1
X_32299_ _08707_ _08705_ _08687_ _08706_ VPWR VGND sg13g2_a21oi_2
X_32300_ _08708_ _08704_ _08707_ VPWR VGND sg13g2_nor2_2
X_32301_ _08709_ _08703_ _08708_ VPWR VGND sg13g2_nand2_1
X_32302_ _08710_ _06143_ _08703_ VPWR VGND sg13g2_nor2_1
X_32303_ _08711_ _08704_ _08707_ _08710_ VPWR VGND sg13g2_o21ai_1
X_32304_ _08712_ _08704_ _08707_ VPWR VGND sg13g2_and2_1
X_32305_ _08713_ _08708_ _08712_ _06361_ VPWR VGND sg13g2_o21ai_1
X_32306_ _08714_ _08709_ _08711_ _08713_ VPWR VGND sg13g2_nand3_1
X_32307_ _08715_ \memory_i.freq_inst.dsmod_cos.i_osr[0]\ _08708_ VPWR VGND sg13g2_nor2_1
X_32308_ _08716_ \memory_i.freq_inst.dsmod_cos.i_osr[0]\ _08703_ _08715_ VPWR VGND sg13g2_a21oi_1
X_32309_ _08717_ \memory_i.freq_inst.dsmod_sin.data_ext_w[15]\ _08716_ VPWR VGND sg13g2_nor2_1
X_32310_ _08718_ _08717_ _08710_ _08712_ VPWR VGND sg13g2_mux2_1
X_32311_ _08719_ \memory_i.freq_inst.dsmod_sin.data_ext_w[15]\ _08714_ _08718_ VPWR VGND sg13g2_a21o_1
X_32312_ _08720_ _08677_ _08719_ \memory_i.freq_inst.dsmod_cos.i_osr[1]\ VPWR VGND sg13g2_mux2_1
X_32313_ _08721_ _08234_ _08720_ VPWR VGND sg13g2_nand2_1
X_32314_ _01816_ _08702_ _08721_ _08576_ VPWR VGND sg13g2_a21oi_1
X_32315_ _08722_ _08021_ VPWR VGND sg13g2_buf_1
X_32316_ _08723_ \memory_i.freq_inst.dsmod_sin.data_ext_w[17]\ \memory_i.freq_inst.dsmod_sin.data_pre_r[17]\ VPWR VGND sg13g2_xnor2_1
X_32317_ _08724_ _06020_ _08723_ VPWR VGND sg13g2_nor2_1
X_32318_ _08725_ _08704_ _08707_ \memory_i.freq_inst.dsmod_sin.data_ext_w[15]\ VPWR VGND sg13g2_a21oi_1
X_32319_ _08726_ _08708_ _08725_ \memory_i.freq_inst.dsmod_sin.data_pre_r[16]\ VPWR VGND sg13g2_o21ai_1
X_32320_ _08727_ _08726_ VPWR VGND sg13g2_buf_1
X_32321_ _08728_ _08723_ _08724_ _08727_ VPWR VGND sg13g2_mux2_1
X_32322_ _08729_ \memory_i.freq_inst.dsmod_sin.data_pre_r[16]\ _08708_ _08725_ VPWR VGND sg13g2_nor3_1
X_32323_ _08730_ _08729_ VPWR VGND sg13g2_inv_1
X_32324_ _08731_ _08727_ _08730_ \memory_i.freq_inst.dsmod_cos.i_osr[0]\ VPWR VGND sg13g2_a21oi_1
X_32325_ _08732_ _08728_ _08731_ VPWR VGND sg13g2_or2_1
X_32326_ _08733_ _08724_ _08729_ VPWR VGND sg13g2_nand2b_1
X_32327_ _08734_ \memory_i.freq_inst.dsmod_cos.i_osr[0]\ _08723_ VPWR VGND sg13g2_and2_1
X_32328_ _08735_ _06086_ _08727_ _08734_ VPWR VGND sg13g2_a21oi_1
X_32329_ _08736_ \memory_i.freq_inst.dsmod_sin.data_ext_w[16]\ _08735_ _08730_ VPWR VGND sg13g2_o21ai_1
X_32330_ _08737_ \memory_i.freq_inst.dsmod_sin.data_ext_w[16]\ _08732_ _08733_ _08736_ VPWR
+ VGND
+ sg13g2_a22oi_1
X_32331_ _08738_ _08698_ _08737_ \memory_i.freq_inst.dsmod_cos.i_osr[1]\ VPWR VGND sg13g2_mux2_1
X_32332_ _08739_ _08660_ _08738_ VPWR VGND sg13g2_nor2_1
X_32333_ _08740_ \memory_i.freq_inst.dsmod_sin.data_step_r[9]\ _15883_ _08739_ VPWR VGND sg13g2_a21oi_1
X_32334_ _01817_ _08722_ _08740_ VPWR VGND sg13g2_nor2_1
X_32335_ _08741_ \memory_i.freq_inst.dsmod_sin.data_step_r[10]\ _08577_ VPWR VGND sg13g2_nand2_1
X_32336_ _08742_ \memory_i.freq_inst.dsmod_sin.data_ext_w[18]\ \memory_i.freq_inst.dsmod_sin.data_pre_r[18]\ VPWR VGND sg13g2_xnor2_1
X_32337_ _08743_ _06021_ _08742_ VPWR VGND sg13g2_nor2_1
X_32338_ _08744_ \memory_i.freq_inst.dsmod_sin.data_ext_w[16]\ _08729_ _08727_ VPWR VGND sg13g2_o21ai_1
X_32339_ _08745_ \memory_i.freq_inst.dsmod_sin.data_pre_r[17]\ _08744_ VPWR VGND sg13g2_nand2_2
X_32340_ _08746_ _08742_ _08743_ _08745_ VPWR VGND sg13g2_mux2_1
X_32341_ _08747_ \memory_i.freq_inst.dsmod_sin.data_pre_r[17]\ _08744_ VPWR VGND sg13g2_or2_1
X_32342_ _08748_ _08747_ VPWR VGND sg13g2_buf_1
X_32343_ _08749_ _08745_ _08748_ \memory_i.freq_inst.dsmod_cos.i_osr[0]\ VPWR VGND sg13g2_a21oi_1
X_32344_ _08750_ _08746_ _08749_ \memory_i.freq_inst.dsmod_sin.data_ext_w[17]\ VPWR VGND sg13g2_o21ai_1
X_32345_ _08751_ \memory_i.freq_inst.dsmod_cos.i_osr[0]\ _08742_ VPWR VGND sg13g2_and2_1
X_32346_ _08752_ _06143_ _08745_ _08751_ VPWR VGND sg13g2_a21oi_1
X_32347_ _08753_ \memory_i.freq_inst.dsmod_sin.data_ext_w[17]\ _08752_ _08748_ VPWR VGND sg13g2_o21ai_1
X_32348_ _08754_ _08743_ _08748_ _08753_ VPWR VGND sg13g2_o21ai_1
X_32349_ _08755_ _08750_ _08754_ VPWR VGND sg13g2_nand2_1
X_32350_ _08756_ _08719_ _08755_ \memory_i.freq_inst.dsmod_cos.i_osr[1]\ VPWR VGND sg13g2_mux2_1
X_32351_ _08757_ _08234_ _08756_ VPWR VGND sg13g2_nand2_1
X_32352_ _01818_ _08741_ _08757_ _08576_ VPWR VGND sg13g2_a21oi_1
X_32353_ _08758_ \memory_i.freq_inst.dsmod_sin.data_ext_w[17]\ VPWR VGND sg13g2_inv_1
X_32354_ _08759_ \memory_i.freq_inst.dsmod_sin.data_pre_r[17]\ _08744_ _08758_ VPWR VGND sg13g2_o21ai_1
X_32355_ _08760_ \memory_i.freq_inst.dsmod_sin.data_pre_r[18]\ VPWR VGND sg13g2_inv_1
X_32356_ _08761_ _08745_ _08759_ _08760_ VPWR VGND sg13g2_a21oi_1
X_32357_ _08762_ _08760_ _08745_ _08759_ VPWR VGND sg13g2_nand3_1
X_32358_ _08763_ _08762_ VPWR VGND sg13g2_buf_1
X_32359_ _08764_ _08761_ _08763_ VPWR VGND sg13g2_nor2b_1
X_32360_ _08765_ \memory_i.freq_inst.dsmod_sin.data_ext_w[19]\ \memory_i.freq_inst.dsmod_sin.data_pre_r[19]\ VPWR VGND sg13g2_xor2_1
X_32361_ _08766_ \memory_i.freq_inst.dsmod_cos.i_osr[0]\ _08765_ VPWR VGND sg13g2_nand2_1
X_32362_ _08767_ _08766_ _08765_ _08761_ VPWR VGND sg13g2_mux2_1
X_32363_ _08768_ \memory_i.freq_inst.dsmod_cos.i_osr[0]\ _08764_ _08767_ VPWR VGND sg13g2_o21ai_1
X_32364_ _08769_ \memory_i.freq_inst.dsmod_sin.data_ext_w[18]\ _08768_ VPWR VGND sg13g2_nand2_1
X_32365_ _08770_ _08763_ _08766_ VPWR VGND sg13g2_nand2b_1
X_32366_ _08771_ _08765_ _08761_ _06030_ VPWR VGND sg13g2_mux2_1
X_32367_ _08772_ \memory_i.freq_inst.dsmod_sin.data_ext_w[18]\ _08771_ _08763_ VPWR VGND sg13g2_o21ai_1
X_32368_ _08773_ _08770_ _08772_ VPWR VGND sg13g2_nand2_1
X_32369_ _08774_ _08769_ _08773_ _03154_ VPWR VGND sg13g2_a21oi_1
X_32370_ _08775_ \memory_i.freq_inst.dsmod_cos.i_osr[1]\ _08737_ VPWR VGND sg13g2_nor2_1
X_32371_ _08776_ _08774_ _08775_ VPWR VGND sg13g2_nor2_1
X_32372_ _08777_ _08660_ _08776_ VPWR VGND sg13g2_nor2_1
X_32373_ _08778_ \memory_i.freq_inst.dsmod_sin.data_step_r[11]\ _15883_ _08777_ VPWR VGND sg13g2_a21oi_1
X_32374_ _01819_ _08722_ _08778_ VPWR VGND sg13g2_nor2_1
X_32375_ _08779_ \memory_i.freq_inst.dsmod_sin.data_step_r[12]\ _15821_ VPWR VGND sg13g2_nand2_1
X_32376_ _08780_ \memory_i.freq_inst.dsmod_sin.data_ext_w[20]\ \memory_i.freq_inst.dsmod_sin.data_pre_r[20]\ VPWR VGND sg13g2_xnor2_1
X_32377_ _08781_ _06020_ _08780_ VPWR VGND sg13g2_nor2_1
X_32378_ _08782_ _03073_ _08763_ _08761_ VPWR VGND sg13g2_a21o_1
X_32379_ _08783_ _08782_ VPWR VGND sg13g2_buf_4
X_32380_ _08784_ \memory_i.freq_inst.dsmod_sin.data_pre_r[19]\ _08783_ VPWR VGND sg13g2_nand2_2
X_32381_ _08785_ _08780_ _08781_ _08784_ VPWR VGND sg13g2_mux2_1
X_32382_ _08786_ \memory_i.freq_inst.dsmod_sin.data_pre_r[19]\ _08783_ VPWR VGND sg13g2_or2_1
X_32383_ _08787_ _08786_ VPWR VGND sg13g2_buf_1
X_32384_ _08788_ _08784_ _08787_ \memory_i.freq_inst.dsmod_cos.i_osr[0]\ VPWR VGND sg13g2_a21oi_1
X_32385_ _08789_ _08785_ _08788_ \memory_i.freq_inst.dsmod_sin.data_ext_w[19]\ VPWR VGND sg13g2_o21ai_1
X_32386_ _08790_ \memory_i.freq_inst.dsmod_cos.i_osr[0]\ _08780_ VPWR VGND sg13g2_and2_1
X_32387_ _08791_ _06086_ _08784_ _08790_ VPWR VGND sg13g2_a21oi_1
X_32388_ _08792_ \memory_i.freq_inst.dsmod_sin.data_ext_w[19]\ _08791_ _08787_ VPWR VGND sg13g2_o21ai_1
X_32389_ _08793_ _08781_ _08787_ _08792_ VPWR VGND sg13g2_o21ai_1
X_32390_ _08794_ _08789_ _08793_ VPWR VGND sg13g2_and2_1
X_32391_ _08795_ \memory_i.freq_inst.dsmod_cos.i_osr[1]\ _08755_ VPWR VGND sg13g2_nor2_1
X_32392_ _08796_ \memory_i.freq_inst.dsmod_cos.i_osr[1]\ _08794_ _08795_ VPWR VGND sg13g2_a21oi_1
X_32393_ _08797_ _08234_ _08796_ VPWR VGND sg13g2_nand2_1
X_32394_ _01820_ _08779_ _08797_ _08576_ VPWR VGND sg13g2_a21oi_1
X_32395_ _08798_ \memory_i.freq_inst.dsmod_sin.data_ext_w[21]\ \memory_i.freq_inst.dsmod_sin.data_pre_r[21]\ VPWR VGND sg13g2_xnor2_1
X_32396_ _08799_ _06021_ _08798_ VPWR VGND sg13g2_nor2_1
X_32397_ _08800_ \memory_i.freq_inst.dsmod_sin.data_ext_w[19]\ VPWR VGND sg13g2_inv_1
X_32398_ _08801_ \memory_i.freq_inst.dsmod_sin.data_pre_r[19]\ _08783_ _08800_ VPWR VGND sg13g2_o21ai_1
X_32399_ _08802_ _08801_ VPWR VGND sg13g2_buf_4
X_32400_ _08803_ \memory_i.freq_inst.dsmod_sin.data_pre_r[20]\ VPWR VGND sg13g2_inv_1
X_32401_ _08804_ _08784_ _08802_ _08803_ VPWR VGND sg13g2_a21o_1
X_32402_ _08805_ _08798_ _08799_ _08804_ VPWR VGND sg13g2_mux2_1
X_32403_ _08806_ \memory_i.freq_inst.dsmod_sin.data_pre_r[19]\ _08783_ \memory_i.freq_inst.dsmod_sin.data_pre_r[20]\ VPWR VGND sg13g2_a21oi_1
X_32404_ _08807_ _08802_ _08806_ VPWR VGND sg13g2_nand2_1
X_32405_ _08808_ _08804_ _08807_ \memory_i.freq_inst.dsmod_cos.i_osr[0]\ VPWR VGND sg13g2_a21oi_1
X_32406_ _08809_ _08805_ _08808_ \memory_i.freq_inst.dsmod_sin.data_ext_w[20]\ VPWR VGND sg13g2_o21ai_1
X_32407_ _08810_ _08784_ _08802_ _08803_ VPWR VGND sg13g2_a21oi_1
X_32408_ _08811_ \memory_i.freq_inst.dsmod_cos.i_osr[0]\ _08810_ VPWR VGND sg13g2_nor2_1
X_32409_ _08812_ \memory_i.freq_inst.dsmod_cos.i_osr[0]\ _08798_ _08811_ VPWR VGND sg13g2_a21oi_1
X_32410_ _08813_ \memory_i.freq_inst.dsmod_sin.data_ext_w[20]\ _08812_ _08807_ VPWR VGND sg13g2_o21ai_1
X_32411_ _08814_ _08799_ _08807_ _08813_ VPWR VGND sg13g2_o21ai_1
X_32412_ _08815_ _08809_ _08814_ VPWR VGND sg13g2_nand2_1
X_32413_ _08816_ _08769_ _08773_ \memory_i.freq_inst.dsmod_cos.i_osr[1]\ VPWR VGND sg13g2_a21oi_1
X_32414_ _08817_ \memory_i.freq_inst.dsmod_cos.i_osr[1]\ _08815_ _08816_ VPWR VGND sg13g2_a21oi_1
X_32415_ _08818_ _08660_ _08817_ VPWR VGND sg13g2_nor2_1
X_32416_ _08819_ \memory_i.freq_inst.dsmod_sin.data_step_r[13]\ _15883_ _08818_ VPWR VGND sg13g2_a21oi_1
X_32417_ _01821_ _08722_ _08819_ VPWR VGND sg13g2_nor2_1
X_32418_ _08820_ _08802_ _08806_ \memory_i.freq_inst.dsmod_sin.data_ext_w[20]\ VPWR VGND sg13g2_a21oi_1
X_32419_ _08821_ \memory_i.freq_inst.dsmod_sin.data_pre_r[21]\ _08810_ _08820_ VPWR VGND sg13g2_nor3_1
X_32420_ _08822_ \memory_i.freq_inst.dsmod_sin.data_ext_w[22]\ \memory_i.freq_inst.dsmod_sin.data_pre_r[22]\ VPWR VGND sg13g2_xor2_1
X_32421_ _08823_ \memory_i.freq_inst.dsmod_cos.i_osr[0]\ _08822_ VPWR VGND sg13g2_and2_1
X_32422_ _08824_ _08810_ _08820_ \memory_i.freq_inst.dsmod_sin.data_pre_r[21]\ VPWR VGND sg13g2_o21ai_1
X_32423_ _08825_ _08824_ VPWR VGND sg13g2_buf_4
X_32424_ _08826_ _08821_ _08825_ VPWR VGND sg13g2_nor2b_1
X_32425_ _08827_ _08822_ _08825_ VPWR VGND sg13g2_nor2_1
X_32426_ _08828_ _08823_ _08825_ _08827_ VPWR VGND sg13g2_a21oi_1
X_32427_ _08829_ \memory_i.freq_inst.dsmod_cos.i_osr[0]\ _08826_ _08828_ VPWR VGND sg13g2_o21ai_1
X_32428_ _08830_ _06030_ _08822_ VPWR VGND sg13g2_nor2_1
X_32429_ _08831_ _06143_ _08825_ _08830_ VPWR VGND sg13g2_a21oi_1
X_32430_ _08832_ \memory_i.freq_inst.dsmod_sin.data_ext_w[21]\ _08821_ _08831_ VPWR VGND sg13g2_nor3_1
X_32431_ _08833_ _08821_ _08823_ _08829_ \memory_i.freq_inst.dsmod_sin.data_ext_w[21]\ _08832_
+ VPWR
+ VGND sg13g2_a221oi_1
X_32432_ _08834_ _08794_ _08833_ \memory_i.freq_inst.dsmod_cos.i_osr[1]\ VPWR VGND sg13g2_mux2_1
X_32433_ _08835_ _08660_ _08834_ VPWR VGND sg13g2_nor2_1
X_32434_ _08836_ \memory_i.freq_inst.dsmod_sin.data_step_r[14]\ _15883_ _08835_ VPWR VGND sg13g2_a21oi_1
X_32435_ _01822_ _08722_ _08836_ VPWR VGND sg13g2_nor2_1
X_32436_ _08837_ \memory_i.freq_inst.dsmod_sin.data_step_r[15]\ _15821_ VPWR VGND sg13g2_nand2_1
X_32437_ _08838_ \memory_i.freq_inst.dsmod_sin.data_ext_w[23]\ \memory_i.freq_inst.dsmod_sin.data_pre_r[23]\ VPWR VGND sg13g2_xnor2_1
X_32438_ _08839_ _06030_ _08838_ VPWR VGND sg13g2_nor2_1
X_32439_ _08840_ \memory_i.freq_inst.dsmod_sin.data_pre_r[21]\ \memory_i.freq_inst.dsmod_sin.data_pre_r[20]\ VPWR VGND sg13g2_or2_1
X_32440_ _08841_ \memory_i.freq_inst.dsmod_sin.data_pre_r[19]\ _08783_ _08840_ VPWR VGND sg13g2_a21oi_1
X_32441_ _08842_ \memory_i.freq_inst.dsmod_sin.data_pre_r[21]\ \memory_i.freq_inst.dsmod_sin.data_ext_w[20]\ VPWR VGND sg13g2_nand2b_1
X_32442_ _08843_ \memory_i.freq_inst.dsmod_sin.data_pre_r[19]\ _08783_ _08842_ VPWR VGND sg13g2_a21oi_1
X_32443_ _08844_ _08841_ _08843_ _08802_ VPWR VGND sg13g2_o21ai_1
X_32444_ _08845_ \memory_i.freq_inst.dsmod_sin.data_pre_r[20]\ _08842_ VPWR VGND sg13g2_nor2_1
X_32445_ _08846_ \memory_i.freq_inst.dsmod_sin.data_ext_w[21]\ _08845_ VPWR VGND sg13g2_nor2_1
X_32446_ _08847_ _08844_ _08846_ VPWR VGND sg13g2_nand2_1
X_32447_ _08848_ \memory_i.freq_inst.dsmod_sin.data_pre_r[22]\ VPWR VGND sg13g2_inv_1
X_32448_ _08849_ _08825_ _08847_ _08848_ VPWR VGND sg13g2_a21oi_1
X_32449_ _08850_ _08839_ _08838_ _08849_ VPWR VGND sg13g2_mux2_1
X_32450_ _08851_ _08849_ VPWR VGND sg13g2_inv_1
X_32451_ _08852_ _08844_ _08846_ \memory_i.freq_inst.dsmod_sin.data_pre_r[22]\ VPWR VGND sg13g2_a21oi_1
X_32452_ _08853_ _08825_ _08852_ VPWR VGND sg13g2_nand2_1
X_32453_ _08854_ _08851_ _08853_ \memory_i.freq_inst.dsmod_cos.i_osr[0]\ VPWR VGND sg13g2_a21oi_1
X_32454_ _08855_ _08850_ _08854_ \memory_i.freq_inst.dsmod_sin.data_ext_w[22]\ VPWR VGND sg13g2_o21ai_1
X_32455_ _08856_ \memory_i.freq_inst.dsmod_cos.i_osr[0]\ _08849_ VPWR VGND sg13g2_nor2_1
X_32456_ _08857_ \memory_i.freq_inst.dsmod_cos.i_osr[0]\ _08838_ _08856_ VPWR VGND sg13g2_a21oi_1
X_32457_ _08858_ \memory_i.freq_inst.dsmod_sin.data_ext_w[22]\ _08857_ _08853_ VPWR VGND sg13g2_o21ai_1
X_32458_ _08859_ _08839_ _08853_ _08858_ VPWR VGND sg13g2_o21ai_1
X_32459_ _08860_ _08855_ _08859_ VPWR VGND sg13g2_nand2_1
X_32460_ _08861_ _08815_ _08860_ \memory_i.freq_inst.dsmod_cos.i_osr[1]\ VPWR VGND sg13g2_mux2_1
X_32461_ _08862_ _08234_ _08861_ VPWR VGND sg13g2_nand2_1
X_32462_ _01823_ _08837_ _08862_ _08576_ VPWR VGND sg13g2_a21oi_1
X_32463_ _08863_ \memory_i.freq_inst.dsmod_sin.data_pre_r[23]\ VPWR VGND sg13g2_inv_1
X_32464_ _08864_ \memory_i.freq_inst.dsmod_sin.data_ext_w[22]\ VPWR VGND sg13g2_inv_1
X_32465_ _08865_ _08864_ _08853_ _08849_ VPWR VGND sg13g2_a21oi_1
X_32466_ _08866_ _08863_ _08865_ VPWR VGND sg13g2_and2_1
X_32467_ _08867_ _08866_ VPWR VGND sg13g2_buf_1
X_32468_ _08868_ _08863_ _08865_ VPWR VGND sg13g2_nor2_1
X_32469_ _08869_ _08867_ _08868_ _06022_ VPWR VGND sg13g2_o21ai_1
X_32470_ _08870_ \memory_i.freq_inst.dsmod_sin.data_ext_w[24]\ \memory_i.freq_inst.dsmod_sin.data_pre_r[24]\ VPWR VGND sg13g2_xor2_1
X_32471_ _08871_ \memory_i.freq_inst.dsmod_cos.i_osr[0]\ _08870_ _08868_ VPWR VGND sg13g2_a21oi_1
X_32472_ _08872_ _08870_ _08868_ _08871_ VPWR VGND sg13g2_a21o_1
X_32473_ _08873_ \memory_i.freq_inst.dsmod_sin.data_ext_w[23]\ _08869_ _08872_ VPWR VGND sg13g2_and3_1
X_32474_ _08874_ \memory_i.freq_inst.dsmod_cos.i_osr[0]\ _08867_ _08868_ VPWR VGND sg13g2_nor3_1
X_32475_ _08875_ _06022_ _08867_ _08870_ VPWR VGND sg13g2_nor3_1
X_32476_ _08876_ \memory_i.freq_inst.dsmod_sin.data_ext_w[23]\ _08874_ _08875_ VPWR VGND sg13g2_nor3_1
X_32477_ _08877_ \memory_i.freq_inst.dsmod_cos.i_osr[0]\ _08867_ _08870_ VPWR VGND sg13g2_nand3_1
X_32478_ _08878_ _08873_ _08876_ _08877_ VPWR VGND sg13g2_o21ai_1
X_32479_ _08879_ \memory_i.freq_inst.dsmod_cos.i_osr[1]\ _08833_ VPWR VGND sg13g2_nor2_1
X_32480_ _08880_ \memory_i.freq_inst.dsmod_cos.i_osr[1]\ _08878_ _08879_ VPWR VGND sg13g2_a21oi_1
X_32481_ _08881_ \memory_i.freq_inst.dsmod_sin.data_step_r[16]\ _08660_ VPWR VGND sg13g2_nand2_1
X_32482_ _08882_ _08660_ _08880_ _08881_ VPWR VGND sg13g2_o21ai_1
X_32483_ _01824_ \memory_i.freq_inst.cordic.rstn_i\ _08882_ VPWR VGND sg13g2_and2_1
X_32484_ _08883_ \memory_i.freq_inst.dsmod_sin.data_step_r[17]\ _15821_ VPWR VGND sg13g2_nand2_1
X_32485_ _08884_ \memory_i.freq_inst.dsmod_sin.data_pre_r[24]\ VPWR VGND sg13g2_inv_1
X_32486_ _08885_ \memory_i.freq_inst.dsmod_sin.data_ext_w[23]\ VPWR VGND sg13g2_inv_1
X_32487_ _08886_ _08844_ _08846_ _08864_ VPWR VGND sg13g2_a21oi_1
X_32488_ _08887_ _08852_ _08886_ _08825_ VPWR VGND sg13g2_o21ai_1
X_32489_ _08888_ _08887_ VPWR VGND sg13g2_buf_4
X_32490_ _08889_ \memory_i.freq_inst.dsmod_sin.data_ext_w[23]\ _08863_ _08848_ \memory_i.freq_inst.dsmod_sin.data_ext_w[22]\ VPWR
+ VGND
+ sg13g2_a22oi_1
X_32491_ _08890_ _08889_ VPWR VGND sg13g2_buf_1
X_32492_ _08891_ _08885_ \memory_i.freq_inst.dsmod_sin.data_pre_r[23]\ _08888_ _08890_ VPWR
+ VGND
+ sg13g2_a22oi_1
X_32493_ _08892_ _08891_ VPWR VGND sg13g2_buf_1
X_32494_ _08893_ _08884_ _08892_ VPWR VGND sg13g2_nand2_1
X_32495_ _08894_ \memory_i.freq_inst.dsmod_sin.data_ext_w[25]\ \memory_i.freq_inst.dsmod_sin.data_pre_r[25]\ VPWR VGND sg13g2_xnor2_1
X_32496_ _08895_ _06361_ _08894_ VPWR VGND sg13g2_nor2_1
X_32497_ _08896_ \memory_i.freq_inst.dsmod_sin.data_ext_w[25]\ \memory_i.freq_inst.dsmod_sin.data_pre_r[25]\ VPWR VGND sg13g2_xor2_1
X_32498_ _08897_ _08884_ _08892_ VPWR VGND sg13g2_nor2_1
X_32499_ _08898_ _08897_ VPWR VGND sg13g2_buf_2
X_32500_ _08899_ _08896_ _08898_ _06086_ VPWR VGND sg13g2_mux2_1
X_32501_ _08900_ \memory_i.freq_inst.dsmod_sin.data_ext_w[24]\ _08899_ _08893_ VPWR VGND sg13g2_o21ai_1
X_32502_ _08901_ _08893_ _08895_ _08900_ VPWR VGND sg13g2_o21ai_1
X_32503_ _08902_ _08898_ VPWR VGND sg13g2_inv_1
X_32504_ _08903_ _08893_ _08902_ \memory_i.freq_inst.dsmod_cos.i_osr[0]\ VPWR VGND sg13g2_a21oi_1
X_32505_ _08904_ \memory_i.freq_inst.dsmod_cos.i_osr[0]\ _08896_ VPWR VGND sg13g2_nand2_1
X_32506_ _08905_ _08894_ _08898_ VPWR VGND sg13g2_nand2_1
X_32507_ _08906_ _08904_ _08898_ _08905_ VPWR VGND sg13g2_o21ai_1
X_32508_ _08907_ _08903_ _08906_ \memory_i.freq_inst.dsmod_sin.data_ext_w[24]\ VPWR VGND sg13g2_o21ai_1
X_32509_ _08908_ _08901_ _08907_ VPWR VGND sg13g2_nand2_1
X_32510_ _08909_ _08860_ _08908_ \memory_i.freq_inst.dsmod_cos.i_osr[1]\ VPWR VGND sg13g2_mux2_1
X_32511_ _08910_ _08234_ _08909_ VPWR VGND sg13g2_nand2_1
X_32512_ _08911_ _06006_ VPWR VGND sg13g2_buf_1
X_32513_ _01825_ _08883_ _08910_ _08911_ VPWR VGND sg13g2_a21oi_1
X_32514_ _08912_ _08884_ _08892_ \memory_i.freq_inst.dsmod_sin.data_ext_w[24]\ VPWR VGND sg13g2_a21oi_1
X_32515_ _08913_ _08898_ _08912_ VPWR VGND sg13g2_nor2_1
X_32516_ _08914_ _08894_ _08913_ VPWR VGND sg13g2_xnor2_1
X_32517_ _08915_ \memory_i.freq_inst.dsmod_sin.data_ext_w[26]\ \memory_i.freq_inst.dsmod_sin.data_pre_r[26]\ VPWR VGND sg13g2_xor2_1
X_32518_ _08916_ \memory_i.freq_inst.dsmod_sin.data_ext_w[25]\ _08915_ VPWR VGND sg13g2_nor2_1
X_32519_ _08917_ \memory_i.freq_inst.dsmod_sin.data_pre_r[25]\ _08898_ _08912_ VPWR VGND sg13g2_nor3_1
X_32520_ _08918_ _08898_ _08912_ \memory_i.freq_inst.dsmod_sin.data_pre_r[25]\ VPWR VGND sg13g2_o21ai_1
X_32521_ _08919_ \memory_i.freq_inst.dsmod_sin.data_ext_w[25]\ _08918_ _08917_ VPWR VGND sg13g2_a21oi_1
X_32522_ _08920_ _08919_ VPWR VGND sg13g2_buf_4
X_32523_ _08921_ _08920_ _08915_ VPWR VGND sg13g2_nor2b_1
X_32524_ _08922_ \memory_i.freq_inst.dsmod_sin.data_ext_w[25]\ _08918_ _08915_ VPWR VGND sg13g2_a21oi_1
X_32525_ _08923_ _06035_ _08921_ _08922_ VPWR VGND sg13g2_nor3_1
X_32526_ _08924_ _06035_ _08914_ _08916_ _08917_ _08923_
+ VPWR
+ VGND sg13g2_a221oi_1
X_32527_ _08925_ \memory_i.freq_inst.dsmod_cos.i_osr[1]\ _08924_ VPWR VGND sg13g2_nand2_1
X_32528_ _08926_ _06629_ _08878_ _08606_ VPWR VGND sg13g2_a21oi_1
X_32529_ _08927_ \memory_i.freq_inst.dsmod_sin.data_step_r[18]\ _15889_ \memory_i.freq_inst.cordic.rstn_i\ VPWR VGND sg13g2_o21ai_1
X_32530_ _01826_ _08925_ _08926_ _08927_ VPWR VGND sg13g2_a21oi_1
X_32531_ _08928_ \memory_i.freq_inst.dsmod_sin.data_ext_w[27]\ \memory_i.freq_inst.dsmod_sin.data_pre_r[27]\ VPWR VGND sg13g2_xnor2_1
X_32532_ _08929_ \memory_i.freq_inst.dsmod_sin.data_ext_w[26]\ _08928_ VPWR VGND sg13g2_nor2_1
X_32533_ _08930_ \memory_i.freq_inst.dsmod_sin.data_pre_r[26]\ _08920_ _08929_ VPWR VGND sg13g2_o21ai_1
X_32534_ _08931_ \memory_i.freq_inst.dsmod_sin.data_ext_w[26]\ _08928_ VPWR VGND sg13g2_nand2_1
X_32535_ _08932_ \memory_i.freq_inst.dsmod_sin.data_pre_r[26]\ _08920_ _08931_ VPWR VGND sg13g2_a21o_1
X_32536_ _08933_ \memory_i.freq_inst.dsmod_sin.data_ext_w[27]\ \memory_i.freq_inst.dsmod_sin.data_pre_r[27]\ VPWR VGND sg13g2_xor2_1
X_32537_ _08934_ \memory_i.freq_inst.dsmod_sin.data_pre_r[26]\ _08920_ _08933_ VPWR VGND sg13g2_nand3_1
X_32538_ _08935_ _08930_ _08932_ _08934_ VPWR VGND sg13g2_nand3_1
X_32539_ _08936_ _08915_ _08920_ VPWR VGND sg13g2_xor2_1
X_32540_ _08937_ \memory_i.freq_inst.dsmod_sin.data_ext_w[26]\ \memory_i.freq_inst.dsmod_sin.data_pre_r[26]\ _08920_ _08933_ VPWR
+ VGND
+ sg13g2_or4_1
X_32541_ _08938_ \memory_i.freq_inst.dsmod_cos.i_osr[0]\ _08936_ _08937_ VPWR VGND sg13g2_o21ai_1
X_32542_ _08939_ \memory_i.freq_inst.dsmod_cos.i_osr[0]\ _08935_ _08938_ VPWR VGND sg13g2_a21oi_1
X_32543_ _08940_ \memory_i.freq_inst.dsmod_cos.i_osr[1]\ _08939_ VPWR VGND sg13g2_nand2_1
X_32544_ _08941_ _06629_ _08908_ _08606_ VPWR VGND sg13g2_a21oi_1
X_32545_ _08942_ \memory_i.freq_inst.dsmod_sin.data_step_r[19]\ _15889_ \memory_i.freq_inst.cordic.rstn_i\ VPWR VGND sg13g2_o21ai_1
X_32546_ _01827_ _08940_ _08941_ _08942_ VPWR VGND sg13g2_a21oi_1
X_32547_ _08943_ \memory_i.freq_inst.dsmod_sin.data_pre_r[26]\ _08920_ VPWR VGND sg13g2_nand2_1
X_32548_ _08944_ \memory_i.freq_inst.dsmod_sin.data_ext_w[26]\ VPWR VGND sg13g2_inv_1
X_32549_ _08945_ \memory_i.freq_inst.dsmod_sin.data_pre_r[26]\ _08920_ _08944_ VPWR VGND sg13g2_o21ai_1
X_32550_ _08946_ _06035_ _08928_ VPWR VGND sg13g2_nand2_1
X_32551_ _08947_ _08943_ _08945_ _08946_ VPWR VGND sg13g2_a21oi_1
X_32552_ _08948_ _06035_ _08943_ _08933_ _08945_ VPWR
+ VGND
+ sg13g2_nand4_1
X_32553_ _08949_ _08885_ \memory_i.freq_inst.dsmod_sin.data_pre_r[23]\ VPWR VGND sg13g2_nand2_1
X_32554_ _08950_ _08870_ _08896_ _08915_ _08933_ VPWR
+ VGND
+ sg13g2_nor4_1
X_32555_ _08951_ _08949_ _08950_ VPWR VGND sg13g2_nand2_1
X_32556_ _08952_ _08888_ _08890_ _08951_ VPWR VGND sg13g2_a21oi_2
X_32557_ _08953_ \memory_i.freq_inst.dsmod_sin.data_pre_r[26]\ VPWR VGND sg13g2_inv_1
X_32558_ _08954_ \memory_i.freq_inst.dsmod_sin.data_ext_w[24]\ _08884_ VPWR VGND sg13g2_nand2_1
X_32559_ _08955_ \memory_i.freq_inst.dsmod_sin.data_pre_r[25]\ _08954_ VPWR VGND sg13g2_nor2_1
X_32560_ _08956_ \memory_i.freq_inst.dsmod_sin.data_ext_w[25]\ _08955_ VPWR VGND sg13g2_nor2_1
X_32561_ _08957_ _08944_ \memory_i.freq_inst.dsmod_sin.data_pre_r[26]\ \memory_i.freq_inst.dsmod_sin.data_pre_r[25]\ _08954_ _08956_
+ VPWR
+ VGND sg13g2_a221oi_1
X_32562_ _08958_ \memory_i.freq_inst.dsmod_sin.data_ext_w[26]\ _08953_ _08957_ VPWR VGND sg13g2_a21oi_1
X_32563_ _08959_ \memory_i.freq_inst.dsmod_sin.data_pre_r[27]\ _08958_ VPWR VGND sg13g2_nor2_1
X_32564_ _08960_ \memory_i.freq_inst.dsmod_sin.data_pre_r[27]\ _08958_ VPWR VGND sg13g2_nand2_1
X_32565_ _08961_ \memory_i.freq_inst.dsmod_sin.data_ext_w[27]\ _08959_ _08960_ VPWR VGND sg13g2_o21ai_1
X_32566_ _08962_ _08961_ VPWR VGND sg13g2_inv_1
X_32567_ _08963_ _08952_ _08962_ VPWR VGND sg13g2_nor2_1
X_32568_ _08964_ \memory_i.freq_inst.dsmod_sin.data_ext_w[28]\ \memory_i.freq_inst.dsmod_sin.data_pre_r[28]\ VPWR VGND sg13g2_xnor2_1
X_32569_ _08965_ _08963_ _08964_ VPWR VGND sg13g2_xnor2_1
X_32570_ _08966_ \memory_i.freq_inst.dsmod_cos.i_osr[0]\ _08965_ VPWR VGND sg13g2_nand2_1
X_32571_ _08967_ _08947_ _08948_ _08966_ VPWR VGND sg13g2_nand3b_1
X_32572_ _08968_ \memory_i.freq_inst.dsmod_cos.i_osr[1]\ _08967_ VPWR VGND sg13g2_nand2_1
X_32573_ _08969_ _06629_ _08924_ _08606_ VPWR VGND sg13g2_a21oi_1
X_32574_ _08970_ \memory_i.freq_inst.dsmod_sin.data_step_r[20]\ _15889_ \memory_i.freq_inst.cordic.rstn_i\ VPWR VGND sg13g2_o21ai_1
X_32575_ _01828_ _08968_ _08969_ _08970_ VPWR VGND sg13g2_a21oi_1
X_32576_ _08971_ \memory_i.freq_inst.dsmod_cos.i_osr[1]\ _08939_ VPWR VGND sg13g2_nor2_1
X_32577_ _08972_ \memory_i.freq_inst.dsmod_sin.data_ext_w[29]\ \memory_i.freq_inst.dsmod_sin.data_pre_r[29]\ VPWR VGND sg13g2_xnor2_1
X_32578_ _08973_ _06086_ _08972_ VPWR VGND sg13g2_nor2_1
X_32579_ _08974_ \memory_i.freq_inst.dsmod_sin.data_pre_r[28]\ _08963_ VPWR VGND sg13g2_nand2_1
X_32580_ _08975_ _08974_ VPWR VGND sg13g2_inv_1
X_32581_ _08976_ \memory_i.freq_inst.dsmod_sin.data_pre_r[28]\ _08963_ VPWR VGND sg13g2_xnor2_1
X_32582_ _08977_ \memory_i.freq_inst.dsmod_cos.i_osr[0]\ _08972_ _08974_ VPWR VGND sg13g2_nand3_1
X_32583_ _08978_ \memory_i.freq_inst.dsmod_cos.i_osr[0]\ _08976_ _08977_ VPWR VGND sg13g2_o21ai_1
X_32584_ _08979_ \memory_i.freq_inst.dsmod_sin.data_pre_r[28]\ VPWR VGND sg13g2_inv_1
X_32585_ _08980_ _08952_ _08962_ _08979_ VPWR VGND sg13g2_o21ai_1
X_32586_ _08981_ _08980_ VPWR VGND sg13g2_buf_1
X_32587_ _08982_ _08972_ _08973_ _08981_ VPWR VGND sg13g2_mux2_1
X_32588_ _08983_ _06361_ _08976_ _08982_ VPWR VGND sg13g2_a21oi_1
X_32589_ _08984_ \memory_i.freq_inst.dsmod_sin.data_ext_w[28]\ _08983_ VPWR VGND sg13g2_nor2_1
X_32590_ _08985_ _08973_ _08975_ _08978_ \memory_i.freq_inst.dsmod_sin.data_ext_w[28]\ _08984_
+ VPWR
+ VGND sg13g2_a221oi_1
X_32591_ _08986_ _12945_ _08660_ VPWR VGND sg13g2_nor2_1
X_32592_ _08987_ _06629_ _08985_ _08986_ VPWR VGND sg13g2_o21ai_1
X_32593_ _08988_ \memory_i.freq_inst.cordic.rstn_i\ \memory_i.freq_inst.dsmod_sin.data_step_r[21]\ _08577_ VPWR VGND sg13g2_nand3_1
X_32594_ _01829_ _08971_ _08987_ _08988_ VPWR VGND sg13g2_o21ai_1
X_32595_ _08989_ _06629_ _08967_ VPWR VGND sg13g2_nand2_1
X_32596_ _08990_ \memory_i.freq_inst.dsmod_sin.data_pre_r[28]\ _08961_ VPWR VGND sg13g2_nand2_1
X_32597_ _08991_ _08952_ _08990_ \memory_i.freq_inst.dsmod_sin.data_ext_w[28]\ VPWR VGND sg13g2_o21ai_1
X_32598_ _08992_ _08981_ _08991_ VPWR VGND sg13g2_nand2_1
X_32599_ _08993_ _08972_ _08992_ VPWR VGND sg13g2_xnor2_1
X_32600_ _08994_ \memory_i.freq_inst.dsmod_sin.data_ext_w[30]\ VPWR VGND sg13g2_inv_1
X_32601_ _08995_ _08994_ \memory_i.freq_inst.dsmod_sin.data_pre_r[30]\ VPWR VGND sg13g2_nor2_1
X_32602_ _08996_ _08994_ \memory_i.freq_inst.dsmod_sin.data_pre_r[30]\ VPWR VGND sg13g2_nand2_1
X_32603_ _08997_ _08995_ _08996_ VPWR VGND sg13g2_nand2b_1
X_32604_ _08998_ \memory_i.freq_inst.dsmod_sin.data_ext_w[29]\ _08997_ VPWR VGND sg13g2_nor2_1
X_32605_ _08999_ _08981_ _08991_ \memory_i.freq_inst.dsmod_sin.data_pre_r[29]\ VPWR VGND sg13g2_a21oi_1
X_32606_ _09000_ \memory_i.freq_inst.dsmod_sin.data_pre_r[29]\ _08981_ _08991_ VPWR VGND sg13g2_nand3_1
X_32607_ _09001_ \memory_i.freq_inst.dsmod_sin.data_ext_w[29]\ _09000_ _08999_ VPWR VGND sg13g2_a21oi_1
X_32608_ _09002_ _08997_ _09001_ VPWR VGND sg13g2_nand2_1
X_32609_ _09003_ _08995_ _08996_ VPWR VGND sg13g2_nor2b_1
X_32610_ _09004_ \memory_i.freq_inst.dsmod_sin.data_ext_w[29]\ _09003_ _09000_ VPWR VGND sg13g2_nand3_1
X_32611_ _09005_ _09002_ _09004_ _06035_ VPWR VGND sg13g2_a21oi_1
X_32612_ _09006_ _06035_ _08993_ _08998_ _08999_ _09005_
+ VPWR
+ VGND sg13g2_a221oi_1
X_32613_ _09007_ \memory_i.freq_inst.dsmod_cos.i_osr[1]\ _09006_ _08606_ VPWR VGND sg13g2_a21oi_1
X_32614_ _09008_ \memory_i.freq_inst.dsmod_sin.data_step_r[22]\ _15889_ \memory_i.freq_inst.cordic.rstn_i\ VPWR VGND sg13g2_o21ai_1
X_32615_ _01830_ _08989_ _09007_ _09008_ VPWR VGND sg13g2_a21oi_1
X_32616_ _09009_ \memory_i.freq_inst.dsmod_sin.data_pre_r[30]\ _09001_ VPWR VGND sg13g2_nand2_1
X_32617_ _09010_ \memory_i.freq_inst.dsmod_sin.data_pre_r[30]\ _09001_ _08994_ VPWR VGND sg13g2_o21ai_1
X_32618_ _09011_ \memory_i.freq_inst.dsmod_sin.data_ext_w[31]\ \memory_i.freq_inst.dsmod_sin.data_pre_r[31]\ VPWR VGND sg13g2_xnor2_1
X_32619_ _09012_ _09009_ _09010_ _09011_ VPWR VGND sg13g2_a21oi_1
X_32620_ _09013_ \memory_i.freq_inst.dsmod_sin.data_ext_w[30]\ _09009_ _09011_ VPWR VGND sg13g2_and3_1
X_32621_ _09014_ _09012_ _09013_ \memory_i.freq_inst.dsmod_cos.i_osr[0]\ VPWR VGND sg13g2_o21ai_1
X_32622_ _09015_ _08997_ _09001_ VPWR VGND sg13g2_xnor2_1
X_32623_ _09016_ _08994_ _09011_ VPWR VGND sg13g2_nand2_1
X_32624_ _09017_ \memory_i.freq_inst.dsmod_sin.data_pre_r[30]\ _09001_ _09016_ VPWR VGND sg13g2_nor3_1
X_32625_ _09018_ _06035_ _09015_ _09017_ VPWR VGND sg13g2_a21oi_1
X_32626_ _09019_ \memory_i.freq_inst.dsmod_cos.i_osr[1]\ _09014_ _09018_ VPWR VGND sg13g2_nand3_1
X_32627_ _09020_ _06629_ _08985_ _08606_ VPWR VGND sg13g2_a21oi_1
X_32628_ _09021_ \memory_i.freq_inst.dsmod_sin.data_step_r[23]\ _15889_ \memory_i.freq_inst.cordic.rstn_i\ VPWR VGND sg13g2_o21ai_1
X_32629_ _01831_ _09019_ _09020_ _09021_ VPWR VGND sg13g2_a21oi_1
X_32630_ _09022_ _09009_ _09011_ _09010_ VPWR VGND sg13g2_nand3_1
X_32631_ _09023_ _09012_ _09022_ VPWR VGND sg13g2_nor2b_1
X_32632_ _09024_ \memory_i.freq_inst.dsmod_sin.data_ext_w[32]\ VPWR VGND sg13g2_inv_1
X_32633_ _09025_ _08964_ _08972_ _09003_ _09011_ VPWR
+ VGND
+ sg13g2_nand4_1
X_32634_ _09026_ _09025_ _08949_ _08950_ VPWR VGND sg13g2_nand3b_1
X_32635_ _09027_ _08888_ _08890_ _09026_ VPWR VGND sg13g2_a21oi_2
X_32636_ _09028_ \memory_i.freq_inst.dsmod_sin.data_ext_w[28]\ _08979_ VPWR VGND sg13g2_nand2_1
X_32637_ _09029_ \memory_i.freq_inst.dsmod_sin.data_pre_r[29]\ _09028_ VPWR VGND sg13g2_nor2_1
X_32638_ _09030_ \memory_i.freq_inst.dsmod_sin.data_ext_w[29]\ _09029_ VPWR VGND sg13g2_nor2_1
X_32639_ _09031_ \memory_i.freq_inst.dsmod_sin.data_pre_r[29]\ _09028_ _09030_ VPWR VGND sg13g2_a21oi_1
X_32640_ _09032_ _08996_ _09031_ _08995_ VPWR VGND sg13g2_a21oi_1
X_32641_ _09033_ \memory_i.freq_inst.dsmod_sin.data_pre_r[31]\ _09032_ VPWR VGND sg13g2_nor2_1
X_32642_ _09034_ \memory_i.freq_inst.dsmod_sin.data_pre_r[31]\ _09032_ VPWR VGND sg13g2_nand2_1
X_32643_ _09035_ \memory_i.freq_inst.dsmod_sin.data_ext_w[31]\ _09033_ _09034_ VPWR VGND sg13g2_o21ai_1
X_32644_ _09036_ _08961_ _09025_ _09035_ VPWR VGND sg13g2_o21ai_1
X_32645_ _09037_ _09036_ VPWR VGND sg13g2_buf_1
X_32646_ _09038_ _09027_ _09037_ VPWR VGND sg13g2_nor2_1
X_32647_ _09039_ \memory_i.freq_inst.dsmod_sin.data_pre_r[32]\ _09038_ VPWR VGND sg13g2_xnor2_1
X_32648_ _09040_ _09024_ _09039_ VPWR VGND sg13g2_xnor2_1
X_32649_ _09041_ \memory_i.freq_inst.dsmod_cos.i_osr[0]\ _09040_ VPWR VGND sg13g2_nand2_1
X_32650_ _09042_ \memory_i.freq_inst.dsmod_cos.i_osr[0]\ _09023_ _09041_ VPWR VGND sg13g2_o21ai_1
X_32651_ _09043_ \memory_i.freq_inst.cordic.rstn_i\ \memory_i.freq_inst.dsmod_cos.i_osr[1]\ _15815_ VPWR VGND sg13g2_nand3_1
X_32652_ _09044_ _12944_ \memory_i.freq_inst.dsmod_cos.i_osr[1]\ _15820_ VPWR VGND sg13g2_nor3_1
X_32653_ _09045_ \memory_i.freq_inst.cordic.rstn_i\ \memory_i.freq_inst.dsmod_sin.data_step_r[24]\ VPWR VGND sg13g2_and2_1
X_32654_ _09046_ _09006_ _09044_ _09045_ _08606_ VPWR
+ VGND
+ sg13g2_a22oi_1
X_32655_ _01832_ _09042_ _09043_ _09046_ VPWR VGND sg13g2_o21ai_1
X_32656_ _09047_ _09014_ _09018_ _09044_ VPWR VGND sg13g2_nand3_1
X_32657_ _09048_ \memory_i.freq_inst.dsmod_sin.data_ext_w[33]\ \memory_i.freq_inst.dsmod_sin.data_pre_r[33]\ VPWR VGND sg13g2_xnor2_1
X_32658_ _09049_ _06020_ _09048_ VPWR VGND sg13g2_nor2_1
X_32659_ _09050_ \memory_i.freq_inst.dsmod_sin.data_pre_r[32]\ VPWR VGND sg13g2_inv_1
X_32660_ _09051_ _09050_ _09027_ _09037_ VPWR VGND sg13g2_nor3_1
X_32661_ _09052_ _09051_ _09048_ \memory_i.freq_inst.dsmod_cos.i_osr[0]\ VPWR VGND sg13g2_nand3b_1
X_32662_ _09053_ \memory_i.freq_inst.dsmod_cos.i_osr[0]\ _09039_ _09052_ VPWR VGND sg13g2_o21ai_1
X_32663_ _09054_ _09027_ _09037_ _09050_ VPWR VGND sg13g2_o21ai_1
X_32664_ _09055_ _09048_ _09049_ _09054_ VPWR VGND sg13g2_mux2_1
X_32665_ _09056_ _06361_ _09039_ _09055_ VPWR VGND sg13g2_a21oi_1
X_32666_ _09057_ \memory_i.freq_inst.dsmod_sin.data_ext_w[32]\ _09056_ VPWR VGND sg13g2_nor2_1
X_32667_ _09058_ _09049_ _09051_ _09053_ \memory_i.freq_inst.dsmod_sin.data_ext_w[32]\ _09057_
+ VPWR
+ VGND sg13g2_a221oi_1
X_32668_ _09059_ _09043_ _09058_ VPWR VGND sg13g2_nand2b_1
X_32669_ _09060_ \memory_i.freq_inst.cordic.rstn_i\ \memory_i.freq_inst.dsmod_sin.data_step_r[25]\ _08606_ VPWR VGND sg13g2_nand3_1
X_32670_ _01833_ _09047_ _09059_ _09060_ VPWR VGND sg13g2_nand3_1
X_32671_ _09061_ \memory_i.freq_inst.dsmod_cos.i_osr[0]\ _09040_ \memory_i.freq_inst.dsmod_cos.i_osr[1]\ VPWR VGND sg13g2_a21oi_1
X_32672_ _09062_ \memory_i.freq_inst.dsmod_cos.i_osr[0]\ _09023_ _09061_ VPWR VGND sg13g2_o21ai_1
X_32673_ _09063_ _09024_ _09054_ _09051_ VPWR VGND sg13g2_a21o_1
X_32674_ _09064_ _09063_ VPWR VGND sg13g2_buf_1
X_32675_ _09065_ \memory_i.freq_inst.dsmod_sin.data_pre_r[33]\ _09064_ VPWR VGND sg13g2_xor2_1
X_32676_ _09066_ \memory_i.freq_inst.dsmod_sin.data_ext_w[34]\ \memory_i.freq_inst.dsmod_sin.data_pre_r[34]\ VPWR VGND sg13g2_xor2_1
X_32677_ _09067_ \memory_i.freq_inst.dsmod_cos.i_osr[0]\ _09066_ VPWR VGND sg13g2_nand2_1
X_32678_ _09068_ \memory_i.freq_inst.dsmod_sin.data_pre_r[33]\ _09064_ VPWR VGND sg13g2_nand2_1
X_32679_ _09069_ _09066_ _09067_ _09068_ VPWR VGND sg13g2_mux2_1
X_32680_ _09070_ \memory_i.freq_inst.dsmod_cos.i_osr[0]\ _09065_ _09069_ VPWR VGND sg13g2_o21ai_1
X_32681_ _09071_ _06361_ _09066_ VPWR VGND sg13g2_nor2_1
X_32682_ _09072_ \memory_i.freq_inst.dsmod_sin.data_pre_r[33]\ _09064_ VPWR VGND sg13g2_or2_1
X_32683_ _09073_ _06035_ _09065_ _09071_ _09072_ VPWR
+ VGND
+ sg13g2_a22oi_1
X_32684_ _09074_ _09072_ _09067_ VPWR VGND sg13g2_or2_1
X_32685_ _09075_ \memory_i.freq_inst.dsmod_sin.data_ext_w[33]\ _09073_ _09074_ VPWR VGND sg13g2_o21ai_1
X_32686_ _09076_ \memory_i.freq_inst.dsmod_sin.data_ext_w[33]\ _09070_ _09075_ VPWR VGND sg13g2_a21o_1
X_32687_ _09077_ \memory_i.freq_inst.dsmod_cos.i_osr[1]\ _09076_ _08606_ VPWR VGND sg13g2_a21oi_1
X_32688_ _09078_ \memory_i.freq_inst.dsmod_sin.data_step_r[26]\ _15889_ \memory_i.freq_inst.cordic.rstn_i\ VPWR VGND sg13g2_o21ai_1
X_32689_ _01834_ _09062_ _09077_ _09078_ VPWR VGND sg13g2_a21oi_1
X_32690_ _09079_ \memory_i.freq_inst.dsmod_sin.data_step_r[27]\ _15821_ VPWR VGND sg13g2_nand2_1
X_32691_ _09080_ \memory_i.freq_inst.dsmod_sin.data_ext_w[34]\ VPWR VGND sg13g2_inv_1
X_32692_ _09081_ _08888_ _08890_ _09026_ VPWR VGND sg13g2_a21o_1
X_32693_ _09082_ _09081_ VPWR VGND sg13g2_buf_4
X_32694_ _09083_ _09037_ VPWR VGND sg13g2_inv_1
X_32695_ _09084_ \memory_i.freq_inst.dsmod_sin.data_pre_r[34]\ \memory_i.freq_inst.dsmod_sin.data_pre_r[33]\ \memory_i.freq_inst.dsmod_sin.data_pre_r[32]\ VPWR VGND sg13g2_or3_1
X_32696_ _09085_ \memory_i.freq_inst.dsmod_sin.data_pre_r[34]\ \memory_i.freq_inst.dsmod_sin.data_ext_w[33]\ VPWR VGND sg13g2_nand2b_1
X_32697_ _09086_ _09085_ _09050_ VPWR VGND sg13g2_nand2b_1
X_32698_ _09087_ _09082_ _09083_ _09084_ _09086_ VPWR
+ VGND
+ sg13g2_a22oi_1
X_32699_ _09088_ _09024_ \memory_i.freq_inst.dsmod_sin.data_pre_r[34]\ VPWR VGND sg13g2_nor2_1
X_32700_ _09089_ \memory_i.freq_inst.dsmod_sin.data_pre_r[33]\ _09088_ VPWR VGND sg13g2_nand2b_1
X_32701_ _09090_ \memory_i.freq_inst.dsmod_sin.data_ext_w[33]\ \memory_i.freq_inst.dsmod_sin.data_ext_w[32]\ VPWR VGND sg13g2_nand2_1
X_32702_ _09091_ \memory_i.freq_inst.dsmod_sin.data_pre_r[34]\ _09090_ VPWR VGND sg13g2_or2_1
X_32703_ _09092_ _09082_ _09083_ _09089_ _09091_ VPWR
+ VGND
+ sg13g2_a22oi_1
X_32704_ _09093_ \memory_i.freq_inst.dsmod_sin.data_pre_r[33]\ \memory_i.freq_inst.dsmod_sin.data_pre_r[32]\ VPWR VGND sg13g2_nor2_1
X_32705_ _09094_ \memory_i.freq_inst.dsmod_sin.data_pre_r[34]\ \memory_i.freq_inst.dsmod_sin.data_pre_r[32]\ _09090_ VPWR VGND sg13g2_nor3_1
X_32706_ _09095_ _09088_ _09093_ _09094_ VPWR VGND sg13g2_a21oi_1
X_32707_ _09096_ \memory_i.freq_inst.dsmod_sin.data_pre_r[33]\ _09085_ _09095_ VPWR VGND sg13g2_o21ai_1
X_32708_ _09097_ _09087_ _09092_ _09096_ VPWR VGND sg13g2_nor3_2
X_32709_ _09098_ _09097_ VPWR VGND sg13g2_buf_2
X_32710_ _09099_ \memory_i.freq_inst.dsmod_sin.data_pre_r[34]\ \memory_i.freq_inst.dsmod_sin.data_pre_r[33]\ \memory_i.freq_inst.dsmod_sin.data_pre_r[32]\ VPWR VGND sg13g2_nand3_1
X_32711_ _09100_ _09027_ _09037_ _09099_ VPWR VGND sg13g2_nor3_1
X_32712_ _09101_ \memory_i.freq_inst.dsmod_sin.data_ext_w[33]\ \memory_i.freq_inst.dsmod_sin.data_pre_r[34]\ VPWR VGND sg13g2_nor2b_1
X_32713_ _09102_ \memory_i.freq_inst.dsmod_sin.data_pre_r[32]\ _09082_ _09083_ _09101_ VPWR
+ VGND
+ sg13g2_and4_1
X_32714_ _09103_ \memory_i.freq_inst.dsmod_sin.data_ext_w[32]\ \memory_i.freq_inst.dsmod_sin.data_pre_r[34]\ VPWR VGND sg13g2_nor2b_1
X_32715_ _09104_ \memory_i.freq_inst.dsmod_sin.data_pre_r[33]\ _09082_ _09083_ _09103_ VPWR
+ VGND
+ sg13g2_and4_1
X_32716_ _09105_ \memory_i.freq_inst.dsmod_sin.data_ext_w[33]\ \memory_i.freq_inst.dsmod_sin.data_ext_w[32]\ VPWR VGND sg13g2_nor2_1
X_32717_ _09106_ \memory_i.freq_inst.dsmod_sin.data_pre_r[34]\ _09082_ _09083_ _09105_ VPWR
+ VGND
+ sg13g2_and4_1
X_32718_ _09107_ _09100_ _09102_ _09104_ _09106_ VPWR
+ VGND
+ sg13g2_nor4_2
X_32719_ _09108_ _09107_ VPWR VGND sg13g2_buf_4
X_32720_ _09109_ \memory_i.freq_inst.dsmod_sin.data_pre_r[33]\ \memory_i.freq_inst.dsmod_sin.data_pre_r[32]\ _09103_ VPWR VGND sg13g2_nand3_1
X_32721_ _09110_ \memory_i.freq_inst.dsmod_sin.data_pre_r[34]\ \memory_i.freq_inst.dsmod_sin.data_pre_r[32]\ _09105_ VPWR VGND sg13g2_nand3_1
X_32722_ _09111_ _09109_ _09110_ VPWR VGND sg13g2_nand2_1
X_32723_ _09112_ \memory_i.freq_inst.dsmod_sin.data_pre_r[33]\ _09101_ _09111_ VPWR VGND sg13g2_a21oi_1
X_32724_ _09113_ _09112_ VPWR VGND sg13g2_buf_1
X_32725_ _09114_ _09098_ _09108_ _09113_ VPWR VGND sg13g2_nand3_1
X_32726_ _09115_ \memory_i.freq_inst.dsmod_sin.data_ext_w[35]\ \memory_i.freq_inst.dsmod_sin.data_pre_r[35]\ VPWR VGND sg13g2_xor2_1
X_32727_ _09116_ \memory_i.freq_inst.dsmod_cos.i_osr[0]\ _09115_ VPWR VGND sg13g2_and2_1
X_32728_ _09117_ _09108_ _09113_ VPWR VGND sg13g2_and2_1
X_32729_ _09118_ _09108_ _09113_ _09115_ VPWR VGND sg13g2_a21oi_1
X_32730_ _09119_ _06361_ _09114_ _09116_ _09117_ _09118_
+ VPWR
+ VGND sg13g2_a221oi_1
X_32731_ _09120_ \memory_i.freq_inst.dsmod_sin.data_ext_w[34]\ _06143_ _09115_ VPWR VGND sg13g2_nor3_1
X_32732_ _09121_ _09116_ _09120_ _09098_ VPWR VGND sg13g2_mux2_1
X_32733_ _09122_ \memory_i.freq_inst.dsmod_sin.data_ext_w[34]\ \memory_i.freq_inst.dsmod_cos.i_osr[0]\ VPWR VGND sg13g2_nor2_1
X_32734_ _09123_ _09098_ _09108_ _09113_ _09122_ VPWR
+ VGND
+ sg13g2_nand4_1
X_32735_ _09124_ _09121_ _09123_ VPWR VGND sg13g2_nor2b_1
X_32736_ _09125_ _09080_ _09119_ _09124_ VPWR VGND sg13g2_o21ai_1
X_32737_ _09126_ _09058_ _09125_ \memory_i.freq_inst.dsmod_cos.i_osr[1]\ VPWR VGND sg13g2_mux2_1
X_32738_ _09127_ _15817_ _09126_ VPWR VGND sg13g2_nand2_1
X_32739_ _01835_ _09079_ _09127_ _08911_ VPWR VGND sg13g2_a21oi_1
X_32740_ _09128_ \memory_i.freq_inst.dsmod_sin.data_ext_w[34]\ _09108_ _09113_ VPWR VGND sg13g2_nand3_1
X_32741_ _09129_ _09128_ VPWR VGND sg13g2_buf_4
X_32742_ _09130_ \memory_i.freq_inst.dsmod_sin.data_ext_w[36]\ \memory_i.freq_inst.dsmod_sin.data_pre_r[36]\ VPWR VGND sg13g2_xor2_1
X_32743_ _09131_ \memory_i.freq_inst.dsmod_cos.i_osr[0]\ _09130_ VPWR VGND sg13g2_nand2_1
X_32744_ _09132_ \memory_i.freq_inst.dsmod_sin.data_pre_r[35]\ _09131_ VPWR VGND sg13g2_nand2_1
X_32745_ _09133_ _09098_ _09129_ _09132_ VPWR VGND sg13g2_a21o_1
X_32746_ _09134_ \memory_i.freq_inst.dsmod_sin.data_pre_r[35]\ VPWR VGND sg13g2_inv_1
X_32747_ _09135_ _09134_ _09098_ _09129_ _09131_ VPWR
+ VGND
+ sg13g2_nand4_1
X_32748_ _09136_ \memory_i.freq_inst.dsmod_cos.i_osr[0]\ _09134_ _09130_ VPWR VGND sg13g2_nand3_1
X_32749_ _09137_ _09098_ _09129_ _09136_ VPWR VGND sg13g2_a21o_1
X_32750_ _09138_ _06022_ _09134_ _09130_ VPWR VGND sg13g2_nor3_1
X_32751_ _09139_ \memory_i.freq_inst.dsmod_sin.data_ext_w[35]\ _09138_ VPWR VGND sg13g2_nor2_1
X_32752_ _09140_ _09133_ _09135_ _09137_ _09139_ VPWR
+ VGND
+ sg13g2_nand4_1
X_32753_ _09141_ \memory_i.freq_inst.dsmod_sin.data_ext_w[36]\ \memory_i.freq_inst.dsmod_sin.data_pre_r[36]\ VPWR VGND sg13g2_xnor2_1
X_32754_ _09142_ \memory_i.freq_inst.dsmod_sin.data_ext_w[35]\ \memory_i.freq_inst.dsmod_cos.i_osr[0]\ _09141_ VPWR VGND sg13g2_nand3_1
X_32755_ _09143_ \memory_i.freq_inst.dsmod_sin.data_pre_r[35]\ _09097_ VPWR VGND sg13g2_and2_1
X_32756_ _09144_ _09129_ _09143_ VPWR VGND sg13g2_and2_1
X_32757_ _09145_ _09144_ VPWR VGND sg13g2_buf_4
X_32758_ _09146_ _09142_ _09131_ _09145_ VPWR VGND sg13g2_mux2_1
X_32759_ _09147_ \memory_i.freq_inst.dsmod_cos.i_osr[0]\ \memory_i.freq_inst.dsmod_sin.data_ext_w[35]\ VPWR VGND sg13g2_nor2b_1
X_32760_ _09148_ \memory_i.freq_inst.dsmod_sin.data_pre_r[35]\ _09147_ VPWR VGND sg13g2_nand2_1
X_32761_ _09149_ _09098_ _09129_ _09148_ VPWR VGND sg13g2_a21oi_1
X_32762_ _09150_ _09134_ _09098_ _09129_ _09147_ VPWR
+ VGND
+ sg13g2_nand4_1
X_32763_ _09151_ _09149_ _09150_ VPWR VGND sg13g2_nor2b_1
X_32764_ _09152_ \memory_i.freq_inst.dsmod_cos.i_osr[1]\ _09140_ _09146_ _09151_ VPWR
+ VGND
+ sg13g2_and4_1
X_32765_ _09153_ _06629_ _09076_ _09152_ VPWR VGND sg13g2_a21oi_1
X_32766_ _09154_ \memory_i.freq_inst.dsmod_sin.data_step_r[28]\ _08287_ \memory_i.freq_inst.cordic.rstn_i\ VPWR VGND sg13g2_o21ai_1
X_32767_ _01836_ _08234_ _09153_ _09154_ VPWR VGND sg13g2_a21oi_1
X_32768_ _09155_ \memory_i.freq_inst.dsmod_sin.data_ext_w[37]\ \memory_i.freq_inst.dsmod_sin.data_pre_r[37]\ VPWR VGND sg13g2_xnor2_1
X_32769_ _09156_ \memory_i.freq_inst.dsmod_sin.data_pre_r[35]\ _09097_ VPWR VGND sg13g2_nor2_1
X_32770_ _09157_ \memory_i.freq_inst.dsmod_sin.data_ext_w[34]\ _09134_ _09108_ _09113_ VPWR
+ VGND
+ sg13g2_and4_1
X_32771_ _09158_ \memory_i.freq_inst.dsmod_sin.data_ext_w[35]\ _09156_ _09157_ VPWR VGND sg13g2_nor3_1
X_32772_ _09159_ \memory_i.freq_inst.dsmod_sin.data_ext_w[36]\ \memory_i.freq_inst.dsmod_sin.data_pre_r[36]\ _09145_ _09158_ VPWR
+ VGND
+ sg13g2_nor4_2
X_32773_ _09160_ _09155_ _09159_ _03154_ VPWR VGND sg13g2_a21oi_1
X_32774_ _09161_ _09155_ VPWR VGND sg13g2_inv_1
X_32775_ _09162_ \memory_i.freq_inst.dsmod_sin.data_pre_r[36]\ _09129_ _09143_ VPWR VGND sg13g2_nand3_1
X_32776_ _09163_ \memory_i.freq_inst.dsmod_sin.data_pre_r[36]\ VPWR VGND sg13g2_inv_1
X_32777_ _09164_ \memory_i.freq_inst.dsmod_sin.data_ext_w[35]\ _09163_ _09156_ _09157_ VPWR
+ VGND
+ sg13g2_or4_1
X_32778_ _09165_ \memory_i.freq_inst.dsmod_sin.data_ext_w[36]\ _09134_ VPWR VGND sg13g2_nor2_1
X_32779_ _09166_ _09098_ _09165_ VPWR VGND sg13g2_and2_1
X_32780_ _09167_ \memory_i.freq_inst.dsmod_sin.data_ext_w[36]\ \memory_i.freq_inst.dsmod_sin.data_ext_w[35]\ VPWR VGND sg13g2_nor2_1
X_32781_ _09168_ _09098_ _09167_ VPWR VGND sg13g2_and2_1
X_32782_ _09169_ _09166_ _09168_ _09129_ VPWR VGND sg13g2_o21ai_1
X_32783_ _09170_ \memory_i.freq_inst.dsmod_sin.data_ext_w[36]\ _09163_ VPWR VGND sg13g2_nor2_1
X_32784_ _09171_ \memory_i.freq_inst.dsmod_sin.data_pre_r[35]\ _09167_ _09170_ VPWR VGND sg13g2_a21oi_1
X_32785_ _09172_ _09162_ _09164_ _09169_ _09171_ VPWR
+ VGND
+ sg13g2_nand4_1
X_32786_ _09173_ \memory_i.freq_inst.dsmod_cos.i_osr[0]\ _09161_ _09172_ VPWR VGND sg13g2_nand3_1
X_32787_ _09174_ \memory_i.freq_inst.dsmod_sin.data_ext_w[36]\ \memory_i.freq_inst.dsmod_cos.i_osr[0]\ VPWR VGND sg13g2_and2_1
X_32788_ _09175_ _09155_ _09162_ _09164_ _09174_ VPWR
+ VGND
+ sg13g2_nand4_1
X_32789_ _09176_ _09145_ _09158_ VPWR VGND sg13g2_or2_1
X_32790_ _09177_ _09176_ VPWR VGND sg13g2_buf_4
X_32791_ _09178_ \memory_i.freq_inst.dsmod_cos.i_osr[0]\ _09141_ VPWR VGND sg13g2_nor2_1
X_32792_ _09179_ \memory_i.freq_inst.dsmod_cos.i_osr[0]\ _09130_ _09145_ _09158_ VPWR
+ VGND
+ sg13g2_nor4_1
X_32793_ _09180_ _09177_ _09178_ _09179_ VPWR VGND sg13g2_a21oi_1
X_32794_ _09181_ _09160_ _09173_ _09175_ _09180_ VPWR
+ VGND
+ sg13g2_nand4_1
X_32795_ _09182_ _06629_ _09125_ _08606_ VPWR VGND sg13g2_a21oi_1
X_32796_ _09183_ \memory_i.freq_inst.dsmod_sin.data_step_r[29]\ _08287_ \memory_i.freq_inst.cordic.rstn_i\ VPWR VGND sg13g2_o21ai_1
X_32797_ _01837_ _09181_ _09182_ _09183_ VPWR VGND sg13g2_a21oi_1
X_32798_ _09184_ _09161_ _09172_ VPWR VGND sg13g2_xnor2_1
X_32799_ _09185_ \memory_i.freq_inst.dsmod_cos.i_osr[1]\ _09184_ VPWR VGND sg13g2_and2_1
X_32800_ _09186_ _09140_ _09146_ _09151_ VPWR VGND sg13g2_nand3_1
X_32801_ _09187_ \memory_i.freq_inst.cordic.rstn_i\ _15815_ VPWR VGND sg13g2_nand2_1
X_32802_ _09188_ _06629_ _09186_ _09187_ VPWR VGND sg13g2_a21o_1
X_32803_ _09189_ \memory_i.freq_inst.cordic.rstn_i\ \memory_i.freq_inst.dsmod_sin.data_step_r[30]\ _08577_ VPWR VGND sg13g2_nand3_1
X_32804_ _01838_ _09185_ _09188_ _09189_ VPWR VGND sg13g2_o21ai_1
X_32805_ _09190_ _03147_ _09155_ VPWR VGND sg13g2_nor2_1
X_32806_ _09191_ _09170_ _09190_ VPWR VGND sg13g2_nand2_1
X_32807_ _09192_ _09190_ VPWR VGND sg13g2_inv_1
X_32808_ _09193_ \memory_i.freq_inst.dsmod_sin.data_ext_w[36]\ _09192_ VPWR VGND sg13g2_nor2_1
X_32809_ _09194_ _03147_ _09170_ VPWR VGND sg13g2_and2_1
X_32810_ _09195_ _09193_ _09194_ _09177_ VPWR VGND sg13g2_o21ai_1
X_32811_ _09196_ _09191_ _09195_ VPWR VGND sg13g2_nand2_1
X_32812_ _09197_ \memory_i.freq_inst.dsmod_cos.i_osr[1]\ \memory_i.freq_inst.dsmod_cos.i_osr[0]\ _09145_ _09158_ VPWR
+ VGND
+ sg13g2_nor4_1
X_32813_ _09198_ _09177_ _09197_ _09163_ VPWR VGND sg13g2_mux2_1
X_32814_ _09199_ \memory_i.freq_inst.dsmod_sin.data_ext_w[36]\ _09192_ VPWR VGND sg13g2_nand2_1
X_32815_ _09200_ _09163_ _09192_ VPWR VGND sg13g2_nor2_1
X_32816_ _09201_ _09159_ _09192_ _09200_ _09177_ _09187_
+ VPWR
+ VGND sg13g2_a221oi_1
X_32817_ _09202_ _09198_ _09199_ _09201_ VPWR VGND sg13g2_o21ai_1
X_32818_ _09203_ \memory_i.freq_inst.cordic.rstn_i\ \memory_i.freq_inst.dsmod_sin.data_step_r[31]\ _08577_ VPWR VGND sg13g2_nand3_1
X_32819_ _01839_ _09196_ _09202_ _09203_ VPWR VGND sg13g2_o21ai_1
X_32820_ _09204_ \memory_i.freq_inst.dsmod_sin.data_step_r[32]\ _08660_ VPWR VGND sg13g2_nand2_1
X_32821_ _09205_ _08660_ _09184_ _09204_ VPWR VGND sg13g2_o21ai_1
X_32822_ _01840_ \memory_i.freq_inst.cordic.rstn_i\ _09205_ VPWR VGND sg13g2_and2_1
X_32823_ _09206_ \memory_i.freq_inst.dsmod_cos.i_ena_mod\ \memory_i.freq_inst.dsmod_sin.data_interp_r[0]\ VPWR VGND sg13g2_nand2_1
X_32824_ _09207_ \memory_i.freq_inst.dsmod_sin.accu1_r[0]\ _09206_ VPWR VGND sg13g2_xor2_1
X_32825_ _01841_ _08722_ _09207_ VPWR VGND sg13g2_nor2_1
X_32826_ _09208_ \memory_i.freq_inst.dsmod_sin.accu1_r[0]\ \memory_i.freq_inst.dsmod_sin.data_interp_r[0]\ VPWR VGND sg13g2_nand2_1
X_32827_ _09209_ \memory_i.freq_inst.dsmod_sin.data_interp_r[1]\ _09208_ VPWR VGND sg13g2_xnor2_1
X_32828_ _09210_ \memory_i.freq_inst.dsmod_cos.i_ena_mod\ _09209_ VPWR VGND sg13g2_nand2_1
X_32829_ _09211_ \memory_i.freq_inst.dsmod_sin.accu1_r[1]\ _09210_ VPWR VGND sg13g2_xor2_1
X_32830_ _01842_ _08722_ _09211_ VPWR VGND sg13g2_nor2_1
X_32831_ _09212_ \memory_i.freq_inst.dsmod_sin.accu1_r[0]\ \memory_i.freq_inst.dsmod_sin.data_interp_r[0]\ \memory_i.freq_inst.dsmod_sin.data_interp_r[1]\ VPWR VGND sg13g2_a21o_1
X_32832_ _09213_ \memory_i.freq_inst.dsmod_sin.accu1_r[0]\ \memory_i.freq_inst.dsmod_sin.data_interp_r[1]\ \memory_i.freq_inst.dsmod_sin.data_interp_r[0]\ VPWR VGND sg13g2_and3_1
X_32833_ _09214_ \memory_i.freq_inst.dsmod_sin.accu1_r[1]\ _09212_ _09213_ VPWR VGND sg13g2_a21oi_1
X_32834_ _09215_ \memory_i.freq_inst.dsmod_sin.data_interp_r[2]\ _09214_ VPWR VGND sg13g2_xnor2_1
X_32835_ _09216_ \memory_i.freq_inst.dsmod_cos.i_ena_mod\ _09215_ VPWR VGND sg13g2_nand2_1
X_32836_ _09217_ \memory_i.freq_inst.dsmod_sin.accu1_r[2]\ _09216_ VPWR VGND sg13g2_xor2_1
X_32837_ _01843_ _08722_ _09217_ VPWR VGND sg13g2_nor2_1
X_32838_ _09218_ \memory_i.freq_inst.dsmod_sin.accu1_r[2]\ \memory_i.freq_inst.dsmod_sin.data_interp_r[2]\ VPWR VGND sg13g2_nor2_1
X_32839_ _09219_ \memory_i.freq_inst.dsmod_sin.accu1_r[2]\ \memory_i.freq_inst.dsmod_sin.data_interp_r[2]\ VPWR VGND sg13g2_nand2_1
X_32840_ _09220_ _09214_ _09218_ _09219_ VPWR VGND sg13g2_o21ai_1
X_32841_ _09221_ \memory_i.freq_inst.dsmod_sin.data_interp_r[3]\ _09220_ VPWR VGND sg13g2_or2_1
X_32842_ _09222_ \memory_i.freq_inst.dsmod_sin.data_interp_r[3]\ _09220_ VPWR VGND sg13g2_nand2_1
X_32843_ _09223_ \memory_i.freq_inst.dsmod_cos.i_ena_mod\ _09221_ _09222_ VPWR VGND sg13g2_nand3_1
X_32844_ _09224_ \memory_i.freq_inst.dsmod_sin.accu1_r[3]\ _09223_ VPWR VGND sg13g2_xor2_1
X_32845_ _01844_ _08722_ _09224_ VPWR VGND sg13g2_nor2_1
X_32846_ _09225_ \memory_i.freq_inst.dsmod_sin.accu1_r[4]\ VPWR VGND sg13g2_inv_1
X_32847_ _09226_ \memory_i.freq_inst.dsmod_sin.data_interp_r[4]\ VPWR VGND sg13g2_inv_1
X_32848_ _09227_ \memory_i.freq_inst.dsmod_sin.data_interp_r[3]\ _09220_ \memory_i.freq_inst.dsmod_sin.accu1_r[3]\ VPWR VGND sg13g2_o21ai_1
X_32849_ _09228_ _09222_ _09227_ VPWR VGND sg13g2_nand2_1
X_32850_ _09229_ _09226_ _09228_ VPWR VGND sg13g2_xnor2_1
X_32851_ _09230_ \memory_i.freq_inst.dsmod_cos.i_ena_mod\ _09229_ VPWR VGND sg13g2_nand2_1
X_32852_ _09231_ _09225_ _09230_ VPWR VGND sg13g2_xnor2_1
X_32853_ _01845_ _08722_ _09231_ VPWR VGND sg13g2_nor2_1
X_32854_ _09232_ \memory_i.freq_inst.dsmod_sin.accu1_r[5]\ VPWR VGND sg13g2_inv_1
X_32855_ _09233_ _09225_ _09226_ VPWR VGND sg13g2_nor2_1
X_32856_ _09234_ _09225_ _09226_ _09222_ _09227_ VPWR
+ VGND
+ sg13g2_a22oi_1
X_32857_ _09235_ \memory_i.freq_inst.dsmod_sin.data_interp_r[5]\ _09233_ _09234_ VPWR VGND sg13g2_nor3_1
X_32858_ _09236_ _09233_ _09234_ \memory_i.freq_inst.dsmod_sin.data_interp_r[5]\ VPWR VGND sg13g2_o21ai_1
X_32859_ _09237_ _09235_ _09236_ \memory_i.freq_inst.dsmod_cos.i_ena_mod\ VPWR VGND sg13g2_nand3b_1
X_32860_ _09238_ _09232_ _09237_ VPWR VGND sg13g2_xnor2_1
X_32861_ _01846_ _08722_ _09238_ VPWR VGND sg13g2_nor2_1
X_32862_ _09239_ _08021_ VPWR VGND sg13g2_buf_1
X_32863_ _09240_ _09232_ _09235_ _09236_ VPWR VGND sg13g2_o21ai_1
X_32864_ _09241_ \memory_i.freq_inst.dsmod_sin.data_interp_r[6]\ _09240_ VPWR VGND sg13g2_xnor2_1
X_32865_ _09242_ _07821_ _09241_ VPWR VGND sg13g2_nor2_1
X_32866_ _09243_ \memory_i.freq_inst.dsmod_sin.accu1_r[6]\ _09242_ VPWR VGND sg13g2_xnor2_1
X_32867_ _01847_ _09239_ _09243_ VPWR VGND sg13g2_nor2_1
X_32868_ _09244_ \memory_i.freq_inst.dsmod_sin.accu1_r[6]\ \memory_i.freq_inst.dsmod_sin.data_interp_r[6]\ VPWR VGND sg13g2_or2_1
X_32869_ _09245_ \memory_i.freq_inst.dsmod_sin.accu1_r[6]\ \memory_i.freq_inst.dsmod_sin.data_interp_r[6]\ VPWR VGND sg13g2_and2_1
X_32870_ _09246_ _09240_ _09244_ _09245_ VPWR VGND sg13g2_a21o_1
X_32871_ _09247_ _09246_ VPWR VGND sg13g2_buf_1
X_32872_ _09248_ \memory_i.freq_inst.dsmod_sin.data_interp_r[7]\ _09247_ VPWR VGND sg13g2_nor2_1
X_32873_ _09249_ \memory_i.freq_inst.dsmod_sin.data_interp_r[7]\ _09247_ VPWR VGND sg13g2_and2_1
X_32874_ _09250_ _05783_ _09248_ _09249_ VPWR VGND sg13g2_nor3_1
X_32875_ _09251_ \memory_i.freq_inst.dsmod_sin.accu1_r[7]\ _09250_ VPWR VGND sg13g2_xnor2_1
X_32876_ _01848_ _09239_ _09251_ VPWR VGND sg13g2_nor2_1
X_32877_ _09252_ \memory_i.freq_inst.dsmod_sin.data_interp_r[8]\ VPWR VGND sg13g2_inv_1
X_32878_ _09253_ \memory_i.freq_inst.dsmod_sin.data_interp_r[7]\ _09247_ \memory_i.freq_inst.dsmod_sin.accu1_r[7]\ VPWR VGND sg13g2_a21oi_1
X_32879_ _09254_ _09252_ _09248_ _09253_ VPWR VGND sg13g2_nor3_1
X_32880_ _09255_ _09248_ _09253_ _09252_ VPWR VGND sg13g2_o21ai_1
X_32881_ _09256_ _09254_ \memory_i.freq_inst.dsmod_cos.i_ena_mod\ _09255_ VPWR VGND sg13g2_nand3b_1
X_32882_ _09257_ \memory_i.freq_inst.dsmod_sin.accu1_r[8]\ _09256_ VPWR VGND sg13g2_xor2_1
X_32883_ _01849_ _09239_ _09257_ VPWR VGND sg13g2_nor2_1
X_32884_ _09258_ \memory_i.freq_inst.dsmod_sin.accu1_r[8]\ \memory_i.freq_inst.dsmod_sin.data_interp_r[8]\ VPWR VGND sg13g2_and2_1
X_32885_ _09259_ \memory_i.freq_inst.dsmod_sin.accu1_r[8]\ \memory_i.freq_inst.dsmod_sin.data_interp_r[8]\ VPWR VGND sg13g2_nor2_1
X_32886_ _09260_ _09248_ _09253_ _09259_ VPWR VGND sg13g2_nor3_1
X_32887_ _09261_ _09258_ _09260_ VPWR VGND sg13g2_nor2_1
X_32888_ _09262_ \memory_i.freq_inst.dsmod_sin.data_interp_r[9]\ _09261_ VPWR VGND sg13g2_xnor2_1
X_32889_ _09263_ \memory_i.freq_inst.dsmod_cos.i_ena_mod\ _09262_ VPWR VGND sg13g2_nand2_1
X_32890_ _09264_ \memory_i.freq_inst.dsmod_sin.accu1_r[9]\ _09263_ VPWR VGND sg13g2_xor2_1
X_32891_ _01850_ _09239_ _09264_ VPWR VGND sg13g2_nor2_1
X_32892_ _09265_ \memory_i.freq_inst.dsmod_sin.accu1_r[9]\ \memory_i.freq_inst.dsmod_sin.data_interp_r[9]\ VPWR VGND sg13g2_nor2_1
X_32893_ _09266_ \memory_i.freq_inst.dsmod_sin.accu1_r[9]\ \memory_i.freq_inst.dsmod_sin.data_interp_r[9]\ VPWR VGND sg13g2_nand2_1
X_32894_ _09267_ _09261_ _09265_ _09266_ VPWR VGND sg13g2_o21ai_1
X_32895_ _09268_ _09267_ VPWR VGND sg13g2_buf_1
X_32896_ _09269_ \memory_i.freq_inst.dsmod_sin.data_interp_r[10]\ _09268_ VPWR VGND sg13g2_xnor2_1
X_32897_ _09270_ _07821_ _09269_ VPWR VGND sg13g2_nor2_1
X_32898_ _09271_ \memory_i.freq_inst.dsmod_sin.accu1_r[10]\ _09270_ VPWR VGND sg13g2_xnor2_1
X_32899_ _01851_ _09239_ _09271_ VPWR VGND sg13g2_nor2_1
X_32900_ _09272_ \memory_i.freq_inst.dsmod_sin.accu1_r[10]\ \memory_i.freq_inst.dsmod_sin.data_interp_r[10]\ VPWR VGND sg13g2_nor2_1
X_32901_ _09273_ _09272_ _09268_ VPWR VGND sg13g2_nand2b_1
X_32902_ _09274_ \memory_i.freq_inst.dsmod_sin.accu1_r[10]\ \memory_i.freq_inst.dsmod_sin.data_interp_r[10]\ VPWR VGND sg13g2_nand2_1
X_32903_ _09275_ _09273_ _09274_ VPWR VGND sg13g2_nand2_1
X_32904_ _09276_ \memory_i.freq_inst.dsmod_sin.data_interp_r[11]\ _09275_ VPWR VGND sg13g2_xor2_1
X_32905_ _09277_ \memory_i.freq_inst.dsmod_cos.i_ena_mod\ _09276_ VPWR VGND sg13g2_nand2_1
X_32906_ _09278_ \memory_i.freq_inst.dsmod_sin.accu1_r[11]\ _09277_ VPWR VGND sg13g2_xor2_1
X_32907_ _01852_ _09239_ _09278_ VPWR VGND sg13g2_nor2_1
X_32908_ _09279_ \memory_i.freq_inst.dsmod_sin.accu1_r[11]\ _09275_ VPWR VGND sg13g2_nand2_1
X_32909_ _09280_ _09272_ \memory_i.freq_inst.dsmod_sin.data_interp_r[11]\ VPWR VGND sg13g2_nor2b_1
X_32910_ _09281_ \memory_i.freq_inst.dsmod_sin.accu1_r[10]\ \memory_i.freq_inst.dsmod_sin.data_interp_r[10]\ \memory_i.freq_inst.dsmod_sin.accu1_r[11]\ VPWR VGND sg13g2_a21oi_1
X_32911_ _09282_ _09281_ \memory_i.freq_inst.dsmod_sin.data_interp_r[11]\ VPWR VGND sg13g2_nor2b_1
X_32912_ _09283_ _09268_ _09280_ _09282_ VPWR VGND sg13g2_a21oi_1
X_32913_ _09284_ _09279_ _09283_ VPWR VGND sg13g2_nand2_1
X_32914_ _09285_ \memory_i.freq_inst.dsmod_sin.data_interp_r[12]\ _09284_ VPWR VGND sg13g2_nor2_1
X_32915_ _09286_ _09279_ _09283_ _08353_ VPWR VGND sg13g2_a21oi_1
X_32916_ _09287_ _05783_ _09285_ _09286_ VPWR VGND sg13g2_nor3_1
X_32917_ _09288_ \memory_i.freq_inst.dsmod_sin.accu1_r[12]\ _09287_ VPWR VGND sg13g2_xnor2_1
X_32918_ _01853_ _09239_ _09288_ VPWR VGND sg13g2_nor2_1
X_32919_ _09289_ \memory_i.freq_inst.dsmod_sin.data_interp_r[12]\ _09284_ \memory_i.freq_inst.dsmod_sin.accu1_r[12]\ VPWR VGND sg13g2_a21oi_1
X_32920_ _09290_ _09285_ _09289_ VPWR VGND sg13g2_nor2_1
X_32921_ _09291_ \memory_i.freq_inst.dsmod_sin.data_interp_r[13]\ _09290_ VPWR VGND sg13g2_xor2_1
X_32922_ _09292_ \memory_i.freq_inst.dsmod_cos.i_ena_mod\ _09291_ VPWR VGND sg13g2_nand2_1
X_32923_ _09293_ \memory_i.freq_inst.dsmod_sin.accu1_r[13]\ _09292_ VPWR VGND sg13g2_xor2_1
X_32924_ _01854_ _09239_ _09293_ VPWR VGND sg13g2_nor2_1
X_32925_ _09294_ _09265_ _09274_ VPWR VGND sg13g2_nand2_1
X_32926_ _09295_ _09272_ _09294_ \memory_i.freq_inst.dsmod_sin.accu1_r[11]\ VPWR VGND sg13g2_nand3b_1
X_32927_ _09296_ _09266_ _09274_ VPWR VGND sg13g2_nand2_1
X_32928_ _09297_ _09258_ _09260_ _09296_ VPWR VGND sg13g2_nor3_1
X_32929_ _09298_ \memory_i.freq_inst.dsmod_sin.accu1_r[13]\ \memory_i.freq_inst.dsmod_sin.data_interp_r[13]\ \memory_i.freq_inst.dsmod_sin.data_interp_r[12]\ VPWR VGND sg13g2_a21oi_1
X_32930_ _09299_ _09295_ _09297_ _09298_ VPWR VGND sg13g2_o21ai_1
X_32931_ _09300_ \memory_i.freq_inst.dsmod_sin.accu1_r[13]\ \memory_i.freq_inst.dsmod_sin.data_interp_r[13]\ \memory_i.freq_inst.dsmod_sin.accu1_r[12]\ VPWR VGND sg13g2_a21oi_1
X_32932_ _09301_ _09295_ _09297_ _09300_ VPWR VGND sg13g2_o21ai_1
X_32933_ _09302_ _09268_ _09280_ _09299_ _09301_ _09282_
+ VPWR
+ VGND sg13g2_a221oi_1
X_32934_ _09303_ _09302_ VPWR VGND sg13g2_buf_1
X_32935_ _09304_ \memory_i.freq_inst.dsmod_sin.accu1_r[13]\ \memory_i.freq_inst.dsmod_sin.data_interp_r[13]\ VPWR VGND sg13g2_nand2_1
X_32936_ _09305_ \memory_i.freq_inst.dsmod_sin.accu1_r[12]\ _08353_ _09304_ VPWR VGND sg13g2_nand3b_1
X_32937_ _09306_ \memory_i.freq_inst.dsmod_sin.accu1_r[13]\ \memory_i.freq_inst.dsmod_sin.data_interp_r[13]\ _09305_ VPWR VGND sg13g2_o21ai_1
X_32938_ _09307_ _09306_ VPWR VGND sg13g2_buf_1
X_32939_ _09308_ _09303_ _09307_ VPWR VGND sg13g2_or2_1
X_32940_ _09309_ _09308_ VPWR VGND sg13g2_buf_1
X_32941_ _09310_ \memory_i.freq_inst.dsmod_sin.data_interp_r[14]\ _09309_ VPWR VGND sg13g2_xnor2_1
X_32942_ _09311_ \memory_i.freq_inst.dsmod_cos.i_ena_mod\ _09310_ VPWR VGND sg13g2_nand2_1
X_32943_ _09312_ \memory_i.freq_inst.dsmod_sin.accu1_r[14]\ _09311_ VPWR VGND sg13g2_xor2_1
X_32944_ _01855_ _09239_ _09312_ VPWR VGND sg13g2_nor2_1
X_32945_ _09313_ _08358_ _09309_ VPWR VGND sg13g2_nor2_1
X_32946_ _09314_ _08358_ _09309_ VPWR VGND sg13g2_nand2_1
X_32947_ _09315_ \memory_i.freq_inst.dsmod_sin.accu1_r[14]\ _09313_ _09314_ VPWR VGND sg13g2_o21ai_1
X_32948_ _09316_ \memory_i.freq_inst.dsmod_sin.data_interp_r[15]\ _09315_ VPWR VGND sg13g2_xnor2_1
X_32949_ _09317_ \memory_i.freq_inst.dsmod_cos.i_ena_mod\ _09316_ VPWR VGND sg13g2_nand2_1
X_32950_ _09318_ \memory_i.freq_inst.dsmod_sin.accu1_r[15]\ _09317_ VPWR VGND sg13g2_xor2_1
X_32951_ _01856_ _09239_ _09318_ VPWR VGND sg13g2_nor2_1
X_32952_ _09319_ _08021_ VPWR VGND sg13g2_buf_1
X_32953_ _09320_ \memory_i.freq_inst.dsmod_sin.accu1_r[15]\ \memory_i.freq_inst.dsmod_sin.data_interp_r[15]\ VPWR VGND sg13g2_and2_1
X_32954_ _09321_ _09320_ VPWR VGND sg13g2_buf_1
X_32955_ _09322_ \memory_i.freq_inst.dsmod_sin.data_interp_r[16]\ \memory_i.freq_inst.dsmod_sin.data_interp_r[14]\ _09321_ VPWR VGND sg13g2_nor3_1
X_32956_ _09323_ _09303_ _09307_ _09322_ VPWR VGND sg13g2_o21ai_1
X_32957_ _09324_ \memory_i.freq_inst.dsmod_sin.accu1_r[14]\ \memory_i.freq_inst.dsmod_sin.data_interp_r[16]\ _09321_ VPWR VGND sg13g2_nor3_1
X_32958_ _09325_ _09303_ _09307_ _09324_ VPWR VGND sg13g2_o21ai_1
X_32959_ _09326_ _09323_ _09325_ VPWR VGND sg13g2_and2_1
X_32960_ _09327_ \memory_i.freq_inst.dsmod_sin.accu1_r[15]\ \memory_i.freq_inst.dsmod_sin.data_interp_r[15]\ VPWR VGND sg13g2_or2_1
X_32961_ _09328_ _09327_ VPWR VGND sg13g2_buf_1
X_32962_ _09329_ \memory_i.freq_inst.dsmod_sin.data_interp_r[16]\ _09328_ VPWR VGND sg13g2_nor2_1
X_32963_ _09330_ _08358_ _09324_ _09329_ VPWR VGND sg13g2_a21oi_1
X_32964_ _09331_ \memory_i.freq_inst.dsmod_sin.data_interp_r[16]\ \memory_i.freq_inst.dsmod_sin.data_interp_r[14]\ _09328_ VPWR VGND sg13g2_nand3_1
X_32965_ _09332_ _09303_ _09307_ _09331_ VPWR VGND sg13g2_nor3_1
X_32966_ _09333_ \memory_i.freq_inst.dsmod_sin.accu1_r[14]\ \memory_i.freq_inst.dsmod_sin.data_interp_r[16]\ _09328_ VPWR VGND sg13g2_nand3_1
X_32967_ _09334_ _09303_ _09307_ _09333_ VPWR VGND sg13g2_nor3_1
X_32968_ _09335_ \memory_i.freq_inst.dsmod_sin.data_interp_r[16]\ _09321_ VPWR VGND sg13g2_nand2_1
X_32969_ _09336_ _08358_ _09333_ _09335_ VPWR VGND sg13g2_o21ai_1
X_32970_ _09337_ _09332_ _09334_ _09336_ VPWR VGND sg13g2_nor3_1
X_32971_ _09338_ \memory_i.freq_inst.dsmod_cos.i_ena_mod\ _09326_ _09330_ _09337_ VPWR
+ VGND
+ sg13g2_nand4_1
X_32972_ _09339_ \memory_i.freq_inst.dsmod_sin.accu1_r[16]\ _09338_ VPWR VGND sg13g2_xor2_1
X_32973_ _01857_ _09319_ _09339_ VPWR VGND sg13g2_nor2_1
X_32974_ _09340_ \memory_i.freq_inst.dsmod_sin.accu1_r[16]\ _09323_ _09325_ _09330_ VPWR
+ VGND
+ sg13g2_nand4_1
X_32975_ _09341_ _09337_ _09340_ VPWR VGND sg13g2_nand2_1
X_32976_ _09342_ _08394_ _09341_ VPWR VGND sg13g2_xnor2_1
X_32977_ _09343_ \memory_i.freq_inst.dsmod_cos.i_ena_mod\ _09342_ VPWR VGND sg13g2_nand2_1
X_32978_ _09344_ \memory_i.freq_inst.dsmod_sin.accu1_r[17]\ _09343_ VPWR VGND sg13g2_xor2_1
X_32979_ _01858_ _09319_ _09344_ VPWR VGND sg13g2_nor2_1
X_32980_ _09345_ \memory_i.freq_inst.dsmod_sin.accu1_r[17]\ \memory_i.freq_inst.dsmod_sin.data_interp_r[17]\ VPWR VGND sg13g2_or2_1
X_32981_ _09346_ \memory_i.freq_inst.dsmod_sin.accu1_r[17]\ \memory_i.freq_inst.dsmod_sin.data_interp_r[17]\ VPWR VGND sg13g2_nand2_1
X_32982_ _09347_ _09346_ VPWR VGND sg13g2_inv_1
X_32983_ _09348_ _09341_ _09345_ _09347_ VPWR VGND sg13g2_a21o_1
X_32984_ _09349_ \memory_i.freq_inst.dsmod_sin.data_interp_r[18]\ _09348_ VPWR VGND sg13g2_xnor2_1
X_32985_ _09350_ _07821_ _09349_ VPWR VGND sg13g2_nor2_1
X_32986_ _09351_ \memory_i.freq_inst.dsmod_sin.accu1_r[18]\ _09350_ VPWR VGND sg13g2_xnor2_1
X_32987_ _01859_ _09319_ _09351_ VPWR VGND sg13g2_nor2_1
X_32988_ _09352_ \memory_i.freq_inst.dsmod_sin.data_interp_r[18]\ _09346_ VPWR VGND sg13g2_nand2b_1
X_32989_ _09353_ _09332_ _09334_ _09336_ _09352_ VPWR
+ VGND
+ sg13g2_nor4_1
X_32990_ _09354_ \memory_i.freq_inst.dsmod_sin.accu1_r[18]\ _09346_ VPWR VGND sg13g2_nand2b_1
X_32991_ _09355_ _09332_ _09334_ _09336_ _09354_ VPWR
+ VGND
+ sg13g2_nor4_1
X_32992_ _09356_ _09353_ _09355_ _09340_ VPWR VGND sg13g2_o21ai_1
X_32993_ _09357_ \memory_i.freq_inst.dsmod_sin.accu1_r[18]\ \memory_i.freq_inst.dsmod_sin.data_interp_r[18]\ VPWR VGND sg13g2_nor2_1
X_32994_ _09358_ \memory_i.freq_inst.dsmod_sin.accu1_r[18]\ \memory_i.freq_inst.dsmod_sin.data_interp_r[18]\ _09345_ VPWR VGND sg13g2_a21oi_1
X_32995_ _09359_ _09357_ _09358_ VPWR VGND sg13g2_nor2_1
X_32996_ _09360_ _09356_ _09359_ VPWR VGND sg13g2_and2_1
X_32997_ _09361_ _09360_ VPWR VGND sg13g2_buf_1
X_32998_ _09362_ \memory_i.freq_inst.dsmod_sin.data_interp_r[19]\ _09361_ VPWR VGND sg13g2_nor2_1
X_32999_ _09363_ \memory_i.freq_inst.dsmod_sin.data_interp_r[19]\ _09361_ VPWR VGND sg13g2_and2_1
X_33000_ _09364_ _05783_ _09362_ _09363_ VPWR VGND sg13g2_nor3_1
X_33001_ _09365_ \memory_i.freq_inst.dsmod_sin.accu1_r[19]\ _09364_ VPWR VGND sg13g2_xnor2_1
X_33002_ _01860_ _09319_ _09365_ VPWR VGND sg13g2_nor2_1
X_33003_ _09366_ \memory_i.freq_inst.dsmod_sin.accu1_r[19]\ \memory_i.freq_inst.dsmod_sin.data_interp_r[19]\ VPWR VGND sg13g2_or2_1
X_33004_ _09367_ _09366_ VPWR VGND sg13g2_buf_1
X_33005_ _09368_ \memory_i.freq_inst.dsmod_sin.accu1_r[19]\ \memory_i.freq_inst.dsmod_sin.data_interp_r[19]\ VPWR VGND sg13g2_and2_1
X_33006_ _09369_ _09361_ _09367_ _09368_ VPWR VGND sg13g2_a21o_1
X_33007_ _09370_ \memory_i.freq_inst.dsmod_sin.data_interp_r[20]\ _09369_ VPWR VGND sg13g2_xnor2_1
X_33008_ _09371_ _07821_ _09370_ VPWR VGND sg13g2_nor2_1
X_33009_ _09372_ \memory_i.freq_inst.dsmod_sin.accu1_r[20]\ _09371_ VPWR VGND sg13g2_xnor2_1
X_33010_ _01861_ _09319_ _09372_ VPWR VGND sg13g2_nor2_1
X_33011_ _09373_ \memory_i.freq_inst.dsmod_sin.data_interp_r[20]\ _09356_ _09359_ _09367_ VPWR
+ VGND
+ sg13g2_nand4_1
X_33012_ _09374_ \memory_i.freq_inst.dsmod_sin.accu1_r[20]\ _09356_ _09359_ _09367_ VPWR
+ VGND
+ sg13g2_nand4_1
X_33013_ _09375_ \memory_i.freq_inst.dsmod_sin.accu1_r[20]\ \memory_i.freq_inst.dsmod_sin.data_interp_r[20]\ _09368_ VPWR VGND sg13g2_o21ai_1
X_33014_ _09376_ \memory_i.freq_inst.dsmod_sin.accu1_r[20]\ \memory_i.freq_inst.dsmod_sin.data_interp_r[20]\ VPWR VGND sg13g2_nand2_1
X_33015_ _09377_ _09373_ _09374_ _09375_ _09376_ VPWR
+ VGND
+ sg13g2_nand4_1
X_33016_ _09378_ _09377_ VPWR VGND sg13g2_buf_1
X_33017_ _09379_ \memory_i.freq_inst.dsmod_sin.data_interp_r[21]\ _09378_ VPWR VGND sg13g2_xnor2_1
X_33018_ _09380_ _07821_ _09379_ VPWR VGND sg13g2_nor2_1
X_33019_ _09381_ \memory_i.freq_inst.dsmod_sin.accu1_r[21]\ _09380_ VPWR VGND sg13g2_xnor2_1
X_33020_ _01862_ _09319_ _09381_ VPWR VGND sg13g2_nor2_1
X_33021_ _09382_ \memory_i.freq_inst.dsmod_sin.accu1_r[22]\ VPWR VGND sg13g2_inv_1
X_33022_ _09383_ \memory_i.freq_inst.dsmod_sin.data_interp_r[21]\ _09378_ \memory_i.freq_inst.dsmod_sin.accu1_r[21]\ VPWR VGND sg13g2_a21o_1
X_33023_ _09384_ \memory_i.freq_inst.dsmod_sin.data_interp_r[21]\ _09378_ _09383_ VPWR VGND sg13g2_o21ai_1
X_33024_ _09385_ \memory_i.freq_inst.dsmod_sin.data_interp_r[22]\ _09384_ VPWR VGND sg13g2_xnor2_1
X_33025_ _09386_ \memory_i.freq_inst.dsmod_cos.i_ena_mod\ _09385_ VPWR VGND sg13g2_nand2_1
X_33026_ _09387_ _09382_ _09386_ VPWR VGND sg13g2_xnor2_1
X_33027_ _01863_ _09319_ _09387_ VPWR VGND sg13g2_nor2_1
X_33028_ _09388_ _09382_ _09384_ VPWR VGND sg13g2_nand2_1
X_33029_ _09389_ _09382_ _09384_ VPWR VGND sg13g2_nor2_1
X_33030_ _09390_ \memory_i.freq_inst.dsmod_sin.data_interp_r[22]\ _09388_ _09389_ VPWR VGND sg13g2_a21oi_1
X_33031_ _09391_ \memory_i.freq_inst.dsmod_sin.data_interp_r[23]\ _09390_ VPWR VGND sg13g2_xnor2_1
X_33032_ _09392_ \memory_i.freq_inst.dsmod_cos.i_ena_mod\ _09391_ VPWR VGND sg13g2_nand2_1
X_33033_ _09393_ \memory_i.freq_inst.dsmod_sin.accu1_r[23]\ _09392_ VPWR VGND sg13g2_xor2_1
X_33034_ _01864_ _09319_ _09393_ VPWR VGND sg13g2_nor2_1
X_33035_ _09394_ \memory_i.freq_inst.dsmod_sin.accu1_r[21]\ \memory_i.freq_inst.dsmod_sin.data_interp_r[21]\ VPWR VGND sg13g2_or2_1
X_33036_ _09395_ \memory_i.freq_inst.dsmod_sin.accu1_r[22]\ \memory_i.freq_inst.dsmod_sin.data_interp_r[22]\ _09394_ VPWR VGND sg13g2_o21ai_1
X_33037_ _09396_ \memory_i.freq_inst.dsmod_sin.accu1_r[23]\ \memory_i.freq_inst.dsmod_sin.data_interp_r[23]\ VPWR VGND sg13g2_nor2_1
X_33038_ _09397_ \memory_i.freq_inst.dsmod_sin.accu1_r[22]\ \memory_i.freq_inst.dsmod_sin.data_interp_r[22]\ _09396_ VPWR VGND sg13g2_a21oi_1
X_33039_ _09398_ _09395_ _09397_ VPWR VGND sg13g2_nand2b_1
X_33040_ _09399_ \memory_i.freq_inst.dsmod_sin.accu1_r[23]\ \memory_i.freq_inst.dsmod_sin.data_interp_r[23]\ _09398_ VPWR VGND sg13g2_a21oi_1
X_33041_ _09400_ \memory_i.freq_inst.dsmod_sin.accu1_r[21]\ \memory_i.freq_inst.dsmod_sin.data_interp_r[21]\ \memory_i.freq_inst.dsmod_sin.data_interp_r[22]\ VPWR VGND sg13g2_a21oi_1
X_33042_ _09401_ \memory_i.freq_inst.dsmod_sin.accu1_r[21]\ \memory_i.freq_inst.dsmod_sin.data_interp_r[22]\ \memory_i.freq_inst.dsmod_sin.data_interp_r[21]\ VPWR VGND sg13g2_nand3_1
X_33043_ _09402_ _09382_ _09400_ _09401_ VPWR VGND sg13g2_o21ai_1
X_33044_ _09403_ \memory_i.freq_inst.dsmod_sin.accu1_r[23]\ \memory_i.freq_inst.dsmod_sin.data_interp_r[23]\ _09402_ VPWR VGND sg13g2_a21oi_1
X_33045_ _09404_ _09396_ _09403_ VPWR VGND sg13g2_nor2_1
X_33046_ _09405_ _09378_ _09399_ _09404_ VPWR VGND sg13g2_a21oi_1
X_33047_ _09406_ _08467_ _09405_ VPWR VGND sg13g2_nor2_1
X_33048_ _09407_ _08467_ _09405_ VPWR VGND sg13g2_nand2_1
X_33049_ _09408_ _09406_ \memory_i.freq_inst.dsmod_cos.i_ena_mod\ _09407_ VPWR VGND sg13g2_nand3b_1
X_33050_ _09409_ \memory_i.freq_inst.dsmod_sin.accu1_r[24]\ _09408_ VPWR VGND sg13g2_xor2_1
X_33051_ _01865_ _09319_ _09409_ VPWR VGND sg13g2_nor2_1
X_33052_ _09410_ \memory_i.freq_inst.dsmod_sin.accu1_r[25]\ VPWR VGND sg13g2_inv_1
X_33053_ _09411_ \memory_i.freq_inst.dsmod_sin.accu1_r[24]\ _09407_ _09406_ VPWR VGND sg13g2_a21oi_1
X_33054_ _09412_ _08478_ _09411_ VPWR VGND sg13g2_nor2_1
X_33055_ _09413_ _08478_ _09411_ VPWR VGND sg13g2_nand2_1
X_33056_ _09414_ _09412_ _09413_ \memory_i.freq_inst.dsmod_cos.i_ena_mod\ VPWR VGND sg13g2_nand3b_1
X_33057_ _09415_ _09410_ _09414_ VPWR VGND sg13g2_xnor2_1
X_33058_ _01866_ _09319_ _09415_ VPWR VGND sg13g2_nor2_1
X_33059_ _09416_ _08021_ VPWR VGND sg13g2_buf_1
X_33060_ _09417_ _05649_ VPWR VGND sg13g2_buf_1
X_33061_ _09418_ \memory_i.freq_inst.dsmod_sin.data_interp_r[26]\ VPWR VGND sg13g2_inv_1
X_33062_ _09419_ _08478_ _09411_ _09410_ VPWR VGND sg13g2_o21ai_1
X_33063_ _09420_ _09413_ _09419_ VPWR VGND sg13g2_nand2_1
X_33064_ _09421_ _09418_ _09420_ VPWR VGND sg13g2_xnor2_1
X_33065_ _09422_ _09417_ _09421_ VPWR VGND sg13g2_nor2_1
X_33066_ _09423_ \memory_i.freq_inst.dsmod_sin.accu1_r[26]\ _09422_ VPWR VGND sg13g2_xnor2_1
X_33067_ _01867_ _09416_ _09423_ VPWR VGND sg13g2_nor2_1
X_33068_ _09424_ _09413_ _09419_ \memory_i.freq_inst.dsmod_sin.accu1_r[26]\ VPWR VGND sg13g2_a21oi_1
X_33069_ _09425_ \memory_i.freq_inst.dsmod_sin.accu1_r[26]\ _09413_ _09419_ VPWR VGND sg13g2_nand3_1
X_33070_ _09426_ _09418_ _09424_ _09425_ VPWR VGND sg13g2_o21ai_1
X_33071_ _09427_ \memory_i.freq_inst.dsmod_sin.data_interp_r[27]\ _09426_ VPWR VGND sg13g2_xor2_1
X_33072_ _09428_ \memory_i.freq_inst.dsmod_cos.i_ena_mod\ _09427_ VPWR VGND sg13g2_nand2_1
X_33073_ _09429_ \memory_i.freq_inst.dsmod_sin.accu1_r[27]\ _09428_ VPWR VGND sg13g2_xor2_1
X_33074_ _01868_ _09416_ _09429_ VPWR VGND sg13g2_nor2_1
X_33075_ _09430_ \memory_i.freq_inst.dsmod_sin.accu1_r[26]\ \memory_i.freq_inst.dsmod_sin.data_interp_r[26]\ VPWR VGND sg13g2_nand2_1
X_33076_ _09431_ \memory_i.freq_inst.dsmod_sin.accu1_r[26]\ \memory_i.freq_inst.dsmod_sin.data_interp_r[26]\ VPWR VGND sg13g2_or2_1
X_33077_ _09432_ \memory_i.freq_inst.dsmod_sin.accu1_r[27]\ \memory_i.freq_inst.dsmod_sin.data_interp_r[27]\ VPWR VGND sg13g2_xor2_1
X_33078_ _09433_ _09430_ _09431_ _09432_ VPWR VGND sg13g2_nand3_1
X_33079_ _09434_ \memory_i.freq_inst.dsmod_sin.accu1_r[24]\ \memory_i.freq_inst.dsmod_sin.data_interp_r[24]\ VPWR VGND sg13g2_and2_1
X_33080_ _09435_ _09434_ VPWR VGND sg13g2_buf_1
X_33081_ _09436_ \memory_i.freq_inst.dsmod_sin.accu1_r[24]\ \memory_i.freq_inst.dsmod_sin.data_interp_r[24]\ VPWR VGND sg13g2_nor2_1
X_33082_ _09437_ \memory_i.freq_inst.dsmod_sin.accu1_r[25]\ \memory_i.freq_inst.dsmod_sin.data_interp_r[25]\ VPWR VGND sg13g2_xnor2_1
X_33083_ _09438_ _09433_ _09435_ _09436_ _09437_ VPWR
+ VGND
+ sg13g2_nor4_1
X_33084_ _09439_ _09438_ VPWR VGND sg13g2_inv_1
X_33085_ _09440_ \memory_i.freq_inst.dsmod_sin.accu1_r[26]\ \memory_i.freq_inst.dsmod_sin.data_interp_r[26]\ VPWR VGND sg13g2_nor2_1
X_33086_ _09441_ \memory_i.freq_inst.dsmod_sin.data_interp_r[25]\ _09435_ \memory_i.freq_inst.dsmod_sin.accu1_r[25]\ VPWR VGND sg13g2_a21o_1
X_33087_ _09442_ \memory_i.freq_inst.dsmod_sin.data_interp_r[25]\ _09435_ _09441_ VPWR VGND sg13g2_o21ai_1
X_33088_ _09443_ _09440_ _09442_ _09430_ VPWR VGND sg13g2_o21ai_1
X_33089_ _09444_ \memory_i.freq_inst.dsmod_sin.data_interp_r[27]\ _09443_ \memory_i.freq_inst.dsmod_sin.accu1_r[27]\ VPWR VGND sg13g2_a21oi_1
X_33090_ _09445_ \memory_i.freq_inst.dsmod_sin.data_interp_r[27]\ _09443_ VPWR VGND sg13g2_nor2_1
X_33091_ _09446_ _09444_ _09445_ VPWR VGND sg13g2_nor2_1
X_33092_ _09447_ _09446_ VPWR VGND sg13g2_inv_1
X_33093_ _09448_ _09405_ _09439_ _09447_ VPWR VGND sg13g2_o21ai_1
X_33094_ _09449_ \memory_i.freq_inst.dsmod_sin.data_interp_r[28]\ _09448_ VPWR VGND sg13g2_or2_1
X_33095_ _09450_ _09449_ VPWR VGND sg13g2_buf_1
X_33096_ _09451_ \memory_i.freq_inst.dsmod_sin.data_interp_r[28]\ _09448_ VPWR VGND sg13g2_nand2_1
X_33097_ _09452_ \memory_i.freq_inst.dsmod_cos.i_ena_mod\ _09450_ _09451_ VPWR VGND sg13g2_nand3_1
X_33098_ _09453_ \memory_i.freq_inst.dsmod_sin.accu1_r[28]\ _09452_ VPWR VGND sg13g2_xor2_1
X_33099_ _01869_ _09416_ _09453_ VPWR VGND sg13g2_nor2_1
X_33100_ _09454_ \memory_i.freq_inst.dsmod_sin.data_interp_r[28]\ _09448_ \memory_i.freq_inst.dsmod_sin.accu1_r[28]\ VPWR VGND sg13g2_a21o_1
X_33101_ _09455_ _09454_ VPWR VGND sg13g2_buf_1
X_33102_ _09456_ \memory_i.freq_inst.dsmod_sin.data_interp_r[29]\ _09450_ _09455_ VPWR VGND sg13g2_and3_1
X_33103_ _09457_ _09450_ _09455_ \memory_i.freq_inst.dsmod_sin.data_interp_r[29]\ VPWR VGND sg13g2_a21oi_1
X_33104_ _09458_ _12939_ _09456_ _09457_ VPWR VGND sg13g2_nor3_1
X_33105_ _09459_ \memory_i.freq_inst.dsmod_sin.accu1_r[29]\ _09458_ VPWR VGND sg13g2_xnor2_1
X_33106_ _01870_ _09416_ _09459_ VPWR VGND sg13g2_nor2_1
X_33107_ _09460_ _09450_ _09455_ \memory_i.freq_inst.dsmod_sin.data_interp_r[29]\ VPWR VGND sg13g2_a21o_1
X_33108_ _09461_ \memory_i.freq_inst.dsmod_sin.accu1_r[29]\ _09460_ _09456_ VPWR VGND sg13g2_a21oi_1
X_33109_ _09462_ \memory_i.freq_inst.dsmod_sin.data_interp_r[30]\ _09461_ VPWR VGND sg13g2_xnor2_1
X_33110_ _09463_ \memory_i.freq_inst.dsmod_cos.i_ena_mod\ _09462_ VPWR VGND sg13g2_nand2_1
X_33111_ _09464_ \memory_i.freq_inst.dsmod_sin.accu1_r[30]\ _09463_ VPWR VGND sg13g2_xor2_1
X_33112_ _01871_ _09416_ _09464_ VPWR VGND sg13g2_nor2_1
X_33113_ _09465_ \memory_i.freq_inst.dsmod_sin.accu1_r[30]\ \memory_i.freq_inst.dsmod_sin.data_interp_r[30]\ VPWR VGND sg13g2_nor2_1
X_33114_ _09466_ \memory_i.freq_inst.dsmod_sin.accu1_r[30]\ \memory_i.freq_inst.dsmod_sin.data_interp_r[30]\ VPWR VGND sg13g2_nand2_1
X_33115_ _09467_ _09461_ _09465_ _09466_ VPWR VGND sg13g2_o21ai_1
X_33116_ _09468_ \memory_i.freq_inst.dsmod_sin.data_interp_r[31]\ _09467_ VPWR VGND sg13g2_xor2_1
X_33117_ _09469_ \memory_i.freq_inst.dsmod_cos.i_ena_mod\ _09468_ VPWR VGND sg13g2_nand2_1
X_33118_ _09470_ \memory_i.freq_inst.dsmod_sin.accu1_r[31]\ _09469_ VPWR VGND sg13g2_xor2_1
X_33119_ _01872_ _09416_ _09470_ VPWR VGND sg13g2_nor2_1
X_33120_ _09471_ \memory_i.freq_inst.dsmod_sin.accu1_r[32]\ VPWR VGND sg13g2_inv_1
X_33121_ _09472_ \memory_i.freq_inst.dsmod_sin.data_interp_r[32]\ VPWR VGND sg13g2_inv_1
X_33122_ _09473_ \memory_i.freq_inst.dsmod_sin.accu1_r[30]\ \memory_i.freq_inst.dsmod_sin.data_interp_r[30]\ VPWR VGND sg13g2_and2_1
X_33123_ _09474_ \memory_i.freq_inst.dsmod_sin.accu1_r[29]\ \memory_i.freq_inst.dsmod_sin.data_interp_r[29]\ VPWR VGND sg13g2_xnor2_1
X_33124_ _09475_ _09465_ _09473_ _09474_ VPWR VGND sg13g2_nor3_1
X_33125_ _09476_ \memory_i.freq_inst.dsmod_sin.accu1_r[28]\ \memory_i.freq_inst.dsmod_sin.data_interp_r[28]\ VPWR VGND sg13g2_xor2_1
X_33126_ _09477_ \memory_i.freq_inst.dsmod_sin.accu1_r[31]\ \memory_i.freq_inst.dsmod_sin.data_interp_r[31]\ VPWR VGND sg13g2_nand2_1
X_33127_ _09478_ \memory_i.freq_inst.dsmod_sin.accu1_r[31]\ \memory_i.freq_inst.dsmod_sin.data_interp_r[31]\ VPWR VGND sg13g2_or2_1
X_33128_ _09479_ _09475_ _09476_ _09477_ _09478_ VPWR
+ VGND
+ sg13g2_and4_1
X_33129_ _09480_ _09479_ VPWR VGND sg13g2_buf_1
X_33130_ _09481_ _09399_ _09438_ _09480_ VPWR VGND sg13g2_and3_1
X_33131_ _09482_ \memory_i.freq_inst.dsmod_sin.accu1_r[29]\ VPWR VGND sg13g2_inv_1
X_33132_ _09483_ \memory_i.freq_inst.dsmod_sin.accu1_r[28]\ \memory_i.freq_inst.dsmod_sin.data_interp_r[28]\ \memory_i.freq_inst.dsmod_sin.data_interp_r[29]\ VPWR VGND sg13g2_a21oi_1
X_33133_ _09484_ \memory_i.freq_inst.dsmod_sin.accu1_r[28]\ \memory_i.freq_inst.dsmod_sin.data_interp_r[29]\ \memory_i.freq_inst.dsmod_sin.data_interp_r[28]\ VPWR VGND sg13g2_nand3_1
X_33134_ _09485_ _09482_ _09483_ _09484_ VPWR VGND sg13g2_o21ai_1
X_33135_ _09486_ \memory_i.freq_inst.dsmod_sin.data_interp_r[30]\ _09485_ \memory_i.freq_inst.dsmod_sin.accu1_r[30]\ VPWR VGND sg13g2_a21oi_1
X_33136_ _09487_ \memory_i.freq_inst.dsmod_sin.data_interp_r[30]\ _09485_ VPWR VGND sg13g2_nor2_1
X_33137_ _09488_ _09486_ _09487_ _09477_ VPWR VGND sg13g2_o21ai_1
X_33138_ _09489_ _09446_ _09480_ VPWR VGND sg13g2_nand2_1
X_33139_ _09490_ _09404_ _09438_ _09480_ VPWR VGND sg13g2_nand3_1
X_33140_ _09491_ _09489_ _09490_ VPWR VGND sg13g2_nand2_1
X_33141_ _09492_ _09378_ _09481_ _09488_ _09478_ _09491_
+ VPWR
+ VGND sg13g2_a221oi_1
X_33142_ _09493_ _09472_ _09492_ VPWR VGND sg13g2_nand2_1
X_33143_ _09494_ _09492_ \memory_i.freq_inst.dsmod_sin.data_interp_r[32]\ VPWR VGND sg13g2_nand2b_1
X_33144_ _09495_ \memory_i.freq_inst.dsmod_cos.i_ena_mod\ _09493_ _09494_ VPWR VGND sg13g2_nand3_1
X_33145_ _09496_ _09471_ _09495_ VPWR VGND sg13g2_xnor2_1
X_33146_ _01873_ _09416_ _09496_ VPWR VGND sg13g2_nor2_1
X_33147_ _09497_ _09471_ _09494_ VPWR VGND sg13g2_nand2_1
X_33148_ _09498_ _09493_ _09497_ VPWR VGND sg13g2_nand2_1
X_33149_ _09499_ _08549_ _09498_ VPWR VGND sg13g2_xnor2_1
X_33150_ _09500_ _09417_ _09499_ VPWR VGND sg13g2_nor2_1
X_33151_ _09501_ \memory_i.freq_inst.dsmod_sin.accu1_r[33]\ _09500_ VPWR VGND sg13g2_xnor2_1
X_33152_ _01874_ _09416_ _09501_ VPWR VGND sg13g2_nor2_1
X_33153_ _09502_ \memory_i.freq_inst.dsmod_sin.accu1_r[33]\ VPWR VGND sg13g2_inv_1
X_33154_ _09503_ _09502_ _08549_ _09472_ _09471_ _09492_
+ VPWR
+ VGND sg13g2_a221oi_1
X_33155_ _09504_ _09503_ VPWR VGND sg13g2_buf_1
X_33156_ _09505_ _09471_ _09472_ VPWR VGND sg13g2_nor2_1
X_33157_ _09506_ \memory_i.freq_inst.dsmod_sin.accu1_r[33]\ \memory_i.freq_inst.dsmod_sin.data_interp_r[33]\ _09505_ VPWR VGND sg13g2_o21ai_1
X_33158_ _09507_ _09502_ _08549_ _09506_ VPWR VGND sg13g2_o21ai_1
X_33159_ _09508_ _09504_ _09507_ VPWR VGND sg13g2_nor2_1
X_33160_ _09509_ _08557_ _09508_ VPWR VGND sg13g2_xnor2_1
X_33161_ _09510_ _09417_ _09509_ VPWR VGND sg13g2_nor2_1
X_33162_ _09511_ \memory_i.freq_inst.dsmod_sin.accu1_r[34]\ _09510_ VPWR VGND sg13g2_xnor2_1
X_33163_ _01875_ _09416_ _09511_ VPWR VGND sg13g2_nor2_1
X_33164_ _09512_ \memory_i.freq_inst.dsmod_sin.accu1_r[34]\ VPWR VGND sg13g2_inv_1
X_33165_ _09513_ _09504_ _09507_ \memory_i.freq_inst.dsmod_sin.data_interp_r[34]\ VPWR VGND sg13g2_o21ai_1
X_33166_ _09514_ \memory_i.freq_inst.dsmod_sin.data_interp_r[34]\ _09504_ _09507_ VPWR VGND sg13g2_nor3_1
X_33167_ _09515_ _09512_ _09513_ _09514_ VPWR VGND sg13g2_a21oi_1
X_33168_ _09516_ \memory_i.freq_inst.dsmod_sin.data_interp_r[35]\ _09515_ VPWR VGND sg13g2_xnor2_1
X_33169_ _09517_ _09417_ _09516_ VPWR VGND sg13g2_nor2_1
X_33170_ _09518_ \memory_i.freq_inst.dsmod_sin.accu1_r[35]\ _09517_ VPWR VGND sg13g2_xnor2_1
X_33171_ _01876_ _09416_ _09518_ VPWR VGND sg13g2_nor2_1
X_33172_ _09519_ _08021_ VPWR VGND sg13g2_buf_1
X_33173_ _09520_ \memory_i.freq_inst.dsmod_sin.accu1_r[35]\ \memory_i.freq_inst.dsmod_sin.data_interp_r[35]\ VPWR VGND sg13g2_nand2_1
X_33174_ _09521_ \memory_i.freq_inst.dsmod_sin.accu1_r[35]\ \memory_i.freq_inst.dsmod_sin.data_interp_r[35]\ VPWR VGND sg13g2_or2_1
X_33175_ _09522_ _09515_ _09521_ VPWR VGND sg13g2_nand2_1
X_33176_ _09523_ _09520_ _09522_ VPWR VGND sg13g2_nand2_1
X_33177_ _09524_ \memory_i.freq_inst.dsmod_sin.data_interp_r[36]\ _09523_ VPWR VGND sg13g2_xor2_1
X_33178_ _09525_ \memory_i.freq_inst.dsmod_cos.i_ena_mod\ _09524_ VPWR VGND sg13g2_nand2_1
X_33179_ _09526_ \memory_i.freq_inst.dsmod_sin.accu1_r[36]\ _09525_ VPWR VGND sg13g2_xor2_1
X_33180_ _01877_ _09519_ _09526_ VPWR VGND sg13g2_nor2_1
X_33181_ _09527_ \memory_i.freq_inst.dsmod_sin.accu1_r[35]\ \memory_i.freq_inst.dsmod_sin.data_interp_r[35]\ \memory_i.freq_inst.dsmod_sin.accu1_r[36]\ VPWR VGND sg13g2_a21oi_1
X_33182_ _09528_ \memory_i.freq_inst.dsmod_sin.accu1_r[35]\ \memory_i.freq_inst.dsmod_sin.data_interp_r[35]\ \memory_i.freq_inst.dsmod_sin.data_interp_r[36]\ VPWR VGND sg13g2_a21oi_1
X_33183_ _09529_ _09515_ VPWR VGND sg13g2_inv_1
X_33184_ _09530_ \memory_i.freq_inst.dsmod_sin.accu1_r[36]\ _09521_ \memory_i.freq_inst.dsmod_sin.data_interp_r[36]\ VPWR VGND sg13g2_a21oi_1
X_33185_ _09531_ _09522_ _09527_ _09528_ _09529_ _09530_
+ VPWR
+ VGND sg13g2_a221oi_1
X_33186_ _09532_ _09531_ VPWR VGND sg13g2_buf_1
X_33187_ _09533_ \memory_i.freq_inst.dsmod_sin.data_interp_r[37]\ _09532_ VPWR VGND sg13g2_xnor2_1
X_33188_ _09534_ \memory_i.freq_inst.dsmod_cos.i_ena_mod\ _09533_ VPWR VGND sg13g2_nand2_1
X_33189_ _09535_ \memory_i.freq_inst.dsmod_sin.accu1_r[37]\ _09534_ VPWR VGND sg13g2_xor2_1
X_33190_ _01878_ _09519_ _09535_ VPWR VGND sg13g2_nor2_1
X_33191_ _09536_ \memory_i.freq_inst.dsmod_sin.accu1_r[38]\ VPWR VGND sg13g2_inv_1
X_33192_ _09537_ _12945_ _09536_ VPWR VGND sg13g2_nor2_1
X_33193_ _09538_ _12945_ \memory_i.freq_inst.dsmod_sin.accu1_r[38]\ VPWR VGND sg13g2_nor2_1
X_33194_ _09539_ _12939_ _13400_ VPWR VGND sg13g2_nor2_1
X_33195_ _09540_ _12939_ _13387_ VPWR VGND sg13g2_nor2_1
X_33196_ _09541_ _09532_ \memory_i.freq_inst.dsmod_sin.data_interp_r[37]\ VPWR VGND sg13g2_nand2b_1
X_33197_ _09542_ \memory_i.freq_inst.dsmod_sin.data_interp_r[37]\ _09532_ VPWR VGND sg13g2_nor2b_1
X_33198_ _09543_ \memory_i.freq_inst.dsmod_sin.accu1_r[37]\ _09541_ _09542_ VPWR VGND sg13g2_a21oi_1
X_33199_ _09544_ _09539_ _09540_ _09543_ VPWR VGND sg13g2_mux2_1
X_33200_ _01879_ _09537_ _09538_ _09544_ VPWR VGND sg13g2_mux2_1
X_33201_ _09545_ \memory_i.freq_inst.dsmod_sin.accu3_r[41]\ \memory_i.freq_inst.dsmod_sin.accu1_r[39]\ \memory_i.freq_inst.dsmod_sin.accu1_r[38]\ VPWR VGND sg13g2_and3_1
X_33202_ _09546_ \memory_i.freq_inst.dsmod_sin.accu1_r[39]\ VPWR VGND sg13g2_inv_1
X_33203_ _09547_ \memory_i.freq_inst.dsmod_sin.accu3_r[41]\ _09546_ \memory_i.freq_inst.dsmod_sin.accu1_r[38]\ _13380_ VPWR
+ VGND
+ sg13g2_nor4_1
X_33204_ _09548_ _09545_ _09547_ _09543_ VPWR VGND sg13g2_mux2_1
X_33205_ _09549_ _09546_ _09536_ VPWR VGND sg13g2_nand2_1
X_33206_ _09550_ \memory_i.freq_inst.dsmod_sin.accu1_r[38]\ _13380_ VPWR VGND sg13g2_nor2_1
X_33207_ _09551_ \memory_i.freq_inst.dsmod_sin.accu1_r[37]\ \memory_i.freq_inst.dsmod_sin.data_interp_r[37]\ VPWR VGND sg13g2_nand2b_1
X_33208_ _09552_ \memory_i.freq_inst.dsmod_sin.accu3_r[41]\ _09551_ VPWR VGND sg13g2_nand2_1
X_33209_ _09553_ \memory_i.freq_inst.dsmod_sin.accu3_r[41]\ _09550_ _09552_ \memory_i.freq_inst.dsmod_sin.accu1_r[38]\ VPWR
+ VGND
+ sg13g2_a22oi_1
X_33210_ _09554_ \memory_i.freq_inst.dsmod_sin.data_interp_r[37]\ \memory_i.freq_inst.dsmod_sin.accu1_r[37]\ VPWR VGND sg13g2_nor2b_1
X_33211_ _09555_ _09536_ \memory_i.ds_lo_conf[5]\ VPWR VGND sg13g2_nor2_1
X_33212_ _09556_ _09554_ _09555_ _08216_ VPWR VGND sg13g2_a21oi_1
X_33213_ _09557_ \memory_i.freq_inst.dsmod_sin.accu1_r[39]\ _09553_ _09556_ VPWR VGND sg13g2_o21ai_1
X_33214_ _09558_ \memory_i.freq_inst.dsmod_sin.accu1_r[39]\ _09536_ _09532_ _09554_ VPWR
+ VGND
+ sg13g2_nor4_1
X_33215_ _09559_ _09532_ _09551_ _09555_ VPWR VGND sg13g2_and3_1
X_33216_ _09560_ _09557_ _09558_ _09559_ VPWR VGND sg13g2_nor3_1
X_33217_ _09561_ _09543_ _09549_ _09560_ VPWR VGND sg13g2_o21ai_1
X_33218_ _09562_ _12941_ \memory_i.freq_inst.cordic.rstn_i\ \memory_i.freq_inst.dsmod_sin.accu1_r[39]\ VPWR VGND sg13g2_nand3_1
X_33219_ _01880_ _09548_ _09561_ _09562_ VPWR VGND sg13g2_o21ai_1
X_33220_ _09563_ \memory_i.freq_inst.dsmod_sin.accu2_r[0]\ _09206_ VPWR VGND sg13g2_xor2_1
X_33221_ _01881_ _09519_ _09563_ VPWR VGND sg13g2_nor2_1
X_33222_ _09564_ \memory_i.freq_inst.dsmod_sin.accu2_r[1]\ VPWR VGND sg13g2_inv_1
X_33223_ _09565_ \memory_i.freq_inst.dsmod_sin.accu2_r[0]\ \memory_i.freq_inst.dsmod_sin.data_interp_r[0]\ VPWR VGND sg13g2_nand2_1
X_33224_ _09566_ \memory_i.freq_inst.dsmod_sin.data_interp_r[1]\ _09565_ VPWR VGND sg13g2_xnor2_1
X_33225_ _09567_ \memory_i.freq_inst.dsmod_cos.i_ena_mod\ _09566_ VPWR VGND sg13g2_nand2_1
X_33226_ _09568_ _09564_ _09567_ VPWR VGND sg13g2_xnor2_1
X_33227_ _01882_ _09519_ _09568_ VPWR VGND sg13g2_nor2_1
X_33228_ _09569_ \memory_i.freq_inst.dsmod_sin.accu2_r[2]\ \memory_i.freq_inst.dsmod_sin.data_interp_r[2]\ VPWR VGND sg13g2_or2_1
X_33229_ _09570_ \memory_i.freq_inst.dsmod_sin.accu2_r[2]\ \memory_i.freq_inst.dsmod_sin.data_interp_r[2]\ VPWR VGND sg13g2_nand2_1
X_33230_ _09571_ \memory_i.freq_inst.dsmod_sin.accu2_r[0]\ \memory_i.freq_inst.dsmod_sin.data_interp_r[0]\ \memory_i.freq_inst.dsmod_sin.accu2_r[1]\ VPWR VGND sg13g2_a21o_1
X_33231_ _09572_ \memory_i.freq_inst.dsmod_sin.accu2_r[1]\ \memory_i.freq_inst.dsmod_sin.accu2_r[0]\ \memory_i.freq_inst.dsmod_sin.data_interp_r[0]\ VPWR VGND sg13g2_and3_1
X_33232_ _09573_ _09569_ _09570_ _09571_ \memory_i.freq_inst.dsmod_sin.data_interp_r[1]\ _09572_
+ VPWR
+ VGND sg13g2_a221oi_1
X_33233_ _09574_ \memory_i.freq_inst.dsmod_sin.accu2_r[2]\ \memory_i.freq_inst.dsmod_sin.data_interp_r[2]\ VPWR VGND sg13g2_nand2b_1
X_33234_ _09575_ \memory_i.freq_inst.dsmod_sin.data_interp_r[2]\ \memory_i.freq_inst.dsmod_sin.accu2_r[2]\ VPWR VGND sg13g2_nand2b_1
X_33235_ _09576_ \memory_i.freq_inst.dsmod_sin.accu2_r[0]\ \memory_i.freq_inst.dsmod_sin.data_interp_r[1]\ \memory_i.freq_inst.dsmod_sin.data_interp_r[0]\ VPWR VGND sg13g2_nand3_1
X_33236_ _09577_ \memory_i.freq_inst.dsmod_sin.accu2_r[0]\ \memory_i.freq_inst.dsmod_sin.data_interp_r[0]\ \memory_i.freq_inst.dsmod_sin.data_interp_r[1]\ VPWR VGND sg13g2_a21oi_1
X_33237_ _09578_ _09574_ _09575_ _09576_ _09564_ _09577_
+ VPWR
+ VGND sg13g2_a221oi_1
X_33238_ _09579_ _09573_ _09578_ VPWR VGND sg13g2_nor2_1
X_33239_ _09580_ \memory_i.freq_inst.dsmod_cos.i_ena_mod\ _09579_ VPWR VGND sg13g2_nand2_1
X_33240_ _09581_ _08219_ \memory_i.freq_inst.dsmod_sin.accu2_r[2]\ VPWR VGND sg13g2_nand2_1
X_33241_ _01883_ _09580_ _09581_ _08911_ VPWR VGND sg13g2_a21oi_1
X_33242_ _09582_ \memory_i.freq_inst.dsmod_sin.accu2_r[2]\ \memory_i.freq_inst.dsmod_sin.data_interp_r[2]\ \memory_i.freq_inst.dsmod_sin.accu2_r[1]\ VPWR VGND sg13g2_a21oi_1
X_33243_ _09583_ \memory_i.freq_inst.dsmod_sin.accu2_r[2]\ \memory_i.freq_inst.dsmod_sin.data_interp_r[2]\ VPWR VGND sg13g2_nor2_1
X_33244_ _09584_ _09570_ _09577_ _09582_ _09576_ _09583_
+ VPWR
+ VGND sg13g2_a221oi_1
X_33245_ _09585_ _09584_ VPWR VGND sg13g2_buf_2
X_33246_ _09586_ \memory_i.freq_inst.dsmod_sin.data_interp_r[3]\ _09585_ VPWR VGND sg13g2_xnor2_1
X_33247_ _09587_ _09417_ _09586_ VPWR VGND sg13g2_nor2_1
X_33248_ _09588_ \memory_i.freq_inst.dsmod_sin.accu2_r[3]\ _09587_ VPWR VGND sg13g2_xnor2_1
X_33249_ _01884_ _09519_ _09588_ VPWR VGND sg13g2_nor2_1
X_33250_ _09589_ \memory_i.freq_inst.dsmod_sin.accu2_r[3]\ VPWR VGND sg13g2_inv_1
X_33251_ _09590_ _09589_ _09583_ _09577_ VPWR VGND sg13g2_nor3_1
X_33252_ _09591_ _09564_ _09576_ VPWR VGND sg13g2_nand2_1
X_33253_ _09592_ _08260_ _09570_ _09589_ VPWR VGND sg13g2_a21oi_1
X_33254_ _09593_ \memory_i.freq_inst.dsmod_sin.data_interp_r[3]\ _09585_ _09590_ _09591_ _09592_
+ VPWR
+ VGND sg13g2_a221oi_1
X_33255_ _09594_ _09593_ VPWR VGND sg13g2_buf_2
X_33256_ _09595_ \memory_i.freq_inst.dsmod_sin.data_interp_r[4]\ _09594_ VPWR VGND sg13g2_xnor2_1
X_33257_ _09596_ \memory_i.freq_inst.dsmod_cos.i_ena_mod\ _09595_ VPWR VGND sg13g2_nand2_1
X_33258_ _09597_ \memory_i.freq_inst.dsmod_sin.accu2_r[4]\ _09596_ VPWR VGND sg13g2_xor2_1
X_33259_ _01885_ _09519_ _09597_ VPWR VGND sg13g2_nor2_1
X_33260_ _09598_ \memory_i.freq_inst.dsmod_sin.accu2_r[5]\ \memory_i.freq_inst.dsmod_sin.data_interp_r[5]\ VPWR VGND sg13g2_xor2_1
X_33261_ _09599_ \memory_i.freq_inst.dsmod_sin.accu2_r[4]\ \memory_i.freq_inst.dsmod_sin.data_interp_r[4]\ VPWR VGND sg13g2_nand2_1
X_33262_ _09600_ \memory_i.freq_inst.dsmod_sin.accu2_r[4]\ \memory_i.freq_inst.dsmod_sin.data_interp_r[4]\ VPWR VGND sg13g2_nor2_1
X_33263_ _09601_ _09594_ _09599_ _09600_ VPWR VGND sg13g2_a21oi_1
X_33264_ _09602_ _09598_ _09601_ VPWR VGND sg13g2_xnor2_1
X_33265_ _09603_ _12940_ _09602_ VPWR VGND sg13g2_nor2_1
X_33266_ _09604_ _08219_ \memory_i.freq_inst.dsmod_sin.accu2_r[5]\ _09603_ VPWR VGND sg13g2_a21oi_1
X_33267_ _01886_ _09519_ _09604_ VPWR VGND sg13g2_nor2_1
X_33268_ _09605_ \memory_i.freq_inst.dsmod_cos.i_ena_mod\ \memory_i.freq_inst.dsmod_sin.accu2_r[6]\ VPWR VGND sg13g2_nor2_1
X_33269_ _09606_ \memory_i.freq_inst.dsmod_sin.accu2_r[6]\ \memory_i.freq_inst.dsmod_sin.data_interp_r[6]\ VPWR VGND sg13g2_xor2_1
X_33270_ _09607_ \memory_i.freq_inst.dsmod_sin.accu2_r[5]\ \memory_i.freq_inst.dsmod_sin.data_interp_r[5]\ VPWR VGND sg13g2_and2_1
X_33271_ _09608_ _09607_ VPWR VGND sg13g2_buf_1
X_33272_ _09609_ \memory_i.freq_inst.dsmod_sin.accu2_r[5]\ \memory_i.freq_inst.dsmod_sin.data_interp_r[5]\ VPWR VGND sg13g2_or2_1
X_33273_ _09610_ _09609_ VPWR VGND sg13g2_buf_1
X_33274_ _09611_ _09601_ _09608_ _09610_ VPWR VGND sg13g2_o21ai_1
X_33275_ _09612_ _09606_ _09611_ VPWR VGND sg13g2_xnor2_1
X_33276_ _09613_ _05651_ _09612_ VPWR VGND sg13g2_nor2_1
X_33277_ _01887_ _03328_ _09605_ _09613_ VPWR VGND sg13g2_nor3_1
X_33278_ _09614_ \memory_i.freq_inst.dsmod_sin.accu2_r[7]\ \memory_i.freq_inst.dsmod_sin.data_interp_r[7]\ VPWR VGND sg13g2_xnor2_1
X_33279_ _09615_ \memory_i.freq_inst.dsmod_sin.accu2_r[6]\ \memory_i.freq_inst.dsmod_sin.accu2_r[4]\ _09610_ VPWR VGND sg13g2_and3_1
X_33280_ _09616_ \memory_i.freq_inst.dsmod_sin.accu2_r[6]\ \memory_i.freq_inst.dsmod_sin.data_interp_r[4]\ _09610_ VPWR VGND sg13g2_nand3_1
X_33281_ _09617_ \memory_i.freq_inst.dsmod_sin.accu2_r[6]\ \memory_i.freq_inst.dsmod_sin.accu2_r[4]\ _09610_ VPWR VGND sg13g2_nand3_1
X_33282_ _09618_ _09616_ _09617_ _09594_ VPWR VGND sg13g2_a21oi_1
X_33283_ _09619_ \memory_i.freq_inst.dsmod_sin.accu2_r[6]\ _09608_ _09615_ \memory_i.freq_inst.dsmod_sin.data_interp_r[4]\ _09618_
+ VPWR
+ VGND sg13g2_a221oi_1
X_33284_ _09620_ \memory_i.freq_inst.dsmod_sin.accu2_r[6]\ \memory_i.freq_inst.dsmod_sin.data_interp_r[4]\ _09608_ VPWR VGND sg13g2_nor3_1
X_33285_ _09621_ \memory_i.freq_inst.dsmod_sin.accu2_r[6]\ \memory_i.freq_inst.dsmod_sin.accu2_r[4]\ _09608_ VPWR VGND sg13g2_nor3_1
X_33286_ _09622_ _09620_ _09621_ _09594_ VPWR VGND sg13g2_o21ai_1
X_33287_ _09623_ \memory_i.freq_inst.dsmod_sin.accu2_r[6]\ _09610_ VPWR VGND sg13g2_nor2_1
X_33288_ _09624_ _09226_ _09621_ _09623_ VPWR VGND sg13g2_a21oi_1
X_33289_ _09625_ \memory_i.freq_inst.dsmod_sin.data_interp_r[6]\ _09622_ _09624_ VPWR VGND sg13g2_nand3_1
X_33290_ _09626_ _09619_ _09625_ VPWR VGND sg13g2_nand2_1
X_33291_ _09627_ _09614_ _09626_ VPWR VGND sg13g2_xnor2_1
X_33292_ _09628_ \memory_i.freq_inst.dsmod_cos.i_ena_mod\ \memory_i.freq_inst.dsmod_sin.accu2_r[7]\ VPWR VGND sg13g2_nor2b_1
X_33293_ _09629_ \memory_i.freq_inst.dsmod_cos.i_ena_mod\ _09627_ _09628_ VPWR VGND sg13g2_a21oi_1
X_33294_ _01888_ _09519_ _09629_ VPWR VGND sg13g2_nor2_1
X_33295_ _09630_ \memory_i.freq_inst.dsmod_sin.accu2_r[7]\ \memory_i.freq_inst.dsmod_sin.data_interp_r[7]\ VPWR VGND sg13g2_nand2_1
X_33296_ _09631_ \memory_i.freq_inst.dsmod_sin.accu2_r[7]\ \memory_i.freq_inst.dsmod_sin.data_interp_r[7]\ VPWR VGND sg13g2_or2_1
X_33297_ _09632_ _09631_ VPWR VGND sg13g2_buf_1
X_33298_ _09633_ \memory_i.freq_inst.dsmod_sin.accu2_r[5]\ \memory_i.freq_inst.dsmod_sin.data_interp_r[5]\ \memory_i.freq_inst.dsmod_sin.data_interp_r[6]\ VPWR VGND sg13g2_a21o_1
X_33299_ _09634_ \memory_i.freq_inst.dsmod_sin.accu2_r[6]\ _09632_ _09633_ VPWR VGND sg13g2_nand3_1
X_33300_ _09635_ \memory_i.freq_inst.dsmod_sin.data_interp_r[6]\ _09608_ _09632_ VPWR VGND sg13g2_nand3_1
X_33301_ _09636_ _09599_ _09630_ _09634_ _09635_ VPWR
+ VGND
+ sg13g2_and4_1
X_33302_ _09637_ _09600_ _09632_ VPWR VGND sg13g2_nor2b_1
X_33303_ _09638_ \memory_i.freq_inst.dsmod_sin.accu2_r[5]\ \memory_i.freq_inst.dsmod_sin.data_interp_r[6]\ \memory_i.freq_inst.dsmod_sin.data_interp_r[5]\ VPWR VGND sg13g2_nor3_1
X_33304_ _09639_ \memory_i.freq_inst.dsmod_sin.accu2_r[7]\ \memory_i.freq_inst.dsmod_sin.data_interp_r[7]\ \memory_i.freq_inst.dsmod_sin.accu2_r[6]\ VPWR VGND sg13g2_a21oi_1
X_33305_ _09640_ \memory_i.freq_inst.dsmod_sin.accu2_r[5]\ \memory_i.freq_inst.dsmod_sin.data_interp_r[5]\ \memory_i.freq_inst.dsmod_sin.data_interp_r[6]\ VPWR VGND sg13g2_o21ai_1
X_33306_ _09641_ _09630_ _09638_ _09639_ _09640_ VPWR
+ VGND
+ sg13g2_a22oi_1
X_33307_ _09642_ _09637_ _09641_ VPWR VGND sg13g2_nand2_1
X_33308_ _09643_ _09630_ _09634_ _09635_ VPWR VGND sg13g2_and3_1
X_33309_ _09644_ _09643_ VPWR VGND sg13g2_buf_1
X_33310_ _09645_ _09594_ _09636_ _09642_ _09644_ VPWR
+ VGND
+ sg13g2_a22oi_1
X_33311_ _09646_ _09645_ VPWR VGND sg13g2_buf_1
X_33312_ _09647_ \memory_i.freq_inst.dsmod_sin.accu2_r[8]\ \memory_i.freq_inst.dsmod_sin.data_interp_r[8]\ VPWR VGND sg13g2_xnor2_1
X_33313_ _09648_ _09646_ _09647_ VPWR VGND sg13g2_xnor2_1
X_33314_ _09649_ \memory_i.freq_inst.dsmod_cos.i_ena_mod\ \memory_i.freq_inst.dsmod_sin.accu2_r[8]\ VPWR VGND sg13g2_nor2b_1
X_33315_ _09650_ \memory_i.freq_inst.dsmod_cos.i_ena_mod\ _09648_ _09649_ VPWR VGND sg13g2_a21oi_1
X_33316_ _01889_ _09519_ _09650_ VPWR VGND sg13g2_nor2_1
X_33317_ _09651_ \memory_i.freq_inst.dsmod_sin.accu2_r[9]\ \memory_i.freq_inst.dsmod_sin.data_interp_r[9]\ VPWR VGND sg13g2_xnor2_1
X_33318_ _09652_ \memory_i.freq_inst.dsmod_sin.accu2_r[8]\ \memory_i.freq_inst.dsmod_sin.data_interp_r[8]\ VPWR VGND sg13g2_and2_1
X_33319_ _09653_ \memory_i.freq_inst.dsmod_sin.accu2_r[8]\ \memory_i.freq_inst.dsmod_sin.data_interp_r[8]\ VPWR VGND sg13g2_or2_1
X_33320_ _09654_ _09646_ _09652_ _09653_ VPWR VGND sg13g2_o21ai_1
X_33321_ _09655_ _09651_ _09654_ VPWR VGND sg13g2_xor2_1
X_33322_ _09656_ \memory_i.freq_inst.dsmod_cos.i_ena_mod\ \memory_i.freq_inst.dsmod_sin.accu2_r[9]\ VPWR VGND sg13g2_nor2b_1
X_33323_ _09657_ \memory_i.freq_inst.dsmod_cos.i_ena_mod\ _09655_ _09656_ VPWR VGND sg13g2_a21oi_1
X_33324_ _01890_ _09519_ _09657_ VPWR VGND sg13g2_nor2_1
X_33325_ _09658_ \memory_i.freq_inst.dsmod_cos.i_ena_mod\ \memory_i.freq_inst.dsmod_sin.accu2_r[10]\ VPWR VGND sg13g2_nor2_1
X_33326_ _09659_ \memory_i.freq_inst.dsmod_sin.accu2_r[10]\ \memory_i.freq_inst.dsmod_sin.data_interp_r[10]\ VPWR VGND sg13g2_xnor2_1
X_33327_ _09660_ \memory_i.freq_inst.dsmod_sin.accu2_r[9]\ \memory_i.freq_inst.dsmod_sin.data_interp_r[9]\ VPWR VGND sg13g2_nand2_1
X_33328_ _09661_ \memory_i.freq_inst.dsmod_sin.accu2_r[9]\ \memory_i.freq_inst.dsmod_sin.data_interp_r[9]\ VPWR VGND sg13g2_nor2_1
X_33329_ _09662_ _09654_ _09660_ _09661_ VPWR VGND sg13g2_a21oi_1
X_33330_ _09663_ _09659_ _09662_ VPWR VGND sg13g2_xnor2_1
X_33331_ _09664_ _05651_ _09663_ VPWR VGND sg13g2_nor2_1
X_33332_ _01891_ _03328_ _09658_ _09664_ VPWR VGND sg13g2_nor3_1
X_33333_ _09665_ \memory_i.freq_inst.dsmod_cos.i_ena_mod\ \memory_i.freq_inst.dsmod_sin.accu2_r[11]\ VPWR VGND sg13g2_nor2_1
X_33334_ _09666_ \memory_i.freq_inst.dsmod_sin.accu2_r[11]\ \memory_i.freq_inst.dsmod_sin.data_interp_r[11]\ VPWR VGND sg13g2_xnor2_1
X_33335_ _09667_ \memory_i.freq_inst.dsmod_sin.accu2_r[10]\ VPWR VGND sg13g2_inv_1
X_33336_ _09668_ \memory_i.freq_inst.dsmod_sin.accu2_r[9]\ \memory_i.freq_inst.dsmod_sin.data_interp_r[9]\ \memory_i.freq_inst.dsmod_sin.data_interp_r[8]\ _09646_ \memory_i.freq_inst.dsmod_sin.accu2_r[10]\
+ VPWR
+ VGND sg13g2_a221oi_1
X_33337_ _09669_ \memory_i.freq_inst.dsmod_sin.data_interp_r[8]\ _09646_ \memory_i.freq_inst.dsmod_sin.accu2_r[8]\ VPWR VGND sg13g2_o21ai_1
X_33338_ _09670_ \memory_i.freq_inst.dsmod_sin.data_interp_r[10]\ VPWR VGND sg13g2_inv_1
X_33339_ _09671_ _09667_ _09661_ _09668_ _09669_ _09670_
+ VPWR
+ VGND sg13g2_a221oi_1
X_33340_ _09672_ \memory_i.freq_inst.dsmod_sin.accu2_r[10]\ _09662_ _09671_ VPWR VGND sg13g2_a21oi_1
X_33341_ _09673_ _09666_ _09672_ VPWR VGND sg13g2_xor2_1
X_33342_ _09674_ _09673_ VPWR VGND sg13g2_buf_1
X_33343_ _09675_ _05651_ _09674_ VPWR VGND sg13g2_nor2_1
X_33344_ _01892_ _03328_ _09665_ _09675_ VPWR VGND sg13g2_nor3_1
X_33345_ _09676_ \memory_i.freq_inst.dsmod_cos.i_ena_mod\ \memory_i.freq_inst.dsmod_sin.accu2_r[12]\ VPWR VGND sg13g2_nor2_1
X_33346_ _09677_ _09647_ _09651_ _09659_ _09666_ VPWR
+ VGND
+ sg13g2_nor4_1
X_33347_ _09678_ _09677_ VPWR VGND sg13g2_inv_1
X_33348_ _09679_ _09594_ _09636_ _09642_ _09644_ _09678_
+ VPWR
+ VGND sg13g2_a221oi_1
X_33349_ _09680_ _09679_ VPWR VGND sg13g2_buf_2
X_33350_ _09681_ \memory_i.freq_inst.dsmod_sin.accu2_r[10]\ \memory_i.freq_inst.dsmod_sin.data_interp_r[10]\ \memory_i.freq_inst.dsmod_sin.accu2_r[9]\ VPWR VGND sg13g2_o21ai_1
X_33351_ _09682_ \memory_i.freq_inst.dsmod_sin.accu2_r[8]\ \memory_i.freq_inst.dsmod_sin.data_interp_r[8]\ \memory_i.freq_inst.dsmod_sin.data_interp_r[9]\ VPWR VGND sg13g2_a21o_1
X_33352_ _09683_ _09681_ _09682_ VPWR VGND sg13g2_nand2b_1
X_33353_ _09684_ \memory_i.freq_inst.dsmod_sin.accu2_r[8]\ \memory_i.freq_inst.dsmod_sin.data_interp_r[9]\ \memory_i.freq_inst.dsmod_sin.data_interp_r[8]\ VPWR VGND sg13g2_and3_1
X_33354_ _09685_ \memory_i.freq_inst.dsmod_sin.accu2_r[10]\ \memory_i.freq_inst.dsmod_sin.data_interp_r[10]\ _09684_ VPWR VGND sg13g2_o21ai_1
X_33355_ _09686_ \memory_i.freq_inst.dsmod_sin.accu2_r[10]\ \memory_i.freq_inst.dsmod_sin.data_interp_r[10]\ \memory_i.freq_inst.dsmod_sin.data_interp_r[11]\ VPWR VGND sg13g2_a21oi_1
X_33356_ _09687_ _09683_ _09685_ _09686_ VPWR VGND sg13g2_nand3_1
X_33357_ _09688_ \memory_i.freq_inst.dsmod_sin.accu2_r[10]\ \memory_i.freq_inst.dsmod_sin.data_interp_r[10]\ _09682_ \memory_i.freq_inst.dsmod_sin.accu2_r[9]\ _09684_
+ VPWR
+ VGND sg13g2_a221oi_1
X_33358_ _09689_ \memory_i.freq_inst.dsmod_sin.accu2_r[10]\ \memory_i.freq_inst.dsmod_sin.data_interp_r[10]\ \memory_i.freq_inst.dsmod_sin.data_interp_r[11]\ VPWR VGND sg13g2_o21ai_1
X_33359_ _09690_ _09688_ _09689_ VPWR VGND sg13g2_nor2_1
X_33360_ _09691_ \memory_i.freq_inst.dsmod_sin.accu2_r[11]\ _09687_ _09690_ VPWR VGND sg13g2_a21o_1
X_33361_ _09692_ _09691_ VPWR VGND sg13g2_buf_1
X_33362_ _09693_ _09680_ _09692_ VPWR VGND sg13g2_nor2_1
X_33363_ _09694_ \memory_i.freq_inst.dsmod_sin.accu2_r[12]\ \memory_i.freq_inst.dsmod_sin.data_interp_r[12]\ VPWR VGND sg13g2_xor2_1
X_33364_ _09695_ _09693_ _09694_ VPWR VGND sg13g2_xnor2_1
X_33365_ _09696_ _05651_ _09695_ VPWR VGND sg13g2_nor2_1
X_33366_ _01893_ _03328_ _09676_ _09696_ VPWR VGND sg13g2_nor3_1
X_33367_ _09697_ _15823_ VPWR VGND sg13g2_buf_1
X_33368_ _09698_ \memory_i.freq_inst.dsmod_sin.accu2_r[12]\ VPWR VGND sg13g2_inv_1
X_33369_ _09699_ \memory_i.freq_inst.dsmod_sin.data_interp_r[12]\ _09680_ _09692_ VPWR VGND sg13g2_nor3_1
X_33370_ _09700_ _09680_ _09692_ \memory_i.freq_inst.dsmod_sin.data_interp_r[12]\ VPWR VGND sg13g2_o21ai_1
X_33371_ _09701_ _09698_ _09699_ _09700_ VPWR VGND sg13g2_o21ai_1
X_33372_ _09702_ \memory_i.freq_inst.dsmod_sin.data_interp_r[13]\ _09701_ VPWR VGND sg13g2_xnor2_1
X_33373_ _09703_ _09417_ _09702_ VPWR VGND sg13g2_nor2_1
X_33374_ _09704_ \memory_i.freq_inst.dsmod_sin.accu2_r[13]\ _09703_ VPWR VGND sg13g2_xnor2_1
X_33375_ _01894_ _09697_ _09704_ VPWR VGND sg13g2_nor2_1
X_33376_ _09705_ \memory_i.freq_inst.dsmod_cos.i_ena_mod\ \memory_i.freq_inst.dsmod_sin.accu2_r[14]\ VPWR VGND sg13g2_nor2_1
X_33377_ _09706_ \memory_i.freq_inst.dsmod_sin.accu2_r[12]\ \memory_i.freq_inst.dsmod_sin.data_interp_r[12]\ VPWR VGND sg13g2_nor2_1
X_33378_ _09707_ \memory_i.freq_inst.dsmod_sin.accu2_r[13]\ \memory_i.freq_inst.dsmod_sin.data_interp_r[13]\ VPWR VGND sg13g2_nor2_1
X_33379_ _09708_ _09706_ _09707_ VPWR VGND sg13g2_nor2_1
X_33380_ _09709_ _09637_ _09641_ _09677_ _09708_ VPWR
+ VGND
+ sg13g2_nand4_1
X_33381_ _09710_ _09594_ _09599_ _09709_ VPWR VGND sg13g2_a21oi_2
X_33382_ _09711_ \memory_i.freq_inst.dsmod_sin.accu2_r[11]\ VPWR VGND sg13g2_inv_1
X_33383_ _09712_ _09688_ _09689_ _09711_ VPWR VGND sg13g2_o21ai_1
X_33384_ _09713_ _09687_ _09708_ _09712_ VPWR VGND sg13g2_and3_1
X_33385_ _09714_ \memory_i.freq_inst.dsmod_sin.accu2_r[13]\ \memory_i.freq_inst.dsmod_sin.data_interp_r[13]\ \memory_i.freq_inst.dsmod_sin.data_interp_r[12]\ \memory_i.freq_inst.dsmod_sin.accu2_r[12]\ VPWR
+ VGND
+ sg13g2_a22oi_1
X_33386_ _09715_ _09707_ _09714_ VPWR VGND sg13g2_nor2_1
X_33387_ _09716_ _09644_ _09678_ _09706_ _09707_ VPWR
+ VGND
+ sg13g2_nor4_1
X_33388_ _09717_ _09710_ _09713_ _09715_ _09716_ VPWR
+ VGND
+ sg13g2_nor4_2
X_33389_ _09718_ \memory_i.freq_inst.dsmod_sin.accu2_r[14]\ \memory_i.freq_inst.dsmod_sin.data_interp_r[14]\ VPWR VGND sg13g2_xor2_1
X_33390_ _09719_ _09717_ _09718_ VPWR VGND sg13g2_xnor2_1
X_33391_ _09720_ _05651_ _09719_ VPWR VGND sg13g2_nor2_1
X_33392_ _01895_ _03328_ _09705_ _09720_ VPWR VGND sg13g2_nor3_1
X_33393_ _09721_ \memory_i.freq_inst.dsmod_sin.accu2_r[15]\ \memory_i.freq_inst.dsmod_sin.data_interp_r[15]\ VPWR VGND sg13g2_xor2_1
X_33394_ _09722_ _09710_ _09713_ _09715_ _09716_ VPWR
+ VGND
+ sg13g2_or4_1
X_33395_ _09723_ _09722_ VPWR VGND sg13g2_buf_1
X_33396_ _09724_ \memory_i.freq_inst.dsmod_sin.data_interp_r[14]\ _09723_ \memory_i.freq_inst.dsmod_sin.accu2_r[14]\ VPWR VGND sg13g2_o21ai_1
X_33397_ _09725_ _08358_ _09717_ _09724_ VPWR VGND sg13g2_o21ai_1
X_33398_ _09726_ _09721_ _09725_ VPWR VGND sg13g2_xnor2_1
X_33399_ _09727_ \memory_i.freq_inst.dsmod_cos.i_ena_mod\ _09726_ VPWR VGND sg13g2_nand2_1
X_33400_ _09728_ \memory_i.freq_inst.dsmod_cos.i_ena_mod\ \memory_i.freq_inst.dsmod_sin.accu2_r[15]\ _09727_ VPWR VGND sg13g2_o21ai_1
X_33401_ _01896_ _09697_ _09728_ VPWR VGND sg13g2_nor2_1
X_33402_ _09729_ \memory_i.freq_inst.dsmod_cos.i_ena_mod\ \memory_i.freq_inst.dsmod_sin.accu2_r[16]\ VPWR VGND sg13g2_nor2_1
X_33403_ _09730_ \memory_i.freq_inst.dsmod_sin.accu2_r[16]\ \memory_i.freq_inst.dsmod_sin.data_interp_r[16]\ VPWR VGND sg13g2_xnor2_1
X_33404_ _09731_ _09708_ _09718_ _09721_ VPWR VGND sg13g2_nand3_1
X_33405_ _09732_ \memory_i.freq_inst.dsmod_sin.accu2_r[14]\ \memory_i.freq_inst.dsmod_sin.data_interp_r[14]\ VPWR VGND sg13g2_nor2_1
X_33406_ _09733_ \memory_i.freq_inst.dsmod_sin.accu2_r[15]\ \memory_i.freq_inst.dsmod_sin.data_interp_r[15]\ VPWR VGND sg13g2_nor2_1
X_33407_ _09734_ \memory_i.freq_inst.dsmod_sin.accu2_r[15]\ \memory_i.freq_inst.dsmod_sin.data_interp_r[15]\ VPWR VGND sg13g2_nand2_1
X_33408_ _09735_ _09732_ _09733_ _09734_ VPWR VGND sg13g2_o21ai_1
X_33409_ _09736_ \memory_i.freq_inst.dsmod_sin.accu2_r[15]\ \memory_i.freq_inst.dsmod_sin.data_interp_r[15]\ \memory_i.freq_inst.dsmod_sin.data_interp_r[14]\ \memory_i.freq_inst.dsmod_sin.accu2_r[14]\ VPWR
+ VGND
+ sg13g2_a22oi_1
X_33410_ _09737_ _09707_ _09714_ _09736_ VPWR VGND sg13g2_o21ai_1
X_33411_ _09738_ _09735_ _09737_ VPWR VGND sg13g2_nand2_1
X_33412_ _09739_ _09693_ _09731_ _09738_ VPWR VGND sg13g2_o21ai_1
X_33413_ _09740_ _09730_ _09739_ VPWR VGND sg13g2_xnor2_1
X_33414_ _09741_ _05651_ _09740_ VPWR VGND sg13g2_nor2_1
X_33415_ _01897_ _03328_ _09729_ _09741_ VPWR VGND sg13g2_nor3_1
X_33416_ _09742_ _09735_ _09737_ VPWR VGND sg13g2_and2_1
X_33417_ _09743_ \memory_i.freq_inst.dsmod_sin.data_interp_r[16]\ _09742_ VPWR VGND sg13g2_nor2_1
X_33418_ _09744_ _09733_ _09736_ VPWR VGND sg13g2_nor2_1
X_33419_ _09745_ \memory_i.freq_inst.dsmod_sin.accu2_r[16]\ _09744_ VPWR VGND sg13g2_nor2_1
X_33420_ _09746_ \memory_i.freq_inst.dsmod_sin.data_interp_r[16]\ _09735_ \memory_i.freq_inst.dsmod_sin.accu2_r[16]\ VPWR VGND sg13g2_a21oi_1
X_33421_ _09747_ _09731_ _09743_ _09746_ VPWR VGND sg13g2_a21o_1
X_33422_ _09748_ _09693_ _09743_ _09745_ _09717_ _09747_
+ VPWR
+ VGND sg13g2_a221oi_1
X_33423_ _09749_ _09748_ VPWR VGND sg13g2_buf_2
X_33424_ _09750_ \memory_i.freq_inst.dsmod_sin.accu2_r[17]\ \memory_i.freq_inst.dsmod_sin.data_interp_r[17]\ VPWR VGND sg13g2_xnor2_1
X_33425_ _09751_ _09749_ _09750_ VPWR VGND sg13g2_xnor2_1
X_33426_ _09752_ \memory_i.freq_inst.dsmod_cos.i_ena_mod\ _09751_ VPWR VGND sg13g2_nand2_1
X_33427_ _09753_ _08219_ \memory_i.freq_inst.dsmod_sin.accu2_r[17]\ VPWR VGND sg13g2_nand2_1
X_33428_ _01898_ _09752_ _09753_ _08911_ VPWR VGND sg13g2_a21oi_1
X_33429_ _09754_ \memory_i.freq_inst.dsmod_sin.accu2_r[18]\ \memory_i.freq_inst.dsmod_sin.data_interp_r[18]\ VPWR VGND sg13g2_xnor2_1
X_33430_ _09755_ \memory_i.freq_inst.dsmod_sin.accu2_r[17]\ _09749_ \memory_i.freq_inst.dsmod_sin.data_interp_r[17]\ VPWR VGND sg13g2_a21oi_1
X_33431_ _09756_ \memory_i.freq_inst.dsmod_sin.accu2_r[17]\ _09749_ VPWR VGND sg13g2_nor2_1
X_33432_ _09757_ _09755_ _09756_ VPWR VGND sg13g2_nor2_1
X_33433_ _09758_ _09754_ _09757_ VPWR VGND sg13g2_xor2_1
X_33434_ _09759_ _12940_ _09758_ VPWR VGND sg13g2_nor2_1
X_33435_ _09760_ _08219_ \memory_i.freq_inst.dsmod_sin.accu2_r[18]\ _09759_ VPWR VGND sg13g2_a21oi_1
X_33436_ _01899_ _09697_ _09760_ VPWR VGND sg13g2_nor2_1
X_33437_ _09761_ \memory_i.freq_inst.dsmod_sin.data_interp_r[16]\ _09680_ _09692_ _09742_ VPWR
+ VGND
+ sg13g2_nor4_1
X_33438_ _09762_ \memory_i.freq_inst.dsmod_sin.accu2_r[18]\ VPWR VGND sg13g2_inv_1
X_33439_ _09763_ \memory_i.freq_inst.dsmod_sin.accu2_r[17]\ \memory_i.freq_inst.dsmod_sin.data_interp_r[17]\ \memory_i.freq_inst.dsmod_sin.data_interp_r[18]\ VPWR VGND sg13g2_a21oi_1
X_33440_ _09764_ \memory_i.freq_inst.dsmod_sin.accu2_r[17]\ \memory_i.freq_inst.dsmod_sin.data_interp_r[18]\ \memory_i.freq_inst.dsmod_sin.data_interp_r[17]\ VPWR VGND sg13g2_nand3_1
X_33441_ _09765_ _09762_ _09763_ _09764_ VPWR VGND sg13g2_o21ai_1
X_33442_ _09766_ _09765_ VPWR VGND sg13g2_buf_1
X_33443_ _09767_ _09766_ VPWR VGND sg13g2_inv_1
X_33444_ _09768_ _09761_ _09747_ _09767_ VPWR VGND sg13g2_o21ai_1
X_33445_ _09769_ \memory_i.freq_inst.dsmod_sin.accu2_r[16]\ _09744_ _09766_ VPWR VGND sg13g2_nor3_1
X_33446_ _09770_ \memory_i.freq_inst.dsmod_sin.accu2_r[17]\ \memory_i.freq_inst.dsmod_sin.data_interp_r[17]\ \memory_i.freq_inst.dsmod_sin.data_interp_r[18]\ VPWR VGND sg13g2_o21ai_1
X_33447_ _09771_ \memory_i.freq_inst.dsmod_sin.accu2_r[17]\ \memory_i.freq_inst.dsmod_sin.data_interp_r[18]\ \memory_i.freq_inst.dsmod_sin.data_interp_r[17]\ VPWR VGND sg13g2_nor3_1
X_33448_ _09772_ _09762_ _09770_ _09771_ VPWR VGND sg13g2_a21oi_1
X_33449_ _09773_ _09772_ VPWR VGND sg13g2_inv_1
X_33450_ _09774_ _09717_ _09769_ _09773_ VPWR VGND sg13g2_a21oi_1
X_33451_ _09775_ _09768_ _09774_ VPWR VGND sg13g2_and2_1
X_33452_ _09776_ \memory_i.freq_inst.dsmod_sin.accu2_r[19]\ \memory_i.freq_inst.dsmod_sin.data_interp_r[19]\ VPWR VGND sg13g2_xnor2_1
X_33453_ _09777_ _09775_ _09776_ VPWR VGND sg13g2_xnor2_1
X_33454_ _09778_ \memory_i.freq_inst.dsmod_cos.i_ena_mod\ \memory_i.freq_inst.dsmod_sin.accu2_r[19]\ VPWR VGND sg13g2_nor2b_1
X_33455_ _09779_ \memory_i.freq_inst.dsmod_cos.i_ena_mod\ _09777_ _09778_ VPWR VGND sg13g2_a21oi_1
X_33456_ _01900_ _09697_ _09779_ VPWR VGND sg13g2_nor2_1
X_33457_ _09780_ \memory_i.freq_inst.dsmod_sin.data_interp_r[19]\ _09766_ VPWR VGND sg13g2_or2_1
X_33458_ _09781_ \memory_i.freq_inst.dsmod_sin.accu2_r[19]\ _09766_ VPWR VGND sg13g2_or2_1
X_33459_ _09782_ _09780_ _09781_ _09749_ VPWR VGND sg13g2_a21o_1
X_33460_ _09783_ _09782_ VPWR VGND sg13g2_buf_1
X_33461_ _09784_ \memory_i.freq_inst.dsmod_sin.accu2_r[19]\ \memory_i.freq_inst.dsmod_sin.data_interp_r[19]\ _09772_ VPWR VGND sg13g2_a21oi_1
X_33462_ _09785_ \memory_i.freq_inst.dsmod_sin.accu2_r[19]\ \memory_i.freq_inst.dsmod_sin.data_interp_r[19]\ VPWR VGND sg13g2_nor2_1
X_33463_ _09786_ _09784_ _09785_ VPWR VGND sg13g2_nor2_1
X_33464_ _09787_ _09783_ _09786_ VPWR VGND sg13g2_nand2_1
X_33465_ _09788_ _09787_ VPWR VGND sg13g2_buf_1
X_33466_ _09789_ \memory_i.freq_inst.dsmod_sin.data_interp_r[20]\ _09788_ VPWR VGND sg13g2_xnor2_1
X_33467_ _09790_ \memory_i.freq_inst.dsmod_cos.i_ena_mod\ _09789_ VPWR VGND sg13g2_nand2_1
X_33468_ _09791_ \memory_i.freq_inst.dsmod_sin.accu2_r[20]\ _09790_ VPWR VGND sg13g2_xor2_1
X_33469_ _01901_ _09697_ _09791_ VPWR VGND sg13g2_nor2_1
X_33470_ _09792_ \memory_i.freq_inst.dsmod_sin.accu2_r[20]\ \memory_i.freq_inst.dsmod_sin.data_interp_r[20]\ VPWR VGND sg13g2_or2_1
X_33471_ _09793_ _09792_ VPWR VGND sg13g2_buf_1
X_33472_ _09794_ \memory_i.freq_inst.dsmod_sin.accu2_r[20]\ \memory_i.freq_inst.dsmod_sin.data_interp_r[20]\ VPWR VGND sg13g2_nand2_1
X_33473_ _09795_ _09788_ _09794_ VPWR VGND sg13g2_nand2_1
X_33474_ _09796_ _09793_ _09795_ \memory_i.freq_inst.dsmod_sin.data_interp_r[21]\ VPWR VGND sg13g2_a21oi_1
X_33475_ _09797_ \memory_i.freq_inst.dsmod_sin.data_interp_r[21]\ _09793_ _09795_ VPWR VGND sg13g2_and3_1
X_33476_ _09798_ _12939_ _09796_ _09797_ VPWR VGND sg13g2_nor3_1
X_33477_ _09799_ \memory_i.freq_inst.dsmod_sin.accu2_r[21]\ _09798_ VPWR VGND sg13g2_xnor2_1
X_33478_ _01902_ _09697_ _09799_ VPWR VGND sg13g2_nor2_1
X_33479_ _09800_ \memory_i.freq_inst.dsmod_sin.accu2_r[21]\ \memory_i.freq_inst.dsmod_sin.data_interp_r[21]\ VPWR VGND sg13g2_and2_1
X_33480_ _09801_ _09800_ VPWR VGND sg13g2_buf_1
X_33481_ _09802_ \memory_i.freq_inst.dsmod_sin.data_interp_r[20]\ \memory_i.freq_inst.dsmod_sin.data_interp_r[19]\ _09801_ VPWR VGND sg13g2_or3_1
X_33482_ _09803_ \memory_i.freq_inst.dsmod_sin.accu2_r[20]\ \memory_i.freq_inst.dsmod_sin.data_interp_r[19]\ _09801_ VPWR VGND sg13g2_or3_1
X_33483_ _09804_ _09768_ _09774_ _09802_ _09803_ VPWR
+ VGND
+ sg13g2_a22oi_1
X_33484_ _09805_ _09804_ VPWR VGND sg13g2_buf_2
X_33485_ _09806_ \memory_i.freq_inst.dsmod_sin.accu2_r[19]\ \memory_i.freq_inst.dsmod_sin.data_interp_r[20]\ _09801_ VPWR VGND sg13g2_or3_1
X_33486_ _09807_ \memory_i.freq_inst.dsmod_sin.accu2_r[20]\ \memory_i.freq_inst.dsmod_sin.accu2_r[19]\ _09801_ VPWR VGND sg13g2_or3_1
X_33487_ _09808_ _09768_ _09774_ _09806_ _09807_ VPWR
+ VGND
+ sg13g2_a22oi_1
X_33488_ _09809_ _09808_ VPWR VGND sg13g2_buf_2
X_33489_ _09810_ _09806_ _09807_ \memory_i.freq_inst.dsmod_sin.data_interp_r[19]\ VPWR VGND sg13g2_a21o_1
X_33490_ _09811_ _09793_ _09801_ _09810_ VPWR VGND sg13g2_o21ai_1
X_33491_ _09812_ _09811_ VPWR VGND sg13g2_buf_2
X_33492_ _09813_ \memory_i.freq_inst.dsmod_sin.accu2_r[21]\ \memory_i.freq_inst.dsmod_sin.data_interp_r[21]\ VPWR VGND sg13g2_nor2_1
X_33493_ _09814_ _09805_ _09809_ _09812_ _09813_ VPWR
+ VGND
+ sg13g2_nor4_1
X_33494_ _09815_ \memory_i.freq_inst.dsmod_sin.data_interp_r[22]\ _09814_ VPWR VGND sg13g2_xnor2_1
X_33495_ _09816_ _09417_ _09815_ VPWR VGND sg13g2_nor2_1
X_33496_ _09817_ \memory_i.freq_inst.dsmod_sin.accu2_r[22]\ _09816_ VPWR VGND sg13g2_xnor2_1
X_33497_ _01903_ _09697_ _09817_ VPWR VGND sg13g2_nor2_1
X_33498_ _09818_ \memory_i.freq_inst.dsmod_sin.accu2_r[21]\ \memory_i.freq_inst.dsmod_sin.data_interp_r[21]\ \memory_i.freq_inst.dsmod_sin.accu2_r[22]\ VPWR VGND sg13g2_o21ai_1
X_33499_ _09819_ _09805_ _09809_ _09812_ _09818_ VPWR
+ VGND
+ sg13g2_nor4_1
X_33500_ _09820_ \memory_i.freq_inst.dsmod_sin.accu2_r[22]\ \memory_i.freq_inst.dsmod_sin.data_interp_r[22]\ VPWR VGND sg13g2_nand2_1
X_33501_ _09821_ _09819_ _09820_ VPWR VGND sg13g2_nand2b_1
X_33502_ _09822_ \memory_i.freq_inst.dsmod_sin.data_interp_r[22]\ _09814_ _09821_ VPWR VGND sg13g2_a21oi_1
X_33503_ _09823_ \memory_i.freq_inst.dsmod_sin.accu2_r[23]\ \memory_i.freq_inst.dsmod_sin.data_interp_r[23]\ VPWR VGND sg13g2_xor2_1
X_33504_ _09824_ _09822_ _09823_ VPWR VGND sg13g2_xnor2_1
X_33505_ _09825_ _09824_ VPWR VGND sg13g2_buf_1
X_33506_ _09826_ \memory_i.freq_inst.dsmod_cos.i_ena_mod\ _09825_ VPWR VGND sg13g2_nand2_1
X_33507_ _09827_ _08219_ \memory_i.freq_inst.dsmod_sin.accu2_r[23]\ VPWR VGND sg13g2_nand2_1
X_33508_ _01904_ _09826_ _09827_ _08911_ VPWR VGND sg13g2_a21oi_1
X_33509_ _09828_ \memory_i.freq_inst.dsmod_sin.accu2_r[24]\ VPWR VGND sg13g2_inv_1
X_33510_ _09829_ \memory_i.freq_inst.dsmod_sin.accu2_r[23]\ \memory_i.freq_inst.dsmod_sin.data_interp_r[23]\ VPWR VGND sg13g2_nor2_1
X_33511_ _09830_ _09813_ _09829_ VPWR VGND sg13g2_nor2_1
X_33512_ _09831_ \memory_i.freq_inst.dsmod_sin.data_interp_r[22]\ _09830_ VPWR VGND sg13g2_nand2_1
X_33513_ _09832_ _09805_ _09809_ _09812_ _09831_ VPWR
+ VGND
+ sg13g2_nor4_1
X_33514_ _09833_ _09832_ VPWR VGND sg13g2_buf_4
X_33515_ _09834_ \memory_i.freq_inst.dsmod_sin.accu2_r[22]\ _09830_ VPWR VGND sg13g2_nand2_1
X_33516_ _09835_ _09805_ _09809_ _09812_ _09834_ VPWR
+ VGND
+ sg13g2_nor4_1
X_33517_ _09836_ _09835_ VPWR VGND sg13g2_buf_2
X_33518_ _09837_ \memory_i.freq_inst.dsmod_sin.accu2_r[23]\ \memory_i.freq_inst.dsmod_sin.data_interp_r[23]\ VPWR VGND sg13g2_nand2_1
X_33519_ _09838_ _09820_ _09829_ _09837_ VPWR VGND sg13g2_o21ai_1
X_33520_ _09839_ _09838_ VPWR VGND sg13g2_buf_2
X_33521_ _09840_ _09833_ _09836_ _09839_ VPWR VGND sg13g2_or3_1
X_33522_ _09841_ _09840_ VPWR VGND sg13g2_buf_1
X_33523_ _09842_ _08467_ _09841_ VPWR VGND sg13g2_xnor2_1
X_33524_ _09843_ \memory_i.freq_inst.dsmod_cos.i_ena_mod\ _09842_ VPWR VGND sg13g2_nand2_1
X_33525_ _09844_ _09828_ _09843_ VPWR VGND sg13g2_xnor2_1
X_33526_ _01905_ _09697_ _09844_ VPWR VGND sg13g2_nor2_1
X_33527_ _09845_ _09833_ _09836_ _09839_ VPWR VGND sg13g2_nor3_2
X_33528_ _09846_ \memory_i.freq_inst.dsmod_sin.accu2_r[24]\ \memory_i.freq_inst.dsmod_sin.data_interp_r[24]\ VPWR VGND sg13g2_nand2_1
X_33529_ _09847_ \memory_i.freq_inst.dsmod_sin.accu2_r[24]\ \memory_i.freq_inst.dsmod_sin.data_interp_r[24]\ VPWR VGND sg13g2_nor2_1
X_33530_ _09848_ _09845_ _09846_ _09847_ VPWR VGND sg13g2_a21oi_1
X_33531_ _09849_ _09848_ VPWR VGND sg13g2_buf_4
X_33532_ _09850_ _08478_ _09849_ VPWR VGND sg13g2_xnor2_1
X_33533_ _09851_ \memory_i.freq_inst.dsmod_cos.i_ena_mod\ _09850_ VPWR VGND sg13g2_nand2_1
X_33534_ _09852_ \memory_i.freq_inst.dsmod_sin.accu2_r[25]\ _09851_ VPWR VGND sg13g2_xor2_1
X_33535_ _01906_ _09697_ _09852_ VPWR VGND sg13g2_nor2_1
X_33536_ _09853_ \memory_i.freq_inst.dsmod_sin.accu2_r[26]\ \memory_i.freq_inst.dsmod_sin.data_interp_r[26]\ VPWR VGND sg13g2_xnor2_1
X_33537_ _09854_ \memory_i.freq_inst.dsmod_sin.accu2_r[25]\ \memory_i.freq_inst.dsmod_sin.data_interp_r[25]\ VPWR VGND sg13g2_or2_1
X_33538_ _09855_ \memory_i.freq_inst.dsmod_sin.accu2_r[25]\ \memory_i.freq_inst.dsmod_sin.data_interp_r[25]\ VPWR VGND sg13g2_and2_1
X_33539_ _09856_ _09849_ _09854_ _09855_ VPWR VGND sg13g2_a21oi_1
X_33540_ _09857_ _09853_ _09856_ VPWR VGND sg13g2_xnor2_1
X_33541_ _09858_ \memory_i.freq_inst.dsmod_cos.i_ena_mod\ _09857_ VPWR VGND sg13g2_nand2_1
X_33542_ _09859_ \memory_i.freq_inst.dsmod_cos.i_ena_mod\ \memory_i.freq_inst.dsmod_sin.accu2_r[26]\ _09858_ VPWR VGND sg13g2_o21ai_1
X_33543_ _01907_ _09697_ _09859_ VPWR VGND sg13g2_nor2_1
X_33544_ _09860_ _15823_ VPWR VGND sg13g2_buf_1
X_33545_ _09861_ \memory_i.freq_inst.dsmod_sin.accu2_r[26]\ \memory_i.freq_inst.dsmod_sin.data_interp_r[26]\ VPWR VGND sg13g2_nand2_1
X_33546_ _09862_ _09855_ _09861_ VPWR VGND sg13g2_nor2b_1
X_33547_ _09863_ _09849_ _09862_ VPWR VGND sg13g2_nand2b_1
X_33548_ _09864_ \memory_i.freq_inst.dsmod_sin.accu2_r[27]\ \memory_i.freq_inst.dsmod_sin.data_interp_r[27]\ VPWR VGND sg13g2_xor2_1
X_33549_ _09865_ \memory_i.freq_inst.dsmod_sin.accu2_r[25]\ \memory_i.freq_inst.dsmod_sin.data_interp_r[25]\ VPWR VGND sg13g2_nor2_1
X_33550_ _09866_ \memory_i.freq_inst.dsmod_sin.accu2_r[26]\ \memory_i.freq_inst.dsmod_sin.data_interp_r[26]\ VPWR VGND sg13g2_nor2_1
X_33551_ _09867_ _09865_ _09861_ _09866_ VPWR VGND sg13g2_a21oi_1
X_33552_ _09868_ _09864_ _09867_ VPWR VGND sg13g2_and2_1
X_33553_ _09869_ \memory_i.freq_inst.dsmod_sin.accu2_r[26]\ \memory_i.freq_inst.dsmod_sin.data_interp_r[26]\ \memory_i.freq_inst.dsmod_sin.data_interp_r[25]\ \memory_i.freq_inst.dsmod_sin.accu2_r[25]\ _09864_
+ VPWR
+ VGND sg13g2_a221oi_1
X_33554_ _09870_ _09869_ VPWR VGND sg13g2_inv_1
X_33555_ _09871_ _09864_ _09867_ VPWR VGND sg13g2_or2_1
X_33556_ _09872_ _09849_ _09870_ _09871_ VPWR VGND sg13g2_o21ai_1
X_33557_ _09873_ _09863_ _09868_ _09872_ VPWR VGND sg13g2_a21oi_1
X_33558_ _09874_ \memory_i.freq_inst.dsmod_cos.i_ena_mod\ \memory_i.freq_inst.dsmod_sin.accu2_r[27]\ VPWR VGND sg13g2_nor2b_1
X_33559_ _09875_ \memory_i.freq_inst.dsmod_cos.i_ena_mod\ _09873_ _09874_ VPWR VGND sg13g2_a21oi_1
X_33560_ _01908_ _09860_ _09875_ VPWR VGND sg13g2_nor2_1
X_33561_ _09876_ \memory_i.freq_inst.dsmod_sin.accu2_r[25]\ \memory_i.freq_inst.dsmod_sin.data_interp_r[25]\ VPWR VGND sg13g2_xnor2_1
X_33562_ _09877_ _09876_ VPWR VGND sg13g2_buf_1
X_33563_ _09878_ \memory_i.freq_inst.dsmod_sin.accu2_r[24]\ \memory_i.freq_inst.dsmod_sin.data_interp_r[24]\ VPWR VGND sg13g2_xnor2_1
X_33564_ _09879_ _09877_ _09878_ VPWR VGND sg13g2_nor2_1
X_33565_ _09880_ _09853_ _09864_ _09879_ VPWR VGND sg13g2_nand3b_1
X_33566_ _09881_ _09880_ VPWR VGND sg13g2_buf_1
X_33567_ _09882_ _09881_ VPWR VGND sg13g2_inv_1
X_33568_ _09883_ _09828_ _08467_ VPWR VGND sg13g2_nor2_1
X_33569_ _09884_ \memory_i.freq_inst.dsmod_sin.data_interp_r[25]\ _09883_ \memory_i.freq_inst.dsmod_sin.accu2_r[25]\ VPWR VGND sg13g2_a21o_1
X_33570_ _09885_ \memory_i.freq_inst.dsmod_sin.data_interp_r[25]\ _09883_ _09884_ VPWR VGND sg13g2_o21ai_1
X_33571_ _09886_ _09866_ _09885_ _09861_ VPWR VGND sg13g2_o21ai_1
X_33572_ _09887_ \memory_i.freq_inst.dsmod_sin.data_interp_r[27]\ _09886_ \memory_i.freq_inst.dsmod_sin.accu2_r[27]\ VPWR VGND sg13g2_a21oi_1
X_33573_ _09888_ \memory_i.freq_inst.dsmod_sin.data_interp_r[27]\ _09886_ VPWR VGND sg13g2_nor2_1
X_33574_ _09889_ _09887_ _09888_ VPWR VGND sg13g2_nor2_1
X_33575_ _09890_ _09841_ _09882_ _09889_ VPWR VGND sg13g2_a21oi_1
X_33576_ _09891_ \memory_i.freq_inst.dsmod_sin.accu2_r[28]\ \memory_i.freq_inst.dsmod_sin.data_interp_r[28]\ VPWR VGND sg13g2_xnor2_1
X_33577_ _09892_ _09890_ _09891_ VPWR VGND sg13g2_xnor2_1
X_33578_ _09893_ _12940_ _09892_ VPWR VGND sg13g2_nor2_1
X_33579_ _09894_ _07051_ \memory_i.freq_inst.dsmod_sin.accu2_r[28]\ _09893_ VPWR VGND sg13g2_a21oi_1
X_33580_ _01909_ _09860_ _09894_ VPWR VGND sg13g2_nor2_1
X_33581_ _09895_ \memory_i.freq_inst.dsmod_sin.accu2_r[29]\ \memory_i.freq_inst.dsmod_sin.data_interp_r[29]\ VPWR VGND sg13g2_xnor2_1
X_33582_ _09896_ \memory_i.freq_inst.dsmod_sin.accu2_r[28]\ \memory_i.freq_inst.dsmod_sin.data_interp_r[28]\ VPWR VGND sg13g2_nor2_1
X_33583_ _09897_ \memory_i.freq_inst.dsmod_sin.accu2_r[28]\ \memory_i.freq_inst.dsmod_sin.data_interp_r[28]\ VPWR VGND sg13g2_nand2_1
X_33584_ _09898_ _09890_ _09896_ _09897_ VPWR VGND sg13g2_o21ai_1
X_33585_ _09899_ _09895_ _09898_ VPWR VGND sg13g2_xnor2_1
X_33586_ _09900_ \memory_i.freq_inst.dsmod_cos.i_ena_mod\ _09899_ VPWR VGND sg13g2_nand2_1
X_33587_ _09901_ _08219_ \memory_i.freq_inst.dsmod_sin.accu2_r[29]\ VPWR VGND sg13g2_nand2_1
X_33588_ _01910_ _09900_ _09901_ _08911_ VPWR VGND sg13g2_a21oi_1
X_33589_ _09902_ \memory_i.freq_inst.dsmod_sin.accu2_r[29]\ \memory_i.freq_inst.dsmod_sin.data_interp_r[29]\ \memory_i.freq_inst.dsmod_sin.data_interp_r[28]\ VPWR VGND sg13g2_a21oi_1
X_33590_ _09903_ _09887_ _09888_ _09902_ VPWR VGND sg13g2_o21ai_1
X_33591_ _09904_ _09833_ _09836_ _09839_ _09903_ VPWR
+ VGND
+ sg13g2_nor4_1
X_33592_ _09905_ \memory_i.freq_inst.dsmod_sin.accu2_r[29]\ \memory_i.freq_inst.dsmod_sin.data_interp_r[29]\ \memory_i.freq_inst.dsmod_sin.accu2_r[28]\ VPWR VGND sg13g2_a21oi_1
X_33593_ _09906_ _09887_ _09888_ _09905_ VPWR VGND sg13g2_o21ai_1
X_33594_ _09907_ _09833_ _09836_ _09839_ _09906_ VPWR
+ VGND
+ sg13g2_nor4_1
X_33595_ _09908_ \memory_i.freq_inst.dsmod_sin.accu2_r[29]\ \memory_i.freq_inst.dsmod_sin.data_interp_r[29]\ VPWR VGND sg13g2_nand2_1
X_33596_ _09909_ _09881_ _09902_ VPWR VGND sg13g2_nand2_1
X_33597_ _09910_ _09881_ _09905_ VPWR VGND sg13g2_nand2_1
X_33598_ _09911_ _09909_ _09910_ _09889_ VPWR VGND sg13g2_a21oi_1
X_33599_ _09912_ _09896_ _09908_ _09911_ VPWR VGND sg13g2_a21o_1
X_33600_ _09913_ _09912_ VPWR VGND sg13g2_buf_1
X_33601_ _09914_ \memory_i.freq_inst.dsmod_sin.accu2_r[29]\ \memory_i.freq_inst.dsmod_sin.data_interp_r[29]\ VPWR VGND sg13g2_nor2_1
X_33602_ _09915_ _09904_ _09907_ _09913_ _09914_ VPWR
+ VGND
+ sg13g2_nor4_1
X_33603_ _09916_ \memory_i.freq_inst.dsmod_sin.accu2_r[30]\ \memory_i.freq_inst.dsmod_sin.data_interp_r[30]\ VPWR VGND sg13g2_xnor2_1
X_33604_ _09917_ _09915_ _09916_ VPWR VGND sg13g2_xnor2_1
X_33605_ _09918_ _09917_ VPWR VGND sg13g2_buf_1
X_33606_ _09919_ \memory_i.freq_inst.dsmod_cos.i_ena_mod\ \memory_i.freq_inst.dsmod_sin.accu2_r[30]\ VPWR VGND sg13g2_nor2b_1
X_33607_ _09920_ \memory_i.freq_inst.dsmod_cos.i_ena_mod\ _09918_ _09919_ VPWR VGND sg13g2_a21oi_1
X_33608_ _01911_ _09860_ _09920_ VPWR VGND sg13g2_nor2_1
X_33609_ _09921_ \memory_i.freq_inst.dsmod_sin.accu2_r[31]\ \memory_i.freq_inst.dsmod_sin.data_interp_r[31]\ VPWR VGND sg13g2_xor2_1
X_33610_ _09922_ \memory_i.freq_inst.dsmod_sin.accu2_r[30]\ _09915_ \memory_i.freq_inst.dsmod_sin.data_interp_r[30]\ VPWR VGND sg13g2_a21o_1
X_33611_ _09923_ \memory_i.freq_inst.dsmod_sin.accu2_r[30]\ _09915_ _09922_ VPWR VGND sg13g2_o21ai_1
X_33612_ _09924_ _09921_ _09923_ VPWR VGND sg13g2_xnor2_1
X_33613_ _09925_ _09924_ VPWR VGND sg13g2_buf_1
X_33614_ _09926_ \memory_i.freq_inst.dsmod_cos.i_ena_mod\ \memory_i.freq_inst.dsmod_sin.accu2_r[31]\ VPWR VGND sg13g2_nor2b_1
X_33615_ _09927_ \memory_i.freq_inst.dsmod_cos.i_ena_mod\ _09925_ _09926_ VPWR VGND sg13g2_a21oi_1
X_33616_ _01912_ _09860_ _09927_ VPWR VGND sg13g2_nor2_1
X_33617_ _09928_ \memory_i.freq_inst.dsmod_sin.accu2_r[31]\ \memory_i.freq_inst.dsmod_sin.data_interp_r[31]\ VPWR VGND sg13g2_nor2_1
X_33618_ _09929_ _09914_ _09928_ VPWR VGND sg13g2_nor2_1
X_33619_ _09930_ \memory_i.freq_inst.dsmod_sin.data_interp_r[30]\ _09929_ VPWR VGND sg13g2_nand2_1
X_33620_ _09931_ _09904_ _09907_ _09913_ _09930_ VPWR
+ VGND
+ sg13g2_nor4_2
X_33621_ _09932_ \memory_i.freq_inst.dsmod_sin.accu2_r[30]\ _09929_ VPWR VGND sg13g2_nand2_1
X_33622_ _09933_ _09904_ _09907_ _09913_ _09932_ VPWR
+ VGND
+ sg13g2_nor4_2
X_33623_ _09934_ \memory_i.freq_inst.dsmod_sin.accu2_r[30]\ \memory_i.freq_inst.dsmod_sin.data_interp_r[30]\ VPWR VGND sg13g2_nand2_1
X_33624_ _09935_ \memory_i.freq_inst.dsmod_sin.accu2_r[31]\ \memory_i.freq_inst.dsmod_sin.data_interp_r[31]\ VPWR VGND sg13g2_nand2_1
X_33625_ _09936_ _09928_ _09934_ _09935_ VPWR VGND sg13g2_o21ai_1
X_33626_ _09937_ _09931_ _09933_ _09936_ VPWR VGND sg13g2_nor3_2
X_33627_ _09938_ _09472_ _09937_ VPWR VGND sg13g2_xnor2_1
X_33628_ _09939_ _09417_ _09938_ VPWR VGND sg13g2_nor2_1
X_33629_ _09940_ \memory_i.freq_inst.dsmod_sin.accu2_r[32]\ _09939_ VPWR VGND sg13g2_xnor2_1
X_33630_ _01913_ _09860_ _09940_ VPWR VGND sg13g2_nor2_1
X_33631_ _09941_ \memory_i.freq_inst.dsmod_sin.accu2_r[33]\ \memory_i.freq_inst.dsmod_sin.data_interp_r[33]\ VPWR VGND sg13g2_xnor2_1
X_33632_ _09942_ _09472_ _09937_ VPWR VGND sg13g2_nor2_1
X_33633_ _09943_ \memory_i.freq_inst.dsmod_sin.accu2_r[32]\ _09942_ VPWR VGND sg13g2_nor2_1
X_33634_ _09944_ _09472_ _09937_ _09943_ VPWR VGND sg13g2_a21oi_1
X_33635_ _09945_ _09941_ _09944_ VPWR VGND sg13g2_xnor2_1
X_33636_ _09946_ _09945_ VPWR VGND sg13g2_buf_1
X_33637_ _09947_ \memory_i.freq_inst.dsmod_cos.i_ena_mod\ \memory_i.freq_inst.dsmod_sin.accu2_r[33]\ VPWR VGND sg13g2_nor2b_1
X_33638_ _09948_ \memory_i.freq_inst.dsmod_cos.i_ena_mod\ _09946_ _09947_ VPWR VGND sg13g2_a21oi_1
X_33639_ _01914_ _09860_ _09948_ VPWR VGND sg13g2_nor2_1
X_33640_ _09949_ \memory_i.freq_inst.dsmod_cos.i_ena_mod\ \memory_i.freq_inst.dsmod_sin.accu2_r[34]\ VPWR VGND sg13g2_nor2_1
X_33641_ _09950_ \memory_i.freq_inst.dsmod_sin.accu2_r[33]\ \memory_i.freq_inst.dsmod_sin.data_interp_r[33]\ VPWR VGND sg13g2_and2_1
X_33642_ _09951_ \memory_i.freq_inst.dsmod_sin.accu2_r[33]\ \memory_i.freq_inst.dsmod_sin.data_interp_r[33]\ VPWR VGND sg13g2_or2_1
X_33643_ _09952_ _09951_ VPWR VGND sg13g2_buf_1
X_33644_ _09953_ _09944_ _09950_ _09952_ VPWR VGND sg13g2_o21ai_1
X_33645_ _09954_ \memory_i.freq_inst.dsmod_sin.accu2_r[34]\ \memory_i.freq_inst.dsmod_sin.data_interp_r[34]\ VPWR VGND sg13g2_xor2_1
X_33646_ _09955_ _09953_ _09954_ VPWR VGND sg13g2_xnor2_1
X_33647_ _09956_ _09955_ VPWR VGND sg13g2_buf_2
X_33648_ _09957_ _05651_ _09956_ VPWR VGND sg13g2_nor2_1
X_33649_ _01915_ _03328_ _09949_ _09957_ VPWR VGND sg13g2_nor3_1
X_33650_ _09958_ \memory_i.freq_inst.dsmod_cos.i_ena_mod\ \memory_i.freq_inst.dsmod_sin.accu2_r[35]\ VPWR VGND sg13g2_nor2_1
X_33651_ _09959_ \memory_i.freq_inst.dsmod_sin.accu2_r[34]\ VPWR VGND sg13g2_inv_1
X_33652_ _09960_ \memory_i.freq_inst.dsmod_sin.accu2_r[33]\ \memory_i.freq_inst.dsmod_sin.data_interp_r[33]\ VPWR VGND sg13g2_nand2_1
X_33653_ _09961_ _08557_ _09472_ _09960_ VPWR VGND sg13g2_nand3_1
X_33654_ _09962_ _09931_ _09933_ _09936_ _09961_ VPWR
+ VGND
+ sg13g2_nor4_1
X_33655_ _09963_ \memory_i.freq_inst.dsmod_sin.accu2_r[32]\ _08557_ _09960_ VPWR VGND sg13g2_nand3b_1
X_33656_ _09964_ _09931_ _09933_ _09936_ _09963_ VPWR
+ VGND
+ sg13g2_nor4_1
X_33657_ _09965_ \memory_i.freq_inst.dsmod_sin.accu2_r[33]\ \memory_i.freq_inst.dsmod_sin.data_interp_r[33]\ VPWR VGND sg13g2_nor2_1
X_33658_ _09966_ _08557_ _09965_ VPWR VGND sg13g2_nand2_1
X_33659_ _09967_ \memory_i.freq_inst.dsmod_sin.data_interp_r[32]\ _09963_ _09966_ VPWR VGND sg13g2_o21ai_1
X_33660_ _09968_ _09959_ _09962_ _09964_ _09967_ VPWR
+ VGND
+ sg13g2_nor4_2
X_33661_ _09969_ \memory_i.freq_inst.dsmod_sin.data_interp_r[34]\ \memory_i.freq_inst.dsmod_sin.data_interp_r[32]\ _09952_ VPWR VGND sg13g2_nand3_1
X_33662_ _09970_ \memory_i.freq_inst.dsmod_sin.accu2_r[32]\ \memory_i.freq_inst.dsmod_sin.data_interp_r[34]\ _09952_ VPWR VGND sg13g2_nand3_1
X_33663_ _09971_ _09969_ _09970_ _09937_ VPWR VGND sg13g2_a21oi_1
X_33664_ _09972_ \memory_i.freq_inst.dsmod_sin.data_interp_r[34]\ _09950_ VPWR VGND sg13g2_nand2_1
X_33665_ _09973_ _09472_ _09970_ _09972_ VPWR VGND sg13g2_o21ai_1
X_33666_ _09974_ _09973_ VPWR VGND sg13g2_buf_1
X_33667_ _09975_ _09968_ _09971_ _09974_ VPWR VGND sg13g2_nor3_1
X_33668_ _09976_ \memory_i.freq_inst.dsmod_sin.accu2_r[35]\ \memory_i.freq_inst.dsmod_sin.data_interp_r[35]\ VPWR VGND sg13g2_xor2_1
X_33669_ _09977_ _09975_ _09976_ VPWR VGND sg13g2_xnor2_1
X_33670_ _09978_ _09977_ VPWR VGND sg13g2_buf_1
X_33671_ _09979_ _05651_ _09978_ VPWR VGND sg13g2_nor2_1
X_33672_ _01916_ _03328_ _09958_ _09979_ VPWR VGND sg13g2_nor3_1
X_33673_ _09980_ \memory_i.freq_inst.dsmod_sin.accu2_r[36]\ \memory_i.freq_inst.dsmod_sin.data_interp_r[36]\ VPWR VGND sg13g2_xor2_1
X_33674_ _09981_ _09975_ \memory_i.freq_inst.dsmod_sin.data_interp_r[35]\ VPWR VGND sg13g2_nor2b_1
X_33675_ _09982_ \memory_i.freq_inst.dsmod_sin.data_interp_r[35]\ _09975_ VPWR VGND sg13g2_nand2b_1
X_33676_ _09983_ \memory_i.freq_inst.dsmod_sin.accu2_r[35]\ _09981_ _09982_ VPWR VGND sg13g2_o21ai_1
X_33677_ _09984_ _09980_ _09983_ VPWR VGND sg13g2_xnor2_1
X_33678_ _09985_ \memory_i.freq_inst.dsmod_cos.i_ena_mod\ \memory_i.freq_inst.dsmod_sin.accu2_r[36]\ VPWR VGND sg13g2_nor2b_1
X_33679_ _09986_ \memory_i.freq_inst.dsmod_cos.i_ena_mod\ _09984_ _09985_ VPWR VGND sg13g2_a21oi_1
X_33680_ _01917_ _09860_ _09986_ VPWR VGND sg13g2_nor2_1
X_33681_ _09987_ \memory_i.freq_inst.dsmod_sin.accu2_r[37]\ VPWR VGND sg13g2_inv_1
X_33682_ _09988_ \memory_i.freq_inst.dsmod_sin.accu2_r[36]\ \memory_i.freq_inst.dsmod_sin.data_interp_r[36]\ VPWR VGND sg13g2_or2_1
X_33683_ _09989_ _08569_ _09968_ _09971_ _09974_ VPWR
+ VGND
+ sg13g2_nor4_1
X_33684_ _09990_ \memory_i.freq_inst.dsmod_sin.accu2_r[36]\ \memory_i.freq_inst.dsmod_sin.data_interp_r[35]\ VPWR VGND sg13g2_or2_1
X_33685_ _09991_ _09968_ _09971_ _09974_ _09990_ VPWR
+ VGND
+ sg13g2_nor4_1
X_33686_ _09992_ \memory_i.freq_inst.dsmod_sin.accu2_r[35]\ \memory_i.freq_inst.dsmod_sin.data_interp_r[36]\ VPWR VGND sg13g2_or2_1
X_33687_ _09993_ _09968_ _09971_ _09974_ _09992_ VPWR
+ VGND
+ sg13g2_nor4_1
X_33688_ _09994_ \memory_i.freq_inst.dsmod_sin.accu2_r[36]\ \memory_i.freq_inst.dsmod_sin.accu2_r[35]\ VPWR VGND sg13g2_or2_1
X_33689_ _09995_ _09968_ _09971_ _09974_ _09994_ VPWR
+ VGND
+ sg13g2_nor4_1
X_33690_ _09996_ _09989_ _09991_ _09993_ _09995_ VPWR
+ VGND
+ sg13g2_nor4_1
X_33691_ _09997_ _09992_ _09994_ \memory_i.freq_inst.dsmod_sin.data_interp_r[35]\ VPWR VGND sg13g2_a21o_1
X_33692_ _09998_ _09988_ _09996_ _09997_ VPWR VGND sg13g2_nand3_1
X_33693_ _09999_ \memory_i.freq_inst.dsmod_sin.data_interp_r[37]\ _09998_ VPWR VGND sg13g2_nor2_1
X_33694_ _10000_ \memory_i.freq_inst.dsmod_sin.data_interp_r[37]\ _09998_ VPWR VGND sg13g2_nand2_1
X_33695_ _10001_ _09999_ _10000_ VPWR VGND sg13g2_nor2b_1
X_33696_ _10002_ _10001_ VPWR VGND sg13g2_buf_1
X_33697_ _10003_ \memory_i.freq_inst.dsmod_cos.i_ena_mod\ _10002_ VPWR VGND sg13g2_nand2_1
X_33698_ _10004_ _09987_ _10003_ VPWR VGND sg13g2_xnor2_1
X_33699_ _01918_ _09860_ _10004_ VPWR VGND sg13g2_nor2_1
X_33700_ _10005_ \memory_i.freq_inst.dsmod_sin.accu2_r[38]\ VPWR VGND sg13g2_inv_1
X_33701_ _10006_ \memory_i.freq_inst.dsmod_sin.accu2_r[37]\ _09999_ _10000_ VPWR VGND sg13g2_o21ai_1
X_33702_ _10007_ _10006_ VPWR VGND sg13g2_buf_2
X_33703_ _10008_ _10005_ _10007_ VPWR VGND sg13g2_xnor2_1
X_33704_ _10009_ _10008_ VPWR VGND sg13g2_buf_4
X_33705_ _10010_ _13386_ _10009_ VPWR VGND sg13g2_xnor2_1
X_33706_ _10011_ _10010_ VPWR VGND sg13g2_buf_4
X_33707_ _10012_ _12940_ _10011_ VPWR VGND sg13g2_nor2_1
X_33708_ _10013_ _07051_ \memory_i.freq_inst.dsmod_sin.accu2_r[38]\ _10012_ VPWR VGND sg13g2_a21oi_1
X_33709_ _01919_ _09860_ _10013_ VPWR VGND sg13g2_nor2_1
X_33710_ _10014_ \memory_i.freq_inst.dsmod_sin.accu2_r[38]\ _13386_ VPWR VGND sg13g2_nand2_1
X_33711_ _10015_ _10005_ _13399_ VPWR VGND sg13g2_nand2_1
X_33712_ _10016_ _10014_ _10015_ _10007_ VPWR VGND sg13g2_mux2_1
X_33713_ _10017_ \memory_i.freq_inst.dsmod_sin.accu2_r[39]\ _10016_ VPWR VGND sg13g2_xnor2_1
X_33714_ _10018_ _10017_ VPWR VGND sg13g2_buf_4
X_33715_ _10019_ \memory_i.freq_inst.dsmod_cos.i_ena_mod\ _10018_ VPWR VGND sg13g2_nand2_1
X_33716_ _10020_ _08219_ \memory_i.freq_inst.dsmod_sin.accu2_r[39]\ VPWR VGND sg13g2_nand2_1
X_33717_ _01920_ _10019_ _10020_ _08911_ VPWR VGND sg13g2_a21oi_1
X_33718_ _10021_ \memory_i.freq_inst.dsmod_sin.accu2_r[38]\ \memory_i.freq_inst.dsmod_sin.accu2_r[37]\ VPWR VGND sg13g2_nor2_1
X_33719_ _10022_ \memory_i.freq_inst.dsmod_sin.accu2_r[38]\ _10000_ _13399_ VPWR VGND sg13g2_o21ai_1
X_33720_ _10023_ \memory_i.freq_inst.dsmod_sin.data_interp_r[37]\ _13399_ VPWR VGND sg13g2_nor2_1
X_33721_ _10024_ _10002_ _10021_ _10022_ \memory_i.freq_inst.dsmod_sin.accu2_r[37]\ _10023_
+ VPWR
+ VGND sg13g2_a221oi_1
X_33722_ _10025_ \memory_i.freq_inst.dsmod_sin.accu2_r[39]\ _10024_ VPWR VGND sg13g2_nand2b_1
X_33723_ _10026_ _10005_ _10007_ _13386_ VPWR VGND sg13g2_o21ai_1
X_33724_ _10027_ \memory_i.freq_inst.dsmod_sin.accu2_r[39]\ _10026_ VPWR VGND sg13g2_nand2_1
X_33725_ _10028_ \memory_i.freq_inst.dsmod_sin.accu2_r[39]\ \memory_i.freq_inst.dsmod_sin.accu2_r[37]\ _09999_ VPWR VGND sg13g2_nand3_1
X_33726_ _10029_ \memory_i.freq_inst.dsmod_sin.accu2_r[39]\ _13399_ _10028_ VPWR VGND sg13g2_o21ai_1
X_33727_ _10030_ _10025_ _10027_ _10029_ \memory_i.freq_inst.dsmod_sin.accu2_r[38]\ VPWR
+ VGND
+ sg13g2_a22oi_1
X_33728_ _10031_ _10005_ _10028_ VPWR VGND sg13g2_or2_1
X_33729_ _10032_ \memory_i.freq_inst.dsmod_sin.accu2_r[39]\ \memory_i.freq_inst.dsmod_sin.accu2_r[38]\ \memory_i.freq_inst.dsmod_sin.accu2_r[37]\ _10000_ VPWR
+ VGND
+ sg13g2_or4_1
X_33730_ _10033_ \memory_i.freq_inst.dsmod_sin.accu2_r[40]\ _13399_ VPWR VGND sg13g2_xnor2_1
X_33731_ _10034_ _10031_ _10032_ _10033_ VPWR VGND sg13g2_a21oi_1
X_33732_ _10035_ _10031_ _10032_ _10033_ VPWR VGND sg13g2_nand3_1
X_33733_ _10036_ _10034_ _10035_ VPWR VGND sg13g2_nor2b_1
X_33734_ _10037_ _10030_ _10036_ VPWR VGND sg13g2_xnor2_1
X_33735_ _10038_ _10037_ VPWR VGND sg13g2_buf_1
X_33736_ _10039_ _10038_ VPWR VGND sg13g2_inv_1
X_33737_ _10040_ \memory_i.freq_inst.dsmod_cos.i_ena_mod\ _10039_ VPWR VGND sg13g2_nand2_1
X_33738_ _10041_ _08219_ \memory_i.freq_inst.dsmod_sin.accu2_r[40]\ VPWR VGND sg13g2_nand2_1
X_33739_ _01921_ _10040_ _10041_ _08911_ VPWR VGND sg13g2_a21oi_1
X_33740_ _10042_ \memory_i.freq_inst.dsmod_sin.accu2_r[40]\ \memory_i.freq_inst.dsmod_sin.accu2_r[39]\ \memory_i.freq_inst.dsmod_sin.accu2_r[38]\ _13386_ VPWR
+ VGND
+ sg13g2_nand4_1
X_33741_ _10043_ \memory_i.freq_inst.dsmod_sin.accu2_r[40]\ \memory_i.freq_inst.dsmod_sin.accu2_r[39]\ _10015_ VPWR VGND sg13g2_nor3_1
X_33742_ _10044_ _10007_ _10043_ VPWR VGND sg13g2_nand2_1
X_33743_ _10045_ _10007_ _10042_ _10044_ VPWR VGND sg13g2_o21ai_1
X_33744_ _10046_ \memory_i.freq_inst.dsmod_cos.i_ena_mod\ _10045_ VPWR VGND sg13g2_nand2_1
X_33745_ _10047_ \memory_i.freq_inst.dsmod_sin.accu2_r[41]\ _10046_ VPWR VGND sg13g2_xor2_1
X_33746_ _01922_ _09860_ _10047_ VPWR VGND sg13g2_nor2_1
X_33747_ _10048_ _15823_ VPWR VGND sg13g2_buf_1
X_33748_ _10049_ \memory_i.freq_inst.dsmod_sin.accu2_r[0]\ \memory_i.freq_inst.dsmod_sin.data_interp_r[0]\ VPWR VGND sg13g2_xnor2_1
X_33749_ _10050_ _09417_ _10049_ VPWR VGND sg13g2_nor2_1
X_33750_ _10051_ \memory_i.freq_inst.dsmod_sin.accu3_r[0]\ _10050_ VPWR VGND sg13g2_xnor2_1
X_33751_ _01923_ _10048_ _10051_ VPWR VGND sg13g2_nor2_1
X_33752_ _10052_ \memory_i.freq_inst.dsmod_sin.accu3_r[1]\ VPWR VGND sg13g2_inv_1
X_33753_ _10053_ \memory_i.freq_inst.dsmod_sin.accu2_r[0]\ \memory_i.freq_inst.dsmod_sin.data_interp_r[0]\ VPWR VGND sg13g2_nor2_1
X_33754_ _10054_ \memory_i.freq_inst.dsmod_sin.accu2_r[0]\ \memory_i.freq_inst.dsmod_sin.data_interp_r[0]\ \memory_i.freq_inst.dsmod_sin.accu3_r[0]\ VPWR VGND sg13g2_a21oi_1
X_33755_ _10055_ \memory_i.freq_inst.dsmod_sin.accu2_r[1]\ \memory_i.freq_inst.dsmod_sin.data_interp_r[1]\ VPWR VGND sg13g2_xnor2_1
X_33756_ _10056_ _10053_ _10054_ _10055_ VPWR VGND sg13g2_o21ai_1
X_33757_ _10057_ _10055_ _10053_ _10054_ VPWR VGND sg13g2_or3_1
X_33758_ _10058_ \memory_i.freq_inst.dsmod_cos.i_ena_mod\ _10056_ _10057_ VPWR VGND sg13g2_nand3_1
X_33759_ _10059_ _10052_ _10058_ VPWR VGND sg13g2_xnor2_1
X_33760_ _01924_ _10048_ _10059_ VPWR VGND sg13g2_nor2_1
X_33761_ _10060_ \memory_i.freq_inst.dsmod_sin.accu2_r[0]\ \memory_i.freq_inst.dsmod_sin.data_interp_r[0]\ \memory_i.freq_inst.dsmod_sin.accu3_r[0]\ VPWR VGND sg13g2_o21ai_1
X_33762_ _10061_ _10055_ _10060_ _10052_ VPWR VGND sg13g2_o21ai_1
X_33763_ _10062_ _09565_ _10055_ VPWR VGND sg13g2_or2_1
X_33764_ _10063_ _10056_ _10061_ _10062_ VPWR VGND sg13g2_and3_1
X_33765_ _10064_ _09579_ _10063_ VPWR VGND sg13g2_xnor2_1
X_33766_ _10065_ _09417_ _10064_ VPWR VGND sg13g2_nor2_1
X_33767_ _10066_ \memory_i.freq_inst.dsmod_sin.accu3_r[2]\ _10065_ VPWR VGND sg13g2_xnor2_1
X_33768_ _01925_ _10048_ _10066_ VPWR VGND sg13g2_nor2_1
X_33769_ _10067_ \memory_i.freq_inst.dsmod_sin.accu3_r[2]\ _10056_ VPWR VGND sg13g2_and2_1
X_33770_ _10068_ _10061_ _10062_ VPWR VGND sg13g2_and2_1
X_33771_ _10069_ \memory_i.freq_inst.dsmod_sin.accu3_r[2]\ VPWR VGND sg13g2_inv_1
X_33772_ _10070_ _10069_ _09573_ _09578_ VPWR VGND sg13g2_nor3_1
X_33773_ _10071_ _09579_ _10063_ _10067_ _10068_ _10070_
+ VPWR
+ VGND sg13g2_a221oi_1
X_33774_ _10072_ \memory_i.freq_inst.dsmod_sin.accu2_r[3]\ \memory_i.freq_inst.dsmod_sin.data_interp_r[3]\ VPWR VGND sg13g2_xnor2_1
X_33775_ _10073_ _09585_ _10072_ VPWR VGND sg13g2_xnor2_1
X_33776_ _10074_ _10071_ _10073_ VPWR VGND sg13g2_xnor2_1
X_33777_ _10075_ \memory_i.freq_inst.dsmod_cos.i_ena_mod\ _10074_ VPWR VGND sg13g2_nand2_1
X_33778_ _10076_ \memory_i.freq_inst.dsmod_sin.accu3_r[3]\ _10075_ VPWR VGND sg13g2_xor2_1
X_33779_ _01926_ _10048_ _10076_ VPWR VGND sg13g2_nor2_1
X_33780_ _10077_ \memory_i.freq_inst.dsmod_sin.accu2_r[4]\ _09595_ VPWR VGND sg13g2_xnor2_1
X_33781_ _10078_ \memory_i.freq_inst.dsmod_sin.accu3_r[3]\ _10073_ VPWR VGND sg13g2_nand2_1
X_33782_ _10079_ \memory_i.freq_inst.dsmod_sin.accu3_r[3]\ _10073_ VPWR VGND sg13g2_nor2_1
X_33783_ _10080_ _10071_ _10078_ _10079_ VPWR VGND sg13g2_a21o_1
X_33784_ _10081_ _10080_ VPWR VGND sg13g2_buf_1
X_33785_ _10082_ _10077_ _10081_ VPWR VGND sg13g2_xnor2_1
X_33786_ _10083_ _05737_ _10082_ VPWR VGND sg13g2_nor2_1
X_33787_ _10084_ \memory_i.freq_inst.dsmod_sin.accu3_r[4]\ _10083_ VPWR VGND sg13g2_xnor2_1
X_33788_ _01927_ _10048_ _10084_ VPWR VGND sg13g2_nor2_1
X_33789_ _10085_ \memory_i.freq_inst.dsmod_sin.accu3_r[4]\ VPWR VGND sg13g2_inv_1
X_33790_ _10086_ _10085_ _10081_ _10077_ VPWR VGND sg13g2_o21ai_1
X_33791_ _10087_ _10085_ _10081_ VPWR VGND sg13g2_nand2_1
X_33792_ _10088_ _10086_ _10087_ _09602_ VPWR VGND sg13g2_a21o_1
X_33793_ _10089_ _09602_ _10086_ _10087_ VPWR VGND sg13g2_nand3_1
X_33794_ _10090_ _10088_ _10089_ _05737_ VPWR VGND sg13g2_a21oi_1
X_33795_ _10091_ \memory_i.freq_inst.dsmod_sin.accu3_r[5]\ _10090_ VPWR VGND sg13g2_xnor2_1
X_33796_ _01928_ _10048_ _10091_ VPWR VGND sg13g2_nor2_1
X_33797_ _10092_ _10085_ _10077_ _10081_ VPWR VGND sg13g2_o21ai_1
X_33798_ _10093_ \memory_i.freq_inst.dsmod_sin.accu3_r[5]\ VPWR VGND sg13g2_inv_1
X_33799_ _10094_ _10093_ _09602_ _10077_ _10085_ VPWR
+ VGND
+ sg13g2_a22oi_1
X_33800_ _10095_ _10093_ _09602_ VPWR VGND sg13g2_nor2_1
X_33801_ _10096_ _10092_ _10094_ _10095_ VPWR VGND sg13g2_a21oi_1
X_33802_ _10097_ _09612_ _10096_ VPWR VGND sg13g2_xnor2_1
X_33803_ _10098_ \memory_i.freq_inst.dsmod_cos.i_ena_mod\ _10097_ VPWR VGND sg13g2_nand2_1
X_33804_ _10099_ \memory_i.freq_inst.dsmod_sin.accu3_r[6]\ _10098_ VPWR VGND sg13g2_xor2_1
X_33805_ _01929_ _10048_ _10099_ VPWR VGND sg13g2_nor2_1
X_33806_ _10100_ \memory_i.freq_inst.dsmod_sin.accu3_r[7]\ VPWR VGND sg13g2_inv_1
X_33807_ _10101_ \memory_i.freq_inst.dsmod_sin.accu3_r[6]\ _09612_ _10092_ _10094_ _10095_
+ VPWR
+ VGND sg13g2_a221oi_1
X_33808_ _10102_ \memory_i.freq_inst.dsmod_sin.accu3_r[6]\ _09612_ VPWR VGND sg13g2_nor2_1
X_33809_ _10103_ _10101_ _10102_ VPWR VGND sg13g2_nor2_1
X_33810_ _10104_ _09627_ _10103_ VPWR VGND sg13g2_xnor2_1
X_33811_ _10105_ _10104_ \memory_i.freq_inst.dsmod_cos.i_ena_mod\ VPWR VGND sg13g2_nand2b_1
X_33812_ _10106_ _10100_ _10105_ VPWR VGND sg13g2_xnor2_1
X_33813_ _01930_ _10048_ _10106_ VPWR VGND sg13g2_nor2_1
X_33814_ _10107_ \memory_i.freq_inst.dsmod_sin.accu3_r[8]\ VPWR VGND sg13g2_inv_1
X_33815_ _10108_ _09648_ VPWR VGND sg13g2_inv_1
X_33816_ _10109_ \memory_i.freq_inst.dsmod_sin.accu3_r[7]\ _09627_ VPWR VGND sg13g2_or2_1
X_33817_ _10110_ _09614_ VPWR VGND sg13g2_inv_1
X_33818_ _10111_ \memory_i.freq_inst.dsmod_sin.accu3_r[7]\ _10110_ _09619_ _09625_ VPWR
+ VGND
+ sg13g2_and4_1
X_33819_ _10112_ _10100_ _10110_ _09619_ VPWR VGND sg13g2_nor3_1
X_33820_ _10113_ \memory_i.freq_inst.dsmod_sin.accu2_r[6]\ VPWR VGND sg13g2_inv_1
X_33821_ _10114_ \memory_i.freq_inst.dsmod_sin.accu3_r[7]\ \memory_i.freq_inst.dsmod_sin.data_interp_r[6]\ _09614_ VPWR VGND sg13g2_nand3_1
X_33822_ _10115_ _10113_ _09611_ _10114_ VPWR VGND sg13g2_a21oi_1
X_33823_ _10116_ _10111_ _10112_ _10115_ VPWR VGND sg13g2_nor3_1
X_33824_ _10117_ _10101_ _10102_ _10116_ VPWR VGND sg13g2_o21ai_1
X_33825_ _10118_ _10109_ _10117_ VPWR VGND sg13g2_and2_1
X_33826_ _10119_ _10118_ VPWR VGND sg13g2_buf_1
X_33827_ _10120_ _10108_ _10119_ VPWR VGND sg13g2_xnor2_1
X_33828_ _10121_ \memory_i.freq_inst.dsmod_cos.i_ena_mod\ _10120_ VPWR VGND sg13g2_nand2_1
X_33829_ _10122_ _10107_ _10121_ VPWR VGND sg13g2_xnor2_1
X_33830_ _01931_ _10048_ _10122_ VPWR VGND sg13g2_nor2_1
X_33831_ _10123_ \memory_i.freq_inst.dsmod_sin.accu3_r[9]\ VPWR VGND sg13g2_inv_1
X_33832_ _10124_ \memory_i.freq_inst.dsmod_sin.accu3_r[8]\ _10119_ VPWR VGND sg13g2_nor2_1
X_33833_ _10125_ \memory_i.freq_inst.dsmod_sin.accu3_r[8]\ _10119_ _09648_ VPWR VGND sg13g2_a21oi_1
X_33834_ _10126_ _10124_ _10125_ VPWR VGND sg13g2_nor2_1
X_33835_ _10127_ _09655_ _10126_ VPWR VGND sg13g2_xor2_1
X_33836_ _10128_ \memory_i.freq_inst.dsmod_cos.i_ena_mod\ _10127_ VPWR VGND sg13g2_nand2_1
X_33837_ _10129_ _10123_ _10128_ VPWR VGND sg13g2_xnor2_1
X_33838_ _01932_ _10048_ _10129_ VPWR VGND sg13g2_nor2_1
X_33839_ _10130_ _15823_ VPWR VGND sg13g2_buf_1
X_33840_ _10131_ _09659_ _09662_ VPWR VGND sg13g2_xor2_1
X_33841_ _10132_ \memory_i.freq_inst.dsmod_sin.accu3_r[8]\ _09648_ _09655_ VPWR VGND sg13g2_a21oi_1
X_33842_ _10133_ \memory_i.freq_inst.dsmod_sin.accu3_r[8]\ _09648_ _09655_ VPWR VGND sg13g2_nand3_1
X_33843_ _10134_ _10123_ _10132_ _10133_ VPWR VGND sg13g2_o21ai_1
X_33844_ _10135_ _10134_ VPWR VGND sg13g2_buf_1
X_33845_ _10136_ \memory_i.freq_inst.dsmod_sin.accu3_r[9]\ _09655_ VPWR VGND sg13g2_nor2_1
X_33846_ _10137_ _10107_ _10108_ _10136_ VPWR VGND sg13g2_a21oi_1
X_33847_ _10138_ _10109_ _10117_ _10137_ VPWR VGND sg13g2_nand3_1
X_33848_ _10139_ _10135_ _10138_ VPWR VGND sg13g2_nor2b_1
X_33849_ _10140_ _10131_ _10139_ VPWR VGND sg13g2_nor2_1
X_33850_ _10141_ _10131_ _10139_ VPWR VGND sg13g2_nand2_1
X_33851_ _10142_ _10140_ _10141_ \memory_i.freq_inst.dsmod_cos.i_ena_mod\ VPWR VGND sg13g2_nand3b_1
X_33852_ _10143_ \memory_i.freq_inst.dsmod_sin.accu3_r[10]\ _10142_ VPWR VGND sg13g2_xor2_1
X_33853_ _01933_ _10130_ _10143_ VPWR VGND sg13g2_nor2_1
X_33854_ _10144_ \memory_i.freq_inst.dsmod_sin.accu3_r[10]\ _10140_ _10141_ VPWR VGND sg13g2_o21ai_1
X_33855_ _10145_ _09674_ _10144_ VPWR VGND sg13g2_xnor2_1
X_33856_ _10146_ \memory_i.freq_inst.dsmod_cos.i_ena_mod\ _10145_ VPWR VGND sg13g2_nand2_1
X_33857_ _10147_ \memory_i.freq_inst.dsmod_sin.accu3_r[11]\ _10146_ VPWR VGND sg13g2_xor2_1
X_33858_ _01934_ _10130_ _10147_ VPWR VGND sg13g2_nor2_1
X_33859_ _10148_ _09663_ _09674_ _10135_ VPWR VGND sg13g2_nor3_1
X_33860_ _10149_ \memory_i.freq_inst.dsmod_sin.accu3_r[10]\ _09674_ _10135_ VPWR VGND sg13g2_nor3_1
X_33861_ _10150_ _10148_ _10149_ _10138_ VPWR VGND sg13g2_o21ai_1
X_33862_ _10151_ \memory_i.freq_inst.dsmod_sin.accu3_r[11]\ _09663_ _10135_ VPWR VGND sg13g2_nor3_1
X_33863_ _10152_ \memory_i.freq_inst.dsmod_sin.accu3_r[11]\ \memory_i.freq_inst.dsmod_sin.accu3_r[10]\ _10135_ VPWR VGND sg13g2_nor3_1
X_33864_ _10153_ _10151_ _10152_ _10138_ VPWR VGND sg13g2_o21ai_1
X_33865_ _10154_ \memory_i.freq_inst.dsmod_sin.accu3_r[11]\ _09674_ VPWR VGND sg13g2_nor2_1
X_33866_ _10155_ \memory_i.freq_inst.dsmod_sin.accu3_r[10]\ _09663_ _09674_ VPWR VGND sg13g2_nor3_1
X_33867_ _10156_ \memory_i.freq_inst.dsmod_sin.accu3_r[11]\ \memory_i.freq_inst.dsmod_sin.accu3_r[10]\ _09663_ VPWR VGND sg13g2_nor3_1
X_33868_ _10157_ _10154_ _10155_ _10156_ VPWR VGND sg13g2_nor3_1
X_33869_ _10158_ _10150_ _10153_ _10157_ VPWR VGND sg13g2_nand3_1
X_33870_ _10159_ _09695_ _10158_ VPWR VGND sg13g2_xnor2_1
X_33871_ _10160_ \memory_i.freq_inst.dsmod_cos.i_ena_mod\ _10159_ VPWR VGND sg13g2_nand2_1
X_33872_ _10161_ \memory_i.freq_inst.dsmod_sin.accu3_r[12]\ _10160_ VPWR VGND sg13g2_xor2_1
X_33873_ _01935_ _10130_ _10161_ VPWR VGND sg13g2_nor2_1
X_33874_ _10162_ \memory_i.freq_inst.dsmod_sin.accu2_r[13]\ _09702_ VPWR VGND sg13g2_xnor2_1
X_33875_ _10163_ \memory_i.freq_inst.dsmod_sin.accu3_r[12]\ _09695_ VPWR VGND sg13g2_nor2_1
X_33876_ _10164_ \memory_i.freq_inst.dsmod_sin.accu3_r[12]\ _09695_ VPWR VGND sg13g2_nand2_1
X_33877_ _10165_ _10158_ _10163_ _10164_ VPWR VGND sg13g2_o21ai_1
X_33878_ _10166_ _10162_ _10165_ VPWR VGND sg13g2_xor2_1
X_33879_ _10167_ \memory_i.freq_inst.dsmod_cos.i_ena_mod\ _10166_ VPWR VGND sg13g2_nand2_1
X_33880_ _10168_ \memory_i.freq_inst.dsmod_sin.accu3_r[13]\ _10167_ VPWR VGND sg13g2_xor2_1
X_33881_ _01936_ _10130_ _10168_ VPWR VGND sg13g2_nor2_1
X_33882_ _10169_ _10164_ VPWR VGND sg13g2_inv_1
X_33883_ _10170_ _10162_ _10169_ VPWR VGND sg13g2_nor2_1
X_33884_ _10171_ _10162_ _10169_ \memory_i.freq_inst.dsmod_sin.accu3_r[13]\ VPWR VGND sg13g2_a21oi_1
X_33885_ _10172_ \memory_i.freq_inst.dsmod_sin.accu3_r[13]\ _10162_ VPWR VGND sg13g2_xnor2_1
X_33886_ _10173_ _10169_ _10163_ _10172_ VPWR VGND sg13g2_nor3_1
X_33887_ _10174_ _10150_ _10153_ _10157_ _10173_ VPWR
+ VGND
+ sg13g2_nand4_1
X_33888_ _10175_ _10174_ VPWR VGND sg13g2_buf_1
X_33889_ _10176_ _10170_ _10171_ _10175_ VPWR VGND sg13g2_o21ai_1
X_33890_ _10177_ _10176_ VPWR VGND sg13g2_buf_1
X_33891_ _10178_ _09719_ _10177_ VPWR VGND sg13g2_xnor2_1
X_33892_ _10179_ _05737_ _10178_ VPWR VGND sg13g2_nor2_1
X_33893_ _10180_ \memory_i.freq_inst.dsmod_sin.accu3_r[14]\ _10179_ VPWR VGND sg13g2_xnor2_1
X_33894_ _01937_ _10130_ _10180_ VPWR VGND sg13g2_nor2_1
X_33895_ _10181_ \memory_i.freq_inst.dsmod_sin.accu3_r[15]\ VPWR VGND sg13g2_inv_1
X_33896_ _10182_ _09719_ _10177_ \memory_i.freq_inst.dsmod_sin.accu3_r[14]\ VPWR VGND sg13g2_a21o_1
X_33897_ _10183_ _09719_ _10177_ _10182_ VPWR VGND sg13g2_o21ai_1
X_33898_ _10184_ _09726_ _10183_ VPWR VGND sg13g2_nor2_1
X_33899_ _10185_ _09726_ _10183_ VPWR VGND sg13g2_nand2_1
X_33900_ _10186_ _10184_ _10185_ \memory_i.freq_inst.dsmod_cos.i_ena_mod\ VPWR VGND sg13g2_nand3b_1
X_33901_ _10187_ _10181_ _10186_ VPWR VGND sg13g2_xnor2_1
X_33902_ _01938_ _10130_ _10187_ VPWR VGND sg13g2_nor2_1
X_33903_ _10188_ \memory_i.freq_inst.dsmod_sin.accu3_r[16]\ VPWR VGND sg13g2_inv_1
X_33904_ _10189_ \memory_i.freq_inst.dsmod_sin.accu3_r[15]\ _10185_ _10184_ VPWR VGND sg13g2_a21oi_1
X_33905_ _10190_ _09740_ _10189_ VPWR VGND sg13g2_xnor2_1
X_33906_ _10191_ \memory_i.freq_inst.dsmod_cos.i_ena_mod\ _10190_ VPWR VGND sg13g2_nand2_1
X_33907_ _10192_ _10188_ _10191_ VPWR VGND sg13g2_xnor2_1
X_33908_ _01939_ _10130_ _10192_ VPWR VGND sg13g2_nor2_1
X_33909_ _10193_ _10189_ VPWR VGND sg13g2_inv_1
X_33910_ _10194_ \memory_i.freq_inst.dsmod_sin.accu3_r[16]\ _10193_ _09740_ VPWR VGND sg13g2_a21oi_1
X_33911_ _10195_ _10188_ _10189_ _10194_ VPWR VGND sg13g2_a21oi_1
X_33912_ _10196_ _09751_ _10195_ VPWR VGND sg13g2_xor2_1
X_33913_ _10197_ \memory_i.freq_inst.dsmod_cos.i_ena_mod\ _10196_ VPWR VGND sg13g2_nand2_1
X_33914_ _10198_ \memory_i.freq_inst.dsmod_sin.accu3_r[17]\ _10197_ VPWR VGND sg13g2_xor2_1
X_33915_ _01940_ _10130_ _10198_ VPWR VGND sg13g2_nor2_1
X_33916_ _10199_ _09754_ _09757_ VPWR VGND sg13g2_xnor2_1
X_33917_ _10200_ \memory_i.freq_inst.dsmod_sin.accu3_r[17]\ _09751_ VPWR VGND sg13g2_or2_1
X_33918_ _10201_ _10200_ VPWR VGND sg13g2_buf_2
X_33919_ _10202_ \memory_i.freq_inst.dsmod_sin.accu3_r[16]\ _09740_ VPWR VGND sg13g2_and2_1
X_33920_ _10203_ \memory_i.freq_inst.dsmod_sin.accu3_r[17]\ _09751_ VPWR VGND sg13g2_and2_1
X_33921_ _10204_ _10201_ _10202_ _10203_ VPWR VGND sg13g2_a21oi_1
X_33922_ _10205_ \memory_i.freq_inst.dsmod_sin.accu2_r[14]\ \memory_i.freq_inst.dsmod_sin.data_interp_r[14]\ VPWR VGND sg13g2_nand2_1
X_33923_ _10206_ \memory_i.freq_inst.dsmod_sin.accu3_r[14]\ _09723_ \memory_i.freq_inst.dsmod_sin.accu3_r[15]\ VPWR VGND sg13g2_o21ai_1
X_33924_ _10207_ \memory_i.freq_inst.dsmod_sin.accu3_r[14]\ _09723_ VPWR VGND sg13g2_nand2_1
X_33925_ _10208_ _10205_ _10206_ _10207_ _09732_ VPWR
+ VGND
+ sg13g2_a22oi_1
X_33926_ _10209_ _09723_ _09718_ \memory_i.freq_inst.dsmod_sin.accu3_r[14]\ VPWR VGND sg13g2_o21ai_1
X_33927_ _10210_ \memory_i.freq_inst.dsmod_sin.accu3_r[15]\ \memory_i.freq_inst.dsmod_sin.accu3_r[14]\ _09723_ VPWR VGND sg13g2_and3_1
X_33928_ _10211_ _09723_ _09718_ VPWR VGND sg13g2_nand2_1
X_33929_ _10212_ _10205_ _10210_ _10211_ VPWR VGND sg13g2_o21ai_1
X_33930_ _10213_ _10181_ _10209_ _10212_ _09721_ VPWR
+ VGND
+ sg13g2_a22oi_1
X_33931_ _10214_ _09721_ _10208_ _10213_ VPWR VGND sg13g2_o21ai_1
X_33932_ _10215_ _10204_ _10214_ VPWR VGND sg13g2_and2_1
X_33933_ _10216_ _10215_ VPWR VGND sg13g2_inv_1
X_33934_ _10217_ \memory_i.freq_inst.dsmod_sin.accu3_r[14]\ _09719_ VPWR VGND sg13g2_nor2_1
X_33935_ _10218_ _10181_ _10217_ _09726_ VPWR VGND sg13g2_o21ai_1
X_33936_ _10219_ _10181_ _10217_ VPWR VGND sg13g2_nand2_1
X_33937_ _10220_ _09740_ _10201_ _10218_ _10219_ VPWR
+ VGND
+ sg13g2_nand4_1
X_33938_ _10221_ \memory_i.freq_inst.dsmod_sin.accu3_r[16]\ _10201_ _10218_ _10219_ VPWR
+ VGND
+ sg13g2_nand4_1
X_33939_ _10222_ _10220_ _10221_ VPWR VGND sg13g2_and2_1
X_33940_ _10223_ _10222_ VPWR VGND sg13g2_buf_1
X_33941_ _10224_ _10204_ _10223_ VPWR VGND sg13g2_nand2_1
X_33942_ _10225_ _10177_ _10216_ _10224_ VPWR VGND sg13g2_o21ai_1
X_33943_ _10226_ _10199_ _10225_ VPWR VGND sg13g2_xnor2_1
X_33944_ _10227_ \memory_i.freq_inst.dsmod_cos.i_ena_mod\ _10226_ VPWR VGND sg13g2_nand2_1
X_33945_ _10228_ \memory_i.freq_inst.dsmod_sin.accu3_r[18]\ _10227_ VPWR VGND sg13g2_xor2_1
X_33946_ _01941_ _10130_ _10228_ VPWR VGND sg13g2_nor2_1
X_33947_ _10229_ _09758_ _10225_ VPWR VGND sg13g2_nor2_1
X_33948_ _10230_ _09758_ _10225_ VPWR VGND sg13g2_nand2_1
X_33949_ _10231_ \memory_i.freq_inst.dsmod_sin.accu3_r[18]\ _10229_ _10230_ VPWR VGND sg13g2_o21ai_1
X_33950_ _10232_ _09777_ _10231_ VPWR VGND sg13g2_xnor2_1
X_33951_ _10233_ \memory_i.freq_inst.dsmod_cos.i_ena_mod\ _10232_ VPWR VGND sg13g2_nand2_1
X_33952_ _10234_ \memory_i.freq_inst.dsmod_sin.accu3_r[19]\ _10233_ VPWR VGND sg13g2_xor2_1
X_33953_ _01942_ _10130_ _10234_ VPWR VGND sg13g2_nor2_1
X_33954_ _10235_ _15823_ VPWR VGND sg13g2_buf_1
X_33955_ _10236_ _10170_ _10171_ VPWR VGND sg13g2_nor2_1
X_33956_ _10237_ _10236_ _10215_ VPWR VGND sg13g2_nor2b_1
X_33957_ _10238_ \memory_i.freq_inst.dsmod_sin.accu3_r[19]\ _09777_ VPWR VGND sg13g2_or2_1
X_33958_ _10239_ _10199_ _10238_ VPWR VGND sg13g2_nand2_1
X_33959_ _10240_ _10204_ _10223_ _10237_ _10175_ _10239_
+ VPWR
+ VGND sg13g2_a221oi_1
X_33960_ _10241_ \memory_i.freq_inst.dsmod_sin.accu3_r[18]\ _10238_ VPWR VGND sg13g2_nand2_1
X_33961_ _10242_ _10204_ _10223_ _10237_ _10175_ _10241_
+ VPWR
+ VGND sg13g2_a221oi_1
X_33962_ _10243_ \memory_i.freq_inst.dsmod_sin.accu3_r[19]\ _09777_ VPWR VGND sg13g2_nand2_1
X_33963_ _10244_ _09758_ _10241_ _10243_ VPWR VGND sg13g2_o21ai_1
X_33964_ _10245_ _10240_ _10242_ _10244_ VPWR VGND sg13g2_nor3_2
X_33965_ _10246_ \memory_i.freq_inst.dsmod_sin.accu2_r[20]\ \memory_i.freq_inst.dsmod_sin.data_interp_r[20]\ VPWR VGND sg13g2_xnor2_1
X_33966_ _10247_ _09788_ _10246_ VPWR VGND sg13g2_xnor2_1
X_33967_ _10248_ _10245_ _10247_ VPWR VGND sg13g2_xnor2_1
X_33968_ _10249_ _05737_ _10248_ VPWR VGND sg13g2_nor2_1
X_33969_ _10250_ \memory_i.freq_inst.dsmod_sin.accu3_r[20]\ _10249_ VPWR VGND sg13g2_xnor2_1
X_33970_ _01943_ _10235_ _10250_ VPWR VGND sg13g2_nor2_1
X_33971_ _10251_ \memory_i.freq_inst.dsmod_sin.accu2_r[21]\ \memory_i.freq_inst.dsmod_sin.data_interp_r[21]\ VPWR VGND sg13g2_xor2_1
X_33972_ _10252_ _09788_ _10245_ VPWR VGND sg13g2_nand2_1
X_33973_ _10253_ _09788_ _10245_ VPWR VGND sg13g2_nor2_1
X_33974_ _10254_ _09794_ _10253_ VPWR VGND sg13g2_nand2b_1
X_33975_ _10255_ _09793_ _10252_ _10254_ VPWR VGND sg13g2_o21ai_1
X_33976_ _10256_ \memory_i.freq_inst.dsmod_sin.data_interp_r[20]\ _10252_ _10253_ VPWR VGND sg13g2_a21o_1
X_33977_ _10257_ \memory_i.freq_inst.dsmod_sin.data_interp_r[20]\ _10253_ _10256_ \memory_i.freq_inst.dsmod_sin.accu2_r[20]\ VPWR
+ VGND
+ sg13g2_a22oi_1
X_33978_ _10258_ \memory_i.freq_inst.dsmod_sin.accu2_r[20]\ _10256_ VPWR VGND sg13g2_or2_1
X_33979_ _10259_ \memory_i.freq_inst.dsmod_sin.data_interp_r[20]\ _10252_ _10258_ VPWR VGND sg13g2_o21ai_1
X_33980_ _10260_ \memory_i.freq_inst.dsmod_sin.accu3_r[20]\ _10259_ VPWR VGND sg13g2_nor2_1
X_33981_ _10261_ \memory_i.freq_inst.dsmod_sin.accu3_r[20]\ _10257_ _10260_ VPWR VGND sg13g2_a21oi_1
X_33982_ _10262_ _10255_ _10261_ VPWR VGND sg13g2_nor2_1
X_33983_ _10263_ _10251_ _10262_ VPWR VGND sg13g2_xor2_1
X_33984_ _10264_ \memory_i.freq_inst.dsmod_cos.i_ena_mod\ _10263_ VPWR VGND sg13g2_nand2_1
X_33985_ _10265_ \memory_i.freq_inst.dsmod_sin.accu3_r[21]\ _10264_ VPWR VGND sg13g2_xor2_1
X_33986_ _01944_ _10235_ _10265_ VPWR VGND sg13g2_nor2_1
X_33987_ _10266_ \memory_i.freq_inst.dsmod_sin.accu2_r[22]\ _09815_ VPWR VGND sg13g2_xnor2_1
X_33988_ _10267_ _09788_ _10246_ VPWR VGND sg13g2_nand2_1
X_33989_ _10268_ \memory_i.freq_inst.dsmod_sin.accu3_r[20]\ _10267_ \memory_i.freq_inst.dsmod_sin.accu3_r[21]\ VPWR VGND sg13g2_a21oi_1
X_33990_ _10269_ _09783_ _09786_ VPWR VGND sg13g2_and2_1
X_33991_ _10270_ _10269_ VPWR VGND sg13g2_buf_1
X_33992_ _10271_ \memory_i.freq_inst.dsmod_sin.accu3_r[20]\ _10270_ \memory_i.freq_inst.dsmod_sin.accu3_r[21]\ VPWR VGND sg13g2_o21ai_1
X_33993_ _10272_ \memory_i.freq_inst.dsmod_sin.accu3_r[20]\ _10270_ _09793_ VPWR VGND sg13g2_a21oi_1
X_33994_ _10273_ _09794_ _10271_ _10272_ VPWR VGND sg13g2_a21oi_1
X_33995_ _10274_ _09788_ _10246_ VPWR VGND sg13g2_nor2_1
X_33996_ _10275_ \memory_i.freq_inst.dsmod_sin.accu3_r[21]\ \memory_i.freq_inst.dsmod_sin.accu3_r[20]\ _09783_ _09786_ VPWR
+ VGND
+ sg13g2_nand4_1
X_33997_ _10276_ _09794_ _10275_ VPWR VGND sg13g2_nor2b_1
X_33998_ _10277_ _10274_ _10276_ _10251_ VPWR VGND sg13g2_o21ai_1
X_33999_ _10278_ _10251_ _10273_ _10277_ VPWR VGND sg13g2_o21ai_1
X_34000_ _10279_ _10268_ _10278_ VPWR VGND sg13g2_nor2_1
X_34001_ _10280_ \memory_i.freq_inst.dsmod_sin.accu3_r[20]\ \memory_i.freq_inst.dsmod_sin.accu2_r[20]\ VPWR VGND sg13g2_xor2_1
X_34002_ _10281_ \memory_i.freq_inst.dsmod_sin.accu3_r[21]\ _10251_ VPWR VGND sg13g2_xnor2_1
X_34003_ _10282_ \memory_i.freq_inst.dsmod_sin.data_interp_r[20]\ _10281_ VPWR VGND sg13g2_or2_1
X_34004_ _10283_ \memory_i.freq_inst.dsmod_sin.data_interp_r[20]\ _10270_ _10281_ VPWR VGND sg13g2_nand3_1
X_34005_ _10284_ _10270_ _10282_ _10283_ VPWR VGND sg13g2_o21ai_1
X_34006_ _10285_ \memory_i.freq_inst.dsmod_sin.accu3_r[20]\ \memory_i.freq_inst.dsmod_sin.accu2_r[20]\ VPWR VGND sg13g2_or2_1
X_34007_ _10286_ \memory_i.freq_inst.dsmod_sin.accu3_r[20]\ \memory_i.freq_inst.dsmod_sin.accu2_r[20]\ _10281_ VPWR VGND sg13g2_nand3_1
X_34008_ _10287_ _10281_ _10285_ _10286_ VPWR VGND sg13g2_o21ai_1
X_34009_ _10288_ _10280_ _10284_ _10287_ _09789_ VPWR
+ VGND
+ sg13g2_a22oi_1
X_34010_ _10289_ _10245_ _10288_ VPWR VGND sg13g2_nor2_1
X_34011_ _10290_ _10279_ _10289_ VPWR VGND sg13g2_or2_1
X_34012_ _10291_ _10266_ _10290_ VPWR VGND sg13g2_and2_1
X_34013_ _10292_ _10266_ _10290_ VPWR VGND sg13g2_or2_1
X_34014_ _10293_ _10291_ \memory_i.freq_inst.dsmod_cos.i_ena_mod\ _10292_ VPWR VGND sg13g2_nand3b_1
X_34015_ _10294_ \memory_i.freq_inst.dsmod_sin.accu3_r[22]\ _10293_ VPWR VGND sg13g2_xor2_1
X_34016_ _01945_ _10235_ _10294_ VPWR VGND sg13g2_nor2_1
X_34017_ _10295_ \memory_i.freq_inst.dsmod_sin.accu3_r[22]\ _10292_ _10291_ VPWR VGND sg13g2_a21oi_1
X_34018_ _10296_ _09825_ _10295_ VPWR VGND sg13g2_xnor2_1
X_34019_ _10297_ \memory_i.freq_inst.dsmod_cos.i_ena_mod\ _10296_ VPWR VGND sg13g2_nand2_1
X_34020_ _10298_ \memory_i.freq_inst.dsmod_sin.accu3_r[23]\ _10297_ VPWR VGND sg13g2_xor2_1
X_34021_ _01946_ _10235_ _10298_ VPWR VGND sg13g2_nor2_1
X_34022_ _10299_ _09825_ _10295_ VPWR VGND sg13g2_nand2b_1
X_34023_ _10300_ _10295_ _09825_ VPWR VGND sg13g2_nor2b_1
X_34024_ _10301_ \memory_i.freq_inst.dsmod_sin.accu3_r[23]\ _10299_ _10300_ VPWR VGND sg13g2_a21oi_1
X_34025_ _10302_ _09845_ _09878_ VPWR VGND sg13g2_xnor2_1
X_34026_ _10303_ _10301_ _10302_ VPWR VGND sg13g2_nor2_1
X_34027_ _10304_ _10301_ _10302_ VPWR VGND sg13g2_and2_1
X_34028_ _10305_ _12939_ _10303_ _10304_ VPWR VGND sg13g2_nor3_1
X_34029_ _10306_ \memory_i.freq_inst.dsmod_sin.accu3_r[24]\ _10305_ VPWR VGND sg13g2_xnor2_1
X_34030_ _01947_ _10235_ _10306_ VPWR VGND sg13g2_nor2_1
X_34031_ _10307_ _09849_ _09877_ VPWR VGND sg13g2_xor2_1
X_34032_ _10308_ \memory_i.freq_inst.dsmod_sin.accu3_r[24]\ VPWR VGND sg13g2_inv_1
X_34033_ _10309_ _10301_ _10302_ _10308_ VPWR VGND sg13g2_a21oi_1
X_34034_ _10310_ _10303_ _10309_ VPWR VGND sg13g2_nor2_1
X_34035_ _10311_ _10307_ _10310_ VPWR VGND sg13g2_xnor2_1
X_34036_ _10312_ _05737_ _10311_ VPWR VGND sg13g2_nor2_1
X_34037_ _10313_ \memory_i.freq_inst.dsmod_sin.accu3_r[25]\ _10312_ VPWR VGND sg13g2_xnor2_1
X_34038_ _01948_ _10235_ _10313_ VPWR VGND sg13g2_nor2_1
X_34039_ _10314_ \memory_i.freq_inst.dsmod_sin.accu3_r[25]\ \memory_i.freq_inst.dsmod_sin.accu3_r[24]\ _09841_ _09883_ VPWR
+ VGND
+ sg13g2_nand4_1
X_34040_ _10315_ _09849_ _10314_ _09877_ VPWR VGND sg13g2_a21o_1
X_34041_ _10316_ _10308_ _09845_ _09847_ VPWR VGND sg13g2_o21ai_1
X_34042_ _10317_ \memory_i.freq_inst.dsmod_sin.accu3_r[25]\ VPWR VGND sg13g2_inv_1
X_34043_ _10318_ \memory_i.freq_inst.dsmod_sin.accu3_r[24]\ _09833_ _09836_ _09839_ VPWR
+ VGND
+ sg13g2_nor4_1
X_34044_ _10319_ _10317_ _10318_ _09846_ VPWR VGND sg13g2_o21ai_1
X_34045_ _10320_ _09877_ _10316_ _10319_ VPWR VGND sg13g2_nand3_1
X_34046_ _10321_ _09845_ _09878_ _10308_ VPWR VGND sg13g2_a21o_1
X_34047_ _10322_ _10315_ _10320_ _10321_ _10317_ VPWR
+ VGND
+ sg13g2_a22oi_1
X_34048_ _10323_ _10322_ VPWR VGND sg13g2_buf_1
X_34049_ _10324_ \memory_i.freq_inst.dsmod_sin.accu3_r[24]\ \memory_i.freq_inst.dsmod_sin.accu2_r[24]\ VPWR VGND sg13g2_xor2_1
X_34050_ _10325_ \memory_i.freq_inst.dsmod_sin.data_interp_r[24]\ _09841_ VPWR VGND sg13g2_nand2_1
X_34051_ _10326_ \memory_i.freq_inst.dsmod_sin.accu3_r[25]\ _09877_ VPWR VGND sg13g2_xnor2_1
X_34052_ _10327_ _08467_ _09845_ _10326_ VPWR VGND sg13g2_nand3_1
X_34053_ _10328_ _10325_ _10326_ _10327_ VPWR VGND sg13g2_o21ai_1
X_34054_ _10329_ \memory_i.freq_inst.dsmod_sin.accu3_r[24]\ \memory_i.freq_inst.dsmod_sin.accu2_r[24]\ VPWR VGND sg13g2_nand2_1
X_34055_ _10330_ _10308_ _09828_ _10326_ VPWR VGND sg13g2_nand3_1
X_34056_ _10331_ _10326_ _10329_ _10330_ VPWR VGND sg13g2_o21ai_1
X_34057_ _10332_ _10324_ _10328_ _10331_ _09842_ VPWR
+ VGND
+ sg13g2_a22oi_1
X_34058_ _10333_ _10301_ _10332_ VPWR VGND sg13g2_nor2_1
X_34059_ _10334_ _10323_ _10333_ VPWR VGND sg13g2_nor2_1
X_34060_ _10335_ _09857_ _10334_ VPWR VGND sg13g2_xnor2_1
X_34061_ _10336_ _05737_ _10335_ VPWR VGND sg13g2_nor2_1
X_34062_ _10337_ \memory_i.freq_inst.dsmod_sin.accu3_r[26]\ _10336_ VPWR VGND sg13g2_xnor2_1
X_34063_ _01949_ _10235_ _10337_ VPWR VGND sg13g2_nor2_1
X_34064_ _10338_ \memory_i.freq_inst.dsmod_sin.accu3_r[26]\ _10323_ _10333_ VPWR VGND sg13g2_nor3_1
X_34065_ _10339_ _10323_ _10333_ \memory_i.freq_inst.dsmod_sin.accu3_r[26]\ VPWR VGND sg13g2_o21ai_1
X_34066_ _10340_ _09857_ _10338_ _10339_ VPWR VGND sg13g2_o21ai_1
X_34067_ _10341_ _09873_ _10340_ VPWR VGND sg13g2_xor2_1
X_34068_ _10342_ \memory_i.freq_inst.dsmod_cos.i_ena_mod\ _10341_ VPWR VGND sg13g2_nand2_1
X_34069_ _10343_ \memory_i.freq_inst.dsmod_sin.accu3_r[27]\ _10342_ VPWR VGND sg13g2_xor2_1
X_34070_ _01950_ _10235_ _10343_ VPWR VGND sg13g2_nor2_1
X_34071_ _10344_ \memory_i.freq_inst.dsmod_sin.accu3_r[22]\ _10279_ _10266_ VPWR VGND sg13g2_a21oi_1
X_34072_ _10345_ \memory_i.freq_inst.dsmod_sin.accu3_r[22]\ _10279_ VPWR VGND sg13g2_nor2_1
X_34073_ _10346_ \memory_i.freq_inst.dsmod_sin.accu3_r[23]\ _09825_ VPWR VGND sg13g2_nand2_1
X_34074_ _10347_ _10344_ _10345_ _10346_ VPWR VGND sg13g2_o21ai_1
X_34075_ _10348_ \memory_i.freq_inst.dsmod_sin.accu3_r[22]\ _10266_ VPWR VGND sg13g2_nor2_1
X_34076_ _10349_ _10245_ _10288_ _10348_ VPWR VGND sg13g2_nor3_1
X_34077_ _10350_ \memory_i.freq_inst.dsmod_sin.accu3_r[23]\ _09825_ VPWR VGND sg13g2_nor2_1
X_34078_ _10351_ _09853_ _09856_ VPWR VGND sg13g2_xor2_1
X_34079_ _10352_ \memory_i.freq_inst.dsmod_sin.accu3_r[26]\ _10351_ VPWR VGND sg13g2_xnor2_1
X_34080_ _10353_ _10332_ _10350_ _10352_ VPWR VGND sg13g2_nor3_1
X_34081_ _10354_ _10347_ _10349_ _10353_ VPWR VGND sg13g2_o21ai_1
X_34082_ _10355_ \memory_i.freq_inst.dsmod_sin.accu3_r[26]\ _09857_ VPWR VGND sg13g2_nand2b_1
X_34083_ _10356_ \memory_i.freq_inst.dsmod_sin.accu3_r[26]\ _10351_ _10323_ VPWR VGND sg13g2_a21o_1
X_34084_ _10357_ \memory_i.freq_inst.dsmod_sin.accu3_r[27]\ _09873_ _10355_ _10356_ VPWR
+ VGND
+ sg13g2_a22oi_1
X_34085_ _10358_ \memory_i.freq_inst.dsmod_sin.accu3_r[27]\ _09873_ VPWR VGND sg13g2_nor2_1
X_34086_ _10359_ _10354_ _10357_ _10358_ VPWR VGND sg13g2_a21o_1
X_34087_ _10360_ _09892_ _10359_ VPWR VGND sg13g2_nor2_1
X_34088_ _10361_ _09892_ _10359_ VPWR VGND sg13g2_nand2_1
X_34089_ _10362_ _10360_ _10361_ \memory_i.freq_inst.dsmod_cos.i_ena_mod\ VPWR VGND sg13g2_nand3b_1
X_34090_ _10363_ \memory_i.freq_inst.dsmod_sin.accu3_r[28]\ _10362_ VPWR VGND sg13g2_xor2_1
X_34091_ _01951_ _10235_ _10363_ VPWR VGND sg13g2_nor2_1
X_34092_ _10364_ \memory_i.freq_inst.dsmod_sin.accu3_r[28]\ _10360_ _10361_ VPWR VGND sg13g2_o21ai_1
X_34093_ _10365_ _09899_ _10364_ VPWR VGND sg13g2_xnor2_1
X_34094_ _10366_ \memory_i.freq_inst.dsmod_cos.i_ena_mod\ _10365_ VPWR VGND sg13g2_nand2_1
X_34095_ _10367_ \memory_i.freq_inst.dsmod_sin.accu3_r[29]\ _10366_ VPWR VGND sg13g2_xor2_1
X_34096_ _01952_ _10235_ _10367_ VPWR VGND sg13g2_nor2_1
X_34097_ _10368_ _15823_ VPWR VGND sg13g2_buf_1
X_34098_ _10369_ _09918_ VPWR VGND sg13g2_inv_1
X_34099_ _10370_ \memory_i.freq_inst.dsmod_sin.accu3_r[29]\ _09899_ VPWR VGND sg13g2_or2_1
X_34100_ _10371_ _10370_ VPWR VGND sg13g2_buf_1
X_34101_ _10372_ \memory_i.freq_inst.dsmod_sin.accu3_r[29]\ _09899_ VPWR VGND sg13g2_nand2_1
X_34102_ _10373_ _09892_ _10357_ _10372_ VPWR VGND sg13g2_and3_1
X_34103_ _10374_ _09892_ VPWR VGND sg13g2_inv_1
X_34104_ _10375_ _10358_ _10372_ VPWR VGND sg13g2_nand2_1
X_34105_ _10376_ \memory_i.freq_inst.dsmod_sin.accu3_r[28]\ _10374_ _10375_ VPWR VGND sg13g2_a21oi_1
X_34106_ _10377_ _10354_ _10373_ _10376_ VPWR VGND sg13g2_a21oi_2
X_34107_ _10378_ \memory_i.freq_inst.dsmod_sin.accu3_r[29]\ _09899_ \memory_i.freq_inst.dsmod_sin.accu3_r[28]\ VPWR VGND sg13g2_a21oi_1
X_34108_ _10379_ _10357_ _10378_ VPWR VGND sg13g2_and2_1
X_34109_ _10380_ \memory_i.freq_inst.dsmod_sin.accu3_r[28]\ _10374_ VPWR VGND sg13g2_nor2_1
X_34110_ _10381_ _10354_ _10379_ _10380_ _10372_ VPWR
+ VGND
+ sg13g2_a22oi_1
X_34111_ _10382_ _10381_ VPWR VGND sg13g2_buf_2
X_34112_ _10383_ _10371_ _10377_ _10382_ VPWR VGND sg13g2_nand3_1
X_34113_ _10384_ _10383_ VPWR VGND sg13g2_buf_1
X_34114_ _10385_ _10369_ _10384_ VPWR VGND sg13g2_xnor2_1
X_34115_ _10386_ _05737_ _10385_ VPWR VGND sg13g2_nor2_1
X_34116_ _10387_ \memory_i.freq_inst.dsmod_sin.accu3_r[30]\ _10386_ VPWR VGND sg13g2_xnor2_1
X_34117_ _01953_ _10368_ _10387_ VPWR VGND sg13g2_nor2_1
X_34118_ _10388_ _10369_ _10384_ VPWR VGND sg13g2_nand2_1
X_34119_ _10389_ _10369_ _10384_ VPWR VGND sg13g2_nor2_1
X_34120_ _10390_ \memory_i.freq_inst.dsmod_sin.accu3_r[30]\ _10388_ _10389_ VPWR VGND sg13g2_a21oi_1
X_34121_ _10391_ _09925_ _10390_ VPWR VGND sg13g2_xnor2_1
X_34122_ _10392_ \memory_i.freq_inst.dsmod_cos.i_ena_mod\ _10391_ VPWR VGND sg13g2_nand2_1
X_34123_ _10393_ \memory_i.freq_inst.dsmod_sin.accu3_r[31]\ _10392_ VPWR VGND sg13g2_xor2_1
X_34124_ _01954_ _10368_ _10393_ VPWR VGND sg13g2_nor2_1
X_34125_ _10394_ \memory_i.freq_inst.dsmod_sin.accu2_r[32]\ _09938_ VPWR VGND sg13g2_xnor2_1
X_34126_ _10395_ _09918_ _10371_ VPWR VGND sg13g2_and2_1
X_34127_ _10396_ _09925_ _10377_ _10382_ _10395_ VPWR
+ VGND
+ sg13g2_nand4_1
X_34128_ _10397_ \memory_i.freq_inst.dsmod_sin.accu3_r[30]\ _10371_ VPWR VGND sg13g2_and2_1
X_34129_ _10398_ _09925_ _10377_ _10382_ _10397_ VPWR
+ VGND
+ sg13g2_nand4_1
X_34130_ _10399_ \memory_i.freq_inst.dsmod_sin.accu3_r[31]\ _09918_ VPWR VGND sg13g2_and2_1
X_34131_ _10400_ _10371_ _10377_ _10382_ _10399_ VPWR
+ VGND
+ sg13g2_nand4_1
X_34132_ _10401_ \memory_i.freq_inst.dsmod_sin.accu3_r[31]\ \memory_i.freq_inst.dsmod_sin.accu3_r[30]\ VPWR VGND sg13g2_and2_1
X_34133_ _10402_ _10371_ _10377_ _10382_ _10401_ VPWR
+ VGND
+ sg13g2_nand4_1
X_34134_ _10403_ _10396_ _10398_ _10400_ _10402_ VPWR
+ VGND
+ sg13g2_and4_1
X_34135_ _10404_ _10403_ VPWR VGND sg13g2_buf_4
X_34136_ _10405_ \memory_i.freq_inst.dsmod_sin.accu3_r[30]\ _09918_ _09925_ VPWR VGND sg13g2_and3_1
X_34137_ _10406_ \memory_i.freq_inst.dsmod_sin.accu3_r[31]\ _09925_ _10401_ _09918_ _10405_
+ VPWR
+ VGND sg13g2_a221oi_1
X_34138_ _10407_ _10406_ VPWR VGND sg13g2_buf_2
X_34139_ _10408_ _10404_ _10407_ VPWR VGND sg13g2_nand2_1
X_34140_ _10409_ _10394_ _10408_ VPWR VGND sg13g2_xor2_1
X_34141_ _10410_ \memory_i.freq_inst.dsmod_cos.i_ena_mod\ _10409_ VPWR VGND sg13g2_nand2_1
X_34142_ _10411_ \memory_i.freq_inst.dsmod_sin.accu3_r[32]\ _10410_ VPWR VGND sg13g2_xor2_1
X_34143_ _01955_ _10368_ _10411_ VPWR VGND sg13g2_nor2_1
X_34144_ _10412_ \memory_i.freq_inst.dsmod_sin.accu3_r[32]\ _10394_ VPWR VGND sg13g2_or2_1
X_34145_ _10413_ _10412_ VPWR VGND sg13g2_buf_1
X_34146_ _10414_ \memory_i.freq_inst.dsmod_sin.accu3_r[32]\ _10394_ VPWR VGND sg13g2_and2_1
X_34147_ _10415_ _10414_ VPWR VGND sg13g2_buf_1
X_34148_ _10416_ _10408_ _10413_ _10415_ VPWR VGND sg13g2_a21oi_1
X_34149_ _10417_ _09946_ _10416_ VPWR VGND sg13g2_xor2_1
X_34150_ _10418_ _10417_ \memory_i.freq_inst.dsmod_cos.i_ena_mod\ VPWR VGND sg13g2_nand2b_1
X_34151_ _10419_ \memory_i.freq_inst.dsmod_sin.accu3_r[33]\ _10418_ VPWR VGND sg13g2_xor2_1
X_34152_ _01956_ _10368_ _10419_ VPWR VGND sg13g2_nor2_1
X_34153_ _10420_ _09946_ _09956_ _10413_ VPWR VGND sg13g2_nand3_1
X_34154_ _10421_ \memory_i.freq_inst.dsmod_sin.accu3_r[33]\ _09956_ _10413_ VPWR VGND sg13g2_nand3_1
X_34155_ _10422_ _10404_ _10407_ _10420_ _10421_ VPWR
+ VGND
+ sg13g2_a22oi_1
X_34156_ _10423_ _10422_ VPWR VGND sg13g2_buf_4
X_34157_ _10424_ \memory_i.freq_inst.dsmod_sin.accu3_r[33]\ _09946_ _09956_ VPWR VGND sg13g2_nand3_1
X_34158_ _10425_ _09946_ _09956_ _10415_ VPWR VGND sg13g2_nand3_1
X_34159_ _10426_ \memory_i.freq_inst.dsmod_sin.accu3_r[33]\ _09956_ _10415_ VPWR VGND sg13g2_nand3_1
X_34160_ _10427_ _10424_ _10425_ _10426_ VPWR VGND sg13g2_nand3_1
X_34161_ _10428_ _10427_ VPWR VGND sg13g2_buf_2
X_34162_ _10429_ _10423_ _10428_ VPWR VGND sg13g2_or2_1
X_34163_ _10430_ _09946_ _09956_ _10415_ VPWR VGND sg13g2_nor3_1
X_34164_ _10431_ _10404_ _10407_ _10430_ VPWR VGND sg13g2_nand3_1
X_34165_ _10432_ \memory_i.freq_inst.dsmod_sin.accu3_r[33]\ _09955_ _10415_ VPWR VGND sg13g2_nor3_1
X_34166_ _10433_ _10404_ _10407_ _10432_ VPWR VGND sg13g2_nand3_1
X_34167_ _10434_ _10433_ VPWR VGND sg13g2_buf_1
X_34168_ _10435_ \memory_i.freq_inst.dsmod_sin.accu3_r[33]\ _09946_ _09956_ VPWR VGND sg13g2_nor3_1
X_34169_ _10436_ _09946_ _09956_ _10413_ VPWR VGND sg13g2_nor3_1
X_34170_ _10437_ \memory_i.freq_inst.dsmod_sin.accu3_r[33]\ _09956_ _10413_ VPWR VGND sg13g2_nor3_1
X_34171_ _10438_ _10435_ _10436_ _10437_ VPWR VGND sg13g2_nor3_1
X_34172_ _10439_ _10431_ _10434_ _10438_ VPWR VGND sg13g2_nand3_1
X_34173_ _10440_ _12939_ _10429_ _10439_ VPWR VGND sg13g2_nor3_1
X_34174_ _10441_ \memory_i.freq_inst.dsmod_sin.accu3_r[34]\ _10440_ VPWR VGND sg13g2_xnor2_1
X_34175_ _01957_ _10368_ _10441_ VPWR VGND sg13g2_nor2_1
X_34176_ _10442_ \memory_i.freq_inst.dsmod_sin.accu3_r[35]\ VPWR VGND sg13g2_inv_1
X_34177_ _10443_ \memory_i.freq_inst.dsmod_sin.accu3_r[34]\ _10431_ _10434_ _10438_ VPWR
+ VGND
+ sg13g2_nand4_1
X_34178_ _10444_ _10443_ VPWR VGND sg13g2_buf_2
X_34179_ _10445_ _10429_ _10444_ VPWR VGND sg13g2_nand2b_1
X_34180_ _10446_ _09978_ _10445_ VPWR VGND sg13g2_xor2_1
X_34181_ _10447_ \memory_i.freq_inst.dsmod_cos.i_ena_mod\ _10446_ VPWR VGND sg13g2_nand2_1
X_34182_ _10448_ _10442_ _10447_ VPWR VGND sg13g2_xnor2_1
X_34183_ _01958_ _10368_ _10448_ VPWR VGND sg13g2_nor2_1
X_34184_ _10449_ _10423_ _10428_ _09978_ VPWR VGND sg13g2_o21ai_1
X_34185_ _10450_ \memory_i.freq_inst.dsmod_sin.accu3_r[34]\ _09978_ VPWR VGND sg13g2_and2_1
X_34186_ _10451_ _10431_ _10434_ _10438_ _10450_ VPWR
+ VGND
+ sg13g2_nand4_1
X_34187_ _10452_ _10442_ _10449_ _10451_ VPWR VGND sg13g2_nand3_1
X_34188_ _10453_ _09978_ _10445_ _10452_ VPWR VGND sg13g2_o21ai_1
X_34189_ _10454_ _09984_ _10453_ VPWR VGND sg13g2_xnor2_1
X_34190_ _10455_ \memory_i.freq_inst.dsmod_cos.i_ena_mod\ _10454_ VPWR VGND sg13g2_nand2_1
X_34191_ _10456_ \memory_i.freq_inst.dsmod_sin.accu3_r[36]\ _10455_ VPWR VGND sg13g2_xor2_1
X_34192_ _01959_ _10368_ _10456_ VPWR VGND sg13g2_nor2_1
X_34193_ _10457_ \memory_i.freq_inst.dsmod_sin.accu3_r[37]\ VPWR VGND sg13g2_inv_1
X_34194_ _10458_ _09987_ _10002_ VPWR VGND sg13g2_xnor2_1
X_34195_ _10459_ _10458_ VPWR VGND sg13g2_buf_2
X_34196_ _10460_ \memory_i.freq_inst.dsmod_sin.accu3_r[36]\ _09984_ VPWR VGND sg13g2_nand2_1
X_34197_ _10461_ _09978_ _10460_ VPWR VGND sg13g2_nand2b_1
X_34198_ _10462_ _10423_ _10428_ _10461_ VPWR VGND sg13g2_nor3_1
X_34199_ _10463_ _10442_ _10460_ VPWR VGND sg13g2_nand2_1
X_34200_ _10464_ _10423_ _10428_ _10463_ VPWR VGND sg13g2_nor3_1
X_34201_ _10465_ _10462_ _10464_ _10444_ VPWR VGND sg13g2_o21ai_1
X_34202_ _10466_ _10465_ VPWR VGND sg13g2_buf_4
X_34203_ _10467_ \memory_i.freq_inst.dsmod_sin.accu3_r[35]\ _09978_ VPWR VGND sg13g2_nor2_1
X_34204_ _10468_ \memory_i.freq_inst.dsmod_sin.accu3_r[36]\ _09984_ VPWR VGND sg13g2_nor2_1
X_34205_ _10469_ _10460_ _10467_ _10468_ VPWR VGND sg13g2_a21oi_1
X_34206_ _10470_ _10469_ VPWR VGND sg13g2_buf_2
X_34207_ _10471_ _10459_ _10466_ _10470_ VPWR VGND sg13g2_nand3_1
X_34208_ _10472_ _10471_ VPWR VGND sg13g2_buf_1
X_34209_ _10473_ \memory_i.freq_inst.dsmod_sin.accu2_r[37]\ _10002_ VPWR VGND sg13g2_xnor2_1
X_34210_ _10474_ _10473_ VPWR VGND sg13g2_buf_2
X_34211_ _10475_ _10474_ VPWR VGND sg13g2_buf_1
X_34212_ _10476_ _10466_ _10470_ VPWR VGND sg13g2_nand2_1
X_34213_ _10477_ _10476_ VPWR VGND sg13g2_buf_2
X_34214_ _10478_ _10475_ _10477_ VPWR VGND sg13g2_nand2_1
X_34215_ _10479_ _10472_ _10478_ _12939_ VPWR VGND sg13g2_a21o_1
X_34216_ _10480_ _10457_ _10479_ VPWR VGND sg13g2_xnor2_1
X_34217_ _01960_ _10368_ _10480_ VPWR VGND sg13g2_nor2_1
X_34218_ _10481_ \memory_i.freq_inst.dsmod_sin.accu3_r[38]\ VPWR VGND sg13g2_inv_1
X_34219_ _10482_ \memory_i.freq_inst.dsmod_sin.accu2_r[38]\ _10007_ VPWR VGND sg13g2_xnor2_1
X_34220_ _10483_ _10482_ VPWR VGND sg13g2_buf_1
X_34221_ _10484_ \memory_i.freq_inst.dsmod_sin.accu3_r[37]\ _10459_ VPWR VGND sg13g2_nand2_1
X_34222_ _10485_ _10457_ _10475_ _10477_ VPWR VGND sg13g2_nand3_1
X_34223_ _10486_ _10477_ _10484_ _10485_ VPWR VGND sg13g2_o21ai_1
X_34224_ _10487_ _10483_ _10486_ VPWR VGND sg13g2_xnor2_1
X_34225_ _10488_ \memory_i.freq_inst.dsmod_cos.i_ena_mod\ _10487_ VPWR VGND sg13g2_nand2_1
X_34226_ _10489_ _10481_ _10488_ VPWR VGND sg13g2_xnor2_1
X_34227_ _01961_ _10368_ _10489_ VPWR VGND sg13g2_nor2_1
X_34228_ _10490_ \memory_i.freq_inst.dsmod_sin.accu3_r[39]\ _10018_ VPWR VGND sg13g2_xor2_1
X_34229_ _10491_ _10490_ VPWR VGND sg13g2_buf_2
X_34230_ _10492_ _09978_ _10423_ _10428_ VPWR VGND sg13g2_nor3_1
X_34231_ _10493_ _10444_ _10492_ _10442_ VPWR VGND sg13g2_a21oi_1
X_34232_ _10494_ _10449_ _10451_ _10474_ _10460_ VPWR
+ VGND
+ sg13g2_nand4_1
X_34233_ _10495_ _10474_ _10468_ _10457_ VPWR VGND sg13g2_a21oi_1
X_34234_ _10496_ _10493_ _10494_ _10495_ VPWR VGND sg13g2_o21ai_1
X_34235_ _10497_ _10472_ _10496_ _10011_ VPWR VGND sg13g2_a21oi_1
X_34236_ _10498_ _10011_ _10472_ _10496_ VPWR VGND sg13g2_nand3_1
X_34237_ _10499_ \memory_i.freq_inst.dsmod_sin.accu3_r[38]\ _10497_ _10498_ VPWR VGND sg13g2_o21ai_1
X_34238_ _10500_ _10491_ _10499_ VPWR VGND sg13g2_xnor2_1
X_34239_ _10501_ \memory_i.freq_inst.dsmod_sin.accu3_r[38]\ \memory_i.freq_inst.dsmod_sin.accu3_r[37]\ VPWR VGND sg13g2_nor2_1
X_34240_ _10502_ _10501_ VPWR VGND sg13g2_buf_1
X_34241_ _10503_ _13400_ _10475_ _10477_ _10502_ VPWR
+ VGND
+ sg13g2_nand4_1
X_34242_ _10504_ _10459_ VPWR VGND sg13g2_buf_1
X_34243_ _10505_ _10466_ _10470_ VPWR VGND sg13g2_and2_1
X_34244_ _10506_ _10505_ VPWR VGND sg13g2_buf_4
X_34245_ _10507_ _10481_ _10457_ VPWR VGND sg13g2_nor2_1
X_34246_ _10508_ _13387_ _10504_ _10506_ _10507_ VPWR
+ VGND
+ sg13g2_nand4_1
X_34247_ _10509_ _10503_ _10508_ _10009_ VPWR VGND sg13g2_a21oi_1
X_34248_ _10510_ _10466_ VPWR VGND sg13g2_buf_8
X_34249_ _10511_ _10470_ VPWR VGND sg13g2_buf_2
X_34250_ _10512_ \memory_i.freq_inst.dsmod_sin.accu3_r[38]\ \memory_i.freq_inst.dsmod_sin.accu3_r[37]\ _13399_ _10459_ VPWR
+ VGND
+ sg13g2_nor4_1
X_34251_ _10513_ _10483_ _10510_ _10511_ _10512_ VPWR
+ VGND
+ sg13g2_nand4_1
X_34252_ _10514_ \memory_i.freq_inst.dsmod_sin.accu3_r[38]\ \memory_i.freq_inst.dsmod_sin.accu3_r[37]\ VPWR VGND sg13g2_nand2_1
X_34253_ _10515_ _13386_ _10009_ _10459_ _10514_ VPWR
+ VGND
+ sg13g2_nor4_1
X_34254_ _10516_ _10510_ _10511_ _10515_ VPWR VGND sg13g2_nand3_1
X_34255_ _10517_ \memory_i.freq_inst.dsmod_sin.accu3_r[38]\ _10457_ VPWR VGND sg13g2_nand2_1
X_34256_ _10518_ _13400_ _10483_ _10459_ _10517_ VPWR
+ VGND
+ sg13g2_nor4_1
X_34257_ _10519_ _10510_ _10511_ _10518_ VPWR VGND sg13g2_nand3_1
X_34258_ _10520_ _10481_ \memory_i.freq_inst.dsmod_sin.accu3_r[37]\ VPWR VGND sg13g2_nand2_1
X_34259_ _10521_ _13386_ _10483_ _10459_ _10520_ VPWR
+ VGND
+ sg13g2_nor4_1
X_34260_ _10522_ _10510_ _10511_ _10521_ VPWR VGND sg13g2_nand3_1
X_34261_ _10523_ _10513_ _10516_ _10519_ _10522_ VPWR
+ VGND
+ sg13g2_and4_1
X_34262_ _10524_ _13387_ _10009_ _10475_ _10517_ VPWR
+ VGND
+ sg13g2_nor4_1
X_34263_ _10525_ _13400_ _10483_ _10475_ _10520_ VPWR
+ VGND
+ sg13g2_nor4_1
X_34264_ _10526_ _10524_ _10525_ _10506_ VPWR VGND sg13g2_o21ai_1
X_34265_ _10527_ _13400_ _10009_ _10504_ _10502_ VPWR
+ VGND
+ sg13g2_nand4_1
X_34266_ _10528_ \memory_i.freq_inst.dsmod_sin.accu3_r[38]\ _10457_ VPWR VGND sg13g2_nor2_1
X_34267_ _10529_ _13387_ _10483_ _10475_ _10528_ VPWR
+ VGND
+ sg13g2_nand4_1
X_34268_ _10530_ _10527_ _10529_ _10477_ VPWR VGND sg13g2_mux2_1
X_34269_ _10531_ _10481_ \memory_i.freq_inst.dsmod_sin.accu3_r[37]\ VPWR VGND sg13g2_nor2_1
X_34270_ _10532_ _13387_ _10009_ _10459_ _10531_ VPWR
+ VGND
+ sg13g2_nand4_1
X_34271_ _10533_ _13400_ _10009_ _10459_ _10528_ VPWR
+ VGND
+ sg13g2_nand4_1
X_34272_ _10534_ _10510_ _10511_ _10532_ _10533_ VPWR
+ VGND
+ sg13g2_a22oi_1
X_34273_ _10535_ _13387_ _10009_ _10474_ _10507_ VPWR
+ VGND
+ sg13g2_nand4_1
X_34274_ _10536_ _13400_ _10009_ _10474_ _10531_ VPWR
+ VGND
+ sg13g2_nand4_1
X_34275_ _10537_ _10510_ _10511_ _10535_ _10536_ VPWR
+ VGND
+ sg13g2_a22oi_1
X_34276_ _10538_ _13387_ _10483_ _10504_ _10502_ VPWR
+ VGND
+ sg13g2_nand4_1
X_34277_ _10539_ _13400_ _10483_ _10504_ _10507_ VPWR
+ VGND
+ sg13g2_nand4_1
X_34278_ _10540_ _10510_ _10511_ _10538_ _10539_ VPWR
+ VGND
+ sg13g2_a22oi_1
X_34279_ _10541_ _10534_ _10537_ _10540_ VPWR VGND sg13g2_nor3_1
X_34280_ _10542_ _10523_ _10526_ _10530_ _10541_ VPWR
+ VGND
+ sg13g2_nand4_1
X_34281_ _10543_ _10509_ _10542_ VPWR VGND sg13g2_nor2_1
X_34282_ _10544_ _10500_ _10543_ VPWR VGND sg13g2_xnor2_1
X_34283_ _10545_ \memory_i.freq_inst.dsmod_cos.i_ena_mod\ \memory_i.freq_inst.dsmod_sin.accu3_r[39]\ VPWR VGND sg13g2_nor2b_1
X_34284_ _10546_ \memory_i.freq_inst.dsmod_cos.i_ena_mod\ _10544_ _10545_ VPWR VGND sg13g2_a21oi_1
X_34285_ _01962_ _10368_ _10546_ VPWR VGND sg13g2_nor2_1
X_34286_ _10547_ \memory_i.freq_inst.dsmod_sin.accu3_r[40]\ VPWR VGND sg13g2_inv_1
X_34287_ _10548_ _12945_ _10547_ VPWR VGND sg13g2_nor2_1
X_34288_ _10549_ _12945_ \memory_i.freq_inst.dsmod_sin.accu3_r[40]\ VPWR VGND sg13g2_nor2_1
X_34289_ _10550_ \memory_i.freq_inst.dsmod_sin.accu3_r[39]\ _10018_ VPWR VGND sg13g2_nor2_1
X_34290_ _10551_ _10011_ _10550_ VPWR VGND sg13g2_nor2_1
X_34291_ _10552_ _10504_ _10510_ _10511_ _10551_ VPWR
+ VGND
+ sg13g2_nand4_1
X_34292_ _10553_ \memory_i.freq_inst.dsmod_sin.accu3_r[39]\ _10018_ VPWR VGND sg13g2_or2_1
X_34293_ _10554_ _10553_ VPWR VGND sg13g2_buf_1
X_34294_ _10555_ _10481_ _10474_ VPWR VGND sg13g2_nor2_1
X_34295_ _10556_ _10510_ _10511_ _10554_ _10555_ VPWR
+ VGND
+ sg13g2_nand4_1
X_34296_ _10557_ \memory_i.freq_inst.dsmod_sin.accu3_r[37]\ _10466_ _10470_ _10551_ VPWR
+ VGND
+ sg13g2_nand4_1
X_34297_ _10558_ _10510_ _10511_ _10507_ _10554_ VPWR
+ VGND
+ sg13g2_nand4_1
X_34298_ _10559_ _10552_ _10556_ _10557_ _10558_ VPWR
+ VGND
+ sg13g2_and4_1
X_34299_ _10560_ _10474_ _10514_ VPWR VGND sg13g2_nor2_1
X_34300_ _10561_ _10011_ _10484_ _10550_ VPWR VGND sg13g2_nor3_1
X_34301_ _10562_ \memory_i.freq_inst.dsmod_sin.accu3_r[38]\ _10551_ _10560_ _10554_ _10561_
+ VPWR
+ VGND sg13g2_a221oi_1
X_34302_ _10563_ \memory_i.freq_inst.dsmod_sin.accu3_r[39]\ _10018_ VPWR VGND sg13g2_and2_1
X_34303_ _10564_ _10563_ VPWR VGND sg13g2_buf_1
X_34304_ _10565_ _10038_ _10564_ VPWR VGND sg13g2_nor2_1
X_34305_ _10566_ _10559_ _10562_ _10565_ VPWR VGND sg13g2_nand3_1
X_34306_ _10567_ _10481_ _10039_ _10550_ VPWR VGND sg13g2_nor3_1
X_34307_ _10568_ _10038_ _10551_ VPWR VGND sg13g2_nand2_1
X_34308_ _10569_ _10472_ _10496_ _10568_ VPWR VGND sg13g2_a21oi_1
X_34309_ _10570_ _10038_ _10564_ _10567_ _10498_ _10569_
+ VPWR
+ VGND sg13g2_a221oi_1
X_34310_ _10571_ _10566_ _10570_ VPWR VGND sg13g2_and2_1
X_34311_ _10572_ _10509_ _10542_ _10491_ VPWR VGND sg13g2_mux2_1
X_34312_ _10573_ _10571_ _10572_ VPWR VGND sg13g2_xor2_1
X_34313_ _10574_ _12940_ _10573_ VPWR VGND sg13g2_nor2_1
X_34314_ _01963_ _10548_ _10549_ _10574_ VPWR VGND sg13g2_mux2_1
X_34315_ _10575_ _10011_ _10474_ _10491_ _10507_ VPWR
+ VGND
+ sg13g2_nand4_1
X_34316_ _10576_ _13399_ _10009_ VPWR VGND sg13g2_xnor2_1
X_34317_ _10577_ _10576_ VPWR VGND sg13g2_buf_1
X_34318_ _10578_ _10577_ _10475_ _10491_ _10528_ VPWR
+ VGND
+ sg13g2_nand4_1
X_34319_ _10579_ _10575_ _10578_ _10477_ VPWR VGND sg13g2_a21oi_1
X_34320_ _10580_ _10011_ _10504_ _10491_ _10531_ VPWR
+ VGND
+ sg13g2_nand4_1
X_34321_ _10581_ _10577_ _10504_ _10490_ _10502_ VPWR
+ VGND
+ sg13g2_nand4_1
X_34322_ _10582_ _10580_ _10581_ _10477_ VPWR VGND sg13g2_a21oi_1
X_34323_ _10583_ _10577_ _10475_ _10491_ _10531_ VPWR
+ VGND
+ sg13g2_nand4_1
X_34324_ _10584_ _10011_ _10491_ _10560_ VPWR VGND sg13g2_nand3_1
X_34325_ _10585_ _10583_ _10584_ _10506_ VPWR VGND sg13g2_a21oi_1
X_34326_ _10586_ _10577_ _10504_ _10491_ _10528_ VPWR
+ VGND
+ sg13g2_nand4_1
X_34327_ _10587_ \memory_i.freq_inst.dsmod_sin.accu3_r[39]\ _10018_ VPWR VGND sg13g2_xnor2_1
X_34328_ _10588_ _10011_ _10475_ _10587_ _10502_ VPWR
+ VGND
+ sg13g2_nand4_1
X_34329_ _10589_ _10586_ _10588_ _10506_ VPWR VGND sg13g2_a21oi_1
X_34330_ _10590_ _10579_ _10582_ _10585_ _10589_ VPWR
+ VGND
+ sg13g2_nor4_1
X_34331_ _10591_ _10577_ _10504_ _10587_ _10517_ VPWR
+ VGND
+ sg13g2_nor4_1
X_34332_ _10592_ _10577_ _10475_ _10491_ _10502_ VPWR
+ VGND
+ sg13g2_and4_1
X_34333_ _10593_ _10591_ _10592_ _10506_ VPWR VGND sg13g2_o21ai_1
X_34334_ _10594_ _10011_ _10504_ _10491_ _10528_ VPWR
+ VGND
+ sg13g2_nand4_1
X_34335_ _10595_ _10575_ _10594_ _10506_ VPWR VGND sg13g2_mux2_1
X_34336_ _10596_ _10578_ _10580_ _10506_ VPWR VGND sg13g2_a21o_1
X_34337_ _10597_ _10577_ _10587_ _10560_ VPWR VGND sg13g2_nand3_1
X_34338_ _10598_ _10581_ _10597_ _10506_ VPWR VGND sg13g2_mux2_1
X_34339_ _10599_ _10593_ _10595_ _10596_ _10598_ VPWR
+ VGND
+ sg13g2_and4_1
X_34340_ _10600_ _13387_ _10599_ _10547_ VPWR VGND sg13g2_a21oi_1
X_34341_ _10601_ _10566_ _10570_ _10599_ _13387_ \memory_i.freq_inst.dsmod_sin.accu3_r[40]\
+ VPWR
+ VGND sg13g2_a221oi_1
X_34342_ _10602_ _13400_ _10590_ _10600_ _10571_ _10601_
+ VPWR
+ VGND sg13g2_a221oi_1
X_34343_ _10603_ \memory_i.freq_inst.dsmod_sin.accu3_r[41]\ \memory_i.freq_inst.dsmod_sin.accu1_r[39]\ VPWR VGND sg13g2_xnor2_1
X_34344_ _10604_ \memory_i.ds_lo_conf[5]\ _10603_ VPWR VGND sg13g2_nor2_1
X_34345_ _10605_ \memory_i.freq_inst.dsmod_sin.accu2_r[41]\ _10604_ VPWR VGND sg13g2_xnor2_1
X_34346_ _10606_ _10045_ _10605_ VPWR VGND sg13g2_xnor2_1
X_34347_ _10607_ _10038_ _10606_ VPWR VGND sg13g2_nor2b_1
X_34348_ _10608_ \memory_i.freq_inst.dsmod_sin.accu3_r[40]\ _10606_ VPWR VGND sg13g2_and2_1
X_34349_ _10609_ _10608_ VPWR VGND sg13g2_buf_1
X_34350_ _10610_ _10559_ _10562_ VPWR VGND sg13g2_nand2_1
X_34351_ _10611_ _10607_ _10609_ _10610_ VPWR VGND sg13g2_o21ai_1
X_34352_ _10612_ _10039_ _10564_ _10606_ VPWR VGND sg13g2_or3_1
X_34353_ _10613_ \memory_i.freq_inst.dsmod_sin.accu3_r[40]\ _10606_ VPWR VGND sg13g2_nor2_1
X_34354_ _10614_ _10564_ _10613_ VPWR VGND sg13g2_nand2b_1
X_34355_ _10615_ _10612_ _10614_ _10610_ VPWR VGND sg13g2_a21o_1
X_34356_ _10616_ _10564_ _10606_ VPWR VGND sg13g2_and2_1
X_34357_ _10617_ _10609_ _10616_ _10039_ VPWR VGND sg13g2_o21ai_1
X_34358_ _10618_ _10564_ _10609_ _10613_ _10038_ VPWR
+ VGND
+ sg13g2_a22oi_1
X_34359_ _10619_ _10611_ _10615_ _10617_ _10618_ VPWR
+ VGND
+ sg13g2_nand4_1
X_34360_ _10620_ _10602_ _10619_ VPWR VGND sg13g2_xor2_1
X_34361_ _10621_ \memory_i.freq_inst.dsmod_cos.i_ena_mod\ \memory_i.freq_inst.dsmod_sin.accu3_r[41]\ \memory_i.freq_inst.cordic.rstn_i\ VPWR VGND sg13g2_o21ai_1
X_34362_ _01964_ \memory_i.freq_inst.dsmod_cos.i_ena_mod\ _10620_ _10621_ VPWR VGND sg13g2_a21oi_1
X_34363_ _10622_ \memory_i.freq_inst.dsmod_sin.fetch_ctr_r[0]\ \memory_i.freq_inst.dsmod_cos.i_ena_mod\ VPWR VGND sg13g2_nand2b_1
X_34364_ _10623_ _10622_ VPWR VGND sg13g2_buf_1
X_34365_ _10624_ _08219_ \memory_i.freq_inst.dsmod_sin.fetch_ctr_r[0]\ VPWR VGND sg13g2_nand2_1
X_34366_ _01965_ _10623_ _10624_ _08911_ VPWR VGND sg13g2_a21oi_1
X_34367_ _10625_ \memory_i.freq_inst.dsmod_sin.fetch_ctr_r[1]\ _10623_ VPWR VGND sg13g2_xor2_1
X_34368_ _01966_ _12946_ _10625_ VPWR VGND sg13g2_nor2_1
X_34369_ _10626_ \memory_i.freq_inst.dsmod_sin.fetch_ctr_r[2]\ \memory_i.freq_inst.dsmod_sin.fetch_ctr_r[1]\ _10623_ VPWR VGND sg13g2_or3_1
X_34370_ _10627_ _10626_ VPWR VGND sg13g2_buf_1
X_34371_ _10628_ \memory_i.freq_inst.dsmod_sin.fetch_ctr_r[1]\ _10623_ \memory_i.freq_inst.dsmod_sin.fetch_ctr_r[2]\ VPWR VGND sg13g2_o21ai_1
X_34372_ _01967_ _10627_ _10628_ _08911_ VPWR VGND sg13g2_a21oi_1
X_34373_ _10629_ \memory_i.freq_inst.dsmod_sin.fetch_ctr_r[3]\ _10627_ VPWR VGND sg13g2_xor2_1
X_34374_ _01968_ _12946_ _10629_ VPWR VGND sg13g2_nor2_1
X_34375_ _10630_ \memory_i.freq_inst.dsmod_sin.fetch_ctr_r[3]\ _10627_ \memory_i.freq_inst.dsmod_sin.fetch_ctr_r[4]\ VPWR VGND sg13g2_o21ai_1
X_34376_ _10631_ _15810_ _10630_ VPWR VGND sg13g2_nor2b_1
X_34377_ _01969_ _12946_ _10631_ VPWR VGND sg13g2_nor2_1
X_34378_ _10632_ _15810_ \memory_i.freq_inst.dsmod_sin.fetch_ctr_r[5]\ VPWR VGND sg13g2_nor2b_1
X_34379_ _10633_ _15813_ _03147_ _15812_ VPWR VGND sg13g2_a21oi_1
X_34380_ _10634_ _10632_ _10633_ \memory_i.freq_inst.cordic.rstn_i\ VPWR VGND sg13g2_o21ai_1
X_34381_ _01970_ _10634_ VPWR VGND sg13g2_inv_1
X_34382_ _10635_ \memory_i.freq_inst.dsmod_sin.fetch_ctr_r[7]\ \memory_i.freq_inst.dsmod_cos.i_osr[1]\ VPWR VGND sg13g2_nor2_1
X_34383_ _10636_ \memory_i.freq_inst.dsmod_sin.fetch_ctr_r[6]\ _15812_ _10635_ VPWR VGND sg13g2_nor3_1
X_34384_ _10637_ \memory_i.freq_inst.dsmod_sin.fetch_ctr_r[6]\ _15812_ _10636_ VPWR VGND sg13g2_a21oi_1
X_34385_ _01971_ _12946_ _10637_ VPWR VGND sg13g2_nor2_1
X_34386_ _10638_ \memory_i.freq_inst.dsmod_sin.fetch_ctr_r[6]\ _15812_ \memory_i.freq_inst.dsmod_sin.fetch_ctr_r[7]\ VPWR VGND sg13g2_o21ai_1
X_34387_ _10639_ \memory_i.freq_inst.dsmod_sin.fetch_ctr_r[7]\ \memory_i.freq_inst.dsmod_sin.fetch_ctr_r[6]\ _15812_ _03163_ VPWR
+ VGND
+ sg13g2_or4_1
X_34388_ _01972_ _10638_ _10639_ _03810_ VPWR VGND sg13g2_a21oi_1
X_34389_ _00046_ clk VPWR VGND sg13g2_inv_1
X_34390_ _10640_ \memory_i.freq_inst.dsmod_cos.i_ena_mod\ \memory_i.freq_inst.lo_gen.lo_i_r\ VPWR VGND sg13g2_xnor2_1
X_34391_ _01974_ _12946_ _10640_ VPWR VGND sg13g2_nor2_1
X_34392_ _10641_ \memory_i.freq_inst.dsmod_cos.i_ena_mod\ \memory_i.freq_inst.lo_gen.lo_ctr_r[0]\ VPWR VGND sg13g2_xnor2_1
X_34393_ _01975_ _12946_ _10641_ VPWR VGND sg13g2_nor2_1
X_34394_ _10642_ \memory_i.freq_inst.dsmod_cos.i_ena_mod\ \memory_i.freq_inst.lo_gen.lo_ctr_r[0]\ VPWR VGND sg13g2_nand2_1
X_34395_ _10643_ \memory_i.freq_inst.lo_gen.lo_ctr_r[1]\ _10642_ VPWR VGND sg13g2_xor2_1
X_34396_ _01976_ _12946_ _10643_ VPWR VGND sg13g2_nor2_1
X_34397_ _10644_ \memory_i.freq_inst.dsmod_cos.i_ena_mod\ \memory_i.freq_inst.lo_gen.lo_ctr_r[1]\ \memory_i.freq_inst.lo_gen.lo_ctr_r[0]\ VPWR VGND sg13g2_nand3_1
X_34398_ _10645_ \memory_i.freq_inst.lo_gen.lo_ctr_r[2]\ _10644_ VPWR VGND sg13g2_xor2_1
X_34399_ _01977_ _12946_ _10645_ VPWR VGND sg13g2_nor2_1
X_34400_ _10646_ \memory_i.freq_inst.dsmod_cos.i_ena_mod\ \memory_i.freq_inst.lo_gen.lo_ctr_r[2]\ \memory_i.freq_inst.lo_gen.lo_ctr_r[1]\ \memory_i.freq_inst.lo_gen.lo_ctr_r[0]\ VPWR
+ VGND
+ sg13g2_nand4_1
X_34401_ _10647_ \memory_i.freq_inst.lo_gen.lo_ctr_r[3]\ _10646_ VPWR VGND sg13g2_xor2_1
X_34402_ _01978_ _12946_ _10647_ VPWR VGND sg13g2_nor2_1
X_34403_ _10648_ \memory_i.i2c_master.sda_i_sync1\ \memory_i.i2c_master.state[2]\ VPWR VGND sg13g2_nor2b_1
X_34404_ _10649_ \memory_i.i2c_master.state[6]\ \memory_i.i2c_master.state[2]\ _13141_ VPWR VGND sg13g2_o21ai_1
X_34405_ _10650_ \memory_i.i2c_acks[4]\ VPWR VGND sg13g2_inv_1
X_34406_ _10651_ _13141_ _10648_ _10649_ _10650_ VPWR
+ VGND
+ sg13g2_a22oi_1
X_34407_ _01979_ _10651_ reset VPWR VGND sg13g2_nand2b_1
X_34408_ _10652_ \memory_i.i2c_master.state[1]\ \memory_i.i2c_master.state[6]\ VPWR VGND sg13g2_nor2_1
X_34409_ _10653_ _13139_ _13107_ _10652_ VPWR VGND sg13g2_nor3_1
X_34410_ _10654_ \memory_i.i2c_master.frame_index[1]\ \memory_i.i2c_master.frame_index[0]\ \memory_i.i2c_master.state[1]\ VPWR VGND sg13g2_o21ai_1
X_34411_ _10655_ _10653_ _10654_ \memory_i.i2c_acks[0]\ VPWR VGND sg13g2_a21oi_1
X_34412_ _10656_ \memory_i.i2c_master.sda_i_sync1\ _13141_ \memory_i.i2c_master.state[1]\ VPWR VGND sg13g2_nand3b_1
X_34413_ _10657_ _10656_ VPWR VGND sg13g2_buf_1
X_34414_ _10658_ \memory_i.i2c_master.frame_index[1]\ \memory_i.i2c_master.frame_index[0]\ _10657_ VPWR VGND sg13g2_nor3_1
X_34415_ _01980_ _10655_ _10658_ reset VPWR VGND sg13g2_o21ai_1
X_34416_ _10659_ \memory_i.i2c_master.frame_index[1]\ VPWR VGND sg13g2_inv_1
X_34417_ _10660_ _10659_ \memory_i.i2c_master.frame_index[0]\ VPWR VGND sg13g2_nand2_1
X_34418_ _10661_ \memory_i.i2c_master.state[1]\ _10660_ VPWR VGND sg13g2_nand2_1
X_34419_ _10662_ _10653_ _10661_ \memory_i.i2c_acks[1]\ VPWR VGND sg13g2_a21oi_1
X_34420_ _10663_ _10657_ _10660_ VPWR VGND sg13g2_nor2_1
X_34421_ _01981_ _10662_ _10663_ reset VPWR VGND sg13g2_o21ai_1
X_34422_ _10664_ \memory_i.i2c_master.frame_index[1]\ _13117_ VPWR VGND sg13g2_nand2_1
X_34423_ _10665_ \memory_i.i2c_master.state[1]\ _10664_ VPWR VGND sg13g2_nand2_1
X_34424_ _10666_ _10653_ _10665_ \memory_i.i2c_acks[2]\ VPWR VGND sg13g2_a21oi_1
X_34425_ _10667_ _10657_ _10664_ VPWR VGND sg13g2_nor2_1
X_34426_ _01982_ _10666_ _10667_ reset VPWR VGND sg13g2_o21ai_1
X_34427_ _10668_ \memory_i.i2c_master.frame_index[1]\ \memory_i.i2c_master.frame_index[0]\ VPWR VGND sg13g2_nand2_1
X_34428_ _10669_ \memory_i.i2c_master.state[1]\ _10668_ VPWR VGND sg13g2_nand2_1
X_34429_ _10670_ _10653_ _10669_ \memory_i.i2c_acks[3]\ VPWR VGND sg13g2_a21oi_1
X_34430_ _10671_ _10657_ _10668_ VPWR VGND sg13g2_nor2_1
X_34431_ _01983_ _10670_ _10671_ reset VPWR VGND sg13g2_o21ai_1
X_34432_ _10672_ \memory_i.i2c_master.state[6]\ _13115_ _12948_ VPWR VGND sg13g2_a21o_1
X_34433_ _10673_ _10672_ VPWR VGND sg13g2_buf_1
X_34434_ _10674_ _10673_ VPWR VGND sg13g2_buf_1
X_34435_ _10675_ \memory_i.i2c_master.state[8]\ _13141_ VPWR VGND sg13g2_and2_1
X_34436_ _10676_ _10675_ VPWR VGND sg13g2_buf_1
X_34437_ _10677_ _13126_ _10676_ VPWR VGND sg13g2_nand2_1
X_34438_ _10678_ _10677_ VPWR VGND sg13g2_buf_1
X_34439_ _10679_ \memory_i.i2c_master.frame_index[1]\ \memory_i.i2c_master.frame_index[0]\ _10678_ VPWR VGND sg13g2_nor3_1
X_34440_ _10680_ \memory_i.i2c_dataout[0]\ \memory_i.i2c_master.sda_i_sync1\ _10679_ VPWR VGND sg13g2_mux2_1
X_34441_ _01984_ _10674_ _10680_ VPWR VGND sg13g2_nor2b_1
X_34442_ _10681_ \memory_i.i2c_master.index[2]\ VPWR VGND sg13g2_inv_1
X_34443_ _10682_ _10681_ _13117_ VPWR VGND sg13g2_nand2_1
X_34444_ _10683_ _10682_ VPWR VGND sg13g2_buf_1
X_34445_ _10684_ _13124_ _10682_ VPWR VGND sg13g2_nor2_1
X_34446_ _10685_ \memory_i.i2c_master.frame_index[1]\ _10684_ VPWR VGND sg13g2_xnor2_1
X_34447_ _10686_ _10676_ _10685_ VPWR VGND sg13g2_nand2_1
X_34448_ _10687_ _10686_ VPWR VGND sg13g2_inv_1
X_34449_ _10688_ _13414_ _10687_ VPWR VGND sg13g2_nand2_1
X_34450_ _10689_ _10688_ VPWR VGND sg13g2_buf_1
X_34451_ _10690_ _10683_ _10689_ VPWR VGND sg13g2_nor2_1
X_34452_ _10691_ \memory_i.i2c_master.sda_i_sync1\ _10690_ VPWR VGND sg13g2_nand2_1
X_34453_ _10692_ _10683_ _10689_ \memory_i.i2c_dataout[1]\ VPWR VGND sg13g2_o21ai_1
X_34454_ _01985_ _10691_ _10692_ _10674_ VPWR VGND sg13g2_a21oi_1
X_34455_ _10693_ \memory_i.i2c_master.index[0]\ \memory_i.i2c_master.index[1]\ VPWR VGND sg13g2_nor2b_1
X_34456_ _10694_ _10693_ VPWR VGND sg13g2_buf_1
X_34457_ _10695_ _10687_ _10694_ VPWR VGND sg13g2_nand2_1
X_34458_ _10696_ _10695_ VPWR VGND sg13g2_buf_1
X_34459_ _10697_ _10683_ _10696_ VPWR VGND sg13g2_nor2_1
X_34460_ _10698_ \memory_i.i2c_master.sda_i_sync1\ _10697_ VPWR VGND sg13g2_nand2_1
X_34461_ _10699_ _10683_ _10696_ \memory_i.i2c_dataout[2]\ VPWR VGND sg13g2_o21ai_1
X_34462_ _01986_ _10698_ _10699_ _10674_ VPWR VGND sg13g2_a21oi_1
X_34463_ _10700_ \memory_i.i2c_master.index[1]\ \memory_i.i2c_master.index[0]\ _10687_ VPWR VGND sg13g2_nand3_1
X_34464_ _10701_ _10700_ VPWR VGND sg13g2_buf_1
X_34465_ _10702_ _10683_ _10701_ VPWR VGND sg13g2_nor2_1
X_34466_ _10703_ \memory_i.i2c_master.sda_i_sync1\ _10702_ VPWR VGND sg13g2_nand2_1
X_34467_ _10704_ _10683_ _10701_ \memory_i.i2c_dataout[3]\ VPWR VGND sg13g2_o21ai_1
X_34468_ _01987_ _10703_ _10704_ _10674_ VPWR VGND sg13g2_a21oi_1
X_34469_ _10705_ \memory_i.i2c_master.index[2]\ _13117_ VPWR VGND sg13g2_nand2_1
X_34470_ _10706_ _10705_ VPWR VGND sg13g2_buf_1
X_34471_ _10707_ _13124_ _10686_ _10706_ VPWR VGND sg13g2_nor3_1
X_34472_ _10708_ \memory_i.i2c_dataout[4]\ \memory_i.i2c_master.sda_i_sync1\ _10707_ VPWR VGND sg13g2_mux2_1
X_34473_ _01988_ _10674_ _10708_ VPWR VGND sg13g2_nor2b_1
X_34474_ _10709_ _10706_ VPWR VGND sg13g2_inv_1
X_34475_ _10710_ \memory_i.i2c_master.sda_i_sync1\ _13414_ _10687_ _10709_ VPWR
+ VGND
+ sg13g2_nand4_1
X_34476_ _10711_ _10689_ _10706_ \memory_i.i2c_dataout[5]\ VPWR VGND sg13g2_o21ai_1
X_34477_ _01989_ _10710_ _10711_ _10674_ VPWR VGND sg13g2_a21oi_1
X_34478_ _10712_ \memory_i.i2c_master.sda_i_sync1\ _10687_ _10694_ _10709_ VPWR
+ VGND
+ sg13g2_nand4_1
X_34479_ _10713_ _10696_ _10706_ \memory_i.i2c_dataout[6]\ VPWR VGND sg13g2_o21ai_1
X_34480_ _10714_ _10673_ VPWR VGND sg13g2_buf_1
X_34481_ _01990_ _10712_ _10713_ _10714_ VPWR VGND sg13g2_a21oi_1
X_34482_ _10715_ _10701_ _10706_ VPWR VGND sg13g2_nor2_1
X_34483_ _10716_ \memory_i.i2c_master.sda_i_sync1\ _10715_ VPWR VGND sg13g2_nand2_1
X_34484_ _10717_ _10701_ _10706_ \memory_i.i2c_dataout[7]\ VPWR VGND sg13g2_o21ai_1
X_34485_ _01991_ _10716_ _10717_ _10714_ VPWR VGND sg13g2_a21oi_1
X_34486_ _10718_ _10660_ _10678_ VPWR VGND sg13g2_nor2_1
X_34487_ _10719_ \memory_i.i2c_master.sda_i_sync1\ _10718_ VPWR VGND sg13g2_nand2_1
X_34488_ _10720_ _10660_ _10678_ \memory_i.i2c_dataout[8]\ VPWR VGND sg13g2_o21ai_1
X_34489_ _01992_ _10719_ _10720_ _10714_ VPWR VGND sg13g2_a21oi_1
X_34490_ _10721_ _10681_ \memory_i.i2c_master.frame_index[0]\ VPWR VGND sg13g2_nand2_1
X_34491_ _10722_ _10721_ VPWR VGND sg13g2_buf_1
X_34492_ _10723_ _10689_ _10722_ VPWR VGND sg13g2_nor2_1
X_34493_ _10724_ \memory_i.i2c_master.sda_i_sync1\ _10723_ VPWR VGND sg13g2_nand2_1
X_34494_ _10725_ _10689_ _10722_ \memory_i.i2c_dataout[9]\ VPWR VGND sg13g2_o21ai_1
X_34495_ _01993_ _10724_ _10725_ _10714_ VPWR VGND sg13g2_a21oi_1
X_34496_ _10726_ _10696_ _10722_ VPWR VGND sg13g2_nor2_1
X_34497_ _10727_ \memory_i.i2c_master.sda_i_sync1\ _10726_ VPWR VGND sg13g2_nand2_1
X_34498_ _10728_ _10696_ _10722_ \memory_i.i2c_dataout[10]\ VPWR VGND sg13g2_o21ai_1
X_34499_ _01994_ _10727_ _10728_ _10714_ VPWR VGND sg13g2_a21oi_1
X_34500_ _10729_ _10701_ _10722_ VPWR VGND sg13g2_nor2_1
X_34501_ _10730_ \memory_i.i2c_master.sda_i_sync1\ _10729_ VPWR VGND sg13g2_nand2_1
X_34502_ _10731_ _10701_ _10722_ \memory_i.i2c_dataout[11]\ VPWR VGND sg13g2_o21ai_1
X_34503_ _01995_ _10730_ _10731_ _10714_ VPWR VGND sg13g2_a21oi_1
X_34504_ _10732_ \memory_i.i2c_master.index[2]\ \memory_i.i2c_master.frame_index[0]\ VPWR VGND sg13g2_nand2_1
X_34505_ _10733_ _13124_ _10686_ _10732_ VPWR VGND sg13g2_nor3_1
X_34506_ _10734_ \memory_i.i2c_dataout[12]\ \memory_i.i2c_master.sda_i_sync1\ _10733_ VPWR VGND sg13g2_mux2_1
X_34507_ _01996_ _10674_ _10734_ VPWR VGND sg13g2_nor2b_1
X_34508_ _10735_ _10732_ VPWR VGND sg13g2_buf_1
X_34509_ _10736_ _10689_ _10735_ VPWR VGND sg13g2_nor2_1
X_34510_ _10737_ \memory_i.i2c_master.sda_i_sync1\ _10736_ VPWR VGND sg13g2_nand2_1
X_34511_ _10738_ _10689_ _10735_ \memory_i.i2c_dataout[13]\ VPWR VGND sg13g2_o21ai_1
X_34512_ _01997_ _10737_ _10738_ _10714_ VPWR VGND sg13g2_a21oi_1
X_34513_ _10739_ _10696_ _10735_ VPWR VGND sg13g2_nor2_1
X_34514_ _10740_ \memory_i.i2c_master.sda_i_sync1\ _10739_ VPWR VGND sg13g2_nand2_1
X_34515_ _10741_ _10696_ _10735_ \memory_i.i2c_dataout[14]\ VPWR VGND sg13g2_o21ai_1
X_34516_ _01998_ _10740_ _10741_ _10714_ VPWR VGND sg13g2_a21oi_1
X_34517_ _10742_ _10701_ _10735_ VPWR VGND sg13g2_nor2_1
X_34518_ _10743_ \memory_i.i2c_master.sda_i_sync1\ _10742_ VPWR VGND sg13g2_nand2_1
X_34519_ _10744_ _10701_ _10735_ \memory_i.i2c_dataout[15]\ VPWR VGND sg13g2_o21ai_1
X_34520_ _01999_ _10743_ _10744_ _10714_ VPWR VGND sg13g2_a21oi_1
X_34521_ _10745_ _10664_ _10678_ VPWR VGND sg13g2_nor2_1
X_34522_ _10746_ \memory_i.i2c_master.sda_i_sync1\ _10745_ VPWR VGND sg13g2_nand2_1
X_34523_ _10747_ _10664_ _10678_ \memory_i.i2c_dataout[16]\ VPWR VGND sg13g2_o21ai_1
X_34524_ _02000_ _10746_ _10747_ _10714_ VPWR VGND sg13g2_a21oi_1
X_34525_ _10748_ _10676_ VPWR VGND sg13g2_inv_1
X_34526_ _10749_ _10659_ _10748_ _10684_ VPWR VGND sg13g2_nor3_1
X_34527_ _10750_ _10749_ VPWR VGND sg13g2_buf_1
X_34528_ _10751_ _13414_ _10750_ VPWR VGND sg13g2_nand2_1
X_34529_ _10752_ _10751_ VPWR VGND sg13g2_buf_1
X_34530_ _10753_ _10683_ _10752_ VPWR VGND sg13g2_nor2_1
X_34531_ _10754_ \memory_i.i2c_master.sda_i_sync1\ _10753_ VPWR VGND sg13g2_nand2_1
X_34532_ _10755_ _10683_ _10752_ \memory_i.i2c_dataout[17]\ VPWR VGND sg13g2_o21ai_1
X_34533_ _10756_ _10673_ VPWR VGND sg13g2_buf_1
X_34534_ _02001_ _10754_ _10755_ _10756_ VPWR VGND sg13g2_a21oi_1
X_34535_ _10757_ _10694_ _10750_ VPWR VGND sg13g2_nand2_1
X_34536_ _10758_ _10757_ VPWR VGND sg13g2_buf_1
X_34537_ _10759_ _10682_ _10758_ VPWR VGND sg13g2_nor2_1
X_34538_ _10760_ \memory_i.i2c_master.sda_i_sync1\ _10759_ VPWR VGND sg13g2_nand2_1
X_34539_ _10761_ _10683_ _10758_ \memory_i.i2c_dataout[18]\ VPWR VGND sg13g2_o21ai_1
X_34540_ _02002_ _10760_ _10761_ _10756_ VPWR VGND sg13g2_a21oi_1
X_34541_ _10762_ \memory_i.i2c_master.index[1]\ \memory_i.i2c_master.index[0]\ _10750_ VPWR VGND sg13g2_nand3_1
X_34542_ _10763_ _10762_ VPWR VGND sg13g2_buf_1
X_34543_ _10764_ _10682_ _10763_ VPWR VGND sg13g2_nor2_1
X_34544_ _10765_ \memory_i.i2c_master.sda_i_sync1\ _10764_ VPWR VGND sg13g2_nand2_1
X_34545_ _10766_ _10683_ _10763_ \memory_i.i2c_dataout[19]\ VPWR VGND sg13g2_o21ai_1
X_34546_ _02003_ _10765_ _10766_ _10756_ VPWR VGND sg13g2_a21oi_1
X_34547_ _10767_ _13409_ _10709_ _10750_ VPWR VGND sg13g2_nand3_1
X_34548_ _10768_ \memory_i.i2c_master.sda_i_sync1\ \memory_i.i2c_dataout[20]\ _10767_ VPWR VGND sg13g2_mux2_1
X_34549_ _02004_ _10674_ _10768_ VPWR VGND sg13g2_nor2b_1
X_34550_ _10769_ \memory_i.i2c_master.sda_i_sync1\ _13414_ _10709_ _10750_ VPWR
+ VGND
+ sg13g2_nand4_1
X_34551_ _10770_ _10706_ _10752_ \memory_i.i2c_dataout[21]\ VPWR VGND sg13g2_o21ai_1
X_34552_ _02005_ _10769_ _10770_ _10756_ VPWR VGND sg13g2_a21oi_1
X_34553_ _10771_ \memory_i.i2c_master.sda_i_sync1\ _10694_ _10709_ _10750_ VPWR
+ VGND
+ sg13g2_nand4_1
X_34554_ _10772_ _10706_ _10758_ \memory_i.i2c_dataout[22]\ VPWR VGND sg13g2_o21ai_1
X_34555_ _02006_ _10771_ _10772_ _10756_ VPWR VGND sg13g2_a21oi_1
X_34556_ _10773_ _10706_ _10763_ VPWR VGND sg13g2_nor2_1
X_34557_ _10774_ \memory_i.i2c_master.sda_i_sync1\ _10773_ VPWR VGND sg13g2_nand2_1
X_34558_ _10775_ _10706_ _10763_ \memory_i.i2c_dataout[23]\ VPWR VGND sg13g2_o21ai_1
X_34559_ _02007_ _10774_ _10775_ _10756_ VPWR VGND sg13g2_a21oi_1
X_34560_ _10776_ _10668_ _10678_ VPWR VGND sg13g2_nor2_1
X_34561_ _10777_ \memory_i.i2c_dataout[24]\ \memory_i.i2c_master.sda_i_sync1\ _10776_ VPWR VGND sg13g2_mux2_1
X_34562_ _02008_ _10674_ _10777_ VPWR VGND sg13g2_nor2b_1
X_34563_ _10778_ _10722_ _10752_ VPWR VGND sg13g2_nor2_1
X_34564_ _10779_ \memory_i.i2c_master.sda_i_sync1\ _10778_ VPWR VGND sg13g2_nand2_1
X_34565_ _10780_ _10722_ _10752_ \memory_i.i2c_dataout[25]\ VPWR VGND sg13g2_o21ai_1
X_34566_ _02009_ _10779_ _10780_ _10756_ VPWR VGND sg13g2_a21oi_1
X_34567_ _10781_ _10721_ _10758_ VPWR VGND sg13g2_nor2_1
X_34568_ _10782_ \memory_i.i2c_master.sda_i_sync1\ _10781_ VPWR VGND sg13g2_nand2_1
X_34569_ _10783_ _10722_ _10758_ \memory_i.i2c_dataout[26]\ VPWR VGND sg13g2_o21ai_1
X_34570_ _02010_ _10782_ _10783_ _10756_ VPWR VGND sg13g2_a21oi_1
X_34571_ _10784_ _10721_ _10763_ VPWR VGND sg13g2_nor2_1
X_34572_ _10785_ \memory_i.i2c_master.sda_i_sync1\ _10784_ VPWR VGND sg13g2_nand2_1
X_34573_ _10786_ _10722_ _10763_ \memory_i.i2c_dataout[27]\ VPWR VGND sg13g2_o21ai_1
X_34574_ _02011_ _10785_ _10786_ _10756_ VPWR VGND sg13g2_a21oi_1
X_34575_ _10787_ \memory_i.i2c_master.index[2]\ \memory_i.i2c_master.frame_index[0]\ _13409_ _10750_ VPWR
+ VGND
+ sg13g2_nand4_1
X_34576_ _10788_ \memory_i.i2c_master.sda_i_sync1\ \memory_i.i2c_dataout[28]\ _10787_ VPWR VGND sg13g2_mux2_1
X_34577_ _02012_ _10674_ _10788_ VPWR VGND sg13g2_nor2b_1
X_34578_ _10789_ _10735_ _10752_ VPWR VGND sg13g2_nor2_1
X_34579_ _10790_ \memory_i.i2c_master.sda_i_sync1\ _10789_ VPWR VGND sg13g2_nand2_1
X_34580_ _10791_ _10735_ _10752_ \memory_i.i2c_dataout[29]\ VPWR VGND sg13g2_o21ai_1
X_34581_ _02013_ _10790_ _10791_ _10756_ VPWR VGND sg13g2_a21oi_1
X_34582_ _10792_ _10732_ _10758_ VPWR VGND sg13g2_nor2_1
X_34583_ _10793_ \memory_i.i2c_master.sda_i_sync1\ _10792_ VPWR VGND sg13g2_nand2_1
X_34584_ _10794_ _10735_ _10758_ \memory_i.i2c_dataout[30]\ VPWR VGND sg13g2_o21ai_1
X_34585_ _02014_ _10793_ _10794_ _10673_ VPWR VGND sg13g2_a21oi_1
X_34586_ _10795_ _10732_ _10763_ VPWR VGND sg13g2_nor2_1
X_34587_ _10796_ \memory_i.i2c_master.sda_i_sync1\ _10795_ VPWR VGND sg13g2_nand2_1
X_34588_ _10797_ _10735_ _10763_ \memory_i.i2c_dataout[31]\ VPWR VGND sg13g2_o21ai_1
X_34589_ _02015_ _10796_ _10797_ _10673_ VPWR VGND sg13g2_a21oi_1
X_34590_ _10798_ \memory_i.i2c_master.scl_ratio[12]\ VPWR VGND sg13g2_inv_1
X_34591_ _10799_ _10798_ \memory_i.i2c_master.scl_counter[12]\ VPWR VGND sg13g2_nand2_1
X_34592_ _10800_ \memory_i.i2c_master.scl_counter[12]\ \memory_i.i2c_master.scl_ratio[12]\ VPWR VGND sg13g2_nand2b_1
X_34593_ _10801_ \memory_i.i2c_master.scl_counter[8]\ VPWR VGND sg13g2_inv_1
X_34594_ _10802_ \memory_i.i2c_master.scl_ratio[13]\ \memory_i.i2c_master.scl_counter[13]\ VPWR VGND sg13g2_nor2b_1
X_34595_ _10803_ \memory_i.i2c_master.scl_ratio[8]\ _10801_ _10802_ VPWR VGND sg13g2_a21oi_1
X_34596_ _10804_ \memory_i.i2c_master.scl_ratio[8]\ VPWR VGND sg13g2_inv_1
X_34597_ _10805_ \memory_i.i2c_master.scl_ratio[9]\ VPWR VGND sg13g2_inv_1
X_34598_ _10806_ _10804_ \memory_i.i2c_master.scl_counter[8]\ \memory_i.i2c_master.scl_counter[9]\ _10805_ VPWR
+ VGND
+ sg13g2_a22oi_1
X_34599_ _10807_ _10799_ _10800_ _10803_ _10806_ VPWR
+ VGND
+ sg13g2_nand4_1
X_34600_ _10808_ \memory_i.i2c_master.scl_ratio[14]\ \memory_i.i2c_master.scl_counter[14]\ VPWR VGND sg13g2_xnor2_1
X_34601_ _10809_ \memory_i.i2c_master.scl_counter[13]\ \memory_i.i2c_master.scl_ratio[13]\ VPWR VGND sg13g2_nand2b_1
X_34602_ _10810_ \memory_i.i2c_master.scl_ratio[15]\ \memory_i.i2c_master.scl_counter[15]\ VPWR VGND sg13g2_xnor2_1
X_34603_ _10811_ _10808_ _10809_ _10810_ VPWR VGND sg13g2_nand3_1
X_34604_ _10812_ \memory_i.i2c_master.scl_ratio[10]\ \memory_i.i2c_master.scl_counter[10]\ VPWR VGND sg13g2_nand2b_1
X_34605_ _10813_ \memory_i.i2c_master.scl_counter[10]\ \memory_i.i2c_master.scl_ratio[10]\ VPWR VGND sg13g2_nand2b_1
X_34606_ _10814_ \memory_i.i2c_master.scl_counter[9]\ \memory_i.i2c_master.scl_ratio[9]\ VPWR VGND sg13g2_nand2b_1
X_34607_ _10815_ \memory_i.i2c_master.scl_ratio[11]\ \memory_i.i2c_master.scl_counter[11]\ VPWR VGND sg13g2_xnor2_1
X_34608_ _10816_ _10812_ _10813_ _10814_ _10815_ VPWR
+ VGND
+ sg13g2_nand4_1
X_34609_ _10817_ _10811_ _10816_ VPWR VGND sg13g2_or2_1
X_34610_ _10818_ \memory_i.i2c_master.scl_counter[5]\ \memory_i.i2c_master.scl_ratio[5]\ VPWR VGND sg13g2_nand2b_1
X_34611_ _10819_ \memory_i.i2c_master.scl_counter[4]\ VPWR VGND sg13g2_inv_1
X_34612_ _10820_ \memory_i.i2c_master.scl_ratio[4]\ _10819_ VPWR VGND sg13g2_nand2_1
X_34613_ _10821_ \memory_i.i2c_master.scl_ratio[6]\ \memory_i.i2c_master.scl_counter[6]\ VPWR VGND sg13g2_xnor2_1
X_34614_ _10822_ \memory_i.i2c_master.scl_ratio[5]\ \memory_i.i2c_master.scl_counter[5]\ VPWR VGND sg13g2_nand2b_1
X_34615_ _10823_ \memory_i.i2c_master.scl_ratio[4]\ _10819_ _10822_ VPWR VGND sg13g2_o21ai_1
X_34616_ _10824_ \memory_i.i2c_master.scl_ratio[7]\ \memory_i.i2c_master.scl_counter[7]\ VPWR VGND sg13g2_xor2_1
X_34617_ _10825_ _10823_ _10824_ VPWR VGND sg13g2_nor2_1
X_34618_ _10826_ _10818_ _10820_ _10821_ _10825_ VPWR
+ VGND
+ sg13g2_nand4_1
X_34619_ _10827_ \memory_i.i2c_master.scl_ratio[3]\ \memory_i.i2c_master.scl_counter[3]\ VPWR VGND sg13g2_xnor2_1
X_34620_ _10828_ \memory_i.i2c_master.scl_ratio[0]\ \memory_i.i2c_master.scl_counter[0]\ VPWR VGND sg13g2_xnor2_1
X_34621_ _10829_ \memory_i.i2c_master.scl_ratio[2]\ \memory_i.i2c_master.scl_counter[2]\ VPWR VGND sg13g2_xnor2_1
X_34622_ _10830_ \memory_i.i2c_master.scl_ratio[1]\ \memory_i.i2c_master.scl_counter[1]\ VPWR VGND sg13g2_xnor2_1
X_34623_ _10831_ _10827_ _10828_ _10829_ _10830_ VPWR
+ VGND
+ sg13g2_nand4_1
X_34624_ _10832_ _10807_ _10817_ _10826_ _10831_ VPWR
+ VGND
+ sg13g2_nor4_1
X_34625_ _10833_ scl _10832_ VPWR VGND sg13g2_xnor2_1
X_34626_ _02016_ _13085_ _10833_ VPWR VGND sg13g2_nand2b_1
X_34627_ _10834_ \memory_i.i2c_master.state[1]\ \memory_i.i2c_master.state[5]\ VPWR VGND sg13g2_nor2_1
X_34628_ _10835_ \memory_i.i2c_master.state[3]\ _13126_ VPWR VGND sg13g2_nand2_1
X_34629_ _10836_ \memory_i.i2c_master.state[3]\ _10834_ _10835_ VPWR VGND sg13g2_o21ai_1
X_34630_ _10837_ _13115_ _13136_ _10836_ VPWR VGND sg13g2_nand3_1
X_34631_ _10838_ _10837_ VPWR VGND sg13g2_buf_1
X_34632_ _10839_ _02389_ \memory_i.i2c_mask[1]\ \memory_i.i2c_mask[3]\ VPWR VGND sg13g2_a21oi_1
X_34633_ _10840_ \memory_i.i2c_master.frame_index[0]\ \memory_i.i2c_mask[2]\ _02386_ \memory_i.i2c_mask[0]\ VPWR
+ VGND
+ sg13g2_a22oi_1
X_34634_ _10841_ _10840_ \memory_i.i2c_master.frame_index[1]\ VPWR VGND sg13g2_nand2b_1
X_34635_ _10842_ _10659_ \memory_i.i2c_master.frame_index[0]\ \memory_i.i2c_mask[0]\ VPWR VGND sg13g2_nand3_1
X_34636_ _10843_ _13111_ _10841_ _10842_ VPWR VGND sg13g2_nand3_1
X_34637_ _10844_ _13111_ _10839_ _10843_ VPWR VGND sg13g2_o21ai_1
X_34638_ _10845_ _13117_ _10838_ VPWR VGND sg13g2_nand2_1
X_34639_ _10846_ _10838_ _10844_ _10845_ VPWR VGND sg13g2_o21ai_1
X_34640_ _02017_ reset _10846_ VPWR VGND sg13g2_nand2_1
X_34641_ _10847_ \memory_i.i2c_mask[1]\ \memory_i.i2c_mask[0]\ VPWR VGND sg13g2_nor2_1
X_34642_ _10848_ \memory_i.i2c_master.frame_index[0]\ \memory_i.i2c_mask[0]\ \memory_i.i2c_master.frame_index[1]\ VPWR VGND sg13g2_a21oi_1
X_34643_ _10849_ _10834_ _10847_ _10848_ VPWR VGND sg13g2_or3_1
X_34644_ _10850_ \memory_i.i2c_mask[3]\ _13111_ _10849_ VPWR VGND sg13g2_o21ai_1
X_34645_ _10851_ _10847_ _10664_ _10842_ VPWR VGND sg13g2_o21ai_1
X_34646_ _10852_ _02389_ _10850_ _10851_ _13111_ _10838_
+ VPWR
+ VGND sg13g2_a221oi_1
X_34647_ _10853_ \memory_i.i2c_master.frame_index[1]\ _10838_ VPWR VGND sg13g2_nand2_1
X_34648_ _02018_ _10852_ reset _10853_ VPWR VGND sg13g2_nand3b_1
X_34649_ _10854_ \memory_i.i2c_master.state[6]\ _13109_ _13115_ VPWR VGND sg13g2_o21ai_1
X_34650_ _10855_ \memory_i.i2c_master.state[3]\ \memory_i.i2c_master.state[8]\ \memory_i.i2c_master.state[10]\ VPWR VGND sg13g2_nor3_1
X_34651_ _10856_ \memory_i.i2c_master.index[0]\ _10855_ VPWR VGND sg13g2_nor2_1
X_34652_ _10857_ \memory_i.i2c_master.index[0]\ _10854_ _10856_ _13116_ VPWR
+ VGND
+ sg13g2_a22oi_1
X_34653_ _02019_ _13086_ _10857_ VPWR VGND sg13g2_nor2_1
X_34654_ _10858_ _13116_ _10694_ _13414_ VPWR VGND sg13g2_a21oi_1
X_34655_ _10859_ \memory_i.i2c_master.index[1]\ _10854_ VPWR VGND sg13g2_nand2b_1
X_34656_ _10860_ _10855_ _10858_ _10859_ VPWR VGND sg13g2_o21ai_1
X_34657_ _02020_ _13085_ _10860_ VPWR VGND sg13g2_nand2b_1
X_34658_ _10861_ \memory_i.i2c_master.index[2]\ _13115_ _13409_ VPWR VGND sg13g2_nand3_1
X_34659_ _10862_ \memory_i.i2c_master.index[2]\ _13409_ _10861_ VPWR VGND sg13g2_o21ai_1
X_34660_ _10863_ _10681_ _10854_ _10862_ _13109_ VPWR
+ VGND
+ sg13g2_a22oi_1
X_34661_ _02021_ _13085_ _10863_ VPWR VGND sg13g2_or2_1
X_34662_ _10864_ _02408_ \memory_i.i2c_master.scl_counter[3]\ VPWR VGND sg13g2_nand2_1
X_34663_ _10865_ \memory_i.i2c_master.scl_counter[0]\ \memory_i.i2c_master.scl_ratio[0]\ VPWR VGND sg13g2_nand2b_1
X_34664_ _10866_ \memory_i.i2c_master.scl_counter[1]\ _10865_ VPWR VGND sg13g2_nand2_1
X_34665_ _10867_ \memory_i.i2c_master.scl_counter[1]\ _10865_ VPWR VGND sg13g2_nor2_1
X_34666_ _10868_ \memory_i.i2c_master.scl_ratio[1]\ _10866_ _10867_ VPWR VGND sg13g2_a21oi_1
X_34667_ _10869_ \memory_i.i2c_master.scl_counter[2]\ _10868_ VPWR VGND sg13g2_nor2_1
X_34668_ _10870_ \memory_i.i2c_master.scl_counter[2]\ _10868_ VPWR VGND sg13g2_nand2_1
X_34669_ _10871_ \memory_i.i2c_master.scl_ratio[2]\ _10869_ _10870_ VPWR VGND sg13g2_o21ai_1
X_34670_ _10872_ _02408_ \memory_i.i2c_master.scl_counter[3]\ _10871_ VPWR VGND sg13g2_o21ai_1
X_34671_ _10873_ _10864_ _10872_ _10826_ VPWR VGND sg13g2_a21oi_1
X_34672_ _10874_ \memory_i.i2c_master.scl_counter[6]\ _10823_ _10818_ VPWR VGND sg13g2_nand3_1
X_34673_ _10875_ _10823_ _10818_ \memory_i.i2c_master.scl_counter[6]\ VPWR VGND sg13g2_a21oi_1
X_34674_ _10876_ \memory_i.i2c_master.scl_ratio[6]\ _10874_ _10875_ VPWR VGND sg13g2_a21oi_1
X_34675_ _10877_ \memory_i.i2c_master.scl_counter[7]\ _10876_ VPWR VGND sg13g2_nand2_1
X_34676_ _10878_ \memory_i.i2c_master.scl_counter[7]\ _10876_ VPWR VGND sg13g2_nor2_1
X_34677_ _10879_ \memory_i.i2c_master.scl_ratio[7]\ _10877_ _10878_ VPWR VGND sg13g2_a21oi_1
X_34678_ _10880_ _10807_ _10817_ VPWR VGND sg13g2_nor2_1
X_34679_ _10881_ _10873_ _10879_ _10880_ VPWR VGND sg13g2_o21ai_1
X_34680_ _10882_ \memory_i.i2c_master.scl_ratio[14]\ \memory_i.i2c_master.scl_counter[14]\ VPWR VGND sg13g2_nor2b_1
X_34681_ _10883_ \memory_i.i2c_master.scl_counter[15]\ _10882_ _13085_ VPWR VGND sg13g2_a21oi_1
X_34682_ _10884_ \memory_i.i2c_master.scl_ratio[15]\ VPWR VGND sg13g2_inv_1
X_34683_ _10885_ \memory_i.i2c_master.scl_counter[15]\ _10882_ _10884_ VPWR VGND sg13g2_o21ai_1
X_34684_ _10886_ \memory_i.i2c_master.scl_counter[11]\ _10812_ VPWR VGND sg13g2_nand2b_1
X_34685_ _10887_ \memory_i.i2c_master.scl_counter[10]\ \memory_i.i2c_master.scl_counter[11]\ VPWR VGND sg13g2_nand2_1
X_34686_ _10888_ \memory_i.i2c_master.scl_ratio[10]\ _10887_ \memory_i.i2c_master.scl_ratio[11]\ VPWR VGND sg13g2_o21ai_1
X_34687_ _10889_ _10798_ \memory_i.i2c_master.scl_counter[12]\ _10886_ _10888_ VPWR
+ VGND
+ sg13g2_a22oi_1
X_34688_ _10890_ _10806_ _10816_ _10889_ VPWR VGND sg13g2_o21ai_1
X_34689_ _10891_ _10800_ _10890_ _10802_ VPWR VGND sg13g2_a21oi_1
X_34690_ _10892_ _10811_ _10891_ VPWR VGND sg13g2_or2_1
X_34691_ _10893_ _10881_ _10883_ _10885_ _10892_ VPWR
+ VGND
+ sg13g2_nand4_1
X_34692_ _10894_ _10893_ VPWR VGND sg13g2_buf_1
X_34693_ _02022_ \memory_i.i2c_master.scl_counter[0]\ _10894_ VPWR VGND sg13g2_nor2_1
X_34694_ _10895_ _10894_ VPWR VGND sg13g2_buf_1
X_34695_ _10896_ \memory_i.i2c_master.scl_counter[1]\ \memory_i.i2c_master.scl_counter[0]\ VPWR VGND sg13g2_xnor2_1
X_34696_ _02023_ _10895_ _10896_ VPWR VGND sg13g2_nor2_1
X_34697_ _10897_ \memory_i.i2c_master.scl_counter[1]\ \memory_i.i2c_master.scl_counter[0]\ VPWR VGND sg13g2_nand2_1
X_34698_ _10898_ \memory_i.i2c_master.scl_counter[2]\ _10897_ VPWR VGND sg13g2_xor2_1
X_34699_ _02024_ _10895_ _10898_ VPWR VGND sg13g2_nor2_1
X_34700_ _10899_ \memory_i.i2c_master.scl_counter[3]\ VPWR VGND sg13g2_inv_1
X_34701_ _10900_ \memory_i.i2c_master.scl_counter[1]\ \memory_i.i2c_master.scl_counter[0]\ \memory_i.i2c_master.scl_counter[2]\ VPWR VGND sg13g2_nand3_1
X_34702_ _10901_ _10899_ _10900_ VPWR VGND sg13g2_xnor2_1
X_34703_ _02025_ _10895_ _10901_ VPWR VGND sg13g2_nor2_1
X_34704_ _10902_ _10899_ _10900_ VPWR VGND sg13g2_nor2_1
X_34705_ _10903_ \memory_i.i2c_master.scl_counter[4]\ _10902_ VPWR VGND sg13g2_xnor2_1
X_34706_ _02026_ _10895_ _10903_ VPWR VGND sg13g2_nor2_1
X_34707_ _10904_ \memory_i.i2c_master.scl_counter[4]\ _10902_ VPWR VGND sg13g2_nand2_1
X_34708_ _10905_ \memory_i.i2c_master.scl_counter[5]\ _10904_ VPWR VGND sg13g2_xor2_1
X_34709_ _02027_ _10895_ _10905_ VPWR VGND sg13g2_nor2_1
X_34710_ _10906_ \memory_i.i2c_master.scl_counter[4]\ \memory_i.i2c_master.scl_counter[5]\ _10902_ VPWR VGND sg13g2_nand3_1
X_34711_ _10907_ \memory_i.i2c_master.scl_counter[6]\ _10906_ VPWR VGND sg13g2_xor2_1
X_34712_ _02028_ _10895_ _10907_ VPWR VGND sg13g2_nor2_1
X_34713_ _10908_ \memory_i.i2c_master.scl_counter[7]\ VPWR VGND sg13g2_inv_1
X_34714_ _10909_ \memory_i.i2c_master.scl_counter[4]\ \memory_i.i2c_master.scl_counter[5]\ \memory_i.i2c_master.scl_counter[6]\ _10902_ VPWR
+ VGND
+ sg13g2_nand4_1
X_34715_ _10910_ _10908_ _10909_ VPWR VGND sg13g2_xnor2_1
X_34716_ _02029_ _10895_ _10910_ VPWR VGND sg13g2_nor2_1
X_34717_ _10911_ _10908_ _10909_ VPWR VGND sg13g2_nor2_1
X_34718_ _10912_ \memory_i.i2c_master.scl_counter[8]\ _10911_ VPWR VGND sg13g2_xnor2_1
X_34719_ _02030_ _10895_ _10912_ VPWR VGND sg13g2_nor2_1
X_34720_ _10913_ \memory_i.i2c_master.scl_counter[8]\ _10911_ VPWR VGND sg13g2_nand2_1
X_34721_ _10914_ \memory_i.i2c_master.scl_counter[9]\ _10913_ VPWR VGND sg13g2_xor2_1
X_34722_ _02031_ _10895_ _10914_ VPWR VGND sg13g2_nor2_1
X_34723_ _10915_ \memory_i.i2c_master.scl_counter[8]\ \memory_i.i2c_master.scl_counter[9]\ _10911_ VPWR VGND sg13g2_nand3_1
X_34724_ _10916_ \memory_i.i2c_master.scl_counter[10]\ _10915_ VPWR VGND sg13g2_xor2_1
X_34725_ _02032_ _10895_ _10916_ VPWR VGND sg13g2_nor2_1
X_34726_ _10917_ \memory_i.i2c_master.scl_counter[8]\ \memory_i.i2c_master.scl_counter[9]\ \memory_i.i2c_master.scl_counter[10]\ _10911_ VPWR
+ VGND
+ sg13g2_nand4_1
X_34727_ _10918_ \memory_i.i2c_master.scl_counter[11]\ _10917_ VPWR VGND sg13g2_xor2_1
X_34728_ _02033_ _10894_ _10918_ VPWR VGND sg13g2_nor2_1
X_34729_ _10919_ _10887_ _10915_ VPWR VGND sg13g2_nor2_1
X_34730_ _10920_ \memory_i.i2c_master.scl_counter[12]\ _10919_ VPWR VGND sg13g2_xnor2_1
X_34731_ _02034_ _10894_ _10920_ VPWR VGND sg13g2_nor2_1
X_34732_ _10921_ \memory_i.i2c_master.scl_counter[12]\ _10919_ VPWR VGND sg13g2_nand2_1
X_34733_ _10922_ \memory_i.i2c_master.scl_counter[13]\ _10921_ VPWR VGND sg13g2_xor2_1
X_34734_ _02035_ _10894_ _10922_ VPWR VGND sg13g2_nor2_1
X_34735_ _10923_ \memory_i.i2c_master.scl_counter[12]\ \memory_i.i2c_master.scl_counter[13]\ _10919_ VPWR VGND sg13g2_nand3_1
X_34736_ _10924_ \memory_i.i2c_master.scl_counter[14]\ _10923_ VPWR VGND sg13g2_xor2_1
X_34737_ _02036_ _10894_ _10924_ VPWR VGND sg13g2_nor2_1
X_34738_ _10925_ \memory_i.i2c_master.scl_counter[15]\ VPWR VGND sg13g2_inv_1
X_34739_ _10926_ \memory_i.i2c_master.scl_counter[12]\ \memory_i.i2c_master.scl_counter[13]\ \memory_i.i2c_master.scl_counter[14]\ _10919_ VPWR
+ VGND
+ sg13g2_nand4_1
X_34740_ _02037_ _10925_ _10926_ _10894_ VPWR VGND sg13g2_a21oi_1
X_34741_ _10927_ \memory_i.sram_master.state[2]\ \memory_i.sram_master.state[5]\ VPWR VGND sg13g2_nor2_1
X_34742_ _10928_ \memory_i.addr_reg[0]\ \memory_i.addr_reg[2]\ \memory_i.addr_reg[1]\ \memory_i.addr_reg[3]\ \memory_i.sram_master.index[1]\
+ \memory_i.sram_master.index[0]\
+ VPWR VGND sg13g2_mux4_1
X_34743_ _10929_ \memory_i.addr_reg[4]\ \memory_i.addr_reg[6]\ \memory_i.addr_reg[5]\ \memory_i.addr_reg[7]\ \memory_i.sram_master.index[1]\
+ \memory_i.sram_master.index[0]\
+ VPWR VGND sg13g2_mux4_1
X_34744_ _10930_ \memory_i.datain_reg[0]\ \memory_i.datain_reg[1]\ \memory_i.datain_reg[2]\ \memory_i.datain_reg[3]\ \memory_i.sram_master.index[0]\
+ \memory_i.sram_master.index[1]\
+ VPWR VGND sg13g2_mux4_1
X_34745_ _10931_ \memory_i.datain_reg[4]\ \memory_i.datain_reg[5]\ \memory_i.datain_reg[6]\ \memory_i.datain_reg[7]\ \memory_i.sram_master.index[0]\
+ \memory_i.sram_master.index[1]\
+ VPWR VGND sg13g2_mux4_1
X_34746_ _10932_ _10928_ _10929_ _10930_ _10931_ \memory_i.sram_master.index[2]\
+ \memory_i.sram_master.state[5]\
+ VPWR VGND sg13g2_mux4_1
X_34747_ _10933_ \memory_i.addr_reg[8]\ \memory_i.addr_reg[10]\ \memory_i.addr_reg[9]\ \memory_i.addr_reg[11]\ \memory_i.sram_master.index[1]\
+ \memory_i.sram_master.index[0]\
+ VPWR VGND sg13g2_mux4_1
X_34748_ _10934_ \memory_i.addr_reg[12]\ \memory_i.addr_reg[14]\ \memory_i.addr_reg[13]\ \memory_i.addr_reg[15]\ \memory_i.sram_master.index[1]\
+ \memory_i.sram_master.index[0]\
+ VPWR VGND sg13g2_mux4_1
X_34749_ _10935_ \memory_i.datain_reg[8]\ \memory_i.datain_reg[9]\ \memory_i.datain_reg[10]\ \memory_i.datain_reg[11]\ \memory_i.sram_master.index[0]\
+ \memory_i.sram_master.index[1]\
+ VPWR VGND sg13g2_mux4_1
X_34750_ _10936_ \memory_i.datain_reg[12]\ \memory_i.datain_reg[13]\ \memory_i.datain_reg[14]\ \memory_i.datain_reg[15]\ \memory_i.sram_master.index[0]\
+ \memory_i.sram_master.index[1]\
+ VPWR VGND sg13g2_mux4_1
X_34751_ _10937_ _10933_ _10934_ _10935_ _10936_ \memory_i.sram_master.index[2]\
+ \memory_i.sram_master.state[5]\
+ VPWR VGND sg13g2_mux4_1
X_34752_ _10938_ \memory_i.addr_reg[16]\ \memory_i.addr_reg[18]\ \memory_i.addr_reg[17]\ \memory_i.addr_reg[19]\ \memory_i.sram_master.index[1]\
+ \memory_i.sram_master.index[0]\
+ VPWR VGND sg13g2_mux4_1
X_34753_ _10939_ \memory_i.addr_reg[20]\ \memory_i.addr_reg[22]\ \memory_i.addr_reg[21]\ \memory_i.addr_reg[23]\ \memory_i.sram_master.index[1]\
+ \memory_i.sram_master.index[0]\
+ VPWR VGND sg13g2_mux4_1
X_34754_ _10940_ \memory_i.datain_reg[16]\ \memory_i.datain_reg[17]\ \memory_i.datain_reg[18]\ \memory_i.datain_reg[19]\ \memory_i.sram_master.index[0]\
+ \memory_i.sram_master.index[1]\
+ VPWR VGND sg13g2_mux4_1
X_34755_ _10941_ \memory_i.datain_reg[20]\ \memory_i.datain_reg[21]\ \memory_i.datain_reg[22]\ \memory_i.datain_reg[23]\ \memory_i.sram_master.index[0]\
+ \memory_i.sram_master.index[1]\
+ VPWR VGND sg13g2_mux4_1
X_34756_ _10942_ _10938_ _10939_ _10940_ _10941_ \memory_i.sram_master.index[2]\
+ \memory_i.sram_master.state[5]\
+ VPWR VGND sg13g2_mux4_1
X_34757_ _10943_ \memory_i.datain_reg[24]\ \memory_i.datain_reg[25]\ \memory_i.datain_reg[26]\ \memory_i.datain_reg[27]\ \memory_i.sram_master.index[0]\
+ \memory_i.sram_master.index[1]\
+ VPWR VGND sg13g2_mux4_1
X_34758_ _10944_ \memory_i.datain_reg[28]\ \memory_i.datain_reg[30]\ \memory_i.datain_reg[29]\ \memory_i.datain_reg[31]\ \memory_i.sram_master.index[1]\
+ \memory_i.sram_master.index[0]\
+ VPWR VGND sg13g2_mux4_1
X_34759_ _10945_ _10943_ _10944_ \memory_i.sram_master.index[2]\ VPWR VGND sg13g2_mux2_1
X_34760_ _10946_ \memory_i.sram_master.state[5]\ _10945_ VPWR VGND sg13g2_and2_1
X_34761_ _10947_ _10932_ _10937_ _10942_ _10946_ \memory_i.sram_master.index[3]\
+ \memory_i.sram_master.index[4]\
+ VPWR VGND sg13g2_mux4_1
X_34762_ _10948_ \memory_i.sram_master.index[2]\ \memory_i.sram_master.index[1]\ VPWR VGND sg13g2_nor2_1
X_34763_ _10949_ _13046_ \memory_i.sram_master.index[0]\ _10948_ VPWR VGND sg13g2_o21ai_1
X_34764_ _10950_ \memory_i.sram_master.state[4]\ _10927_ _10949_ VPWR VGND sg13g2_nand3_1
X_34765_ _10951_ _10927_ _10947_ _10950_ VPWR VGND sg13g2_o21ai_1
X_34766_ _10952_ \memory_i.sram_master.state[4]\ _10927_ VPWR VGND sg13g2_nand2b_1
X_34767_ _10953_ _13082_ _10952_ si VPWR VGND sg13g2_a21o_1
X_34768_ _10954_ \memory_i.target[0]\ _12952_ _10953_ VPWR VGND sg13g2_nand3_1
X_34769_ _02038_ _13082_ _10951_ _10954_ VPWR VGND sg13g2_a21oi_1
X_34770_ _10955_ sclk VPWR VGND sg13g2_inv_1
X_34771_ _02039_ _10955_ \memory_i.sram_master.negedge_trigger\ _13057_ VPWR VGND sg13g2_o21ai_1
X_34772_ _10956_ \memory_i.sram_master.state[0]\ _13082_ VPWR VGND sg13g2_nand2_1
X_34773_ _10957_ sram_ce VPWR VGND sg13g2_inv_1
X_34774_ _02040_ \memory_i.sram_master.state[3]\ _13082_ _10956_ _10957_ _13060_
+ VPWR
+ VGND sg13g2_a221oi_1
X_34775_ _10958_ \memory_i.sram_master.state[1]\ _13082_ VPWR VGND sg13g2_nand2_1
X_34776_ _10959_ _10958_ VPWR VGND sg13g2_buf_1
X_34777_ _10960_ _13052_ _10959_ VPWR VGND sg13g2_nor2_1
X_34778_ _10961_ so _10960_ VPWR VGND sg13g2_nand2_1
X_34779_ _10962_ _13052_ _10959_ \memory_i.sram_dataout[0]\ VPWR VGND sg13g2_o21ai_1
X_34780_ _02041_ _10961_ _10962_ _02721_ VPWR VGND sg13g2_a21oi_1
X_34781_ _10963_ _13048_ so VPWR VGND sg13g2_nor2b_1
X_34782_ _10964_ \memory_i.sram_master.index[1]\ \memory_i.sram_master.index[0]\ VPWR VGND sg13g2_nor2b_1
X_34783_ _10965_ _10964_ VPWR VGND sg13g2_buf_1
X_34784_ _10966_ \memory_i.sram_master.index[4]\ _13050_ VPWR VGND sg13g2_xnor2_1
X_34785_ _10967_ _10959_ _10966_ VPWR VGND sg13g2_nor2b_1
X_34786_ _10968_ _10967_ VPWR VGND sg13g2_buf_1
X_34787_ _10969_ \memory_i.sram_master.index[3]\ \memory_i.sram_master.index[2]\ VPWR VGND sg13g2_nor2_1
X_34788_ _10970_ _10969_ VPWR VGND sg13g2_buf_1
X_34789_ _10971_ _10965_ _10968_ _10970_ VPWR VGND sg13g2_nand3_1
X_34790_ _10972_ _10963_ \memory_i.sram_dataout[1]\ _10971_ VPWR VGND sg13g2_mux2_1
X_34791_ _02042_ reset _10972_ VPWR VGND sg13g2_and2_1
X_34792_ _10973_ _10959_ _10966_ VPWR VGND sg13g2_nand2b_1
X_34793_ _10974_ \memory_i.sram_master.index[0]\ \memory_i.sram_master.index[1]\ VPWR VGND sg13g2_nand2b_1
X_34794_ _10975_ _10973_ _10974_ VPWR VGND sg13g2_nor2_1
X_34795_ _10976_ _10975_ VPWR VGND sg13g2_buf_1
X_34796_ _10977_ so _10970_ _10976_ VPWR VGND sg13g2_nand3_1
X_34797_ _10978_ _10970_ _10976_ VPWR VGND sg13g2_nand2_1
X_34798_ _10979_ \memory_i.sram_dataout[2]\ _10978_ VPWR VGND sg13g2_nand2_1
X_34799_ _02043_ _10977_ _10979_ _02721_ VPWR VGND sg13g2_a21oi_1
X_34800_ _10980_ so _13052_ VPWR VGND sg13g2_and2_1
X_34801_ _10981_ _10980_ VPWR VGND sg13g2_buf_1
X_34802_ _10982_ \memory_i.sram_master.index[1]\ \memory_i.sram_master.index[0]\ _10968_ _10970_ VPWR
+ VGND
+ sg13g2_nand4_1
X_34803_ _10983_ _10981_ \memory_i.sram_dataout[3]\ _10982_ VPWR VGND sg13g2_mux2_1
X_34804_ _02044_ reset _10983_ VPWR VGND sg13g2_and2_1
X_34805_ _10984_ \memory_i.sram_master.index[1]\ \memory_i.sram_master.index[0]\ VPWR VGND sg13g2_nor2_1
X_34806_ _10985_ _10984_ VPWR VGND sg13g2_buf_1
X_34807_ _10986_ \memory_i.sram_master.index[3]\ \memory_i.sram_master.index[2]\ VPWR VGND sg13g2_nor2b_1
X_34808_ _10987_ _10986_ VPWR VGND sg13g2_buf_1
X_34809_ _10988_ _10968_ _10987_ VPWR VGND sg13g2_and2_1
X_34810_ _10989_ _10988_ VPWR VGND sg13g2_buf_1
X_34811_ _10990_ so _10985_ _10989_ VPWR VGND sg13g2_nand3_1
X_34812_ _10991_ _10985_ _10989_ VPWR VGND sg13g2_nand2_1
X_34813_ _10992_ \memory_i.sram_dataout[4]\ _10991_ VPWR VGND sg13g2_nand2_1
X_34814_ _02045_ _10990_ _10992_ _02721_ VPWR VGND sg13g2_a21oi_1
X_34815_ _10993_ _10965_ _10981_ _10989_ VPWR VGND sg13g2_nand3_1
X_34816_ _10994_ _10965_ _10989_ VPWR VGND sg13g2_nand2_1
X_34817_ _10995_ \memory_i.sram_dataout[5]\ _10994_ VPWR VGND sg13g2_nand2_1
X_34818_ _02046_ _10993_ _10995_ _02721_ VPWR VGND sg13g2_a21oi_1
X_34819_ _10996_ so _10976_ _10987_ VPWR VGND sg13g2_nand3_1
X_34820_ _10997_ _10976_ _10987_ VPWR VGND sg13g2_nand2_1
X_34821_ _10998_ \memory_i.sram_dataout[6]\ _10997_ VPWR VGND sg13g2_nand2_1
X_34822_ _02047_ _10996_ _10998_ _02721_ VPWR VGND sg13g2_a21oi_1
X_34823_ _10999_ \memory_i.sram_master.index[1]\ \memory_i.sram_master.index[0]\ VPWR VGND sg13g2_nand2_1
X_34824_ _11000_ _10999_ _10989_ VPWR VGND sg13g2_nor2b_1
X_34825_ _11001_ \memory_i.sram_dataout[7]\ _10981_ _11000_ VPWR VGND sg13g2_mux2_1
X_34826_ _02048_ reset _11001_ VPWR VGND sg13g2_and2_1
X_34827_ _11002_ \memory_i.sram_master.index[3]\ so _13048_ _10968_ VPWR
+ VGND
+ sg13g2_nand4_1
X_34828_ _11003_ \memory_i.sram_master.index[3]\ _13048_ VPWR VGND sg13g2_nand2_1
X_34829_ _11004_ \memory_i.sram_master.index[4]\ _10959_ VPWR VGND sg13g2_or2_1
X_34830_ _11005_ _11004_ VPWR VGND sg13g2_buf_1
X_34831_ _11006_ _11003_ _11005_ \memory_i.sram_dataout[8]\ VPWR VGND sg13g2_o21ai_1
X_34832_ _02049_ _11002_ _11006_ _02721_ VPWR VGND sg13g2_a21oi_1
X_34833_ _11007_ \memory_i.sram_master.index[2]\ \memory_i.sram_master.index[3]\ VPWR VGND sg13g2_nor2b_1
X_34834_ _11008_ _11007_ VPWR VGND sg13g2_buf_1
X_34835_ _11009_ _10965_ _11008_ VPWR VGND sg13g2_nand2_1
X_34836_ _11010_ _10973_ _11009_ VPWR VGND sg13g2_or2_1
X_34837_ _11011_ _10963_ \memory_i.sram_dataout[9]\ _11010_ VPWR VGND sg13g2_mux2_1
X_34838_ _02050_ reset _11011_ VPWR VGND sg13g2_and2_1
X_34839_ _11012_ so _10976_ _11008_ VPWR VGND sg13g2_nand3_1
X_34840_ _11013_ _10976_ _11008_ VPWR VGND sg13g2_nand2_1
X_34841_ _11014_ \memory_i.sram_dataout[10]\ _11013_ VPWR VGND sg13g2_nand2_1
X_34842_ _02051_ _11012_ _11014_ _02721_ VPWR VGND sg13g2_a21oi_1
X_34843_ _11015_ _10999_ _11008_ VPWR VGND sg13g2_nand2b_1
X_34844_ _11016_ _11005_ _11015_ VPWR VGND sg13g2_nor2_1
X_34845_ _11017_ so _11016_ VPWR VGND sg13g2_nand2_1
X_34846_ _11018_ _11005_ _11015_ \memory_i.sram_dataout[11]\ VPWR VGND sg13g2_o21ai_1
X_34847_ _11019_ _02635_ VPWR VGND sg13g2_buf_1
X_34848_ _02052_ _11017_ _11018_ _11019_ VPWR VGND sg13g2_a21oi_1
X_34849_ _11020_ \memory_i.sram_master.index[3]\ \memory_i.sram_master.index[2]\ _10985_ _10968_ VPWR
+ VGND
+ sg13g2_nand4_1
X_34850_ _11021_ so \memory_i.sram_dataout[12]\ _11020_ VPWR VGND sg13g2_mux2_1
X_34851_ _02053_ reset _11021_ VPWR VGND sg13g2_and2_1
X_34852_ _11022_ \memory_i.sram_master.index[3]\ \memory_i.sram_master.index[2]\ _10965_ VPWR VGND sg13g2_nand3_1
X_34853_ _11023_ _11005_ _11022_ VPWR VGND sg13g2_nor2_1
X_34854_ _11024_ _10981_ _11023_ VPWR VGND sg13g2_nand2_1
X_34855_ _11025_ _11005_ _11022_ \memory_i.sram_dataout[13]\ VPWR VGND sg13g2_o21ai_1
X_34856_ _02054_ _11024_ _11025_ _11019_ VPWR VGND sg13g2_a21oi_1
X_34857_ _11026_ \memory_i.sram_master.index[3]\ \memory_i.sram_master.index[2]\ _10976_ VPWR VGND sg13g2_nand3_1
X_34858_ _11027_ so \memory_i.sram_dataout[14]\ _11026_ VPWR VGND sg13g2_mux2_1
X_34859_ _02055_ reset _11027_ VPWR VGND sg13g2_and2_1
X_34860_ _11028_ \memory_i.sram_master.index[3]\ \memory_i.sram_master.index[2]\ VPWR VGND sg13g2_nand2_1
X_34861_ _11029_ _10999_ _11005_ _11028_ VPWR VGND sg13g2_nor3_1
X_34862_ _11030_ \memory_i.sram_dataout[15]\ _10981_ _11029_ VPWR VGND sg13g2_mux2_1
X_34863_ _02056_ reset _11030_ VPWR VGND sg13g2_and2_1
X_34864_ _11031_ \memory_i.sram_master.index[4]\ \memory_i.sram_master.state[1]\ _13050_ _13082_ VPWR
+ VGND
+ sg13g2_nand4_1
X_34865_ _11032_ so \memory_i.sram_dataout[16]\ _11031_ VPWR VGND sg13g2_mux2_1
X_34866_ _02057_ reset _11032_ VPWR VGND sg13g2_and2_1
X_34867_ _11033_ _10959_ _10966_ VPWR VGND sg13g2_nor2_1
X_34868_ _11034_ _11033_ VPWR VGND sg13g2_buf_1
X_34869_ _11035_ _10965_ _10970_ _11034_ VPWR VGND sg13g2_nand3_1
X_34870_ _11036_ _10963_ \memory_i.sram_dataout[17]\ _11035_ VPWR VGND sg13g2_mux2_1
X_34871_ _02058_ reset _11036_ VPWR VGND sg13g2_and2_1
X_34872_ _11037_ _10959_ _10966_ _10974_ VPWR VGND sg13g2_nor3_1
X_34873_ _11038_ _11037_ VPWR VGND sg13g2_buf_1
X_34874_ _11039_ so _10970_ _11038_ VPWR VGND sg13g2_nand3_1
X_34875_ _11040_ _10970_ _11038_ VPWR VGND sg13g2_nand2_1
X_34876_ _11041_ \memory_i.sram_dataout[18]\ _11040_ VPWR VGND sg13g2_nand2_1
X_34877_ _02059_ _11039_ _11041_ _11019_ VPWR VGND sg13g2_a21oi_1
X_34878_ _11042_ \memory_i.sram_master.index[1]\ \memory_i.sram_master.index[0]\ _10970_ _11034_ VPWR
+ VGND
+ sg13g2_nand4_1
X_34879_ _11043_ _10981_ \memory_i.sram_dataout[19]\ _11042_ VPWR VGND sg13g2_mux2_1
X_34880_ _02060_ reset _11043_ VPWR VGND sg13g2_and2_1
X_34881_ _11044_ _10985_ _10987_ _11034_ VPWR VGND sg13g2_nand3_1
X_34882_ _11045_ so \memory_i.sram_dataout[20]\ _11044_ VPWR VGND sg13g2_mux2_1
X_34883_ _02061_ reset _11045_ VPWR VGND sg13g2_and2_1
X_34884_ _11046_ _10965_ _10987_ _11034_ VPWR VGND sg13g2_nand3_1
X_34885_ _11047_ _10981_ \memory_i.sram_dataout[21]\ _11046_ VPWR VGND sg13g2_mux2_1
X_34886_ _02062_ reset _11047_ VPWR VGND sg13g2_and2_1
X_34887_ _11048_ so _10987_ _11038_ VPWR VGND sg13g2_nand3_1
X_34888_ _11049_ _10987_ _11038_ VPWR VGND sg13g2_nand2_1
X_34889_ _11050_ \memory_i.sram_dataout[22]\ _11049_ VPWR VGND sg13g2_nand2_1
X_34890_ _02063_ _11048_ _11050_ _11019_ VPWR VGND sg13g2_a21oi_1
X_34891_ _11051_ \memory_i.sram_master.index[1]\ \memory_i.sram_master.index[0]\ _10987_ _11034_ VPWR
+ VGND
+ sg13g2_nand4_1
X_34892_ _11052_ _10981_ \memory_i.sram_dataout[23]\ _11051_ VPWR VGND sg13g2_mux2_1
X_34893_ _02064_ reset _11052_ VPWR VGND sg13g2_and2_1
X_34894_ _11053_ \memory_i.sram_master.index[3]\ so _13048_ _11034_ VPWR
+ VGND
+ sg13g2_nand4_1
X_34895_ _11054_ \memory_i.sram_master.index[4]\ \memory_i.sram_master.state[1]\ _13082_ VPWR VGND sg13g2_nand3_1
X_34896_ _11055_ _11054_ VPWR VGND sg13g2_buf_1
X_34897_ _11056_ _11003_ _11055_ \memory_i.sram_dataout[24]\ VPWR VGND sg13g2_o21ai_1
X_34898_ _02065_ _11053_ _11056_ _11019_ VPWR VGND sg13g2_a21oi_1
X_34899_ _11057_ so _10965_ _11008_ _11034_ VPWR
+ VGND
+ sg13g2_nand4_1
X_34900_ _11058_ _11009_ _11055_ \memory_i.sram_dataout[25]\ VPWR VGND sg13g2_o21ai_1
X_34901_ _02066_ _11057_ _11058_ _11019_ VPWR VGND sg13g2_a21oi_1
X_34902_ _11059_ so _11008_ _11038_ VPWR VGND sg13g2_nand3_1
X_34903_ _11060_ _11008_ _11038_ VPWR VGND sg13g2_nand2_1
X_34904_ _11061_ \memory_i.sram_dataout[26]\ _11060_ VPWR VGND sg13g2_nand2_1
X_34905_ _02067_ _11059_ _11061_ _11019_ VPWR VGND sg13g2_a21oi_1
X_34906_ _11062_ \memory_i.sram_master.index[1]\ \memory_i.sram_master.index[0]\ _11008_ _11034_ VPWR
+ VGND
+ sg13g2_nand4_1
X_34907_ _11063_ _10981_ \memory_i.sram_dataout[27]\ _11062_ VPWR VGND sg13g2_mux2_1
X_34908_ _02068_ reset _11063_ VPWR VGND sg13g2_and2_1
X_34909_ _11064_ \memory_i.sram_master.index[3]\ \memory_i.sram_master.index[2]\ _10985_ _11034_ VPWR
+ VGND
+ sg13g2_nand4_1
X_34910_ _11065_ so \memory_i.sram_dataout[28]\ _11064_ VPWR VGND sg13g2_mux2_1
X_34911_ _02069_ reset _11065_ VPWR VGND sg13g2_and2_1
X_34912_ _11066_ \memory_i.sram_master.index[3]\ \memory_i.sram_master.index[2]\ _10965_ _11034_ VPWR
+ VGND
+ sg13g2_nand4_1
X_34913_ _11067_ _10981_ \memory_i.sram_dataout[29]\ _11066_ VPWR VGND sg13g2_mux2_1
X_34914_ _02070_ reset _11067_ VPWR VGND sg13g2_and2_1
X_34915_ _11068_ _11028_ _11038_ VPWR VGND sg13g2_nor2b_1
X_34916_ _11069_ \memory_i.sram_dataout[30]\ so _11068_ VPWR VGND sg13g2_mux2_1
X_34917_ _02071_ reset _11069_ VPWR VGND sg13g2_and2_1
X_34918_ _11070_ _10999_ _11028_ _11055_ VPWR VGND sg13g2_nor3_1
X_34919_ _11071_ \memory_i.sram_dataout[31]\ so _11070_ VPWR VGND sg13g2_mux2_1
X_34920_ _02072_ reset _11071_ VPWR VGND sg13g2_and2_1
X_34921_ _11072_ \memory_i.sram_master.state[2]\ \memory_i.sram_master.state[5]\ \memory_i.sram_master.state[4]\ \memory_i.sram_master.state[1]\ VPWR
+ VGND
+ sg13g2_nor4_1
X_34922_ _11073_ _13057_ _11072_ _10956_ VPWR VGND sg13g2_o21ai_1
X_34923_ _11074_ _13077_ _11073_ VPWR VGND sg13g2_and2_1
X_34924_ _11075_ _11074_ VPWR VGND sg13g2_buf_1
X_34925_ _11076_ \memory_i.sram_master.posedge_trigger\ _11075_ VPWR VGND sg13g2_nand2_1
X_34926_ _11077_ _13055_ _13076_ _11076_ VPWR VGND sg13g2_a21oi_1
X_34927_ _11078_ \memory_i.sram_master.index[0]\ _11077_ VPWR VGND sg13g2_nand2_1
X_34928_ _11079_ \memory_i.sram_master.index[0]\ _11075_ _11078_ VPWR VGND sg13g2_o21ai_1
X_34929_ _02073_ reset _11079_ VPWR VGND sg13g2_nand2_1
X_34930_ _11080_ \memory_i.sram_master.index[0]\ \memory_i.sram_master.posedge_trigger\ VPWR VGND sg13g2_nand2_1
X_34931_ _11081_ _11075_ _11080_ \memory_i.sram_master.index[1]\ VPWR VGND sg13g2_a21oi_1
X_34932_ _11082_ _10974_ _11076_ VPWR VGND sg13g2_nor2_1
X_34933_ _02074_ _11081_ _11082_ reset VPWR VGND sg13g2_o21ai_1
X_34934_ _11083_ \memory_i.sram_master.index[1]\ \memory_i.sram_master.index[0]\ \memory_i.sram_master.posedge_trigger\ VPWR VGND sg13g2_o21ai_1
X_34935_ _11084_ _11075_ _11083_ \memory_i.sram_master.index[2]\ VPWR VGND sg13g2_a21oi_1
X_34936_ _11085_ \memory_i.sram_master.index[2]\ \memory_i.sram_master.posedge_trigger\ _10985_ _11075_ VPWR
+ VGND
+ sg13g2_and4_1
X_34937_ _02075_ _11084_ _11085_ reset VPWR VGND sg13g2_o21ai_1
X_34938_ _11086_ \memory_i.sram_master.state[1]\ _10927_ VPWR VGND sg13g2_nand2b_1
X_34939_ _11087_ _13073_ _11086_ \memory_i.sram_master.posedge_trigger\ VPWR VGND sg13g2_o21ai_1
X_34940_ _11088_ _13048_ _11087_ _11075_ VPWR VGND sg13g2_o21ai_1
X_34941_ _11089_ _11075_ VPWR VGND sg13g2_inv_1
X_34942_ _11090_ _11089_ _11087_ VPWR VGND sg13g2_nor2_1
X_34943_ _11091_ \memory_i.sram_master.index[3]\ _11088_ _11090_ _13050_ VPWR
+ VGND
+ sg13g2_a22oi_1
X_34944_ _02076_ _17189_ _11091_ VPWR VGND sg13g2_nor2_1
X_34945_ _11092_ _13057_ _13050_ _11075_ VPWR VGND sg13g2_o21ai_1
X_34946_ _11093_ _13052_ _11076_ VPWR VGND sg13g2_nor2_1
X_34947_ _11094_ \memory_i.sram_master.index[4]\ _11092_ _11093_ VPWR VGND sg13g2_a21oi_1
X_34948_ _02077_ _17189_ _11094_ VPWR VGND sg13g2_nor2_1
X_34949_ _11095_ _16952_ VPWR VGND sg13g2_buf_1
X_34950_ _11096_ \memory_i.sram_master.posedge_trigger\ _13052_ _11089_ VPWR VGND sg13g2_a21o_1
X_34951_ _11097_ _13072_ _11077_ _11096_ \memory_i.sram_master.index[5]\ VPWR
+ VGND
+ sg13g2_a22oi_1
X_34952_ _02078_ _11095_ _11097_ VPWR VGND sg13g2_nor2_1
X_34953_ _11098_ _13057_ _13072_ _11075_ VPWR VGND sg13g2_o21ai_1
X_34954_ _11099_ _13053_ _11077_ _11098_ \memory_i.sram_master.index[6]\ VPWR
+ VGND
+ sg13g2_a22oi_1
X_34955_ _02079_ _11095_ _11099_ VPWR VGND sg13g2_nor2_1
X_34956_ _11100_ _13057_ _13053_ _11075_ VPWR VGND sg13g2_o21ai_1
X_34957_ _11101_ _13073_ _13076_ _11076_ VPWR VGND sg13g2_nor3_1
X_34958_ _11102_ \memory_i.sram_master.index[7]\ _11100_ _11101_ VPWR VGND sg13g2_a21oi_1
X_34959_ _02080_ _11095_ _11102_ VPWR VGND sg13g2_nor2_1
X_34960_ _11103_ _13132_ _13046_ _10956_ VPWR VGND sg13g2_mux2_1
X_34961_ _02081_ _11095_ _11103_ VPWR VGND sg13g2_nor2_1
X_34962_ _02082_ \memory_i.sram_master.clk_counter[0]\ _13305_ VPWR VGND sg13g2_nor2_1
X_34963_ _11104_ \memory_i.uart_receiver.uart_rx_en\ \memory_i.uart_receiver.rxd_reg\ VPWR VGND sg13g2_nand2b_1
X_34964_ _11105_ \memory_i.uart_receiver.rxd_reg_0\ \memory_i.uart_receiver.uart_rx_en\ VPWR VGND sg13g2_nand2_1
X_34965_ _02083_ reset _11104_ _11105_ VPWR VGND sg13g2_nand3_1
X_34966_ _11106_ \memory_i.uart_receiver.uart_rx_en\ \memory_i.uart_receiver.rxd_reg_0\ VPWR VGND sg13g2_nand2b_1
X_34967_ _11107_ rx \memory_i.uart_receiver.uart_rx_en\ VPWR VGND sg13g2_nand2_1
X_34968_ _02084_ reset _11106_ _11107_ VPWR VGND sg13g2_nand3_1
X_34969_ _11108_ reset _13296_ VPWR VGND sg13g2_nand2_1
X_34970_ _11109_ _11108_ VPWR VGND sg13g2_buf_1
X_34971_ _11110_ \memory_i.uart_receiver.fsm_state[3]\ \memory_i.uart_receiver.fsm_state[2]\ \memory_i.uart_receiver.fsm_state[1]\ VPWR VGND sg13g2_nor3_1
X_34972_ _11111_ \memory_i.uart_receiver.cycle_counter[0]\ _11110_ VPWR VGND sg13g2_nor2b_1
X_34973_ _11112_ _11110_ \memory_i.uart_receiver.cycle_counter[0]\ VPWR VGND sg13g2_nor2b_1
X_34974_ _02085_ _11109_ _11111_ _11112_ VPWR VGND sg13g2_nor3_1
X_34975_ _11113_ _11109_ VPWR VGND sg13g2_buf_1
X_34976_ _11114_ \memory_i.uart_receiver.cycle_counter[1]\ _11112_ VPWR VGND sg13g2_xnor2_1
X_34977_ _02086_ _11113_ _11114_ VPWR VGND sg13g2_nor2_1
X_34978_ _11115_ \memory_i.uart_receiver.cycle_counter[1]\ _11112_ VPWR VGND sg13g2_and2_1
X_34979_ _11116_ _11115_ VPWR VGND sg13g2_buf_1
X_34980_ _11117_ \memory_i.uart_receiver.cycle_counter[2]\ _11116_ VPWR VGND sg13g2_xnor2_1
X_34981_ _02087_ _11113_ _11117_ VPWR VGND sg13g2_nor2_1
X_34982_ _11118_ \memory_i.uart_receiver.cycle_counter[2]\ _11116_ VPWR VGND sg13g2_nand2_1
X_34983_ _11119_ \memory_i.uart_receiver.cycle_counter[3]\ _11118_ VPWR VGND sg13g2_xor2_1
X_34984_ _02088_ _11113_ _11119_ VPWR VGND sg13g2_nor2_1
X_34985_ _11120_ \memory_i.uart_receiver.cycle_counter[4]\ VPWR VGND sg13g2_inv_1
X_34986_ _11121_ \memory_i.uart_receiver.cycle_counter[3]\ \memory_i.uart_receiver.cycle_counter[2]\ _11116_ VPWR VGND sg13g2_nand3_1
X_34987_ _11122_ _11120_ _11121_ VPWR VGND sg13g2_xnor2_1
X_34988_ _02089_ _11113_ _11122_ VPWR VGND sg13g2_nor2_1
X_34989_ _11123_ _11120_ _11121_ VPWR VGND sg13g2_nor2_1
X_34990_ _11124_ \memory_i.uart_receiver.cycle_counter[5]\ _11123_ VPWR VGND sg13g2_xnor2_1
X_34991_ _02090_ _11113_ _11124_ VPWR VGND sg13g2_nor2_1
X_34992_ _11125_ \memory_i.uart_receiver.cycle_counter[5]\ _11123_ VPWR VGND sg13g2_nand2_1
X_34993_ _11126_ \memory_i.uart_receiver.cycle_counter[6]\ _11125_ VPWR VGND sg13g2_xor2_1
X_34994_ _02091_ _11113_ _11126_ VPWR VGND sg13g2_nor2_1
X_34995_ _11127_ \memory_i.uart_receiver.cycle_counter[7]\ VPWR VGND sg13g2_inv_1
X_34996_ _11128_ \memory_i.uart_receiver.cycle_counter[6]\ \memory_i.uart_receiver.cycle_counter[5]\ _11123_ VPWR VGND sg13g2_nand3_1
X_34997_ _11129_ _11127_ _11128_ VPWR VGND sg13g2_xnor2_1
X_34998_ _02092_ _11113_ _11129_ VPWR VGND sg13g2_nor2_1
X_34999_ _11130_ _11127_ _11128_ VPWR VGND sg13g2_nor2_1
X_35000_ _11131_ \memory_i.uart_receiver.cycle_counter[8]\ _11130_ VPWR VGND sg13g2_xnor2_1
X_35001_ _02093_ _11113_ _11131_ VPWR VGND sg13g2_nor2_1
X_35002_ _11132_ \memory_i.uart_receiver.cycle_counter[8]\ _11130_ VPWR VGND sg13g2_nand2_1
X_35003_ _11133_ \memory_i.uart_receiver.cycle_counter[9]\ _11132_ VPWR VGND sg13g2_xor2_1
X_35004_ _02094_ _11113_ _11133_ VPWR VGND sg13g2_nor2_1
X_35005_ _11134_ \memory_i.uart_receiver.cycle_counter[10]\ VPWR VGND sg13g2_inv_1
X_35006_ _11135_ \memory_i.uart_receiver.cycle_counter[9]\ \memory_i.uart_receiver.cycle_counter[8]\ _11130_ VPWR VGND sg13g2_nand3_1
X_35007_ _11136_ _11134_ _11135_ VPWR VGND sg13g2_xnor2_1
X_35008_ _02095_ _11113_ _11136_ VPWR VGND sg13g2_nor2_1
X_35009_ _11137_ _11134_ _11135_ VPWR VGND sg13g2_nor2_1
X_35010_ _11138_ \memory_i.uart_receiver.cycle_counter[11]\ _11137_ VPWR VGND sg13g2_xnor2_1
X_35011_ _02096_ _11109_ _11138_ VPWR VGND sg13g2_nor2_1
X_35012_ _11139_ \memory_i.uart_receiver.cycle_counter[11]\ _11137_ VPWR VGND sg13g2_nand2_1
X_35013_ _11140_ \memory_i.uart_receiver.cycle_counter[12]\ _11139_ VPWR VGND sg13g2_xor2_1
X_35014_ _02097_ _11109_ _11140_ VPWR VGND sg13g2_nor2_1
X_35015_ _11141_ \memory_i.uart_receiver.cycle_counter[13]\ VPWR VGND sg13g2_inv_1
X_35016_ _11142_ \memory_i.uart_receiver.cycle_counter[12]\ \memory_i.uart_receiver.cycle_counter[11]\ _11137_ VPWR VGND sg13g2_nand3_1
X_35017_ _11143_ _11141_ _11142_ VPWR VGND sg13g2_xnor2_1
X_35018_ _02098_ _11109_ _11143_ VPWR VGND sg13g2_nor2_1
X_35019_ _11144_ _11141_ _11142_ VPWR VGND sg13g2_nor2_1
X_35020_ _11145_ \memory_i.uart_receiver.cycle_counter[14]\ _11144_ VPWR VGND sg13g2_xnor2_1
X_35021_ _02099_ _11109_ _11145_ VPWR VGND sg13g2_nor2_1
X_35022_ _11146_ \memory_i.uart_receiver.cycle_counter[14]\ _11144_ VPWR VGND sg13g2_nand2_1
X_35023_ _11147_ \memory_i.uart_receiver.cycle_counter[15]\ _11146_ VPWR VGND sg13g2_xor2_1
X_35024_ _02100_ _11109_ _11147_ VPWR VGND sg13g2_nor2_1
X_35025_ _11148_ \memory_i.uart_receiver.cycle_counter[15]\ _13292_ VPWR VGND sg13g2_nor2_1
X_35026_ _11149_ \memory_i.uart_receiver.rxd_reg\ _11148_ VPWR VGND sg13g2_nand2_1
X_35027_ _11150_ \memory_i.uart_receiver.cycle_counter[15]\ _13292_ \memory_i.uart_receiver.bit_sample\ VPWR VGND sg13g2_o21ai_1
X_35028_ _02101_ _11149_ _11150_ _11019_ VPWR VGND sg13g2_a21oi_1
X_35029_ _11151_ \memory_i.uart_receiver.fsm_state[3]\ _12948_ \memory_i.uart_receiver.fsm_state[0]\ \memory_i.uart_receiver.fsm_state[2]\ VPWR
+ VGND
+ sg13g2_or4_1
X_35030_ _11152_ _11151_ VPWR VGND sg13g2_buf_1
X_35031_ _11153_ \memory_i.uart_receiver.fsm_state[1]\ _13302_ VPWR VGND sg13g2_and2_1
X_35032_ _11154_ _11153_ VPWR VGND sg13g2_buf_1
X_35033_ _11155_ _11154_ VPWR VGND sg13g2_buf_1
X_35034_ _11156_ \memory_i.uart_receiver.bit_counter[0]\ _11155_ VPWR VGND sg13g2_xnor2_1
X_35035_ _02102_ _11152_ _11156_ VPWR VGND sg13g2_nor2_1
X_35036_ _11157_ \memory_i.uart_receiver.bit_counter[0]\ _11155_ VPWR VGND sg13g2_nand2_1
X_35037_ _11158_ \memory_i.uart_receiver.bit_counter[1]\ _11157_ VPWR VGND sg13g2_xor2_1
X_35038_ _02103_ _11152_ _11158_ VPWR VGND sg13g2_nor2_1
X_35039_ _11159_ \memory_i.uart_receiver.bit_counter[1]\ \memory_i.uart_receiver.bit_counter[0]\ _11154_ VPWR VGND sg13g2_nand3_1
X_35040_ _11160_ \memory_i.uart_receiver.bit_counter[2]\ _11159_ VPWR VGND sg13g2_xor2_1
X_35041_ _02104_ _11152_ _11160_ VPWR VGND sg13g2_nor2_1
X_35042_ _11161_ \memory_i.uart_receiver.bit_counter[2]\ \memory_i.uart_receiver.bit_counter[1]\ \memory_i.uart_receiver.bit_counter[0]\ _11154_ VPWR
+ VGND
+ sg13g2_nand4_1
X_35043_ _11162_ _13297_ _11161_ VPWR VGND sg13g2_xnor2_1
X_35044_ _02105_ _11152_ _11162_ VPWR VGND sg13g2_nor2_1
X_35045_ _11163_ _12948_ \memory_i.uart_receiver.fsm_state[0]\ VPWR VGND sg13g2_nor2_1
X_35046_ _11164_ _11163_ VPWR VGND sg13g2_buf_1
X_35047_ _11165_ \memory_i.uart_receiver.recieved_data[0]\ \memory_i.uart_receiver.recieved_data[1]\ _11155_ VPWR VGND sg13g2_mux2_1
X_35048_ _02106_ _11164_ _11165_ VPWR VGND sg13g2_and2_1
X_35049_ _11166_ \memory_i.uart_receiver.recieved_data[1]\ \memory_i.uart_receiver.recieved_data[2]\ _11155_ VPWR VGND sg13g2_mux2_1
X_35050_ _02107_ _11164_ _11166_ VPWR VGND sg13g2_and2_1
X_35051_ _11167_ \memory_i.uart_receiver.recieved_data[2]\ \memory_i.uart_receiver.recieved_data[3]\ _11155_ VPWR VGND sg13g2_mux2_1
X_35052_ _02108_ _11164_ _11167_ VPWR VGND sg13g2_and2_1
X_35053_ _11168_ \memory_i.uart_receiver.recieved_data[3]\ \memory_i.uart_receiver.recieved_data[4]\ _11155_ VPWR VGND sg13g2_mux2_1
X_35054_ _02109_ _11164_ _11168_ VPWR VGND sg13g2_and2_1
X_35055_ _11169_ \memory_i.uart_receiver.recieved_data[4]\ \memory_i.uart_receiver.recieved_data[5]\ _11155_ VPWR VGND sg13g2_mux2_1
X_35056_ _02110_ _11164_ _11169_ VPWR VGND sg13g2_and2_1
X_35057_ _11170_ \memory_i.uart_receiver.recieved_data[5]\ \memory_i.uart_receiver.recieved_data[6]\ _11155_ VPWR VGND sg13g2_mux2_1
X_35058_ _02111_ _11164_ _11170_ VPWR VGND sg13g2_and2_1
X_35059_ _11171_ \memory_i.uart_receiver.recieved_data[6]\ \memory_i.uart_receiver.recieved_data[7]\ _11155_ VPWR VGND sg13g2_mux2_1
X_35060_ _02112_ _11164_ _11171_ VPWR VGND sg13g2_and2_1
X_35061_ _11172_ \memory_i.uart_receiver.recieved_data[7]\ \memory_i.uart_receiver.bit_sample\ _11155_ VPWR VGND sg13g2_mux2_1
X_35062_ _02113_ _11164_ _11172_ VPWR VGND sg13g2_and2_1
X_35063_ _11173_ \memory_i.uart_receiver.fsm_state[3]\ \memory_i.uart_receiver.recieved_data[0]\ VPWR VGND sg13g2_nand2_1
X_35064_ _11174_ \memory_i.uart_receiver.fsm_state[3]\ \memory_i.uart_receiver.uart_rx_data[0]\ VPWR VGND sg13g2_nand2b_1
X_35065_ _02114_ _11173_ _11174_ _11019_ VPWR VGND sg13g2_a21oi_1
X_35066_ _11175_ \memory_i.uart_receiver.fsm_state[3]\ \memory_i.uart_receiver.recieved_data[1]\ VPWR VGND sg13g2_nand2_1
X_35067_ _11176_ \memory_i.uart_receiver.fsm_state[3]\ \memory_i.uart_receiver.uart_rx_data[1]\ VPWR VGND sg13g2_nand2b_1
X_35068_ _02115_ _11175_ _11176_ _11019_ VPWR VGND sg13g2_a21oi_1
X_35069_ _11177_ \memory_i.uart_receiver.fsm_state[3]\ \memory_i.uart_receiver.recieved_data[2]\ VPWR VGND sg13g2_nand2_1
X_35070_ _11178_ \memory_i.uart_receiver.fsm_state[3]\ \memory_i.uart_receiver.uart_rx_data[2]\ VPWR VGND sg13g2_nand2b_1
X_35071_ _11179_ _02635_ VPWR VGND sg13g2_buf_1
X_35072_ _02116_ _11177_ _11178_ _11179_ VPWR VGND sg13g2_a21oi_1
X_35073_ _11180_ \memory_i.uart_receiver.fsm_state[3]\ \memory_i.uart_receiver.recieved_data[3]\ VPWR VGND sg13g2_nand2_1
X_35074_ _11181_ \memory_i.uart_receiver.fsm_state[3]\ \memory_i.uart_receiver.uart_rx_data[3]\ VPWR VGND sg13g2_nand2b_1
X_35075_ _02117_ _11180_ _11181_ _11179_ VPWR VGND sg13g2_a21oi_1
X_35076_ _11182_ \memory_i.uart_receiver.fsm_state[3]\ \memory_i.uart_receiver.recieved_data[4]\ VPWR VGND sg13g2_nand2_1
X_35077_ _11183_ \memory_i.uart_receiver.fsm_state[3]\ \memory_i.uart_receiver.uart_rx_data[4]\ VPWR VGND sg13g2_nand2b_1
X_35078_ _02118_ _11182_ _11183_ _11179_ VPWR VGND sg13g2_a21oi_1
X_35079_ _11184_ \memory_i.uart_receiver.fsm_state[3]\ \memory_i.uart_receiver.recieved_data[5]\ VPWR VGND sg13g2_nand2_1
X_35080_ _11185_ \memory_i.uart_receiver.fsm_state[3]\ \memory_i.uart_receiver.uart_rx_data[5]\ VPWR VGND sg13g2_nand2b_1
X_35081_ _02119_ _11184_ _11185_ _11179_ VPWR VGND sg13g2_a21oi_1
X_35082_ _11186_ \memory_i.uart_receiver.fsm_state[3]\ \memory_i.uart_receiver.recieved_data[6]\ VPWR VGND sg13g2_nand2_1
X_35083_ _11187_ \memory_i.uart_receiver.fsm_state[3]\ \memory_i.uart_receiver.uart_rx_data[6]\ VPWR VGND sg13g2_nand2b_1
X_35084_ _02120_ _11186_ _11187_ _11179_ VPWR VGND sg13g2_a21oi_1
X_35085_ _11188_ \memory_i.uart_receiver.recieved_data[7]\ \memory_i.uart_receiver.fsm_state[3]\ VPWR VGND sg13g2_nand2_1
X_35086_ _11189_ \memory_i.uart_receiver.fsm_state[3]\ \memory_i.uart_receiver.uart_rx_data[7]\ VPWR VGND sg13g2_nand2b_1
X_35087_ _02121_ _11188_ _11189_ _11179_ VPWR VGND sg13g2_a21oi_1
X_35088_ _11190_ \memory_i.uart_transmitter.fsm_state[1]\ \memory_i.uart_transmitter.fsm_state[0]\ VPWR VGND sg13g2_nand2b_1
X_35089_ _11191_ \memory_i.uart_transmitter.data_to_send[0]\ _15800_ _11190_ VPWR VGND sg13g2_o21ai_1
X_35090_ _02122_ reset _11191_ VPWR VGND sg13g2_nand2_1
X_35091_ _11192_ _15795_ reset VPWR VGND sg13g2_nand2b_1
X_35092_ _11193_ _11192_ VPWR VGND sg13g2_buf_1
X_35093_ _11194_ \memory_i.uart_transmitter.cycle_counter[0]\ \memory_i.uart_transmitter.fsm_state[1]\ \memory_i.uart_transmitter.fsm_state[0]\ VPWR VGND sg13g2_nor3_1
X_35094_ _11195_ _12961_ \memory_i.uart_transmitter.cycle_counter[0]\ VPWR VGND sg13g2_nor2b_1
X_35095_ _02123_ _11193_ _11194_ _11195_ VPWR VGND sg13g2_nor3_1
X_35096_ _11196_ _11193_ VPWR VGND sg13g2_buf_1
X_35097_ _11197_ \memory_i.uart_transmitter.cycle_counter[1]\ _11195_ VPWR VGND sg13g2_xnor2_1
X_35098_ _02124_ _11196_ _11197_ VPWR VGND sg13g2_nor2_1
X_35099_ _11198_ \memory_i.uart_transmitter.cycle_counter[1]\ _11195_ VPWR VGND sg13g2_and2_1
X_35100_ _11199_ _11198_ VPWR VGND sg13g2_buf_1
X_35101_ _11200_ \memory_i.uart_transmitter.cycle_counter[2]\ _11199_ VPWR VGND sg13g2_xnor2_1
X_35102_ _02125_ _11196_ _11200_ VPWR VGND sg13g2_nor2_1
X_35103_ _11201_ \memory_i.uart_transmitter.cycle_counter[2]\ _11199_ VPWR VGND sg13g2_nand2_1
X_35104_ _11202_ \memory_i.uart_transmitter.cycle_counter[3]\ _11201_ VPWR VGND sg13g2_xor2_1
X_35105_ _02126_ _11196_ _11202_ VPWR VGND sg13g2_nor2_1
X_35106_ _11203_ \memory_i.uart_transmitter.cycle_counter[4]\ VPWR VGND sg13g2_inv_1
X_35107_ _11204_ \memory_i.uart_transmitter.cycle_counter[3]\ \memory_i.uart_transmitter.cycle_counter[2]\ _11199_ VPWR VGND sg13g2_nand3_1
X_35108_ _11205_ _11203_ _11204_ VPWR VGND sg13g2_xnor2_1
X_35109_ _02127_ _11196_ _11205_ VPWR VGND sg13g2_nor2_1
X_35110_ _11206_ _11203_ _11204_ VPWR VGND sg13g2_nor2_1
X_35111_ _11207_ \memory_i.uart_transmitter.cycle_counter[5]\ _11206_ VPWR VGND sg13g2_xnor2_1
X_35112_ _02128_ _11196_ _11207_ VPWR VGND sg13g2_nor2_1
X_35113_ _11208_ \memory_i.uart_transmitter.cycle_counter[5]\ _11206_ VPWR VGND sg13g2_nand2_1
X_35114_ _11209_ \memory_i.uart_transmitter.cycle_counter[6]\ _11208_ VPWR VGND sg13g2_xor2_1
X_35115_ _02129_ _11196_ _11209_ VPWR VGND sg13g2_nor2_1
X_35116_ _11210_ \memory_i.uart_transmitter.cycle_counter[7]\ VPWR VGND sg13g2_inv_1
X_35117_ _11211_ \memory_i.uart_transmitter.cycle_counter[6]\ \memory_i.uart_transmitter.cycle_counter[5]\ _11206_ VPWR VGND sg13g2_nand3_1
X_35118_ _11212_ _11210_ _11211_ VPWR VGND sg13g2_xnor2_1
X_35119_ _02130_ _11196_ _11212_ VPWR VGND sg13g2_nor2_1
X_35120_ _11213_ _11210_ _11211_ VPWR VGND sg13g2_nor2_1
X_35121_ _11214_ \memory_i.uart_transmitter.cycle_counter[8]\ _11213_ VPWR VGND sg13g2_xnor2_1
X_35122_ _02131_ _11196_ _11214_ VPWR VGND sg13g2_nor2_1
X_35123_ _11215_ \memory_i.uart_transmitter.cycle_counter[8]\ _11213_ VPWR VGND sg13g2_nand2_1
X_35124_ _11216_ \memory_i.uart_transmitter.cycle_counter[9]\ _11215_ VPWR VGND sg13g2_xor2_1
X_35125_ _02132_ _11196_ _11216_ VPWR VGND sg13g2_nor2_1
X_35126_ _11217_ \memory_i.uart_transmitter.cycle_counter[10]\ VPWR VGND sg13g2_inv_1
X_35127_ _11218_ \memory_i.uart_transmitter.cycle_counter[9]\ \memory_i.uart_transmitter.cycle_counter[8]\ _11213_ VPWR VGND sg13g2_nand3_1
X_35128_ _11219_ _11217_ _11218_ VPWR VGND sg13g2_xnor2_1
X_35129_ _02133_ _11196_ _11219_ VPWR VGND sg13g2_nor2_1
X_35130_ _11220_ _11217_ _11218_ VPWR VGND sg13g2_nor2_1
X_35131_ _11221_ \memory_i.uart_transmitter.cycle_counter[11]\ _11220_ VPWR VGND sg13g2_xnor2_1
X_35132_ _02134_ _11193_ _11221_ VPWR VGND sg13g2_nor2_1
X_35133_ _11222_ \memory_i.uart_transmitter.cycle_counter[11]\ _11220_ VPWR VGND sg13g2_nand2_1
X_35134_ _11223_ \memory_i.uart_transmitter.cycle_counter[12]\ _11222_ VPWR VGND sg13g2_xor2_1
X_35135_ _02135_ _11193_ _11223_ VPWR VGND sg13g2_nor2_1
X_35136_ _11224_ \memory_i.uart_transmitter.cycle_counter[13]\ VPWR VGND sg13g2_inv_1
X_35137_ _11225_ \memory_i.uart_transmitter.cycle_counter[12]\ \memory_i.uart_transmitter.cycle_counter[11]\ _11220_ VPWR VGND sg13g2_nand3_1
X_35138_ _11226_ _11224_ _11225_ VPWR VGND sg13g2_xnor2_1
X_35139_ _02136_ _11193_ _11226_ VPWR VGND sg13g2_nor2_1
X_35140_ _11227_ _11224_ _11225_ VPWR VGND sg13g2_nor2_1
X_35141_ _11228_ \memory_i.uart_transmitter.cycle_counter[14]\ _11227_ VPWR VGND sg13g2_xnor2_1
X_35142_ _02137_ _11193_ _11228_ VPWR VGND sg13g2_nor2_1
X_35143_ _11229_ \memory_i.uart_transmitter.cycle_counter[14]\ _11227_ VPWR VGND sg13g2_nand2_1
X_35144_ _11230_ \memory_i.uart_transmitter.cycle_counter[15]\ _11229_ VPWR VGND sg13g2_xor2_1
X_35145_ _02138_ _11193_ _11230_ VPWR VGND sg13g2_nor2_1
X_35146_ _11231_ \memory_i.uart_transmitter.fsm_state[1]\ reset VPWR VGND sg13g2_and2_1
X_35147_ _11232_ _15800_ _15801_ _11231_ VPWR VGND sg13g2_o21ai_1
X_35148_ _11233_ _11232_ VPWR VGND sg13g2_buf_1
X_35149_ _11234_ \memory_i.uart_transmitter.fsm_state[1]\ _15795_ VPWR VGND sg13g2_and2_1
X_35150_ _11235_ _11234_ VPWR VGND sg13g2_buf_1
X_35151_ _11236_ \memory_i.uart_transmitter.bit_counter[0]\ _11235_ VPWR VGND sg13g2_xnor2_1
X_35152_ _02139_ _11233_ _11236_ VPWR VGND sg13g2_nor2_1
X_35153_ _11237_ \memory_i.uart_transmitter.bit_counter[0]\ _11235_ VPWR VGND sg13g2_nand2_1
X_35154_ _11238_ \memory_i.uart_transmitter.bit_counter[1]\ _11237_ VPWR VGND sg13g2_xor2_1
X_35155_ _02140_ _11233_ _11238_ VPWR VGND sg13g2_nor2_1
X_35156_ _11239_ \memory_i.uart_transmitter.bit_counter[1]\ \memory_i.uart_transmitter.bit_counter[0]\ _11235_ VPWR VGND sg13g2_nand3_1
X_35157_ _11240_ \memory_i.uart_transmitter.bit_counter[2]\ _11239_ VPWR VGND sg13g2_xor2_1
X_35158_ _02141_ _11233_ _11240_ VPWR VGND sg13g2_nor2_1
X_35159_ _11241_ \memory_i.uart_transmitter.bit_counter[2]\ \memory_i.uart_transmitter.bit_counter[1]\ \memory_i.uart_transmitter.bit_counter[0]\ _11235_ VPWR
+ VGND
+ sg13g2_nand4_1
X_35160_ _11242_ \memory_i.uart_transmitter.bit_counter[3]\ _11241_ VPWR VGND sg13g2_xor2_1
X_35161_ _02142_ _11233_ _11242_ VPWR VGND sg13g2_nor2_1
X_35162_ _11243_ _15803_ VPWR VGND sg13g2_buf_1
X_35163_ _11244_ \memory_i.datain_reg[0]\ _11243_ VPWR VGND sg13g2_nor2_1
X_35164_ _11245_ \memory_i.uart_transmitter.fsm_state[0]\ _15795_ \memory_i.uart_transmitter.fsm_state[1]\ VPWR VGND sg13g2_nand3b_1
X_35165_ _11246_ _11245_ VPWR VGND sg13g2_buf_1
X_35166_ _11247_ \memory_i.uart_transmitter.data_to_send[1]\ \memory_i.uart_transmitter.data_to_send[0]\ _11246_ VPWR VGND sg13g2_mux2_1
X_35167_ _11248_ _11247_ _11243_ VPWR VGND sg13g2_nor2b_1
X_35168_ _02143_ _15734_ _11244_ _11248_ VPWR VGND sg13g2_nor3_1
X_35169_ _11249_ \memory_i.datain_reg[1]\ _11243_ VPWR VGND sg13g2_nor2_1
X_35170_ _11250_ \memory_i.uart_transmitter.data_to_send[2]\ \memory_i.uart_transmitter.data_to_send[1]\ _11246_ VPWR VGND sg13g2_mux2_1
X_35171_ _11251_ _11250_ _11243_ VPWR VGND sg13g2_nor2b_1
X_35172_ _02144_ _15734_ _11249_ _11251_ VPWR VGND sg13g2_nor3_1
X_35173_ _11252_ \memory_i.datain_reg[2]\ _11243_ VPWR VGND sg13g2_nor2_1
X_35174_ _11253_ \memory_i.uart_transmitter.data_to_send[3]\ \memory_i.uart_transmitter.data_to_send[2]\ _11246_ VPWR VGND sg13g2_mux2_1
X_35175_ _11254_ _11253_ _15803_ VPWR VGND sg13g2_nor2b_1
X_35176_ _02145_ _15734_ _11252_ _11254_ VPWR VGND sg13g2_nor3_1
X_35177_ _11255_ \memory_i.datain_reg[3]\ _11243_ VPWR VGND sg13g2_nor2_1
X_35178_ _11256_ \memory_i.uart_transmitter.data_to_send[4]\ \memory_i.uart_transmitter.data_to_send[3]\ _11246_ VPWR VGND sg13g2_mux2_1
X_35179_ _11257_ _11256_ _15803_ VPWR VGND sg13g2_nor2b_1
X_35180_ _02146_ _15734_ _11255_ _11257_ VPWR VGND sg13g2_nor3_1
X_35181_ _11258_ \memory_i.datain_reg[4]\ _11243_ VPWR VGND sg13g2_nor2_1
X_35182_ _11259_ \memory_i.uart_transmitter.data_to_send[5]\ \memory_i.uart_transmitter.data_to_send[4]\ _11246_ VPWR VGND sg13g2_mux2_1
X_35183_ _11260_ _11259_ _15803_ VPWR VGND sg13g2_nor2b_1
X_35184_ _02147_ _15734_ _11258_ _11260_ VPWR VGND sg13g2_nor3_1
X_35185_ _11261_ \memory_i.datain_reg[5]\ _11243_ VPWR VGND sg13g2_nor2_1
X_35186_ _11262_ \memory_i.uart_transmitter.data_to_send[6]\ \memory_i.uart_transmitter.data_to_send[5]\ _11246_ VPWR VGND sg13g2_mux2_1
X_35187_ _11263_ _11262_ _15803_ VPWR VGND sg13g2_nor2b_1
X_35188_ _02148_ _15734_ _11261_ _11263_ VPWR VGND sg13g2_nor3_1
X_35189_ _11264_ \memory_i.datain_reg[6]\ _11243_ VPWR VGND sg13g2_nor2_1
X_35190_ _11265_ \memory_i.uart_transmitter.data_to_send[7]\ \memory_i.uart_transmitter.data_to_send[6]\ _11246_ VPWR VGND sg13g2_mux2_1
X_35191_ _11266_ _11265_ _15803_ VPWR VGND sg13g2_nor2b_1
X_35192_ _02149_ _15734_ _11264_ _11266_ VPWR VGND sg13g2_nor3_1
X_35193_ _11267_ \memory_i.datain_reg[7]\ \memory_i.uart_transmitter.uart_tx_en\ _12961_ VPWR VGND sg13g2_nand3_1
X_35194_ _11268_ \memory_i.uart_transmitter.data_to_send[7]\ _11243_ VPWR VGND sg13g2_nand2_1
X_35195_ _02150_ _11267_ _11268_ _11179_ VPWR VGND sg13g2_a21oi_1
X_35196_ _11269_ \mem_dataout[0]\ \control_i.state_q[3]\ \control_i.mem_valid\ VPWR VGND sg13g2_nand3_1
X_35197_ _11270_ \control_i.state_q[3]\ \control_i.mem_valid\ VPWR VGND sg13g2_nand2_1
X_35198_ _11271_ _11270_ VPWR VGND sg13g2_buf_1
X_35199_ _11272_ _11271_ VPWR VGND sg13g2_buf_1
X_35200_ _11273_ \alu_i.instruction[0]\ _11272_ VPWR VGND sg13g2_nand2_1
X_35201_ _02151_ _11269_ _11273_ _11179_ VPWR VGND sg13g2_a21oi_1
X_35202_ _11274_ \mem_dataout[1]\ \control_i.state_q[3]\ \control_i.mem_valid\ VPWR VGND sg13g2_nand3_1
X_35203_ _11275_ \alu_i.instruction[1]\ _11272_ VPWR VGND sg13g2_nand2_1
X_35204_ _02152_ _11274_ _11275_ _11179_ VPWR VGND sg13g2_a21oi_1
X_35205_ _11276_ \mem_dataout[2]\ \control_i.state_q[3]\ \control_i.mem_valid\ VPWR VGND sg13g2_nand3_1
X_35206_ _11277_ \alu_i.instruction[2]\ _11272_ VPWR VGND sg13g2_nand2_1
X_35207_ _02153_ _11276_ _11277_ _11179_ VPWR VGND sg13g2_a21oi_1
X_35208_ _11278_ \mem_dataout[3]\ \control_i.state_q[3]\ \control_i.mem_valid\ VPWR VGND sg13g2_nand3_1
X_35209_ _11279_ \alu_i.instruction[3]\ _11272_ VPWR VGND sg13g2_nand2_1
X_35210_ _11280_ _02635_ VPWR VGND sg13g2_buf_1
X_35211_ _02154_ _11278_ _11279_ _11280_ VPWR VGND sg13g2_a21oi_1
X_35212_ _11281_ \mem_dataout[4]\ \control_i.state_q[3]\ \control_i.mem_valid\ VPWR VGND sg13g2_nand3_1
X_35213_ _11282_ \alu_i.instruction[4]\ _11272_ VPWR VGND sg13g2_nand2_1
X_35214_ _02155_ _11281_ _11282_ _11280_ VPWR VGND sg13g2_a21oi_1
X_35215_ _11283_ \mem_dataout[5]\ \control_i.state_q[3]\ \control_i.mem_valid\ VPWR VGND sg13g2_nand3_1
X_35216_ _11284_ \alu_i.instruction[5]\ _11272_ VPWR VGND sg13g2_nand2_1
X_35217_ _02156_ _11283_ _11284_ _11280_ VPWR VGND sg13g2_a21oi_1
X_35218_ _11285_ \mem_dataout[6]\ \control_i.state_q[3]\ \control_i.mem_valid\ VPWR VGND sg13g2_nand3_1
X_35219_ _11286_ \alu_i.instruction[6]\ _11272_ VPWR VGND sg13g2_nand2_1
X_35220_ _02157_ _11285_ _11286_ _11280_ VPWR VGND sg13g2_a21oi_1
X_35221_ _11287_ \mem_dataout[7]\ \control_i.state_q[3]\ \control_i.mem_valid\ VPWR VGND sg13g2_nand3_1
X_35222_ _11288_ \control_i.imm_gen_i.iword[7]\ _11272_ VPWR VGND sg13g2_nand2_1
X_35223_ _02158_ _11287_ _11288_ _11280_ VPWR VGND sg13g2_a21oi_1
X_35224_ _11289_ \mem_dataout[8]\ \control_i.state_q[3]\ \control_i.mem_valid\ VPWR VGND sg13g2_nand3_1
X_35225_ _11290_ \control_i.imm_gen_i.iword[8]\ _11272_ VPWR VGND sg13g2_nand2_1
X_35226_ _02159_ _11289_ _11290_ _11280_ VPWR VGND sg13g2_a21oi_1
X_35227_ _11291_ \mem_dataout[9]\ \control_i.state_q[3]\ \control_i.mem_valid\ VPWR VGND sg13g2_nand3_1
X_35228_ _11292_ \control_i.imm_gen_i.iword[9]\ _11272_ VPWR VGND sg13g2_nand2_1
X_35229_ _02160_ _11291_ _11292_ _11280_ VPWR VGND sg13g2_a21oi_1
X_35230_ _11293_ \mem_dataout[10]\ \control_i.state_q[3]\ \control_i.mem_valid\ VPWR VGND sg13g2_nand3_1
X_35231_ _11294_ _11271_ VPWR VGND sg13g2_buf_1
X_35232_ _11295_ \control_i.imm_gen_i.iword[10]\ _11294_ VPWR VGND sg13g2_nand2_1
X_35233_ _02161_ _11293_ _11295_ _11280_ VPWR VGND sg13g2_a21oi_1
X_35234_ _11296_ \mem_dataout[11]\ \control_i.state_q[3]\ \control_i.mem_valid\ VPWR VGND sg13g2_nand3_1
X_35235_ _11297_ \control_i.imm_gen_i.iword[11]\ _11294_ VPWR VGND sg13g2_nand2_1
X_35236_ _02162_ _11296_ _11297_ _11280_ VPWR VGND sg13g2_a21oi_1
X_35237_ _11298_ \mem_dataout[12]\ \control_i.state_q[3]\ \control_i.mem_valid\ VPWR VGND sg13g2_nand3_1
X_35238_ _11299_ \alu_i.funct3[0]\ _11294_ VPWR VGND sg13g2_nand2_1
X_35239_ _02163_ _11298_ _11299_ _11280_ VPWR VGND sg13g2_a21oi_1
X_35240_ _11300_ \mem_dataout[13]\ \control_i.state_q[3]\ \control_i.mem_valid\ VPWR VGND sg13g2_nand3_1
X_35241_ _11301_ \alu_i.funct3[1]\ _11294_ VPWR VGND sg13g2_nand2_1
X_35242_ _11302_ _02635_ VPWR VGND sg13g2_buf_1
X_35243_ _02164_ _11300_ _11301_ _11302_ VPWR VGND sg13g2_a21oi_1
X_35244_ _11303_ \mem_dataout[14]\ \control_i.state_q[3]\ \control_i.mem_valid\ VPWR VGND sg13g2_nand3_1
X_35245_ _11304_ \alu_i.funct3[2]\ _11294_ VPWR VGND sg13g2_nand2_1
X_35246_ _02165_ _11303_ _11304_ _11302_ VPWR VGND sg13g2_a21oi_1
X_35247_ _11305_ \mem_dataout[15]\ \control_i.state_q[3]\ \control_i.mem_valid\ VPWR VGND sg13g2_nand3_1
X_35248_ _11306_ \control_i.imm_gen_i.iword[15]\ _11294_ VPWR VGND sg13g2_nand2_1
X_35249_ _02166_ _11305_ _11306_ _11302_ VPWR VGND sg13g2_a21oi_1
X_35250_ _11307_ \mem_dataout[16]\ \control_i.state_q[3]\ \control_i.mem_valid\ VPWR VGND sg13g2_nand3_1
X_35251_ _11308_ \control_i.imm_gen_i.iword[16]\ _11294_ VPWR VGND sg13g2_nand2_1
X_35252_ _02167_ _11307_ _11308_ _11302_ VPWR VGND sg13g2_a21oi_1
X_35253_ _11309_ \mem_dataout[17]\ \control_i.state_q[3]\ \control_i.mem_valid\ VPWR VGND sg13g2_nand3_1
X_35254_ _11310_ \control_i.imm_gen_i.iword[17]\ _11294_ VPWR VGND sg13g2_nand2_1
X_35255_ _02168_ _11309_ _11310_ _11302_ VPWR VGND sg13g2_a21oi_1
X_35256_ _11311_ \mem_dataout[18]\ \control_i.state_q[3]\ \control_i.mem_valid\ VPWR VGND sg13g2_nand3_1
X_35257_ _11312_ \control_i.imm_gen_i.iword[18]\ _11294_ VPWR VGND sg13g2_nand2_1
X_35258_ _02169_ _11311_ _11312_ _11302_ VPWR VGND sg13g2_a21oi_1
X_35259_ _11313_ \mem_dataout[19]\ \control_i.state_q[3]\ \control_i.mem_valid\ VPWR VGND sg13g2_nand3_1
X_35260_ _11314_ \control_i.imm_gen_i.iword[19]\ _11294_ VPWR VGND sg13g2_nand2_1
X_35261_ _02170_ _11313_ _11314_ _11302_ VPWR VGND sg13g2_a21oi_1
X_35262_ _11315_ \mem_dataout[20]\ \control_i.state_q[3]\ \control_i.mem_valid\ VPWR VGND sg13g2_nand3_1
X_35263_ _11316_ _11271_ VPWR VGND sg13g2_buf_1
X_35264_ _11317_ \control_i.imm_gen_i.iword[20]\ _11316_ VPWR VGND sg13g2_nand2_1
X_35265_ _02171_ _11315_ _11317_ _11302_ VPWR VGND sg13g2_a21oi_1
X_35266_ _11318_ \mem_dataout[21]\ \control_i.state_q[3]\ \control_i.mem_valid\ VPWR VGND sg13g2_nand3_1
X_35267_ _11319_ \control_i.imm_gen_i.iword[21]\ _11316_ VPWR VGND sg13g2_nand2_1
X_35268_ _02172_ _11318_ _11319_ _11302_ VPWR VGND sg13g2_a21oi_1
X_35269_ _11320_ \mem_dataout[22]\ \control_i.state_q[3]\ \control_i.mem_valid\ VPWR VGND sg13g2_nand3_1
X_35270_ _11321_ \control_i.imm_gen_i.iword[22]\ _11316_ VPWR VGND sg13g2_nand2_1
X_35271_ _02173_ _11320_ _11321_ _11302_ VPWR VGND sg13g2_a21oi_1
X_35272_ _11322_ \mem_dataout[23]\ \control_i.state_q[3]\ \control_i.mem_valid\ VPWR VGND sg13g2_nand3_1
X_35273_ _11323_ \control_i.imm_gen_i.iword[23]\ _11316_ VPWR VGND sg13g2_nand2_1
X_35274_ _11324_ _12949_ VPWR VGND sg13g2_buf_1
X_35275_ _02174_ _11322_ _11323_ _11324_ VPWR VGND sg13g2_a21oi_1
X_35276_ _11325_ \mem_dataout[24]\ \control_i.state_q[3]\ \control_i.mem_valid\ VPWR VGND sg13g2_nand3_1
X_35277_ _11326_ \control_i.imm_gen_i.iword[24]\ _11316_ VPWR VGND sg13g2_nand2_1
X_35278_ _02175_ _11325_ _11326_ _11324_ VPWR VGND sg13g2_a21oi_1
X_35279_ _11327_ \mem_dataout[25]\ \control_i.state_q[3]\ \control_i.mem_valid\ VPWR VGND sg13g2_nand3_1
X_35280_ _11328_ \alu_i.funct7[0]\ _11316_ VPWR VGND sg13g2_nand2_1
X_35281_ _02176_ _11327_ _11328_ _11324_ VPWR VGND sg13g2_a21oi_1
X_35282_ _11329_ \mem_dataout[26]\ \control_i.state_q[3]\ \control_i.mem_valid\ VPWR VGND sg13g2_nand3_1
X_35283_ _11330_ \alu_i.funct7[1]\ _11316_ VPWR VGND sg13g2_nand2_1
X_35284_ _02177_ _11329_ _11330_ _11324_ VPWR VGND sg13g2_a21oi_1
X_35285_ _11331_ \mem_dataout[27]\ \control_i.state_q[3]\ \control_i.mem_valid\ VPWR VGND sg13g2_nand3_1
X_35286_ _11332_ \alu_i.funct7[2]\ _11316_ VPWR VGND sg13g2_nand2_1
X_35287_ _02178_ _11331_ _11332_ _11324_ VPWR VGND sg13g2_a21oi_1
X_35288_ _11333_ \mem_dataout[28]\ \control_i.state_q[3]\ \control_i.mem_valid\ VPWR VGND sg13g2_nand3_1
X_35289_ _11334_ \alu_i.funct7[3]\ _11316_ VPWR VGND sg13g2_nand2_1
X_35290_ _02179_ _11333_ _11334_ _11324_ VPWR VGND sg13g2_a21oi_1
X_35291_ _11335_ \mem_dataout[29]\ \control_i.state_q[3]\ \control_i.mem_valid\ VPWR VGND sg13g2_nand3_1
X_35292_ _11336_ \alu_i.funct7[4]\ _11316_ VPWR VGND sg13g2_nand2_1
X_35293_ _02180_ _11335_ _11336_ _11324_ VPWR VGND sg13g2_a21oi_1
X_35294_ _11337_ \mem_dataout[30]\ \control_i.state_q[3]\ \control_i.mem_valid\ VPWR VGND sg13g2_nand3_1
X_35295_ _11338_ \alu_i.funct7[5]\ _11271_ VPWR VGND sg13g2_nand2_1
X_35296_ _02181_ _11337_ _11338_ _11324_ VPWR VGND sg13g2_a21oi_1
X_35297_ _11339_ \mem_dataout[31]\ \control_i.state_q[3]\ \control_i.mem_valid\ VPWR VGND sg13g2_nand3_1
X_35298_ _11340_ \alu_i.funct7[6]\ _11271_ VPWR VGND sg13g2_nand2_1
X_35299_ _02182_ _11339_ _11340_ _11324_ VPWR VGND sg13g2_a21oi_1
X_35300_ _11341_ \alu_i.instruction[6]\ \alu_i.instruction[3]\ VPWR VGND sg13g2_nor2_1
X_35301_ _11342_ \alu_i.instruction[2]\ \alu_i.instruction[4]\ \alu_i.instruction[5]\ VPWR VGND sg13g2_nand3b_1
X_35302_ _11343_ _13226_ _11341_ _11342_ VPWR VGND sg13g2_nand3_1
X_35303_ _11344_ _13228_ _11343_ _13225_ VPWR VGND sg13g2_a21oi_1
X_35304_ _11345_ _16758_ _15756_ _11344_ VPWR VGND sg13g2_mux2_1
X_35305_ _11346_ _11345_ VPWR VGND sg13g2_buf_4
X_35306_ _11347_ _11346_ VPWR VGND sg13g2_buf_1
X_35307_ _11348_ _11347_ VPWR VGND sg13g2_buf_1
X_35308_ _11349_ _11348_ VPWR VGND sg13g2_buf_1
X_35309_ _11350_ \alu_i.instruction[5]\ _13218_ _13238_ VPWR VGND sg13g2_and3_1
X_35310_ _11351_ _11350_ VPWR VGND sg13g2_buf_1
X_35311_ _11352_ _13203_ _13201_ _13190_ VPWR VGND sg13g2_a21oi_1
X_35312_ _11353_ \alu_i.instruction[6]\ \alu_i.instruction[5]\ _13011_ _13231_ VPWR
+ VGND
+ sg13g2_nor4_1
X_35313_ _11354_ _11353_ VPWR VGND sg13g2_buf_1
X_35314_ _11355_ _11354_ VPWR VGND sg13g2_buf_2
X_35315_ _11356_ _11355_ VPWR VGND sg13g2_buf_1
X_35316_ _11357_ _11356_ VPWR VGND sg13g2_buf_1
X_35317_ _11358_ _11357_ VPWR VGND sg13g2_buf_1
X_35318_ _11359_ _11358_ VPWR VGND sg13g2_buf_1
X_35319_ _11360_ _11359_ VPWR VGND sg13g2_buf_1
X_35320_ _11361_ _11360_ VPWR VGND sg13g2_buf_1
X_35321_ _11362_ _13203_ _13190_ _11361_ VPWR VGND sg13g2_a21oi_1
X_35322_ _11363_ _13237_ _11352_ _11362_ VPWR VGND sg13g2_o21ai_1
X_35323_ _11364_ _11363_ VPWR VGND sg13g2_buf_1
X_35324_ _11365_ _11364_ VPWR VGND sg13g2_buf_1
X_35325_ _11366_ \alu_i.funct3[2]\ _13201_ VPWR VGND sg13g2_nand2_1
X_35326_ _11367_ \alu_i.funct3[0]\ _11366_ VPWR VGND sg13g2_nor2_1
X_35327_ _11368_ _11367_ VPWR VGND sg13g2_buf_1
X_35328_ _11369_ \alu_i.instruction[5]\ _13233_ VPWR VGND sg13g2_and2_1
X_35329_ _11370_ _11369_ VPWR VGND sg13g2_buf_1
X_35330_ _11371_ _11351_ _11365_ _11368_ _11370_ VPWR
+ VGND
+ sg13g2_nor4_1
X_35331_ _11372_ _11354_ \csr_i.data_in[0]\ VPWR VGND sg13g2_nor2b_1
X_35332_ _11373_ \csr_i.pc[0]\ _11354_ _11372_ VPWR VGND sg13g2_a21oi_1
X_35333_ _11374_ _11373_ VPWR VGND sg13g2_buf_1
X_35334_ _11375_ _11349_ _11371_ _11374_ VPWR VGND sg13g2_o21ai_1
X_35335_ _11376_ \alu_i.instruction[5]\ _13233_ VPWR VGND sg13g2_nand2_1
X_35336_ _11377_ _11376_ VPWR VGND sg13g2_buf_1
X_35337_ _11378_ \alu_i.funct3[2]\ \alu_i.funct3[1]\ \alu_i.funct3[0]\ _13201_ VPWR
+ VGND
+ sg13g2_nand4_1
X_35338_ _11379_ _11378_ VPWR VGND sg13g2_buf_1
X_35339_ _11380_ _11379_ VPWR VGND sg13g2_buf_1
X_35340_ _11381_ _11377_ _11380_ VPWR VGND sg13g2_nand2_1
X_35341_ _11382_ _11374_ _11349_ _11381_ VPWR VGND sg13g2_nor3_1
X_35342_ _11383_ _11344_ VPWR VGND sg13g2_buf_2
X_35343_ _11384_ \memory_i.datain[0]\ \control_i.immediate[0]\ _11383_ VPWR VGND sg13g2_mux2_1
X_35344_ _11385_ _11384_ VPWR VGND sg13g2_buf_1
X_35345_ _11386_ _11385_ VPWR VGND sg13g2_buf_1
X_35346_ _11387_ _11386_ VPWR VGND sg13g2_buf_1
X_35347_ _11388_ _11387_ VPWR VGND sg13g2_buf_1
X_35348_ _11389_ _11388_ VPWR VGND sg13g2_buf_1
X_35349_ _11390_ _11389_ VPWR VGND sg13g2_buf_1
X_35350_ _11391_ \alu_i.funct3[2]\ _13212_ _13201_ VPWR VGND sg13g2_nand3_1
X_35351_ _11392_ _11391_ VPWR VGND sg13g2_buf_1
X_35352_ _11393_ _11392_ VPWR VGND sg13g2_buf_1
X_35353_ _11394_ \alu_i.funct3[1]\ _11393_ _13244_ VPWR VGND sg13g2_o21ai_1
X_35354_ _11395_ _11390_ _11365_ _11394_ VPWR VGND sg13g2_nor3_1
X_35355_ _11396_ \alu_i.funct3[1]\ _11368_ VPWR VGND sg13g2_nand2_1
X_35356_ _11397_ _11382_ _11395_ _11396_ VPWR VGND sg13g2_o21ai_1
X_35357_ _11398_ _11383_ VPWR VGND sg13g2_buf_1
X_35358_ _11399_ _11398_ VPWR VGND sg13g2_buf_1
X_35359_ _11400_ _11383_ \memory_i.datain[4]\ VPWR VGND sg13g2_nor2b_1
X_35360_ _11401_ \control_i.immediate[4]\ _11399_ _11400_ VPWR VGND sg13g2_a21oi_1
X_35361_ _11402_ _11401_ VPWR VGND sg13g2_buf_1
X_35362_ _11403_ _11402_ VPWR VGND sg13g2_buf_1
X_35363_ _11404_ _11403_ VPWR VGND sg13g2_buf_1
X_35364_ _11405_ _11399_ VPWR VGND sg13g2_buf_1
X_35365_ _11406_ _11405_ VPWR VGND sg13g2_buf_1
X_35366_ _11407_ _11406_ VPWR VGND sg13g2_buf_1
X_35367_ _11408_ _11407_ VPWR VGND sg13g2_buf_1
X_35368_ _11409_ _11383_ \memory_i.datain[3]\ VPWR VGND sg13g2_nor2b_1
X_35369_ _11410_ \control_i.immediate[3]\ _11408_ _11409_ VPWR VGND sg13g2_a21o_1
X_35370_ _11411_ _11410_ VPWR VGND sg13g2_buf_1
X_35371_ _11412_ _11411_ VPWR VGND sg13g2_buf_1
X_35372_ _11413_ _11412_ VPWR VGND sg13g2_buf_1
X_35373_ _11414_ _11413_ VPWR VGND sg13g2_buf_1
X_35374_ _11415_ _11408_ \memory_i.datain[2]\ VPWR VGND sg13g2_nor2b_1
X_35375_ _11416_ \control_i.immediate[2]\ _11408_ _11415_ VPWR VGND sg13g2_a21oi_1
X_35376_ _11417_ _11416_ VPWR VGND sg13g2_buf_1
X_35377_ _11418_ _11417_ VPWR VGND sg13g2_buf_1
X_35378_ _11419_ _11418_ VPWR VGND sg13g2_buf_1
X_35379_ _11420_ \memory_i.datain[1]\ \control_i.immediate[1]\ _11383_ VPWR VGND sg13g2_mux2_1
X_35380_ _11421_ _11420_ VPWR VGND sg13g2_buf_1
X_35381_ _11422_ _11421_ VPWR VGND sg13g2_buf_1
X_35382_ _11423_ _11422_ VPWR VGND sg13g2_buf_1
X_35383_ _11424_ _11423_ VPWR VGND sg13g2_buf_1
X_35384_ _11425_ _11347_ VPWR VGND sg13g2_buf_1
X_35385_ _11426_ _11358_ \csr_i.data_in[18]\ VPWR VGND sg13g2_nor2b_1
X_35386_ _11427_ \csr_i.pc[18]\ _11359_ _11426_ VPWR VGND sg13g2_a21oi_1
X_35387_ _11428_ _11427_ VPWR VGND sg13g2_buf_1
X_35388_ _11429_ _11359_ \csr_i.data_in[19]\ VPWR VGND sg13g2_nor2b_1
X_35389_ _11430_ \csr_i.pc[19]\ _11360_ _11429_ VPWR VGND sg13g2_a21o_1
X_35390_ _11431_ _11430_ VPWR VGND sg13g2_buf_1
X_35391_ _11432_ _11347_ _11431_ VPWR VGND sg13g2_nor2_1
X_35392_ _11433_ _11425_ _11428_ _11432_ VPWR VGND sg13g2_a21oi_1
X_35393_ _11434_ _11421_ VPWR VGND sg13g2_buf_1
X_35394_ _11435_ _11434_ VPWR VGND sg13g2_buf_1
X_35395_ _11436_ _11357_ \csr_i.data_in[16]\ VPWR VGND sg13g2_nor2b_1
X_35396_ _11437_ \csr_i.pc[16]\ _11358_ _11436_ VPWR VGND sg13g2_a21o_1
X_35397_ _11438_ _11437_ VPWR VGND sg13g2_buf_1
X_35398_ _11439_ _11386_ VPWR VGND sg13g2_buf_1
X_35399_ _11440_ _11358_ \csr_i.data_in[17]\ VPWR VGND sg13g2_nor2b_1
X_35400_ _11441_ \csr_i.pc[17]\ _11358_ _11440_ VPWR VGND sg13g2_a21oi_1
X_35401_ _11442_ _11439_ _11441_ VPWR VGND sg13g2_nand2_1
X_35402_ _11443_ _11387_ _11438_ _11442_ VPWR VGND sg13g2_o21ai_1
X_35403_ _11444_ _11435_ _11443_ VPWR VGND sg13g2_nor2_1
X_35404_ _11445_ _11424_ _11433_ _11444_ VPWR VGND sg13g2_a21oi_1
X_35405_ _11446_ \control_i.immediate[1]\ VPWR VGND sg13g2_inv_1
X_35406_ _11447_ _16764_ _11446_ _11344_ VPWR VGND sg13g2_mux2_1
X_35407_ _11448_ _11447_ VPWR VGND sg13g2_buf_4
X_35408_ _11449_ _11448_ VPWR VGND sg13g2_buf_1
X_35409_ _11450_ _11449_ VPWR VGND sg13g2_buf_1
X_35410_ _11451_ \alu_i.instruction[5]\ _13233_ VPWR VGND sg13g2_nand2b_1
X_35411_ _11452_ _11451_ VPWR VGND sg13g2_buf_1
X_35412_ _11453_ \csr_i.data_in[23]\ _11452_ VPWR VGND sg13g2_nand2_1
X_35413_ _11454_ _11453_ VPWR VGND sg13g2_buf_1
X_35414_ _11455_ _11439_ _11454_ VPWR VGND sg13g2_nand2_1
X_35415_ _11456_ _11360_ \csr_i.data_in[22]\ VPWR VGND sg13g2_nor2b_1
X_35416_ _11457_ \csr_i.pc[22]\ _11360_ _11456_ VPWR VGND sg13g2_a21oi_1
X_35417_ _11458_ _11457_ VPWR VGND sg13g2_buf_1
X_35418_ _11459_ _11347_ _11458_ VPWR VGND sg13g2_nand2_1
X_35419_ _11460_ _11455_ _11459_ VPWR VGND sg13g2_nand2_1
X_35420_ _11461_ _11359_ \csr_i.data_in[20]\ VPWR VGND sg13g2_nor2b_1
X_35421_ _11462_ \csr_i.pc[20]\ _11360_ _11461_ VPWR VGND sg13g2_a21o_1
X_35422_ _11463_ _11462_ VPWR VGND sg13g2_buf_1
X_35423_ _11464_ _11439_ _11463_ VPWR VGND sg13g2_nor2_1
X_35424_ _11465_ _11360_ \csr_i.data_in[21]\ VPWR VGND sg13g2_nor2b_1
X_35425_ _11466_ \csr_i.pc[21]\ _11360_ _11465_ VPWR VGND sg13g2_a21o_1
X_35426_ _11467_ _11466_ VPWR VGND sg13g2_buf_1
X_35427_ _11468_ _11347_ _11467_ VPWR VGND sg13g2_nor2_1
X_35428_ _11469_ _11434_ _11464_ _11468_ VPWR VGND sg13g2_or3_1
X_35429_ _11470_ _11450_ _11460_ _11469_ VPWR VGND sg13g2_o21ai_1
X_35430_ _11471_ _11418_ _11470_ VPWR VGND sg13g2_nor2_1
X_35431_ _11472_ _11419_ _11445_ _11471_ VPWR VGND sg13g2_a21oi_1
X_35432_ _11473_ _11413_ VPWR VGND sg13g2_buf_1
X_35433_ _11474_ \memory_i.datain[2]\ \control_i.immediate[2]\ _11383_ VPWR VGND sg13g2_mux2_1
X_35434_ _11475_ _11474_ VPWR VGND sg13g2_buf_4
X_35435_ _11476_ _11475_ VPWR VGND sg13g2_buf_1
X_35436_ _11477_ _11448_ VPWR VGND sg13g2_buf_1
X_35437_ _11478_ _11361_ \csr_i.data_in[29]\ VPWR VGND sg13g2_nor2b_1
X_35438_ _11479_ _11478_ VPWR VGND sg13g2_buf_1
X_35439_ _11480_ \csr_i.data_in[28]\ _11452_ VPWR VGND sg13g2_nand2_1
X_35440_ _11481_ _11480_ VPWR VGND sg13g2_buf_1
X_35441_ _11482_ _11346_ _11481_ VPWR VGND sg13g2_nand2_1
X_35442_ _11483_ _11346_ _11479_ _11482_ VPWR VGND sg13g2_o21ai_1
X_35443_ _11484_ \csr_i.data_in[31]\ _11452_ VPWR VGND sg13g2_nand2_1
X_35444_ _11485_ _11361_ \csr_i.data_in[30]\ VPWR VGND sg13g2_nor2b_1
X_35445_ _11486_ _11485_ VPWR VGND sg13g2_buf_1
X_35446_ _11487_ _11386_ _11486_ VPWR VGND sg13g2_nor2_1
X_35447_ _11488_ _11386_ _11484_ _11487_ VPWR VGND sg13g2_a21oi_1
X_35448_ _11489_ _11488_ VPWR VGND sg13g2_buf_1
X_35449_ _11490_ _11477_ _11489_ VPWR VGND sg13g2_nor2_1
X_35450_ _11491_ _11477_ _11483_ _11490_ VPWR VGND sg13g2_a21oi_1
X_35451_ _11492_ _11361_ \csr_i.data_in[27]\ VPWR VGND sg13g2_nor2b_1
X_35452_ _11493_ _11492_ VPWR VGND sg13g2_buf_1
X_35453_ _11494_ \csr_i.data_in[26]\ _11452_ VPWR VGND sg13g2_nand2_1
X_35454_ _11495_ _11494_ VPWR VGND sg13g2_buf_1
X_35455_ _11496_ _11346_ _11495_ VPWR VGND sg13g2_nand2_1
X_35456_ _11497_ _11346_ _11493_ _11496_ VPWR VGND sg13g2_o21ai_1
X_35457_ _11498_ _11361_ \csr_i.data_in[24]\ VPWR VGND sg13g2_nor2b_1
X_35458_ _11499_ \csr_i.data_in[25]\ _11452_ VPWR VGND sg13g2_nand2_1
X_35459_ _11500_ _11499_ VPWR VGND sg13g2_buf_1
X_35460_ _11501_ _11386_ _11500_ VPWR VGND sg13g2_nand2_1
X_35461_ _11502_ _11439_ _11498_ _11501_ VPWR VGND sg13g2_o21ai_1
X_35462_ _11503_ _11497_ _11502_ _11477_ VPWR VGND sg13g2_mux2_1
X_35463_ _11504_ _11476_ _11503_ VPWR VGND sg13g2_nor2_1
X_35464_ _11505_ _11476_ _11491_ _11504_ VPWR VGND sg13g2_a21oi_1
X_35465_ _11506_ _11473_ _11505_ VPWR VGND sg13g2_nand2_1
X_35466_ _11507_ _11414_ _11472_ _11506_ VPWR VGND sg13g2_o21ai_1
X_35467_ _11508_ _11402_ VPWR VGND sg13g2_buf_1
X_35468_ _11509_ \control_i.immediate[3]\ _11383_ _11409_ VPWR VGND sg13g2_a21oi_1
X_35469_ _11510_ _11509_ VPWR VGND sg13g2_buf_1
X_35470_ _11511_ _11510_ VPWR VGND sg13g2_buf_1
X_35471_ _11512_ _11511_ VPWR VGND sg13g2_buf_1
X_35472_ _11513_ _11512_ VPWR VGND sg13g2_buf_1
X_35473_ _11514_ _11418_ VPWR VGND sg13g2_buf_1
X_35474_ _11515_ _11357_ \csr_i.data_in[12]\ VPWR VGND sg13g2_nor2b_1
X_35475_ _11516_ \csr_i.pc[12]\ _11357_ _11515_ VPWR VGND sg13g2_a21o_1
X_35476_ _11517_ _11516_ VPWR VGND sg13g2_buf_1
X_35477_ _11518_ _11356_ \csr_i.data_in[13]\ VPWR VGND sg13g2_nor2b_1
X_35478_ _11519_ \csr_i.pc[13]\ _11359_ _11518_ VPWR VGND sg13g2_a21oi_1
X_35479_ _11520_ _11519_ VPWR VGND sg13g2_buf_1
X_35480_ _11521_ _11388_ _11520_ VPWR VGND sg13g2_nand2_1
X_35481_ _11522_ _11388_ _11517_ _11521_ VPWR VGND sg13g2_o21ai_1
X_35482_ _11523_ _11357_ \csr_i.data_in[14]\ VPWR VGND sg13g2_nor2b_1
X_35483_ _11524_ \csr_i.pc[14]\ _11358_ _11523_ VPWR VGND sg13g2_a21oi_1
X_35484_ _11525_ _11524_ VPWR VGND sg13g2_buf_1
X_35485_ _11526_ \csr_i.data_in[15]\ \csr_i.pc[15]\ _11357_ VPWR VGND sg13g2_mux2_1
X_35486_ _11527_ _11526_ VPWR VGND sg13g2_buf_1
X_35487_ _11528_ _11347_ _11527_ VPWR VGND sg13g2_nor2_1
X_35488_ _11529_ _11347_ _11525_ _11528_ VPWR VGND sg13g2_a21oi_1
X_35489_ _11530_ _11424_ _11529_ VPWR VGND sg13g2_nand2_1
X_35490_ _11531_ _11424_ _11522_ _11530_ VPWR VGND sg13g2_o21ai_1
X_35491_ _11532_ _11475_ VPWR VGND sg13g2_buf_1
X_35492_ _11533_ _11357_ \csr_i.data_in[10]\ VPWR VGND sg13g2_nor2b_1
X_35493_ _11534_ \csr_i.pc[10]\ _11357_ _11533_ VPWR VGND sg13g2_a21o_1
X_35494_ _11535_ _11534_ VPWR VGND sg13g2_buf_1
X_35495_ _11536_ _11448_ _11535_ VPWR VGND sg13g2_nor2_1
X_35496_ _11537_ _11356_ \csr_i.data_in[8]\ VPWR VGND sg13g2_nor2b_1
X_35497_ _11538_ \csr_i.pc[8]\ _11357_ _11537_ VPWR VGND sg13g2_a21oi_1
X_35498_ _11539_ _11538_ VPWR VGND sg13g2_buf_1
X_35499_ _11540_ _11448_ _11539_ VPWR VGND sg13g2_nand2_1
X_35500_ _11541_ _11536_ _11540_ VPWR VGND sg13g2_nor2b_1
X_35501_ _11542_ \csr_i.data_in[11]\ \csr_i.pc[11]\ _11357_ VPWR VGND sg13g2_mux2_1
X_35502_ _11543_ _11542_ VPWR VGND sg13g2_buf_1
X_35503_ _11544_ _11449_ _11543_ VPWR VGND sg13g2_nor2_1
X_35504_ _11545_ \csr_i.data_in[9]\ \csr_i.pc[9]\ _11356_ VPWR VGND sg13g2_mux2_1
X_35505_ _11546_ _11545_ VPWR VGND sg13g2_buf_1
X_35506_ _11547_ _11421_ _11546_ VPWR VGND sg13g2_nor2_1
X_35507_ _11548_ _11425_ _11544_ _11547_ VPWR VGND sg13g2_nor3_1
X_35508_ _11549_ _11348_ _11541_ _11548_ VPWR VGND sg13g2_a21o_1
X_35509_ _11550_ _11532_ _11549_ VPWR VGND sg13g2_or2_1
X_35510_ _11551_ _11514_ _11531_ _11550_ VPWR VGND sg13g2_o21ai_1
X_35511_ _11552_ _11511_ VPWR VGND sg13g2_buf_1
X_35512_ _11553_ _11419_ VPWR VGND sg13g2_buf_1
X_35513_ _11554_ _11435_ VPWR VGND sg13g2_buf_1
X_35514_ _11555_ _11355_ \csr_i.data_in[3]\ VPWR VGND sg13g2_nor2b_1
X_35515_ _11556_ \csr_i.pc[3]\ _11355_ _11555_ VPWR VGND sg13g2_a21oi_1
X_35516_ _11557_ _11556_ VPWR VGND sg13g2_buf_2
X_35517_ _11558_ _11354_ \csr_i.data_in[1]\ VPWR VGND sg13g2_nor2b_1
X_35518_ _11559_ \csr_i.pc[1]\ _11355_ _11558_ VPWR VGND sg13g2_a21o_1
X_35519_ _11560_ _11559_ VPWR VGND sg13g2_buf_1
X_35520_ _11561_ _11424_ _11560_ VPWR VGND sg13g2_nor2_1
X_35521_ _11562_ _11554_ _11557_ _11561_ VPWR VGND sg13g2_a21oi_1
X_35522_ _11563_ _11390_ _11562_ VPWR VGND sg13g2_nand2_1
X_35523_ _11564_ _11477_ VPWR VGND sg13g2_buf_1
X_35524_ _11565_ _11564_ VPWR VGND sg13g2_buf_1
X_35525_ _11566_ \csr_i.data_in[2]\ \csr_i.pc[2]\ _11355_ VPWR VGND sg13g2_mux2_1
X_35526_ _11567_ _11566_ VPWR VGND sg13g2_buf_2
X_35527_ _11568_ _11449_ _11567_ VPWR VGND sg13g2_nor2_1
X_35528_ _11569_ _11374_ _11565_ _11568_ VPWR VGND sg13g2_a21oi_1
X_35529_ _11570_ _11349_ _11569_ VPWR VGND sg13g2_nand2_1
X_35530_ _11571_ _11553_ _11563_ _11570_ VPWR VGND sg13g2_nand3_1
X_35531_ _11572_ _11476_ VPWR VGND sg13g2_buf_1
X_35532_ _11573_ _11572_ VPWR VGND sg13g2_buf_1
X_35533_ _11574_ _11355_ \csr_i.data_in[7]\ VPWR VGND sg13g2_nor2b_1
X_35534_ _11575_ \csr_i.pc[7]\ _11359_ _11574_ VPWR VGND sg13g2_a21oi_1
X_35535_ _11576_ _11575_ VPWR VGND sg13g2_buf_1
X_35536_ _11577_ \csr_i.data_in[5]\ \csr_i.pc[5]\ _11355_ VPWR VGND sg13g2_mux2_1
X_35537_ _11578_ _11577_ VPWR VGND sg13g2_buf_1
X_35538_ _11579_ _11421_ _11578_ VPWR VGND sg13g2_nor2_1
X_35539_ _11580_ _11435_ _11576_ _11579_ VPWR VGND sg13g2_a21oi_1
X_35540_ _11581_ _11355_ \csr_i.data_in[4]\ VPWR VGND sg13g2_nor2b_1
X_35541_ _11582_ \csr_i.pc[4]\ _11356_ _11581_ VPWR VGND sg13g2_a21o_1
X_35542_ _11583_ _11582_ VPWR VGND sg13g2_buf_1
X_35543_ _11584_ _11355_ \csr_i.data_in[6]\ VPWR VGND sg13g2_nor2b_1
X_35544_ _11585_ \csr_i.pc[6]\ _11358_ _11584_ VPWR VGND sg13g2_a21oi_1
X_35545_ _11586_ _11421_ _11585_ VPWR VGND sg13g2_nand2_1
X_35546_ _11587_ _11435_ _11583_ _11586_ VPWR VGND sg13g2_o21ai_1
X_35547_ _11588_ _11389_ _11587_ VPWR VGND sg13g2_nor2_1
X_35548_ _11589_ _11389_ _11580_ _11588_ VPWR VGND sg13g2_a21oi_1
X_35549_ _11590_ _11573_ _11589_ VPWR VGND sg13g2_nand2_1
X_35550_ _11591_ _11552_ _11571_ _11590_ VPWR VGND sg13g2_nand3_1
X_35551_ _11592_ _11513_ _11551_ _11591_ VPWR VGND sg13g2_o21ai_1
X_35552_ _11593_ _11508_ _11592_ VPWR VGND sg13g2_nand2_1
X_35553_ _11594_ _11404_ _11507_ _11593_ VPWR VGND sg13g2_o21ai_1
X_35554_ _11595_ _13221_ VPWR VGND sg13g2_buf_1
X_35555_ _11596_ \control_i.immediate[4]\ _11383_ _11400_ VPWR VGND sg13g2_a21o_1
X_35556_ _11597_ _11596_ VPWR VGND sg13g2_buf_1
X_35557_ _11598_ _11597_ VPWR VGND sg13g2_buf_1
X_35558_ _11599_ _11598_ VPWR VGND sg13g2_buf_1
X_35559_ _11600_ _11599_ VPWR VGND sg13g2_buf_1
X_35560_ _11601_ _11374_ _11389_ VPWR VGND sg13g2_nor2_1
X_35561_ _11602_ _13246_ _11412_ VPWR VGND sg13g2_nor2_1
X_35562_ _11603_ _11422_ _11475_ VPWR VGND sg13g2_nor2_1
X_35563_ _11604_ _11603_ VPWR VGND sg13g2_buf_1
X_35564_ _11605_ _11601_ _11602_ _11604_ VPWR VGND sg13g2_nand3_1
X_35565_ _11606_ _11600_ _11605_ VPWR VGND sg13g2_nor2_1
X_35566_ _11607_ _11375_ _11397_ _11594_ _11595_ _11606_
+ VPWR
+ VGND sg13g2_a221oi_1
X_35567_ _11608_ _11361_ \csr_i.data_in[28]\ VPWR VGND sg13g2_nor2b_1
X_35568_ _11609_ \memory_i.datain[28]\ \control_i.immediate[28]\ _11408_ VPWR VGND sg13g2_mux2_1
X_35569_ _11610_ _11609_ VPWR VGND sg13g2_buf_1
X_35570_ _11611_ _11608_ _11610_ VPWR VGND sg13g2_nor2_1
X_35571_ _11612_ _11608_ _11610_ VPWR VGND sg13g2_nand2_1
X_35572_ _11613_ _11611_ _11612_ VPWR VGND sg13g2_nand2b_1
X_35573_ _11614_ \memory_i.datain[30]\ \control_i.immediate[30]\ _11408_ VPWR VGND sg13g2_mux2_1
X_35574_ _11615_ _11614_ VPWR VGND sg13g2_buf_1
X_35575_ _11616_ _11486_ _11615_ VPWR VGND sg13g2_xnor2_1
X_35576_ _11617_ _11407_ \memory_i.datain[29]\ VPWR VGND sg13g2_nor2b_1
X_35577_ _11618_ \control_i.immediate[29]\ _11408_ _11617_ VPWR VGND sg13g2_a21o_1
X_35578_ _11619_ _11618_ VPWR VGND sg13g2_buf_1
X_35579_ _11620_ _11479_ _11619_ VPWR VGND sg13g2_nor2_1
X_35580_ _11621_ _11479_ _11619_ VPWR VGND sg13g2_nand2_1
X_35581_ _11622_ _11620_ _11621_ VPWR VGND sg13g2_nand2b_1
X_35582_ _11623_ _11622_ VPWR VGND sg13g2_buf_1
X_35583_ _11624_ _11361_ \csr_i.data_in[31]\ VPWR VGND sg13g2_nor2b_1
X_35584_ _11625_ _11624_ VPWR VGND sg13g2_buf_1
X_35585_ _11626_ \memory_i.datain[31]\ \control_i.immediate[31]\ _11408_ VPWR VGND sg13g2_mux2_1
X_35586_ _11627_ _11626_ VPWR VGND sg13g2_buf_1
X_35587_ _11628_ _11625_ _11627_ VPWR VGND sg13g2_xnor2_1
X_35588_ _11629_ _11628_ VPWR VGND sg13g2_buf_1
X_35589_ _11630_ _11613_ _11616_ _11623_ _11629_ VPWR
+ VGND
+ sg13g2_nand4_1
X_35590_ _11631_ \csr_i.pc[14]\ _11359_ _11523_ VPWR VGND sg13g2_a21o_1
X_35591_ _11632_ _11631_ VPWR VGND sg13g2_buf_1
X_35592_ _11633_ _11399_ \memory_i.datain[14]\ VPWR VGND sg13g2_nor2b_1
X_35593_ _11634_ \control_i.immediate[14]\ _11405_ _11633_ VPWR VGND sg13g2_a21oi_1
X_35594_ _11635_ _11634_ VPWR VGND sg13g2_buf_1
X_35595_ _11636_ _11632_ _11635_ VPWR VGND sg13g2_xnor2_1
X_35596_ _11637_ \memory_i.datain[13]\ \control_i.immediate[13]\ _11399_ VPWR VGND sg13g2_mux2_1
X_35597_ _11638_ _11637_ VPWR VGND sg13g2_buf_1
X_35598_ _11639_ _11520_ _11638_ VPWR VGND sg13g2_xnor2_1
X_35599_ _11640_ \memory_i.datain[15]\ \control_i.immediate[15]\ _11399_ VPWR VGND sg13g2_mux2_1
X_35600_ _11641_ _11640_ VPWR VGND sg13g2_buf_1
X_35601_ _11642_ _11527_ _11641_ VPWR VGND sg13g2_xor2_1
X_35602_ _11643_ \csr_i.pc[12]\ _11358_ _11515_ VPWR VGND sg13g2_a21oi_1
X_35603_ _11644_ _11643_ VPWR VGND sg13g2_buf_1
X_35604_ _11645_ \memory_i.datain[12]\ \control_i.immediate[12]\ _11399_ VPWR VGND sg13g2_mux2_1
X_35605_ _11646_ _11645_ VPWR VGND sg13g2_buf_1
X_35606_ _11647_ _11644_ _11646_ VPWR VGND sg13g2_xnor2_1
X_35607_ _11648_ _11636_ _11639_ _11642_ _11647_ VPWR
+ VGND
+ sg13g2_nor4_1
X_35608_ _11649_ \memory_i.datain[7]\ \control_i.immediate[7]\ _11383_ VPWR VGND sg13g2_mux2_1
X_35609_ _11650_ _11649_ VPWR VGND sg13g2_buf_1
X_35610_ _11651_ _11650_ VPWR VGND sg13g2_inv_1
X_35611_ _11652_ _11398_ \memory_i.datain[6]\ VPWR VGND sg13g2_nor2b_1
X_35612_ _11653_ \control_i.immediate[6]\ _11398_ _11652_ VPWR VGND sg13g2_a21o_1
X_35613_ _11654_ _11653_ VPWR VGND sg13g2_buf_1
X_35614_ _11655_ _11567_ VPWR VGND sg13g2_inv_1
X_35615_ _11656_ _11475_ _11655_ VPWR VGND sg13g2_nand2_1
X_35616_ _11657_ _11475_ _11655_ VPWR VGND sg13g2_nor2_1
X_35617_ _11658_ \csr_i.pc[1]\ _11355_ _11558_ VPWR VGND sg13g2_a21oi_1
X_35618_ _11659_ _11658_ VPWR VGND sg13g2_buf_1
X_35619_ _11660_ _11421_ _11659_ VPWR VGND sg13g2_nor2_1
X_35620_ _11661_ _11374_ _11385_ _11421_ _11659_ VPWR
+ VGND
+ sg13g2_a22oi_1
X_35621_ _11662_ _11657_ _11660_ _11661_ VPWR VGND sg13g2_or3_1
X_35622_ _11663_ _11662_ VPWR VGND sg13g2_buf_1
X_35623_ _11664_ _11510_ _11656_ _11663_ VPWR VGND sg13g2_nand3_1
X_35624_ _11665_ _11656_ _11663_ _11510_ VPWR VGND sg13g2_a21oi_1
X_35625_ _11666_ _11557_ _11664_ _11665_ VPWR VGND sg13g2_a21oi_1
X_35626_ _11667_ _11401_ _11666_ _11583_ VPWR VGND sg13g2_o21ai_1
X_35627_ _11668_ _11402_ _11666_ VPWR VGND sg13g2_nand2_1
X_35628_ _11669_ _11383_ \memory_i.datain[5]\ VPWR VGND sg13g2_nor2b_1
X_35629_ _11670_ \control_i.immediate[5]\ _11398_ _11669_ VPWR VGND sg13g2_a21o_1
X_35630_ _11671_ _11670_ VPWR VGND sg13g2_buf_1
X_35631_ _11672_ _11667_ _11668_ _11671_ VPWR VGND sg13g2_a21oi_1
X_35632_ _11673_ _11671_ _11667_ _11668_ VPWR VGND sg13g2_nand3_1
X_35633_ _11674_ _11578_ _11672_ _11673_ VPWR VGND sg13g2_o21ai_1
X_35634_ _11675_ _11674_ VPWR VGND sg13g2_buf_1
X_35635_ _11676_ _11654_ _11675_ _11585_ VPWR VGND sg13g2_o21ai_1
X_35636_ _11677_ _11654_ _11675_ VPWR VGND sg13g2_nand2_1
X_35637_ _11678_ _11651_ _11676_ _11677_ VPWR VGND sg13g2_nand3_1
X_35638_ _11679_ _11676_ _11677_ _11651_ VPWR VGND sg13g2_a21oi_1
X_35639_ _11680_ _11576_ _11678_ _11679_ VPWR VGND sg13g2_a21o_1
X_35640_ _11681_ _11680_ VPWR VGND sg13g2_buf_1
X_35641_ _11682_ \csr_i.pc[10]\ _11358_ _11533_ VPWR VGND sg13g2_a21oi_1
X_35642_ _11683_ _11398_ \memory_i.datain[10]\ VPWR VGND sg13g2_nor2b_1
X_35643_ _11684_ \control_i.immediate[10]\ _11398_ _11683_ VPWR VGND sg13g2_a21o_1
X_35644_ _11685_ _11684_ VPWR VGND sg13g2_buf_1
X_35645_ _11686_ _11682_ _11685_ VPWR VGND sg13g2_nand2_1
X_35646_ _11687_ \control_i.immediate[10]\ _11399_ _11683_ VPWR VGND sg13g2_a21oi_1
X_35647_ _11688_ _11687_ VPWR VGND sg13g2_buf_1
X_35648_ _11689_ _11535_ _11688_ VPWR VGND sg13g2_nand2_1
X_35649_ _11690_ _11686_ _11689_ VPWR VGND sg13g2_nand2_1
X_35650_ _11691_ \memory_i.datain[9]\ \control_i.immediate[9]\ _11398_ VPWR VGND sg13g2_mux2_1
X_35651_ _11692_ _11691_ VPWR VGND sg13g2_buf_1
X_35652_ _11693_ _11546_ _11692_ VPWR VGND sg13g2_nor2b_1
X_35653_ _11694_ _11692_ _11546_ VPWR VGND sg13g2_nand2b_1
X_35654_ _11695_ _11693_ _11694_ VPWR VGND sg13g2_nand2b_1
X_35655_ _11696_ \csr_i.pc[8]\ _11356_ _11537_ VPWR VGND sg13g2_a21o_1
X_35656_ _11697_ _11696_ VPWR VGND sg13g2_buf_1
X_35657_ _11698_ _11398_ \memory_i.datain[8]\ VPWR VGND sg13g2_nor2b_1
X_35658_ _11699_ \control_i.immediate[8]\ _11399_ _11698_ VPWR VGND sg13g2_a21oi_1
X_35659_ _11700_ _11697_ _11699_ VPWR VGND sg13g2_xnor2_1
X_35660_ _11701_ \memory_i.datain[11]\ \control_i.immediate[11]\ _11399_ VPWR VGND sg13g2_mux2_1
X_35661_ _11702_ _11701_ VPWR VGND sg13g2_buf_1
X_35662_ _11703_ _11543_ _11702_ VPWR VGND sg13g2_nand2b_1
X_35663_ _11704_ _11702_ _11543_ VPWR VGND sg13g2_nand2b_1
X_35664_ _11705_ _11703_ _11704_ VPWR VGND sg13g2_nand2_1
X_35665_ _11706_ _11690_ _11695_ _11700_ _11705_ VPWR
+ VGND
+ sg13g2_nor4_1
X_35666_ _11707_ _11706_ VPWR VGND sg13g2_inv_1
X_35667_ _11708_ _11697_ _11699_ VPWR VGND sg13g2_nand2_1
X_35668_ _11709_ _11693_ _11708_ _11694_ VPWR VGND sg13g2_o21ai_1
X_35669_ _11710_ _11686_ _11709_ VPWR VGND sg13g2_nand2_1
X_35670_ _11711_ _11689_ _11704_ _11710_ VPWR VGND sg13g2_nand3_1
X_35671_ _11712_ _11703_ _11711_ VPWR VGND sg13g2_nand2_1
X_35672_ _11713_ _11681_ _11707_ _11712_ VPWR VGND sg13g2_o21ai_1
X_35673_ _11714_ _11713_ VPWR VGND sg13g2_buf_1
X_35674_ _11715_ \control_i.immediate[14]\ _11405_ _11633_ VPWR VGND sg13g2_a21o_1
X_35675_ _11716_ _11715_ VPWR VGND sg13g2_buf_1
X_35676_ _11717_ _11525_ _11716_ VPWR VGND sg13g2_nand2_1
X_35677_ _11718_ \csr_i.pc[13]\ _11356_ _11518_ VPWR VGND sg13g2_a21o_1
X_35678_ _11719_ _11718_ VPWR VGND sg13g2_buf_1
X_35679_ _11720_ _11644_ _11638_ _11646_ VPWR VGND sg13g2_nor3_1
X_35680_ _11721_ _11644_ _11646_ _11638_ VPWR VGND sg13g2_o21ai_1
X_35681_ _11722_ _11719_ _11720_ _11721_ VPWR VGND sg13g2_o21ai_1
X_35682_ _11723_ _11722_ VPWR VGND sg13g2_inv_1
X_35683_ _11724_ _11525_ _11716_ VPWR VGND sg13g2_nor2_1
X_35684_ _11725_ _11717_ _11723_ _11724_ VPWR VGND sg13g2_a21oi_1
X_35685_ _11726_ _11641_ _11725_ VPWR VGND sg13g2_nor2_1
X_35686_ _11727_ _11527_ _11726_ VPWR VGND sg13g2_nor2_1
X_35687_ _11728_ _11641_ _11725_ _11727_ VPWR VGND sg13g2_a21oi_1
X_35688_ _11729_ _11648_ _11714_ _11728_ VPWR VGND sg13g2_a21o_1
X_35689_ _11730_ \csr_i.pc[19]\ _11359_ _11429_ VPWR VGND sg13g2_a21oi_1
X_35690_ _11731_ \memory_i.datain[19]\ \control_i.immediate[19]\ _11405_ VPWR VGND sg13g2_mux2_1
X_35691_ _11732_ _11731_ VPWR VGND sg13g2_buf_1
X_35692_ _11733_ _11730_ _11732_ VPWR VGND sg13g2_xnor2_1
X_35693_ _11734_ \csr_i.pc[18]\ _11359_ _11426_ VPWR VGND sg13g2_a21o_1
X_35694_ _11735_ _11734_ VPWR VGND sg13g2_buf_1
X_35695_ _11736_ _11405_ \memory_i.datain[18]\ VPWR VGND sg13g2_nor2b_1
X_35696_ _11737_ \control_i.immediate[18]\ _11406_ _11736_ VPWR VGND sg13g2_a21oi_1
X_35697_ _11738_ _11735_ _11737_ VPWR VGND sg13g2_nand2_1
X_35698_ _11739_ \control_i.immediate[18]\ _11406_ _11736_ VPWR VGND sg13g2_a21o_1
X_35699_ _11740_ _11739_ VPWR VGND sg13g2_buf_1
X_35700_ _11741_ _11428_ _11740_ VPWR VGND sg13g2_nand2_1
X_35701_ _11742_ _11738_ _11741_ VPWR VGND sg13g2_nand2_1
X_35702_ _11743_ \csr_i.pc[17]\ _11358_ _11440_ VPWR VGND sg13g2_a21o_1
X_35703_ _11744_ _11743_ VPWR VGND sg13g2_buf_1
X_35704_ _11745_ _11405_ \memory_i.datain[17]\ VPWR VGND sg13g2_nor2b_1
X_35705_ _11746_ \control_i.immediate[17]\ _11405_ _11745_ VPWR VGND sg13g2_a21oi_1
X_35706_ _11747_ _11744_ _11746_ VPWR VGND sg13g2_nand2_1
X_35707_ _11748_ \control_i.immediate[17]\ _11405_ _11745_ VPWR VGND sg13g2_a21o_1
X_35708_ _11749_ _11748_ VPWR VGND sg13g2_buf_1
X_35709_ _11750_ _11441_ _11749_ VPWR VGND sg13g2_nand2_1
X_35710_ _11751_ _11747_ _11750_ VPWR VGND sg13g2_nand2_1
X_35711_ _11752_ _11399_ \memory_i.datain[16]\ VPWR VGND sg13g2_nor2b_1
X_35712_ _11753_ \control_i.immediate[16]\ _11405_ _11752_ VPWR VGND sg13g2_a21oi_1
X_35713_ _11754_ _11438_ _11753_ VPWR VGND sg13g2_nand2_1
X_35714_ _11755_ \csr_i.pc[16]\ _11359_ _11436_ VPWR VGND sg13g2_a21oi_1
X_35715_ _11756_ \control_i.immediate[16]\ _11405_ _11752_ VPWR VGND sg13g2_a21o_1
X_35716_ _11757_ _11756_ VPWR VGND sg13g2_buf_1
X_35717_ _11758_ _11755_ _11757_ VPWR VGND sg13g2_nand2_1
X_35718_ _11759_ _11754_ _11758_ VPWR VGND sg13g2_nand2_1
X_35719_ _11760_ _11733_ _11742_ _11751_ _11759_ VPWR
+ VGND
+ sg13g2_nor4_1
X_35720_ _11761_ _11747_ _11754_ VPWR VGND sg13g2_nand2_1
X_35721_ _11762_ _11741_ _11750_ _11761_ VPWR VGND sg13g2_nand3_1
X_35722_ _11763_ _11738_ _11762_ VPWR VGND sg13g2_and2_1
X_35723_ _11764_ _11732_ _11763_ VPWR VGND sg13g2_nand2_1
X_35724_ _11765_ _11732_ _11763_ _11730_ VPWR VGND sg13g2_o21ai_1
X_35725_ _11766_ _11729_ _11760_ _11764_ _11765_ VPWR
+ VGND
+ sg13g2_a22oi_1
X_35726_ _11767_ _11766_ VPWR VGND sg13g2_buf_1
X_35727_ _11768_ \memory_i.datain[22]\ \control_i.immediate[22]\ _11406_ VPWR VGND sg13g2_mux2_1
X_35728_ _11769_ _11768_ VPWR VGND sg13g2_buf_1
X_35729_ _11770_ \csr_i.pc[22]\ _11361_ _11456_ VPWR VGND sg13g2_a21o_1
X_35730_ _11771_ _11770_ VPWR VGND sg13g2_buf_1
X_35731_ _11772_ _11769_ _11771_ VPWR VGND sg13g2_nand2b_1
X_35732_ _11773_ _11458_ _11769_ VPWR VGND sg13g2_nand2_1
X_35733_ _11774_ _11772_ _11773_ VPWR VGND sg13g2_nand2_1
X_35734_ _11775_ _11406_ \memory_i.datain[20]\ VPWR VGND sg13g2_nor2b_1
X_35735_ _11776_ \control_i.immediate[20]\ _11406_ _11775_ VPWR VGND sg13g2_a21oi_1
X_35736_ _11777_ _11776_ VPWR VGND sg13g2_buf_1
X_35737_ _11778_ _11463_ _11777_ VPWR VGND sg13g2_nand2_1
X_35738_ _11779_ \csr_i.pc[20]\ _11360_ _11461_ VPWR VGND sg13g2_a21oi_1
X_35739_ _11780_ _11779_ VPWR VGND sg13g2_buf_1
X_35740_ _11781_ \control_i.immediate[20]\ _11407_ _11775_ VPWR VGND sg13g2_a21o_1
X_35741_ _11782_ _11781_ VPWR VGND sg13g2_buf_1
X_35742_ _11783_ _11780_ _11782_ VPWR VGND sg13g2_nand2_1
X_35743_ _11784_ _11778_ _11783_ VPWR VGND sg13g2_nand2_1
X_35744_ _11785_ _11406_ \memory_i.datain[21]\ VPWR VGND sg13g2_nor2b_1
X_35745_ _11786_ \control_i.immediate[21]\ _11406_ _11785_ VPWR VGND sg13g2_a21oi_1
X_35746_ _11787_ _11786_ VPWR VGND sg13g2_buf_1
X_35747_ _11788_ _11467_ _11787_ VPWR VGND sg13g2_xnor2_1
X_35748_ _11789_ _11406_ \memory_i.datain[23]\ VPWR VGND sg13g2_nor2b_1
X_35749_ _11790_ \control_i.immediate[23]\ _11406_ _11789_ VPWR VGND sg13g2_a21oi_1
X_35750_ _11791_ _11790_ VPWR VGND sg13g2_buf_1
X_35751_ _11792_ _11454_ _11791_ VPWR VGND sg13g2_nand2_1
X_35752_ _11793_ _11360_ \csr_i.data_in[23]\ VPWR VGND sg13g2_nor2b_1
X_35753_ _11794_ _11793_ VPWR VGND sg13g2_buf_1
X_35754_ _11795_ _11791_ _11794_ VPWR VGND sg13g2_nand2b_1
X_35755_ _11796_ _11792_ _11795_ VPWR VGND sg13g2_and2_1
X_35756_ _11797_ _11796_ VPWR VGND sg13g2_buf_1
X_35757_ _11798_ _11774_ _11784_ _11788_ _11797_ VPWR
+ VGND
+ sg13g2_or4_1
X_35758_ _11799_ _11794_ _11791_ VPWR VGND sg13g2_nand2_1
X_35759_ _11800_ \csr_i.pc[21]\ _11360_ _11465_ VPWR VGND sg13g2_a21oi_1
X_35760_ _11801_ _11800_ VPWR VGND sg13g2_buf_1
X_35761_ _11802_ \control_i.immediate[21]\ _11407_ _11785_ VPWR VGND sg13g2_a21o_1
X_35762_ _11803_ _11802_ VPWR VGND sg13g2_buf_1
X_35763_ _11804_ _11801_ _11803_ VPWR VGND sg13g2_nand2_1
X_35764_ _11805_ _11801_ _11803_ _11778_ VPWR VGND sg13g2_o21ai_1
X_35765_ _11806_ _11773_ _11804_ _11805_ VPWR VGND sg13g2_nand3_1
X_35766_ _11807_ _11772_ _11799_ _11806_ VPWR VGND sg13g2_nand3_1
X_35767_ _11808_ _11794_ _11791_ _11807_ VPWR VGND sg13g2_o21ai_1
X_35768_ _11809_ _11767_ _11798_ _11808_ VPWR VGND sg13g2_o21ai_1
X_35769_ _11810_ _11407_ \memory_i.datain[25]\ VPWR VGND sg13g2_nor2b_1
X_35770_ _11811_ \control_i.immediate[25]\ _11407_ _11810_ VPWR VGND sg13g2_a21oi_1
X_35771_ _11812_ _11811_ VPWR VGND sg13g2_buf_1
X_35772_ _11813_ _11500_ _11812_ VPWR VGND sg13g2_xnor2_1
X_35773_ _11814_ \csr_i.data_in[24]\ _11452_ VPWR VGND sg13g2_nand2_1
X_35774_ _11815_ _11814_ VPWR VGND sg13g2_buf_1
X_35775_ _11816_ _11407_ \memory_i.datain[24]\ VPWR VGND sg13g2_nor2b_1
X_35776_ _11817_ \control_i.immediate[24]\ _11407_ _11816_ VPWR VGND sg13g2_a21oi_1
X_35777_ _11818_ _11817_ VPWR VGND sg13g2_buf_1
X_35778_ _11819_ _11815_ _11818_ VPWR VGND sg13g2_xnor2_1
X_35779_ _11820_ \csr_i.data_in[27]\ _11452_ VPWR VGND sg13g2_nand2_1
X_35780_ _11821_ _11820_ VPWR VGND sg13g2_buf_1
X_35781_ _11822_ \memory_i.datain[27]\ \control_i.immediate[27]\ _11407_ VPWR VGND sg13g2_mux2_1
X_35782_ _11823_ _11822_ VPWR VGND sg13g2_buf_1
X_35783_ _11824_ _11821_ _11823_ VPWR VGND sg13g2_xnor2_1
X_35784_ _11825_ _11824_ VPWR VGND sg13g2_inv_1
X_35785_ _11826_ \memory_i.datain[26]\ \control_i.immediate[26]\ _11407_ VPWR VGND sg13g2_mux2_1
X_35786_ _11827_ _11826_ VPWR VGND sg13g2_buf_1
X_35787_ _11828_ _11827_ _11495_ VPWR VGND sg13g2_nand2b_1
X_35788_ _11829_ _11361_ \csr_i.data_in[26]\ VPWR VGND sg13g2_nor2b_1
X_35789_ _11830_ _11829_ _11827_ VPWR VGND sg13g2_nand2_1
X_35790_ _11831_ _11828_ _11830_ VPWR VGND sg13g2_nand2_1
X_35791_ _11832_ _11813_ _11819_ _11825_ _11831_ VPWR
+ VGND
+ sg13g2_nand4_1
X_35792_ _11833_ _11832_ VPWR VGND sg13g2_inv_1
X_35793_ _11834_ _11821_ _11823_ VPWR VGND sg13g2_nand2_1
X_35794_ _11835_ _11821_ _11823_ VPWR VGND sg13g2_nor2_1
X_35795_ _11836_ _11812_ VPWR VGND sg13g2_inv_1
X_35796_ _11837_ _11361_ \csr_i.data_in[25]\ VPWR VGND sg13g2_nor2b_1
X_35797_ _11838_ _11837_ _11812_ _11818_ _11498_ VPWR
+ VGND
+ sg13g2_a22oi_1
X_35798_ _11839_ _11500_ _11836_ _11827_ _11495_ _11838_
+ VPWR
+ VGND sg13g2_a221oi_1
X_35799_ _11840_ _11495_ _11827_ VPWR VGND sg13g2_nor2_1
X_35800_ _11841_ _11835_ _11839_ _11840_ VPWR VGND sg13g2_or3_1
X_35801_ _11842_ _11809_ _11833_ _11834_ _11841_ VPWR
+ VGND
+ sg13g2_a22oi_1
X_35802_ _11843_ _11842_ VPWR VGND sg13g2_buf_1
X_35803_ _11844_ \csr_i.data_in[30]\ _11452_ VPWR VGND sg13g2_nand2_1
X_35804_ _11845_ _11844_ VPWR VGND sg13g2_buf_1
X_35805_ _11846_ _11845_ _11615_ VPWR VGND sg13g2_nand2_1
X_35806_ _11847_ \csr_i.data_in[29]\ _11452_ VPWR VGND sg13g2_nand2_1
X_35807_ _11848_ \control_i.immediate[29]\ _11408_ _11617_ VPWR VGND sg13g2_a21oi_1
X_35808_ _11849_ _11481_ _11610_ VPWR VGND sg13g2_nor2_1
X_35809_ _11850_ _11479_ _11848_ _11849_ VPWR VGND sg13g2_o21ai_1
X_35810_ _11851_ _11847_ _11619_ _11850_ VPWR VGND sg13g2_o21ai_1
X_35811_ _11852_ _11845_ _11615_ VPWR VGND sg13g2_nor2_1
X_35812_ _11853_ _11846_ _11851_ _11852_ VPWR VGND sg13g2_a21oi_1
X_35813_ _11854_ _11484_ VPWR VGND sg13g2_buf_1
X_35814_ _11855_ _11627_ _11853_ _11854_ VPWR VGND sg13g2_o21ai_1
X_35815_ _11856_ _11627_ _11853_ VPWR VGND sg13g2_nand2_1
X_35816_ _11857_ _11855_ _11856_ VPWR VGND sg13g2_nand2_1
X_35817_ _11858_ _11630_ _11843_ _11857_ VPWR VGND sg13g2_o21ai_1
X_35818_ _11859_ _11858_ VPWR VGND sg13g2_buf_1
X_35819_ _11860_ \alu_i.funct3[0]\ _11629_ VPWR VGND sg13g2_nor2_1
X_35820_ _11861_ _11859_ _11860_ VPWR VGND sg13g2_xnor2_1
X_35821_ _11862_ _13201_ _13204_ _11861_ VPWR VGND sg13g2_nand3_1
X_35822_ _02183_ _11607_ _11862_ _11324_ VPWR VGND sg13g2_a21oi_1
X_35823_ _11863_ _15632_ _11364_ VPWR VGND sg13g2_nor2_1
X_35824_ _11864_ _11448_ _11659_ VPWR VGND sg13g2_xnor2_1
X_35825_ _11865_ _11374_ _11349_ _11864_ VPWR VGND sg13g2_nor3_1
X_35826_ _11866_ _11863_ _11865_ _13244_ VPWR VGND sg13g2_o21ai_1
X_35827_ _11867_ _11864_ VPWR VGND sg13g2_inv_1
X_35828_ _11868_ _11390_ _11867_ _11863_ VPWR VGND sg13g2_nand3_1
X_35829_ _11869_ _11351_ _11867_ _11868_ VPWR VGND sg13g2_o21ai_1
X_35830_ _11870_ _15632_ VPWR VGND sg13g2_inv_1
X_35831_ _11871_ _11364_ VPWR VGND sg13g2_inv_1
X_35832_ _11872_ _11870_ _11871_ VPWR VGND sg13g2_nand2_1
X_35833_ _11873_ _11374_ _11872_ _11390_ VPWR VGND sg13g2_o21ai_1
X_35834_ _11874_ _11374_ _11869_ _11873_ _11864_ VPWR
+ VGND
+ sg13g2_a22oi_1
X_35835_ _11875_ _11380_ VPWR VGND sg13g2_buf_1
X_35836_ _11876_ \alu_i.funct3[2]\ _13212_ _13201_ VPWR VGND sg13g2_and3_1
X_35837_ _11877_ _11876_ VPWR VGND sg13g2_buf_1
X_35838_ _11878_ _11877_ VPWR VGND sg13g2_buf_1
X_35839_ _11879_ _11565_ _11878_ VPWR VGND sg13g2_nand2_1
X_35840_ _11880_ _11565_ _11875_ _11879_ VPWR VGND sg13g2_o21ai_1
X_35841_ _11881_ _11377_ VPWR VGND sg13g2_buf_1
X_35842_ _11882_ _11881_ VPWR VGND sg13g2_buf_1
X_35843_ _11883_ \alu_i.funct3[1]\ _11659_ _11878_ VPWR VGND sg13g2_o21ai_1
X_35844_ _11884_ _11882_ _11883_ _11565_ VPWR VGND sg13g2_a21oi_1
X_35845_ _11885_ _11866_ _11874_ _11880_ _11560_ _11884_
+ VPWR
+ VGND sg13g2_a221oi_1
X_35846_ _11886_ _13220_ VPWR VGND sg13g2_buf_1
X_35847_ _11887_ _11439_ _11431_ VPWR VGND sg13g2_nor2_1
X_35848_ _11888_ _11387_ _11780_ _11887_ VPWR VGND sg13g2_a21oi_1
X_35849_ _11889_ _11439_ _11744_ VPWR VGND sg13g2_nor2_1
X_35850_ _11890_ _11387_ _11428_ _11889_ VPWR VGND sg13g2_a21oi_1
X_35851_ _11891_ _11450_ _11890_ VPWR VGND sg13g2_and2_1
X_35852_ _11892_ _11424_ _11888_ _11891_ VPWR VGND sg13g2_a21oi_1
X_35853_ _11893_ _11386_ _11815_ VPWR VGND sg13g2_nand2_1
X_35854_ _11894_ _11439_ _11794_ _11893_ VPWR VGND sg13g2_o21ai_1
X_35855_ _11895_ _11386_ _11467_ VPWR VGND sg13g2_nor2_1
X_35856_ _11896_ _11439_ _11458_ _11895_ VPWR VGND sg13g2_a21oi_1
X_35857_ _11897_ _11477_ _11896_ VPWR VGND sg13g2_nand2_1
X_35858_ _11898_ _11450_ _11894_ _11897_ VPWR VGND sg13g2_o21ai_1
X_35859_ _11899_ _11418_ _11898_ VPWR VGND sg13g2_nor2_1
X_35860_ _11900_ _11419_ _11892_ _11899_ VPWR VGND sg13g2_a21oi_1
X_35861_ _11901_ _11412_ VPWR VGND sg13g2_buf_1
X_35862_ _11902_ _11417_ VPWR VGND sg13g2_buf_1
X_35863_ _11903_ _11385_ _11845_ VPWR VGND sg13g2_nand2_1
X_35864_ _11904_ _11386_ _11479_ _11903_ VPWR VGND sg13g2_o21ai_1
X_35865_ _11905_ _11904_ VPWR VGND sg13g2_buf_1
X_35866_ _11906_ _11450_ _11625_ VPWR VGND sg13g2_nor2_1
X_35867_ _11907_ _11564_ _11905_ _11906_ VPWR VGND sg13g2_a21oi_1
X_35868_ _11908_ _11346_ _11821_ VPWR VGND sg13g2_nand2_1
X_35869_ _11909_ _11346_ _11608_ _11908_ VPWR VGND sg13g2_o21ai_1
X_35870_ _11910_ _11386_ _11495_ VPWR VGND sg13g2_nand2_1
X_35871_ _11911_ _11346_ _11500_ VPWR VGND sg13g2_nand2_1
X_35872_ _11912_ _11910_ _11911_ VPWR VGND sg13g2_nand2_1
X_35873_ _11913_ _11909_ _11912_ _11477_ VPWR VGND sg13g2_mux2_1
X_35874_ _11914_ _11418_ _11913_ VPWR VGND sg13g2_nand2_1
X_35875_ _11915_ _11902_ _11907_ _11914_ VPWR VGND sg13g2_o21ai_1
X_35876_ _11916_ _11901_ _11915_ VPWR VGND sg13g2_nand2_1
X_35877_ _11917_ _11473_ _11900_ _11916_ VPWR VGND sg13g2_o21ai_1
X_35878_ _11918_ \alu_i.funct3[2]\ _13213_ _13214_ VPWR VGND sg13g2_and3_1
X_35879_ _11919_ _11918_ VPWR VGND sg13g2_buf_1
X_35880_ _11920_ _11425_ _11423_ _11625_ VPWR VGND sg13g2_nand3_1
X_35881_ _11921_ _11435_ _11905_ _11920_ VPWR VGND sg13g2_o21ai_1
X_35882_ _11922_ _11419_ _11921_ _11914_ VPWR VGND sg13g2_o21ai_1
X_35883_ _11923_ _11552_ _11900_ VPWR VGND sg13g2_nand2_1
X_35884_ _11924_ _11513_ _11922_ _11923_ VPWR VGND sg13g2_o21ai_1
X_35885_ _11925_ _11919_ _11924_ VPWR VGND sg13g2_nand2_1
X_35886_ _11926_ _11886_ _11917_ _11925_ VPWR VGND sg13g2_o21ai_1
X_35887_ _11927_ _11602_ VPWR VGND sg13g2_buf_1
X_35888_ _11928_ _11374_ _11386_ VPWR VGND sg13g2_nand2_1
X_35889_ _11929_ _11346_ _11659_ VPWR VGND sg13g2_nand2_1
X_35890_ _11930_ _11928_ _11929_ VPWR VGND sg13g2_and2_1
X_35891_ _11931_ _11930_ VPWR VGND sg13g2_buf_1
X_35892_ _11932_ _11927_ _11604_ _11931_ VPWR VGND sg13g2_nand3_1
X_35893_ _11933_ \csr_i.pc[4]\ _11356_ _11581_ VPWR VGND sg13g2_a21oi_1
X_35894_ _11934_ _11554_ _11567_ VPWR VGND sg13g2_nor2_1
X_35895_ _11935_ _11554_ _11933_ _11934_ VPWR VGND sg13g2_a21oi_1
X_35896_ _11936_ \csr_i.pc[6]\ _11356_ _11584_ VPWR VGND sg13g2_a21o_1
X_35897_ _11937_ _11936_ VPWR VGND sg13g2_buf_1
X_35898_ _11938_ _11422_ _11937_ VPWR VGND sg13g2_nor2_1
X_35899_ _11939_ _11423_ _11539_ _11938_ VPWR VGND sg13g2_a21oi_1
X_35900_ _11940_ _11562_ _11580_ _11935_ _11939_ _11573_
+ _11390_
+ VPWR VGND sg13g2_mux4_1
X_35901_ _11941_ _11448_ _11517_ VPWR VGND sg13g2_nor2_1
X_35902_ _11942_ _11422_ _11535_ VPWR VGND sg13g2_nor2_1
X_35903_ _11943_ _11941_ _11942_ VPWR VGND sg13g2_nor2_1
X_35904_ _11944_ _11387_ VPWR VGND sg13g2_buf_1
X_35905_ _11945_ _11944_ _11544_ _11547_ VPWR VGND sg13g2_nor3_1
X_35906_ _11946_ _11389_ _11943_ _11945_ VPWR VGND sg13g2_a21oi_1
X_35907_ _11947_ _11439_ _11755_ VPWR VGND sg13g2_nand2_1
X_35908_ _11948_ _11387_ _11527_ _11947_ VPWR VGND sg13g2_o21ai_1
X_35909_ _11949_ _11347_ _11632_ VPWR VGND sg13g2_nor2_1
X_35910_ _11950_ _11425_ _11520_ _11949_ VPWR VGND sg13g2_a21oi_1
X_35911_ _11951_ _11564_ _11950_ VPWR VGND sg13g2_nand2_1
X_35912_ _11952_ _11565_ _11948_ _11951_ VPWR VGND sg13g2_o21ai_1
X_35913_ _11953_ _11514_ _11952_ VPWR VGND sg13g2_nor2_1
X_35914_ _11954_ _11553_ _11946_ _11953_ VPWR VGND sg13g2_a21oi_1
X_35915_ _11955_ _11901_ VPWR VGND sg13g2_buf_1
X_35916_ _11956_ _11940_ _11954_ _11955_ VPWR VGND sg13g2_mux2_1
X_35917_ _11957_ _11595_ _11956_ VPWR VGND sg13g2_nand2_1
X_35918_ _11958_ _11404_ _11932_ _11957_ VPWR VGND sg13g2_nand3_1
X_35919_ _11959_ _11404_ _11926_ _11958_ VPWR VGND sg13g2_o21ai_1
X_35920_ _02184_ _11885_ _11959_ _15251_ VPWR VGND sg13g2_a21oi_1
X_35921_ _11960_ _11872_ VPWR VGND sg13g2_buf_1
X_35922_ _11961_ _11657_ _11656_ VPWR VGND sg13g2_nand2b_1
X_35923_ _11962_ _11373_ _11345_ _11447_ VPWR VGND sg13g2_o21ai_1
X_35924_ _11963_ _11373_ _11346_ _11448_ VPWR VGND sg13g2_nor3_1
X_35925_ _11964_ _11560_ _11962_ _11963_ VPWR VGND sg13g2_a21oi_1
X_35926_ _11965_ _11961_ _11964_ VPWR VGND sg13g2_xnor2_1
X_35927_ _11966_ _11960_ _11965_ VPWR VGND sg13g2_nand2_1
X_35928_ _11967_ _11660_ _11661_ VPWR VGND sg13g2_nor2_1
X_35929_ _11968_ _11967_ _11961_ VPWR VGND sg13g2_xor2_1
X_35930_ _11969_ _11418_ VPWR VGND sg13g2_buf_1
X_35931_ _11970_ _11969_ VPWR VGND sg13g2_buf_1
X_35932_ _11971_ _11970_ _11877_ VPWR VGND sg13g2_nand2_1
X_35933_ _11972_ _11970_ _11875_ _11971_ VPWR VGND sg13g2_o21ai_1
X_35934_ _11973_ \alu_i.funct3[1]\ _11655_ _11877_ VPWR VGND sg13g2_o21ai_1
X_35935_ _11974_ _11882_ _11973_ _11970_ VPWR VGND sg13g2_a21oi_1
X_35936_ _11975_ _11351_ _11968_ _11972_ _11567_ _11974_
+ VPWR
+ VGND sg13g2_a221oi_1
X_35937_ _11976_ _13216_ _13220_ VPWR VGND sg13g2_and2_1
X_35938_ _11977_ _11976_ VPWR VGND sg13g2_buf_1
X_35939_ _11978_ \csr_i.pc[7]\ _11356_ _11574_ VPWR VGND sg13g2_a21o_1
X_35940_ _11979_ _11978_ VPWR VGND sg13g2_buf_1
X_35941_ _11980_ _11421_ _11979_ VPWR VGND sg13g2_nor2_1
X_35942_ _11981_ _11449_ _11546_ VPWR VGND sg13g2_nor2_1
X_35943_ _11982_ _11980_ _11981_ VPWR VGND sg13g2_nor2_1
X_35944_ _11983_ _11448_ _11578_ VPWR VGND sg13g2_nor2_1
X_35945_ _11984_ _11565_ _11557_ _11983_ VPWR VGND sg13g2_a21oi_1
X_35946_ _11985_ _11939_ _11935_ _11982_ _11984_ _11969_
+ _11390_
+ VPWR VGND sg13g2_mux4_1
X_35947_ _11986_ _11450_ _11529_ VPWR VGND sg13g2_nand2_1
X_35948_ _11987_ _11564_ _11443_ _11986_ VPWR VGND sg13g2_o21ai_1
X_35949_ _11988_ _11422_ _11543_ VPWR VGND sg13g2_nor2_1
X_35950_ _11989_ _11423_ _11520_ _11988_ VPWR VGND sg13g2_a21oi_1
X_35951_ _11990_ _11388_ _11941_ _11942_ VPWR VGND sg13g2_nor3_1
X_35952_ _11991_ _11944_ _11989_ _11990_ VPWR VGND sg13g2_a21oi_1
X_35953_ _11992_ _11419_ _11991_ VPWR VGND sg13g2_nand2_1
X_35954_ _11993_ _11514_ _11987_ _11992_ VPWR VGND sg13g2_o21ai_1
X_35955_ _11994_ _11552_ _11993_ VPWR VGND sg13g2_nor2_1
X_35956_ _11995_ _11513_ _11985_ _11994_ VPWR VGND sg13g2_a21oi_1
X_35957_ _11996_ _11374_ _11347_ VPWR VGND sg13g2_nand2b_1
X_35958_ _11997_ _11439_ _11567_ VPWR VGND sg13g2_nor2_1
X_35959_ _11998_ _11387_ _11659_ _11997_ VPWR VGND sg13g2_a21oi_1
X_35960_ _11999_ _11450_ _11998_ VPWR VGND sg13g2_nand2_1
X_35961_ _12000_ _11996_ _11564_ _11999_ VPWR VGND sg13g2_o21ai_1
X_35962_ _12001_ _11927_ _11970_ _12000_ VPWR VGND sg13g2_nand3_1
X_35963_ _12002_ _11977_ _11995_ _12001_ VPWR VGND sg13g2_o21ai_1
X_35964_ _12003_ _11404_ _12002_ VPWR VGND sg13g2_nand2_1
X_35965_ _12004_ _11449_ _11455_ _11459_ VPWR VGND sg13g2_nand3_1
X_35966_ _12005_ _11477_ _11502_ _12004_ VPWR VGND sg13g2_o21ai_1
X_35967_ _12006_ _11450_ _11464_ _11468_ VPWR VGND sg13g2_nor3_1
X_35968_ _12007_ _11564_ _11433_ _12006_ VPWR VGND sg13g2_a21oi_1
X_35969_ _12008_ _11419_ _12007_ VPWR VGND sg13g2_nand2_1
X_35970_ _12009_ _11514_ _12005_ _12008_ VPWR VGND sg13g2_o21ai_1
X_35971_ _12010_ _11512_ _12009_ VPWR VGND sg13g2_nand2_1
X_35972_ _12011_ _11424_ _11417_ VPWR VGND sg13g2_nor2_1
X_35973_ _12012_ _11497_ _11483_ _11434_ VPWR VGND sg13g2_mux2_1
X_35974_ _12013_ _11476_ _12012_ VPWR VGND sg13g2_nor2_1
X_35975_ _12014_ _11489_ _12011_ _12013_ VPWR VGND sg13g2_a21oi_1
X_35976_ _12015_ _11473_ _12014_ _13216_ VPWR VGND sg13g2_a21oi_1
X_35977_ _12016_ _12010_ _12015_ VPWR VGND sg13g2_and2_1
X_35978_ _12017_ _11418_ _11906_ VPWR VGND sg13g2_nor2_1
X_35979_ _12018_ _11554_ _11489_ _12017_ VPWR VGND sg13g2_o21ai_1
X_35980_ _12019_ _12013_ _12018_ VPWR VGND sg13g2_nor2b_1
X_35981_ _12020_ _11414_ _12019_ _11886_ VPWR VGND sg13g2_a21oi_1
X_35982_ _12021_ _12010_ _12020_ VPWR VGND sg13g2_and2_1
X_35983_ _12022_ _12016_ _12021_ _11600_ VPWR VGND sg13g2_o21ai_1
X_35984_ _12023_ _11966_ _11975_ _12003_ _12022_ VPWR
+ VGND
+ sg13g2_nand4_1
X_35985_ _02185_ reset _12023_ VPWR VGND sg13g2_and2_1
X_35986_ _12024_ _11411_ _11557_ VPWR VGND sg13g2_xnor2_1
X_35987_ _12025_ _11475_ _11567_ VPWR VGND sg13g2_nor2_1
X_35988_ _12026_ _11475_ _11567_ _11962_ _11560_ _11963_
+ VPWR
+ VGND sg13g2_a221oi_1
X_35989_ _12027_ _12026_ VPWR VGND sg13g2_buf_1
X_35990_ _12028_ _12025_ _12027_ VPWR VGND sg13g2_nor2_1
X_35991_ _12029_ _12024_ _12028_ VPWR VGND sg13g2_xor2_1
X_35992_ _12030_ _11656_ _11663_ VPWR VGND sg13g2_and2_1
X_35993_ _12031_ _12030_ _12024_ VPWR VGND sg13g2_xnor2_1
X_35994_ _12032_ _11368_ _11557_ _11370_ VPWR VGND sg13g2_a21oi_1
X_35995_ _12033_ \alu_i.funct3[2]\ \alu_i.funct3[1]\ \alu_i.funct3[0]\ _13201_ VPWR
+ VGND
+ sg13g2_nand4_1
X_35996_ _12034_ _12033_ VPWR VGND sg13g2_buf_1
X_35997_ _12035_ \alu_i.funct3[1]\ _11552_ _11368_ VPWR VGND sg13g2_o21ai_1
X_35998_ _12036_ _11513_ _12034_ _12035_ VPWR VGND sg13g2_o21ai_1
X_35999_ _12037_ _11557_ _12036_ VPWR VGND sg13g2_nand2b_1
X_36000_ _12038_ _11513_ _12032_ _12037_ VPWR VGND sg13g2_o21ai_1
X_36001_ _12039_ _11960_ _12029_ _12031_ _11351_ _12038_
+ VPWR
+ VGND sg13g2_a221oi_1
X_36002_ _12040_ _11419_ _11854_ VPWR VGND sg13g2_nor2_1
X_36003_ _12041_ _11421_ _11909_ VPWR VGND sg13g2_or2_1
X_36004_ _12042_ _11449_ _11905_ _12041_ VPWR VGND sg13g2_o21ai_1
X_36005_ _12043_ _11902_ _12042_ _11511_ VPWR VGND sg13g2_a21o_1
X_36006_ _12044_ _11888_ _11896_ _11423_ VPWR VGND sg13g2_mux2_1
X_36007_ _12045_ _11894_ _11912_ _11423_ VPWR VGND sg13g2_mux2_1
X_36008_ _12046_ _11476_ _12045_ VPWR VGND sg13g2_nand2_1
X_36009_ _12047_ _11532_ _12044_ _12046_ VPWR VGND sg13g2_o21ai_1
X_36010_ _12048_ _11511_ _12047_ VPWR VGND sg13g2_nand2_1
X_36011_ _12049_ _12040_ _12043_ _12048_ VPWR VGND sg13g2_o21ai_1
X_36012_ _12050_ _11532_ VPWR VGND sg13g2_buf_1
X_36013_ _12051_ _11389_ _11424_ _11854_ VPWR VGND sg13g2_nor3_1
X_36014_ _12052_ _12050_ _12051_ _12043_ VPWR VGND sg13g2_a21oi_1
X_36015_ _12053_ _12052_ _11919_ _12048_ VPWR VGND sg13g2_nand3b_1
X_36016_ _12054_ _11886_ _12049_ _12053_ VPWR VGND sg13g2_o21ai_1
X_36017_ _12055_ _11347_ _11557_ VPWR VGND sg13g2_nand2_1
X_36018_ _12056_ _11425_ _11567_ _12055_ VPWR VGND sg13g2_o21ai_1
X_36019_ _12057_ _11435_ _11931_ VPWR VGND sg13g2_nand2_1
X_36020_ _12058_ _11435_ _12056_ _12057_ VPWR VGND sg13g2_o21ai_1
X_36021_ _12059_ _11927_ _11970_ _12058_ VPWR VGND sg13g2_nand3_1
X_36022_ _12060_ _11425_ VPWR VGND sg13g2_buf_1
X_36023_ _12061_ _11541_ _11982_ _12060_ VPWR VGND sg13g2_mux2_1
X_36024_ _12062_ _11390_ _11984_ VPWR VGND sg13g2_nor2_1
X_36025_ _12063_ _11390_ _11587_ _12062_ VPWR VGND sg13g2_a21oi_1
X_36026_ _12064_ _11423_ _11890_ VPWR VGND sg13g2_nand2_1
X_36027_ _12065_ _11435_ _11948_ _12064_ VPWR VGND sg13g2_o21ai_1
X_36028_ _12066_ _11387_ _11543_ VPWR VGND sg13g2_nor2_1
X_36029_ _12067_ _11388_ _11644_ _12066_ VPWR VGND sg13g2_a21oi_1
X_36030_ _12068_ _12067_ _11950_ _11424_ VPWR VGND sg13g2_mux2_1
X_36031_ _12069_ _12061_ _12063_ _12065_ _12068_ _11970_
+ _11955_
+ VPWR VGND sg13g2_mux4_1
X_36032_ _12070_ _11595_ _12069_ VPWR VGND sg13g2_nand2_1
X_36033_ _12071_ _12059_ _12070_ _11600_ VPWR VGND sg13g2_a21oi_1
X_36034_ _12072_ _11600_ _12054_ _12071_ VPWR VGND sg13g2_a21oi_1
X_36035_ _02186_ _12039_ _12072_ _15251_ VPWR VGND sg13g2_a21oi_1
X_36036_ _12073_ _11351_ VPWR VGND sg13g2_buf_1
X_36037_ _12074_ _11598_ _11933_ VPWR VGND sg13g2_xnor2_1
X_36038_ _12075_ _11666_ _12074_ VPWR VGND sg13g2_xnor2_1
X_36039_ _12076_ _11556_ _12025_ VPWR VGND sg13g2_or2_1
X_36040_ _12077_ _12027_ _12076_ _11510_ VPWR VGND sg13g2_o21ai_1
X_36041_ _12078_ _12025_ _12027_ _11557_ VPWR VGND sg13g2_o21ai_1
X_36042_ _12079_ _12077_ _12078_ VPWR VGND sg13g2_nand2_1
X_36043_ _12080_ _12074_ _12079_ VPWR VGND sg13g2_xnor2_1
X_36044_ _12081_ _11960_ VPWR VGND sg13g2_buf_1
X_36045_ _12082_ _12073_ _12075_ _12080_ _12081_ VPWR
+ VGND
+ sg13g2_a22oi_1
X_36046_ _12083_ _11393_ _11583_ _11882_ VPWR VGND sg13g2_o21ai_1
X_36047_ _12084_ \alu_i.funct3[1]\ _11508_ _11368_ VPWR VGND sg13g2_o21ai_1
X_36048_ _12085_ _11404_ _12034_ _12084_ VPWR VGND sg13g2_o21ai_1
X_36049_ _12086_ _11387_ _11557_ VPWR VGND sg13g2_nand2_1
X_36050_ _12087_ _11387_ _11583_ _12086_ VPWR VGND sg13g2_o21ai_1
X_36051_ _12088_ _11435_ _11998_ VPWR VGND sg13g2_nand2_1
X_36052_ _12089_ _11435_ _12087_ _12088_ VPWR VGND sg13g2_o21ai_1
X_36053_ _12090_ _11996_ _11554_ _11902_ VPWR VGND sg13g2_nor3_1
X_36054_ _12091_ _11969_ _12089_ _12090_ VPWR VGND sg13g2_a21o_1
X_36055_ _12092_ _11927_ _12091_ VPWR VGND sg13g2_nand2_1
X_36056_ _12093_ _11598_ VPWR VGND sg13g2_buf_1
X_36057_ _12094_ _12050_ _11445_ VPWR VGND sg13g2_nand2_1
X_36058_ _12095_ _11573_ _11531_ _12094_ VPWR VGND sg13g2_o21ai_1
X_36059_ _12096_ _11514_ _11549_ VPWR VGND sg13g2_nor2_1
X_36060_ _12097_ _11553_ _11589_ _12096_ VPWR VGND sg13g2_a21oi_1
X_36061_ _12098_ _11414_ _12097_ VPWR VGND sg13g2_nor2_1
X_36062_ _12099_ _11955_ _12095_ _12098_ VPWR VGND sg13g2_a21oi_1
X_36063_ _12100_ _12093_ _12099_ _11595_ VPWR VGND sg13g2_o21ai_1
X_36064_ _12101_ _11511_ VPWR VGND sg13g2_buf_1
X_36065_ _12102_ _11532_ _11503_ VPWR VGND sg13g2_nand2_1
X_36066_ _12103_ _11572_ _11470_ _12102_ VPWR VGND sg13g2_o21ai_1
X_36067_ _12104_ _11418_ _11491_ VPWR VGND sg13g2_and2_1
X_36068_ _12105_ _12104_ VPWR VGND sg13g2_buf_1
X_36069_ _12106_ _12105_ VPWR VGND sg13g2_inv_1
X_36070_ _12107_ _11512_ _12040_ VPWR VGND sg13g2_nor2_1
X_36071_ _12108_ _12101_ _12103_ _12106_ _12107_ _11886_
+ VPWR
+ VGND sg13g2_a221oi_1
X_36072_ _12109_ _11511_ _12105_ _11919_ VPWR VGND sg13g2_o21ai_1
X_36073_ _12110_ _12101_ _12103_ _12109_ VPWR VGND sg13g2_a21oi_1
X_36074_ _12111_ _12108_ _12110_ VPWR VGND sg13g2_nor2_1
X_36075_ _12112_ _12092_ _12100_ _12111_ _11600_ VPWR
+ VGND
+ sg13g2_a22oi_1
X_36076_ _12113_ _11600_ _12083_ _12085_ _11583_ _12112_
+ VPWR
+ VGND sg13g2_a221oi_1
X_36077_ _02187_ _12082_ _12113_ _15251_ VPWR VGND sg13g2_a21oi_1
X_36078_ _12114_ _11393_ _11578_ _11882_ VPWR VGND sg13g2_o21ai_1
X_36079_ _12115_ \control_i.immediate[5]\ _11398_ _11669_ VPWR VGND sg13g2_a21oi_1
X_36080_ _12116_ \alu_i.funct3[1]\ _12115_ _11368_ VPWR VGND sg13g2_o21ai_1
X_36081_ _12117_ _12034_ _12115_ _12116_ VPWR VGND sg13g2_o21ai_1
X_36082_ _12118_ _11434_ _11557_ _11579_ VPWR VGND sg13g2_a21oi_1
X_36083_ _12119_ _11434_ _11583_ VPWR VGND sg13g2_nor2_1
X_36084_ _12120_ _11425_ _11568_ _12119_ VPWR VGND sg13g2_nor3_1
X_36085_ _12121_ _11348_ _12118_ _12120_ VPWR VGND sg13g2_a21oi_1
X_36086_ _12122_ _11476_ _12121_ VPWR VGND sg13g2_nor2_1
X_36087_ _12123_ _11931_ _12011_ _12122_ VPWR VGND sg13g2_a21oi_1
X_36088_ _12124_ _12123_ _11927_ VPWR VGND sg13g2_nand2b_1
X_36089_ _12125_ _12050_ _11892_ VPWR VGND sg13g2_nand2_1
X_36090_ _12126_ _11573_ _11952_ _12125_ VPWR VGND sg13g2_o21ai_1
X_36091_ _12127_ _11349_ _11580_ VPWR VGND sg13g2_nand2_1
X_36092_ _12128_ _11390_ _11939_ VPWR VGND sg13g2_nand2_1
X_36093_ _12129_ _11553_ _12127_ _12128_ VPWR VGND sg13g2_nand3_1
X_36094_ _12130_ _11573_ _11946_ VPWR VGND sg13g2_nand2_1
X_36095_ _12131_ _12129_ _12130_ _11414_ VPWR VGND sg13g2_a21oi_1
X_36096_ _12132_ _11955_ _12126_ _12131_ VPWR VGND sg13g2_a21oi_1
X_36097_ _12133_ _12093_ _12132_ _11595_ VPWR VGND sg13g2_o21ai_1
X_36098_ _12134_ _11475_ _11913_ VPWR VGND sg13g2_nand2_1
X_36099_ _12135_ _11476_ _11898_ _12134_ VPWR VGND sg13g2_o21ai_1
X_36100_ _12136_ _11412_ _12135_ VPWR VGND sg13g2_or2_1
X_36101_ _12137_ _11510_ _11532_ VPWR VGND sg13g2_nor2_1
X_36102_ _12138_ _11921_ _12137_ VPWR VGND sg13g2_nand2_1
X_36103_ _12139_ _12136_ _12138_ _13216_ VPWR VGND sg13g2_a21oi_1
X_36104_ _12140_ _11604_ _11625_ VPWR VGND sg13g2_nor2_1
X_36105_ _12141_ _11604_ _11905_ _12140_ VPWR VGND sg13g2_a21oi_1
X_36106_ _12142_ _11901_ _12141_ VPWR VGND sg13g2_nand2_1
X_36107_ _12143_ _12136_ _12142_ _11886_ VPWR VGND sg13g2_a21o_1
X_36108_ _12144_ _12139_ _12143_ VPWR VGND sg13g2_nor2b_1
X_36109_ _12145_ _12124_ _12133_ _12144_ _11600_ VPWR
+ VGND
+ sg13g2_a22oi_1
X_36110_ _12146_ _11671_ _12114_ _12117_ _11578_ _12145_
+ VPWR
+ VGND sg13g2_a221oi_1
X_36111_ _12147_ _11578_ _12115_ VPWR VGND sg13g2_xnor2_1
X_36112_ _12148_ _12077_ _12078_ _11597_ VPWR VGND sg13g2_a21oi_1
X_36113_ _12149_ _11598_ _12077_ _12078_ VPWR VGND sg13g2_nand3_1
X_36114_ _12150_ _11933_ _12148_ _12149_ VPWR VGND sg13g2_o21ai_1
X_36115_ _12151_ _12150_ VPWR VGND sg13g2_buf_1
X_36116_ _12152_ _12147_ _12151_ VPWR VGND sg13g2_xor2_1
X_36117_ _12153_ _11667_ _11668_ VPWR VGND sg13g2_nand2_1
X_36118_ _12154_ _12153_ _12147_ VPWR VGND sg13g2_xnor2_1
X_36119_ _12155_ _12081_ _12152_ _12154_ _12073_ VPWR
+ VGND
+ sg13g2_a22oi_1
X_36120_ _02188_ _12146_ _12155_ _15251_ VPWR VGND sg13g2_a21oi_1
X_36121_ _12156_ \control_i.immediate[6]\ _11408_ _11652_ VPWR VGND sg13g2_a21oi_1
X_36122_ _12157_ _11937_ _12156_ VPWR VGND sg13g2_xnor2_1
X_36123_ _12158_ _11675_ _12157_ VPWR VGND sg13g2_xor2_1
X_36124_ _12159_ _11578_ _12115_ VPWR VGND sg13g2_nand2b_1
X_36125_ _12160_ _11578_ _11671_ VPWR VGND sg13g2_and2_1
X_36126_ _12161_ _12151_ _12159_ _12160_ VPWR VGND sg13g2_a21oi_1
X_36127_ _12162_ _12161_ _12157_ VPWR VGND sg13g2_xor2_1
X_36128_ _12163_ _11393_ _11937_ _11881_ VPWR VGND sg13g2_o21ai_1
X_36129_ _12164_ \alu_i.funct3[1]\ _12156_ _11368_ VPWR VGND sg13g2_o21ai_1
X_36130_ _12165_ _12034_ _12156_ _12164_ VPWR VGND sg13g2_o21ai_1
X_36131_ _12166_ _11423_ _11933_ _11938_ VPWR VGND sg13g2_a21oi_1
X_36132_ _12167_ _11348_ _12166_ VPWR VGND sg13g2_and2_1
X_36133_ _12168_ _11389_ _12118_ _12167_ VPWR VGND sg13g2_a21oi_1
X_36134_ _12169_ _11419_ _12000_ VPWR VGND sg13g2_nor2_1
X_36135_ _12170_ _11969_ _12168_ _12169_ VPWR VGND sg13g2_a21oi_1
X_36136_ _12171_ _11927_ _12170_ VPWR VGND sg13g2_nand2_1
X_36137_ _12172_ _11532_ _12007_ VPWR VGND sg13g2_nand2_1
X_36138_ _12173_ _11572_ _11987_ _12172_ VPWR VGND sg13g2_o21ai_1
X_36139_ _12174_ _12060_ _11939_ VPWR VGND sg13g2_nand2_1
X_36140_ _12175_ _11944_ _11982_ VPWR VGND sg13g2_nand2_1
X_36141_ _12176_ _11902_ _12174_ _12175_ VPWR VGND sg13g2_nand3_1
X_36142_ _12177_ _11532_ _11991_ VPWR VGND sg13g2_nand2_1
X_36143_ _12178_ _12176_ _12177_ _11413_ VPWR VGND sg13g2_a21oi_1
X_36144_ _12179_ _11901_ _12173_ _12178_ VPWR VGND sg13g2_a21oi_1
X_36145_ _12180_ _11598_ _12179_ _11595_ VPWR VGND sg13g2_o21ai_1
X_36146_ _12181_ _11475_ _12012_ VPWR VGND sg13g2_nand2_1
X_36147_ _12182_ _11475_ _12005_ _12181_ VPWR VGND sg13g2_o21ai_1
X_36148_ _12183_ _11412_ _12182_ VPWR VGND sg13g2_or2_1
X_36149_ _12184_ _11412_ _11604_ _11489_ VPWR VGND sg13g2_nand3_1
X_36150_ _12185_ _12183_ _12184_ _13216_ VPWR VGND sg13g2_a21oi_1
X_36151_ _12186_ _11489_ VPWR VGND sg13g2_inv_1
X_36152_ _12187_ _11604_ _12186_ _12140_ VPWR VGND sg13g2_a21oi_1
X_36153_ _12188_ _11413_ _12187_ VPWR VGND sg13g2_nand2_1
X_36154_ _12189_ _12183_ _12188_ _13220_ VPWR VGND sg13g2_a21oi_1
X_36155_ _12190_ _12185_ _12189_ VPWR VGND sg13g2_nor2_1
X_36156_ _12191_ _12171_ _12180_ _12190_ _11599_ VPWR
+ VGND
+ sg13g2_a22oi_1
X_36157_ _12192_ _11654_ _12163_ _12165_ _11937_ _12191_
+ VPWR
+ VGND sg13g2_a221oi_1
X_36158_ _12193_ _11863_ _12162_ _12192_ VPWR VGND sg13g2_o21ai_1
X_36159_ _12194_ _12073_ _12158_ _12193_ VPWR VGND sg13g2_a21oi_1
X_36160_ _02189_ _11095_ _12194_ VPWR VGND sg13g2_nor2_1
X_36161_ _12195_ _11676_ _11677_ VPWR VGND sg13g2_nand2_1
X_36162_ _12196_ _11576_ _11650_ VPWR VGND sg13g2_xnor2_1
X_36163_ _12197_ _12195_ _12196_ VPWR VGND sg13g2_xor2_1
X_36164_ _12198_ _12161_ VPWR VGND sg13g2_inv_1
X_36165_ _12199_ _12156_ _12161_ _11585_ VPWR VGND sg13g2_o21ai_1
X_36166_ _12200_ _11654_ _12198_ _12199_ VPWR VGND sg13g2_o21ai_1
X_36167_ _12201_ _12196_ _12200_ VPWR VGND sg13g2_xor2_1
X_36168_ _12202_ _12044_ _11476_ VPWR VGND sg13g2_nand2b_1
X_36169_ _12203_ _11532_ _12065_ _12202_ VPWR VGND sg13g2_o21ai_1
X_36170_ _12204_ _11511_ _12203_ VPWR VGND sg13g2_nor2_1
X_36171_ _12205_ _11572_ _12061_ VPWR VGND sg13g2_nor2_1
X_36172_ _12206_ _11514_ _12068_ VPWR VGND sg13g2_nor2_1
X_36173_ _12207_ _11413_ _12205_ _12206_ VPWR VGND sg13g2_nor3_1
X_36174_ _12208_ _11598_ _12204_ _12207_ VPWR VGND sg13g2_nor3_1
X_36175_ _12209_ _11980_ _11983_ VPWR VGND sg13g2_nor2_1
X_36176_ _12210_ _12166_ _12209_ _12060_ VPWR VGND sg13g2_mux2_1
X_36177_ _12211_ _12058_ _12210_ _11902_ VPWR VGND sg13g2_mux2_1
X_36178_ _12212_ _11927_ _12211_ VPWR VGND sg13g2_nand2_1
X_36179_ _12213_ _11977_ _12208_ _12212_ VPWR VGND sg13g2_o21ai_1
X_36180_ _12214_ _11417_ _12042_ VPWR VGND sg13g2_nor2_1
X_36181_ _12215_ _11417_ _12045_ _12214_ VPWR VGND sg13g2_a21oi_1
X_36182_ _12216_ _12051_ _12137_ _12215_ _11511_ VPWR
+ VGND
+ sg13g2_a22oi_1
X_36183_ _12217_ _12216_ _11919_ VPWR VGND sg13g2_nand2b_1
X_36184_ _12218_ _11412_ _11854_ _13220_ VPWR VGND sg13g2_a21o_1
X_36185_ _12219_ _12218_ VPWR VGND sg13g2_buf_1
X_36186_ _12220_ _11413_ _12215_ VPWR VGND sg13g2_nor2_1
X_36187_ _12221_ _12219_ _12220_ VPWR VGND sg13g2_nor2_1
X_36188_ _12222_ _11403_ _12221_ VPWR VGND sg13g2_nor2_1
X_36189_ _12223_ _12217_ _12222_ VPWR VGND sg13g2_nand2_1
X_36190_ _12224_ _11875_ _11576_ _11882_ VPWR VGND sg13g2_o21ai_1
X_36191_ _12225_ \alu_i.funct3[2]\ _13212_ _13201_ VPWR VGND sg13g2_nand3_1
X_36192_ _12226_ _12225_ VPWR VGND sg13g2_buf_1
X_36193_ _12227_ \alu_i.funct3[1]\ _11576_ _11651_ VPWR VGND sg13g2_nor3_1
X_36194_ _12228_ _11979_ _11650_ VPWR VGND sg13g2_nor2_1
X_36195_ _12229_ _12226_ _12227_ _12228_ VPWR VGND sg13g2_nor3_1
X_36196_ _12230_ _12213_ _12223_ _12224_ _11650_ _12229_
+ VPWR
+ VGND sg13g2_a221oi_1
X_36197_ _12231_ _11863_ _12201_ _12230_ VPWR VGND sg13g2_o21ai_1
X_36198_ _12232_ _12073_ _12197_ _12231_ VPWR VGND sg13g2_a21oi_1
X_36199_ _02190_ _11095_ _12232_ VPWR VGND sg13g2_nor2_1
X_36200_ _12233_ _11681_ _11700_ VPWR VGND sg13g2_xnor2_1
X_36201_ _12234_ \control_i.immediate[8]\ _11398_ _11698_ VPWR VGND sg13g2_a21o_1
X_36202_ _12235_ _12234_ VPWR VGND sg13g2_buf_1
X_36203_ _12236_ \alu_i.funct3[1]\ _11370_ VPWR VGND sg13g2_nor2_1
X_36204_ _12237_ _12236_ VPWR VGND sg13g2_buf_1
X_36205_ _12238_ _11697_ _12235_ _12237_ VPWR VGND sg13g2_nand3_1
X_36206_ _12239_ _11381_ _12235_ VPWR VGND sg13g2_nand2_1
X_36207_ _12240_ _11392_ _11377_ VPWR VGND sg13g2_nand2_1
X_36208_ _12241_ _12235_ _12240_ VPWR VGND sg13g2_nand2_1
X_36209_ _12242_ _11393_ _12239_ _12241_ _11539_ VPWR
+ VGND
+ sg13g2_a22oi_1
X_36210_ _12243_ _11578_ _11671_ VPWR VGND sg13g2_nand2_1
X_36211_ _12244_ _11979_ _11650_ VPWR VGND sg13g2_nand2_1
X_36212_ _12245_ _12243_ _12244_ VPWR VGND sg13g2_nand2_1
X_36213_ _12246_ _11937_ _11654_ _12151_ _12159_ _12245_
+ VPWR
+ VGND sg13g2_a221oi_1
X_36214_ _12247_ _12246_ VPWR VGND sg13g2_buf_1
X_36215_ _12248_ _11937_ _11654_ VPWR VGND sg13g2_nor2_1
X_36216_ _12249_ _12248_ _12244_ _12228_ VPWR VGND sg13g2_a21o_1
X_36217_ _12250_ _12249_ VPWR VGND sg13g2_buf_1
X_36218_ _12251_ _12247_ _12250_ VPWR VGND sg13g2_nor2_1
X_36219_ _12252_ _11700_ _12251_ VPWR VGND sg13g2_xor2_1
X_36220_ _12253_ _13214_ _13234_ VPWR VGND sg13g2_and2_1
X_36221_ _12254_ _12253_ VPWR VGND sg13g2_buf_1
X_36222_ _12255_ _12254_ VPWR VGND sg13g2_buf_1
X_36223_ _12256_ _11540_ _11586_ VPWR VGND sg13g2_and2_1
X_36224_ _12257_ _12209_ _12256_ _11425_ VPWR VGND sg13g2_mux2_1
X_36225_ _12258_ _11476_ _12257_ VPWR VGND sg13g2_or2_1
X_36226_ _12259_ _11902_ _12089_ _12258_ VPWR VGND sg13g2_o21ai_1
X_36227_ _12260_ _11601_ _11413_ _11604_ VPWR VGND sg13g2_nand3_1
X_36228_ _12261_ _11413_ _12259_ _12260_ VPWR VGND sg13g2_o21ai_1
X_36229_ _12262_ _12255_ _12261_ VPWR VGND sg13g2_nand2_1
X_36230_ _12263_ _11512_ _11472_ VPWR VGND sg13g2_nor2_1
X_36231_ _12264_ _12101_ _11551_ _12263_ VPWR VGND sg13g2_a21oi_1
X_36232_ _12265_ _11599_ _12264_ _11595_ VPWR VGND sg13g2_o21ai_1
X_36233_ _12266_ _11412_ _11854_ _13220_ VPWR VGND sg13g2_a21oi_1
X_36234_ _12267_ _13216_ _11412_ VPWR VGND sg13g2_nor2_1
X_36235_ _12268_ _12267_ VPWR VGND sg13g2_buf_1
X_36236_ _12269_ _12266_ _12268_ VPWR VGND sg13g2_nor2_1
X_36237_ _12270_ _11505_ VPWR VGND sg13g2_inv_1
X_36238_ _12271_ _11901_ _12270_ VPWR VGND sg13g2_nor2_1
X_36239_ _12272_ _12269_ _12271_ VPWR VGND sg13g2_or2_1
X_36240_ _12273_ _12262_ _12265_ _12272_ _12093_ VPWR
+ VGND
+ sg13g2_a22oi_1
X_36241_ _12274_ _12238_ _12242_ _12252_ _11960_ _12273_
+ VPWR
+ VGND sg13g2_a221oi_1
X_36242_ _12275_ _13244_ _12233_ _12274_ VPWR VGND sg13g2_o21ai_1
X_36243_ _02191_ reset _12275_ VPWR VGND sg13g2_and2_1
X_36244_ _12276_ _12235_ _12251_ _11697_ VPWR VGND sg13g2_a21o_1
X_36245_ _12277_ _12235_ _12251_ _12276_ VPWR VGND sg13g2_o21ai_1
X_36246_ _12278_ _11695_ _12277_ VPWR VGND sg13g2_xnor2_1
X_36247_ _12279_ _11692_ _12240_ _11546_ VPWR VGND sg13g2_a21o_1
X_36248_ _12280_ _11546_ _11692_ VPWR VGND sg13g2_and2_1
X_36249_ _12281_ _12280_ VPWR VGND sg13g2_buf_1
X_36250_ _12282_ _11381_ _11692_ VPWR VGND sg13g2_nand2_1
X_36251_ _12283_ _12237_ _12281_ _12282_ _11393_ VPWR
+ VGND
+ sg13g2_a22oi_1
X_36252_ _12284_ _11423_ _11576_ _11547_ VPWR VGND sg13g2_a21oi_1
X_36253_ _12285_ _12256_ _12284_ _11348_ VPWR VGND sg13g2_mux2_1
X_36254_ _12286_ _11476_ _12121_ VPWR VGND sg13g2_nand2_1
X_36255_ _12287_ _11532_ _12285_ _12286_ VPWR VGND sg13g2_o21ai_1
X_36256_ _12288_ _11413_ _11604_ _11931_ VPWR VGND sg13g2_nand3_1
X_36257_ _12289_ _11901_ _12287_ _12288_ VPWR VGND sg13g2_o21ai_1
X_36258_ _12290_ _12255_ _12289_ VPWR VGND sg13g2_nand2_1
X_36259_ _12291_ _11954_ _11900_ _11414_ VPWR VGND sg13g2_mux2_1
X_36260_ _12292_ _12093_ _12291_ _11595_ VPWR VGND sg13g2_o21ai_1
X_36261_ _12293_ _11513_ _11915_ _12219_ VPWR VGND sg13g2_a21oi_1
X_36262_ _12294_ _11919_ _11511_ VPWR VGND sg13g2_nand2_1
X_36263_ _12295_ _11922_ _12294_ VPWR VGND sg13g2_nor2_1
X_36264_ _12296_ _11508_ _12293_ _12295_ VPWR VGND sg13g2_nor3_1
X_36265_ _12297_ _12290_ _12292_ _12296_ VPWR VGND sg13g2_a21oi_1
X_36266_ _12298_ _11960_ _12278_ _12279_ _12283_ _12297_
+ VPWR
+ VGND sg13g2_a221oi_1
X_36267_ _12299_ _11681_ _11708_ VPWR VGND sg13g2_nand2_1
X_36268_ _12300_ _11697_ _11699_ _12299_ VPWR VGND sg13g2_o21ai_1
X_36269_ _12301_ _11695_ _12300_ VPWR VGND sg13g2_xor2_1
X_36270_ _12302_ _12073_ _12301_ VPWR VGND sg13g2_nand2_1
X_36271_ _02192_ _12298_ _12302_ _15251_ VPWR VGND sg13g2_a21oi_1
X_36272_ _12303_ _11546_ _11692_ VPWR VGND sg13g2_nor2_1
X_36273_ _12304_ _11546_ _11692_ VPWR VGND sg13g2_nand2_1
X_36274_ _12305_ _12277_ _12303_ _12304_ VPWR VGND sg13g2_o21ai_1
X_36275_ _12306_ _11690_ _12305_ VPWR VGND sg13g2_xor2_1
X_36276_ _12307_ _11692_ _12300_ VPWR VGND sg13g2_nand2_1
X_36277_ _12308_ _11692_ _12300_ VPWR VGND sg13g2_nor2_1
X_36278_ _12309_ _11546_ _12307_ _12308_ VPWR VGND sg13g2_a21oi_1
X_36279_ _12310_ _11690_ _12309_ VPWR VGND sg13g2_xor2_1
X_36280_ _12311_ _11423_ _11539_ _11942_ VPWR VGND sg13g2_a21oi_1
X_36281_ _12312_ _12284_ _12311_ _12060_ VPWR VGND sg13g2_mux2_1
X_36282_ _12313_ _11572_ _12312_ VPWR VGND sg13g2_nor2_1
X_36283_ _12314_ _12050_ _12168_ _12313_ VPWR VGND sg13g2_a21oi_1
X_36284_ _12315_ _12000_ _12137_ _12314_ _12101_ VPWR
+ VGND
+ sg13g2_a22oi_1
X_36285_ _12316_ _13246_ _12315_ VPWR VGND sg13g2_nor2_1
X_36286_ _12317_ _11993_ _12009_ _11473_ VPWR VGND sg13g2_mux2_1
X_36287_ _12318_ _11403_ _12317_ _11977_ VPWR VGND sg13g2_a21oi_1
X_36288_ _12319_ _12316_ _12318_ VPWR VGND sg13g2_nor2_1
X_36289_ _12320_ _11552_ _12019_ _12219_ VPWR VGND sg13g2_a21oi_1
X_36290_ _12321_ _12014_ _12294_ VPWR VGND sg13g2_nor2_1
X_36291_ _12322_ _11508_ _12320_ _12321_ VPWR VGND sg13g2_nor3_1
X_36292_ _12323_ _13848_ _13212_ _11366_ VPWR VGND sg13g2_nor3_1
X_36293_ _12324_ _11370_ _12323_ VPWR VGND sg13g2_nor2_1
X_36294_ _12325_ _12324_ _11688_ _11393_ VPWR VGND sg13g2_o21ai_1
X_36295_ _12326_ _11877_ _11370_ VPWR VGND sg13g2_nor2_1
X_36296_ _12327_ _11688_ _12326_ _11682_ VPWR VGND sg13g2_o21ai_1
X_36297_ _12328_ _11535_ _11685_ _12237_ VPWR VGND sg13g2_nand3_1
X_36298_ _12329_ _12325_ _12327_ _12328_ VPWR VGND sg13g2_nand3_1
X_36299_ _12330_ _12319_ _12322_ _12329_ VPWR VGND sg13g2_o21ai_1
X_36300_ _12331_ _12081_ _12306_ _12310_ _12073_ _12330_
+ VPWR
+ VGND sg13g2_a221oi_1
X_36301_ _02193_ _11095_ _12331_ VPWR VGND sg13g2_nor2_1
X_36302_ _12332_ _11688_ _11699_ _12303_ VPWR VGND sg13g2_or3_1
X_36303_ _12333_ _12247_ _12250_ _12332_ VPWR VGND sg13g2_nor3_1
X_36304_ _12334_ _11697_ _11685_ VPWR VGND sg13g2_nand2_1
X_36305_ _12335_ _12247_ _12250_ _12303_ _12334_ VPWR
+ VGND
+ sg13g2_nor4_1
X_36306_ _12336_ _11685_ _12281_ VPWR VGND sg13g2_nand2_1
X_36307_ _12337_ _11539_ _12332_ _12336_ VPWR VGND sg13g2_o21ai_1
X_36308_ _12338_ _12333_ _12335_ _12337_ VPWR VGND sg13g2_nor3_1
X_36309_ _12339_ _11685_ _12235_ _12281_ VPWR VGND sg13g2_nor3_1
X_36310_ _12340_ _12247_ _12250_ _12339_ VPWR VGND sg13g2_o21ai_1
X_36311_ _12341_ _11697_ _11685_ _12281_ VPWR VGND sg13g2_nor3_1
X_36312_ _12342_ _12247_ _12250_ _12341_ VPWR VGND sg13g2_o21ai_1
X_36313_ _12343_ _11688_ _12303_ _12339_ _11539_ VPWR
+ VGND
+ sg13g2_a22oi_1
X_36314_ _12344_ _12340_ _12342_ _12343_ VPWR VGND sg13g2_nand3_1
X_36315_ _12345_ _12344_ VPWR VGND sg13g2_buf_1
X_36316_ _12346_ _11682_ _12338_ _12345_ VPWR VGND sg13g2_a21oi_1
X_36317_ _12347_ _11705_ _12346_ VPWR VGND sg13g2_xor2_1
X_36318_ _12348_ _11535_ _11688_ VPWR VGND sg13g2_nor2_1
X_36319_ _12349_ _12348_ _12309_ _11689_ VPWR VGND sg13g2_o21ai_1
X_36320_ _12350_ _11705_ _12349_ VPWR VGND sg13g2_xnor2_1
X_36321_ _12351_ _11393_ _11543_ _11882_ VPWR VGND sg13g2_o21ai_1
X_36322_ _12352_ _13848_ _11702_ _11392_ VPWR VGND sg13g2_a21oi_1
X_36323_ _12353_ _12323_ _11702_ _12352_ VPWR VGND sg13g2_a21o_1
X_36324_ _12354_ _11702_ _12351_ _12353_ _11543_ VPWR
+ VGND
+ sg13g2_a22oi_1
X_36325_ _12355_ _11981_ _11988_ VPWR VGND sg13g2_nor2_1
X_36326_ _12356_ _12311_ _12355_ _12060_ VPWR VGND sg13g2_mux2_1
X_36327_ _12357_ _12210_ _12356_ _11902_ VPWR VGND sg13g2_mux2_1
X_36328_ _12358_ _12058_ _12137_ _12357_ _11512_ VPWR
+ VGND
+ sg13g2_a22oi_1
X_36329_ _12359_ _13246_ _12358_ VPWR VGND sg13g2_nor2_1
X_36330_ _12360_ _12068_ _12065_ _12050_ VPWR VGND sg13g2_mux2_1
X_36331_ _12361_ _11473_ _12047_ VPWR VGND sg13g2_nand2_1
X_36332_ _12362_ _11414_ _12360_ _12361_ VPWR VGND sg13g2_o21ai_1
X_36333_ _12363_ _11403_ _12362_ _11977_ VPWR VGND sg13g2_a21oi_1
X_36334_ _12364_ _11573_ _12269_ VPWR VGND sg13g2_nor2_1
X_36335_ _12365_ _13220_ _11854_ VPWR VGND sg13g2_nor2_1
X_36336_ _12366_ _11412_ _11572_ _12365_ VPWR VGND sg13g2_o21ai_1
X_36337_ _12367_ _12050_ _12051_ _12268_ VPWR VGND sg13g2_nand3_1
X_36338_ _12368_ _12366_ _12367_ VPWR VGND sg13g2_nand2_1
X_36339_ _12369_ _12042_ _12364_ _12368_ VPWR VGND sg13g2_a21oi_1
X_36340_ _12370_ _12093_ _12369_ VPWR VGND sg13g2_nand2_1
X_36341_ _12371_ _12359_ _12363_ _12370_ VPWR VGND sg13g2_o21ai_1
X_36342_ _12372_ _12354_ _12371_ VPWR VGND sg13g2_nand2_1
X_36343_ _12373_ _12081_ _12347_ _12350_ _12073_ _12372_
+ VPWR
+ VGND sg13g2_a221oi_1
X_36344_ _02194_ _11095_ _12373_ VPWR VGND sg13g2_nor2_1
X_36345_ _12374_ _11543_ _11702_ VPWR VGND sg13g2_nand2_1
X_36346_ _12375_ _11543_ _11702_ _11535_ VPWR VGND sg13g2_a21oi_1
X_36347_ _12376_ _12345_ _12374_ _12375_ _12338_ VPWR
+ VGND
+ sg13g2_a22oi_1
X_36348_ _12377_ _11543_ _11702_ _12376_ VPWR VGND sg13g2_o21ai_1
X_36349_ _12378_ _11647_ _12377_ VPWR VGND sg13g2_xnor2_1
X_36350_ _12379_ _11379_ _11644_ _11377_ VPWR VGND sg13g2_o21ai_1
X_36351_ _12380_ _11646_ _12379_ _11877_ VPWR VGND sg13g2_a21o_1
X_36352_ _12381_ _11714_ _11646_ VPWR VGND sg13g2_nand2b_1
X_36353_ _12382_ _11646_ _11714_ VPWR VGND sg13g2_nand2b_1
X_36354_ _12383_ _12380_ _12381_ _12382_ VPWR VGND sg13g2_o21ai_1
X_36355_ _12384_ _11517_ _11646_ _12237_ VPWR VGND sg13g2_nand3_1
X_36356_ _12385_ _12384_ _12380_ VPWR VGND sg13g2_nand2_1
X_36357_ _12386_ _11517_ _12385_ _12381_ _12382_ VPWR
+ VGND
+ sg13g2_and4_1
X_36358_ _12387_ _11644_ _12383_ _12386_ VPWR VGND sg13g2_a21oi_1
X_36359_ _12388_ _11517_ _11646_ VPWR VGND sg13g2_nor2_1
X_36360_ _12389_ _12385_ _12388_ _13244_ VPWR VGND sg13g2_o21ai_1
X_36361_ _12390_ _11477_ _11644_ _11536_ VPWR VGND sg13g2_a21o_1
X_36362_ _12391_ _11944_ _12355_ VPWR VGND sg13g2_nand2_1
X_36363_ _12392_ _11389_ _12390_ _12391_ VPWR VGND sg13g2_o21ai_1
X_36364_ _12393_ _12257_ _11572_ VPWR VGND sg13g2_nand2b_1
X_36365_ _12394_ _12050_ _12392_ _12393_ VPWR VGND sg13g2_o21ai_1
X_36366_ _12395_ _11473_ _12091_ VPWR VGND sg13g2_nand2_1
X_36367_ _12396_ _11955_ _12394_ _12395_ VPWR VGND sg13g2_o21ai_1
X_36368_ _12397_ _12255_ _12396_ VPWR VGND sg13g2_nand2_1
X_36369_ _12398_ _11473_ _12103_ VPWR VGND sg13g2_and2_1
X_36370_ _12399_ _11513_ _12095_ _12398_ VPWR VGND sg13g2_a21oi_1
X_36371_ _12400_ _12093_ _12399_ _11595_ VPWR VGND sg13g2_o21ai_1
X_36372_ _12401_ _12269_ _12105_ VPWR VGND sg13g2_nand2b_1
X_36373_ _12402_ _12093_ _12366_ VPWR VGND sg13g2_and2_1
X_36374_ _12403_ _12397_ _12400_ _12401_ _12402_ VPWR
+ VGND
+ sg13g2_a22oi_1
X_36375_ _12404_ _12081_ _12378_ _12387_ _12389_ _12403_
+ VPWR
+ VGND sg13g2_a221oi_1
X_36376_ _02195_ _11095_ _12404_ VPWR VGND sg13g2_nor2_1
X_36377_ _12405_ _11434_ _11719_ VPWR VGND sg13g2_nor2_1
X_36378_ _12406_ _11388_ _11544_ _12405_ VPWR VGND sg13g2_nor3_1
X_36379_ _12407_ _11348_ _12390_ VPWR VGND sg13g2_nor2_1
X_36380_ _12408_ _12406_ _12407_ VPWR VGND sg13g2_nor2_1
X_36381_ _12409_ _11418_ _12285_ VPWR VGND sg13g2_nor2_1
X_36382_ _12410_ _11514_ _12408_ _12409_ VPWR VGND sg13g2_a21oi_1
X_36383_ _12411_ _11512_ _12123_ VPWR VGND sg13g2_nor2_1
X_36384_ _12412_ _12101_ _12410_ _12411_ VPWR VGND sg13g2_a21oi_1
X_36385_ _12413_ _13246_ _12412_ VPWR VGND sg13g2_nor2_1
X_36386_ _12414_ _12126_ _12135_ _11955_ VPWR VGND sg13g2_mux2_1
X_36387_ _12415_ _11404_ _12414_ _11977_ VPWR VGND sg13g2_a21oi_1
X_36388_ _12416_ _11955_ _12141_ _12266_ VPWR VGND sg13g2_o21ai_1
X_36389_ _12417_ _11970_ _11921_ _12268_ VPWR VGND sg13g2_nand3_1
X_36390_ _12418_ _11600_ _12416_ _12417_ VPWR VGND sg13g2_nand3_1
X_36391_ _12419_ _12413_ _12415_ _12418_ VPWR VGND sg13g2_o21ai_1
X_36392_ _12420_ _11644_ _12377_ VPWR VGND sg13g2_nor2_1
X_36393_ _12421_ _11644_ _12377_ VPWR VGND sg13g2_nand2_1
X_36394_ _12422_ _11646_ _12420_ _12421_ VPWR VGND sg13g2_o21ai_1
X_36395_ _12423_ _11639_ _12422_ VPWR VGND sg13g2_xnor2_1
X_36396_ _12424_ _11380_ _11520_ _11377_ VPWR VGND sg13g2_o21ai_1
X_36397_ _12425_ _11638_ _12424_ VPWR VGND sg13g2_nand2_1
X_36398_ _12426_ _11719_ _11638_ VPWR VGND sg13g2_nand2_1
X_36399_ _12427_ _12426_ VPWR VGND sg13g2_inv_1
X_36400_ _12428_ _11392_ _12425_ _12427_ _12237_ VPWR
+ VGND
+ sg13g2_a22oi_1
X_36401_ _12429_ _11719_ _11638_ VPWR VGND sg13g2_or2_1
X_36402_ _12430_ _12429_ VPWR VGND sg13g2_buf_1
X_36403_ _12431_ _12428_ _12430_ VPWR VGND sg13g2_nand2_1
X_36404_ _12432_ _12382_ VPWR VGND sg13g2_inv_1
X_36405_ _12433_ _11517_ _12381_ _12432_ VPWR VGND sg13g2_a21oi_1
X_36406_ _12434_ _11638_ _12433_ VPWR VGND sg13g2_nand2_1
X_36407_ _12435_ _11638_ _12433_ VPWR VGND sg13g2_or2_1
X_36408_ _12436_ _12435_ VPWR VGND sg13g2_buf_1
X_36409_ _12437_ _12428_ _12434_ _12436_ VPWR VGND sg13g2_o21ai_1
X_36410_ _12438_ _12436_ _12434_ VPWR VGND sg13g2_nand2_1
X_36411_ _12439_ _11520_ _12428_ _12438_ VPWR VGND sg13g2_nor3_1
X_36412_ _12440_ _13244_ _12431_ _12437_ _11520_ _12439_
+ VPWR
+ VGND sg13g2_a221oi_1
X_36413_ _12441_ _12081_ _12423_ _12440_ VPWR VGND sg13g2_a21oi_1
X_36414_ _02196_ _12419_ _12441_ _15251_ VPWR VGND sg13g2_a21oi_1
X_36415_ _12442_ _11542_ _11702_ _12430_ VPWR VGND sg13g2_o21ai_1
X_36416_ _12443_ _12442_ _11645_ VPWR VGND sg13g2_nand2b_1
X_36417_ _12444_ _12345_ _12374_ _12375_ _12338_ _12443_
+ VPWR
+ VGND sg13g2_a221oi_1
X_36418_ _12445_ _12444_ VPWR VGND sg13g2_buf_1
X_36419_ _12446_ _12442_ _11517_ VPWR VGND sg13g2_nand2b_1
X_36420_ _12447_ _12345_ _12374_ _12375_ _12338_ _12446_
+ VPWR
+ VGND sg13g2_a221oi_1
X_36421_ _12448_ _12447_ VPWR VGND sg13g2_buf_1
X_36422_ _12449_ _11517_ _11646_ _12430_ VPWR VGND sg13g2_nand3_1
X_36423_ _12450_ _12426_ _12449_ VPWR VGND sg13g2_nand2_1
X_36424_ _12451_ _12445_ _12448_ _12450_ VPWR VGND sg13g2_nor3_1
X_36425_ _12452_ _11636_ _12451_ VPWR VGND sg13g2_xnor2_1
X_36426_ _12453_ _12434_ VPWR VGND sg13g2_inv_1
X_36427_ _12454_ _11520_ _12436_ _12453_ VPWR VGND sg13g2_a21oi_1
X_36428_ _12455_ _11636_ _12454_ VPWR VGND sg13g2_xnor2_1
X_36429_ _12456_ _11351_ VPWR VGND sg13g2_buf_1
X_36430_ _12457_ _12173_ _12182_ _11473_ VPWR VGND sg13g2_mux2_1
X_36431_ _12458_ _11403_ _12457_ VPWR VGND sg13g2_nand2_1
X_36432_ _12459_ _11477_ _11525_ _11941_ VPWR VGND sg13g2_a21oi_1
X_36433_ _12460_ _11425_ _11544_ _12405_ VPWR VGND sg13g2_nor3_1
X_36434_ _12461_ _12060_ _12459_ _12460_ VPWR VGND sg13g2_a21oi_1
X_36435_ _12462_ _11902_ _12312_ VPWR VGND sg13g2_nor2_1
X_36436_ _12463_ _11969_ _12461_ _12462_ VPWR VGND sg13g2_a21oi_1
X_36437_ _12464_ _12101_ _12463_ VPWR VGND sg13g2_nand2_1
X_36438_ _12465_ _11473_ _12170_ VPWR VGND sg13g2_nand2_1
X_36439_ _12466_ _12464_ _12465_ _13246_ VPWR VGND sg13g2_a21oi_1
X_36440_ _12467_ _11595_ _12458_ _12466_ VPWR VGND sg13g2_a21oi_1
X_36441_ _12468_ _11955_ _12187_ _12266_ VPWR VGND sg13g2_o21ai_1
X_36442_ _12469_ _11604_ _11489_ _12268_ VPWR VGND sg13g2_nand3_1
X_36443_ _12470_ _12093_ _12468_ _12469_ VPWR VGND sg13g2_and3_1
X_36444_ _12471_ _12324_ _11635_ _12226_ VPWR VGND sg13g2_o21ai_1
X_36445_ _12472_ _11635_ _12326_ _11525_ VPWR VGND sg13g2_o21ai_1
X_36446_ _12473_ _11632_ _11716_ _12237_ VPWR VGND sg13g2_nand3_1
X_36447_ _12474_ _12471_ _12472_ _12473_ VPWR VGND sg13g2_nand3_1
X_36448_ _12475_ _12467_ _12470_ _12474_ VPWR VGND sg13g2_o21ai_1
X_36449_ _12476_ _11960_ _12452_ _12455_ _12456_ _12475_
+ VPWR
+ VGND sg13g2_a221oi_1
X_36450_ _02197_ _11095_ _12476_ VPWR VGND sg13g2_nor2_1
X_36451_ _12477_ _12950_ VPWR VGND sg13g2_buf_1
X_36452_ _12478_ _11635_ _12451_ _11525_ VPWR VGND sg13g2_o21ai_1
X_36453_ _12479_ _11635_ _12451_ VPWR VGND sg13g2_nand2_1
X_36454_ _12480_ _12478_ _12479_ VPWR VGND sg13g2_nand2_1
X_36455_ _12481_ _11642_ _12480_ VPWR VGND sg13g2_xnor2_1
X_36456_ _12482_ _11717_ _12454_ _11724_ VPWR VGND sg13g2_a21oi_1
X_36457_ _12483_ _11642_ _12482_ VPWR VGND sg13g2_xor2_1
X_36458_ _12484_ _11552_ _12215_ VPWR VGND sg13g2_nor2_1
X_36459_ _12485_ _11513_ _12203_ _12484_ VPWR VGND sg13g2_a21oi_1
X_36460_ _12486_ _11402_ _12365_ VPWR VGND sg13g2_nor2_1
X_36461_ _12487_ _12486_ VPWR VGND sg13g2_buf_1
X_36462_ _12488_ _11553_ _12051_ _12268_ VPWR VGND sg13g2_nand3_1
X_36463_ _12489_ _11977_ _12487_ _12488_ VPWR VGND sg13g2_o21ai_1
X_36464_ _12490_ _11600_ _12485_ _12489_ VPWR VGND sg13g2_o21ai_1
X_36465_ _12491_ _12254_ _11402_ VPWR VGND sg13g2_nand2_1
X_36466_ _12492_ _11422_ _11520_ VPWR VGND sg13g2_nand2_1
X_36467_ _12493_ _11422_ _11527_ _12492_ VPWR VGND sg13g2_o21ai_1
X_36468_ _12494_ _11388_ _12493_ VPWR VGND sg13g2_nor2_1
X_36469_ _12495_ _11944_ _12459_ _12494_ VPWR VGND sg13g2_a21oi_1
X_36470_ _12496_ _11902_ _12495_ VPWR VGND sg13g2_nand2_1
X_36471_ _12497_ _11419_ _12356_ _12496_ VPWR VGND sg13g2_o21ai_1
X_36472_ _12498_ _11901_ _12211_ VPWR VGND sg13g2_nand2_1
X_36473_ _12499_ _11901_ _12497_ _12498_ VPWR VGND sg13g2_o21ai_1
X_36474_ _12500_ _12491_ _12499_ VPWR VGND sg13g2_nand2b_1
X_36475_ _12501_ _11393_ _11527_ _11881_ VPWR VGND sg13g2_o21ai_1
X_36476_ _12502_ _13848_ _11641_ _11392_ VPWR VGND sg13g2_a21oi_1
X_36477_ _12503_ _12323_ _11641_ _12502_ VPWR VGND sg13g2_a21o_1
X_36478_ _12504_ _11641_ _12501_ _12503_ _11527_ VPWR
+ VGND
+ sg13g2_a22oi_1
X_36479_ _12505_ _12490_ _12500_ _12504_ VPWR VGND sg13g2_nand3_1
X_36480_ _12506_ _11960_ _12481_ _12483_ _12456_ _12505_
+ VPWR
+ VGND sg13g2_a221oi_1
X_36481_ _02198_ _12477_ _12506_ VPWR VGND sg13g2_nor2_1
X_36482_ _12507_ _11527_ _11641_ VPWR VGND sg13g2_nand2_1
X_36483_ _12508_ _11635_ _12507_ VPWR VGND sg13g2_nand2_1
X_36484_ _12509_ _12445_ _12448_ _12450_ _12508_ VPWR
+ VGND
+ sg13g2_nor4_1
X_36485_ _12510_ _11525_ _12507_ VPWR VGND sg13g2_nand2_1
X_36486_ _12511_ _12445_ _12448_ _12450_ _12510_ VPWR
+ VGND
+ sg13g2_nor4_1
X_36487_ _12512_ _11525_ _11635_ _12507_ VPWR VGND sg13g2_nand3_1
X_36488_ _12513_ _11527_ _11641_ _12512_ VPWR VGND sg13g2_o21ai_1
X_36489_ _12514_ _12509_ _12511_ _12513_ VPWR VGND sg13g2_or3_1
X_36490_ _12515_ _12514_ VPWR VGND sg13g2_buf_1
X_36491_ _12516_ _11759_ _12515_ VPWR VGND sg13g2_xnor2_1
X_36492_ _12517_ _11729_ _11759_ VPWR VGND sg13g2_xnor2_1
X_36493_ _12518_ _11977_ _11507_ _12487_ VPWR VGND sg13g2_nor3_1
X_36494_ _12519_ _11422_ _11525_ VPWR VGND sg13g2_nand2_1
X_36495_ _12520_ _11434_ _11438_ _12519_ VPWR VGND sg13g2_o21ai_1
X_36496_ _12521_ _11944_ _12520_ VPWR VGND sg13g2_nor2_1
X_36497_ _12522_ _12060_ _12493_ VPWR VGND sg13g2_nor2_1
X_36498_ _12523_ _12521_ _12522_ VPWR VGND sg13g2_or2_1
X_36499_ _12524_ _12392_ _12523_ _11969_ VPWR VGND sg13g2_mux2_1
X_36500_ _12525_ _12101_ _12259_ VPWR VGND sg13g2_nor2_1
X_36501_ _12526_ _11513_ _12524_ _12525_ VPWR VGND sg13g2_a21oi_1
X_36502_ _12527_ _11380_ _11755_ _11377_ VPWR VGND sg13g2_o21ai_1
X_36503_ _12528_ \alu_i.funct3[1]\ _11753_ _11438_ VPWR VGND sg13g2_o21ai_1
X_36504_ _12529_ _11758_ _12528_ VPWR VGND sg13g2_nand2_1
X_36505_ _12530_ _11598_ _11854_ VPWR VGND sg13g2_nand2_1
X_36506_ _12531_ _12530_ VPWR VGND sg13g2_buf_1
X_36507_ _12532_ _13220_ _12531_ VPWR VGND sg13g2_nand2b_1
X_36508_ _12533_ _12532_ VPWR VGND sg13g2_buf_1
X_36509_ _12534_ _11605_ _12533_ _11402_ VPWR VGND sg13g2_a21oi_1
X_36510_ _12535_ _11757_ _12527_ _12529_ _11877_ _12534_
+ VPWR
+ VGND sg13g2_a221oi_1
X_36511_ _12536_ _12491_ _12526_ _12535_ VPWR VGND sg13g2_o21ai_1
X_36512_ _12537_ _12518_ _12536_ VPWR VGND sg13g2_or2_1
X_36513_ _12538_ _11960_ _12516_ _12517_ _12456_ _12537_
+ VPWR
+ VGND sg13g2_a221oi_1
X_36514_ _02199_ _12477_ _12538_ VPWR VGND sg13g2_nor2_1
X_36515_ _12539_ _11648_ _11714_ _11728_ VPWR VGND sg13g2_a21oi_1
X_36516_ _12540_ _11758_ VPWR VGND sg13g2_inv_1
X_36517_ _12541_ _12539_ _11754_ _12540_ VPWR VGND sg13g2_a21oi_1
X_36518_ _12542_ _11751_ _12541_ VPWR VGND sg13g2_xnor2_1
X_36519_ _12543_ _11438_ _11757_ VPWR VGND sg13g2_nand2_1
X_36520_ _12544_ _11438_ _11757_ VPWR VGND sg13g2_nor2_1
X_36521_ _12545_ _12515_ _12543_ _12544_ VPWR VGND sg13g2_a21oi_1
X_36522_ _12546_ _11751_ _12545_ VPWR VGND sg13g2_xor2_1
X_36523_ _12547_ _11875_ _11441_ _11882_ VPWR VGND sg13g2_o21ai_1
X_36524_ _12548_ \alu_i.funct3[1]\ _11746_ _11744_ VPWR VGND sg13g2_o21ai_1
X_36525_ _12549_ _11750_ _12548_ VPWR VGND sg13g2_nand2_1
X_36526_ _12550_ _11749_ _12547_ _12549_ _11878_ VPWR
+ VGND
+ sg13g2_a22oi_1
X_36527_ _12551_ _11919_ _11404_ _11924_ VPWR VGND sg13g2_nand3_1
X_36528_ _12552_ _11448_ _11527_ VPWR VGND sg13g2_nor2_1
X_36529_ _12553_ _11449_ _11441_ _12552_ VPWR VGND sg13g2_a21oi_1
X_36530_ _12554_ _11348_ _12553_ VPWR VGND sg13g2_nand2_1
X_36531_ _12555_ _11348_ _12520_ _12554_ VPWR VGND sg13g2_o21ai_1
X_36532_ _12556_ _11572_ _12555_ VPWR VGND sg13g2_nor2_1
X_36533_ _12557_ _12050_ _12408_ _12556_ VPWR VGND sg13g2_a21oi_1
X_36534_ _12558_ _11473_ _12287_ VPWR VGND sg13g2_nand2_1
X_36535_ _12559_ _11414_ _12557_ _12558_ VPWR VGND sg13g2_o21ai_1
X_36536_ _12560_ _11932_ _12491_ _12559_ _11403_ VPWR
+ VGND
+ sg13g2_a22oi_1
X_36537_ _12561_ _11403_ _11917_ _12533_ VPWR VGND sg13g2_a21oi_1
X_36538_ _12562_ _12560_ _12561_ VPWR VGND sg13g2_nor2_1
X_36539_ _12563_ _12550_ _12551_ _12562_ VPWR VGND sg13g2_nand3_1
X_36540_ _12564_ _12456_ _12542_ _12546_ _12081_ _12563_
+ VPWR
+ VGND sg13g2_a221oi_1
X_36541_ _02200_ _12477_ _12564_ VPWR VGND sg13g2_nor2_1
X_36542_ _12565_ _11422_ _11755_ VPWR VGND sg13g2_nand2_1
X_36543_ _12566_ _11434_ _11735_ _12565_ VPWR VGND sg13g2_o21ai_1
X_36544_ _12567_ _11388_ _12553_ VPWR VGND sg13g2_nand2_1
X_36545_ _12568_ _11944_ _12566_ _12567_ VPWR VGND sg13g2_o21ai_1
X_36546_ _12569_ _11532_ _12461_ VPWR VGND sg13g2_nand2_1
X_36547_ _12570_ _11572_ _12568_ _12569_ VPWR VGND sg13g2_o21ai_1
X_36548_ _12571_ _11955_ _12314_ VPWR VGND sg13g2_nand2_1
X_36549_ _12572_ _11955_ _12570_ _12571_ VPWR VGND sg13g2_o21ai_1
X_36550_ _12573_ _12255_ _12572_ _12016_ VPWR VGND sg13g2_a21oi_1
X_36551_ _12574_ _12001_ _12487_ _12573_ _11404_ VPWR
+ VGND
+ sg13g2_a22oi_1
X_36552_ _12575_ _11875_ _11428_ _11882_ VPWR VGND sg13g2_o21ai_1
X_36553_ _12576_ \alu_i.funct3[1]\ _11737_ _11735_ VPWR VGND sg13g2_o21ai_1
X_36554_ _12577_ _11741_ _12576_ _12226_ VPWR VGND sg13g2_a21oi_1
X_36555_ _12578_ _12021_ _12531_ _12575_ _11740_ _12577_
+ VPWR
+ VGND sg13g2_a221oi_1
X_36556_ _12579_ _12574_ _12578_ VPWR VGND sg13g2_nor2b_1
X_36557_ _12580_ _11751_ _11759_ VPWR VGND sg13g2_nand2_1
X_36558_ _12581_ _12515_ _12580_ VPWR VGND sg13g2_nor2_1
X_36559_ _12582_ _11441_ _11746_ _12543_ VPWR VGND sg13g2_o21ai_1
X_36560_ _12583_ _11744_ _11749_ _12582_ VPWR VGND sg13g2_o21ai_1
X_36561_ _12584_ _12581_ _12583_ VPWR VGND sg13g2_nand2b_1
X_36562_ _12585_ _11742_ _12584_ VPWR VGND sg13g2_xor2_1
X_36563_ _12586_ _11747_ VPWR VGND sg13g2_inv_1
X_36564_ _12587_ _12586_ _12541_ _11750_ VPWR VGND sg13g2_o21ai_1
X_36565_ _12588_ _11742_ _12587_ VPWR VGND sg13g2_xor2_1
X_36566_ _12589_ _12081_ _12585_ _12588_ _12073_ VPWR
+ VGND
+ sg13g2_a22oi_1
X_36567_ _02201_ _12579_ _12589_ _15251_ VPWR VGND sg13g2_a21oi_1
X_36568_ _12590_ _11735_ _11740_ _12584_ VPWR VGND sg13g2_a21oi_1
X_36569_ _12591_ _11428_ _11737_ _12590_ VPWR VGND sg13g2_a21o_1
X_36570_ _12592_ _11733_ _12591_ VPWR VGND sg13g2_xnor2_1
X_36571_ _12593_ _11741_ VPWR VGND sg13g2_inv_1
X_36572_ _12594_ _12593_ _12587_ _11738_ VPWR VGND sg13g2_o21ai_1
X_36573_ _12595_ _11733_ _12594_ VPWR VGND sg13g2_xor2_1
X_36574_ _12596_ _11508_ _12049_ _12533_ VPWR VGND sg13g2_a21oi_1
X_36575_ _12597_ _11448_ _11744_ VPWR VGND sg13g2_nor2_1
X_36576_ _12598_ _11449_ _11730_ _12597_ VPWR VGND sg13g2_a21oi_1
X_36577_ _12599_ _11425_ _12598_ VPWR VGND sg13g2_nand2_1
X_36578_ _12600_ _11348_ _12566_ _12599_ VPWR VGND sg13g2_o21ai_1
X_36579_ _12601_ _11572_ _12600_ VPWR VGND sg13g2_nor2_1
X_36580_ _12602_ _12050_ _12495_ _12601_ VPWR VGND sg13g2_a21oi_1
X_36581_ _12603_ _11512_ _12357_ VPWR VGND sg13g2_or2_1
X_36582_ _12604_ _11414_ _12602_ _12603_ VPWR VGND sg13g2_o21ai_1
X_36583_ _12605_ _12059_ _12491_ _12604_ _11403_ VPWR
+ VGND
+ sg13g2_a22oi_1
X_36584_ _12606_ \alu_i.funct3[1]\ _11730_ VPWR VGND sg13g2_nor2_1
X_36585_ _12607_ _11431_ _11732_ VPWR VGND sg13g2_nor2_1
X_36586_ _12608_ _11732_ _12606_ _12607_ VPWR VGND sg13g2_a21oi_1
X_36587_ _12609_ _11380_ _11730_ _11377_ VPWR VGND sg13g2_o21ai_1
X_36588_ _12610_ _11877_ _12608_ _12609_ _11732_ VPWR
+ VGND
+ sg13g2_a22oi_1
X_36589_ _12611_ _11599_ _12053_ _12610_ VPWR VGND sg13g2_o21ai_1
X_36590_ _12612_ _12596_ _12605_ _12611_ VPWR VGND sg13g2_nor3_1
X_36591_ _12613_ _13244_ _12595_ _12612_ VPWR VGND sg13g2_o21ai_1
X_36592_ _12614_ _12081_ _12592_ _12613_ VPWR VGND sg13g2_a21oi_1
X_36593_ _02202_ _12477_ _12614_ VPWR VGND sg13g2_nor2_1
X_36594_ _12615_ _11431_ _11732_ VPWR VGND sg13g2_nand2_1
X_36595_ _12616_ _12607_ _12591_ _12615_ VPWR VGND sg13g2_o21ai_1
X_36596_ _12617_ _11784_ _12616_ VPWR VGND sg13g2_xor2_1
X_36597_ _12618_ _11767_ _11784_ VPWR VGND sg13g2_xor2_1
X_36598_ _12619_ _11422_ _11428_ VPWR VGND sg13g2_nand2_1
X_36599_ _12620_ _11434_ _11463_ _12619_ VPWR VGND sg13g2_o21ai_1
X_36600_ _12621_ _11944_ _12620_ VPWR VGND sg13g2_nor2_1
X_36601_ _12622_ _11944_ _12598_ _12621_ VPWR VGND sg13g2_a21oi_1
X_36602_ _12623_ _11514_ _12622_ VPWR VGND sg13g2_nand2_1
X_36603_ _12624_ _11969_ _12523_ _12623_ VPWR VGND sg13g2_o21ai_1
X_36604_ _12625_ _11414_ _12624_ VPWR VGND sg13g2_nor2_1
X_36605_ _12626_ _11552_ _12394_ VPWR VGND sg13g2_nor2_1
X_36606_ _12627_ _12625_ _12626_ _12255_ VPWR VGND sg13g2_o21ai_1
X_36607_ _12628_ _11599_ _12110_ VPWR VGND sg13g2_nor2_1
X_36608_ _12629_ _12092_ _12487_ _12627_ _12628_ VPWR
+ VGND
+ sg13g2_a22oi_1
X_36609_ _12630_ _11875_ _11780_ _11881_ VPWR VGND sg13g2_o21ai_1
X_36610_ _12631_ \alu_i.funct3[1]\ _11777_ _11463_ VPWR VGND sg13g2_o21ai_1
X_36611_ _12632_ _11783_ _12631_ _12226_ VPWR VGND sg13g2_a21oi_1
X_36612_ _12633_ _12108_ _12531_ _12630_ _11782_ _12632_
+ VPWR
+ VGND sg13g2_a221oi_1
X_36613_ _12634_ _12629_ _12633_ VPWR VGND sg13g2_nand2b_1
X_36614_ _12635_ _11960_ _12617_ _12618_ _12456_ _12634_
+ VPWR
+ VGND sg13g2_a221oi_1
X_36615_ _02203_ _12477_ _12635_ VPWR VGND sg13g2_nor2_1
X_36616_ _12636_ _11782_ _12616_ VPWR VGND sg13g2_nor2_1
X_36617_ _12637_ _11782_ _12616_ VPWR VGND sg13g2_nand2_1
X_36618_ _12638_ _11780_ _12636_ _12637_ VPWR VGND sg13g2_o21ai_1
X_36619_ _12639_ _11788_ _12638_ VPWR VGND sg13g2_xor2_1
X_36620_ _12640_ _11463_ _11777_ VPWR VGND sg13g2_nor2_1
X_36621_ _12641_ _11767_ _11778_ _12640_ VPWR VGND sg13g2_a21oi_1
X_36622_ _12642_ _11788_ _12641_ VPWR VGND sg13g2_xnor2_1
X_36623_ _12643_ _11449_ _11431_ VPWR VGND sg13g2_nor2_1
X_36624_ _12644_ _11477_ _11801_ _12643_ VPWR VGND sg13g2_a21oi_1
X_36625_ _12645_ _11348_ _12620_ VPWR VGND sg13g2_nor2_1
X_36626_ _12646_ _12060_ _12644_ _12645_ VPWR VGND sg13g2_a21oi_1
X_36627_ _12647_ _11418_ _12555_ VPWR VGND sg13g2_nor2_1
X_36628_ _12648_ _11514_ _12646_ _12647_ VPWR VGND sg13g2_a21oi_1
X_36629_ _12649_ _12410_ _12648_ _11512_ VPWR VGND sg13g2_mux2_1
X_36630_ _12650_ _12255_ _12649_ _12139_ VPWR VGND sg13g2_a21oi_1
X_36631_ _12651_ _12124_ _12487_ _12650_ _11508_ VPWR
+ VGND
+ sg13g2_a22oi_1
X_36632_ _12652_ _11402_ _11625_ VPWR VGND sg13g2_nor2_1
X_36633_ _12653_ _11380_ _11801_ _11377_ VPWR VGND sg13g2_o21ai_1
X_36634_ _12654_ \alu_i.funct3[1]\ _11787_ _11467_ VPWR VGND sg13g2_o21ai_1
X_36635_ _12655_ _11804_ _12654_ VPWR VGND sg13g2_nand2_1
X_36636_ _12656_ _11803_ _12653_ _12655_ _11877_ VPWR
+ VGND
+ sg13g2_a22oi_1
X_36637_ _12657_ _12143_ _12652_ _12656_ VPWR VGND sg13g2_o21ai_1
X_36638_ _12658_ _12651_ _12657_ VPWR VGND sg13g2_or2_1
X_36639_ _12659_ _11960_ _12639_ _12642_ _12456_ _12658_
+ VPWR
+ VGND sg13g2_a221oi_1
X_36640_ _02204_ _12477_ _12659_ VPWR VGND sg13g2_nor2_1
X_36641_ _12660_ _11787_ _12641_ _11467_ VPWR VGND sg13g2_a21o_1
X_36642_ _12661_ _11787_ _12641_ _12660_ VPWR VGND sg13g2_o21ai_1
X_36643_ _12662_ _11774_ _12661_ VPWR VGND sg13g2_xor2_1
X_36644_ _12663_ _11733_ _11742_ VPWR VGND sg13g2_and2_1
X_36645_ _12664_ _11777_ _11787_ VPWR VGND sg13g2_nand2_1
X_36646_ _12665_ _11801_ _11777_ VPWR VGND sg13g2_nand2_1
X_36647_ _12666_ _11737_ _12583_ _11428_ VPWR VGND sg13g2_a21oi_1
X_36648_ _12667_ _11737_ _12583_ VPWR VGND sg13g2_nor2_1
X_36649_ _12668_ _12666_ _12667_ VPWR VGND sg13g2_nor2_1
X_36650_ _12669_ _12607_ _12668_ _12615_ VPWR VGND sg13g2_o21ai_1
X_36651_ _12670_ _12581_ _12663_ _12664_ _12665_ _12669_
+ VPWR
+ VGND sg13g2_a221oi_1
X_36652_ _12671_ _11780_ _11787_ VPWR VGND sg13g2_nand2_1
X_36653_ _12672_ _11780_ _11801_ VPWR VGND sg13g2_nand2_1
X_36654_ _12673_ _12581_ _12663_ _12671_ _12672_ _12669_
+ VPWR
+ VGND sg13g2_a221oi_1
X_36655_ _12674_ _11463_ _11467_ VPWR VGND sg13g2_nor2_1
X_36656_ _12675_ _11801_ _11787_ _12674_ _11777_ VPWR
+ VGND
+ sg13g2_a22oi_1
X_36657_ _12676_ _11463_ _12664_ _12675_ VPWR VGND sg13g2_o21ai_1
X_36658_ _12677_ _12670_ _12673_ _12676_ VPWR VGND sg13g2_or3_1
X_36659_ _12678_ _11774_ _12677_ VPWR VGND sg13g2_xnor2_1
X_36660_ _12679_ _11449_ _11463_ VPWR VGND sg13g2_nor2_1
X_36661_ _12680_ _11434_ _11771_ VPWR VGND sg13g2_nor2_1
X_36662_ _12681_ _11388_ _12679_ _12680_ VPWR VGND sg13g2_nor3_1
X_36663_ _12682_ _11944_ _12644_ _12681_ VPWR VGND sg13g2_a21oi_1
X_36664_ _12683_ _11902_ _12682_ VPWR VGND sg13g2_nand2_1
X_36665_ _12684_ _11514_ _12568_ _12683_ VPWR VGND sg13g2_o21ai_1
X_36666_ _12685_ _11901_ _12684_ VPWR VGND sg13g2_nor2_1
X_36667_ _12686_ _11414_ _12463_ _12685_ VPWR VGND sg13g2_a21oi_1
X_36668_ _12687_ _13246_ _12686_ VPWR VGND sg13g2_nor2_1
X_36669_ _12688_ _12185_ _12687_ _11404_ VPWR VGND sg13g2_o21ai_1
X_36670_ _12689_ _11875_ _11458_ _11882_ VPWR VGND sg13g2_o21ai_1
X_36671_ _12690_ _13848_ _11769_ VPWR VGND sg13g2_and2_1
X_36672_ _12691_ _11458_ _12690_ _11773_ VPWR VGND sg13g2_o21ai_1
X_36673_ _12692_ _11769_ _12689_ _12691_ _11878_ VPWR
+ VGND
+ sg13g2_a22oi_1
X_36674_ _12693_ _12171_ _12533_ VPWR VGND sg13g2_nand2_1
X_36675_ _12694_ _12093_ _12189_ _12693_ VPWR VGND sg13g2_o21ai_1
X_36676_ _12695_ _12688_ _12692_ _12694_ VPWR VGND sg13g2_nand3_1
X_36677_ _12696_ _12456_ _12662_ _12678_ _12081_ _12695_
+ VPWR
+ VGND sg13g2_a221oi_1
X_36678_ _02205_ _12477_ _12696_ VPWR VGND sg13g2_nor2_1
X_36679_ _12697_ _11771_ _11769_ VPWR VGND sg13g2_nand2_1
X_36680_ _12698_ _11771_ _11769_ VPWR VGND sg13g2_nor2_1
X_36681_ _12699_ _12677_ _12697_ _12698_ VPWR VGND sg13g2_a21oi_1
X_36682_ _12700_ _11797_ _12699_ VPWR VGND sg13g2_xnor2_1
X_36683_ _12701_ _11871_ _12700_ VPWR VGND sg13g2_or2_1
X_36684_ _12702_ _11773_ VPWR VGND sg13g2_inv_1
X_36685_ _12703_ _12702_ _12661_ _11772_ VPWR VGND sg13g2_o21ai_1
X_36686_ _12704_ _11797_ _12703_ VPWR VGND sg13g2_xnor2_1
X_36687_ _12705_ _11450_ _11467_ VPWR VGND sg13g2_nor2_1
X_36688_ _12706_ _11564_ _11454_ _12705_ VPWR VGND sg13g2_a21oi_1
X_36689_ _12707_ _12060_ _12679_ _12680_ VPWR VGND sg13g2_nor3_1
X_36690_ _12708_ _11349_ _12706_ _12707_ VPWR VGND sg13g2_a21oi_1
X_36691_ _12709_ _11419_ _12600_ VPWR VGND sg13g2_nor2_1
X_36692_ _12710_ _11969_ _12708_ _12709_ VPWR VGND sg13g2_a21oi_1
X_36693_ _12711_ _11512_ _12710_ VPWR VGND sg13g2_nand2_1
X_36694_ _12712_ _12101_ _12497_ _12711_ VPWR VGND sg13g2_o21ai_1
X_36695_ _12713_ _12255_ _12712_ _11599_ VPWR VGND sg13g2_a21oi_1
X_36696_ _12714_ _12212_ _12487_ _12713_ _12217_ VPWR
+ VGND
+ sg13g2_a22oi_1
X_36697_ _12715_ \alu_i.funct3[1]\ _11791_ _11368_ VPWR VGND sg13g2_o21ai_1
X_36698_ _12716_ _12034_ _11791_ _12715_ VPWR VGND sg13g2_o21ai_1
X_36699_ _12717_ _11877_ _11454_ _11370_ VPWR VGND sg13g2_a21oi_1
X_36700_ _12718_ _11791_ _12717_ _11870_ VPWR VGND sg13g2_o21ai_1
X_36701_ _12719_ _12221_ _12531_ _12716_ _11794_ _12718_
+ VPWR
+ VGND sg13g2_a221oi_1
X_36702_ _12720_ _12714_ _12719_ VPWR VGND sg13g2_nand2b_1
X_36703_ _12721_ _12073_ _12704_ _12720_ VPWR VGND sg13g2_a21oi_1
X_36704_ _02206_ _12701_ _12721_ _15251_ VPWR VGND sg13g2_a21oi_1
X_36705_ _12722_ \alu_i.funct3[0]\ _11859_ VPWR VGND sg13g2_xnor2_1
X_36706_ _12723_ \alu_i.funct3[1]\ _11629_ \alu_i.funct3[2]\ VPWR VGND sg13g2_o21ai_1
X_36707_ _12724_ _11630_ _11648_ VPWR VGND sg13g2_nor2b_1
X_36708_ _12725_ _11996_ _11928_ VPWR VGND sg13g2_nand2_1
X_36709_ _12726_ _12147_ _12157_ _12196_ _12725_ VPWR
+ VGND
+ sg13g2_nor4_1
X_36710_ _12727_ _11867_ _11961_ _12024_ _12074_ VPWR
+ VGND
+ sg13g2_nor4_1
X_36711_ _12728_ _12726_ _12727_ VPWR VGND sg13g2_nand2_1
X_36712_ _12729_ _11798_ _11832_ _12728_ VPWR VGND sg13g2_nor3_1
X_36713_ _12730_ _11706_ _11760_ _12724_ _12729_ VPWR
+ VGND
+ sg13g2_and4_1
X_36714_ _12731_ _13212_ _12730_ VPWR VGND sg13g2_xnor2_1
X_36715_ _12732_ _11629_ VPWR VGND sg13g2_inv_1
X_36716_ _12733_ \alu_i.funct3[2]\ _12732_ _12722_ VPWR VGND sg13g2_nand3_1
X_36717_ _12734_ \alu_i.funct3[2]\ _12731_ _12733_ VPWR VGND sg13g2_o21ai_1
X_36718_ _12735_ _13848_ _12734_ VPWR VGND sg13g2_nand2_1
X_36719_ _12736_ _12722_ _12723_ _12735_ VPWR VGND sg13g2_o21ai_1
X_36720_ _12737_ _11454_ _11791_ VPWR VGND sg13g2_nor2_1
X_36721_ _12738_ _12737_ _12699_ _11792_ VPWR VGND sg13g2_o21ai_1
X_36722_ _12739_ _11819_ _12738_ VPWR VGND sg13g2_xor2_1
X_36723_ _12740_ _11809_ _11819_ VPWR VGND sg13g2_xnor2_1
X_36724_ _12741_ _11402_ _11927_ VPWR VGND sg13g2_nand2_1
X_36725_ _12742_ _12060_ _11458_ _11468_ VPWR VGND sg13g2_a21oi_1
X_36726_ _12743_ _11388_ _11498_ _11455_ VPWR VGND sg13g2_o21ai_1
X_36727_ _12744_ _11554_ _12743_ VPWR VGND sg13g2_nor2_1
X_36728_ _12745_ _11554_ _12742_ _12744_ VPWR VGND sg13g2_a21oi_1
X_36729_ _12746_ _12622_ _12745_ _11553_ VPWR VGND sg13g2_mux2_1
X_36730_ _12747_ \alu_i.funct3[1]\ _11815_ _11818_ VPWR VGND sg13g2_nor3_1
X_36731_ _12748_ _11815_ _11818_ _12747_ VPWR VGND sg13g2_a21oi_1
X_36732_ _12749_ _11380_ _11815_ _11377_ VPWR VGND sg13g2_o21ai_1
X_36733_ _12750_ \control_i.immediate[24]\ _11408_ _11816_ VPWR VGND sg13g2_a21o_1
X_36734_ _12751_ _12750_ VPWR VGND sg13g2_buf_1
X_36735_ _12752_ _11877_ _12748_ _12749_ _12751_ VPWR
+ VGND
+ sg13g2_a22oi_1
X_36736_ _12753_ _12741_ _12746_ _12752_ VPWR VGND sg13g2_o21ai_1
X_36737_ _12754_ _12219_ _12271_ _12652_ VPWR VGND sg13g2_nor3_1
X_36738_ _12755_ _13246_ _11511_ VPWR VGND sg13g2_nor2_1
X_36739_ _12756_ _12270_ _12268_ _12524_ _12755_ VPWR
+ VGND
+ sg13g2_a22oi_1
X_36740_ _12757_ _12262_ _12487_ _12756_ _11403_ VPWR
+ VGND
+ sg13g2_a22oi_1
X_36741_ _12758_ _12753_ _12754_ _12757_ VPWR VGND sg13g2_nor3_1
X_36742_ _12759_ _13244_ _12740_ _12758_ VPWR VGND sg13g2_o21ai_1
X_36743_ _12760_ _13209_ _12736_ _12739_ _11365_ _12759_
+ VPWR
+ VGND sg13g2_a221oi_1
X_36744_ _02207_ _12477_ _12760_ VPWR VGND sg13g2_nor2_1
X_36745_ _12761_ _11792_ _12751_ _12699_ VPWR VGND sg13g2_nand3_1
X_36746_ _12762_ _11795_ _11818_ _11815_ VPWR VGND sg13g2_o21ai_1
X_36747_ _12763_ _12762_ VPWR VGND sg13g2_inv_1
X_36748_ _12764_ _11818_ _12738_ _12761_ _12763_ VPWR
+ VGND
+ sg13g2_a22oi_1
X_36749_ _12765_ _12764_ VPWR VGND sg13g2_buf_1
X_36750_ _12766_ _11813_ _12765_ VPWR VGND sg13g2_xnor2_1
X_36751_ _12767_ _11498_ _11818_ _11809_ VPWR VGND sg13g2_a21oi_1
X_36752_ _12768_ _11815_ _12751_ _12767_ VPWR VGND sg13g2_a21oi_1
X_36753_ _12769_ _11813_ _12768_ VPWR VGND sg13g2_xor2_1
X_36754_ _12770_ _12557_ _12755_ _12295_ VPWR VGND sg13g2_a21oi_1
X_36755_ _12771_ _12290_ _12487_ _12770_ _11508_ VPWR
+ VGND
+ sg13g2_a22oi_1
X_36756_ _12772_ _12771_ VPWR VGND sg13g2_inv_1
X_36757_ _12773_ _12293_ _12531_ VPWR VGND sg13g2_nand2_1
X_36758_ _12774_ _11573_ _12646_ VPWR VGND sg13g2_nand2_1
X_36759_ _12775_ _11458_ _11454_ _11815_ _11500_ _11349_
+ _11565_
+ VPWR VGND sg13g2_mux4_1
X_36760_ _12776_ _11970_ _12775_ VPWR VGND sg13g2_nand2_1
X_36761_ _12777_ _11508_ _11927_ _12774_ _12776_ VPWR
+ VGND
+ sg13g2_nand4_1
X_36762_ _12778_ _11875_ _11500_ _11881_ VPWR VGND sg13g2_o21ai_1
X_36763_ _12779_ \alu_i.funct3[1]\ _11812_ _11837_ VPWR VGND sg13g2_o21ai_1
X_36764_ _12780_ _11837_ _11812_ _12779_ VPWR VGND sg13g2_o21ai_1
X_36765_ _12781_ _11836_ _12778_ _12780_ _11878_ VPWR
+ VGND
+ sg13g2_a22oi_1
X_36766_ _12782_ _12772_ _12773_ _12777_ _12781_ VPWR
+ VGND
+ sg13g2_nand4_1
X_36767_ _12783_ _11365_ _12766_ _12769_ _12456_ _12782_
+ VPWR
+ VGND sg13g2_a221oi_1
X_36768_ _02208_ _12477_ _12783_ VPWR VGND sg13g2_nor2_1
X_36769_ _12784_ _11831_ VPWR VGND sg13g2_inv_1
X_36770_ _12785_ _11500_ _11812_ VPWR VGND sg13g2_nor2_1
X_36771_ _12786_ _11500_ _11812_ VPWR VGND sg13g2_nand2_1
X_36772_ _12787_ _12785_ _12765_ _12786_ VPWR VGND sg13g2_o21ai_1
X_36773_ _12788_ _12784_ _12787_ VPWR VGND sg13g2_xnor2_1
X_36774_ _12789_ _11812_ _12768_ VPWR VGND sg13g2_nor2_1
X_36775_ _12790_ _11812_ _12768_ _11837_ VPWR VGND sg13g2_a21oi_1
X_36776_ _12791_ _12789_ _12790_ VPWR VGND sg13g2_nor2_1
X_36777_ _12792_ _12784_ _12791_ VPWR VGND sg13g2_xnor2_1
X_36778_ _12793_ _11886_ _11854_ _11599_ VPWR VGND sg13g2_o21ai_1
X_36779_ _12794_ _11564_ _11496_ _11501_ VPWR VGND sg13g2_nand3_1
X_36780_ _12795_ _11565_ _12743_ _12794_ VPWR VGND sg13g2_o21ai_1
X_36781_ _12796_ _11969_ _12795_ VPWR VGND sg13g2_nand2_1
X_36782_ _12797_ _11553_ _12682_ _12796_ VPWR VGND sg13g2_o21ai_1
X_36783_ _12798_ _11512_ _12570_ VPWR VGND sg13g2_nor2_1
X_36784_ _12799_ _11552_ _12797_ _12798_ VPWR VGND sg13g2_a21oi_1
X_36785_ _12800_ _11599_ _12321_ VPWR VGND sg13g2_nor2_1
X_36786_ _12801_ _13246_ _12799_ _12800_ VPWR VGND sg13g2_o21ai_1
X_36787_ _12802_ _12316_ _12793_ _12801_ VPWR VGND sg13g2_o21ai_1
X_36788_ _12803_ _12320_ _12531_ VPWR VGND sg13g2_nand2_1
X_36789_ _12804_ _11875_ _11495_ _11881_ VPWR VGND sg13g2_o21ai_1
X_36790_ _12805_ _13848_ _11827_ VPWR VGND sg13g2_and2_1
X_36791_ _12806_ _11495_ _11827_ VPWR VGND sg13g2_nand2_1
X_36792_ _12807_ _11495_ _12805_ _12806_ VPWR VGND sg13g2_o21ai_1
X_36793_ _12808_ _11827_ _12804_ _12807_ _11878_ VPWR
+ VGND
+ sg13g2_a22oi_1
X_36794_ _12809_ _12802_ _12803_ _12808_ VPWR VGND sg13g2_nand3_1
X_36795_ _12810_ _11365_ _12788_ _12792_ _12456_ _12809_
+ VPWR
+ VGND sg13g2_a221oi_1
X_36796_ _02209_ _12477_ _12810_ VPWR VGND sg13g2_nor2_1
X_36797_ _12811_ _11830_ _12787_ VPWR VGND sg13g2_nand2_1
X_36798_ _12812_ _11824_ _11828_ VPWR VGND sg13g2_nor2b_1
X_36799_ _12813_ _11500_ _11812_ _11830_ VPWR VGND sg13g2_o21ai_1
X_36800_ _12814_ _11828_ _12813_ VPWR VGND sg13g2_nand2_1
X_36801_ _12815_ _12811_ _12812_ _12814_ _11824_ VPWR
+ VGND
+ sg13g2_a22oi_1
X_36802_ _12816_ _12786_ _11824_ _12784_ _12765_ VPWR
+ VGND
+ sg13g2_and4_1
X_36803_ _12817_ _11871_ _12815_ _12816_ VPWR VGND sg13g2_nor3_1
X_36804_ _12818_ _12806_ _12791_ _11840_ VPWR VGND sg13g2_a21oi_1
X_36805_ _12819_ _11825_ _12818_ VPWR VGND sg13g2_xnor2_1
X_36806_ _12820_ _11351_ _12819_ VPWR VGND sg13g2_nand2_1
X_36807_ _12821_ _12602_ _12755_ _11598_ VPWR VGND sg13g2_a21oi_1
X_36808_ _12822_ _12369_ _12821_ VPWR VGND sg13g2_nand2_1
X_36809_ _12823_ _12359_ _12793_ _12822_ VPWR VGND sg13g2_o21ai_1
X_36810_ _12824_ _11565_ _11908_ _11910_ VPWR VGND sg13g2_nand3_1
X_36811_ _12825_ _11554_ _11893_ _11911_ VPWR VGND sg13g2_nand3_1
X_36812_ _12826_ _12824_ _12825_ VPWR VGND sg13g2_nand2_1
X_36813_ _12827_ _11970_ _12826_ VPWR VGND sg13g2_nand2_1
X_36814_ _12828_ _11970_ _12708_ _12827_ VPWR VGND sg13g2_o21ai_1
X_36815_ _12829_ _12741_ _12828_ VPWR VGND sg13g2_nand2b_1
X_36816_ _12830_ _11875_ _11821_ _11881_ VPWR VGND sg13g2_o21ai_1
X_36817_ _12831_ _13848_ _11823_ VPWR VGND sg13g2_and2_1
X_36818_ _12832_ _11821_ _12831_ _11834_ VPWR VGND sg13g2_o21ai_1
X_36819_ _12833_ _11823_ _12830_ _12832_ _11878_ VPWR
+ VGND
+ sg13g2_a22oi_1
X_36820_ _12834_ _12820_ _12823_ _12829_ _12833_ VPWR
+ VGND
+ sg13g2_nand4_1
X_36821_ _12835_ _12817_ _12834_ reset VPWR VGND sg13g2_o21ai_1
X_36822_ _02210_ _12835_ VPWR VGND sg13g2_inv_1
X_36823_ _12836_ _11613_ _11843_ VPWR VGND sg13g2_xnor2_1
X_36824_ _12837_ _11493_ _11823_ VPWR VGND sg13g2_nor2_1
X_36825_ _12838_ _11493_ _11823_ VPWR VGND sg13g2_nand2_1
X_36826_ _12839_ _12837_ _12814_ _12838_ VPWR VGND sg13g2_o21ai_1
X_36827_ _12840_ _12816_ _12839_ VPWR VGND sg13g2_nor2_1
X_36828_ _12841_ _11613_ _12840_ VPWR VGND sg13g2_xor2_1
X_36829_ _12842_ _11573_ _12745_ VPWR VGND sg13g2_nand2_1
X_36830_ _12843_ _11450_ _11829_ VPWR VGND sg13g2_nor2_1
X_36831_ _12844_ _11564_ _11481_ _12843_ VPWR VGND sg13g2_a21oi_1
X_36832_ _12845_ _11424_ _11500_ VPWR VGND sg13g2_nand2_1
X_36833_ _12846_ _11424_ _11493_ _12845_ VPWR VGND sg13g2_o21ai_1
X_36834_ _12847_ _11389_ _12846_ VPWR VGND sg13g2_nand2_1
X_36835_ _12848_ _11389_ _12844_ _12847_ VPWR VGND sg13g2_o21ai_1
X_36836_ _12849_ _11553_ _12848_ VPWR VGND sg13g2_nand2_1
X_36837_ _12850_ _12101_ _12842_ _12849_ VPWR VGND sg13g2_nand3_1
X_36838_ _12851_ _11513_ _12624_ _12850_ VPWR VGND sg13g2_o21ai_1
X_36839_ _12852_ _12105_ _12268_ _12851_ _12255_ _12093_
+ VPWR
+ VGND sg13g2_a221oi_1
X_36840_ _12853_ _12255_ _12396_ _11404_ VPWR VGND sg13g2_a21oi_1
X_36841_ _12854_ _11380_ _11481_ _11881_ VPWR VGND sg13g2_o21ai_1
X_36842_ _12855_ \alu_i.funct3[1]\ _11481_ VPWR VGND sg13g2_nor2_1
X_36843_ _12856_ _11610_ _12855_ _11611_ VPWR VGND sg13g2_a21oi_1
X_36844_ _12857_ _11598_ _11413_ _12050_ VPWR VGND sg13g2_nor3_1
X_36845_ _12858_ _11854_ _12857_ VPWR VGND sg13g2_nor2_1
X_36846_ _12859_ _11491_ _12857_ _12858_ VPWR VGND sg13g2_a21oi_1
X_36847_ _12860_ _11886_ _12859_ VPWR VGND sg13g2_nor2_1
X_36848_ _12861_ _11610_ _12854_ _12856_ _11878_ _12860_
+ VPWR
+ VGND sg13g2_a221oi_1
X_36849_ _12862_ _12852_ _12853_ _12861_ VPWR VGND sg13g2_o21ai_1
X_36850_ _12863_ _12456_ _12836_ _12841_ _11365_ _12862_
+ VPWR
+ VGND sg13g2_a221oi_1
X_36851_ _02211_ _13305_ _12863_ VPWR VGND sg13g2_nor2_1
X_36852_ _12864_ _11612_ _12840_ _11611_ VPWR VGND sg13g2_a21o_1
X_36853_ _12865_ _12864_ VPWR VGND sg13g2_buf_1
X_36854_ _12866_ _11623_ _12865_ VPWR VGND sg13g2_or2_1
X_36855_ _12867_ _11623_ _12865_ VPWR VGND sg13g2_nand2_1
X_36856_ _12868_ _11365_ _12866_ _12867_ VPWR VGND sg13g2_nand3_1
X_36857_ _12869_ _11610_ _11843_ _11481_ VPWR VGND sg13g2_a21o_1
X_36858_ _12870_ _11610_ _11843_ _12869_ VPWR VGND sg13g2_o21ai_1
X_36859_ _12871_ _11623_ _12870_ VPWR VGND sg13g2_xor2_1
X_36860_ _12872_ _11380_ _11847_ _11881_ VPWR VGND sg13g2_o21ai_1
X_36861_ _12873_ \alu_i.funct3[1]\ _11847_ _11848_ VPWR VGND sg13g2_nor3_1
X_36862_ _12874_ _11620_ _12873_ VPWR VGND sg13g2_nor2_1
X_36863_ _12875_ _11598_ _11901_ _11625_ VPWR VGND sg13g2_o21ai_1
X_36864_ _12876_ _11402_ _11552_ _12141_ VPWR VGND sg13g2_nand3_1
X_36865_ _12877_ _12875_ _12876_ _11886_ VPWR VGND sg13g2_a21oi_1
X_36866_ _12878_ _11619_ _12872_ _12874_ _11878_ _12877_
+ VPWR
+ VGND sg13g2_a221oi_1
X_36867_ _12879_ _11450_ _11493_ VPWR VGND sg13g2_nor2_1
X_36868_ _12880_ _11564_ _11847_ _12879_ VPWR VGND sg13g2_a21oi_1
X_36869_ _12881_ _12844_ _12880_ _11349_ VPWR VGND sg13g2_mux2_1
X_36870_ _12882_ _11969_ _12881_ VPWR VGND sg13g2_nand2_1
X_36871_ _12883_ _11553_ _12775_ _12882_ VPWR VGND sg13g2_o21ai_1
X_36872_ _12884_ _12648_ _12755_ _12883_ _11927_ VPWR
+ VGND
+ sg13g2_a22oi_1
X_36873_ _12885_ _12417_ _12884_ _11599_ VPWR VGND sg13g2_a21oi_1
X_36874_ _12886_ _11600_ _12413_ _12885_ VPWR VGND sg13g2_a21oi_1
X_36875_ _12887_ _12878_ _12886_ VPWR VGND sg13g2_nand2_1
X_36876_ _12888_ _12073_ _12871_ _12887_ VPWR VGND sg13g2_a21oi_1
X_36877_ _02212_ _12868_ _12888_ _15251_ VPWR VGND sg13g2_a21oi_1
X_36878_ _12889_ _11848_ _12870_ VPWR VGND sg13g2_nor2_1
X_36879_ _12890_ _11848_ _12870_ _11479_ VPWR VGND sg13g2_a21oi_1
X_36880_ _12891_ _12889_ _12890_ VPWR VGND sg13g2_nor2_1
X_36881_ _12892_ _11616_ _12891_ VPWR VGND sg13g2_xor2_1
X_36882_ _12893_ _11621_ _12865_ _11620_ VPWR VGND sg13g2_a21oi_1
X_36883_ _12894_ _11616_ _12893_ VPWR VGND sg13g2_xnor2_1
X_36884_ _12895_ _11554_ _11481_ VPWR VGND sg13g2_nand2_1
X_36885_ _12896_ _11565_ _11845_ VPWR VGND sg13g2_nand2_1
X_36886_ _12897_ _11349_ _12895_ _12896_ VPWR VGND sg13g2_nand3_1
X_36887_ _12898_ _11390_ _12880_ VPWR VGND sg13g2_nand2_1
X_36888_ _12899_ _12897_ _12898_ _11573_ VPWR VGND sg13g2_a21oi_1
X_36889_ _12900_ _11573_ _12795_ _12899_ VPWR VGND sg13g2_a21oi_1
X_36890_ _12901_ _12741_ _12900_ VPWR VGND sg13g2_or2_1
X_36891_ _12902_ _11380_ _11845_ _11881_ VPWR VGND sg13g2_o21ai_1
X_36892_ _12903_ _13848_ _11615_ VPWR VGND sg13g2_and2_1
X_36893_ _12904_ _11845_ _12903_ _11846_ VPWR VGND sg13g2_o21ai_1
X_36894_ _12905_ _11402_ _11552_ _12187_ VPWR VGND sg13g2_nand3_1
X_36895_ _12906_ _12875_ _12905_ _11886_ VPWR VGND sg13g2_a21oi_1
X_36896_ _12907_ _11615_ _12902_ _12904_ _11878_ _12906_
+ VPWR
+ VGND sg13g2_a221oi_1
X_36897_ _12908_ _12684_ _12755_ VPWR VGND sg13g2_nand2b_1
X_36898_ _12909_ _11508_ _12469_ _12908_ VPWR VGND sg13g2_nand3_1
X_36899_ _12910_ _11508_ _12466_ _12909_ VPWR VGND sg13g2_o21ai_1
X_36900_ _12911_ _12901_ _12907_ _12910_ VPWR VGND sg13g2_nand3_1
X_36901_ _12912_ _11351_ _12892_ _12894_ _11365_ _12911_
+ VPWR
+ VGND sg13g2_a221oi_1
X_36902_ _02213_ _13305_ _12912_ VPWR VGND sg13g2_nor2_1
X_36903_ _12913_ _11846_ _12891_ _11852_ VPWR VGND sg13g2_a21oi_1
X_36904_ _12914_ _11859_ _12913_ _12732_ VPWR VGND sg13g2_mux2_1
X_36905_ _12915_ _12708_ VPWR VGND sg13g2_inv_1
X_36906_ _12916_ _11486_ _11625_ _11608_ _11479_ _11349_
+ _11554_
+ VPWR VGND sg13g2_mux4_1
X_36907_ _12917_ _12600_ _12915_ _12826_ _12916_ _11553_
+ _12101_
+ VPWR VGND sg13g2_mux4_1
X_36908_ _12918_ _12499_ _12917_ _11403_ VPWR VGND sg13g2_mux2_1
X_36909_ _12919_ _11393_ _11625_ _11882_ VPWR VGND sg13g2_o21ai_1
X_36910_ _12920_ _11599_ _12488_ VPWR VGND sg13g2_or2_1
X_36911_ _12921_ _11486_ _11615_ VPWR VGND sg13g2_nor2_1
X_36912_ _12922_ _11365_ _12921_ _12732_ VPWR VGND sg13g2_nand3_1
X_36913_ _12923_ _13848_ _11627_ VPWR VGND sg13g2_nand2_1
X_36914_ _12924_ _12323_ _11627_ _12923_ _11368_ VPWR
+ VGND
+ sg13g2_a22oi_1
X_36915_ _12925_ _11886_ _12924_ _11854_ VPWR VGND sg13g2_a21o_1
X_36916_ _12926_ _12920_ _12922_ _12925_ VPWR VGND sg13g2_nand3_1
X_36917_ _12927_ _12255_ _12918_ _12919_ _11627_ _12926_
+ VPWR
+ VGND sg13g2_a221oi_1
X_36918_ _12928_ _13244_ _12914_ _12927_ VPWR VGND sg13g2_o21ai_1
X_36919_ _12929_ _11615_ _11629_ VPWR VGND sg13g2_nand2b_1
X_36920_ _12930_ _11845_ _11629_ VPWR VGND sg13g2_nand2_1
X_36921_ _12931_ _12929_ _12930_ _12893_ VPWR VGND sg13g2_a21o_1
X_36922_ _12932_ _11486_ _11615_ VPWR VGND sg13g2_nand2_1
X_36923_ _12933_ _12921_ _11629_ VPWR VGND sg13g2_nand2_1
X_36924_ _12934_ _12932_ _11629_ _12933_ VPWR VGND sg13g2_o21ai_1
X_36925_ _12935_ _12732_ _12893_ _12934_ VPWR VGND sg13g2_a21oi_1
X_36926_ _12936_ reset _11365_ _12931_ _12935_ VPWR
+ VGND
+ sg13g2_and4_1
X_36927_ _02214_ reset _12928_ _12936_ VPWR VGND sg13g2_a21o_1
X_36928_ \memory_i.state[0]\ clk _00031_ _17346_ VPWR VGND sg13g2_dfrbpq_1
X_36929_ \memory_i.state[1]\ clk _00032_ _17347_ VPWR VGND sg13g2_dfrbpq_1
X_36930_ \memory_i.state[2]\ clk _00033_ _17348_ VPWR VGND sg13g2_dfrbpq_1
X_36931_ \memory_i.state[4]\ clk _00034_ _17349_ VPWR VGND sg13g2_dfrbpq_1
X_36932_ \control_i.mem_valid\ clk _00035_ _17350_ VPWR VGND sg13g2_dfrbpq_1
X_36933_ \memory_i.state[6]\ clk _00036_ _17351_ VPWR VGND sg13g2_dfrbpq_1
X_36934_ \control_i.load_access_fault\ clk _00037_ _17352_ VPWR VGND sg13g2_dfrbpq_1
X_36935_ \memory_i.sram_master.state[0]\ clk _00024_ _17353_ VPWR VGND sg13g2_dfrbpq_1
X_36936_ \memory_i.sram_master.state[1]\ clk _00025_ _17354_ VPWR VGND sg13g2_dfrbpq_1
X_36937_ \memory_i.sram_master.state[2]\ clk _00026_ _17355_ VPWR VGND sg13g2_dfrbpq_1
X_36938_ \memory_i.sram_master.state[3]\ clk _00027_ _17356_ VPWR VGND sg13g2_dfrbpq_1
X_36939_ \memory_i.sram_master.state[4]\ clk _00028_ _17357_ VPWR VGND sg13g2_dfrbpq_1
X_36940_ \memory_i.sram_master.state[5]\ clk _00029_ _17358_ VPWR VGND sg13g2_dfrbpq_1
X_36941_ \memory_i.sram_master.state[6]\ clk _00030_ _17359_ VPWR VGND sg13g2_dfrbpq_1
X_36942_ \memory_i.i2c_master.state[0]\ clk _00013_ _17360_ VPWR VGND sg13g2_dfrbpq_1
X_36943_ \memory_i.i2c_master.state[1]\ clk _00015_ _17361_ VPWR VGND sg13g2_dfrbpq_1
X_36944_ \memory_i.i2c_master.state[2]\ clk _00016_ _17362_ VPWR VGND sg13g2_dfrbpq_1
X_36945_ \memory_i.i2c_master.state[3]\ clk _00017_ _17363_ VPWR VGND sg13g2_dfrbpq_1
X_36946_ \memory_i.i2c_master.state[4]\ clk _00018_ _17364_ VPWR VGND sg13g2_dfrbpq_1
X_36947_ \memory_i.i2c_master.state[5]\ clk _00019_ _17365_ VPWR VGND sg13g2_dfrbpq_1
X_36948_ \memory_i.i2c_master.state[6]\ clk _00020_ _17366_ VPWR VGND sg13g2_dfrbpq_1
X_36949_ \memory_i.i2c_master.state[7]\ clk _00021_ _17367_ VPWR VGND sg13g2_dfrbpq_1
X_36950_ \memory_i.i2c_master.state[8]\ clk _00022_ _17368_ VPWR VGND sg13g2_dfrbpq_1
X_36951_ \memory_i.i2c_master.state[9]\ clk _00023_ _17369_ VPWR VGND sg13g2_dfrbpq_1
X_36952_ \memory_i.i2c_master.state[10]\ clk _00014_ _17370_ VPWR VGND sg13g2_dfrbpq_1
X_36953_ \memory_i.freq_inst.transmit_state[0]\ clk _00009_ _17371_ VPWR VGND sg13g2_dfrbpq_1
X_36954_ \memory_i.freq_inst.transmit_state[1]\ clk _00010_ _17372_ VPWR VGND sg13g2_dfrbpq_1
X_36955_ \memory_i.freq_inst.transmit_state[2]\ clk _00011_ _17373_ VPWR VGND sg13g2_dfrbpq_1
X_36956_ \memory_i.freq_inst.transmit_state[3]\ clk _00012_ _17374_ VPWR VGND sg13g2_dfrbpq_1
X_36957_ \control_i.state_q[0]\ clk _00002_ _17375_ VPWR VGND sg13g2_dfrbpq_1
X_36958_ \control_i.jump_to_isr\ clk _00003_ _17376_ VPWR VGND sg13g2_dfrbpq_1
X_36959_ \control_i.state_q[2]\ clk _00000_ _17377_ VPWR VGND sg13g2_dfrbpq_1
X_36960_ \control_i.state_q[3]\ clk _00004_ _17378_ VPWR VGND sg13g2_dfrbpq_1
X_36961_ \control_i.state_q[4]\ clk _00005_ _17379_ VPWR VGND sg13g2_dfrbpq_1
X_36962_ \control_i.state_q[5]\ clk _00006_ _17380_ VPWR VGND sg13g2_dfrbpq_1
X_36963_ \control_i.state_q[6]\ clk _00007_ _17381_ VPWR VGND sg13g2_dfrbpq_1
X_36964_ \control_i.state_q[7]\ clk _00001_ _17414_ VPWR VGND sg13g2_dfrbpq_1
X_36965_ \control_i.pcflag\ clk _00008_ _17345_ VPWR VGND sg13g2_dfrbpq_1
X_36966_ \csr_i.data_in[0]\ clk _00047_ _18003_ VPWR VGND sg13g2_dfrbpq_1
X_36967_ \csr_i.data_in[1]\ clk _00048_ _18002_ VPWR VGND sg13g2_dfrbpq_1
X_36968_ \csr_i.data_in[2]\ clk _00049_ _18001_ VPWR VGND sg13g2_dfrbpq_1
X_36969_ \csr_i.data_in[3]\ clk _00050_ _18000_ VPWR VGND sg13g2_dfrbpq_1
X_36970_ \csr_i.data_in[4]\ clk _00051_ _17999_ VPWR VGND sg13g2_dfrbpq_1
X_36971_ \csr_i.data_in[5]\ clk _00052_ _17998_ VPWR VGND sg13g2_dfrbpq_1
X_36972_ \csr_i.data_in[6]\ clk _00053_ _17997_ VPWR VGND sg13g2_dfrbpq_1
X_36973_ \csr_i.data_in[7]\ clk _00054_ _17996_ VPWR VGND sg13g2_dfrbpq_1
X_36974_ \csr_i.data_in[8]\ clk _00055_ _17995_ VPWR VGND sg13g2_dfrbpq_1
X_36975_ \csr_i.data_in[9]\ clk _00056_ _17994_ VPWR VGND sg13g2_dfrbpq_1
X_36976_ \csr_i.data_in[10]\ clk _00057_ _17993_ VPWR VGND sg13g2_dfrbpq_1
X_36977_ \csr_i.data_in[11]\ clk _00058_ _17992_ VPWR VGND sg13g2_dfrbpq_1
X_36978_ \csr_i.data_in[12]\ clk _00059_ _17991_ VPWR VGND sg13g2_dfrbpq_1
X_36979_ \csr_i.data_in[13]\ clk _00060_ _17990_ VPWR VGND sg13g2_dfrbpq_1
X_36980_ \csr_i.data_in[14]\ clk _00061_ _17989_ VPWR VGND sg13g2_dfrbpq_1
X_36981_ \csr_i.data_in[15]\ clk _00062_ _17988_ VPWR VGND sg13g2_dfrbpq_1
X_36982_ \csr_i.data_in[16]\ clk _00063_ _17987_ VPWR VGND sg13g2_dfrbpq_1
X_36983_ \csr_i.data_in[17]\ clk _00064_ _17986_ VPWR VGND sg13g2_dfrbpq_1
X_36984_ \csr_i.data_in[18]\ clk _00065_ _17985_ VPWR VGND sg13g2_dfrbpq_1
X_36985_ \csr_i.data_in[19]\ clk _00066_ _17984_ VPWR VGND sg13g2_dfrbpq_1
X_36986_ \csr_i.data_in[20]\ clk _00067_ _17983_ VPWR VGND sg13g2_dfrbpq_1
X_36987_ \csr_i.data_in[21]\ clk _00068_ _17982_ VPWR VGND sg13g2_dfrbpq_1
X_36988_ \csr_i.data_in[22]\ clk _00069_ _17981_ VPWR VGND sg13g2_dfrbpq_1
X_36989_ \csr_i.data_in[23]\ clk _00070_ _17980_ VPWR VGND sg13g2_dfrbpq_1
X_36990_ \csr_i.data_in[24]\ clk _00071_ _17979_ VPWR VGND sg13g2_dfrbpq_1
X_36991_ \csr_i.data_in[25]\ clk _00072_ _17978_ VPWR VGND sg13g2_dfrbpq_1
X_36992_ \csr_i.data_in[26]\ clk _00073_ _17977_ VPWR VGND sg13g2_dfrbpq_1
X_36993_ \csr_i.data_in[27]\ clk _00074_ _17976_ VPWR VGND sg13g2_dfrbpq_1
X_36994_ \csr_i.data_in[28]\ clk _00075_ _17975_ VPWR VGND sg13g2_dfrbpq_1
X_36995_ \csr_i.data_in[29]\ clk _00076_ _17974_ VPWR VGND sg13g2_dfrbpq_1
X_36996_ \csr_i.data_in[30]\ clk _00077_ _17973_ VPWR VGND sg13g2_dfrbpq_1
X_36997_ \csr_i.data_in[31]\ clk _00078_ _17415_ VPWR VGND sg13g2_dfrbpq_1
X_36998_ \memory_i.freq_inst.cordic.rstn_i\ clk \memory_i.freq_inst.reset_n\ _17416_ VPWR VGND sg13g2_dfrbpq_1
X_36999_ \memory_i.i2c_master.sda_i_sync1\ clk \memory_i.i2c_master.sda_i_sync0\ _17417_ VPWR VGND sg13g2_dfrbpq_1
X_37000_ \memory_i.i2c_master.sda_i_sync0\ clk sda_i _17418_ VPWR VGND sg13g2_dfrbpq_1
X_37001_ \memory_i.sram_master.negedge_trigger\ clk \memory_i.sram_master.clk_counter[0]\ _17451_ VPWR VGND sg13g2_dfrbpq_1
X_37002_ \memory_i.sram_master.posedge_trigger\ clk _00045_ _17972_ VPWR VGND sg13g2_dfrbpq_1
X_37003_ \memory_i.datain[0]\ clk _00079_ _17971_ VPWR VGND sg13g2_dfrbpq_1
X_37004_ \memory_i.datain[1]\ clk _00080_ _17970_ VPWR VGND sg13g2_dfrbpq_1
X_37005_ \memory_i.datain[2]\ clk _00081_ _17969_ VPWR VGND sg13g2_dfrbpq_1
X_37006_ \memory_i.datain[3]\ clk _00082_ _17968_ VPWR VGND sg13g2_dfrbpq_1
X_37007_ \memory_i.datain[4]\ clk _00083_ _17967_ VPWR VGND sg13g2_dfrbpq_1
X_37008_ \memory_i.datain[5]\ clk _00084_ _17966_ VPWR VGND sg13g2_dfrbpq_1
X_37009_ \memory_i.datain[6]\ clk _00085_ _17965_ VPWR VGND sg13g2_dfrbpq_1
X_37010_ \memory_i.datain[7]\ clk _00086_ _17964_ VPWR VGND sg13g2_dfrbpq_1
X_37011_ \memory_i.datain[8]\ clk _00087_ _17963_ VPWR VGND sg13g2_dfrbpq_1
X_37012_ \memory_i.datain[9]\ clk _00088_ _17962_ VPWR VGND sg13g2_dfrbpq_1
X_37013_ \memory_i.datain[10]\ clk _00089_ _17961_ VPWR VGND sg13g2_dfrbpq_1
X_37014_ \memory_i.datain[11]\ clk _00090_ _17960_ VPWR VGND sg13g2_dfrbpq_1
X_37015_ \memory_i.datain[12]\ clk _00091_ _17959_ VPWR VGND sg13g2_dfrbpq_1
X_37016_ \memory_i.datain[13]\ clk _00092_ _17958_ VPWR VGND sg13g2_dfrbpq_1
X_37017_ \memory_i.datain[14]\ clk _00093_ _17957_ VPWR VGND sg13g2_dfrbpq_1
X_37018_ \memory_i.datain[15]\ clk _00094_ _17956_ VPWR VGND sg13g2_dfrbpq_1
X_37019_ \memory_i.datain[16]\ clk _00095_ _17955_ VPWR VGND sg13g2_dfrbpq_1
X_37020_ \memory_i.datain[17]\ clk _00096_ _17954_ VPWR VGND sg13g2_dfrbpq_1
X_37021_ \memory_i.datain[18]\ clk _00097_ _17953_ VPWR VGND sg13g2_dfrbpq_1
X_37022_ \memory_i.datain[19]\ clk _00098_ _17952_ VPWR VGND sg13g2_dfrbpq_1
X_37023_ \memory_i.datain[20]\ clk _00099_ _17951_ VPWR VGND sg13g2_dfrbpq_1
X_37024_ \memory_i.datain[21]\ clk _00100_ _17950_ VPWR VGND sg13g2_dfrbpq_1
X_37025_ \memory_i.datain[22]\ clk _00101_ _17949_ VPWR VGND sg13g2_dfrbpq_1
X_37026_ \memory_i.datain[23]\ clk _00102_ _17948_ VPWR VGND sg13g2_dfrbpq_1
X_37027_ \memory_i.datain[24]\ clk _00103_ _17947_ VPWR VGND sg13g2_dfrbpq_1
X_37028_ \memory_i.datain[25]\ clk _00104_ _17946_ VPWR VGND sg13g2_dfrbpq_1
X_37029_ \memory_i.datain[26]\ clk _00105_ _17945_ VPWR VGND sg13g2_dfrbpq_1
X_37030_ \memory_i.datain[27]\ clk _00106_ _17944_ VPWR VGND sg13g2_dfrbpq_1
X_37031_ \memory_i.datain[28]\ clk _00107_ _17943_ VPWR VGND sg13g2_dfrbpq_1
X_37032_ \memory_i.datain[29]\ clk _00108_ _17942_ VPWR VGND sg13g2_dfrbpq_1
X_37033_ \memory_i.datain[30]\ clk _00109_ _17941_ VPWR VGND sg13g2_dfrbpq_1
X_37034_ \memory_i.datain[31]\ clk _00110_ _17452_ VPWR VGND sg13g2_dfrbpq_1
X_37035_ \csr_i.addr_reg[0]\ clk \control_i.imm_gen_i.iword[20]\ _17453_ VPWR VGND sg13g2_dfrbpq_1
X_37036_ \csr_i.addr_reg[1]\ clk \control_i.imm_gen_i.iword[21]\ _17454_ VPWR VGND sg13g2_dfrbpq_1
X_37037_ \csr_i.addr_reg[2]\ clk \control_i.imm_gen_i.iword[22]\ _17455_ VPWR VGND sg13g2_dfrbpq_1
X_37038_ \csr_i.addr_reg[3]\ clk \control_i.imm_gen_i.iword[23]\ _17456_ VPWR VGND sg13g2_dfrbpq_1
X_37039_ \csr_i.addr_reg[4]\ clk \control_i.imm_gen_i.iword[24]\ _17457_ VPWR VGND sg13g2_dfrbpq_1
X_37040_ \csr_i.addr_reg[5]\ clk \alu_i.funct7[0]\ _17458_ VPWR VGND sg13g2_dfrbpq_1
X_37041_ \csr_i.addr_reg[6]\ clk \alu_i.funct7[1]\ _17459_ VPWR VGND sg13g2_dfrbpq_1
X_37042_ \csr_i.addr_reg[7]\ clk \alu_i.funct7[2]\ _17460_ VPWR VGND sg13g2_dfrbpq_1
X_37043_ \csr_i.addr_reg[8]\ clk \alu_i.funct7[3]\ _17461_ VPWR VGND sg13g2_dfrbpq_1
X_37044_ \csr_i.addr_reg[9]\ clk \alu_i.funct7[4]\ _17462_ VPWR VGND sg13g2_dfrbpq_1
X_37045_ \csr_i.addr_reg[10]\ clk \alu_i.funct7[5]\ _19567_ VPWR VGND sg13g2_dfrbpq_1
X_37046_ \csr_i.addr_reg[11]\ clk \alu_i.funct7[6]\ _17940_ VPWR VGND sg13g2_dfrbpq_1
X_37047_ \mem_dataout[31]\ clk _00111_ _17939_ VPWR VGND sg13g2_dfrbpq_1
X_37048_ \mem_dataout[30]\ clk _00112_ _17937_ VPWR VGND sg13g2_dfrbpq_1
X_37049_ \mem_dataout[29]\ clk _00113_ _17935_ VPWR VGND sg13g2_dfrbpq_1
X_37050_ \mem_dataout[28]\ clk _00114_ _17933_ VPWR VGND sg13g2_dfrbpq_1
X_37051_ \mem_dataout[27]\ clk _00115_ _17931_ VPWR VGND sg13g2_dfrbpq_1
X_37052_ \mem_dataout[26]\ clk _00116_ _17929_ VPWR VGND sg13g2_dfrbpq_1
X_37053_ \mem_dataout[25]\ clk _00117_ _17927_ VPWR VGND sg13g2_dfrbpq_1
X_37054_ \mem_dataout[24]\ clk _00118_ _17925_ VPWR VGND sg13g2_dfrbpq_1
X_37055_ \mem_dataout[23]\ clk _00119_ _17923_ VPWR VGND sg13g2_dfrbpq_1
X_37056_ \mem_dataout[22]\ clk _00120_ _17921_ VPWR VGND sg13g2_dfrbpq_1
X_37057_ \mem_dataout[21]\ clk _00121_ _17919_ VPWR VGND sg13g2_dfrbpq_1
X_37058_ \mem_dataout[20]\ clk _00122_ _17917_ VPWR VGND sg13g2_dfrbpq_1
X_37059_ \mem_dataout[19]\ clk _00123_ _17915_ VPWR VGND sg13g2_dfrbpq_1
X_37060_ \mem_dataout[18]\ clk _00124_ _17913_ VPWR VGND sg13g2_dfrbpq_1
X_37061_ \mem_dataout[17]\ clk _00125_ _17911_ VPWR VGND sg13g2_dfrbpq_1
X_37062_ \mem_dataout[16]\ clk _00126_ _17909_ VPWR VGND sg13g2_dfrbpq_1
X_37063_ \mem_dataout[15]\ clk _00127_ _17907_ VPWR VGND sg13g2_dfrbpq_1
X_37064_ \mem_dataout[14]\ clk _00128_ _17905_ VPWR VGND sg13g2_dfrbpq_1
X_37065_ \mem_dataout[13]\ clk _00129_ _17903_ VPWR VGND sg13g2_dfrbpq_1
X_37066_ \mem_dataout[12]\ clk _00130_ _17901_ VPWR VGND sg13g2_dfrbpq_1
X_37067_ \mem_dataout[11]\ clk _00131_ _17899_ VPWR VGND sg13g2_dfrbpq_1
X_37068_ \mem_dataout[10]\ clk _00132_ _17897_ VPWR VGND sg13g2_dfrbpq_1
X_37069_ \mem_dataout[9]\ clk _00133_ _17895_ VPWR VGND sg13g2_dfrbpq_1
X_37070_ \mem_dataout[8]\ clk _00134_ _17893_ VPWR VGND sg13g2_dfrbpq_1
X_37071_ \mem_dataout[7]\ clk _00135_ _17891_ VPWR VGND sg13g2_dfrbpq_1
X_37072_ \mem_dataout[6]\ clk _00136_ _17889_ VPWR VGND sg13g2_dfrbpq_1
X_37073_ \mem_dataout[5]\ clk _00137_ _17887_ VPWR VGND sg13g2_dfrbpq_1
X_37074_ \mem_dataout[4]\ clk _00138_ _17885_ VPWR VGND sg13g2_dfrbpq_1
X_37075_ \control_i.immediate[31]\ clk _00139_ _17883_ VPWR VGND sg13g2_dfrbpq_1
X_37076_ \control_i.immediate[30]\ clk _00140_ _17882_ VPWR VGND sg13g2_dfrbpq_1
X_37077_ \control_i.immediate[29]\ clk _00141_ _17881_ VPWR VGND sg13g2_dfrbpq_1
X_37078_ \control_i.immediate[28]\ clk _00142_ _17880_ VPWR VGND sg13g2_dfrbpq_1
X_37079_ \control_i.immediate[27]\ clk _00143_ _17879_ VPWR VGND sg13g2_dfrbpq_1
X_37080_ \control_i.immediate[26]\ clk _00144_ _17878_ VPWR VGND sg13g2_dfrbpq_1
X_37081_ \control_i.immediate[25]\ clk _00145_ _17877_ VPWR VGND sg13g2_dfrbpq_1
X_37082_ \control_i.immediate[24]\ clk _00146_ _17876_ VPWR VGND sg13g2_dfrbpq_1
X_37083_ \control_i.immediate[23]\ clk _00147_ _17875_ VPWR VGND sg13g2_dfrbpq_1
X_37084_ \control_i.immediate[22]\ clk _00148_ _17874_ VPWR VGND sg13g2_dfrbpq_1
X_37085_ \control_i.immediate[21]\ clk _00149_ _17873_ VPWR VGND sg13g2_dfrbpq_1
X_37086_ \control_i.immediate[20]\ clk _00150_ _17872_ VPWR VGND sg13g2_dfrbpq_1
X_37087_ \control_i.immediate[19]\ clk _00151_ _17871_ VPWR VGND sg13g2_dfrbpq_1
X_37088_ \control_i.immediate[18]\ clk _00152_ _17870_ VPWR VGND sg13g2_dfrbpq_1
X_37089_ \control_i.immediate[17]\ clk _00153_ _17869_ VPWR VGND sg13g2_dfrbpq_1
X_37090_ \control_i.immediate[16]\ clk _00154_ _17868_ VPWR VGND sg13g2_dfrbpq_1
X_37091_ \control_i.immediate[15]\ clk _00155_ _17867_ VPWR VGND sg13g2_dfrbpq_1
X_37092_ \control_i.immediate[14]\ clk _00156_ _17866_ VPWR VGND sg13g2_dfrbpq_1
X_37093_ \control_i.immediate[13]\ clk _00157_ _17865_ VPWR VGND sg13g2_dfrbpq_1
X_37094_ \control_i.immediate[12]\ clk _00158_ _17864_ VPWR VGND sg13g2_dfrbpq_1
X_37095_ \control_i.immediate[11]\ clk _00159_ _17863_ VPWR VGND sg13g2_dfrbpq_1
X_37096_ \control_i.immediate[10]\ clk _00160_ _17862_ VPWR VGND sg13g2_dfrbpq_1
X_37097_ \control_i.immediate[9]\ clk _00161_ _17861_ VPWR VGND sg13g2_dfrbpq_1
X_37098_ \control_i.immediate[8]\ clk _00162_ _17860_ VPWR VGND sg13g2_dfrbpq_1
X_37099_ \control_i.immediate[7]\ clk _00163_ _17859_ VPWR VGND sg13g2_dfrbpq_1
X_37100_ \control_i.immediate[6]\ clk _00164_ _17858_ VPWR VGND sg13g2_dfrbpq_1
X_37101_ \control_i.immediate[5]\ clk _00165_ _17857_ VPWR VGND sg13g2_dfrbpq_1
X_37102_ \control_i.immediate[4]\ clk _00166_ _17856_ VPWR VGND sg13g2_dfrbpq_1
X_37103_ \control_i.immediate[3]\ clk _00167_ _17855_ VPWR VGND sg13g2_dfrbpq_1
X_37104_ \control_i.immediate[2]\ clk _00168_ _17854_ VPWR VGND sg13g2_dfrbpq_1
X_37105_ \control_i.immediate[1]\ clk _00169_ _17853_ VPWR VGND sg13g2_dfrbpq_1
X_37106_ \control_i.immediate[0]\ clk _00170_ _17852_ VPWR VGND sg13g2_dfrbpq_1
X_37107_ \regs.registers[0][0]\ clk _00171_ _17851_ VPWR VGND sg13g2_dfrbpq_1
X_37108_ \regs.registers[0][1]\ clk _00172_ _17850_ VPWR VGND sg13g2_dfrbpq_1
X_37109_ \regs.registers[0][2]\ clk _00173_ _17849_ VPWR VGND sg13g2_dfrbpq_1
X_37110_ \regs.registers[0][3]\ clk _00174_ _17848_ VPWR VGND sg13g2_dfrbpq_1
X_37111_ \regs.registers[0][4]\ clk _00175_ _17847_ VPWR VGND sg13g2_dfrbpq_1
X_37112_ \regs.registers[0][5]\ clk _00176_ _17846_ VPWR VGND sg13g2_dfrbpq_1
X_37113_ \regs.registers[0][6]\ clk _00177_ _17845_ VPWR VGND sg13g2_dfrbpq_1
X_37114_ \regs.registers[0][7]\ clk _00178_ _17844_ VPWR VGND sg13g2_dfrbpq_1
X_37115_ \regs.registers[0][8]\ clk _00179_ _17843_ VPWR VGND sg13g2_dfrbpq_1
X_37116_ \regs.registers[0][9]\ clk _00180_ _17842_ VPWR VGND sg13g2_dfrbpq_1
X_37117_ \regs.registers[0][10]\ clk _00181_ _17841_ VPWR VGND sg13g2_dfrbpq_1
X_37118_ \regs.registers[0][11]\ clk _00182_ _17840_ VPWR VGND sg13g2_dfrbpq_1
X_37119_ \regs.registers[0][12]\ clk _00183_ _17839_ VPWR VGND sg13g2_dfrbpq_1
X_37120_ \regs.registers[0][13]\ clk _00184_ _17838_ VPWR VGND sg13g2_dfrbpq_1
X_37121_ \regs.registers[0][14]\ clk _00185_ _17837_ VPWR VGND sg13g2_dfrbpq_1
X_37122_ \regs.registers[0][15]\ clk _00186_ _17836_ VPWR VGND sg13g2_dfrbpq_1
X_37123_ \regs.registers[0][16]\ clk _00187_ _17835_ VPWR VGND sg13g2_dfrbpq_1
X_37124_ \regs.registers[0][17]\ clk _00188_ _17834_ VPWR VGND sg13g2_dfrbpq_1
X_37125_ \regs.registers[0][18]\ clk _00189_ _17833_ VPWR VGND sg13g2_dfrbpq_1
X_37126_ \regs.registers[0][19]\ clk _00190_ _17832_ VPWR VGND sg13g2_dfrbpq_1
X_37127_ \regs.registers[0][20]\ clk _00191_ _17831_ VPWR VGND sg13g2_dfrbpq_1
X_37128_ \regs.registers[0][21]\ clk _00192_ _17830_ VPWR VGND sg13g2_dfrbpq_1
X_37129_ \regs.registers[0][22]\ clk _00193_ _17829_ VPWR VGND sg13g2_dfrbpq_1
X_37130_ \regs.registers[0][23]\ clk _00194_ _17828_ VPWR VGND sg13g2_dfrbpq_1
X_37131_ \regs.registers[0][24]\ clk _00195_ _17827_ VPWR VGND sg13g2_dfrbpq_1
X_37132_ \regs.registers[0][25]\ clk _00196_ _17826_ VPWR VGND sg13g2_dfrbpq_1
X_37133_ \regs.registers[0][26]\ clk _00197_ _17825_ VPWR VGND sg13g2_dfrbpq_1
X_37134_ \regs.registers[0][27]\ clk _00198_ _17824_ VPWR VGND sg13g2_dfrbpq_1
X_37135_ \regs.registers[0][28]\ clk _00199_ _17823_ VPWR VGND sg13g2_dfrbpq_1
X_37136_ \regs.registers[0][29]\ clk _00200_ _17822_ VPWR VGND sg13g2_dfrbpq_1
X_37137_ \regs.registers[0][30]\ clk _00201_ _17821_ VPWR VGND sg13g2_dfrbpq_1
X_37138_ \regs.registers[0][31]\ clk _00202_ _17820_ VPWR VGND sg13g2_dfrbpq_1
X_37139_ \regs.registers[10][0]\ clk _00203_ _17819_ VPWR VGND sg13g2_dfrbpq_1
X_37140_ \regs.registers[10][1]\ clk _00204_ _17818_ VPWR VGND sg13g2_dfrbpq_1
X_37141_ \regs.registers[10][2]\ clk _00205_ _17817_ VPWR VGND sg13g2_dfrbpq_1
X_37142_ \regs.registers[10][3]\ clk _00206_ _17816_ VPWR VGND sg13g2_dfrbpq_1
X_37143_ \regs.registers[10][4]\ clk _00207_ _17815_ VPWR VGND sg13g2_dfrbpq_1
X_37144_ \regs.registers[10][5]\ clk _00208_ _17814_ VPWR VGND sg13g2_dfrbpq_1
X_37145_ \regs.registers[10][6]\ clk _00209_ _17813_ VPWR VGND sg13g2_dfrbpq_1
X_37146_ \regs.registers[10][7]\ clk _00210_ _17812_ VPWR VGND sg13g2_dfrbpq_1
X_37147_ \regs.registers[10][8]\ clk _00211_ _17811_ VPWR VGND sg13g2_dfrbpq_1
X_37148_ \regs.registers[10][9]\ clk _00212_ _17810_ VPWR VGND sg13g2_dfrbpq_1
X_37149_ \regs.registers[10][10]\ clk _00213_ _17809_ VPWR VGND sg13g2_dfrbpq_1
X_37150_ \regs.registers[10][11]\ clk _00214_ _17808_ VPWR VGND sg13g2_dfrbpq_1
X_37151_ \regs.registers[10][12]\ clk _00215_ _17807_ VPWR VGND sg13g2_dfrbpq_1
X_37152_ \regs.registers[10][13]\ clk _00216_ _17806_ VPWR VGND sg13g2_dfrbpq_1
X_37153_ \regs.registers[10][14]\ clk _00217_ _17805_ VPWR VGND sg13g2_dfrbpq_1
X_37154_ \regs.registers[10][15]\ clk _00218_ _17804_ VPWR VGND sg13g2_dfrbpq_1
X_37155_ \regs.registers[10][16]\ clk _00219_ _17803_ VPWR VGND sg13g2_dfrbpq_1
X_37156_ \regs.registers[10][17]\ clk _00220_ _17802_ VPWR VGND sg13g2_dfrbpq_1
X_37157_ \regs.registers[10][18]\ clk _00221_ _17801_ VPWR VGND sg13g2_dfrbpq_1
X_37158_ \regs.registers[10][19]\ clk _00222_ _17800_ VPWR VGND sg13g2_dfrbpq_1
X_37159_ \regs.registers[10][20]\ clk _00223_ _17799_ VPWR VGND sg13g2_dfrbpq_1
X_37160_ \regs.registers[10][21]\ clk _00224_ _17798_ VPWR VGND sg13g2_dfrbpq_1
X_37161_ \regs.registers[10][22]\ clk _00225_ _17797_ VPWR VGND sg13g2_dfrbpq_1
X_37162_ \regs.registers[10][23]\ clk _00226_ _17796_ VPWR VGND sg13g2_dfrbpq_1
X_37163_ \regs.registers[10][24]\ clk _00227_ _17795_ VPWR VGND sg13g2_dfrbpq_1
X_37164_ \regs.registers[10][25]\ clk _00228_ _17794_ VPWR VGND sg13g2_dfrbpq_1
X_37165_ \regs.registers[10][26]\ clk _00229_ _17793_ VPWR VGND sg13g2_dfrbpq_1
X_37166_ \regs.registers[10][27]\ clk _00230_ _17792_ VPWR VGND sg13g2_dfrbpq_1
X_37167_ \regs.registers[10][28]\ clk _00231_ _17791_ VPWR VGND sg13g2_dfrbpq_1
X_37168_ \regs.registers[10][29]\ clk _00232_ _17790_ VPWR VGND sg13g2_dfrbpq_1
X_37169_ \regs.registers[10][30]\ clk _00233_ _17789_ VPWR VGND sg13g2_dfrbpq_1
X_37170_ \regs.registers[10][31]\ clk _00234_ _17788_ VPWR VGND sg13g2_dfrbpq_1
X_37171_ \regs.registers[11][0]\ clk _00235_ _17787_ VPWR VGND sg13g2_dfrbpq_1
X_37172_ \regs.registers[11][1]\ clk _00236_ _17786_ VPWR VGND sg13g2_dfrbpq_1
X_37173_ \regs.registers[11][2]\ clk _00237_ _17785_ VPWR VGND sg13g2_dfrbpq_1
X_37174_ \regs.registers[11][3]\ clk _00238_ _17784_ VPWR VGND sg13g2_dfrbpq_1
X_37175_ \regs.registers[11][4]\ clk _00239_ _17783_ VPWR VGND sg13g2_dfrbpq_1
X_37176_ \regs.registers[11][5]\ clk _00240_ _17782_ VPWR VGND sg13g2_dfrbpq_1
X_37177_ \regs.registers[11][6]\ clk _00241_ _17781_ VPWR VGND sg13g2_dfrbpq_1
X_37178_ \regs.registers[11][7]\ clk _00242_ _17780_ VPWR VGND sg13g2_dfrbpq_1
X_37179_ \regs.registers[11][8]\ clk _00243_ _17779_ VPWR VGND sg13g2_dfrbpq_1
X_37180_ \regs.registers[11][9]\ clk _00244_ _17778_ VPWR VGND sg13g2_dfrbpq_1
X_37181_ \regs.registers[11][10]\ clk _00245_ _17777_ VPWR VGND sg13g2_dfrbpq_1
X_37182_ \regs.registers[11][11]\ clk _00246_ _17776_ VPWR VGND sg13g2_dfrbpq_1
X_37183_ \regs.registers[11][12]\ clk _00247_ _17775_ VPWR VGND sg13g2_dfrbpq_1
X_37184_ \regs.registers[11][13]\ clk _00248_ _17774_ VPWR VGND sg13g2_dfrbpq_1
X_37185_ \regs.registers[11][14]\ clk _00249_ _17773_ VPWR VGND sg13g2_dfrbpq_1
X_37186_ \regs.registers[11][15]\ clk _00250_ _17772_ VPWR VGND sg13g2_dfrbpq_1
X_37187_ \regs.registers[11][16]\ clk _00251_ _17771_ VPWR VGND sg13g2_dfrbpq_1
X_37188_ \regs.registers[11][17]\ clk _00252_ _17770_ VPWR VGND sg13g2_dfrbpq_1
X_37189_ \regs.registers[11][18]\ clk _00253_ _17769_ VPWR VGND sg13g2_dfrbpq_1
X_37190_ \regs.registers[11][19]\ clk _00254_ _17768_ VPWR VGND sg13g2_dfrbpq_1
X_37191_ \regs.registers[11][20]\ clk _00255_ _17767_ VPWR VGND sg13g2_dfrbpq_1
X_37192_ \regs.registers[11][21]\ clk _00256_ _17766_ VPWR VGND sg13g2_dfrbpq_1
X_37193_ \regs.registers[11][22]\ clk _00257_ _17765_ VPWR VGND sg13g2_dfrbpq_1
X_37194_ \regs.registers[11][23]\ clk _00258_ _17764_ VPWR VGND sg13g2_dfrbpq_1
X_37195_ \regs.registers[11][24]\ clk _00259_ _17763_ VPWR VGND sg13g2_dfrbpq_1
X_37196_ \regs.registers[11][25]\ clk _00260_ _17762_ VPWR VGND sg13g2_dfrbpq_1
X_37197_ \regs.registers[11][26]\ clk _00261_ _17761_ VPWR VGND sg13g2_dfrbpq_1
X_37198_ \regs.registers[11][27]\ clk _00262_ _17760_ VPWR VGND sg13g2_dfrbpq_1
X_37199_ \regs.registers[11][28]\ clk _00263_ _17759_ VPWR VGND sg13g2_dfrbpq_1
X_37200_ \regs.registers[11][29]\ clk _00264_ _17758_ VPWR VGND sg13g2_dfrbpq_1
X_37201_ \regs.registers[11][30]\ clk _00265_ _17757_ VPWR VGND sg13g2_dfrbpq_1
X_37202_ \regs.registers[11][31]\ clk _00266_ _17756_ VPWR VGND sg13g2_dfrbpq_1
X_37203_ \regs.registers[12][0]\ clk _00267_ _17755_ VPWR VGND sg13g2_dfrbpq_1
X_37204_ \regs.registers[12][1]\ clk _00268_ _17754_ VPWR VGND sg13g2_dfrbpq_1
X_37205_ \regs.registers[12][2]\ clk _00269_ _17753_ VPWR VGND sg13g2_dfrbpq_1
X_37206_ \regs.registers[12][3]\ clk _00270_ _17752_ VPWR VGND sg13g2_dfrbpq_1
X_37207_ \regs.registers[12][4]\ clk _00271_ _17751_ VPWR VGND sg13g2_dfrbpq_1
X_37208_ \regs.registers[12][5]\ clk _00272_ _17750_ VPWR VGND sg13g2_dfrbpq_1
X_37209_ \regs.registers[12][6]\ clk _00273_ _17749_ VPWR VGND sg13g2_dfrbpq_1
X_37210_ \regs.registers[12][7]\ clk _00274_ _17748_ VPWR VGND sg13g2_dfrbpq_1
X_37211_ \regs.registers[12][8]\ clk _00275_ _17747_ VPWR VGND sg13g2_dfrbpq_1
X_37212_ \regs.registers[12][9]\ clk _00276_ _17746_ VPWR VGND sg13g2_dfrbpq_1
X_37213_ \regs.registers[12][10]\ clk _00277_ _17745_ VPWR VGND sg13g2_dfrbpq_1
X_37214_ \regs.registers[12][11]\ clk _00278_ _17744_ VPWR VGND sg13g2_dfrbpq_1
X_37215_ \regs.registers[12][12]\ clk _00279_ _17743_ VPWR VGND sg13g2_dfrbpq_1
X_37216_ \regs.registers[12][13]\ clk _00280_ _17742_ VPWR VGND sg13g2_dfrbpq_1
X_37217_ \regs.registers[12][14]\ clk _00281_ _17741_ VPWR VGND sg13g2_dfrbpq_1
X_37218_ \regs.registers[12][15]\ clk _00282_ _17740_ VPWR VGND sg13g2_dfrbpq_1
X_37219_ \regs.registers[12][16]\ clk _00283_ _17739_ VPWR VGND sg13g2_dfrbpq_1
X_37220_ \regs.registers[12][17]\ clk _00284_ _17738_ VPWR VGND sg13g2_dfrbpq_1
X_37221_ \regs.registers[12][18]\ clk _00285_ _17737_ VPWR VGND sg13g2_dfrbpq_1
X_37222_ \regs.registers[12][19]\ clk _00286_ _17736_ VPWR VGND sg13g2_dfrbpq_1
X_37223_ \regs.registers[12][20]\ clk _00287_ _17735_ VPWR VGND sg13g2_dfrbpq_1
X_37224_ \regs.registers[12][21]\ clk _00288_ _17734_ VPWR VGND sg13g2_dfrbpq_1
X_37225_ \regs.registers[12][22]\ clk _00289_ _17733_ VPWR VGND sg13g2_dfrbpq_1
X_37226_ \regs.registers[12][23]\ clk _00290_ _17732_ VPWR VGND sg13g2_dfrbpq_1
X_37227_ \regs.registers[12][24]\ clk _00291_ _17731_ VPWR VGND sg13g2_dfrbpq_1
X_37228_ \regs.registers[12][25]\ clk _00292_ _17730_ VPWR VGND sg13g2_dfrbpq_1
X_37229_ \regs.registers[12][26]\ clk _00293_ _17729_ VPWR VGND sg13g2_dfrbpq_1
X_37230_ \regs.registers[12][27]\ clk _00294_ _17728_ VPWR VGND sg13g2_dfrbpq_1
X_37231_ \regs.registers[12][28]\ clk _00295_ _17727_ VPWR VGND sg13g2_dfrbpq_1
X_37232_ \regs.registers[12][29]\ clk _00296_ _17726_ VPWR VGND sg13g2_dfrbpq_1
X_37233_ \regs.registers[12][30]\ clk _00297_ _17725_ VPWR VGND sg13g2_dfrbpq_1
X_37234_ \regs.registers[12][31]\ clk _00298_ _17724_ VPWR VGND sg13g2_dfrbpq_1
X_37235_ \regs.registers[13][0]\ clk _00299_ _17723_ VPWR VGND sg13g2_dfrbpq_1
X_37236_ \regs.registers[13][1]\ clk _00300_ _17722_ VPWR VGND sg13g2_dfrbpq_1
X_37237_ \regs.registers[13][2]\ clk _00301_ _17721_ VPWR VGND sg13g2_dfrbpq_1
X_37238_ \regs.registers[13][3]\ clk _00302_ _17720_ VPWR VGND sg13g2_dfrbpq_1
X_37239_ \regs.registers[13][4]\ clk _00303_ _17719_ VPWR VGND sg13g2_dfrbpq_1
X_37240_ \regs.registers[13][5]\ clk _00304_ _17718_ VPWR VGND sg13g2_dfrbpq_1
X_37241_ \regs.registers[13][6]\ clk _00305_ _17717_ VPWR VGND sg13g2_dfrbpq_1
X_37242_ \regs.registers[13][7]\ clk _00306_ _17716_ VPWR VGND sg13g2_dfrbpq_1
X_37243_ \regs.registers[13][8]\ clk _00307_ _17715_ VPWR VGND sg13g2_dfrbpq_1
X_37244_ \regs.registers[13][9]\ clk _00308_ _17714_ VPWR VGND sg13g2_dfrbpq_1
X_37245_ \regs.registers[13][10]\ clk _00309_ _17713_ VPWR VGND sg13g2_dfrbpq_1
X_37246_ \regs.registers[13][11]\ clk _00310_ _17712_ VPWR VGND sg13g2_dfrbpq_1
X_37247_ \regs.registers[13][12]\ clk _00311_ _17711_ VPWR VGND sg13g2_dfrbpq_1
X_37248_ \regs.registers[13][13]\ clk _00312_ _17710_ VPWR VGND sg13g2_dfrbpq_1
X_37249_ \regs.registers[13][14]\ clk _00313_ _17709_ VPWR VGND sg13g2_dfrbpq_1
X_37250_ \regs.registers[13][15]\ clk _00314_ _17708_ VPWR VGND sg13g2_dfrbpq_1
X_37251_ \regs.registers[13][16]\ clk _00315_ _17707_ VPWR VGND sg13g2_dfrbpq_1
X_37252_ \regs.registers[13][17]\ clk _00316_ _17706_ VPWR VGND sg13g2_dfrbpq_1
X_37253_ \regs.registers[13][18]\ clk _00317_ _17705_ VPWR VGND sg13g2_dfrbpq_1
X_37254_ \regs.registers[13][19]\ clk _00318_ _17704_ VPWR VGND sg13g2_dfrbpq_1
X_37255_ \regs.registers[13][20]\ clk _00319_ _17703_ VPWR VGND sg13g2_dfrbpq_1
X_37256_ \regs.registers[13][21]\ clk _00320_ _17702_ VPWR VGND sg13g2_dfrbpq_1
X_37257_ \regs.registers[13][22]\ clk _00321_ _17701_ VPWR VGND sg13g2_dfrbpq_1
X_37258_ \regs.registers[13][23]\ clk _00322_ _17700_ VPWR VGND sg13g2_dfrbpq_1
X_37259_ \regs.registers[13][24]\ clk _00323_ _17699_ VPWR VGND sg13g2_dfrbpq_1
X_37260_ \regs.registers[13][25]\ clk _00324_ _17698_ VPWR VGND sg13g2_dfrbpq_1
X_37261_ \regs.registers[13][26]\ clk _00325_ _17697_ VPWR VGND sg13g2_dfrbpq_1
X_37262_ \regs.registers[13][27]\ clk _00326_ _17696_ VPWR VGND sg13g2_dfrbpq_1
X_37263_ \regs.registers[13][28]\ clk _00327_ _17695_ VPWR VGND sg13g2_dfrbpq_1
X_37264_ \regs.registers[13][29]\ clk _00328_ _17694_ VPWR VGND sg13g2_dfrbpq_1
X_37265_ \regs.registers[13][30]\ clk _00329_ _17693_ VPWR VGND sg13g2_dfrbpq_1
X_37266_ \regs.registers[13][31]\ clk _00330_ _17692_ VPWR VGND sg13g2_dfrbpq_1
X_37267_ \regs.registers[14][0]\ clk _00331_ _17691_ VPWR VGND sg13g2_dfrbpq_1
X_37268_ \regs.registers[14][1]\ clk _00332_ _17690_ VPWR VGND sg13g2_dfrbpq_1
X_37269_ \regs.registers[14][2]\ clk _00333_ _17689_ VPWR VGND sg13g2_dfrbpq_1
X_37270_ \regs.registers[14][3]\ clk _00334_ _17688_ VPWR VGND sg13g2_dfrbpq_1
X_37271_ \regs.registers[14][4]\ clk _00335_ _17687_ VPWR VGND sg13g2_dfrbpq_1
X_37272_ \regs.registers[14][5]\ clk _00336_ _17686_ VPWR VGND sg13g2_dfrbpq_1
X_37273_ \regs.registers[14][6]\ clk _00337_ _17685_ VPWR VGND sg13g2_dfrbpq_1
X_37274_ \regs.registers[14][7]\ clk _00338_ _17684_ VPWR VGND sg13g2_dfrbpq_1
X_37275_ \regs.registers[14][8]\ clk _00339_ _17683_ VPWR VGND sg13g2_dfrbpq_1
X_37276_ \regs.registers[14][9]\ clk _00340_ _17682_ VPWR VGND sg13g2_dfrbpq_1
X_37277_ \regs.registers[14][10]\ clk _00341_ _17681_ VPWR VGND sg13g2_dfrbpq_1
X_37278_ \regs.registers[14][11]\ clk _00342_ _17680_ VPWR VGND sg13g2_dfrbpq_1
X_37279_ \regs.registers[14][12]\ clk _00343_ _17679_ VPWR VGND sg13g2_dfrbpq_1
X_37280_ \regs.registers[14][13]\ clk _00344_ _17678_ VPWR VGND sg13g2_dfrbpq_1
X_37281_ \regs.registers[14][14]\ clk _00345_ _17677_ VPWR VGND sg13g2_dfrbpq_1
X_37282_ \regs.registers[14][15]\ clk _00346_ _17676_ VPWR VGND sg13g2_dfrbpq_1
X_37283_ \regs.registers[14][16]\ clk _00347_ _17675_ VPWR VGND sg13g2_dfrbpq_1
X_37284_ \regs.registers[14][17]\ clk _00348_ _17674_ VPWR VGND sg13g2_dfrbpq_1
X_37285_ \regs.registers[14][18]\ clk _00349_ _17673_ VPWR VGND sg13g2_dfrbpq_1
X_37286_ \regs.registers[14][19]\ clk _00350_ _17672_ VPWR VGND sg13g2_dfrbpq_1
X_37287_ \regs.registers[14][20]\ clk _00351_ _17671_ VPWR VGND sg13g2_dfrbpq_1
X_37288_ \regs.registers[14][21]\ clk _00352_ _17670_ VPWR VGND sg13g2_dfrbpq_1
X_37289_ \regs.registers[14][22]\ clk _00353_ _17669_ VPWR VGND sg13g2_dfrbpq_1
X_37290_ \regs.registers[14][23]\ clk _00354_ _17668_ VPWR VGND sg13g2_dfrbpq_1
X_37291_ \regs.registers[14][24]\ clk _00355_ _17667_ VPWR VGND sg13g2_dfrbpq_1
X_37292_ \regs.registers[14][25]\ clk _00356_ _17666_ VPWR VGND sg13g2_dfrbpq_1
X_37293_ \regs.registers[14][26]\ clk _00357_ _17665_ VPWR VGND sg13g2_dfrbpq_1
X_37294_ \regs.registers[14][27]\ clk _00358_ _17664_ VPWR VGND sg13g2_dfrbpq_1
X_37295_ \regs.registers[14][28]\ clk _00359_ _17663_ VPWR VGND sg13g2_dfrbpq_1
X_37296_ \regs.registers[14][29]\ clk _00360_ _17662_ VPWR VGND sg13g2_dfrbpq_1
X_37297_ \regs.registers[14][30]\ clk _00361_ _17661_ VPWR VGND sg13g2_dfrbpq_1
X_37298_ \regs.registers[14][31]\ clk _00362_ _17660_ VPWR VGND sg13g2_dfrbpq_1
X_37299_ \regs.registers[15][0]\ clk _00363_ _17659_ VPWR VGND sg13g2_dfrbpq_1
X_37300_ \regs.registers[15][1]\ clk _00364_ _17658_ VPWR VGND sg13g2_dfrbpq_1
X_37301_ \regs.registers[15][2]\ clk _00365_ _17657_ VPWR VGND sg13g2_dfrbpq_1
X_37302_ \regs.registers[15][3]\ clk _00366_ _17656_ VPWR VGND sg13g2_dfrbpq_1
X_37303_ \regs.registers[15][4]\ clk _00367_ _17655_ VPWR VGND sg13g2_dfrbpq_1
X_37304_ \regs.registers[15][5]\ clk _00368_ _17654_ VPWR VGND sg13g2_dfrbpq_1
X_37305_ \regs.registers[15][6]\ clk _00369_ _17653_ VPWR VGND sg13g2_dfrbpq_1
X_37306_ \regs.registers[15][7]\ clk _00370_ _17652_ VPWR VGND sg13g2_dfrbpq_1
X_37307_ \regs.registers[15][8]\ clk _00371_ _17651_ VPWR VGND sg13g2_dfrbpq_1
X_37308_ \regs.registers[15][9]\ clk _00372_ _17650_ VPWR VGND sg13g2_dfrbpq_1
X_37309_ \regs.registers[15][10]\ clk _00373_ _17649_ VPWR VGND sg13g2_dfrbpq_1
X_37310_ \regs.registers[15][11]\ clk _00374_ _17648_ VPWR VGND sg13g2_dfrbpq_1
X_37311_ \regs.registers[15][12]\ clk _00375_ _17647_ VPWR VGND sg13g2_dfrbpq_1
X_37312_ \regs.registers[15][13]\ clk _00376_ _17646_ VPWR VGND sg13g2_dfrbpq_1
X_37313_ \regs.registers[15][14]\ clk _00377_ _17645_ VPWR VGND sg13g2_dfrbpq_1
X_37314_ \regs.registers[15][15]\ clk _00378_ _17644_ VPWR VGND sg13g2_dfrbpq_1
X_37315_ \regs.registers[15][16]\ clk _00379_ _17643_ VPWR VGND sg13g2_dfrbpq_1
X_37316_ \regs.registers[15][17]\ clk _00380_ _17642_ VPWR VGND sg13g2_dfrbpq_1
X_37317_ \regs.registers[15][18]\ clk _00381_ _17641_ VPWR VGND sg13g2_dfrbpq_1
X_37318_ \regs.registers[15][19]\ clk _00382_ _17640_ VPWR VGND sg13g2_dfrbpq_1
X_37319_ \regs.registers[15][20]\ clk _00383_ _17639_ VPWR VGND sg13g2_dfrbpq_1
X_37320_ \regs.registers[15][21]\ clk _00384_ _17638_ VPWR VGND sg13g2_dfrbpq_1
X_37321_ \regs.registers[15][22]\ clk _00385_ _17637_ VPWR VGND sg13g2_dfrbpq_1
X_37322_ \regs.registers[15][23]\ clk _00386_ _17636_ VPWR VGND sg13g2_dfrbpq_1
X_37323_ \regs.registers[15][24]\ clk _00387_ _17635_ VPWR VGND sg13g2_dfrbpq_1
X_37324_ \regs.registers[15][25]\ clk _00388_ _17634_ VPWR VGND sg13g2_dfrbpq_1
X_37325_ \regs.registers[15][26]\ clk _00389_ _17633_ VPWR VGND sg13g2_dfrbpq_1
X_37326_ \regs.registers[15][27]\ clk _00390_ _17632_ VPWR VGND sg13g2_dfrbpq_1
X_37327_ \regs.registers[15][28]\ clk _00391_ _17631_ VPWR VGND sg13g2_dfrbpq_1
X_37328_ \regs.registers[15][29]\ clk _00392_ _17630_ VPWR VGND sg13g2_dfrbpq_1
X_37329_ \regs.registers[15][30]\ clk _00393_ _17629_ VPWR VGND sg13g2_dfrbpq_1
X_37330_ \regs.registers[15][31]\ clk _00394_ _17628_ VPWR VGND sg13g2_dfrbpq_1
X_37331_ \regs.registers[1][0]\ clk _00395_ _17627_ VPWR VGND sg13g2_dfrbpq_1
X_37332_ \regs.registers[1][1]\ clk _00396_ _17626_ VPWR VGND sg13g2_dfrbpq_1
X_37333_ \regs.registers[1][2]\ clk _00397_ _17625_ VPWR VGND sg13g2_dfrbpq_1
X_37334_ \regs.registers[1][3]\ clk _00398_ _17624_ VPWR VGND sg13g2_dfrbpq_1
X_37335_ \regs.registers[1][4]\ clk _00399_ _17623_ VPWR VGND sg13g2_dfrbpq_1
X_37336_ \regs.registers[1][5]\ clk _00400_ _17622_ VPWR VGND sg13g2_dfrbpq_1
X_37337_ \regs.registers[1][6]\ clk _00401_ _17621_ VPWR VGND sg13g2_dfrbpq_1
X_37338_ \regs.registers[1][7]\ clk _00402_ _17620_ VPWR VGND sg13g2_dfrbpq_1
X_37339_ \regs.registers[1][8]\ clk _00403_ _17619_ VPWR VGND sg13g2_dfrbpq_1
X_37340_ \regs.registers[1][9]\ clk _00404_ _17618_ VPWR VGND sg13g2_dfrbpq_1
X_37341_ \regs.registers[1][10]\ clk _00405_ _17617_ VPWR VGND sg13g2_dfrbpq_1
X_37342_ \regs.registers[1][11]\ clk _00406_ _17616_ VPWR VGND sg13g2_dfrbpq_1
X_37343_ \regs.registers[1][12]\ clk _00407_ _17615_ VPWR VGND sg13g2_dfrbpq_1
X_37344_ \regs.registers[1][13]\ clk _00408_ _17614_ VPWR VGND sg13g2_dfrbpq_1
X_37345_ \regs.registers[1][14]\ clk _00409_ _17613_ VPWR VGND sg13g2_dfrbpq_1
X_37346_ \regs.registers[1][15]\ clk _00410_ _17612_ VPWR VGND sg13g2_dfrbpq_1
X_37347_ \regs.registers[1][16]\ clk _00411_ _17611_ VPWR VGND sg13g2_dfrbpq_1
X_37348_ \regs.registers[1][17]\ clk _00412_ _17610_ VPWR VGND sg13g2_dfrbpq_1
X_37349_ \regs.registers[1][18]\ clk _00413_ _17609_ VPWR VGND sg13g2_dfrbpq_1
X_37350_ \regs.registers[1][19]\ clk _00414_ _17608_ VPWR VGND sg13g2_dfrbpq_1
X_37351_ \regs.registers[1][20]\ clk _00415_ _17607_ VPWR VGND sg13g2_dfrbpq_1
X_37352_ \regs.registers[1][21]\ clk _00416_ _17606_ VPWR VGND sg13g2_dfrbpq_1
X_37353_ \regs.registers[1][22]\ clk _00417_ _17605_ VPWR VGND sg13g2_dfrbpq_1
X_37354_ \regs.registers[1][23]\ clk _00418_ _17604_ VPWR VGND sg13g2_dfrbpq_1
X_37355_ \regs.registers[1][24]\ clk _00419_ _17603_ VPWR VGND sg13g2_dfrbpq_1
X_37356_ \regs.registers[1][25]\ clk _00420_ _17602_ VPWR VGND sg13g2_dfrbpq_1
X_37357_ \regs.registers[1][26]\ clk _00421_ _17601_ VPWR VGND sg13g2_dfrbpq_1
X_37358_ \regs.registers[1][27]\ clk _00422_ _17600_ VPWR VGND sg13g2_dfrbpq_1
X_37359_ \regs.registers[1][28]\ clk _00423_ _17599_ VPWR VGND sg13g2_dfrbpq_1
X_37360_ \regs.registers[1][29]\ clk _00424_ _17598_ VPWR VGND sg13g2_dfrbpq_1
X_37361_ \regs.registers[1][30]\ clk _00425_ _17597_ VPWR VGND sg13g2_dfrbpq_1
X_37362_ \regs.registers[1][31]\ clk _00426_ _17596_ VPWR VGND sg13g2_dfrbpq_1
X_37363_ \regs.registers[2][0]\ clk _00427_ _17595_ VPWR VGND sg13g2_dfrbpq_1
X_37364_ \regs.registers[2][1]\ clk _00428_ _17594_ VPWR VGND sg13g2_dfrbpq_1
X_37365_ \regs.registers[2][2]\ clk _00429_ _17593_ VPWR VGND sg13g2_dfrbpq_1
X_37366_ \regs.registers[2][3]\ clk _00430_ _17592_ VPWR VGND sg13g2_dfrbpq_1
X_37367_ \regs.registers[2][4]\ clk _00431_ _17591_ VPWR VGND sg13g2_dfrbpq_1
X_37368_ \regs.registers[2][5]\ clk _00432_ _17590_ VPWR VGND sg13g2_dfrbpq_1
X_37369_ \regs.registers[2][6]\ clk _00433_ _17589_ VPWR VGND sg13g2_dfrbpq_1
X_37370_ \regs.registers[2][7]\ clk _00434_ _17588_ VPWR VGND sg13g2_dfrbpq_1
X_37371_ \regs.registers[2][8]\ clk _00435_ _17587_ VPWR VGND sg13g2_dfrbpq_1
X_37372_ \regs.registers[2][9]\ clk _00436_ _17586_ VPWR VGND sg13g2_dfrbpq_1
X_37373_ \regs.registers[2][10]\ clk _00437_ _17585_ VPWR VGND sg13g2_dfrbpq_1
X_37374_ \regs.registers[2][11]\ clk _00438_ _17584_ VPWR VGND sg13g2_dfrbpq_1
X_37375_ \regs.registers[2][12]\ clk _00439_ _17583_ VPWR VGND sg13g2_dfrbpq_1
X_37376_ \regs.registers[2][13]\ clk _00440_ _17582_ VPWR VGND sg13g2_dfrbpq_1
X_37377_ \regs.registers[2][14]\ clk _00441_ _17581_ VPWR VGND sg13g2_dfrbpq_1
X_37378_ \regs.registers[2][15]\ clk _00442_ _17580_ VPWR VGND sg13g2_dfrbpq_1
X_37379_ \regs.registers[2][16]\ clk _00443_ _17579_ VPWR VGND sg13g2_dfrbpq_1
X_37380_ \regs.registers[2][17]\ clk _00444_ _17578_ VPWR VGND sg13g2_dfrbpq_1
X_37381_ \regs.registers[2][18]\ clk _00445_ _17577_ VPWR VGND sg13g2_dfrbpq_1
X_37382_ \regs.registers[2][19]\ clk _00446_ _17576_ VPWR VGND sg13g2_dfrbpq_1
X_37383_ \regs.registers[2][20]\ clk _00447_ _17575_ VPWR VGND sg13g2_dfrbpq_1
X_37384_ \regs.registers[2][21]\ clk _00448_ _17574_ VPWR VGND sg13g2_dfrbpq_1
X_37385_ \regs.registers[2][22]\ clk _00449_ _17573_ VPWR VGND sg13g2_dfrbpq_1
X_37386_ \regs.registers[2][23]\ clk _00450_ _17572_ VPWR VGND sg13g2_dfrbpq_1
X_37387_ \regs.registers[2][24]\ clk _00451_ _17571_ VPWR VGND sg13g2_dfrbpq_1
X_37388_ \regs.registers[2][25]\ clk _00452_ _17570_ VPWR VGND sg13g2_dfrbpq_1
X_37389_ \regs.registers[2][26]\ clk _00453_ _17569_ VPWR VGND sg13g2_dfrbpq_1
X_37390_ \regs.registers[2][27]\ clk _00454_ _17568_ VPWR VGND sg13g2_dfrbpq_1
X_37391_ \regs.registers[2][28]\ clk _00455_ _17567_ VPWR VGND sg13g2_dfrbpq_1
X_37392_ \regs.registers[2][29]\ clk _00456_ _17566_ VPWR VGND sg13g2_dfrbpq_1
X_37393_ \regs.registers[2][30]\ clk _00457_ _17565_ VPWR VGND sg13g2_dfrbpq_1
X_37394_ \regs.registers[2][31]\ clk _00458_ _17564_ VPWR VGND sg13g2_dfrbpq_1
X_37395_ \regs.registers[3][0]\ clk _00459_ _17563_ VPWR VGND sg13g2_dfrbpq_1
X_37396_ \regs.registers[3][1]\ clk _00460_ _17562_ VPWR VGND sg13g2_dfrbpq_1
X_37397_ \regs.registers[3][2]\ clk _00461_ _17561_ VPWR VGND sg13g2_dfrbpq_1
X_37398_ \regs.registers[3][3]\ clk _00462_ _17560_ VPWR VGND sg13g2_dfrbpq_1
X_37399_ \regs.registers[3][4]\ clk _00463_ _17559_ VPWR VGND sg13g2_dfrbpq_1
X_37400_ \regs.registers[3][5]\ clk _00464_ _17558_ VPWR VGND sg13g2_dfrbpq_1
X_37401_ \regs.registers[3][6]\ clk _00465_ _17557_ VPWR VGND sg13g2_dfrbpq_1
X_37402_ \regs.registers[3][7]\ clk _00466_ _17556_ VPWR VGND sg13g2_dfrbpq_1
X_37403_ \regs.registers[3][8]\ clk _00467_ _17555_ VPWR VGND sg13g2_dfrbpq_1
X_37404_ \regs.registers[3][9]\ clk _00468_ _17554_ VPWR VGND sg13g2_dfrbpq_1
X_37405_ \regs.registers[3][10]\ clk _00469_ _17553_ VPWR VGND sg13g2_dfrbpq_1
X_37406_ \regs.registers[3][11]\ clk _00470_ _17552_ VPWR VGND sg13g2_dfrbpq_1
X_37407_ \regs.registers[3][12]\ clk _00471_ _17551_ VPWR VGND sg13g2_dfrbpq_1
X_37408_ \regs.registers[3][13]\ clk _00472_ _17550_ VPWR VGND sg13g2_dfrbpq_1
X_37409_ \regs.registers[3][14]\ clk _00473_ _17549_ VPWR VGND sg13g2_dfrbpq_1
X_37410_ \regs.registers[3][15]\ clk _00474_ _17548_ VPWR VGND sg13g2_dfrbpq_1
X_37411_ \regs.registers[3][16]\ clk _00475_ _17547_ VPWR VGND sg13g2_dfrbpq_1
X_37412_ \regs.registers[3][17]\ clk _00476_ _17546_ VPWR VGND sg13g2_dfrbpq_1
X_37413_ \regs.registers[3][18]\ clk _00477_ _17545_ VPWR VGND sg13g2_dfrbpq_1
X_37414_ \regs.registers[3][19]\ clk _00478_ _17544_ VPWR VGND sg13g2_dfrbpq_1
X_37415_ \regs.registers[3][20]\ clk _00479_ _17543_ VPWR VGND sg13g2_dfrbpq_1
X_37416_ \regs.registers[3][21]\ clk _00480_ _17542_ VPWR VGND sg13g2_dfrbpq_1
X_37417_ \regs.registers[3][22]\ clk _00481_ _17541_ VPWR VGND sg13g2_dfrbpq_1
X_37418_ \regs.registers[3][23]\ clk _00482_ _17540_ VPWR VGND sg13g2_dfrbpq_1
X_37419_ \regs.registers[3][24]\ clk _00483_ _17539_ VPWR VGND sg13g2_dfrbpq_1
X_37420_ \regs.registers[3][25]\ clk _00484_ _17538_ VPWR VGND sg13g2_dfrbpq_1
X_37421_ \regs.registers[3][26]\ clk _00485_ _17537_ VPWR VGND sg13g2_dfrbpq_1
X_37422_ \regs.registers[3][27]\ clk _00486_ _17536_ VPWR VGND sg13g2_dfrbpq_1
X_37423_ \regs.registers[3][28]\ clk _00487_ _17535_ VPWR VGND sg13g2_dfrbpq_1
X_37424_ \regs.registers[3][29]\ clk _00488_ _17534_ VPWR VGND sg13g2_dfrbpq_1
X_37425_ \regs.registers[3][30]\ clk _00489_ _17533_ VPWR VGND sg13g2_dfrbpq_1
X_37426_ \regs.registers[3][31]\ clk _00490_ _17532_ VPWR VGND sg13g2_dfrbpq_1
X_37427_ \regs.registers[4][0]\ clk _00491_ _17531_ VPWR VGND sg13g2_dfrbpq_1
X_37428_ \regs.registers[4][1]\ clk _00492_ _17530_ VPWR VGND sg13g2_dfrbpq_1
X_37429_ \regs.registers[4][2]\ clk _00493_ _17529_ VPWR VGND sg13g2_dfrbpq_1
X_37430_ \regs.registers[4][3]\ clk _00494_ _17528_ VPWR VGND sg13g2_dfrbpq_1
X_37431_ \regs.registers[4][4]\ clk _00495_ _17527_ VPWR VGND sg13g2_dfrbpq_1
X_37432_ \regs.registers[4][5]\ clk _00496_ _17526_ VPWR VGND sg13g2_dfrbpq_1
X_37433_ \regs.registers[4][6]\ clk _00497_ _17525_ VPWR VGND sg13g2_dfrbpq_1
X_37434_ \regs.registers[4][7]\ clk _00498_ _17524_ VPWR VGND sg13g2_dfrbpq_1
X_37435_ \regs.registers[4][8]\ clk _00499_ _17523_ VPWR VGND sg13g2_dfrbpq_1
X_37436_ \regs.registers[4][9]\ clk _00500_ _17522_ VPWR VGND sg13g2_dfrbpq_1
X_37437_ \regs.registers[4][10]\ clk _00501_ _17521_ VPWR VGND sg13g2_dfrbpq_1
X_37438_ \regs.registers[4][11]\ clk _00502_ _17520_ VPWR VGND sg13g2_dfrbpq_1
X_37439_ \regs.registers[4][12]\ clk _00503_ _17519_ VPWR VGND sg13g2_dfrbpq_1
X_37440_ \regs.registers[4][13]\ clk _00504_ _17518_ VPWR VGND sg13g2_dfrbpq_1
X_37441_ \regs.registers[4][14]\ clk _00505_ _17517_ VPWR VGND sg13g2_dfrbpq_1
X_37442_ \regs.registers[4][15]\ clk _00506_ _17516_ VPWR VGND sg13g2_dfrbpq_1
X_37443_ \regs.registers[4][16]\ clk _00507_ _17515_ VPWR VGND sg13g2_dfrbpq_1
X_37444_ \regs.registers[4][17]\ clk _00508_ _17514_ VPWR VGND sg13g2_dfrbpq_1
X_37445_ \regs.registers[4][18]\ clk _00509_ _17513_ VPWR VGND sg13g2_dfrbpq_1
X_37446_ \regs.registers[4][19]\ clk _00510_ _17512_ VPWR VGND sg13g2_dfrbpq_1
X_37447_ \regs.registers[4][20]\ clk _00511_ _17511_ VPWR VGND sg13g2_dfrbpq_1
X_37448_ \regs.registers[4][21]\ clk _00512_ _17510_ VPWR VGND sg13g2_dfrbpq_1
X_37449_ \regs.registers[4][22]\ clk _00513_ _17509_ VPWR VGND sg13g2_dfrbpq_1
X_37450_ \regs.registers[4][23]\ clk _00514_ _17508_ VPWR VGND sg13g2_dfrbpq_1
X_37451_ \regs.registers[4][24]\ clk _00515_ _17507_ VPWR VGND sg13g2_dfrbpq_1
X_37452_ \regs.registers[4][25]\ clk _00516_ _17506_ VPWR VGND sg13g2_dfrbpq_1
X_37453_ \regs.registers[4][26]\ clk _00517_ _17505_ VPWR VGND sg13g2_dfrbpq_1
X_37454_ \regs.registers[4][27]\ clk _00518_ _17504_ VPWR VGND sg13g2_dfrbpq_1
X_37455_ \regs.registers[4][28]\ clk _00519_ _17503_ VPWR VGND sg13g2_dfrbpq_1
X_37456_ \regs.registers[4][29]\ clk _00520_ _17502_ VPWR VGND sg13g2_dfrbpq_1
X_37457_ \regs.registers[4][30]\ clk _00521_ _17501_ VPWR VGND sg13g2_dfrbpq_1
X_37458_ \regs.registers[4][31]\ clk _00522_ _17500_ VPWR VGND sg13g2_dfrbpq_1
X_37459_ \regs.registers[5][0]\ clk _00523_ _17499_ VPWR VGND sg13g2_dfrbpq_1
X_37460_ \regs.registers[5][1]\ clk _00524_ _17498_ VPWR VGND sg13g2_dfrbpq_1
X_37461_ \regs.registers[5][2]\ clk _00525_ _17497_ VPWR VGND sg13g2_dfrbpq_1
X_37462_ \regs.registers[5][3]\ clk _00526_ _17496_ VPWR VGND sg13g2_dfrbpq_1
X_37463_ \regs.registers[5][4]\ clk _00527_ _17495_ VPWR VGND sg13g2_dfrbpq_1
X_37464_ \regs.registers[5][5]\ clk _00528_ _17494_ VPWR VGND sg13g2_dfrbpq_1
X_37465_ \regs.registers[5][6]\ clk _00529_ _17493_ VPWR VGND sg13g2_dfrbpq_1
X_37466_ \regs.registers[5][7]\ clk _00530_ _17492_ VPWR VGND sg13g2_dfrbpq_1
X_37467_ \regs.registers[5][8]\ clk _00531_ _17491_ VPWR VGND sg13g2_dfrbpq_1
X_37468_ \regs.registers[5][9]\ clk _00532_ _17490_ VPWR VGND sg13g2_dfrbpq_1
X_37469_ \regs.registers[5][10]\ clk _00533_ _17489_ VPWR VGND sg13g2_dfrbpq_1
X_37470_ \regs.registers[5][11]\ clk _00534_ _17488_ VPWR VGND sg13g2_dfrbpq_1
X_37471_ \regs.registers[5][12]\ clk _00535_ _17487_ VPWR VGND sg13g2_dfrbpq_1
X_37472_ \regs.registers[5][13]\ clk _00536_ _17486_ VPWR VGND sg13g2_dfrbpq_1
X_37473_ \regs.registers[5][14]\ clk _00537_ _17485_ VPWR VGND sg13g2_dfrbpq_1
X_37474_ \regs.registers[5][15]\ clk _00538_ _17484_ VPWR VGND sg13g2_dfrbpq_1
X_37475_ \regs.registers[5][16]\ clk _00539_ _17483_ VPWR VGND sg13g2_dfrbpq_1
X_37476_ \regs.registers[5][17]\ clk _00540_ _17482_ VPWR VGND sg13g2_dfrbpq_1
X_37477_ \regs.registers[5][18]\ clk _00541_ _17481_ VPWR VGND sg13g2_dfrbpq_1
X_37478_ \regs.registers[5][19]\ clk _00542_ _17480_ VPWR VGND sg13g2_dfrbpq_1
X_37479_ \regs.registers[5][20]\ clk _00543_ _17479_ VPWR VGND sg13g2_dfrbpq_1
X_37480_ \regs.registers[5][21]\ clk _00544_ _17478_ VPWR VGND sg13g2_dfrbpq_1
X_37481_ \regs.registers[5][22]\ clk _00545_ _17477_ VPWR VGND sg13g2_dfrbpq_1
X_37482_ \regs.registers[5][23]\ clk _00546_ _17476_ VPWR VGND sg13g2_dfrbpq_1
X_37483_ \regs.registers[5][24]\ clk _00547_ _17475_ VPWR VGND sg13g2_dfrbpq_1
X_37484_ \regs.registers[5][25]\ clk _00548_ _17474_ VPWR VGND sg13g2_dfrbpq_1
X_37485_ \regs.registers[5][26]\ clk _00549_ _17473_ VPWR VGND sg13g2_dfrbpq_1
X_37486_ \regs.registers[5][27]\ clk _00550_ _17472_ VPWR VGND sg13g2_dfrbpq_1
X_37487_ \regs.registers[5][28]\ clk _00551_ _17471_ VPWR VGND sg13g2_dfrbpq_1
X_37488_ \regs.registers[5][29]\ clk _00552_ _17470_ VPWR VGND sg13g2_dfrbpq_1
X_37489_ \regs.registers[5][30]\ clk _00553_ _17469_ VPWR VGND sg13g2_dfrbpq_1
X_37490_ \regs.registers[5][31]\ clk _00554_ _17468_ VPWR VGND sg13g2_dfrbpq_1
X_37491_ \regs.registers[6][0]\ clk _00555_ _17467_ VPWR VGND sg13g2_dfrbpq_1
X_37492_ \regs.registers[6][1]\ clk _00556_ _17466_ VPWR VGND sg13g2_dfrbpq_1
X_37493_ \regs.registers[6][2]\ clk _00557_ _17465_ VPWR VGND sg13g2_dfrbpq_1
X_37494_ \regs.registers[6][3]\ clk _00558_ _17464_ VPWR VGND sg13g2_dfrbpq_1
X_37495_ \regs.registers[6][4]\ clk _00559_ _17463_ VPWR VGND sg13g2_dfrbpq_1
X_37496_ \regs.registers[6][5]\ clk _00560_ _17450_ VPWR VGND sg13g2_dfrbpq_1
X_37497_ \regs.registers[6][6]\ clk _00561_ _17449_ VPWR VGND sg13g2_dfrbpq_1
X_37498_ \regs.registers[6][7]\ clk _00562_ _17448_ VPWR VGND sg13g2_dfrbpq_1
X_37499_ \regs.registers[6][8]\ clk _00563_ _17447_ VPWR VGND sg13g2_dfrbpq_1
X_37500_ \regs.registers[6][9]\ clk _00564_ _17446_ VPWR VGND sg13g2_dfrbpq_1
X_37501_ \regs.registers[6][10]\ clk _00565_ _17445_ VPWR VGND sg13g2_dfrbpq_1
X_37502_ \regs.registers[6][11]\ clk _00566_ _17444_ VPWR VGND sg13g2_dfrbpq_1
X_37503_ \regs.registers[6][12]\ clk _00567_ _17443_ VPWR VGND sg13g2_dfrbpq_1
X_37504_ \regs.registers[6][13]\ clk _00568_ _17442_ VPWR VGND sg13g2_dfrbpq_1
X_37505_ \regs.registers[6][14]\ clk _00569_ _17441_ VPWR VGND sg13g2_dfrbpq_1
X_37506_ \regs.registers[6][15]\ clk _00570_ _17440_ VPWR VGND sg13g2_dfrbpq_1
X_37507_ \regs.registers[6][16]\ clk _00571_ _17439_ VPWR VGND sg13g2_dfrbpq_1
X_37508_ \regs.registers[6][17]\ clk _00572_ _17438_ VPWR VGND sg13g2_dfrbpq_1
X_37509_ \regs.registers[6][18]\ clk _00573_ _17437_ VPWR VGND sg13g2_dfrbpq_1
X_37510_ \regs.registers[6][19]\ clk _00574_ _17436_ VPWR VGND sg13g2_dfrbpq_1
X_37511_ \regs.registers[6][20]\ clk _00575_ _17435_ VPWR VGND sg13g2_dfrbpq_1
X_37512_ \regs.registers[6][21]\ clk _00576_ _17434_ VPWR VGND sg13g2_dfrbpq_1
X_37513_ \regs.registers[6][22]\ clk _00577_ _17433_ VPWR VGND sg13g2_dfrbpq_1
X_37514_ \regs.registers[6][23]\ clk _00578_ _17432_ VPWR VGND sg13g2_dfrbpq_1
X_37515_ \regs.registers[6][24]\ clk _00579_ _17431_ VPWR VGND sg13g2_dfrbpq_1
X_37516_ \regs.registers[6][25]\ clk _00580_ _17430_ VPWR VGND sg13g2_dfrbpq_1
X_37517_ \regs.registers[6][26]\ clk _00581_ _17429_ VPWR VGND sg13g2_dfrbpq_1
X_37518_ \regs.registers[6][27]\ clk _00582_ _17428_ VPWR VGND sg13g2_dfrbpq_1
X_37519_ \regs.registers[6][28]\ clk _00583_ _17427_ VPWR VGND sg13g2_dfrbpq_1
X_37520_ \regs.registers[6][29]\ clk _00584_ _17426_ VPWR VGND sg13g2_dfrbpq_1
X_37521_ \regs.registers[6][30]\ clk _00585_ _17425_ VPWR VGND sg13g2_dfrbpq_1
X_37522_ \regs.registers[6][31]\ clk _00586_ _17424_ VPWR VGND sg13g2_dfrbpq_1
X_37523_ \regs.registers[7][0]\ clk _00587_ _17423_ VPWR VGND sg13g2_dfrbpq_1
X_37524_ \regs.registers[7][1]\ clk _00588_ _17422_ VPWR VGND sg13g2_dfrbpq_1
X_37525_ \regs.registers[7][2]\ clk _00589_ _17421_ VPWR VGND sg13g2_dfrbpq_1
X_37526_ \regs.registers[7][3]\ clk _00590_ _17420_ VPWR VGND sg13g2_dfrbpq_1
X_37527_ \regs.registers[7][4]\ clk _00591_ _17419_ VPWR VGND sg13g2_dfrbpq_1
X_37528_ \regs.registers[7][5]\ clk _00592_ _17413_ VPWR VGND sg13g2_dfrbpq_1
X_37529_ \regs.registers[7][6]\ clk _00593_ _17412_ VPWR VGND sg13g2_dfrbpq_1
X_37530_ \regs.registers[7][7]\ clk _00594_ _17411_ VPWR VGND sg13g2_dfrbpq_1
X_37531_ \regs.registers[7][8]\ clk _00595_ _17410_ VPWR VGND sg13g2_dfrbpq_1
X_37532_ \regs.registers[7][9]\ clk _00596_ _17409_ VPWR VGND sg13g2_dfrbpq_1
X_37533_ \regs.registers[7][10]\ clk _00597_ _17408_ VPWR VGND sg13g2_dfrbpq_1
X_37534_ \regs.registers[7][11]\ clk _00598_ _17407_ VPWR VGND sg13g2_dfrbpq_1
X_37535_ \regs.registers[7][12]\ clk _00599_ _17406_ VPWR VGND sg13g2_dfrbpq_1
X_37536_ \regs.registers[7][13]\ clk _00600_ _17405_ VPWR VGND sg13g2_dfrbpq_1
X_37537_ \regs.registers[7][14]\ clk _00601_ _17404_ VPWR VGND sg13g2_dfrbpq_1
X_37538_ \regs.registers[7][15]\ clk _00602_ _17403_ VPWR VGND sg13g2_dfrbpq_1
X_37539_ \regs.registers[7][16]\ clk _00603_ _17402_ VPWR VGND sg13g2_dfrbpq_1
X_37540_ \regs.registers[7][17]\ clk _00604_ _17401_ VPWR VGND sg13g2_dfrbpq_1
X_37541_ \regs.registers[7][18]\ clk _00605_ _17400_ VPWR VGND sg13g2_dfrbpq_1
X_37542_ \regs.registers[7][19]\ clk _00606_ _17399_ VPWR VGND sg13g2_dfrbpq_1
X_37543_ \regs.registers[7][20]\ clk _00607_ _17398_ VPWR VGND sg13g2_dfrbpq_1
X_37544_ \regs.registers[7][21]\ clk _00608_ _17397_ VPWR VGND sg13g2_dfrbpq_1
X_37545_ \regs.registers[7][22]\ clk _00609_ _17396_ VPWR VGND sg13g2_dfrbpq_1
X_37546_ \regs.registers[7][23]\ clk _00610_ _17395_ VPWR VGND sg13g2_dfrbpq_1
X_37547_ \regs.registers[7][24]\ clk _00611_ _17394_ VPWR VGND sg13g2_dfrbpq_1
X_37548_ \regs.registers[7][25]\ clk _00612_ _17393_ VPWR VGND sg13g2_dfrbpq_1
X_37549_ \regs.registers[7][26]\ clk _00613_ _17392_ VPWR VGND sg13g2_dfrbpq_1
X_37550_ \regs.registers[7][27]\ clk _00614_ _17391_ VPWR VGND sg13g2_dfrbpq_1
X_37551_ \regs.registers[7][28]\ clk _00615_ _17390_ VPWR VGND sg13g2_dfrbpq_1
X_37552_ \regs.registers[7][29]\ clk _00616_ _17389_ VPWR VGND sg13g2_dfrbpq_1
X_37553_ \regs.registers[7][30]\ clk _00617_ _17388_ VPWR VGND sg13g2_dfrbpq_1
X_37554_ \regs.registers[7][31]\ clk _00618_ _17387_ VPWR VGND sg13g2_dfrbpq_1
X_37555_ \regs.registers[8][0]\ clk _00619_ _17386_ VPWR VGND sg13g2_dfrbpq_1
X_37556_ \regs.registers[8][1]\ clk _00620_ _17385_ VPWR VGND sg13g2_dfrbpq_1
X_37557_ \regs.registers[8][2]\ clk _00621_ _17384_ VPWR VGND sg13g2_dfrbpq_1
X_37558_ \regs.registers[8][3]\ clk _00622_ _17383_ VPWR VGND sg13g2_dfrbpq_1
X_37559_ \regs.registers[8][4]\ clk _00623_ _17382_ VPWR VGND sg13g2_dfrbpq_1
X_37560_ \regs.registers[8][5]\ clk _00624_ _17344_ VPWR VGND sg13g2_dfrbpq_1
X_37561_ \regs.registers[8][6]\ clk _00625_ _19566_ VPWR VGND sg13g2_dfrbpq_1
X_37562_ \regs.registers[8][7]\ clk _00626_ _19565_ VPWR VGND sg13g2_dfrbpq_1
X_37563_ \regs.registers[8][8]\ clk _00627_ _19564_ VPWR VGND sg13g2_dfrbpq_1
X_37564_ \regs.registers[8][9]\ clk _00628_ _19563_ VPWR VGND sg13g2_dfrbpq_1
X_37565_ \regs.registers[8][10]\ clk _00629_ _19562_ VPWR VGND sg13g2_dfrbpq_1
X_37566_ \regs.registers[8][11]\ clk _00630_ _19561_ VPWR VGND sg13g2_dfrbpq_1
X_37567_ \regs.registers[8][12]\ clk _00631_ _19560_ VPWR VGND sg13g2_dfrbpq_1
X_37568_ \regs.registers[8][13]\ clk _00632_ _19559_ VPWR VGND sg13g2_dfrbpq_1
X_37569_ \regs.registers[8][14]\ clk _00633_ _19558_ VPWR VGND sg13g2_dfrbpq_1
X_37570_ \regs.registers[8][15]\ clk _00634_ _19557_ VPWR VGND sg13g2_dfrbpq_1
X_37571_ \regs.registers[8][16]\ clk _00635_ _19556_ VPWR VGND sg13g2_dfrbpq_1
X_37572_ \regs.registers[8][17]\ clk _00636_ _19555_ VPWR VGND sg13g2_dfrbpq_1
X_37573_ \regs.registers[8][18]\ clk _00637_ _19554_ VPWR VGND sg13g2_dfrbpq_1
X_37574_ \regs.registers[8][19]\ clk _00638_ _19553_ VPWR VGND sg13g2_dfrbpq_1
X_37575_ \regs.registers[8][20]\ clk _00639_ _19552_ VPWR VGND sg13g2_dfrbpq_1
X_37576_ \regs.registers[8][21]\ clk _00640_ _19551_ VPWR VGND sg13g2_dfrbpq_1
X_37577_ \regs.registers[8][22]\ clk _00641_ _19550_ VPWR VGND sg13g2_dfrbpq_1
X_37578_ \regs.registers[8][23]\ clk _00642_ _19549_ VPWR VGND sg13g2_dfrbpq_1
X_37579_ \regs.registers[8][24]\ clk _00643_ _19548_ VPWR VGND sg13g2_dfrbpq_1
X_37580_ \regs.registers[8][25]\ clk _00644_ _19547_ VPWR VGND sg13g2_dfrbpq_1
X_37581_ \regs.registers[8][26]\ clk _00645_ _19546_ VPWR VGND sg13g2_dfrbpq_1
X_37582_ \regs.registers[8][27]\ clk _00646_ _19545_ VPWR VGND sg13g2_dfrbpq_1
X_37583_ \regs.registers[8][28]\ clk _00647_ _19544_ VPWR VGND sg13g2_dfrbpq_1
X_37584_ \regs.registers[8][29]\ clk _00648_ _19543_ VPWR VGND sg13g2_dfrbpq_1
X_37585_ \regs.registers[8][30]\ clk _00649_ _19542_ VPWR VGND sg13g2_dfrbpq_1
X_37586_ \regs.registers[8][31]\ clk _00650_ _19541_ VPWR VGND sg13g2_dfrbpq_1
X_37587_ \regs.registers[9][0]\ clk _00651_ _19540_ VPWR VGND sg13g2_dfrbpq_1
X_37588_ \regs.registers[9][1]\ clk _00652_ _19539_ VPWR VGND sg13g2_dfrbpq_1
X_37589_ \regs.registers[9][2]\ clk _00653_ _19538_ VPWR VGND sg13g2_dfrbpq_1
X_37590_ \regs.registers[9][3]\ clk _00654_ _19537_ VPWR VGND sg13g2_dfrbpq_1
X_37591_ \regs.registers[9][4]\ clk _00655_ _19536_ VPWR VGND sg13g2_dfrbpq_1
X_37592_ \regs.registers[9][5]\ clk _00656_ _19535_ VPWR VGND sg13g2_dfrbpq_1
X_37593_ \regs.registers[9][6]\ clk _00657_ _19534_ VPWR VGND sg13g2_dfrbpq_1
X_37594_ \regs.registers[9][7]\ clk _00658_ _19533_ VPWR VGND sg13g2_dfrbpq_1
X_37595_ \regs.registers[9][8]\ clk _00659_ _19532_ VPWR VGND sg13g2_dfrbpq_1
X_37596_ \regs.registers[9][9]\ clk _00660_ _19531_ VPWR VGND sg13g2_dfrbpq_1
X_37597_ \regs.registers[9][10]\ clk _00661_ _19530_ VPWR VGND sg13g2_dfrbpq_1
X_37598_ \regs.registers[9][11]\ clk _00662_ _19529_ VPWR VGND sg13g2_dfrbpq_1
X_37599_ \regs.registers[9][12]\ clk _00663_ _19528_ VPWR VGND sg13g2_dfrbpq_1
X_37600_ \regs.registers[9][13]\ clk _00664_ _19527_ VPWR VGND sg13g2_dfrbpq_1
X_37601_ \regs.registers[9][14]\ clk _00665_ _19526_ VPWR VGND sg13g2_dfrbpq_1
X_37602_ \regs.registers[9][15]\ clk _00666_ _19525_ VPWR VGND sg13g2_dfrbpq_1
X_37603_ \regs.registers[9][16]\ clk _00667_ _19524_ VPWR VGND sg13g2_dfrbpq_1
X_37604_ \regs.registers[9][17]\ clk _00668_ _19523_ VPWR VGND sg13g2_dfrbpq_1
X_37605_ \regs.registers[9][18]\ clk _00669_ _19522_ VPWR VGND sg13g2_dfrbpq_1
X_37606_ \regs.registers[9][19]\ clk _00670_ _19521_ VPWR VGND sg13g2_dfrbpq_1
X_37607_ \regs.registers[9][20]\ clk _00671_ _19520_ VPWR VGND sg13g2_dfrbpq_1
X_37608_ \regs.registers[9][21]\ clk _00672_ _19519_ VPWR VGND sg13g2_dfrbpq_1
X_37609_ \regs.registers[9][22]\ clk _00673_ _19518_ VPWR VGND sg13g2_dfrbpq_1
X_37610_ \regs.registers[9][23]\ clk _00674_ _19517_ VPWR VGND sg13g2_dfrbpq_1
X_37611_ \regs.registers[9][24]\ clk _00675_ _19516_ VPWR VGND sg13g2_dfrbpq_1
X_37612_ \regs.registers[9][25]\ clk _00676_ _19515_ VPWR VGND sg13g2_dfrbpq_1
X_37613_ \regs.registers[9][26]\ clk _00677_ _19514_ VPWR VGND sg13g2_dfrbpq_1
X_37614_ \regs.registers[9][27]\ clk _00678_ _19513_ VPWR VGND sg13g2_dfrbpq_1
X_37615_ \regs.registers[9][28]\ clk _00679_ _19512_ VPWR VGND sg13g2_dfrbpq_1
X_37616_ \regs.registers[9][29]\ clk _00680_ _19511_ VPWR VGND sg13g2_dfrbpq_1
X_37617_ \regs.registers[9][30]\ clk _00681_ _19510_ VPWR VGND sg13g2_dfrbpq_1
X_37618_ \regs.registers[9][31]\ clk _00682_ _19509_ VPWR VGND sg13g2_dfrbpq_1
X_37619_ \csr_i.pc[2]\ clk _00683_ _19508_ VPWR VGND sg13g2_dfrbpq_1
X_37620_ \csr_i.pc[3]\ clk _00684_ _19506_ VPWR VGND sg13g2_dfrbpq_1
X_37621_ \csr_i.pc[4]\ clk _00685_ _19504_ VPWR VGND sg13g2_dfrbpq_1
X_37622_ \csr_i.pc[5]\ clk _00686_ _19502_ VPWR VGND sg13g2_dfrbpq_1
X_37623_ \csr_i.pc[6]\ clk _00687_ _19500_ VPWR VGND sg13g2_dfrbpq_1
X_37624_ \csr_i.pc[7]\ clk _00688_ _19498_ VPWR VGND sg13g2_dfrbpq_1
X_37625_ \csr_i.pc[8]\ clk _00689_ _19496_ VPWR VGND sg13g2_dfrbpq_1
X_37626_ \csr_i.pc[9]\ clk _00690_ _19494_ VPWR VGND sg13g2_dfrbpq_1
X_37627_ \csr_i.pc[10]\ clk _00691_ _19492_ VPWR VGND sg13g2_dfrbpq_1
X_37628_ \csr_i.pc[11]\ clk _00692_ _19490_ VPWR VGND sg13g2_dfrbpq_1
X_37629_ \csr_i.pc[12]\ clk _00693_ _19488_ VPWR VGND sg13g2_dfrbpq_1
X_37630_ \csr_i.pc[13]\ clk _00694_ _19486_ VPWR VGND sg13g2_dfrbpq_1
X_37631_ \csr_i.pc[14]\ clk _00695_ _19484_ VPWR VGND sg13g2_dfrbpq_1
X_37632_ \csr_i.pc[15]\ clk _00696_ _19482_ VPWR VGND sg13g2_dfrbpq_1
X_37633_ \csr_i.pc[16]\ clk _00697_ _19480_ VPWR VGND sg13g2_dfrbpq_1
X_37634_ \csr_i.pc[17]\ clk _00698_ _19478_ VPWR VGND sg13g2_dfrbpq_1
X_37635_ \csr_i.pc[18]\ clk _00699_ _19476_ VPWR VGND sg13g2_dfrbpq_1
X_37636_ \csr_i.pc[19]\ clk _00700_ _19474_ VPWR VGND sg13g2_dfrbpq_1
X_37637_ \csr_i.pc[20]\ clk _00701_ _19472_ VPWR VGND sg13g2_dfrbpq_1
X_37638_ \csr_i.pc[21]\ clk _00702_ _19470_ VPWR VGND sg13g2_dfrbpq_1
X_37639_ \csr_i.pc[22]\ clk _00703_ _19468_ VPWR VGND sg13g2_dfrbpq_1
X_37640_ \csr_i.pc[0]\ clk _00704_ _19466_ VPWR VGND sg13g2_dfrbpq_1
X_37641_ \csr_i.pc[1]\ clk _00705_ _19464_ VPWR VGND sg13g2_dfrbpq_1
X_37642_ \memory_i.uart_transmitter.fsm_state[0]\ clk _00706_ _19462_ VPWR VGND sg13g2_dfrbpq_1
X_37643_ \memory_i.uart_transmitter.fsm_state[1]\ clk _00707_ _19461_ VPWR VGND sg13g2_dfrbpq_1
X_37644_ \memory_i.freq_inst.dsmod_sin.data_pre_r[8]\ clk _00708_ _19460_ VPWR VGND sg13g2_dfrbpq_1
X_37645_ \memory_i.freq_inst.dsmod_sin.data_pre_r[9]\ clk _00709_ _19458_ VPWR VGND sg13g2_dfrbpq_1
X_37646_ \memory_i.freq_inst.dsmod_sin.data_pre_r[10]\ clk _00710_ _19456_ VPWR VGND sg13g2_dfrbpq_1
X_37647_ \memory_i.freq_inst.dsmod_sin.data_pre_r[11]\ clk _00711_ _19454_ VPWR VGND sg13g2_dfrbpq_1
X_37648_ \memory_i.freq_inst.dsmod_sin.data_pre_r[12]\ clk _00712_ _19452_ VPWR VGND sg13g2_dfrbpq_1
X_37649_ \memory_i.freq_inst.dsmod_sin.data_pre_r[13]\ clk _00713_ _19450_ VPWR VGND sg13g2_dfrbpq_1
X_37650_ \memory_i.freq_inst.dsmod_sin.data_pre_r[14]\ clk _00714_ _19448_ VPWR VGND sg13g2_dfrbpq_1
X_37651_ \memory_i.freq_inst.dsmod_sin.data_pre_r[15]\ clk _00715_ _19446_ VPWR VGND sg13g2_dfrbpq_1
X_37652_ \memory_i.freq_inst.dsmod_sin.data_pre_r[16]\ clk _00716_ _19444_ VPWR VGND sg13g2_dfrbpq_1
X_37653_ \memory_i.freq_inst.dsmod_sin.data_pre_r[17]\ clk _00717_ _19442_ VPWR VGND sg13g2_dfrbpq_1
X_37654_ \memory_i.freq_inst.dsmod_sin.data_pre_r[18]\ clk _00718_ _19440_ VPWR VGND sg13g2_dfrbpq_1
X_37655_ \memory_i.freq_inst.dsmod_sin.data_pre_r[19]\ clk _00719_ _19438_ VPWR VGND sg13g2_dfrbpq_1
X_37656_ \memory_i.freq_inst.dsmod_sin.data_pre_r[20]\ clk _00720_ _19436_ VPWR VGND sg13g2_dfrbpq_1
X_37657_ \memory_i.freq_inst.dsmod_sin.data_pre_r[21]\ clk _00721_ _19434_ VPWR VGND sg13g2_dfrbpq_1
X_37658_ \memory_i.freq_inst.dsmod_sin.data_pre_r[22]\ clk _00722_ _19432_ VPWR VGND sg13g2_dfrbpq_1
X_37659_ \memory_i.freq_inst.dsmod_sin.data_pre_r[23]\ clk _00723_ _19430_ VPWR VGND sg13g2_dfrbpq_1
X_37660_ \memory_i.freq_inst.dsmod_sin.data_pre_r[24]\ clk _00724_ _19428_ VPWR VGND sg13g2_dfrbpq_1
X_37661_ \memory_i.freq_inst.dsmod_sin.data_pre_r[25]\ clk _00725_ _19426_ VPWR VGND sg13g2_dfrbpq_1
X_37662_ \memory_i.freq_inst.dsmod_sin.data_pre_r[26]\ clk _00726_ _19424_ VPWR VGND sg13g2_dfrbpq_1
X_37663_ \memory_i.freq_inst.dsmod_sin.data_pre_r[27]\ clk _00727_ _19422_ VPWR VGND sg13g2_dfrbpq_1
X_37664_ \memory_i.freq_inst.dsmod_sin.data_pre_r[28]\ clk _00728_ _19420_ VPWR VGND sg13g2_dfrbpq_1
X_37665_ \memory_i.freq_inst.dsmod_sin.data_pre_r[29]\ clk _00729_ _19418_ VPWR VGND sg13g2_dfrbpq_1
X_37666_ \memory_i.freq_inst.dsmod_sin.data_pre_r[30]\ clk _00730_ _19416_ VPWR VGND sg13g2_dfrbpq_1
X_37667_ \memory_i.freq_inst.dsmod_sin.data_pre_r[31]\ clk _00731_ _19414_ VPWR VGND sg13g2_dfrbpq_1
X_37668_ \memory_i.freq_inst.dsmod_sin.data_pre_r[32]\ clk _00732_ _19412_ VPWR VGND sg13g2_dfrbpq_1
X_37669_ \memory_i.freq_inst.dsmod_sin.data_pre_r[33]\ clk _00733_ _19410_ VPWR VGND sg13g2_dfrbpq_1
X_37670_ \memory_i.freq_inst.dsmod_sin.data_pre_r[34]\ clk _00734_ _19408_ VPWR VGND sg13g2_dfrbpq_1
X_37671_ \memory_i.freq_inst.dsmod_sin.data_pre_r[35]\ clk _00735_ _19406_ VPWR VGND sg13g2_dfrbpq_1
X_37672_ \memory_i.freq_inst.dsmod_sin.data_pre_r[36]\ clk _00736_ _19404_ VPWR VGND sg13g2_dfrbpq_1
X_37673_ \memory_i.freq_inst.dsmod_sin.data_pre_r[37]\ clk _00737_ _19402_ VPWR VGND sg13g2_dfrbpq_1
X_37674_ \memory_i.freq_inst.dsmod_cos.data_pre_r[8]\ clk _00738_ _19400_ VPWR VGND sg13g2_dfrbpq_1
X_37675_ \memory_i.freq_inst.dsmod_cos.data_pre_r[9]\ clk _00739_ _19398_ VPWR VGND sg13g2_dfrbpq_1
X_37676_ \memory_i.freq_inst.dsmod_cos.data_pre_r[10]\ clk _00740_ _19396_ VPWR VGND sg13g2_dfrbpq_1
X_37677_ \memory_i.freq_inst.dsmod_cos.data_pre_r[11]\ clk _00741_ _19394_ VPWR VGND sg13g2_dfrbpq_1
X_37678_ \memory_i.freq_inst.dsmod_cos.data_pre_r[12]\ clk _00742_ _19392_ VPWR VGND sg13g2_dfrbpq_1
X_37679_ \memory_i.freq_inst.dsmod_cos.data_pre_r[13]\ clk _00743_ _19390_ VPWR VGND sg13g2_dfrbpq_1
X_37680_ \memory_i.freq_inst.dsmod_cos.data_pre_r[14]\ clk _00744_ _19388_ VPWR VGND sg13g2_dfrbpq_1
X_37681_ \memory_i.freq_inst.dsmod_cos.data_pre_r[15]\ clk _00745_ _19386_ VPWR VGND sg13g2_dfrbpq_1
X_37682_ \memory_i.freq_inst.dsmod_cos.data_pre_r[16]\ clk _00746_ _19384_ VPWR VGND sg13g2_dfrbpq_1
X_37683_ \memory_i.freq_inst.dsmod_cos.data_pre_r[17]\ clk _00747_ _19382_ VPWR VGND sg13g2_dfrbpq_1
X_37684_ \memory_i.freq_inst.dsmod_cos.data_pre_r[18]\ clk _00748_ _19380_ VPWR VGND sg13g2_dfrbpq_1
X_37685_ \memory_i.freq_inst.dsmod_cos.data_pre_r[19]\ clk _00749_ _19378_ VPWR VGND sg13g2_dfrbpq_1
X_37686_ \memory_i.freq_inst.dsmod_cos.data_pre_r[20]\ clk _00750_ _19376_ VPWR VGND sg13g2_dfrbpq_1
X_37687_ \memory_i.freq_inst.dsmod_cos.data_pre_r[21]\ clk _00751_ _19374_ VPWR VGND sg13g2_dfrbpq_1
X_37688_ \memory_i.freq_inst.dsmod_cos.data_pre_r[22]\ clk _00752_ _19372_ VPWR VGND sg13g2_dfrbpq_1
X_37689_ \memory_i.freq_inst.dsmod_cos.data_pre_r[23]\ clk _00753_ _19370_ VPWR VGND sg13g2_dfrbpq_1
X_37690_ \memory_i.freq_inst.dsmod_cos.data_pre_r[24]\ clk _00754_ _19368_ VPWR VGND sg13g2_dfrbpq_1
X_37691_ \memory_i.freq_inst.dsmod_cos.data_pre_r[25]\ clk _00755_ _19366_ VPWR VGND sg13g2_dfrbpq_1
X_37692_ \memory_i.freq_inst.dsmod_cos.data_pre_r[26]\ clk _00756_ _19364_ VPWR VGND sg13g2_dfrbpq_1
X_37693_ \memory_i.freq_inst.dsmod_cos.data_pre_r[27]\ clk _00757_ _19362_ VPWR VGND sg13g2_dfrbpq_1
X_37694_ \memory_i.freq_inst.dsmod_cos.data_pre_r[28]\ clk _00758_ _19360_ VPWR VGND sg13g2_dfrbpq_1
X_37695_ \memory_i.freq_inst.dsmod_cos.data_pre_r[29]\ clk _00759_ _19358_ VPWR VGND sg13g2_dfrbpq_1
X_37696_ \memory_i.freq_inst.dsmod_cos.data_pre_r[30]\ clk _00760_ _19356_ VPWR VGND sg13g2_dfrbpq_1
X_37697_ \memory_i.freq_inst.dsmod_cos.data_pre_r[31]\ clk _00761_ _19354_ VPWR VGND sg13g2_dfrbpq_1
X_37698_ \memory_i.freq_inst.dsmod_cos.data_pre_r[32]\ clk _00762_ _19352_ VPWR VGND sg13g2_dfrbpq_1
X_37699_ \memory_i.freq_inst.dsmod_cos.data_pre_r[33]\ clk _00763_ _19350_ VPWR VGND sg13g2_dfrbpq_1
X_37700_ \memory_i.freq_inst.dsmod_cos.data_pre_r[34]\ clk _00764_ _19348_ VPWR VGND sg13g2_dfrbpq_1
X_37701_ \memory_i.freq_inst.dsmod_cos.data_pre_r[35]\ clk _00765_ _19346_ VPWR VGND sg13g2_dfrbpq_1
X_37702_ \memory_i.freq_inst.dsmod_cos.data_pre_r[36]\ clk _00766_ _19344_ VPWR VGND sg13g2_dfrbpq_1
X_37703_ \memory_i.freq_inst.dsmod_cos.data_pre_r[37]\ clk _00767_ _19342_ VPWR VGND sg13g2_dfrbpq_1
X_37704_ \csr_i.mstatus[3]\ clk _00768_ _19340_ VPWR VGND sg13g2_dfrbpq_1
X_37705_ \csr_i.mstatus[0]\ clk _00769_ _19339_ VPWR VGND sg13g2_dfrbpq_1
X_37706_ \csr_i.mstatus[1]\ clk _00770_ _19337_ VPWR VGND sg13g2_dfrbpq_1
X_37707_ \csr_i.mstatus[2]\ clk _00771_ _19335_ VPWR VGND sg13g2_dfrbpq_1
X_37708_ \csr_i.mstatus[4]\ clk _00772_ _19333_ VPWR VGND sg13g2_dfrbpq_1
X_37709_ \csr_i.mstatus[5]\ clk _00773_ _19331_ VPWR VGND sg13g2_dfrbpq_1
X_37710_ \csr_i.mstatus[6]\ clk _00774_ _19329_ VPWR VGND sg13g2_dfrbpq_1
X_37711_ \csr_i.mstatus[7]\ clk _00775_ _19327_ VPWR VGND sg13g2_dfrbpq_1
X_37712_ \csr_i.mstatus[8]\ clk _00776_ _19325_ VPWR VGND sg13g2_dfrbpq_1
X_37713_ \csr_i.mstatus[9]\ clk _00777_ _19323_ VPWR VGND sg13g2_dfrbpq_1
X_37714_ \csr_i.mstatus[10]\ clk _00778_ _19321_ VPWR VGND sg13g2_dfrbpq_1
X_37715_ \csr_i.mstatus[11]\ clk _00779_ _19319_ VPWR VGND sg13g2_dfrbpq_1
X_37716_ \csr_i.mstatus[12]\ clk _00780_ _19317_ VPWR VGND sg13g2_dfrbpq_1
X_37717_ \csr_i.mstatus[13]\ clk _00781_ _19315_ VPWR VGND sg13g2_dfrbpq_1
X_37718_ \csr_i.mstatus[14]\ clk _00782_ _19313_ VPWR VGND sg13g2_dfrbpq_1
X_37719_ \csr_i.mstatus[15]\ clk _00783_ _19311_ VPWR VGND sg13g2_dfrbpq_1
X_37720_ \csr_i.mstatus[16]\ clk _00784_ _19309_ VPWR VGND sg13g2_dfrbpq_1
X_37721_ \csr_i.mstatus[17]\ clk _00785_ _19307_ VPWR VGND sg13g2_dfrbpq_1
X_37722_ \csr_i.mstatus[18]\ clk _00786_ _19305_ VPWR VGND sg13g2_dfrbpq_1
X_37723_ \csr_i.mstatus[19]\ clk _00787_ _19303_ VPWR VGND sg13g2_dfrbpq_1
X_37724_ \csr_i.mstatus[20]\ clk _00788_ _19301_ VPWR VGND sg13g2_dfrbpq_1
X_37725_ \csr_i.mstatus[21]\ clk _00789_ _19299_ VPWR VGND sg13g2_dfrbpq_1
X_37726_ \csr_i.mstatus[22]\ clk _00790_ _19297_ VPWR VGND sg13g2_dfrbpq_1
X_37727_ \csr_i.mstatus[23]\ clk _00791_ _19295_ VPWR VGND sg13g2_dfrbpq_1
X_37728_ \csr_i.mstatus[24]\ clk _00792_ _19293_ VPWR VGND sg13g2_dfrbpq_1
X_37729_ \csr_i.mstatus[25]\ clk _00793_ _19291_ VPWR VGND sg13g2_dfrbpq_1
X_37730_ \csr_i.mstatus[26]\ clk _00794_ _19289_ VPWR VGND sg13g2_dfrbpq_1
X_37731_ \csr_i.mstatus[27]\ clk _00795_ _19287_ VPWR VGND sg13g2_dfrbpq_1
X_37732_ \csr_i.mstatus[28]\ clk _00796_ _19285_ VPWR VGND sg13g2_dfrbpq_1
X_37733_ \csr_i.mstatus[29]\ clk _00797_ _19283_ VPWR VGND sg13g2_dfrbpq_1
X_37734_ \csr_i.mstatus[30]\ clk _00798_ _19281_ VPWR VGND sg13g2_dfrbpq_1
X_37735_ \csr_i.mstatus[31]\ clk _00799_ _19279_ VPWR VGND sg13g2_dfrbpq_1
X_37736_ \csr_i.mie[0]\ clk _00800_ _19277_ VPWR VGND sg13g2_dfrbpq_1
X_37737_ \csr_i.mie[1]\ clk _00801_ _19275_ VPWR VGND sg13g2_dfrbpq_1
X_37738_ \csr_i.mie[2]\ clk _00802_ _19273_ VPWR VGND sg13g2_dfrbpq_1
X_37739_ \csr_i.mie[3]\ clk _00803_ _19271_ VPWR VGND sg13g2_dfrbpq_1
X_37740_ \csr_i.mie[4]\ clk _00804_ _19269_ VPWR VGND sg13g2_dfrbpq_1
X_37741_ \csr_i.mie[5]\ clk _00805_ _19267_ VPWR VGND sg13g2_dfrbpq_1
X_37742_ \csr_i.mie[6]\ clk _00806_ _19265_ VPWR VGND sg13g2_dfrbpq_1
X_37743_ \csr_i.mie[7]\ clk _00807_ _19263_ VPWR VGND sg13g2_dfrbpq_1
X_37744_ \csr_i.mie[8]\ clk _00808_ _19261_ VPWR VGND sg13g2_dfrbpq_1
X_37745_ \csr_i.mie[9]\ clk _00809_ _19259_ VPWR VGND sg13g2_dfrbpq_1
X_37746_ \csr_i.mie[10]\ clk _00810_ _19257_ VPWR VGND sg13g2_dfrbpq_1
X_37747_ \csr_i.mie[11]\ clk _00811_ _19255_ VPWR VGND sg13g2_dfrbpq_1
X_37748_ \csr_i.mie[12]\ clk _00812_ _19253_ VPWR VGND sg13g2_dfrbpq_1
X_37749_ \csr_i.mie[13]\ clk _00813_ _19251_ VPWR VGND sg13g2_dfrbpq_1
X_37750_ \csr_i.mie[14]\ clk _00814_ _19249_ VPWR VGND sg13g2_dfrbpq_1
X_37751_ \csr_i.mie[15]\ clk _00815_ _19247_ VPWR VGND sg13g2_dfrbpq_1
X_37752_ \csr_i.mie[16]\ clk _00816_ _19245_ VPWR VGND sg13g2_dfrbpq_1
X_37753_ \csr_i.mie[17]\ clk _00817_ _19243_ VPWR VGND sg13g2_dfrbpq_1
X_37754_ \csr_i.mie[18]\ clk _00818_ _19241_ VPWR VGND sg13g2_dfrbpq_1
X_37755_ \csr_i.mie[19]\ clk _00819_ _19239_ VPWR VGND sg13g2_dfrbpq_1
X_37756_ \csr_i.mie[20]\ clk _00820_ _19237_ VPWR VGND sg13g2_dfrbpq_1
X_37757_ \csr_i.mie[21]\ clk _00821_ _19235_ VPWR VGND sg13g2_dfrbpq_1
X_37758_ \csr_i.mie[22]\ clk _00822_ _19233_ VPWR VGND sg13g2_dfrbpq_1
X_37759_ \csr_i.mie[23]\ clk _00823_ _19231_ VPWR VGND sg13g2_dfrbpq_1
X_37760_ \csr_i.mie[24]\ clk _00824_ _19229_ VPWR VGND sg13g2_dfrbpq_1
X_37761_ \csr_i.mie[25]\ clk _00825_ _19227_ VPWR VGND sg13g2_dfrbpq_1
X_37762_ \csr_i.mie[26]\ clk _00826_ _19225_ VPWR VGND sg13g2_dfrbpq_1
X_37763_ \csr_i.mie[27]\ clk _00827_ _19223_ VPWR VGND sg13g2_dfrbpq_1
X_37764_ \csr_i.mie[28]\ clk _00828_ _19221_ VPWR VGND sg13g2_dfrbpq_1
X_37765_ \csr_i.mie[29]\ clk _00829_ _19219_ VPWR VGND sg13g2_dfrbpq_1
X_37766_ \csr_i.mie[30]\ clk _00830_ _19217_ VPWR VGND sg13g2_dfrbpq_1
X_37767_ \csr_i.mie[31]\ clk _00831_ _19215_ VPWR VGND sg13g2_dfrbpq_1
X_37768_ \csr_i.mtvec[0]\ clk _00832_ _19213_ VPWR VGND sg13g2_dfrbpq_1
X_37769_ \csr_i.mtvec[1]\ clk _00833_ _19211_ VPWR VGND sg13g2_dfrbpq_1
X_37770_ \csr_i.mtvec[2]\ clk _00834_ _19209_ VPWR VGND sg13g2_dfrbpq_1
X_37771_ \csr_i.mtvec[3]\ clk _00835_ _19207_ VPWR VGND sg13g2_dfrbpq_1
X_37772_ \csr_i.mtvec[4]\ clk _00836_ _19205_ VPWR VGND sg13g2_dfrbpq_1
X_37773_ \csr_i.mtvec[5]\ clk _00837_ _19203_ VPWR VGND sg13g2_dfrbpq_1
X_37774_ \csr_i.mtvec[6]\ clk _00838_ _19201_ VPWR VGND sg13g2_dfrbpq_1
X_37775_ \csr_i.mtvec[7]\ clk _00839_ _19199_ VPWR VGND sg13g2_dfrbpq_1
X_37776_ \csr_i.mtvec[8]\ clk _00840_ _19197_ VPWR VGND sg13g2_dfrbpq_1
X_37777_ \csr_i.mtvec[9]\ clk _00841_ _19195_ VPWR VGND sg13g2_dfrbpq_1
X_37778_ \csr_i.mtvec[10]\ clk _00842_ _19193_ VPWR VGND sg13g2_dfrbpq_1
X_37779_ \csr_i.mtvec[11]\ clk _00843_ _19191_ VPWR VGND sg13g2_dfrbpq_1
X_37780_ \csr_i.mtvec[12]\ clk _00844_ _19189_ VPWR VGND sg13g2_dfrbpq_1
X_37781_ \csr_i.mtvec[13]\ clk _00845_ _19187_ VPWR VGND sg13g2_dfrbpq_1
X_37782_ \csr_i.mtvec[14]\ clk _00846_ _19185_ VPWR VGND sg13g2_dfrbpq_1
X_37783_ \csr_i.mtvec[15]\ clk _00847_ _19183_ VPWR VGND sg13g2_dfrbpq_1
X_37784_ \csr_i.mtvec[16]\ clk _00848_ _19181_ VPWR VGND sg13g2_dfrbpq_1
X_37785_ \csr_i.mtvec[17]\ clk _00849_ _19179_ VPWR VGND sg13g2_dfrbpq_1
X_37786_ \csr_i.mtvec[18]\ clk _00850_ _19177_ VPWR VGND sg13g2_dfrbpq_1
X_37787_ \csr_i.mtvec[19]\ clk _00851_ _19175_ VPWR VGND sg13g2_dfrbpq_1
X_37788_ \csr_i.mtvec[20]\ clk _00852_ _19173_ VPWR VGND sg13g2_dfrbpq_1
X_37789_ \csr_i.mtvec[21]\ clk _00853_ _19171_ VPWR VGND sg13g2_dfrbpq_1
X_37790_ \csr_i.mtvec[22]\ clk _00854_ _19169_ VPWR VGND sg13g2_dfrbpq_1
X_37791_ \csr_i.mtvec[23]\ clk _00855_ _19167_ VPWR VGND sg13g2_dfrbpq_1
X_37792_ \csr_i.mtvec[24]\ clk _00856_ _19165_ VPWR VGND sg13g2_dfrbpq_1
X_37793_ \csr_i.mtvec[25]\ clk _00857_ _19163_ VPWR VGND sg13g2_dfrbpq_1
X_37794_ \csr_i.mtvec[26]\ clk _00858_ _19161_ VPWR VGND sg13g2_dfrbpq_1
X_37795_ \csr_i.mtvec[27]\ clk _00859_ _19159_ VPWR VGND sg13g2_dfrbpq_1
X_37796_ \csr_i.mtvec[28]\ clk _00860_ _19157_ VPWR VGND sg13g2_dfrbpq_1
X_37797_ \csr_i.mtvec[29]\ clk _00861_ _19155_ VPWR VGND sg13g2_dfrbpq_1
X_37798_ \csr_i.mtvec[30]\ clk _00862_ _19153_ VPWR VGND sg13g2_dfrbpq_1
X_37799_ \csr_i.mtvec[31]\ clk _00863_ _19151_ VPWR VGND sg13g2_dfrbpq_1
X_37800_ \csr_i.isr_return[0]\ clk _00864_ _19149_ VPWR VGND sg13g2_dfrbpq_1
X_37801_ \csr_i.isr_return[1]\ clk _00865_ _19148_ VPWR VGND sg13g2_dfrbpq_1
X_37802_ \csr_i.isr_return[2]\ clk _00866_ _19147_ VPWR VGND sg13g2_dfrbpq_1
X_37803_ \csr_i.isr_return[3]\ clk _00867_ _19146_ VPWR VGND sg13g2_dfrbpq_1
X_37804_ \csr_i.isr_return[4]\ clk _00868_ _19145_ VPWR VGND sg13g2_dfrbpq_1
X_37805_ \csr_i.isr_return[5]\ clk _00869_ _19144_ VPWR VGND sg13g2_dfrbpq_1
X_37806_ \csr_i.isr_return[6]\ clk _00870_ _19143_ VPWR VGND sg13g2_dfrbpq_1
X_37807_ \csr_i.isr_return[7]\ clk _00871_ _19142_ VPWR VGND sg13g2_dfrbpq_1
X_37808_ \csr_i.isr_return[8]\ clk _00872_ _19141_ VPWR VGND sg13g2_dfrbpq_1
X_37809_ \csr_i.isr_return[9]\ clk _00873_ _19140_ VPWR VGND sg13g2_dfrbpq_1
X_37810_ \csr_i.isr_return[10]\ clk _00874_ _19139_ VPWR VGND sg13g2_dfrbpq_1
X_37811_ \csr_i.isr_return[11]\ clk _00875_ _19138_ VPWR VGND sg13g2_dfrbpq_1
X_37812_ \csr_i.isr_return[12]\ clk _00876_ _19137_ VPWR VGND sg13g2_dfrbpq_1
X_37813_ \csr_i.isr_return[13]\ clk _00877_ _19136_ VPWR VGND sg13g2_dfrbpq_1
X_37814_ \csr_i.isr_return[14]\ clk _00878_ _19135_ VPWR VGND sg13g2_dfrbpq_1
X_37815_ \csr_i.isr_return[15]\ clk _00879_ _19134_ VPWR VGND sg13g2_dfrbpq_1
X_37816_ \csr_i.isr_return[16]\ clk _00880_ _19133_ VPWR VGND sg13g2_dfrbpq_1
X_37817_ \csr_i.isr_return[17]\ clk _00881_ _19132_ VPWR VGND sg13g2_dfrbpq_1
X_37818_ \csr_i.isr_return[18]\ clk _00882_ _19131_ VPWR VGND sg13g2_dfrbpq_1
X_37819_ \csr_i.isr_return[19]\ clk _00883_ _19130_ VPWR VGND sg13g2_dfrbpq_1
X_37820_ \csr_i.isr_return[20]\ clk _00884_ _19129_ VPWR VGND sg13g2_dfrbpq_1
X_37821_ \csr_i.isr_return[21]\ clk _00885_ _19128_ VPWR VGND sg13g2_dfrbpq_1
X_37822_ \csr_i.isr_return[22]\ clk _00886_ _19127_ VPWR VGND sg13g2_dfrbpq_1
X_37823_ \csr_i.mepc[23]\ clk _00887_ _19126_ VPWR VGND sg13g2_dfrbpq_1
X_37824_ \csr_i.mepc[24]\ clk _00888_ _19125_ VPWR VGND sg13g2_dfrbpq_1
X_37825_ \csr_i.mepc[25]\ clk _00889_ _19124_ VPWR VGND sg13g2_dfrbpq_1
X_37826_ \csr_i.mepc[26]\ clk _00890_ _19123_ VPWR VGND sg13g2_dfrbpq_1
X_37827_ \csr_i.mepc[27]\ clk _00891_ _19122_ VPWR VGND sg13g2_dfrbpq_1
X_37828_ \csr_i.mepc[28]\ clk _00892_ _19121_ VPWR VGND sg13g2_dfrbpq_1
X_37829_ \csr_i.mepc[29]\ clk _00893_ _19120_ VPWR VGND sg13g2_dfrbpq_1
X_37830_ \csr_i.mepc[30]\ clk _00894_ _19119_ VPWR VGND sg13g2_dfrbpq_1
X_37831_ \csr_i.mepc[31]\ clk _00895_ _19118_ VPWR VGND sg13g2_dfrbpq_1
X_37832_ \csr_i.mcause[0]\ clk _00896_ _19117_ VPWR VGND sg13g2_dfrbpq_1
X_37833_ \csr_i.mcause[1]\ clk _00897_ _19115_ VPWR VGND sg13g2_dfrbpq_1
X_37834_ \csr_i.mcause[3]\ clk _00898_ _19113_ VPWR VGND sg13g2_dfrbpq_1
X_37835_ \csr_i.mcause[31]\ clk _00899_ _19111_ VPWR VGND sg13g2_dfrbpq_1
X_37836_ \csr_i.mcause[5]\ clk _00900_ _19109_ VPWR VGND sg13g2_dfrbpq_1
X_37837_ \csr_i.mcause[6]\ clk _00901_ _19107_ VPWR VGND sg13g2_dfrbpq_1
X_37838_ \csr_i.mcause[7]\ clk _00902_ _19105_ VPWR VGND sg13g2_dfrbpq_1
X_37839_ \csr_i.mcause[8]\ clk _00903_ _19103_ VPWR VGND sg13g2_dfrbpq_1
X_37840_ \csr_i.mcause[9]\ clk _00904_ _19101_ VPWR VGND sg13g2_dfrbpq_1
X_37841_ \csr_i.mcause[10]\ clk _00905_ _19099_ VPWR VGND sg13g2_dfrbpq_1
X_37842_ \csr_i.mcause[11]\ clk _00906_ _19097_ VPWR VGND sg13g2_dfrbpq_1
X_37843_ \csr_i.mcause[12]\ clk _00907_ _19095_ VPWR VGND sg13g2_dfrbpq_1
X_37844_ \csr_i.mcause[13]\ clk _00908_ _19093_ VPWR VGND sg13g2_dfrbpq_1
X_37845_ \csr_i.mcause[14]\ clk _00909_ _19091_ VPWR VGND sg13g2_dfrbpq_1
X_37846_ \csr_i.mcause[15]\ clk _00910_ _19089_ VPWR VGND sg13g2_dfrbpq_1
X_37847_ \csr_i.mcause[16]\ clk _00911_ _19087_ VPWR VGND sg13g2_dfrbpq_1
X_37848_ \csr_i.mcause[17]\ clk _00912_ _19085_ VPWR VGND sg13g2_dfrbpq_1
X_37849_ \csr_i.mcause[18]\ clk _00913_ _19083_ VPWR VGND sg13g2_dfrbpq_1
X_37850_ \csr_i.mcause[19]\ clk _00914_ _19081_ VPWR VGND sg13g2_dfrbpq_1
X_37851_ \csr_i.mcause[20]\ clk _00915_ _19079_ VPWR VGND sg13g2_dfrbpq_1
X_37852_ \csr_i.mcause[21]\ clk _00916_ _19077_ VPWR VGND sg13g2_dfrbpq_1
X_37853_ \csr_i.mcause[22]\ clk _00917_ _19075_ VPWR VGND sg13g2_dfrbpq_1
X_37854_ \csr_i.mcause[23]\ clk _00918_ _19073_ VPWR VGND sg13g2_dfrbpq_1
X_37855_ \csr_i.mcause[24]\ clk _00919_ _19071_ VPWR VGND sg13g2_dfrbpq_1
X_37856_ \csr_i.mcause[25]\ clk _00920_ _19069_ VPWR VGND sg13g2_dfrbpq_1
X_37857_ \csr_i.mcause[26]\ clk _00921_ _19067_ VPWR VGND sg13g2_dfrbpq_1
X_37858_ \csr_i.mcause[27]\ clk _00922_ _19065_ VPWR VGND sg13g2_dfrbpq_1
X_37859_ \csr_i.mcause[28]\ clk _00923_ _19063_ VPWR VGND sg13g2_dfrbpq_1
X_37860_ \csr_i.mcause[29]\ clk _00924_ _19061_ VPWR VGND sg13g2_dfrbpq_1
X_37861_ \csr_i.mcause[30]\ clk _00925_ _19059_ VPWR VGND sg13g2_dfrbpq_1
X_37862_ \csr_i.mcause[2]\ clk _00926_ _19057_ VPWR VGND sg13g2_dfrbpq_1
X_37863_ \csr_i.mcause[4]\ clk _00927_ _19055_ VPWR VGND sg13g2_dfrbpq_1
X_37864_ \csr_i.mip[7]\ clk _00928_ _19053_ VPWR VGND sg13g2_dfrbpq_1
X_37865_ \csr_i.mip[11]\ clk _00929_ _19052_ VPWR VGND sg13g2_dfrbpq_1
X_37866_ \csr_i.mip[16]\ clk _00930_ _19051_ VPWR VGND sg13g2_dfrbpq_1
X_37867_ \csr_i.mip[0]\ clk _00931_ _19050_ VPWR VGND sg13g2_dfrbpq_1
X_37868_ \csr_i.mip[1]\ clk _00932_ _19048_ VPWR VGND sg13g2_dfrbpq_1
X_37869_ \csr_i.mip[2]\ clk _00933_ _19046_ VPWR VGND sg13g2_dfrbpq_1
X_37870_ \csr_i.mip[3]\ clk _00934_ _19044_ VPWR VGND sg13g2_dfrbpq_1
X_37871_ \csr_i.mip[4]\ clk _00935_ _19042_ VPWR VGND sg13g2_dfrbpq_1
X_37872_ \csr_i.mip[5]\ clk _00936_ _19040_ VPWR VGND sg13g2_dfrbpq_1
X_37873_ \csr_i.mip[6]\ clk _00937_ _19038_ VPWR VGND sg13g2_dfrbpq_1
X_37874_ \csr_i.mip[8]\ clk _00938_ _19036_ VPWR VGND sg13g2_dfrbpq_1
X_37875_ \csr_i.mip[9]\ clk _00939_ _19034_ VPWR VGND sg13g2_dfrbpq_1
X_37876_ \csr_i.mip[10]\ clk _00940_ _19032_ VPWR VGND sg13g2_dfrbpq_1
X_37877_ \csr_i.mip[12]\ clk _00941_ _19030_ VPWR VGND sg13g2_dfrbpq_1
X_37878_ \csr_i.mip[13]\ clk _00942_ _19028_ VPWR VGND sg13g2_dfrbpq_1
X_37879_ \csr_i.mip[14]\ clk _00943_ _19026_ VPWR VGND sg13g2_dfrbpq_1
X_37880_ \csr_i.mip[15]\ clk _00944_ _19024_ VPWR VGND sg13g2_dfrbpq_1
X_37881_ \csr_i.mip[17]\ clk _00945_ _19022_ VPWR VGND sg13g2_dfrbpq_1
X_37882_ \csr_i.mip[18]\ clk _00946_ _19020_ VPWR VGND sg13g2_dfrbpq_1
X_37883_ \csr_i.mip[19]\ clk _00947_ _19018_ VPWR VGND sg13g2_dfrbpq_1
X_37884_ \csr_i.mip[20]\ clk _00948_ _19016_ VPWR VGND sg13g2_dfrbpq_1
X_37885_ \csr_i.mip[21]\ clk _00949_ _19014_ VPWR VGND sg13g2_dfrbpq_1
X_37886_ \csr_i.mip[22]\ clk _00950_ _19012_ VPWR VGND sg13g2_dfrbpq_1
X_37887_ \csr_i.mip[23]\ clk _00951_ _19010_ VPWR VGND sg13g2_dfrbpq_1
X_37888_ \csr_i.mip[24]\ clk _00952_ _19008_ VPWR VGND sg13g2_dfrbpq_1
X_37889_ \csr_i.mip[25]\ clk _00953_ _19006_ VPWR VGND sg13g2_dfrbpq_1
X_37890_ \csr_i.mip[26]\ clk _00954_ _19004_ VPWR VGND sg13g2_dfrbpq_1
X_37891_ \csr_i.mip[27]\ clk _00955_ _19002_ VPWR VGND sg13g2_dfrbpq_1
X_37892_ \csr_i.mip[28]\ clk _00956_ _19000_ VPWR VGND sg13g2_dfrbpq_1
X_37893_ \csr_i.mip[29]\ clk _00957_ _18998_ VPWR VGND sg13g2_dfrbpq_1
X_37894_ \csr_i.mip[30]\ clk _00958_ _18996_ VPWR VGND sg13g2_dfrbpq_1
X_37895_ \csr_i.mip[31]\ clk _00959_ _18994_ VPWR VGND sg13g2_dfrbpq_1
X_37896_ gpio_out[0] clk _00960_ _18992_ VPWR VGND sg13g2_dfrbpq_1
X_37897_ gpio_out[1] clk _00961_ _18990_ VPWR VGND sg13g2_dfrbpq_1
X_37898_ gpio_out[2] clk _00962_ _18988_ VPWR VGND sg13g2_dfrbpq_1
X_37899_ gpio_out[3] clk _00963_ _18986_ VPWR VGND sg13g2_dfrbpq_1
X_37900_ \mem_dataout[0]\ clk _00964_ _18984_ VPWR VGND sg13g2_dfrbpq_1
X_37901_ \mem_dataout[1]\ clk _00965_ _18983_ VPWR VGND sg13g2_dfrbpq_1
X_37902_ \mem_dataout[2]\ clk _00966_ _18982_ VPWR VGND sg13g2_dfrbpq_1
X_37903_ \mem_dataout[3]\ clk _00967_ _18981_ VPWR VGND sg13g2_dfrbpq_1
X_37904_ \memory_i.addr_reg[0]\ clk _00968_ _18980_ VPWR VGND sg13g2_dfrbpq_1
X_37905_ \memory_i.addr_reg[1]\ clk _00969_ _18979_ VPWR VGND sg13g2_dfrbpq_1
X_37906_ \memory_i.addr_reg[2]\ clk _00970_ _18978_ VPWR VGND sg13g2_dfrbpq_1
X_37907_ \memory_i.addr_reg[3]\ clk _00971_ _18977_ VPWR VGND sg13g2_dfrbpq_1
X_37908_ \memory_i.addr_reg[4]\ clk _00972_ _18976_ VPWR VGND sg13g2_dfrbpq_1
X_37909_ \memory_i.addr_reg[5]\ clk _00973_ _18975_ VPWR VGND sg13g2_dfrbpq_1
X_37910_ \memory_i.addr_reg[6]\ clk _00974_ _18974_ VPWR VGND sg13g2_dfrbpq_1
X_37911_ \memory_i.addr_reg[7]\ clk _00975_ _18973_ VPWR VGND sg13g2_dfrbpq_1
X_37912_ \memory_i.addr_reg[8]\ clk _00976_ _18972_ VPWR VGND sg13g2_dfrbpq_1
X_37913_ \memory_i.addr_reg[9]\ clk _00977_ _18971_ VPWR VGND sg13g2_dfrbpq_1
X_37914_ \memory_i.addr_reg[10]\ clk _00978_ _18970_ VPWR VGND sg13g2_dfrbpq_1
X_37915_ \memory_i.addr_reg[11]\ clk _00979_ _18969_ VPWR VGND sg13g2_dfrbpq_1
X_37916_ \memory_i.addr_reg[12]\ clk _00980_ _18968_ VPWR VGND sg13g2_dfrbpq_1
X_37917_ \memory_i.addr_reg[13]\ clk _00981_ _18967_ VPWR VGND sg13g2_dfrbpq_1
X_37918_ \memory_i.addr_reg[14]\ clk _00982_ _18966_ VPWR VGND sg13g2_dfrbpq_1
X_37919_ \memory_i.addr_reg[15]\ clk _00983_ _18965_ VPWR VGND sg13g2_dfrbpq_1
X_37920_ \memory_i.addr_reg[16]\ clk _00984_ _18964_ VPWR VGND sg13g2_dfrbpq_1
X_37921_ \memory_i.addr_reg[17]\ clk _00985_ _18963_ VPWR VGND sg13g2_dfrbpq_1
X_37922_ \memory_i.addr_reg[18]\ clk _00986_ _18962_ VPWR VGND sg13g2_dfrbpq_1
X_37923_ \memory_i.addr_reg[19]\ clk _00987_ _18961_ VPWR VGND sg13g2_dfrbpq_1
X_37924_ \memory_i.addr_reg[20]\ clk _00988_ _18960_ VPWR VGND sg13g2_dfrbpq_1
X_37925_ \memory_i.addr_reg[21]\ clk _00989_ _18959_ VPWR VGND sg13g2_dfrbpq_1
X_37926_ \memory_i.addr_reg[22]\ clk _00990_ _18958_ VPWR VGND sg13g2_dfrbpq_1
X_37927_ \memory_i.addr_reg[23]\ clk _00991_ _18957_ VPWR VGND sg13g2_dfrbpq_1
X_37928_ \memory_i.addr_reg[24]\ clk _00992_ _18956_ VPWR VGND sg13g2_dfrbpq_1
X_37929_ \memory_i.addr_reg[25]\ clk _00993_ _18955_ VPWR VGND sg13g2_dfrbpq_1
X_37930_ \memory_i.addr_reg[26]\ clk _00994_ _18954_ VPWR VGND sg13g2_dfrbpq_1
X_37931_ \memory_i.addr_reg[27]\ clk _00995_ _18953_ VPWR VGND sg13g2_dfrbpq_1
X_37932_ \memory_i.addr_reg[28]\ clk _00996_ _18952_ VPWR VGND sg13g2_dfrbpq_1
X_37933_ \memory_i.addr_reg[29]\ clk _00997_ _18951_ VPWR VGND sg13g2_dfrbpq_1
X_37934_ \memory_i.addr_reg[30]\ clk _00998_ _18950_ VPWR VGND sg13g2_dfrbpq_1
X_37935_ \memory_i.addr_reg[31]\ clk _00999_ _18949_ VPWR VGND sg13g2_dfrbpq_1
X_37936_ \memory_i.mtime[0]\ clk _01000_ _18948_ VPWR VGND sg13g2_dfrbpq_1
X_37937_ \memory_i.mtime[1]\ clk _01001_ _18947_ VPWR VGND sg13g2_dfrbpq_1
X_37938_ \memory_i.mtime[2]\ clk _01002_ _18946_ VPWR VGND sg13g2_dfrbpq_1
X_37939_ \memory_i.mtime[3]\ clk _01003_ _18945_ VPWR VGND sg13g2_dfrbpq_1
X_37940_ \memory_i.mtime[4]\ clk _01004_ _18944_ VPWR VGND sg13g2_dfrbpq_1
X_37941_ \memory_i.mtime[5]\ clk _01005_ _18943_ VPWR VGND sg13g2_dfrbpq_1
X_37942_ \memory_i.mtime[6]\ clk _01006_ _18942_ VPWR VGND sg13g2_dfrbpq_1
X_37943_ \memory_i.mtime[7]\ clk _01007_ _18941_ VPWR VGND sg13g2_dfrbpq_1
X_37944_ \memory_i.mtime[8]\ clk _01008_ _18940_ VPWR VGND sg13g2_dfrbpq_1
X_37945_ \memory_i.mtime[9]\ clk _01009_ _18939_ VPWR VGND sg13g2_dfrbpq_1
X_37946_ \memory_i.mtime[10]\ clk _01010_ _18938_ VPWR VGND sg13g2_dfrbpq_1
X_37947_ \memory_i.mtime[11]\ clk _01011_ _18937_ VPWR VGND sg13g2_dfrbpq_1
X_37948_ \memory_i.mtime[12]\ clk _01012_ _18936_ VPWR VGND sg13g2_dfrbpq_1
X_37949_ \memory_i.mtime[13]\ clk _01013_ _18935_ VPWR VGND sg13g2_dfrbpq_1
X_37950_ \memory_i.mtime[14]\ clk _01014_ _18934_ VPWR VGND sg13g2_dfrbpq_1
X_37951_ \memory_i.mtime[15]\ clk _01015_ _18933_ VPWR VGND sg13g2_dfrbpq_1
X_37952_ \memory_i.mtime[16]\ clk _01016_ _18932_ VPWR VGND sg13g2_dfrbpq_1
X_37953_ \memory_i.mtime[17]\ clk _01017_ _18931_ VPWR VGND sg13g2_dfrbpq_1
X_37954_ \memory_i.mtime[18]\ clk _01018_ _18930_ VPWR VGND sg13g2_dfrbpq_1
X_37955_ \memory_i.mtime[19]\ clk _01019_ _18929_ VPWR VGND sg13g2_dfrbpq_1
X_37956_ \memory_i.mtime[20]\ clk _01020_ _18928_ VPWR VGND sg13g2_dfrbpq_1
X_37957_ \memory_i.mtime[21]\ clk _01021_ _18927_ VPWR VGND sg13g2_dfrbpq_1
X_37958_ \memory_i.mtime[22]\ clk _01022_ _18926_ VPWR VGND sg13g2_dfrbpq_1
X_37959_ \memory_i.mtime[23]\ clk _01023_ _18925_ VPWR VGND sg13g2_dfrbpq_1
X_37960_ \memory_i.mtime[24]\ clk _01024_ _18924_ VPWR VGND sg13g2_dfrbpq_1
X_37961_ \memory_i.mtime[25]\ clk _01025_ _18923_ VPWR VGND sg13g2_dfrbpq_1
X_37962_ \memory_i.mtime[26]\ clk _01026_ _18922_ VPWR VGND sg13g2_dfrbpq_1
X_37963_ \memory_i.mtime[27]\ clk _01027_ _18921_ VPWR VGND sg13g2_dfrbpq_1
X_37964_ \memory_i.mtime[28]\ clk _01028_ _18920_ VPWR VGND sg13g2_dfrbpq_1
X_37965_ \memory_i.mtime[29]\ clk _01029_ _18919_ VPWR VGND sg13g2_dfrbpq_1
X_37966_ \memory_i.mtime[30]\ clk _01030_ _18918_ VPWR VGND sg13g2_dfrbpq_1
X_37967_ \memory_i.mtime[31]\ clk _01031_ _18917_ VPWR VGND sg13g2_dfrbpq_1
X_37968_ \memory_i.mtime[32]\ clk _01032_ _18916_ VPWR VGND sg13g2_dfrbpq_1
X_37969_ \memory_i.mtime[33]\ clk _01033_ _18915_ VPWR VGND sg13g2_dfrbpq_1
X_37970_ \memory_i.mtime[34]\ clk _01034_ _18914_ VPWR VGND sg13g2_dfrbpq_1
X_37971_ \memory_i.mtime[35]\ clk _01035_ _18913_ VPWR VGND sg13g2_dfrbpq_1
X_37972_ \memory_i.mtime[36]\ clk _01036_ _18912_ VPWR VGND sg13g2_dfrbpq_1
X_37973_ \memory_i.mtime[37]\ clk _01037_ _18911_ VPWR VGND sg13g2_dfrbpq_1
X_37974_ \memory_i.mtime[38]\ clk _01038_ _18910_ VPWR VGND sg13g2_dfrbpq_1
X_37975_ \memory_i.mtime[39]\ clk _01039_ _18909_ VPWR VGND sg13g2_dfrbpq_1
X_37976_ \memory_i.mtime[40]\ clk _01040_ _18908_ VPWR VGND sg13g2_dfrbpq_1
X_37977_ \memory_i.mtime[41]\ clk _01041_ _18907_ VPWR VGND sg13g2_dfrbpq_1
X_37978_ \memory_i.mtime[42]\ clk _01042_ _18906_ VPWR VGND sg13g2_dfrbpq_1
X_37979_ \memory_i.mtime[43]\ clk _01043_ _18905_ VPWR VGND sg13g2_dfrbpq_1
X_37980_ \memory_i.mtime[44]\ clk _01044_ _18904_ VPWR VGND sg13g2_dfrbpq_1
X_37981_ \memory_i.mtime[45]\ clk _01045_ _18903_ VPWR VGND sg13g2_dfrbpq_1
X_37982_ \memory_i.mtime[46]\ clk _01046_ _18902_ VPWR VGND sg13g2_dfrbpq_1
X_37983_ \memory_i.mtime[47]\ clk _01047_ _18901_ VPWR VGND sg13g2_dfrbpq_1
X_37984_ \memory_i.mtime[48]\ clk _01048_ _18900_ VPWR VGND sg13g2_dfrbpq_1
X_37985_ \memory_i.mtime[49]\ clk _01049_ _18899_ VPWR VGND sg13g2_dfrbpq_1
X_37986_ \memory_i.mtime[50]\ clk _01050_ _18898_ VPWR VGND sg13g2_dfrbpq_1
X_37987_ \memory_i.mtime[51]\ clk _01051_ _18897_ VPWR VGND sg13g2_dfrbpq_1
X_37988_ \memory_i.mtime[52]\ clk _01052_ _18896_ VPWR VGND sg13g2_dfrbpq_1
X_37989_ \memory_i.mtime[53]\ clk _01053_ _18895_ VPWR VGND sg13g2_dfrbpq_1
X_37990_ \memory_i.mtime[54]\ clk _01054_ _18894_ VPWR VGND sg13g2_dfrbpq_1
X_37991_ \memory_i.mtime[55]\ clk _01055_ _18893_ VPWR VGND sg13g2_dfrbpq_1
X_37992_ \memory_i.mtime[56]\ clk _01056_ _18892_ VPWR VGND sg13g2_dfrbpq_1
X_37993_ \memory_i.mtime[57]\ clk _01057_ _18891_ VPWR VGND sg13g2_dfrbpq_1
X_37994_ \memory_i.mtime[58]\ clk _01058_ _18890_ VPWR VGND sg13g2_dfrbpq_1
X_37995_ \memory_i.mtime[59]\ clk _01059_ _18889_ VPWR VGND sg13g2_dfrbpq_1
X_37996_ \memory_i.mtime[60]\ clk _01060_ _18888_ VPWR VGND sg13g2_dfrbpq_1
X_37997_ \memory_i.mtime[61]\ clk _01061_ _18887_ VPWR VGND sg13g2_dfrbpq_1
X_37998_ \memory_i.mtime[62]\ clk _01062_ _18886_ VPWR VGND sg13g2_dfrbpq_1
X_37999_ \memory_i.mtime[63]\ clk _01063_ _18885_ VPWR VGND sg13g2_dfrbpq_1
X_38000_ \memory_i.mtimecmp[0]\ clk _01064_ _18884_ VPWR VGND sg13g2_dfrbpq_1
X_38001_ \memory_i.mtimecmp[1]\ clk _01065_ _18882_ VPWR VGND sg13g2_dfrbpq_1
X_38002_ \memory_i.mtimecmp[2]\ clk _01066_ _18880_ VPWR VGND sg13g2_dfrbpq_1
X_38003_ \memory_i.mtimecmp[3]\ clk _01067_ _18878_ VPWR VGND sg13g2_dfrbpq_1
X_38004_ \memory_i.mtimecmp[4]\ clk _01068_ _18876_ VPWR VGND sg13g2_dfrbpq_1
X_38005_ \memory_i.mtimecmp[5]\ clk _01069_ _18874_ VPWR VGND sg13g2_dfrbpq_1
X_38006_ \memory_i.mtimecmp[6]\ clk _01070_ _18872_ VPWR VGND sg13g2_dfrbpq_1
X_38007_ \memory_i.mtimecmp[7]\ clk _01071_ _18870_ VPWR VGND sg13g2_dfrbpq_1
X_38008_ \memory_i.mtimecmp[8]\ clk _01072_ _18868_ VPWR VGND sg13g2_dfrbpq_1
X_38009_ \memory_i.mtimecmp[9]\ clk _01073_ _18866_ VPWR VGND sg13g2_dfrbpq_1
X_38010_ \memory_i.mtimecmp[10]\ clk _01074_ _18864_ VPWR VGND sg13g2_dfrbpq_1
X_38011_ \memory_i.mtimecmp[11]\ clk _01075_ _18862_ VPWR VGND sg13g2_dfrbpq_1
X_38012_ \memory_i.mtimecmp[12]\ clk _01076_ _18860_ VPWR VGND sg13g2_dfrbpq_1
X_38013_ \memory_i.mtimecmp[13]\ clk _01077_ _18858_ VPWR VGND sg13g2_dfrbpq_1
X_38014_ \memory_i.mtimecmp[14]\ clk _01078_ _18856_ VPWR VGND sg13g2_dfrbpq_1
X_38015_ \memory_i.mtimecmp[15]\ clk _01079_ _18854_ VPWR VGND sg13g2_dfrbpq_1
X_38016_ \memory_i.mtimecmp[16]\ clk _01080_ _18852_ VPWR VGND sg13g2_dfrbpq_1
X_38017_ \memory_i.mtimecmp[17]\ clk _01081_ _18850_ VPWR VGND sg13g2_dfrbpq_1
X_38018_ \memory_i.mtimecmp[18]\ clk _01082_ _18848_ VPWR VGND sg13g2_dfrbpq_1
X_38019_ \memory_i.mtimecmp[19]\ clk _01083_ _18846_ VPWR VGND sg13g2_dfrbpq_1
X_38020_ \memory_i.mtimecmp[20]\ clk _01084_ _18844_ VPWR VGND sg13g2_dfrbpq_1
X_38021_ \memory_i.mtimecmp[21]\ clk _01085_ _18842_ VPWR VGND sg13g2_dfrbpq_1
X_38022_ \memory_i.mtimecmp[22]\ clk _01086_ _18840_ VPWR VGND sg13g2_dfrbpq_1
X_38023_ \memory_i.mtimecmp[23]\ clk _01087_ _18838_ VPWR VGND sg13g2_dfrbpq_1
X_38024_ \memory_i.mtimecmp[24]\ clk _01088_ _18836_ VPWR VGND sg13g2_dfrbpq_1
X_38025_ \memory_i.mtimecmp[25]\ clk _01089_ _18834_ VPWR VGND sg13g2_dfrbpq_1
X_38026_ \memory_i.mtimecmp[26]\ clk _01090_ _18832_ VPWR VGND sg13g2_dfrbpq_1
X_38027_ \memory_i.mtimecmp[27]\ clk _01091_ _18830_ VPWR VGND sg13g2_dfrbpq_1
X_38028_ \memory_i.mtimecmp[28]\ clk _01092_ _18828_ VPWR VGND sg13g2_dfrbpq_1
X_38029_ \memory_i.mtimecmp[29]\ clk _01093_ _18826_ VPWR VGND sg13g2_dfrbpq_1
X_38030_ \memory_i.mtimecmp[30]\ clk _01094_ _18824_ VPWR VGND sg13g2_dfrbpq_1
X_38031_ \memory_i.mtimecmp[31]\ clk _01095_ _18822_ VPWR VGND sg13g2_dfrbpq_1
X_38032_ \memory_i.mtimecmp[32]\ clk _01096_ _18820_ VPWR VGND sg13g2_dfrbpq_1
X_38033_ \memory_i.mtimecmp[33]\ clk _01097_ _18818_ VPWR VGND sg13g2_dfrbpq_1
X_38034_ \memory_i.mtimecmp[34]\ clk _01098_ _18816_ VPWR VGND sg13g2_dfrbpq_1
X_38035_ \memory_i.mtimecmp[35]\ clk _01099_ _18814_ VPWR VGND sg13g2_dfrbpq_1
X_38036_ \memory_i.mtimecmp[36]\ clk _01100_ _18812_ VPWR VGND sg13g2_dfrbpq_1
X_38037_ \memory_i.mtimecmp[37]\ clk _01101_ _18810_ VPWR VGND sg13g2_dfrbpq_1
X_38038_ \memory_i.mtimecmp[38]\ clk _01102_ _18808_ VPWR VGND sg13g2_dfrbpq_1
X_38039_ \memory_i.mtimecmp[39]\ clk _01103_ _18806_ VPWR VGND sg13g2_dfrbpq_1
X_38040_ \memory_i.mtimecmp[40]\ clk _01104_ _18804_ VPWR VGND sg13g2_dfrbpq_1
X_38041_ \memory_i.mtimecmp[41]\ clk _01105_ _18802_ VPWR VGND sg13g2_dfrbpq_1
X_38042_ \memory_i.mtimecmp[42]\ clk _01106_ _18800_ VPWR VGND sg13g2_dfrbpq_1
X_38043_ \memory_i.mtimecmp[43]\ clk _01107_ _18798_ VPWR VGND sg13g2_dfrbpq_1
X_38044_ \memory_i.mtimecmp[44]\ clk _01108_ _18796_ VPWR VGND sg13g2_dfrbpq_1
X_38045_ \memory_i.mtimecmp[45]\ clk _01109_ _18794_ VPWR VGND sg13g2_dfrbpq_1
X_38046_ \memory_i.mtimecmp[46]\ clk _01110_ _18792_ VPWR VGND sg13g2_dfrbpq_1
X_38047_ \memory_i.mtimecmp[47]\ clk _01111_ _18790_ VPWR VGND sg13g2_dfrbpq_1
X_38048_ \memory_i.mtimecmp[48]\ clk _01112_ _18788_ VPWR VGND sg13g2_dfrbpq_1
X_38049_ \memory_i.mtimecmp[49]\ clk _01113_ _18786_ VPWR VGND sg13g2_dfrbpq_1
X_38050_ \memory_i.mtimecmp[50]\ clk _01114_ _18784_ VPWR VGND sg13g2_dfrbpq_1
X_38051_ \memory_i.mtimecmp[51]\ clk _01115_ _18782_ VPWR VGND sg13g2_dfrbpq_1
X_38052_ \memory_i.mtimecmp[52]\ clk _01116_ _18780_ VPWR VGND sg13g2_dfrbpq_1
X_38053_ \memory_i.mtimecmp[53]\ clk _01117_ _18778_ VPWR VGND sg13g2_dfrbpq_1
X_38054_ \memory_i.mtimecmp[54]\ clk _01118_ _18776_ VPWR VGND sg13g2_dfrbpq_1
X_38055_ \memory_i.mtimecmp[55]\ clk _01119_ _18774_ VPWR VGND sg13g2_dfrbpq_1
X_38056_ \memory_i.mtimecmp[56]\ clk _01120_ _18772_ VPWR VGND sg13g2_dfrbpq_1
X_38057_ \memory_i.mtimecmp[57]\ clk _01121_ _18770_ VPWR VGND sg13g2_dfrbpq_1
X_38058_ \memory_i.mtimecmp[58]\ clk _01122_ _18768_ VPWR VGND sg13g2_dfrbpq_1
X_38059_ \memory_i.mtimecmp[59]\ clk _01123_ _18766_ VPWR VGND sg13g2_dfrbpq_1
X_38060_ \memory_i.mtimecmp[60]\ clk _01124_ _18764_ VPWR VGND sg13g2_dfrbpq_1
X_38061_ \memory_i.mtimecmp[61]\ clk _01125_ _18762_ VPWR VGND sg13g2_dfrbpq_1
X_38062_ \memory_i.mtimecmp[62]\ clk _01126_ _18760_ VPWR VGND sg13g2_dfrbpq_1
X_38063_ \memory_i.mtimecmp[63]\ clk _01127_ _18758_ VPWR VGND sg13g2_dfrbpq_1
X_38064_ \memory_i.datain_reg[0]\ clk _01128_ _18756_ VPWR VGND sg13g2_dfrbpq_1
X_38065_ \memory_i.datain_reg[1]\ clk _01129_ _18755_ VPWR VGND sg13g2_dfrbpq_1
X_38066_ \memory_i.datain_reg[2]\ clk _01130_ _18754_ VPWR VGND sg13g2_dfrbpq_1
X_38067_ \memory_i.datain_reg[3]\ clk _01131_ _18753_ VPWR VGND sg13g2_dfrbpq_1
X_38068_ \memory_i.datain_reg[4]\ clk _01132_ _18752_ VPWR VGND sg13g2_dfrbpq_1
X_38069_ \memory_i.datain_reg[5]\ clk _01133_ _18751_ VPWR VGND sg13g2_dfrbpq_1
X_38070_ \memory_i.datain_reg[6]\ clk _01134_ _18750_ VPWR VGND sg13g2_dfrbpq_1
X_38071_ \memory_i.datain_reg[7]\ clk _01135_ _18749_ VPWR VGND sg13g2_dfrbpq_1
X_38072_ \memory_i.datain_reg[8]\ clk _01136_ _18748_ VPWR VGND sg13g2_dfrbpq_1
X_38073_ \memory_i.datain_reg[9]\ clk _01137_ _18747_ VPWR VGND sg13g2_dfrbpq_1
X_38074_ \memory_i.datain_reg[10]\ clk _01138_ _18746_ VPWR VGND sg13g2_dfrbpq_1
X_38075_ \memory_i.datain_reg[11]\ clk _01139_ _18745_ VPWR VGND sg13g2_dfrbpq_1
X_38076_ \memory_i.datain_reg[12]\ clk _01140_ _18744_ VPWR VGND sg13g2_dfrbpq_1
X_38077_ \memory_i.datain_reg[13]\ clk _01141_ _18743_ VPWR VGND sg13g2_dfrbpq_1
X_38078_ \memory_i.datain_reg[14]\ clk _01142_ _18742_ VPWR VGND sg13g2_dfrbpq_1
X_38079_ \memory_i.datain_reg[15]\ clk _01143_ _18741_ VPWR VGND sg13g2_dfrbpq_1
X_38080_ \memory_i.datain_reg[16]\ clk _01144_ _18740_ VPWR VGND sg13g2_dfrbpq_1
X_38081_ \memory_i.datain_reg[17]\ clk _01145_ _18739_ VPWR VGND sg13g2_dfrbpq_1
X_38082_ \memory_i.datain_reg[18]\ clk _01146_ _18738_ VPWR VGND sg13g2_dfrbpq_1
X_38083_ \memory_i.datain_reg[19]\ clk _01147_ _18737_ VPWR VGND sg13g2_dfrbpq_1
X_38084_ \memory_i.datain_reg[20]\ clk _01148_ _18736_ VPWR VGND sg13g2_dfrbpq_1
X_38085_ \memory_i.datain_reg[21]\ clk _01149_ _18735_ VPWR VGND sg13g2_dfrbpq_1
X_38086_ \memory_i.datain_reg[22]\ clk _01150_ _18734_ VPWR VGND sg13g2_dfrbpq_1
X_38087_ \memory_i.datain_reg[23]\ clk _01151_ _18733_ VPWR VGND sg13g2_dfrbpq_1
X_38088_ \memory_i.datain_reg[24]\ clk _01152_ _18732_ VPWR VGND sg13g2_dfrbpq_1
X_38089_ \memory_i.datain_reg[25]\ clk _01153_ _18731_ VPWR VGND sg13g2_dfrbpq_1
X_38090_ \memory_i.datain_reg[26]\ clk _01154_ _18730_ VPWR VGND sg13g2_dfrbpq_1
X_38091_ \memory_i.datain_reg[27]\ clk _01155_ _18729_ VPWR VGND sg13g2_dfrbpq_1
X_38092_ \memory_i.datain_reg[28]\ clk _01156_ _18728_ VPWR VGND sg13g2_dfrbpq_1
X_38093_ \memory_i.datain_reg[29]\ clk _01157_ _18727_ VPWR VGND sg13g2_dfrbpq_1
X_38094_ \memory_i.datain_reg[30]\ clk _01158_ _18726_ VPWR VGND sg13g2_dfrbpq_1
X_38095_ \memory_i.datain_reg[31]\ clk _01159_ _18725_ VPWR VGND sg13g2_dfrbpq_1
X_38096_ \memory_i.i2c_master.write\ clk _01160_ _18724_ VPWR VGND sg13g2_dfrbpq_1
X_38097_ \memory_i.i2c_addr[0]\ clk _01161_ _18723_ VPWR VGND sg13g2_dfrbpq_1
X_38098_ \memory_i.i2c_addr[1]\ clk _01162_ _18721_ VPWR VGND sg13g2_dfrbpq_1
X_38099_ \memory_i.i2c_addr[2]\ clk _01163_ _18719_ VPWR VGND sg13g2_dfrbpq_1
X_38100_ \memory_i.i2c_addr[3]\ clk _01164_ _18717_ VPWR VGND sg13g2_dfrbpq_1
X_38101_ \memory_i.i2c_addr[4]\ clk _01165_ _18715_ VPWR VGND sg13g2_dfrbpq_1
X_38102_ \memory_i.i2c_addr[5]\ clk _01166_ _18713_ VPWR VGND sg13g2_dfrbpq_1
X_38103_ \memory_i.i2c_addr[6]\ clk _01167_ _18711_ VPWR VGND sg13g2_dfrbpq_1
X_38104_ \memory_i.i2c_mask[0]\ clk _01168_ _18709_ VPWR VGND sg13g2_dfrbpq_1
X_38105_ \memory_i.i2c_mask[1]\ clk _01169_ _18707_ VPWR VGND sg13g2_dfrbpq_1
X_38106_ \memory_i.i2c_mask[2]\ clk _01170_ _18705_ VPWR VGND sg13g2_dfrbpq_1
X_38107_ \memory_i.i2c_mask[3]\ clk _01171_ _18703_ VPWR VGND sg13g2_dfrbpq_1
X_38108_ \csr_i.intr_ext_sync\ clk _01172_ _18701_ VPWR VGND sg13g2_dfrbpq_1
X_38109_ \memory_i.gpio_in_sync[1]\ clk _01173_ _18700_ VPWR VGND sg13g2_dfrbpq_1
X_38110_ \memory_i.gpio_in_sync[2]\ clk _01174_ _18699_ VPWR VGND sg13g2_dfrbpq_1
X_38111_ \memory_i.gpio_in_sync[3]\ clk _01175_ _18698_ VPWR VGND sg13g2_dfrbpq_1
X_38112_ \memory_i.sclk_flag\ clk _01176_ _18697_ VPWR VGND sg13g2_dfrbpq_1
X_38113_ \memory_i.i2c_master.scl_ratio[0]\ clk _01177_ _18695_ VPWR VGND sg13g2_dfrbpq_1
X_38114_ \memory_i.i2c_master.scl_ratio[1]\ clk _01178_ _18693_ VPWR VGND sg13g2_dfrbpq_1
X_38115_ \memory_i.i2c_master.scl_ratio[2]\ clk _01179_ _18691_ VPWR VGND sg13g2_dfrbpq_1
X_38116_ \memory_i.i2c_master.scl_ratio[3]\ clk _01180_ _18689_ VPWR VGND sg13g2_dfrbpq_1
X_38117_ \memory_i.i2c_master.scl_ratio[4]\ clk _01181_ _18687_ VPWR VGND sg13g2_dfrbpq_1
X_38118_ \memory_i.i2c_master.scl_ratio[5]\ clk _01182_ _18685_ VPWR VGND sg13g2_dfrbpq_1
X_38119_ \memory_i.i2c_master.scl_ratio[6]\ clk _01183_ _18683_ VPWR VGND sg13g2_dfrbpq_1
X_38120_ \memory_i.i2c_master.scl_ratio[7]\ clk _01184_ _18681_ VPWR VGND sg13g2_dfrbpq_1
X_38121_ \memory_i.i2c_master.scl_ratio[8]\ clk _01185_ _18679_ VPWR VGND sg13g2_dfrbpq_1
X_38122_ \memory_i.i2c_master.scl_ratio[9]\ clk _01186_ _18677_ VPWR VGND sg13g2_dfrbpq_1
X_38123_ \memory_i.i2c_master.scl_ratio[10]\ clk _01187_ _18675_ VPWR VGND sg13g2_dfrbpq_1
X_38124_ \memory_i.i2c_master.scl_ratio[11]\ clk _01188_ _18673_ VPWR VGND sg13g2_dfrbpq_1
X_38125_ \memory_i.i2c_master.scl_ratio[12]\ clk _01189_ _18671_ VPWR VGND sg13g2_dfrbpq_1
X_38126_ \memory_i.i2c_master.scl_ratio[13]\ clk _01190_ _18669_ VPWR VGND sg13g2_dfrbpq_1
X_38127_ \memory_i.i2c_master.scl_ratio[14]\ clk _01191_ _18667_ VPWR VGND sg13g2_dfrbpq_1
X_38128_ \memory_i.i2c_master.scl_ratio[15]\ clk _01192_ _18665_ VPWR VGND sg13g2_dfrbpq_1
X_38129_ \memory_i.uart_transmitter.uart_tx_en\ clk _01193_ _18663_ VPWR VGND sg13g2_dfrbpq_1
X_38130_ \memory_i.uart_transmitter.CYCLES_PER_BIT[0]\ clk _01194_ _18661_ VPWR VGND sg13g2_dfrbpq_1
X_38131_ \memory_i.uart_transmitter.CYCLES_PER_BIT[1]\ clk _01195_ _18659_ VPWR VGND sg13g2_dfrbpq_1
X_38132_ \memory_i.uart_transmitter.CYCLES_PER_BIT[2]\ clk _01196_ _18657_ VPWR VGND sg13g2_dfrbpq_1
X_38133_ \memory_i.uart_transmitter.CYCLES_PER_BIT[3]\ clk _01197_ _18655_ VPWR VGND sg13g2_dfrbpq_1
X_38134_ \memory_i.uart_transmitter.CYCLES_PER_BIT[4]\ clk _01198_ _18653_ VPWR VGND sg13g2_dfrbpq_1
X_38135_ \memory_i.uart_transmitter.CYCLES_PER_BIT[5]\ clk _01199_ _18651_ VPWR VGND sg13g2_dfrbpq_1
X_38136_ \memory_i.uart_transmitter.CYCLES_PER_BIT[6]\ clk _01200_ _18649_ VPWR VGND sg13g2_dfrbpq_1
X_38137_ \memory_i.uart_transmitter.CYCLES_PER_BIT[7]\ clk _01201_ _18647_ VPWR VGND sg13g2_dfrbpq_1
X_38138_ \memory_i.uart_transmitter.CYCLES_PER_BIT[8]\ clk _01202_ _18645_ VPWR VGND sg13g2_dfrbpq_1
X_38139_ \memory_i.uart_transmitter.CYCLES_PER_BIT[9]\ clk _01203_ _18643_ VPWR VGND sg13g2_dfrbpq_1
X_38140_ \memory_i.uart_transmitter.CYCLES_PER_BIT[10]\ clk _01204_ _18641_ VPWR VGND sg13g2_dfrbpq_1
X_38141_ \memory_i.uart_transmitter.CYCLES_PER_BIT[11]\ clk _01205_ _18639_ VPWR VGND sg13g2_dfrbpq_1
X_38142_ \memory_i.uart_transmitter.CYCLES_PER_BIT[12]\ clk _01206_ _18637_ VPWR VGND sg13g2_dfrbpq_1
X_38143_ \memory_i.uart_transmitter.CYCLES_PER_BIT[13]\ clk _01207_ _18635_ VPWR VGND sg13g2_dfrbpq_1
X_38144_ \memory_i.uart_transmitter.CYCLES_PER_BIT[14]\ clk _01208_ _18633_ VPWR VGND sg13g2_dfrbpq_1
X_38145_ \memory_i.uart_transmitter.CYCLES_PER_BIT[15]\ clk _01209_ _18631_ VPWR VGND sg13g2_dfrbpq_1
X_38146_ \memory_i.uart_receiver.uart_rx_en\ clk _01210_ _18629_ VPWR VGND sg13g2_dfrbpq_1
X_38147_ \memory_i.uart_receiver.CYCLES_PER_BIT[0]\ clk _01211_ _18627_ VPWR VGND sg13g2_dfrbpq_1
X_38148_ \memory_i.uart_receiver.CYCLES_PER_BIT[1]\ clk _01212_ _18625_ VPWR VGND sg13g2_dfrbpq_1
X_38149_ \memory_i.uart_receiver.CYCLES_PER_BIT[2]\ clk _01213_ _18623_ VPWR VGND sg13g2_dfrbpq_1
X_38150_ \memory_i.uart_receiver.CYCLES_PER_BIT[3]\ clk _01214_ _18621_ VPWR VGND sg13g2_dfrbpq_1
X_38151_ \memory_i.uart_receiver.CYCLES_PER_BIT[4]\ clk _01215_ _18619_ VPWR VGND sg13g2_dfrbpq_1
X_38152_ \memory_i.uart_receiver.CYCLES_PER_BIT[5]\ clk _01216_ _18617_ VPWR VGND sg13g2_dfrbpq_1
X_38153_ \memory_i.uart_receiver.CYCLES_PER_BIT[6]\ clk _01217_ _18615_ VPWR VGND sg13g2_dfrbpq_1
X_38154_ \memory_i.uart_receiver.CYCLES_PER_BIT[7]\ clk _01218_ _18613_ VPWR VGND sg13g2_dfrbpq_1
X_38155_ \memory_i.uart_receiver.CYCLES_PER_BIT[8]\ clk _01219_ _18611_ VPWR VGND sg13g2_dfrbpq_1
X_38156_ \memory_i.uart_receiver.CYCLES_PER_BIT[9]\ clk _01220_ _18609_ VPWR VGND sg13g2_dfrbpq_1
X_38157_ \memory_i.uart_receiver.CYCLES_PER_BIT[10]\ clk _01221_ _18607_ VPWR VGND sg13g2_dfrbpq_1
X_38158_ \memory_i.uart_receiver.CYCLES_PER_BIT[11]\ clk _01222_ _18605_ VPWR VGND sg13g2_dfrbpq_1
X_38159_ \memory_i.uart_receiver.CYCLES_PER_BIT[12]\ clk _01223_ _18603_ VPWR VGND sg13g2_dfrbpq_1
X_38160_ \memory_i.uart_receiver.CYCLES_PER_BIT[13]\ clk _01224_ _18601_ VPWR VGND sg13g2_dfrbpq_1
X_38161_ \memory_i.uart_receiver.CYCLES_PER_BIT[14]\ clk _01225_ _18599_ VPWR VGND sg13g2_dfrbpq_1
X_38162_ \memory_i.uart_receiver.CYCLES_PER_BIT[15]\ clk _01226_ _18597_ VPWR VGND sg13g2_dfrbpq_1
X_38163_ \memory_i.freq_inst.reset_n\ clk _01227_ _18595_ VPWR VGND sg13g2_dfrbpq_1
X_38164_ \memory_i.freq_inst.start\ clk _01228_ _18593_ VPWR VGND sg13g2_dfrbpq_1
X_38165_ lo_I_oe clk _01229_ _18591_ VPWR VGND sg13g2_dfrbpq_1
X_38166_ ds_I_oe clk _01230_ _18589_ VPWR VGND sg13g2_dfrbpq_1
X_38167_ Q_ae clk _01231_ _18587_ VPWR VGND sg13g2_dfrbpq_1
X_38168_ I_ae clk _01232_ _18585_ VPWR VGND sg13g2_dfrbpq_1
X_38169_ analog_en clk _01233_ _18583_ VPWR VGND sg13g2_dfrbpq_1
X_38170_ \memory_i.freq_inst.f_c[0]\ clk _01234_ _18581_ VPWR VGND sg13g2_dfrbpq_1
X_38171_ \memory_i.freq_inst.f_c[1]\ clk _01235_ _18579_ VPWR VGND sg13g2_dfrbpq_1
X_38172_ \memory_i.freq_inst.f_c[2]\ clk _01236_ _18577_ VPWR VGND sg13g2_dfrbpq_1
X_38173_ \memory_i.freq_inst.f_c[3]\ clk _01237_ _18575_ VPWR VGND sg13g2_dfrbpq_1
X_38174_ \memory_i.freq_inst.f_c[4]\ clk _01238_ _18573_ VPWR VGND sg13g2_dfrbpq_1
X_38175_ \memory_i.freq_inst.f_c[5]\ clk _01239_ _18571_ VPWR VGND sg13g2_dfrbpq_1
X_38176_ \memory_i.freq_inst.f_c[6]\ clk _01240_ _18569_ VPWR VGND sg13g2_dfrbpq_1
X_38177_ \memory_i.freq_inst.f_c[7]\ clk _01241_ _18567_ VPWR VGND sg13g2_dfrbpq_1
X_38178_ \memory_i.freq_inst.f_c[8]\ clk _01242_ _18565_ VPWR VGND sg13g2_dfrbpq_1
X_38179_ \memory_i.freq_inst.f_c[9]\ clk _01243_ _18563_ VPWR VGND sg13g2_dfrbpq_1
X_38180_ \memory_i.freq_inst.f_c[10]\ clk _01244_ _18561_ VPWR VGND sg13g2_dfrbpq_1
X_38181_ \memory_i.freq_inst.f_c[11]\ clk _01245_ _18559_ VPWR VGND sg13g2_dfrbpq_1
X_38182_ \memory_i.freq_inst.f_c[12]\ clk _01246_ _18557_ VPWR VGND sg13g2_dfrbpq_1
X_38183_ \memory_i.freq_inst.f_c[13]\ clk _01247_ _18555_ VPWR VGND sg13g2_dfrbpq_1
X_38184_ \memory_i.freq_inst.f_c[14]\ clk _01248_ _18553_ VPWR VGND sg13g2_dfrbpq_1
X_38185_ \memory_i.freq_inst.f_c[15]\ clk _01249_ _18551_ VPWR VGND sg13g2_dfrbpq_1
X_38186_ \memory_i.freq_inst.f_c[16]\ clk _01250_ _18549_ VPWR VGND sg13g2_dfrbpq_1
X_38187_ \memory_i.freq_inst.f_c[17]\ clk _01251_ _18547_ VPWR VGND sg13g2_dfrbpq_1
X_38188_ \memory_i.freq_inst.f_c[18]\ clk _01252_ _18545_ VPWR VGND sg13g2_dfrbpq_1
X_38189_ \memory_i.freq_inst.f_c[19]\ clk _01253_ _18543_ VPWR VGND sg13g2_dfrbpq_1
X_38190_ \memory_i.freq_inst.f_c[20]\ clk _01254_ _18541_ VPWR VGND sg13g2_dfrbpq_1
X_38191_ \memory_i.freq_inst.f_c[21]\ clk _01255_ _18539_ VPWR VGND sg13g2_dfrbpq_1
X_38192_ \memory_i.freq_inst.f_c[22]\ clk _01256_ _18537_ VPWR VGND sg13g2_dfrbpq_1
X_38193_ \memory_i.freq_inst.f_c[23]\ clk _01257_ _18535_ VPWR VGND sg13g2_dfrbpq_1
X_38194_ \memory_i.freq_inst.f_c[24]\ clk _01258_ _18533_ VPWR VGND sg13g2_dfrbpq_1
X_38195_ \memory_i.freq_inst.f_c[25]\ clk _01259_ _18531_ VPWR VGND sg13g2_dfrbpq_1
X_38196_ \memory_i.freq_inst.f_c[26]\ clk _01260_ _18529_ VPWR VGND sg13g2_dfrbpq_1
X_38197_ \memory_i.freq_inst.f_c[27]\ clk _01261_ _18527_ VPWR VGND sg13g2_dfrbpq_1
X_38198_ \memory_i.freq_inst.f_c[28]\ clk _01262_ _18525_ VPWR VGND sg13g2_dfrbpq_1
X_38199_ \memory_i.freq_inst.f_c[29]\ clk _01263_ _18523_ VPWR VGND sg13g2_dfrbpq_1
X_38200_ \memory_i.freq_inst.dsmod_cos.i_osr[0]\ clk _01264_ _18521_ VPWR VGND sg13g2_dfrbpq_1
X_38201_ \memory_i.freq_inst.dsmod_cos.i_osr[1]\ clk _01265_ _18519_ VPWR VGND sg13g2_dfrbpq_1
X_38202_ \memory_i.ds_lo_conf[0]\ clk _01266_ _18517_ VPWR VGND sg13g2_dfrbpq_1
X_38203_ \memory_i.ds_lo_conf[1]\ clk _01267_ _18515_ VPWR VGND sg13g2_dfrbpq_1
X_38204_ \memory_i.ds_lo_conf[2]\ clk _01268_ _18513_ VPWR VGND sg13g2_dfrbpq_1
X_38205_ \memory_i.ds_lo_conf[3]\ clk _01269_ _18511_ VPWR VGND sg13g2_dfrbpq_1
X_38206_ \memory_i.ds_lo_conf[4]\ clk _01270_ _18509_ VPWR VGND sg13g2_dfrbpq_1
X_38207_ \memory_i.ds_lo_conf[5]\ clk _01271_ _18507_ VPWR VGND sg13g2_dfrbpq_1
X_38208_ \memory_i.ds_lo_conf[6]\ clk _01272_ _18505_ VPWR VGND sg13g2_dfrbpq_1
X_38209_ \memory_i.ds_lo_conf[7]\ clk _01273_ _18503_ VPWR VGND sg13g2_dfrbpq_1
X_38210_ \memory_i.ds_defaults[0]\ clk _01274_ _18501_ VPWR VGND sg13g2_dfrbpq_1
X_38211_ \memory_i.ds_defaults[1]\ clk _01275_ _18499_ VPWR VGND sg13g2_dfrbpq_1
X_38212_ \memory_i.ds_defaults[2]\ clk _01276_ _18497_ VPWR VGND sg13g2_dfrbpq_1
X_38213_ \memory_i.ds_defaults[3]\ clk _01277_ _18495_ VPWR VGND sg13g2_dfrbpq_1
X_38214_ \memory_i.ds_defaults[4]\ clk _01278_ _18493_ VPWR VGND sg13g2_dfrbpq_1
X_38215_ \memory_i.ds_defaults[5]\ clk _01279_ _18491_ VPWR VGND sg13g2_dfrbpq_1
X_38216_ \memory_i.ds_defaults[6]\ clk _01280_ _18489_ VPWR VGND sg13g2_dfrbpq_1
X_38217_ \memory_i.ds_defaults[7]\ clk _01281_ _18487_ VPWR VGND sg13g2_dfrbpq_1
X_38218_ \memory_i.cordic_I[0]\ clk _01282_ _18485_ VPWR VGND sg13g2_dfrbpq_1
X_38219_ \memory_i.cordic_I[1]\ clk _01283_ _18483_ VPWR VGND sg13g2_dfrbpq_1
X_38220_ \memory_i.cordic_I[2]\ clk _01284_ _18481_ VPWR VGND sg13g2_dfrbpq_1
X_38221_ \memory_i.cordic_I[3]\ clk _01285_ _18479_ VPWR VGND sg13g2_dfrbpq_1
X_38222_ \memory_i.cordic_I[4]\ clk _01286_ _18477_ VPWR VGND sg13g2_dfrbpq_1
X_38223_ \memory_i.cordic_I[5]\ clk _01287_ _18475_ VPWR VGND sg13g2_dfrbpq_1
X_38224_ \memory_i.cordic_I[6]\ clk _01288_ _18473_ VPWR VGND sg13g2_dfrbpq_1
X_38225_ \memory_i.cordic_I[7]\ clk _01289_ _18471_ VPWR VGND sg13g2_dfrbpq_1
X_38226_ \memory_i.cordic_I[8]\ clk _01290_ _18469_ VPWR VGND sg13g2_dfrbpq_1
X_38227_ \memory_i.cordic_I[9]\ clk _01291_ _18467_ VPWR VGND sg13g2_dfrbpq_1
X_38228_ \memory_i.cordic_I[10]\ clk _01292_ _18465_ VPWR VGND sg13g2_dfrbpq_1
X_38229_ \memory_i.cordic_I[11]\ clk _01293_ _18463_ VPWR VGND sg13g2_dfrbpq_1
X_38230_ \memory_i.cordic_I[12]\ clk _01294_ _18461_ VPWR VGND sg13g2_dfrbpq_1
X_38231_ \memory_i.cordic_I[13]\ clk _01295_ _18459_ VPWR VGND sg13g2_dfrbpq_1
X_38232_ \memory_i.cordic_I[14]\ clk _01296_ _18457_ VPWR VGND sg13g2_dfrbpq_1
X_38233_ \memory_i.cordic_I[15]\ clk _01297_ _18455_ VPWR VGND sg13g2_dfrbpq_1
X_38234_ \memory_i.cordic_I[16]\ clk _01298_ _18453_ VPWR VGND sg13g2_dfrbpq_1
X_38235_ \memory_i.cordic_I[17]\ clk _01299_ _18451_ VPWR VGND sg13g2_dfrbpq_1
X_38236_ \memory_i.cordic_I[18]\ clk _01300_ _18449_ VPWR VGND sg13g2_dfrbpq_1
X_38237_ \memory_i.cordic_I[19]\ clk _01301_ _18447_ VPWR VGND sg13g2_dfrbpq_1
X_38238_ \memory_i.cordic_I[20]\ clk _01302_ _18445_ VPWR VGND sg13g2_dfrbpq_1
X_38239_ \memory_i.cordic_I[21]\ clk _01303_ _18443_ VPWR VGND sg13g2_dfrbpq_1
X_38240_ \memory_i.cordic_I[22]\ clk _01304_ _18441_ VPWR VGND sg13g2_dfrbpq_1
X_38241_ \memory_i.cordic_I[23]\ clk _01305_ _18439_ VPWR VGND sg13g2_dfrbpq_1
X_38242_ \memory_i.cordic_I[24]\ clk _01306_ _18437_ VPWR VGND sg13g2_dfrbpq_1
X_38243_ \memory_i.cordic_I[25]\ clk _01307_ _18435_ VPWR VGND sg13g2_dfrbpq_1
X_38244_ \memory_i.cordic_I[26]\ clk _01308_ _18433_ VPWR VGND sg13g2_dfrbpq_1
X_38245_ \memory_i.cordic_I[27]\ clk _01309_ _18431_ VPWR VGND sg13g2_dfrbpq_1
X_38246_ \memory_i.cordic_I[28]\ clk _01310_ _18429_ VPWR VGND sg13g2_dfrbpq_1
X_38247_ \memory_i.cordic_I[29]\ clk _01311_ _18427_ VPWR VGND sg13g2_dfrbpq_1
X_38248_ \memory_i.freq_inst.cordic.Z_i[0]\ clk _01312_ _18425_ VPWR VGND sg13g2_dfrbpq_1
X_38249_ \memory_i.freq_inst.cordic.Z_i[1]\ clk _01313_ _18424_ VPWR VGND sg13g2_dfrbpq_1
X_38250_ \memory_i.freq_inst.cordic.Z_i[2]\ clk _01314_ _18423_ VPWR VGND sg13g2_dfrbpq_1
X_38251_ \memory_i.freq_inst.cordic.Z_i[3]\ clk _01315_ _18422_ VPWR VGND sg13g2_dfrbpq_1
X_38252_ \memory_i.freq_inst.cordic.Z_i[4]\ clk _01316_ _18421_ VPWR VGND sg13g2_dfrbpq_1
X_38253_ \memory_i.freq_inst.cordic.Z_i[5]\ clk _01317_ _18420_ VPWR VGND sg13g2_dfrbpq_1
X_38254_ \memory_i.freq_inst.cordic.Z_i[6]\ clk _01318_ _18419_ VPWR VGND sg13g2_dfrbpq_1
X_38255_ \memory_i.freq_inst.cordic.Z_i[7]\ clk _01319_ _18418_ VPWR VGND sg13g2_dfrbpq_1
X_38256_ \memory_i.freq_inst.cordic.Z_i[8]\ clk _01320_ _18417_ VPWR VGND sg13g2_dfrbpq_1
X_38257_ \memory_i.freq_inst.cordic.Z_i[9]\ clk _01321_ _18416_ VPWR VGND sg13g2_dfrbpq_1
X_38258_ \memory_i.freq_inst.cordic.Z_i[10]\ clk _01322_ _18415_ VPWR VGND sg13g2_dfrbpq_1
X_38259_ \memory_i.freq_inst.cordic.Z_i[11]\ clk _01323_ _18414_ VPWR VGND sg13g2_dfrbpq_1
X_38260_ \memory_i.freq_inst.cordic.Z_i[12]\ clk _01324_ _18413_ VPWR VGND sg13g2_dfrbpq_1
X_38261_ \memory_i.freq_inst.cordic.Z_i[13]\ clk _01325_ _18412_ VPWR VGND sg13g2_dfrbpq_1
X_38262_ \memory_i.freq_inst.cordic.Z_i[14]\ clk _01326_ _18411_ VPWR VGND sg13g2_dfrbpq_1
X_38263_ \memory_i.freq_inst.cordic.Z_i[15]\ clk _01327_ _18410_ VPWR VGND sg13g2_dfrbpq_1
X_38264_ \memory_i.freq_inst.cordic.Z_i[16]\ clk _01328_ _18409_ VPWR VGND sg13g2_dfrbpq_1
X_38265_ \memory_i.freq_inst.cordic.Z_i[17]\ clk _01329_ _18408_ VPWR VGND sg13g2_dfrbpq_1
X_38266_ \memory_i.freq_inst.cordic.Z_i[18]\ clk _01330_ _18407_ VPWR VGND sg13g2_dfrbpq_1
X_38267_ \memory_i.freq_inst.cordic.Z_i[19]\ clk _01331_ _18406_ VPWR VGND sg13g2_dfrbpq_1
X_38268_ \memory_i.freq_inst.cordic.Z_i[20]\ clk _01332_ _18405_ VPWR VGND sg13g2_dfrbpq_1
X_38269_ \memory_i.freq_inst.cordic.Z_i[21]\ clk _01333_ _18404_ VPWR VGND sg13g2_dfrbpq_1
X_38270_ \memory_i.freq_inst.cordic.Z_i[22]\ clk _01334_ _18403_ VPWR VGND sg13g2_dfrbpq_1
X_38271_ \memory_i.freq_inst.cordic.Z_i[23]\ clk _01335_ _18402_ VPWR VGND sg13g2_dfrbpq_1
X_38272_ \memory_i.freq_inst.cordic.Z_i[24]\ clk _01336_ _18401_ VPWR VGND sg13g2_dfrbpq_1
X_38273_ \memory_i.freq_inst.cordic.Z_i[25]\ clk _01337_ _18400_ VPWR VGND sg13g2_dfrbpq_1
X_38274_ \memory_i.freq_inst.cordic.Z_i[26]\ clk _01338_ _18399_ VPWR VGND sg13g2_dfrbpq_1
X_38275_ \memory_i.freq_inst.cordic.Z_i[27]\ clk _01339_ _18398_ VPWR VGND sg13g2_dfrbpq_1
X_38276_ \memory_i.freq_inst.cordic.Z_i[28]\ clk _01340_ _18397_ VPWR VGND sg13g2_dfrbpq_1
X_38277_ \memory_i.freq_inst.cordic.Z_i[29]\ clk _01341_ _18396_ VPWR VGND sg13g2_dfrbpq_1
X_38278_ \memory_i.freq_inst.cosine[0]\ clk _01342_ _18395_ VPWR VGND sg13g2_dfrbpq_1
X_38279_ \memory_i.freq_inst.cosine[1]\ clk _01343_ _18393_ VPWR VGND sg13g2_dfrbpq_1
X_38280_ \memory_i.freq_inst.cosine[2]\ clk _01344_ _18391_ VPWR VGND sg13g2_dfrbpq_1
X_38281_ \memory_i.freq_inst.cosine[3]\ clk _01345_ _18389_ VPWR VGND sg13g2_dfrbpq_1
X_38282_ \memory_i.freq_inst.cosine[4]\ clk _01346_ _18387_ VPWR VGND sg13g2_dfrbpq_1
X_38283_ \memory_i.freq_inst.cosine[5]\ clk _01347_ _18385_ VPWR VGND sg13g2_dfrbpq_1
X_38284_ \memory_i.freq_inst.cosine[6]\ clk _01348_ _18383_ VPWR VGND sg13g2_dfrbpq_1
X_38285_ \memory_i.freq_inst.cosine[7]\ clk _01349_ _18381_ VPWR VGND sg13g2_dfrbpq_1
X_38286_ \memory_i.freq_inst.cosine[8]\ clk _01350_ _18379_ VPWR VGND sg13g2_dfrbpq_1
X_38287_ \memory_i.freq_inst.cosine[9]\ clk _01351_ _18377_ VPWR VGND sg13g2_dfrbpq_1
X_38288_ \memory_i.freq_inst.cosine[10]\ clk _01352_ _18375_ VPWR VGND sg13g2_dfrbpq_1
X_38289_ \memory_i.freq_inst.cosine[11]\ clk _01353_ _18373_ VPWR VGND sg13g2_dfrbpq_1
X_38290_ \memory_i.freq_inst.cosine[12]\ clk _01354_ _18371_ VPWR VGND sg13g2_dfrbpq_1
X_38291_ \memory_i.freq_inst.cosine[13]\ clk _01355_ _18369_ VPWR VGND sg13g2_dfrbpq_1
X_38292_ \memory_i.freq_inst.cosine[14]\ clk _01356_ _18367_ VPWR VGND sg13g2_dfrbpq_1
X_38293_ \memory_i.freq_inst.cosine[15]\ clk _01357_ _18365_ VPWR VGND sg13g2_dfrbpq_1
X_38294_ \memory_i.freq_inst.cosine[16]\ clk _01358_ _18363_ VPWR VGND sg13g2_dfrbpq_1
X_38295_ \memory_i.freq_inst.cosine[17]\ clk _01359_ _18361_ VPWR VGND sg13g2_dfrbpq_1
X_38296_ \memory_i.freq_inst.cosine[18]\ clk _01360_ _18359_ VPWR VGND sg13g2_dfrbpq_1
X_38297_ \memory_i.freq_inst.cosine[19]\ clk _01361_ _18357_ VPWR VGND sg13g2_dfrbpq_1
X_38298_ \memory_i.freq_inst.cosine[20]\ clk _01362_ _18355_ VPWR VGND sg13g2_dfrbpq_1
X_38299_ \memory_i.freq_inst.cosine[21]\ clk _01363_ _18353_ VPWR VGND sg13g2_dfrbpq_1
X_38300_ \memory_i.freq_inst.cosine[22]\ clk _01364_ _18351_ VPWR VGND sg13g2_dfrbpq_1
X_38301_ \memory_i.freq_inst.cosine[23]\ clk _01365_ _18349_ VPWR VGND sg13g2_dfrbpq_1
X_38302_ \memory_i.freq_inst.cosine[24]\ clk _01366_ _18347_ VPWR VGND sg13g2_dfrbpq_1
X_38303_ \memory_i.freq_inst.cosine[25]\ clk _01367_ _18345_ VPWR VGND sg13g2_dfrbpq_1
X_38304_ \memory_i.freq_inst.cosine[26]\ clk _01368_ _18343_ VPWR VGND sg13g2_dfrbpq_1
X_38305_ \memory_i.freq_inst.cosine[27]\ clk _01369_ _18341_ VPWR VGND sg13g2_dfrbpq_1
X_38306_ \memory_i.freq_inst.cosine[28]\ clk _01370_ _18339_ VPWR VGND sg13g2_dfrbpq_1
X_38307_ \memory_i.freq_inst.cosine[29]\ clk _01371_ _18337_ VPWR VGND sg13g2_dfrbpq_1
X_38308_ \memory_i.freq_inst.dsmod_sin.data_ext_w[8]\ clk _01372_ _18335_ VPWR VGND sg13g2_dfrbpq_1
X_38309_ \memory_i.freq_inst.dsmod_sin.data_ext_w[9]\ clk _01373_ _18333_ VPWR VGND sg13g2_dfrbpq_1
X_38310_ \memory_i.freq_inst.dsmod_sin.data_ext_w[10]\ clk _01374_ _18331_ VPWR VGND sg13g2_dfrbpq_1
X_38311_ \memory_i.freq_inst.dsmod_sin.data_ext_w[11]\ clk _01375_ _18329_ VPWR VGND sg13g2_dfrbpq_1
X_38312_ \memory_i.freq_inst.dsmod_sin.data_ext_w[12]\ clk _01376_ _18327_ VPWR VGND sg13g2_dfrbpq_1
X_38313_ \memory_i.freq_inst.dsmod_sin.data_ext_w[13]\ clk _01377_ _18325_ VPWR VGND sg13g2_dfrbpq_1
X_38314_ \memory_i.freq_inst.dsmod_sin.data_ext_w[14]\ clk _01378_ _18323_ VPWR VGND sg13g2_dfrbpq_1
X_38315_ \memory_i.freq_inst.dsmod_sin.data_ext_w[15]\ clk _01379_ _18321_ VPWR VGND sg13g2_dfrbpq_1
X_38316_ \memory_i.freq_inst.dsmod_sin.data_ext_w[16]\ clk _01380_ _18319_ VPWR VGND sg13g2_dfrbpq_1
X_38317_ \memory_i.freq_inst.dsmod_sin.data_ext_w[17]\ clk _01381_ _18317_ VPWR VGND sg13g2_dfrbpq_1
X_38318_ \memory_i.freq_inst.dsmod_sin.data_ext_w[18]\ clk _01382_ _18315_ VPWR VGND sg13g2_dfrbpq_1
X_38319_ \memory_i.freq_inst.dsmod_sin.data_ext_w[19]\ clk _01383_ _18313_ VPWR VGND sg13g2_dfrbpq_1
X_38320_ \memory_i.freq_inst.dsmod_sin.data_ext_w[20]\ clk _01384_ _18311_ VPWR VGND sg13g2_dfrbpq_1
X_38321_ \memory_i.freq_inst.dsmod_sin.data_ext_w[21]\ clk _01385_ _18309_ VPWR VGND sg13g2_dfrbpq_1
X_38322_ \memory_i.freq_inst.dsmod_sin.data_ext_w[22]\ clk _01386_ _18307_ VPWR VGND sg13g2_dfrbpq_1
X_38323_ \memory_i.freq_inst.dsmod_sin.data_ext_w[23]\ clk _01387_ _18305_ VPWR VGND sg13g2_dfrbpq_1
X_38324_ \memory_i.freq_inst.dsmod_sin.data_ext_w[24]\ clk _01388_ _18303_ VPWR VGND sg13g2_dfrbpq_1
X_38325_ \memory_i.freq_inst.dsmod_sin.data_ext_w[25]\ clk _01389_ _18301_ VPWR VGND sg13g2_dfrbpq_1
X_38326_ \memory_i.freq_inst.dsmod_sin.data_ext_w[26]\ clk _01390_ _18299_ VPWR VGND sg13g2_dfrbpq_1
X_38327_ \memory_i.freq_inst.dsmod_sin.data_ext_w[27]\ clk _01391_ _18297_ VPWR VGND sg13g2_dfrbpq_1
X_38328_ \memory_i.freq_inst.dsmod_sin.data_ext_w[28]\ clk _01392_ _18295_ VPWR VGND sg13g2_dfrbpq_1
X_38329_ \memory_i.freq_inst.dsmod_sin.data_ext_w[29]\ clk _01393_ _18293_ VPWR VGND sg13g2_dfrbpq_1
X_38330_ \memory_i.freq_inst.dsmod_sin.data_ext_w[30]\ clk _01394_ _18291_ VPWR VGND sg13g2_dfrbpq_1
X_38331_ \memory_i.freq_inst.dsmod_sin.data_ext_w[31]\ clk _01395_ _18289_ VPWR VGND sg13g2_dfrbpq_1
X_38332_ \memory_i.freq_inst.dsmod_sin.data_ext_w[32]\ clk _01396_ _18287_ VPWR VGND sg13g2_dfrbpq_1
X_38333_ \memory_i.freq_inst.dsmod_sin.data_ext_w[33]\ clk _01397_ _18285_ VPWR VGND sg13g2_dfrbpq_1
X_38334_ \memory_i.freq_inst.dsmod_sin.data_ext_w[34]\ clk _01398_ _18283_ VPWR VGND sg13g2_dfrbpq_1
X_38335_ \memory_i.freq_inst.dsmod_sin.data_ext_w[35]\ clk _01399_ _18281_ VPWR VGND sg13g2_dfrbpq_1
X_38336_ \memory_i.freq_inst.dsmod_sin.data_ext_w[36]\ clk _01400_ _18279_ VPWR VGND sg13g2_dfrbpq_1
X_38337_ \memory_i.freq_inst.dsmod_sin.data_ext_w[37]\ clk _01401_ _18277_ VPWR VGND sg13g2_dfrbpq_1
X_38338_ \memory_i.freq_inst.cordic.strb_data_valid_i\ clk _01402_ _18275_ VPWR VGND sg13g2_dfrbpq_1
X_38339_ \memory_i.freq_inst.dsmod_cos.i_ena_mod\ clk _01403_ _18273_ VPWR VGND sg13g2_dfrbpq_1
X_38340_ \memory_i.freq_inst.transmit_counter[0]\ clk _01404_ _18271_ VPWR VGND sg13g2_dfrbpq_1
X_38341_ \memory_i.freq_inst.transmit_counter[1]\ clk _01405_ _18269_ VPWR VGND sg13g2_dfrbpq_1
X_38342_ \memory_i.freq_inst.transmit_counter[2]\ clk _01406_ _18267_ VPWR VGND sg13g2_dfrbpq_1
X_38343_ \memory_i.freq_inst.transmit_counter[3]\ clk _01407_ _18265_ VPWR VGND sg13g2_dfrbpq_1
X_38344_ \memory_i.freq_inst.transmit_counter[4]\ clk _01408_ _18263_ VPWR VGND sg13g2_dfrbpq_1
X_38345_ \memory_i.freq_inst.transmit_counter[5]\ clk _01409_ _18261_ VPWR VGND sg13g2_dfrbpq_1
X_38346_ \memory_i.freq_inst.transmit_counter[6]\ clk _01410_ _18259_ VPWR VGND sg13g2_dfrbpq_1
X_38347_ \memory_i.freq_inst.transmit_counter[7]\ clk _01411_ _18257_ VPWR VGND sg13g2_dfrbpq_1
X_38348_ \memory_i.freq_inst.cordic.shift_value[0]\ clk _01412_ _18255_ VPWR VGND sg13g2_dfrbpq_1
X_38349_ \memory_i.freq_inst.cordic.shift_value[1]\ clk _01413_ _18253_ VPWR VGND sg13g2_dfrbpq_1
X_38350_ \memory_i.freq_inst.cordic.shift_value[2]\ clk _01414_ _18251_ VPWR VGND sg13g2_dfrbpq_1
X_38351_ \memory_i.freq_inst.cordic.shift_value[3]\ clk _01415_ _18249_ VPWR VGND sg13g2_dfrbpq_1
X_38352_ \memory_i.freq_inst.cordic.shift_value[4]\ clk _01416_ _18247_ VPWR VGND sg13g2_dfrbpq_1
X_38353_ \memory_i.freq_inst.cordic.roc_in_X[0]\ clk _01417_ _18245_ VPWR VGND sg13g2_dfrbpq_1
X_38354_ \memory_i.freq_inst.cordic.roc_in_X[1]\ clk _01418_ _18243_ VPWR VGND sg13g2_dfrbpq_1
X_38355_ \memory_i.freq_inst.cordic.roc_in_X[2]\ clk _01419_ _18241_ VPWR VGND sg13g2_dfrbpq_1
X_38356_ \memory_i.freq_inst.cordic.roc_in_X[3]\ clk _01420_ _18239_ VPWR VGND sg13g2_dfrbpq_1
X_38357_ \memory_i.freq_inst.cordic.roc_in_X[4]\ clk _01421_ _18237_ VPWR VGND sg13g2_dfrbpq_1
X_38358_ \memory_i.freq_inst.cordic.roc_in_X[5]\ clk _01422_ _18235_ VPWR VGND sg13g2_dfrbpq_1
X_38359_ \memory_i.freq_inst.cordic.roc_in_X[6]\ clk _01423_ _18233_ VPWR VGND sg13g2_dfrbpq_1
X_38360_ \memory_i.freq_inst.cordic.roc_in_X[7]\ clk _01424_ _18231_ VPWR VGND sg13g2_dfrbpq_1
X_38361_ \memory_i.freq_inst.cordic.roc_in_X[8]\ clk _01425_ _18229_ VPWR VGND sg13g2_dfrbpq_1
X_38362_ \memory_i.freq_inst.cordic.roc_in_X[9]\ clk _01426_ _18227_ VPWR VGND sg13g2_dfrbpq_1
X_38363_ \memory_i.freq_inst.cordic.roc_in_X[10]\ clk _01427_ _18225_ VPWR VGND sg13g2_dfrbpq_1
X_38364_ \memory_i.freq_inst.cordic.roc_in_X[11]\ clk _01428_ _18223_ VPWR VGND sg13g2_dfrbpq_1
X_38365_ \memory_i.freq_inst.cordic.roc_in_X[12]\ clk _01429_ _18221_ VPWR VGND sg13g2_dfrbpq_1
X_38366_ \memory_i.freq_inst.cordic.roc_in_X[13]\ clk _01430_ _18219_ VPWR VGND sg13g2_dfrbpq_1
X_38367_ \memory_i.freq_inst.cordic.roc_in_X[14]\ clk _01431_ _18217_ VPWR VGND sg13g2_dfrbpq_1
X_38368_ \memory_i.freq_inst.cordic.roc_in_X[15]\ clk _01432_ _18215_ VPWR VGND sg13g2_dfrbpq_1
X_38369_ \memory_i.freq_inst.cordic.roc_in_X[16]\ clk _01433_ _18213_ VPWR VGND sg13g2_dfrbpq_1
X_38370_ \memory_i.freq_inst.cordic.roc_in_X[17]\ clk _01434_ _18211_ VPWR VGND sg13g2_dfrbpq_1
X_38371_ \memory_i.freq_inst.cordic.roc_in_X[18]\ clk _01435_ _18209_ VPWR VGND sg13g2_dfrbpq_1
X_38372_ \memory_i.freq_inst.cordic.roc_in_X[19]\ clk _01436_ _18207_ VPWR VGND sg13g2_dfrbpq_1
X_38373_ \memory_i.freq_inst.cordic.roc_in_X[20]\ clk _01437_ _18205_ VPWR VGND sg13g2_dfrbpq_1
X_38374_ \memory_i.freq_inst.cordic.roc_in_X[21]\ clk _01438_ _18203_ VPWR VGND sg13g2_dfrbpq_1
X_38375_ \memory_i.freq_inst.cordic.roc_in_X[22]\ clk _01439_ _18201_ VPWR VGND sg13g2_dfrbpq_1
X_38376_ \memory_i.freq_inst.cordic.roc_in_X[23]\ clk _01440_ _18199_ VPWR VGND sg13g2_dfrbpq_1
X_38377_ \memory_i.freq_inst.cordic.roc_in_X[24]\ clk _01441_ _18197_ VPWR VGND sg13g2_dfrbpq_1
X_38378_ \memory_i.freq_inst.cordic.roc_in_X[25]\ clk _01442_ _18195_ VPWR VGND sg13g2_dfrbpq_1
X_38379_ \memory_i.freq_inst.cordic.roc_in_X[26]\ clk _01443_ _18193_ VPWR VGND sg13g2_dfrbpq_1
X_38380_ \memory_i.freq_inst.cordic.roc_in_X[27]\ clk _01444_ _18191_ VPWR VGND sg13g2_dfrbpq_1
X_38381_ \memory_i.freq_inst.cordic.roc_in_X[28]\ clk _01445_ _18189_ VPWR VGND sg13g2_dfrbpq_1
X_38382_ \memory_i.freq_inst.cordic.roc_in_X[29]\ clk _01446_ _18187_ VPWR VGND sg13g2_dfrbpq_1
X_38383_ \memory_i.freq_inst.cordic.roc_in_Z[0]\ clk _01447_ _18185_ VPWR VGND sg13g2_dfrbpq_1
X_38384_ \memory_i.freq_inst.cordic.roc_in_Z[1]\ clk _01448_ _18183_ VPWR VGND sg13g2_dfrbpq_1
X_38385_ \memory_i.freq_inst.cordic.roc_in_Z[2]\ clk _01449_ _18181_ VPWR VGND sg13g2_dfrbpq_1
X_38386_ \memory_i.freq_inst.cordic.roc_in_Z[3]\ clk _01450_ _18179_ VPWR VGND sg13g2_dfrbpq_1
X_38387_ \memory_i.freq_inst.cordic.roc_in_Z[4]\ clk _01451_ _18177_ VPWR VGND sg13g2_dfrbpq_1
X_38388_ \memory_i.freq_inst.cordic.roc_in_Z[5]\ clk _01452_ _18175_ VPWR VGND sg13g2_dfrbpq_1
X_38389_ \memory_i.freq_inst.cordic.roc_in_Z[6]\ clk _01453_ _18173_ VPWR VGND sg13g2_dfrbpq_1
X_38390_ \memory_i.freq_inst.cordic.roc_in_Z[7]\ clk _01454_ _18171_ VPWR VGND sg13g2_dfrbpq_1
X_38391_ \memory_i.freq_inst.cordic.roc_in_Z[8]\ clk _01455_ _18169_ VPWR VGND sg13g2_dfrbpq_1
X_38392_ \memory_i.freq_inst.cordic.roc_in_Z[9]\ clk _01456_ _18167_ VPWR VGND sg13g2_dfrbpq_1
X_38393_ \memory_i.freq_inst.cordic.roc_in_Z[10]\ clk _01457_ _18165_ VPWR VGND sg13g2_dfrbpq_1
X_38394_ \memory_i.freq_inst.cordic.roc_in_Z[11]\ clk _01458_ _18163_ VPWR VGND sg13g2_dfrbpq_1
X_38395_ \memory_i.freq_inst.cordic.roc_in_Z[12]\ clk _01459_ _18161_ VPWR VGND sg13g2_dfrbpq_1
X_38396_ \memory_i.freq_inst.cordic.roc_in_Z[13]\ clk _01460_ _18159_ VPWR VGND sg13g2_dfrbpq_1
X_38397_ \memory_i.freq_inst.cordic.roc_in_Z[14]\ clk _01461_ _18157_ VPWR VGND sg13g2_dfrbpq_1
X_38398_ \memory_i.freq_inst.cordic.roc_in_Z[15]\ clk _01462_ _18155_ VPWR VGND sg13g2_dfrbpq_1
X_38399_ \memory_i.freq_inst.cordic.roc_in_Z[16]\ clk _01463_ _18153_ VPWR VGND sg13g2_dfrbpq_1
X_38400_ \memory_i.freq_inst.cordic.roc_in_Z[17]\ clk _01464_ _18151_ VPWR VGND sg13g2_dfrbpq_1
X_38401_ \memory_i.freq_inst.cordic.roc_in_Z[18]\ clk _01465_ _18149_ VPWR VGND sg13g2_dfrbpq_1
X_38402_ \memory_i.freq_inst.cordic.roc_in_Z[19]\ clk _01466_ _18147_ VPWR VGND sg13g2_dfrbpq_1
X_38403_ \memory_i.freq_inst.cordic.roc_in_Z[20]\ clk _01467_ _18145_ VPWR VGND sg13g2_dfrbpq_1
X_38404_ \memory_i.freq_inst.cordic.roc_in_Z[21]\ clk _01468_ _18143_ VPWR VGND sg13g2_dfrbpq_1
X_38405_ \memory_i.freq_inst.cordic.roc_in_Z[22]\ clk _01469_ _18141_ VPWR VGND sg13g2_dfrbpq_1
X_38406_ \memory_i.freq_inst.cordic.roc_in_Z[23]\ clk _01470_ _18139_ VPWR VGND sg13g2_dfrbpq_1
X_38407_ \memory_i.freq_inst.cordic.roc_in_Z[24]\ clk _01471_ _18137_ VPWR VGND sg13g2_dfrbpq_1
X_38408_ \memory_i.freq_inst.cordic.roc_in_Z[25]\ clk _01472_ _18135_ VPWR VGND sg13g2_dfrbpq_1
X_38409_ \memory_i.freq_inst.cordic.roc_in_Z[26]\ clk _01473_ _18133_ VPWR VGND sg13g2_dfrbpq_1
X_38410_ \memory_i.freq_inst.cordic.roc_in_Z[27]\ clk _01474_ _18131_ VPWR VGND sg13g2_dfrbpq_1
X_38411_ \memory_i.freq_inst.cordic.roc_in_Z[28]\ clk _01475_ _18129_ VPWR VGND sg13g2_dfrbpq_1
X_38412_ \memory_i.freq_inst.cordic.roc_in_Z[29]\ clk _01476_ _18127_ VPWR VGND sg13g2_dfrbpq_1
X_38413_ \memory_i.freq_inst.Z_o[0]\ clk _01477_ _18125_ VPWR VGND sg13g2_dfrbpq_1
X_38414_ \memory_i.freq_inst.Z_o[1]\ clk _01478_ _18124_ VPWR VGND sg13g2_dfrbpq_1
X_38415_ \memory_i.freq_inst.Z_o[2]\ clk _01479_ _18123_ VPWR VGND sg13g2_dfrbpq_1
X_38416_ \memory_i.freq_inst.Z_o[3]\ clk _01480_ _18122_ VPWR VGND sg13g2_dfrbpq_1
X_38417_ \memory_i.freq_inst.Z_o[4]\ clk _01481_ _18121_ VPWR VGND sg13g2_dfrbpq_1
X_38418_ \memory_i.freq_inst.Z_o[5]\ clk _01482_ _18120_ VPWR VGND sg13g2_dfrbpq_1
X_38419_ \memory_i.freq_inst.Z_o[6]\ clk _01483_ _18119_ VPWR VGND sg13g2_dfrbpq_1
X_38420_ \memory_i.freq_inst.Z_o[7]\ clk _01484_ _18118_ VPWR VGND sg13g2_dfrbpq_1
X_38421_ \memory_i.freq_inst.Z_o[8]\ clk _01485_ _18117_ VPWR VGND sg13g2_dfrbpq_1
X_38422_ \memory_i.freq_inst.Z_o[9]\ clk _01486_ _18116_ VPWR VGND sg13g2_dfrbpq_1
X_38423_ \memory_i.freq_inst.Z_o[10]\ clk _01487_ _18115_ VPWR VGND sg13g2_dfrbpq_1
X_38424_ \memory_i.freq_inst.Z_o[11]\ clk _01488_ _18114_ VPWR VGND sg13g2_dfrbpq_1
X_38425_ \memory_i.freq_inst.Z_o[12]\ clk _01489_ _18113_ VPWR VGND sg13g2_dfrbpq_1
X_38426_ \memory_i.freq_inst.Z_o[13]\ clk _01490_ _18112_ VPWR VGND sg13g2_dfrbpq_1
X_38427_ \memory_i.freq_inst.Z_o[14]\ clk _01491_ _18111_ VPWR VGND sg13g2_dfrbpq_1
X_38428_ \memory_i.freq_inst.Z_o[15]\ clk _01492_ _18110_ VPWR VGND sg13g2_dfrbpq_1
X_38429_ \memory_i.freq_inst.Z_o[16]\ clk _01493_ _18109_ VPWR VGND sg13g2_dfrbpq_1
X_38430_ \memory_i.freq_inst.Z_o[17]\ clk _01494_ _18108_ VPWR VGND sg13g2_dfrbpq_1
X_38431_ \memory_i.freq_inst.Z_o[18]\ clk _01495_ _18107_ VPWR VGND sg13g2_dfrbpq_1
X_38432_ \memory_i.freq_inst.Z_o[19]\ clk _01496_ _18106_ VPWR VGND sg13g2_dfrbpq_1
X_38433_ \memory_i.freq_inst.Z_o[20]\ clk _01497_ _18105_ VPWR VGND sg13g2_dfrbpq_1
X_38434_ \memory_i.freq_inst.Z_o[21]\ clk _01498_ _18104_ VPWR VGND sg13g2_dfrbpq_1
X_38435_ \memory_i.freq_inst.Z_o[22]\ clk _01499_ _18103_ VPWR VGND sg13g2_dfrbpq_1
X_38436_ \memory_i.freq_inst.Z_o[23]\ clk _01500_ _18102_ VPWR VGND sg13g2_dfrbpq_1
X_38437_ \memory_i.freq_inst.Z_o[24]\ clk _01501_ _18101_ VPWR VGND sg13g2_dfrbpq_1
X_38438_ \memory_i.freq_inst.Z_o[25]\ clk _01502_ _18100_ VPWR VGND sg13g2_dfrbpq_1
X_38439_ \memory_i.freq_inst.Z_o[26]\ clk _01503_ _18099_ VPWR VGND sg13g2_dfrbpq_1
X_38440_ \memory_i.freq_inst.Z_o[27]\ clk _01504_ _18098_ VPWR VGND sg13g2_dfrbpq_1
X_38441_ \memory_i.freq_inst.Z_o[28]\ clk _01505_ _18097_ VPWR VGND sg13g2_dfrbpq_1
X_38442_ \memory_i.freq_inst.Z_o[29]\ clk _01506_ _18096_ VPWR VGND sg13g2_dfrbpq_1
X_38443_ \memory_i.freq_inst.Y_o[0]\ clk _01507_ _18095_ VPWR VGND sg13g2_dfrbpq_1
X_38444_ \memory_i.freq_inst.Y_o[1]\ clk _01508_ _18094_ VPWR VGND sg13g2_dfrbpq_1
X_38445_ \memory_i.freq_inst.Y_o[2]\ clk _01509_ _18093_ VPWR VGND sg13g2_dfrbpq_1
X_38446_ \memory_i.freq_inst.Y_o[3]\ clk _01510_ _18092_ VPWR VGND sg13g2_dfrbpq_1
X_38447_ \memory_i.freq_inst.Y_o[4]\ clk _01511_ _18091_ VPWR VGND sg13g2_dfrbpq_1
X_38448_ \memory_i.freq_inst.Y_o[5]\ clk _01512_ _18090_ VPWR VGND sg13g2_dfrbpq_1
X_38449_ \memory_i.freq_inst.Y_o[6]\ clk _01513_ _18089_ VPWR VGND sg13g2_dfrbpq_1
X_38450_ \memory_i.freq_inst.Y_o[7]\ clk _01514_ _18088_ VPWR VGND sg13g2_dfrbpq_1
X_38451_ \memory_i.freq_inst.Y_o[8]\ clk _01515_ _18087_ VPWR VGND sg13g2_dfrbpq_1
X_38452_ \memory_i.freq_inst.Y_o[9]\ clk _01516_ _18086_ VPWR VGND sg13g2_dfrbpq_1
X_38453_ \memory_i.freq_inst.Y_o[10]\ clk _01517_ _18085_ VPWR VGND sg13g2_dfrbpq_1
X_38454_ \memory_i.freq_inst.Y_o[11]\ clk _01518_ _18084_ VPWR VGND sg13g2_dfrbpq_1
X_38455_ \memory_i.freq_inst.Y_o[12]\ clk _01519_ _18083_ VPWR VGND sg13g2_dfrbpq_1
X_38456_ \memory_i.freq_inst.Y_o[13]\ clk _01520_ _18082_ VPWR VGND sg13g2_dfrbpq_1
X_38457_ \memory_i.freq_inst.Y_o[14]\ clk _01521_ _18081_ VPWR VGND sg13g2_dfrbpq_1
X_38458_ \memory_i.freq_inst.Y_o[15]\ clk _01522_ _18080_ VPWR VGND sg13g2_dfrbpq_1
X_38459_ \memory_i.freq_inst.Y_o[16]\ clk _01523_ _18079_ VPWR VGND sg13g2_dfrbpq_1
X_38460_ \memory_i.freq_inst.Y_o[17]\ clk _01524_ _18078_ VPWR VGND sg13g2_dfrbpq_1
X_38461_ \memory_i.freq_inst.Y_o[18]\ clk _01525_ _18077_ VPWR VGND sg13g2_dfrbpq_1
X_38462_ \memory_i.freq_inst.Y_o[19]\ clk _01526_ _18076_ VPWR VGND sg13g2_dfrbpq_1
X_38463_ \memory_i.freq_inst.Y_o[20]\ clk _01527_ _18075_ VPWR VGND sg13g2_dfrbpq_1
X_38464_ \memory_i.freq_inst.Y_o[21]\ clk _01528_ _18074_ VPWR VGND sg13g2_dfrbpq_1
X_38465_ \memory_i.freq_inst.Y_o[22]\ clk _01529_ _18073_ VPWR VGND sg13g2_dfrbpq_1
X_38466_ \memory_i.freq_inst.Y_o[23]\ clk _01530_ _18072_ VPWR VGND sg13g2_dfrbpq_1
X_38467_ \memory_i.freq_inst.Y_o[24]\ clk _01531_ _18071_ VPWR VGND sg13g2_dfrbpq_1
X_38468_ \memory_i.freq_inst.Y_o[25]\ clk _01532_ _18070_ VPWR VGND sg13g2_dfrbpq_1
X_38469_ \memory_i.freq_inst.Y_o[26]\ clk _01533_ _18069_ VPWR VGND sg13g2_dfrbpq_1
X_38470_ \memory_i.freq_inst.Y_o[27]\ clk _01534_ _18068_ VPWR VGND sg13g2_dfrbpq_1
X_38471_ \memory_i.freq_inst.Y_o[28]\ clk _01535_ _18067_ VPWR VGND sg13g2_dfrbpq_1
X_38472_ \memory_i.freq_inst.Y_o[29]\ clk _01536_ _18066_ VPWR VGND sg13g2_dfrbpq_1
X_38473_ \memory_i.freq_inst.X_o[0]\ clk _01537_ _18065_ VPWR VGND sg13g2_dfrbpq_1
X_38474_ \memory_i.freq_inst.X_o[1]\ clk _01538_ _18064_ VPWR VGND sg13g2_dfrbpq_1
X_38475_ \memory_i.freq_inst.X_o[2]\ clk _01539_ _18063_ VPWR VGND sg13g2_dfrbpq_1
X_38476_ \memory_i.freq_inst.X_o[3]\ clk _01540_ _18062_ VPWR VGND sg13g2_dfrbpq_1
X_38477_ \memory_i.freq_inst.X_o[4]\ clk _01541_ _18061_ VPWR VGND sg13g2_dfrbpq_1
X_38478_ \memory_i.freq_inst.X_o[5]\ clk _01542_ _18060_ VPWR VGND sg13g2_dfrbpq_1
X_38479_ \memory_i.freq_inst.X_o[6]\ clk _01543_ _18059_ VPWR VGND sg13g2_dfrbpq_1
X_38480_ \memory_i.freq_inst.X_o[7]\ clk _01544_ _18058_ VPWR VGND sg13g2_dfrbpq_1
X_38481_ \memory_i.freq_inst.X_o[8]\ clk _01545_ _18057_ VPWR VGND sg13g2_dfrbpq_1
X_38482_ \memory_i.freq_inst.X_o[9]\ clk _01546_ _18056_ VPWR VGND sg13g2_dfrbpq_1
X_38483_ \memory_i.freq_inst.X_o[10]\ clk _01547_ _18055_ VPWR VGND sg13g2_dfrbpq_1
X_38484_ \memory_i.freq_inst.X_o[11]\ clk _01548_ _18054_ VPWR VGND sg13g2_dfrbpq_1
X_38485_ \memory_i.freq_inst.X_o[12]\ clk _01549_ _18053_ VPWR VGND sg13g2_dfrbpq_1
X_38486_ \memory_i.freq_inst.X_o[13]\ clk _01550_ _18052_ VPWR VGND sg13g2_dfrbpq_1
X_38487_ \memory_i.freq_inst.X_o[14]\ clk _01551_ _18051_ VPWR VGND sg13g2_dfrbpq_1
X_38488_ \memory_i.freq_inst.X_o[15]\ clk _01552_ _18050_ VPWR VGND sg13g2_dfrbpq_1
X_38489_ \memory_i.freq_inst.X_o[16]\ clk _01553_ _18049_ VPWR VGND sg13g2_dfrbpq_1
X_38490_ \memory_i.freq_inst.X_o[17]\ clk _01554_ _18048_ VPWR VGND sg13g2_dfrbpq_1
X_38491_ \memory_i.freq_inst.X_o[18]\ clk _01555_ _18047_ VPWR VGND sg13g2_dfrbpq_1
X_38492_ \memory_i.freq_inst.X_o[19]\ clk _01556_ _18046_ VPWR VGND sg13g2_dfrbpq_1
X_38493_ \memory_i.freq_inst.X_o[20]\ clk _01557_ _18045_ VPWR VGND sg13g2_dfrbpq_1
X_38494_ \memory_i.freq_inst.X_o[21]\ clk _01558_ _18044_ VPWR VGND sg13g2_dfrbpq_1
X_38495_ \memory_i.freq_inst.X_o[22]\ clk _01559_ _18043_ VPWR VGND sg13g2_dfrbpq_1
X_38496_ \memory_i.freq_inst.X_o[23]\ clk _01560_ _18042_ VPWR VGND sg13g2_dfrbpq_1
X_38497_ \memory_i.freq_inst.X_o[24]\ clk _01561_ _18041_ VPWR VGND sg13g2_dfrbpq_1
X_38498_ \memory_i.freq_inst.X_o[25]\ clk _01562_ _18040_ VPWR VGND sg13g2_dfrbpq_1
X_38499_ \memory_i.freq_inst.X_o[26]\ clk _01563_ _18039_ VPWR VGND sg13g2_dfrbpq_1
X_38500_ \memory_i.freq_inst.X_o[27]\ clk _01564_ _18038_ VPWR VGND sg13g2_dfrbpq_1
X_38501_ \memory_i.freq_inst.X_o[28]\ clk _01565_ _18037_ VPWR VGND sg13g2_dfrbpq_1
X_38502_ \memory_i.freq_inst.X_o[29]\ clk _01566_ _18036_ VPWR VGND sg13g2_dfrbpq_1
X_38503_ \memory_i.freq_inst.dsmod_cos.data_interp_r[0]\ clk _01567_ _18035_ VPWR VGND sg13g2_dfrbpq_1
X_38504_ \memory_i.freq_inst.dsmod_cos.data_interp_r[1]\ clk _01568_ _18033_ VPWR VGND sg13g2_dfrbpq_1
X_38505_ \memory_i.freq_inst.dsmod_cos.data_interp_r[2]\ clk _01569_ _18031_ VPWR VGND sg13g2_dfrbpq_1
X_38506_ \memory_i.freq_inst.dsmod_cos.data_interp_r[3]\ clk _01570_ _18029_ VPWR VGND sg13g2_dfrbpq_1
X_38507_ \memory_i.freq_inst.dsmod_cos.data_interp_r[4]\ clk _01571_ _18027_ VPWR VGND sg13g2_dfrbpq_1
X_38508_ \memory_i.freq_inst.dsmod_cos.data_interp_r[5]\ clk _01572_ _18025_ VPWR VGND sg13g2_dfrbpq_1
X_38509_ \memory_i.freq_inst.dsmod_cos.data_interp_r[6]\ clk _01573_ _18023_ VPWR VGND sg13g2_dfrbpq_1
X_38510_ \memory_i.freq_inst.dsmod_cos.data_interp_r[7]\ clk _01574_ _18021_ VPWR VGND sg13g2_dfrbpq_1
X_38511_ \memory_i.freq_inst.dsmod_cos.data_interp_r[8]\ clk _01575_ _18019_ VPWR VGND sg13g2_dfrbpq_1
X_38512_ \memory_i.freq_inst.dsmod_cos.data_interp_r[9]\ clk _01576_ _18017_ VPWR VGND sg13g2_dfrbpq_1
X_38513_ \memory_i.freq_inst.dsmod_cos.data_interp_r[10]\ clk _01577_ _18015_ VPWR VGND sg13g2_dfrbpq_1
X_38514_ \memory_i.freq_inst.dsmod_cos.data_interp_r[11]\ clk _01578_ _18013_ VPWR VGND sg13g2_dfrbpq_1
X_38515_ \memory_i.freq_inst.dsmod_cos.data_interp_r[12]\ clk _01579_ _18011_ VPWR VGND sg13g2_dfrbpq_1
X_38516_ \memory_i.freq_inst.dsmod_cos.data_interp_r[13]\ clk _01580_ _18009_ VPWR VGND sg13g2_dfrbpq_1
X_38517_ \memory_i.freq_inst.dsmod_cos.data_interp_r[14]\ clk _01581_ _18007_ VPWR VGND sg13g2_dfrbpq_1
X_38518_ \memory_i.freq_inst.dsmod_cos.data_interp_r[15]\ clk _01582_ _18005_ VPWR VGND sg13g2_dfrbpq_1
X_38519_ \memory_i.freq_inst.dsmod_cos.data_interp_r[16]\ clk _01583_ _17938_ VPWR VGND sg13g2_dfrbpq_1
X_38520_ \memory_i.freq_inst.dsmod_cos.data_interp_r[17]\ clk _01584_ _17934_ VPWR VGND sg13g2_dfrbpq_1
X_38521_ \memory_i.freq_inst.dsmod_cos.data_interp_r[18]\ clk _01585_ _17930_ VPWR VGND sg13g2_dfrbpq_1
X_38522_ \memory_i.freq_inst.dsmod_cos.data_interp_r[19]\ clk _01586_ _17926_ VPWR VGND sg13g2_dfrbpq_1
X_38523_ \memory_i.freq_inst.dsmod_cos.data_interp_r[20]\ clk _01587_ _17922_ VPWR VGND sg13g2_dfrbpq_1
X_38524_ \memory_i.freq_inst.dsmod_cos.data_interp_r[21]\ clk _01588_ _17918_ VPWR VGND sg13g2_dfrbpq_1
X_38525_ \memory_i.freq_inst.dsmod_cos.data_interp_r[22]\ clk _01589_ _17914_ VPWR VGND sg13g2_dfrbpq_1
X_38526_ \memory_i.freq_inst.dsmod_cos.data_interp_r[23]\ clk _01590_ _17910_ VPWR VGND sg13g2_dfrbpq_1
X_38527_ \memory_i.freq_inst.dsmod_cos.data_interp_r[24]\ clk _01591_ _17906_ VPWR VGND sg13g2_dfrbpq_1
X_38528_ \memory_i.freq_inst.dsmod_cos.data_interp_r[25]\ clk _01592_ _17902_ VPWR VGND sg13g2_dfrbpq_1
X_38529_ \memory_i.freq_inst.dsmod_cos.data_interp_r[26]\ clk _01593_ _17898_ VPWR VGND sg13g2_dfrbpq_1
X_38530_ \memory_i.freq_inst.dsmod_cos.data_interp_r[27]\ clk _01594_ _17894_ VPWR VGND sg13g2_dfrbpq_1
X_38531_ \memory_i.freq_inst.dsmod_cos.data_interp_r[28]\ clk _01595_ _17890_ VPWR VGND sg13g2_dfrbpq_1
X_38532_ \memory_i.freq_inst.dsmod_cos.data_interp_r[29]\ clk _01596_ _17886_ VPWR VGND sg13g2_dfrbpq_1
X_38533_ \memory_i.freq_inst.dsmod_cos.data_interp_r[30]\ clk _01597_ _19507_ VPWR VGND sg13g2_dfrbpq_1
X_38534_ \memory_i.freq_inst.dsmod_cos.data_interp_r[31]\ clk _01598_ _19503_ VPWR VGND sg13g2_dfrbpq_1
X_38535_ \memory_i.freq_inst.dsmod_cos.data_interp_r[32]\ clk _01599_ _19499_ VPWR VGND sg13g2_dfrbpq_1
X_38536_ \memory_i.freq_inst.dsmod_cos.data_interp_r[33]\ clk _01600_ _19495_ VPWR VGND sg13g2_dfrbpq_1
X_38537_ \memory_i.freq_inst.dsmod_cos.data_interp_r[34]\ clk _01601_ _19491_ VPWR VGND sg13g2_dfrbpq_1
X_38538_ \memory_i.freq_inst.dsmod_cos.data_interp_r[35]\ clk _01602_ _19487_ VPWR VGND sg13g2_dfrbpq_1
X_38539_ \memory_i.freq_inst.dsmod_cos.data_interp_r[36]\ clk _01603_ _19483_ VPWR VGND sg13g2_dfrbpq_1
X_38540_ \memory_i.freq_inst.dsmod_cos.data_interp_r[37]\ clk _01604_ _19479_ VPWR VGND sg13g2_dfrbpq_1
X_38541_ \memory_i.freq_inst.dsmod_cos.data_step_r[0]\ clk _01605_ _19475_ VPWR VGND sg13g2_dfrbpq_1
X_38542_ \memory_i.freq_inst.dsmod_cos.data_step_r[1]\ clk _01606_ _19471_ VPWR VGND sg13g2_dfrbpq_1
X_38543_ \memory_i.freq_inst.dsmod_cos.data_step_r[2]\ clk _01607_ _19467_ VPWR VGND sg13g2_dfrbpq_1
X_38544_ \memory_i.freq_inst.dsmod_cos.data_step_r[3]\ clk _01608_ _19463_ VPWR VGND sg13g2_dfrbpq_1
X_38545_ \memory_i.freq_inst.dsmod_cos.data_step_r[4]\ clk _01609_ _19457_ VPWR VGND sg13g2_dfrbpq_1
X_38546_ \memory_i.freq_inst.dsmod_cos.data_step_r[5]\ clk _01610_ _19453_ VPWR VGND sg13g2_dfrbpq_1
X_38547_ \memory_i.freq_inst.dsmod_cos.data_step_r[6]\ clk _01611_ _19449_ VPWR VGND sg13g2_dfrbpq_1
X_38548_ \memory_i.freq_inst.dsmod_cos.data_step_r[7]\ clk _01612_ _19445_ VPWR VGND sg13g2_dfrbpq_1
X_38549_ \memory_i.freq_inst.dsmod_cos.data_step_r[8]\ clk _01613_ _19441_ VPWR VGND sg13g2_dfrbpq_1
X_38550_ \memory_i.freq_inst.dsmod_cos.data_step_r[9]\ clk _01614_ _19437_ VPWR VGND sg13g2_dfrbpq_1
X_38551_ \memory_i.freq_inst.dsmod_cos.data_step_r[10]\ clk _01615_ _19433_ VPWR VGND sg13g2_dfrbpq_1
X_38552_ \memory_i.freq_inst.dsmod_cos.data_step_r[11]\ clk _01616_ _19429_ VPWR VGND sg13g2_dfrbpq_1
X_38553_ \memory_i.freq_inst.dsmod_cos.data_step_r[12]\ clk _01617_ _19425_ VPWR VGND sg13g2_dfrbpq_1
X_38554_ \memory_i.freq_inst.dsmod_cos.data_step_r[13]\ clk _01618_ _19421_ VPWR VGND sg13g2_dfrbpq_1
X_38555_ \memory_i.freq_inst.dsmod_cos.data_step_r[14]\ clk _01619_ _19417_ VPWR VGND sg13g2_dfrbpq_1
X_38556_ \memory_i.freq_inst.dsmod_cos.data_step_r[15]\ clk _01620_ _19413_ VPWR VGND sg13g2_dfrbpq_1
X_38557_ \memory_i.freq_inst.dsmod_cos.data_step_r[16]\ clk _01621_ _19409_ VPWR VGND sg13g2_dfrbpq_1
X_38558_ \memory_i.freq_inst.dsmod_cos.data_step_r[17]\ clk _01622_ _19405_ VPWR VGND sg13g2_dfrbpq_1
X_38559_ \memory_i.freq_inst.dsmod_cos.data_step_r[18]\ clk _01623_ _19401_ VPWR VGND sg13g2_dfrbpq_1
X_38560_ \memory_i.freq_inst.dsmod_cos.data_step_r[19]\ clk _01624_ _19397_ VPWR VGND sg13g2_dfrbpq_1
X_38561_ \memory_i.freq_inst.dsmod_cos.data_step_r[20]\ clk _01625_ _19393_ VPWR VGND sg13g2_dfrbpq_1
X_38562_ \memory_i.freq_inst.dsmod_cos.data_step_r[21]\ clk _01626_ _19389_ VPWR VGND sg13g2_dfrbpq_1
X_38563_ \memory_i.freq_inst.dsmod_cos.data_step_r[22]\ clk _01627_ _19385_ VPWR VGND sg13g2_dfrbpq_1
X_38564_ \memory_i.freq_inst.dsmod_cos.data_step_r[23]\ clk _01628_ _19381_ VPWR VGND sg13g2_dfrbpq_1
X_38565_ \memory_i.freq_inst.dsmod_cos.data_step_r[24]\ clk _01629_ _19377_ VPWR VGND sg13g2_dfrbpq_1
X_38566_ \memory_i.freq_inst.dsmod_cos.data_step_r[25]\ clk _01630_ _19373_ VPWR VGND sg13g2_dfrbpq_1
X_38567_ \memory_i.freq_inst.dsmod_cos.data_step_r[26]\ clk _01631_ _19369_ VPWR VGND sg13g2_dfrbpq_1
X_38568_ \memory_i.freq_inst.dsmod_cos.data_step_r[27]\ clk _01632_ _19365_ VPWR VGND sg13g2_dfrbpq_1
X_38569_ \memory_i.freq_inst.dsmod_cos.data_step_r[28]\ clk _01633_ _19361_ VPWR VGND sg13g2_dfrbpq_1
X_38570_ \memory_i.freq_inst.dsmod_cos.data_step_r[29]\ clk _01634_ _19357_ VPWR VGND sg13g2_dfrbpq_1
X_38571_ \memory_i.freq_inst.dsmod_cos.data_step_r[30]\ clk _01635_ _19353_ VPWR VGND sg13g2_dfrbpq_1
X_38572_ \memory_i.freq_inst.dsmod_cos.data_step_r[31]\ clk _01636_ _19349_ VPWR VGND sg13g2_dfrbpq_1
X_38573_ \memory_i.freq_inst.dsmod_cos.data_step_r[32]\ clk _01637_ _19345_ VPWR VGND sg13g2_dfrbpq_1
X_38574_ \memory_i.freq_inst.dsmod_cos.accu1_r[0]\ clk _01638_ _19341_ VPWR VGND sg13g2_dfrbpq_1
X_38575_ \memory_i.freq_inst.dsmod_cos.accu1_r[1]\ clk _01639_ _19336_ VPWR VGND sg13g2_dfrbpq_1
X_38576_ \memory_i.freq_inst.dsmod_cos.accu1_r[2]\ clk _01640_ _19332_ VPWR VGND sg13g2_dfrbpq_1
X_38577_ \memory_i.freq_inst.dsmod_cos.accu1_r[3]\ clk _01641_ _19328_ VPWR VGND sg13g2_dfrbpq_1
X_38578_ \memory_i.freq_inst.dsmod_cos.accu1_r[4]\ clk _01642_ _19324_ VPWR VGND sg13g2_dfrbpq_1
X_38579_ \memory_i.freq_inst.dsmod_cos.accu1_r[5]\ clk _01643_ _19320_ VPWR VGND sg13g2_dfrbpq_1
X_38580_ \memory_i.freq_inst.dsmod_cos.accu1_r[6]\ clk _01644_ _19316_ VPWR VGND sg13g2_dfrbpq_1
X_38581_ \memory_i.freq_inst.dsmod_cos.accu1_r[7]\ clk _01645_ _19312_ VPWR VGND sg13g2_dfrbpq_1
X_38582_ \memory_i.freq_inst.dsmod_cos.accu1_r[8]\ clk _01646_ _19308_ VPWR VGND sg13g2_dfrbpq_1
X_38583_ \memory_i.freq_inst.dsmod_cos.accu1_r[9]\ clk _01647_ _19304_ VPWR VGND sg13g2_dfrbpq_1
X_38584_ \memory_i.freq_inst.dsmod_cos.accu1_r[10]\ clk _01648_ _19300_ VPWR VGND sg13g2_dfrbpq_1
X_38585_ \memory_i.freq_inst.dsmod_cos.accu1_r[11]\ clk _01649_ _19296_ VPWR VGND sg13g2_dfrbpq_1
X_38586_ \memory_i.freq_inst.dsmod_cos.accu1_r[12]\ clk _01650_ _19292_ VPWR VGND sg13g2_dfrbpq_1
X_38587_ \memory_i.freq_inst.dsmod_cos.accu1_r[13]\ clk _01651_ _19288_ VPWR VGND sg13g2_dfrbpq_1
X_38588_ \memory_i.freq_inst.dsmod_cos.accu1_r[14]\ clk _01652_ _19284_ VPWR VGND sg13g2_dfrbpq_1
X_38589_ \memory_i.freq_inst.dsmod_cos.accu1_r[15]\ clk _01653_ _19280_ VPWR VGND sg13g2_dfrbpq_1
X_38590_ \memory_i.freq_inst.dsmod_cos.accu1_r[16]\ clk _01654_ _19276_ VPWR VGND sg13g2_dfrbpq_1
X_38591_ \memory_i.freq_inst.dsmod_cos.accu1_r[17]\ clk _01655_ _19272_ VPWR VGND sg13g2_dfrbpq_1
X_38592_ \memory_i.freq_inst.dsmod_cos.accu1_r[18]\ clk _01656_ _19268_ VPWR VGND sg13g2_dfrbpq_1
X_38593_ \memory_i.freq_inst.dsmod_cos.accu1_r[19]\ clk _01657_ _19264_ VPWR VGND sg13g2_dfrbpq_1
X_38594_ \memory_i.freq_inst.dsmod_cos.accu1_r[20]\ clk _01658_ _19260_ VPWR VGND sg13g2_dfrbpq_1
X_38595_ \memory_i.freq_inst.dsmod_cos.accu1_r[21]\ clk _01659_ _19256_ VPWR VGND sg13g2_dfrbpq_1
X_38596_ \memory_i.freq_inst.dsmod_cos.accu1_r[22]\ clk _01660_ _19252_ VPWR VGND sg13g2_dfrbpq_1
X_38597_ \memory_i.freq_inst.dsmod_cos.accu1_r[23]\ clk _01661_ _19248_ VPWR VGND sg13g2_dfrbpq_1
X_38598_ \memory_i.freq_inst.dsmod_cos.accu1_r[24]\ clk _01662_ _19244_ VPWR VGND sg13g2_dfrbpq_1
X_38599_ \memory_i.freq_inst.dsmod_cos.accu1_r[25]\ clk _01663_ _19240_ VPWR VGND sg13g2_dfrbpq_1
X_38600_ \memory_i.freq_inst.dsmod_cos.accu1_r[26]\ clk _01664_ _19236_ VPWR VGND sg13g2_dfrbpq_1
X_38601_ \memory_i.freq_inst.dsmod_cos.accu1_r[27]\ clk _01665_ _19232_ VPWR VGND sg13g2_dfrbpq_1
X_38602_ \memory_i.freq_inst.dsmod_cos.accu1_r[28]\ clk _01666_ _19228_ VPWR VGND sg13g2_dfrbpq_1
X_38603_ \memory_i.freq_inst.dsmod_cos.accu1_r[29]\ clk _01667_ _19224_ VPWR VGND sg13g2_dfrbpq_1
X_38604_ \memory_i.freq_inst.dsmod_cos.accu1_r[30]\ clk _01668_ _19220_ VPWR VGND sg13g2_dfrbpq_1
X_38605_ \memory_i.freq_inst.dsmod_cos.accu1_r[31]\ clk _01669_ _19216_ VPWR VGND sg13g2_dfrbpq_1
X_38606_ \memory_i.freq_inst.dsmod_cos.accu1_r[32]\ clk _01670_ _19212_ VPWR VGND sg13g2_dfrbpq_1
X_38607_ \memory_i.freq_inst.dsmod_cos.accu1_r[33]\ clk _01671_ _19208_ VPWR VGND sg13g2_dfrbpq_1
X_38608_ \memory_i.freq_inst.dsmod_cos.accu1_r[34]\ clk _01672_ _19204_ VPWR VGND sg13g2_dfrbpq_1
X_38609_ \memory_i.freq_inst.dsmod_cos.accu1_r[35]\ clk _01673_ _19200_ VPWR VGND sg13g2_dfrbpq_1
X_38610_ \memory_i.freq_inst.dsmod_cos.accu1_r[36]\ clk _01674_ _19196_ VPWR VGND sg13g2_dfrbpq_1
X_38611_ \memory_i.freq_inst.dsmod_cos.accu1_r[37]\ clk _01675_ _19192_ VPWR VGND sg13g2_dfrbpq_1
X_38612_ \memory_i.freq_inst.dsmod_cos.accu1_r[38]\ clk _01676_ _19188_ VPWR VGND sg13g2_dfrbpq_1
X_38613_ \memory_i.freq_inst.dsmod_cos.accu1_r[39]\ clk _01677_ _19184_ VPWR VGND sg13g2_dfrbpq_1
X_38614_ \memory_i.freq_inst.dsmod_cos.accu2_r[0]\ clk _01678_ _19180_ VPWR VGND sg13g2_dfrbpq_1
X_38615_ \memory_i.freq_inst.dsmod_cos.accu2_r[1]\ clk _01679_ _19176_ VPWR VGND sg13g2_dfrbpq_1
X_38616_ \memory_i.freq_inst.dsmod_cos.accu2_r[2]\ clk _01680_ _19172_ VPWR VGND sg13g2_dfrbpq_1
X_38617_ \memory_i.freq_inst.dsmod_cos.accu2_r[3]\ clk _01681_ _19168_ VPWR VGND sg13g2_dfrbpq_1
X_38618_ \memory_i.freq_inst.dsmod_cos.accu2_r[4]\ clk _01682_ _19164_ VPWR VGND sg13g2_dfrbpq_1
X_38619_ \memory_i.freq_inst.dsmod_cos.accu2_r[5]\ clk _01683_ _19160_ VPWR VGND sg13g2_dfrbpq_1
X_38620_ \memory_i.freq_inst.dsmod_cos.accu2_r[6]\ clk _01684_ _19156_ VPWR VGND sg13g2_dfrbpq_1
X_38621_ \memory_i.freq_inst.dsmod_cos.accu2_r[7]\ clk _01685_ _19152_ VPWR VGND sg13g2_dfrbpq_1
X_38622_ \memory_i.freq_inst.dsmod_cos.accu2_r[8]\ clk _01686_ _19116_ VPWR VGND sg13g2_dfrbpq_1
X_38623_ \memory_i.freq_inst.dsmod_cos.accu2_r[9]\ clk _01687_ _19112_ VPWR VGND sg13g2_dfrbpq_1
X_38624_ \memory_i.freq_inst.dsmod_cos.accu2_r[10]\ clk _01688_ _19108_ VPWR VGND sg13g2_dfrbpq_1
X_38625_ \memory_i.freq_inst.dsmod_cos.accu2_r[11]\ clk _01689_ _19104_ VPWR VGND sg13g2_dfrbpq_1
X_38626_ \memory_i.freq_inst.dsmod_cos.accu2_r[12]\ clk _01690_ _19100_ VPWR VGND sg13g2_dfrbpq_1
X_38627_ \memory_i.freq_inst.dsmod_cos.accu2_r[13]\ clk _01691_ _19096_ VPWR VGND sg13g2_dfrbpq_1
X_38628_ \memory_i.freq_inst.dsmod_cos.accu2_r[14]\ clk _01692_ _19092_ VPWR VGND sg13g2_dfrbpq_1
X_38629_ \memory_i.freq_inst.dsmod_cos.accu2_r[15]\ clk _01693_ _19088_ VPWR VGND sg13g2_dfrbpq_1
X_38630_ \memory_i.freq_inst.dsmod_cos.accu2_r[16]\ clk _01694_ _19084_ VPWR VGND sg13g2_dfrbpq_1
X_38631_ \memory_i.freq_inst.dsmod_cos.accu2_r[17]\ clk _01695_ _19080_ VPWR VGND sg13g2_dfrbpq_1
X_38632_ \memory_i.freq_inst.dsmod_cos.accu2_r[18]\ clk _01696_ _19076_ VPWR VGND sg13g2_dfrbpq_1
X_38633_ \memory_i.freq_inst.dsmod_cos.accu2_r[19]\ clk _01697_ _19072_ VPWR VGND sg13g2_dfrbpq_1
X_38634_ \memory_i.freq_inst.dsmod_cos.accu2_r[20]\ clk _01698_ _19068_ VPWR VGND sg13g2_dfrbpq_1
X_38635_ \memory_i.freq_inst.dsmod_cos.accu2_r[21]\ clk _01699_ _19064_ VPWR VGND sg13g2_dfrbpq_1
X_38636_ \memory_i.freq_inst.dsmod_cos.accu2_r[22]\ clk _01700_ _19060_ VPWR VGND sg13g2_dfrbpq_1
X_38637_ \memory_i.freq_inst.dsmod_cos.accu2_r[23]\ clk _01701_ _19056_ VPWR VGND sg13g2_dfrbpq_1
X_38638_ \memory_i.freq_inst.dsmod_cos.accu2_r[24]\ clk _01702_ _19049_ VPWR VGND sg13g2_dfrbpq_1
X_38639_ \memory_i.freq_inst.dsmod_cos.accu2_r[25]\ clk _01703_ _19045_ VPWR VGND sg13g2_dfrbpq_1
X_38640_ \memory_i.freq_inst.dsmod_cos.accu2_r[26]\ clk _01704_ _19041_ VPWR VGND sg13g2_dfrbpq_1
X_38641_ \memory_i.freq_inst.dsmod_cos.accu2_r[27]\ clk _01705_ _19037_ VPWR VGND sg13g2_dfrbpq_1
X_38642_ \memory_i.freq_inst.dsmod_cos.accu2_r[28]\ clk _01706_ _19033_ VPWR VGND sg13g2_dfrbpq_1
X_38643_ \memory_i.freq_inst.dsmod_cos.accu2_r[29]\ clk _01707_ _19029_ VPWR VGND sg13g2_dfrbpq_1
X_38644_ \memory_i.freq_inst.dsmod_cos.accu2_r[30]\ clk _01708_ _19025_ VPWR VGND sg13g2_dfrbpq_1
X_38645_ \memory_i.freq_inst.dsmod_cos.accu2_r[31]\ clk _01709_ _19021_ VPWR VGND sg13g2_dfrbpq_1
X_38646_ \memory_i.freq_inst.dsmod_cos.accu2_r[32]\ clk _01710_ _19017_ VPWR VGND sg13g2_dfrbpq_1
X_38647_ \memory_i.freq_inst.dsmod_cos.accu2_r[33]\ clk _01711_ _19013_ VPWR VGND sg13g2_dfrbpq_1
X_38648_ \memory_i.freq_inst.dsmod_cos.accu2_r[34]\ clk _01712_ _19009_ VPWR VGND sg13g2_dfrbpq_1
X_38649_ \memory_i.freq_inst.dsmod_cos.accu2_r[35]\ clk _01713_ _19005_ VPWR VGND sg13g2_dfrbpq_1
X_38650_ \memory_i.freq_inst.dsmod_cos.accu2_r[36]\ clk _01714_ _19001_ VPWR VGND sg13g2_dfrbpq_1
X_38651_ \memory_i.freq_inst.dsmod_cos.accu2_r[37]\ clk _01715_ _18997_ VPWR VGND sg13g2_dfrbpq_1
X_38652_ \memory_i.freq_inst.dsmod_cos.accu2_r[38]\ clk _01716_ _18993_ VPWR VGND sg13g2_dfrbpq_1
X_38653_ \memory_i.freq_inst.dsmod_cos.accu2_r[39]\ clk _01717_ _18989_ VPWR VGND sg13g2_dfrbpq_1
X_38654_ \memory_i.freq_inst.dsmod_cos.accu2_r[40]\ clk _01718_ _18985_ VPWR VGND sg13g2_dfrbpq_1
X_38655_ \memory_i.freq_inst.dsmod_cos.accu2_r[41]\ clk _01719_ _18881_ VPWR VGND sg13g2_dfrbpq_1
X_38656_ \memory_i.freq_inst.dsmod_cos.accu3_r[0]\ clk _01720_ _18877_ VPWR VGND sg13g2_dfrbpq_1
X_38657_ \memory_i.freq_inst.dsmod_cos.accu3_r[1]\ clk _01721_ _18873_ VPWR VGND sg13g2_dfrbpq_1
X_38658_ \memory_i.freq_inst.dsmod_cos.accu3_r[2]\ clk _01722_ _18869_ VPWR VGND sg13g2_dfrbpq_1
X_38659_ \memory_i.freq_inst.dsmod_cos.accu3_r[3]\ clk _01723_ _18865_ VPWR VGND sg13g2_dfrbpq_1
X_38660_ \memory_i.freq_inst.dsmod_cos.accu3_r[4]\ clk _01724_ _18861_ VPWR VGND sg13g2_dfrbpq_1
X_38661_ \memory_i.freq_inst.dsmod_cos.accu3_r[5]\ clk _01725_ _18857_ VPWR VGND sg13g2_dfrbpq_1
X_38662_ \memory_i.freq_inst.dsmod_cos.accu3_r[6]\ clk _01726_ _18853_ VPWR VGND sg13g2_dfrbpq_1
X_38663_ \memory_i.freq_inst.dsmod_cos.accu3_r[7]\ clk _01727_ _18849_ VPWR VGND sg13g2_dfrbpq_1
X_38664_ \memory_i.freq_inst.dsmod_cos.accu3_r[8]\ clk _01728_ _18845_ VPWR VGND sg13g2_dfrbpq_1
X_38665_ \memory_i.freq_inst.dsmod_cos.accu3_r[9]\ clk _01729_ _18841_ VPWR VGND sg13g2_dfrbpq_1
X_38666_ \memory_i.freq_inst.dsmod_cos.accu3_r[10]\ clk _01730_ _18837_ VPWR VGND sg13g2_dfrbpq_1
X_38667_ \memory_i.freq_inst.dsmod_cos.accu3_r[11]\ clk _01731_ _18833_ VPWR VGND sg13g2_dfrbpq_1
X_38668_ \memory_i.freq_inst.dsmod_cos.accu3_r[12]\ clk _01732_ _18829_ VPWR VGND sg13g2_dfrbpq_1
X_38669_ \memory_i.freq_inst.dsmod_cos.accu3_r[13]\ clk _01733_ _18825_ VPWR VGND sg13g2_dfrbpq_1
X_38670_ \memory_i.freq_inst.dsmod_cos.accu3_r[14]\ clk _01734_ _18821_ VPWR VGND sg13g2_dfrbpq_1
X_38671_ \memory_i.freq_inst.dsmod_cos.accu3_r[15]\ clk _01735_ _18817_ VPWR VGND sg13g2_dfrbpq_1
X_38672_ \memory_i.freq_inst.dsmod_cos.accu3_r[16]\ clk _01736_ _18813_ VPWR VGND sg13g2_dfrbpq_1
X_38673_ \memory_i.freq_inst.dsmod_cos.accu3_r[17]\ clk _01737_ _18809_ VPWR VGND sg13g2_dfrbpq_1
X_38674_ \memory_i.freq_inst.dsmod_cos.accu3_r[18]\ clk _01738_ _18805_ VPWR VGND sg13g2_dfrbpq_1
X_38675_ \memory_i.freq_inst.dsmod_cos.accu3_r[19]\ clk _01739_ _18801_ VPWR VGND sg13g2_dfrbpq_1
X_38676_ \memory_i.freq_inst.dsmod_cos.accu3_r[20]\ clk _01740_ _18797_ VPWR VGND sg13g2_dfrbpq_1
X_38677_ \memory_i.freq_inst.dsmod_cos.accu3_r[21]\ clk _01741_ _18793_ VPWR VGND sg13g2_dfrbpq_1
X_38678_ \memory_i.freq_inst.dsmod_cos.accu3_r[22]\ clk _01742_ _18789_ VPWR VGND sg13g2_dfrbpq_1
X_38679_ \memory_i.freq_inst.dsmod_cos.accu3_r[23]\ clk _01743_ _18785_ VPWR VGND sg13g2_dfrbpq_1
X_38680_ \memory_i.freq_inst.dsmod_cos.accu3_r[24]\ clk _01744_ _18781_ VPWR VGND sg13g2_dfrbpq_1
X_38681_ \memory_i.freq_inst.dsmod_cos.accu3_r[25]\ clk _01745_ _18777_ VPWR VGND sg13g2_dfrbpq_1
X_38682_ \memory_i.freq_inst.dsmod_cos.accu3_r[26]\ clk _01746_ _18773_ VPWR VGND sg13g2_dfrbpq_1
X_38683_ \memory_i.freq_inst.dsmod_cos.accu3_r[27]\ clk _01747_ _18769_ VPWR VGND sg13g2_dfrbpq_1
X_38684_ \memory_i.freq_inst.dsmod_cos.accu3_r[28]\ clk _01748_ _18765_ VPWR VGND sg13g2_dfrbpq_1
X_38685_ \memory_i.freq_inst.dsmod_cos.accu3_r[29]\ clk _01749_ _18761_ VPWR VGND sg13g2_dfrbpq_1
X_38686_ \memory_i.freq_inst.dsmod_cos.accu3_r[30]\ clk _01750_ _18757_ VPWR VGND sg13g2_dfrbpq_1
X_38687_ \memory_i.freq_inst.dsmod_cos.accu3_r[31]\ clk _01751_ _18720_ VPWR VGND sg13g2_dfrbpq_1
X_38688_ \memory_i.freq_inst.dsmod_cos.accu3_r[32]\ clk _01752_ _18716_ VPWR VGND sg13g2_dfrbpq_1
X_38689_ \memory_i.freq_inst.dsmod_cos.accu3_r[33]\ clk _01753_ _18712_ VPWR VGND sg13g2_dfrbpq_1
X_38690_ \memory_i.freq_inst.dsmod_cos.accu3_r[34]\ clk _01754_ _18708_ VPWR VGND sg13g2_dfrbpq_1
X_38691_ \memory_i.freq_inst.dsmod_cos.accu3_r[35]\ clk _01755_ _18704_ VPWR VGND sg13g2_dfrbpq_1
X_38692_ \memory_i.freq_inst.dsmod_cos.accu3_r[36]\ clk _01756_ _18696_ VPWR VGND sg13g2_dfrbpq_1
X_38693_ \memory_i.freq_inst.dsmod_cos.accu3_r[37]\ clk _01757_ _18692_ VPWR VGND sg13g2_dfrbpq_1
X_38694_ \memory_i.freq_inst.dsmod_cos.accu3_r[38]\ clk _01758_ _18688_ VPWR VGND sg13g2_dfrbpq_1
X_38695_ \memory_i.freq_inst.dsmod_cos.accu3_r[39]\ clk _01759_ _18684_ VPWR VGND sg13g2_dfrbpq_1
X_38696_ \memory_i.freq_inst.dsmod_cos.accu3_r[40]\ clk _01760_ _18680_ VPWR VGND sg13g2_dfrbpq_1
X_38697_ \memory_i.freq_inst.dsmod_cos.accu3_r[41]\ clk _01761_ _18676_ VPWR VGND sg13g2_dfrbpq_1
X_38698_ \memory_i.freq_inst.dsmod_cos.fetch_ctr_r[0]\ clk _01762_ _18672_ VPWR VGND sg13g2_dfrbpq_1
X_38699_ \memory_i.freq_inst.dsmod_cos.fetch_ctr_r[1]\ clk _01763_ _18668_ VPWR VGND sg13g2_dfrbpq_1
X_38700_ \memory_i.freq_inst.dsmod_cos.fetch_ctr_r[2]\ clk _01764_ _18664_ VPWR VGND sg13g2_dfrbpq_1
X_38701_ \memory_i.freq_inst.dsmod_cos.fetch_ctr_r[3]\ clk _01765_ _18660_ VPWR VGND sg13g2_dfrbpq_1
X_38702_ \memory_i.freq_inst.dsmod_cos.fetch_ctr_r[4]\ clk _01766_ _18656_ VPWR VGND sg13g2_dfrbpq_1
X_38703_ \memory_i.freq_inst.dsmod_cos.fetch_ctr_r[5]\ clk _01767_ _18652_ VPWR VGND sg13g2_dfrbpq_1
X_38704_ \memory_i.freq_inst.dsmod_cos.fetch_ctr_r[6]\ clk _01768_ _18648_ VPWR VGND sg13g2_dfrbpq_1
X_38705_ \memory_i.freq_inst.dsmod_cos.fetch_ctr_r[7]\ clk _01769_ _18644_ VPWR VGND sg13g2_dfrbpq_1
X_38706_ \memory_i.freq_inst.dsmod_sin.data_interp_r[0]\ clk _01770_ _18640_ VPWR VGND sg13g2_dfrbpq_1
X_38707_ \memory_i.freq_inst.dsmod_sin.data_interp_r[1]\ clk _01771_ _18636_ VPWR VGND sg13g2_dfrbpq_1
X_38708_ \memory_i.freq_inst.dsmod_sin.data_interp_r[2]\ clk _01772_ _18632_ VPWR VGND sg13g2_dfrbpq_1
X_38709_ \memory_i.freq_inst.dsmod_sin.data_interp_r[3]\ clk _01773_ _18628_ VPWR VGND sg13g2_dfrbpq_1
X_38710_ \memory_i.freq_inst.dsmod_sin.data_interp_r[4]\ clk _01774_ _18624_ VPWR VGND sg13g2_dfrbpq_1
X_38711_ \memory_i.freq_inst.dsmod_sin.data_interp_r[5]\ clk _01775_ _18620_ VPWR VGND sg13g2_dfrbpq_1
X_38712_ \memory_i.freq_inst.dsmod_sin.data_interp_r[6]\ clk _01776_ _18616_ VPWR VGND sg13g2_dfrbpq_1
X_38713_ \memory_i.freq_inst.dsmod_sin.data_interp_r[7]\ clk _01777_ _18612_ VPWR VGND sg13g2_dfrbpq_1
X_38714_ \memory_i.freq_inst.dsmod_sin.data_interp_r[8]\ clk _01778_ _18608_ VPWR VGND sg13g2_dfrbpq_1
X_38715_ \memory_i.freq_inst.dsmod_sin.data_interp_r[9]\ clk _01779_ _18604_ VPWR VGND sg13g2_dfrbpq_1
X_38716_ \memory_i.freq_inst.dsmod_sin.data_interp_r[10]\ clk _01780_ _18600_ VPWR VGND sg13g2_dfrbpq_1
X_38717_ \memory_i.freq_inst.dsmod_sin.data_interp_r[11]\ clk _01781_ _18596_ VPWR VGND sg13g2_dfrbpq_1
X_38718_ \memory_i.freq_inst.dsmod_sin.data_interp_r[12]\ clk _01782_ _18592_ VPWR VGND sg13g2_dfrbpq_1
X_38719_ \memory_i.freq_inst.dsmod_sin.data_interp_r[13]\ clk _01783_ _18588_ VPWR VGND sg13g2_dfrbpq_1
X_38720_ \memory_i.freq_inst.dsmod_sin.data_interp_r[14]\ clk _01784_ _18584_ VPWR VGND sg13g2_dfrbpq_1
X_38721_ \memory_i.freq_inst.dsmod_sin.data_interp_r[15]\ clk _01785_ _18580_ VPWR VGND sg13g2_dfrbpq_1
X_38722_ \memory_i.freq_inst.dsmod_sin.data_interp_r[16]\ clk _01786_ _18576_ VPWR VGND sg13g2_dfrbpq_1
X_38723_ \memory_i.freq_inst.dsmod_sin.data_interp_r[17]\ clk _01787_ _18572_ VPWR VGND sg13g2_dfrbpq_1
X_38724_ \memory_i.freq_inst.dsmod_sin.data_interp_r[18]\ clk _01788_ _18568_ VPWR VGND sg13g2_dfrbpq_1
X_38725_ \memory_i.freq_inst.dsmod_sin.data_interp_r[19]\ clk _01789_ _18564_ VPWR VGND sg13g2_dfrbpq_1
X_38726_ \memory_i.freq_inst.dsmod_sin.data_interp_r[20]\ clk _01790_ _18560_ VPWR VGND sg13g2_dfrbpq_1
X_38727_ \memory_i.freq_inst.dsmod_sin.data_interp_r[21]\ clk _01791_ _18556_ VPWR VGND sg13g2_dfrbpq_1
X_38728_ \memory_i.freq_inst.dsmod_sin.data_interp_r[22]\ clk _01792_ _18552_ VPWR VGND sg13g2_dfrbpq_1
X_38729_ \memory_i.freq_inst.dsmod_sin.data_interp_r[23]\ clk _01793_ _18548_ VPWR VGND sg13g2_dfrbpq_1
X_38730_ \memory_i.freq_inst.dsmod_sin.data_interp_r[24]\ clk _01794_ _18544_ VPWR VGND sg13g2_dfrbpq_1
X_38731_ \memory_i.freq_inst.dsmod_sin.data_interp_r[25]\ clk _01795_ _18540_ VPWR VGND sg13g2_dfrbpq_1
X_38732_ \memory_i.freq_inst.dsmod_sin.data_interp_r[26]\ clk _01796_ _18536_ VPWR VGND sg13g2_dfrbpq_1
X_38733_ \memory_i.freq_inst.dsmod_sin.data_interp_r[27]\ clk _01797_ _18532_ VPWR VGND sg13g2_dfrbpq_1
X_38734_ \memory_i.freq_inst.dsmod_sin.data_interp_r[28]\ clk _01798_ _18528_ VPWR VGND sg13g2_dfrbpq_1
X_38735_ \memory_i.freq_inst.dsmod_sin.data_interp_r[29]\ clk _01799_ _18524_ VPWR VGND sg13g2_dfrbpq_1
X_38736_ \memory_i.freq_inst.dsmod_sin.data_interp_r[30]\ clk _01800_ _18520_ VPWR VGND sg13g2_dfrbpq_1
X_38737_ \memory_i.freq_inst.dsmod_sin.data_interp_r[31]\ clk _01801_ _18516_ VPWR VGND sg13g2_dfrbpq_1
X_38738_ \memory_i.freq_inst.dsmod_sin.data_interp_r[32]\ clk _01802_ _18512_ VPWR VGND sg13g2_dfrbpq_1
X_38739_ \memory_i.freq_inst.dsmod_sin.data_interp_r[33]\ clk _01803_ _18508_ VPWR VGND sg13g2_dfrbpq_1
X_38740_ \memory_i.freq_inst.dsmod_sin.data_interp_r[34]\ clk _01804_ _18504_ VPWR VGND sg13g2_dfrbpq_1
X_38741_ \memory_i.freq_inst.dsmod_sin.data_interp_r[35]\ clk _01805_ _18500_ VPWR VGND sg13g2_dfrbpq_1
X_38742_ \memory_i.freq_inst.dsmod_sin.data_interp_r[36]\ clk _01806_ _18496_ VPWR VGND sg13g2_dfrbpq_1
X_38743_ \memory_i.freq_inst.dsmod_sin.data_interp_r[37]\ clk _01807_ _18492_ VPWR VGND sg13g2_dfrbpq_1
X_38744_ \memory_i.freq_inst.dsmod_sin.data_step_r[0]\ clk _01808_ _18488_ VPWR VGND sg13g2_dfrbpq_1
X_38745_ \memory_i.freq_inst.dsmod_sin.data_step_r[1]\ clk _01809_ _18484_ VPWR VGND sg13g2_dfrbpq_1
X_38746_ \memory_i.freq_inst.dsmod_sin.data_step_r[2]\ clk _01810_ _18480_ VPWR VGND sg13g2_dfrbpq_1
X_38747_ \memory_i.freq_inst.dsmod_sin.data_step_r[3]\ clk _01811_ _18476_ VPWR VGND sg13g2_dfrbpq_1
X_38748_ \memory_i.freq_inst.dsmod_sin.data_step_r[4]\ clk _01812_ _18472_ VPWR VGND sg13g2_dfrbpq_1
X_38749_ \memory_i.freq_inst.dsmod_sin.data_step_r[5]\ clk _01813_ _18468_ VPWR VGND sg13g2_dfrbpq_1
X_38750_ \memory_i.freq_inst.dsmod_sin.data_step_r[6]\ clk _01814_ _18464_ VPWR VGND sg13g2_dfrbpq_1
X_38751_ \memory_i.freq_inst.dsmod_sin.data_step_r[7]\ clk _01815_ _18460_ VPWR VGND sg13g2_dfrbpq_1
X_38752_ \memory_i.freq_inst.dsmod_sin.data_step_r[8]\ clk _01816_ _18456_ VPWR VGND sg13g2_dfrbpq_1
X_38753_ \memory_i.freq_inst.dsmod_sin.data_step_r[9]\ clk _01817_ _18452_ VPWR VGND sg13g2_dfrbpq_1
X_38754_ \memory_i.freq_inst.dsmod_sin.data_step_r[10]\ clk _01818_ _18448_ VPWR VGND sg13g2_dfrbpq_1
X_38755_ \memory_i.freq_inst.dsmod_sin.data_step_r[11]\ clk _01819_ _18444_ VPWR VGND sg13g2_dfrbpq_1
X_38756_ \memory_i.freq_inst.dsmod_sin.data_step_r[12]\ clk _01820_ _18440_ VPWR VGND sg13g2_dfrbpq_1
X_38757_ \memory_i.freq_inst.dsmod_sin.data_step_r[13]\ clk _01821_ _18436_ VPWR VGND sg13g2_dfrbpq_1
X_38758_ \memory_i.freq_inst.dsmod_sin.data_step_r[14]\ clk _01822_ _18432_ VPWR VGND sg13g2_dfrbpq_1
X_38759_ \memory_i.freq_inst.dsmod_sin.data_step_r[15]\ clk _01823_ _18428_ VPWR VGND sg13g2_dfrbpq_1
X_38760_ \memory_i.freq_inst.dsmod_sin.data_step_r[16]\ clk _01824_ _18394_ VPWR VGND sg13g2_dfrbpq_1
X_38761_ \memory_i.freq_inst.dsmod_sin.data_step_r[17]\ clk _01825_ _18390_ VPWR VGND sg13g2_dfrbpq_1
X_38762_ \memory_i.freq_inst.dsmod_sin.data_step_r[18]\ clk _01826_ _18386_ VPWR VGND sg13g2_dfrbpq_1
X_38763_ \memory_i.freq_inst.dsmod_sin.data_step_r[19]\ clk _01827_ _18382_ VPWR VGND sg13g2_dfrbpq_1
X_38764_ \memory_i.freq_inst.dsmod_sin.data_step_r[20]\ clk _01828_ _18378_ VPWR VGND sg13g2_dfrbpq_1
X_38765_ \memory_i.freq_inst.dsmod_sin.data_step_r[21]\ clk _01829_ _18374_ VPWR VGND sg13g2_dfrbpq_1
X_38766_ \memory_i.freq_inst.dsmod_sin.data_step_r[22]\ clk _01830_ _18370_ VPWR VGND sg13g2_dfrbpq_1
X_38767_ \memory_i.freq_inst.dsmod_sin.data_step_r[23]\ clk _01831_ _18366_ VPWR VGND sg13g2_dfrbpq_1
X_38768_ \memory_i.freq_inst.dsmod_sin.data_step_r[24]\ clk _01832_ _18362_ VPWR VGND sg13g2_dfrbpq_1
X_38769_ \memory_i.freq_inst.dsmod_sin.data_step_r[25]\ clk _01833_ _18358_ VPWR VGND sg13g2_dfrbpq_1
X_38770_ \memory_i.freq_inst.dsmod_sin.data_step_r[26]\ clk _01834_ _18354_ VPWR VGND sg13g2_dfrbpq_1
X_38771_ \memory_i.freq_inst.dsmod_sin.data_step_r[27]\ clk _01835_ _18350_ VPWR VGND sg13g2_dfrbpq_1
X_38772_ \memory_i.freq_inst.dsmod_sin.data_step_r[28]\ clk _01836_ _18346_ VPWR VGND sg13g2_dfrbpq_1
X_38773_ \memory_i.freq_inst.dsmod_sin.data_step_r[29]\ clk _01837_ _18342_ VPWR VGND sg13g2_dfrbpq_1
X_38774_ \memory_i.freq_inst.dsmod_sin.data_step_r[30]\ clk _01838_ _18338_ VPWR VGND sg13g2_dfrbpq_1
X_38775_ \memory_i.freq_inst.dsmod_sin.data_step_r[31]\ clk _01839_ _18334_ VPWR VGND sg13g2_dfrbpq_1
X_38776_ \memory_i.freq_inst.dsmod_sin.data_step_r[32]\ clk _01840_ _18330_ VPWR VGND sg13g2_dfrbpq_1
X_38777_ \memory_i.freq_inst.dsmod_sin.accu1_r[0]\ clk _01841_ _18326_ VPWR VGND sg13g2_dfrbpq_1
X_38778_ \memory_i.freq_inst.dsmod_sin.accu1_r[1]\ clk _01842_ _18322_ VPWR VGND sg13g2_dfrbpq_1
X_38779_ \memory_i.freq_inst.dsmod_sin.accu1_r[2]\ clk _01843_ _18318_ VPWR VGND sg13g2_dfrbpq_1
X_38780_ \memory_i.freq_inst.dsmod_sin.accu1_r[3]\ clk _01844_ _18314_ VPWR VGND sg13g2_dfrbpq_1
X_38781_ \memory_i.freq_inst.dsmod_sin.accu1_r[4]\ clk _01845_ _18310_ VPWR VGND sg13g2_dfrbpq_1
X_38782_ \memory_i.freq_inst.dsmod_sin.accu1_r[5]\ clk _01846_ _18306_ VPWR VGND sg13g2_dfrbpq_1
X_38783_ \memory_i.freq_inst.dsmod_sin.accu1_r[6]\ clk _01847_ _18302_ VPWR VGND sg13g2_dfrbpq_1
X_38784_ \memory_i.freq_inst.dsmod_sin.accu1_r[7]\ clk _01848_ _18298_ VPWR VGND sg13g2_dfrbpq_1
X_38785_ \memory_i.freq_inst.dsmod_sin.accu1_r[8]\ clk _01849_ _18294_ VPWR VGND sg13g2_dfrbpq_1
X_38786_ \memory_i.freq_inst.dsmod_sin.accu1_r[9]\ clk _01850_ _18290_ VPWR VGND sg13g2_dfrbpq_1
X_38787_ \memory_i.freq_inst.dsmod_sin.accu1_r[10]\ clk _01851_ _18286_ VPWR VGND sg13g2_dfrbpq_1
X_38788_ \memory_i.freq_inst.dsmod_sin.accu1_r[11]\ clk _01852_ _18282_ VPWR VGND sg13g2_dfrbpq_1
X_38789_ \memory_i.freq_inst.dsmod_sin.accu1_r[12]\ clk _01853_ _18278_ VPWR VGND sg13g2_dfrbpq_1
X_38790_ \memory_i.freq_inst.dsmod_sin.accu1_r[13]\ clk _01854_ _18274_ VPWR VGND sg13g2_dfrbpq_1
X_38791_ \memory_i.freq_inst.dsmod_sin.accu1_r[14]\ clk _01855_ _18270_ VPWR VGND sg13g2_dfrbpq_1
X_38792_ \memory_i.freq_inst.dsmod_sin.accu1_r[15]\ clk _01856_ _18266_ VPWR VGND sg13g2_dfrbpq_1
X_38793_ \memory_i.freq_inst.dsmod_sin.accu1_r[16]\ clk _01857_ _18262_ VPWR VGND sg13g2_dfrbpq_1
X_38794_ \memory_i.freq_inst.dsmod_sin.accu1_r[17]\ clk _01858_ _18258_ VPWR VGND sg13g2_dfrbpq_1
X_38795_ \memory_i.freq_inst.dsmod_sin.accu1_r[18]\ clk _01859_ _18254_ VPWR VGND sg13g2_dfrbpq_1
X_38796_ \memory_i.freq_inst.dsmod_sin.accu1_r[19]\ clk _01860_ _18250_ VPWR VGND sg13g2_dfrbpq_1
X_38797_ \memory_i.freq_inst.dsmod_sin.accu1_r[20]\ clk _01861_ _18246_ VPWR VGND sg13g2_dfrbpq_1
X_38798_ \memory_i.freq_inst.dsmod_sin.accu1_r[21]\ clk _01862_ _18242_ VPWR VGND sg13g2_dfrbpq_1
X_38799_ \memory_i.freq_inst.dsmod_sin.accu1_r[22]\ clk _01863_ _18238_ VPWR VGND sg13g2_dfrbpq_1
X_38800_ \memory_i.freq_inst.dsmod_sin.accu1_r[23]\ clk _01864_ _18234_ VPWR VGND sg13g2_dfrbpq_1
X_38801_ \memory_i.freq_inst.dsmod_sin.accu1_r[24]\ clk _01865_ _18230_ VPWR VGND sg13g2_dfrbpq_1
X_38802_ \memory_i.freq_inst.dsmod_sin.accu1_r[25]\ clk _01866_ _18226_ VPWR VGND sg13g2_dfrbpq_1
X_38803_ \memory_i.freq_inst.dsmod_sin.accu1_r[26]\ clk _01867_ _18222_ VPWR VGND sg13g2_dfrbpq_1
X_38804_ \memory_i.freq_inst.dsmod_sin.accu1_r[27]\ clk _01868_ _18218_ VPWR VGND sg13g2_dfrbpq_1
X_38805_ \memory_i.freq_inst.dsmod_sin.accu1_r[28]\ clk _01869_ _18214_ VPWR VGND sg13g2_dfrbpq_1
X_38806_ \memory_i.freq_inst.dsmod_sin.accu1_r[29]\ clk _01870_ _18210_ VPWR VGND sg13g2_dfrbpq_1
X_38807_ \memory_i.freq_inst.dsmod_sin.accu1_r[30]\ clk _01871_ _18206_ VPWR VGND sg13g2_dfrbpq_1
X_38808_ \memory_i.freq_inst.dsmod_sin.accu1_r[31]\ clk _01872_ _18202_ VPWR VGND sg13g2_dfrbpq_1
X_38809_ \memory_i.freq_inst.dsmod_sin.accu1_r[32]\ clk _01873_ _18198_ VPWR VGND sg13g2_dfrbpq_1
X_38810_ \memory_i.freq_inst.dsmod_sin.accu1_r[33]\ clk _01874_ _18194_ VPWR VGND sg13g2_dfrbpq_1
X_38811_ \memory_i.freq_inst.dsmod_sin.accu1_r[34]\ clk _01875_ _18190_ VPWR VGND sg13g2_dfrbpq_1
X_38812_ \memory_i.freq_inst.dsmod_sin.accu1_r[35]\ clk _01876_ _18186_ VPWR VGND sg13g2_dfrbpq_1
X_38813_ \memory_i.freq_inst.dsmod_sin.accu1_r[36]\ clk _01877_ _18182_ VPWR VGND sg13g2_dfrbpq_1
X_38814_ \memory_i.freq_inst.dsmod_sin.accu1_r[37]\ clk _01878_ _18178_ VPWR VGND sg13g2_dfrbpq_1
X_38815_ \memory_i.freq_inst.dsmod_sin.accu1_r[38]\ clk _01879_ _18174_ VPWR VGND sg13g2_dfrbpq_1
X_38816_ \memory_i.freq_inst.dsmod_sin.accu1_r[39]\ clk _01880_ _18170_ VPWR VGND sg13g2_dfrbpq_1
X_38817_ \memory_i.freq_inst.dsmod_sin.accu2_r[0]\ clk _01881_ _18166_ VPWR VGND sg13g2_dfrbpq_1
X_38818_ \memory_i.freq_inst.dsmod_sin.accu2_r[1]\ clk _01882_ _18162_ VPWR VGND sg13g2_dfrbpq_1
X_38819_ \memory_i.freq_inst.dsmod_sin.accu2_r[2]\ clk _01883_ _18158_ VPWR VGND sg13g2_dfrbpq_1
X_38820_ \memory_i.freq_inst.dsmod_sin.accu2_r[3]\ clk _01884_ _18154_ VPWR VGND sg13g2_dfrbpq_1
X_38821_ \memory_i.freq_inst.dsmod_sin.accu2_r[4]\ clk _01885_ _18150_ VPWR VGND sg13g2_dfrbpq_1
X_38822_ \memory_i.freq_inst.dsmod_sin.accu2_r[5]\ clk _01886_ _18146_ VPWR VGND sg13g2_dfrbpq_1
X_38823_ \memory_i.freq_inst.dsmod_sin.accu2_r[6]\ clk _01887_ _18142_ VPWR VGND sg13g2_dfrbpq_1
X_38824_ \memory_i.freq_inst.dsmod_sin.accu2_r[7]\ clk _01888_ _18138_ VPWR VGND sg13g2_dfrbpq_1
X_38825_ \memory_i.freq_inst.dsmod_sin.accu2_r[8]\ clk _01889_ _18134_ VPWR VGND sg13g2_dfrbpq_1
X_38826_ \memory_i.freq_inst.dsmod_sin.accu2_r[9]\ clk _01890_ _18130_ VPWR VGND sg13g2_dfrbpq_1
X_38827_ \memory_i.freq_inst.dsmod_sin.accu2_r[10]\ clk _01891_ _18126_ VPWR VGND sg13g2_dfrbpq_1
X_38828_ \memory_i.freq_inst.dsmod_sin.accu2_r[11]\ clk _01892_ _18032_ VPWR VGND sg13g2_dfrbpq_1
X_38829_ \memory_i.freq_inst.dsmod_sin.accu2_r[12]\ clk _01893_ _18028_ VPWR VGND sg13g2_dfrbpq_1
X_38830_ \memory_i.freq_inst.dsmod_sin.accu2_r[13]\ clk _01894_ _18024_ VPWR VGND sg13g2_dfrbpq_1
X_38831_ \memory_i.freq_inst.dsmod_sin.accu2_r[14]\ clk _01895_ _18020_ VPWR VGND sg13g2_dfrbpq_1
X_38832_ \memory_i.freq_inst.dsmod_sin.accu2_r[15]\ clk _01896_ _18016_ VPWR VGND sg13g2_dfrbpq_1
X_38833_ \memory_i.freq_inst.dsmod_sin.accu2_r[16]\ clk _01897_ _18012_ VPWR VGND sg13g2_dfrbpq_1
X_38834_ \memory_i.freq_inst.dsmod_sin.accu2_r[17]\ clk _01898_ _18008_ VPWR VGND sg13g2_dfrbpq_1
X_38835_ \memory_i.freq_inst.dsmod_sin.accu2_r[18]\ clk _01899_ _18004_ VPWR VGND sg13g2_dfrbpq_1
X_38836_ \memory_i.freq_inst.dsmod_sin.accu2_r[19]\ clk _01900_ _17932_ VPWR VGND sg13g2_dfrbpq_1
X_38837_ \memory_i.freq_inst.dsmod_sin.accu2_r[20]\ clk _01901_ _17924_ VPWR VGND sg13g2_dfrbpq_1
X_38838_ \memory_i.freq_inst.dsmod_sin.accu2_r[21]\ clk _01902_ _17916_ VPWR VGND sg13g2_dfrbpq_1
X_38839_ \memory_i.freq_inst.dsmod_sin.accu2_r[22]\ clk _01903_ _17908_ VPWR VGND sg13g2_dfrbpq_1
X_38840_ \memory_i.freq_inst.dsmod_sin.accu2_r[23]\ clk _01904_ _17900_ VPWR VGND sg13g2_dfrbpq_1
X_38841_ \memory_i.freq_inst.dsmod_sin.accu2_r[24]\ clk _01905_ _17892_ VPWR VGND sg13g2_dfrbpq_1
X_38842_ \memory_i.freq_inst.dsmod_sin.accu2_r[25]\ clk _01906_ _17884_ VPWR VGND sg13g2_dfrbpq_1
X_38843_ \memory_i.freq_inst.dsmod_sin.accu2_r[26]\ clk _01907_ _19501_ VPWR VGND sg13g2_dfrbpq_1
X_38844_ \memory_i.freq_inst.dsmod_sin.accu2_r[27]\ clk _01908_ _19493_ VPWR VGND sg13g2_dfrbpq_1
X_38845_ \memory_i.freq_inst.dsmod_sin.accu2_r[28]\ clk _01909_ _19485_ VPWR VGND sg13g2_dfrbpq_1
X_38846_ \memory_i.freq_inst.dsmod_sin.accu2_r[29]\ clk _01910_ _19477_ VPWR VGND sg13g2_dfrbpq_1
X_38847_ \memory_i.freq_inst.dsmod_sin.accu2_r[30]\ clk _01911_ _19469_ VPWR VGND sg13g2_dfrbpq_1
X_38848_ \memory_i.freq_inst.dsmod_sin.accu2_r[31]\ clk _01912_ _19459_ VPWR VGND sg13g2_dfrbpq_1
X_38849_ \memory_i.freq_inst.dsmod_sin.accu2_r[32]\ clk _01913_ _19451_ VPWR VGND sg13g2_dfrbpq_1
X_38850_ \memory_i.freq_inst.dsmod_sin.accu2_r[33]\ clk _01914_ _19443_ VPWR VGND sg13g2_dfrbpq_1
X_38851_ \memory_i.freq_inst.dsmod_sin.accu2_r[34]\ clk _01915_ _19435_ VPWR VGND sg13g2_dfrbpq_1
X_38852_ \memory_i.freq_inst.dsmod_sin.accu2_r[35]\ clk _01916_ _19427_ VPWR VGND sg13g2_dfrbpq_1
X_38853_ \memory_i.freq_inst.dsmod_sin.accu2_r[36]\ clk _01917_ _19419_ VPWR VGND sg13g2_dfrbpq_1
X_38854_ \memory_i.freq_inst.dsmod_sin.accu2_r[37]\ clk _01918_ _19411_ VPWR VGND sg13g2_dfrbpq_1
X_38855_ \memory_i.freq_inst.dsmod_sin.accu2_r[38]\ clk _01919_ _19403_ VPWR VGND sg13g2_dfrbpq_1
X_38856_ \memory_i.freq_inst.dsmod_sin.accu2_r[39]\ clk _01920_ _19395_ VPWR VGND sg13g2_dfrbpq_1
X_38857_ \memory_i.freq_inst.dsmod_sin.accu2_r[40]\ clk _01921_ _19387_ VPWR VGND sg13g2_dfrbpq_1
X_38858_ \memory_i.freq_inst.dsmod_sin.accu2_r[41]\ clk _01922_ _19379_ VPWR VGND sg13g2_dfrbpq_1
X_38859_ \memory_i.freq_inst.dsmod_sin.accu3_r[0]\ clk _01923_ _19371_ VPWR VGND sg13g2_dfrbpq_1
X_38860_ \memory_i.freq_inst.dsmod_sin.accu3_r[1]\ clk _01924_ _19363_ VPWR VGND sg13g2_dfrbpq_1
X_38861_ \memory_i.freq_inst.dsmod_sin.accu3_r[2]\ clk _01925_ _19355_ VPWR VGND sg13g2_dfrbpq_1
X_38862_ \memory_i.freq_inst.dsmod_sin.accu3_r[3]\ clk _01926_ _19347_ VPWR VGND sg13g2_dfrbpq_1
X_38863_ \memory_i.freq_inst.dsmod_sin.accu3_r[4]\ clk _01927_ _19338_ VPWR VGND sg13g2_dfrbpq_1
X_38864_ \memory_i.freq_inst.dsmod_sin.accu3_r[5]\ clk _01928_ _19330_ VPWR VGND sg13g2_dfrbpq_1
X_38865_ \memory_i.freq_inst.dsmod_sin.accu3_r[6]\ clk _01929_ _19322_ VPWR VGND sg13g2_dfrbpq_1
X_38866_ \memory_i.freq_inst.dsmod_sin.accu3_r[7]\ clk _01930_ _19314_ VPWR VGND sg13g2_dfrbpq_1
X_38867_ \memory_i.freq_inst.dsmod_sin.accu3_r[8]\ clk _01931_ _19306_ VPWR VGND sg13g2_dfrbpq_1
X_38868_ \memory_i.freq_inst.dsmod_sin.accu3_r[9]\ clk _01932_ _19298_ VPWR VGND sg13g2_dfrbpq_1
X_38869_ \memory_i.freq_inst.dsmod_sin.accu3_r[10]\ clk _01933_ _19290_ VPWR VGND sg13g2_dfrbpq_1
X_38870_ \memory_i.freq_inst.dsmod_sin.accu3_r[11]\ clk _01934_ _19282_ VPWR VGND sg13g2_dfrbpq_1
X_38871_ \memory_i.freq_inst.dsmod_sin.accu3_r[12]\ clk _01935_ _19274_ VPWR VGND sg13g2_dfrbpq_1
X_38872_ \memory_i.freq_inst.dsmod_sin.accu3_r[13]\ clk _01936_ _19266_ VPWR VGND sg13g2_dfrbpq_1
X_38873_ \memory_i.freq_inst.dsmod_sin.accu3_r[14]\ clk _01937_ _19258_ VPWR VGND sg13g2_dfrbpq_1
X_38874_ \memory_i.freq_inst.dsmod_sin.accu3_r[15]\ clk _01938_ _19250_ VPWR VGND sg13g2_dfrbpq_1
X_38875_ \memory_i.freq_inst.dsmod_sin.accu3_r[16]\ clk _01939_ _19242_ VPWR VGND sg13g2_dfrbpq_1
X_38876_ \memory_i.freq_inst.dsmod_sin.accu3_r[17]\ clk _01940_ _19234_ VPWR VGND sg13g2_dfrbpq_1
X_38877_ \memory_i.freq_inst.dsmod_sin.accu3_r[18]\ clk _01941_ _19226_ VPWR VGND sg13g2_dfrbpq_1
X_38878_ \memory_i.freq_inst.dsmod_sin.accu3_r[19]\ clk _01942_ _19218_ VPWR VGND sg13g2_dfrbpq_1
X_38879_ \memory_i.freq_inst.dsmod_sin.accu3_r[20]\ clk _01943_ _19210_ VPWR VGND sg13g2_dfrbpq_1
X_38880_ \memory_i.freq_inst.dsmod_sin.accu3_r[21]\ clk _01944_ _19202_ VPWR VGND sg13g2_dfrbpq_1
X_38881_ \memory_i.freq_inst.dsmod_sin.accu3_r[22]\ clk _01945_ _19194_ VPWR VGND sg13g2_dfrbpq_1
X_38882_ \memory_i.freq_inst.dsmod_sin.accu3_r[23]\ clk _01946_ _19186_ VPWR VGND sg13g2_dfrbpq_1
X_38883_ \memory_i.freq_inst.dsmod_sin.accu3_r[24]\ clk _01947_ _19178_ VPWR VGND sg13g2_dfrbpq_1
X_38884_ \memory_i.freq_inst.dsmod_sin.accu3_r[25]\ clk _01948_ _19170_ VPWR VGND sg13g2_dfrbpq_1
X_38885_ \memory_i.freq_inst.dsmod_sin.accu3_r[26]\ clk _01949_ _19162_ VPWR VGND sg13g2_dfrbpq_1
X_38886_ \memory_i.freq_inst.dsmod_sin.accu3_r[27]\ clk _01950_ _19154_ VPWR VGND sg13g2_dfrbpq_1
X_38887_ \memory_i.freq_inst.dsmod_sin.accu3_r[28]\ clk _01951_ _19114_ VPWR VGND sg13g2_dfrbpq_1
X_38888_ \memory_i.freq_inst.dsmod_sin.accu3_r[29]\ clk _01952_ _19106_ VPWR VGND sg13g2_dfrbpq_1
X_38889_ \memory_i.freq_inst.dsmod_sin.accu3_r[30]\ clk _01953_ _19098_ VPWR VGND sg13g2_dfrbpq_1
X_38890_ \memory_i.freq_inst.dsmod_sin.accu3_r[31]\ clk _01954_ _19090_ VPWR VGND sg13g2_dfrbpq_1
X_38891_ \memory_i.freq_inst.dsmod_sin.accu3_r[32]\ clk _01955_ _19082_ VPWR VGND sg13g2_dfrbpq_1
X_38892_ \memory_i.freq_inst.dsmod_sin.accu3_r[33]\ clk _01956_ _19074_ VPWR VGND sg13g2_dfrbpq_1
X_38893_ \memory_i.freq_inst.dsmod_sin.accu3_r[34]\ clk _01957_ _19066_ VPWR VGND sg13g2_dfrbpq_1
X_38894_ \memory_i.freq_inst.dsmod_sin.accu3_r[35]\ clk _01958_ _19058_ VPWR VGND sg13g2_dfrbpq_1
X_38895_ \memory_i.freq_inst.dsmod_sin.accu3_r[36]\ clk _01959_ _19047_ VPWR VGND sg13g2_dfrbpq_1
X_38896_ \memory_i.freq_inst.dsmod_sin.accu3_r[37]\ clk _01960_ _19039_ VPWR VGND sg13g2_dfrbpq_1
X_38897_ \memory_i.freq_inst.dsmod_sin.accu3_r[38]\ clk _01961_ _19031_ VPWR VGND sg13g2_dfrbpq_1
X_38898_ \memory_i.freq_inst.dsmod_sin.accu3_r[39]\ clk _01962_ _19023_ VPWR VGND sg13g2_dfrbpq_1
X_38899_ \memory_i.freq_inst.dsmod_sin.accu3_r[40]\ clk _01963_ _19015_ VPWR VGND sg13g2_dfrbpq_1
X_38900_ \memory_i.freq_inst.dsmod_sin.accu3_r[41]\ clk _01964_ _19007_ VPWR VGND sg13g2_dfrbpq_1
X_38901_ \memory_i.freq_inst.dsmod_sin.fetch_ctr_r[0]\ clk _01965_ _18999_ VPWR VGND sg13g2_dfrbpq_1
X_38902_ \memory_i.freq_inst.dsmod_sin.fetch_ctr_r[1]\ clk _01966_ _18991_ VPWR VGND sg13g2_dfrbpq_1
X_38903_ \memory_i.freq_inst.dsmod_sin.fetch_ctr_r[2]\ clk _01967_ _18883_ VPWR VGND sg13g2_dfrbpq_1
X_38904_ \memory_i.freq_inst.dsmod_sin.fetch_ctr_r[3]\ clk _01968_ _18875_ VPWR VGND sg13g2_dfrbpq_1
X_38905_ \memory_i.freq_inst.dsmod_sin.fetch_ctr_r[4]\ clk _01969_ _18867_ VPWR VGND sg13g2_dfrbpq_1
X_38906_ \memory_i.freq_inst.dsmod_sin.fetch_ctr_r[5]\ clk _01970_ _18859_ VPWR VGND sg13g2_dfrbpq_1
X_38907_ \memory_i.freq_inst.dsmod_sin.fetch_ctr_r[6]\ clk _01971_ _18851_ VPWR VGND sg13g2_dfrbpq_1
X_38908_ \memory_i.freq_inst.dsmod_sin.fetch_ctr_r[7]\ clk _01972_ _18843_ VPWR VGND sg13g2_dfrbpq_1
X_38909_ \memory_i.freq_inst.lo_gen.lo_q_r\ _00046_ _01973_ _18835_ VPWR VGND sg13g2_dfrbpq_1
X_38910_ \memory_i.freq_inst.lo_gen.lo_i_r\ clk _01974_ _18823_ VPWR VGND sg13g2_dfrbpq_1
X_38911_ \memory_i.freq_inst.lo_gen.lo_ctr_r[0]\ clk _01975_ _18815_ VPWR VGND sg13g2_dfrbpq_1
X_38912_ \memory_i.freq_inst.lo_gen.lo_ctr_r[1]\ clk _01976_ _18807_ VPWR VGND sg13g2_dfrbpq_1
X_38913_ \memory_i.freq_inst.lo_gen.lo_ctr_r[2]\ clk _01977_ _18799_ VPWR VGND sg13g2_dfrbpq_1
X_38914_ \memory_i.freq_inst.lo_gen.lo_ctr_r[3]\ clk _01978_ _18791_ VPWR VGND sg13g2_dfrbpq_1
X_38915_ \memory_i.i2c_acks[4]\ clk _01979_ _18783_ VPWR VGND sg13g2_dfrbpq_1
X_38916_ \memory_i.i2c_acks[0]\ clk _01980_ _18775_ VPWR VGND sg13g2_dfrbpq_1
X_38917_ \memory_i.i2c_acks[1]\ clk _01981_ _18767_ VPWR VGND sg13g2_dfrbpq_1
X_38918_ \memory_i.i2c_acks[2]\ clk _01982_ _18759_ VPWR VGND sg13g2_dfrbpq_1
X_38919_ \memory_i.i2c_acks[3]\ clk _01983_ _18718_ VPWR VGND sg13g2_dfrbpq_1
X_38920_ \memory_i.i2c_dataout[0]\ clk _01984_ _18710_ VPWR VGND sg13g2_dfrbpq_1
X_38921_ \memory_i.i2c_dataout[1]\ clk _01985_ _18706_ VPWR VGND sg13g2_dfrbpq_1
X_38922_ \memory_i.i2c_dataout[2]\ clk _01986_ _18702_ VPWR VGND sg13g2_dfrbpq_1
X_38923_ \memory_i.i2c_dataout[3]\ clk _01987_ _18694_ VPWR VGND sg13g2_dfrbpq_1
X_38924_ \memory_i.i2c_dataout[4]\ clk _01988_ _18690_ VPWR VGND sg13g2_dfrbpq_1
X_38925_ \memory_i.i2c_dataout[5]\ clk _01989_ _18686_ VPWR VGND sg13g2_dfrbpq_1
X_38926_ \memory_i.i2c_dataout[6]\ clk _01990_ _18682_ VPWR VGND sg13g2_dfrbpq_1
X_38927_ \memory_i.i2c_dataout[7]\ clk _01991_ _18678_ VPWR VGND sg13g2_dfrbpq_1
X_38928_ \memory_i.i2c_dataout[8]\ clk _01992_ _18674_ VPWR VGND sg13g2_dfrbpq_1
X_38929_ \memory_i.i2c_dataout[9]\ clk _01993_ _18670_ VPWR VGND sg13g2_dfrbpq_1
X_38930_ \memory_i.i2c_dataout[10]\ clk _01994_ _18666_ VPWR VGND sg13g2_dfrbpq_1
X_38931_ \memory_i.i2c_dataout[11]\ clk _01995_ _18662_ VPWR VGND sg13g2_dfrbpq_1
X_38932_ \memory_i.i2c_dataout[12]\ clk _01996_ _18658_ VPWR VGND sg13g2_dfrbpq_1
X_38933_ \memory_i.i2c_dataout[13]\ clk _01997_ _18654_ VPWR VGND sg13g2_dfrbpq_1
X_38934_ \memory_i.i2c_dataout[14]\ clk _01998_ _18650_ VPWR VGND sg13g2_dfrbpq_1
X_38935_ \memory_i.i2c_dataout[15]\ clk _01999_ _18646_ VPWR VGND sg13g2_dfrbpq_1
X_38936_ \memory_i.i2c_dataout[16]\ clk _02000_ _18642_ VPWR VGND sg13g2_dfrbpq_1
X_38937_ \memory_i.i2c_dataout[17]\ clk _02001_ _18638_ VPWR VGND sg13g2_dfrbpq_1
X_38938_ \memory_i.i2c_dataout[18]\ clk _02002_ _18634_ VPWR VGND sg13g2_dfrbpq_1
X_38939_ \memory_i.i2c_dataout[19]\ clk _02003_ _18630_ VPWR VGND sg13g2_dfrbpq_1
X_38940_ \memory_i.i2c_dataout[20]\ clk _02004_ _18626_ VPWR VGND sg13g2_dfrbpq_1
X_38941_ \memory_i.i2c_dataout[21]\ clk _02005_ _18622_ VPWR VGND sg13g2_dfrbpq_1
X_38942_ \memory_i.i2c_dataout[22]\ clk _02006_ _18618_ VPWR VGND sg13g2_dfrbpq_1
X_38943_ \memory_i.i2c_dataout[23]\ clk _02007_ _18614_ VPWR VGND sg13g2_dfrbpq_1
X_38944_ \memory_i.i2c_dataout[24]\ clk _02008_ _18610_ VPWR VGND sg13g2_dfrbpq_1
X_38945_ \memory_i.i2c_dataout[25]\ clk _02009_ _18606_ VPWR VGND sg13g2_dfrbpq_1
X_38946_ \memory_i.i2c_dataout[26]\ clk _02010_ _18602_ VPWR VGND sg13g2_dfrbpq_1
X_38947_ \memory_i.i2c_dataout[27]\ clk _02011_ _18598_ VPWR VGND sg13g2_dfrbpq_1
X_38948_ \memory_i.i2c_dataout[28]\ clk _02012_ _18594_ VPWR VGND sg13g2_dfrbpq_1
X_38949_ \memory_i.i2c_dataout[29]\ clk _02013_ _18590_ VPWR VGND sg13g2_dfrbpq_1
X_38950_ \memory_i.i2c_dataout[30]\ clk _02014_ _18586_ VPWR VGND sg13g2_dfrbpq_1
X_38951_ \memory_i.i2c_dataout[31]\ clk _02015_ _18582_ VPWR VGND sg13g2_dfrbpq_1
X_38952_ scl clk _02016_ _18578_ VPWR VGND sg13g2_dfrbpq_1
X_38953_ \memory_i.i2c_master.frame_index[0]\ clk _02017_ _18570_ VPWR VGND sg13g2_dfrbpq_1
X_38954_ \memory_i.i2c_master.frame_index[1]\ clk _02018_ _18562_ VPWR VGND sg13g2_dfrbpq_1
X_38955_ \memory_i.i2c_master.index[0]\ clk _02019_ _18554_ VPWR VGND sg13g2_dfrbpq_1
X_38956_ \memory_i.i2c_master.index[1]\ clk _02020_ _18546_ VPWR VGND sg13g2_dfrbpq_1
X_38957_ \memory_i.i2c_master.index[2]\ clk _02021_ _18538_ VPWR VGND sg13g2_dfrbpq_1
X_38958_ \memory_i.i2c_master.scl_counter[0]\ clk _02022_ _18530_ VPWR VGND sg13g2_dfrbpq_1
X_38959_ \memory_i.i2c_master.scl_counter[1]\ clk _02023_ _18526_ VPWR VGND sg13g2_dfrbpq_1
X_38960_ \memory_i.i2c_master.scl_counter[2]\ clk _02024_ _18522_ VPWR VGND sg13g2_dfrbpq_1
X_38961_ \memory_i.i2c_master.scl_counter[3]\ clk _02025_ _18518_ VPWR VGND sg13g2_dfrbpq_1
X_38962_ \memory_i.i2c_master.scl_counter[4]\ clk _02026_ _18514_ VPWR VGND sg13g2_dfrbpq_1
X_38963_ \memory_i.i2c_master.scl_counter[5]\ clk _02027_ _18510_ VPWR VGND sg13g2_dfrbpq_1
X_38964_ \memory_i.i2c_master.scl_counter[6]\ clk _02028_ _18506_ VPWR VGND sg13g2_dfrbpq_1
X_38965_ \memory_i.i2c_master.scl_counter[7]\ clk _02029_ _18502_ VPWR VGND sg13g2_dfrbpq_1
X_38966_ \memory_i.i2c_master.scl_counter[8]\ clk _02030_ _18498_ VPWR VGND sg13g2_dfrbpq_1
X_38967_ \memory_i.i2c_master.scl_counter[9]\ clk _02031_ _18494_ VPWR VGND sg13g2_dfrbpq_1
X_38968_ \memory_i.i2c_master.scl_counter[10]\ clk _02032_ _18490_ VPWR VGND sg13g2_dfrbpq_1
X_38969_ \memory_i.i2c_master.scl_counter[11]\ clk _02033_ _18486_ VPWR VGND sg13g2_dfrbpq_1
X_38970_ \memory_i.i2c_master.scl_counter[12]\ clk _02034_ _18482_ VPWR VGND sg13g2_dfrbpq_1
X_38971_ \memory_i.i2c_master.scl_counter[13]\ clk _02035_ _18478_ VPWR VGND sg13g2_dfrbpq_1
X_38972_ \memory_i.i2c_master.scl_counter[14]\ clk _02036_ _18474_ VPWR VGND sg13g2_dfrbpq_1
X_38973_ \memory_i.i2c_master.scl_counter[15]\ clk _02037_ _18470_ VPWR VGND sg13g2_dfrbpq_1
X_38974_ si clk _02038_ _18466_ VPWR VGND sg13g2_dfrbpq_1
X_38975_ sclk clk _02039_ _18458_ VPWR VGND sg13g2_dfrbpq_1
X_38976_ sram_ce clk _02040_ _18450_ VPWR VGND sg13g2_dfrbpq_1
X_38977_ \memory_i.sram_dataout[0]\ clk _02041_ _18442_ VPWR VGND sg13g2_dfrbpq_1
X_38978_ \memory_i.sram_dataout[1]\ clk _02042_ _18434_ VPWR VGND sg13g2_dfrbpq_1
X_38979_ \memory_i.sram_dataout[2]\ clk _02043_ _18426_ VPWR VGND sg13g2_dfrbpq_1
X_38980_ \memory_i.sram_dataout[3]\ clk _02044_ _18388_ VPWR VGND sg13g2_dfrbpq_1
X_38981_ \memory_i.sram_dataout[4]\ clk _02045_ _18380_ VPWR VGND sg13g2_dfrbpq_1
X_38982_ \memory_i.sram_dataout[5]\ clk _02046_ _18372_ VPWR VGND sg13g2_dfrbpq_1
X_38983_ \memory_i.sram_dataout[6]\ clk _02047_ _18364_ VPWR VGND sg13g2_dfrbpq_1
X_38984_ \memory_i.sram_dataout[7]\ clk _02048_ _18356_ VPWR VGND sg13g2_dfrbpq_1
X_38985_ \memory_i.sram_dataout[8]\ clk _02049_ _18348_ VPWR VGND sg13g2_dfrbpq_1
X_38986_ \memory_i.sram_dataout[9]\ clk _02050_ _18340_ VPWR VGND sg13g2_dfrbpq_1
X_38987_ \memory_i.sram_dataout[10]\ clk _02051_ _18332_ VPWR VGND sg13g2_dfrbpq_1
X_38988_ \memory_i.sram_dataout[11]\ clk _02052_ _18324_ VPWR VGND sg13g2_dfrbpq_1
X_38989_ \memory_i.sram_dataout[12]\ clk _02053_ _18316_ VPWR VGND sg13g2_dfrbpq_1
X_38990_ \memory_i.sram_dataout[13]\ clk _02054_ _18308_ VPWR VGND sg13g2_dfrbpq_1
X_38991_ \memory_i.sram_dataout[14]\ clk _02055_ _18300_ VPWR VGND sg13g2_dfrbpq_1
X_38992_ \memory_i.sram_dataout[15]\ clk _02056_ _18292_ VPWR VGND sg13g2_dfrbpq_1
X_38993_ \memory_i.sram_dataout[16]\ clk _02057_ _18284_ VPWR VGND sg13g2_dfrbpq_1
X_38994_ \memory_i.sram_dataout[17]\ clk _02058_ _18276_ VPWR VGND sg13g2_dfrbpq_1
X_38995_ \memory_i.sram_dataout[18]\ clk _02059_ _18268_ VPWR VGND sg13g2_dfrbpq_1
X_38996_ \memory_i.sram_dataout[19]\ clk _02060_ _18260_ VPWR VGND sg13g2_dfrbpq_1
X_38997_ \memory_i.sram_dataout[20]\ clk _02061_ _18252_ VPWR VGND sg13g2_dfrbpq_1
X_38998_ \memory_i.sram_dataout[21]\ clk _02062_ _18244_ VPWR VGND sg13g2_dfrbpq_1
X_38999_ \memory_i.sram_dataout[22]\ clk _02063_ _18236_ VPWR VGND sg13g2_dfrbpq_1
X_39000_ \memory_i.sram_dataout[23]\ clk _02064_ _18228_ VPWR VGND sg13g2_dfrbpq_1
X_39001_ \memory_i.sram_dataout[24]\ clk _02065_ _18220_ VPWR VGND sg13g2_dfrbpq_1
X_39002_ \memory_i.sram_dataout[25]\ clk _02066_ _18212_ VPWR VGND sg13g2_dfrbpq_1
X_39003_ \memory_i.sram_dataout[26]\ clk _02067_ _18204_ VPWR VGND sg13g2_dfrbpq_1
X_39004_ \memory_i.sram_dataout[27]\ clk _02068_ _18196_ VPWR VGND sg13g2_dfrbpq_1
X_39005_ \memory_i.sram_dataout[28]\ clk _02069_ _18188_ VPWR VGND sg13g2_dfrbpq_1
X_39006_ \memory_i.sram_dataout[29]\ clk _02070_ _18180_ VPWR VGND sg13g2_dfrbpq_1
X_39007_ \memory_i.sram_dataout[30]\ clk _02071_ _18172_ VPWR VGND sg13g2_dfrbpq_1
X_39008_ \memory_i.sram_dataout[31]\ clk _02072_ _18164_ VPWR VGND sg13g2_dfrbpq_1
X_39009_ \memory_i.sram_master.index[0]\ clk _02073_ _18156_ VPWR VGND sg13g2_dfrbpq_1
X_39010_ \memory_i.sram_master.index[1]\ clk _02074_ _18148_ VPWR VGND sg13g2_dfrbpq_1
X_39011_ \memory_i.sram_master.index[2]\ clk _02075_ _18140_ VPWR VGND sg13g2_dfrbpq_1
X_39012_ \memory_i.sram_master.index[3]\ clk _02076_ _18132_ VPWR VGND sg13g2_dfrbpq_1
X_39013_ \memory_i.sram_master.index[4]\ clk _02077_ _18034_ VPWR VGND sg13g2_dfrbpq_1
X_39014_ \memory_i.sram_master.index[5]\ clk _02078_ _18026_ VPWR VGND sg13g2_dfrbpq_1
X_39015_ \memory_i.sram_master.index[6]\ clk _02079_ _18018_ VPWR VGND sg13g2_dfrbpq_1
X_39016_ \memory_i.sram_master.index[7]\ clk _02080_ _18010_ VPWR VGND sg13g2_dfrbpq_1
X_39017_ \memory_i.sram_master.write_reg\ clk _02081_ _17936_ VPWR VGND sg13g2_dfrbpq_1
X_39018_ \memory_i.sram_master.clk_counter[0]\ clk _02082_ _17920_ VPWR VGND sg13g2_dfrbpq_1
X_39019_ \memory_i.uart_receiver.rxd_reg\ clk _02083_ _17912_ VPWR VGND sg13g2_dfrbpq_1
X_39020_ \memory_i.uart_receiver.rxd_reg_0\ clk _02084_ _17896_ VPWR VGND sg13g2_dfrbpq_1
X_39021_ \memory_i.uart_receiver.cycle_counter[0]\ clk _02085_ _19505_ VPWR VGND sg13g2_dfrbpq_1
X_39022_ \memory_i.uart_receiver.cycle_counter[1]\ clk _02086_ _19489_ VPWR VGND sg13g2_dfrbpq_1
X_39023_ \memory_i.uart_receiver.cycle_counter[2]\ clk _02087_ _19473_ VPWR VGND sg13g2_dfrbpq_1
X_39024_ \memory_i.uart_receiver.cycle_counter[3]\ clk _02088_ _19455_ VPWR VGND sg13g2_dfrbpq_1
X_39025_ \memory_i.uart_receiver.cycle_counter[4]\ clk _02089_ _19439_ VPWR VGND sg13g2_dfrbpq_1
X_39026_ \memory_i.uart_receiver.cycle_counter[5]\ clk _02090_ _19423_ VPWR VGND sg13g2_dfrbpq_1
X_39027_ \memory_i.uart_receiver.cycle_counter[6]\ clk _02091_ _19407_ VPWR VGND sg13g2_dfrbpq_1
X_39028_ \memory_i.uart_receiver.cycle_counter[7]\ clk _02092_ _19391_ VPWR VGND sg13g2_dfrbpq_1
X_39029_ \memory_i.uart_receiver.cycle_counter[8]\ clk _02093_ _19375_ VPWR VGND sg13g2_dfrbpq_1
X_39030_ \memory_i.uart_receiver.cycle_counter[9]\ clk _02094_ _19359_ VPWR VGND sg13g2_dfrbpq_1
X_39031_ \memory_i.uart_receiver.cycle_counter[10]\ clk _02095_ _19343_ VPWR VGND sg13g2_dfrbpq_1
X_39032_ \memory_i.uart_receiver.cycle_counter[11]\ clk _02096_ _19326_ VPWR VGND sg13g2_dfrbpq_1
X_39033_ \memory_i.uart_receiver.cycle_counter[12]\ clk _02097_ _19310_ VPWR VGND sg13g2_dfrbpq_1
X_39034_ \memory_i.uart_receiver.cycle_counter[13]\ clk _02098_ _19294_ VPWR VGND sg13g2_dfrbpq_1
X_39035_ \memory_i.uart_receiver.cycle_counter[14]\ clk _02099_ _19278_ VPWR VGND sg13g2_dfrbpq_1
X_39036_ \memory_i.uart_receiver.cycle_counter[15]\ clk _02100_ _19262_ VPWR VGND sg13g2_dfrbpq_1
X_39037_ \memory_i.uart_receiver.bit_sample\ clk _02101_ _19246_ VPWR VGND sg13g2_dfrbpq_1
X_39038_ \memory_i.uart_receiver.bit_counter[0]\ clk _02102_ _19230_ VPWR VGND sg13g2_dfrbpq_1
X_39039_ \memory_i.uart_receiver.bit_counter[1]\ clk _02103_ _19214_ VPWR VGND sg13g2_dfrbpq_1
X_39040_ \memory_i.uart_receiver.bit_counter[2]\ clk _02104_ _19198_ VPWR VGND sg13g2_dfrbpq_1
X_39041_ \memory_i.uart_receiver.bit_counter[3]\ clk _02105_ _19182_ VPWR VGND sg13g2_dfrbpq_1
X_39042_ \memory_i.uart_receiver.recieved_data[0]\ clk _02106_ _19166_ VPWR VGND sg13g2_dfrbpq_1
X_39043_ \memory_i.uart_receiver.recieved_data[1]\ clk _02107_ _19150_ VPWR VGND sg13g2_dfrbpq_1
X_39044_ \memory_i.uart_receiver.recieved_data[2]\ clk _02108_ _19102_ VPWR VGND sg13g2_dfrbpq_1
X_39045_ \memory_i.uart_receiver.recieved_data[3]\ clk _02109_ _19086_ VPWR VGND sg13g2_dfrbpq_1
X_39046_ \memory_i.uart_receiver.recieved_data[4]\ clk _02110_ _19070_ VPWR VGND sg13g2_dfrbpq_1
X_39047_ \memory_i.uart_receiver.recieved_data[5]\ clk _02111_ _19054_ VPWR VGND sg13g2_dfrbpq_1
X_39048_ \memory_i.uart_receiver.recieved_data[6]\ clk _02112_ _19035_ VPWR VGND sg13g2_dfrbpq_1
X_39049_ \memory_i.uart_receiver.recieved_data[7]\ clk _02113_ _19019_ VPWR VGND sg13g2_dfrbpq_1
X_39050_ \memory_i.uart_receiver.uart_rx_data[0]\ clk _02114_ _19003_ VPWR VGND sg13g2_dfrbpq_1
X_39051_ \memory_i.uart_receiver.uart_rx_data[1]\ clk _02115_ _18987_ VPWR VGND sg13g2_dfrbpq_1
X_39052_ \memory_i.uart_receiver.uart_rx_data[2]\ clk _02116_ _18871_ VPWR VGND sg13g2_dfrbpq_1
X_39053_ \memory_i.uart_receiver.uart_rx_data[3]\ clk _02117_ _18855_ VPWR VGND sg13g2_dfrbpq_1
X_39054_ \memory_i.uart_receiver.uart_rx_data[4]\ clk _02118_ _18839_ VPWR VGND sg13g2_dfrbpq_1
X_39055_ \memory_i.uart_receiver.uart_rx_data[5]\ clk _02119_ _18827_ VPWR VGND sg13g2_dfrbpq_1
X_39056_ \memory_i.uart_receiver.uart_rx_data[6]\ clk _02120_ _18811_ VPWR VGND sg13g2_dfrbpq_1
X_39057_ \memory_i.uart_receiver.uart_rx_data[7]\ clk _02121_ _18795_ VPWR VGND sg13g2_dfrbpq_1
X_39058_ tx clk _02122_ _18779_ VPWR VGND sg13g2_dfrbpq_1
X_39059_ \memory_i.uart_transmitter.cycle_counter[0]\ clk _02123_ _18763_ VPWR VGND sg13g2_dfrbpq_1
X_39060_ \memory_i.uart_transmitter.cycle_counter[1]\ clk _02124_ _18714_ VPWR VGND sg13g2_dfrbpq_1
X_39061_ \memory_i.uart_transmitter.cycle_counter[2]\ clk _02125_ _18566_ VPWR VGND sg13g2_dfrbpq_1
X_39062_ \memory_i.uart_transmitter.cycle_counter[3]\ clk _02126_ _18550_ VPWR VGND sg13g2_dfrbpq_1
X_39063_ \memory_i.uart_transmitter.cycle_counter[4]\ clk _02127_ _18534_ VPWR VGND sg13g2_dfrbpq_1
X_39064_ \memory_i.uart_transmitter.cycle_counter[5]\ clk _02128_ _18454_ VPWR VGND sg13g2_dfrbpq_1
X_39065_ \memory_i.uart_transmitter.cycle_counter[6]\ clk _02129_ _18438_ VPWR VGND sg13g2_dfrbpq_1
X_39066_ \memory_i.uart_transmitter.cycle_counter[7]\ clk _02130_ _18392_ VPWR VGND sg13g2_dfrbpq_1
X_39067_ \memory_i.uart_transmitter.cycle_counter[8]\ clk _02131_ _18376_ VPWR VGND sg13g2_dfrbpq_1
X_39068_ \memory_i.uart_transmitter.cycle_counter[9]\ clk _02132_ _18360_ VPWR VGND sg13g2_dfrbpq_1
X_39069_ \memory_i.uart_transmitter.cycle_counter[10]\ clk _02133_ _18344_ VPWR VGND sg13g2_dfrbpq_1
X_39070_ \memory_i.uart_transmitter.cycle_counter[11]\ clk _02134_ _18328_ VPWR VGND sg13g2_dfrbpq_1
X_39071_ \memory_i.uart_transmitter.cycle_counter[12]\ clk _02135_ _18312_ VPWR VGND sg13g2_dfrbpq_1
X_39072_ \memory_i.uart_transmitter.cycle_counter[13]\ clk _02136_ _18296_ VPWR VGND sg13g2_dfrbpq_1
X_39073_ \memory_i.uart_transmitter.cycle_counter[14]\ clk _02137_ _18280_ VPWR VGND sg13g2_dfrbpq_1
X_39074_ \memory_i.uart_transmitter.cycle_counter[15]\ clk _02138_ _18264_ VPWR VGND sg13g2_dfrbpq_1
X_39075_ \memory_i.uart_transmitter.bit_counter[0]\ clk _02139_ _18248_ VPWR VGND sg13g2_dfrbpq_1
X_39076_ \memory_i.uart_transmitter.bit_counter[1]\ clk _02140_ _18232_ VPWR VGND sg13g2_dfrbpq_1
X_39077_ \memory_i.uart_transmitter.bit_counter[2]\ clk _02141_ _18216_ VPWR VGND sg13g2_dfrbpq_1
X_39078_ \memory_i.uart_transmitter.bit_counter[3]\ clk _02142_ _18200_ VPWR VGND sg13g2_dfrbpq_1
X_39079_ \memory_i.uart_transmitter.data_to_send[0]\ clk _02143_ _18184_ VPWR VGND sg13g2_dfrbpq_1
X_39080_ \memory_i.uart_transmitter.data_to_send[1]\ clk _02144_ _18168_ VPWR VGND sg13g2_dfrbpq_1
X_39081_ \memory_i.uart_transmitter.data_to_send[2]\ clk _02145_ _18152_ VPWR VGND sg13g2_dfrbpq_1
X_39082_ \memory_i.uart_transmitter.data_to_send[3]\ clk _02146_ _18136_ VPWR VGND sg13g2_dfrbpq_1
X_39083_ \memory_i.uart_transmitter.data_to_send[4]\ clk _02147_ _18030_ VPWR VGND sg13g2_dfrbpq_1
X_39084_ \memory_i.uart_transmitter.data_to_send[5]\ clk _02148_ _18014_ VPWR VGND sg13g2_dfrbpq_1
X_39085_ \memory_i.uart_transmitter.data_to_send[6]\ clk _02149_ _17928_ VPWR VGND sg13g2_dfrbpq_1
X_39086_ \memory_i.uart_transmitter.data_to_send[7]\ clk _02150_ _17888_ VPWR VGND sg13g2_dfrbpq_1
X_39087_ \alu_i.instruction[0]\ clk _02151_ _19481_ VPWR VGND sg13g2_dfrbpq_1
X_39088_ \alu_i.instruction[1]\ clk _02152_ _19447_ VPWR VGND sg13g2_dfrbpq_1
X_39089_ \alu_i.instruction[2]\ clk _02153_ _19415_ VPWR VGND sg13g2_dfrbpq_1
X_39090_ \alu_i.instruction[3]\ clk _02154_ _19383_ VPWR VGND sg13g2_dfrbpq_1
X_39091_ \alu_i.instruction[4]\ clk _02155_ _19351_ VPWR VGND sg13g2_dfrbpq_1
X_39092_ \alu_i.instruction[5]\ clk _02156_ _19318_ VPWR VGND sg13g2_dfrbpq_1
X_39093_ \alu_i.instruction[6]\ clk _02157_ _19286_ VPWR VGND sg13g2_dfrbpq_1
X_39094_ \control_i.imm_gen_i.iword[7]\ clk _02158_ _19254_ VPWR VGND sg13g2_dfrbpq_1
X_39095_ \control_i.imm_gen_i.iword[8]\ clk _02159_ _19222_ VPWR VGND sg13g2_dfrbpq_1
X_39096_ \control_i.imm_gen_i.iword[9]\ clk _02160_ _19190_ VPWR VGND sg13g2_dfrbpq_1
X_39097_ \control_i.imm_gen_i.iword[10]\ clk _02161_ _19158_ VPWR VGND sg13g2_dfrbpq_1
X_39098_ \control_i.imm_gen_i.iword[11]\ clk _02162_ _19094_ VPWR VGND sg13g2_dfrbpq_1
X_39099_ \alu_i.funct3[0]\ clk _02163_ _19062_ VPWR VGND sg13g2_dfrbpq_1
X_39100_ \alu_i.funct3[1]\ clk _02164_ _19027_ VPWR VGND sg13g2_dfrbpq_1
X_39101_ \alu_i.funct3[2]\ clk _02165_ _18995_ VPWR VGND sg13g2_dfrbpq_1
X_39102_ \control_i.imm_gen_i.iword[15]\ clk _02166_ _18863_ VPWR VGND sg13g2_dfrbpq_1
X_39103_ \control_i.imm_gen_i.iword[16]\ clk _02167_ _18831_ VPWR VGND sg13g2_dfrbpq_1
X_39104_ \control_i.imm_gen_i.iword[17]\ clk _02168_ _18803_ VPWR VGND sg13g2_dfrbpq_1
X_39105_ \control_i.imm_gen_i.iword[18]\ clk _02169_ _18771_ VPWR VGND sg13g2_dfrbpq_1
X_39106_ \control_i.imm_gen_i.iword[19]\ clk _02170_ _18574_ VPWR VGND sg13g2_dfrbpq_1
X_39107_ \control_i.imm_gen_i.iword[20]\ clk _02171_ _18542_ VPWR VGND sg13g2_dfrbpq_1
X_39108_ \control_i.imm_gen_i.iword[21]\ clk _02172_ _18446_ VPWR VGND sg13g2_dfrbpq_1
X_39109_ \control_i.imm_gen_i.iword[22]\ clk _02173_ _18384_ VPWR VGND sg13g2_dfrbpq_1
X_39110_ \control_i.imm_gen_i.iword[23]\ clk _02174_ _18352_ VPWR VGND sg13g2_dfrbpq_1
X_39111_ \control_i.imm_gen_i.iword[24]\ clk _02175_ _18320_ VPWR VGND sg13g2_dfrbpq_1
X_39112_ \alu_i.funct7[0]\ clk _02176_ _18288_ VPWR VGND sg13g2_dfrbpq_1
X_39113_ \alu_i.funct7[1]\ clk _02177_ _18256_ VPWR VGND sg13g2_dfrbpq_1
X_39114_ \alu_i.funct7[2]\ clk _02178_ _18224_ VPWR VGND sg13g2_dfrbpq_1
X_39115_ \alu_i.funct7[3]\ clk _02179_ _18192_ VPWR VGND sg13g2_dfrbpq_1
X_39116_ \alu_i.funct7[4]\ clk _02180_ _18160_ VPWR VGND sg13g2_dfrbpq_1
X_39117_ \alu_i.funct7[5]\ clk _02181_ _18128_ VPWR VGND sg13g2_dfrbpq_1
X_39118_ \alu_i.funct7[6]\ clk _02182_ _18006_ VPWR VGND sg13g2_dfrbpq_1
X_39119_ \rd_alu[0]\ clk _02183_ _19497_ VPWR VGND sg13g2_dfrbpq_1
X_39120_ \rd_alu[1]\ clk _02184_ _19465_ VPWR VGND sg13g2_dfrbpq_1
X_39121_ \rd_alu[2]\ clk _02185_ _19431_ VPWR VGND sg13g2_dfrbpq_1
X_39122_ \rd_alu[3]\ clk _02186_ _19399_ VPWR VGND sg13g2_dfrbpq_1
X_39123_ \rd_alu[4]\ clk _02187_ _19367_ VPWR VGND sg13g2_dfrbpq_1
X_39124_ \rd_alu[5]\ clk _02188_ _19334_ VPWR VGND sg13g2_dfrbpq_1
X_39125_ \rd_alu[6]\ clk _02189_ _19302_ VPWR VGND sg13g2_dfrbpq_1
X_39126_ \rd_alu[7]\ clk _02190_ _19270_ VPWR VGND sg13g2_dfrbpq_1
X_39127_ \rd_alu[8]\ clk _02191_ _19238_ VPWR VGND sg13g2_dfrbpq_1
X_39128_ \rd_alu[9]\ clk _02192_ _19206_ VPWR VGND sg13g2_dfrbpq_1
X_39129_ \rd_alu[10]\ clk _02193_ _19174_ VPWR VGND sg13g2_dfrbpq_1
X_39130_ \rd_alu[11]\ clk _02194_ _19110_ VPWR VGND sg13g2_dfrbpq_1
X_39131_ \rd_alu[12]\ clk _02195_ _19078_ VPWR VGND sg13g2_dfrbpq_1
X_39132_ \rd_alu[13]\ clk _02196_ _19043_ VPWR VGND sg13g2_dfrbpq_1
X_39133_ \rd_alu[14]\ clk _02197_ _19011_ VPWR VGND sg13g2_dfrbpq_1
X_39134_ \rd_alu[15]\ clk _02198_ _18879_ VPWR VGND sg13g2_dfrbpq_1
X_39135_ \rd_alu[16]\ clk _02199_ _18847_ VPWR VGND sg13g2_dfrbpq_1
X_39136_ \rd_alu[17]\ clk _02200_ _18819_ VPWR VGND sg13g2_dfrbpq_1
X_39137_ \rd_alu[18]\ clk _02201_ _18787_ VPWR VGND sg13g2_dfrbpq_1
X_39138_ \rd_alu[19]\ clk _02202_ _18722_ VPWR VGND sg13g2_dfrbpq_1
X_39139_ \rd_alu[20]\ clk _02203_ _18558_ VPWR VGND sg13g2_dfrbpq_1
X_39140_ \rd_alu[21]\ clk _02204_ _18462_ VPWR VGND sg13g2_dfrbpq_1
X_39141_ \rd_alu[22]\ clk _02205_ _18430_ VPWR VGND sg13g2_dfrbpq_1
X_39142_ \rd_alu[23]\ clk _02206_ _18368_ VPWR VGND sg13g2_dfrbpq_1
X_39143_ \rd_alu[24]\ clk _02207_ _18336_ VPWR VGND sg13g2_dfrbpq_1
X_39144_ \rd_alu[25]\ clk _02208_ _18304_ VPWR VGND sg13g2_dfrbpq_1
X_39145_ \rd_alu[26]\ clk _02209_ _18272_ VPWR VGND sg13g2_dfrbpq_1
X_39146_ \rd_alu[27]\ clk _02210_ _18240_ VPWR VGND sg13g2_dfrbpq_1
X_39147_ \rd_alu[28]\ clk _02211_ _18208_ VPWR VGND sg13g2_dfrbpq_1
X_39148_ \rd_alu[29]\ clk _02212_ _18176_ VPWR VGND sg13g2_dfrbpq_1
X_39149_ \rd_alu[30]\ clk _02213_ _18144_ VPWR VGND sg13g2_dfrbpq_1
X_39150_ \rd_alu[31]\ clk _02214_ _19568_ VPWR VGND sg13g2_dfrbpq_1
X_39151_ \memory_i.uart_receiver.fsm_state[0]\ clk _00041_ _19569_ VPWR VGND sg13g2_dfrbpq_1
X_39152_ \memory_i.uart_receiver.fsm_state[1]\ clk _00042_ _19570_ VPWR VGND sg13g2_dfrbpq_1
X_39153_ \memory_i.uart_receiver.fsm_state[2]\ clk _00043_ _19571_ VPWR VGND sg13g2_dfrbpq_1
X_39154_ \memory_i.uart_receiver.fsm_state[3]\ clk _00044_ _19572_ VPWR VGND sg13g2_dfrbpq_1
X_39155_ \memory_i.target[0]\ clk _00038_ _19573_ VPWR VGND sg13g2_dfrbpq_1
X_39156_ \memory_i.target[2]\ clk _00039_ _17904_ VPWR VGND sg13g2_dfrbpq_1
X_39157_ \memory_i.target[3]\ clk _00040_ _18022_ VPWR VGND sg13g2_dfrbpq_1
X_39158_ _17344_ VPWR VGND sg13g2_tiehi
X_39159_ _17345_ VPWR VGND sg13g2_tiehi
X_39160_ _17346_ VPWR VGND sg13g2_tiehi
X_39161_ _17347_ VPWR VGND sg13g2_tiehi
X_39162_ _17348_ VPWR VGND sg13g2_tiehi
X_39163_ _17349_ VPWR VGND sg13g2_tiehi
X_39164_ _17350_ VPWR VGND sg13g2_tiehi
X_39165_ _17351_ VPWR VGND sg13g2_tiehi
X_39166_ _17352_ VPWR VGND sg13g2_tiehi
X_39167_ _17353_ VPWR VGND sg13g2_tiehi
X_39168_ _17354_ VPWR VGND sg13g2_tiehi
X_39169_ _17355_ VPWR VGND sg13g2_tiehi
X_39170_ _17356_ VPWR VGND sg13g2_tiehi
X_39171_ _17357_ VPWR VGND sg13g2_tiehi
X_39172_ _17358_ VPWR VGND sg13g2_tiehi
X_39173_ _17359_ VPWR VGND sg13g2_tiehi
X_39174_ _17360_ VPWR VGND sg13g2_tiehi
X_39175_ _17361_ VPWR VGND sg13g2_tiehi
X_39176_ _17362_ VPWR VGND sg13g2_tiehi
X_39177_ _17363_ VPWR VGND sg13g2_tiehi
X_39178_ _17364_ VPWR VGND sg13g2_tiehi
X_39179_ _17365_ VPWR VGND sg13g2_tiehi
X_39180_ _17366_ VPWR VGND sg13g2_tiehi
X_39181_ _17367_ VPWR VGND sg13g2_tiehi
X_39182_ _17368_ VPWR VGND sg13g2_tiehi
X_39183_ _17369_ VPWR VGND sg13g2_tiehi
X_39184_ _17370_ VPWR VGND sg13g2_tiehi
X_39185_ _17371_ VPWR VGND sg13g2_tiehi
X_39186_ _17372_ VPWR VGND sg13g2_tiehi
X_39187_ _17373_ VPWR VGND sg13g2_tiehi
X_39188_ _17374_ VPWR VGND sg13g2_tiehi
X_39189_ _17375_ VPWR VGND sg13g2_tiehi
X_39190_ _17376_ VPWR VGND sg13g2_tiehi
X_39191_ _17377_ VPWR VGND sg13g2_tiehi
X_39192_ _17378_ VPWR VGND sg13g2_tiehi
X_39193_ _17379_ VPWR VGND sg13g2_tiehi
X_39194_ _17380_ VPWR VGND sg13g2_tiehi
X_39195_ _17381_ VPWR VGND sg13g2_tiehi
X_39196_ _17382_ VPWR VGND sg13g2_tiehi
X_39197_ _17383_ VPWR VGND sg13g2_tiehi
X_39198_ _17384_ VPWR VGND sg13g2_tiehi
X_39199_ _17385_ VPWR VGND sg13g2_tiehi
X_39200_ _17386_ VPWR VGND sg13g2_tiehi
X_39201_ _17387_ VPWR VGND sg13g2_tiehi
X_39202_ _17388_ VPWR VGND sg13g2_tiehi
X_39203_ _17389_ VPWR VGND sg13g2_tiehi
X_39204_ _17390_ VPWR VGND sg13g2_tiehi
X_39205_ _17391_ VPWR VGND sg13g2_tiehi
X_39206_ _17392_ VPWR VGND sg13g2_tiehi
X_39207_ _17393_ VPWR VGND sg13g2_tiehi
X_39208_ _17394_ VPWR VGND sg13g2_tiehi
X_39209_ _17395_ VPWR VGND sg13g2_tiehi
X_39210_ _17396_ VPWR VGND sg13g2_tiehi
X_39211_ _17397_ VPWR VGND sg13g2_tiehi
X_39212_ _17398_ VPWR VGND sg13g2_tiehi
X_39213_ _17399_ VPWR VGND sg13g2_tiehi
X_39214_ _17400_ VPWR VGND sg13g2_tiehi
X_39215_ _17401_ VPWR VGND sg13g2_tiehi
X_39216_ _17402_ VPWR VGND sg13g2_tiehi
X_39217_ _17403_ VPWR VGND sg13g2_tiehi
X_39218_ _17404_ VPWR VGND sg13g2_tiehi
X_39219_ _17405_ VPWR VGND sg13g2_tiehi
X_39220_ _17406_ VPWR VGND sg13g2_tiehi
X_39221_ _17407_ VPWR VGND sg13g2_tiehi
X_39222_ _17408_ VPWR VGND sg13g2_tiehi
X_39223_ _17409_ VPWR VGND sg13g2_tiehi
X_39224_ _17410_ VPWR VGND sg13g2_tiehi
X_39225_ _17411_ VPWR VGND sg13g2_tiehi
X_39226_ _17412_ VPWR VGND sg13g2_tiehi
X_39227_ _17413_ VPWR VGND sg13g2_tiehi
X_39228_ _17414_ VPWR VGND sg13g2_tiehi
X_39229_ _17415_ VPWR VGND sg13g2_tiehi
X_39230_ _17416_ VPWR VGND sg13g2_tiehi
X_39231_ _17417_ VPWR VGND sg13g2_tiehi
X_39232_ _17418_ VPWR VGND sg13g2_tiehi
X_39233_ _17419_ VPWR VGND sg13g2_tiehi
X_39234_ _17420_ VPWR VGND sg13g2_tiehi
X_39235_ _17421_ VPWR VGND sg13g2_tiehi
X_39236_ _17422_ VPWR VGND sg13g2_tiehi
X_39237_ _17423_ VPWR VGND sg13g2_tiehi
X_39238_ _17424_ VPWR VGND sg13g2_tiehi
X_39239_ _17425_ VPWR VGND sg13g2_tiehi
X_39240_ _17426_ VPWR VGND sg13g2_tiehi
X_39241_ _17427_ VPWR VGND sg13g2_tiehi
X_39242_ _17428_ VPWR VGND sg13g2_tiehi
X_39243_ _17429_ VPWR VGND sg13g2_tiehi
X_39244_ _17430_ VPWR VGND sg13g2_tiehi
X_39245_ _17431_ VPWR VGND sg13g2_tiehi
X_39246_ _17432_ VPWR VGND sg13g2_tiehi
X_39247_ _17433_ VPWR VGND sg13g2_tiehi
X_39248_ _17434_ VPWR VGND sg13g2_tiehi
X_39249_ _17435_ VPWR VGND sg13g2_tiehi
X_39250_ _17436_ VPWR VGND sg13g2_tiehi
X_39251_ _17437_ VPWR VGND sg13g2_tiehi
X_39252_ _17438_ VPWR VGND sg13g2_tiehi
X_39253_ _17439_ VPWR VGND sg13g2_tiehi
X_39254_ _17440_ VPWR VGND sg13g2_tiehi
X_39255_ _17441_ VPWR VGND sg13g2_tiehi
X_39256_ _17442_ VPWR VGND sg13g2_tiehi
X_39257_ _17443_ VPWR VGND sg13g2_tiehi
X_39258_ _17444_ VPWR VGND sg13g2_tiehi
X_39259_ _17445_ VPWR VGND sg13g2_tiehi
X_39260_ _17446_ VPWR VGND sg13g2_tiehi
X_39261_ _17447_ VPWR VGND sg13g2_tiehi
X_39262_ _17448_ VPWR VGND sg13g2_tiehi
X_39263_ _17449_ VPWR VGND sg13g2_tiehi
X_39264_ _17450_ VPWR VGND sg13g2_tiehi
X_39265_ _17451_ VPWR VGND sg13g2_tiehi
X_39266_ _17452_ VPWR VGND sg13g2_tiehi
X_39267_ _17453_ VPWR VGND sg13g2_tiehi
X_39268_ _17454_ VPWR VGND sg13g2_tiehi
X_39269_ _17455_ VPWR VGND sg13g2_tiehi
X_39270_ _17456_ VPWR VGND sg13g2_tiehi
X_39271_ _17457_ VPWR VGND sg13g2_tiehi
X_39272_ _17458_ VPWR VGND sg13g2_tiehi
X_39273_ _17459_ VPWR VGND sg13g2_tiehi
X_39274_ _17460_ VPWR VGND sg13g2_tiehi
X_39275_ _17461_ VPWR VGND sg13g2_tiehi
X_39276_ _17462_ VPWR VGND sg13g2_tiehi
X_39277_ _17463_ VPWR VGND sg13g2_tiehi
X_39278_ _17464_ VPWR VGND sg13g2_tiehi
X_39279_ _17465_ VPWR VGND sg13g2_tiehi
X_39280_ _17466_ VPWR VGND sg13g2_tiehi
X_39281_ _17467_ VPWR VGND sg13g2_tiehi
X_39282_ _17468_ VPWR VGND sg13g2_tiehi
X_39283_ _17469_ VPWR VGND sg13g2_tiehi
X_39284_ _17470_ VPWR VGND sg13g2_tiehi
X_39285_ _17471_ VPWR VGND sg13g2_tiehi
X_39286_ _17472_ VPWR VGND sg13g2_tiehi
X_39287_ _17473_ VPWR VGND sg13g2_tiehi
X_39288_ _17474_ VPWR VGND sg13g2_tiehi
X_39289_ _17475_ VPWR VGND sg13g2_tiehi
X_39290_ _17476_ VPWR VGND sg13g2_tiehi
X_39291_ _17477_ VPWR VGND sg13g2_tiehi
X_39292_ _17478_ VPWR VGND sg13g2_tiehi
X_39293_ _17479_ VPWR VGND sg13g2_tiehi
X_39294_ _17480_ VPWR VGND sg13g2_tiehi
X_39295_ _17481_ VPWR VGND sg13g2_tiehi
X_39296_ _17482_ VPWR VGND sg13g2_tiehi
X_39297_ _17483_ VPWR VGND sg13g2_tiehi
X_39298_ _17484_ VPWR VGND sg13g2_tiehi
X_39299_ _17485_ VPWR VGND sg13g2_tiehi
X_39300_ _17486_ VPWR VGND sg13g2_tiehi
X_39301_ _17487_ VPWR VGND sg13g2_tiehi
X_39302_ _17488_ VPWR VGND sg13g2_tiehi
X_39303_ _17489_ VPWR VGND sg13g2_tiehi
X_39304_ _17490_ VPWR VGND sg13g2_tiehi
X_39305_ _17491_ VPWR VGND sg13g2_tiehi
X_39306_ _17492_ VPWR VGND sg13g2_tiehi
X_39307_ _17493_ VPWR VGND sg13g2_tiehi
X_39308_ _17494_ VPWR VGND sg13g2_tiehi
X_39309_ _17495_ VPWR VGND sg13g2_tiehi
X_39310_ _17496_ VPWR VGND sg13g2_tiehi
X_39311_ _17497_ VPWR VGND sg13g2_tiehi
X_39312_ _17498_ VPWR VGND sg13g2_tiehi
X_39313_ _17499_ VPWR VGND sg13g2_tiehi
X_39314_ _17500_ VPWR VGND sg13g2_tiehi
X_39315_ _17501_ VPWR VGND sg13g2_tiehi
X_39316_ _17502_ VPWR VGND sg13g2_tiehi
X_39317_ _17503_ VPWR VGND sg13g2_tiehi
X_39318_ _17504_ VPWR VGND sg13g2_tiehi
X_39319_ _17505_ VPWR VGND sg13g2_tiehi
X_39320_ _17506_ VPWR VGND sg13g2_tiehi
X_39321_ _17507_ VPWR VGND sg13g2_tiehi
X_39322_ _17508_ VPWR VGND sg13g2_tiehi
X_39323_ _17509_ VPWR VGND sg13g2_tiehi
X_39324_ _17510_ VPWR VGND sg13g2_tiehi
X_39325_ _17511_ VPWR VGND sg13g2_tiehi
X_39326_ _17512_ VPWR VGND sg13g2_tiehi
X_39327_ _17513_ VPWR VGND sg13g2_tiehi
X_39328_ _17514_ VPWR VGND sg13g2_tiehi
X_39329_ _17515_ VPWR VGND sg13g2_tiehi
X_39330_ _17516_ VPWR VGND sg13g2_tiehi
X_39331_ _17517_ VPWR VGND sg13g2_tiehi
X_39332_ _17518_ VPWR VGND sg13g2_tiehi
X_39333_ _17519_ VPWR VGND sg13g2_tiehi
X_39334_ _17520_ VPWR VGND sg13g2_tiehi
X_39335_ _17521_ VPWR VGND sg13g2_tiehi
X_39336_ _17522_ VPWR VGND sg13g2_tiehi
X_39337_ _17523_ VPWR VGND sg13g2_tiehi
X_39338_ _17524_ VPWR VGND sg13g2_tiehi
X_39339_ _17525_ VPWR VGND sg13g2_tiehi
X_39340_ _17526_ VPWR VGND sg13g2_tiehi
X_39341_ _17527_ VPWR VGND sg13g2_tiehi
X_39342_ _17528_ VPWR VGND sg13g2_tiehi
X_39343_ _17529_ VPWR VGND sg13g2_tiehi
X_39344_ _17530_ VPWR VGND sg13g2_tiehi
X_39345_ _17531_ VPWR VGND sg13g2_tiehi
X_39346_ _17532_ VPWR VGND sg13g2_tiehi
X_39347_ _17533_ VPWR VGND sg13g2_tiehi
X_39348_ _17534_ VPWR VGND sg13g2_tiehi
X_39349_ _17535_ VPWR VGND sg13g2_tiehi
X_39350_ _17536_ VPWR VGND sg13g2_tiehi
X_39351_ _17537_ VPWR VGND sg13g2_tiehi
X_39352_ _17538_ VPWR VGND sg13g2_tiehi
X_39353_ _17539_ VPWR VGND sg13g2_tiehi
X_39354_ _17540_ VPWR VGND sg13g2_tiehi
X_39355_ _17541_ VPWR VGND sg13g2_tiehi
X_39356_ _17542_ VPWR VGND sg13g2_tiehi
X_39357_ _17543_ VPWR VGND sg13g2_tiehi
X_39358_ _17544_ VPWR VGND sg13g2_tiehi
X_39359_ _17545_ VPWR VGND sg13g2_tiehi
X_39360_ _17546_ VPWR VGND sg13g2_tiehi
X_39361_ _17547_ VPWR VGND sg13g2_tiehi
X_39362_ _17548_ VPWR VGND sg13g2_tiehi
X_39363_ _17549_ VPWR VGND sg13g2_tiehi
X_39364_ _17550_ VPWR VGND sg13g2_tiehi
X_39365_ _17551_ VPWR VGND sg13g2_tiehi
X_39366_ _17552_ VPWR VGND sg13g2_tiehi
X_39367_ _17553_ VPWR VGND sg13g2_tiehi
X_39368_ _17554_ VPWR VGND sg13g2_tiehi
X_39369_ _17555_ VPWR VGND sg13g2_tiehi
X_39370_ _17556_ VPWR VGND sg13g2_tiehi
X_39371_ _17557_ VPWR VGND sg13g2_tiehi
X_39372_ _17558_ VPWR VGND sg13g2_tiehi
X_39373_ _17559_ VPWR VGND sg13g2_tiehi
X_39374_ _17560_ VPWR VGND sg13g2_tiehi
X_39375_ _17561_ VPWR VGND sg13g2_tiehi
X_39376_ _17562_ VPWR VGND sg13g2_tiehi
X_39377_ _17563_ VPWR VGND sg13g2_tiehi
X_39378_ _17564_ VPWR VGND sg13g2_tiehi
X_39379_ _17565_ VPWR VGND sg13g2_tiehi
X_39380_ _17566_ VPWR VGND sg13g2_tiehi
X_39381_ _17567_ VPWR VGND sg13g2_tiehi
X_39382_ _17568_ VPWR VGND sg13g2_tiehi
X_39383_ _17569_ VPWR VGND sg13g2_tiehi
X_39384_ _17570_ VPWR VGND sg13g2_tiehi
X_39385_ _17571_ VPWR VGND sg13g2_tiehi
X_39386_ _17572_ VPWR VGND sg13g2_tiehi
X_39387_ _17573_ VPWR VGND sg13g2_tiehi
X_39388_ _17574_ VPWR VGND sg13g2_tiehi
X_39389_ _17575_ VPWR VGND sg13g2_tiehi
X_39390_ _17576_ VPWR VGND sg13g2_tiehi
X_39391_ _17577_ VPWR VGND sg13g2_tiehi
X_39392_ _17578_ VPWR VGND sg13g2_tiehi
X_39393_ _17579_ VPWR VGND sg13g2_tiehi
X_39394_ _17580_ VPWR VGND sg13g2_tiehi
X_39395_ _17581_ VPWR VGND sg13g2_tiehi
X_39396_ _17582_ VPWR VGND sg13g2_tiehi
X_39397_ _17583_ VPWR VGND sg13g2_tiehi
X_39398_ _17584_ VPWR VGND sg13g2_tiehi
X_39399_ _17585_ VPWR VGND sg13g2_tiehi
X_39400_ _17586_ VPWR VGND sg13g2_tiehi
X_39401_ _17587_ VPWR VGND sg13g2_tiehi
X_39402_ _17588_ VPWR VGND sg13g2_tiehi
X_39403_ _17589_ VPWR VGND sg13g2_tiehi
X_39404_ _17590_ VPWR VGND sg13g2_tiehi
X_39405_ _17591_ VPWR VGND sg13g2_tiehi
X_39406_ _17592_ VPWR VGND sg13g2_tiehi
X_39407_ _17593_ VPWR VGND sg13g2_tiehi
X_39408_ _17594_ VPWR VGND sg13g2_tiehi
X_39409_ _17595_ VPWR VGND sg13g2_tiehi
X_39410_ _17596_ VPWR VGND sg13g2_tiehi
X_39411_ _17597_ VPWR VGND sg13g2_tiehi
X_39412_ _17598_ VPWR VGND sg13g2_tiehi
X_39413_ _17599_ VPWR VGND sg13g2_tiehi
X_39414_ _17600_ VPWR VGND sg13g2_tiehi
X_39415_ _17601_ VPWR VGND sg13g2_tiehi
X_39416_ _17602_ VPWR VGND sg13g2_tiehi
X_39417_ _17603_ VPWR VGND sg13g2_tiehi
X_39418_ _17604_ VPWR VGND sg13g2_tiehi
X_39419_ _17605_ VPWR VGND sg13g2_tiehi
X_39420_ _17606_ VPWR VGND sg13g2_tiehi
X_39421_ _17607_ VPWR VGND sg13g2_tiehi
X_39422_ _17608_ VPWR VGND sg13g2_tiehi
X_39423_ _17609_ VPWR VGND sg13g2_tiehi
X_39424_ _17610_ VPWR VGND sg13g2_tiehi
X_39425_ _17611_ VPWR VGND sg13g2_tiehi
X_39426_ _17612_ VPWR VGND sg13g2_tiehi
X_39427_ _17613_ VPWR VGND sg13g2_tiehi
X_39428_ _17614_ VPWR VGND sg13g2_tiehi
X_39429_ _17615_ VPWR VGND sg13g2_tiehi
X_39430_ _17616_ VPWR VGND sg13g2_tiehi
X_39431_ _17617_ VPWR VGND sg13g2_tiehi
X_39432_ _17618_ VPWR VGND sg13g2_tiehi
X_39433_ _17619_ VPWR VGND sg13g2_tiehi
X_39434_ _17620_ VPWR VGND sg13g2_tiehi
X_39435_ _17621_ VPWR VGND sg13g2_tiehi
X_39436_ _17622_ VPWR VGND sg13g2_tiehi
X_39437_ _17623_ VPWR VGND sg13g2_tiehi
X_39438_ _17624_ VPWR VGND sg13g2_tiehi
X_39439_ _17625_ VPWR VGND sg13g2_tiehi
X_39440_ _17626_ VPWR VGND sg13g2_tiehi
X_39441_ _17627_ VPWR VGND sg13g2_tiehi
X_39442_ _17628_ VPWR VGND sg13g2_tiehi
X_39443_ _17629_ VPWR VGND sg13g2_tiehi
X_39444_ _17630_ VPWR VGND sg13g2_tiehi
X_39445_ _17631_ VPWR VGND sg13g2_tiehi
X_39446_ _17632_ VPWR VGND sg13g2_tiehi
X_39447_ _17633_ VPWR VGND sg13g2_tiehi
X_39448_ _17634_ VPWR VGND sg13g2_tiehi
X_39449_ _17635_ VPWR VGND sg13g2_tiehi
X_39450_ _17636_ VPWR VGND sg13g2_tiehi
X_39451_ _17637_ VPWR VGND sg13g2_tiehi
X_39452_ _17638_ VPWR VGND sg13g2_tiehi
X_39453_ _17639_ VPWR VGND sg13g2_tiehi
X_39454_ _17640_ VPWR VGND sg13g2_tiehi
X_39455_ _17641_ VPWR VGND sg13g2_tiehi
X_39456_ _17642_ VPWR VGND sg13g2_tiehi
X_39457_ _17643_ VPWR VGND sg13g2_tiehi
X_39458_ _17644_ VPWR VGND sg13g2_tiehi
X_39459_ _17645_ VPWR VGND sg13g2_tiehi
X_39460_ _17646_ VPWR VGND sg13g2_tiehi
X_39461_ _17647_ VPWR VGND sg13g2_tiehi
X_39462_ _17648_ VPWR VGND sg13g2_tiehi
X_39463_ _17649_ VPWR VGND sg13g2_tiehi
X_39464_ _17650_ VPWR VGND sg13g2_tiehi
X_39465_ _17651_ VPWR VGND sg13g2_tiehi
X_39466_ _17652_ VPWR VGND sg13g2_tiehi
X_39467_ _17653_ VPWR VGND sg13g2_tiehi
X_39468_ _17654_ VPWR VGND sg13g2_tiehi
X_39469_ _17655_ VPWR VGND sg13g2_tiehi
X_39470_ _17656_ VPWR VGND sg13g2_tiehi
X_39471_ _17657_ VPWR VGND sg13g2_tiehi
X_39472_ _17658_ VPWR VGND sg13g2_tiehi
X_39473_ _17659_ VPWR VGND sg13g2_tiehi
X_39474_ _17660_ VPWR VGND sg13g2_tiehi
X_39475_ _17661_ VPWR VGND sg13g2_tiehi
X_39476_ _17662_ VPWR VGND sg13g2_tiehi
X_39477_ _17663_ VPWR VGND sg13g2_tiehi
X_39478_ _17664_ VPWR VGND sg13g2_tiehi
X_39479_ _17665_ VPWR VGND sg13g2_tiehi
X_39480_ _17666_ VPWR VGND sg13g2_tiehi
X_39481_ _17667_ VPWR VGND sg13g2_tiehi
X_39482_ _17668_ VPWR VGND sg13g2_tiehi
X_39483_ _17669_ VPWR VGND sg13g2_tiehi
X_39484_ _17670_ VPWR VGND sg13g2_tiehi
X_39485_ _17671_ VPWR VGND sg13g2_tiehi
X_39486_ _17672_ VPWR VGND sg13g2_tiehi
X_39487_ _17673_ VPWR VGND sg13g2_tiehi
X_39488_ _17674_ VPWR VGND sg13g2_tiehi
X_39489_ _17675_ VPWR VGND sg13g2_tiehi
X_39490_ _17676_ VPWR VGND sg13g2_tiehi
X_39491_ _17677_ VPWR VGND sg13g2_tiehi
X_39492_ _17678_ VPWR VGND sg13g2_tiehi
X_39493_ _17679_ VPWR VGND sg13g2_tiehi
X_39494_ _17680_ VPWR VGND sg13g2_tiehi
X_39495_ _17681_ VPWR VGND sg13g2_tiehi
X_39496_ _17682_ VPWR VGND sg13g2_tiehi
X_39497_ _17683_ VPWR VGND sg13g2_tiehi
X_39498_ _17684_ VPWR VGND sg13g2_tiehi
X_39499_ _17685_ VPWR VGND sg13g2_tiehi
X_39500_ _17686_ VPWR VGND sg13g2_tiehi
X_39501_ _17687_ VPWR VGND sg13g2_tiehi
X_39502_ _17688_ VPWR VGND sg13g2_tiehi
X_39503_ _17689_ VPWR VGND sg13g2_tiehi
X_39504_ _17690_ VPWR VGND sg13g2_tiehi
X_39505_ _17691_ VPWR VGND sg13g2_tiehi
X_39506_ _17692_ VPWR VGND sg13g2_tiehi
X_39507_ _17693_ VPWR VGND sg13g2_tiehi
X_39508_ _17694_ VPWR VGND sg13g2_tiehi
X_39509_ _17695_ VPWR VGND sg13g2_tiehi
X_39510_ _17696_ VPWR VGND sg13g2_tiehi
X_39511_ _17697_ VPWR VGND sg13g2_tiehi
X_39512_ _17698_ VPWR VGND sg13g2_tiehi
X_39513_ _17699_ VPWR VGND sg13g2_tiehi
X_39514_ _17700_ VPWR VGND sg13g2_tiehi
X_39515_ _17701_ VPWR VGND sg13g2_tiehi
X_39516_ _17702_ VPWR VGND sg13g2_tiehi
X_39517_ _17703_ VPWR VGND sg13g2_tiehi
X_39518_ _17704_ VPWR VGND sg13g2_tiehi
X_39519_ _17705_ VPWR VGND sg13g2_tiehi
X_39520_ _17706_ VPWR VGND sg13g2_tiehi
X_39521_ _17707_ VPWR VGND sg13g2_tiehi
X_39522_ _17708_ VPWR VGND sg13g2_tiehi
X_39523_ _17709_ VPWR VGND sg13g2_tiehi
X_39524_ _17710_ VPWR VGND sg13g2_tiehi
X_39525_ _17711_ VPWR VGND sg13g2_tiehi
X_39526_ _17712_ VPWR VGND sg13g2_tiehi
X_39527_ _17713_ VPWR VGND sg13g2_tiehi
X_39528_ _17714_ VPWR VGND sg13g2_tiehi
X_39529_ _17715_ VPWR VGND sg13g2_tiehi
X_39530_ _17716_ VPWR VGND sg13g2_tiehi
X_39531_ _17717_ VPWR VGND sg13g2_tiehi
X_39532_ _17718_ VPWR VGND sg13g2_tiehi
X_39533_ _17719_ VPWR VGND sg13g2_tiehi
X_39534_ _17720_ VPWR VGND sg13g2_tiehi
X_39535_ _17721_ VPWR VGND sg13g2_tiehi
X_39536_ _17722_ VPWR VGND sg13g2_tiehi
X_39537_ _17723_ VPWR VGND sg13g2_tiehi
X_39538_ _17724_ VPWR VGND sg13g2_tiehi
X_39539_ _17725_ VPWR VGND sg13g2_tiehi
X_39540_ _17726_ VPWR VGND sg13g2_tiehi
X_39541_ _17727_ VPWR VGND sg13g2_tiehi
X_39542_ _17728_ VPWR VGND sg13g2_tiehi
X_39543_ _17729_ VPWR VGND sg13g2_tiehi
X_39544_ _17730_ VPWR VGND sg13g2_tiehi
X_39545_ _17731_ VPWR VGND sg13g2_tiehi
X_39546_ _17732_ VPWR VGND sg13g2_tiehi
X_39547_ _17733_ VPWR VGND sg13g2_tiehi
X_39548_ _17734_ VPWR VGND sg13g2_tiehi
X_39549_ _17735_ VPWR VGND sg13g2_tiehi
X_39550_ _17736_ VPWR VGND sg13g2_tiehi
X_39551_ _17737_ VPWR VGND sg13g2_tiehi
X_39552_ _17738_ VPWR VGND sg13g2_tiehi
X_39553_ _17739_ VPWR VGND sg13g2_tiehi
X_39554_ _17740_ VPWR VGND sg13g2_tiehi
X_39555_ _17741_ VPWR VGND sg13g2_tiehi
X_39556_ _17742_ VPWR VGND sg13g2_tiehi
X_39557_ _17743_ VPWR VGND sg13g2_tiehi
X_39558_ _17744_ VPWR VGND sg13g2_tiehi
X_39559_ _17745_ VPWR VGND sg13g2_tiehi
X_39560_ _17746_ VPWR VGND sg13g2_tiehi
X_39561_ _17747_ VPWR VGND sg13g2_tiehi
X_39562_ _17748_ VPWR VGND sg13g2_tiehi
X_39563_ _17749_ VPWR VGND sg13g2_tiehi
X_39564_ _17750_ VPWR VGND sg13g2_tiehi
X_39565_ _17751_ VPWR VGND sg13g2_tiehi
X_39566_ _17752_ VPWR VGND sg13g2_tiehi
X_39567_ _17753_ VPWR VGND sg13g2_tiehi
X_39568_ _17754_ VPWR VGND sg13g2_tiehi
X_39569_ _17755_ VPWR VGND sg13g2_tiehi
X_39570_ _17756_ VPWR VGND sg13g2_tiehi
X_39571_ _17757_ VPWR VGND sg13g2_tiehi
X_39572_ _17758_ VPWR VGND sg13g2_tiehi
X_39573_ _17759_ VPWR VGND sg13g2_tiehi
X_39574_ _17760_ VPWR VGND sg13g2_tiehi
X_39575_ _17761_ VPWR VGND sg13g2_tiehi
X_39576_ _17762_ VPWR VGND sg13g2_tiehi
X_39577_ _17763_ VPWR VGND sg13g2_tiehi
X_39578_ _17764_ VPWR VGND sg13g2_tiehi
X_39579_ _17765_ VPWR VGND sg13g2_tiehi
X_39580_ _17766_ VPWR VGND sg13g2_tiehi
X_39581_ _17767_ VPWR VGND sg13g2_tiehi
X_39582_ _17768_ VPWR VGND sg13g2_tiehi
X_39583_ _17769_ VPWR VGND sg13g2_tiehi
X_39584_ _17770_ VPWR VGND sg13g2_tiehi
X_39585_ _17771_ VPWR VGND sg13g2_tiehi
X_39586_ _17772_ VPWR VGND sg13g2_tiehi
X_39587_ _17773_ VPWR VGND sg13g2_tiehi
X_39588_ _17774_ VPWR VGND sg13g2_tiehi
X_39589_ _17775_ VPWR VGND sg13g2_tiehi
X_39590_ _17776_ VPWR VGND sg13g2_tiehi
X_39591_ _17777_ VPWR VGND sg13g2_tiehi
X_39592_ _17778_ VPWR VGND sg13g2_tiehi
X_39593_ _17779_ VPWR VGND sg13g2_tiehi
X_39594_ _17780_ VPWR VGND sg13g2_tiehi
X_39595_ _17781_ VPWR VGND sg13g2_tiehi
X_39596_ _17782_ VPWR VGND sg13g2_tiehi
X_39597_ _17783_ VPWR VGND sg13g2_tiehi
X_39598_ _17784_ VPWR VGND sg13g2_tiehi
X_39599_ _17785_ VPWR VGND sg13g2_tiehi
X_39600_ _17786_ VPWR VGND sg13g2_tiehi
X_39601_ _17787_ VPWR VGND sg13g2_tiehi
X_39602_ _17788_ VPWR VGND sg13g2_tiehi
X_39603_ _17789_ VPWR VGND sg13g2_tiehi
X_39604_ _17790_ VPWR VGND sg13g2_tiehi
X_39605_ _17791_ VPWR VGND sg13g2_tiehi
X_39606_ _17792_ VPWR VGND sg13g2_tiehi
X_39607_ _17793_ VPWR VGND sg13g2_tiehi
X_39608_ _17794_ VPWR VGND sg13g2_tiehi
X_39609_ _17795_ VPWR VGND sg13g2_tiehi
X_39610_ _17796_ VPWR VGND sg13g2_tiehi
X_39611_ _17797_ VPWR VGND sg13g2_tiehi
X_39612_ _17798_ VPWR VGND sg13g2_tiehi
X_39613_ _17799_ VPWR VGND sg13g2_tiehi
X_39614_ _17800_ VPWR VGND sg13g2_tiehi
X_39615_ _17801_ VPWR VGND sg13g2_tiehi
X_39616_ _17802_ VPWR VGND sg13g2_tiehi
X_39617_ _17803_ VPWR VGND sg13g2_tiehi
X_39618_ _17804_ VPWR VGND sg13g2_tiehi
X_39619_ _17805_ VPWR VGND sg13g2_tiehi
X_39620_ _17806_ VPWR VGND sg13g2_tiehi
X_39621_ _17807_ VPWR VGND sg13g2_tiehi
X_39622_ _17808_ VPWR VGND sg13g2_tiehi
X_39623_ _17809_ VPWR VGND sg13g2_tiehi
X_39624_ _17810_ VPWR VGND sg13g2_tiehi
X_39625_ _17811_ VPWR VGND sg13g2_tiehi
X_39626_ _17812_ VPWR VGND sg13g2_tiehi
X_39627_ _17813_ VPWR VGND sg13g2_tiehi
X_39628_ _17814_ VPWR VGND sg13g2_tiehi
X_39629_ _17815_ VPWR VGND sg13g2_tiehi
X_39630_ _17816_ VPWR VGND sg13g2_tiehi
X_39631_ _17817_ VPWR VGND sg13g2_tiehi
X_39632_ _17818_ VPWR VGND sg13g2_tiehi
X_39633_ _17819_ VPWR VGND sg13g2_tiehi
X_39634_ _17820_ VPWR VGND sg13g2_tiehi
X_39635_ _17821_ VPWR VGND sg13g2_tiehi
X_39636_ _17822_ VPWR VGND sg13g2_tiehi
X_39637_ _17823_ VPWR VGND sg13g2_tiehi
X_39638_ _17824_ VPWR VGND sg13g2_tiehi
X_39639_ _17825_ VPWR VGND sg13g2_tiehi
X_39640_ _17826_ VPWR VGND sg13g2_tiehi
X_39641_ _17827_ VPWR VGND sg13g2_tiehi
X_39642_ _17828_ VPWR VGND sg13g2_tiehi
X_39643_ _17829_ VPWR VGND sg13g2_tiehi
X_39644_ _17830_ VPWR VGND sg13g2_tiehi
X_39645_ _17831_ VPWR VGND sg13g2_tiehi
X_39646_ _17832_ VPWR VGND sg13g2_tiehi
X_39647_ _17833_ VPWR VGND sg13g2_tiehi
X_39648_ _17834_ VPWR VGND sg13g2_tiehi
X_39649_ _17835_ VPWR VGND sg13g2_tiehi
X_39650_ _17836_ VPWR VGND sg13g2_tiehi
X_39651_ _17837_ VPWR VGND sg13g2_tiehi
X_39652_ _17838_ VPWR VGND sg13g2_tiehi
X_39653_ _17839_ VPWR VGND sg13g2_tiehi
X_39654_ _17840_ VPWR VGND sg13g2_tiehi
X_39655_ _17841_ VPWR VGND sg13g2_tiehi
X_39656_ _17842_ VPWR VGND sg13g2_tiehi
X_39657_ _17843_ VPWR VGND sg13g2_tiehi
X_39658_ _17844_ VPWR VGND sg13g2_tiehi
X_39659_ _17845_ VPWR VGND sg13g2_tiehi
X_39660_ _17846_ VPWR VGND sg13g2_tiehi
X_39661_ _17847_ VPWR VGND sg13g2_tiehi
X_39662_ _17848_ VPWR VGND sg13g2_tiehi
X_39663_ _17849_ VPWR VGND sg13g2_tiehi
X_39664_ _17850_ VPWR VGND sg13g2_tiehi
X_39665_ _17851_ VPWR VGND sg13g2_tiehi
X_39666_ _17852_ VPWR VGND sg13g2_tiehi
X_39667_ _17853_ VPWR VGND sg13g2_tiehi
X_39668_ _17854_ VPWR VGND sg13g2_tiehi
X_39669_ _17855_ VPWR VGND sg13g2_tiehi
X_39670_ _17856_ VPWR VGND sg13g2_tiehi
X_39671_ _17857_ VPWR VGND sg13g2_tiehi
X_39672_ _17858_ VPWR VGND sg13g2_tiehi
X_39673_ _17859_ VPWR VGND sg13g2_tiehi
X_39674_ _17860_ VPWR VGND sg13g2_tiehi
X_39675_ _17861_ VPWR VGND sg13g2_tiehi
X_39676_ _17862_ VPWR VGND sg13g2_tiehi
X_39677_ _17863_ VPWR VGND sg13g2_tiehi
X_39678_ _17864_ VPWR VGND sg13g2_tiehi
X_39679_ _17865_ VPWR VGND sg13g2_tiehi
X_39680_ _17866_ VPWR VGND sg13g2_tiehi
X_39681_ _17867_ VPWR VGND sg13g2_tiehi
X_39682_ _17868_ VPWR VGND sg13g2_tiehi
X_39683_ _17869_ VPWR VGND sg13g2_tiehi
X_39684_ _17870_ VPWR VGND sg13g2_tiehi
X_39685_ _17871_ VPWR VGND sg13g2_tiehi
X_39686_ _17872_ VPWR VGND sg13g2_tiehi
X_39687_ _17873_ VPWR VGND sg13g2_tiehi
X_39688_ _17874_ VPWR VGND sg13g2_tiehi
X_39689_ _17875_ VPWR VGND sg13g2_tiehi
X_39690_ _17876_ VPWR VGND sg13g2_tiehi
X_39691_ _17877_ VPWR VGND sg13g2_tiehi
X_39692_ _17878_ VPWR VGND sg13g2_tiehi
X_39693_ _17879_ VPWR VGND sg13g2_tiehi
X_39694_ _17880_ VPWR VGND sg13g2_tiehi
X_39695_ _17881_ VPWR VGND sg13g2_tiehi
X_39696_ _17882_ VPWR VGND sg13g2_tiehi
X_39697_ _17883_ VPWR VGND sg13g2_tiehi
X_39698_ _17884_ VPWR VGND sg13g2_tiehi
X_39699_ _17885_ VPWR VGND sg13g2_tiehi
X_39700_ _17886_ VPWR VGND sg13g2_tiehi
X_39701_ _17887_ VPWR VGND sg13g2_tiehi
X_39702_ _17888_ VPWR VGND sg13g2_tiehi
X_39703_ _17889_ VPWR VGND sg13g2_tiehi
X_39704_ _17890_ VPWR VGND sg13g2_tiehi
X_39705_ _17891_ VPWR VGND sg13g2_tiehi
X_39706_ _17892_ VPWR VGND sg13g2_tiehi
X_39707_ _17893_ VPWR VGND sg13g2_tiehi
X_39708_ _17894_ VPWR VGND sg13g2_tiehi
X_39709_ _17895_ VPWR VGND sg13g2_tiehi
X_39710_ _17896_ VPWR VGND sg13g2_tiehi
X_39711_ _17897_ VPWR VGND sg13g2_tiehi
X_39712_ _17898_ VPWR VGND sg13g2_tiehi
X_39713_ _17899_ VPWR VGND sg13g2_tiehi
X_39714_ _17900_ VPWR VGND sg13g2_tiehi
X_39715_ _17901_ VPWR VGND sg13g2_tiehi
X_39716_ _17902_ VPWR VGND sg13g2_tiehi
X_39717_ _17903_ VPWR VGND sg13g2_tiehi
X_39718_ _17904_ VPWR VGND sg13g2_tiehi
X_39719_ _17905_ VPWR VGND sg13g2_tiehi
X_39720_ _17906_ VPWR VGND sg13g2_tiehi
X_39721_ _17907_ VPWR VGND sg13g2_tiehi
X_39722_ _17908_ VPWR VGND sg13g2_tiehi
X_39723_ _17909_ VPWR VGND sg13g2_tiehi
X_39724_ _17910_ VPWR VGND sg13g2_tiehi
X_39725_ _17911_ VPWR VGND sg13g2_tiehi
X_39726_ _17912_ VPWR VGND sg13g2_tiehi
X_39727_ _17913_ VPWR VGND sg13g2_tiehi
X_39728_ _17914_ VPWR VGND sg13g2_tiehi
X_39729_ _17915_ VPWR VGND sg13g2_tiehi
X_39730_ _17916_ VPWR VGND sg13g2_tiehi
X_39731_ _17917_ VPWR VGND sg13g2_tiehi
X_39732_ _17918_ VPWR VGND sg13g2_tiehi
X_39733_ _17919_ VPWR VGND sg13g2_tiehi
X_39734_ _17920_ VPWR VGND sg13g2_tiehi
X_39735_ _17921_ VPWR VGND sg13g2_tiehi
X_39736_ _17922_ VPWR VGND sg13g2_tiehi
X_39737_ _17923_ VPWR VGND sg13g2_tiehi
X_39738_ _17924_ VPWR VGND sg13g2_tiehi
X_39739_ _17925_ VPWR VGND sg13g2_tiehi
X_39740_ _17926_ VPWR VGND sg13g2_tiehi
X_39741_ _17927_ VPWR VGND sg13g2_tiehi
X_39742_ _17928_ VPWR VGND sg13g2_tiehi
X_39743_ _17929_ VPWR VGND sg13g2_tiehi
X_39744_ _17930_ VPWR VGND sg13g2_tiehi
X_39745_ _17931_ VPWR VGND sg13g2_tiehi
X_39746_ _17932_ VPWR VGND sg13g2_tiehi
X_39747_ _17933_ VPWR VGND sg13g2_tiehi
X_39748_ _17934_ VPWR VGND sg13g2_tiehi
X_39749_ _17935_ VPWR VGND sg13g2_tiehi
X_39750_ _17936_ VPWR VGND sg13g2_tiehi
X_39751_ _17937_ VPWR VGND sg13g2_tiehi
X_39752_ _17938_ VPWR VGND sg13g2_tiehi
X_39753_ _17939_ VPWR VGND sg13g2_tiehi
X_39754_ _17940_ VPWR VGND sg13g2_tiehi
X_39755_ _17941_ VPWR VGND sg13g2_tiehi
X_39756_ _17942_ VPWR VGND sg13g2_tiehi
X_39757_ _17943_ VPWR VGND sg13g2_tiehi
X_39758_ _17944_ VPWR VGND sg13g2_tiehi
X_39759_ _17945_ VPWR VGND sg13g2_tiehi
X_39760_ _17946_ VPWR VGND sg13g2_tiehi
X_39761_ _17947_ VPWR VGND sg13g2_tiehi
X_39762_ _17948_ VPWR VGND sg13g2_tiehi
X_39763_ _17949_ VPWR VGND sg13g2_tiehi
X_39764_ _17950_ VPWR VGND sg13g2_tiehi
X_39765_ _17951_ VPWR VGND sg13g2_tiehi
X_39766_ _17952_ VPWR VGND sg13g2_tiehi
X_39767_ _17953_ VPWR VGND sg13g2_tiehi
X_39768_ _17954_ VPWR VGND sg13g2_tiehi
X_39769_ _17955_ VPWR VGND sg13g2_tiehi
X_39770_ _17956_ VPWR VGND sg13g2_tiehi
X_39771_ _17957_ VPWR VGND sg13g2_tiehi
X_39772_ _17958_ VPWR VGND sg13g2_tiehi
X_39773_ _17959_ VPWR VGND sg13g2_tiehi
X_39774_ _17960_ VPWR VGND sg13g2_tiehi
X_39775_ _17961_ VPWR VGND sg13g2_tiehi
X_39776_ _17962_ VPWR VGND sg13g2_tiehi
X_39777_ _17963_ VPWR VGND sg13g2_tiehi
X_39778_ _17964_ VPWR VGND sg13g2_tiehi
X_39779_ _17965_ VPWR VGND sg13g2_tiehi
X_39780_ _17966_ VPWR VGND sg13g2_tiehi
X_39781_ _17967_ VPWR VGND sg13g2_tiehi
X_39782_ _17968_ VPWR VGND sg13g2_tiehi
X_39783_ _17969_ VPWR VGND sg13g2_tiehi
X_39784_ _17970_ VPWR VGND sg13g2_tiehi
X_39785_ _17971_ VPWR VGND sg13g2_tiehi
X_39786_ _17972_ VPWR VGND sg13g2_tiehi
X_39787_ _17973_ VPWR VGND sg13g2_tiehi
X_39788_ _17974_ VPWR VGND sg13g2_tiehi
X_39789_ _17975_ VPWR VGND sg13g2_tiehi
X_39790_ _17976_ VPWR VGND sg13g2_tiehi
X_39791_ _17977_ VPWR VGND sg13g2_tiehi
X_39792_ _17978_ VPWR VGND sg13g2_tiehi
X_39793_ _17979_ VPWR VGND sg13g2_tiehi
X_39794_ _17980_ VPWR VGND sg13g2_tiehi
X_39795_ _17981_ VPWR VGND sg13g2_tiehi
X_39796_ _17982_ VPWR VGND sg13g2_tiehi
X_39797_ _17983_ VPWR VGND sg13g2_tiehi
X_39798_ _17984_ VPWR VGND sg13g2_tiehi
X_39799_ _17985_ VPWR VGND sg13g2_tiehi
X_39800_ _17986_ VPWR VGND sg13g2_tiehi
X_39801_ _17987_ VPWR VGND sg13g2_tiehi
X_39802_ _17988_ VPWR VGND sg13g2_tiehi
X_39803_ _17989_ VPWR VGND sg13g2_tiehi
X_39804_ _17990_ VPWR VGND sg13g2_tiehi
X_39805_ _17991_ VPWR VGND sg13g2_tiehi
X_39806_ _17992_ VPWR VGND sg13g2_tiehi
X_39807_ _17993_ VPWR VGND sg13g2_tiehi
X_39808_ _17994_ VPWR VGND sg13g2_tiehi
X_39809_ _17995_ VPWR VGND sg13g2_tiehi
X_39810_ _17996_ VPWR VGND sg13g2_tiehi
X_39811_ _17997_ VPWR VGND sg13g2_tiehi
X_39812_ _17998_ VPWR VGND sg13g2_tiehi
X_39813_ _17999_ VPWR VGND sg13g2_tiehi
X_39814_ _18000_ VPWR VGND sg13g2_tiehi
X_39815_ _18001_ VPWR VGND sg13g2_tiehi
X_39816_ _18002_ VPWR VGND sg13g2_tiehi
X_39817_ _18003_ VPWR VGND sg13g2_tiehi
X_39818_ _18004_ VPWR VGND sg13g2_tiehi
X_39819_ _18005_ VPWR VGND sg13g2_tiehi
X_39820_ _18006_ VPWR VGND sg13g2_tiehi
X_39821_ _18007_ VPWR VGND sg13g2_tiehi
X_39822_ _18008_ VPWR VGND sg13g2_tiehi
X_39823_ _18009_ VPWR VGND sg13g2_tiehi
X_39824_ _18010_ VPWR VGND sg13g2_tiehi
X_39825_ _18011_ VPWR VGND sg13g2_tiehi
X_39826_ _18012_ VPWR VGND sg13g2_tiehi
X_39827_ _18013_ VPWR VGND sg13g2_tiehi
X_39828_ _18014_ VPWR VGND sg13g2_tiehi
X_39829_ _18015_ VPWR VGND sg13g2_tiehi
X_39830_ _18016_ VPWR VGND sg13g2_tiehi
X_39831_ _18017_ VPWR VGND sg13g2_tiehi
X_39832_ _18018_ VPWR VGND sg13g2_tiehi
X_39833_ _18019_ VPWR VGND sg13g2_tiehi
X_39834_ _18020_ VPWR VGND sg13g2_tiehi
X_39835_ _18021_ VPWR VGND sg13g2_tiehi
X_39836_ _18022_ VPWR VGND sg13g2_tiehi
X_39837_ _18023_ VPWR VGND sg13g2_tiehi
X_39838_ _18024_ VPWR VGND sg13g2_tiehi
X_39839_ _18025_ VPWR VGND sg13g2_tiehi
X_39840_ _18026_ VPWR VGND sg13g2_tiehi
X_39841_ _18027_ VPWR VGND sg13g2_tiehi
X_39842_ _18028_ VPWR VGND sg13g2_tiehi
X_39843_ _18029_ VPWR VGND sg13g2_tiehi
X_39844_ _18030_ VPWR VGND sg13g2_tiehi
X_39845_ _18031_ VPWR VGND sg13g2_tiehi
X_39846_ _18032_ VPWR VGND sg13g2_tiehi
X_39847_ _18033_ VPWR VGND sg13g2_tiehi
X_39848_ _18034_ VPWR VGND sg13g2_tiehi
X_39849_ _18035_ VPWR VGND sg13g2_tiehi
X_39850_ _18036_ VPWR VGND sg13g2_tiehi
X_39851_ _18037_ VPWR VGND sg13g2_tiehi
X_39852_ _18038_ VPWR VGND sg13g2_tiehi
X_39853_ _18039_ VPWR VGND sg13g2_tiehi
X_39854_ _18040_ VPWR VGND sg13g2_tiehi
X_39855_ _18041_ VPWR VGND sg13g2_tiehi
X_39856_ _18042_ VPWR VGND sg13g2_tiehi
X_39857_ _18043_ VPWR VGND sg13g2_tiehi
X_39858_ _18044_ VPWR VGND sg13g2_tiehi
X_39859_ _18045_ VPWR VGND sg13g2_tiehi
X_39860_ _18046_ VPWR VGND sg13g2_tiehi
X_39861_ _18047_ VPWR VGND sg13g2_tiehi
X_39862_ _18048_ VPWR VGND sg13g2_tiehi
X_39863_ _18049_ VPWR VGND sg13g2_tiehi
X_39864_ _18050_ VPWR VGND sg13g2_tiehi
X_39865_ _18051_ VPWR VGND sg13g2_tiehi
X_39866_ _18052_ VPWR VGND sg13g2_tiehi
X_39867_ _18053_ VPWR VGND sg13g2_tiehi
X_39868_ _18054_ VPWR VGND sg13g2_tiehi
X_39869_ _18055_ VPWR VGND sg13g2_tiehi
X_39870_ _18056_ VPWR VGND sg13g2_tiehi
X_39871_ _18057_ VPWR VGND sg13g2_tiehi
X_39872_ _18058_ VPWR VGND sg13g2_tiehi
X_39873_ _18059_ VPWR VGND sg13g2_tiehi
X_39874_ _18060_ VPWR VGND sg13g2_tiehi
X_39875_ _18061_ VPWR VGND sg13g2_tiehi
X_39876_ _18062_ VPWR VGND sg13g2_tiehi
X_39877_ _18063_ VPWR VGND sg13g2_tiehi
X_39878_ _18064_ VPWR VGND sg13g2_tiehi
X_39879_ _18065_ VPWR VGND sg13g2_tiehi
X_39880_ _18066_ VPWR VGND sg13g2_tiehi
X_39881_ _18067_ VPWR VGND sg13g2_tiehi
X_39882_ _18068_ VPWR VGND sg13g2_tiehi
X_39883_ _18069_ VPWR VGND sg13g2_tiehi
X_39884_ _18070_ VPWR VGND sg13g2_tiehi
X_39885_ _18071_ VPWR VGND sg13g2_tiehi
X_39886_ _18072_ VPWR VGND sg13g2_tiehi
X_39887_ _18073_ VPWR VGND sg13g2_tiehi
X_39888_ _18074_ VPWR VGND sg13g2_tiehi
X_39889_ _18075_ VPWR VGND sg13g2_tiehi
X_39890_ _18076_ VPWR VGND sg13g2_tiehi
X_39891_ _18077_ VPWR VGND sg13g2_tiehi
X_39892_ _18078_ VPWR VGND sg13g2_tiehi
X_39893_ _18079_ VPWR VGND sg13g2_tiehi
X_39894_ _18080_ VPWR VGND sg13g2_tiehi
X_39895_ _18081_ VPWR VGND sg13g2_tiehi
X_39896_ _18082_ VPWR VGND sg13g2_tiehi
X_39897_ _18083_ VPWR VGND sg13g2_tiehi
X_39898_ _18084_ VPWR VGND sg13g2_tiehi
X_39899_ _18085_ VPWR VGND sg13g2_tiehi
X_39900_ _18086_ VPWR VGND sg13g2_tiehi
X_39901_ _18087_ VPWR VGND sg13g2_tiehi
X_39902_ _18088_ VPWR VGND sg13g2_tiehi
X_39903_ _18089_ VPWR VGND sg13g2_tiehi
X_39904_ _18090_ VPWR VGND sg13g2_tiehi
X_39905_ _18091_ VPWR VGND sg13g2_tiehi
X_39906_ _18092_ VPWR VGND sg13g2_tiehi
X_39907_ _18093_ VPWR VGND sg13g2_tiehi
X_39908_ _18094_ VPWR VGND sg13g2_tiehi
X_39909_ _18095_ VPWR VGND sg13g2_tiehi
X_39910_ _18096_ VPWR VGND sg13g2_tiehi
X_39911_ _18097_ VPWR VGND sg13g2_tiehi
X_39912_ _18098_ VPWR VGND sg13g2_tiehi
X_39913_ _18099_ VPWR VGND sg13g2_tiehi
X_39914_ _18100_ VPWR VGND sg13g2_tiehi
X_39915_ _18101_ VPWR VGND sg13g2_tiehi
X_39916_ _18102_ VPWR VGND sg13g2_tiehi
X_39917_ _18103_ VPWR VGND sg13g2_tiehi
X_39918_ _18104_ VPWR VGND sg13g2_tiehi
X_39919_ _18105_ VPWR VGND sg13g2_tiehi
X_39920_ _18106_ VPWR VGND sg13g2_tiehi
X_39921_ _18107_ VPWR VGND sg13g2_tiehi
X_39922_ _18108_ VPWR VGND sg13g2_tiehi
X_39923_ _18109_ VPWR VGND sg13g2_tiehi
X_39924_ _18110_ VPWR VGND sg13g2_tiehi
X_39925_ _18111_ VPWR VGND sg13g2_tiehi
X_39926_ _18112_ VPWR VGND sg13g2_tiehi
X_39927_ _18113_ VPWR VGND sg13g2_tiehi
X_39928_ _18114_ VPWR VGND sg13g2_tiehi
X_39929_ _18115_ VPWR VGND sg13g2_tiehi
X_39930_ _18116_ VPWR VGND sg13g2_tiehi
X_39931_ _18117_ VPWR VGND sg13g2_tiehi
X_39932_ _18118_ VPWR VGND sg13g2_tiehi
X_39933_ _18119_ VPWR VGND sg13g2_tiehi
X_39934_ _18120_ VPWR VGND sg13g2_tiehi
X_39935_ _18121_ VPWR VGND sg13g2_tiehi
X_39936_ _18122_ VPWR VGND sg13g2_tiehi
X_39937_ _18123_ VPWR VGND sg13g2_tiehi
X_39938_ _18124_ VPWR VGND sg13g2_tiehi
X_39939_ _18125_ VPWR VGND sg13g2_tiehi
X_39940_ _18126_ VPWR VGND sg13g2_tiehi
X_39941_ _18127_ VPWR VGND sg13g2_tiehi
X_39942_ _18128_ VPWR VGND sg13g2_tiehi
X_39943_ _18129_ VPWR VGND sg13g2_tiehi
X_39944_ _18130_ VPWR VGND sg13g2_tiehi
X_39945_ _18131_ VPWR VGND sg13g2_tiehi
X_39946_ _18132_ VPWR VGND sg13g2_tiehi
X_39947_ _18133_ VPWR VGND sg13g2_tiehi
X_39948_ _18134_ VPWR VGND sg13g2_tiehi
X_39949_ _18135_ VPWR VGND sg13g2_tiehi
X_39950_ _18136_ VPWR VGND sg13g2_tiehi
X_39951_ _18137_ VPWR VGND sg13g2_tiehi
X_39952_ _18138_ VPWR VGND sg13g2_tiehi
X_39953_ _18139_ VPWR VGND sg13g2_tiehi
X_39954_ _18140_ VPWR VGND sg13g2_tiehi
X_39955_ _18141_ VPWR VGND sg13g2_tiehi
X_39956_ _18142_ VPWR VGND sg13g2_tiehi
X_39957_ _18143_ VPWR VGND sg13g2_tiehi
X_39958_ _18144_ VPWR VGND sg13g2_tiehi
X_39959_ _18145_ VPWR VGND sg13g2_tiehi
X_39960_ _18146_ VPWR VGND sg13g2_tiehi
X_39961_ _18147_ VPWR VGND sg13g2_tiehi
X_39962_ _18148_ VPWR VGND sg13g2_tiehi
X_39963_ _18149_ VPWR VGND sg13g2_tiehi
X_39964_ _18150_ VPWR VGND sg13g2_tiehi
X_39965_ _18151_ VPWR VGND sg13g2_tiehi
X_39966_ _18152_ VPWR VGND sg13g2_tiehi
X_39967_ _18153_ VPWR VGND sg13g2_tiehi
X_39968_ _18154_ VPWR VGND sg13g2_tiehi
X_39969_ _18155_ VPWR VGND sg13g2_tiehi
X_39970_ _18156_ VPWR VGND sg13g2_tiehi
X_39971_ _18157_ VPWR VGND sg13g2_tiehi
X_39972_ _18158_ VPWR VGND sg13g2_tiehi
X_39973_ _18159_ VPWR VGND sg13g2_tiehi
X_39974_ _18160_ VPWR VGND sg13g2_tiehi
X_39975_ _18161_ VPWR VGND sg13g2_tiehi
X_39976_ _18162_ VPWR VGND sg13g2_tiehi
X_39977_ _18163_ VPWR VGND sg13g2_tiehi
X_39978_ _18164_ VPWR VGND sg13g2_tiehi
X_39979_ _18165_ VPWR VGND sg13g2_tiehi
X_39980_ _18166_ VPWR VGND sg13g2_tiehi
X_39981_ _18167_ VPWR VGND sg13g2_tiehi
X_39982_ _18168_ VPWR VGND sg13g2_tiehi
X_39983_ _18169_ VPWR VGND sg13g2_tiehi
X_39984_ _18170_ VPWR VGND sg13g2_tiehi
X_39985_ _18171_ VPWR VGND sg13g2_tiehi
X_39986_ _18172_ VPWR VGND sg13g2_tiehi
X_39987_ _18173_ VPWR VGND sg13g2_tiehi
X_39988_ _18174_ VPWR VGND sg13g2_tiehi
X_39989_ _18175_ VPWR VGND sg13g2_tiehi
X_39990_ _18176_ VPWR VGND sg13g2_tiehi
X_39991_ _18177_ VPWR VGND sg13g2_tiehi
X_39992_ _18178_ VPWR VGND sg13g2_tiehi
X_39993_ _18179_ VPWR VGND sg13g2_tiehi
X_39994_ _18180_ VPWR VGND sg13g2_tiehi
X_39995_ _18181_ VPWR VGND sg13g2_tiehi
X_39996_ _18182_ VPWR VGND sg13g2_tiehi
X_39997_ _18183_ VPWR VGND sg13g2_tiehi
X_39998_ _18184_ VPWR VGND sg13g2_tiehi
X_39999_ _18185_ VPWR VGND sg13g2_tiehi
X_40000_ _18186_ VPWR VGND sg13g2_tiehi
X_40001_ _18187_ VPWR VGND sg13g2_tiehi
X_40002_ _18188_ VPWR VGND sg13g2_tiehi
X_40003_ _18189_ VPWR VGND sg13g2_tiehi
X_40004_ _18190_ VPWR VGND sg13g2_tiehi
X_40005_ _18191_ VPWR VGND sg13g2_tiehi
X_40006_ _18192_ VPWR VGND sg13g2_tiehi
X_40007_ _18193_ VPWR VGND sg13g2_tiehi
X_40008_ _18194_ VPWR VGND sg13g2_tiehi
X_40009_ _18195_ VPWR VGND sg13g2_tiehi
X_40010_ _18196_ VPWR VGND sg13g2_tiehi
X_40011_ _18197_ VPWR VGND sg13g2_tiehi
X_40012_ _18198_ VPWR VGND sg13g2_tiehi
X_40013_ _18199_ VPWR VGND sg13g2_tiehi
X_40014_ _18200_ VPWR VGND sg13g2_tiehi
X_40015_ _18201_ VPWR VGND sg13g2_tiehi
X_40016_ _18202_ VPWR VGND sg13g2_tiehi
X_40017_ _18203_ VPWR VGND sg13g2_tiehi
X_40018_ _18204_ VPWR VGND sg13g2_tiehi
X_40019_ _18205_ VPWR VGND sg13g2_tiehi
X_40020_ _18206_ VPWR VGND sg13g2_tiehi
X_40021_ _18207_ VPWR VGND sg13g2_tiehi
X_40022_ _18208_ VPWR VGND sg13g2_tiehi
X_40023_ _18209_ VPWR VGND sg13g2_tiehi
X_40024_ _18210_ VPWR VGND sg13g2_tiehi
X_40025_ _18211_ VPWR VGND sg13g2_tiehi
X_40026_ _18212_ VPWR VGND sg13g2_tiehi
X_40027_ _18213_ VPWR VGND sg13g2_tiehi
X_40028_ _18214_ VPWR VGND sg13g2_tiehi
X_40029_ _18215_ VPWR VGND sg13g2_tiehi
X_40030_ _18216_ VPWR VGND sg13g2_tiehi
X_40031_ _18217_ VPWR VGND sg13g2_tiehi
X_40032_ _18218_ VPWR VGND sg13g2_tiehi
X_40033_ _18219_ VPWR VGND sg13g2_tiehi
X_40034_ _18220_ VPWR VGND sg13g2_tiehi
X_40035_ _18221_ VPWR VGND sg13g2_tiehi
X_40036_ _18222_ VPWR VGND sg13g2_tiehi
X_40037_ _18223_ VPWR VGND sg13g2_tiehi
X_40038_ _18224_ VPWR VGND sg13g2_tiehi
X_40039_ _18225_ VPWR VGND sg13g2_tiehi
X_40040_ _18226_ VPWR VGND sg13g2_tiehi
X_40041_ _18227_ VPWR VGND sg13g2_tiehi
X_40042_ _18228_ VPWR VGND sg13g2_tiehi
X_40043_ _18229_ VPWR VGND sg13g2_tiehi
X_40044_ _18230_ VPWR VGND sg13g2_tiehi
X_40045_ _18231_ VPWR VGND sg13g2_tiehi
X_40046_ _18232_ VPWR VGND sg13g2_tiehi
X_40047_ _18233_ VPWR VGND sg13g2_tiehi
X_40048_ _18234_ VPWR VGND sg13g2_tiehi
X_40049_ _18235_ VPWR VGND sg13g2_tiehi
X_40050_ _18236_ VPWR VGND sg13g2_tiehi
X_40051_ _18237_ VPWR VGND sg13g2_tiehi
X_40052_ _18238_ VPWR VGND sg13g2_tiehi
X_40053_ _18239_ VPWR VGND sg13g2_tiehi
X_40054_ _18240_ VPWR VGND sg13g2_tiehi
X_40055_ _18241_ VPWR VGND sg13g2_tiehi
X_40056_ _18242_ VPWR VGND sg13g2_tiehi
X_40057_ _18243_ VPWR VGND sg13g2_tiehi
X_40058_ _18244_ VPWR VGND sg13g2_tiehi
X_40059_ _18245_ VPWR VGND sg13g2_tiehi
X_40060_ _18246_ VPWR VGND sg13g2_tiehi
X_40061_ _18247_ VPWR VGND sg13g2_tiehi
X_40062_ _18248_ VPWR VGND sg13g2_tiehi
X_40063_ _18249_ VPWR VGND sg13g2_tiehi
X_40064_ _18250_ VPWR VGND sg13g2_tiehi
X_40065_ _18251_ VPWR VGND sg13g2_tiehi
X_40066_ _18252_ VPWR VGND sg13g2_tiehi
X_40067_ _18253_ VPWR VGND sg13g2_tiehi
X_40068_ _18254_ VPWR VGND sg13g2_tiehi
X_40069_ _18255_ VPWR VGND sg13g2_tiehi
X_40070_ _18256_ VPWR VGND sg13g2_tiehi
X_40071_ _18257_ VPWR VGND sg13g2_tiehi
X_40072_ _18258_ VPWR VGND sg13g2_tiehi
X_40073_ _18259_ VPWR VGND sg13g2_tiehi
X_40074_ _18260_ VPWR VGND sg13g2_tiehi
X_40075_ _18261_ VPWR VGND sg13g2_tiehi
X_40076_ _18262_ VPWR VGND sg13g2_tiehi
X_40077_ _18263_ VPWR VGND sg13g2_tiehi
X_40078_ _18264_ VPWR VGND sg13g2_tiehi
X_40079_ _18265_ VPWR VGND sg13g2_tiehi
X_40080_ _18266_ VPWR VGND sg13g2_tiehi
X_40081_ _18267_ VPWR VGND sg13g2_tiehi
X_40082_ _18268_ VPWR VGND sg13g2_tiehi
X_40083_ _18269_ VPWR VGND sg13g2_tiehi
X_40084_ _18270_ VPWR VGND sg13g2_tiehi
X_40085_ _18271_ VPWR VGND sg13g2_tiehi
X_40086_ _18272_ VPWR VGND sg13g2_tiehi
X_40087_ _18273_ VPWR VGND sg13g2_tiehi
X_40088_ _18274_ VPWR VGND sg13g2_tiehi
X_40089_ _18275_ VPWR VGND sg13g2_tiehi
X_40090_ _18276_ VPWR VGND sg13g2_tiehi
X_40091_ _18277_ VPWR VGND sg13g2_tiehi
X_40092_ _18278_ VPWR VGND sg13g2_tiehi
X_40093_ _18279_ VPWR VGND sg13g2_tiehi
X_40094_ _18280_ VPWR VGND sg13g2_tiehi
X_40095_ _18281_ VPWR VGND sg13g2_tiehi
X_40096_ _18282_ VPWR VGND sg13g2_tiehi
X_40097_ _18283_ VPWR VGND sg13g2_tiehi
X_40098_ _18284_ VPWR VGND sg13g2_tiehi
X_40099_ _18285_ VPWR VGND sg13g2_tiehi
X_40100_ _18286_ VPWR VGND sg13g2_tiehi
X_40101_ _18287_ VPWR VGND sg13g2_tiehi
X_40102_ _18288_ VPWR VGND sg13g2_tiehi
X_40103_ _18289_ VPWR VGND sg13g2_tiehi
X_40104_ _18290_ VPWR VGND sg13g2_tiehi
X_40105_ _18291_ VPWR VGND sg13g2_tiehi
X_40106_ _18292_ VPWR VGND sg13g2_tiehi
X_40107_ _18293_ VPWR VGND sg13g2_tiehi
X_40108_ _18294_ VPWR VGND sg13g2_tiehi
X_40109_ _18295_ VPWR VGND sg13g2_tiehi
X_40110_ _18296_ VPWR VGND sg13g2_tiehi
X_40111_ _18297_ VPWR VGND sg13g2_tiehi
X_40112_ _18298_ VPWR VGND sg13g2_tiehi
X_40113_ _18299_ VPWR VGND sg13g2_tiehi
X_40114_ _18300_ VPWR VGND sg13g2_tiehi
X_40115_ _18301_ VPWR VGND sg13g2_tiehi
X_40116_ _18302_ VPWR VGND sg13g2_tiehi
X_40117_ _18303_ VPWR VGND sg13g2_tiehi
X_40118_ _18304_ VPWR VGND sg13g2_tiehi
X_40119_ _18305_ VPWR VGND sg13g2_tiehi
X_40120_ _18306_ VPWR VGND sg13g2_tiehi
X_40121_ _18307_ VPWR VGND sg13g2_tiehi
X_40122_ _18308_ VPWR VGND sg13g2_tiehi
X_40123_ _18309_ VPWR VGND sg13g2_tiehi
X_40124_ _18310_ VPWR VGND sg13g2_tiehi
X_40125_ _18311_ VPWR VGND sg13g2_tiehi
X_40126_ _18312_ VPWR VGND sg13g2_tiehi
X_40127_ _18313_ VPWR VGND sg13g2_tiehi
X_40128_ _18314_ VPWR VGND sg13g2_tiehi
X_40129_ _18315_ VPWR VGND sg13g2_tiehi
X_40130_ _18316_ VPWR VGND sg13g2_tiehi
X_40131_ _18317_ VPWR VGND sg13g2_tiehi
X_40132_ _18318_ VPWR VGND sg13g2_tiehi
X_40133_ _18319_ VPWR VGND sg13g2_tiehi
X_40134_ _18320_ VPWR VGND sg13g2_tiehi
X_40135_ _18321_ VPWR VGND sg13g2_tiehi
X_40136_ _18322_ VPWR VGND sg13g2_tiehi
X_40137_ _18323_ VPWR VGND sg13g2_tiehi
X_40138_ _18324_ VPWR VGND sg13g2_tiehi
X_40139_ _18325_ VPWR VGND sg13g2_tiehi
X_40140_ _18326_ VPWR VGND sg13g2_tiehi
X_40141_ _18327_ VPWR VGND sg13g2_tiehi
X_40142_ _18328_ VPWR VGND sg13g2_tiehi
X_40143_ _18329_ VPWR VGND sg13g2_tiehi
X_40144_ _18330_ VPWR VGND sg13g2_tiehi
X_40145_ _18331_ VPWR VGND sg13g2_tiehi
X_40146_ _18332_ VPWR VGND sg13g2_tiehi
X_40147_ _18333_ VPWR VGND sg13g2_tiehi
X_40148_ _18334_ VPWR VGND sg13g2_tiehi
X_40149_ _18335_ VPWR VGND sg13g2_tiehi
X_40150_ _18336_ VPWR VGND sg13g2_tiehi
X_40151_ _18337_ VPWR VGND sg13g2_tiehi
X_40152_ _18338_ VPWR VGND sg13g2_tiehi
X_40153_ _18339_ VPWR VGND sg13g2_tiehi
X_40154_ _18340_ VPWR VGND sg13g2_tiehi
X_40155_ _18341_ VPWR VGND sg13g2_tiehi
X_40156_ _18342_ VPWR VGND sg13g2_tiehi
X_40157_ _18343_ VPWR VGND sg13g2_tiehi
X_40158_ _18344_ VPWR VGND sg13g2_tiehi
X_40159_ _18345_ VPWR VGND sg13g2_tiehi
X_40160_ _18346_ VPWR VGND sg13g2_tiehi
X_40161_ _18347_ VPWR VGND sg13g2_tiehi
X_40162_ _18348_ VPWR VGND sg13g2_tiehi
X_40163_ _18349_ VPWR VGND sg13g2_tiehi
X_40164_ _18350_ VPWR VGND sg13g2_tiehi
X_40165_ _18351_ VPWR VGND sg13g2_tiehi
X_40166_ _18352_ VPWR VGND sg13g2_tiehi
X_40167_ _18353_ VPWR VGND sg13g2_tiehi
X_40168_ _18354_ VPWR VGND sg13g2_tiehi
X_40169_ _18355_ VPWR VGND sg13g2_tiehi
X_40170_ _18356_ VPWR VGND sg13g2_tiehi
X_40171_ _18357_ VPWR VGND sg13g2_tiehi
X_40172_ _18358_ VPWR VGND sg13g2_tiehi
X_40173_ _18359_ VPWR VGND sg13g2_tiehi
X_40174_ _18360_ VPWR VGND sg13g2_tiehi
X_40175_ _18361_ VPWR VGND sg13g2_tiehi
X_40176_ _18362_ VPWR VGND sg13g2_tiehi
X_40177_ _18363_ VPWR VGND sg13g2_tiehi
X_40178_ _18364_ VPWR VGND sg13g2_tiehi
X_40179_ _18365_ VPWR VGND sg13g2_tiehi
X_40180_ _18366_ VPWR VGND sg13g2_tiehi
X_40181_ _18367_ VPWR VGND sg13g2_tiehi
X_40182_ _18368_ VPWR VGND sg13g2_tiehi
X_40183_ _18369_ VPWR VGND sg13g2_tiehi
X_40184_ _18370_ VPWR VGND sg13g2_tiehi
X_40185_ _18371_ VPWR VGND sg13g2_tiehi
X_40186_ _18372_ VPWR VGND sg13g2_tiehi
X_40187_ _18373_ VPWR VGND sg13g2_tiehi
X_40188_ _18374_ VPWR VGND sg13g2_tiehi
X_40189_ _18375_ VPWR VGND sg13g2_tiehi
X_40190_ _18376_ VPWR VGND sg13g2_tiehi
X_40191_ _18377_ VPWR VGND sg13g2_tiehi
X_40192_ _18378_ VPWR VGND sg13g2_tiehi
X_40193_ _18379_ VPWR VGND sg13g2_tiehi
X_40194_ _18380_ VPWR VGND sg13g2_tiehi
X_40195_ _18381_ VPWR VGND sg13g2_tiehi
X_40196_ _18382_ VPWR VGND sg13g2_tiehi
X_40197_ _18383_ VPWR VGND sg13g2_tiehi
X_40198_ _18384_ VPWR VGND sg13g2_tiehi
X_40199_ _18385_ VPWR VGND sg13g2_tiehi
X_40200_ _18386_ VPWR VGND sg13g2_tiehi
X_40201_ _18387_ VPWR VGND sg13g2_tiehi
X_40202_ _18388_ VPWR VGND sg13g2_tiehi
X_40203_ _18389_ VPWR VGND sg13g2_tiehi
X_40204_ _18390_ VPWR VGND sg13g2_tiehi
X_40205_ _18391_ VPWR VGND sg13g2_tiehi
X_40206_ _18392_ VPWR VGND sg13g2_tiehi
X_40207_ _18393_ VPWR VGND sg13g2_tiehi
X_40208_ _18394_ VPWR VGND sg13g2_tiehi
X_40209_ _18395_ VPWR VGND sg13g2_tiehi
X_40210_ _18396_ VPWR VGND sg13g2_tiehi
X_40211_ _18397_ VPWR VGND sg13g2_tiehi
X_40212_ _18398_ VPWR VGND sg13g2_tiehi
X_40213_ _18399_ VPWR VGND sg13g2_tiehi
X_40214_ _18400_ VPWR VGND sg13g2_tiehi
X_40215_ _18401_ VPWR VGND sg13g2_tiehi
X_40216_ _18402_ VPWR VGND sg13g2_tiehi
X_40217_ _18403_ VPWR VGND sg13g2_tiehi
X_40218_ _18404_ VPWR VGND sg13g2_tiehi
X_40219_ _18405_ VPWR VGND sg13g2_tiehi
X_40220_ _18406_ VPWR VGND sg13g2_tiehi
X_40221_ _18407_ VPWR VGND sg13g2_tiehi
X_40222_ _18408_ VPWR VGND sg13g2_tiehi
X_40223_ _18409_ VPWR VGND sg13g2_tiehi
X_40224_ _18410_ VPWR VGND sg13g2_tiehi
X_40225_ _18411_ VPWR VGND sg13g2_tiehi
X_40226_ _18412_ VPWR VGND sg13g2_tiehi
X_40227_ _18413_ VPWR VGND sg13g2_tiehi
X_40228_ _18414_ VPWR VGND sg13g2_tiehi
X_40229_ _18415_ VPWR VGND sg13g2_tiehi
X_40230_ _18416_ VPWR VGND sg13g2_tiehi
X_40231_ _18417_ VPWR VGND sg13g2_tiehi
X_40232_ _18418_ VPWR VGND sg13g2_tiehi
X_40233_ _18419_ VPWR VGND sg13g2_tiehi
X_40234_ _18420_ VPWR VGND sg13g2_tiehi
X_40235_ _18421_ VPWR VGND sg13g2_tiehi
X_40236_ _18422_ VPWR VGND sg13g2_tiehi
X_40237_ _18423_ VPWR VGND sg13g2_tiehi
X_40238_ _18424_ VPWR VGND sg13g2_tiehi
X_40239_ _18425_ VPWR VGND sg13g2_tiehi
X_40240_ _18426_ VPWR VGND sg13g2_tiehi
X_40241_ _18427_ VPWR VGND sg13g2_tiehi
X_40242_ _18428_ VPWR VGND sg13g2_tiehi
X_40243_ _18429_ VPWR VGND sg13g2_tiehi
X_40244_ _18430_ VPWR VGND sg13g2_tiehi
X_40245_ _18431_ VPWR VGND sg13g2_tiehi
X_40246_ _18432_ VPWR VGND sg13g2_tiehi
X_40247_ _18433_ VPWR VGND sg13g2_tiehi
X_40248_ _18434_ VPWR VGND sg13g2_tiehi
X_40249_ _18435_ VPWR VGND sg13g2_tiehi
X_40250_ _18436_ VPWR VGND sg13g2_tiehi
X_40251_ _18437_ VPWR VGND sg13g2_tiehi
X_40252_ _18438_ VPWR VGND sg13g2_tiehi
X_40253_ _18439_ VPWR VGND sg13g2_tiehi
X_40254_ _18440_ VPWR VGND sg13g2_tiehi
X_40255_ _18441_ VPWR VGND sg13g2_tiehi
X_40256_ _18442_ VPWR VGND sg13g2_tiehi
X_40257_ _18443_ VPWR VGND sg13g2_tiehi
X_40258_ _18444_ VPWR VGND sg13g2_tiehi
X_40259_ _18445_ VPWR VGND sg13g2_tiehi
X_40260_ _18446_ VPWR VGND sg13g2_tiehi
X_40261_ _18447_ VPWR VGND sg13g2_tiehi
X_40262_ _18448_ VPWR VGND sg13g2_tiehi
X_40263_ _18449_ VPWR VGND sg13g2_tiehi
X_40264_ _18450_ VPWR VGND sg13g2_tiehi
X_40265_ _18451_ VPWR VGND sg13g2_tiehi
X_40266_ _18452_ VPWR VGND sg13g2_tiehi
X_40267_ _18453_ VPWR VGND sg13g2_tiehi
X_40268_ _18454_ VPWR VGND sg13g2_tiehi
X_40269_ _18455_ VPWR VGND sg13g2_tiehi
X_40270_ _18456_ VPWR VGND sg13g2_tiehi
X_40271_ _18457_ VPWR VGND sg13g2_tiehi
X_40272_ _18458_ VPWR VGND sg13g2_tiehi
X_40273_ _18459_ VPWR VGND sg13g2_tiehi
X_40274_ _18460_ VPWR VGND sg13g2_tiehi
X_40275_ _18461_ VPWR VGND sg13g2_tiehi
X_40276_ _18462_ VPWR VGND sg13g2_tiehi
X_40277_ _18463_ VPWR VGND sg13g2_tiehi
X_40278_ _18464_ VPWR VGND sg13g2_tiehi
X_40279_ _18465_ VPWR VGND sg13g2_tiehi
X_40280_ _18466_ VPWR VGND sg13g2_tiehi
X_40281_ _18467_ VPWR VGND sg13g2_tiehi
X_40282_ _18468_ VPWR VGND sg13g2_tiehi
X_40283_ _18469_ VPWR VGND sg13g2_tiehi
X_40284_ _18470_ VPWR VGND sg13g2_tiehi
X_40285_ _18471_ VPWR VGND sg13g2_tiehi
X_40286_ _18472_ VPWR VGND sg13g2_tiehi
X_40287_ _18473_ VPWR VGND sg13g2_tiehi
X_40288_ _18474_ VPWR VGND sg13g2_tiehi
X_40289_ _18475_ VPWR VGND sg13g2_tiehi
X_40290_ _18476_ VPWR VGND sg13g2_tiehi
X_40291_ _18477_ VPWR VGND sg13g2_tiehi
X_40292_ _18478_ VPWR VGND sg13g2_tiehi
X_40293_ _18479_ VPWR VGND sg13g2_tiehi
X_40294_ _18480_ VPWR VGND sg13g2_tiehi
X_40295_ _18481_ VPWR VGND sg13g2_tiehi
X_40296_ _18482_ VPWR VGND sg13g2_tiehi
X_40297_ _18483_ VPWR VGND sg13g2_tiehi
X_40298_ _18484_ VPWR VGND sg13g2_tiehi
X_40299_ _18485_ VPWR VGND sg13g2_tiehi
X_40300_ _18486_ VPWR VGND sg13g2_tiehi
X_40301_ _18487_ VPWR VGND sg13g2_tiehi
X_40302_ _18488_ VPWR VGND sg13g2_tiehi
X_40303_ _18489_ VPWR VGND sg13g2_tiehi
X_40304_ _18490_ VPWR VGND sg13g2_tiehi
X_40305_ _18491_ VPWR VGND sg13g2_tiehi
X_40306_ _18492_ VPWR VGND sg13g2_tiehi
X_40307_ _18493_ VPWR VGND sg13g2_tiehi
X_40308_ _18494_ VPWR VGND sg13g2_tiehi
X_40309_ _18495_ VPWR VGND sg13g2_tiehi
X_40310_ _18496_ VPWR VGND sg13g2_tiehi
X_40311_ _18497_ VPWR VGND sg13g2_tiehi
X_40312_ _18498_ VPWR VGND sg13g2_tiehi
X_40313_ _18499_ VPWR VGND sg13g2_tiehi
X_40314_ _18500_ VPWR VGND sg13g2_tiehi
X_40315_ _18501_ VPWR VGND sg13g2_tiehi
X_40316_ _18502_ VPWR VGND sg13g2_tiehi
X_40317_ _18503_ VPWR VGND sg13g2_tiehi
X_40318_ _18504_ VPWR VGND sg13g2_tiehi
X_40319_ _18505_ VPWR VGND sg13g2_tiehi
X_40320_ _18506_ VPWR VGND sg13g2_tiehi
X_40321_ _18507_ VPWR VGND sg13g2_tiehi
X_40322_ _18508_ VPWR VGND sg13g2_tiehi
X_40323_ _18509_ VPWR VGND sg13g2_tiehi
X_40324_ _18510_ VPWR VGND sg13g2_tiehi
X_40325_ _18511_ VPWR VGND sg13g2_tiehi
X_40326_ _18512_ VPWR VGND sg13g2_tiehi
X_40327_ _18513_ VPWR VGND sg13g2_tiehi
X_40328_ _18514_ VPWR VGND sg13g2_tiehi
X_40329_ _18515_ VPWR VGND sg13g2_tiehi
X_40330_ _18516_ VPWR VGND sg13g2_tiehi
X_40331_ _18517_ VPWR VGND sg13g2_tiehi
X_40332_ _18518_ VPWR VGND sg13g2_tiehi
X_40333_ _18519_ VPWR VGND sg13g2_tiehi
X_40334_ _18520_ VPWR VGND sg13g2_tiehi
X_40335_ _18521_ VPWR VGND sg13g2_tiehi
X_40336_ _18522_ VPWR VGND sg13g2_tiehi
X_40337_ _18523_ VPWR VGND sg13g2_tiehi
X_40338_ _18524_ VPWR VGND sg13g2_tiehi
X_40339_ _18525_ VPWR VGND sg13g2_tiehi
X_40340_ _18526_ VPWR VGND sg13g2_tiehi
X_40341_ _18527_ VPWR VGND sg13g2_tiehi
X_40342_ _18528_ VPWR VGND sg13g2_tiehi
X_40343_ _18529_ VPWR VGND sg13g2_tiehi
X_40344_ _18530_ VPWR VGND sg13g2_tiehi
X_40345_ _18531_ VPWR VGND sg13g2_tiehi
X_40346_ _18532_ VPWR VGND sg13g2_tiehi
X_40347_ _18533_ VPWR VGND sg13g2_tiehi
X_40348_ _18534_ VPWR VGND sg13g2_tiehi
X_40349_ _18535_ VPWR VGND sg13g2_tiehi
X_40350_ _18536_ VPWR VGND sg13g2_tiehi
X_40351_ _18537_ VPWR VGND sg13g2_tiehi
X_40352_ _18538_ VPWR VGND sg13g2_tiehi
X_40353_ _18539_ VPWR VGND sg13g2_tiehi
X_40354_ _18540_ VPWR VGND sg13g2_tiehi
X_40355_ _18541_ VPWR VGND sg13g2_tiehi
X_40356_ _18542_ VPWR VGND sg13g2_tiehi
X_40357_ _18543_ VPWR VGND sg13g2_tiehi
X_40358_ _18544_ VPWR VGND sg13g2_tiehi
X_40359_ _18545_ VPWR VGND sg13g2_tiehi
X_40360_ _18546_ VPWR VGND sg13g2_tiehi
X_40361_ _18547_ VPWR VGND sg13g2_tiehi
X_40362_ _18548_ VPWR VGND sg13g2_tiehi
X_40363_ _18549_ VPWR VGND sg13g2_tiehi
X_40364_ _18550_ VPWR VGND sg13g2_tiehi
X_40365_ _18551_ VPWR VGND sg13g2_tiehi
X_40366_ _18552_ VPWR VGND sg13g2_tiehi
X_40367_ _18553_ VPWR VGND sg13g2_tiehi
X_40368_ _18554_ VPWR VGND sg13g2_tiehi
X_40369_ _18555_ VPWR VGND sg13g2_tiehi
X_40370_ _18556_ VPWR VGND sg13g2_tiehi
X_40371_ _18557_ VPWR VGND sg13g2_tiehi
X_40372_ _18558_ VPWR VGND sg13g2_tiehi
X_40373_ _18559_ VPWR VGND sg13g2_tiehi
X_40374_ _18560_ VPWR VGND sg13g2_tiehi
X_40375_ _18561_ VPWR VGND sg13g2_tiehi
X_40376_ _18562_ VPWR VGND sg13g2_tiehi
X_40377_ _18563_ VPWR VGND sg13g2_tiehi
X_40378_ _18564_ VPWR VGND sg13g2_tiehi
X_40379_ _18565_ VPWR VGND sg13g2_tiehi
X_40380_ _18566_ VPWR VGND sg13g2_tiehi
X_40381_ _18567_ VPWR VGND sg13g2_tiehi
X_40382_ _18568_ VPWR VGND sg13g2_tiehi
X_40383_ _18569_ VPWR VGND sg13g2_tiehi
X_40384_ _18570_ VPWR VGND sg13g2_tiehi
X_40385_ _18571_ VPWR VGND sg13g2_tiehi
X_40386_ _18572_ VPWR VGND sg13g2_tiehi
X_40387_ _18573_ VPWR VGND sg13g2_tiehi
X_40388_ _18574_ VPWR VGND sg13g2_tiehi
X_40389_ _18575_ VPWR VGND sg13g2_tiehi
X_40390_ _18576_ VPWR VGND sg13g2_tiehi
X_40391_ _18577_ VPWR VGND sg13g2_tiehi
X_40392_ _18578_ VPWR VGND sg13g2_tiehi
X_40393_ _18579_ VPWR VGND sg13g2_tiehi
X_40394_ _18580_ VPWR VGND sg13g2_tiehi
X_40395_ _18581_ VPWR VGND sg13g2_tiehi
X_40396_ _18582_ VPWR VGND sg13g2_tiehi
X_40397_ _18583_ VPWR VGND sg13g2_tiehi
X_40398_ _18584_ VPWR VGND sg13g2_tiehi
X_40399_ _18585_ VPWR VGND sg13g2_tiehi
X_40400_ _18586_ VPWR VGND sg13g2_tiehi
X_40401_ _18587_ VPWR VGND sg13g2_tiehi
X_40402_ _18588_ VPWR VGND sg13g2_tiehi
X_40403_ _18589_ VPWR VGND sg13g2_tiehi
X_40404_ _18590_ VPWR VGND sg13g2_tiehi
X_40405_ _18591_ VPWR VGND sg13g2_tiehi
X_40406_ _18592_ VPWR VGND sg13g2_tiehi
X_40407_ _18593_ VPWR VGND sg13g2_tiehi
X_40408_ _18594_ VPWR VGND sg13g2_tiehi
X_40409_ _18595_ VPWR VGND sg13g2_tiehi
X_40410_ _18596_ VPWR VGND sg13g2_tiehi
X_40411_ _18597_ VPWR VGND sg13g2_tiehi
X_40412_ _18598_ VPWR VGND sg13g2_tiehi
X_40413_ _18599_ VPWR VGND sg13g2_tiehi
X_40414_ _18600_ VPWR VGND sg13g2_tiehi
X_40415_ _18601_ VPWR VGND sg13g2_tiehi
X_40416_ _18602_ VPWR VGND sg13g2_tiehi
X_40417_ _18603_ VPWR VGND sg13g2_tiehi
X_40418_ _18604_ VPWR VGND sg13g2_tiehi
X_40419_ _18605_ VPWR VGND sg13g2_tiehi
X_40420_ _18606_ VPWR VGND sg13g2_tiehi
X_40421_ _18607_ VPWR VGND sg13g2_tiehi
X_40422_ _18608_ VPWR VGND sg13g2_tiehi
X_40423_ _18609_ VPWR VGND sg13g2_tiehi
X_40424_ _18610_ VPWR VGND sg13g2_tiehi
X_40425_ _18611_ VPWR VGND sg13g2_tiehi
X_40426_ _18612_ VPWR VGND sg13g2_tiehi
X_40427_ _18613_ VPWR VGND sg13g2_tiehi
X_40428_ _18614_ VPWR VGND sg13g2_tiehi
X_40429_ _18615_ VPWR VGND sg13g2_tiehi
X_40430_ _18616_ VPWR VGND sg13g2_tiehi
X_40431_ _18617_ VPWR VGND sg13g2_tiehi
X_40432_ _18618_ VPWR VGND sg13g2_tiehi
X_40433_ _18619_ VPWR VGND sg13g2_tiehi
X_40434_ _18620_ VPWR VGND sg13g2_tiehi
X_40435_ _18621_ VPWR VGND sg13g2_tiehi
X_40436_ _18622_ VPWR VGND sg13g2_tiehi
X_40437_ _18623_ VPWR VGND sg13g2_tiehi
X_40438_ _18624_ VPWR VGND sg13g2_tiehi
X_40439_ _18625_ VPWR VGND sg13g2_tiehi
X_40440_ _18626_ VPWR VGND sg13g2_tiehi
X_40441_ _18627_ VPWR VGND sg13g2_tiehi
X_40442_ _18628_ VPWR VGND sg13g2_tiehi
X_40443_ _18629_ VPWR VGND sg13g2_tiehi
X_40444_ _18630_ VPWR VGND sg13g2_tiehi
X_40445_ _18631_ VPWR VGND sg13g2_tiehi
X_40446_ _18632_ VPWR VGND sg13g2_tiehi
X_40447_ _18633_ VPWR VGND sg13g2_tiehi
X_40448_ _18634_ VPWR VGND sg13g2_tiehi
X_40449_ _18635_ VPWR VGND sg13g2_tiehi
X_40450_ _18636_ VPWR VGND sg13g2_tiehi
X_40451_ _18637_ VPWR VGND sg13g2_tiehi
X_40452_ _18638_ VPWR VGND sg13g2_tiehi
X_40453_ _18639_ VPWR VGND sg13g2_tiehi
X_40454_ _18640_ VPWR VGND sg13g2_tiehi
X_40455_ _18641_ VPWR VGND sg13g2_tiehi
X_40456_ _18642_ VPWR VGND sg13g2_tiehi
X_40457_ _18643_ VPWR VGND sg13g2_tiehi
X_40458_ _18644_ VPWR VGND sg13g2_tiehi
X_40459_ _18645_ VPWR VGND sg13g2_tiehi
X_40460_ _18646_ VPWR VGND sg13g2_tiehi
X_40461_ _18647_ VPWR VGND sg13g2_tiehi
X_40462_ _18648_ VPWR VGND sg13g2_tiehi
X_40463_ _18649_ VPWR VGND sg13g2_tiehi
X_40464_ _18650_ VPWR VGND sg13g2_tiehi
X_40465_ _18651_ VPWR VGND sg13g2_tiehi
X_40466_ _18652_ VPWR VGND sg13g2_tiehi
X_40467_ _18653_ VPWR VGND sg13g2_tiehi
X_40468_ _18654_ VPWR VGND sg13g2_tiehi
X_40469_ _18655_ VPWR VGND sg13g2_tiehi
X_40470_ _18656_ VPWR VGND sg13g2_tiehi
X_40471_ _18657_ VPWR VGND sg13g2_tiehi
X_40472_ _18658_ VPWR VGND sg13g2_tiehi
X_40473_ _18659_ VPWR VGND sg13g2_tiehi
X_40474_ _18660_ VPWR VGND sg13g2_tiehi
X_40475_ _18661_ VPWR VGND sg13g2_tiehi
X_40476_ _18662_ VPWR VGND sg13g2_tiehi
X_40477_ _18663_ VPWR VGND sg13g2_tiehi
X_40478_ _18664_ VPWR VGND sg13g2_tiehi
X_40479_ _18665_ VPWR VGND sg13g2_tiehi
X_40480_ _18666_ VPWR VGND sg13g2_tiehi
X_40481_ _18667_ VPWR VGND sg13g2_tiehi
X_40482_ _18668_ VPWR VGND sg13g2_tiehi
X_40483_ _18669_ VPWR VGND sg13g2_tiehi
X_40484_ _18670_ VPWR VGND sg13g2_tiehi
X_40485_ _18671_ VPWR VGND sg13g2_tiehi
X_40486_ _18672_ VPWR VGND sg13g2_tiehi
X_40487_ _18673_ VPWR VGND sg13g2_tiehi
X_40488_ _18674_ VPWR VGND sg13g2_tiehi
X_40489_ _18675_ VPWR VGND sg13g2_tiehi
X_40490_ _18676_ VPWR VGND sg13g2_tiehi
X_40491_ _18677_ VPWR VGND sg13g2_tiehi
X_40492_ _18678_ VPWR VGND sg13g2_tiehi
X_40493_ _18679_ VPWR VGND sg13g2_tiehi
X_40494_ _18680_ VPWR VGND sg13g2_tiehi
X_40495_ _18681_ VPWR VGND sg13g2_tiehi
X_40496_ _18682_ VPWR VGND sg13g2_tiehi
X_40497_ _18683_ VPWR VGND sg13g2_tiehi
X_40498_ _18684_ VPWR VGND sg13g2_tiehi
X_40499_ _18685_ VPWR VGND sg13g2_tiehi
X_40500_ _18686_ VPWR VGND sg13g2_tiehi
X_40501_ _18687_ VPWR VGND sg13g2_tiehi
X_40502_ _18688_ VPWR VGND sg13g2_tiehi
X_40503_ _18689_ VPWR VGND sg13g2_tiehi
X_40504_ _18690_ VPWR VGND sg13g2_tiehi
X_40505_ _18691_ VPWR VGND sg13g2_tiehi
X_40506_ _18692_ VPWR VGND sg13g2_tiehi
X_40507_ _18693_ VPWR VGND sg13g2_tiehi
X_40508_ _18694_ VPWR VGND sg13g2_tiehi
X_40509_ _18695_ VPWR VGND sg13g2_tiehi
X_40510_ _18696_ VPWR VGND sg13g2_tiehi
X_40511_ _18697_ VPWR VGND sg13g2_tiehi
X_40512_ _18698_ VPWR VGND sg13g2_tiehi
X_40513_ _18699_ VPWR VGND sg13g2_tiehi
X_40514_ _18700_ VPWR VGND sg13g2_tiehi
X_40515_ _18701_ VPWR VGND sg13g2_tiehi
X_40516_ _18702_ VPWR VGND sg13g2_tiehi
X_40517_ _18703_ VPWR VGND sg13g2_tiehi
X_40518_ _18704_ VPWR VGND sg13g2_tiehi
X_40519_ _18705_ VPWR VGND sg13g2_tiehi
X_40520_ _18706_ VPWR VGND sg13g2_tiehi
X_40521_ _18707_ VPWR VGND sg13g2_tiehi
X_40522_ _18708_ VPWR VGND sg13g2_tiehi
X_40523_ _18709_ VPWR VGND sg13g2_tiehi
X_40524_ _18710_ VPWR VGND sg13g2_tiehi
X_40525_ _18711_ VPWR VGND sg13g2_tiehi
X_40526_ _18712_ VPWR VGND sg13g2_tiehi
X_40527_ _18713_ VPWR VGND sg13g2_tiehi
X_40528_ _18714_ VPWR VGND sg13g2_tiehi
X_40529_ _18715_ VPWR VGND sg13g2_tiehi
X_40530_ _18716_ VPWR VGND sg13g2_tiehi
X_40531_ _18717_ VPWR VGND sg13g2_tiehi
X_40532_ _18718_ VPWR VGND sg13g2_tiehi
X_40533_ _18719_ VPWR VGND sg13g2_tiehi
X_40534_ _18720_ VPWR VGND sg13g2_tiehi
X_40535_ _18721_ VPWR VGND sg13g2_tiehi
X_40536_ _18722_ VPWR VGND sg13g2_tiehi
X_40537_ _18723_ VPWR VGND sg13g2_tiehi
X_40538_ _18724_ VPWR VGND sg13g2_tiehi
X_40539_ _18725_ VPWR VGND sg13g2_tiehi
X_40540_ _18726_ VPWR VGND sg13g2_tiehi
X_40541_ _18727_ VPWR VGND sg13g2_tiehi
X_40542_ _18728_ VPWR VGND sg13g2_tiehi
X_40543_ _18729_ VPWR VGND sg13g2_tiehi
X_40544_ _18730_ VPWR VGND sg13g2_tiehi
X_40545_ _18731_ VPWR VGND sg13g2_tiehi
X_40546_ _18732_ VPWR VGND sg13g2_tiehi
X_40547_ _18733_ VPWR VGND sg13g2_tiehi
X_40548_ _18734_ VPWR VGND sg13g2_tiehi
X_40549_ _18735_ VPWR VGND sg13g2_tiehi
X_40550_ _18736_ VPWR VGND sg13g2_tiehi
X_40551_ _18737_ VPWR VGND sg13g2_tiehi
X_40552_ _18738_ VPWR VGND sg13g2_tiehi
X_40553_ _18739_ VPWR VGND sg13g2_tiehi
X_40554_ _18740_ VPWR VGND sg13g2_tiehi
X_40555_ _18741_ VPWR VGND sg13g2_tiehi
X_40556_ _18742_ VPWR VGND sg13g2_tiehi
X_40557_ _18743_ VPWR VGND sg13g2_tiehi
X_40558_ _18744_ VPWR VGND sg13g2_tiehi
X_40559_ _18745_ VPWR VGND sg13g2_tiehi
X_40560_ _18746_ VPWR VGND sg13g2_tiehi
X_40561_ _18747_ VPWR VGND sg13g2_tiehi
X_40562_ _18748_ VPWR VGND sg13g2_tiehi
X_40563_ _18749_ VPWR VGND sg13g2_tiehi
X_40564_ _18750_ VPWR VGND sg13g2_tiehi
X_40565_ _18751_ VPWR VGND sg13g2_tiehi
X_40566_ _18752_ VPWR VGND sg13g2_tiehi
X_40567_ _18753_ VPWR VGND sg13g2_tiehi
X_40568_ _18754_ VPWR VGND sg13g2_tiehi
X_40569_ _18755_ VPWR VGND sg13g2_tiehi
X_40570_ _18756_ VPWR VGND sg13g2_tiehi
X_40571_ _18757_ VPWR VGND sg13g2_tiehi
X_40572_ _18758_ VPWR VGND sg13g2_tiehi
X_40573_ _18759_ VPWR VGND sg13g2_tiehi
X_40574_ _18760_ VPWR VGND sg13g2_tiehi
X_40575_ _18761_ VPWR VGND sg13g2_tiehi
X_40576_ _18762_ VPWR VGND sg13g2_tiehi
X_40577_ _18763_ VPWR VGND sg13g2_tiehi
X_40578_ _18764_ VPWR VGND sg13g2_tiehi
X_40579_ _18765_ VPWR VGND sg13g2_tiehi
X_40580_ _18766_ VPWR VGND sg13g2_tiehi
X_40581_ _18767_ VPWR VGND sg13g2_tiehi
X_40582_ _18768_ VPWR VGND sg13g2_tiehi
X_40583_ _18769_ VPWR VGND sg13g2_tiehi
X_40584_ _18770_ VPWR VGND sg13g2_tiehi
X_40585_ _18771_ VPWR VGND sg13g2_tiehi
X_40586_ _18772_ VPWR VGND sg13g2_tiehi
X_40587_ _18773_ VPWR VGND sg13g2_tiehi
X_40588_ _18774_ VPWR VGND sg13g2_tiehi
X_40589_ _18775_ VPWR VGND sg13g2_tiehi
X_40590_ _18776_ VPWR VGND sg13g2_tiehi
X_40591_ _18777_ VPWR VGND sg13g2_tiehi
X_40592_ _18778_ VPWR VGND sg13g2_tiehi
X_40593_ _18779_ VPWR VGND sg13g2_tiehi
X_40594_ _18780_ VPWR VGND sg13g2_tiehi
X_40595_ _18781_ VPWR VGND sg13g2_tiehi
X_40596_ _18782_ VPWR VGND sg13g2_tiehi
X_40597_ _18783_ VPWR VGND sg13g2_tiehi
X_40598_ _18784_ VPWR VGND sg13g2_tiehi
X_40599_ _18785_ VPWR VGND sg13g2_tiehi
X_40600_ _18786_ VPWR VGND sg13g2_tiehi
X_40601_ _18787_ VPWR VGND sg13g2_tiehi
X_40602_ _18788_ VPWR VGND sg13g2_tiehi
X_40603_ _18789_ VPWR VGND sg13g2_tiehi
X_40604_ _18790_ VPWR VGND sg13g2_tiehi
X_40605_ _18791_ VPWR VGND sg13g2_tiehi
X_40606_ _18792_ VPWR VGND sg13g2_tiehi
X_40607_ _18793_ VPWR VGND sg13g2_tiehi
X_40608_ _18794_ VPWR VGND sg13g2_tiehi
X_40609_ _18795_ VPWR VGND sg13g2_tiehi
X_40610_ _18796_ VPWR VGND sg13g2_tiehi
X_40611_ _18797_ VPWR VGND sg13g2_tiehi
X_40612_ _18798_ VPWR VGND sg13g2_tiehi
X_40613_ _18799_ VPWR VGND sg13g2_tiehi
X_40614_ _18800_ VPWR VGND sg13g2_tiehi
X_40615_ _18801_ VPWR VGND sg13g2_tiehi
X_40616_ _18802_ VPWR VGND sg13g2_tiehi
X_40617_ _18803_ VPWR VGND sg13g2_tiehi
X_40618_ _18804_ VPWR VGND sg13g2_tiehi
X_40619_ _18805_ VPWR VGND sg13g2_tiehi
X_40620_ _18806_ VPWR VGND sg13g2_tiehi
X_40621_ _18807_ VPWR VGND sg13g2_tiehi
X_40622_ _18808_ VPWR VGND sg13g2_tiehi
X_40623_ _18809_ VPWR VGND sg13g2_tiehi
X_40624_ _18810_ VPWR VGND sg13g2_tiehi
X_40625_ _18811_ VPWR VGND sg13g2_tiehi
X_40626_ _18812_ VPWR VGND sg13g2_tiehi
X_40627_ _18813_ VPWR VGND sg13g2_tiehi
X_40628_ _18814_ VPWR VGND sg13g2_tiehi
X_40629_ _18815_ VPWR VGND sg13g2_tiehi
X_40630_ _18816_ VPWR VGND sg13g2_tiehi
X_40631_ _18817_ VPWR VGND sg13g2_tiehi
X_40632_ _18818_ VPWR VGND sg13g2_tiehi
X_40633_ _18819_ VPWR VGND sg13g2_tiehi
X_40634_ _18820_ VPWR VGND sg13g2_tiehi
X_40635_ _18821_ VPWR VGND sg13g2_tiehi
X_40636_ _18822_ VPWR VGND sg13g2_tiehi
X_40637_ _18823_ VPWR VGND sg13g2_tiehi
X_40638_ _18824_ VPWR VGND sg13g2_tiehi
X_40639_ _18825_ VPWR VGND sg13g2_tiehi
X_40640_ _18826_ VPWR VGND sg13g2_tiehi
X_40641_ _18827_ VPWR VGND sg13g2_tiehi
X_40642_ _18828_ VPWR VGND sg13g2_tiehi
X_40643_ _18829_ VPWR VGND sg13g2_tiehi
X_40644_ _18830_ VPWR VGND sg13g2_tiehi
X_40645_ _18831_ VPWR VGND sg13g2_tiehi
X_40646_ _18832_ VPWR VGND sg13g2_tiehi
X_40647_ _18833_ VPWR VGND sg13g2_tiehi
X_40648_ _18834_ VPWR VGND sg13g2_tiehi
X_40649_ _18835_ VPWR VGND sg13g2_tiehi
X_40650_ _18836_ VPWR VGND sg13g2_tiehi
X_40651_ _18837_ VPWR VGND sg13g2_tiehi
X_40652_ _18838_ VPWR VGND sg13g2_tiehi
X_40653_ _18839_ VPWR VGND sg13g2_tiehi
X_40654_ _18840_ VPWR VGND sg13g2_tiehi
X_40655_ _18841_ VPWR VGND sg13g2_tiehi
X_40656_ _18842_ VPWR VGND sg13g2_tiehi
X_40657_ _18843_ VPWR VGND sg13g2_tiehi
X_40658_ _18844_ VPWR VGND sg13g2_tiehi
X_40659_ _18845_ VPWR VGND sg13g2_tiehi
X_40660_ _18846_ VPWR VGND sg13g2_tiehi
X_40661_ _18847_ VPWR VGND sg13g2_tiehi
X_40662_ _18848_ VPWR VGND sg13g2_tiehi
X_40663_ _18849_ VPWR VGND sg13g2_tiehi
X_40664_ _18850_ VPWR VGND sg13g2_tiehi
X_40665_ _18851_ VPWR VGND sg13g2_tiehi
X_40666_ _18852_ VPWR VGND sg13g2_tiehi
X_40667_ _18853_ VPWR VGND sg13g2_tiehi
X_40668_ _18854_ VPWR VGND sg13g2_tiehi
X_40669_ _18855_ VPWR VGND sg13g2_tiehi
X_40670_ _18856_ VPWR VGND sg13g2_tiehi
X_40671_ _18857_ VPWR VGND sg13g2_tiehi
X_40672_ _18858_ VPWR VGND sg13g2_tiehi
X_40673_ _18859_ VPWR VGND sg13g2_tiehi
X_40674_ _18860_ VPWR VGND sg13g2_tiehi
X_40675_ _18861_ VPWR VGND sg13g2_tiehi
X_40676_ _18862_ VPWR VGND sg13g2_tiehi
X_40677_ _18863_ VPWR VGND sg13g2_tiehi
X_40678_ _18864_ VPWR VGND sg13g2_tiehi
X_40679_ _18865_ VPWR VGND sg13g2_tiehi
X_40680_ _18866_ VPWR VGND sg13g2_tiehi
X_40681_ _18867_ VPWR VGND sg13g2_tiehi
X_40682_ _18868_ VPWR VGND sg13g2_tiehi
X_40683_ _18869_ VPWR VGND sg13g2_tiehi
X_40684_ _18870_ VPWR VGND sg13g2_tiehi
X_40685_ _18871_ VPWR VGND sg13g2_tiehi
X_40686_ _18872_ VPWR VGND sg13g2_tiehi
X_40687_ _18873_ VPWR VGND sg13g2_tiehi
X_40688_ _18874_ VPWR VGND sg13g2_tiehi
X_40689_ _18875_ VPWR VGND sg13g2_tiehi
X_40690_ _18876_ VPWR VGND sg13g2_tiehi
X_40691_ _18877_ VPWR VGND sg13g2_tiehi
X_40692_ _18878_ VPWR VGND sg13g2_tiehi
X_40693_ _18879_ VPWR VGND sg13g2_tiehi
X_40694_ _18880_ VPWR VGND sg13g2_tiehi
X_40695_ _18881_ VPWR VGND sg13g2_tiehi
X_40696_ _18882_ VPWR VGND sg13g2_tiehi
X_40697_ _18883_ VPWR VGND sg13g2_tiehi
X_40698_ _18884_ VPWR VGND sg13g2_tiehi
X_40699_ _18885_ VPWR VGND sg13g2_tiehi
X_40700_ _18886_ VPWR VGND sg13g2_tiehi
X_40701_ _18887_ VPWR VGND sg13g2_tiehi
X_40702_ _18888_ VPWR VGND sg13g2_tiehi
X_40703_ _18889_ VPWR VGND sg13g2_tiehi
X_40704_ _18890_ VPWR VGND sg13g2_tiehi
X_40705_ _18891_ VPWR VGND sg13g2_tiehi
X_40706_ _18892_ VPWR VGND sg13g2_tiehi
X_40707_ _18893_ VPWR VGND sg13g2_tiehi
X_40708_ _18894_ VPWR VGND sg13g2_tiehi
X_40709_ _18895_ VPWR VGND sg13g2_tiehi
X_40710_ _18896_ VPWR VGND sg13g2_tiehi
X_40711_ _18897_ VPWR VGND sg13g2_tiehi
X_40712_ _18898_ VPWR VGND sg13g2_tiehi
X_40713_ _18899_ VPWR VGND sg13g2_tiehi
X_40714_ _18900_ VPWR VGND sg13g2_tiehi
X_40715_ _18901_ VPWR VGND sg13g2_tiehi
X_40716_ _18902_ VPWR VGND sg13g2_tiehi
X_40717_ _18903_ VPWR VGND sg13g2_tiehi
X_40718_ _18904_ VPWR VGND sg13g2_tiehi
X_40719_ _18905_ VPWR VGND sg13g2_tiehi
X_40720_ _18906_ VPWR VGND sg13g2_tiehi
X_40721_ _18907_ VPWR VGND sg13g2_tiehi
X_40722_ _18908_ VPWR VGND sg13g2_tiehi
X_40723_ _18909_ VPWR VGND sg13g2_tiehi
X_40724_ _18910_ VPWR VGND sg13g2_tiehi
X_40725_ _18911_ VPWR VGND sg13g2_tiehi
X_40726_ _18912_ VPWR VGND sg13g2_tiehi
X_40727_ _18913_ VPWR VGND sg13g2_tiehi
X_40728_ _18914_ VPWR VGND sg13g2_tiehi
X_40729_ _18915_ VPWR VGND sg13g2_tiehi
X_40730_ _18916_ VPWR VGND sg13g2_tiehi
X_40731_ _18917_ VPWR VGND sg13g2_tiehi
X_40732_ _18918_ VPWR VGND sg13g2_tiehi
X_40733_ _18919_ VPWR VGND sg13g2_tiehi
X_40734_ _18920_ VPWR VGND sg13g2_tiehi
X_40735_ _18921_ VPWR VGND sg13g2_tiehi
X_40736_ _18922_ VPWR VGND sg13g2_tiehi
X_40737_ _18923_ VPWR VGND sg13g2_tiehi
X_40738_ _18924_ VPWR VGND sg13g2_tiehi
X_40739_ _18925_ VPWR VGND sg13g2_tiehi
X_40740_ _18926_ VPWR VGND sg13g2_tiehi
X_40741_ _18927_ VPWR VGND sg13g2_tiehi
X_40742_ _18928_ VPWR VGND sg13g2_tiehi
X_40743_ _18929_ VPWR VGND sg13g2_tiehi
X_40744_ _18930_ VPWR VGND sg13g2_tiehi
X_40745_ _18931_ VPWR VGND sg13g2_tiehi
X_40746_ _18932_ VPWR VGND sg13g2_tiehi
X_40747_ _18933_ VPWR VGND sg13g2_tiehi
X_40748_ _18934_ VPWR VGND sg13g2_tiehi
X_40749_ _18935_ VPWR VGND sg13g2_tiehi
X_40750_ _18936_ VPWR VGND sg13g2_tiehi
X_40751_ _18937_ VPWR VGND sg13g2_tiehi
X_40752_ _18938_ VPWR VGND sg13g2_tiehi
X_40753_ _18939_ VPWR VGND sg13g2_tiehi
X_40754_ _18940_ VPWR VGND sg13g2_tiehi
X_40755_ _18941_ VPWR VGND sg13g2_tiehi
X_40756_ _18942_ VPWR VGND sg13g2_tiehi
X_40757_ _18943_ VPWR VGND sg13g2_tiehi
X_40758_ _18944_ VPWR VGND sg13g2_tiehi
X_40759_ _18945_ VPWR VGND sg13g2_tiehi
X_40760_ _18946_ VPWR VGND sg13g2_tiehi
X_40761_ _18947_ VPWR VGND sg13g2_tiehi
X_40762_ _18948_ VPWR VGND sg13g2_tiehi
X_40763_ _18949_ VPWR VGND sg13g2_tiehi
X_40764_ _18950_ VPWR VGND sg13g2_tiehi
X_40765_ _18951_ VPWR VGND sg13g2_tiehi
X_40766_ _18952_ VPWR VGND sg13g2_tiehi
X_40767_ _18953_ VPWR VGND sg13g2_tiehi
X_40768_ _18954_ VPWR VGND sg13g2_tiehi
X_40769_ _18955_ VPWR VGND sg13g2_tiehi
X_40770_ _18956_ VPWR VGND sg13g2_tiehi
X_40771_ _18957_ VPWR VGND sg13g2_tiehi
X_40772_ _18958_ VPWR VGND sg13g2_tiehi
X_40773_ _18959_ VPWR VGND sg13g2_tiehi
X_40774_ _18960_ VPWR VGND sg13g2_tiehi
X_40775_ _18961_ VPWR VGND sg13g2_tiehi
X_40776_ _18962_ VPWR VGND sg13g2_tiehi
X_40777_ _18963_ VPWR VGND sg13g2_tiehi
X_40778_ _18964_ VPWR VGND sg13g2_tiehi
X_40779_ _18965_ VPWR VGND sg13g2_tiehi
X_40780_ _18966_ VPWR VGND sg13g2_tiehi
X_40781_ _18967_ VPWR VGND sg13g2_tiehi
X_40782_ _18968_ VPWR VGND sg13g2_tiehi
X_40783_ _18969_ VPWR VGND sg13g2_tiehi
X_40784_ _18970_ VPWR VGND sg13g2_tiehi
X_40785_ _18971_ VPWR VGND sg13g2_tiehi
X_40786_ _18972_ VPWR VGND sg13g2_tiehi
X_40787_ _18973_ VPWR VGND sg13g2_tiehi
X_40788_ _18974_ VPWR VGND sg13g2_tiehi
X_40789_ _18975_ VPWR VGND sg13g2_tiehi
X_40790_ _18976_ VPWR VGND sg13g2_tiehi
X_40791_ _18977_ VPWR VGND sg13g2_tiehi
X_40792_ _18978_ VPWR VGND sg13g2_tiehi
X_40793_ _18979_ VPWR VGND sg13g2_tiehi
X_40794_ _18980_ VPWR VGND sg13g2_tiehi
X_40795_ _18981_ VPWR VGND sg13g2_tiehi
X_40796_ _18982_ VPWR VGND sg13g2_tiehi
X_40797_ _18983_ VPWR VGND sg13g2_tiehi
X_40798_ _18984_ VPWR VGND sg13g2_tiehi
X_40799_ _18985_ VPWR VGND sg13g2_tiehi
X_40800_ _18986_ VPWR VGND sg13g2_tiehi
X_40801_ _18987_ VPWR VGND sg13g2_tiehi
X_40802_ _18988_ VPWR VGND sg13g2_tiehi
X_40803_ _18989_ VPWR VGND sg13g2_tiehi
X_40804_ _18990_ VPWR VGND sg13g2_tiehi
X_40805_ _18991_ VPWR VGND sg13g2_tiehi
X_40806_ _18992_ VPWR VGND sg13g2_tiehi
X_40807_ _18993_ VPWR VGND sg13g2_tiehi
X_40808_ _18994_ VPWR VGND sg13g2_tiehi
X_40809_ _18995_ VPWR VGND sg13g2_tiehi
X_40810_ _18996_ VPWR VGND sg13g2_tiehi
X_40811_ _18997_ VPWR VGND sg13g2_tiehi
X_40812_ _18998_ VPWR VGND sg13g2_tiehi
X_40813_ _18999_ VPWR VGND sg13g2_tiehi
X_40814_ _19000_ VPWR VGND sg13g2_tiehi
X_40815_ _19001_ VPWR VGND sg13g2_tiehi
X_40816_ _19002_ VPWR VGND sg13g2_tiehi
X_40817_ _19003_ VPWR VGND sg13g2_tiehi
X_40818_ _19004_ VPWR VGND sg13g2_tiehi
X_40819_ _19005_ VPWR VGND sg13g2_tiehi
X_40820_ _19006_ VPWR VGND sg13g2_tiehi
X_40821_ _19007_ VPWR VGND sg13g2_tiehi
X_40822_ _19008_ VPWR VGND sg13g2_tiehi
X_40823_ _19009_ VPWR VGND sg13g2_tiehi
X_40824_ _19010_ VPWR VGND sg13g2_tiehi
X_40825_ _19011_ VPWR VGND sg13g2_tiehi
X_40826_ _19012_ VPWR VGND sg13g2_tiehi
X_40827_ _19013_ VPWR VGND sg13g2_tiehi
X_40828_ _19014_ VPWR VGND sg13g2_tiehi
X_40829_ _19015_ VPWR VGND sg13g2_tiehi
X_40830_ _19016_ VPWR VGND sg13g2_tiehi
X_40831_ _19017_ VPWR VGND sg13g2_tiehi
X_40832_ _19018_ VPWR VGND sg13g2_tiehi
X_40833_ _19019_ VPWR VGND sg13g2_tiehi
X_40834_ _19020_ VPWR VGND sg13g2_tiehi
X_40835_ _19021_ VPWR VGND sg13g2_tiehi
X_40836_ _19022_ VPWR VGND sg13g2_tiehi
X_40837_ _19023_ VPWR VGND sg13g2_tiehi
X_40838_ _19024_ VPWR VGND sg13g2_tiehi
X_40839_ _19025_ VPWR VGND sg13g2_tiehi
X_40840_ _19026_ VPWR VGND sg13g2_tiehi
X_40841_ _19027_ VPWR VGND sg13g2_tiehi
X_40842_ _19028_ VPWR VGND sg13g2_tiehi
X_40843_ _19029_ VPWR VGND sg13g2_tiehi
X_40844_ _19030_ VPWR VGND sg13g2_tiehi
X_40845_ _19031_ VPWR VGND sg13g2_tiehi
X_40846_ _19032_ VPWR VGND sg13g2_tiehi
X_40847_ _19033_ VPWR VGND sg13g2_tiehi
X_40848_ _19034_ VPWR VGND sg13g2_tiehi
X_40849_ _19035_ VPWR VGND sg13g2_tiehi
X_40850_ _19036_ VPWR VGND sg13g2_tiehi
X_40851_ _19037_ VPWR VGND sg13g2_tiehi
X_40852_ _19038_ VPWR VGND sg13g2_tiehi
X_40853_ _19039_ VPWR VGND sg13g2_tiehi
X_40854_ _19040_ VPWR VGND sg13g2_tiehi
X_40855_ _19041_ VPWR VGND sg13g2_tiehi
X_40856_ _19042_ VPWR VGND sg13g2_tiehi
X_40857_ _19043_ VPWR VGND sg13g2_tiehi
X_40858_ _19044_ VPWR VGND sg13g2_tiehi
X_40859_ _19045_ VPWR VGND sg13g2_tiehi
X_40860_ _19046_ VPWR VGND sg13g2_tiehi
X_40861_ _19047_ VPWR VGND sg13g2_tiehi
X_40862_ _19048_ VPWR VGND sg13g2_tiehi
X_40863_ _19049_ VPWR VGND sg13g2_tiehi
X_40864_ _19050_ VPWR VGND sg13g2_tiehi
X_40865_ _19051_ VPWR VGND sg13g2_tiehi
X_40866_ _19052_ VPWR VGND sg13g2_tiehi
X_40867_ _19053_ VPWR VGND sg13g2_tiehi
X_40868_ _19054_ VPWR VGND sg13g2_tiehi
X_40869_ _19055_ VPWR VGND sg13g2_tiehi
X_40870_ _19056_ VPWR VGND sg13g2_tiehi
X_40871_ _19057_ VPWR VGND sg13g2_tiehi
X_40872_ _19058_ VPWR VGND sg13g2_tiehi
X_40873_ _19059_ VPWR VGND sg13g2_tiehi
X_40874_ _19060_ VPWR VGND sg13g2_tiehi
X_40875_ _19061_ VPWR VGND sg13g2_tiehi
X_40876_ _19062_ VPWR VGND sg13g2_tiehi
X_40877_ _19063_ VPWR VGND sg13g2_tiehi
X_40878_ _19064_ VPWR VGND sg13g2_tiehi
X_40879_ _19065_ VPWR VGND sg13g2_tiehi
X_40880_ _19066_ VPWR VGND sg13g2_tiehi
X_40881_ _19067_ VPWR VGND sg13g2_tiehi
X_40882_ _19068_ VPWR VGND sg13g2_tiehi
X_40883_ _19069_ VPWR VGND sg13g2_tiehi
X_40884_ _19070_ VPWR VGND sg13g2_tiehi
X_40885_ _19071_ VPWR VGND sg13g2_tiehi
X_40886_ _19072_ VPWR VGND sg13g2_tiehi
X_40887_ _19073_ VPWR VGND sg13g2_tiehi
X_40888_ _19074_ VPWR VGND sg13g2_tiehi
X_40889_ _19075_ VPWR VGND sg13g2_tiehi
X_40890_ _19076_ VPWR VGND sg13g2_tiehi
X_40891_ _19077_ VPWR VGND sg13g2_tiehi
X_40892_ _19078_ VPWR VGND sg13g2_tiehi
X_40893_ _19079_ VPWR VGND sg13g2_tiehi
X_40894_ _19080_ VPWR VGND sg13g2_tiehi
X_40895_ _19081_ VPWR VGND sg13g2_tiehi
X_40896_ _19082_ VPWR VGND sg13g2_tiehi
X_40897_ _19083_ VPWR VGND sg13g2_tiehi
X_40898_ _19084_ VPWR VGND sg13g2_tiehi
X_40899_ _19085_ VPWR VGND sg13g2_tiehi
X_40900_ _19086_ VPWR VGND sg13g2_tiehi
X_40901_ _19087_ VPWR VGND sg13g2_tiehi
X_40902_ _19088_ VPWR VGND sg13g2_tiehi
X_40903_ _19089_ VPWR VGND sg13g2_tiehi
X_40904_ _19090_ VPWR VGND sg13g2_tiehi
X_40905_ _19091_ VPWR VGND sg13g2_tiehi
X_40906_ _19092_ VPWR VGND sg13g2_tiehi
X_40907_ _19093_ VPWR VGND sg13g2_tiehi
X_40908_ _19094_ VPWR VGND sg13g2_tiehi
X_40909_ _19095_ VPWR VGND sg13g2_tiehi
X_40910_ _19096_ VPWR VGND sg13g2_tiehi
X_40911_ _19097_ VPWR VGND sg13g2_tiehi
X_40912_ _19098_ VPWR VGND sg13g2_tiehi
X_40913_ _19099_ VPWR VGND sg13g2_tiehi
X_40914_ _19100_ VPWR VGND sg13g2_tiehi
X_40915_ _19101_ VPWR VGND sg13g2_tiehi
X_40916_ _19102_ VPWR VGND sg13g2_tiehi
X_40917_ _19103_ VPWR VGND sg13g2_tiehi
X_40918_ _19104_ VPWR VGND sg13g2_tiehi
X_40919_ _19105_ VPWR VGND sg13g2_tiehi
X_40920_ _19106_ VPWR VGND sg13g2_tiehi
X_40921_ _19107_ VPWR VGND sg13g2_tiehi
X_40922_ _19108_ VPWR VGND sg13g2_tiehi
X_40923_ _19109_ VPWR VGND sg13g2_tiehi
X_40924_ _19110_ VPWR VGND sg13g2_tiehi
X_40925_ _19111_ VPWR VGND sg13g2_tiehi
X_40926_ _19112_ VPWR VGND sg13g2_tiehi
X_40927_ _19113_ VPWR VGND sg13g2_tiehi
X_40928_ _19114_ VPWR VGND sg13g2_tiehi
X_40929_ _19115_ VPWR VGND sg13g2_tiehi
X_40930_ _19116_ VPWR VGND sg13g2_tiehi
X_40931_ _19117_ VPWR VGND sg13g2_tiehi
X_40932_ _19118_ VPWR VGND sg13g2_tiehi
X_40933_ _19119_ VPWR VGND sg13g2_tiehi
X_40934_ _19120_ VPWR VGND sg13g2_tiehi
X_40935_ _19121_ VPWR VGND sg13g2_tiehi
X_40936_ _19122_ VPWR VGND sg13g2_tiehi
X_40937_ _19123_ VPWR VGND sg13g2_tiehi
X_40938_ _19124_ VPWR VGND sg13g2_tiehi
X_40939_ _19125_ VPWR VGND sg13g2_tiehi
X_40940_ _19126_ VPWR VGND sg13g2_tiehi
X_40941_ _19127_ VPWR VGND sg13g2_tiehi
X_40942_ _19128_ VPWR VGND sg13g2_tiehi
X_40943_ _19129_ VPWR VGND sg13g2_tiehi
X_40944_ _19130_ VPWR VGND sg13g2_tiehi
X_40945_ _19131_ VPWR VGND sg13g2_tiehi
X_40946_ _19132_ VPWR VGND sg13g2_tiehi
X_40947_ _19133_ VPWR VGND sg13g2_tiehi
X_40948_ _19134_ VPWR VGND sg13g2_tiehi
X_40949_ _19135_ VPWR VGND sg13g2_tiehi
X_40950_ _19136_ VPWR VGND sg13g2_tiehi
X_40951_ _19137_ VPWR VGND sg13g2_tiehi
X_40952_ _19138_ VPWR VGND sg13g2_tiehi
X_40953_ _19139_ VPWR VGND sg13g2_tiehi
X_40954_ _19140_ VPWR VGND sg13g2_tiehi
X_40955_ _19141_ VPWR VGND sg13g2_tiehi
X_40956_ _19142_ VPWR VGND sg13g2_tiehi
X_40957_ _19143_ VPWR VGND sg13g2_tiehi
X_40958_ _19144_ VPWR VGND sg13g2_tiehi
X_40959_ _19145_ VPWR VGND sg13g2_tiehi
X_40960_ _19146_ VPWR VGND sg13g2_tiehi
X_40961_ _19147_ VPWR VGND sg13g2_tiehi
X_40962_ _19148_ VPWR VGND sg13g2_tiehi
X_40963_ _19149_ VPWR VGND sg13g2_tiehi
X_40964_ _19150_ VPWR VGND sg13g2_tiehi
X_40965_ _19151_ VPWR VGND sg13g2_tiehi
X_40966_ _19152_ VPWR VGND sg13g2_tiehi
X_40967_ _19153_ VPWR VGND sg13g2_tiehi
X_40968_ _19154_ VPWR VGND sg13g2_tiehi
X_40969_ _19155_ VPWR VGND sg13g2_tiehi
X_40970_ _19156_ VPWR VGND sg13g2_tiehi
X_40971_ _19157_ VPWR VGND sg13g2_tiehi
X_40972_ _19158_ VPWR VGND sg13g2_tiehi
X_40973_ _19159_ VPWR VGND sg13g2_tiehi
X_40974_ _19160_ VPWR VGND sg13g2_tiehi
X_40975_ _19161_ VPWR VGND sg13g2_tiehi
X_40976_ _19162_ VPWR VGND sg13g2_tiehi
X_40977_ _19163_ VPWR VGND sg13g2_tiehi
X_40978_ _19164_ VPWR VGND sg13g2_tiehi
X_40979_ _19165_ VPWR VGND sg13g2_tiehi
X_40980_ _19166_ VPWR VGND sg13g2_tiehi
X_40981_ _19167_ VPWR VGND sg13g2_tiehi
X_40982_ _19168_ VPWR VGND sg13g2_tiehi
X_40983_ _19169_ VPWR VGND sg13g2_tiehi
X_40984_ _19170_ VPWR VGND sg13g2_tiehi
X_40985_ _19171_ VPWR VGND sg13g2_tiehi
X_40986_ _19172_ VPWR VGND sg13g2_tiehi
X_40987_ _19173_ VPWR VGND sg13g2_tiehi
X_40988_ _19174_ VPWR VGND sg13g2_tiehi
X_40989_ _19175_ VPWR VGND sg13g2_tiehi
X_40990_ _19176_ VPWR VGND sg13g2_tiehi
X_40991_ _19177_ VPWR VGND sg13g2_tiehi
X_40992_ _19178_ VPWR VGND sg13g2_tiehi
X_40993_ _19179_ VPWR VGND sg13g2_tiehi
X_40994_ _19180_ VPWR VGND sg13g2_tiehi
X_40995_ _19181_ VPWR VGND sg13g2_tiehi
X_40996_ _19182_ VPWR VGND sg13g2_tiehi
X_40997_ _19183_ VPWR VGND sg13g2_tiehi
X_40998_ _19184_ VPWR VGND sg13g2_tiehi
X_40999_ _19185_ VPWR VGND sg13g2_tiehi
X_41000_ _19186_ VPWR VGND sg13g2_tiehi
X_41001_ _19187_ VPWR VGND sg13g2_tiehi
X_41002_ _19188_ VPWR VGND sg13g2_tiehi
X_41003_ _19189_ VPWR VGND sg13g2_tiehi
X_41004_ _19190_ VPWR VGND sg13g2_tiehi
X_41005_ _19191_ VPWR VGND sg13g2_tiehi
X_41006_ _19192_ VPWR VGND sg13g2_tiehi
X_41007_ _19193_ VPWR VGND sg13g2_tiehi
X_41008_ _19194_ VPWR VGND sg13g2_tiehi
X_41009_ _19195_ VPWR VGND sg13g2_tiehi
X_41010_ _19196_ VPWR VGND sg13g2_tiehi
X_41011_ _19197_ VPWR VGND sg13g2_tiehi
X_41012_ _19198_ VPWR VGND sg13g2_tiehi
X_41013_ _19199_ VPWR VGND sg13g2_tiehi
X_41014_ _19200_ VPWR VGND sg13g2_tiehi
X_41015_ _19201_ VPWR VGND sg13g2_tiehi
X_41016_ _19202_ VPWR VGND sg13g2_tiehi
X_41017_ _19203_ VPWR VGND sg13g2_tiehi
X_41018_ _19204_ VPWR VGND sg13g2_tiehi
X_41019_ _19205_ VPWR VGND sg13g2_tiehi
X_41020_ _19206_ VPWR VGND sg13g2_tiehi
X_41021_ _19207_ VPWR VGND sg13g2_tiehi
X_41022_ _19208_ VPWR VGND sg13g2_tiehi
X_41023_ _19209_ VPWR VGND sg13g2_tiehi
X_41024_ _19210_ VPWR VGND sg13g2_tiehi
X_41025_ _19211_ VPWR VGND sg13g2_tiehi
X_41026_ _19212_ VPWR VGND sg13g2_tiehi
X_41027_ _19213_ VPWR VGND sg13g2_tiehi
X_41028_ _19214_ VPWR VGND sg13g2_tiehi
X_41029_ _19215_ VPWR VGND sg13g2_tiehi
X_41030_ _19216_ VPWR VGND sg13g2_tiehi
X_41031_ _19217_ VPWR VGND sg13g2_tiehi
X_41032_ _19218_ VPWR VGND sg13g2_tiehi
X_41033_ _19219_ VPWR VGND sg13g2_tiehi
X_41034_ _19220_ VPWR VGND sg13g2_tiehi
X_41035_ _19221_ VPWR VGND sg13g2_tiehi
X_41036_ _19222_ VPWR VGND sg13g2_tiehi
X_41037_ _19223_ VPWR VGND sg13g2_tiehi
X_41038_ _19224_ VPWR VGND sg13g2_tiehi
X_41039_ _19225_ VPWR VGND sg13g2_tiehi
X_41040_ _19226_ VPWR VGND sg13g2_tiehi
X_41041_ _19227_ VPWR VGND sg13g2_tiehi
X_41042_ _19228_ VPWR VGND sg13g2_tiehi
X_41043_ _19229_ VPWR VGND sg13g2_tiehi
X_41044_ _19230_ VPWR VGND sg13g2_tiehi
X_41045_ _19231_ VPWR VGND sg13g2_tiehi
X_41046_ _19232_ VPWR VGND sg13g2_tiehi
X_41047_ _19233_ VPWR VGND sg13g2_tiehi
X_41048_ _19234_ VPWR VGND sg13g2_tiehi
X_41049_ _19235_ VPWR VGND sg13g2_tiehi
X_41050_ _19236_ VPWR VGND sg13g2_tiehi
X_41051_ _19237_ VPWR VGND sg13g2_tiehi
X_41052_ _19238_ VPWR VGND sg13g2_tiehi
X_41053_ _19239_ VPWR VGND sg13g2_tiehi
X_41054_ _19240_ VPWR VGND sg13g2_tiehi
X_41055_ _19241_ VPWR VGND sg13g2_tiehi
X_41056_ _19242_ VPWR VGND sg13g2_tiehi
X_41057_ _19243_ VPWR VGND sg13g2_tiehi
X_41058_ _19244_ VPWR VGND sg13g2_tiehi
X_41059_ _19245_ VPWR VGND sg13g2_tiehi
X_41060_ _19246_ VPWR VGND sg13g2_tiehi
X_41061_ _19247_ VPWR VGND sg13g2_tiehi
X_41062_ _19248_ VPWR VGND sg13g2_tiehi
X_41063_ _19249_ VPWR VGND sg13g2_tiehi
X_41064_ _19250_ VPWR VGND sg13g2_tiehi
X_41065_ _19251_ VPWR VGND sg13g2_tiehi
X_41066_ _19252_ VPWR VGND sg13g2_tiehi
X_41067_ _19253_ VPWR VGND sg13g2_tiehi
X_41068_ _19254_ VPWR VGND sg13g2_tiehi
X_41069_ _19255_ VPWR VGND sg13g2_tiehi
X_41070_ _19256_ VPWR VGND sg13g2_tiehi
X_41071_ _19257_ VPWR VGND sg13g2_tiehi
X_41072_ _19258_ VPWR VGND sg13g2_tiehi
X_41073_ _19259_ VPWR VGND sg13g2_tiehi
X_41074_ _19260_ VPWR VGND sg13g2_tiehi
X_41075_ _19261_ VPWR VGND sg13g2_tiehi
X_41076_ _19262_ VPWR VGND sg13g2_tiehi
X_41077_ _19263_ VPWR VGND sg13g2_tiehi
X_41078_ _19264_ VPWR VGND sg13g2_tiehi
X_41079_ _19265_ VPWR VGND sg13g2_tiehi
X_41080_ _19266_ VPWR VGND sg13g2_tiehi
X_41081_ _19267_ VPWR VGND sg13g2_tiehi
X_41082_ _19268_ VPWR VGND sg13g2_tiehi
X_41083_ _19269_ VPWR VGND sg13g2_tiehi
X_41084_ _19270_ VPWR VGND sg13g2_tiehi
X_41085_ _19271_ VPWR VGND sg13g2_tiehi
X_41086_ _19272_ VPWR VGND sg13g2_tiehi
X_41087_ _19273_ VPWR VGND sg13g2_tiehi
X_41088_ _19274_ VPWR VGND sg13g2_tiehi
X_41089_ _19275_ VPWR VGND sg13g2_tiehi
X_41090_ _19276_ VPWR VGND sg13g2_tiehi
X_41091_ _19277_ VPWR VGND sg13g2_tiehi
X_41092_ _19278_ VPWR VGND sg13g2_tiehi
X_41093_ _19279_ VPWR VGND sg13g2_tiehi
X_41094_ _19280_ VPWR VGND sg13g2_tiehi
X_41095_ _19281_ VPWR VGND sg13g2_tiehi
X_41096_ _19282_ VPWR VGND sg13g2_tiehi
X_41097_ _19283_ VPWR VGND sg13g2_tiehi
X_41098_ _19284_ VPWR VGND sg13g2_tiehi
X_41099_ _19285_ VPWR VGND sg13g2_tiehi
X_41100_ _19286_ VPWR VGND sg13g2_tiehi
X_41101_ _19287_ VPWR VGND sg13g2_tiehi
X_41102_ _19288_ VPWR VGND sg13g2_tiehi
X_41103_ _19289_ VPWR VGND sg13g2_tiehi
X_41104_ _19290_ VPWR VGND sg13g2_tiehi
X_41105_ _19291_ VPWR VGND sg13g2_tiehi
X_41106_ _19292_ VPWR VGND sg13g2_tiehi
X_41107_ _19293_ VPWR VGND sg13g2_tiehi
X_41108_ _19294_ VPWR VGND sg13g2_tiehi
X_41109_ _19295_ VPWR VGND sg13g2_tiehi
X_41110_ _19296_ VPWR VGND sg13g2_tiehi
X_41111_ _19297_ VPWR VGND sg13g2_tiehi
X_41112_ _19298_ VPWR VGND sg13g2_tiehi
X_41113_ _19299_ VPWR VGND sg13g2_tiehi
X_41114_ _19300_ VPWR VGND sg13g2_tiehi
X_41115_ _19301_ VPWR VGND sg13g2_tiehi
X_41116_ _19302_ VPWR VGND sg13g2_tiehi
X_41117_ _19303_ VPWR VGND sg13g2_tiehi
X_41118_ _19304_ VPWR VGND sg13g2_tiehi
X_41119_ _19305_ VPWR VGND sg13g2_tiehi
X_41120_ _19306_ VPWR VGND sg13g2_tiehi
X_41121_ _19307_ VPWR VGND sg13g2_tiehi
X_41122_ _19308_ VPWR VGND sg13g2_tiehi
X_41123_ _19309_ VPWR VGND sg13g2_tiehi
X_41124_ _19310_ VPWR VGND sg13g2_tiehi
X_41125_ _19311_ VPWR VGND sg13g2_tiehi
X_41126_ _19312_ VPWR VGND sg13g2_tiehi
X_41127_ _19313_ VPWR VGND sg13g2_tiehi
X_41128_ _19314_ VPWR VGND sg13g2_tiehi
X_41129_ _19315_ VPWR VGND sg13g2_tiehi
X_41130_ _19316_ VPWR VGND sg13g2_tiehi
X_41131_ _19317_ VPWR VGND sg13g2_tiehi
X_41132_ _19318_ VPWR VGND sg13g2_tiehi
X_41133_ _19319_ VPWR VGND sg13g2_tiehi
X_41134_ _19320_ VPWR VGND sg13g2_tiehi
X_41135_ _19321_ VPWR VGND sg13g2_tiehi
X_41136_ _19322_ VPWR VGND sg13g2_tiehi
X_41137_ _19323_ VPWR VGND sg13g2_tiehi
X_41138_ _19324_ VPWR VGND sg13g2_tiehi
X_41139_ _19325_ VPWR VGND sg13g2_tiehi
X_41140_ _19326_ VPWR VGND sg13g2_tiehi
X_41141_ _19327_ VPWR VGND sg13g2_tiehi
X_41142_ _19328_ VPWR VGND sg13g2_tiehi
X_41143_ _19329_ VPWR VGND sg13g2_tiehi
X_41144_ _19330_ VPWR VGND sg13g2_tiehi
X_41145_ _19331_ VPWR VGND sg13g2_tiehi
X_41146_ _19332_ VPWR VGND sg13g2_tiehi
X_41147_ _19333_ VPWR VGND sg13g2_tiehi
X_41148_ _19334_ VPWR VGND sg13g2_tiehi
X_41149_ _19335_ VPWR VGND sg13g2_tiehi
X_41150_ _19336_ VPWR VGND sg13g2_tiehi
X_41151_ _19337_ VPWR VGND sg13g2_tiehi
X_41152_ _19338_ VPWR VGND sg13g2_tiehi
X_41153_ _19339_ VPWR VGND sg13g2_tiehi
X_41154_ _19340_ VPWR VGND sg13g2_tiehi
X_41155_ _19341_ VPWR VGND sg13g2_tiehi
X_41156_ _19342_ VPWR VGND sg13g2_tiehi
X_41157_ _19343_ VPWR VGND sg13g2_tiehi
X_41158_ _19344_ VPWR VGND sg13g2_tiehi
X_41159_ _19345_ VPWR VGND sg13g2_tiehi
X_41160_ _19346_ VPWR VGND sg13g2_tiehi
X_41161_ _19347_ VPWR VGND sg13g2_tiehi
X_41162_ _19348_ VPWR VGND sg13g2_tiehi
X_41163_ _19349_ VPWR VGND sg13g2_tiehi
X_41164_ _19350_ VPWR VGND sg13g2_tiehi
X_41165_ _19351_ VPWR VGND sg13g2_tiehi
X_41166_ _19352_ VPWR VGND sg13g2_tiehi
X_41167_ _19353_ VPWR VGND sg13g2_tiehi
X_41168_ _19354_ VPWR VGND sg13g2_tiehi
X_41169_ _19355_ VPWR VGND sg13g2_tiehi
X_41170_ _19356_ VPWR VGND sg13g2_tiehi
X_41171_ _19357_ VPWR VGND sg13g2_tiehi
X_41172_ _19358_ VPWR VGND sg13g2_tiehi
X_41173_ _19359_ VPWR VGND sg13g2_tiehi
X_41174_ _19360_ VPWR VGND sg13g2_tiehi
X_41175_ _19361_ VPWR VGND sg13g2_tiehi
X_41176_ _19362_ VPWR VGND sg13g2_tiehi
X_41177_ _19363_ VPWR VGND sg13g2_tiehi
X_41178_ _19364_ VPWR VGND sg13g2_tiehi
X_41179_ _19365_ VPWR VGND sg13g2_tiehi
X_41180_ _19366_ VPWR VGND sg13g2_tiehi
X_41181_ _19367_ VPWR VGND sg13g2_tiehi
X_41182_ _19368_ VPWR VGND sg13g2_tiehi
X_41183_ _19369_ VPWR VGND sg13g2_tiehi
X_41184_ _19370_ VPWR VGND sg13g2_tiehi
X_41185_ _19371_ VPWR VGND sg13g2_tiehi
X_41186_ _19372_ VPWR VGND sg13g2_tiehi
X_41187_ _19373_ VPWR VGND sg13g2_tiehi
X_41188_ _19374_ VPWR VGND sg13g2_tiehi
X_41189_ _19375_ VPWR VGND sg13g2_tiehi
X_41190_ _19376_ VPWR VGND sg13g2_tiehi
X_41191_ _19377_ VPWR VGND sg13g2_tiehi
X_41192_ _19378_ VPWR VGND sg13g2_tiehi
X_41193_ _19379_ VPWR VGND sg13g2_tiehi
X_41194_ _19380_ VPWR VGND sg13g2_tiehi
X_41195_ _19381_ VPWR VGND sg13g2_tiehi
X_41196_ _19382_ VPWR VGND sg13g2_tiehi
X_41197_ _19383_ VPWR VGND sg13g2_tiehi
X_41198_ _19384_ VPWR VGND sg13g2_tiehi
X_41199_ _19385_ VPWR VGND sg13g2_tiehi
X_41200_ _19386_ VPWR VGND sg13g2_tiehi
X_41201_ _19387_ VPWR VGND sg13g2_tiehi
X_41202_ _19388_ VPWR VGND sg13g2_tiehi
X_41203_ _19389_ VPWR VGND sg13g2_tiehi
X_41204_ _19390_ VPWR VGND sg13g2_tiehi
X_41205_ _19391_ VPWR VGND sg13g2_tiehi
X_41206_ _19392_ VPWR VGND sg13g2_tiehi
X_41207_ _19393_ VPWR VGND sg13g2_tiehi
X_41208_ _19394_ VPWR VGND sg13g2_tiehi
X_41209_ _19395_ VPWR VGND sg13g2_tiehi
X_41210_ _19396_ VPWR VGND sg13g2_tiehi
X_41211_ _19397_ VPWR VGND sg13g2_tiehi
X_41212_ _19398_ VPWR VGND sg13g2_tiehi
X_41213_ _19399_ VPWR VGND sg13g2_tiehi
X_41214_ _19400_ VPWR VGND sg13g2_tiehi
X_41215_ _19401_ VPWR VGND sg13g2_tiehi
X_41216_ _19402_ VPWR VGND sg13g2_tiehi
X_41217_ _19403_ VPWR VGND sg13g2_tiehi
X_41218_ _19404_ VPWR VGND sg13g2_tiehi
X_41219_ _19405_ VPWR VGND sg13g2_tiehi
X_41220_ _19406_ VPWR VGND sg13g2_tiehi
X_41221_ _19407_ VPWR VGND sg13g2_tiehi
X_41222_ _19408_ VPWR VGND sg13g2_tiehi
X_41223_ _19409_ VPWR VGND sg13g2_tiehi
X_41224_ _19410_ VPWR VGND sg13g2_tiehi
X_41225_ _19411_ VPWR VGND sg13g2_tiehi
X_41226_ _19412_ VPWR VGND sg13g2_tiehi
X_41227_ _19413_ VPWR VGND sg13g2_tiehi
X_41228_ _19414_ VPWR VGND sg13g2_tiehi
X_41229_ _19415_ VPWR VGND sg13g2_tiehi
X_41230_ _19416_ VPWR VGND sg13g2_tiehi
X_41231_ _19417_ VPWR VGND sg13g2_tiehi
X_41232_ _19418_ VPWR VGND sg13g2_tiehi
X_41233_ _19419_ VPWR VGND sg13g2_tiehi
X_41234_ _19420_ VPWR VGND sg13g2_tiehi
X_41235_ _19421_ VPWR VGND sg13g2_tiehi
X_41236_ _19422_ VPWR VGND sg13g2_tiehi
X_41237_ _19423_ VPWR VGND sg13g2_tiehi
X_41238_ _19424_ VPWR VGND sg13g2_tiehi
X_41239_ _19425_ VPWR VGND sg13g2_tiehi
X_41240_ _19426_ VPWR VGND sg13g2_tiehi
X_41241_ _19427_ VPWR VGND sg13g2_tiehi
X_41242_ _19428_ VPWR VGND sg13g2_tiehi
X_41243_ _19429_ VPWR VGND sg13g2_tiehi
X_41244_ _19430_ VPWR VGND sg13g2_tiehi
X_41245_ _19431_ VPWR VGND sg13g2_tiehi
X_41246_ _19432_ VPWR VGND sg13g2_tiehi
X_41247_ _19433_ VPWR VGND sg13g2_tiehi
X_41248_ _19434_ VPWR VGND sg13g2_tiehi
X_41249_ _19435_ VPWR VGND sg13g2_tiehi
X_41250_ _19436_ VPWR VGND sg13g2_tiehi
X_41251_ _19437_ VPWR VGND sg13g2_tiehi
X_41252_ _19438_ VPWR VGND sg13g2_tiehi
X_41253_ _19439_ VPWR VGND sg13g2_tiehi
X_41254_ _19440_ VPWR VGND sg13g2_tiehi
X_41255_ _19441_ VPWR VGND sg13g2_tiehi
X_41256_ _19442_ VPWR VGND sg13g2_tiehi
X_41257_ _19443_ VPWR VGND sg13g2_tiehi
X_41258_ _19444_ VPWR VGND sg13g2_tiehi
X_41259_ _19445_ VPWR VGND sg13g2_tiehi
X_41260_ _19446_ VPWR VGND sg13g2_tiehi
X_41261_ _19447_ VPWR VGND sg13g2_tiehi
X_41262_ _19448_ VPWR VGND sg13g2_tiehi
X_41263_ _19449_ VPWR VGND sg13g2_tiehi
X_41264_ _19450_ VPWR VGND sg13g2_tiehi
X_41265_ _19451_ VPWR VGND sg13g2_tiehi
X_41266_ _19452_ VPWR VGND sg13g2_tiehi
X_41267_ _19453_ VPWR VGND sg13g2_tiehi
X_41268_ _19454_ VPWR VGND sg13g2_tiehi
X_41269_ _19455_ VPWR VGND sg13g2_tiehi
X_41270_ _19456_ VPWR VGND sg13g2_tiehi
X_41271_ _19457_ VPWR VGND sg13g2_tiehi
X_41272_ _19458_ VPWR VGND sg13g2_tiehi
X_41273_ _19459_ VPWR VGND sg13g2_tiehi
X_41274_ _19460_ VPWR VGND sg13g2_tiehi
X_41275_ _19461_ VPWR VGND sg13g2_tiehi
X_41276_ _19462_ VPWR VGND sg13g2_tiehi
X_41277_ _19463_ VPWR VGND sg13g2_tiehi
X_41278_ _19464_ VPWR VGND sg13g2_tiehi
X_41279_ _19465_ VPWR VGND sg13g2_tiehi
X_41280_ _19466_ VPWR VGND sg13g2_tiehi
X_41281_ _19467_ VPWR VGND sg13g2_tiehi
X_41282_ _19468_ VPWR VGND sg13g2_tiehi
X_41283_ _19469_ VPWR VGND sg13g2_tiehi
X_41284_ _19470_ VPWR VGND sg13g2_tiehi
X_41285_ _19471_ VPWR VGND sg13g2_tiehi
X_41286_ _19472_ VPWR VGND sg13g2_tiehi
X_41287_ _19473_ VPWR VGND sg13g2_tiehi
X_41288_ _19474_ VPWR VGND sg13g2_tiehi
X_41289_ _19475_ VPWR VGND sg13g2_tiehi
X_41290_ _19476_ VPWR VGND sg13g2_tiehi
X_41291_ _19477_ VPWR VGND sg13g2_tiehi
X_41292_ _19478_ VPWR VGND sg13g2_tiehi
X_41293_ _19479_ VPWR VGND sg13g2_tiehi
X_41294_ _19480_ VPWR VGND sg13g2_tiehi
X_41295_ _19481_ VPWR VGND sg13g2_tiehi
X_41296_ _19482_ VPWR VGND sg13g2_tiehi
X_41297_ _19483_ VPWR VGND sg13g2_tiehi
X_41298_ _19484_ VPWR VGND sg13g2_tiehi
X_41299_ _19485_ VPWR VGND sg13g2_tiehi
X_41300_ _19486_ VPWR VGND sg13g2_tiehi
X_41301_ _19487_ VPWR VGND sg13g2_tiehi
X_41302_ _19488_ VPWR VGND sg13g2_tiehi
X_41303_ _19489_ VPWR VGND sg13g2_tiehi
X_41304_ _19490_ VPWR VGND sg13g2_tiehi
X_41305_ _19491_ VPWR VGND sg13g2_tiehi
X_41306_ _19492_ VPWR VGND sg13g2_tiehi
X_41307_ _19493_ VPWR VGND sg13g2_tiehi
X_41308_ _19494_ VPWR VGND sg13g2_tiehi
X_41309_ _19495_ VPWR VGND sg13g2_tiehi
X_41310_ _19496_ VPWR VGND sg13g2_tiehi
X_41311_ _19497_ VPWR VGND sg13g2_tiehi
X_41312_ _19498_ VPWR VGND sg13g2_tiehi
X_41313_ _19499_ VPWR VGND sg13g2_tiehi
X_41314_ _19500_ VPWR VGND sg13g2_tiehi
X_41315_ _19501_ VPWR VGND sg13g2_tiehi
X_41316_ _19502_ VPWR VGND sg13g2_tiehi
X_41317_ _19503_ VPWR VGND sg13g2_tiehi
X_41318_ _19504_ VPWR VGND sg13g2_tiehi
X_41319_ _19505_ VPWR VGND sg13g2_tiehi
X_41320_ _19506_ VPWR VGND sg13g2_tiehi
X_41321_ _19507_ VPWR VGND sg13g2_tiehi
X_41322_ _19508_ VPWR VGND sg13g2_tiehi
X_41323_ _19509_ VPWR VGND sg13g2_tiehi
X_41324_ _19510_ VPWR VGND sg13g2_tiehi
X_41325_ _19511_ VPWR VGND sg13g2_tiehi
X_41326_ _19512_ VPWR VGND sg13g2_tiehi
X_41327_ _19513_ VPWR VGND sg13g2_tiehi
X_41328_ _19514_ VPWR VGND sg13g2_tiehi
X_41329_ _19515_ VPWR VGND sg13g2_tiehi
X_41330_ _19516_ VPWR VGND sg13g2_tiehi
X_41331_ _19517_ VPWR VGND sg13g2_tiehi
X_41332_ _19518_ VPWR VGND sg13g2_tiehi
X_41333_ _19519_ VPWR VGND sg13g2_tiehi
X_41334_ _19520_ VPWR VGND sg13g2_tiehi
X_41335_ _19521_ VPWR VGND sg13g2_tiehi
X_41336_ _19522_ VPWR VGND sg13g2_tiehi
X_41337_ _19523_ VPWR VGND sg13g2_tiehi
X_41338_ _19524_ VPWR VGND sg13g2_tiehi
X_41339_ _19525_ VPWR VGND sg13g2_tiehi
X_41340_ _19526_ VPWR VGND sg13g2_tiehi
X_41341_ _19527_ VPWR VGND sg13g2_tiehi
X_41342_ _19528_ VPWR VGND sg13g2_tiehi
X_41343_ _19529_ VPWR VGND sg13g2_tiehi
X_41344_ _19530_ VPWR VGND sg13g2_tiehi
X_41345_ _19531_ VPWR VGND sg13g2_tiehi
X_41346_ _19532_ VPWR VGND sg13g2_tiehi
X_41347_ _19533_ VPWR VGND sg13g2_tiehi
X_41348_ _19534_ VPWR VGND sg13g2_tiehi
X_41349_ _19535_ VPWR VGND sg13g2_tiehi
X_41350_ _19536_ VPWR VGND sg13g2_tiehi
X_41351_ _19537_ VPWR VGND sg13g2_tiehi
X_41352_ _19538_ VPWR VGND sg13g2_tiehi
X_41353_ _19539_ VPWR VGND sg13g2_tiehi
X_41354_ _19540_ VPWR VGND sg13g2_tiehi
X_41355_ _19541_ VPWR VGND sg13g2_tiehi
X_41356_ _19542_ VPWR VGND sg13g2_tiehi
X_41357_ _19543_ VPWR VGND sg13g2_tiehi
X_41358_ _19544_ VPWR VGND sg13g2_tiehi
X_41359_ _19545_ VPWR VGND sg13g2_tiehi
X_41360_ _19546_ VPWR VGND sg13g2_tiehi
X_41361_ _19547_ VPWR VGND sg13g2_tiehi
X_41362_ _19548_ VPWR VGND sg13g2_tiehi
X_41363_ _19549_ VPWR VGND sg13g2_tiehi
X_41364_ _19550_ VPWR VGND sg13g2_tiehi
X_41365_ _19551_ VPWR VGND sg13g2_tiehi
X_41366_ _19552_ VPWR VGND sg13g2_tiehi
X_41367_ _19553_ VPWR VGND sg13g2_tiehi
X_41368_ _19554_ VPWR VGND sg13g2_tiehi
X_41369_ _19555_ VPWR VGND sg13g2_tiehi
X_41370_ _19556_ VPWR VGND sg13g2_tiehi
X_41371_ _19557_ VPWR VGND sg13g2_tiehi
X_41372_ _19558_ VPWR VGND sg13g2_tiehi
X_41373_ _19559_ VPWR VGND sg13g2_tiehi
X_41374_ _19560_ VPWR VGND sg13g2_tiehi
X_41375_ _19561_ VPWR VGND sg13g2_tiehi
X_41376_ _19562_ VPWR VGND sg13g2_tiehi
X_41377_ _19563_ VPWR VGND sg13g2_tiehi
X_41378_ _19564_ VPWR VGND sg13g2_tiehi
X_41379_ _19565_ VPWR VGND sg13g2_tiehi
X_41380_ _19566_ VPWR VGND sg13g2_tiehi
X_41381_ _19567_ VPWR VGND sg13g2_tiehi
X_41382_ _19568_ VPWR VGND sg13g2_tiehi
X_41383_ _19569_ VPWR VGND sg13g2_tiehi
X_41384_ _19570_ VPWR VGND sg13g2_tiehi
X_41385_ _19571_ VPWR VGND sg13g2_tiehi
X_41386_ _19572_ VPWR VGND sg13g2_tiehi
X_41387_ _19573_ VPWR VGND sg13g2_tiehi
X_41388_ ds_Q_oe ds_I_oe VPWR VGND sg13g2_buf_1
X_41389_ lo_Q_oe lo_I_oe VPWR VGND sg13g2_buf_1

.ends
.end

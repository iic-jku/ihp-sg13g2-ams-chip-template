* NGSPICE file created from counter_top.ext - technology: ihp-sg13g2

* Black-box entry subcircuit for sg13g2_decap_8 abstract view
.subckt sg13g2_decap_8 VDD VSS
.ends

* Black-box entry subcircuit for sg13g2_fill_1 abstract view
.subckt sg13g2_fill_1 VDD VSS
.ends

* Black-box entry subcircuit for sg13g2_decap_4 abstract view
.subckt sg13g2_decap_4 VDD VSS
.ends

* Black-box entry subcircuit for sg13g2_or3_1 abstract view
.subckt sg13g2_or3_1 X A B C VDD VSS
.ends

* Black-box entry subcircuit for sg13g2_mux2_1 abstract view
.subckt sg13g2_mux2_1 X A0 A1 S VDD VSS
.ends

* Black-box entry subcircuit for sg13g2_dlygate4sd3_1 abstract view
.subckt sg13g2_dlygate4sd3_1 X A VDD VSS
.ends

* Black-box entry subcircuit for sg13g2_buf_1 abstract view
.subckt sg13g2_buf_1 X A VDD VSS
.ends

* Black-box entry subcircuit for sg13g2_tiehi abstract view
.subckt sg13g2_tiehi L_HI VDD VSS
.ends

* Black-box entry subcircuit for sg13g2_o21ai_1 abstract view
.subckt sg13g2_o21ai_1 Y A1 A2 B1 VDD VSS
.ends

* Black-box entry subcircuit for sg13g2_nor3_2 abstract view
.subckt sg13g2_nor3_2 Y A B C VDD VSS
.ends

* Black-box entry subcircuit for sg13g2_fill_2 abstract view
.subckt sg13g2_fill_2 VDD VSS
.ends

* Black-box entry subcircuit for sg13g2_nand3_1 abstract view
.subckt sg13g2_nand3_1 Y A B C VDD VSS
.ends

* Black-box entry subcircuit for sg13g2_inv_1 abstract view
.subckt sg13g2_inv_1 Y A VDD VSS
.ends

* Black-box entry subcircuit for sg13g2_a21oi_1 abstract view
.subckt sg13g2_a21oi_1 Y A1 A2 B1 VDD VSS
.ends

* Black-box entry subcircuit for sg13g2_nor2_1 abstract view
.subckt sg13g2_nor2_1 Y A B VDD VSS
.ends

* Black-box entry subcircuit for sg13g2_and2_1 abstract view
.subckt sg13g2_and2_1 X A B VDD VSS
.ends

* Black-box entry subcircuit for sg13g2_nand2_1 abstract view
.subckt sg13g2_nand2_1 Y A B VDD VSS
.ends

* Black-box entry subcircuit for sg13g2_nand4_1 abstract view
.subckt sg13g2_nand4_1 Y A B C D VDD VSS
.ends

* Black-box entry subcircuit for sg13g2_buf_16 abstract view
.subckt sg13g2_buf_16 X A VDD VSS
.ends

* Black-box entry subcircuit for sg13g2_dfrbpq_1 abstract view
.subckt sg13g2_dfrbpq_1 Q CLK D RESET_B VDD VSS
.ends

* Black-box entry subcircuit for sg13g2_xor2_1 abstract view
.subckt sg13g2_xor2_1 X A B VDD VSS
.ends

* Black-box entry subcircuit for sg13g2_buf_4 abstract view
.subckt sg13g2_buf_4 X A VDD VSS
.ends

* Black-box entry subcircuit for sg13g2_xnor2_1 abstract view
.subckt sg13g2_xnor2_1 Y A B VDD VSS
.ends

.subckt counter_top VDD VSS clock_i counter_value_o[0] counter_value_o[1] counter_value_o[2]
+ counter_value_o[3] counter_value_o[4] counter_value_o[5] counter_value_o[6] counter_value_o[7]
+ enable_i reset_n_i
XFILLER_7_7 VDD VSS sg13g2_decap_8
XFILLER_13_133 VDD VSS sg13g2_decap_8
XFILLER_3_56 VDD VSS sg13g2_decap_8
XFILLER_9_137 VDD VSS sg13g2_decap_8
XFILLER_5_387 VDD VSS sg13g2_fill_1
XFILLER_5_343 VDD VSS sg13g2_decap_4
XFILLER_10_147 VDD VSS sg13g2_decap_8
XFILLER_12_21 VDD VSS sg13g2_decap_8
XFILLER_12_98 VDD VSS sg13g2_decap_8
XFILLER_2_357 VDD VSS sg13g2_decap_4
XFILLER_17_280 VDD VSS sg13g2_decap_8
X_66_ _66_/X _66_/A _66_/B _66_/C VDD VSS sg13g2_or3_1
XFILLER_5_140 VDD VSS sg13g2_decap_8
XFILLER_15_217 VDD VSS sg13g2_decap_8
XFILLER_0_35 VDD VSS sg13g2_decap_8
XFILLER_14_294 VDD VSS sg13g2_decap_8
XFILLER_2_154 VDD VSS sg13g2_decap_8
XFILLER_9_88 VDD VSS sg13g2_decap_8
XFILLER_9_11 VDD VSS sg13g2_decap_8
X_49_ _49_/X _45_/X _46_/Y _49_/S VDD VSS sg13g2_mux2_1
XFILLER_11_231 VDD VSS sg13g2_decap_8
XFILLER_7_224 VDD VSS sg13g2_decap_8
XFILLER_16_301 VDD VSS sg13g2_decap_8
Xhold30 _57_/D _68_/Q VDD VSS sg13g2_dlygate4sd3_1
XFILLER_4_238 VDD VSS sg13g2_decap_8
XFILLER_6_56 VDD VSS sg13g2_decap_8
XFILLER_13_315 VDD VSS sg13g2_decap_8
XFILLER_15_21 VDD VSS sg13g2_decap_8
XFILLER_15_98 VDD VSS sg13g2_decap_8
XFILLER_9_319 VDD VSS sg13g2_decap_8
XFILLER_0_252 VDD VSS sg13g2_decap_8
XFILLER_16_175 VDD VSS sg13g2_decap_8
Xoutput7 counter_value_o[4] _72_/Q VDD VSS sg13g2_buf_1
XFILLER_8_374 VDD VSS sg13g2_decap_8
XFILLER_11_0 VDD VSS sg13g2_decap_8
X_75__14 _75__14/L_HI VDD VSS sg13g2_tiehi
XFILLER_13_112 VDD VSS sg13g2_decap_8
XFILLER_13_189 VDD VSS sg13g2_decap_8
XFILLER_3_35 VDD VSS sg13g2_decap_8
XFILLER_9_116 VDD VSS sg13g2_decap_8
XFILLER_5_355 VDD VSS sg13g2_decap_4
XFILLER_5_322 VDD VSS sg13g2_decap_8
X_72__17 _72__17/L_HI VDD VSS sg13g2_tiehi
XFILLER_8_182 VDD VSS sg13g2_decap_8
XFILLER_10_126 VDD VSS sg13g2_decap_8
XFILLER_12_77 VDD VSS sg13g2_decap_8
XFILLER_6_119 VDD VSS sg13g2_decap_8
X_65_ _65_/Y _66_/B _66_/C _66_/A VDD VSS sg13g2_o21ai_1
XFILLER_5_196 VDD VSS sg13g2_decap_8
XFILLER_0_14 VDD VSS sg13g2_decap_8
XFILLER_14_273 VDD VSS sg13g2_decap_8
XFILLER_2_133 VDD VSS sg13g2_decap_8
XFILLER_9_67 VDD VSS sg13g2_decap_8
X_48_ _49_/S _48_/A _66_/B _48_/C VDD VSS sg13g2_nor3_2
XFILLER_11_210 VDD VSS sg13g2_decap_8
XFILLER_11_287 VDD VSS sg13g2_decap_8
XFILLER_7_203 VDD VSS sg13g2_decap_8
XFILLER_15_7 VDD VSS sg13g2_decap_8
XFILLER_6_280 VDD VSS sg13g2_decap_8
Xhold20 _67_/A1 _65_/Y VDD VSS sg13g2_dlygate4sd3_1
Xhold31 _58_/A _71_/Q VDD VSS sg13g2_dlygate4sd3_1
XFILLER_4_217 VDD VSS sg13g2_decap_8
XFILLER_3_294 VDD VSS sg13g2_decap_8
XFILLER_6_35 VDD VSS sg13g2_decap_8
XFILLER_0_231 VDD VSS sg13g2_decap_8
XFILLER_15_77 VDD VSS sg13g2_decap_8
XFILLER_16_154 VDD VSS sg13g2_decap_8
Xoutput10 counter_value_o[7] _75_/Q VDD VSS sg13g2_buf_1
Xoutput8 counter_value_o[5] _73_/Q VDD VSS sg13g2_buf_1
XFILLER_10_308 VDD VSS sg13g2_decap_8
XFILLER_10_319 VDD VSS sg13g2_fill_2
XFILLER_13_168 VDD VSS sg13g2_decap_8
XFILLER_5_301 VDD VSS sg13g2_decap_8
XFILLER_3_14 VDD VSS sg13g2_decap_8
XFILLER_8_161 VDD VSS sg13g2_decap_8
XFILLER_10_105 VDD VSS sg13g2_decap_8
XFILLER_12_56 VDD VSS sg13g2_decap_8
XFILLER_2_315 VDD VSS sg13g2_decap_4
X_64_ _66_/C _72_/Q _71_/Q _70_/Q VDD VSS sg13g2_nand3_1
XFILLER_5_175 VDD VSS sg13g2_decap_8
XFILLER_14_252 VDD VSS sg13g2_decap_8
XFILLER_2_112 VDD VSS sg13g2_decap_8
XFILLER_2_189 VDD VSS sg13g2_decap_8
XFILLER_9_46 VDD VSS sg13g2_decap_8
X_47_ _48_/A _47_/A VDD VSS sg13g2_inv_1
XFILLER_11_266 VDD VSS sg13g2_decap_8
XFILLER_7_259 VDD VSS sg13g2_decap_8
XFILLER_3_273 VDD VSS sg13g2_decap_8
Xhold21 _73_/D _67_/Y VDD VSS sg13g2_dlygate4sd3_1
Xhold32 _59_/B _58_/X VDD VSS sg13g2_dlygate4sd3_1
XFILLER_6_14 VDD VSS sg13g2_decap_8
XFILLER_15_391 VDD VSS sg13g2_fill_1
XFILLER_0_210 VDD VSS sg13g2_decap_8
XFILLER_0_287 VDD VSS sg13g2_decap_8
XFILLER_15_56 VDD VSS sg13g2_decap_8
XFILLER_16_133 VDD VSS sg13g2_decap_8
Xoutput9 counter_value_o[6] _74_/Q VDD VSS sg13g2_buf_1
XFILLER_8_343 VDD VSS sg13g2_fill_1
XFILLER_13_147 VDD VSS sg13g2_decap_8
XFILLER_8_140 VDD VSS sg13g2_decap_8
XFILLER_12_35 VDD VSS sg13g2_decap_8
XFILLER_5_7 VDD VSS sg13g2_decap_8
XFILLER_5_154 VDD VSS sg13g2_decap_8
XFILLER_17_294 VDD VSS sg13g2_decap_8
X_63_ _63_/Y _63_/A1 _62_/X _59_/A VDD VSS sg13g2_a21oi_1
XFILLER_4_91 VDD VSS sg13g2_decap_8
XFILLER_0_49 VDD VSS sg13g2_decap_8
XFILLER_2_168 VDD VSS sg13g2_decap_8
XFILLER_14_231 VDD VSS sg13g2_decap_8
X_46_ _46_/Y _46_/A _59_/A VDD VSS sg13g2_nor2_1
XFILLER_9_25 VDD VSS sg13g2_decap_8
XFILLER_11_245 VDD VSS sg13g2_decap_8
XFILLER_7_238 VDD VSS sg13g2_decap_8
XFILLER_1_81 VDD VSS sg13g2_decap_8
XFILLER_16_315 VDD VSS sg13g2_decap_8
XFILLER_3_252 VDD VSS sg13g2_decap_8
Xhold22 _47_/A _74_/Q VDD VSS sg13g2_dlygate4sd3_1
Xhold33 _46_/A _75_/Q VDD VSS sg13g2_dlygate4sd3_1
XFILLER_0_266 VDD VSS sg13g2_decap_8
XFILLER_13_329 VDD VSS sg13g2_decap_8
XFILLER_15_35 VDD VSS sg13g2_decap_8
XFILLER_16_112 VDD VSS sg13g2_decap_8
XFILLER_16_189 VDD VSS sg13g2_decap_8
XFILLER_8_322 VDD VSS sg13g2_decap_8
XFILLER_7_91 VDD VSS sg13g2_decap_8
XFILLER_13_126 VDD VSS sg13g2_decap_8
XFILLER_3_49 VDD VSS sg13g2_decap_8
XFILLER_5_336 VDD VSS sg13g2_decap_8
XFILLER_12_14 VDD VSS sg13g2_decap_8
XFILLER_8_196 VDD VSS sg13g2_decap_8
XFILLER_4_391 VDD VSS sg13g2_fill_1
XFILLER_5_133 VDD VSS sg13g2_decap_8
XFILLER_17_273 VDD VSS sg13g2_decap_8
XFILLER_1_383 VDD VSS sg13g2_decap_4
X_62_ _62_/X _62_/A _66_/B _62_/C VDD VSS sg13g2_or3_1
XFILLER_2_147 VDD VSS sg13g2_decap_8
XFILLER_4_70 VDD VSS sg13g2_decap_8
XFILLER_0_28 VDD VSS sg13g2_decap_8
XFILLER_14_210 VDD VSS sg13g2_decap_8
XFILLER_14_287 VDD VSS sg13g2_decap_8
X_45_ _45_/X _46_/A _45_/B VDD VSS sg13g2_and2_1
XFILLER_9_291 VDD VSS sg13g2_decap_8
XFILLER_11_224 VDD VSS sg13g2_decap_8
XFILLER_7_217 VDD VSS sg13g2_decap_8
XFILLER_1_60 VDD VSS sg13g2_decap_8
XFILLER_6_294 VDD VSS sg13g2_decap_8
Xhold23 _44_/A1 _41_/Y VDD VSS sg13g2_dlygate4sd3_1
Xhold34 _75_/D _49_/X VDD VSS sg13g2_dlygate4sd3_1
XFILLER_10_91 VDD VSS sg13g2_decap_8
XFILLER_13_7 VDD VSS sg13g2_decap_8
XFILLER_3_231 VDD VSS sg13g2_decap_8
XFILLER_6_49 VDD VSS sg13g2_decap_8
XFILLER_13_308 VDD VSS sg13g2_decap_8
XFILLER_15_14 VDD VSS sg13g2_decap_8
XFILLER_0_245 VDD VSS sg13g2_decap_8
XFILLER_12_352 VDD VSS sg13g2_fill_1
XFILLER_16_168 VDD VSS sg13g2_decap_8
XFILLER_8_356 VDD VSS sg13g2_decap_4
XFILLER_8_301 VDD VSS sg13g2_decap_8
XFILLER_7_70 VDD VSS sg13g2_decap_8
XFILLER_13_105 VDD VSS sg13g2_decap_8
XFILLER_3_28 VDD VSS sg13g2_decap_8
XFILLER_9_109 VDD VSS sg13g2_decap_8
XFILLER_5_359 VDD VSS sg13g2_fill_1
XFILLER_5_315 VDD VSS sg13g2_decap_8
XFILLER_12_182 VDD VSS sg13g2_decap_8
XFILLER_8_175 VDD VSS sg13g2_decap_8
XFILLER_10_119 VDD VSS sg13g2_decap_8
XFILLER_17_252 VDD VSS sg13g2_decap_8
XFILLER_1_373 VDD VSS sg13g2_fill_1
X_61_ _61_/Y _66_/B _62_/C _62_/A VDD VSS sg13g2_o21ai_1
XFILLER_5_189 VDD VSS sg13g2_decap_8
XFILLER_5_112 VDD VSS sg13g2_decap_8
XFILLER_13_91 VDD VSS sg13g2_decap_8
XFILLER_14_266 VDD VSS sg13g2_decap_8
XFILLER_2_126 VDD VSS sg13g2_decap_8
X_44_ _44_/Y _44_/A1 _42_/X _59_/A VDD VSS sg13g2_a21oi_1
XFILLER_9_270 VDD VSS sg13g2_decap_8
XFILLER_11_203 VDD VSS sg13g2_decap_8
XFILLER_10_280 VDD VSS sg13g2_decap_8
XFILLER_6_273 VDD VSS sg13g2_decap_8
Xhold24 _74_/D _44_/Y VDD VSS sg13g2_dlygate4sd3_1
Xhold35 _55_/A _70_/Q VDD VSS sg13g2_dlygate4sd3_1
XFILLER_10_70 VDD VSS sg13g2_decap_8
XFILLER_15_361 VDD VSS sg13g2_fill_1
XFILLER_3_210 VDD VSS sg13g2_decap_8
XFILLER_3_287 VDD VSS sg13g2_decap_8
XFILLER_6_28 VDD VSS sg13g2_decap_8
XFILLER_0_224 VDD VSS sg13g2_decap_8
XFILLER_12_331 VDD VSS sg13g2_decap_8
XFILLER_12_386 VDD VSS sg13g2_decap_4
XFILLER_16_147 VDD VSS sg13g2_decap_8
XFILLER_12_161 VDD VSS sg13g2_decap_8
XFILLER_16_91 VDD VSS sg13g2_decap_8
XFILLER_8_154 VDD VSS sg13g2_decap_8
XFILLER_12_49 VDD VSS sg13g2_decap_8
XFILLER_2_308 VDD VSS sg13g2_decap_8
XFILLER_2_319 VDD VSS sg13g2_fill_2
XFILLER_17_231 VDD VSS sg13g2_decap_8
XFILLER_1_341 VDD VSS sg13g2_decap_8
X_60_ _62_/C _71_/Q _70_/Q VDD VSS sg13g2_nand2_1
XFILLER_5_168 VDD VSS sg13g2_decap_8
XFILLER_13_70 VDD VSS sg13g2_decap_8
XFILLER_14_245 VDD VSS sg13g2_decap_8
XFILLER_2_105 VDD VSS sg13g2_decap_8
XFILLER_3_7 VDD VSS sg13g2_decap_8
XFILLER_9_39 VDD VSS sg13g2_decap_8
XFILLER_1_193 VDD VSS sg13g2_decap_8
X_43_ _59_/A _45_/B VDD VSS sg13g2_inv_1
XFILLER_11_259 VDD VSS sg13g2_decap_8
XFILLER_1_4 VDD VSS sg13g2_decap_8
XFILLER_6_252 VDD VSS sg13g2_decap_8
XFILLER_1_95 VDD VSS sg13g2_decap_8
Xhold25 _62_/A _72_/Q VDD VSS sg13g2_dlygate4sd3_1
XFILLER_16_329 VDD VSS sg13g2_fill_2
XFILLER_3_266 VDD VSS sg13g2_decap_8
XFILLER_15_49 VDD VSS sg13g2_decap_8
XFILLER_0_203 VDD VSS sg13g2_decap_8
XFILLER_12_376 VDD VSS sg13g2_fill_1
XFILLER_16_126 VDD VSS sg13g2_decap_8
XFILLER_8_336 VDD VSS sg13g2_fill_2
XFILLER_7_391 VDD VSS sg13g2_fill_1
XFILLER_12_140 VDD VSS sg13g2_decap_8
XFILLER_16_70 VDD VSS sg13g2_decap_8
XFILLER_8_133 VDD VSS sg13g2_decap_8
XFILLER_4_350 VDD VSS sg13g2_decap_4
XFILLER_12_28 VDD VSS sg13g2_decap_8
XFILLER_17_210 VDD VSS sg13g2_decap_8
XFILLER_5_147 VDD VSS sg13g2_decap_8
XFILLER_17_287 VDD VSS sg13g2_decap_8
XFILLER_4_84 VDD VSS sg13g2_decap_8
XFILLER_14_224 VDD VSS sg13g2_decap_8
XFILLER_9_18 VDD VSS sg13g2_decap_8
XFILLER_1_172 VDD VSS sg13g2_decap_8
X_42_ _42_/X _47_/A _66_/B _48_/C VDD VSS sg13g2_or3_1
XFILLER_11_238 VDD VSS sg13g2_decap_8
XFILLER_6_231 VDD VSS sg13g2_decap_8
XFILLER_1_74 VDD VSS sg13g2_decap_8
XFILLER_16_308 VDD VSS sg13g2_decap_8
XFILLER_3_245 VDD VSS sg13g2_decap_8
Xhold26 _63_/A1 _61_/Y VDD VSS sg13g2_dlygate4sd3_1
XFILLER_0_259 VDD VSS sg13g2_decap_8
XFILLER_15_28 VDD VSS sg13g2_decap_8
XFILLER_16_105 VDD VSS sg13g2_decap_8
XFILLER_11_7 VDD VSS sg13g2_decap_8
XFILLER_12_322 VDD VSS sg13g2_decap_4
XFILLER_15_182 VDD VSS sg13g2_decap_8
X_69__18 _69__18/L_HI VDD VSS sg13g2_tiehi
XFILLER_8_315 VDD VSS sg13g2_decap_8
XFILLER_13_119 VDD VSS sg13g2_decap_8
XFILLER_7_84 VDD VSS sg13g2_decap_8
XFILLER_12_196 VDD VSS sg13g2_decap_8
XFILLER_8_189 VDD VSS sg13g2_decap_8
XFILLER_8_112 VDD VSS sg13g2_decap_8
XFILLER_5_329 VDD VSS sg13g2_decap_8
X_71__13 _71__13/L_HI VDD VSS sg13g2_tiehi
XFILLER_4_384 VDD VSS sg13g2_decap_8
XFILLER_5_126 VDD VSS sg13g2_decap_8
XFILLER_17_266 VDD VSS sg13g2_decap_8
XFILLER_1_387 VDD VSS sg13g2_fill_1
XFILLER_4_63 VDD VSS sg13g2_decap_8
XFILLER_14_203 VDD VSS sg13g2_decap_8
XFILLER_1_151 VDD VSS sg13g2_decap_8
X_41_ _41_/Y _66_/B _48_/C _47_/A VDD VSS sg13g2_o21ai_1
XFILLER_11_217 VDD VSS sg13g2_decap_8
XFILLER_13_280 VDD VSS sg13g2_decap_8
XFILLER_9_284 VDD VSS sg13g2_decap_8
XFILLER_6_210 VDD VSS sg13g2_decap_8
XFILLER_10_294 VDD VSS sg13g2_decap_8
XFILLER_1_53 VDD VSS sg13g2_decap_8
XFILLER_6_287 VDD VSS sg13g2_decap_8
XFILLER_3_224 VDD VSS sg13g2_decap_8
Xhold27 _72_/D _63_/Y VDD VSS sg13g2_dlygate4sd3_1
XFILLER_10_84 VDD VSS sg13g2_decap_8
XFILLER_0_238 VDD VSS sg13g2_decap_8
XFILLER_12_301 VDD VSS sg13g2_decap_8
XFILLER_12_345 VDD VSS sg13g2_decap_8
XFILLER_8_349 VDD VSS sg13g2_decap_8
XFILLER_15_161 VDD VSS sg13g2_decap_8
XFILLER_7_63 VDD VSS sg13g2_decap_8
XFILLER_5_308 VDD VSS sg13g2_decap_8
XFILLER_12_175 VDD VSS sg13g2_decap_8
XFILLER_8_168 VDD VSS sg13g2_decap_8
XFILLER_5_105 VDD VSS sg13g2_decap_8
XFILLER_17_245 VDD VSS sg13g2_decap_8
XFILLER_1_366 VDD VSS sg13g2_decap_8
XFILLER_4_42 VDD VSS sg13g2_decap_8
XFILLER_4_182 VDD VSS sg13g2_decap_8
XFILLER_2_119 VDD VSS sg13g2_decap_8
XFILLER_13_84 VDD VSS sg13g2_decap_8
XFILLER_14_259 VDD VSS sg13g2_decap_8
XFILLER_1_130 VDD VSS sg13g2_decap_8
X_40_ _48_/C _66_/A _62_/A _58_/A _70_/Q VDD VSS sg13g2_nand4_1
XFILLER_8_0 VDD VSS sg13g2_decap_8
XFILLER_9_263 VDD VSS sg13g2_decap_8
XFILLER_10_273 VDD VSS sg13g2_decap_8
XFILLER_1_32 VDD VSS sg13g2_decap_8
XFILLER_6_266 VDD VSS sg13g2_decap_8
Xhold28 _57_/C _69_/Q VDD VSS sg13g2_dlygate4sd3_1
XFILLER_10_63 VDD VSS sg13g2_decap_8
XFILLER_3_203 VDD VSS sg13g2_decap_8
XFILLER_0_217 VDD VSS sg13g2_decap_8
XFILLER_2_280 VDD VSS sg13g2_decap_8
XFILLER_15_140 VDD VSS sg13g2_decap_8
XFILLER_7_42 VDD VSS sg13g2_decap_8
XFILLER_12_154 VDD VSS sg13g2_decap_8
XFILLER_16_84 VDD VSS sg13g2_decap_8
XFILLER_8_147 VDD VSS sg13g2_decap_8
XFILLER_17_224 VDD VSS sg13g2_decap_8
XFILLER_1_312 VDD VSS sg13g2_decap_8
XFILLER_4_161 VDD VSS sg13g2_decap_8
XFILLER_4_98 VDD VSS sg13g2_decap_8
XFILLER_4_21 VDD VSS sg13g2_decap_8
XFILLER_13_63 VDD VSS sg13g2_decap_8
XFILLER_14_238 VDD VSS sg13g2_decap_8
XFILLER_1_186 VDD VSS sg13g2_decap_8
XFILLER_9_242 VDD VSS sg13g2_decap_8
XFILLER_10_252 VDD VSS sg13g2_decap_8
XFILLER_1_11 VDD VSS sg13g2_decap_8
XFILLER_1_88 VDD VSS sg13g2_decap_8
XFILLER_6_245 VDD VSS sg13g2_decap_8
Xhold29 _54_/B _53_/X VDD VSS sg13g2_dlygate4sd3_1
XFILLER_10_42 VDD VSS sg13g2_decap_8
XFILLER_15_322 VDD VSS sg13g2_decap_8
XFILLER_3_259 VDD VSS sg13g2_decap_8
XFILLER_16_119 VDD VSS sg13g2_decap_8
XFILLER_8_329 VDD VSS sg13g2_decap_8
XFILLER_11_391 VDD VSS sg13g2_fill_1
XFILLER_15_196 VDD VSS sg13g2_decap_8
XFILLER_7_98 VDD VSS sg13g2_decap_8
XFILLER_7_351 VDD VSS sg13g2_decap_8
XFILLER_7_21 VDD VSS sg13g2_decap_8
XFILLER_16_0 VDD VSS sg13g2_decap_8
Xclkbuf_1_1__f_clock_i _75_/CLK clkbuf_0_clock_i/X VDD VSS sg13g2_buf_16
XFILLER_12_133 VDD VSS sg13g2_decap_8
XFILLER_16_63 VDD VSS sg13g2_decap_8
XFILLER_8_126 VDD VSS sg13g2_decap_8
XFILLER_4_354 VDD VSS sg13g2_fill_1
XFILLER_4_343 VDD VSS sg13g2_decap_8
XFILLER_17_203 VDD VSS sg13g2_decap_8
XFILLER_16_280 VDD VSS sg13g2_decap_8
XFILLER_4_140 VDD VSS sg13g2_decap_8
XFILLER_4_77 VDD VSS sg13g2_decap_8
XFILLER_13_42 VDD VSS sg13g2_decap_8
XFILLER_14_217 VDD VSS sg13g2_decap_8
XFILLER_13_294 VDD VSS sg13g2_decap_8
XFILLER_1_165 VDD VSS sg13g2_decap_8
XFILLER_9_298 VDD VSS sg13g2_decap_8
XFILLER_9_221 VDD VSS sg13g2_decap_8
XFILLER_10_231 VDD VSS sg13g2_decap_8
XFILLER_6_224 VDD VSS sg13g2_decap_8
XFILLER_1_67 VDD VSS sg13g2_decap_8
Xhold19 _66_/A _73_/Q VDD VSS sg13g2_dlygate4sd3_1
XFILLER_10_21 VDD VSS sg13g2_decap_8
XFILLER_10_98 VDD VSS sg13g2_decap_8
XFILLER_15_301 VDD VSS sg13g2_decap_8
XFILLER_3_238 VDD VSS sg13g2_decap_8
XFILLER_15_389 VDD VSS sg13g2_fill_2
XFILLER_12_315 VDD VSS sg13g2_decap_8
XFILLER_12_326 VDD VSS sg13g2_fill_2
XFILLER_8_308 VDD VSS sg13g2_decap_8
XFILLER_15_175 VDD VSS sg13g2_decap_8
XFILLER_7_77 VDD VSS sg13g2_decap_8
XFILLER_12_112 VDD VSS sg13g2_decap_8
XFILLER_12_189 VDD VSS sg13g2_decap_8
XFILLER_16_42 VDD VSS sg13g2_decap_8
XFILLER_8_105 VDD VSS sg13g2_decap_8
XFILLER_4_377 VDD VSS sg13g2_decap_8
XFILLER_4_322 VDD VSS sg13g2_decap_8
XFILLER_7_182 VDD VSS sg13g2_decap_8
XFILLER_5_119 VDD VSS sg13g2_decap_8
XFILLER_17_259 VDD VSS sg13g2_decap_8
XFILLER_4_56 VDD VSS sg13g2_decap_8
XFILLER_4_196 VDD VSS sg13g2_decap_8
XFILLER_13_21 VDD VSS sg13g2_decap_8
XFILLER_13_273 VDD VSS sg13g2_decap_8
XFILLER_13_98 VDD VSS sg13g2_decap_8
XFILLER_1_144 VDD VSS sg13g2_decap_8
XFILLER_9_277 VDD VSS sg13g2_decap_8
XFILLER_9_200 VDD VSS sg13g2_decap_8
XFILLER_10_210 VDD VSS sg13g2_decap_8
XFILLER_10_287 VDD VSS sg13g2_decap_8
XFILLER_6_203 VDD VSS sg13g2_decap_8
XFILLER_6_0 VDD VSS sg13g2_decap_8
XFILLER_1_46 VDD VSS sg13g2_decap_8
XFILLER_5_280 VDD VSS sg13g2_decap_8
XFILLER_10_77 VDD VSS sg13g2_decap_8
XFILLER_3_217 VDD VSS sg13g2_decap_8
Xinput1 _57_/A enable_i VDD VSS sg13g2_buf_1
XFILLER_15_346 VDD VSS sg13g2_fill_2
XFILLER_15_357 VDD VSS sg13g2_decap_4
XFILLER_2_294 VDD VSS sg13g2_decap_8
XFILLER_12_338 VDD VSS sg13g2_decap_8
XFILLER_15_154 VDD VSS sg13g2_decap_8
X_68__12 _68__12/L_HI VDD VSS sg13g2_tiehi
X_74__15 _74__15/L_HI VDD VSS sg13g2_tiehi
XFILLER_7_56 VDD VSS sg13g2_decap_8
XFILLER_12_168 VDD VSS sg13g2_decap_8
XFILLER_16_21 VDD VSS sg13g2_decap_8
XFILLER_16_98 VDD VSS sg13g2_decap_8
XFILLER_4_301 VDD VSS sg13g2_decap_8
XFILLER_7_161 VDD VSS sg13g2_decap_8
XFILLER_1_326 VDD VSS sg13g2_fill_2
XFILLER_1_348 VDD VSS sg13g2_fill_1
XFILLER_17_238 VDD VSS sg13g2_decap_8
XFILLER_4_35 VDD VSS sg13g2_decap_8
XFILLER_4_175 VDD VSS sg13g2_decap_8
XFILLER_13_77 VDD VSS sg13g2_decap_8
XFILLER_1_123 VDD VSS sg13g2_decap_8
XFILLER_13_252 VDD VSS sg13g2_decap_8
XFILLER_9_256 VDD VSS sg13g2_decap_8
XFILLER_10_266 VDD VSS sg13g2_decap_8
XFILLER_1_25 VDD VSS sg13g2_decap_8
XFILLER_6_259 VDD VSS sg13g2_decap_8
XFILLER_10_56 VDD VSS sg13g2_decap_8
Xinput2 _45_/B reset_n_i VDD VSS sg13g2_buf_1
XFILLER_2_273 VDD VSS sg13g2_decap_8
XFILLER_15_133 VDD VSS sg13g2_decap_8
XFILLER_7_35 VDD VSS sg13g2_decap_8
XFILLER_7_343 VDD VSS sg13g2_decap_4
XFILLER_12_147 VDD VSS sg13g2_decap_8
XFILLER_16_77 VDD VSS sg13g2_decap_8
XFILLER_7_140 VDD VSS sg13g2_decap_8
XFILLER_14_0 VDD VSS sg13g2_decap_8
XFILLER_17_217 VDD VSS sg13g2_decap_8
XFILLER_1_305 VDD VSS sg13g2_decap_8
XFILLER_4_14 VDD VSS sg13g2_decap_8
XFILLER_4_154 VDD VSS sg13g2_decap_8
XFILLER_0_371 VDD VSS sg13g2_decap_8
XFILLER_16_294 VDD VSS sg13g2_decap_8
Xclkbuf_1_0__f_clock_i _71_/CLK clkbuf_0_clock_i/X VDD VSS sg13g2_buf_16
XFILLER_13_56 VDD VSS sg13g2_decap_8
XFILLER_1_102 VDD VSS sg13g2_decap_8
XFILLER_1_179 VDD VSS sg13g2_decap_8
XFILLER_13_231 VDD VSS sg13g2_decap_8
XFILLER_9_235 VDD VSS sg13g2_decap_8
XFILLER_10_245 VDD VSS sg13g2_decap_8
XFILLER_6_238 VDD VSS sg13g2_decap_8
XFILLER_10_35 VDD VSS sg13g2_decap_8
XFILLER_15_315 VDD VSS sg13g2_decap_8
XFILLER_2_252 VDD VSS sg13g2_decap_8
XFILLER_2_91 VDD VSS sg13g2_decap_8
XFILLER_15_112 VDD VSS sg13g2_decap_8
XFILLER_15_189 VDD VSS sg13g2_decap_8
XFILLER_7_322 VDD VSS sg13g2_decap_8
XFILLER_7_14 VDD VSS sg13g2_decap_8
XFILLER_12_126 VDD VSS sg13g2_decap_8
XFILLER_16_56 VDD VSS sg13g2_decap_8
XFILLER_8_119 VDD VSS sg13g2_decap_8
XFILLER_4_336 VDD VSS sg13g2_decap_8
XFILLER_3_391 VDD VSS sg13g2_fill_1
XFILLER_7_196 VDD VSS sg13g2_decap_8
XFILLER_1_328 VDD VSS sg13g2_fill_1
XFILLER_0_350 VDD VSS sg13g2_decap_8
XFILLER_16_273 VDD VSS sg13g2_decap_8
XFILLER_4_133 VDD VSS sg13g2_decap_8
XFILLER_13_35 VDD VSS sg13g2_decap_8
XFILLER_1_158 VDD VSS sg13g2_decap_8
XFILLER_13_210 VDD VSS sg13g2_decap_8
XFILLER_13_287 VDD VSS sg13g2_decap_8
XFILLER_9_214 VDD VSS sg13g2_decap_8
XFILLER_8_280 VDD VSS sg13g2_decap_8
XFILLER_5_91 VDD VSS sg13g2_decap_8
XFILLER_10_224 VDD VSS sg13g2_decap_8
XFILLER_6_217 VDD VSS sg13g2_decap_8
XFILLER_5_294 VDD VSS sg13g2_decap_8
XFILLER_10_14 VDD VSS sg13g2_decap_8
XFILLER_2_231 VDD VSS sg13g2_decap_8
XFILLER_4_0 VDD VSS sg13g2_decap_8
XFILLER_12_308 VDD VSS sg13g2_decap_8
XFILLER_2_70 VDD VSS sg13g2_decap_8
XFILLER_11_330 VDD VSS sg13g2_decap_8
XFILLER_15_168 VDD VSS sg13g2_decap_8
XFILLER_7_389 VDD VSS sg13g2_fill_2
XFILLER_7_301 VDD VSS sg13g2_decap_8
XFILLER_12_105 VDD VSS sg13g2_decap_8
XFILLER_16_35 VDD VSS sg13g2_decap_8
XFILLER_4_315 VDD VSS sg13g2_decap_8
XFILLER_11_182 VDD VSS sg13g2_decap_8
XFILLER_3_370 VDD VSS sg13g2_decap_8
XFILLER_7_175 VDD VSS sg13g2_decap_8
XFILLER_8_91 VDD VSS sg13g2_decap_8
XFILLER_16_252 VDD VSS sg13g2_decap_8
XFILLER_4_112 VDD VSS sg13g2_decap_8
XFILLER_4_49 VDD VSS sg13g2_decap_8
XFILLER_4_189 VDD VSS sg13g2_decap_8
XFILLER_13_14 VDD VSS sg13g2_decap_8
XFILLER_13_266 VDD VSS sg13g2_decap_8
XFILLER_1_137 VDD VSS sg13g2_decap_8
XFILLER_8_7 VDD VSS sg13g2_decap_8
XFILLER_5_70 VDD VSS sg13g2_decap_8
XFILLER_10_203 VDD VSS sg13g2_decap_8
XFILLER_1_39 VDD VSS sg13g2_decap_8
XFILLER_5_273 VDD VSS sg13g2_decap_8
XFILLER_15_339 VDD VSS sg13g2_decap_8
XFILLER_2_210 VDD VSS sg13g2_decap_8
XFILLER_2_287 VDD VSS sg13g2_decap_8
X_59_ _71_/D _59_/A _59_/B VDD VSS sg13g2_nor2_1
XFILLER_15_147 VDD VSS sg13g2_decap_8
XFILLER_7_49 VDD VSS sg13g2_decap_8
XFILLER_11_91 VDD VSS sg13g2_decap_8
XFILLER_16_14 VDD VSS sg13g2_decap_8
XFILLER_11_161 VDD VSS sg13g2_decap_8
XFILLER_7_154 VDD VSS sg13g2_decap_8
XFILLER_1_319 VDD VSS sg13g2_decap_8
XFILLER_8_70 VDD VSS sg13g2_decap_8
XFILLER_0_385 VDD VSS sg13g2_fill_2
XFILLER_16_231 VDD VSS sg13g2_decap_8
XFILLER_4_168 VDD VSS sg13g2_decap_8
XFILLER_4_28 VDD VSS sg13g2_decap_8
XFILLER_12_0 VDD VSS sg13g2_decap_8
XFILLER_13_245 VDD VSS sg13g2_decap_8
XFILLER_1_116 VDD VSS sg13g2_decap_8
XFILLER_9_249 VDD VSS sg13g2_decap_8
XFILLER_0_182 VDD VSS sg13g2_decap_8
XFILLER_10_259 VDD VSS sg13g2_decap_8
XFILLER_14_91 VDD VSS sg13g2_decap_8
XFILLER_1_18 VDD VSS sg13g2_decap_8
XFILLER_5_252 VDD VSS sg13g2_decap_8
XFILLER_10_49 VDD VSS sg13g2_decap_8
X_75_ _75_/Q _75_/CLK _75_/D _75__14/L_HI VDD VSS sg13g2_dfrbpq_1
XFILLER_2_266 VDD VSS sg13g2_decap_8
XFILLER_14_384 VDD VSS sg13g2_decap_4
X_58_ _58_/X _58_/A _58_/B VDD VSS sg13g2_xor2_1
XFILLER_15_126 VDD VSS sg13g2_decap_8
XFILLER_11_70 VDD VSS sg13g2_decap_8
XFILLER_16_7 VDD VSS sg13g2_decap_8
XFILLER_7_336 VDD VSS sg13g2_decap_8
XFILLER_7_28 VDD VSS sg13g2_decap_8
XFILLER_6_391 VDD VSS sg13g2_fill_1
XFILLER_11_140 VDD VSS sg13g2_decap_8
XFILLER_7_133 VDD VSS sg13g2_decap_8
XFILLER_0_364 VDD VSS sg13g2_decap_8
XFILLER_4_147 VDD VSS sg13g2_decap_8
XFILLER_16_210 VDD VSS sg13g2_decap_8
XFILLER_16_287 VDD VSS sg13g2_decap_8
XFILLER_17_91 VDD VSS sg13g2_decap_8
XFILLER_13_224 VDD VSS sg13g2_decap_8
XFILLER_13_49 VDD VSS sg13g2_decap_8
XFILLER_0_161 VDD VSS sg13g2_decap_8
XFILLER_9_228 VDD VSS sg13g2_decap_8
XFILLER_10_238 VDD VSS sg13g2_decap_8
XFILLER_8_294 VDD VSS sg13g2_decap_8
XFILLER_14_70 VDD VSS sg13g2_decap_8
XFILLER_5_231 VDD VSS sg13g2_decap_8
XFILLER_10_28 VDD VSS sg13g2_decap_8
X_74_ _74_/Q _75_/CLK _74_/D _74__15/L_HI VDD VSS sg13g2_dfrbpq_1
XFILLER_15_308 VDD VSS sg13g2_decap_8
XFILLER_2_245 VDD VSS sg13g2_decap_8
XFILLER_2_84 VDD VSS sg13g2_decap_8
XFILLER_15_105 VDD VSS sg13g2_decap_8
X_57_ _58_/B _57_/A _70_/Q _57_/C _57_/D VDD VSS sg13g2_nand4_1
XFILLER_11_322 VDD VSS sg13g2_decap_4
XFILLER_11_344 VDD VSS sg13g2_decap_4
XFILLER_11_355 VDD VSS sg13g2_fill_2
XFILLER_2_0 VDD VSS sg13g2_decap_8
XFILLER_7_315 VDD VSS sg13g2_decap_8
XFILLER_12_119 VDD VSS sg13g2_decap_8
XFILLER_14_182 VDD VSS sg13g2_decap_8
XFILLER_16_49 VDD VSS sg13g2_decap_8
XFILLER_11_196 VDD VSS sg13g2_decap_8
XFILLER_7_112 VDD VSS sg13g2_decap_8
XFILLER_4_329 VDD VSS sg13g2_decap_8
XFILLER_3_351 VDD VSS sg13g2_fill_2
XFILLER_3_384 VDD VSS sg13g2_decap_8
XFILLER_7_189 VDD VSS sg13g2_decap_8
XFILLER_4_126 VDD VSS sg13g2_decap_8
XFILLER_0_343 VDD VSS sg13g2_decap_8
XFILLER_0_387 VDD VSS sg13g2_fill_1
XFILLER_16_266 VDD VSS sg13g2_decap_8
XFILLER_17_70 VDD VSS sg13g2_decap_8
XFILLER_13_28 VDD VSS sg13g2_decap_8
XFILLER_0_140 VDD VSS sg13g2_decap_8
XFILLER_13_203 VDD VSS sg13g2_decap_8
XFILLER_9_207 VDD VSS sg13g2_decap_8
XFILLER_12_280 VDD VSS sg13g2_decap_8
XFILLER_8_273 VDD VSS sg13g2_decap_8
XFILLER_5_84 VDD VSS sg13g2_decap_8
XFILLER_10_217 VDD VSS sg13g2_decap_8
XFILLER_6_7 VDD VSS sg13g2_decap_8
XFILLER_17_372 VDD VSS sg13g2_decap_8
XFILLER_17_383 VDD VSS sg13g2_fill_1
X_73_ _73_/Q _75_/CLK _73_/D _73__11/L_HI VDD VSS sg13g2_dfrbpq_1
XFILLER_5_287 VDD VSS sg13g2_decap_8
XFILLER_5_210 VDD VSS sg13g2_decap_8
XFILLER_2_224 VDD VSS sg13g2_decap_8
XFILLER_2_63 VDD VSS sg13g2_decap_8
X_56_ _70_/D _59_/A _56_/B VDD VSS sg13g2_nor2_1
XFILLER_11_301 VDD VSS sg13g2_decap_8
XFILLER_11_389 VDD VSS sg13g2_fill_2
XFILLER_14_161 VDD VSS sg13g2_decap_8
XFILLER_16_28 VDD VSS sg13g2_decap_8
X_39_ _66_/B _39_/A VDD VSS sg13g2_buf_4
X_73__11 _73__11/L_HI VDD VSS sg13g2_tiehi
XFILLER_4_308 VDD VSS sg13g2_decap_8
XFILLER_11_175 VDD VSS sg13g2_decap_8
XFILLER_3_330 VDD VSS sg13g2_decap_8
XFILLER_7_168 VDD VSS sg13g2_decap_8
XFILLER_4_105 VDD VSS sg13g2_decap_8
XFILLER_8_84 VDD VSS sg13g2_decap_8
XFILLER_0_322 VDD VSS sg13g2_decap_8
XFILLER_16_245 VDD VSS sg13g2_decap_8
XFILLER_3_182 VDD VSS sg13g2_decap_8
XFILLER_0_196 VDD VSS sg13g2_decap_8
XFILLER_13_259 VDD VSS sg13g2_decap_8
XFILLER_10_0 VDD VSS sg13g2_decap_8
XFILLER_8_252 VDD VSS sg13g2_decap_8
XFILLER_5_63 VDD VSS sg13g2_decap_8
XFILLER_17_351 VDD VSS sg13g2_decap_8
X_72_ _72_/Q _75_/CLK _72_/D _72__17/L_HI VDD VSS sg13g2_dfrbpq_1
XFILLER_5_266 VDD VSS sg13g2_decap_8
XFILLER_2_203 VDD VSS sg13g2_decap_8
XFILLER_1_291 VDD VSS sg13g2_decap_8
XFILLER_2_42 VDD VSS sg13g2_decap_8
X_55_ _56_/B _55_/A _66_/B VDD VSS sg13g2_xor2_1
XFILLER_11_84 VDD VSS sg13g2_decap_8
XFILLER_14_140 VDD VSS sg13g2_decap_8
X_38_ _39_/A _57_/A _57_/C _57_/D VDD VSS sg13g2_nand3_1
XFILLER_11_154 VDD VSS sg13g2_decap_8
XFILLER_14_7 VDD VSS sg13g2_decap_8
XFILLER_7_147 VDD VSS sg13g2_decap_8
XFILLER_8_63 VDD VSS sg13g2_decap_8
XFILLER_0_301 VDD VSS sg13g2_decap_8
XFILLER_0_378 VDD VSS sg13g2_decap_8
XFILLER_16_224 VDD VSS sg13g2_decap_8
XFILLER_3_161 VDD VSS sg13g2_decap_8
XFILLER_13_238 VDD VSS sg13g2_decap_8
XFILLER_1_109 VDD VSS sg13g2_decap_8
XFILLER_0_175 VDD VSS sg13g2_decap_8
XFILLER_8_231 VDD VSS sg13g2_decap_8
XFILLER_5_42 VDD VSS sg13g2_decap_8
XFILLER_14_84 VDD VSS sg13g2_decap_8
X_71_ _71_/Q _71_/CLK _71_/D _71__13/L_HI VDD VSS sg13g2_dfrbpq_1
XFILLER_5_245 VDD VSS sg13g2_decap_8
XFILLER_14_322 VDD VSS sg13g2_decap_8
XFILLER_2_259 VDD VSS sg13g2_decap_8
XFILLER_17_182 VDD VSS sg13g2_decap_8
XFILLER_1_270 VDD VSS sg13g2_decap_8
XFILLER_2_21 VDD VSS sg13g2_decap_8
XFILLER_2_98 VDD VSS sg13g2_decap_8
X_54_ _69_/D _59_/A _54_/B VDD VSS sg13g2_nor2_1
XFILLER_15_119 VDD VSS sg13g2_decap_8
XFILLER_9_381 VDD VSS sg13g2_decap_8
XFILLER_7_329 VDD VSS sg13g2_decap_8
XFILLER_11_63 VDD VSS sg13g2_decap_8
XFILLER_14_196 VDD VSS sg13g2_decap_8
XFILLER_0_0 VDD VSS sg13g2_decap_8
XFILLER_11_133 VDD VSS sg13g2_decap_8
XFILLER_7_126 VDD VSS sg13g2_decap_8
X_70__16 _70__16/L_HI VDD VSS sg13g2_tiehi
XFILLER_8_42 VDD VSS sg13g2_decap_8
XFILLER_0_357 VDD VSS sg13g2_decap_8
XFILLER_16_203 VDD VSS sg13g2_decap_8
XFILLER_17_84 VDD VSS sg13g2_decap_8
XFILLER_15_280 VDD VSS sg13g2_decap_8
XFILLER_3_140 VDD VSS sg13g2_decap_8
XFILLER_13_217 VDD VSS sg13g2_decap_8
XFILLER_0_154 VDD VSS sg13g2_decap_8
XFILLER_12_294 VDD VSS sg13g2_decap_8
XFILLER_8_287 VDD VSS sg13g2_decap_8
XFILLER_8_210 VDD VSS sg13g2_decap_8
XFILLER_5_21 VDD VSS sg13g2_decap_8
XFILLER_5_98 VDD VSS sg13g2_decap_8
XFILLER_14_63 VDD VSS sg13g2_decap_8
XFILLER_5_224 VDD VSS sg13g2_decap_8
X_70_ _70_/Q _71_/CLK _70_/D _70__16/L_HI VDD VSS sg13g2_dfrbpq_1
XFILLER_2_238 VDD VSS sg13g2_decap_8
XFILLER_4_7 VDD VSS sg13g2_decap_8
XFILLER_14_301 VDD VSS sg13g2_decap_8
XFILLER_14_345 VDD VSS sg13g2_fill_1
XFILLER_17_161 VDD VSS sg13g2_decap_8
XFILLER_2_77 VDD VSS sg13g2_decap_8
X_53_ _53_/X _57_/C _53_/B VDD VSS sg13g2_xor2_1
XFILLER_11_315 VDD VSS sg13g2_decap_8
XFILLER_11_337 VDD VSS sg13g2_decap_8
XFILLER_11_42 VDD VSS sg13g2_decap_8
XFILLER_14_175 VDD VSS sg13g2_decap_8
XFILLER_7_308 VDD VSS sg13g2_decap_8
XFILLER_11_112 VDD VSS sg13g2_decap_8
XFILLER_11_189 VDD VSS sg13g2_decap_8
XFILLER_3_322 VDD VSS sg13g2_decap_4
XFILLER_3_344 VDD VSS sg13g2_decap_8
XFILLER_3_377 VDD VSS sg13g2_decap_8
XFILLER_7_105 VDD VSS sg13g2_decap_8
XFILLER_8_98 VDD VSS sg13g2_decap_8
XFILLER_8_21 VDD VSS sg13g2_decap_8
XFILLER_6_182 VDD VSS sg13g2_decap_8
XFILLER_0_336 VDD VSS sg13g2_decap_8
XFILLER_4_119 VDD VSS sg13g2_decap_8
XFILLER_16_259 VDD VSS sg13g2_decap_8
XFILLER_17_63 VDD VSS sg13g2_decap_8
XFILLER_3_196 VDD VSS sg13g2_decap_8
XFILLER_0_133 VDD VSS sg13g2_decap_8
XFILLER_12_273 VDD VSS sg13g2_decap_8
XFILLER_8_266 VDD VSS sg13g2_decap_8
XFILLER_5_77 VDD VSS sg13g2_decap_8
XFILLER_14_42 VDD VSS sg13g2_decap_8
XFILLER_5_203 VDD VSS sg13g2_decap_8
XFILLER_17_365 VDD VSS sg13g2_decap_8
XFILLER_4_280 VDD VSS sg13g2_decap_8
XFILLER_2_217 VDD VSS sg13g2_decap_8
XFILLER_2_56 VDD VSS sg13g2_decap_8
X_52_ _53_/B _57_/A _68_/Q VDD VSS sg13g2_nand2_1
XFILLER_17_140 VDD VSS sg13g2_decap_8
XFILLER_11_21 VDD VSS sg13g2_decap_8
XFILLER_11_98 VDD VSS sg13g2_decap_8
XFILLER_14_154 VDD VSS sg13g2_decap_8
XFILLER_10_382 VDD VSS sg13g2_decap_4
XFILLER_11_168 VDD VSS sg13g2_decap_8
XFILLER_3_301 VDD VSS sg13g2_decap_8
XFILLER_8_77 VDD VSS sg13g2_decap_8
XFILLER_6_161 VDD VSS sg13g2_decap_8
XFILLER_0_315 VDD VSS sg13g2_decap_8
XFILLER_16_238 VDD VSS sg13g2_decap_8
XFILLER_17_42 VDD VSS sg13g2_decap_8
XFILLER_3_175 VDD VSS sg13g2_decap_8
XFILLER_12_7 VDD VSS sg13g2_decap_8
XFILLER_0_112 VDD VSS sg13g2_decap_8
XFILLER_0_189 VDD VSS sg13g2_decap_8
XFILLER_12_252 VDD VSS sg13g2_decap_8
XFILLER_8_245 VDD VSS sg13g2_decap_8
XFILLER_5_56 VDD VSS sg13g2_decap_8
XFILLER_14_21 VDD VSS sg13g2_decap_8
XFILLER_14_98 VDD VSS sg13g2_decap_8
XFILLER_17_322 VDD VSS sg13g2_decap_8
XFILLER_17_344 VDD VSS sg13g2_decap_8
XFILLER_5_259 VDD VSS sg13g2_decap_8
XFILLER_14_358 VDD VSS sg13g2_fill_1
XFILLER_13_380 VDD VSS sg13g2_decap_8
XFILLER_13_391 VDD VSS sg13g2_fill_1
XFILLER_17_196 VDD VSS sg13g2_decap_8
XFILLER_1_284 VDD VSS sg13g2_decap_8
XFILLER_2_35 VDD VSS sg13g2_decap_8
XFILLER_9_340 VDD VSS sg13g2_fill_2
X_51_ _68_/D _59_/A _51_/B VDD VSS sg13g2_nor2_1
XFILLER_11_77 VDD VSS sg13g2_decap_8
XFILLER_14_133 VDD VSS sg13g2_decap_8
XFILLER_11_147 VDD VSS sg13g2_decap_8
XFILLER_8_56 VDD VSS sg13g2_decap_8
XFILLER_6_140 VDD VSS sg13g2_decap_8
XFILLER_16_217 VDD VSS sg13g2_decap_8
XFILLER_17_21 VDD VSS sg13g2_decap_8
XFILLER_17_98 VDD VSS sg13g2_decap_8
XFILLER_3_154 VDD VSS sg13g2_decap_8
XFILLER_15_294 VDD VSS sg13g2_decap_8
XFILLER_0_168 VDD VSS sg13g2_decap_8
XFILLER_12_231 VDD VSS sg13g2_decap_8
XFILLER_8_224 VDD VSS sg13g2_decap_8
XFILLER_5_35 VDD VSS sg13g2_decap_8
XFILLER_14_77 VDD VSS sg13g2_decap_8
XFILLER_17_301 VDD VSS sg13g2_decap_8
XFILLER_5_238 VDD VSS sg13g2_decap_8
XFILLER_14_315 VDD VSS sg13g2_decap_8
XFILLER_17_175 VDD VSS sg13g2_decap_8
XFILLER_1_263 VDD VSS sg13g2_decap_8
XFILLER_2_14 VDD VSS sg13g2_decap_8
XFILLER_9_330 VDD VSS sg13g2_fill_1
X_50_ _51_/B _57_/A _57_/D VDD VSS sg13g2_xnor2_1
XFILLER_11_56 VDD VSS sg13g2_decap_8
XFILLER_2_7 VDD VSS sg13g2_decap_8
XFILLER_14_112 VDD VSS sg13g2_decap_8
XFILLER_14_189 VDD VSS sg13g2_decap_8
XFILLER_6_322 VDD VSS sg13g2_decap_8
XFILLER_9_193 VDD VSS sg13g2_decap_8
XFILLER_11_126 VDD VSS sg13g2_decap_8
XFILLER_7_119 VDD VSS sg13g2_decap_8
XFILLER_8_35 VDD VSS sg13g2_decap_8
XFILLER_6_196 VDD VSS sg13g2_decap_8
XFILLER_17_77 VDD VSS sg13g2_decap_8
XFILLER_15_273 VDD VSS sg13g2_decap_8
XFILLER_3_133 VDD VSS sg13g2_decap_8
XFILLER_0_91 VDD VSS sg13g2_decap_8
XFILLER_0_147 VDD VSS sg13g2_decap_8
XFILLER_12_210 VDD VSS sg13g2_decap_8
XFILLER_12_287 VDD VSS sg13g2_decap_8
XFILLER_8_203 VDD VSS sg13g2_decap_8
XFILLER_5_14 VDD VSS sg13g2_decap_8
XFILLER_7_280 VDD VSS sg13g2_decap_8
XFILLER_14_56 VDD VSS sg13g2_decap_8
XFILLER_5_217 VDD VSS sg13g2_decap_8
XFILLER_17_379 VDD VSS sg13g2_decap_4
XFILLER_4_294 VDD VSS sg13g2_decap_8
XFILLER_14_338 VDD VSS sg13g2_decap_8
XFILLER_17_154 VDD VSS sg13g2_decap_8
XFILLER_1_242 VDD VSS sg13g2_decap_8
XFILLER_9_342 VDD VSS sg13g2_fill_1
XFILLER_11_308 VDD VSS sg13g2_decap_8
XFILLER_11_35 VDD VSS sg13g2_decap_8
XFILLER_14_168 VDD VSS sg13g2_decap_8
XFILLER_6_378 VDD VSS sg13g2_decap_4
XFILLER_6_301 VDD VSS sg13g2_decap_8
XFILLER_9_172 VDD VSS sg13g2_decap_8
XFILLER_11_105 VDD VSS sg13g2_decap_8
XFILLER_3_315 VDD VSS sg13g2_decap_8
XFILLER_3_337 VDD VSS sg13g2_decap_8
XFILLER_3_91 VDD VSS sg13g2_decap_8
XFILLER_10_182 VDD VSS sg13g2_decap_8
XFILLER_8_14 VDD VSS sg13g2_decap_8
XFILLER_6_175 VDD VSS sg13g2_decap_8
XFILLER_0_329 VDD VSS sg13g2_decap_8
XFILLER_17_56 VDD VSS sg13g2_decap_8
XFILLER_15_252 VDD VSS sg13g2_decap_8
XFILLER_3_112 VDD VSS sg13g2_decap_8
XFILLER_3_189 VDD VSS sg13g2_decap_8
XFILLER_0_70 VDD VSS sg13g2_decap_8
XFILLER_17_0 VDD VSS sg13g2_decap_8
XFILLER_0_126 VDD VSS sg13g2_decap_8
XFILLER_12_266 VDD VSS sg13g2_decap_8
XFILLER_8_259 VDD VSS sg13g2_decap_8
XFILLER_10_7 VDD VSS sg13g2_decap_8
XFILLER_14_35 VDD VSS sg13g2_decap_8
XFILLER_17_358 VDD VSS sg13g2_decap_8
XFILLER_4_273 VDD VSS sg13g2_decap_8
XFILLER_16_391 VDD VSS sg13g2_fill_1
XFILLER_6_91 VDD VSS sg13g2_decap_8
XFILLER_17_133 VDD VSS sg13g2_decap_8
XFILLER_1_221 VDD VSS sg13g2_decap_8
XFILLER_1_298 VDD VSS sg13g2_decap_8
XFILLER_2_49 VDD VSS sg13g2_decap_8
XFILLER_10_375 VDD VSS sg13g2_decap_8
XFILLER_10_386 VDD VSS sg13g2_fill_2
XFILLER_11_14 VDD VSS sg13g2_decap_8
XFILLER_14_147 VDD VSS sg13g2_decap_8
XFILLER_9_151 VDD VSS sg13g2_decap_8
XFILLER_3_70 VDD VSS sg13g2_decap_8
XFILLER_10_161 VDD VSS sg13g2_decap_8
XFILLER_6_154 VDD VSS sg13g2_decap_8
XFILLER_0_308 VDD VSS sg13g2_decap_8
XFILLER_17_35 VDD VSS sg13g2_decap_8
XFILLER_3_168 VDD VSS sg13g2_decap_8
XFILLER_15_231 VDD VSS sg13g2_decap_8
XFILLER_0_105 VDD VSS sg13g2_decap_8
XFILLER_12_245 VDD VSS sg13g2_decap_8
XFILLER_8_238 VDD VSS sg13g2_decap_8
XFILLER_5_49 VDD VSS sg13g2_decap_8
XFILLER_14_14 VDD VSS sg13g2_decap_8
XFILLER_17_315 VDD VSS sg13g2_decap_8
XFILLER_4_252 VDD VSS sg13g2_decap_8
XFILLER_6_70 VDD VSS sg13g2_decap_8
XFILLER_17_112 VDD VSS sg13g2_decap_8
XFILLER_1_200 VDD VSS sg13g2_decap_8
XFILLER_1_277 VDD VSS sg13g2_decap_8
XFILLER_2_28 VDD VSS sg13g2_decap_8
XFILLER_17_189 VDD VSS sg13g2_decap_8
XFILLER_9_388 VDD VSS sg13g2_decap_4
XFILLER_14_126 VDD VSS sg13g2_decap_8
XFILLER_9_130 VDD VSS sg13g2_decap_8
XFILLER_7_0 VDD VSS sg13g2_decap_8
XFILLER_6_336 VDD VSS sg13g2_fill_2
XFILLER_0_7 VDD VSS sg13g2_decap_8
XFILLER_10_140 VDD VSS sg13g2_decap_8
XFILLER_12_91 VDD VSS sg13g2_decap_8
XFILLER_8_49 VDD VSS sg13g2_decap_8
XFILLER_6_133 VDD VSS sg13g2_decap_8
XFILLER_17_14 VDD VSS sg13g2_decap_8
XFILLER_3_147 VDD VSS sg13g2_decap_8
XFILLER_15_210 VDD VSS sg13g2_decap_8
XFILLER_15_287 VDD VSS sg13g2_decap_8
XFILLER_9_81 VDD VSS sg13g2_decap_8
XFILLER_12_224 VDD VSS sg13g2_decap_8
XFILLER_8_217 VDD VSS sg13g2_decap_8
XFILLER_5_28 VDD VSS sg13g2_decap_8
XFILLER_7_294 VDD VSS sg13g2_decap_8
XFILLER_4_231 VDD VSS sg13g2_decap_8
XFILLER_14_308 VDD VSS sg13g2_decap_8
XFILLER_1_256 VDD VSS sg13g2_decap_8
XFILLER_9_4 VDD VSS sg13g2_decap_8
XFILLER_15_91 VDD VSS sg13g2_decap_8
XFILLER_17_168 VDD VSS sg13g2_decap_8
XFILLER_9_312 VDD VSS sg13g2_decap_8
XFILLER_11_49 VDD VSS sg13g2_decap_8
XFILLER_14_105 VDD VSS sg13g2_decap_8
XFILLER_6_315 VDD VSS sg13g2_decap_8
XFILLER_11_119 VDD VSS sg13g2_decap_8
XFILLER_13_182 VDD VSS sg13g2_decap_8
XFILLER_9_186 VDD VSS sg13g2_decap_8
XFILLER_8_28 VDD VSS sg13g2_decap_8
XFILLER_10_196 VDD VSS sg13g2_decap_8
XFILLER_12_70 VDD VSS sg13g2_decap_8
XFILLER_6_189 VDD VSS sg13g2_decap_8
XFILLER_6_112 VDD VSS sg13g2_decap_8
XFILLER_3_126 VDD VSS sg13g2_decap_8
XFILLER_15_266 VDD VSS sg13g2_decap_8
XFILLER_0_84 VDD VSS sg13g2_decap_8
XFILLER_9_60 VDD VSS sg13g2_decap_8
XFILLER_12_203 VDD VSS sg13g2_decap_8
XFILLER_11_280 VDD VSS sg13g2_decap_8
XFILLER_15_0 VDD VSS sg13g2_decap_8
XFILLER_7_273 VDD VSS sg13g2_decap_8
XFILLER_14_49 VDD VSS sg13g2_decap_8
XFILLER_16_372 VDD VSS sg13g2_decap_4
XFILLER_4_287 VDD VSS sg13g2_decap_8
XFILLER_4_210 VDD VSS sg13g2_decap_8
XFILLER_15_70 VDD VSS sg13g2_decap_8
XFILLER_17_147 VDD VSS sg13g2_decap_8
XFILLER_1_235 VDD VSS sg13g2_decap_8
XFILLER_11_28 VDD VSS sg13g2_decap_8
XFILLER_10_301 VDD VSS sg13g2_decap_8
XFILLER_13_161 VDD VSS sg13g2_decap_8
XFILLER_3_84 VDD VSS sg13g2_decap_8
XFILLER_9_165 VDD VSS sg13g2_decap_8
XFILLER_3_308 VDD VSS sg13g2_decap_8
XFILLER_10_175 VDD VSS sg13g2_decap_8
XFILLER_6_168 VDD VSS sg13g2_decap_8
XFILLER_17_49 VDD VSS sg13g2_decap_8
XFILLER_15_245 VDD VSS sg13g2_decap_8
XFILLER_3_105 VDD VSS sg13g2_decap_8
XFILLER_0_63 VDD VSS sg13g2_decap_8
XFILLER_2_182 VDD VSS sg13g2_decap_8
XFILLER_0_119 VDD VSS sg13g2_decap_8
XFILLER_12_259 VDD VSS sg13g2_decap_8
XFILLER_7_252 VDD VSS sg13g2_decap_8
XFILLER_14_28 VDD VSS sg13g2_decap_8
XFILLER_17_329 VDD VSS sg13g2_fill_2
XFILLER_4_266 VDD VSS sg13g2_decap_8
XFILLER_6_84 VDD VSS sg13g2_decap_8
XFILLER_13_343 VDD VSS sg13g2_decap_8
XFILLER_13_387 VDD VSS sg13g2_decap_4
XFILLER_17_126 VDD VSS sg13g2_decap_8
XFILLER_1_214 VDD VSS sg13g2_decap_8
XFILLER_0_280 VDD VSS sg13g2_decap_8
XFILLER_13_140 VDD VSS sg13g2_decap_8
XFILLER_3_63 VDD VSS sg13g2_decap_8
XFILLER_9_144 VDD VSS sg13g2_decap_8
XFILLER_10_154 VDD VSS sg13g2_decap_8
XFILLER_6_147 VDD VSS sg13g2_decap_8
XFILLER_5_0 VDD VSS sg13g2_decap_8
XFILLER_17_28 VDD VSS sg13g2_decap_8
XFILLER_15_224 VDD VSS sg13g2_decap_8
XFILLER_0_42 VDD VSS sg13g2_decap_8
XFILLER_2_161 VDD VSS sg13g2_decap_8
XFILLER_9_95 VDD VSS sg13g2_decap_8
XFILLER_12_238 VDD VSS sg13g2_decap_8
XFILLER_7_231 VDD VSS sg13g2_decap_8
XFILLER_17_308 VDD VSS sg13g2_decap_8
XFILLER_4_245 VDD VSS sg13g2_decap_8
XFILLER_6_63 VDD VSS sg13g2_decap_8
XFILLER_13_322 VDD VSS sg13g2_decap_8
XFILLER_17_105 VDD VSS sg13g2_decap_8
XFILLER_16_182 VDD VSS sg13g2_decap_8
XFILLER_9_326 VDD VSS sg13g2_decap_4
Xoutput3 counter_value_o[0] _68_/Q VDD VSS sg13g2_buf_1
XFILLER_14_119 VDD VSS sg13g2_decap_8
XFILLER_8_381 VDD VSS sg13g2_decap_8
XFILLER_6_329 VDD VSS sg13g2_decap_8
XFILLER_13_196 VDD VSS sg13g2_decap_8
XFILLER_9_123 VDD VSS sg13g2_decap_8
XFILLER_3_42 VDD VSS sg13g2_decap_8
XFILLER_10_133 VDD VSS sg13g2_decap_8
XFILLER_12_84 VDD VSS sg13g2_decap_8
XFILLER_6_126 VDD VSS sg13g2_decap_8
XFILLER_15_203 VDD VSS sg13g2_decap_8
X_69_ _69_/Q _71_/CLK _69_/D _69__18/L_HI VDD VSS sg13g2_dfrbpq_1
XFILLER_0_21 VDD VSS sg13g2_decap_8
XFILLER_0_98 VDD VSS sg13g2_decap_8
XFILLER_2_140 VDD VSS sg13g2_decap_8
XFILLER_12_217 VDD VSS sg13g2_decap_8
XFILLER_14_280 VDD VSS sg13g2_decap_8
XFILLER_9_74 VDD VSS sg13g2_decap_8
XFILLER_11_294 VDD VSS sg13g2_decap_8
XFILLER_7_210 VDD VSS sg13g2_decap_8
XFILLER_7_287 VDD VSS sg13g2_decap_8
XFILLER_4_224 VDD VSS sg13g2_decap_8
XFILLER_16_331 VDD VSS sg13g2_fill_1
XFILLER_6_42 VDD VSS sg13g2_decap_8
XFILLER_13_0 VDD VSS sg13g2_decap_8
XFILLER_1_249 VDD VSS sg13g2_decap_8
XFILLER_13_301 VDD VSS sg13g2_decap_8
XFILLER_15_84 VDD VSS sg13g2_decap_8
XFILLER_9_305 VDD VSS sg13g2_decap_8
Xoutput4 counter_value_o[1] _69_/Q VDD VSS sg13g2_buf_1
XFILLER_16_161 VDD VSS sg13g2_decap_8
XFILLER_8_360 VDD VSS sg13g2_fill_1
XFILLER_10_315 VDD VSS sg13g2_decap_4
XFILLER_13_175 VDD VSS sg13g2_decap_8
XFILLER_9_102 VDD VSS sg13g2_decap_8
XFILLER_6_308 VDD VSS sg13g2_decap_8
XFILLER_3_21 VDD VSS sg13g2_decap_8
XFILLER_3_98 VDD VSS sg13g2_decap_8
XFILLER_9_179 VDD VSS sg13g2_decap_8
XFILLER_5_385 VDD VSS sg13g2_fill_2
XFILLER_10_112 VDD VSS sg13g2_decap_8
XFILLER_10_189 VDD VSS sg13g2_decap_8
XFILLER_12_63 VDD VSS sg13g2_decap_8
XFILLER_6_105 VDD VSS sg13g2_decap_8
XFILLER_2_388 VDD VSS sg13g2_decap_4
XFILLER_5_182 VDD VSS sg13g2_decap_8
XFILLER_3_119 VDD VSS sg13g2_decap_8
X_68_ _68_/Q _71_/CLK _68_/D _68__12/L_HI VDD VSS sg13g2_dfrbpq_1
XFILLER_15_259 VDD VSS sg13g2_decap_8
XFILLER_17_7 VDD VSS sg13g2_decap_8
XFILLER_2_196 VDD VSS sg13g2_decap_8
XFILLER_0_77 VDD VSS sg13g2_decap_8
XFILLER_9_53 VDD VSS sg13g2_decap_8
XFILLER_11_273 VDD VSS sg13g2_decap_8
XFILLER_7_266 VDD VSS sg13g2_decap_8
XFILLER_4_203 VDD VSS sg13g2_decap_8
XFILLER_16_376 VDD VSS sg13g2_fill_2
XFILLER_16_387 VDD VSS sg13g2_decap_4
XFILLER_6_98 VDD VSS sg13g2_decap_8
XFILLER_6_21 VDD VSS sg13g2_decap_8
XFILLER_1_228 VDD VSS sg13g2_decap_8
XFILLER_3_280 VDD VSS sg13g2_decap_8
Xclkbuf_0_clock_i clkbuf_0_clock_i/X clock_i VDD VSS sg13g2_buf_16
XFILLER_0_294 VDD VSS sg13g2_decap_8
XFILLER_15_63 VDD VSS sg13g2_decap_8
Xoutput5 counter_value_o[2] _70_/Q VDD VSS sg13g2_buf_1
XFILLER_12_390 VDD VSS sg13g2_fill_2
XFILLER_16_140 VDD VSS sg13g2_decap_8
XFILLER_13_154 VDD VSS sg13g2_decap_8
XFILLER_3_77 VDD VSS sg13g2_decap_8
XFILLER_9_158 VDD VSS sg13g2_decap_8
XFILLER_10_168 VDD VSS sg13g2_decap_8
XFILLER_12_42 VDD VSS sg13g2_decap_8
XFILLER_2_301 VDD VSS sg13g2_decap_8
X_67_ _67_/Y _67_/A1 _66_/X _59_/A VDD VSS sg13g2_a21oi_1
XFILLER_5_161 VDD VSS sg13g2_decap_8
XFILLER_15_238 VDD VSS sg13g2_decap_8
XFILLER_2_175 VDD VSS sg13g2_decap_8
XFILLER_3_0 VDD VSS sg13g2_decap_8
XFILLER_0_56 VDD VSS sg13g2_decap_8
XFILLER_9_32 VDD VSS sg13g2_decap_8
XFILLER_11_252 VDD VSS sg13g2_decap_8
XFILLER_7_245 VDD VSS sg13g2_decap_8
XFILLER_16_322 VDD VSS sg13g2_decap_8
XFILLER_4_259 VDD VSS sg13g2_decap_8
XFILLER_6_77 VDD VSS sg13g2_decap_8
XFILLER_13_336 VDD VSS sg13g2_decap_8
XFILLER_15_42 VDD VSS sg13g2_decap_8
XFILLER_17_119 VDD VSS sg13g2_decap_8
XFILLER_1_207 VDD VSS sg13g2_decap_8
Xoutput6 counter_value_o[3] _71_/Q VDD VSS sg13g2_buf_1
XFILLER_0_273 VDD VSS sg13g2_decap_8
XFILLER_16_196 VDD VSS sg13g2_decap_8
.ends

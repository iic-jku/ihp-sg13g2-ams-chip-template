* PEX produced on Sun Aug 23 03:51:07 PM CEST 2026 using /foss/tools/sak/sak-pex.sh with m=3 and s=1 (extresist threshold=10000 mOhm, minres=1000 mOhm, mindelay=1 ps)
* NGSPICE file created from counter_top_pex.ext - technology: ihp-sg13g2

.subckt counter_top_pex VDD VSS clock_i reset_n_i enable_i counter_value_o[0]
+ counter_value_o[1] counter_value_o[2] counter_value_o[3] counter_value_o[4]
+ counter_value_o[5] counter_value_o[6] counter_value_o[7]
X0 VSS.t402 VDD VSS.t344 VSS.t401 sg13_lv_nmos ad=0.1428p pd=1.52u as=0 ps=0 w=0.42u l=1u
X1 VDD a_19984_13942# a_19929_14037# VDD sg13_lv_pmos ad=2.75157p pd=17.885u as=93.45f ps=0.865u w=0.42u l=0.13u
X2 VDD VSS.t1653 VDD VDD sg13_lv_pmos ad=0.19p pd=1.38u as=3.17921n ps=0.0124 w=1u l=1u
X3 VDD clock_i a_16078_14484# VDD sg13_lv_pmos ad=0.2128p pd=1.5u as=0.2128p ps=1.5u w=1.12u l=0.13u
X4 VDD VSS.t210 VDD VDD sg13_lv_pmos ad=0.34p pd=2.68u as=0 ps=0 w=1u l=1u
X5 VDD a_12335_14845# a_12592_14726# VDD sg13_lv_pmos ad=2.75157p pd=17.885u as=79.8f ps=0.8u w=0.42u l=0.13u
X6 VSS.t1251 VDD VSS.t1252 VSS.t305 sg13_lv_nmos ad=79.8f pd=0.8u as=0 ps=0 w=0.42u l=1u
X7 VSS.t2320 VDD VSS.t2319 VSS.t2318 sg13_lv_nmos ad=0.1428p pd=1.52u as=0 ps=0 w=0.42u l=1u
X8 VSS.t1933 VDD VSS.t1935 VSS.t1934 sg13_lv_nmos ad=79.8f pd=0.8u as=0 ps=0 w=0.42u l=1u
X9 a_2684_15532# sg13g2_dlygate4sd3_1_2.X VDD VDD sg13_lv_pmos ad=0.2128p pd=1.5u as=0.2128p ps=1.5u w=1.12u l=0.13u
X10 VDD VSS.t71 VDD VDD sg13_lv_pmos ad=0.34p pd=2.68u as=0 ps=0 w=1u l=1u
X11 VDD VSS.t1379 VDD VDD sg13_lv_pmos ad=0.34p pd=2.68u as=0 ps=0 w=1u l=1u
X12 sg13g2_dfrbpq_1_7.CLK a_19630_15238# VDD VDD sg13_lv_pmos ad=0.2128p pd=1.5u as=0.2128p ps=1.5u w=1.12u l=0.13u
X13 VSS.t52 sg13g2_nor2b_1_0.A sg13g2_nor2b_1_0.Y VSS.t3287 sg13_lv_nmos ad=0.2516p pd=2.16u as=0.1406p ps=1.12u w=0.74u l=0.13u
X14 VDD VSS.t1251 VDD VDD sg13_lv_pmos ad=0.19p pd=1.38u as=0 ps=0 w=1u l=1u
X15 VSS.t2395 VDD VSS.t2394 VSS.t2393 sg13_lv_nmos ad=0.1428p pd=1.52u as=0 ps=0 w=0.42u l=1u
X16 VSS.t1681 VDD VSS.t1680 VSS.t1679 sg13_lv_nmos ad=0.1428p pd=1.52u as=0 ps=0 w=0.42u l=1u
X17 VSS.t3210 VDD VSS.t3209 VSS.t3208 sg13_lv_nmos ad=0.1428p pd=1.52u as=0 ps=0 w=0.42u l=1u
X18 VDD VSS.t2354 VDD VDD sg13_lv_pmos ad=0.34p pd=2.68u as=0 ps=0 w=1u l=1u
X19 a_24669_14854# sg13g2_nor4_2_0.Y VSS.t25 VSS.t7 sg13_lv_nmos ad=0.13135p pd=1.095u as=0.18945p ps=1.27u w=0.74u l=0.13u
X20 VSS.t969 VDD VSS.t968 VSS.t967 sg13_lv_nmos ad=0.1428p pd=1.52u as=0 ps=0 w=0.42u l=1u
X21 VSS.t2760 VDD VSS.t2761 VSS.t2710 sg13_lv_nmos ad=79.8f pd=0.8u as=0 ps=0 w=0.42u l=1u
X22 a_25094_15238# a_24824_15238# VSS.t104 VSS.t3 sg13_lv_nmos ad=0.1428p pd=1.52u as=79.8f ps=0.8u w=0.42u l=0.5u
X23 VDD a_26085_14495# a_26187_14495# VDD sg13_lv_pmos ad=2.75157p pd=17.885u as=0.3864p ps=2.93u w=1.12u l=0.13u
X24 VSS.t1014 VDD VSS.t1013 VSS.t1012 sg13_lv_nmos ad=0.1428p pd=1.52u as=0 ps=0 w=0.42u l=1u
X25 VSS.t889 VDD VSS.t891 VSS.t890 sg13_lv_nmos ad=79.8f pd=0.8u as=0 ps=0 w=0.42u l=1u
X26 VSS.t1324 VDD VSS.t1325 VSS.t305 sg13_lv_nmos ad=79.8f pd=0.8u as=0 ps=0 w=0.42u l=1u
X27 VSS.t2828 VDD VSS.t2829 VSS.t2710 sg13_lv_nmos ad=79.8f pd=0.8u as=0 ps=0 w=0.42u l=1u
X28 VSS.t1963 VDD VSS.t1962 VSS.t1961 sg13_lv_nmos ad=0.1428p pd=1.52u as=0 ps=0 w=0.42u l=1u
X29 VDD VSS.t1803 VDD VDD sg13_lv_pmos ad=0.19p pd=1.38u as=0 ps=0 w=1u l=1u
X30 VDD VSS.t3097 VDD VDD sg13_lv_pmos ad=0.19p pd=1.38u as=0 ps=0 w=1u l=1u
X31 VDD VSS.t1960 VDD VDD sg13_lv_pmos ad=0.19p pd=1.38u as=0 ps=0 w=1u l=1u
X32 VDD a_12308_15202# sg13g2_dfrbpq_1_2.CLK VDD sg13_lv_pmos ad=0.2128p pd=1.5u as=0.2128p ps=1.5u w=1.12u l=0.13u
X33 VSS.t1676 VDD VSS.t1675 VSS.t1674 sg13_lv_nmos ad=0.1428p pd=1.52u as=0 ps=0 w=0.42u l=1u
X34 VSS.t2804 VDD VSS.t2803 VSS.t2710 sg13_lv_nmos ad=0.1428p pd=1.52u as=0 ps=0 w=0.42u l=1u
X35 VSS.t719 VDD VSS.t719 VSS.t837 sg13_lv_nmos ad=0.1428p pd=1.52u as=0 ps=0 w=0.42u l=1u
X36 VSS.t2203 VDD VSS.t2202 VSS.t2201 sg13_lv_nmos ad=0.1428p pd=1.52u as=0 ps=0 w=0.42u l=1u
X37 VSS.t52 sg13g2_buf_1_9.X.t2 a_23566_13764# VSS.t51 sg13_lv_nmos ad=0.17255p pd=1.25u as=0.187p ps=1.78u w=0.55u l=0.13u
X38 VDD VSS.t1323 VDD VDD sg13_lv_pmos ad=0.34p pd=2.68u as=0 ps=0 w=1u l=1u
X39 VDD VSS.t2829 VDD VDD sg13_lv_pmos ad=0.34p pd=2.68u as=0 ps=0 w=1u l=1u
X40 a_17038_15423# a_17153_15424# VSS.t35 VSS.t21 sg13_lv_nmos ad=0.1428p pd=1.52u as=0.1426p ps=1.16u w=0.42u l=0.5u
X41 VSS.t657 VDD VSS.t656 VSS.t655 sg13_lv_nmos ad=0.1428p pd=1.52u as=0 ps=0 w=0.42u l=1u
X42 VSS.t1074 VDD VSS.t1076 VSS.t1075 sg13_lv_nmos ad=79.8f pd=0.8u as=0 ps=0 w=0.42u l=1u
X43 VDD VSS.t2492 VDD VDD sg13_lv_pmos ad=0.19p pd=1.38u as=0 ps=0 w=1u l=1u
X44 VDD VSS.t2150 VDD VDD sg13_lv_pmos ad=0.19p pd=1.38u as=0 ps=0 w=1u l=1u
X45 a_10139_14832# sg13g2_xnor2_1_1.A VSS.t32 VSS.t95 sg13_lv_nmos ad=78.39999f pd=0.885u as=0.2272p ps=1.99u w=0.64u l=0.13u
X46 VDD VSS.t2327 VDD VDD sg13_lv_pmos ad=0.19p pd=1.38u as=0 ps=0 w=1u l=1u
X47 VDD a_20015_14845# a_20272_14726# VDD sg13_lv_pmos ad=2.75157p pd=17.885u as=79.8f ps=0.8u w=0.42u l=0.13u
X48 VDD VSS.t941 VDD VDD sg13_lv_pmos ad=0.19p pd=1.38u as=0 ps=0 w=1u l=1u
X49 VSS.t1342 VDD VSS.t1342 VSS.t305 sg13_lv_nmos ad=79.8f pd=0.8u as=0 ps=0 w=0.42u l=1u
X50 VDD clock_i a_16078_14484# VDD sg13_lv_pmos ad=0.2128p pd=1.5u as=0.2128p ps=1.5u w=1.12u l=0.13u
X51 VSS.t71 VDD VSS.t71 VSS.t588 sg13_lv_nmos ad=0.1428p pd=1.52u as=0 ps=0 w=0.42u l=1u
X52 VDD VSS.t285 VDD VDD sg13_lv_pmos ad=0.19p pd=1.38u as=0 ps=0 w=1u l=1u
X53 VSS.t2748 VDD VSS.t2747 VSS.t2710 sg13_lv_nmos ad=0.1428p pd=1.52u as=0 ps=0 w=0.42u l=1u
X54 sg13g2_dfrbpq_1_6.Q a_20682_14484# VDD VDD sg13_lv_pmos ad=0.3808p pd=2.92u as=0.2128p ps=1.5u w=1.12u l=0.13u
X55 VSS.t2510 VDD VSS.t2512 VSS.t2511 sg13_lv_nmos ad=79.8f pd=0.8u as=0 ps=0 w=0.42u l=1u
X56 VDD VSS.t1598 VDD VDD sg13_lv_pmos ad=0.19p pd=1.38u as=0 ps=0 w=1u l=1u
X57 VDD VSS.t1615 VDD VDD sg13_lv_pmos ad=0.34p pd=2.68u as=0 ps=0 w=1u l=1u
X58 VSS.t2718 VDD VSS.t2719 VSS.t2710 sg13_lv_nmos ad=79.8f pd=0.8u as=0 ps=0 w=0.42u l=1u
X59 VSS.t2415 VDD VSS.t2414 VSS.t2413 sg13_lv_nmos ad=0.1428p pd=1.52u as=0 ps=0 w=0.42u l=1u
X60 a_8752_15454# sg13g2_dfrbpq_1_1.RESET_B VDD VDD sg13_lv_pmos ad=79.8f pd=0.8u as=2.4406p ps=15.34u w=0.42u l=0.13u
X61 sg13g2_dfrbpq_1_7.CLK a_19630_15238# VDD VDD sg13_lv_pmos ad=0.2128p pd=1.5u as=0.2128p ps=1.5u w=1.12u l=0.13u
X62 VDD VSS.t71 VDD VDD sg13_lv_pmos ad=0.34p pd=2.68u as=0 ps=0 w=1u l=1u
X63 VDD VSS.t2177 VDD VDD sg13_lv_pmos ad=0.34p pd=2.68u as=0 ps=0 w=1u l=1u
X64 VSS.t1044 VDD VSS.t1046 VSS.t1045 sg13_lv_nmos ad=79.8f pd=0.8u as=0 ps=0 w=0.42u l=1u
X65 VDD VSS.t1033 VDD VDD sg13_lv_pmos ad=0.34p pd=2.68u as=0 ps=0 w=1u l=1u
X66 VDD VSS.t1315 VDD VDD sg13_lv_pmos ad=0.34p pd=2.68u as=0 ps=0 w=1u l=1u
X67 VDD VSS.t1952 VDD VDD sg13_lv_pmos ad=0.34p pd=2.68u as=0 ps=0 w=1u l=1u
X68 VDD VSS.t2793 VDD VDD sg13_lv_pmos ad=0.34p pd=2.68u as=0 ps=0 w=1u l=1u
X69 VSS.t564 VDD VSS.t564 VSS.t613 sg13_lv_nmos ad=79.8f pd=0.8u as=0 ps=0 w=0.42u l=1u
X70 VDD VSS.t2719 VDD VDD sg13_lv_pmos ad=0.34p pd=2.68u as=0 ps=0 w=1u l=1u
X71 VDD VSS.t3117 VDD VDD sg13_lv_pmos ad=0.19p pd=1.38u as=0 ps=0 w=1u l=1u
X72 VDD VSS.t1980 VDD VDD sg13_lv_pmos ad=0.19p pd=1.38u as=0 ps=0 w=1u l=1u
X73 VSS.t167 VDD VSS.t167 VSS.t576 sg13_lv_nmos ad=0.1428p pd=1.52u as=0 ps=0 w=0.42u l=1u
X74 VSS.t81 sg13g2_dfrbpq_1_4.RESET_B a_25764_15234# VSS.t253 sg13_lv_nmos ad=0.1626p pd=1.415u as=60.89999f ps=0.71u w=0.42u l=0.13u
X75 VSS.t1796 VDD VSS.t1798 VSS.t1797 sg13_lv_nmos ad=79.8f pd=0.8u as=0 ps=0 w=0.42u l=1u
X76 VDD VSS.t564 VDD VDD sg13_lv_pmos ad=0.19p pd=1.38u as=0 ps=0 w=1u l=1u
X77 VSS.t2188 VDD VSS.t2187 VSS.t2186 sg13_lv_nmos ad=0.1428p pd=1.52u as=0 ps=0 w=0.42u l=1u
X78 VDD VSS.t2142 VDD VDD sg13_lv_pmos ad=0.34p pd=2.68u as=0 ps=0 w=1u l=1u
X79 a_26458_13690# sg13g2_inv_1_1.A VDD VDD sg13_lv_pmos ad=0.1428p pd=1.52u as=0.1523p ps=1.38u w=0.42u l=0.13u
X80 VDD VSS.t1242 VDD VDD sg13_lv_pmos ad=0.34p pd=2.68u as=0 ps=0 w=1u l=1u
X81 VSS.t380 VDD VSS.t382 VSS.t381 sg13_lv_nmos ad=79.8f pd=0.8u as=0 ps=0 w=0.42u l=1u
X82 VDD VSS.t1096 VDD VDD sg13_lv_pmos ad=0.19p pd=1.38u as=0 ps=0 w=1u l=1u
X83 VSS.t1495 VDD VSS.t1357 VSS.t305 sg13_lv_nmos ad=79.8f pd=0.8u as=0 ps=0 w=0.42u l=1u
X84 VSS.t1666 VDD VSS.t1668 VSS.t1667 sg13_lv_nmos ad=79.8f pd=0.8u as=0 ps=0 w=0.42u l=1u
X85 VDD VSS.t2444 VDD VDD sg13_lv_pmos ad=0.34p pd=2.68u as=0 ps=0 w=1u l=1u
X86 VSS.t964 VDD VSS.t966 VSS.t965 sg13_lv_nmos ad=79.8f pd=0.8u as=0 ps=0 w=0.42u l=1u
X87 VSS.t1536 VDD VSS.t1538 VSS.t1537 sg13_lv_nmos ad=79.8f pd=0.8u as=0 ps=0 w=0.42u l=1u
X88 VSS.t92 a_32492_15960# counter_value_o[6] VSS.t91 sg13_lv_nmos ad=0.14875p pd=1.16u as=0.2886p ps=2.26u w=0.74u l=0.13u
X89 VSS.t2730 VDD VSS.t2731 VSS.t2710 sg13_lv_nmos ad=79.8f pd=0.8u as=0 ps=0 w=0.42u l=1u
X90 VDD VSS.t516 VDD VDD sg13_lv_pmos ad=0.34p pd=2.68u as=0 ps=0 w=1u l=1u
X91 VDD VSS.t1243 VDD VDD sg13_lv_pmos ad=0.19p pd=1.38u as=0 ps=0 w=1u l=1u
X92 VDD VSS.t2020 VDD VDD sg13_lv_pmos ad=0.19p pd=1.38u as=0 ps=0 w=1u l=1u
X93 VSS.t1014 VDD VSS.t1013 VSS.t1012 sg13_lv_nmos ad=0.1428p pd=1.52u as=0 ps=0 w=0.42u l=1u
X94 VDD VSS.t2339 VDD VDD sg13_lv_pmos ad=0.34p pd=2.68u as=0 ps=0 w=1u l=1u
X95 VSS.t109 sg13g2_a21oi_1_0.A2 a_16673_15260# VSS.t21 sg13_lv_nmos ad=0.2516p pd=2.16u as=0.1406p ps=1.12u w=0.74u l=0.13u
X96 VSS.t545 VDD VSS.t545 VSS.t600 sg13_lv_nmos ad=0.1428p pd=1.52u as=0 ps=0 w=0.42u l=1u
X97 VDD VSS.t1937 VDD VDD sg13_lv_pmos ad=0.34p pd=2.68u as=0 ps=0 w=1u l=1u
X98 VSS.t2849 VDD VSS.t2978 VSS.t2710 sg13_lv_nmos ad=0.1428p pd=1.52u as=0 ps=0 w=0.42u l=1u
X99 VDD VSS.t2731 VDD VDD sg13_lv_pmos ad=0.34p pd=2.68u as=0 ps=0 w=1u l=1u
X100 VSS.t695 VDD VSS.t700 VSS.t818 sg13_lv_nmos ad=79.8f pd=0.8u as=0 ps=0 w=0.42u l=1u
X101 VDD VSS.t2823 VDD VDD sg13_lv_pmos ad=0.19p pd=1.38u as=0 ps=0 w=1u l=1u
X102 VDD a_14362_15960# a_14081_16262# VDD sg13_lv_pmos ad=0.1523p pd=1.38u as=0.34p ps=2.68u w=1u l=0.5u
X103 VDD VSS.t545 VDD VDD sg13_lv_pmos ad=0.34p pd=2.68u as=0 ps=0 w=1u l=1u
X104 VDD VSS.t3259 VDD VDD sg13_lv_pmos ad=0.34p pd=2.68u as=0 ps=0 w=1u l=1u
X105 VDD VSS.t649 VDD VDD sg13_lv_pmos ad=0.19p pd=1.38u as=0 ps=0 w=1u l=1u
X106 VDD sg13g2_inv_1_1.A sg13g2_inv_1_1.Y VDD sg13_lv_pmos ad=0.3808p pd=2.92u as=0.3808p ps=2.92u w=1.12u l=0.13u
X107 VSS.t719 VDD VSS.t719 VSS.t718 sg13_lv_nmos ad=0.1428p pd=1.52u as=0 ps=0 w=0.42u l=1u
X108 VSS.t2796 VDD VSS.t2795 VSS.t2710 sg13_lv_nmos ad=0.1428p pd=1.52u as=0 ps=0 w=0.42u l=1u
X109 a_32492_15960# sg13g2_inv_1_1.A VSS.t92 VSS.t171 sg13_lv_nmos ad=0.187p pd=1.78u as=0.14875p ps=1.16u w=0.55u l=0.13u
X110 a_22691_14020# sg13g2_nand2_2_0.Y a_22589_14020# VDD sg13_lv_pmos ad=0.2464p pd=1.56u as=0.2128p ps=1.5u w=1.12u l=0.13u
X111 VSS.t1074 VDD VSS.t1076 VSS.t1075 sg13_lv_nmos ad=79.8f pd=0.8u as=0 ps=0 w=0.42u l=1u
X112 VDD VSS.t1063 VDD VDD sg13_lv_pmos ad=0.34p pd=2.68u as=0 ps=0 w=1u l=1u
X113 VDD VSS.t1333 VDD VDD sg13_lv_pmos ad=0.34p pd=2.68u as=0 ps=0 w=1u l=1u
X114 a_26313_15625# a_25956_15552# VDD VDD sg13_lv_pmos ad=63f pd=0.72u as=0.1563p ps=1.22u w=0.42u l=0.13u
X115 VDD VSS.t871 VDD VDD sg13_lv_pmos ad=0.19p pd=1.38u as=0 ps=0 w=1u l=1u
X116 VSS.t1756 VDD VSS.t1755 VSS.t1754 sg13_lv_nmos ad=0.1428p pd=1.52u as=0 ps=0 w=0.42u l=1u
X117 VSS.t2751 VDD VSS.t2752 VSS.t2710 sg13_lv_nmos ad=79.8f pd=0.8u as=0 ps=0 w=0.42u l=1u
X118 VDD VSS.t2477 VDD VDD sg13_lv_pmos ad=0.19p pd=1.38u as=0 ps=0 w=1u l=1u
X119 VSS.t374 VDD VSS.t376 VSS.t375 sg13_lv_nmos ad=79.8f pd=0.8u as=0 ps=0 w=0.42u l=1u
X120 VSS.t167 sg13g2_dlygate4sd3_1_2.X a_2513_15288# VSS.t337 sg13_lv_nmos ad=0.15245p pd=1.17u as=0.17462p ps=1.185u w=0.55u l=0.13u
X121 VDD a_27472_15454# a_27417_15549# VDD sg13_lv_pmos ad=2.4406p pd=15.34u as=93.45f ps=0.865u w=0.42u l=0.13u
X122 VDD VSS.t1658 VDD VDD sg13_lv_pmos ad=0.19p pd=1.38u as=0 ps=0 w=1u l=1u
X123 VDD VSS.t1992 VDD VDD sg13_lv_pmos ad=0.34p pd=2.68u as=0 ps=0 w=1u l=1u
X124 VSS.t934 VDD VSS.t933 VSS.t932 sg13_lv_nmos ad=0.1428p pd=1.52u as=0 ps=0 w=0.42u l=1u
X125 VSS.t2740 VDD VSS.t2740 VSS.t2710 sg13_lv_nmos ad=0.1428p pd=1.52u as=0 ps=0 w=0.42u l=1u
X126 a_18756_13735# a_18987_13844# a_18442_13945# VSS.t242 sg13_lv_nmos ad=0.2373p pd=1.97u as=79.8f ps=0.8u w=0.42u l=0.13u
X127 a_18694_13735# sg13g2_dfrbpq_1_7.RESET_B VSS.t243 VSS.t242 sg13_lv_nmos ad=37.8f pd=0.6u as=0.1701p ps=1.65u w=0.42u l=0.13u
X128 VDD VSS.t700 VDD VDD sg13_lv_pmos ad=0.19p pd=1.38u as=0 ps=0 w=1u l=1u
X129 VDD VSS.t986 VDD VDD sg13_lv_pmos ad=0.19p pd=1.38u as=0 ps=0 w=1u l=1u
X130 VDD VSS.t2786 VDD VDD sg13_lv_pmos ad=0.19p pd=1.38u as=0 ps=0 w=1u l=1u
X131 VSS.t2058 VDD VSS.t2057 VSS.t2056 sg13_lv_nmos ad=0.1428p pd=1.52u as=0 ps=0 w=0.42u l=1u
X132 VDD VSS.t1274 VDD VDD sg13_lv_pmos ad=0.34p pd=2.68u as=0 ps=0 w=1u l=1u
X133 VSS.t364 sg13g2_buf_4_0.X a_17699_16265# VSS.t3276 sg13_lv_nmos ad=0.1045p pd=0.93u as=0.198p ps=1.27u w=0.55u l=0.13u
X134 sg13g2_dfrbpq_1_6.Q a_20682_14484# VSS.t125 VSS.t7 sg13_lv_nmos ad=0.2516p pd=2.16u as=0.1406p ps=1.12u w=0.74u l=0.13u
X135 VDD VSS.t693 VDD VDD sg13_lv_pmos ad=0.19p pd=1.38u as=0 ps=0 w=1u l=1u
X136 VSS.t2400 VDD VSS.t2399 VSS.t2398 sg13_lv_nmos ad=0.1428p pd=1.52u as=0 ps=0 w=0.42u l=1u
X137 VSS.t39 VDD VSS.t39 VSS.t802 sg13_lv_nmos ad=0.1428p pd=1.52u as=0 ps=0 w=0.42u l=1u
X138 VDD VSS.t2359 VDD VDD sg13_lv_pmos ad=0.34p pd=2.68u as=0 ps=0 w=1u l=1u
X139 a_2540_15960# sg13g2_dlygate4sd3_1_2.A VSS.t322 VSS.t321 sg13_lv_nmos ad=0.187p pd=1.78u as=0.14875p ps=1.16u w=0.55u l=0.13u
X140 sg13g2_xor2_1_1.B sg13g2_nand2_2_0.A a_9854_15242# VSS.t358 sg13_lv_nmos ad=0.2516p pd=2.16u as=0.1406p ps=1.12u w=0.74u l=0.13u
X141 VSS.t2763 VDD VSS.t2764 VSS.t2710 sg13_lv_nmos ad=79.8f pd=0.8u as=0 ps=0 w=0.42u l=1u
X142 VDD VSS.t2532 VDD VDD sg13_lv_pmos ad=0.19p pd=1.38u as=0 ps=0 w=1u l=1u
X143 VSS.t2590 VDD VSS.t2592 VSS.t2591 sg13_lv_nmos ad=79.8f pd=0.8u as=0 ps=0 w=0.42u l=1u
X144 VDD sg13g2_buf_1_9.X.t2 a_23566_13764# VDD sg13_lv_pmos ad=0.2618p pd=1.63u as=0.2856p ps=2.36u w=0.84u l=0.13u
X145 VDD VSS.t861 VDD VDD sg13_lv_pmos ad=0.19p pd=1.38u as=0 ps=0 w=1u l=1u
X146 VSS.t1968 VDD VSS.t1967 VSS.t1966 sg13_lv_nmos ad=0.1428p pd=1.52u as=0 ps=0 w=0.42u l=1u
X147 VSS.t1296 VDD VSS.t1297 VSS.t305 sg13_lv_nmos ad=79.8f pd=0.8u as=0 ps=0 w=0.42u l=1u
X148 VDD VSS.t3102 VDD VDD sg13_lv_pmos ad=0.19p pd=1.38u as=0 ps=0 w=1u l=1u
X149 VDD VSS.t1965 VDD VDD sg13_lv_pmos ad=0.19p pd=1.38u as=0 ps=0 w=1u l=1u
X150 VSS.t2138 VDD VSS.t2140 VSS.t2139 sg13_lv_nmos ad=79.8f pd=0.8u as=0 ps=0 w=0.42u l=1u
X151 VDD VSS.t1026 VDD VDD sg13_lv_pmos ad=0.19p pd=1.38u as=0 ps=0 w=1u l=1u
X152 VDD VSS.t1813 VDD VDD sg13_lv_pmos ad=0.19p pd=1.38u as=0 ps=0 w=1u l=1u
X153 VDD VSS.t1469 VDD VDD sg13_lv_pmos ad=0.34p pd=2.68u as=0 ps=0 w=1u l=1u
X154 VDD VSS.t2832 VDD VDD sg13_lv_pmos ad=0.34p pd=2.68u as=0 ps=0 w=1u l=1u
X155 VSS.t676 VDD VSS.t285 VSS.t678 sg13_lv_nmos ad=79.8f pd=0.8u as=0 ps=0 w=0.42u l=1u
X156 VDD VSS.t129 VDD VDD sg13_lv_pmos ad=0.34p pd=2.68u as=0 ps=0 w=1u l=1u
X157 VDD VSS.t2497 VDD VDD sg13_lv_pmos ad=0.19p pd=1.38u as=0 ps=0 w=1u l=1u
X158 VDD a_27500_15960# counter_value_o[5] VDD sg13_lv_pmos ad=0.2114p pd=1.54u as=0.42p ps=2.99u w=1.12u l=0.13u
X159 VSS.t894 VDD VSS.t896 VSS.t895 sg13_lv_nmos ad=79.8f pd=0.8u as=0 ps=0 w=0.42u l=1u
X160 a_19173_14495# sg13g2_dfrbpq_1_7.CLK VSS.t7 VSS.t199 sg13_lv_nmos ad=0.2516p pd=2.16u as=4.79747p ps=30.975u w=0.74u l=0.13u
X161 VSS.t964 VDD VSS.t966 VSS.t965 sg13_lv_nmos ad=79.8f pd=0.8u as=0 ps=0 w=0.42u l=1u
X162 VDD VSS.t953 VDD VDD sg13_lv_pmos ad=0.34p pd=2.68u as=0 ps=0 w=1u l=1u
X163 VSS.t3010 VDD VSS.t3009 VSS.t3008 sg13_lv_nmos ad=0.1428p pd=1.52u as=0 ps=0 w=0.42u l=1u
X164 VDD sg13g2_and2_1_2.B a_10605_13768# VDD sg13_lv_pmos ad=0.1918p pd=1.5u as=0.1596p ps=1.22u w=0.84u l=0.13u
X165 VSS.t1651 VDD VSS.t1653 VSS.t1652 sg13_lv_nmos ad=79.8f pd=0.8u as=0 ps=0 w=0.42u l=1u
X166 a_18442_13945# a_18885_13701# a_18825_14113# VDD sg13_lv_pmos ad=79.8f pd=0.8u as=63f ps=0.72u w=0.42u l=0.13u
X167 VDD VSS.t683 VDD VDD sg13_lv_pmos ad=0.34p pd=2.68u as=0 ps=0 w=1u l=1u
X168 VSS.t1304 VDD VSS.t1305 VSS.t305 sg13_lv_nmos ad=79.8f pd=0.8u as=0 ps=0 w=0.42u l=1u
X169 VSS.t2721 VDD VSS.t2722 VSS.t2710 sg13_lv_nmos ad=79.8f pd=0.8u as=0 ps=0 w=0.42u l=1u
X170 VDD VSS.t429 VDD VDD sg13_lv_pmos ad=0.19p pd=1.38u as=0 ps=0 w=1u l=1u
X171 VDD VSS.t2524 VDD VDD sg13_lv_pmos ad=0.34p pd=2.68u as=0 ps=0 w=1u l=1u
X172 VDD VSS.t2182 VDD VDD sg13_lv_pmos ad=0.34p pd=2.68u as=0 ps=0 w=1u l=1u
X173 VSS.t676 VDD VSS.t676 VSS.t771 sg13_lv_nmos ad=79.8f pd=0.8u as=0 ps=0 w=0.42u l=1u
X174 VSS.t2575 VDD VSS.t2577 VSS.t2576 sg13_lv_nmos ad=79.8f pd=0.8u as=0 ps=0 w=0.42u l=1u
X175 VSS.t1269 VDD VSS.t1268 VSS.t305 sg13_lv_nmos ad=0.1428p pd=1.52u as=0 ps=0 w=0.42u l=1u
X176 VSS.t1457 VDD VSS.t1310 VSS.t305 sg13_lv_nmos ad=79.8f pd=0.8u as=0 ps=0 w=0.42u l=1u
X177 VDD VSS.t2722 VDD VDD sg13_lv_pmos ad=0.34p pd=2.68u as=0 ps=0 w=1u l=1u
X178 VDD VSS.t1401 VDD VDD sg13_lv_pmos ad=0.19p pd=1.38u as=0 ps=0 w=1u l=1u
X179 VDD VSS.t3087 VDD VDD sg13_lv_pmos ad=0.19p pd=1.38u as=0 ps=0 w=1u l=1u
X180 VDD VSS.t649 VDD VDD sg13_lv_pmos ad=0.19p pd=1.38u as=0 ps=0 w=1u l=1u
X181 VSS.t1801 VDD VSS.t1803 VSS.t1802 sg13_lv_nmos ad=79.8f pd=0.8u as=0 ps=0 w=0.42u l=1u
X182 a_7593_15625# a_7236_15552# VDD VDD sg13_lv_pmos ad=63f pd=0.72u as=0.1563p ps=1.22u w=0.42u l=0.13u
X183 VSS.t864 VDD VSS.t863 VSS.t862 sg13_lv_nmos ad=0.1428p pd=1.52u as=0 ps=0 w=0.42u l=1u
X184 VSS.t2770 VDD VSS.t2770 VSS.t2710 sg13_lv_nmos ad=0.1428p pd=1.52u as=0 ps=0 w=0.42u l=1u
X185 VSS.t934 VDD VSS.t933 VSS.t932 sg13_lv_nmos ad=0.1428p pd=1.52u as=0 ps=0 w=0.42u l=1u
X186 VDD VSS.t1643 VDD VDD sg13_lv_pmos ad=0.19p pd=1.38u as=0 ps=0 w=1u l=1u
X187 VSS.t2839 VDD VSS.t2838 VSS.t2710 sg13_lv_nmos ad=0.1428p pd=1.52u as=0 ps=0 w=0.42u l=1u
X188 VDD VSS.t1977 VDD VDD sg13_lv_pmos ad=0.34p pd=2.68u as=0 ps=0 w=1u l=1u
X189 VSS.t2108 VDD VSS.t2110 VSS.t2109 sg13_lv_nmos ad=79.8f pd=0.8u as=0 ps=0 w=0.42u l=1u
X190 VDD VSS.t1031 VDD VDD sg13_lv_pmos ad=0.19p pd=1.38u as=0 ps=0 w=1u l=1u
X191 VSS.t1287 VDD VSS.t1286 VSS.t305 sg13_lv_nmos ad=0.1428p pd=1.52u as=0 ps=0 w=0.42u l=1u
X192 VDD VSS.t719 VDD VDD sg13_lv_pmos ad=0.19p pd=1.38u as=0 ps=0 w=1u l=1u
X193 VDD VSS.t331 VDD VDD sg13_lv_pmos ad=0.19p pd=1.38u as=0 ps=0 w=1u l=1u
X194 VSS.t657 VDD VSS.t656 VSS.t655 sg13_lv_nmos ad=0.1428p pd=1.52u as=0 ps=0 w=0.42u l=1u
X195 VSS.t705 VDD VSS.t705 VSS.t823 sg13_lv_nmos ad=0.1428p pd=1.52u as=0 ps=0 w=0.42u l=1u
X196 VDD VSS.t2509 VDD VDD sg13_lv_pmos ad=0.34p pd=2.68u as=0 ps=0 w=1u l=1u
X197 sg13g2_nor2b_1_0.Y sg13g2_nor2b_1_0.A a_23788_14020# VDD sg13_lv_pmos ad=0.3808p pd=2.92u as=0.1176p ps=1.33u w=1.12u l=0.13u
X198 VSS.t1292 VDD VSS.t1291 VSS.t305 sg13_lv_nmos ad=0.1428p pd=1.52u as=0 ps=0 w=0.42u l=1u
X199 VSS.t1596 VDD VSS.t1598 VSS.t1597 sg13_lv_nmos ad=79.8f pd=0.8u as=0 ps=0 w=0.42u l=1u
X200 VDD VSS.t2344 VDD VDD sg13_lv_pmos ad=0.34p pd=2.68u as=0 ps=0 w=1u l=1u
X201 a_22806_14484# sg13g2_inv_1_1.Y VDD VDD sg13_lv_pmos ad=0.2128p pd=1.5u as=0.3808p ps=2.92u w=1.12u l=0.13u
X202 VDD VSS.t1942 VDD VDD sg13_lv_pmos ad=0.34p pd=2.68u as=0 ps=0 w=1u l=1u
X203 VDD VSS.t2787 VDD VDD sg13_lv_pmos ad=0.34p pd=2.68u as=0 ps=0 w=1u l=1u
X204 VSS.t1322 VDD VSS.t1323 VSS.t305 sg13_lv_nmos ad=79.8f pd=0.8u as=0 ps=0 w=0.42u l=1u
X205 VDD VSS.t2825 VDD VDD sg13_lv_pmos ad=0.19p pd=1.38u as=0 ps=0 w=1u l=1u
X206 VDD VSS.t2115 VDD VDD sg13_lv_pmos ad=0.19p pd=1.38u as=0 ps=0 w=1u l=1u
X207 VDD VSS.t1319 VDD VDD sg13_lv_pmos ad=0.19p pd=1.38u as=0 ps=0 w=1u l=1u
X208 VSS.t2530 VDD VSS.t2529 VSS.t2528 sg13_lv_nmos ad=0.1428p pd=1.52u as=0 ps=0 w=0.42u l=1u
X209 VSS.t1953 VDD VSS.t1952 VSS.t1951 sg13_lv_nmos ad=0.1428p pd=1.52u as=0 ps=0 w=0.42u l=1u
X210 VDD VSS.t3264 VDD VDD sg13_lv_pmos ad=0.34p pd=2.68u as=0 ps=0 w=1u l=1u
X211 VSS.t1019 VDD VSS.t1018 VSS.t1017 sg13_lv_nmos ad=0.1428p pd=1.52u as=0 ps=0 w=0.42u l=1u
X212 VDD VSS.t2534 VDD VDD sg13_lv_pmos ad=0.34p pd=2.68u as=0 ps=0 w=1u l=1u
X213 VSS.t894 VDD VSS.t896 VSS.t895 sg13_lv_nmos ad=79.8f pd=0.8u as=0 ps=0 w=0.42u l=1u
X214 VSS.t1326 VDD VSS.t1328 VSS.t305 sg13_lv_nmos ad=79.8f pd=0.8u as=0 ps=0 w=0.42u l=1u
X215 VDD VSS.t1798 VDD VDD sg13_lv_pmos ad=0.19p pd=1.38u as=0 ps=0 w=1u l=1u
X216 a_7151_13726# a_7116_13912# sg13g2_xnor2_1_0.Y VSS.t29 sg13_lv_nmos ad=0.1406p pd=1.12u as=0.2516p ps=2.16u w=0.74u l=0.13u
X217 VSS.t2595 VDD VSS.t2597 VSS.t2596 sg13_lv_nmos ad=79.8f pd=0.8u as=0 ps=0 w=0.42u l=1u
X218 VSS.t2754 VDD VSS.t2755 VSS.t2710 sg13_lv_nmos ad=79.8f pd=0.8u as=0 ps=0 w=0.42u l=1u
X219 VDD VSS.t2482 VDD VDD sg13_lv_pmos ad=0.19p pd=1.38u as=0 ps=0 w=1u l=1u
X220 VSS.t2143 VDD VSS.t2142 VSS.t2141 sg13_lv_nmos ad=0.1428p pd=1.52u as=0 ps=0 w=0.42u l=1u
X221 VDD VSS.t998 VDD VDD sg13_lv_pmos ad=0.34p pd=2.68u as=0 ps=0 w=1u l=1u
X222 VDD VSS.t1663 VDD VDD sg13_lv_pmos ad=0.19p pd=1.38u as=0 ps=0 w=1u l=1u
X223 VSS.t545 VDD VSS.t545 VSS.t599 sg13_lv_nmos ad=79.8f pd=0.8u as=0 ps=0 w=0.42u l=1u
X224 VDD VSS.t705 VDD VDD sg13_lv_pmos ad=0.34p pd=2.68u as=0 ps=0 w=1u l=1u
X225 VDD VSS.t729 VDD VDD sg13_lv_pmos ad=0.19p pd=1.38u as=0 ps=0 w=1u l=1u
X226 VSS.t2995 VDD VSS.t2994 VSS.t2993 sg13_lv_nmos ad=0.1428p pd=1.52u as=0 ps=0 w=0.42u l=1u
X227 a_3689_14822# a_3813_14521# VDD VDD sg13_lv_pmos ad=0.2442p pd=2.06u as=2.75157p ps=17.885u w=0.66u l=0.13u
X228 VSS.t724 VDD VSS.t724 VSS.t839 sg13_lv_nmos ad=0.1428p pd=1.52u as=0 ps=0 w=0.42u l=1u
X229 VSS.t2743 VDD VSS.t2742 VSS.t2710 sg13_lv_nmos ad=0.1428p pd=1.52u as=0 ps=0 w=0.42u l=1u
X230 VSS.t2028 VDD VSS.t2027 VSS.t2026 sg13_lv_nmos ad=0.1428p pd=1.52u as=0 ps=0 w=0.42u l=1u
X231 VDD VSS.t545 VDD VDD sg13_lv_pmos ad=0.19p pd=1.38u as=0 ps=0 w=1u l=1u
X232 VSS.t146 VDD VSS.t686 VSS.t688 sg13_lv_nmos ad=0.1428p pd=1.52u as=0 ps=0 w=0.42u l=1u
X233 VDD VSS.t2755 VDD VDD sg13_lv_pmos ad=0.34p pd=2.68u as=0 ps=0 w=1u l=1u
X234 VSS.t208 VDD VSS.t208 VSS.t483 sg13_lv_nmos ad=79.8f pd=0.8u as=0 ps=0 w=0.42u l=1u
X235 VDD VSS.t167 VDD VDD sg13_lv_pmos ad=0.34p pd=2.68u as=0 ps=0 w=1u l=1u
X236 VDD VSS.t946 VDD VDD sg13_lv_pmos ad=0.19p pd=1.38u as=0 ps=0 w=1u l=1u
X237 VSS.t1034 VDD VSS.t1033 VSS.t1032 sg13_lv_nmos ad=0.1428p pd=1.52u as=0 ps=0 w=0.42u l=1u
X238 VDD VSS.t2329 VDD VDD sg13_lv_pmos ad=0.34p pd=2.68u as=0 ps=0 w=1u l=1u
X239 VSS.t2560 VDD VSS.t2562 VSS.t2561 sg13_lv_nmos ad=79.8f pd=0.8u as=0 ps=0 w=0.42u l=1u
X240 VSS.t1477 VDD VSS.t1336 VSS.t305 sg13_lv_nmos ad=79.8f pd=0.8u as=0 ps=0 w=0.42u l=1u
X241 VSS.t1556 VDD VSS.t1555 VSS.t1554 sg13_lv_nmos ad=0.1428p pd=1.52u as=0 ps=0 w=0.42u l=1u
X242 VSS.t2465 VDD VSS.t2464 VSS.t2463 sg13_lv_nmos ad=0.1428p pd=1.52u as=0 ps=0 w=0.42u l=1u
X243 VSS.t24 a_18086_15238# a_18198_15302# VSS.t21 sg13_lv_nmos ad=0.1426p pd=1.16u as=0.1428p ps=1.52u w=0.42u l=0.5u
X244 VDD VSS.t3072 VDD VDD sg13_lv_pmos ad=0.19p pd=1.38u as=0 ps=0 w=1u l=1u
X245 VDD VSS.t3249 VDD VDD sg13_lv_pmos ad=0.34p pd=2.68u as=0 ps=0 w=1u l=1u
X246 VSS.t1938 VDD VSS.t1937 VSS.t1936 sg13_lv_nmos ad=0.1428p pd=1.52u as=0 ps=0 w=0.42u l=1u
X247 VSS.t89 sg13g2_buf_16_1.X a_12308_15202# VSS.t219 sg13_lv_nmos ad=0.1406p pd=1.12u as=0.1406p ps=1.12u w=0.74u l=0.13u
X248 a_23709_14854# sg13g2_nor3_1_0.Y VSS.t58 VSS.t7 sg13_lv_nmos ad=0.13135p pd=1.095u as=0.18945p ps=1.27u w=0.74u l=0.13u
X249 VSS.t733 VDD VSS.t729 VSS.t845 sg13_lv_nmos ad=0.1428p pd=1.52u as=0 ps=0 w=0.42u l=1u
X250 VSS.t864 VDD VSS.t863 VSS.t862 sg13_lv_nmos ad=0.1428p pd=1.52u as=0 ps=0 w=0.42u l=1u
X251 VDD VSS.t1318 VDD VDD sg13_lv_pmos ad=0.34p pd=2.68u as=0 ps=0 w=1u l=1u
X252 VSS.t1094 VDD VSS.t1096 VSS.t1095 sg13_lv_nmos ad=79.8f pd=0.8u as=0 ps=0 w=0.42u l=1u
X253 VDD VSS.t1273 VDD VDD sg13_lv_pmos ad=0.19p pd=1.38u as=0 ps=0 w=1u l=1u
X254 VSS.t2763 VDD VSS.t2762 VSS.t2710 sg13_lv_nmos ad=0.1428p pd=1.52u as=0 ps=0 w=0.42u l=1u
X255 VDD enable_i a_1192_3900# VDD sg13_lv_pmos ad=0.2114p pd=1.54u as=0.2856p ps=2.36u w=0.84u l=0.13u
X256 VSS.t463 VDD VSS.t463 VSS.t462 sg13_lv_nmos ad=0.1428p pd=1.52u as=0 ps=0 w=0.42u l=1u
X257 sg13g2_nand3_1_1.Y sg13g2_nand2_2_0.A a_15704_15242# VSS.t21 sg13_lv_nmos ad=0.2516p pd=2.16u as=0.1406p ps=1.12u w=0.74u l=0.13u
X258 VSS.t146 sg13g2_buf_4_0.X sg13g2_nor3_1_0.Y VSS.t3274 sg13_lv_nmos ad=0.2618p pd=2.22u as=0.1694p ps=1.21u w=0.77u l=0.13u
X259 VDD VSS.t961 VDD VDD sg13_lv_pmos ad=0.19p pd=1.38u as=0 ps=0 w=1u l=1u
X260 VDD VSS.t2713 VDD VDD sg13_lv_pmos ad=0.19p pd=1.38u as=0 ps=0 w=1u l=1u
X261 a_14362_15960# sg13g2_xor2_1_1.X VSS.t326 VSS.t3310 sg13_lv_nmos ad=0.1428p pd=1.52u as=79.8f ps=0.8u w=0.42u l=0.13u
X262 VDD VSS.t1805 VDD VDD sg13_lv_pmos ad=0.34p pd=2.68u as=0 ps=0 w=1u l=1u
X263 VSS.t2093 VDD VSS.t2095 VSS.t2094 sg13_lv_nmos ad=79.8f pd=0.8u as=0 ps=0 w=0.42u l=1u
X264 VSS.t1656 VDD VSS.t1658 VSS.t1657 sg13_lv_nmos ad=79.8f pd=0.8u as=0 ps=0 w=0.42u l=1u
X265 VSS.t3185 VDD VSS.t3187 VSS.t3186 sg13_lv_nmos ad=79.8f pd=0.8u as=0 ps=0 w=0.42u l=1u
X266 a_26927_14845# a_26085_14495# a_25668_14488# VDD sg13_lv_pmos ad=0.2048p pd=1.63u as=0.34p ps=2.68u w=1u l=0.13u
X267 a_18756_13735# a_18468_14040# a_18694_13735# VSS.t242 sg13_lv_nmos ad=0.1428p pd=1.52u as=37.8f ps=0.6u w=0.42u l=0.13u
X268 VDD VSS.t1245 VDD VDD sg13_lv_pmos ad=0.34p pd=2.68u as=0 ps=0 w=1u l=1u
X269 VSS.t2048 VDD VSS.t2047 VSS.t2046 sg13_lv_nmos ad=0.1428p pd=1.52u as=0 ps=0 w=0.42u l=1u
X270 VDD VSS.t898 VDD VDD sg13_lv_pmos ad=0.34p pd=2.68u as=0 ps=0 w=1u l=1u
X271 VSS.t2724 VDD VSS.t2725 VSS.t2710 sg13_lv_nmos ad=79.8f pd=0.8u as=0 ps=0 w=0.42u l=1u
X272 VSS.t1386 VDD VSS.t1385 VSS.t305 sg13_lv_nmos ad=0.1428p pd=1.52u as=0 ps=0 w=0.42u l=1u
X273 VDD VSS.t2494 VDD VDD sg13_lv_pmos ad=0.34p pd=2.68u as=0 ps=0 w=1u l=1u
X274 VDD VSS.t2152 VDD VDD sg13_lv_pmos ad=0.34p pd=2.68u as=0 ps=0 w=1u l=1u
X275 VDD VSS.t559 VDD VDD sg13_lv_pmos ad=0.34p pd=2.68u as=0 ps=0 w=1u l=1u
X276 VDD VSS.t1927 VDD VDD sg13_lv_pmos ad=0.34p pd=2.68u as=0 ps=0 w=1u l=1u
X277 a_19984_13942# sg13g2_dfrbpq_1_7.RESET_B VDD VDD sg13_lv_pmos ad=79.8f pd=0.8u as=2.75157p ps=17.885u w=0.42u l=0.13u
X278 VDD VSS.t2725 VDD VDD sg13_lv_pmos ad=0.34p pd=2.68u as=0 ps=0 w=1u l=1u
X279 VSS.t1019 VDD VSS.t1018 VSS.t1017 sg13_lv_nmos ad=0.1428p pd=1.52u as=0 ps=0 w=0.42u l=1u
X280 VSS.t1064 VDD VSS.t1063 VSS.t1062 sg13_lv_nmos ad=0.1428p pd=1.52u as=0 ps=0 w=0.42u l=1u
X281 VSS.t100 a_12308_15202# sg13g2_dfrbpq_1_2.CLK VSS.t182 sg13_lv_nmos ad=0.1406p pd=1.12u as=0.1406p ps=1.12u w=0.74u l=0.13u
X282 VDD VSS.t1253 VDD VDD sg13_lv_pmos ad=0.34p pd=2.68u as=0 ps=0 w=1u l=1u
X283 VDD VSS.t1364 VDD VDD sg13_lv_pmos ad=0.19p pd=1.38u as=0 ps=0 w=1u l=1u
X284 a_27500_15960# sg13g2_dfrbpq_1_6.Q VSS.t208 VSS.t250 sg13_lv_nmos ad=0.187p pd=1.78u as=0.14875p ps=1.16u w=0.55u l=0.13u
X285 VDD VSS.t683 VDD VDD sg13_lv_pmos ad=0.19p pd=1.38u as=0 ps=0 w=1u l=1u
X286 VDD VSS.t928 VDD VDD sg13_lv_pmos ad=0.34p pd=2.68u as=0 ps=0 w=1u l=1u
X287 VDD VSS.t1116 VDD VDD sg13_lv_pmos ad=0.19p pd=1.38u as=0 ps=0 w=1u l=1u
X288 VSS.t2773 VDD VSS.t2772 VSS.t2710 sg13_lv_nmos ad=0.1428p pd=1.52u as=0 ps=0 w=0.42u l=1u
X289 VDD VSS.t671 VDD VDD sg13_lv_pmos ad=0.34p pd=2.68u as=0 ps=0 w=1u l=1u
X290 VSS.t2580 VDD VSS.t2582 VSS.t2581 sg13_lv_nmos ad=79.8f pd=0.8u as=0 ps=0 w=0.42u l=1u
X291 VDD VSS.t1648 VDD VDD sg13_lv_pmos ad=0.19p pd=1.38u as=0 ps=0 w=1u l=1u
X292 VDD VSS.t3119 VDD VDD sg13_lv_pmos ad=0.34p pd=2.68u as=0 ps=0 w=1u l=1u
X293 VSS.t2841 VDD VSS.t2841 VSS.t2710 sg13_lv_nmos ad=0.1428p pd=1.52u as=0 ps=0 w=0.42u l=1u
X294 VDD VSS.t1982 VDD VDD sg13_lv_pmos ad=0.34p pd=2.68u as=0 ps=0 w=1u l=1u
X295 VSS.t2078 VDD VSS.t2080 VSS.t2079 sg13_lv_nmos ad=79.8f pd=0.8u as=0 ps=0 w=0.42u l=1u
X296 VSS.t984 VDD VSS.t986 VSS.t985 sg13_lv_nmos ad=79.8f pd=0.8u as=0 ps=0 w=0.42u l=1u
X297 VDD VSS.t1653 VDD VDD sg13_lv_pmos ad=0.19p pd=1.38u as=0 ps=0 w=1u l=1u
X298 VSS.t2715 VDD VSS.t2716 VSS.t2710 sg13_lv_nmos ad=79.8f pd=0.8u as=0 ps=0 w=0.42u l=1u
X299 VSS.t1034 VDD VSS.t1033 VSS.t1032 sg13_lv_nmos ad=0.1428p pd=1.52u as=0 ps=0 w=0.42u l=1u
X300 VSS.t1532 VDD VSS.t1398 VSS.t305 sg13_lv_nmos ad=0.1428p pd=1.52u as=0 ps=0 w=0.42u l=1u
X301 VSS.t2450 VDD VSS.t2452 VSS.t2451 sg13_lv_nmos ad=79.8f pd=0.8u as=0 ps=0 w=0.42u l=1u
X302 a_25764_15234# sg13g2_dfrbpq_1_4.D a_25670_15234# VSS.t7 sg13_lv_nmos ad=60.89999f pd=0.71u as=0.1428p ps=1.52u w=0.42u l=0.13u
X303 sg13g2_and2_1_2.B a_10176_14523# a_10325_14854# VSS.t263 sg13_lv_nmos ad=0.2516p pd=2.16u as=0.1406p ps=1.12u w=0.74u l=0.13u
X304 VDD VSS.t991 VDD VDD sg13_lv_pmos ad=0.19p pd=1.38u as=0 ps=0 w=1u l=1u
X305 VDD VSS.t1995 VDD VDD sg13_lv_pmos ad=0.19p pd=1.38u as=0 ps=0 w=1u l=1u
X306 VSS.t1998 VDD VSS.t1997 VSS.t1996 sg13_lv_nmos ad=0.1428p pd=1.52u as=0 ps=0 w=0.42u l=1u
X307 VSS.t66 sg13g2_a21oi_1_0.Y a_17816_15238# VSS.t21 sg13_lv_nmos ad=79.8f pd=0.8u as=0.1428p ps=1.52u w=0.42u l=0.13u
X308 sg13g2_dfrbpq_1_7.CLK a_19630_15238# VSS.t152 VSS.t3 sg13_lv_nmos ad=0.1406p pd=1.12u as=0.1406p ps=1.12u w=0.74u l=0.13u
X309 VSS.t859 VDD VSS.t861 VSS.t860 sg13_lv_nmos ad=79.8f pd=0.8u as=0 ps=0 w=0.42u l=1u
X310 VDD VSS.t2120 VDD VDD sg13_lv_pmos ad=0.19p pd=1.38u as=0 ps=0 w=1u l=1u
X311 VDD VSS.t559 VDD VDD sg13_lv_pmos ad=0.34p pd=2.68u as=0 ps=0 w=1u l=1u
X312 VDD VSS.t809 VDD VDD sg13_lv_pmos ad=0.19p pd=1.38u as=0 ps=0 w=1u l=1u
X313 VDD VSS.t918 VDD VDD sg13_lv_pmos ad=0.34p pd=2.68u as=0 ps=0 w=1u l=1u
X314 VSS.t1541 VDD VSS.t1540 VSS.t1539 sg13_lv_nmos ad=0.1428p pd=1.52u as=0 ps=0 w=0.42u l=1u
X315 sg13g2_dlygate4sd3_1_12.A a_27882_15532# VDD VDD sg13_lv_pmos ad=0.3808p pd=2.92u as=0.2128p ps=1.5u w=1.12u l=0.13u
X316 VSS.t729 VDD VSS.t729 VSS.t728 sg13_lv_nmos ad=0.1428p pd=1.52u as=0 ps=0 w=0.42u l=1u
X317 VDD VSS.t3234 VDD VDD sg13_lv_pmos ad=0.34p pd=2.68u as=0 ps=0 w=1u l=1u
X318 VSS.t2733 VDD VSS.t2732 VSS.t2710 sg13_lv_nmos ad=0.1428p pd=1.52u as=0 ps=0 w=0.42u l=1u
X319 VDD VSS.t425 VDD VDD sg13_lv_pmos ad=0.19p pd=1.38u as=0 ps=0 w=1u l=1u
X320 VSS.t1094 VDD VSS.t1096 VSS.t1095 sg13_lv_nmos ad=79.8f pd=0.8u as=0 ps=0 w=0.42u l=1u
X321 VDD VSS.t1344 VDD VDD sg13_lv_pmos ad=0.34p pd=2.68u as=0 ps=0 w=1u l=1u
X322 VSS.t2790 VDD VSS.t2791 VSS.t2710 sg13_lv_nmos ad=79.8f pd=0.8u as=0 ps=0 w=0.42u l=1u
X323 VDD VSS.t1803 VDD VDD sg13_lv_pmos ad=0.19p pd=1.38u as=0 ps=0 w=1u l=1u
X324 VDD a_8495_15311# a_8752_15454# VDD sg13_lv_pmos ad=2.4406p pd=15.34u as=79.8f ps=0.8u w=0.42u l=0.13u
X325 VSS.t954 VDD VSS.t953 VSS.t952 sg13_lv_nmos ad=0.1428p pd=1.52u as=0 ps=0 w=0.42u l=1u
X326 VSS.t1440 VDD VSS.t1290 VSS.t305 sg13_lv_nmos ad=79.8f pd=0.8u as=0 ps=0 w=0.42u l=1u
X327 VDD VSS.t1633 VDD VDD sg13_lv_pmos ad=0.19p pd=1.38u as=0 ps=0 w=1u l=1u
X328 VSS.t517 VDD VSS.t516 VSS.t515 sg13_lv_nmos ad=0.1428p pd=1.52u as=0 ps=0 w=0.42u l=1u
X329 VDD VSS.t71 VDD VDD sg13_lv_pmos ad=0.19p pd=1.38u as=0 ps=0 w=1u l=1u
X330 VDD VSS.t1381 VDD VDD sg13_lv_pmos ad=0.19p pd=1.38u as=0 ps=0 w=1u l=1u
X331 VSS.t2745 VDD VSS.t2745 VSS.t2710 sg13_lv_nmos ad=0.1428p pd=1.52u as=0 ps=0 w=0.42u l=1u
X332 VDD VSS.t2547 VDD VDD sg13_lv_pmos ad=0.19p pd=1.38u as=0 ps=0 w=1u l=1u
X333 VSS.t2033 VDD VSS.t2032 VSS.t2031 sg13_lv_nmos ad=0.1428p pd=1.52u as=0 ps=0 w=0.42u l=1u
X334 VSS.t695 VDD VSS.t257 VSS.t813 sg13_lv_nmos ad=0.1428p pd=1.52u as=0 ps=0 w=0.42u l=1u
X335 VDD VSS.t695 VDD VDD sg13_lv_pmos ad=0.19p pd=1.38u as=0 ps=0 w=1u l=1u
X336 VSS.t3125 VDD VSS.t3124 VSS.t3123 sg13_lv_nmos ad=0.1428p pd=1.52u as=0 ps=0 w=0.42u l=1u
X337 VDD VSS.t2334 VDD VDD sg13_lv_pmos ad=0.34p pd=2.68u as=0 ps=0 w=1u l=1u
X338 VSS.t2565 VDD VSS.t2567 VSS.t2566 sg13_lv_nmos ad=79.8f pd=0.8u as=0 ps=0 w=0.42u l=1u
X339 sg13g2_dfrbpq_1_7.CLK a_19630_15238# VSS.t126 VSS.t3 sg13_lv_nmos ad=0.1406p pd=1.12u as=0.1406p ps=1.12u w=0.74u l=0.13u
X340 VSS.t540 VDD VSS.t540 VSS.t542 sg13_lv_nmos ad=79.8f pd=0.8u as=0 ps=0 w=0.42u l=1u
X341 VDD VSS.t636 VDD VDD sg13_lv_pmos ad=0.34p pd=2.68u as=0 ps=0 w=1u l=1u
X342 VDD VSS.t881 VDD VDD sg13_lv_pmos ad=0.19p pd=1.38u as=0 ps=0 w=1u l=1u
X343 VDD VSS.t1598 VDD VDD sg13_lv_pmos ad=0.19p pd=1.38u as=0 ps=0 w=1u l=1u
X344 VDD VSS.t2507 VDD VDD sg13_lv_pmos ad=0.19p pd=1.38u as=0 ps=0 w=1u l=1u
X345 VSS.t1064 VDD VSS.t1063 VSS.t1062 sg13_lv_nmos ad=0.1428p pd=1.52u as=0 ps=0 w=0.42u l=1u
X346 VSS.t1731 VDD VSS.t1733 VSS.t1732 sg13_lv_nmos ad=79.8f pd=0.8u as=0 ps=0 w=0.42u l=1u
X347 VSS.t1943 VDD VSS.t1942 VSS.t1941 sg13_lv_nmos ad=0.1428p pd=1.52u as=0 ps=0 w=0.42u l=1u
X348 a_4270_14751# a_4385_14750# VDD VDD sg13_lv_pmos ad=0.34p pd=2.68u as=0.2254p ps=1.53u w=1u l=0.5u
X349 VDD VSS.t705 VDD VDD sg13_lv_pmos ad=0.19p pd=1.38u as=0 ps=0 w=1u l=1u
X350 VDD VSS.t676 VDD VDD sg13_lv_pmos ad=0.34p pd=2.68u as=0 ps=0 w=1u l=1u
X351 VSS.t2113 VDD VSS.t2115 VSS.t2114 sg13_lv_nmos ad=79.8f pd=0.8u as=0 ps=0 w=0.42u l=1u
X352 VDD VSS.t1390 VDD VDD sg13_lv_pmos ad=0.19p pd=1.38u as=0 ps=0 w=1u l=1u
X353 VSS.t1272 VDD VSS.t1273 VSS.t305 sg13_lv_nmos ad=79.8f pd=0.8u as=0 ps=0 w=0.42u l=1u
X354 VDD VSS.t2042 VDD VDD sg13_lv_pmos ad=0.34p pd=2.68u as=0 ps=0 w=1u l=1u
X355 VSS.t2765 VDD VSS.t2765 VSS.t2710 sg13_lv_nmos ad=0.1428p pd=1.52u as=0 ps=0 w=0.42u l=1u
X356 VSS.t984 VDD VSS.t986 VSS.t985 sg13_lv_nmos ad=79.8f pd=0.8u as=0 ps=0 w=0.42u l=1u
X357 VSS.t432 VDD VSS.t434 VSS.t433 sg13_lv_nmos ad=79.8f pd=0.8u as=0 ps=0 w=0.42u l=1u
X358 VDD VSS.t973 VDD VDD sg13_lv_pmos ad=0.34p pd=2.68u as=0 ps=0 w=1u l=1u
X359 VDD VSS.t1810 VDD VDD sg13_lv_pmos ad=0.34p pd=2.68u as=0 ps=0 w=1u l=1u
X360 a_19727_13799# a_18885_13701# a_18468_14040# VDD sg13_lv_pmos ad=0.2048p pd=1.63u as=0.34p ps=2.68u w=1u l=0.13u
X361 VDD VSS.t52 VDD VDD sg13_lv_pmos ad=0.34p pd=2.68u as=0 ps=0 w=1u l=1u
X362 VDD VSS.t1098 VDD VDD sg13_lv_pmos ad=0.34p pd=2.68u as=0 ps=0 w=1u l=1u
X363 VSS.t1661 VDD VSS.t1663 VSS.t1662 sg13_lv_nmos ad=79.8f pd=0.8u as=0 ps=0 w=0.42u l=1u
X364 VSS.t3190 VDD VSS.t3192 VSS.t3191 sg13_lv_nmos ad=79.8f pd=0.8u as=0 ps=0 w=0.42u l=1u
X365 VSS.t2435 VDD VSS.t2437 VSS.t2436 sg13_lv_nmos ad=79.8f pd=0.8u as=0 ps=0 w=0.42u l=1u
X366 sg13g2_buf_16_1.X a_16078_14484# VSS.t66 VSS.t37 sg13_lv_nmos ad=0.1406p pd=1.12u as=0.1406p ps=1.12u w=0.74u l=0.13u
X367 VSS.t859 VDD VSS.t861 VSS.t860 sg13_lv_nmos ad=79.8f pd=0.8u as=0 ps=0 w=0.42u l=1u
X368 VDD VSS.t848 VDD VDD sg13_lv_pmos ad=0.34p pd=2.68u as=0 ps=0 w=1u l=1u
X369 VDD VSS.t2499 VDD VDD sg13_lv_pmos ad=0.34p pd=2.68u as=0 ps=0 w=1u l=1u
X370 VDD VSS.t2157 VDD VDD sg13_lv_pmos ad=0.34p pd=2.68u as=0 ps=0 w=1u l=1u
X371 VDD VSS.t724 VDD VDD sg13_lv_pmos ad=0.19p pd=1.38u as=0 ps=0 w=1u l=1u
X372 VDD VSS.t1036 VDD VDD sg13_lv_pmos ad=0.19p pd=1.38u as=0 ps=0 w=1u l=1u
X373 VDD VSS.t498 VDD VDD sg13_lv_pmos ad=0.34p pd=2.68u as=0 ps=0 w=1u l=1u
X374 VDD VSS.t664 VDD VDD sg13_lv_pmos ad=0.19p pd=1.38u as=0 ps=0 w=1u l=1u
X375 VDD VSS.t705 VDD VDD sg13_lv_pmos ad=0.19p pd=1.38u as=0 ps=0 w=1u l=1u
X376 VSS.t413 VDD VSS.t415 VSS.t414 sg13_lv_nmos ad=79.8f pd=0.8u as=0 ps=0 w=0.42u l=1u
X377 sg13g2_dlygate4sd3_1_0.A a_9162_15532# VDD VDD sg13_lv_pmos ad=0.3808p pd=2.92u as=0.2128p ps=1.5u w=1.12u l=0.13u
X378 VSS.t705 VDD VSS.t705 VSS.t825 sg13_lv_nmos ad=0.1428p pd=1.52u as=0 ps=0 w=0.42u l=1u
X379 VDD VSS.t1313 VDD VDD sg13_lv_pmos ad=0.19p pd=1.38u as=0 ps=0 w=1u l=1u
X380 VDD VSS.t2820 VDD VDD sg13_lv_pmos ad=0.19p pd=1.38u as=0 ps=0 w=1u l=1u
X381 VSS.t2520 VDD VSS.t2519 VSS.t2518 sg13_lv_nmos ad=0.1428p pd=1.52u as=0 ps=0 w=0.42u l=1u
X382 VSS.t2133 VDD VSS.t2135 VSS.t2134 sg13_lv_nmos ad=79.8f pd=0.8u as=0 ps=0 w=0.42u l=1u
X383 sg13g2_buf_4_0.X a_9269_13726# VDD VDD sg13_lv_pmos ad=0.2128p pd=1.5u as=0.2128p ps=1.5u w=1.12u l=0.13u
X384 VSS.t7 a_10967_15315# a_10967_15315# VSS.t3295 sg13_lv_nmos ad=5.1665p pd=33.355u as=0.111p ps=1.34u w=0.3u l=0.13u
X385 VSS.t671 VDD VSS.t671 VSS.t670 sg13_lv_nmos ad=0.1428p pd=1.52u as=0 ps=0 w=0.42u l=1u
X386 VDD VSS.t2200 VDD VDD sg13_lv_pmos ad=0.19p pd=1.38u as=0 ps=0 w=1u l=1u
X387 VSS.t147 VDD VSS.t127 VSS.t3 sg13_lv_nmos ad=0.1428p pd=1.52u as=0 ps=0 w=0.42u l=1u
X388 VSS.t554 VDD VSS.t554 VSS.t556 sg13_lv_nmos ad=79.8f pd=0.8u as=0 ps=0 w=0.42u l=1u
X389 VSS.t954 VDD VSS.t953 VSS.t952 sg13_lv_nmos ad=0.1428p pd=1.52u as=0 ps=0 w=0.42u l=1u
X390 VSS.t1248 VDD VSS.t1249 VSS.t305 sg13_lv_nmos ad=79.8f pd=0.8u as=0 ps=0 w=0.42u l=1u
X391 VDD VSS.t92 VDD VDD sg13_lv_pmos ad=0.19p pd=1.38u as=0 ps=0 w=1u l=1u
X392 VSS.t49 a_4912_15454# a_4561_15311# VSS.t65 sg13_lv_nmos ad=79.8f pd=0.8u as=0.1428p ps=1.52u w=0.42u l=0.13u
X393 VSS.t999 VDD VSS.t998 VSS.t997 sg13_lv_nmos ad=0.1428p pd=1.52u as=0 ps=0 w=0.42u l=1u
X394 VSS.t2758 VDD VSS.t2757 VSS.t2710 sg13_lv_nmos ad=0.1428p pd=1.52u as=0 ps=0 w=0.42u l=1u
X395 a_3813_15213# sg13g2_dfrbpq_1_2.CLK VSS.t7 VSS.t84 sg13_lv_nmos ad=0.2516p pd=2.16u as=4.79747p ps=30.975u w=0.74u l=0.13u
X396 a_25956_15552# a_25930_15457# VDD VDD sg13_lv_pmos ad=0.34p pd=2.68u as=0.36237p ps=2.605u w=1u l=0.13u
X397 a_13956_14909# a_14187_14495# a_13642_14452# VSS.t168 sg13_lv_nmos ad=0.2373p pd=1.97u as=79.8f ps=0.8u w=0.42u l=0.13u
X398 a_14025_14531# a_13668_14488# VDD VDD sg13_lv_pmos ad=63f pd=0.72u as=0.1563p ps=1.22u w=0.42u l=0.13u
X399 VSS.t2585 VDD VSS.t2587 VSS.t2586 sg13_lv_nmos ad=79.8f pd=0.8u as=0 ps=0 w=0.42u l=1u
X400 VDD VSS.t733 VDD VDD sg13_lv_pmos ad=0.19p pd=1.38u as=0 ps=0 w=1u l=1u
X401 VDD VSS.t1618 VDD VDD sg13_lv_pmos ad=0.19p pd=1.38u as=0 ps=0 w=1u l=1u
X402 VDD VSS.t1795 VDD VDD sg13_lv_pmos ad=0.34p pd=2.68u as=0 ps=0 w=1u l=1u
X403 VDD VSS.t3089 VDD VDD sg13_lv_pmos ad=0.34p pd=2.68u as=0 ps=0 w=1u l=1u
X404 VDD VSS.t1987 VDD VDD sg13_lv_pmos ad=0.34p pd=2.68u as=0 ps=0 w=1u l=1u
X405 VSS.t2083 VDD VSS.t2085 VSS.t2084 sg13_lv_nmos ad=79.8f pd=0.8u as=0 ps=0 w=0.42u l=1u
X406 VDD VSS.t391 VDD VDD sg13_lv_pmos ad=0.19p pd=1.38u as=0 ps=0 w=1u l=1u
X407 VSS.t2738 VDD VSS.t2737 VSS.t2710 sg13_lv_nmos ad=0.1428p pd=1.52u as=0 ps=0 w=0.42u l=1u
X408 VSS.t137 a_11866_15202# a_11585_15424# VSS.t139 sg13_lv_nmos ad=79.8f pd=0.8u as=0.1428p ps=1.52u w=0.42u l=0.5u
X409 VSS.t664 VDD VSS.t664 VSS.t757 sg13_lv_nmos ad=0.1428p pd=1.52u as=0 ps=0 w=0.42u l=1u
X410 VSS.t714 VDD VSS.t714 VSS.t831 sg13_lv_nmos ad=0.1428p pd=1.52u as=0 ps=0 w=0.42u l=1u
X411 VDD VSS.t1658 VDD VDD sg13_lv_pmos ad=0.19p pd=1.38u as=0 ps=0 w=1u l=1u
X412 VDD VSS.t2783 VDD VDD sg13_lv_pmos ad=0.19p pd=1.38u as=0 ps=0 w=1u l=1u
X413 VDD VSS.t1003 VDD VDD sg13_lv_pmos ad=0.34p pd=2.68u as=0 ps=0 w=1u l=1u
X414 VDD VSS.t1298 VDD VDD sg13_lv_pmos ad=0.34p pd=2.68u as=0 ps=0 w=1u l=1u
X415 VDD VSS.t636 VDD VDD sg13_lv_pmos ad=0.34p pd=2.68u as=0 ps=0 w=1u l=1u
X416 VSS.t1334 VDD VSS.t1335 VSS.t305 sg13_lv_nmos ad=79.8f pd=0.8u as=0 ps=0 w=0.42u l=1u
X417 VDD VSS.t2319 VDD VDD sg13_lv_pmos ad=0.34p pd=2.68u as=0 ps=0 w=1u l=1u
X418 VSS.t2380 VDD VSS.t2382 VSS.t2381 sg13_lv_nmos ad=79.8f pd=0.8u as=0 ps=0 w=0.42u l=1u
X419 VDD VSS.t664 VDD VDD sg13_lv_pmos ad=0.19p pd=1.38u as=0 ps=0 w=1u l=1u
X420 VSS.t2736 VDD VSS.t2734 VSS.t2710 sg13_lv_nmos ad=0.1428p pd=1.52u as=0 ps=0 w=0.42u l=1u
X421 VSS.t1928 VDD VSS.t1927 VSS.t1926 sg13_lv_nmos ad=0.1428p pd=1.52u as=0 ps=0 w=0.42u l=1u
X422 VSS.t2825 VDD VSS.t2826 VSS.t2710 sg13_lv_nmos ad=79.8f pd=0.8u as=0 ps=0 w=0.42u l=1u
X423 a_9269_13726# sg13g2_buf_4_0.A VDD VDD sg13_lv_pmos ad=0.1596p pd=1.22u as=0.2856p ps=2.36u w=0.84u l=0.13u
X424 VSS.t1338 VDD VSS.t1339 VSS.t305 sg13_lv_nmos ad=79.8f pd=0.8u as=0 ps=0 w=0.42u l=1u
X425 VSS.t1671 VDD VSS.t1670 VSS.t1669 sg13_lv_nmos ad=0.1428p pd=1.52u as=0 ps=0 w=0.42u l=1u
X426 VSS.t2420 VDD VSS.t2422 VSS.t2421 sg13_lv_nmos ad=79.8f pd=0.8u as=0 ps=0 w=0.42u l=1u
X427 VDD VSS.t2362 VDD VDD sg13_lv_pmos ad=0.19p pd=1.38u as=0 ps=0 w=1u l=1u
X428 VDD VSS.t1018 VDD VDD sg13_lv_pmos ad=0.34p pd=2.68u as=0 ps=0 w=1u l=1u
X429 VDD VSS.t3157 VDD VDD sg13_lv_pmos ad=0.19p pd=1.38u as=0 ps=0 w=1u l=1u
X430 a_12335_14845# a_11493_14495# a_11076_14488# VDD sg13_lv_pmos ad=0.2048p pd=1.63u as=0.34p ps=2.68u w=1u l=0.13u
X431 VSS.t7 a_19173_14495# a_19275_14495# VSS.t142 sg13_lv_nmos ad=5.1665p pd=33.355u as=0.2516p ps=2.16u w=0.74u l=0.13u
X432 VDD VSS.t545 VDD VDD sg13_lv_pmos ad=0.34p pd=2.68u as=0 ps=0 w=1u l=1u
X433 VDD VSS.t1320 VDD VDD sg13_lv_pmos ad=0.34p pd=2.68u as=0 ps=0 w=1u l=1u
X434 VDD VSS.t2826 VDD VDD sg13_lv_pmos ad=0.34p pd=2.68u as=0 ps=0 w=1u l=1u
X435 VSS.t2 sg13g2_xor2_1_1.A a_13782_13738# VSS.t60 sg13_lv_nmos ad=0.15245p pd=1.17u as=88.8f ps=0.98u w=0.74u l=0.13u
X436 VDD VSS.t1276 VDD VDD sg13_lv_pmos ad=0.19p pd=1.38u as=0 ps=0 w=1u l=1u
X437 VSS.t1646 VDD VSS.t1648 VSS.t1647 sg13_lv_nmos ad=79.8f pd=0.8u as=0 ps=0 w=0.42u l=1u
X438 VDD VSS.t276 VDD VDD sg13_lv_pmos ad=0.34p pd=2.68u as=0 ps=0 w=1u l=1u
X439 VSS.t2038 VDD VSS.t2037 VSS.t2036 sg13_lv_nmos ad=0.1428p pd=1.52u as=0 ps=0 w=0.42u l=1u
X440 VSS.t573 VDD VSS.t569 VSS.t572 sg13_lv_nmos ad=0.1428p pd=1.52u as=0 ps=0 w=0.42u l=1u
X441 VDD VSS.t1081 VDD VDD sg13_lv_pmos ad=0.19p pd=1.38u as=0 ps=0 w=1u l=1u
X442 VSS.t1487 VDD VSS.t1348 VSS.t305 sg13_lv_nmos ad=79.8f pd=0.8u as=0 ps=0 w=0.42u l=1u
X443 VDD VSS.t461 VDD VDD sg13_lv_pmos ad=0.19p pd=1.38u as=0 ps=0 w=1u l=1u
X444 VDD VSS.t1665 VDD VDD sg13_lv_pmos ad=0.34p pd=2.68u as=0 ps=0 w=1u l=1u
X445 VSS.t2570 VDD VSS.t2572 VSS.t2571 sg13_lv_nmos ad=79.8f pd=0.8u as=0 ps=0 w=0.42u l=1u
X446 VDD VSS.t683 VDD VDD sg13_lv_pmos ad=0.34p pd=2.68u as=0 ps=0 w=1u l=1u
X447 VDD VSS.t2512 VDD VDD sg13_lv_pmos ad=0.19p pd=1.38u as=0 ps=0 w=1u l=1u
X448 a_16571_15532# sg13g2_inv_1_0.Y sg13g2_a21oi_1_0.Y VDD sg13_lv_pmos ad=0.2128p pd=1.5u as=0.3808p ps=2.92u w=1.12u l=0.13u
X449 VDD a_26927_14845# a_27184_14726# VDD sg13_lv_pmos ad=2.75157p pd=17.885u as=79.8f ps=0.8u w=0.42u l=0.13u
X450 VSS.t1736 VDD VSS.t1738 VSS.t1737 sg13_lv_nmos ad=79.8f pd=0.8u as=0 ps=0 w=0.42u l=1u
X451 VSS.t2118 VDD VSS.t2120 VSS.t2119 sg13_lv_nmos ad=79.8f pd=0.8u as=0 ps=0 w=0.42u l=1u
X452 VSS.t1114 VDD VSS.t1116 VSS.t1115 sg13_lv_nmos ad=79.8f pd=0.8u as=0 ps=0 w=0.42u l=1u
X453 VDD VSS.t2012 VDD VDD sg13_lv_pmos ad=0.34p pd=2.68u as=0 ps=0 w=1u l=1u
X454 sg13g2_inv_1_1.A a_27594_14484# VDD VDD sg13_lv_pmos ad=0.3808p pd=2.92u as=0.2128p ps=1.5u w=1.12u l=0.13u
X455 VSS.t999 VDD VSS.t998 VSS.t997 sg13_lv_nmos ad=0.1428p pd=1.52u as=0 ps=0 w=0.42u l=1u
X456 VDD VSS.t2185 VDD VDD sg13_lv_pmos ad=0.19p pd=1.38u as=0 ps=0 w=1u l=1u
X457 VDD VSS.t463 VDD VDD sg13_lv_pmos ad=0.34p pd=2.68u as=0 ps=0 w=1u l=1u
X458 a_20015_14845# a_19173_14495# a_18756_14488# VDD sg13_lv_pmos ad=0.2048p pd=1.63u as=0.34p ps=2.68u w=1u l=0.13u
X459 VSS.t540 VDD VSS.t540 VSS.t594 sg13_lv_nmos ad=0.1428p pd=1.52u as=0 ps=0 w=0.42u l=1u
X460 VDD VSS.t981 VDD VDD sg13_lv_pmos ad=0.19p pd=1.38u as=0 ps=0 w=1u l=1u
X461 VDD VSS.t3142 VDD VDD sg13_lv_pmos ad=0.19p pd=1.38u as=0 ps=0 w=1u l=1u
X462 VDD VSS.t2347 VDD VDD sg13_lv_pmos ad=0.19p pd=1.38u as=0 ps=0 w=1u l=1u
X463 a_25930_15457# a_26373_15213# a_25670_15234# VSS.t3300 sg13_lv_nmos ad=79.8f pd=0.8u as=0.1296p ps=1.52u w=0.42u l=0.13u
X464 VSS.t2750 VDD VSS.t2750 VSS.t2710 sg13_lv_nmos ad=0.1428p pd=1.52u as=0 ps=0 w=0.42u l=1u
X465 VDD VSS.t2137 VDD VDD sg13_lv_pmos ad=0.34p pd=2.68u as=0 ps=0 w=1u l=1u
X466 VDD VSS.t540 VDD VDD sg13_lv_pmos ad=0.34p pd=2.68u as=0 ps=0 w=1u l=1u
X467 VDD VSS.t1256 VDD VDD sg13_lv_pmos ad=0.34p pd=2.68u as=0 ps=0 w=1u l=1u
X468 VDD VSS.t1780 VDD VDD sg13_lv_pmos ad=0.34p pd=2.68u as=0 ps=0 w=1u l=1u
X469 VDD VSS.t1972 VDD VDD sg13_lv_pmos ad=0.34p pd=2.68u as=0 ps=0 w=1u l=1u
X470 VSS.t2068 VDD VSS.t2070 VSS.t2069 sg13_lv_nmos ad=79.8f pd=0.8u as=0 ps=0 w=0.42u l=1u
X471 VDD sg13g2_nand2_1_1.A sg13g2_o21ai_1_0.Y VDD sg13_lv_pmos ad=0.3808p pd=2.92u as=0.2128p ps=1.5u w=1.12u l=0.15u
X472 VSS.t564 VDD VSS.t564 VSS.t567 sg13_lv_nmos ad=0.1428p pd=1.52u as=0 ps=0 w=0.42u l=1u
X473 VDD VSS.t634 VDD VDD sg13_lv_pmos ad=0.19p pd=1.38u as=0 ps=0 w=1u l=1u
X474 VDD VSS.t686 VDD VDD sg13_lv_pmos ad=0.19p pd=1.38u as=0 ps=0 w=1u l=1u
X475 VSS.t1631 VDD VSS.t1633 VSS.t1632 sg13_lv_nmos ad=79.8f pd=0.8u as=0 ps=0 w=0.42u l=1u
X476 VSS.t3160 VDD VSS.t3162 VSS.t3161 sg13_lv_nmos ad=79.8f pd=0.8u as=0 ps=0 w=0.42u l=1u
X477 VSS.t2365 VDD VSS.t2367 VSS.t2366 sg13_lv_nmos ad=79.8f pd=0.8u as=0 ps=0 w=0.42u l=1u
X478 VSS.t705 VDD VSS.t705 VSS.t711 sg13_lv_nmos ad=0.1428p pd=1.52u as=0 ps=0 w=0.42u l=1u
X479 VSS.t683 VDD VSS.t683 VSS.t790 sg13_lv_nmos ad=79.8f pd=0.8u as=0 ps=0 w=0.42u l=1u
X480 a_3813_15213# sg13g2_dfrbpq_1_2.CLK VDD VDD sg13_lv_pmos ad=0.4088p pd=2.97u as=2.35643p ps=14.81u w=1.12u l=0.13u
X481 VDD VSS.t1324 VDD VDD sg13_lv_pmos ad=0.34p pd=2.68u as=0 ps=0 w=1u l=1u
X482 VSS.t1316 VDD VSS.t1317 VSS.t305 sg13_lv_nmos ad=79.8f pd=0.8u as=0 ps=0 w=0.42u l=1u
X483 VDD VSS.t1643 VDD VDD sg13_lv_pmos ad=0.19p pd=1.38u as=0 ps=0 w=1u l=1u
X484 VDD VSS.t569 VDD VDD sg13_lv_pmos ad=0.34p pd=2.68u as=0 ps=0 w=1u l=1u
X485 a_17715_13320# sg13g2_or3_1_0.X VSS.t243 VSS.t290 sg13_lv_nmos ad=0.1406p pd=1.12u as=0.2516p ps=2.16u w=0.74u l=0.13u
X486 VDD VSS.t856 VDD VDD sg13_lv_pmos ad=0.19p pd=1.38u as=0 ps=0 w=1u l=1u
X487 VSS.t2440 VDD VSS.t2442 VSS.t2441 sg13_lv_nmos ad=79.8f pd=0.8u as=0 ps=0 w=0.42u l=1u
X488 VDD VSS.t2504 VDD VDD sg13_lv_pmos ad=0.34p pd=2.68u as=0 ps=0 w=1u l=1u
X489 VDD VSS.t2714 VDD VDD sg13_lv_pmos ad=0.34p pd=2.68u as=0 ps=0 w=1u l=1u
X490 a_24943_14508# sg13g2_nor2b_1_1.Y a_24766_14854# VDD sg13_lv_pmos ad=0.2975p pd=1.595u as=0.2225p ps=1.445u w=1u l=0.13u
X491 VDD VSS.t1265 VDD VDD sg13_lv_pmos ad=0.34p pd=2.68u as=0 ps=0 w=1u l=1u
X492 VSS.t2727 VDD VSS.t2726 VSS.t2710 sg13_lv_nmos ad=0.1428p pd=1.52u as=0 ps=0 w=0.42u l=1u
X493 VSS.t1365 VDD VSS.t1366 VSS.t305 sg13_lv_nmos ad=79.8f pd=0.8u as=0 ps=0 w=0.42u l=1u
X494 VDD sg13g2_mux2_1_0.X a_24824_15238# VDD sg13_lv_pmos ad=0.1523p pd=1.38u as=0.1428p ps=1.52u w=0.42u l=0.13u
X495 VDD VSS.t926 VDD VDD sg13_lv_pmos ad=0.19p pd=1.38u as=0 ps=0 w=1u l=1u
X496 VDD VSS.t1351 VDD VDD sg13_lv_pmos ad=0.19p pd=1.38u as=0 ps=0 w=1u l=1u
X497 VDD VSS.t2856 VDD VDD sg13_lv_pmos ad=0.19p pd=1.38u as=0 ps=0 w=1u l=1u
X498 VSS.t2585 VDD VSS.t2584 VSS.t2583 sg13_lv_nmos ad=0.1428p pd=1.52u as=0 ps=0 w=0.42u l=1u
X499 VSS.t2405 VDD VSS.t2407 VSS.t2406 sg13_lv_nmos ad=79.8f pd=0.8u as=0 ps=0 w=0.42u l=1u
X500 VDD VSS.t2170 VDD VDD sg13_lv_pmos ad=0.19p pd=1.38u as=0 ps=0 w=1u l=1u
X501 a_24333_15280# sg13g2_nor2b_1_1.A VDD VDD sg13_lv_pmos ad=0.1596p pd=1.22u as=0.2856p ps=2.36u w=0.84u l=0.13u
X502 VSS.t2760 VDD VSS.t2760 VSS.t2710 sg13_lv_nmos ad=0.1428p pd=1.52u as=0 ps=0 w=0.42u l=1u
X503 sg13g2_and2_1_0.X a_2733_14832# VDD VDD sg13_lv_pmos ad=0.3808p pd=2.92u as=0.1918p ps=1.5u w=1.12u l=0.13u
X504 VDD VSS.t3094 VDD VDD sg13_lv_pmos ad=0.34p pd=2.68u as=0 ps=0 w=1u l=1u
X505 VSS.t2828 VDD VSS.t2827 VSS.t2710 sg13_lv_nmos ad=0.1428p pd=1.52u as=0 ps=0 w=0.42u l=1u
X506 VDD VSS.t1957 VDD VDD sg13_lv_pmos ad=0.34p pd=2.68u as=0 ps=0 w=1u l=1u
X507 VSS.t1811 VDD VSS.t1810 VSS.t1809 sg13_lv_nmos ad=0.1428p pd=1.52u as=0 ps=0 w=0.42u l=1u
X508 VDD a_16078_14484# sg13g2_buf_16_1.X VDD sg13_lv_pmos ad=0.2128p pd=1.5u as=0.2128p ps=1.5u w=1.12u l=0.13u
X509 VDD VSS.t1011 VDD VDD sg13_lv_pmos ad=0.19p pd=1.38u as=0 ps=0 w=1u l=1u
X510 VDD VSS.t1663 VDD VDD sg13_lv_pmos ad=0.19p pd=1.38u as=0 ps=0 w=1u l=1u
X511 VDD VSS.t2537 VDD VDD sg13_lv_pmos ad=0.19p pd=1.38u as=0 ps=0 w=1u l=1u
X512 VSS.t3115 VDD VSS.t3114 VSS.t3113 sg13_lv_nmos ad=0.1428p pd=1.52u as=0 ps=0 w=0.42u l=1u
X513 VSS.t449 VDD VSS.t451 VSS.t450 sg13_lv_nmos ad=79.8f pd=0.8u as=0 ps=0 w=0.42u l=1u
X514 VSS.t235 a_22508_15960# counter_value_o[4] VSS.t234 sg13_lv_nmos ad=0.14875p pd=1.16u as=0.2886p ps=2.26u w=0.74u l=0.13u
X515 VDD VSS.t2818 VDD VDD sg13_lv_pmos ad=0.19p pd=1.38u as=0 ps=0 w=1u l=1u
X516 VSS.t2555 VDD VSS.t2557 VSS.t2556 sg13_lv_nmos ad=79.8f pd=0.8u as=0 ps=0 w=0.42u l=1u
X517 VSS.t7 a_3689_14822# a_3610_14725# VSS.t176 sg13_lv_nmos ad=5.1665p pd=33.355u as=0.27427p ps=2.28u w=0.795u l=0.13u
X518 VDD VSS.t1356 VDD VDD sg13_lv_pmos ad=0.34p pd=2.68u as=0 ps=0 w=1u l=1u
X519 VSS.t1114 VDD VSS.t1116 VSS.t1115 sg13_lv_nmos ad=79.8f pd=0.8u as=0 ps=0 w=0.42u l=1u
X520 VDD sg13g2_dlygate4sd3_1_0.A sg13g2_xor2_1_1.B VDD sg13_lv_pmos ad=0.2128p pd=1.5u as=0.2128p ps=1.5u w=1.12u l=0.13u
X521 VSS.t2718 VDD VSS.t2716 VSS.t2710 sg13_lv_nmos ad=0.1428p pd=1.52u as=0 ps=0 w=0.42u l=1u
X522 VDD VSS.t2592 VDD VDD sg13_lv_pmos ad=0.19p pd=1.38u as=0 ps=0 w=1u l=1u
X523 VSS.t1307 VDD VSS.t1306 VSS.t305 sg13_lv_nmos ad=0.1428p pd=1.52u as=0 ps=0 w=0.42u l=1u
X524 VSS.t763 VDD VSS.t669 VSS.t764 sg13_lv_nmos ad=79.8f pd=0.8u as=0 ps=0 w=0.42u l=1u
X525 VSS.t2425 VDD VSS.t2427 VSS.t2426 sg13_lv_nmos ad=79.8f pd=0.8u as=0 ps=0 w=0.42u l=1u
X526 VDD VSS.t1997 VDD VDD sg13_lv_pmos ad=0.34p pd=2.68u as=0 ps=0 w=1u l=1u
X527 a_7210_15457# a_7653_15213# a_6950_15234# VSS.t44 sg13_lv_nmos ad=79.8f pd=0.8u as=0.1296p ps=1.52u w=0.42u l=0.13u
X528 VDD sg13g2_buf_16_1.X a_12308_15202# VDD sg13_lv_pmos ad=0.2128p pd=1.5u as=0.2128p ps=1.5u w=1.12u l=0.13u
X529 sg13g2_inv_1_1.A a_27594_14484# VSS.t79 VSS.t134 sg13_lv_nmos ad=0.2516p pd=2.16u as=0.1406p ps=1.12u w=0.74u l=0.13u
X530 VSS.t974 VDD VSS.t973 VSS.t972 sg13_lv_nmos ad=0.1428p pd=1.52u as=0 ps=0 w=0.42u l=1u
X531 VDD VSS.t2332 VDD VDD sg13_lv_pmos ad=0.19p pd=1.38u as=0 ps=0 w=1u l=1u
X532 VSS.t2198 VDD VSS.t2200 VSS.t2199 sg13_lv_nmos ad=79.8f pd=0.8u as=0 ps=0 w=0.42u l=1u
X533 VDD VSS.t705 VDD VDD sg13_lv_pmos ad=0.19p pd=1.38u as=0 ps=0 w=1u l=1u
X534 VSS.t1450 VDD VSS.t1301 VSS.t305 sg13_lv_nmos ad=79.8f pd=0.8u as=0 ps=0 w=0.42u l=1u
X535 VDD VSS.t1393 VDD VDD sg13_lv_pmos ad=0.19p pd=1.38u as=0 ps=0 w=1u l=1u
X536 VDD VSS.t2122 VDD VDD sg13_lv_pmos ad=0.34p pd=2.68u as=0 ps=0 w=1u l=1u
X537 VDD VSS.t634 VDD VDD sg13_lv_pmos ad=0.19p pd=1.38u as=0 ps=0 w=1u l=1u
X538 VSS.t1796 VDD VSS.t1795 VSS.t1794 sg13_lv_nmos ad=0.1428p pd=1.52u as=0 ps=0 w=0.42u l=1u
X539 a_25862_15996# a_25592_16037# VSS.t77 VSS.t76 sg13_lv_nmos ad=0.1428p pd=1.52u as=79.8f ps=0.8u w=0.42u l=0.5u
X540 sg13g2_nand2_2_0.Y sg13g2_nand2_2_0.A a_16089_13723# VSS.t359 sg13_lv_nmos ad=0.1368p pd=1.1u as=0.1404p ps=1.11u w=0.72u l=0.13u
X541 VSS.t849 VDD VSS.t848 VSS.t847 sg13_lv_nmos ad=0.1428p pd=1.52u as=0 ps=0 w=0.42u l=1u
X542 VDD VSS.t1805 VDD VDD sg13_lv_pmos ad=0.34p pd=2.68u as=0 ps=0 w=1u l=1u
X543 VDD a_16078_14484# sg13g2_buf_16_1.X VDD sg13_lv_pmos ad=0.2128p pd=1.5u as=0.2128p ps=1.5u w=1.12u l=0.13u
X544 VSS.t1034 VDD VSS.t1036 VSS.t1035 sg13_lv_nmos ad=79.8f pd=0.8u as=0 ps=0 w=0.42u l=1u
X545 VDD VSS.t2489 VDD VDD sg13_lv_pmos ad=0.34p pd=2.68u as=0 ps=0 w=1u l=1u
X546 VDD VSS.t1635 VDD VDD sg13_lv_pmos ad=0.34p pd=2.68u as=0 ps=0 w=1u l=1u
X547 VDD VSS.t412 VDD VDD sg13_lv_pmos ad=0.34p pd=2.68u as=0 ps=0 w=1u l=1u
X548 VSS.t2540 VDD VSS.t2542 VSS.t2541 sg13_lv_nmos ad=79.8f pd=0.8u as=0 ps=0 w=0.42u l=1u
X549 VSS.t326 sg13g2_inv_1_0.Y sg13g2_dfrbpq_1_3.D VSS.t325 sg13_lv_nmos ad=0.2516p pd=2.16u as=0.1406p ps=1.12u w=0.74u l=0.13u
X550 VDD VSS.t714 VDD VDD sg13_lv_pmos ad=0.19p pd=1.38u as=0 ps=0 w=1u l=1u
X551 VDD VSS.t56 VDD VDD sg13_lv_pmos ad=0.34p pd=2.68u as=0 ps=0 w=1u l=1u
X552 VSS.t733 VDD VSS.t733 VSS.t846 sg13_lv_nmos ad=79.8f pd=0.8u as=0 ps=0 w=0.42u l=1u
X553 VSS.t1706 VDD VSS.t1708 VSS.t1707 sg13_lv_nmos ad=79.8f pd=0.8u as=0 ps=0 w=0.42u l=1u
X554 VDD VSS.t2017 VDD VDD sg13_lv_pmos ad=0.34p pd=2.68u as=0 ps=0 w=1u l=1u
X555 VDD VSS.t502 VDD VDD sg13_lv_pmos ad=0.19p pd=1.38u as=0 ps=0 w=1u l=1u
X556 VSS.t1283 VDD VSS.t1282 VSS.t305 sg13_lv_nmos ad=0.1428p pd=1.52u as=0 ps=0 w=0.42u l=1u
X557 VDD VSS.t1241 VDD VDD sg13_lv_pmos ad=0.34p pd=2.68u as=0 ps=0 w=1u l=1u
X558 VDD VSS.t1342 VDD VDD sg13_lv_pmos ad=0.19p pd=1.38u as=0 ps=0 w=1u l=1u
X559 VDD VSS.t2847 VDD VDD sg13_lv_pmos ad=0.19p pd=1.38u as=0 ps=0 w=1u l=1u
X560 VDD a_12308_15202# sg13g2_dfrbpq_1_2.CLK VDD sg13_lv_pmos ad=0.2128p pd=1.5u as=0.2128p ps=1.5u w=1.12u l=0.13u
X561 VDD VSS.t1373 VDD VDD sg13_lv_pmos ad=0.34p pd=2.68u as=0 ps=0 w=1u l=1u
X562 VSS.t2753 VDD VSS.t2752 VSS.t2710 sg13_lv_nmos ad=0.1428p pd=1.52u as=0 ps=0 w=0.42u l=1u
X563 VSS.t2570 VDD VSS.t2569 VSS.t2568 sg13_lv_nmos ad=0.1428p pd=1.52u as=0 ps=0 w=0.42u l=1u
X564 VSS.t2183 VDD VSS.t2185 VSS.t2184 sg13_lv_nmos ad=79.8f pd=0.8u as=0 ps=0 w=0.42u l=1u
X565 VDD VSS.t1118 VDD VDD sg13_lv_pmos ad=0.34p pd=2.68u as=0 ps=0 w=1u l=1u
X566 a_16056_15552# sg13g2_buf_4_0.X VDD VDD sg13_lv_pmos ad=0.2128p pd=1.5u as=0.3808p ps=2.92u w=1.12u l=0.15u
X567 VSS.t272 sg13g2_buf_4_0.X sg13g2_nor4_2_0.Y VSS.t7 sg13_lv_nmos ad=0.3293p pd=1.63u as=0.1406p ps=1.12u w=0.74u l=0.13u
X568 VSS.t1325 VDD VSS.t1324 VSS.t305 sg13_lv_nmos ad=0.1428p pd=1.52u as=0 ps=0 w=0.42u l=1u
X569 VSS.t2073 VDD VSS.t2075 VSS.t2074 sg13_lv_nmos ad=79.8f pd=0.8u as=0 ps=0 w=0.42u l=1u
X570 VDD a_18970_16237# sg13g2_dfrbpq_1_6.RESET_B VDD sg13_lv_pmos ad=2.4406p pd=15.34u as=0.3927p ps=2.99u w=1.155u l=0.13u
X571 VSS.t3165 VDD VSS.t3167 VSS.t3166 sg13_lv_nmos ad=79.8f pd=0.8u as=0 ps=0 w=0.42u l=1u
X572 VSS.t2370 VDD VSS.t2372 VSS.t2371 sg13_lv_nmos ad=79.8f pd=0.8u as=0 ps=0 w=0.42u l=1u
X573 VSS.t502 VDD VSS.t502 VSS.t504 sg13_lv_nmos ad=0.1428p pd=1.52u as=0 ps=0 w=0.42u l=1u
X574 a_20217_14607# a_19275_14495# a_20015_14845# VDD sg13_lv_pmos ad=93.45f pd=0.865u as=0.2048p ps=1.63u w=0.42u l=0.13u
X575 VSS.t1004 VDD VSS.t1003 VSS.t1002 sg13_lv_nmos ad=0.1428p pd=1.52u as=0 ps=0 w=0.42u l=1u
X576 VDD VSS.t1648 VDD VDD sg13_lv_pmos ad=0.19p pd=1.38u as=0 ps=0 w=1u l=1u
X577 VSS.t71 VDD VSS.t71 VSS.t536 sg13_lv_nmos ad=0.1428p pd=1.52u as=0 ps=0 w=0.42u l=1u
X578 VSS.t32 VDD VSS.t32 VSS.t584 sg13_lv_nmos ad=0.1428p pd=1.52u as=0 ps=0 w=0.42u l=1u
X579 VDD VSS.t1056 VDD VDD sg13_lv_pmos ad=0.19p pd=1.38u as=0 ps=0 w=1u l=1u
X580 VDD VSS.t1703 VDD VDD sg13_lv_pmos ad=0.19p pd=1.38u as=0 ps=0 w=1u l=1u
X581 VSS.t2445 VDD VSS.t2447 VSS.t2446 sg13_lv_nmos ad=79.8f pd=0.8u as=0 ps=0 w=0.42u l=1u
X582 VDD VSS.t394 VDD VDD sg13_lv_pmos ad=0.19p pd=1.38u as=0 ps=0 w=1u l=1u
X583 VDD VSS.t2474 VDD VDD sg13_lv_pmos ad=0.34p pd=2.68u as=0 ps=0 w=1u l=1u
X584 VSS.t2751 VDD VSS.t2751 VSS.t2710 sg13_lv_nmos ad=0.1428p pd=1.52u as=0 ps=0 w=0.42u l=1u
X585 VDD VSS.t719 VDD VDD sg13_lv_pmos ad=0.19p pd=1.38u as=0 ps=0 w=1u l=1u
X586 VDD VSS.t1985 VDD VDD sg13_lv_pmos ad=0.19p pd=1.38u as=0 ps=0 w=1u l=1u
X587 VDD VSS.t2810 VDD VDD sg13_lv_pmos ad=0.19p pd=1.38u as=0 ps=0 w=1u l=1u
X588 VSS.t714 VDD VSS.t714 VSS.t833 sg13_lv_nmos ad=0.1428p pd=1.52u as=0 ps=0 w=0.42u l=1u
X589 VSS.t1666 VDD VSS.t1665 VSS.t1664 sg13_lv_nmos ad=0.1428p pd=1.52u as=0 ps=0 w=0.42u l=1u
X590 VSS.t3195 VDD VSS.t3194 VSS.t3193 sg13_lv_nmos ad=0.1428p pd=1.52u as=0 ps=0 w=0.42u l=1u
X591 sg13g2_dfrbpq_1_7.CLK a_19630_15238# VDD VDD sg13_lv_pmos ad=0.2128p pd=1.5u as=0.2128p ps=1.5u w=1.12u l=0.13u
X592 VDD VSS.t2392 VDD VDD sg13_lv_pmos ad=0.19p pd=1.38u as=0 ps=0 w=1u l=1u
X593 VDD VSS.t2784 VDD VDD sg13_lv_pmos ad=0.34p pd=2.68u as=0 ps=0 w=1u l=1u
X594 VSS.t522 VDD VSS.t521 VSS.t520 sg13_lv_nmos ad=0.1428p pd=1.52u as=0 ps=0 w=0.42u l=1u
X595 VSS.t974 VDD VSS.t973 VSS.t972 sg13_lv_nmos ad=0.1428p pd=1.52u as=0 ps=0 w=0.42u l=1u
X596 VSS.t564 VDD VSS.t564 VSS.t566 sg13_lv_nmos ad=79.8f pd=0.8u as=0 ps=0 w=0.42u l=1u
X597 VDD VSS.t931 VDD VDD sg13_lv_pmos ad=0.19p pd=1.38u as=0 ps=0 w=1u l=1u
X598 VDD VSS.t2577 VDD VDD sg13_lv_pmos ad=0.19p pd=1.38u as=0 ps=0 w=1u l=1u
X599 VDD VSS.t1354 VDD VDD sg13_lv_pmos ad=0.19p pd=1.38u as=0 ps=0 w=1u l=1u
X600 VSS.t1661 VDD VSS.t1660 VSS.t1659 sg13_lv_nmos ad=0.1428p pd=1.52u as=0 ps=0 w=0.42u l=1u
X601 VDD VSS.t2859 VDD VDD sg13_lv_pmos ad=0.19p pd=1.38u as=0 ps=0 w=1u l=1u
X602 VSS.t2590 VDD VSS.t2589 VSS.t2588 sg13_lv_nmos ad=0.1428p pd=1.52u as=0 ps=0 w=0.42u l=1u
X603 VSS.t2410 VDD VSS.t2412 VSS.t2411 sg13_lv_nmos ad=79.8f pd=0.8u as=0 ps=0 w=0.42u l=1u
X604 VDD VSS.t2175 VDD VDD sg13_lv_pmos ad=0.19p pd=1.38u as=0 ps=0 w=1u l=1u
X605 VDD VSS.t569 VDD VDD sg13_lv_pmos ad=0.19p pd=1.38u as=0 ps=0 w=1u l=1u
X606 VDD VSS.t2529 VDD VDD sg13_lv_pmos ad=0.34p pd=2.68u as=0 ps=0 w=1u l=1u
X607 VDD VSS.t3099 VDD VDD sg13_lv_pmos ad=0.34p pd=2.68u as=0 ps=0 w=1u l=1u
X608 VSS.t700 VDD VSS.t700 VSS.t699 sg13_lv_nmos ad=0.1428p pd=1.52u as=0 ps=0 w=0.42u l=1u
X609 VDD VSS.t2135 VDD VDD sg13_lv_pmos ad=0.19p pd=1.38u as=0 ps=0 w=1u l=1u
X610 VSS.t2138 VDD VSS.t2137 VSS.t2136 sg13_lv_nmos ad=0.1428p pd=1.52u as=0 ps=0 w=0.42u l=1u
X611 a_13278_15934# a_13079_16071# VSS.t74 VSS.t3306 sg13_lv_nmos ad=0.27427p pd=2.28u as=5.31717p ps=34.515u w=0.795u l=0.13u
X612 VSS.t849 VDD VSS.t848 VSS.t847 sg13_lv_nmos ad=0.1428p pd=1.52u as=0 ps=0 w=0.42u l=1u
X613 VSS.t1034 VDD VSS.t1036 VSS.t1035 sg13_lv_nmos ad=79.8f pd=0.8u as=0 ps=0 w=0.42u l=1u
X614 VDD VSS.t1309 VDD VDD sg13_lv_pmos ad=0.34p pd=2.68u as=0 ps=0 w=1u l=1u
X615 VDD VSS.t545 VDD VDD sg13_lv_pmos ad=0.34p pd=2.68u as=0 ps=0 w=1u l=1u
X616 VDD VSS.t1633 VDD VDD sg13_lv_pmos ad=0.19p pd=1.38u as=0 ps=0 w=1u l=1u
X617 VDD VSS.t1688 VDD VDD sg13_lv_pmos ad=0.19p pd=1.38u as=0 ps=0 w=1u l=1u
X618 VDD VSS.t49 VDD VDD sg13_lv_pmos ad=0.34p pd=2.68u as=0 ps=0 w=1u l=1u
X619 VDD VSS.t2749 VDD VDD sg13_lv_pmos ad=0.19p pd=1.38u as=0 ps=0 w=1u l=1u
X620 VDD VSS.t2821 VDD VDD sg13_lv_pmos ad=0.19p pd=1.38u as=0 ps=0 w=1u l=1u
X621 VSS.t2088 VDD VSS.t2087 VSS.t2086 sg13_lv_nmos ad=0.1428p pd=1.52u as=0 ps=0 w=0.42u l=1u
X622 a_2513_15288# sg13g2_buf_1_0.X VSS.t167 VSS.t347 sg13_lv_nmos ad=0.17462p pd=1.185u as=0.374p ps=2.46u w=0.55u l=0.13u
X623 VDD VSS.t963 VDD VDD sg13_lv_pmos ad=0.34p pd=2.68u as=0 ps=0 w=1u l=1u
X624 VSS.t3180 VDD VSS.t3179 VSS.t3178 sg13_lv_nmos ad=0.1428p pd=1.52u as=0 ps=0 w=0.42u l=1u
X625 VSS.t2385 VDD VSS.t2384 VSS.t2383 sg13_lv_nmos ad=0.1428p pd=1.52u as=0 ps=0 w=0.42u l=1u
X626 sg13g2_dfrbpq_1_7.CLK a_19630_15238# VDD VDD sg13_lv_pmos ad=0.2128p pd=1.5u as=0.2128p ps=1.5u w=1.12u l=0.13u
X627 VSS.t545 VDD VSS.t545 VSS.t550 sg13_lv_nmos ad=0.1428p pd=1.52u as=0 ps=0 w=0.42u l=1u
X628 VSS.t2721 VDD VSS.t2720 VSS.t2710 sg13_lv_nmos ad=0.1428p pd=1.52u as=0 ps=0 w=0.42u l=1u
X629 VSS.t2812 VDD VSS.t2813 VSS.t2710 sg13_lv_nmos ad=79.8f pd=0.8u as=0 ps=0 w=0.42u l=1u
X630 VDD VSS.t2562 VDD VDD sg13_lv_pmos ad=0.19p pd=1.38u as=0 ps=0 w=1u l=1u
X631 VSS.t66 a_16078_14484# sg13g2_buf_16_1.X VSS.t37 sg13_lv_nmos ad=0.1406p pd=1.12u as=0.1406p ps=1.12u w=0.74u l=0.13u
X632 VDD VSS.t554 VDD VDD sg13_lv_pmos ad=0.34p pd=2.68u as=0 ps=0 w=1u l=1u
X633 VDD VSS.t2002 VDD VDD sg13_lv_pmos ad=0.34p pd=2.68u as=0 ps=0 w=1u l=1u
X634 VDD VSS.t3132 VDD VDD sg13_lv_pmos ad=0.19p pd=1.38u as=0 ps=0 w=1u l=1u
X635 VDD VSS.t2337 VDD VDD sg13_lv_pmos ad=0.19p pd=1.38u as=0 ps=0 w=1u l=1u
X636 a_18885_13701# sg13g2_dfrbpq_1_7.CLK VSS.t202 VSS.t201 sg13_lv_nmos ad=0.2516p pd=2.16u as=30.06137p ps=0.20218m w=0.74u l=0.13u
X637 VSS.t2168 VDD VSS.t2170 VSS.t2169 sg13_lv_nmos ad=79.8f pd=0.8u as=0 ps=0 w=0.42u l=1u
X638 VSS.t662 VDD VSS.t661 VSS.t660 sg13_lv_nmos ad=0.1428p pd=1.52u as=0 ps=0 w=0.42u l=1u
X639 VDD VSS.t2127 VDD VDD sg13_lv_pmos ad=0.34p pd=2.68u as=0 ps=0 w=1u l=1u
X640 VSS.t1004 VDD VSS.t1003 VSS.t1002 sg13_lv_nmos ad=0.1428p pd=1.52u as=0 ps=0 w=0.42u l=1u
X641 VSS.t1381 VDD VSS.t1381 VSS.t305 sg13_lv_nmos ad=0.1428p pd=1.52u as=0 ps=0 w=0.42u l=1u
X642 VSS.t487 VDD VSS.t487 VSS.t490 sg13_lv_nmos ad=79.8f pd=0.8u as=0 ps=0 w=0.42u l=1u
X643 VSS.t3150 VDD VSS.t3152 VSS.t3151 sg13_lv_nmos ad=79.8f pd=0.8u as=0 ps=0 w=0.42u l=1u
X644 VSS.t2355 VDD VSS.t2357 VSS.t2356 sg13_lv_nmos ad=79.8f pd=0.8u as=0 ps=0 w=0.42u l=1u
X645 sg13g2_nand3_1_1.Y sg13g2_dlygate4sd3_1_9.A VDD VDD sg13_lv_pmos ad=0.2128p pd=1.5u as=0.3808p ps=2.92u w=1.12u l=0.13u
X646 VDD VSS.t1810 VDD VDD sg13_lv_pmos ad=0.34p pd=2.68u as=0 ps=0 w=1u l=1u
X647 a_17434_15202# sg13g2_o21ai_1_0.Y VSS.t22 VSS.t21 sg13_lv_nmos ad=0.1428p pd=1.52u as=79.8f ps=0.8u w=0.42u l=0.13u
X648 a_11364_14909# a_11595_14495# a_11050_14452# VSS.t140 sg13_lv_nmos ad=0.2373p pd=1.97u as=79.8f ps=0.8u w=0.42u l=0.13u
X649 VSS.t1716 VDD VSS.t1718 VSS.t1717 sg13_lv_nmos ad=79.8f pd=0.8u as=0 ps=0 w=0.42u l=1u
X650 VSS.t2430 VDD VSS.t2432 VSS.t2431 sg13_lv_nmos ad=79.8f pd=0.8u as=0 ps=0 w=0.42u l=1u
X651 VDD VSS.t1640 VDD VDD sg13_lv_pmos ad=0.34p pd=2.68u as=0 ps=0 w=1u l=1u
X652 a_10790_14922# sg13g2_and2_1_2.X VDD VDD sg13_lv_pmos ad=79.8f pd=0.8u as=0.1428p ps=1.52u w=0.42u l=0.13u
X653 a_19630_15238# sg13g2_buf_16_1.X VSS.t103 VSS.t221 sg13_lv_nmos ad=0.1406p pd=1.12u as=0.2516p ps=2.16u w=0.74u l=0.13u
X654 VDD sg13g2_dfrbpq_1_3.RESET_B a_13382_14922# VDD sg13_lv_pmos ad=0.36237p pd=2.605u as=79.8f ps=0.8u w=0.42u l=0.13u
X655 VDD VSS.t2554 VDD VDD sg13_lv_pmos ad=0.34p pd=2.68u as=0 ps=0 w=1u l=1u
X656 VSS.t1711 VDD VSS.t1713 VSS.t1712 sg13_lv_nmos ad=79.8f pd=0.8u as=0 ps=0 w=0.42u l=1u
X657 VDD VSS.t2776 VDD VDD sg13_lv_pmos ad=0.34p pd=2.68u as=0 ps=0 w=1u l=1u
X658 VSS.t924 VDD VSS.t926 VSS.t925 sg13_lv_nmos ad=79.8f pd=0.8u as=0 ps=0 w=0.42u l=1u
X659 VSS.t2823 VDD VSS.t2824 VSS.t2710 sg13_lv_nmos ad=79.8f pd=0.8u as=0 ps=0 w=0.42u l=1u
X660 VDD VSS.t1244 VDD VDD sg13_lv_pmos ad=0.34p pd=2.68u as=0 ps=0 w=1u l=1u
X661 VSS.t7 a_3813_15213# a_3915_15356# VSS.t84 sg13_lv_nmos ad=5.1665p pd=33.355u as=0.2516p ps=2.16u w=0.74u l=0.13u
X662 VDD VSS.t1345 VDD VDD sg13_lv_pmos ad=0.19p pd=1.38u as=0 ps=0 w=1u l=1u
X663 VDD VSS.t2850 VDD VDD sg13_lv_pmos ad=0.19p pd=1.38u as=0 ps=0 w=1u l=1u
X664 VDD VSS.t2160 VDD VDD sg13_lv_pmos ad=0.19p pd=1.38u as=0 ps=0 w=1u l=1u
X665 VSS.t22 a_16078_14484# sg13g2_buf_16_1.X VSS.t37 sg13_lv_nmos ad=0.1406p pd=1.12u as=0.1406p ps=1.12u w=0.74u l=0.13u
X666 VDD VSS.t2514 VDD VDD sg13_lv_pmos ad=0.34p pd=2.68u as=0 ps=0 w=1u l=1u
X667 VSS.t2575 VDD VSS.t2574 VSS.t2573 sg13_lv_nmos ad=0.1428p pd=1.52u as=0 ps=0 w=0.42u l=1u
X668 VDD VSS.t2824 VDD VDD sg13_lv_pmos ad=0.34p pd=2.68u as=0 ps=0 w=1u l=1u
X669 VDD VSS.t654 VDD VDD sg13_lv_pmos ad=0.19p pd=1.38u as=0 ps=0 w=1u l=1u
X670 VSS.t52 VDD VSS.t52 VSS.t799 sg13_lv_nmos ad=79.8f pd=0.8u as=0 ps=0 w=0.42u l=1u
X671 VDD VSS.t54 VDD VDD sg13_lv_pmos ad=0.19p pd=1.38u as=0 ps=0 w=1u l=1u
X672 VDD VSS.t3084 VDD VDD sg13_lv_pmos ad=0.34p pd=2.68u as=0 ps=0 w=1u l=1u
X673 VSS.t1741 VDD VSS.t1740 VSS.t1739 sg13_lv_nmos ad=0.1428p pd=1.52u as=0 ps=0 w=0.42u l=1u
X674 VDD VSS.t2030 VDD VDD sg13_lv_pmos ad=0.19p pd=1.38u as=0 ps=0 w=1u l=1u
X675 VDD VSS.t448 VDD VDD sg13_lv_pmos ad=0.34p pd=2.68u as=0 ps=0 w=1u l=1u
X676 VDD VSS.t1618 VDD VDD sg13_lv_pmos ad=0.19p pd=1.38u as=0 ps=0 w=1u l=1u
X677 VDD VSS.t1795 VDD VDD sg13_lv_pmos ad=0.34p pd=2.68u as=0 ps=0 w=1u l=1u
X678 VSS.t2415 VDD VSS.t2417 VSS.t2416 sg13_lv_nmos ad=79.8f pd=0.8u as=0 ps=0 w=0.42u l=1u
X679 VDD sg13g2_a21oi_1_1.Y a_18104_13013# VDD sg13_lv_pmos ad=0.1523p pd=1.38u as=0.1428p ps=1.52u w=0.42u l=0.13u
X680 VSS.t1254 VDD VSS.t1255 VSS.t305 sg13_lv_nmos ad=79.8f pd=0.8u as=0 ps=0 w=0.42u l=1u
X681 VDD VSS.t2741 VDD VDD sg13_lv_pmos ad=0.19p pd=1.38u as=0 ps=0 w=1u l=1u
X682 VSS.t2370 VDD VSS.t2369 VSS.t2368 sg13_lv_nmos ad=0.1428p pd=1.52u as=0 ps=0 w=0.42u l=1u
X683 VSS.t1636 VDD VSS.t1635 VSS.t1634 sg13_lv_nmos ad=0.1428p pd=1.52u as=0 ps=0 w=0.42u l=1u
X684 VSS.t3165 VDD VSS.t3164 VSS.t3163 sg13_lv_nmos ad=0.1428p pd=1.52u as=0 ps=0 w=0.42u l=1u
X685 VDD VSS.t2397 VDD VDD sg13_lv_pmos ad=0.19p pd=1.38u as=0 ps=0 w=1u l=1u
X686 VSS.t2712 VDD VSS.t2711 VSS.t2710 sg13_lv_nmos ad=0.1428p pd=1.52u as=0 ps=0 w=0.42u l=1u
X687 VDD VSS.t695 VDD VDD sg13_lv_pmos ad=0.34p pd=2.68u as=0 ps=0 w=1u l=1u
X688 sg13g2_dlygate4sd3_1_11.A a_20394_14020# VDD VDD sg13_lv_pmos ad=0.3808p pd=2.92u as=0.2128p ps=1.5u w=1.12u l=0.13u
X689 VDD VSS.t2841 VDD VDD sg13_lv_pmos ad=0.19p pd=1.38u as=0 ps=0 w=1u l=1u
X690 VDD VSS.t2180 VDD VDD sg13_lv_pmos ad=0.19p pd=1.38u as=0 ps=0 w=1u l=1u
X691 a_4666_14448# sg13g2_dlygate4sd3_1_2.A VDD VDD sg13_lv_pmos ad=0.1428p pd=1.52u as=0.1523p ps=1.38u w=0.42u l=0.13u
X692 a_23983_14508# sg13g2_nor2b_1_0.Y a_23806_14854# VDD sg13_lv_pmos ad=0.2975p pd=1.595u as=0.2225p ps=1.445u w=1u l=0.13u
X693 VDD VSS.t621 VDD VDD sg13_lv_pmos ad=0.34p pd=2.68u as=0 ps=0 w=1u l=1u
X694 VSS.t113 a_16078_14484# sg13g2_buf_16_1.X VSS.t37 sg13_lv_nmos ad=0.1406p pd=1.12u as=0.1406p ps=1.12u w=0.74u l=0.13u
X695 VDD VSS.t883 VDD VDD sg13_lv_pmos ad=0.34p pd=2.68u as=0 ps=0 w=1u l=1u
X696 VSS.t1310 VDD VSS.t1309 VSS.t305 sg13_lv_nmos ad=0.1428p pd=1.52u as=0 ps=0 w=0.42u l=1u
X697 VDD VSS.t28 VDD VDD sg13_lv_pmos ad=0.34p pd=2.68u as=0 ps=0 w=1u l=1u
X698 VSS.t1726 VDD VSS.t1725 VSS.t1724 sg13_lv_nmos ad=0.1428p pd=1.52u as=0 ps=0 w=0.42u l=1u
X699 a_7930_14854# sg13g2_buf_1_0.X sg13g2_xnor2_1_0.B VSS.t11 sg13_lv_nmos ad=0.1406p pd=1.12u as=0.2516p ps=2.16u w=0.74u l=0.13u
X700 VSS.t1263 VDD VSS.t1264 VSS.t305 sg13_lv_nmos ad=79.8f pd=0.8u as=0 ps=0 w=0.42u l=1u
X701 VSS.t1701 VDD VSS.t1703 VSS.t1702 sg13_lv_nmos ad=79.8f pd=0.8u as=0 ps=0 w=0.42u l=1u
X702 VDD VSS.t2377 VDD VDD sg13_lv_pmos ad=0.19p pd=1.38u as=0 ps=0 w=1u l=1u
X703 VSS.t2595 VDD VSS.t2594 VSS.t2593 sg13_lv_nmos ad=0.1428p pd=1.52u as=0 ps=0 w=0.42u l=1u
X704 VSS.t1268 VDD VSS.t1269 VSS.t305 sg13_lv_nmos ad=79.8f pd=0.8u as=0 ps=0 w=0.42u l=1u
X705 VDD VSS.t1975 VDD VDD sg13_lv_pmos ad=0.19p pd=1.38u as=0 ps=0 w=1u l=1u
X706 VSS.t2093 VDD VSS.t2092 VSS.t2091 sg13_lv_nmos ad=0.1428p pd=1.52u as=0 ps=0 w=0.42u l=1u
X707 VSS.t1656 VDD VSS.t1655 VSS.t1654 sg13_lv_nmos ad=0.1428p pd=1.52u as=0 ps=0 w=0.42u l=1u
X708 VSS.t3185 VDD VSS.t3184 VSS.t3183 sg13_lv_nmos ad=0.1428p pd=1.52u as=0 ps=0 w=0.42u l=1u
X709 VDD VSS.t2805 VDD VDD sg13_lv_pmos ad=0.19p pd=1.38u as=0 ps=0 w=1u l=1u
X710 a_22508_14484# sg13g2_nand2_2_0.Y a_22202_14484# VDD sg13_lv_pmos ad=0.2128p pd=1.5u as=0.2128p ps=1.5u w=1.12u l=0.13u
X711 VSS.t924 VDD VSS.t926 VSS.t925 sg13_lv_nmos ad=79.8f pd=0.8u as=0 ps=0 w=0.42u l=1u
X712 VDD VSS.t1665 VDD VDD sg13_lv_pmos ad=0.34p pd=2.68u as=0 ps=0 w=1u l=1u
X713 VDD VSS.t2539 VDD VDD sg13_lv_pmos ad=0.34p pd=2.68u as=0 ps=0 w=1u l=1u
X714 VSS.t1696 VDD VSS.t1698 VSS.t1697 sg13_lv_nmos ad=79.8f pd=0.8u as=0 ps=0 w=0.42u l=1u
X715 VDD VSS.t71 VDD VDD sg13_lv_pmos ad=0.34p pd=2.68u as=0 ps=0 w=1u l=1u
X716 sg13g2_a21oi_1_1.Y sg13g2_dlygate4sd3_1_3.X a_17715_13320# VSS.t301 sg13_lv_nmos ad=0.1406p pd=1.12u as=0.1406p ps=1.12u w=0.74u l=0.13u
X717 VSS.t2815 VDD VSS.t2816 VSS.t2710 sg13_lv_nmos ad=79.8f pd=0.8u as=0 ps=0 w=0.42u l=1u
X718 VDD VSS.t2567 VDD VDD sg13_lv_pmos ad=0.19p pd=1.38u as=0 ps=0 w=1u l=1u
X719 VDD VSS.t714 VDD VDD sg13_lv_pmos ad=0.19p pd=1.38u as=0 ps=0 w=1u l=1u
X720 VDD VSS.t2007 VDD VDD sg13_lv_pmos ad=0.34p pd=2.68u as=0 ps=0 w=1u l=1u
X721 VDD VSS.t3137 VDD VDD sg13_lv_pmos ad=0.19p pd=1.38u as=0 ps=0 w=1u l=1u
X722 VSS.t2400 VDD VSS.t2402 VSS.t2401 sg13_lv_nmos ad=79.8f pd=0.8u as=0 ps=0 w=0.42u l=1u
X723 VDD VSS.t2342 VDD VDD sg13_lv_pmos ad=0.19p pd=1.38u as=0 ps=0 w=1u l=1u
X724 VDD VSS.t654 VDD VDD sg13_lv_pmos ad=0.19p pd=1.38u as=0 ps=0 w=1u l=1u
X725 VDD VSS.t1038 VDD VDD sg13_lv_pmos ad=0.34p pd=2.68u as=0 ps=0 w=1u l=1u
X726 VSS.t2173 VDD VSS.t2175 VSS.t2174 sg13_lv_nmos ad=79.8f pd=0.8u as=0 ps=0 w=0.42u l=1u
X727 VDD VSS.t1282 VDD VDD sg13_lv_pmos ad=0.19p pd=1.38u as=0 ps=0 w=1u l=1u
X728 VDD VSS.t1308 VDD VDD sg13_lv_pmos ad=0.34p pd=2.68u as=0 ps=0 w=1u l=1u
X729 VDD VSS.t2816 VDD VDD sg13_lv_pmos ad=0.34p pd=2.68u as=0 ps=0 w=1u l=1u
X730 VSS.t1354 VDD VSS.t1354 VSS.t305 sg13_lv_nmos ad=79.8f pd=0.8u as=0 ps=0 w=0.42u l=1u
X731 VSS.t418 VDD VSS.t417 VSS.t416 sg13_lv_nmos ad=0.1428p pd=1.52u as=0 ps=0 w=0.42u l=1u
X732 VDD a_3813_15213# a_3915_15356# VDD sg13_lv_pmos ad=2.4406p pd=15.34u as=0.3864p ps=2.93u w=1.12u l=0.13u
X733 VDD a_25094_15238# a_25206_15302# VDD sg13_lv_pmos ad=0.2254p pd=1.53u as=0.34p ps=2.68u w=1u l=0.5u
X734 VSS.t683 VDD VSS.t683 VSS.t684 sg13_lv_nmos ad=79.8f pd=0.8u as=0 ps=0 w=0.42u l=1u
X735 VDD VSS.t1780 VDD VDD sg13_lv_pmos ad=0.34p pd=2.68u as=0 ps=0 w=1u l=1u
X736 VDD VSS.t2192 VDD VDD sg13_lv_pmos ad=0.34p pd=2.68u as=0 ps=0 w=1u l=1u
X737 VDD VSS.t2015 VDD VDD sg13_lv_pmos ad=0.19p pd=1.38u as=0 ps=0 w=1u l=1u
X738 VSS.t1686 VDD VSS.t1688 VSS.t1687 sg13_lv_nmos ad=79.8f pd=0.8u as=0 ps=0 w=0.42u l=1u
X739 VSS.t3215 VDD VSS.t3217 VSS.t3216 sg13_lv_nmos ad=79.8f pd=0.8u as=0 ps=0 w=0.42u l=1u
X740 VSS.t2580 VDD VSS.t2579 VSS.t2578 sg13_lv_nmos ad=0.1428p pd=1.52u as=0 ps=0 w=0.42u l=1u
X741 VDD VSS.t1645 VDD VDD sg13_lv_pmos ad=0.34p pd=2.68u as=0 ps=0 w=1u l=1u
X742 VSS.t351 a_26926_13911# sg13g2_nor2b_1_1.A VSS.t350 sg13_lv_nmos ad=0.1426p pd=1.16u as=0.2516p ps=2.16u w=0.74u l=0.13u
X743 VSS.t2861 VDD VSS.t2862 VSS.t2710 sg13_lv_nmos ad=79.8f pd=0.8u as=0 ps=0 w=0.42u l=1u
X744 VDD VSS.t1053 VDD VDD sg13_lv_pmos ad=0.34p pd=2.68u as=0 ps=0 w=1u l=1u
X745 a_18756_14488# a_19275_14495# a_20015_14845# VSS.t7 sg13_lv_nmos ad=0.3473p pd=2.71u as=0.12665p ps=1.145u w=0.74u l=0.13u
X746 VDD VSS.t2559 VDD VDD sg13_lv_pmos ad=0.34p pd=2.68u as=0 ps=0 w=1u l=1u
X747 VDD VSS.t2779 VDD VDD sg13_lv_pmos ad=0.34p pd=2.68u as=0 ps=0 w=1u l=1u
X748 a_18182_13722# sg13g2_dlygate4sd3_1_10.X VDD VDD sg13_lv_pmos ad=79.8f pd=0.8u as=0.1428p ps=1.52u w=0.42u l=0.13u
X749 VSS.t652 VDD VSS.t654 VSS.t653 sg13_lv_nmos ad=79.8f pd=0.8u as=0 ps=0 w=0.42u l=1u
X750 VDD VSS.t621 VDD VDD sg13_lv_pmos ad=0.34p pd=2.68u as=0 ps=0 w=1u l=1u
X751 VDD VSS.t1348 VDD VDD sg13_lv_pmos ad=0.19p pd=1.38u as=0 ps=0 w=1u l=1u
X752 VDD VSS.t2833 VDD VDD sg13_lv_pmos ad=0.19p pd=1.38u as=0 ps=0 w=1u l=1u
X753 VDD VSS.t2165 VDD VDD sg13_lv_pmos ad=0.19p pd=1.38u as=0 ps=0 w=1u l=1u
X754 VSS.t89 a_12308_15202# sg13g2_dfrbpq_1_2.CLK VSS.t197 sg13_lv_nmos ad=0.1406p pd=1.12u as=0.1406p ps=1.12u w=0.74u l=0.13u
X755 VDD VSS.t2519 VDD VDD sg13_lv_pmos ad=0.34p pd=2.68u as=0 ps=0 w=1u l=1u
X756 VSS.t2545 VDD VSS.t2544 VSS.t2543 sg13_lv_nmos ad=0.1428p pd=1.52u as=0 ps=0 w=0.42u l=1u
X757 VSS.t1336 VDD VSS.t1336 VSS.t305 sg13_lv_nmos ad=0.1428p pd=1.52u as=0 ps=0 w=0.42u l=1u
X758 VSS.t394 VDD VSS.t394 VSS.t397 sg13_lv_nmos ad=79.8f pd=0.8u as=0 ps=0 w=0.42u l=1u
X759 VSS.t3045 VDD VSS.t3047 VSS.t3046 sg13_lv_nmos ad=79.8f pd=0.8u as=0 ps=0 w=0.42u l=1u
X760 VSS.t1711 VDD VSS.t1710 VSS.t1709 sg13_lv_nmos ad=0.1428p pd=1.52u as=0 ps=0 w=0.42u l=1u
X761 VSS.t2128 VDD VSS.t2127 VSS.t2126 sg13_lv_nmos ad=0.1428p pd=1.52u as=0 ps=0 w=0.42u l=1u
X762 VDD VSS.t573 VDD VDD sg13_lv_pmos ad=0.19p pd=1.38u as=0 ps=0 w=1u l=1u
X763 VDD VSS.t664 VDD VDD sg13_lv_pmos ad=0.34p pd=2.68u as=0 ps=0 w=1u l=1u
X764 VSS.t1472 VDD VSS.t1331 VSS.t305 sg13_lv_nmos ad=79.8f pd=0.8u as=0 ps=0 w=0.42u l=1u
X765 VDD VSS.t876 VDD VDD sg13_lv_pmos ad=0.19p pd=1.38u as=0 ps=0 w=1u l=1u
X766 VDD VSS.t1678 VDD VDD sg13_lv_pmos ad=0.19p pd=1.38u as=0 ps=0 w=1u l=1u
X767 VDD VSS.t3149 VDD VDD sg13_lv_pmos ad=0.34p pd=2.68u as=0 ps=0 w=1u l=1u
X768 VDD VSS.t2354 VDD VDD sg13_lv_pmos ad=0.34p pd=2.68u as=0 ps=0 w=1u l=1u
X769 a_13612_15996# sg13g2_dlygate4sd3_1_4.X sg13g2_dfrbpq_1_3.D VDD sg13_lv_pmos ad=0.1176p pd=1.33u as=0.3808p ps=2.92u w=1.12u l=0.13u
X770 sg13g2_nor2b_1_1.Y a_24334_13764# VSS.t54 VSS.t311 sg13_lv_nmos ad=0.1406p pd=1.12u as=0.17255p ps=1.25u w=0.74u l=0.13u
X771 VDD VSS.t1314 VDD VDD sg13_lv_pmos ad=0.19p pd=1.38u as=0 ps=0 w=1u l=1u
X772 VSS.t1371 VDD VSS.t1372 VSS.t305 sg13_lv_nmos ad=79.8f pd=0.8u as=0 ps=0 w=0.42u l=1u
X773 VSS.t559 VDD VSS.t559 VSS.t608 sg13_lv_nmos ad=0.1428p pd=1.52u as=0 ps=0 w=0.42u l=1u
X774 VDD VSS.t1960 VDD VDD sg13_lv_pmos ad=0.19p pd=1.38u as=0 ps=0 w=1u l=1u
X775 VDD VSS.t2744 VDD VDD sg13_lv_pmos ad=0.19p pd=1.38u as=0 ps=0 w=1u l=1u
X776 VDD VSS.t2797 VDD VDD sg13_lv_pmos ad=0.19p pd=1.38u as=0 ps=0 w=1u l=1u
X777 VSS.t2375 VDD VSS.t2374 VSS.t2373 sg13_lv_nmos ad=0.1428p pd=1.52u as=0 ps=0 w=0.42u l=1u
X778 VSS.t2078 VDD VSS.t2077 VSS.t2076 sg13_lv_nmos ad=0.1428p pd=1.52u as=0 ps=0 w=0.42u l=1u
X779 VDD sg13g2_dfrbpq_1_4.RESET_B a_25930_15457# VDD sg13_lv_pmos ad=0.1563p pd=1.22u as=0.147p ps=1.54u w=0.42u l=0.13u
X780 VSS.t517 VDD VSS.t167 VSS.t518 sg13_lv_nmos ad=79.8f pd=0.8u as=0 ps=0 w=0.42u l=1u
X781 VSS.t1641 VDD VSS.t1640 VSS.t1639 sg13_lv_nmos ad=0.1428p pd=1.52u as=0 ps=0 w=0.42u l=1u
X782 VSS.t3170 VDD VSS.t3169 VSS.t3168 sg13_lv_nmos ad=0.1428p pd=1.52u as=0 ps=0 w=0.42u l=1u
X783 VDD VSS.t1277 VDD VDD sg13_lv_pmos ad=0.34p pd=2.68u as=0 ps=0 w=1u l=1u
X784 a_21946_14854# sg13g2_or3_1_0.A VSS.t127 VSS.t7 sg13_lv_nmos ad=0.1406p pd=1.12u as=0.2516p ps=2.16u w=0.74u l=0.13u
X785 sg13g2_buf_16_1.X a_16078_14484# VDD VDD sg13_lv_pmos ad=0.2128p pd=1.5u as=0.2128p ps=1.5u w=1.12u l=0.13u
X786 VDD VSS.t2552 VDD VDD sg13_lv_pmos ad=0.19p pd=1.38u as=0 ps=0 w=1u l=1u
X787 VSS.t2450 VDD VSS.t2449 VSS.t2448 sg13_lv_nmos ad=0.1428p pd=1.52u as=0 ps=0 w=0.42u l=1u
X788 VDD sg13g2_dlygate4sd3_1_0.A a_7048_15996# VDD sg13_lv_pmos ad=0.2114p pd=1.54u as=0.2856p ps=2.36u w=0.84u l=0.13u
X789 VDD VSS.t531 VDD VDD sg13_lv_pmos ad=0.19p pd=1.38u as=0 ps=0 w=1u l=1u
X790 VDD VSS.t1083 VDD VDD sg13_lv_pmos ad=0.34p pd=2.68u as=0 ps=0 w=1u l=1u
X791 VDD VSS.t1241 VDD VDD sg13_lv_pmos ad=0.19p pd=1.38u as=0 ps=0 w=1u l=1u
X792 VDD VSS.t1339 VDD VDD sg13_lv_pmos ad=0.19p pd=1.38u as=0 ps=0 w=1u l=1u
X793 VDD VSS.t2844 VDD VDD sg13_lv_pmos ad=0.19p pd=1.38u as=0 ps=0 w=1u l=1u
X794 VDD VSS.t2150 VDD VDD sg13_lv_pmos ad=0.19p pd=1.38u as=0 ps=0 w=1u l=1u
X795 VDD VSS.t891 VDD VDD sg13_lv_pmos ad=0.19p pd=1.38u as=0 ps=0 w=1u l=1u
X796 VSS.t2565 VDD VSS.t2564 VSS.t2563 sg13_lv_nmos ad=0.1428p pd=1.52u as=0 ps=0 w=0.42u l=1u
X797 VSS.t2385 VDD VSS.t2387 VSS.t2386 sg13_lv_nmos ad=79.8f pd=0.8u as=0 ps=0 w=0.42u l=1u
X798 VDD VSS.t2327 VDD VDD sg13_lv_pmos ad=0.19p pd=1.38u as=0 ps=0 w=1u l=1u
X799 VSS.t2859 VDD VSS.t2860 VSS.t2710 sg13_lv_nmos ad=79.8f pd=0.8u as=0 ps=0 w=0.42u l=1u
X800 VDD VSS.t554 VDD VDD sg13_lv_pmos ad=0.34p pd=2.68u as=0 ps=0 w=1u l=1u
X801 VSS.t1731 VDD VSS.t1730 VSS.t1729 sg13_lv_nmos ad=0.1428p pd=1.52u as=0 ps=0 w=0.42u l=1u
X802 sg13g2_mux2_1_0.X a_23806_14854# VDD VDD sg13_lv_pmos ad=0.6048p pd=3.32u as=0.2198p ps=1.52u w=1.12u l=0.13u
X803 VDD VSS.t2422 VDD VDD sg13_lv_pmos ad=0.19p pd=1.38u as=0 ps=0 w=1u l=1u
X804 VDD a_37484_15960# counter_value_o[7] VDD sg13_lv_pmos ad=0.2114p pd=1.54u as=0.42p ps=2.99u w=1.12u l=0.13u
X805 VDD a_24443_14540# a_24943_14508# VDD sg13_lv_pmos ad=0.2198p pd=1.52u as=0.2975p ps=1.595u w=1u l=0.13u
X806 VSS.t1119 VDD VSS.t1118 VSS.t1117 sg13_lv_nmos ad=0.1428p pd=1.52u as=0 ps=0 w=0.42u l=1u
X807 VDD VSS.t1354 VDD VDD sg13_lv_pmos ad=0.34p pd=2.68u as=0 ps=0 w=1u l=1u
X808 VDD VSS.t2860 VDD VDD sg13_lv_pmos ad=0.34p pd=2.68u as=0 ps=0 w=1u l=1u
X809 VDD VSS.t2177 VDD VDD sg13_lv_pmos ad=0.34p pd=2.68u as=0 ps=0 w=1u l=1u
X810 VSS.t1385 VDD VSS.t1386 VSS.t305 sg13_lv_nmos ad=79.8f pd=0.8u as=0 ps=0 w=0.42u l=1u
X811 VDD VSS.t2205 VDD VDD sg13_lv_pmos ad=0.19p pd=1.38u as=0 ps=0 w=1u l=1u
X812 VSS.t2028 VDD VSS.t2030 VSS.t2029 sg13_lv_nmos ad=79.8f pd=0.8u as=0 ps=0 w=0.42u l=1u
X813 VDD VSS.t733 VDD VDD sg13_lv_pmos ad=0.34p pd=2.68u as=0 ps=0 w=1u l=1u
X814 a_18086_15238# a_17816_15238# VDD VDD sg13_lv_pmos ad=0.34p pd=2.68u as=0.1523p ps=1.38u w=1u l=0.5u
X815 VDD VSS.t1630 VDD VDD sg13_lv_pmos ad=0.34p pd=2.68u as=0 ps=0 w=1u l=1u
X816 VDD VSS.t1980 VDD VDD sg13_lv_pmos ad=0.19p pd=1.38u as=0 ps=0 w=1u l=1u
X817 VSS.t559 VDD VSS.t559 VSS.t560 sg13_lv_nmos ad=0.1428p pd=1.52u as=0 ps=0 w=0.42u l=1u
X818 VSS.t2852 VDD VSS.t2853 VSS.t2710 sg13_lv_nmos ad=79.8f pd=0.8u as=0 ps=0 w=0.42u l=1u
X819 VDD VSS.t2808 VDD VDD sg13_lv_pmos ad=0.19p pd=1.38u as=0 ps=0 w=1u l=1u
X820 VDD VSS.t686 VDD VDD sg13_lv_pmos ad=0.34p pd=2.68u as=0 ps=0 w=1u l=1u
X821 VSS.t1307 VDD VSS.t1308 VSS.t305 sg13_lv_nmos ad=79.8f pd=0.8u as=0 ps=0 w=0.42u l=1u
X822 VDD VSS.t1635 VDD VDD sg13_lv_pmos ad=0.34p pd=2.68u as=0 ps=0 w=1u l=1u
X823 VDD VSS.t564 VDD VDD sg13_lv_pmos ad=0.34p pd=2.68u as=0 ps=0 w=1u l=1u
X824 VDD VSS.t2572 VDD VDD sg13_lv_pmos ad=0.19p pd=1.38u as=0 ps=0 w=1u l=1u
X825 sg13g2_buf_16_1.X a_16078_14484# VDD VDD sg13_lv_pmos ad=0.2128p pd=1.5u as=0.2128p ps=1.5u w=1.12u l=0.13u
X826 VDD VSS.t1046 VDD VDD sg13_lv_pmos ad=0.19p pd=1.38u as=0 ps=0 w=1u l=1u
X827 VDD VSS.t2822 VDD VDD sg13_lv_pmos ad=0.34p pd=2.68u as=0 ps=0 w=1u l=1u
X828 VDD sg13g2_dfrbpq_1_2.RESET_B a_11050_14452# VDD sg13_lv_pmos ad=0.1563p pd=1.22u as=0.147p ps=1.54u w=0.42u l=0.13u
X829 VSS.t1761 VDD VSS.t1763 VSS.t1762 sg13_lv_nmos ad=79.8f pd=0.8u as=0 ps=0 w=0.42u l=1u
X830 VSS.t2178 VDD VSS.t2180 VSS.t2179 sg13_lv_nmos ad=79.8f pd=0.8u as=0 ps=0 w=0.42u l=1u
X831 VSS.t929 VDD VSS.t931 VSS.t930 sg13_lv_nmos ad=79.8f pd=0.8u as=0 ps=0 w=0.42u l=1u
X832 VSS.t2850 VDD VSS.t2851 VSS.t2710 sg13_lv_nmos ad=79.8f pd=0.8u as=0 ps=0 w=0.42u l=1u
X833 VSS.t3030 VDD VSS.t3032 VSS.t3031 sg13_lv_nmos ad=79.8f pd=0.8u as=0 ps=0 w=0.42u l=1u
X834 VDD VSS.t695 VDD VDD sg13_lv_pmos ad=0.34p pd=2.68u as=0 ps=0 w=1u l=1u
X835 VSS.t2063 VDD VSS.t2065 VSS.t2064 sg13_lv_nmos ad=79.8f pd=0.8u as=0 ps=0 w=0.42u l=1u
X836 VDD VSS.t2756 VDD VDD sg13_lv_pmos ad=0.19p pd=1.38u as=0 ps=0 w=1u l=1u
X837 VSS.t2435 VDD VSS.t2434 VSS.t2433 sg13_lv_nmos ad=0.1428p pd=1.52u as=0 ps=0 w=0.42u l=1u
X838 VDD VSS.t2020 VDD VDD sg13_lv_pmos ad=0.19p pd=1.38u as=0 ps=0 w=1u l=1u
X839 VSS.t54 VDD VSS.t54 VSS.t801 sg13_lv_nmos ad=79.8f pd=0.8u as=0 ps=0 w=0.42u l=1u
X840 VDD VSS.t3134 VDD VDD sg13_lv_pmos ad=0.34p pd=2.68u as=0 ps=0 w=1u l=1u
X841 VDD VSS.t2339 VDD VDD sg13_lv_pmos ad=0.34p pd=2.68u as=0 ps=0 w=1u l=1u
X842 VSS.t1691 VDD VSS.t1693 VSS.t1692 sg13_lv_nmos ad=79.8f pd=0.8u as=0 ps=0 w=0.42u l=1u
X843 VSS.t3220 VDD VSS.t3222 VSS.t3221 sg13_lv_nmos ad=79.8f pd=0.8u as=0 ps=0 w=0.42u l=1u
X844 VDD VSS.t2367 VDD VDD sg13_lv_pmos ad=0.19p pd=1.38u as=0 ps=0 w=1u l=1u
X845 VSS.t56 VDD VSS.t56 VSS.t779 sg13_lv_nmos ad=79.8f pd=0.8u as=0 ps=0 w=0.42u l=1u
X846 VSS.t1290 VDD VSS.t1289 VSS.t305 sg13_lv_nmos ad=0.1428p pd=1.52u as=0 ps=0 w=0.42u l=1u
X847 VDD VSS.t1703 VDD VDD sg13_lv_pmos ad=0.19p pd=1.38u as=0 ps=0 w=1u l=1u
X848 VDD sg13g2_dfrbpq_1_1.RESET_B a_7210_15457# VDD sg13_lv_pmos ad=0.1563p pd=1.22u as=0.147p ps=1.54u w=0.42u l=0.13u
X849 a_2827_14832# sg13g2_buf_1_9.X a_2733_14832# VSS.t3294 sg13_lv_nmos ad=0.1216p pd=1.02u as=0.2176p ps=1.96u w=0.64u l=0.13u
X850 VSS.t1591 VDD VSS.t1593 VSS.t1592 sg13_lv_nmos ad=79.8f pd=0.8u as=0 ps=0 w=0.42u l=1u
X851 VSS.t2500 VDD VSS.t2502 VSS.t2501 sg13_lv_nmos ad=79.8f pd=0.8u as=0 ps=0 w=0.42u l=1u
X852 VSS.t1973 VDD VSS.t1975 VSS.t1974 sg13_lv_nmos ad=79.8f pd=0.8u as=0 ps=0 w=0.42u l=1u
X853 VDD VSS.t1013 VDD VDD sg13_lv_pmos ad=0.34p pd=2.68u as=0 ps=0 w=1u l=1u
X854 a_8986_14448# sg13g2_dlygate4sd3_1_0.A VDD VDD sg13_lv_pmos ad=0.1428p pd=1.52u as=0.1523p ps=1.38u w=0.42u l=0.13u
X855 VSS.t454 VDD VSS.t453 VSS.t452 sg13_lv_nmos ad=0.1428p pd=1.52u as=0 ps=0 w=0.42u l=1u
X856 VSS.t92 VDD VSS.t92 VSS.t495 sg13_lv_nmos ad=0.1428p pd=1.52u as=0 ps=0 w=0.42u l=1u
X857 VDD VSS.t1331 VDD VDD sg13_lv_pmos ad=0.19p pd=1.38u as=0 ps=0 w=1u l=1u
X858 VDD VSS.t1992 VDD VDD sg13_lv_pmos ad=0.34p pd=2.68u as=0 ps=0 w=1u l=1u
X859 VDD VSS.t2836 VDD VDD sg13_lv_pmos ad=0.19p pd=1.38u as=0 ps=0 w=1u l=1u
X860 VSS.t884 VDD VSS.t883 VSS.t882 sg13_lv_nmos ad=0.1428p pd=1.52u as=0 ps=0 w=0.42u l=1u
X861 VSS.t2781 VDD VSS.t2782 VSS.t2710 sg13_lv_nmos ad=79.8f pd=0.8u as=0 ps=0 w=0.42u l=1u
X862 VDD VSS.t2814 VDD VDD sg13_lv_pmos ad=0.34p pd=2.68u as=0 ps=0 w=1u l=1u
X863 VSS.t2550 VDD VSS.t2549 VSS.t2548 sg13_lv_nmos ad=0.1428p pd=1.52u as=0 ps=0 w=0.42u l=1u
X864 VSS.t3017 VDD VSS.t3015 VSS.t3016 sg13_lv_nmos ad=79.8f pd=0.8u as=0 ps=0 w=0.42u l=1u
X865 VSS.t1119 VDD VSS.t1118 VSS.t1117 sg13_lv_nmos ad=0.1428p pd=1.52u as=0 ps=0 w=0.42u l=1u
X866 VSS.t1716 VDD VSS.t1715 VSS.t1714 sg13_lv_nmos ad=0.1428p pd=1.52u as=0 ps=0 w=0.42u l=1u
X867 VDD VSS.t1076 VDD VDD sg13_lv_pmos ad=0.19p pd=1.38u as=0 ps=0 w=1u l=1u
X868 VSS.t2825 VDD VSS.t2825 VSS.t2710 sg13_lv_nmos ad=0.1428p pd=1.52u as=0 ps=0 w=0.42u l=1u
X869 VDD VSS.t2584 VDD VDD sg13_lv_pmos ad=0.34p pd=2.68u as=0 ps=0 w=1u l=1u
X870 VDD VSS.t2407 VDD VDD sg13_lv_pmos ad=0.19p pd=1.38u as=0 ps=0 w=1u l=1u
X871 VDD VSS.t673 VDD VDD sg13_lv_pmos ad=0.19p pd=1.38u as=0 ps=0 w=1u l=1u
X872 VDD VSS.t1683 VDD VDD sg13_lv_pmos ad=0.19p pd=1.38u as=0 ps=0 w=1u l=1u
X873 VDD VSS.t3154 VDD VDD sg13_lv_pmos ad=0.34p pd=2.68u as=0 ps=0 w=1u l=1u
X874 VDD VSS.t2359 VDD VDD sg13_lv_pmos ad=0.34p pd=2.68u as=0 ps=0 w=1u l=1u
X875 sg13g2_dlygate4sd3_1_2.A a_5322_15532# VSS.t42 VSS.t3323 sg13_lv_nmos ad=0.2516p pd=2.16u as=0.1406p ps=1.12u w=0.74u l=0.13u
X876 VSS.t766 VDD VSS.t28 VSS.t765 sg13_lv_nmos ad=0.1428p pd=1.52u as=0 ps=0 w=0.42u l=1u
X877 VDD VSS.t2532 VDD VDD sg13_lv_pmos ad=0.19p pd=1.38u as=0 ps=0 w=1u l=1u
X878 VSS.t2193 VDD VSS.t2192 VSS.t2191 sg13_lv_nmos ad=0.1428p pd=1.52u as=0 ps=0 w=0.42u l=1u
X879 VSS.t2013 VDD VSS.t2015 VSS.t2014 sg13_lv_nmos ad=79.8f pd=0.8u as=0 ps=0 w=0.42u l=1u
X880 VSS.t1266 VDD VSS.t1267 VSS.t305 sg13_lv_nmos ad=79.8f pd=0.8u as=0 ps=0 w=0.42u l=1u
X881 VDD VSS.t2190 VDD VDD sg13_lv_pmos ad=0.19p pd=1.38u as=0 ps=0 w=1u l=1u
X882 VSS.t1303 VDD VSS.t1302 VSS.t305 sg13_lv_nmos ad=0.1428p pd=1.52u as=0 ps=0 w=0.42u l=1u
X883 VDD VSS.t1688 VDD VDD sg13_lv_pmos ad=0.19p pd=1.38u as=0 ps=0 w=1u l=1u
X884 VDD VSS.t1394 VDD VDD sg13_lv_pmos ad=0.34p pd=2.68u as=0 ps=0 w=1u l=1u
X885 VDD VSS.t1965 VDD VDD sg13_lv_pmos ad=0.19p pd=1.38u as=0 ps=0 w=1u l=1u
X886 VDD VSS.t2746 VDD VDD sg13_lv_pmos ad=0.19p pd=1.38u as=0 ps=0 w=1u l=1u
X887 VDD VSS.t2800 VDD VDD sg13_lv_pmos ad=0.19p pd=1.38u as=0 ps=0 w=1u l=1u
X888 VSS.t2380 VDD VSS.t2379 VSS.t2378 sg13_lv_nmos ad=0.1428p pd=1.52u as=0 ps=0 w=0.42u l=1u
X889 VSS.t1646 VDD VSS.t1645 VSS.t1644 sg13_lv_nmos ad=0.1428p pd=1.52u as=0 ps=0 w=0.42u l=1u
X890 VSS.t3175 VDD VSS.t3174 VSS.t3173 sg13_lv_nmos ad=0.1428p pd=1.52u as=0 ps=0 w=0.42u l=1u
X891 a_14078_14044# sg13g2_xor2_1_1.B a_13626_13918# VDD sg13_lv_pmos ad=0.1225p pd=1.245u as=0.34p ps=2.68u w=1u l=0.13u
X892 VDD a_26458_13690# a_26177_13912# VDD sg13_lv_pmos ad=0.1523p pd=1.38u as=0.34p ps=2.68u w=1u l=0.5u
X893 VSS.t202 a_18885_13701# a_18987_13844# VSS.t201 sg13_lv_nmos ad=30.06137p pd=0.20218m as=0.2516p ps=2.16u w=0.74u l=0.13u
X894 VDD VSS.t2557 VDD VDD sg13_lv_pmos ad=0.19p pd=1.38u as=0 ps=0 w=1u l=1u
X895 VSS.t2420 VDD VSS.t2419 VSS.t2418 sg13_lv_nmos ad=0.1428p pd=1.52u as=0 ps=0 w=0.42u l=1u
X896 a_19049_16334# a_19173_16033# VDD VDD sg13_lv_pmos ad=0.2442p pd=2.06u as=2.4406p ps=15.34u w=0.66u l=0.13u
X897 VSS.t1039 VDD VSS.t1038 VSS.t1037 sg13_lv_nmos ad=0.1428p pd=1.52u as=0 ps=0 w=0.42u l=1u
X898 VSS.t929 VDD VSS.t931 VSS.t930 sg13_lv_nmos ad=79.8f pd=0.8u as=0 ps=0 w=0.42u l=1u
X899 VDD VSS.t903 VDD VDD sg13_lv_pmos ad=0.34p pd=2.68u as=0 ps=0 w=1u l=1u
X900 VSS.t2773 VDD VSS.t2774 VSS.t2710 sg13_lv_nmos ad=79.8f pd=0.8u as=0 ps=0 w=0.42u l=1u
X901 VDD sg13g2_dfrbpq_1_2.RESET_B a_10790_14922# VDD sg13_lv_pmos ad=0.36237p pd=2.605u as=79.8f ps=0.8u w=0.42u l=0.13u
X902 VDD a_15610_13690# a_15329_13912# VDD sg13_lv_pmos ad=0.1523p pd=1.38u as=0.34p ps=2.68u w=1u l=0.5u
X903 VSS.t2163 VDD VSS.t2165 VSS.t2164 sg13_lv_nmos ad=79.8f pd=0.8u as=0 ps=0 w=0.42u l=1u
X904 VSS.t32 a_8752_15454# a_8401_15311# VSS.t93 sg13_lv_nmos ad=79.8f pd=0.8u as=0.1428p ps=1.52u w=0.42u l=0.13u
X905 VSS.t2841 VDD VSS.t2842 VSS.t2710 sg13_lv_nmos ad=79.8f pd=0.8u as=0 ps=0 w=0.42u l=1u
X906 VSS.t334 a_19150_13239# sg13g2_or3_1_0.A VSS.t333 sg13_lv_nmos ad=0.1426p pd=1.16u as=0.2516p ps=2.16u w=0.74u l=0.13u
X907 VDD VSS.t498 VDD VDD sg13_lv_pmos ad=0.19p pd=1.38u as=0 ps=0 w=1u l=1u
X908 VSS.t652 VDD VSS.t654 VSS.t653 sg13_lv_nmos ad=79.8f pd=0.8u as=0 ps=0 w=0.42u l=1u
X909 VSS.t700 VDD VSS.t705 VSS.t822 sg13_lv_nmos ad=79.8f pd=0.8u as=0 ps=0 w=0.42u l=1u
X910 VDD VSS.t1358 VDD VDD sg13_lv_pmos ad=0.34p pd=2.68u as=0 ps=0 w=1u l=1u
X911 VDD VSS.t2842 VDD VDD sg13_lv_pmos ad=0.34p pd=2.68u as=0 ps=0 w=1u l=1u
X912 VDD VSS.t2182 VDD VDD sg13_lv_pmos ad=0.34p pd=2.68u as=0 ps=0 w=1u l=1u
X913 VDD VSS.t472 VDD VDD sg13_lv_pmos ad=0.19p pd=1.38u as=0 ps=0 w=1u l=1u
X914 VSS.t137 a_11470_15423# sg13g2_xnor2_1_1.A VSS.t138 sg13_lv_nmos ad=0.1426p pd=1.16u as=0.2516p ps=2.16u w=0.74u l=0.13u
X915 VSS.t1249 VDD VSS.t1248 VSS.t305 sg13_lv_nmos ad=0.1428p pd=1.52u as=0 ps=0 w=0.42u l=1u
X916 VSS.t2033 VDD VSS.t2035 VSS.t2034 sg13_lv_nmos ad=79.8f pd=0.8u as=0 ps=0 w=0.42u l=1u
X917 a_6571_14832# sg13g2_buf_1_9.X a_6477_14832# VSS.t3293 sg13_lv_nmos ad=0.1216p pd=1.02u as=0.2176p ps=1.96u w=0.64u l=0.13u
X918 VDD VSS.t966 VDD VDD sg13_lv_pmos ad=0.19p pd=1.38u as=0 ps=0 w=1u l=1u
X919 VSS.t1054 VDD VSS.t1053 VSS.t1052 sg13_lv_nmos ad=0.1428p pd=1.52u as=0 ps=0 w=0.42u l=1u
X920 VSS.t1676 VDD VSS.t1678 VSS.t1677 sg13_lv_nmos ad=79.8f pd=0.8u as=0 ps=0 w=0.42u l=1u
X921 VSS.t3205 VDD VSS.t3207 VSS.t3206 sg13_lv_nmos ad=79.8f pd=0.8u as=0 ps=0 w=0.42u l=1u
X922 VDD VSS.t2352 VDD VDD sg13_lv_pmos ad=0.19p pd=1.38u as=0 ps=0 w=1u l=1u
X923 sg13g2_dfrbpq_1_5.D a_25206_15302# VSS.t4 VSS.t3 sg13_lv_nmos ad=0.2516p pd=2.16u as=0.1426p ps=1.16u w=0.74u l=0.13u
X924 VDD VSS.t2739 VDD VDD sg13_lv_pmos ad=0.19p pd=1.38u as=0 ps=0 w=1u l=1u
X925 VSS.t2068 VDD VSS.t2067 VSS.t2066 sg13_lv_nmos ad=0.1428p pd=1.52u as=0 ps=0 w=0.42u l=1u
X926 VSS.t3160 VDD VSS.t3159 VSS.t3158 sg13_lv_nmos ad=0.1428p pd=1.52u as=0 ps=0 w=0.42u l=1u
X927 VSS.t2365 VDD VSS.t2364 VSS.t2363 sg13_lv_nmos ad=0.1428p pd=1.52u as=0 ps=0 w=0.42u l=1u
X928 VSS.t1576 VDD VSS.t1578 VSS.t1577 sg13_lv_nmos ad=79.8f pd=0.8u as=0 ps=0 w=0.42u l=1u
X929 VDD VSS.t1640 VDD VDD sg13_lv_pmos ad=0.34p pd=2.68u as=0 ps=0 w=1u l=1u
X930 VSS.t2485 VDD VSS.t2487 VSS.t2486 sg13_lv_nmos ad=79.8f pd=0.8u as=0 ps=0 w=0.42u l=1u
X931 counter_value_o[1] a_7048_15996# VSS.t344 VSS.t343 sg13_lv_nmos ad=0.2886p pd=2.26u as=0.14875p ps=1.16u w=0.74u l=0.13u
X932 a_19630_15238# sg13g2_buf_16_1.X VDD VDD sg13_lv_pmos ad=0.2128p pd=1.5u as=0.3808p ps=2.92u w=1.12u l=0.13u
X933 VDD VSS.t1695 VDD VDD sg13_lv_pmos ad=0.34p pd=2.68u as=0 ps=0 w=1u l=1u
X934 VDD VSS.t382 VDD VDD sg13_lv_pmos ad=0.19p pd=1.38u as=0 ps=0 w=1u l=1u
X935 VSS.t884 VDD VSS.t883 VSS.t882 sg13_lv_nmos ad=0.1428p pd=1.52u as=0 ps=0 w=0.42u l=1u
X936 VDD VSS.t2542 VDD VDD sg13_lv_pmos ad=0.19p pd=1.38u as=0 ps=0 w=1u l=1u
X937 VSS.t2440 VDD VSS.t2439 VSS.t2438 sg13_lv_nmos ad=0.1428p pd=1.52u as=0 ps=0 w=0.42u l=1u
X938 VDD VSS.t1058 VDD VDD sg13_lv_pmos ad=0.34p pd=2.68u as=0 ps=0 w=1u l=1u
X939 VDD VSS.t996 VDD VDD sg13_lv_pmos ad=0.19p pd=1.38u as=0 ps=0 w=1u l=1u
X940 VDD VSS.t1294 VDD VDD sg13_lv_pmos ad=0.19p pd=1.38u as=0 ps=0 w=1u l=1u
X941 VSS.t1766 VDD VSS.t1768 VSS.t1767 sg13_lv_nmos ad=79.8f pd=0.8u as=0 ps=0 w=0.42u l=1u
X942 VDD VSS.t1977 VDD VDD sg13_lv_pmos ad=0.34p pd=2.68u as=0 ps=0 w=1u l=1u
X943 VDD VSS.t2806 VDD VDD sg13_lv_pmos ad=0.34p pd=2.68u as=0 ps=0 w=1u l=1u
X944 VSS.t2148 VDD VSS.t2150 VSS.t2149 sg13_lv_nmos ad=79.8f pd=0.8u as=0 ps=0 w=0.42u l=1u
X945 VDD VSS.t719 VDD VDD sg13_lv_pmos ad=0.34p pd=2.68u as=0 ps=0 w=1u l=1u
X946 VSS.t3000 VDD VSS.t3002 VSS.t3001 sg13_lv_nmos ad=79.8f pd=0.8u as=0 ps=0 w=0.42u l=1u
X947 a_37484_15960# sg13g2_dlygate4sd3_1_12.A VSS.t210 VSS.t255 sg13_lv_nmos ad=0.187p pd=1.78u as=0.14875p ps=1.16u w=0.55u l=0.13u
X948 VDD VSS.t1377 VDD VDD sg13_lv_pmos ad=0.19p pd=1.38u as=0 ps=0 w=1u l=1u
X949 VDD VSS.t2569 VDD VDD sg13_lv_pmos ad=0.34p pd=2.68u as=0 ps=0 w=1u l=1u
X950 VSS.t1339 VDD VSS.t1338 VSS.t305 sg13_lv_nmos ad=0.1428p pd=1.52u as=0 ps=0 w=0.42u l=1u
X951 VSS.t1420 VDD VSS.t1261 VSS.t305 sg13_lv_nmos ad=0.1428p pd=1.52u as=0 ps=0 w=0.42u l=1u
X952 VDD VSS.t2759 VDD VDD sg13_lv_pmos ad=0.19p pd=1.38u as=0 ps=0 w=1u l=1u
X953 a_18766_15423# a_18881_15424# VSS.t24 VSS.t23 sg13_lv_nmos ad=0.1428p pd=1.52u as=0.1426p ps=1.16u w=0.42u l=0.5u
X954 VDD VSS.t933 VDD VDD sg13_lv_pmos ad=0.34p pd=2.68u as=0 ps=0 w=1u l=1u
X955 VDD VSS.t3139 VDD VDD sg13_lv_pmos ad=0.34p pd=2.68u as=0 ps=0 w=1u l=1u
X956 VSS.t2405 VDD VSS.t2404 VSS.t2403 sg13_lv_nmos ad=0.1428p pd=1.52u as=0 ps=0 w=0.42u l=1u
X957 VDD VSS.t2344 VDD VDD sg13_lv_pmos ad=0.34p pd=2.68u as=0 ps=0 w=1u l=1u
X958 VSS.t243 sg13g2_a21oi_1_1.Y a_18104_13013# VSS.t352 sg13_lv_nmos ad=79.8f pd=0.8u as=0.1428p ps=1.52u w=0.42u l=0.13u
X959 VSS.t2178 VDD VSS.t2177 VSS.t2176 sg13_lv_nmos ad=0.1428p pd=1.52u as=0 ps=0 w=0.42u l=1u
X960 VDD VSS.t2372 VDD VDD sg13_lv_pmos ad=0.19p pd=1.38u as=0 ps=0 w=1u l=1u
X961 a_18982_14909# sg13g2_dfrbpq_1_6.RESET_B VSS.t24 VSS.t240 sg13_lv_nmos ad=37.8f pd=0.6u as=0.1701p ps=1.65u w=0.42u l=0.13u
X962 VSS.t1561 VDD VSS.t1563 VSS.t1562 sg13_lv_nmos ad=79.8f pd=0.8u as=0 ps=0 w=0.42u l=1u
X963 VSS.t2470 VDD VSS.t2472 VSS.t2471 sg13_lv_nmos ad=79.8f pd=0.8u as=0 ps=0 w=0.42u l=1u
X964 VSS.t1978 VDD VSS.t1980 VSS.t1979 sg13_lv_nmos ad=79.8f pd=0.8u as=0 ps=0 w=0.42u l=1u
X965 VSS.t1039 VDD VSS.t1038 VSS.t1037 sg13_lv_nmos ad=0.1428p pd=1.52u as=0 ps=0 w=0.42u l=1u
X966 VDD VSS.t2534 VDD VDD sg13_lv_pmos ad=0.34p pd=2.68u as=0 ps=0 w=1u l=1u
X967 VDD VSS.t2045 VDD VDD sg13_lv_pmos ad=0.19p pd=1.38u as=0 ps=0 w=1u l=1u
X968 VSS.t1084 VDD VSS.t1083 VSS.t1082 sg13_lv_nmos ad=0.1428p pd=1.52u as=0 ps=0 w=0.42u l=1u
X969 VSS.t167 VDD VSS.t167 VSS.t577 sg13_lv_nmos ad=79.8f pd=0.8u as=0 ps=0 w=0.42u l=1u
X970 a_4666_14448# sg13g2_dlygate4sd3_1_2.A VSS.t49 VSS.t320 sg13_lv_nmos ad=0.1428p pd=1.52u as=79.8f ps=0.8u w=0.42u l=0.13u
X971 VSS.t1348 VDD VSS.t1347 VSS.t305 sg13_lv_nmos ad=0.1428p pd=1.52u as=0 ps=0 w=0.42u l=1u
X972 VSS.t1928 VDD VSS.t1930 VSS.t1929 sg13_lv_nmos ad=79.8f pd=0.8u as=0 ps=0 w=0.42u l=1u
X973 a_3396_15552# a_3915_15356# a_4655_15311# VSS.t213 sg13_lv_nmos ad=0.3473p pd=2.71u as=0.12665p ps=1.145u w=0.74u l=0.13u
X974 VSS.t3020 VDD VSS.t3022 VSS.t3021 sg13_lv_nmos ad=79.8f pd=0.8u as=0 ps=0 w=0.42u l=1u
X975 a_17699_16265# sg13g2_nand3_1_1.Y VSS.t364 VSS.t368 sg13_lv_nmos ad=0.187p pd=1.78u as=0.1045p ps=0.93u w=0.55u l=0.13u
X976 a_22806_14484# sg13g2_buf_4_0.X a_22508_14484# VDD sg13_lv_pmos ad=0.2128p pd=1.5u as=0.2128p ps=1.5u w=1.12u l=0.13u
X977 VSS.t129 VDD VSS.t129 VSS.t786 sg13_lv_nmos ad=0.1428p pd=1.52u as=0 ps=0 w=0.42u l=1u
X978 VSS.t1721 VDD VSS.t1720 VSS.t1719 sg13_lv_nmos ad=0.1428p pd=1.52u as=0 ps=0 w=0.42u l=1u
X979 VDD VSS.t896 VDD VDD sg13_lv_pmos ad=0.19p pd=1.38u as=0 ps=0 w=1u l=1u
X980 VDD VSS.t2412 VDD VDD sg13_lv_pmos ad=0.19p pd=1.38u as=0 ps=0 w=1u l=1u
X981 VSS.t1054 VDD VSS.t1053 VSS.t1052 sg13_lv_nmos ad=0.1428p pd=1.52u as=0 ps=0 w=0.42u l=1u
X982 VSS.t1383 VDD VSS.t1384 VSS.t305 sg13_lv_nmos ad=79.8f pd=0.8u as=0 ps=0 w=0.42u l=1u
X983 VDD VSS.t1349 VDD VDD sg13_lv_pmos ad=0.34p pd=2.68u as=0 ps=0 w=1u l=1u
X984 VDD VSS.t2329 VDD VDD sg13_lv_pmos ad=0.34p pd=2.68u as=0 ps=0 w=1u l=1u
X985 a_4655_15311# a_3813_15213# a_3396_15552# VDD sg13_lv_pmos ad=0.2048p pd=1.63u as=0.34p ps=2.68u w=1u l=0.13u
X986 VSS.t569 VDD VSS.t569 VSS.t616 sg13_lv_nmos ad=0.1428p pd=1.52u as=0 ps=0 w=0.42u l=1u
X987 VSS.t2198 VDD VSS.t2197 VSS.t2196 sg13_lv_nmos ad=0.1428p pd=1.52u as=0 ps=0 w=0.42u l=1u
X988 VSS.t2018 VDD VSS.t2020 VSS.t2019 sg13_lv_nmos ad=79.8f pd=0.8u as=0 ps=0 w=0.42u l=1u
X989 VDD VSS.t2195 VDD VDD sg13_lv_pmos ad=0.19p pd=1.38u as=0 ps=0 w=1u l=1u
X990 VDD VSS.t2730 VDD VDD sg13_lv_pmos ad=0.19p pd=1.38u as=0 ps=0 w=1u l=1u
X991 VDD VSS.t569 VDD VDD sg13_lv_pmos ad=0.34p pd=2.68u as=0 ps=0 w=1u l=1u
X992 VSS.t3145 VDD VSS.t3144 VSS.t3143 sg13_lv_nmos ad=0.1428p pd=1.52u as=0 ps=0 w=0.42u l=1u
X993 VSS.t2350 VDD VSS.t2349 VSS.t2348 sg13_lv_nmos ad=0.1428p pd=1.52u as=0 ps=0 w=0.42u l=1u
X994 VDD VSS.t700 VDD VDD sg13_lv_pmos ad=0.19p pd=1.38u as=0 ps=0 w=1u l=1u
X995 VDD VSS.t1252 VDD VDD sg13_lv_pmos ad=0.19p pd=1.38u as=0 ps=0 w=1u l=1u
X996 VSS.t389 VDD VSS.t387 VSS.t388 sg13_lv_nmos ad=0.1428p pd=1.52u as=0 ps=0 w=0.42u l=1u
X997 sg13g2_mux2_1_1.A0 a_24333_15280# VDD VDD sg13_lv_pmos ad=0.3808p pd=2.92u as=0.1918p ps=1.5u w=1.12u l=0.13u
X998 VDD VSS.t1103 VDD VDD sg13_lv_pmos ad=0.34p pd=2.68u as=0 ps=0 w=1u l=1u
X999 VDD VSS.t1680 VDD VDD sg13_lv_pmos ad=0.34p pd=2.68u as=0 ps=0 w=1u l=1u
X1000 VSS.t3060 VDD VSS.t3062 VSS.t3061 sg13_lv_nmos ad=79.8f pd=0.8u as=0 ps=0 w=0.42u l=1u
X1001 VDD VSS.t2834 VDD VDD sg13_lv_pmos ad=0.19p pd=1.38u as=0 ps=0 w=1u l=1u
X1002 VSS.t2425 VDD VSS.t2424 VSS.t2423 sg13_lv_nmos ad=0.1428p pd=1.52u as=0 ps=0 w=0.42u l=1u
X1003 VSS.t2148 VDD VSS.t2147 VSS.t2146 sg13_lv_nmos ad=0.1428p pd=1.52u as=0 ps=0 w=0.42u l=1u
X1004 a_7054_14751# a_7169_14750# VDD VDD sg13_lv_pmos ad=0.34p pd=2.68u as=0.2254p ps=1.53u w=1u l=0.5u
X1005 VDD VSS.t2384 VDD VDD sg13_lv_pmos ad=0.34p pd=2.68u as=0 ps=0 w=1u l=1u
X1006 VSS.t2776 VDD VSS.t2777 VSS.t2710 sg13_lv_nmos ad=79.8f pd=0.8u as=0 ps=0 w=0.42u l=1u
X1007 VSS.t1751 VDD VSS.t1753 VSS.t1752 sg13_lv_nmos ad=79.8f pd=0.8u as=0 ps=0 w=0.42u l=1u
X1008 a_4270_14751# a_4385_14750# VSS.t177 VSS.t176 sg13_lv_nmos ad=0.1428p pd=1.52u as=0.1426p ps=1.16u w=0.42u l=0.5u
X1009 VDD VSS.t3127 VDD VDD sg13_lv_pmos ad=0.19p pd=1.38u as=0 ps=0 w=1u l=1u
X1010 VSS.t2844 VDD VSS.t2845 VSS.t2710 sg13_lv_nmos ad=79.8f pd=0.8u as=0 ps=0 w=0.42u l=1u
X1011 VDD VSS.t1990 VDD VDD sg13_lv_pmos ad=0.19p pd=1.38u as=0 ps=0 w=1u l=1u
X1012 VSS.t1993 VDD VSS.t1992 VSS.t1991 sg13_lv_nmos ad=0.1428p pd=1.52u as=0 ps=0 w=0.42u l=1u
X1013 VDD VSS.t863 VDD VDD sg13_lv_pmos ad=0.34p pd=2.68u as=0 ps=0 w=1u l=1u
X1014 VSS.t1706 VDD VSS.t1705 VSS.t1704 sg13_lv_nmos ad=0.1428p pd=1.52u as=0 ps=0 w=0.42u l=1u
X1015 VDD a_7450_16237# sg13g2_dfrbpq_1_1.RESET_B VDD sg13_lv_pmos ad=2.4406p pd=15.34u as=0.3927p ps=2.99u w=1.155u l=0.13u
X1016 VDD a_17038_15423# sg13g2_a21oi_1_0.A1 VDD sg13_lv_pmos ad=0.2254p pd=1.53u as=0.4256p ps=3u w=1.12u l=0.13u
X1017 a_22202_14484# sg13g2_nor3_1_0.C sg13g2_nor4_2_0.Y VDD sg13_lv_pmos ad=0.3808p pd=2.92u as=0.2128p ps=1.5u w=1.12u l=0.13u
X1018 VSS.t1366 VDD VSS.t1365 VSS.t305 sg13_lv_nmos ad=0.1428p pd=1.52u as=0 ps=0 w=0.42u l=1u
X1019 VSS.t1529 VDD VSS.t1397 VSS.t305 sg13_lv_nmos ad=79.8f pd=0.8u as=0 ps=0 w=0.42u l=1u
X1020 VDD VSS.t1340 VDD VDD sg13_lv_pmos ad=0.34p pd=2.68u as=0 ps=0 w=1u l=1u
X1021 VDD VSS.t2845 VDD VDD sg13_lv_pmos ad=0.34p pd=2.68u as=0 ps=0 w=1u l=1u
X1022 VDD VSS.t2152 VDD VDD sg13_lv_pmos ad=0.34p pd=2.68u as=0 ps=0 w=1u l=1u
X1023 VSS.t522 VDD VSS.t524 VSS.t523 sg13_lv_nmos ad=79.8f pd=0.8u as=0 ps=0 w=0.42u l=1u
X1024 a_12308_15202# sg13g2_buf_16_1.X VSS.t89 VSS.t216 sg13_lv_nmos ad=0.1406p pd=1.12u as=0.1406p ps=1.12u w=0.74u l=0.13u
X1025 a_4655_15311# a_3813_15213# a_4561_15311# VSS.t260 sg13_lv_nmos ad=0.12665p pd=1.145u as=0.1428p ps=1.52u w=0.42u l=0.13u
X1026 VSS.t1681 VDD VSS.t1683 VSS.t1682 sg13_lv_nmos ad=79.8f pd=0.8u as=0 ps=0 w=0.42u l=1u
X1027 VDD VSS.t2357 VDD VDD sg13_lv_pmos ad=0.19p pd=1.38u as=0 ps=0 w=1u l=1u
X1028 VDD VSS.t39 VDD VDD sg13_lv_pmos ad=0.34p pd=2.68u as=0 ps=0 w=1u l=1u
X1029 VDD VSS.t916 VDD VDD sg13_lv_pmos ad=0.19p pd=1.38u as=0 ps=0 w=1u l=1u
X1030 VSS.t1319 VDD VSS.t1320 VSS.t305 sg13_lv_nmos ad=79.8f pd=0.8u as=0 ps=0 w=0.42u l=1u
X1031 VDD VSS.t656 VDD VDD sg13_lv_pmos ad=0.34p pd=2.68u as=0 ps=0 w=1u l=1u
X1032 VSS.t1084 VDD VSS.t1083 VSS.t1082 sg13_lv_nmos ad=0.1428p pd=1.52u as=0 ps=0 w=0.42u l=1u
X1033 VDD VSS.t1342 VDD VDD sg13_lv_pmos ad=0.19p pd=1.38u as=0 ps=0 w=1u l=1u
X1034 VSS.t1546 VDD VSS.t1548 VSS.t1547 sg13_lv_nmos ad=79.8f pd=0.8u as=0 ps=0 w=0.42u l=1u
X1035 VDD VSS.t1645 VDD VDD sg13_lv_pmos ad=0.34p pd=2.68u as=0 ps=0 w=1u l=1u
X1036 VSS.t1963 VDD VSS.t1965 VSS.t1964 sg13_lv_nmos ad=79.8f pd=0.8u as=0 ps=0 w=0.42u l=1u
X1037 VDD VSS.t1700 VDD VDD sg13_lv_pmos ad=0.34p pd=2.68u as=0 ps=0 w=1u l=1u
X1038 VSS.t160 VDD VSS.t162 VSS.t7 sg13_lv_nmos ad=79.8f pd=0.8u as=0 ps=0 w=0.42u l=1u
X1039 VSS.t481 VDD VSS.t481 VSS.t480 sg13_lv_nmos ad=0.1428p pd=1.52u as=0 ps=0 w=0.42u l=1u
X1040 sg13g2_and2_1_1.X a_6477_14832# VDD VDD sg13_lv_pmos ad=0.3808p pd=2.92u as=0.1918p ps=1.5u w=1.12u l=0.13u
X1041 VSS.t1246 VDD VSS.t1247 VSS.t305 sg13_lv_nmos ad=79.8f pd=0.8u as=0 ps=0 w=0.42u l=1u
X1042 VDD VSS.t1982 VDD VDD sg13_lv_pmos ad=0.34p pd=2.68u as=0 ps=0 w=1u l=1u
X1043 VDD VSS.t2809 VDD VDD sg13_lv_pmos ad=0.34p pd=2.68u as=0 ps=0 w=1u l=1u
X1044 VDD a_12308_15202# sg13g2_dfrbpq_1_2.CLK VDD sg13_lv_pmos ad=0.2128p pd=1.5u as=0.2128p ps=1.5u w=1.12u l=0.13u
X1045 VSS.t3005 VDD VSS.t3007 VSS.t3006 sg13_lv_nmos ad=79.8f pd=0.8u as=0 ps=0 w=0.42u l=1u
X1046 VSS.t1515 VDD VSS.t1377 VSS.t305 sg13_lv_nmos ad=0.1428p pd=1.52u as=0 ps=0 w=0.42u l=1u
X1047 VSS.t331 sg13g2_xnor2_1_0.A a_7572_13768# VSS.t330 sg13_lv_nmos ad=0.2272p pd=1.99u as=78.39999f ps=0.885u w=0.64u l=0.13u
X1048 VSS.t2820 VDD VSS.t2819 VSS.t2710 sg13_lv_nmos ad=0.1428p pd=1.52u as=0 ps=0 w=0.42u l=1u
X1049 VDD VSS.t2574 VDD VDD sg13_lv_pmos ad=0.34p pd=2.68u as=0 ps=0 w=1u l=1u
X1050 VDD VSS.t1995 VDD VDD sg13_lv_pmos ad=0.19p pd=1.38u as=0 ps=0 w=1u l=1u
X1051 VDD VSS.t2761 VDD VDD sg13_lv_pmos ad=0.19p pd=1.38u as=0 ps=0 w=1u l=1u
X1052 VSS.t2410 VDD VSS.t2409 VSS.t2408 sg13_lv_nmos ad=0.1428p pd=1.52u as=0 ps=0 w=0.42u l=1u
X1053 VSS.t2183 VDD VSS.t2182 VSS.t2181 sg13_lv_nmos ad=0.1428p pd=1.52u as=0 ps=0 w=0.42u l=1u
X1054 VDD VSS.t868 VDD VDD sg13_lv_pmos ad=0.34p pd=2.68u as=0 ps=0 w=1u l=1u
X1055 VSS.t1301 VDD VSS.t1300 VSS.t305 sg13_lv_nmos ad=0.1428p pd=1.52u as=0 ps=0 w=0.42u l=1u
X1056 sg13g2_dfrbpq_1_2.CLK a_12308_15202# VSS.t89 VSS.t194 sg13_lv_nmos ad=0.1406p pd=1.12u as=0.1406p ps=1.12u w=0.74u l=0.13u
X1057 VDD VSS.t1678 VDD VDD sg13_lv_pmos ad=0.19p pd=1.38u as=0 ps=0 w=1u l=1u
X1058 VDD VSS.t1033 VDD VDD sg13_lv_pmos ad=0.34p pd=2.68u as=0 ps=0 w=1u l=1u
X1059 VSS.t1566 VDD VSS.t1568 VSS.t1567 sg13_lv_nmos ad=79.8f pd=0.8u as=0 ps=0 w=0.42u l=1u
X1060 VSS.t2475 VDD VSS.t2477 VSS.t2476 sg13_lv_nmos ad=79.8f pd=0.8u as=0 ps=0 w=0.42u l=1u
X1061 VDD sg13g2_dfrbpq_1_3.RESET_B a_13642_14452# VDD sg13_lv_pmos ad=0.1563p pd=1.22u as=0.147p ps=1.54u w=0.42u l=0.13u
X1062 VDD VSS.t2050 VDD VDD sg13_lv_pmos ad=0.19p pd=1.38u as=0 ps=0 w=1u l=1u
X1063 VDD VSS.t92 VDD VDD sg13_lv_pmos ad=0.34p pd=2.68u as=0 ps=0 w=1u l=1u
X1064 VSS.t904 VDD VSS.t903 VSS.t902 sg13_lv_nmos ad=0.1428p pd=1.52u as=0 ps=0 w=0.42u l=1u
X1065 VDD VSS.t1260 VDD VDD sg13_lv_pmos ad=0.19p pd=1.38u as=0 ps=0 w=1u l=1u
X1066 a_25956_14909# a_26187_14495# a_25642_14452# VSS.t282 sg13_lv_nmos ad=0.2373p pd=1.97u as=79.8f ps=0.8u w=0.42u l=0.13u
X1067 a_26025_14531# a_25668_14488# VDD VDD sg13_lv_pmos ad=63f pd=0.72u as=0.1563p ps=1.22u w=0.42u l=0.13u
X1068 VSS.t1259 VDD VSS.t1260 VSS.t305 sg13_lv_nmos ad=79.8f pd=0.8u as=0 ps=0 w=0.42u l=1u
X1069 VSS.t1696 VDD VSS.t1695 VSS.t1694 sg13_lv_nmos ad=0.1428p pd=1.52u as=0 ps=0 w=0.42u l=1u
X1070 VSS.t3225 VDD VSS.t3224 VSS.t3223 sg13_lv_nmos ad=0.1428p pd=1.52u as=0 ps=0 w=0.42u l=1u
X1071 VDD VSS.t2369 VDD VDD sg13_lv_pmos ad=0.34p pd=2.68u as=0 ps=0 w=1u l=1u
X1072 a_26062_13911# a_26177_13912# VDD VDD sg13_lv_pmos ad=0.34p pd=2.68u as=0.2254p ps=1.53u w=1u l=0.5u
X1073 VSS.t2768 VDD VSS.t2769 VSS.t2710 sg13_lv_nmos ad=79.8f pd=0.8u as=0 ps=0 w=0.42u l=1u
X1074 VDD VSS.t1096 VDD VDD sg13_lv_pmos ad=0.19p pd=1.38u as=0 ps=0 w=1u l=1u
X1075 VSS.t1978 VDD VSS.t1977 VSS.t1976 sg13_lv_nmos ad=0.1428p pd=1.52u as=0 ps=0 w=0.42u l=1u
X1076 VDD VSS.t436 VDD VDD sg13_lv_pmos ad=0.34p pd=2.68u as=0 ps=0 w=1u l=1u
X1077 VDD VSS.t208 VDD VDD sg13_lv_pmos ad=0.19p pd=1.38u as=0 ps=0 w=1u l=1u
X1078 sg13g2_dfrbpq_1_6.D a_18198_15302# VDD VDD sg13_lv_pmos ad=0.4256p pd=3u as=0.2254p ps=1.53u w=1.12u l=0.13u
X1079 VSS.t162 a_19630_15238# sg13g2_dfrbpq_1_7.CLK VSS.t3 sg13_lv_nmos ad=0.1406p pd=1.12u as=0.1406p ps=1.12u w=0.74u l=0.13u
X1080 VSS.t1691 VDD VSS.t1690 VSS.t1689 sg13_lv_nmos ad=0.1428p pd=1.52u as=0 ps=0 w=0.42u l=1u
X1081 a_15214_13911# a_15329_13912# VDD VDD sg13_lv_pmos ad=0.34p pd=2.68u as=0.2254p ps=1.53u w=1u l=0.5u
X1082 VSS.t285 VDD VSS.t285 VSS.t774 sg13_lv_nmos ad=0.1428p pd=1.52u as=0 ps=0 w=0.42u l=1u
X1083 VDD VSS.t2334 VDD VDD sg13_lv_pmos ad=0.34p pd=2.68u as=0 ps=0 w=1u l=1u
X1084 VDD VSS.t719 VDD VDD sg13_lv_pmos ad=0.34p pd=2.68u as=0 ps=0 w=1u l=1u
X1085 VDD VSS.t1023 VDD VDD sg13_lv_pmos ad=0.34p pd=2.68u as=0 ps=0 w=1u l=1u
X1086 VSS.t1315 VDD VSS.t1314 VSS.t305 sg13_lv_nmos ad=0.1428p pd=1.52u as=0 ps=0 w=0.42u l=1u
X1087 VSS.t1606 VDD VSS.t1608 VSS.t1607 sg13_lv_nmos ad=79.8f pd=0.8u as=0 ps=0 w=0.42u l=1u
X1088 VDD VSS.t3129 VDD VDD sg13_lv_pmos ad=0.34p pd=2.68u as=0 ps=0 w=1u l=1u
X1089 VSS.t2766 VDD VSS.t2767 VSS.t2710 sg13_lv_nmos ad=79.8f pd=0.8u as=0 ps=0 w=0.42u l=1u
X1090 VDD VSS.t2737 VDD VDD sg13_lv_pmos ad=0.19p pd=1.38u as=0 ps=0 w=1u l=1u
X1091 VDD VSS.t2507 VDD VDD sg13_lv_pmos ad=0.19p pd=1.38u as=0 ps=0 w=1u l=1u
X1092 VDD VSS.t656 VDD VDD sg13_lv_pmos ad=0.34p pd=2.68u as=0 ps=0 w=1u l=1u
X1093 VDD VSS.t705 VDD VDD sg13_lv_pmos ad=0.34p pd=2.68u as=0 ps=0 w=1u l=1u
X1094 sg13g2_dfrbpq_1_2.CLK a_12308_15202# VSS.t89 VSS.t182 sg13_lv_nmos ad=0.1406p pd=1.12u as=0.1406p ps=1.12u w=0.74u l=0.13u
X1095 VDD VSS.t477 VDD VDD sg13_lv_pmos ad=0.19p pd=1.38u as=0 ps=0 w=1u l=1u
X1096 a_23648_15437# sg13g2_buf_1_9.X.t5 VDD VDD sg13_lv_pmos ad=0.1596p pd=1.22u as=0.1918p ps=1.5u w=0.84u l=0.13u
X1097 VDD VSS.t2042 VDD VDD sg13_lv_pmos ad=0.34p pd=2.68u as=0 ps=0 w=1u l=1u
X1098 a_3684_15247# a_3396_15552# a_3622_15247# VSS.t212 sg13_lv_nmos ad=0.1428p pd=1.52u as=37.8f ps=0.6u w=0.42u l=0.13u
X1099 VSS.t686 VDD VSS.t683 VSS.t685 sg13_lv_nmos ad=0.1428p pd=1.52u as=0 ps=0 w=0.42u l=1u
X1100 VSS.t1059 VDD VSS.t1058 VSS.t1057 sg13_lv_nmos ad=0.1428p pd=1.52u as=0 ps=0 w=0.42u l=1u
X1101 VDD VSS.t1630 VDD VDD sg13_lv_pmos ad=0.34p pd=2.68u as=0 ps=0 w=1u l=1u
X1102 VSS.t1403 VDD VSS.t1241 VSS.t305 sg13_lv_nmos ad=0.1428p pd=1.52u as=0 ps=0 w=0.42u l=1u
X1103 VSS.t1350 VDD VSS.t1351 VSS.t305 sg13_lv_nmos ad=79.8f pd=0.8u as=0 ps=0 w=0.42u l=1u
X1104 VDD VSS.t1685 VDD VDD sg13_lv_pmos ad=0.34p pd=2.68u as=0 ps=0 w=1u l=1u
X1105 VSS.t3065 VDD VSS.t3067 VSS.t3066 sg13_lv_nmos ad=79.8f pd=0.8u as=0 ps=0 w=0.42u l=1u
X1106 VSS.t2430 VDD VSS.t2429 VSS.t2428 sg13_lv_nmos ad=0.1428p pd=1.52u as=0 ps=0 w=0.42u l=1u
X1107 a_18756_14488# a_18730_14452# VSS.t24 VSS.t3292 sg13_lv_nmos ad=0.2516p pd=2.16u as=0.1626p ps=1.415u w=0.74u l=0.13u
X1108 VSS.t994 VDD VSS.t996 VSS.t995 sg13_lv_nmos ad=79.8f pd=0.8u as=0 ps=0 w=0.42u l=1u
X1109 VSS.t2778 VDD VSS.t2780 VSS.t2710 sg13_lv_nmos ad=79.8f pd=0.8u as=0 ps=0 w=0.42u l=1u
X1110 sg13g2_nand2_2_0.Y sg13g2_nand2_2_0.A VDD VDD sg13_lv_pmos ad=0.2128p pd=1.5u as=0.2184p ps=1.51u w=1.12u l=0.13u
X1111 VDD VSS.t1063 VDD VDD sg13_lv_pmos ad=0.34p pd=2.68u as=0 ps=0 w=1u l=1u
X1112 VDD VSS.t2747 VDD VDD sg13_lv_pmos ad=0.34p pd=2.68u as=0 ps=0 w=1u l=1u
X1113 VSS.t2847 VDD VSS.t2848 VSS.t2710 sg13_lv_nmos ad=79.8f pd=0.8u as=0 ps=0 w=0.42u l=1u
X1114 VSS.t664 VDD VSS.t664 VSS.t756 sg13_lv_nmos ad=79.8f pd=0.8u as=0 ps=0 w=0.42u l=1u
X1115 VSS.t158 a_19630_15238# sg13g2_dfrbpq_1_7.CLK VSS.t3 sg13_lv_nmos ad=0.1406p pd=1.12u as=0.1406p ps=1.12u w=0.74u l=0.13u
X1116 VSS.t705 VDD VSS.t714 VSS.t830 sg13_lv_nmos ad=79.8f pd=0.8u as=0 ps=0 w=0.42u l=1u
X1117 VDD VSS.t1297 VDD VDD sg13_lv_pmos ad=0.19p pd=1.38u as=0 ps=0 w=1u l=1u
X1118 a_7236_15552# a_7210_15457# VSS.t10 VSS.t44 sg13_lv_nmos ad=0.2516p pd=2.16u as=0.1626p ps=1.415u w=0.74u l=0.13u
X1119 VSS.t637 VDD VSS.t639 VSS.t638 sg13_lv_nmos ad=79.8f pd=0.8u as=0 ps=0 w=0.42u l=1u
X1120 VDD VSS.t986 VDD VDD sg13_lv_pmos ad=0.19p pd=1.38u as=0 ps=0 w=1u l=1u
X1121 VDD VSS.t1342 VDD VDD sg13_lv_pmos ad=0.34p pd=2.68u as=0 ps=0 w=1u l=1u
X1122 VDD VSS.t2754 VDD VDD sg13_lv_pmos ad=0.19p pd=1.38u as=0 ps=0 w=1u l=1u
X1123 VDD VSS.t2978 VDD VDD sg13_lv_pmos ad=0.34p pd=2.68u as=0 ps=0 w=1u l=1u
X1124 VDD VSS.t2157 VDD VDD sg13_lv_pmos ad=0.34p pd=2.68u as=0 ps=0 w=1u l=1u
X1125 VDD a_12524_15960# counter_value_o[2] VDD sg13_lv_pmos ad=0.2114p pd=1.54u as=0.42p ps=2.99u w=1.12u l=0.13u
X1126 VSS.t2395 VDD VSS.t2394 VSS.t2393 sg13_lv_nmos ad=0.1428p pd=1.52u as=0 ps=0 w=0.42u l=1u
X1127 VSS.t2008 VDD VSS.t2010 VSS.t2009 sg13_lv_nmos ad=79.8f pd=0.8u as=0 ps=0 w=0.42u l=1u
X1128 a_13626_13918# sg13g2_xor2_1_1.B VSS.t2 VSS.t1 sg13_lv_nmos ad=0.17462p pd=1.185u as=0.15245p ps=1.17u w=0.55u l=0.13u
X1129 VSS.t1328 VDD VSS.t1326 VSS.t305 sg13_lv_nmos ad=0.1428p pd=1.52u as=0 ps=0 w=0.42u l=1u
X1130 VSS.t1948 VDD VSS.t1947 VSS.t1946 sg13_lv_nmos ad=0.1428p pd=1.52u as=0 ps=0 w=0.42u l=1u
X1131 VSS.t385 VDD VSS.t387 VSS.t386 sg13_lv_nmos ad=79.8f pd=0.8u as=0 ps=0 w=0.42u l=1u
X1132 VDD VSS.t2728 VDD VDD sg13_lv_pmos ad=0.19p pd=1.38u as=0 ps=0 w=1u l=1u
X1133 VSS.t1551 VDD VSS.t1553 VSS.t1552 sg13_lv_nmos ad=79.8f pd=0.8u as=0 ps=0 w=0.42u l=1u
X1134 VSS.t2460 VDD VSS.t2462 VSS.t2461 sg13_lv_nmos ad=79.8f pd=0.8u as=0 ps=0 w=0.42u l=1u
X1135 VDD VSS.t861 VDD VDD sg13_lv_pmos ad=0.19p pd=1.38u as=0 ps=0 w=1u l=1u
X1136 VSS.t904 VDD VSS.t903 VSS.t902 sg13_lv_nmos ad=0.1428p pd=1.52u as=0 ps=0 w=0.42u l=1u
X1137 VSS.t1333 VDD VSS.t1331 VSS.t305 sg13_lv_nmos ad=0.1428p pd=1.52u as=0 ps=0 w=0.42u l=1u
X1138 VSS.t2739 VDD VSS.t2740 VSS.t2710 sg13_lv_nmos ad=79.8f pd=0.8u as=0 ps=0 w=0.42u l=1u
X1139 a_8986_14448# sg13g2_dlygate4sd3_1_0.A VSS.t32 VSS.t3316 sg13_lv_nmos ad=0.1428p pd=1.52u as=79.8f ps=0.8u w=0.42u l=0.13u
X1140 VSS.t695 VDD VSS.t695 VSS.t696 sg13_lv_nmos ad=79.8f pd=0.8u as=0 ps=0 w=0.42u l=1u
X1141 VDD VSS.t1305 VDD VDD sg13_lv_pmos ad=0.19p pd=1.38u as=0 ps=0 w=1u l=1u
X1142 VDD VSS.t2992 VDD VDD sg13_lv_pmos ad=0.19p pd=1.38u as=0 ps=0 w=1u l=1u
X1143 VDD VSS.t2035 VDD VDD sg13_lv_pmos ad=0.19p pd=1.38u as=0 ps=0 w=1u l=1u
X1144 VDD VSS.t540 VDD VDD sg13_lv_pmos ad=0.19p pd=1.38u as=0 ps=0 w=1u l=1u
X1145 VDD VSS.t729 VDD VDD sg13_lv_pmos ad=0.34p pd=2.68u as=0 ps=0 w=1u l=1u
X1146 VDD VSS.t1987 VDD VDD sg13_lv_pmos ad=0.34p pd=2.68u as=0 ps=0 w=1u l=1u
X1147 VSS.t2858 VDD VSS.t2857 VSS.t2710 sg13_lv_nmos ad=0.1428p pd=1.52u as=0 ps=0 w=0.42u l=1u
X1148 VDD VSS.t2740 VDD VDD sg13_lv_pmos ad=0.34p pd=2.68u as=0 ps=0 w=1u l=1u
X1149 VDD VSS.t2811 VDD VDD sg13_lv_pmos ad=0.34p pd=2.68u as=0 ps=0 w=1u l=1u
X1150 VDD VSS.t1268 VDD VDD sg13_lv_pmos ad=0.34p pd=2.68u as=0 ps=0 w=1u l=1u
X1151 sg13g2_buf_1_9.X a_1192_9948# VSS.t306 VSS.t305 sg13_lv_nmos ad=0.2886p pd=2.26u as=0.14875p ps=1.16u w=0.74u l=0.13u
X1152 VSS.t3010 VDD VSS.t3012 VSS.t3011 sg13_lv_nmos ad=79.8f pd=0.8u as=0 ps=0 w=0.42u l=1u
X1153 VDD VSS.t148 VDD VDD sg13_lv_pmos ad=0.19p pd=1.38u as=0 ps=0 w=1u l=1u
X1154 VSS.t1274 VDD VSS.t1273 VSS.t305 sg13_lv_nmos ad=0.1428p pd=1.52u as=0 ps=0 w=0.42u l=1u
X1155 VDD VSS.t953 VDD VDD sg13_lv_pmos ad=0.34p pd=2.68u as=0 ps=0 w=1u l=1u
X1156 VDD VSS.t2764 VDD VDD sg13_lv_pmos ad=0.19p pd=1.38u as=0 ps=0 w=1u l=1u
X1157 VDD VSS.t2544 VDD VDD sg13_lv_pmos ad=0.34p pd=2.68u as=0 ps=0 w=1u l=1u
X1158 VDD VSS.t1068 VDD VDD sg13_lv_pmos ad=0.34p pd=2.68u as=0 ps=0 w=1u l=1u
X1159 VSS.t2786 VDD VSS.t2786 VSS.t2710 sg13_lv_nmos ad=0.1428p pd=1.52u as=0 ps=0 w=0.42u l=1u
X1160 VSS.t2415 VDD VSS.t2414 VSS.t2413 sg13_lv_nmos ad=0.1428p pd=1.52u as=0 ps=0 w=0.42u l=1u
X1161 VDD sg13g2_xnor2_1_0.A sg13g2_buf_4_0.A VDD sg13_lv_pmos ad=0.2128p pd=1.5u as=0.2128p ps=1.5u w=1.12u l=0.13u
X1162 VSS.t1771 VDD VSS.t1770 VSS.t1769 sg13_lv_nmos ad=0.1428p pd=1.52u as=0 ps=0 w=0.42u l=1u
X1163 VDD VSS.t2319 VDD VDD sg13_lv_pmos ad=0.34p pd=2.68u as=0 ps=0 w=1u l=1u
X1164 VDD VSS.t1673 VDD VDD sg13_lv_pmos ad=0.19p pd=1.38u as=0 ps=0 w=1u l=1u
X1165 VSS.t2856 VDD VSS.t2855 VSS.t2710 sg13_lv_nmos ad=0.1428p pd=1.52u as=0 ps=0 w=0.42u l=1u
X1166 VSS.t2759 VDD VSS.t2760 VSS.t2710 sg13_lv_nmos ad=79.8f pd=0.8u as=0 ps=0 w=0.42u l=1u
X1167 VSS.t2153 VDD VSS.t2152 VSS.t2151 sg13_lv_nmos ad=0.1428p pd=1.52u as=0 ps=0 w=0.42u l=1u
X1168 a_3370_15457# a_3813_15213# a_3753_15625# VDD sg13_lv_pmos ad=79.8f pd=0.8u as=63f ps=0.72u w=0.42u l=0.13u
X1169 VDD VSS.t1683 VDD VDD sg13_lv_pmos ad=0.19p pd=1.38u as=0 ps=0 w=1u l=1u
X1170 VSS.t1059 VDD VSS.t1058 VSS.t1057 sg13_lv_nmos ad=0.1428p pd=1.52u as=0 ps=0 w=0.42u l=1u
X1171 VSS.t1104 VDD VSS.t1103 VSS.t1102 sg13_lv_nmos ad=0.1428p pd=1.52u as=0 ps=0 w=0.42u l=1u
X1172 VSS.t994 VDD VSS.t996 VSS.t995 sg13_lv_nmos ad=79.8f pd=0.8u as=0 ps=0 w=0.42u l=1u
X1173 VDD VSS.t1286 VDD VDD sg13_lv_pmos ad=0.34p pd=2.68u as=0 ps=0 w=1u l=1u
X1174 VSS.t1512 VDD VSS.t1377 VSS.t305 sg13_lv_nmos ad=79.8f pd=0.8u as=0 ps=0 w=0.42u l=1u
X1175 VDD VSS.t2055 VDD VDD sg13_lv_pmos ad=0.19p pd=1.38u as=0 ps=0 w=1u l=1u
X1176 VDD VSS.t1263 VDD VDD sg13_lv_pmos ad=0.19p pd=1.38u as=0 ps=0 w=1u l=1u
X1177 VDD VSS.t2829 VDD VDD sg13_lv_pmos ad=0.19p pd=1.38u as=0 ps=0 w=1u l=1u
X1178 VSS.t1701 VDD VSS.t1700 VSS.t1699 sg13_lv_nmos ad=0.1428p pd=1.52u as=0 ps=0 w=0.42u l=1u
X1179 VSS.t3230 VDD VSS.t3229 VSS.t3228 sg13_lv_nmos ad=0.1428p pd=1.52u as=0 ps=0 w=0.42u l=1u
X1180 VDD VSS.t2374 VDD VDD sg13_lv_pmos ad=0.34p pd=2.68u as=0 ps=0 w=1u l=1u
X1181 VSS.t7 a_7653_15213# a_7755_15356# VSS.t45 sg13_lv_nmos ad=5.1665p pd=33.355u as=0.2516p ps=2.16u w=0.74u l=0.13u
X1182 VSS.t2770 VDD VSS.t2771 VSS.t2710 sg13_lv_nmos ad=79.8f pd=0.8u as=0 ps=0 w=0.42u l=1u
X1183 VDD VSS.t1108 VDD VDD sg13_lv_pmos ad=0.34p pd=2.68u as=0 ps=0 w=1u l=1u
X1184 VSS.t2839 VDD VSS.t2840 VSS.t2710 sg13_lv_nmos ad=79.8f pd=0.8u as=0 ps=0 w=0.42u l=1u
X1185 VSS.t1983 VDD VSS.t1982 VSS.t1981 sg13_lv_nmos ad=0.1428p pd=1.52u as=0 ps=0 w=0.42u l=1u
X1186 VSS.t705 VDD VSS.t705 VSS.t710 sg13_lv_nmos ad=79.8f pd=0.8u as=0 ps=0 w=0.42u l=1u
X1187 VSS.t2995 VDD VSS.t2997 VSS.t2996 sg13_lv_nmos ad=79.8f pd=0.8u as=0 ps=0 w=0.42u l=1u
X1188 a_18470_14922# a_19275_14495# a_18730_14452# VDD sg13_lv_pmos ad=0.1428p pd=1.52u as=79.8f ps=0.8u w=0.42u l=0.13u
X1189 VDD VSS.t1323 VDD VDD sg13_lv_pmos ad=0.19p pd=1.38u as=0 ps=0 w=1u l=1u
X1190 VSS.t1395 VDD VSS.t1396 VSS.t305 sg13_lv_nmos ad=79.8f pd=0.8u as=0 ps=0 w=0.42u l=1u
X1191 VDD VSS.t2387 VDD VDD sg13_lv_pmos ad=0.19p pd=1.38u as=0 ps=0 w=1u l=1u
X1192 VDD VSS.t1031 VDD VDD sg13_lv_pmos ad=0.19p pd=1.38u as=0 ps=0 w=1u l=1u
X1193 VDD VSS.t1335 VDD VDD sg13_lv_pmos ad=0.34p pd=2.68u as=0 ps=0 w=1u l=1u
X1194 VSS.t1611 VDD VSS.t1613 VSS.t1612 sg13_lv_nmos ad=79.8f pd=0.8u as=0 ps=0 w=0.42u l=1u
X1195 VDD VSS.t2840 VDD VDD sg13_lv_pmos ad=0.34p pd=2.68u as=0 ps=0 w=1u l=1u
X1196 VSS.t2173 VDD VSS.t2172 VSS.t2171 sg13_lv_nmos ad=0.1428p pd=1.52u as=0 ps=0 w=0.42u l=1u
X1197 VSS.t1993 VDD VSS.t1995 VSS.t1994 sg13_lv_nmos ad=79.8f pd=0.8u as=0 ps=0 w=0.42u l=1u
X1198 VSS.t167 VDD VSS.t167 VSS.t519 sg13_lv_nmos ad=0.1428p pd=1.52u as=0 ps=0 w=0.42u l=1u
X1199 VSS.t914 VDD VSS.t916 VSS.t915 sg13_lv_nmos ad=79.8f pd=0.8u as=0 ps=0 w=0.42u l=1u
X1200 VSS.t2769 VDD VSS.t2770 VSS.t2710 sg13_lv_nmos ad=79.8f pd=0.8u as=0 ps=0 w=0.42u l=1u
X1201 VDD VSS.t2512 VDD VDD sg13_lv_pmos ad=0.19p pd=1.38u as=0 ps=0 w=1u l=1u
X1202 VSS.t1532 VDD VSS.t1400 VSS.t305 sg13_lv_nmos ad=79.8f pd=0.8u as=0 ps=0 w=0.42u l=1u
X1203 VSS.t3025 VDD VSS.t3024 VSS.t3023 sg13_lv_nmos ad=0.1428p pd=1.52u as=0 ps=0 w=0.42u l=1u
X1204 VDD VSS.t2719 VDD VDD sg13_lv_pmos ad=0.19p pd=1.38u as=0 ps=0 w=1u l=1u
X1205 VSS.t1933 VDD VSS.t1932 VSS.t1931 sg13_lv_nmos ad=0.1428p pd=1.52u as=0 ps=0 w=0.42u l=1u
X1206 VDD VSS.t1390 VDD VDD sg13_lv_pmos ad=0.34p pd=2.68u as=0 ps=0 w=1u l=1u
X1207 VSS.t146 sg13g2_nor3_1_0.C sg13g2_nor3_1_0.Y VSS.t145 sg13_lv_nmos ad=0.1463p pd=1.15u as=0.2618p ps=2.22u w=0.77u l=0.13u
X1208 VDD VSS.t1123 VDD VDD sg13_lv_pmos ad=0.34p pd=2.68u as=0 ps=0 w=1u l=1u
X1209 VDD VSS.t2770 VDD VDD sg13_lv_pmos ad=0.34p pd=2.68u as=0 ps=0 w=1u l=1u
X1210 VDD VSS.t2012 VDD VDD sg13_lv_pmos ad=0.34p pd=2.68u as=0 ps=0 w=1u l=1u
X1211 VSS.t686 VDD VSS.t146 VSS.t794 sg13_lv_nmos ad=79.8f pd=0.8u as=0 ps=0 w=0.42u l=1u
X1212 VSS.t32 VDD VSS.t32 VSS.t526 sg13_lv_nmos ad=0.1428p pd=1.52u as=0 ps=0 w=0.42u l=1u
X1213 VDD VSS.t2197 VDD VDD sg13_lv_pmos ad=0.34p pd=2.68u as=0 ps=0 w=1u l=1u
X1214 VSS.t285 VDD VSS.t285 VSS.t773 sg13_lv_nmos ad=79.8f pd=0.8u as=0 ps=0 w=0.42u l=1u
X1215 VDD VSS.t1695 VDD VDD sg13_lv_pmos ad=0.34p pd=2.68u as=0 ps=0 w=1u l=1u
X1216 VDD VSS.t1972 VDD VDD sg13_lv_pmos ad=0.34p pd=2.68u as=0 ps=0 w=1u l=1u
X1217 VDD VSS.t2803 VDD VDD sg13_lv_pmos ad=0.34p pd=2.68u as=0 ps=0 w=1u l=1u
X1218 a_24880_14854# sg13g2_mux2_1_1.A0 a_24766_14854# VSS.t7 sg13_lv_nmos ad=0.3367p pd=1.65u as=0.1628p ps=1.18u w=0.74u l=0.13u
X1219 a_18468_14040# a_18987_13844# a_19727_13799# VSS.t299 sg13_lv_nmos ad=0.3473p pd=2.71u as=0.12665p ps=1.145u w=0.74u l=0.13u
X1220 VSS.t2831 VDD VSS.t2832 VSS.t2710 sg13_lv_nmos ad=79.8f pd=0.8u as=0 ps=0 w=0.42u l=1u
X1221 VSS.t109 a_16078_14484# sg13g2_buf_16_1.X VSS.t37 sg13_lv_nmos ad=0.1406p pd=1.12u as=0.1406p ps=1.12u w=0.74u l=0.13u
X1222 VDD VSS.t998 VDD VDD sg13_lv_pmos ad=0.34p pd=2.68u as=0 ps=0 w=1u l=1u
X1223 VSS.t16 a_9269_13726# sg13g2_buf_4_0.X VSS.t18 sg13_lv_nmos ad=0.2516p pd=2.16u as=0.1406p ps=1.12u w=0.74u l=0.13u
X1224 VSS.t2778 VDD VSS.t2778 VSS.t2710 sg13_lv_nmos ad=0.1428p pd=1.52u as=0 ps=0 w=0.42u l=1u
X1225 VSS.t2400 VDD VSS.t2399 VSS.t2398 sg13_lv_nmos ad=0.1428p pd=1.52u as=0 ps=0 w=0.42u l=1u
X1226 VDD VSS.t257 VDD VDD sg13_lv_pmos ad=0.34p pd=2.68u as=0 ps=0 w=1u l=1u
X1227 VSS.t2847 VDD VSS.t2846 VSS.t2710 sg13_lv_nmos ad=0.1428p pd=1.52u as=0 ps=0 w=0.42u l=1u
X1228 VSS.t2123 VDD VSS.t2125 VSS.t2124 sg13_lv_nmos ad=79.8f pd=0.8u as=0 ps=0 w=0.42u l=1u
X1229 VSS.t1104 VDD VSS.t1103 VSS.t1102 sg13_lv_nmos ad=0.1428p pd=1.52u as=0 ps=0 w=0.42u l=1u
X1230 VDD VSS.t2434 VDD VDD sg13_lv_pmos ad=0.34p pd=2.68u as=0 ps=0 w=1u l=1u
X1231 VSS.t1556 VDD VSS.t1558 VSS.t1557 sg13_lv_nmos ad=79.8f pd=0.8u as=0 ps=0 w=0.42u l=1u
X1232 VSS.t2465 VDD VSS.t2467 VSS.t2466 sg13_lv_nmos ad=79.8f pd=0.8u as=0 ps=0 w=0.42u l=1u
X1233 a_5074_15234# sg13g2_tiehi_1.L_HI VSS.t49 VSS.t3320 sg13_lv_nmos ad=37.8f pd=0.6u as=79.8f ps=0.8u w=0.42u l=0.13u
X1234 VSS.t2741 VDD VSS.t2742 VSS.t2710 sg13_lv_nmos ad=79.8f pd=0.8u as=0 ps=0 w=0.42u l=1u
X1235 VDD VSS.t481 VDD VDD sg13_lv_pmos ad=0.34p pd=2.68u as=0 ps=0 w=1u l=1u
X1236 VSS.t71 VDD VSS.t71 VSS.t538 sg13_lv_nmos ad=0.1428p pd=1.52u as=0 ps=0 w=0.42u l=1u
X1237 VDD VSS.t1675 VDD VDD sg13_lv_pmos ad=0.34p pd=2.68u as=0 ps=0 w=1u l=1u
X1238 VSS.t2043 VDD VSS.t2042 VSS.t2041 sg13_lv_nmos ad=0.1428p pd=1.52u as=0 ps=0 w=0.42u l=1u
X1239 VDD VSS.t1254 VDD VDD sg13_lv_pmos ad=0.19p pd=1.38u as=0 ps=0 w=1u l=1u
X1240 VDD VSS.t2040 VDD VDD sg13_lv_pmos ad=0.19p pd=1.38u as=0 ps=0 w=1u l=1u
X1241 VSS.t1295 VDD VSS.t1294 VSS.t305 sg13_lv_nmos ad=0.1428p pd=1.52u as=0 ps=0 w=0.42u l=1u
X1242 VSS.t1686 VDD VSS.t1685 VSS.t1684 sg13_lv_nmos ad=0.1428p pd=1.52u as=0 ps=0 w=0.42u l=1u
X1243 VDD VSS.t1385 VDD VDD sg13_lv_pmos ad=0.34p pd=2.68u as=0 ps=0 w=1u l=1u
X1244 VDD VSS.t1957 VDD VDD sg13_lv_pmos ad=0.34p pd=2.68u as=0 ps=0 w=1u l=1u
X1245 VDD VSS.t2742 VDD VDD sg13_lv_pmos ad=0.34p pd=2.68u as=0 ps=0 w=1u l=1u
X1246 VDD VSS.t2795 VDD VDD sg13_lv_pmos ad=0.34p pd=2.68u as=0 ps=0 w=1u l=1u
X1247 a_12524_15960# sg13g2_nand2_2_0.A VSS.t357 VSS.t356 sg13_lv_nmos ad=0.187p pd=1.78u as=0.14875p ps=1.16u w=0.55u l=0.13u
X1248 VDD VSS.t1366 VDD VDD sg13_lv_pmos ad=0.19p pd=1.38u as=0 ps=0 w=1u l=1u
X1249 VSS.t427 VDD VSS.t326 VSS.t426 sg13_lv_nmos ad=0.1428p pd=1.52u as=0 ps=0 w=0.42u l=1u
X1250 VDD a_7653_15213# a_7755_15356# VDD sg13_lv_pmos ad=2.4406p pd=15.34u as=0.3864p ps=2.93u w=1.12u l=0.13u
X1251 VDD VSS.t2752 VDD VDD sg13_lv_pmos ad=0.19p pd=1.38u as=0 ps=0 w=1u l=1u
X1252 a_10419_14484# sg13g2_xnor2_1_1.A VDD VDD sg13_lv_pmos ad=0.1428p pd=1.375u as=0.2891p ps=1.695u w=1.12u l=0.13u
X1253 VSS.t108 clock_i a_16078_14484# VSS.t37 sg13_lv_nmos ad=0.1406p pd=1.12u as=0.1406p ps=1.12u w=0.74u l=0.13u
X1254 VSS.t1024 VDD VSS.t1023 VSS.t1022 sg13_lv_nmos ad=0.1428p pd=1.52u as=0 ps=0 w=0.42u l=1u
X1255 VDD VSS.t2549 VDD VDD sg13_lv_pmos ad=0.34p pd=2.68u as=0 ps=0 w=1u l=1u
X1256 VSS.t914 VDD VSS.t916 VSS.t915 sg13_lv_nmos ad=79.8f pd=0.8u as=0 ps=0 w=0.42u l=1u
X1257 VSS.t1313 VDD VSS.t1312 VSS.t305 sg13_lv_nmos ad=0.1428p pd=1.52u as=0 ps=0 w=0.42u l=1u
X1258 a_19173_16033# a_19173_16033# VSS.t74 VSS.t73 sg13_lv_nmos ad=0.111p pd=1.34u as=5.31717p ps=34.515u w=0.3u l=0.13u
X1259 VSS.t1776 VDD VSS.t1775 VSS.t1774 sg13_lv_nmos ad=0.1428p pd=1.52u as=0 ps=0 w=0.42u l=1u
X1260 VSS.t2859 VDD VSS.t2858 VSS.t2710 sg13_lv_nmos ad=0.1428p pd=1.52u as=0 ps=0 w=0.42u l=1u
X1261 VSS.t2761 VDD VSS.t2762 VSS.t2710 sg13_lv_nmos ad=79.8f pd=0.8u as=0 ps=0 w=0.42u l=1u
X1262 VSS.t2158 VDD VSS.t2157 VSS.t2156 sg13_lv_nmos ad=0.1428p pd=1.52u as=0 ps=0 w=0.42u l=1u
X1263 VDD VSS.t729 VDD VDD sg13_lv_pmos ad=0.19p pd=1.38u as=0 ps=0 w=1u l=1u
X1264 VSS.t724 VDD VSS.t724 VSS.t841 sg13_lv_nmos ad=0.1428p pd=1.52u as=0 ps=0 w=0.42u l=1u
X1265 VSS.t1541 VDD VSS.t1543 VSS.t1542 sg13_lv_nmos ad=79.8f pd=0.8u as=0 ps=0 w=0.42u l=1u
X1266 VDD VSS.t2592 VDD VDD sg13_lv_pmos ad=0.19p pd=1.38u as=0 ps=0 w=1u l=1u
X1267 VSS.t210 VDD VSS.t513 VSS.t512 sg13_lv_nmos ad=79.8f pd=0.8u as=0 ps=0 w=0.42u l=1u
X1268 a_24427_15280# sg13g2_nor2b_1_1.A a_24333_15280# VSS.t3 sg13_lv_nmos ad=0.1216p pd=1.02u as=0.2176p ps=1.96u w=0.64u l=0.13u
X1269 VSS.t637 VDD VSS.t639 VSS.t638 sg13_lv_nmos ad=79.8f pd=0.8u as=0 ps=0 w=0.42u l=1u
X1270 VDD VSS.t1997 VDD VDD sg13_lv_pmos ad=0.34p pd=2.68u as=0 ps=0 w=1u l=1u
X1271 VDD VSS.t2762 VDD VDD sg13_lv_pmos ad=0.34p pd=2.68u as=0 ps=0 w=1u l=1u
X1272 VDD VSS.t498 VDD VDD sg13_lv_pmos ad=0.34p pd=2.68u as=0 ps=0 w=1u l=1u
X1273 VSS.t1240 VDD VSS.t306 VSS.t305 sg13_lv_nmos ad=0.1428p pd=1.52u as=0 ps=0 w=0.42u l=1u
X1274 VSS.t1348 VDD VSS.t1349 VSS.t305 sg13_lv_nmos ad=79.8f pd=0.8u as=0 ps=0 w=0.42u l=1u
X1275 VSS.t1271 VDD VSS.t1272 VSS.t305 sg13_lv_nmos ad=79.8f pd=0.8u as=0 ps=0 w=0.42u l=1u
X1276 a_24556_14020# a_24334_13764# VDD VDD sg13_lv_pmos ad=0.1176p pd=1.33u as=0.2618p ps=1.63u w=1.12u l=0.13u
X1277 VDD VSS.t705 VDD VDD sg13_lv_pmos ad=0.34p pd=2.68u as=0 ps=0 w=1u l=1u
X1278 VDD VSS.t1246 VDD VDD sg13_lv_pmos ad=0.19p pd=1.38u as=0 ps=0 w=1u l=1u
X1279 VDD VSS.t2025 VDD VDD sg13_lv_pmos ad=0.19p pd=1.38u as=0 ps=0 w=1u l=1u
X1280 a_20015_14845# a_19173_14495# a_19921_14845# VSS.t7 sg13_lv_nmos ad=0.12665p pd=1.145u as=0.1428p ps=1.52u w=0.42u l=0.13u
X1281 VDD VSS.t2379 VDD VDD sg13_lv_pmos ad=0.34p pd=2.68u as=0 ps=0 w=1u l=1u
X1282 VDD VSS.t1116 VDD VDD sg13_lv_pmos ad=0.19p pd=1.38u as=0 ps=0 w=1u l=1u
X1283 VDD VSS.t1680 VDD VDD sg13_lv_pmos ad=0.34p pd=2.68u as=0 ps=0 w=1u l=1u
X1284 VSS.t1571 VDD VSS.t1570 VSS.t1569 sg13_lv_nmos ad=0.1428p pd=1.52u as=0 ps=0 w=0.42u l=1u
X1285 VDD VSS.t3122 VDD VDD sg13_lv_pmos ad=0.19p pd=1.38u as=0 ps=0 w=1u l=1u
X1286 VSS.t2480 VDD VSS.t2479 VSS.t2478 sg13_lv_nmos ad=0.1428p pd=1.52u as=0 ps=0 w=0.42u l=1u
X1287 VSS.t1988 VDD VSS.t1987 VSS.t1986 sg13_lv_nmos ad=0.1428p pd=1.52u as=0 ps=0 w=0.42u l=1u
X1288 VSS.t502 VDD VSS.t502 VSS.t503 sg13_lv_nmos ad=79.8f pd=0.8u as=0 ps=0 w=0.42u l=1u
X1289 a_2778_15250# sg13g2_buf_1_0.X VSS.t167 VSS.t348 sg13_lv_nmos ad=88.8f pd=0.98u as=0.15245p ps=1.17u w=0.74u l=0.13u
X1290 VSS.t2749 VDD VSS.t2748 VSS.t2710 sg13_lv_nmos ad=0.1428p pd=1.52u as=0 ps=0 w=0.42u l=1u
X1291 VSS.t63 VDD VSS.t784 VSS.t783 sg13_lv_nmos ad=0.1428p pd=1.52u as=0 ps=0 w=0.42u l=1u
X1292 VSS.t2806 VDD VSS.t2807 VSS.t2710 sg13_lv_nmos ad=79.8f pd=0.8u as=0 ps=0 w=0.42u l=1u
X1293 VDD VSS.t1043 VDD VDD sg13_lv_pmos ad=0.34p pd=2.68u as=0 ps=0 w=1u l=1u
X1294 VDD VSS.t1538 VDD VDD sg13_lv_pmos ad=0.19p pd=1.38u as=0 ps=0 w=1u l=1u
X1295 VDD VSS.t384 VDD VDD sg13_lv_pmos ad=0.34p pd=2.68u as=0 ps=0 w=1u l=1u
X1296 VSS.t402 VDD VSS.t404 VSS.t403 sg13_lv_nmos ad=79.8f pd=0.8u as=0 ps=0 w=0.42u l=1u
X1297 VDD VSS.t729 VDD VDD sg13_lv_pmos ad=0.34p pd=2.68u as=0 ps=0 w=1u l=1u
X1298 VDD VSS.t664 VDD VDD sg13_lv_pmos ad=0.34p pd=2.68u as=0 ps=0 w=1u l=1u
X1299 VDD VSS.t714 VDD VDD sg13_lv_pmos ad=0.34p pd=2.68u as=0 ps=0 w=1u l=1u
X1300 VSS.t3030 VDD VSS.t3029 VSS.t3028 sg13_lv_nmos ad=0.1428p pd=1.52u as=0 ps=0 w=0.42u l=1u
X1301 VDD VSS.t2722 VDD VDD sg13_lv_pmos ad=0.19p pd=1.38u as=0 ps=0 w=1u l=1u
X1302 a_12308_15202# sg13g2_buf_16_1.X VDD VDD sg13_lv_pmos ad=0.2128p pd=1.5u as=0.2128p ps=1.5u w=1.12u l=0.13u
X1303 VDD VSS.t1372 VDD VDD sg13_lv_pmos ad=0.34p pd=2.68u as=0 ps=0 w=1u l=1u
X1304 VSS.t1671 VDD VSS.t1673 VSS.t1672 sg13_lv_nmos ad=79.8f pd=0.8u as=0 ps=0 w=0.42u l=1u
X1305 VSS.t3200 VDD VSS.t3202 VSS.t3201 sg13_lv_nmos ad=79.8f pd=0.8u as=0 ps=0 w=0.42u l=1u
X1306 VSS.t580 VDD VSS.t42 VSS.t581 sg13_lv_nmos ad=79.8f pd=0.8u as=0 ps=0 w=0.42u l=1u
X1307 VSS.t1331 VDD VSS.t1330 VSS.t305 sg13_lv_nmos ad=0.1428p pd=1.52u as=0 ps=0 w=0.42u l=1u
X1308 VSS.t1413 VDD VSS.t1252 VSS.t305 sg13_lv_nmos ad=0.1428p pd=1.52u as=0 ps=0 w=0.42u l=1u
X1309 VSS.t1362 VDD VSS.t1363 VSS.t305 sg13_lv_nmos ad=79.8f pd=0.8u as=0 ps=0 w=0.42u l=1u
X1310 VSS.t2063 VDD VSS.t2062 VSS.t2061 sg13_lv_nmos ad=0.1428p pd=1.52u as=0 ps=0 w=0.42u l=1u
X1311 VDD VSS.t2017 VDD VDD sg13_lv_pmos ad=0.34p pd=2.68u as=0 ps=0 w=1u l=1u
X1312 VDD VSS.t918 VDD VDD sg13_lv_pmos ad=0.34p pd=2.68u as=0 ps=0 w=1u l=1u
X1313 VSS.t2733 VDD VSS.t2734 VSS.t2710 sg13_lv_nmos ad=79.8f pd=0.8u as=0 ps=0 w=0.42u l=1u
X1314 VSS.t530 VDD VSS.t531 VSS.t21 sg13_lv_nmos ad=79.8f pd=0.8u as=0 ps=0 w=0.42u l=1u
X1315 VDD VSS.t2202 VDD VDD sg13_lv_pmos ad=0.34p pd=2.68u as=0 ps=0 w=1u l=1u
X1316 VSS.t2595 VDD VSS.t2597 VSS.t2596 sg13_lv_nmos ad=79.8f pd=0.8u as=0 ps=0 w=0.42u l=1u
X1317 VDD VSS.t1700 VDD VDD sg13_lv_pmos ad=0.34p pd=2.68u as=0 ps=0 w=1u l=1u
X1318 VDD VSS.t2734 VDD VDD sg13_lv_pmos ad=0.34p pd=2.68u as=0 ps=0 w=1u l=1u
X1319 VSS.t1973 VDD VSS.t1972 VSS.t1971 sg13_lv_nmos ad=0.1428p pd=1.52u as=0 ps=0 w=0.42u l=1u
X1320 VSS.t1024 VDD VSS.t1023 VSS.t1022 sg13_lv_nmos ad=0.1428p pd=1.52u as=0 ps=0 w=0.42u l=1u
X1321 VSS.t326 a_14362_15960# a_14081_16262# VSS.t3268 sg13_lv_nmos ad=79.8f pd=0.8u as=0.1428p ps=1.52u w=0.42u l=0.5u
X1322 VSS.t657 VDD VSS.t659 VSS.t658 sg13_lv_nmos ad=79.8f pd=0.8u as=0 ps=0 w=0.42u l=1u
X1323 VDD VSS.t2838 VDD VDD sg13_lv_pmos ad=0.34p pd=2.68u as=0 ps=0 w=1u l=1u
X1324 VSS.t444 VDD VSS.t446 VSS.t445 sg13_lv_nmos ad=79.8f pd=0.8u as=0 ps=0 w=0.42u l=1u
X1325 VSS.t2781 VDD VSS.t2781 VSS.t2710 sg13_lv_nmos ad=0.1428p pd=1.52u as=0 ps=0 w=0.42u l=1u
X1326 VSS.t129 sg13g2_or3_1_0.A a_16681_13726# VSS.t128 sg13_lv_nmos ad=0.13395p pd=1.12u as=0.198p ps=1.27u w=0.55u l=0.13u
X1327 VSS.t2850 VDD VSS.t2849 VSS.t2710 sg13_lv_nmos ad=0.1428p pd=1.52u as=0 ps=0 w=0.42u l=1u
X1328 VSS.t68 a_15184_14726# a_14833_14845# VSS.t37 sg13_lv_nmos ad=79.8f pd=0.8u as=0.1428p ps=1.52u w=0.42u l=0.13u
X1329 VDD sg13g2_dfrbpq_1_5.RESET_B a_25382_14922# VDD sg13_lv_pmos ad=0.36237p pd=2.605u as=79.8f ps=0.8u w=0.42u l=0.13u
X1330 VDD VSS.t1281 VDD VDD sg13_lv_pmos ad=0.19p pd=1.38u as=0 ps=0 w=1u l=1u
X1331 VDD VSS.t2791 VDD VDD sg13_lv_pmos ad=0.19p pd=1.38u as=0 ps=0 w=1u l=1u
X1332 VSS.t2128 VDD VSS.t2130 VSS.t2129 sg13_lv_nmos ad=79.8f pd=0.8u as=0 ps=0 w=0.42u l=1u
X1333 sg13g2_dfrbpq_1_2.CLK a_12308_15202# VDD VDD sg13_lv_pmos ad=0.2128p pd=1.5u as=0.2128p ps=1.5u w=1.12u l=0.13u
X1334 VDD VSS.t881 VDD VDD sg13_lv_pmos ad=0.19p pd=1.38u as=0 ps=0 w=1u l=1u
X1335 VDD VSS.t1073 VDD VDD sg13_lv_pmos ad=0.34p pd=2.68u as=0 ps=0 w=1u l=1u
X1336 VSS.t1484 VDD VSS.t1342 VSS.t305 sg13_lv_nmos ad=0.1428p pd=1.52u as=0 ps=0 w=0.42u l=1u
X1337 VSS.t2465 VDD VSS.t2464 VSS.t2463 sg13_lv_nmos ad=0.1428p pd=1.52u as=0 ps=0 w=0.42u l=1u
X1338 VDD VSS.t2404 VDD VDD sg13_lv_pmos ad=0.34p pd=2.68u as=0 ps=0 w=1u l=1u
X1339 VDD VSS.t2577 VDD VDD sg13_lv_pmos ad=0.19p pd=1.38u as=0 ps=0 w=1u l=1u
X1340 VDD a_4270_14751# sg13g2_dlygate4sd3_1_2.X VDD sg13_lv_pmos ad=0.2254p pd=1.53u as=0.4256p ps=3u w=1.12u l=0.13u
X1341 VDD VSS.t1317 VDD VDD sg13_lv_pmos ad=0.19p pd=1.38u as=0 ps=0 w=1u l=1u
X1342 a_3684_15247# a_3915_15356# a_3370_15457# VSS.t212 sg13_lv_nmos ad=0.2373p pd=1.97u as=79.8f ps=0.8u w=0.42u l=0.13u
X1343 VDD VSS.t545 VDD VDD sg13_lv_pmos ad=0.19p pd=1.38u as=0 ps=0 w=1u l=1u
X1344 VSS.t2013 VDD VSS.t2012 VSS.t2011 sg13_lv_nmos ad=0.1428p pd=1.52u as=0 ps=0 w=0.42u l=1u
X1345 VDD VSS.t2529 VDD VDD sg13_lv_pmos ad=0.34p pd=2.68u as=0 ps=0 w=1u l=1u
X1346 VDD VSS.t2187 VDD VDD sg13_lv_pmos ad=0.34p pd=2.68u as=0 ps=0 w=1u l=1u
X1347 VDD VSS.t2010 VDD VDD sg13_lv_pmos ad=0.19p pd=1.38u as=0 ps=0 w=1u l=1u
X1348 VDD VSS.t2364 VDD VDD sg13_lv_pmos ad=0.34p pd=2.68u as=0 ps=0 w=1u l=1u
X1349 a_7529_16334# a_7653_16033# VDD VDD sg13_lv_pmos ad=0.2442p pd=2.06u as=2.4406p ps=15.34u w=0.66u l=0.13u
X1350 a_15184_14726# a_14927_14845# a_15346_14922# VSS.t37 sg13_lv_nmos ad=0.1428p pd=1.52u as=37.8f ps=0.6u w=0.42u l=0.13u
X1351 VSS.t1109 VDD VSS.t1108 VSS.t1107 sg13_lv_nmos ad=0.1428p pd=1.52u as=0 ps=0 w=0.42u l=1u
X1352 VDD VSS.t2745 VDD VDD sg13_lv_pmos ad=0.34p pd=2.68u as=0 ps=0 w=1u l=1u
X1353 sg13g2_buf_16_1.X a_16078_14484# VDD VDD sg13_lv_pmos ad=0.2128p pd=1.5u as=0.2128p ps=1.5u w=1.12u l=0.13u
X1354 VSS.t1515 VDD VSS.t1380 VSS.t305 sg13_lv_nmos ad=79.8f pd=0.8u as=0 ps=0 w=0.42u l=1u
X1355 VDD VSS.t2135 VDD VDD sg13_lv_pmos ad=0.19p pd=1.38u as=0 ps=0 w=1u l=1u
X1356 VDD sg13g2_nor2b_1_0.A a_23648_15437# VDD sg13_lv_pmos ad=0.2856p pd=2.36u as=0.1596p ps=1.22u w=0.84u l=0.13u
X1357 VDD VSS.t973 VDD VDD sg13_lv_pmos ad=0.34p pd=2.68u as=0 ps=0 w=1u l=1u
X1358 sg13g2_and2_1_0.B a_2513_15288# a_2684_15532# VDD sg13_lv_pmos ad=0.3808p pd=2.92u as=0.2128p ps=1.5u w=1.12u l=0.13u
X1359 VDD VSS.t951 VDD VDD sg13_lv_pmos ad=0.19p pd=1.38u as=0 ps=0 w=1u l=1u
X1360 VDD VSS.t1244 VDD VDD sg13_lv_pmos ad=0.19p pd=1.38u as=0 ps=0 w=1u l=1u
X1361 VSS.t2741 VDD VSS.t2741 VSS.t2710 sg13_lv_nmos ad=0.1428p pd=1.52u as=0 ps=0 w=0.42u l=1u
X1362 VSS.t2798 VDD VSS.t2799 VSS.t2710 sg13_lv_nmos ad=79.8f pd=0.8u as=0 ps=0 w=0.42u l=1u
X1363 VDD VSS.t2755 VDD VDD sg13_lv_pmos ad=0.19p pd=1.38u as=0 ps=0 w=1u l=1u
X1364 VDD a_19630_15238# sg13g2_dfrbpq_1_7.CLK VDD sg13_lv_pmos ad=0.2128p pd=1.5u as=0.2128p ps=1.5u w=1.12u l=0.13u
X1365 VDD VSS.t2994 VDD VDD sg13_lv_pmos ad=0.34p pd=2.68u as=0 ps=0 w=1u l=1u
X1366 a_18276_13722# sg13g2_dlygate4sd3_1_10.X a_18182_13722# VSS.t304 sg13_lv_nmos ad=60.89999f pd=0.71u as=0.1428p ps=1.52u w=0.42u l=0.13u
X1367 VDD a_4655_15311# a_5322_15532# VDD sg13_lv_pmos ad=0.2128p pd=1.5u as=0.3864p ps=2.93u w=1.12u l=0.13u
X1368 VSS.t74 a_19049_16334# a_18970_16237# VSS.t3283 sg13_lv_nmos ad=5.31717p pd=34.515u as=0.27427p ps=2.28u w=0.795u l=0.13u
X1369 VDD VSS.t848 VDD VDD sg13_lv_pmos ad=0.34p pd=2.68u as=0 ps=0 w=1u l=1u
X1370 VDD VSS.t1036 VDD VDD sg13_lv_pmos ad=0.19p pd=1.38u as=0 ps=0 w=1u l=1u
X1371 VSS.t1124 VDD VSS.t1123 VSS.t1122 sg13_lv_nmos ad=0.1428p pd=1.52u as=0 ps=0 w=0.42u l=1u
X1372 VSS.t3015 VDD VSS.t3014 VSS.t3013 sg13_lv_nmos ad=0.1428p pd=1.52u as=0 ps=0 w=0.42u l=1u
X1373 VDD sg13g2_dlygate4sd3_1_9.A a_17224_15996# VDD sg13_lv_pmos ad=0.2114p pd=1.54u as=0.2856p ps=2.36u w=0.84u l=0.13u
X1374 VDD a_18586_16237# sg13g2_dfrbpq_1_7.RESET_B VDD sg13_lv_pmos ad=2.4406p pd=15.34u as=0.3927p ps=2.99u w=1.155u l=0.13u
X1375 VSS.t1522 VDD VSS.t1389 VSS.t305 sg13_lv_nmos ad=79.8f pd=0.8u as=0 ps=0 w=0.42u l=1u
X1376 a_17997_16020# sg13g2_buf_4_0.X a_17908_16020# VDD sg13_lv_pmos ad=0.19p pd=1.38u as=0.1575p ps=1.315u w=1u l=0.13u
X1377 a_4912_15454# a_4655_15311# a_5074_15234# VSS.t40 sg13_lv_nmos ad=0.1428p pd=1.52u as=37.8f ps=0.6u w=0.42u l=0.13u
X1378 sg13g2_dfrbpq_1_2.CLK a_12308_15202# VDD VDD sg13_lv_pmos ad=0.2128p pd=1.5u as=0.2128p ps=1.5u w=1.12u l=0.13u
X1379 VDD VSS.t2002 VDD VDD sg13_lv_pmos ad=0.34p pd=2.68u as=0 ps=0 w=1u l=1u
X1380 VDD VSS.t2765 VDD VDD sg13_lv_pmos ad=0.34p pd=2.68u as=0 ps=0 w=1u l=1u
X1381 VDD VSS.t2562 VDD VDD sg13_lv_pmos ad=0.19p pd=1.38u as=0 ps=0 w=1u l=1u
X1382 VDD VSS.t1249 VDD VDD sg13_lv_pmos ad=0.19p pd=1.38u as=0 ps=0 w=1u l=1u
X1383 VSS.t1676 VDD VSS.t1675 VSS.t1674 sg13_lv_nmos ad=0.1428p pd=1.52u as=0 ps=0 w=0.42u l=1u
X1384 VSS.t3205 VDD VSS.t3204 VSS.t3203 sg13_lv_nmos ad=0.1428p pd=1.52u as=0 ps=0 w=0.42u l=1u
X1385 VDD VSS.t2349 VDD VDD sg13_lv_pmos ad=0.34p pd=2.68u as=0 ps=0 w=1u l=1u
X1386 VSS.t2580 VDD VSS.t2582 VSS.t2581 sg13_lv_nmos ad=79.8f pd=0.8u as=0 ps=0 w=0.42u l=1u
X1387 VDD VSS.t641 VDD VDD sg13_lv_pmos ad=0.34p pd=2.68u as=0 ps=0 w=1u l=1u
X1388 VDD VSS.t146 VDD VDD sg13_lv_pmos ad=0.34p pd=2.68u as=0 ps=0 w=1u l=1u
X1389 VDD VSS.t1685 VDD VDD sg13_lv_pmos ad=0.34p pd=2.68u as=0 ps=0 w=1u l=1u
X1390 a_3110_15234# sg13g2_and2_1_0.X VDD VDD sg13_lv_pmos ad=79.8f pd=0.8u as=0.1428p ps=1.52u w=0.42u l=0.13u
X1391 VDD VSS.t1335 VDD VDD sg13_lv_pmos ad=0.19p pd=1.38u as=0 ps=0 w=1u l=1u
X1392 VSS.t1576 VDD VSS.t1575 VSS.t1574 sg13_lv_nmos ad=0.1428p pd=1.52u as=0 ps=0 w=0.42u l=1u
X1393 VSS.t2485 VDD VSS.t2484 VSS.t2483 sg13_lv_nmos ad=0.1428p pd=1.52u as=0 ps=0 w=0.42u l=1u
X1394 VSS.t1958 VDD VSS.t1957 VSS.t1956 sg13_lv_nmos ad=0.1428p pd=1.52u as=0 ps=0 w=0.42u l=1u
X1395 a_16078_14484# clock_i VDD VDD sg13_lv_pmos ad=0.2128p pd=1.5u as=0.2128p ps=1.5u w=1.12u l=0.13u
X1396 VSS.t1746 VDD VSS.t1748 VSS.t1747 sg13_lv_nmos ad=79.8f pd=0.8u as=0 ps=0 w=0.42u l=1u
X1397 VSS.t1284 VDD VSS.t1285 VSS.t305 sg13_lv_nmos ad=79.8f pd=0.8u as=0 ps=0 w=0.42u l=1u
X1398 counter_value_o[3] a_17224_15996# VDD VDD sg13_lv_pmos ad=0.42p pd=2.99u as=0.2114p ps=1.54u w=1.12u l=0.13u
X1399 VDD VSS.t2830 VDD VDD sg13_lv_pmos ad=0.34p pd=2.68u as=0 ps=0 w=1u l=1u
X1400 VDD VSS.t2057 VDD VDD sg13_lv_pmos ad=0.34p pd=2.68u as=0 ps=0 w=1u l=1u
X1401 VSS.t479 VDD VSS.t479 VSS.t478 sg13_lv_nmos ad=0.1428p pd=1.52u as=0 ps=0 w=0.42u l=1u
X1402 VDD VSS.t3187 VDD VDD sg13_lv_pmos ad=0.19p pd=1.38u as=0 ps=0 w=1u l=1u
X1403 VSS.t2450 VDD VSS.t2452 VSS.t2451 sg13_lv_nmos ad=79.8f pd=0.8u as=0 ps=0 w=0.42u l=1u
X1404 VDD a_19630_15238# sg13g2_dfrbpq_1_7.CLK VDD sg13_lv_pmos ad=0.2128p pd=1.5u as=0.2128p ps=1.5u w=1.12u l=0.13u
X1405 VDD VSS.t695 VDD VDD sg13_lv_pmos ad=0.34p pd=2.68u as=0 ps=0 w=1u l=1u
X1406 VDD VSS.t1003 VDD VDD sg13_lv_pmos ad=0.34p pd=2.68u as=0 ps=0 w=1u l=1u
X1407 VSS.t2756 VDD VSS.t2757 VSS.t2710 sg13_lv_nmos ad=79.8f pd=0.8u as=0 ps=0 w=0.42u l=1u
X1408 VDD VSS.t2725 VDD VDD sg13_lv_pmos ad=0.19p pd=1.38u as=0 ps=0 w=1u l=1u
X1409 VSS.t1507 VDD VSS.t1369 VSS.t305 sg13_lv_nmos ad=0.1428p pd=1.52u as=0 ps=0 w=0.42u l=1u
X1410 VSS.t3000 VDD VSS.t2999 VSS.t2998 sg13_lv_nmos ad=0.1428p pd=1.52u as=0 ps=0 w=0.42u l=1u
X1411 a_13642_14452# a_14085_14495# a_14025_14531# VDD sg13_lv_pmos ad=79.8f pd=0.8u as=63f ps=0.72u w=0.42u l=0.13u
X1412 VDD sg13g2_nor4_2_0.Y a_24443_14540# VDD sg13_lv_pmos ad=0.253p pd=1.53u as=0.2856p ps=2.36u w=0.84u l=0.13u
X1413 VSS.t686 VDD VSS.t686 VSS.t687 sg13_lv_nmos ad=79.8f pd=0.8u as=0 ps=0 w=0.42u l=1u
X1414 VDD VSS.t1375 VDD VDD sg13_lv_pmos ad=0.34p pd=2.68u as=0 ps=0 w=1u l=1u
X1415 VDD VSS.t2389 VDD VDD sg13_lv_pmos ad=0.34p pd=2.68u as=0 ps=0 w=1u l=1u
X1416 VDD VSS.t2757 VDD VDD sg13_lv_pmos ad=0.34p pd=2.68u as=0 ps=0 w=1u l=1u
X1417 VSS.t1109 VDD VSS.t1108 VSS.t1107 sg13_lv_nmos ad=0.1428p pd=1.52u as=0 ps=0 w=0.42u l=1u
X1418 VDD VSS.t2514 VDD VDD sg13_lv_pmos ad=0.34p pd=2.68u as=0 ps=0 w=1u l=1u
X1419 VDD VSS.t2172 VDD VDD sg13_lv_pmos ad=0.34p pd=2.68u as=0 ps=0 w=1u l=1u
X1420 VDD VSS.t724 VDD VDD sg13_lv_pmos ad=0.19p pd=1.38u as=0 ps=0 w=1u l=1u
X1421 VDD VSS.t2737 VDD VDD sg13_lv_pmos ad=0.34p pd=2.68u as=0 ps=0 w=1u l=1u
X1422 VDD VSS.t669 VDD VDD sg13_lv_pmos ad=0.19p pd=1.38u as=0 ps=0 w=1u l=1u
X1423 VDD VSS.t1018 VDD VDD sg13_lv_pmos ad=0.34p pd=2.68u as=0 ps=0 w=1u l=1u
X1424 VSS.t459 VDD VSS.t458 VSS.t457 sg13_lv_nmos ad=0.1428p pd=1.52u as=0 ps=0 w=0.42u l=1u
X1425 a_25956_15552# a_26475_15356# a_27215_15311# VSS.t3299 sg13_lv_nmos ad=0.3473p pd=2.71u as=0.12665p ps=1.145u w=0.74u l=0.13u
X1426 VSS.t673 VDD VSS.t673 VSS.t674 sg13_lv_nmos ad=0.1428p pd=1.52u as=0 ps=0 w=0.42u l=1u
X1427 VDD VSS.t1415 VDD VDD sg13_lv_pmos ad=0.34p pd=2.68u as=0 ps=0 w=1u l=1u
X1428 VDD VSS.t2841 VDD VDD sg13_lv_pmos ad=0.34p pd=2.68u as=0 ps=0 w=1u l=1u
X1429 a_23920_14854# sg13g2_mux2_1_0.A0 a_23806_14854# VSS.t7 sg13_lv_nmos ad=0.3367p pd=1.65u as=0.1628p ps=1.18u w=0.74u l=0.13u
X1430 VSS.t2784 VDD VSS.t2783 VSS.t2710 sg13_lv_nmos ad=0.1428p pd=1.52u as=0 ps=0 w=0.42u l=1u
X1431 VSS.t1536 VDD VSS.t1538 VSS.t1537 sg13_lv_nmos ad=79.8f pd=0.8u as=0 ps=0 w=0.42u l=1u
X1432 sg13g2_xnor2_1_0.Y a_7116_13912# VDD VDD sg13_lv_pmos ad=0.2408p pd=1.55u as=0.3808p ps=2.92u w=1.12u l=0.13u
X1433 VDD VSS.t1081 VDD VDD sg13_lv_pmos ad=0.19p pd=1.38u as=0 ps=0 w=1u l=1u
X1434 VSS.t1124 VDD VSS.t1123 VSS.t1122 sg13_lv_nmos ad=0.1428p pd=1.52u as=0 ps=0 w=0.42u l=1u
X1435 VDD reset_n_i a_1192_9948# VDD sg13_lv_pmos ad=0.2114p pd=1.54u as=0.2856p ps=2.36u w=0.84u l=0.13u
X1436 VSS.t1029 VDD VSS.t1031 VSS.t1030 sg13_lv_nmos ad=79.8f pd=0.8u as=0 ps=0 w=0.42u l=1u
X1437 VDD VSS.t1668 VDD VDD sg13_lv_pmos ad=0.19p pd=1.38u as=0 ps=0 w=1u l=1u
X1438 VSS.t2833 VDD VSS.t2833 VSS.t2710 sg13_lv_nmos ad=0.1428p pd=1.52u as=0 ps=0 w=0.42u l=1u
X1439 VSS.t2098 VDD VSS.t2100 VSS.t2099 sg13_lv_nmos ad=79.8f pd=0.8u as=0 ps=0 w=0.42u l=1u
X1440 VDD VSS.t1673 VDD VDD sg13_lv_pmos ad=0.19p pd=1.38u as=0 ps=0 w=1u l=1u
X1441 VDD VSS.t2409 VDD VDD sg13_lv_pmos ad=0.34p pd=2.68u as=0 ps=0 w=1u l=1u
X1442 VDD VSS.t208 VDD VDD sg13_lv_pmos ad=0.34p pd=2.68u as=0 ps=0 w=1u l=1u
X1443 VSS.t673 VDD VSS.t671 VSS.t768 sg13_lv_nmos ad=0.1428p pd=1.52u as=0 ps=0 w=0.42u l=1u
X1444 VDD VSS.t705 VDD VDD sg13_lv_pmos ad=0.34p pd=2.68u as=0 ps=0 w=1u l=1u
X1445 VDD VSS.t733 VDD VDD sg13_lv_pmos ad=0.19p pd=1.38u as=0 ps=0 w=1u l=1u
X1446 VSS.t2018 VDD VSS.t2017 VSS.t2016 sg13_lv_nmos ad=0.1428p pd=1.52u as=0 ps=0 w=0.42u l=1u
X1447 VSS.t729 VDD VSS.t729 VSS.t844 sg13_lv_nmos ad=79.8f pd=0.8u as=0 ps=0 w=0.42u l=1u
X1448 VDD VSS.t641 VDD VDD sg13_lv_pmos ad=0.34p pd=2.68u as=0 ps=0 w=1u l=1u
X1449 VDD VSS.t1397 VDD VDD sg13_lv_pmos ad=0.34p pd=2.68u as=0 ps=0 w=1u l=1u
X1450 VDD VSS.t2732 VDD VDD sg13_lv_pmos ad=0.34p pd=2.68u as=0 ps=0 w=1u l=1u
X1451 sg13g2_dfrbpq_1_6.D a_18198_15302# VSS.t24 VSS.t21 sg13_lv_nmos ad=0.2516p pd=2.16u as=0.1426p ps=1.16u w=0.74u l=0.13u
X1452 a_27472_15454# sg13g2_dfrbpq_1_4.RESET_B VDD VDD sg13_lv_pmos ad=79.8f pd=0.8u as=2.4406p ps=15.34u w=0.42u l=0.13u
X1453 VSS.t1561 VDD VSS.t1560 VSS.t1559 sg13_lv_nmos ad=0.1428p pd=1.52u as=0 ps=0 w=0.42u l=1u
X1454 VSS.t2470 VDD VSS.t2469 VSS.t2468 sg13_lv_nmos ad=0.1428p pd=1.52u as=0 ps=0 w=0.42u l=1u
X1455 VSS.t487 VDD VSS.t487 VSS.t488 sg13_lv_nmos ad=79.8f pd=0.8u as=0 ps=0 w=0.42u l=1u
X1456 VSS.t1756 VDD VSS.t1755 VSS.t1754 sg13_lv_nmos ad=0.1428p pd=1.52u as=0 ps=0 w=0.42u l=1u
X1457 VSS.t2744 VDD VSS.t2743 VSS.t2710 sg13_lv_nmos ad=0.1428p pd=1.52u as=0 ps=0 w=0.42u l=1u
X1458 VSS.t2931 VDD VSS.t2801 VSS.t2710 sg13_lv_nmos ad=79.8f pd=0.8u as=0 ps=0 w=0.42u l=1u
X1459 VSS.t3060 VDD VSS.t3059 VSS.t3058 sg13_lv_nmos ad=0.1428p pd=1.52u as=0 ps=0 w=0.42u l=1u
X1460 VDD VSS.t3172 VDD VDD sg13_lv_pmos ad=0.19p pd=1.38u as=0 ps=0 w=1u l=1u
X1461 VSS.t2435 VDD VSS.t2437 VSS.t2436 sg13_lv_nmos ad=79.8f pd=0.8u as=0 ps=0 w=0.42u l=1u
X1462 VDD VSS.t2377 VDD VDD sg13_lv_pmos ad=0.19p pd=1.38u as=0 ps=0 w=1u l=1u
X1463 VSS.t1751 VDD VSS.t1750 VSS.t1749 sg13_lv_nmos ad=0.1428p pd=1.52u as=0 ps=0 w=0.42u l=1u
X1464 VSS.t2749 VDD VSS.t2750 VSS.t2710 sg13_lv_nmos ad=79.8f pd=0.8u as=0 ps=0 w=0.42u l=1u
X1465 VDD VSS.t1051 VDD VDD sg13_lv_pmos ad=0.19p pd=1.38u as=0 ps=0 w=1u l=1u
X1466 VDD VSS.t3124 VDD VDD sg13_lv_pmos ad=0.34p pd=2.68u as=0 ps=0 w=1u l=1u
X1467 VSS.t2844 VDD VSS.t2843 VSS.t2710 sg13_lv_nmos ad=0.1428p pd=1.52u as=0 ps=0 w=0.42u l=1u
X1468 VDD VSS.t2716 VDD VDD sg13_lv_pmos ad=0.19p pd=1.38u as=0 ps=0 w=1u l=1u
X1469 VSS.t657 VDD VSS.t659 VSS.t658 sg13_lv_nmos ad=79.8f pd=0.8u as=0 ps=0 w=0.42u l=1u
X1470 a_27215_15311# a_26373_15213# a_27121_15311# VSS.t3302 sg13_lv_nmos ad=0.12665p pd=1.145u as=0.1428p ps=1.52u w=0.42u l=0.13u
X1471 a_11493_14495# sg13g2_dfrbpq_1_2.CLK VSS.t7 VSS.t85 sg13_lv_nmos ad=0.2516p pd=2.16u as=4.79747p ps=30.975u w=0.74u l=0.13u
X1472 VSS.t131 a_24443_14540# a_24880_14854# VSS.t7 sg13_lv_nmos ad=0.148p pd=1.14u as=0.3367p ps=1.65u w=0.74u l=0.13u
X1473 VDD VSS.t1288 VDD VDD sg13_lv_pmos ad=0.19p pd=1.38u as=0 ps=0 w=1u l=1u
X1474 VDD VSS.t1367 VDD VDD sg13_lv_pmos ad=0.34p pd=2.68u as=0 ps=0 w=1u l=1u
X1475 sg13g2_buf_16_1.X a_16078_14484# VSS.t66 VSS.t37 sg13_lv_nmos ad=0.1406p pd=1.12u as=0.1406p ps=1.12u w=0.74u l=0.13u
X1476 VDD VSS.t714 VDD VDD sg13_lv_pmos ad=0.34p pd=2.68u as=0 ps=0 w=1u l=1u
X1477 VDD VSS.t2567 VDD VDD sg13_lv_pmos ad=0.19p pd=1.38u as=0 ps=0 w=1u l=1u
X1478 VSS.t2053 VDD VSS.t2052 VSS.t2051 sg13_lv_nmos ad=0.1428p pd=1.52u as=0 ps=0 w=0.42u l=1u
X1479 VDD VSS.t2007 VDD VDD sg13_lv_pmos ad=0.34p pd=2.68u as=0 ps=0 w=1u l=1u
X1480 VDD VSS.t2750 VDD VDD sg13_lv_pmos ad=0.34p pd=2.68u as=0 ps=0 w=1u l=1u
X1481 VSS.t642 VDD VSS.t641 VSS.t640 sg13_lv_nmos ad=0.1428p pd=1.52u as=0 ps=0 w=0.42u l=1u
X1482 VDD a_25175_16301# a_25175_16071# VDD sg13_lv_pmos ad=2.4406p pd=15.34u as=0.2442p ps=2.06u w=0.66u l=0.13u
X1483 VSS.t2585 VDD VSS.t2587 VSS.t2586 sg13_lv_nmos ad=79.8f pd=0.8u as=0 ps=0 w=0.42u l=1u
X1484 VDD VSS.t926 VDD VDD sg13_lv_pmos ad=0.19p pd=1.38u as=0 ps=0 w=1u l=1u
X1485 VDD VSS.t2527 VDD VDD sg13_lv_pmos ad=0.19p pd=1.38u as=0 ps=0 w=1u l=1u
X1486 VSS.t1546 VDD VSS.t1545 VSS.t1544 sg13_lv_nmos ad=0.1428p pd=1.52u as=0 ps=0 w=0.42u l=1u
X1487 VDD VSS.t564 VDD VDD sg13_lv_pmos ad=0.34p pd=2.68u as=0 ps=0 w=1u l=1u
X1488 a_18182_13722# a_18987_13844# a_18442_13945# VDD sg13_lv_pmos ad=0.1428p pd=1.52u as=79.8f ps=0.8u w=0.42u l=0.13u
X1489 VSS.t1324 VDD VSS.t1323 VSS.t305 sg13_lv_nmos ad=0.1428p pd=1.52u as=0 ps=0 w=0.42u l=1u
X1490 a_7236_15552# a_7755_15356# a_8495_15311# VSS.t94 sg13_lv_nmos ad=0.3473p pd=2.71u as=0.12665p ps=1.145u w=0.74u l=0.13u
X1491 VSS.t2923 VDD VSS.t2793 VSS.t2710 sg13_lv_nmos ad=79.8f pd=0.8u as=0 ps=0 w=0.42u l=1u
X1492 VDD VSS.t394 VDD VDD sg13_lv_pmos ad=0.34p pd=2.68u as=0 ps=0 w=1u l=1u
X1493 VDD VSS.t443 VDD VDD sg13_lv_pmos ad=0.34p pd=2.68u as=0 ps=0 w=1u l=1u
X1494 VDD VSS.t2027 VDD VDD sg13_lv_pmos ad=0.34p pd=2.68u as=0 ps=0 w=1u l=1u
X1495 VSS.t175 a_26458_13690# a_26177_13912# VSS.t327 sg13_lv_nmos ad=79.8f pd=0.8u as=0.1428p ps=1.52u w=0.42u l=0.5u
X1496 VSS.t695 VDD VSS.t695 VSS.t697 sg13_lv_nmos ad=0.1428p pd=1.52u as=0 ps=0 w=0.42u l=1u
X1497 VDD VSS.t724 VDD VDD sg13_lv_pmos ad=0.34p pd=2.68u as=0 ps=0 w=1u l=1u
X1498 VDD VSS.t1247 VDD VDD sg13_lv_pmos ad=0.34p pd=2.68u as=0 ps=0 w=1u l=1u
X1499 VDD VSS.t3192 VDD VDD sg13_lv_pmos ad=0.19p pd=1.38u as=0 ps=0 w=1u l=1u
X1500 VSS.t1029 VDD VSS.t1031 VSS.t1030 sg13_lv_nmos ad=79.8f pd=0.8u as=0 ps=0 w=0.42u l=1u
X1501 VDD VSS.t1306 VDD VDD sg13_lv_pmos ad=0.34p pd=2.68u as=0 ps=0 w=1u l=1u
X1502 a_9650_15242# sg13g2_dlygate4sd3_1_2.A VSS.t32 VSS.t319 sg13_lv_nmos ad=0.1406p pd=1.12u as=0.2516p ps=2.16u w=0.74u l=0.13u
X1503 VSS.t554 VDD VSS.t554 VSS.t607 sg13_lv_nmos ad=79.8f pd=0.8u as=0 ps=0 w=0.42u l=1u
X1504 VDD sg13g2_xor2_1_1.A a_14078_14044# VDD sg13_lv_pmos ad=0.36p pd=2.72u as=0.1225p ps=1.245u w=1u l=0.13u
X1505 VSS.t1074 VDD VSS.t1073 VSS.t1072 sg13_lv_nmos ad=0.1428p pd=1.52u as=0 ps=0 w=0.42u l=1u
X1506 VSS.t1264 VDD VSS.t1264 VSS.t305 sg13_lv_nmos ad=0.1428p pd=1.52u as=0 ps=0 w=0.42u l=1u
X1507 VSS.t3005 VDD VSS.t3004 VSS.t3003 sg13_lv_nmos ad=0.1428p pd=1.52u as=0 ps=0 w=0.42u l=1u
X1508 VSS.t569 VDD VSS.t569 VSS.t570 sg13_lv_nmos ad=0.1428p pd=1.52u as=0 ps=0 w=0.42u l=1u
X1509 VSS.t20 a_15610_13690# a_15329_13912# VSS.t19 sg13_lv_nmos ad=79.8f pd=0.8u as=0.1428p ps=1.52u w=0.42u l=0.5u
X1510 VSS.t3175 VDD VSS.t3177 VSS.t3176 sg13_lv_nmos ad=79.8f pd=0.8u as=0 ps=0 w=0.42u l=1u
X1511 VSS.t2380 VDD VSS.t2382 VSS.t2381 sg13_lv_nmos ad=79.8f pd=0.8u as=0 ps=0 w=0.42u l=1u
X1512 VDD VSS.t559 VDD VDD sg13_lv_pmos ad=0.19p pd=1.38u as=0 ps=0 w=1u l=1u
X1513 VDD VSS.t2394 VDD VDD sg13_lv_pmos ad=0.34p pd=2.68u as=0 ps=0 w=1u l=1u
X1514 a_16078_14484# clock_i VSS.t108 VSS.t37 sg13_lv_nmos ad=0.1406p pd=1.12u as=0.1406p ps=1.12u w=0.74u l=0.13u
X1515 VSS.t724 VDD VSS.t724 VSS.t727 sg13_lv_nmos ad=79.8f pd=0.8u as=0 ps=0 w=0.42u l=1u
X1516 VDD VSS.t1540 VDD VDD sg13_lv_pmos ad=0.34p pd=2.68u as=0 ps=0 w=1u l=1u
X1517 sg13g2_buf_4_0.X a_9269_13726# VSS.t14 VSS.t13 sg13_lv_nmos ad=0.1406p pd=1.12u as=0.3293p ps=1.63u w=0.74u l=0.13u
X1518 VSS.t2455 VDD VSS.t2457 VSS.t2456 sg13_lv_nmos ad=79.8f pd=0.8u as=0 ps=0 w=0.42u l=1u
X1519 a_7572_13768# sg13g2_xnor2_1_0.B a_7116_13912# VSS.t3305 sg13_lv_nmos ad=78.39999f pd=0.885u as=0.2176p ps=1.96u w=0.64u l=0.13u
X1520 VSS.t63 sg13g2_xor2_1_1.A a_16089_13723# VSS.t62 sg13_lv_nmos ad=0.1368p pd=1.1u as=0.27p ps=2.19u w=0.72u l=0.13u
X1521 VSS.t2774 VDD VSS.t2773 VSS.t2710 sg13_lv_nmos ad=0.1428p pd=1.52u as=0 ps=0 w=0.42u l=1u
X1522 VDD VSS.t2519 VDD VDD sg13_lv_pmos ad=0.34p pd=2.68u as=0 ps=0 w=1u l=1u
X1523 VSS.t2003 VDD VSS.t2002 VSS.t2001 sg13_lv_nmos ad=0.1428p pd=1.52u as=0 ps=0 w=0.42u l=1u
X1524 VDD VSS.t2722 VDD VDD sg13_lv_pmos ad=0.34p pd=2.68u as=0 ps=0 w=1u l=1u
X1525 VSS.t32 a_8495_15311# a_9162_15532# VSS.t34 sg13_lv_nmos ad=0.1406p pd=1.12u as=0.2516p ps=2.16u w=0.74u l=0.13u
X1526 a_27322_13690# sg13g2_dlygate4sd3_1_12.A VSS.t257 VSS.t256 sg13_lv_nmos ad=0.1428p pd=1.52u as=79.8f ps=0.8u w=0.42u l=0.13u
X1527 VDD VSS.t1675 VDD VDD sg13_lv_pmos ad=0.34p pd=2.68u as=0 ps=0 w=1u l=1u
X1528 VSS.t470 VDD VSS.t469 VSS.t468 sg13_lv_nmos ad=0.1428p pd=1.52u as=0 ps=0 w=0.42u l=1u
X1529 VSS.t949 VDD VSS.t951 VSS.t950 sg13_lv_nmos ad=79.8f pd=0.8u as=0 ps=0 w=0.42u l=1u
X1530 VDD VSS.t2095 VDD VDD sg13_lv_pmos ad=0.19p pd=1.38u as=0 ps=0 w=1u l=1u
X1531 sg13g2_dfrbpq_1_3.RESET_B a_13278_15934# VDD VDD sg13_lv_pmos ad=0.3927p pd=2.99u as=2.4406p ps=15.34u w=1.155u l=0.13u
X1532 VDD VSS.t1258 VDD VDD sg13_lv_pmos ad=0.34p pd=2.68u as=0 ps=0 w=1u l=1u
X1533 VDD VSS.t1360 VDD VDD sg13_lv_pmos ad=0.19p pd=1.38u as=0 ps=0 w=1u l=1u
X1534 VSS.t2768 VDD VSS.t2767 VSS.t2710 sg13_lv_nmos ad=0.1428p pd=1.52u as=0 ps=0 w=0.42u l=1u
X1535 VDD sg13g2_inv_1_1.Y a_22806_14484# VDD sg13_lv_pmos ad=0.3864p pd=2.93u as=0.2128p ps=1.5u w=1.12u l=0.13u
X1536 VSS.t811 VDD VSS.t351 VSS.t812 sg13_lv_nmos ad=79.8f pd=0.8u as=0 ps=0 w=0.42u l=1u
X1537 VDD VSS.t1093 VDD VDD sg13_lv_pmos ad=0.34p pd=2.68u as=0 ps=0 w=1u l=1u
X1538 a_8495_15311# a_7653_15213# a_8401_15311# VSS.t46 sg13_lv_nmos ad=0.12665p pd=1.145u as=0.1428p ps=1.52u w=0.42u l=0.13u
X1539 a_25956_15552# a_25930_15457# VSS.t81 VSS.t105 sg13_lv_nmos ad=0.2516p pd=2.16u as=0.1626p ps=1.415u w=0.74u l=0.13u
X1540 VDD VSS.t3109 VDD VDD sg13_lv_pmos ad=0.34p pd=2.68u as=0 ps=0 w=1u l=1u
X1541 VSS.t2836 VDD VSS.t2835 VSS.t2710 sg13_lv_nmos ad=0.1428p pd=1.52u as=0 ps=0 w=0.42u l=1u
X1542 VSS.t2103 VDD VSS.t2105 VSS.t2104 sg13_lv_nmos ad=79.8f pd=0.8u as=0 ps=0 w=0.42u l=1u
X1543 VSS.t3195 VDD VSS.t3197 VSS.t3196 sg13_lv_nmos ad=79.8f pd=0.8u as=0 ps=0 w=0.42u l=1u
X1544 VSS.t1397 VDD VSS.t1397 VSS.t305 sg13_lv_nmos ad=0.1428p pd=1.52u as=0 ps=0 w=0.42u l=1u
X1545 VDD VSS.t2552 VDD VDD sg13_lv_pmos ad=0.19p pd=1.38u as=0 ps=0 w=1u l=1u
X1546 a_16078_14484# clock_i VSS.t292 VSS.t37 sg13_lv_nmos ad=0.1406p pd=1.12u as=0.2516p ps=2.16u w=0.74u l=0.13u
X1547 VDD VSS.t1733 VDD VDD sg13_lv_pmos ad=0.19p pd=1.38u as=0 ps=0 w=1u l=1u
X1548 VSS.t2023 VDD VSS.t2022 VSS.t2021 sg13_lv_nmos ad=0.1428p pd=1.52u as=0 ps=0 w=0.42u l=1u
X1549 a_9170_16362# sg13g2_dlygate4sd3_1_2.X VSS.t339 VSS.t338 sg13_lv_nmos ad=0.1406p pd=1.12u as=0.2886p ps=2.26u w=0.74u l=0.13u
X1550 VSS.t331 sg13g2_xnor2_1_0.B a_7151_13726# VSS.t3304 sg13_lv_nmos ad=0.1898p pd=1.36u as=0.1406p ps=1.12u w=0.74u l=0.13u
X1551 VSS.t1606 VDD VSS.t1605 VSS.t1604 sg13_lv_nmos ad=0.1428p pd=1.52u as=0 ps=0 w=0.42u l=1u
X1552 VSS.t1391 VDD VSS.t1392 VSS.t305 sg13_lv_nmos ad=79.8f pd=0.8u as=0 ps=0 w=0.42u l=1u
X1553 VDD VSS.t2734 VDD VDD sg13_lv_pmos ad=0.34p pd=2.68u as=0 ps=0 w=1u l=1u
X1554 VSS.t92 VDD VSS.t92 VSS.t493 sg13_lv_nmos ad=0.1428p pd=1.52u as=0 ps=0 w=0.42u l=1u
X1555 VSS.t318 sg13g2_dlygate4sd3_1_2.A a_7930_14854# VSS.t11 sg13_lv_nmos ad=0.2516p pd=2.16u as=0.1406p ps=1.12u w=0.74u l=0.13u
X1556 VSS.t664 VDD VSS.t664 VSS.t667 sg13_lv_nmos ad=79.8f pd=0.8u as=0 ps=0 w=0.42u l=1u
X1557 VSS.t919 VDD VSS.t918 VSS.t917 sg13_lv_nmos ad=0.1428p pd=1.52u as=0 ps=0 w=0.42u l=1u
X1558 VDD VSS.t2826 VDD VDD sg13_lv_pmos ad=0.19p pd=1.38u as=0 ps=0 w=1u l=1u
X1559 VSS.t2133 VDD VSS.t2132 VSS.t2131 sg13_lv_nmos ad=0.1428p pd=1.52u as=0 ps=0 w=0.42u l=1u
X1560 VDD VSS.t971 VDD VDD sg13_lv_pmos ad=0.19p pd=1.38u as=0 ps=0 w=1u l=1u
X1561 VDD VSS.t2422 VDD VDD sg13_lv_pmos ad=0.19p pd=1.38u as=0 ps=0 w=1u l=1u
X1562 VDD VSS.t2080 VDD VDD sg13_lv_pmos ad=0.19p pd=1.38u as=0 ps=0 w=1u l=1u
X1563 VSS.t733 VDD VSS.t733 VSS.t734 sg13_lv_nmos ad=0.1428p pd=1.52u as=0 ps=0 w=0.42u l=1u
X1564 VSS.t2746 VDD VSS.t2746 VSS.t2710 sg13_lv_nmos ad=0.1428p pd=1.52u as=0 ps=0 w=0.42u l=1u
X1565 VDD VSS.t52 VDD VDD sg13_lv_pmos ad=0.19p pd=1.38u as=0 ps=0 w=1u l=1u
X1566 VSS.t796 VDD VSS.t146 VSS.t795 sg13_lv_nmos ad=0.1428p pd=1.52u as=0 ps=0 w=0.42u l=1u
X1567 VDD VSS.t2205 VDD VDD sg13_lv_pmos ad=0.19p pd=1.38u as=0 ps=0 w=1u l=1u
X1568 VSS.t322 a_2540_15960# counter_value_o[0] VSS.t336 sg13_lv_nmos ad=0.14875p pd=1.16u as=0.2886p ps=2.26u w=0.74u l=0.13u
X1569 VSS.t1074 VDD VSS.t1073 VSS.t1072 sg13_lv_nmos ad=0.1428p pd=1.52u as=0 ps=0 w=0.42u l=1u
X1570 VSS.t2440 VDD VSS.t2442 VSS.t2441 sg13_lv_nmos ad=79.8f pd=0.8u as=0 ps=0 w=0.42u l=1u
X1571 VDD VSS.t1056 VDD VDD sg13_lv_pmos ad=0.19p pd=1.38u as=0 ps=0 w=1u l=1u
X1572 VDD VSS.t1538 VDD VDD sg13_lv_pmos ad=0.19p pd=1.38u as=0 ps=0 w=1u l=1u
X1573 VSS.t2711 enable_i a_1192_3900# VSS.t2710 sg13_lv_nmos ad=0.14875p pd=1.16u as=0.187p ps=1.78u w=0.55u l=0.13u
X1574 VSS.t1287 VDD VSS.t1288 VSS.t305 sg13_lv_nmos ad=79.8f pd=0.8u as=0 ps=0 w=0.42u l=1u
X1575 VSS.t374 VDD VSS.t373 VSS.t372 sg13_lv_nmos ad=0.1428p pd=1.52u as=0 ps=0 w=0.42u l=1u
X1576 VSS.t2990 VDD VSS.t2989 VSS.t2988 sg13_lv_nmos ad=0.1428p pd=1.52u as=0 ps=0 w=0.42u l=1u
X1577 VDD VSS.t498 VDD VDD sg13_lv_pmos ad=0.19p pd=1.38u as=0 ps=0 w=1u l=1u
X1578 VDD VSS.t1369 VDD VDD sg13_lv_pmos ad=0.34p pd=2.68u as=0 ps=0 w=1u l=1u
X1579 a_12308_15202# sg13g2_buf_16_1.X VSS.t89 VSS.t220 sg13_lv_nmos ad=0.1406p pd=1.12u as=0.1406p ps=1.12u w=0.74u l=0.13u
X1580 VSS.t238 a_19546_12936# a_19265_13238# VSS.t333 sg13_lv_nmos ad=79.8f pd=0.8u as=0.1428p ps=1.52u w=0.42u l=0.5u
X1581 VSS.t705 VDD VSS.t705 VSS.t824 sg13_lv_nmos ad=79.8f pd=0.8u as=0 ps=0 w=0.42u l=1u
X1582 VDD VSS.t2572 VDD VDD sg13_lv_pmos ad=0.19p pd=1.38u as=0 ps=0 w=1u l=1u
X1583 a_13668_14488# a_13642_14452# VSS.t89 VSS.t230 sg13_lv_nmos ad=0.2516p pd=2.16u as=0.1626p ps=1.415u w=0.74u l=0.13u
X1584 VDD VSS.t700 VDD VDD sg13_lv_pmos ad=0.34p pd=2.68u as=0 ps=0 w=1u l=1u
X1585 VDD VSS.t2752 VDD VDD sg13_lv_pmos ad=0.34p pd=2.68u as=0 ps=0 w=1u l=1u
X1586 VSS.t1556 VDD VSS.t1555 VSS.t1554 sg13_lv_nmos ad=0.1428p pd=1.52u as=0 ps=0 w=0.42u l=1u
X1587 VSS.t100 a_12592_14726# a_12241_14845# VSS.t88 sg13_lv_nmos ad=79.8f pd=0.8u as=0.1428p ps=1.52u w=0.42u l=0.13u
X1588 VSS.t879 VDD VSS.t881 VSS.t880 sg13_lv_nmos ad=79.8f pd=0.8u as=0 ps=0 w=0.42u l=1u
X1589 VSS.t949 VDD VSS.t951 VSS.t950 sg13_lv_nmos ad=79.8f pd=0.8u as=0 ps=0 w=0.42u l=1u
X1590 VDD VSS.t938 VDD VDD sg13_lv_pmos ad=0.34p pd=2.68u as=0 ps=0 w=1u l=1u
X1591 VSS.t2118 VDD VSS.t2117 VSS.t2116 sg13_lv_nmos ad=0.1428p pd=1.52u as=0 ps=0 w=0.42u l=1u
X1592 a_15346_14922# sg13g2_dfrbpq_1_3.RESET_B VSS.t68 VSS.t37 sg13_lv_nmos ad=37.8f pd=0.6u as=79.8f ps=0.8u w=0.42u l=0.13u
X1593 VSS.t1551 VDD VSS.t1550 VSS.t1549 sg13_lv_nmos ad=0.1428p pd=1.52u as=0 ps=0 w=0.42u l=1u
X1594 VSS.t2739 VDD VSS.t2738 VSS.t2710 sg13_lv_nmos ad=0.1428p pd=1.52u as=0 ps=0 w=0.42u l=1u
X1595 VSS.t2460 VDD VSS.t2459 VSS.t2458 sg13_lv_nmos ad=0.1428p pd=1.52u as=0 ps=0 w=0.42u l=1u
X1596 VDD VSS.t479 VDD VDD sg13_lv_pmos ad=0.34p pd=2.68u as=0 ps=0 w=1u l=1u
X1597 VSS.t1721 VDD VSS.t1723 VSS.t1722 sg13_lv_nmos ad=79.8f pd=0.8u as=0 ps=0 w=0.42u l=1u
X1598 VDD VSS.t210 VDD VDD sg13_lv_pmos ad=0.19p pd=1.38u as=0 ps=0 w=1u l=1u
X1599 VDD VSS.t2032 VDD VDD sg13_lv_pmos ad=0.34p pd=2.68u as=0 ps=0 w=1u l=1u
X1600 a_12592_14726# a_12335_14845# a_12754_14922# VSS.t88 sg13_lv_nmos ad=0.1428p pd=1.52u as=37.8f ps=0.6u w=0.42u l=0.13u
X1601 VDD VSS.t1250 VDD VDD sg13_lv_pmos ad=0.34p pd=2.68u as=0 ps=0 w=1u l=1u
X1602 VDD VSS.t1001 VDD VDD sg13_lv_pmos ad=0.19p pd=1.38u as=0 ps=0 w=1u l=1u
X1603 VSS.t1260 VDD VSS.t1259 VSS.t305 sg13_lv_nmos ad=0.1428p pd=1.52u as=0 ps=0 w=0.42u l=1u
X1604 VDD VSS.t3162 VDD VDD sg13_lv_pmos ad=0.19p pd=1.38u as=0 ps=0 w=1u l=1u
X1605 VDD VSS.t2367 VDD VDD sg13_lv_pmos ad=0.19p pd=1.38u as=0 ps=0 w=1u l=1u
X1606 VSS.t676 VDD VSS.t676 VSS.t677 sg13_lv_nmos ad=0.1428p pd=1.52u as=0 ps=0 w=0.42u l=1u
X1607 VDD a_19727_13799# a_19984_13942# VDD sg13_lv_pmos ad=2.75157p pd=17.885u as=79.8f ps=0.8u w=0.42u l=0.13u
X1608 VSS.t2088 VDD VSS.t2090 VSS.t2089 sg13_lv_nmos ad=79.8f pd=0.8u as=0 ps=0 w=0.42u l=1u
X1609 a_25930_15457# a_26373_15213# a_26313_15625# VDD sg13_lv_pmos ad=79.8f pd=0.8u as=63f ps=0.72u w=0.42u l=0.13u
X1610 VSS.t2942 VDD VSS.t2810 VSS.t2710 sg13_lv_nmos ad=0.1428p pd=1.52u as=0 ps=0 w=0.42u l=1u
X1611 VSS.t3180 VDD VSS.t3182 VSS.t3181 sg13_lv_nmos ad=79.8f pd=0.8u as=0 ps=0 w=0.42u l=1u
X1612 VDD VSS.t2399 VDD VDD sg13_lv_pmos ad=0.34p pd=2.68u as=0 ps=0 w=1u l=1u
X1613 sg13g2_dfrbpq_1_2.CLK a_12308_15202# VSS.t100 VSS.t182 sg13_lv_nmos ad=0.1406p pd=1.12u as=0.1406p ps=1.12u w=0.74u l=0.13u
X1614 a_11433_14531# a_11076_14488# VDD VDD sg13_lv_pmos ad=63f pd=0.72u as=0.1563p ps=1.22u w=0.42u l=0.13u
X1615 a_7524_15247# a_7236_15552# a_7462_15247# VSS.t44 sg13_lv_nmos ad=0.1428p pd=1.52u as=37.8f ps=0.6u w=0.42u l=0.13u
X1616 VSS.t126 a_20272_14726# a_19921_14845# VSS.t7 sg13_lv_nmos ad=79.8f pd=0.8u as=0.1428p ps=1.52u w=0.42u l=0.13u
X1617 VDD VSS.t1718 VDD VDD sg13_lv_pmos ad=0.19p pd=1.38u as=0 ps=0 w=1u l=1u
X1618 VSS.t919 VDD VSS.t918 VSS.t917 sg13_lv_nmos ad=0.1428p pd=1.52u as=0 ps=0 w=0.42u l=1u
X1619 VDD VSS.t901 VDD VDD sg13_lv_pmos ad=0.19p pd=1.38u as=0 ps=0 w=1u l=1u
X1620 VSS.t2008 VDD VSS.t2007 VSS.t2006 sg13_lv_nmos ad=0.1428p pd=1.52u as=0 ps=0 w=0.42u l=1u
X1621 VDD sg13g2_nor3_1_0.Y a_23483_14540# VDD sg13_lv_pmos ad=0.253p pd=1.53u as=0.2856p ps=2.36u w=0.84u l=0.13u
X1622 VDD VSS.t1670 VDD VDD sg13_lv_pmos ad=0.34p pd=2.68u as=0 ps=0 w=1u l=1u
X1623 VSS.t2759 VDD VSS.t2758 VSS.t2710 sg13_lv_nmos ad=0.1428p pd=1.52u as=0 ps=0 w=0.42u l=1u
X1624 VDD VSS.t2726 VDD VDD sg13_lv_pmos ad=0.34p pd=2.68u as=0 ps=0 w=1u l=1u
X1625 VDD VSS.t208 VDD VDD sg13_lv_pmos ad=0.34p pd=2.68u as=0 ps=0 w=1u l=1u
X1626 VSS.t309 a_19727_13799# a_20394_14020# VSS.t308 sg13_lv_nmos ad=0.1406p pd=1.12u as=0.2516p ps=2.16u w=0.74u l=0.13u
X1627 VDD VSS.t1016 VDD VDD sg13_lv_pmos ad=0.19p pd=1.38u as=0 ps=0 w=1u l=1u
X1628 VSS.t1457 VDD VSS.t1308 VSS.t305 sg13_lv_nmos ad=0.1428p pd=1.52u as=0 ps=0 w=0.42u l=1u
X1629 VSS.t1741 VDD VSS.t1743 VSS.t1742 sg13_lv_nmos ad=79.8f pd=0.8u as=0 ps=0 w=0.42u l=1u
X1630 VDD VSS.t2584 VDD VDD sg13_lv_pmos ad=0.34p pd=2.68u as=0 ps=0 w=1u l=1u
X1631 VDD VSS.t2407 VDD VDD sg13_lv_pmos ad=0.19p pd=1.38u as=0 ps=0 w=1u l=1u
X1632 a_20272_14726# a_20015_14845# a_20434_14922# VSS.t7 sg13_lv_nmos ad=0.1428p pd=1.52u as=37.8f ps=0.6u w=0.42u l=0.13u
X1633 VSS.t642 VDD VSS.t641 VSS.t640 sg13_lv_nmos ad=0.1428p pd=1.52u as=0 ps=0 w=0.42u l=1u
X1634 VDD VSS.t2827 VDD VDD sg13_lv_pmos ad=0.34p pd=2.68u as=0 ps=0 w=1u l=1u
X1635 VSS.t1351 VDD VSS.t1350 VSS.t305 sg13_lv_nmos ad=0.1428p pd=1.52u as=0 ps=0 w=0.42u l=1u
X1636 VDD VSS.t1363 VDD VDD sg13_lv_pmos ad=0.19p pd=1.38u as=0 ps=0 w=1u l=1u
X1637 VDD VSS.t2190 VDD VDD sg13_lv_pmos ad=0.19p pd=1.38u as=0 ps=0 w=1u l=1u
X1638 a_18086_15238# a_17816_15238# VSS.t66 VSS.t21 sg13_lv_nmos ad=0.1428p pd=1.52u as=79.8f ps=0.8u w=0.42u l=0.5u
X1639 VSS.t125 a_19630_15238# sg13g2_dfrbpq_1_7.CLK VSS.t3 sg13_lv_nmos ad=0.1406p pd=1.12u as=0.1406p ps=1.12u w=0.74u l=0.13u
X1640 VSS.t1049 VDD VSS.t1051 VSS.t1050 sg13_lv_nmos ad=79.8f pd=0.8u as=0 ps=0 w=0.42u l=1u
X1641 VDD a_19546_12936# a_19265_13238# VDD sg13_lv_pmos ad=0.1523p pd=1.38u as=0.34p ps=2.68u w=1u l=0.5u
X1642 VDD sg13g2_tiehi_1.L_HI a_3110_15234# VDD sg13_lv_pmos ad=0.36237p pd=2.605u as=79.8f ps=0.8u w=0.42u l=0.13u
X1643 sg13g2_nor3_1_0.C sg13g2_nand2_1_1.A a_21946_14854# VSS.t7 sg13_lv_nmos ad=0.2516p pd=2.16u as=0.1406p ps=1.12u w=0.74u l=0.13u
X1644 VDD VSS.t3114 VDD VDD sg13_lv_pmos ad=0.34p pd=2.68u as=0 ps=0 w=1u l=1u
X1645 VSS.t2320 VDD VSS.t2322 VSS.t2321 sg13_lv_nmos ad=79.8f pd=0.8u as=0 ps=0 w=0.42u l=1u
X1646 VDD VSS.t719 VDD VDD sg13_lv_pmos ad=0.34p pd=2.68u as=0 ps=0 w=1u l=1u
X1647 VSS.t879 VDD VSS.t881 VSS.t880 sg13_lv_nmos ad=79.8f pd=0.8u as=0 ps=0 w=0.42u l=1u
X1648 VDD VSS.t2557 VDD VDD sg13_lv_pmos ad=0.19p pd=1.38u as=0 ps=0 w=1u l=1u
X1649 VDD VSS.t1738 VDD VDD sg13_lv_pmos ad=0.19p pd=1.38u as=0 ps=0 w=1u l=1u
X1650 sg13g2_dfrbpq_1_2.CLK a_12308_15202# VSS.t137 VSS.t182 sg13_lv_nmos ad=0.1406p pd=1.12u as=0.2516p ps=2.16u w=0.74u l=0.13u
X1651 VSS.t1541 VDD VSS.t1540 VSS.t1539 sg13_lv_nmos ad=0.1428p pd=1.52u as=0 ps=0 w=0.42u l=1u
X1652 VSS.t1360 VDD VSS.t1359 VSS.t305 sg13_lv_nmos ad=0.1428p pd=1.52u as=0 ps=0 w=0.42u l=1u
X1653 VDD VSS.t2716 VDD VDD sg13_lv_pmos ad=0.34p pd=2.68u as=0 ps=0 w=1u l=1u
X1654 a_11050_14452# a_11493_14495# a_11433_14531# VDD sg13_lv_pmos ad=79.8f pd=0.8u as=63f ps=0.72u w=0.42u l=0.13u
X1655 VSS.t2103 VDD VSS.t2102 VSS.t2101 sg13_lv_nmos ad=0.1428p pd=1.52u as=0 ps=0 w=0.42u l=1u
X1656 VDD VSS.t1285 VDD VDD sg13_lv_pmos ad=0.34p pd=2.68u as=0 ps=0 w=1u l=1u
X1657 VSS.t147 VDD VSS.t148 VSS.t3 sg13_lv_nmos ad=79.8f pd=0.8u as=0 ps=0 w=0.42u l=1u
X1658 VDD VSS.t1255 VDD VDD sg13_lv_pmos ad=0.19p pd=1.38u as=0 ps=0 w=1u l=1u
X1659 VSS.t1536 VDD VSS.t1535 VSS.t1534 sg13_lv_nmos ad=0.1428p pd=1.52u as=0 ps=0 w=0.42u l=1u
X1660 a_7054_14751# a_7169_14750# VSS.t10 VSS.t11 sg13_lv_nmos ad=0.1428p pd=1.52u as=0.1426p ps=1.16u w=0.42u l=0.5u
X1661 VSS.t1365 VDD VSS.t1364 VSS.t305 sg13_lv_nmos ad=0.1428p pd=1.52u as=0 ps=0 w=0.42u l=1u
X1662 VSS.t2730 VDD VSS.t2729 VSS.t2710 sg13_lv_nmos ad=0.1428p pd=1.52u as=0 ps=0 w=0.42u l=1u
X1663 VSS.t394 VDD VSS.t393 VSS.t392 sg13_lv_nmos ad=0.1428p pd=1.52u as=0 ps=0 w=0.42u l=1u
X1664 VSS.t2786 VDD VSS.t2919 VSS.t2710 sg13_lv_nmos ad=79.8f pd=0.8u as=0 ps=0 w=0.42u l=1u
X1665 VSS.t2540 VDD VSS.t2539 VSS.t2538 sg13_lv_nmos ad=0.1428p pd=1.52u as=0 ps=0 w=0.42u l=1u
X1666 VSS.t2445 VDD VSS.t2447 VSS.t2446 sg13_lv_nmos ad=79.8f pd=0.8u as=0 ps=0 w=0.42u l=1u
X1667 VDD VSS.t3147 VDD VDD sg13_lv_pmos ad=0.19p pd=1.38u as=0 ps=0 w=1u l=1u
X1668 VDD VSS.t2352 VDD VDD sg13_lv_pmos ad=0.19p pd=1.38u as=0 ps=0 w=1u l=1u
X1669 VSS.t126 a_19630_15238# sg13g2_dfrbpq_1_7.CLK VSS.t3 sg13_lv_nmos ad=0.1406p pd=1.12u as=0.1406p ps=1.12u w=0.74u l=0.13u
X1670 a_7210_15457# a_7653_15213# a_7593_15625# VDD sg13_lv_pmos ad=79.8f pd=0.8u as=63f ps=0.72u w=0.42u l=0.13u
X1671 VSS.t2934 VDD VSS.t2802 VSS.t2710 sg13_lv_nmos ad=0.1428p pd=1.52u as=0 ps=0 w=0.42u l=1u
X1672 VDD VSS.t2542 VDD VDD sg13_lv_pmos ad=0.19p pd=1.38u as=0 ps=0 w=1u l=1u
X1673 VSS.t1079 VDD VSS.t1081 VSS.t1080 sg13_lv_nmos ad=79.8f pd=0.8u as=0 ps=0 w=0.42u l=1u
X1674 VDD VSS.t1264 VDD VDD sg13_lv_pmos ad=0.19p pd=1.38u as=0 ps=0 w=1u l=1u
X1675 a_19044_14909# a_18756_14488# a_18982_14909# VSS.t124 sg13_lv_nmos ad=0.1428p pd=1.52u as=37.8f ps=0.6u w=0.42u l=0.13u
X1676 VSS.t1731 VDD VSS.t1733 VSS.t1732 sg13_lv_nmos ad=79.8f pd=0.8u as=0 ps=0 w=0.42u l=1u
X1677 VSS.t3260 VDD VSS.t3262 VSS.t3261 sg13_lv_nmos ad=79.8f pd=0.8u as=0 ps=0 w=0.42u l=1u
X1678 VDD VSS.t1655 VDD VDD sg13_lv_pmos ad=0.34p pd=2.68u as=0 ps=0 w=1u l=1u
X1679 VSS.t2123 VDD VSS.t2122 VSS.t2121 sg13_lv_nmos ad=0.1428p pd=1.52u as=0 ps=0 w=0.42u l=1u
X1680 VDD VSS.t883 VDD VDD sg13_lv_pmos ad=0.34p pd=2.68u as=0 ps=0 w=1u l=1u
X1681 VDD VSS.t2569 VDD VDD sg13_lv_pmos ad=0.34p pd=2.68u as=0 ps=0 w=1u l=1u
X1682 VDD VSS.t545 VDD VDD sg13_lv_pmos ad=0.19p pd=1.38u as=0 ps=0 w=1u l=1u
X1683 VSS.t1726 VDD VSS.t1728 VSS.t1727 sg13_lv_nmos ad=79.8f pd=0.8u as=0 ps=0 w=0.42u l=1u
X1684 VSS.t1377 VDD VSS.t1376 VSS.t305 sg13_lv_nmos ad=0.1428p pd=1.52u as=0 ps=0 w=0.42u l=1u
X1685 VDD VSS.t2597 VDD VDD sg13_lv_pmos ad=0.19p pd=1.38u as=0 ps=0 w=1u l=1u
X1686 VDD VSS.t2037 VDD VDD sg13_lv_pmos ad=0.34p pd=2.68u as=0 ps=0 w=1u l=1u
X1687 VSS.t564 VDD VSS.t564 VSS.t615 sg13_lv_nmos ad=79.8f pd=0.8u as=0 ps=0 w=0.42u l=1u
X1688 VSS.t1049 VDD VSS.t1051 VSS.t1050 sg13_lv_nmos ad=79.8f pd=0.8u as=0 ps=0 w=0.42u l=1u
X1689 VDD VSS.t1252 VDD VDD sg13_lv_pmos ad=0.34p pd=2.68u as=0 ps=0 w=1u l=1u
X1690 VSS.t475 VDD VSS.t474 VSS.t473 sg13_lv_nmos ad=0.1428p pd=1.52u as=0 ps=0 w=0.42u l=1u
X1691 VDD VSS.t3167 VDD VDD sg13_lv_pmos ad=0.19p pd=1.38u as=0 ps=0 w=1u l=1u
X1692 VDD VSS.t2372 VDD VDD sg13_lv_pmos ad=0.19p pd=1.38u as=0 ps=0 w=1u l=1u
X1693 VSS.t2203 VDD VSS.t2205 VSS.t2204 sg13_lv_nmos ad=79.8f pd=0.8u as=0 ps=0 w=0.42u l=1u
X1694 VDD a_27215_15311# a_27472_15454# VDD sg13_lv_pmos ad=2.4406p pd=15.34u as=79.8f ps=0.8u w=0.42u l=0.13u
X1695 a_14085_14495# sg13g2_dfrbpq_1_2.CLK VSS.t7 VSS.t86 sg13_lv_nmos ad=0.2516p pd=2.16u as=4.79747p ps=30.975u w=0.74u l=0.13u
X1696 a_7653_16033# a_7653_16033# VSS.t74 VSS.t345 sg13_lv_nmos ad=0.111p pd=1.34u as=5.31717p ps=34.515u w=0.3u l=0.13u
X1697 VDD VSS.t569 VDD VDD sg13_lv_pmos ad=0.19p pd=1.38u as=0 ps=0 w=1u l=1u
X1698 VDD VSS.t936 VDD VDD sg13_lv_pmos ad=0.19p pd=1.38u as=0 ps=0 w=1u l=1u
X1699 VDD VSS.t453 VDD VDD sg13_lv_pmos ad=0.34p pd=2.68u as=0 ps=0 w=1u l=1u
X1700 VDD a_9269_13726# sg13g2_buf_4_0.X VDD sg13_lv_pmos ad=0.3808p pd=2.92u as=0.2128p ps=1.5u w=1.12u l=0.13u
X1701 VDD VSS.t1354 VDD VDD sg13_lv_pmos ad=0.19p pd=1.38u as=0 ps=0 w=1u l=1u
X1702 VSS.t2926 VDD VSS.t2794 VSS.t2710 sg13_lv_nmos ad=0.1428p pd=1.52u as=0 ps=0 w=0.42u l=1u
X1703 VDD VSS.t2045 VDD VDD sg13_lv_pmos ad=0.19p pd=1.38u as=0 ps=0 w=1u l=1u
X1704 VSS.t208 a_27500_15960# counter_value_o[5] VSS.t207 sg13_lv_nmos ad=0.14875p pd=1.16u as=0.2886p ps=2.26u w=0.74u l=0.13u
X1705 VDD VSS.t1101 VDD VDD sg13_lv_pmos ad=0.19p pd=1.38u as=0 ps=0 w=1u l=1u
X1706 VDD VSS.t1668 VDD VDD sg13_lv_pmos ad=0.19p pd=1.38u as=0 ps=0 w=1u l=1u
X1707 VDD VSS.t683 VDD VDD sg13_lv_pmos ad=0.19p pd=1.38u as=0 ps=0 w=1u l=1u
X1708 VDD VSS.t3194 VDD VDD sg13_lv_pmos ad=0.34p pd=2.68u as=0 ps=0 w=1u l=1u
X1709 VSS.t2153 VDD VSS.t2155 VSS.t2154 sg13_lv_nmos ad=79.8f pd=0.8u as=0 ps=0 w=0.42u l=1u
X1710 VSS.t3245 VDD VSS.t3247 VSS.t3246 sg13_lv_nmos ad=79.8f pd=0.8u as=0 ps=0 w=0.42u l=1u
X1711 a_7290_14020# sg13g2_xnor2_1_0.B sg13g2_xnor2_1_0.Y VDD sg13_lv_pmos ad=0.1428p pd=1.375u as=0.2408p ps=1.55u w=1.12u l=0.13u
X1712 VSS.t2761 VDD VSS.t2761 VSS.t2710 sg13_lv_nmos ad=0.1428p pd=1.52u as=0 ps=0 w=0.42u l=1u
X1713 sg13g2_a21oi_1_0.Y sg13g2_inv_1_0.Y VSS.t108 VSS.t21 sg13_lv_nmos ad=0.1406p pd=1.12u as=0.2516p ps=2.16u w=0.74u l=0.13u
X1714 a_7116_13912# sg13g2_xnor2_1_0.B VDD VDD sg13_lv_pmos ad=0.1596p pd=1.22u as=0.2891p ps=1.695u w=0.84u l=0.13u
X1715 VSS.t969 VDD VSS.t971 VSS.t970 sg13_lv_nmos ad=79.8f pd=0.8u as=0 ps=0 w=0.42u l=1u
X1716 VDD VSS.t1038 VDD VDD sg13_lv_pmos ad=0.34p pd=2.68u as=0 ps=0 w=1u l=1u
X1717 VDD VSS.t2412 VDD VDD sg13_lv_pmos ad=0.19p pd=1.38u as=0 ps=0 w=1u l=1u
X1718 VDD VSS.t2070 VDD VDD sg13_lv_pmos ad=0.19p pd=1.38u as=0 ps=0 w=1u l=1u
X1719 VSS.t2073 VDD VSS.t2072 VSS.t2071 sg13_lv_nmos ad=0.1428p pd=1.52u as=0 ps=0 w=0.42u l=1u
X1720 VSS.t1391 VDD VSS.t1390 VSS.t305 sg13_lv_nmos ad=0.1428p pd=1.52u as=0 ps=0 w=0.42u l=1u
X1721 VSS.t700 VDD VSS.t700 VSS.t820 sg13_lv_nmos ad=79.8f pd=0.8u as=0 ps=0 w=0.42u l=1u
X1722 VDD VSS.t2195 VDD VDD sg13_lv_pmos ad=0.19p pd=1.38u as=0 ps=0 w=1u l=1u
X1723 a_25374_15934# a_25175_16071# VSS.t74 VSS.t205 sg13_lv_nmos ad=0.27427p pd=2.28u as=5.31717p ps=34.515u w=0.795u l=0.13u
X1724 VSS.t2430 VDD VSS.t2432 VSS.t2431 sg13_lv_nmos ad=79.8f pd=0.8u as=0 ps=0 w=0.42u l=1u
X1725 a_15129_14607# a_14187_14495# a_14927_14845# VDD sg13_lv_pmos ad=93.45f pd=0.865u as=0.2048p ps=1.63u w=0.42u l=0.13u
X1726 VSS.t1983 VDD VSS.t1985 VSS.t1984 sg13_lv_nmos ad=79.8f pd=0.8u as=0 ps=0 w=0.42u l=1u
X1727 VDD VSS.t545 VDD VDD sg13_lv_pmos ad=0.34p pd=2.68u as=0 ps=0 w=1u l=1u
X1728 VSS.t2830 VDD VSS.t2831 VSS.t2710 sg13_lv_nmos ad=79.8f pd=0.8u as=0 ps=0 w=0.42u l=1u
X1729 VSS.t719 VDD VSS.t719 VSS.t721 sg13_lv_nmos ad=0.1428p pd=1.52u as=0 ps=0 w=0.42u l=1u
X1730 VDD VSS.t208 VDD VDD sg13_lv_pmos ad=0.19p pd=1.38u as=0 ps=0 w=1u l=1u
X1731 VSS.t1079 VDD VSS.t1081 VSS.t1080 sg13_lv_nmos ad=79.8f pd=0.8u as=0 ps=0 w=0.42u l=1u
X1732 VDD VSS.t1336 VDD VDD sg13_lv_pmos ad=0.34p pd=2.68u as=0 ps=0 w=1u l=1u
X1733 VDD sg13g2_dfrbpq_1_5.RESET_B a_25642_14452# VDD sg13_lv_pmos ad=0.1563p pd=1.22u as=0.147p ps=1.54u w=0.42u l=0.13u
X1734 VDD VSS.t56 VDD VDD sg13_lv_pmos ad=0.19p pd=1.38u as=0 ps=0 w=1u l=1u
X1735 VDD VSS.t1053 VDD VDD sg13_lv_pmos ad=0.34p pd=2.68u as=0 ps=0 w=1u l=1u
X1736 VDD sg13g2_buf_4_0.A a_9269_13726# VDD sg13_lv_pmos ad=0.203p pd=1.5u as=0.1596p ps=1.22u w=0.84u l=0.13u
X1737 VDD VSS.t1708 VDD VDD sg13_lv_pmos ad=0.19p pd=1.38u as=0 ps=0 w=1u l=1u
X1738 VDD VSS.t3179 VDD VDD sg13_lv_pmos ad=0.34p pd=2.68u as=0 ps=0 w=1u l=1u
X1739 VDD VSS.t2384 VDD VDD sg13_lv_pmos ad=0.34p pd=2.68u as=0 ps=0 w=1u l=1u
X1740 VSS.t939 VDD VSS.t938 VSS.t937 sg13_lv_nmos ad=0.1428p pd=1.52u as=0 ps=0 w=0.42u l=1u
X1741 VSS.t1279 VDD VSS.t1281 VSS.t305 sg13_lv_nmos ad=79.8f pd=0.8u as=0 ps=0 w=0.42u l=1u
X1742 VDD VSS.t2720 VDD VDD sg13_lv_pmos ad=0.34p pd=2.68u as=0 ps=0 w=1u l=1u
X1743 VDD VSS.t1990 VDD VDD sg13_lv_pmos ad=0.19p pd=1.38u as=0 ps=0 w=1u l=1u
X1744 VDD VSS.t2813 VDD VDD sg13_lv_pmos ad=0.19p pd=1.38u as=0 ps=0 w=1u l=1u
X1745 VSS.t2108 VDD VSS.t2107 VSS.t2106 sg13_lv_nmos ad=0.1428p pd=1.52u as=0 ps=0 w=0.42u l=1u
X1746 VDD VSS.t1372 VDD VDD sg13_lv_pmos ad=0.19p pd=1.38u as=0 ps=0 w=1u l=1u
X1747 VSS.t1671 VDD VSS.t1670 VSS.t1669 sg13_lv_nmos ad=0.1428p pd=1.52u as=0 ps=0 w=0.42u l=1u
X1748 VSS.t3200 VDD VSS.t3199 VSS.t3198 sg13_lv_nmos ad=0.1428p pd=1.52u as=0 ps=0 w=0.42u l=1u
X1749 VSS.t690 VDD VSS.t690 VSS.t804 sg13_lv_nmos ad=0.1428p pd=1.52u as=0 ps=0 w=0.42u l=1u
X1750 VDD VSS.t2582 VDD VDD sg13_lv_pmos ad=0.19p pd=1.38u as=0 ps=0 w=1u l=1u
X1751 VDD VSS.t2022 VDD VDD sg13_lv_pmos ad=0.34p pd=2.68u as=0 ps=0 w=1u l=1u
X1752 VSS.t999 VDD VSS.t1001 VSS.t1000 sg13_lv_nmos ad=79.8f pd=0.8u as=0 ps=0 w=0.42u l=1u
X1753 VSS.t2415 VDD VSS.t2417 VSS.t2416 sg13_lv_nmos ad=79.8f pd=0.8u as=0 ps=0 w=0.42u l=1u
X1754 VDD VSS.t866 VDD VDD sg13_lv_pmos ad=0.19p pd=1.38u as=0 ps=0 w=1u l=1u
X1755 VSS.t1806 VDD VSS.t1808 VSS.t1807 sg13_lv_nmos ad=79.8f pd=0.8u as=0 ps=0 w=0.42u l=1u
X1756 VDD VSS.t3152 VDD VDD sg13_lv_pmos ad=0.19p pd=1.38u as=0 ps=0 w=1u l=1u
X1757 VDD VSS.t2357 VDD VDD sg13_lv_pmos ad=0.19p pd=1.38u as=0 ps=0 w=1u l=1u
X1758 a_4857_15549# a_3915_15356# a_4655_15311# VDD sg13_lv_pmos ad=93.45f pd=0.865u as=0.2048p ps=1.63u w=0.42u l=0.13u
X1759 VSS.t2188 VDD VSS.t2190 VSS.t2189 sg13_lv_nmos ad=79.8f pd=0.8u as=0 ps=0 w=0.42u l=1u
X1760 VDD VSS.t210 VDD VDD sg13_lv_pmos ad=0.19p pd=1.38u as=0 ps=0 w=1u l=1u
X1761 VDD sg13g2_a21oi_1_0.A1 a_16571_15532# VDD sg13_lv_pmos ad=0.2128p pd=1.5u as=0.2128p ps=1.5u w=1.12u l=0.13u
X1762 VSS.t714 VDD VSS.t714 VSS.t832 sg13_lv_nmos ad=79.8f pd=0.8u as=0 ps=0 w=0.42u l=1u
X1763 VSS.t899 VDD VSS.t901 VSS.t900 sg13_lv_nmos ad=79.8f pd=0.8u as=0 ps=0 w=0.42u l=1u
X1764 VSS.t2058 VDD VSS.t2060 VSS.t2059 sg13_lv_nmos ad=79.8f pd=0.8u as=0 ps=0 w=0.42u l=1u
X1765 VSS.t969 VDD VSS.t971 VSS.t970 sg13_lv_nmos ad=79.8f pd=0.8u as=0 ps=0 w=0.42u l=1u
X1766 a_26244_15247# a_26475_15356# a_25930_15457# VSS.t3298 sg13_lv_nmos ad=0.2373p pd=1.97u as=79.8f ps=0.8u w=0.42u l=0.13u
X1767 VDD VSS.t958 VDD VDD sg13_lv_pmos ad=0.34p pd=2.68u as=0 ps=0 w=1u l=1u
X1768 VSS.t1736 VDD VSS.t1738 VSS.t1737 sg13_lv_nmos ad=79.8f pd=0.8u as=0 ps=0 w=0.42u l=1u
X1769 VSS.t3230 VDD VSS.t3232 VSS.t3231 sg13_lv_nmos ad=79.8f pd=0.8u as=0 ps=0 w=0.42u l=1u
X1770 a_26182_15247# sg13g2_dfrbpq_1_4.RESET_B VSS.t81 VSS.t251 sg13_lv_nmos ad=37.8f pd=0.6u as=0.1701p ps=1.65u w=0.42u l=0.13u
X1771 VSS.t1014 VDD VSS.t1016 VSS.t1015 sg13_lv_nmos ad=79.8f pd=0.8u as=0 ps=0 w=0.42u l=1u
X1772 VDD VSS.t1660 VDD VDD sg13_lv_pmos ad=0.34p pd=2.68u as=0 ps=0 w=1u l=1u
X1773 VDD VSS.t1540 VDD VDD sg13_lv_pmos ad=0.34p pd=2.68u as=0 ps=0 w=1u l=1u
X1774 VSS.t2754 VDD VSS.t2753 VSS.t2710 sg13_lv_nmos ad=0.1428p pd=1.52u as=0 ps=0 w=0.42u l=1u
X1775 VDD VSS.t1083 VDD VDD sg13_lv_pmos ad=0.34p pd=2.68u as=0 ps=0 w=1u l=1u
X1776 VSS.t2340 VDD VSS.t2339 VSS.t2338 sg13_lv_nmos ad=0.1428p pd=1.52u as=0 ps=0 w=0.42u l=1u
X1777 a_18730_14452# a_19173_14495# a_18470_14922# VSS.t141 sg13_lv_nmos ad=79.8f pd=0.8u as=0.1296p ps=1.52u w=0.42u l=0.13u
X1778 VDD VSS.t158 VDD VDD sg13_lv_pmos ad=0.34p pd=2.68u as=0 ps=0 w=1u l=1u
X1779 VDD sg13g2_inv_1_0.Y a_13612_15996# VDD sg13_lv_pmos ad=0.4032p pd=2.96u as=0.1176p ps=1.33u w=1.12u l=0.13u
X1780 VDD VSS.t2574 VDD VDD sg13_lv_pmos ad=0.34p pd=2.68u as=0 ps=0 w=1u l=1u
X1781 VSS.t695 VDD VSS.t695 VSS.t698 sg13_lv_nmos ad=79.8f pd=0.8u as=0 ps=0 w=0.42u l=1u
X1782 a_22508_15960# sg13g2_dlygate4sd3_1_11.A VDD VDD sg13_lv_pmos ad=0.2856p pd=2.36u as=0.2114p ps=1.54u w=0.84u l=0.13u
X1783 VSS.t719 VDD VSS.t724 VSS.t838 sg13_lv_nmos ad=79.8f pd=0.8u as=0 ps=0 w=0.42u l=1u
X1784 VDD VSS.t1308 VDD VDD sg13_lv_pmos ad=0.19p pd=1.38u as=0 ps=0 w=1u l=1u
X1785 VSS.t1272 VDD VSS.t1271 VSS.t305 sg13_lv_nmos ad=0.1428p pd=1.52u as=0 ps=0 w=0.42u l=1u
X1786 VDD VSS.t690 VDD VDD sg13_lv_pmos ad=0.34p pd=2.68u as=0 ps=0 w=1u l=1u
X1787 VDD VSS.t1021 VDD VDD sg13_lv_pmos ad=0.19p pd=1.38u as=0 ps=0 w=1u l=1u
X1788 VSS.t1311 VDD VSS.t1313 VSS.t305 sg13_lv_nmos ad=79.8f pd=0.8u as=0 ps=0 w=0.42u l=1u
X1789 VDD VSS.t1357 VDD VDD sg13_lv_pmos ad=0.19p pd=1.38u as=0 ps=0 w=1u l=1u
X1790 VDD VSS.t2862 VDD VDD sg13_lv_pmos ad=0.19p pd=1.38u as=0 ps=0 w=1u l=1u
X1791 VSS.t2595 VDD VSS.t2594 VSS.t2593 sg13_lv_nmos ad=0.1428p pd=1.52u as=0 ps=0 w=0.42u l=1u
X1792 VSS.t1791 VDD VSS.t1793 VSS.t1792 sg13_lv_nmos ad=79.8f pd=0.8u as=0 ps=0 w=0.42u l=1u
X1793 VSS.t71 VDD VSS.t71 VSS.t589 sg13_lv_nmos ad=79.8f pd=0.8u as=0 ps=0 w=0.42u l=1u
X1794 VDD VSS.t705 VDD VDD sg13_lv_pmos ad=0.19p pd=1.38u as=0 ps=0 w=1u l=1u
X1795 VSS.t1968 VDD VSS.t1970 VSS.t1969 sg13_lv_nmos ad=79.8f pd=0.8u as=0 ps=0 w=0.42u l=1u
X1796 VSS.t74 a_7529_16334# a_7450_16237# VSS.t3272 sg13_lv_nmos ad=5.31717p pd=34.515u as=0.27427p ps=2.28u w=0.795u l=0.13u
X1797 VDD VSS.t235 VDD VDD sg13_lv_pmos ad=0.34p pd=2.68u as=0 ps=0 w=1u l=1u
X1798 VSS.t1431 VDD VSS.t1276 VSS.t305 sg13_lv_nmos ad=0.1428p pd=1.52u as=0 ps=0 w=0.42u l=1u
X1799 VSS.t487 VDD VSS.t487 VSS.t489 sg13_lv_nmos ad=0.1428p pd=1.52u as=0 ps=0 w=0.42u l=1u
X1800 VSS.t1054 VDD VSS.t1056 VSS.t1055 sg13_lv_nmos ad=79.8f pd=0.8u as=0 ps=0 w=0.42u l=1u
X1801 VSS.t2798 VDD VSS.t2797 VSS.t2710 sg13_lv_nmos ad=0.1428p pd=1.52u as=0 ps=0 w=0.42u l=1u
X1802 VDD VSS.t2050 VDD VDD sg13_lv_pmos ad=0.19p pd=1.38u as=0 ps=0 w=1u l=1u
X1803 VDD VSS.t71 VDD VDD sg13_lv_pmos ad=0.19p pd=1.38u as=0 ps=0 w=1u l=1u
X1804 VSS.t545 VDD VSS.t545 VSS.t549 sg13_lv_nmos ad=79.8f pd=0.8u as=0 ps=0 w=0.42u l=1u
X1805 a_19173_14495# sg13g2_dfrbpq_1_7.CLK VDD VDD sg13_lv_pmos ad=0.4088p pd=2.97u as=2.6415p ps=17.17u w=1.12u l=0.13u
X1806 VSS.t939 VDD VSS.t938 VSS.t937 sg13_lv_nmos ad=0.1428p pd=1.52u as=0 ps=0 w=0.42u l=1u
X1807 VDD VSS.t1693 VDD VDD sg13_lv_pmos ad=0.19p pd=1.38u as=0 ps=0 w=1u l=1u
X1808 VDD VSS.t3164 VDD VDD sg13_lv_pmos ad=0.34p pd=2.68u as=0 ps=0 w=1u l=1u
X1809 VDD VSS.t2369 VDD VDD sg13_lv_pmos ad=0.34p pd=2.68u as=0 ps=0 w=1u l=1u
X1810 VSS.t2158 VDD VSS.t2160 VSS.t2159 sg13_lv_nmos ad=79.8f pd=0.8u as=0 ps=0 w=0.42u l=1u
X1811 VDD sg13g2_buf_1_9.X.t4 a_24333_15280# VDD sg13_lv_pmos ad=0.1918p pd=1.5u as=0.1596p ps=1.22u w=0.84u l=0.13u
X1812 VSS.t25 sg13g2_nor4_2_0.Y a_24443_14540# VSS.t7 sg13_lv_nmos ad=0.18945p pd=1.27u as=0.187p ps=1.78u w=0.55u l=0.13u
X1813 VSS.t2764 VDD VSS.t2763 VSS.t2710 sg13_lv_nmos ad=0.1428p pd=1.52u as=0 ps=0 w=0.42u l=1u
X1814 VDD VSS.t2711 VDD VDD sg13_lv_pmos ad=0.34p pd=2.68u as=0 ps=0 w=1u l=1u
X1815 VDD VSS.t1733 VDD VDD sg13_lv_pmos ad=0.19p pd=1.38u as=0 ps=0 w=1u l=1u
X1816 VSS.t662 VDD VSS.t661 VSS.t751 sg13_lv_nmos ad=0.1428p pd=1.52u as=0 ps=0 w=0.42u l=1u
X1817 VDD VSS.t2075 VDD VDD sg13_lv_pmos ad=0.19p pd=1.38u as=0 ps=0 w=1u l=1u
X1818 VSS.t89 sg13g2_buf_16_1.X a_12308_15202# VSS.t222 sg13_lv_nmos ad=0.2516p pd=2.16u as=0.1406p ps=1.12u w=0.74u l=0.13u
X1819 VSS.t999 VDD VSS.t1001 VSS.t1000 sg13_lv_nmos ad=79.8f pd=0.8u as=0 ps=0 w=0.42u l=1u
X1820 VDD VSS.t988 VDD VDD sg13_lv_pmos ad=0.34p pd=2.68u as=0 ps=0 w=1u l=1u
X1821 VDD VSS.t1289 VDD VDD sg13_lv_pmos ad=0.34p pd=2.68u as=0 ps=0 w=1u l=1u
X1822 VSS.t1363 VDD VSS.t1362 VSS.t305 sg13_lv_nmos ad=0.1428p pd=1.52u as=0 ps=0 w=0.42u l=1u
X1823 sg13g2_buf_16_1.X a_16078_14484# VDD VDD sg13_lv_pmos ad=0.2128p pd=1.5u as=0.2128p ps=1.5u w=1.12u l=0.13u
X1824 VSS.t627 VDD VSS.t626 VSS.t625 sg13_lv_nmos ad=0.1428p pd=1.52u as=0 ps=0 w=0.42u l=1u
X1825 VSS.t1325 VDD VSS.t1326 VSS.t305 sg13_lv_nmos ad=79.8f pd=0.8u as=0 ps=0 w=0.42u l=1u
X1826 VDD VSS.t2853 VDD VDD sg13_lv_pmos ad=0.19p pd=1.38u as=0 ps=0 w=1u l=1u
X1827 VSS.t2580 VDD VSS.t2579 VSS.t2578 sg13_lv_nmos ad=0.1428p pd=1.52u as=0 ps=0 w=0.42u l=1u
X1828 VSS.t74 a_25175_16301# a_25175_16301# VSS.t75 sg13_lv_nmos ad=5.31717p pd=34.515u as=0.111p ps=1.34u w=0.3u l=0.13u
X1829 VDD VSS.t487 VDD VDD sg13_lv_pmos ad=0.34p pd=2.68u as=0 ps=0 w=1u l=1u
X1830 VSS.t1953 VDD VSS.t1955 VSS.t1954 sg13_lv_nmos ad=79.8f pd=0.8u as=0 ps=0 w=0.42u l=1u
X1831 VSS.t1746 VDD VSS.t1745 VSS.t1744 sg13_lv_nmos ad=0.1428p pd=1.52u as=0 ps=0 w=0.42u l=1u
X1832 sg13g2_xor2_1_1.B sg13g2_buf_1_0.X VDD VDD sg13_lv_pmos ad=0.2128p pd=1.5u as=0.2128p ps=1.5u w=1.12u l=0.13u
X1833 VSS.t899 VDD VSS.t901 VSS.t900 sg13_lv_nmos ad=79.8f pd=0.8u as=0 ps=0 w=0.42u l=1u
X1834 VDD VSS.t2437 VDD VDD sg13_lv_pmos ad=0.19p pd=1.38u as=0 ps=0 w=1u l=1u
X1835 VSS.t24 sg13g2_dfrbpq_1_6.RESET_B a_18564_14922# VSS.t239 sg13_lv_nmos ad=0.1626p pd=1.415u as=60.89999f ps=0.71u w=0.42u l=0.13u
X1836 VSS.t1014 VDD VSS.t1016 VSS.t1015 sg13_lv_nmos ad=79.8f pd=0.8u as=0 ps=0 w=0.42u l=1u
X1837 VDD VSS.t1364 VDD VDD sg13_lv_pmos ad=0.34p pd=2.68u as=0 ps=0 w=1u l=1u
X1838 VDD VSS.t1713 VDD VDD sg13_lv_pmos ad=0.19p pd=1.38u as=0 ps=0 w=1u l=1u
X1839 VSS.t2043 VDD VSS.t2045 VSS.t2044 sg13_lv_nmos ad=79.8f pd=0.8u as=0 ps=0 w=0.42u l=1u
X1840 a_7524_15247# a_7755_15356# a_7210_15457# VSS.t44 sg13_lv_nmos ad=0.2373p pd=1.97u as=79.8f ps=0.8u w=0.42u l=0.13u
X1841 a_7462_15247# sg13g2_dfrbpq_1_1.RESET_B VSS.t10 VSS.t44 sg13_lv_nmos ad=37.8f pd=0.6u as=0.1701p ps=1.65u w=0.42u l=0.13u
X1842 a_12308_15202# sg13g2_buf_16_1.X VDD VDD sg13_lv_pmos ad=0.2128p pd=1.5u as=0.2128p ps=1.5u w=1.12u l=0.13u
X1843 VSS.t545 VDD VSS.t545 VSS.t601 sg13_lv_nmos ad=79.8f pd=0.8u as=0 ps=0 w=0.42u l=1u
X1844 a_3813_14521# a_3813_14521# VSS.t7 VSS.t176 sg13_lv_nmos ad=0.111p pd=1.34u as=5.1665p ps=33.355u w=0.3u l=0.13u
X1845 VDD VSS.t2816 VDD VDD sg13_lv_pmos ad=0.19p pd=1.38u as=0 ps=0 w=1u l=1u
X1846 VSS.t2113 VDD VSS.t2112 VSS.t2111 sg13_lv_nmos ad=0.1428p pd=1.52u as=0 ps=0 w=0.42u l=1u
X1847 VDD VSS.t1267 VDD VDD sg13_lv_pmos ad=0.19p pd=1.38u as=0 ps=0 w=1u l=1u
X1848 VSS.t2325 VDD VSS.t2324 VSS.t2323 sg13_lv_nmos ad=0.1428p pd=1.52u as=0 ps=0 w=0.42u l=1u
X1849 VDD VSS.t545 VDD VDD sg13_lv_pmos ad=0.19p pd=1.38u as=0 ps=0 w=1u l=1u
X1850 VSS.t719 VDD VSS.t719 VSS.t720 sg13_lv_nmos ad=79.8f pd=0.8u as=0 ps=0 w=0.42u l=1u
X1851 VSS.t2722 VDD VSS.t2724 VSS.t2710 sg13_lv_nmos ad=79.8f pd=0.8u as=0 ps=0 w=0.42u l=1u
X1852 a_16089_13723# sg13g2_nand2_2_0.A sg13g2_nand2_2_0.Y VSS.t360 sg13_lv_nmos ad=0.2448p pd=2.12u as=0.1368p ps=1.1u w=0.72u l=0.13u
X1853 VDD VSS.t1740 VDD VDD sg13_lv_pmos ad=0.34p pd=2.68u as=0 ps=0 w=1u l=1u
X1854 VSS.t89 sg13g2_buf_16_1.X a_12308_15202# VSS.t217 sg13_lv_nmos ad=0.1406p pd=1.12u as=0.1406p ps=1.12u w=0.74u l=0.13u
X1855 VDD VSS.t1066 VDD VDD sg13_lv_pmos ad=0.19p pd=1.38u as=0 ps=0 w=1u l=1u
X1856 VDD VSS.t2587 VDD VDD sg13_lv_pmos ad=0.19p pd=1.38u as=0 ps=0 w=1u l=1u
X1857 a_23785_15280# sg13g2_buf_1_9.X.t5 VSS.t58 VSS.t3 sg13_lv_nmos ad=0.1216p pd=1.02u as=0.1331p ps=1.12u w=0.64u l=0.13u
X1858 VSS.t1776 VDD VSS.t1778 VSS.t1777 sg13_lv_nmos ad=79.8f pd=0.8u as=0 ps=0 w=0.42u l=1u
X1859 VSS.t2193 VDD VSS.t2195 VSS.t2194 sg13_lv_nmos ad=79.8f pd=0.8u as=0 ps=0 w=0.42u l=1u
X1860 VSS.t934 VDD VSS.t936 VSS.t935 sg13_lv_nmos ad=79.8f pd=0.8u as=0 ps=0 w=0.42u l=1u
X1861 VDD VSS.t2087 VDD VDD sg13_lv_pmos ad=0.34p pd=2.68u as=0 ps=0 w=1u l=1u
X1862 VSS.t1054 VDD VSS.t1056 VSS.t1055 sg13_lv_nmos ad=79.8f pd=0.8u as=0 ps=0 w=0.42u l=1u
X1863 VSS.t1099 VDD VSS.t1101 VSS.t1100 sg13_lv_nmos ad=79.8f pd=0.8u as=0 ps=0 w=0.42u l=1u
X1864 VDD VSS.t3217 VDD VDD sg13_lv_pmos ad=0.19p pd=1.38u as=0 ps=0 w=1u l=1u
X1865 VSS.t2790 VDD VSS.t2789 VSS.t2710 sg13_lv_nmos ad=0.1428p pd=1.52u as=0 ps=0 w=0.42u l=1u
X1866 VDD VSS.t2035 VDD VDD sg13_lv_pmos ad=0.19p pd=1.38u as=0 ps=0 w=1u l=1u
X1867 VSS.t408 VDD VSS.t407 VSS.t406 sg13_lv_nmos ad=0.1428p pd=1.52u as=0 ps=0 w=0.42u l=1u
X1868 VDD VSS.t2782 VDD VDD sg13_lv_pmos ad=0.19p pd=1.38u as=0 ps=0 w=1u l=1u
X1869 VSS.t2450 VDD VSS.t2449 VSS.t2448 sg13_lv_nmos ad=0.1428p pd=1.52u as=0 ps=0 w=0.42u l=1u
X1870 VSS.t39 VDD VSS.t690 VSS.t803 sg13_lv_nmos ad=79.8f pd=0.8u as=0 ps=0 w=0.42u l=1u
X1871 VSS.t2143 VDD VSS.t2145 VSS.t2144 sg13_lv_nmos ad=79.8f pd=0.8u as=0 ps=0 w=0.42u l=1u
X1872 sg13g2_dfrbpq_1_2.CLK a_12308_15202# VDD VDD sg13_lv_pmos ad=0.2128p pd=1.5u as=0.2128p ps=1.5u w=1.12u l=0.13u
X1873 sg13g2_xor2_1_1.X a_13626_13918# VSS.t285 VSS.t284 sg13_lv_nmos ad=0.1628p pd=1.18u as=0.3108p ps=2.32u w=0.74u l=0.13u
X1874 VSS.t1706 VDD VSS.t1708 VSS.t1707 sg13_lv_nmos ad=79.8f pd=0.8u as=0 ps=0 w=0.42u l=1u
X1875 VSS.t3235 VDD VSS.t3237 VSS.t3236 sg13_lv_nmos ad=79.8f pd=0.8u as=0 ps=0 w=0.42u l=1u
X1876 VDD VSS.t2382 VDD VDD sg13_lv_pmos ad=0.19p pd=1.38u as=0 ps=0 w=1u l=1u
X1877 VDD sg13g2_or3_1_0.A a_16877_14020# VDD sg13_lv_pmos ad=0.3822p pd=1.84u as=0.1575p ps=1.315u w=1u l=0.13u
X1878 VDD VSS.t1248 VDD VDD sg13_lv_pmos ad=0.34p pd=2.68u as=0 ps=0 w=1u l=1u
X1879 VSS.t2756 VDD VSS.t2756 VSS.t2710 sg13_lv_nmos ad=0.1428p pd=1.52u as=0 ps=0 w=0.42u l=1u
X1880 VSS.t2098 VDD VSS.t2097 VSS.t2096 sg13_lv_nmos ad=0.1428p pd=1.52u as=0 ps=0 w=0.42u l=1u
X1881 VDD a_23648_15437# sg13g2_mux2_1_0.A0 VDD sg13_lv_pmos ad=0.1918p pd=1.5u as=0.3808p ps=2.92u w=1.12u l=0.13u
X1882 VDD VSS.t1718 VDD VDD sg13_lv_pmos ad=0.19p pd=1.38u as=0 ps=0 w=1u l=1u
X1883 VSS.t705 VDD VSS.t705 VSS.t704 sg13_lv_nmos ad=0.1428p pd=1.52u as=0 ps=0 w=0.42u l=1u
X1884 VDD VSS.t903 VDD VDD sg13_lv_pmos ad=0.34p pd=2.68u as=0 ps=0 w=1u l=1u
X1885 VSS.t2515 VDD VSS.t2517 VSS.t2516 sg13_lv_nmos ad=79.8f pd=0.8u as=0 ps=0 w=0.42u l=1u
X1886 VSS.t1988 VDD VSS.t1990 VSS.t1989 sg13_lv_nmos ad=79.8f pd=0.8u as=0 ps=0 w=0.42u l=1u
X1887 VSS.t1389 VDD VSS.t1388 VSS.t305 sg13_lv_nmos ad=0.1428p pd=1.52u as=0 ps=0 w=0.42u l=1u
X1888 VDD VSS.t1670 VDD VDD sg13_lv_pmos ad=0.34p pd=2.68u as=0 ps=0 w=1u l=1u
X1889 VDD VSS.t2544 VDD VDD sg13_lv_pmos ad=0.34p pd=2.68u as=0 ps=0 w=1u l=1u
X1890 VDD VSS.t1725 VDD VDD sg13_lv_pmos ad=0.34p pd=2.68u as=0 ps=0 w=1u l=1u
X1891 VSS.t137 a_12308_15202# sg13g2_dfrbpq_1_2.CLK VSS.t182 sg13_lv_nmos ad=0.1406p pd=1.12u as=0.1406p ps=1.12u w=0.74u l=0.13u
X1892 sg13g2_nor2b_1_1.Y sg13g2_nor2b_1_1.A a_24556_14020# VDD sg13_lv_pmos ad=0.3808p pd=2.92u as=0.1176p ps=1.33u w=1.12u l=0.13u
X1893 VSS.t1394 VDD VSS.t1393 VSS.t305 sg13_lv_nmos ad=0.1428p pd=1.52u as=0 ps=0 w=0.42u l=1u
X1894 VDD VSS.t956 VDD VDD sg13_lv_pmos ad=0.19p pd=1.38u as=0 ps=0 w=1u l=1u
X1895 VSS.t1938 VDD VSS.t1940 VSS.t1939 sg13_lv_nmos ad=79.8f pd=0.8u as=0 ps=0 w=0.42u l=1u
X1896 VDD a_19630_15238# sg13g2_dfrbpq_1_7.CLK VDD sg13_lv_pmos ad=0.2128p pd=1.5u as=0.2128p ps=1.5u w=1.12u l=0.13u
X1897 VDD a_18766_15423# sg13g2_nand2_1_1.A VDD sg13_lv_pmos ad=0.2254p pd=1.53u as=0.4256p ps=3u w=1.12u l=0.13u
X1898 VDD VSS.t1395 VDD VDD sg13_lv_pmos ad=0.19p pd=1.38u as=0 ps=0 w=1u l=1u
X1899 VSS.t309 VDD VSS.t683 VSS.t789 sg13_lv_nmos ad=0.1428p pd=1.52u as=0 ps=0 w=0.42u l=1u
X1900 VSS.t2931 VDD VSS.t2800 VSS.t2710 sg13_lv_nmos ad=0.1428p pd=1.52u as=0 ps=0 w=0.42u l=1u
X1901 VDD VSS.t2055 VDD VDD sg13_lv_pmos ad=0.19p pd=1.38u as=0 ps=0 w=1u l=1u
X1902 VDD VSS.t210 VDD VDD sg13_lv_pmos ad=0.34p pd=2.68u as=0 ps=0 w=1u l=1u
X1903 VDD VSS.t2774 VDD VDD sg13_lv_pmos ad=0.19p pd=1.38u as=0 ps=0 w=1u l=1u
X1904 VDD VSS.t1698 VDD VDD sg13_lv_pmos ad=0.19p pd=1.38u as=0 ps=0 w=1u l=1u
X1905 VDD VSS.t3169 VDD VDD sg13_lv_pmos ad=0.34p pd=2.68u as=0 ps=0 w=1u l=1u
X1906 VDD VSS.t2374 VDD VDD sg13_lv_pmos ad=0.34p pd=2.68u as=0 ps=0 w=1u l=1u
X1907 a_13668_14488# a_14187_14495# a_14927_14845# VSS.t37 sg13_lv_nmos ad=0.3473p pd=2.71u as=0.12665p ps=1.145u w=0.74u l=0.13u
X1908 sg13g2_dfrbpq_1_2.CLK a_12308_15202# VDD VDD sg13_lv_pmos ad=0.2128p pd=1.5u as=0.3976p ps=2.95u w=1.12u l=0.13u
X1909 VSS.t1278 VDD VSS.t1279 VSS.t305 sg13_lv_nmos ad=79.8f pd=0.8u as=0 ps=0 w=0.42u l=1u
X1910 sg13g2_dfrbpq_1_7.CLK a_19630_15238# VSS.t126 VSS.t3 sg13_lv_nmos ad=0.1406p pd=1.12u as=0.1406p ps=1.12u w=0.74u l=0.13u
X1911 VDD VSS.t1058 VDD VDD sg13_lv_pmos ad=0.34p pd=2.68u as=0 ps=0 w=1u l=1u
X1912 VDD VSS.t1738 VDD VDD sg13_lv_pmos ad=0.19p pd=1.38u as=0 ps=0 w=1u l=1u
X1913 VSS.t1661 VDD VSS.t1660 VSS.t1659 sg13_lv_nmos ad=0.1428p pd=1.52u as=0 ps=0 w=0.42u l=1u
X1914 VSS.t3190 VDD VSS.t3189 VSS.t3188 sg13_lv_nmos ad=0.1428p pd=1.52u as=0 ps=0 w=0.42u l=1u
X1915 sg13g2_nor4_2_0.Y sg13g2_nand2_2_0.Y VSS.t148 VSS.t7 sg13_lv_nmos ad=0.1406p pd=1.12u as=0.3293p ps=1.63u w=0.74u l=0.13u
X1916 VDD VSS.t996 VDD VDD sg13_lv_pmos ad=0.19p pd=1.38u as=0 ps=0 w=1u l=1u
X1917 VDD VSS.t2387 VDD VDD sg13_lv_pmos ad=0.19p pd=1.38u as=0 ps=0 w=1u l=1u
X1918 VSS.t71 a_27215_15311# a_27882_15532# VSS.t107 sg13_lv_nmos ad=0.1406p pd=1.12u as=0.2516p ps=2.16u w=0.74u l=0.13u
X1919 VSS.t2714 VDD VSS.t2715 VSS.t2710 sg13_lv_nmos ad=79.8f pd=0.8u as=0 ps=0 w=0.42u l=1u
X1920 VDD VSS.t2860 VDD VDD sg13_lv_pmos ad=0.19p pd=1.38u as=0 ps=0 w=1u l=1u
X1921 VDD VSS.t344 VDD VDD sg13_lv_pmos ad=0.34p pd=2.68u as=0 ps=0 w=1u l=1u
X1922 VSS.t864 VDD VSS.t866 VSS.t865 sg13_lv_nmos ad=79.8f pd=0.8u as=0 ps=0 w=0.42u l=1u
X1923 VSS.t934 VDD VSS.t936 VSS.t935 sg13_lv_nmos ad=79.8f pd=0.8u as=0 ps=0 w=0.42u l=1u
X1924 VDD VSS.t923 VDD VDD sg13_lv_pmos ad=0.34p pd=2.68u as=0 ps=0 w=1u l=1u
X1925 VDD sg13g2_mux2_1_1.X a_25592_16037# VDD sg13_lv_pmos ad=0.1523p pd=1.38u as=0.1428p ps=1.52u w=0.42u l=0.13u
X1926 VDD VSS.t1347 VDD VDD sg13_lv_pmos ad=0.34p pd=2.68u as=0 ps=0 w=1u l=1u
X1927 VSS.t1958 VDD VSS.t1960 VSS.t1959 sg13_lv_nmos ad=79.8f pd=0.8u as=0 ps=0 w=0.42u l=1u
X1928 a_11470_15423# a_11585_15424# VSS.t137 VSS.t136 sg13_lv_nmos ad=0.1428p pd=1.52u as=0.1426p ps=1.16u w=0.42u l=0.5u
X1929 VSS.t1099 VDD VSS.t1101 VSS.t1100 sg13_lv_nmos ad=79.8f pd=0.8u as=0 ps=0 w=0.42u l=1u
X1930 VDD VSS.t2072 VDD VDD sg13_lv_pmos ad=0.34p pd=2.68u as=0 ps=0 w=1u l=1u
X1931 VDD a_19630_15238# sg13g2_dfrbpq_1_7.CLK VDD sg13_lv_pmos ad=0.2128p pd=1.5u as=0.2128p ps=1.5u w=1.12u l=0.13u
X1932 VSS.t2500 VDD VSS.t2502 VSS.t2501 sg13_lv_nmos ad=79.8f pd=0.8u as=0 ps=0 w=0.42u l=1u
X1933 VDD VSS.t2442 VDD VDD sg13_lv_pmos ad=0.19p pd=1.38u as=0 ps=0 w=1u l=1u
X1934 VSS.t71 VDD VSS.t71 VSS.t537 sg13_lv_nmos ad=79.8f pd=0.8u as=0 ps=0 w=0.42u l=1u
X1935 VSS.t32 VDD VSS.t32 VSS.t585 sg13_lv_nmos ad=79.8f pd=0.8u as=0 ps=0 w=0.42u l=1u
X1936 VSS.t959 VDD VSS.t958 VSS.t957 sg13_lv_nmos ad=0.1428p pd=1.52u as=0 ps=0 w=0.42u l=1u
X1937 VSS.t2048 VDD VSS.t2050 VSS.t2049 sg13_lv_nmos ad=79.8f pd=0.8u as=0 ps=0 w=0.42u l=1u
X1938 VDD VSS.t2197 VDD VDD sg13_lv_pmos ad=0.34p pd=2.68u as=0 ps=0 w=1u l=1u
X1939 VDD VSS.t540 VDD VDD sg13_lv_pmos ad=0.19p pd=1.38u as=0 ps=0 w=1u l=1u
X1940 VSS.t1292 VDD VSS.t1293 VSS.t305 sg13_lv_nmos ad=79.8f pd=0.8u as=0 ps=0 w=0.42u l=1u
X1941 sg13g2_mux2_1_1.X a_24766_14854# VSS.t131 VSS.t7 sg13_lv_nmos ad=0.4033p pd=2.57u as=0.148p ps=1.14u w=0.74u l=0.13u
X1942 VDD VSS.t1384 VDD VDD sg13_lv_pmos ad=0.19p pd=1.38u as=0 ps=0 w=1u l=1u
X1943 a_19630_15238# sg13g2_buf_16_1.X VSS.t103 VSS.t3 sg13_lv_nmos ad=0.1406p pd=1.12u as=0.1406p ps=1.12u w=0.74u l=0.13u
X1944 VSS.t690 VDD VSS.t39 VSS.t689 sg13_lv_nmos ad=0.1428p pd=1.52u as=0 ps=0 w=0.42u l=1u
X1945 VSS.t2083 VDD VSS.t2082 VSS.t2081 sg13_lv_nmos ad=0.1428p pd=1.52u as=0 ps=0 w=0.42u l=1u
X1946 VDD a_17434_15202# a_17153_15424# VDD sg13_lv_pmos ad=0.1523p pd=1.38u as=0.34p ps=2.68u w=1u l=0.5u
X1947 VSS.t695 VDD VSS.t695 VSS.t815 sg13_lv_nmos ad=0.1428p pd=1.52u as=0 ps=0 w=0.42u l=1u
X1948 VSS.t1256 VDD VSS.t1415 VSS.t305 sg13_lv_nmos ad=0.1428p pd=1.52u as=0 ps=0 w=0.42u l=1u
X1949 VDD VSS.t1655 VDD VDD sg13_lv_pmos ad=0.34p pd=2.68u as=0 ps=0 w=1u l=1u
X1950 VDD sg13g2_dlygate4sd3_1_11.A sg13g2_nand3_1_1.Y VDD sg13_lv_pmos ad=0.2128p pd=1.5u as=0.2128p ps=1.5u w=1.12u l=0.13u
X1951 VSS.t1019 VDD VSS.t1021 VSS.t1020 sg13_lv_nmos ad=79.8f pd=0.8u as=0 ps=0 w=0.42u l=1u
X1952 VDD VSS.t1710 VDD VDD sg13_lv_pmos ad=0.34p pd=2.68u as=0 ps=0 w=1u l=1u
X1953 VSS.t1998 VDD VSS.t2000 VSS.t1999 sg13_lv_nmos ad=79.8f pd=0.8u as=0 ps=0 w=0.42u l=1u
X1954 VDD VSS.t886 VDD VDD sg13_lv_pmos ad=0.19p pd=1.38u as=0 ps=0 w=1u l=1u
X1955 VDD VSS.t3032 VDD VDD sg13_lv_pmos ad=0.19p pd=1.38u as=0 ps=0 w=1u l=1u
X1956 VSS.t3090 VDD VSS.t3092 VSS.t3091 sg13_lv_nmos ad=79.8f pd=0.8u as=0 ps=0 w=0.42u l=1u
X1957 VSS.t2455 VDD VSS.t2454 VSS.t2453 sg13_lv_nmos ad=0.1428p pd=1.52u as=0 ps=0 w=0.42u l=1u
X1958 VSS.t258 sg13g2_tiehi_1.L_HI a_3204_15234# VSS.t212 sg13_lv_nmos ad=0.1626p pd=1.415u as=60.89999f ps=0.71u w=0.42u l=0.13u
X1959 VSS.t7 a_14085_14495# a_14187_14495# VSS.t269 sg13_lv_nmos ad=5.1665p pd=33.355u as=0.2516p ps=2.16u w=0.74u l=0.13u
X1960 VSS.t238 a_19984_13942# a_19633_13799# VSS.t317 sg13_lv_nmos ad=79.8f pd=0.8u as=0.1428p ps=1.52u w=0.42u l=0.13u
X1961 VDD VSS.t285 VDD VDD sg13_lv_pmos ad=0.34p pd=2.68u as=0 ps=0 w=1u l=1u
X1962 VSS.t1781 VDD VSS.t1783 VSS.t1782 sg13_lv_nmos ad=79.8f pd=0.8u as=0 ps=0 w=0.42u l=1u
X1963 VSS.t103 sg13g2_buf_16_1.X a_19630_15238# VSS.t223 sg13_lv_nmos ad=0.1406p pd=1.12u as=0.1406p ps=1.12u w=0.74u l=0.13u
X1964 VSS.t724 VDD VSS.t724 VSS.t840 sg13_lv_nmos ad=79.8f pd=0.8u as=0 ps=0 w=0.42u l=1u
X1965 VSS.t2862 VDD VSS.t2863 VSS.t2710 sg13_lv_nmos ad=79.8f pd=0.8u as=0 ps=0 w=0.42u l=1u
X1966 VDD VSS.t2434 VDD VDD sg13_lv_pmos ad=0.34p pd=2.68u as=0 ps=0 w=1u l=1u
X1967 VDD VSS.t2092 VDD VDD sg13_lv_pmos ad=0.34p pd=2.68u as=0 ps=0 w=1u l=1u
X1968 a_18756_14488# a_18730_14452# VDD VDD sg13_lv_pmos ad=0.34p pd=2.68u as=0.36237p ps=2.605u w=1u l=0.13u
X1969 VSS.t627 VDD VSS.t626 VSS.t625 sg13_lv_nmos ad=0.1428p pd=1.52u as=0 ps=0 w=0.42u l=1u
X1970 VDD VSS.t1386 VDD VDD sg13_lv_pmos ad=0.19p pd=1.38u as=0 ps=0 w=1u l=1u
X1971 VDD a_8590_14751# sg13g2_xnor2_1_0.A VDD sg13_lv_pmos ad=0.2254p pd=1.53u as=0.4256p ps=3u w=1.12u l=0.13u
X1972 VSS.t1342 VDD VSS.t1341 VSS.t305 sg13_lv_nmos ad=0.1428p pd=1.52u as=0 ps=0 w=0.42u l=1u
X1973 VSS.t2923 VDD VSS.t2792 VSS.t2710 sg13_lv_nmos ad=0.1428p pd=1.52u as=0 ps=0 w=0.42u l=1u
X1974 VDD VSS.t2040 VDD VDD sg13_lv_pmos ad=0.19p pd=1.38u as=0 ps=0 w=1u l=1u
X1975 VSS.t437 VDD VSS.t439 VSS.t438 sg13_lv_nmos ad=79.8f pd=0.8u as=0 ps=0 w=0.42u l=1u
X1976 a_12537_14607# a_11595_14495# a_12335_14845# VDD sg13_lv_pmos ad=93.45f pd=0.865u as=0.2048p ps=1.63u w=0.42u l=0.13u
X1977 a_19984_13942# a_19727_13799# a_20146_13722# VSS.t307 sg13_lv_nmos ad=0.1428p pd=1.52u as=37.8f ps=0.6u w=0.42u l=0.13u
X1978 VDD VSS.t2766 VDD VDD sg13_lv_pmos ad=0.19p pd=1.38u as=0 ps=0 w=1u l=1u
X1979 VDD VSS.t1365 VDD VDD sg13_lv_pmos ad=0.34p pd=2.68u as=0 ps=0 w=1u l=1u
X1980 VSS.t2420 VDD VSS.t2419 VSS.t2418 sg13_lv_nmos ad=0.1428p pd=1.52u as=0 ps=0 w=0.42u l=1u
X1981 VDD a_7054_14751# sg13g2_and2_1_1.B VDD sg13_lv_pmos ad=0.2254p pd=1.53u as=0.4256p ps=3u w=1.12u l=0.13u
X1982 sg13g2_buf_16_1.X a_16078_14484# VSS.t22 VSS.t37 sg13_lv_nmos ad=0.1406p pd=1.12u as=0.1406p ps=1.12u w=0.74u l=0.13u
X1983 VDD VSS.t1103 VDD VDD sg13_lv_pmos ad=0.34p pd=2.68u as=0 ps=0 w=1u l=1u
X1984 VSS.t1711 VDD VSS.t1713 VSS.t1712 sg13_lv_nmos ad=79.8f pd=0.8u as=0 ps=0 w=0.42u l=1u
X1985 VSS.t3240 VDD VSS.t3242 VSS.t3241 sg13_lv_nmos ad=79.8f pd=0.8u as=0 ps=0 w=0.42u l=1u
X1986 sg13g2_dlygate4sd3_1_10.X a_18486_12996# VDD VDD sg13_lv_pmos ad=0.4256p pd=3u as=0.2254p ps=1.53u w=1.12u l=0.13u
X1987 VDD VSS.t540 VDD VDD sg13_lv_pmos ad=0.19p pd=1.38u as=0 ps=0 w=1u l=1u
X1988 VSS.t92 VDD VSS.t92 VSS.t496 sg13_lv_nmos ad=0.1428p pd=1.52u as=0 ps=0 w=0.42u l=1u
X1989 VDD sg13g2_or3_1_0.X a_17621_12972# VDD sg13_lv_pmos ad=0.2128p pd=1.5u as=0.3808p ps=2.92u w=1.12u l=0.13u
X1990 VSS.t2520 VDD VSS.t2522 VSS.t2521 sg13_lv_nmos ad=79.8f pd=0.8u as=0 ps=0 w=0.42u l=1u
X1991 VSS.t989 VDD VSS.t988 VSS.t987 sg13_lv_nmos ad=0.1428p pd=1.52u as=0 ps=0 w=0.42u l=1u
X1992 VDD VSS.t1320 VDD VDD sg13_lv_pmos ad=0.19p pd=1.38u as=0 ps=0 w=1u l=1u
X1993 VDD VSS.t2549 VDD VDD sg13_lv_pmos ad=0.34p pd=2.68u as=0 ps=0 w=1u l=1u
X1994 VDD VSS.t554 VDD VDD sg13_lv_pmos ad=0.19p pd=1.38u as=0 ps=0 w=1u l=1u
X1995 sg13g2_buf_4_0.X a_9269_13726# VDD VDD sg13_lv_pmos ad=0.2128p pd=1.5u as=0.203p ps=1.5u w=1.12u l=0.13u
X1996 VSS.t864 VDD VSS.t866 VSS.t865 sg13_lv_nmos ad=79.8f pd=0.8u as=0 ps=0 w=0.42u l=1u
X1997 VDD VSS.t1041 VDD VDD sg13_lv_pmos ad=0.19p pd=1.38u as=0 ps=0 w=1u l=1u
X1998 VSS.t2791 VDD VSS.t2790 VSS.t2710 sg13_lv_nmos ad=0.1428p pd=1.52u as=0 ps=0 w=0.42u l=1u
X1999 VDD VSS.t2851 VDD VDD sg13_lv_pmos ad=0.19p pd=1.38u as=0 ps=0 w=1u l=1u
X2000 VSS.t243 a_18374_12972# a_18486_12996# VSS.t333 sg13_lv_nmos ad=0.1426p pd=1.16u as=0.1428p ps=1.52u w=0.42u l=0.5u
X2001 VSS.t1741 VDD VSS.t1740 VSS.t1739 sg13_lv_nmos ad=0.1428p pd=1.52u as=0 ps=0 w=0.42u l=1u
X2002 VDD VSS.t3017 VDD VDD sg13_lv_pmos ad=0.19p pd=1.38u as=0 ps=0 w=1u l=1u
X2003 VSS.t418 VDD VSS.t420 VSS.t419 sg13_lv_nmos ad=79.8f pd=0.8u as=0 ps=0 w=0.42u l=1u
X2004 VSS.t331 VDD VSS.t331 VSS.t753 sg13_lv_nmos ad=0.1428p pd=1.52u as=0 ps=0 w=0.42u l=1u
X2005 VDD VSS.t664 VDD VDD sg13_lv_pmos ad=0.19p pd=1.38u as=0 ps=0 w=1u l=1u
X2006 VDD VSS.t714 VDD VDD sg13_lv_pmos ad=0.19p pd=1.38u as=0 ps=0 w=1u l=1u
X2007 VDD VSS.t2825 VDD VDD sg13_lv_pmos ad=0.34p pd=2.68u as=0 ps=0 w=1u l=1u
X2008 VSS.t79 a_27184_14726# a_26833_14845# VSS.t281 sg13_lv_nmos ad=79.8f pd=0.8u as=0.1428p ps=1.52u w=0.42u l=0.13u
X2009 VSS.t693 a_26062_13911# sg13g2_nor2b_1_0.A VSS.t3318 sg13_lv_nmos ad=0.1426p pd=1.16u as=0.2516p ps=2.16u w=0.74u l=0.13u
X2010 VSS.t705 VDD VSS.t705 VSS.t827 sg13_lv_nmos ad=0.1428p pd=1.52u as=0 ps=0 w=0.42u l=1u
X2011 VSS.t1943 VDD VSS.t1945 VSS.t1944 sg13_lv_nmos ad=79.8f pd=0.8u as=0 ps=0 w=0.42u l=1u
X2012 VSS.t632 VDD VSS.t631 VSS.t630 sg13_lv_nmos ad=0.1428p pd=1.52u as=0 ps=0 w=0.42u l=1u
X2013 VDD VSS.t1247 VDD VDD sg13_lv_pmos ad=0.19p pd=1.38u as=0 ps=0 w=1u l=1u
X2014 VSS.t3035 VDD VSS.t3037 VSS.t3036 sg13_lv_nmos ad=79.8f pd=0.8u as=0 ps=0 w=0.42u l=1u
X2015 VSS.t959 VDD VSS.t958 VSS.t957 sg13_lv_nmos ad=0.1428p pd=1.52u as=0 ps=0 w=0.42u l=1u
X2016 VSS.t1495 VDD VSS.t1354 VSS.t305 sg13_lv_nmos ad=0.1428p pd=1.52u as=0 ps=0 w=0.42u l=1u
X2017 VDD VSS.t1397 VDD VDD sg13_lv_pmos ad=0.19p pd=1.38u as=0 ps=0 w=1u l=1u
X2018 VSS.t1736 VDD VSS.t1735 VSS.t1734 sg13_lv_nmos ad=0.1428p pd=1.52u as=0 ps=0 w=0.42u l=1u
X2019 VSS.t2485 VDD VSS.t2487 VSS.t2486 sg13_lv_nmos ad=79.8f pd=0.8u as=0 ps=0 w=0.42u l=1u
X2020 VSS.t380 VDD VSS.t322 VSS.t379 sg13_lv_nmos ad=0.1428p pd=1.52u as=0 ps=0 w=0.42u l=1u
X2021 VSS.t272 VDD VSS.t276 VSS.t3 sg13_lv_nmos ad=0.1428p pd=1.52u as=0 ps=0 w=0.42u l=1u
X2022 VSS.t554 VDD VSS.t559 VSS.t558 sg13_lv_nmos ad=79.8f pd=0.8u as=0 ps=0 w=0.42u l=1u
X2023 VDD VSS.t916 VDD VDD sg13_lv_pmos ad=0.19p pd=1.38u as=0 ps=0 w=1u l=1u
X2024 VDD VSS.t2427 VDD VDD sg13_lv_pmos ad=0.19p pd=1.38u as=0 ps=0 w=1u l=1u
X2025 VDD VSS.t2777 VDD VDD sg13_lv_pmos ad=0.19p pd=1.38u as=0 ps=0 w=1u l=1u
X2026 VSS.t2440 VDD VSS.t2439 VSS.t2438 sg13_lv_nmos ad=0.1428p pd=1.52u as=0 ps=0 w=0.42u l=1u
X2027 VDD VSS.t2025 VDD VDD sg13_lv_pmos ad=0.19p pd=1.38u as=0 ps=0 w=1u l=1u
X2028 VDD VSS.t559 VDD VDD sg13_lv_pmos ad=0.19p pd=1.38u as=0 ps=0 w=1u l=1u
X2029 VSS.t56 a_15214_13911# sg13g2_xor2_1_1.A VSS.t288 sg13_lv_nmos ad=0.1426p pd=1.16u as=0.2516p ps=2.16u w=0.74u l=0.13u
X2030 VDD VSS.t3174 VDD VDD sg13_lv_pmos ad=0.34p pd=2.68u as=0 ps=0 w=1u l=1u
X2031 VDD VSS.t2379 VDD VDD sg13_lv_pmos ad=0.34p pd=2.68u as=0 ps=0 w=1u l=1u
X2032 a_27184_14726# a_26927_14845# a_27346_14922# VSS.t279 sg13_lv_nmos ad=0.1428p pd=1.52u as=37.8f ps=0.6u w=0.42u l=0.13u
X2033 a_13652_14020# a_13626_13918# sg13g2_xor2_1_1.X VDD sg13_lv_pmos ad=0.2128p pd=1.5u as=0.3808p ps=2.92u w=1.12u l=0.13u
X2034 sg13g2_buf_16_1.X a_16078_14484# VSS.t113 VSS.t37 sg13_lv_nmos ad=0.1406p pd=1.12u as=0.1406p ps=1.12u w=0.74u l=0.13u
X2035 VDD VSS.t1708 VDD VDD sg13_lv_pmos ad=0.19p pd=1.38u as=0 ps=0 w=1u l=1u
X2036 VSS.t760 VDD VSS.t14 VSS.t759 sg13_lv_nmos ad=0.1428p pd=1.52u as=0 ps=0 w=0.42u l=1u
X2037 VSS.t1019 VDD VSS.t1021 VSS.t1020 sg13_lv_nmos ad=79.8f pd=0.8u as=0 ps=0 w=0.42u l=1u
X2038 VDD VSS.t1300 VDD VDD sg13_lv_pmos ad=0.34p pd=2.68u as=0 ps=0 w=1u l=1u
X2039 VDD VSS.t1763 VDD VDD sg13_lv_pmos ad=0.19p pd=1.38u as=0 ps=0 w=1u l=1u
X2040 VSS.t513 VDD VSS.t513 VSS.t74 sg13_lv_nmos ad=0.1428p pd=1.52u as=0 ps=0 w=0.42u l=1u
X2041 VSS.t647 VDD VSS.t646 VSS.t645 sg13_lv_nmos ad=0.1428p pd=1.52u as=0 ps=0 w=0.42u l=1u
X2042 VSS.t1064 VDD VSS.t1066 VSS.t1065 sg13_lv_nmos ad=79.8f pd=0.8u as=0 ps=0 w=0.42u l=1u
X2043 VSS.t58 sg13g2_nor3_1_0.Y a_23483_14540# VSS.t7 sg13_lv_nmos ad=0.18945p pd=1.27u as=0.187p ps=1.78u w=0.55u l=0.13u
X2044 VDD VSS.t1278 VDD VDD sg13_lv_pmos ad=0.19p pd=1.38u as=0 ps=0 w=1u l=1u
X2045 VSS.t2163 VDD VSS.t2162 VSS.t2161 sg13_lv_nmos ad=0.1428p pd=1.52u as=0 ps=0 w=0.42u l=1u
X2046 VSS.t1726 VDD VSS.t1725 VSS.t1724 sg13_lv_nmos ad=0.1428p pd=1.52u as=0 ps=0 w=0.42u l=1u
X2047 VSS.t3255 VDD VSS.t3254 VSS.t3253 sg13_lv_nmos ad=0.1428p pd=1.52u as=0 ps=0 w=0.42u l=1u
X2048 VSS.t3075 VDD VSS.t3077 VSS.t3076 sg13_lv_nmos ad=79.8f pd=0.8u as=0 ps=0 w=0.42u l=1u
X2049 VDD VSS.t2842 VDD VDD sg13_lv_pmos ad=0.19p pd=1.38u as=0 ps=0 w=1u l=1u
X2050 VDD VSS.t376 VDD VDD sg13_lv_pmos ad=0.19p pd=1.38u as=0 ps=0 w=1u l=1u
X2051 VSS.t2784 VDD VSS.t2785 VSS.t2710 sg13_lv_nmos ad=79.8f pd=0.8u as=0 ps=0 w=0.42u l=1u
X2052 VSS.t540 VDD VSS.t540 VSS.t543 sg13_lv_nmos ad=0.1428p pd=1.52u as=0 ps=0 w=0.42u l=1u
X2053 VDD VSS.t868 VDD VDD sg13_lv_pmos ad=0.34p pd=2.68u as=0 ps=0 w=1u l=1u
X2054 VDD VSS.t1071 VDD VDD sg13_lv_pmos ad=0.19p pd=1.38u as=0 ps=0 w=1u l=1u
X2055 VSS.t2853 VDD VSS.t2854 VSS.t2710 sg13_lv_nmos ad=79.8f pd=0.8u as=0 ps=0 w=0.42u l=1u
X2056 VDD VSS.t2077 VDD VDD sg13_lv_pmos ad=0.34p pd=2.68u as=0 ps=0 w=1u l=1u
X2057 VSS.t2470 VDD VSS.t2472 VSS.t2471 sg13_lv_nmos ad=79.8f pd=0.8u as=0 ps=0 w=0.42u l=1u
X2058 VDD VSS.t3207 VDD VDD sg13_lv_pmos ad=0.19p pd=1.38u as=0 ps=0 w=1u l=1u
X2059 VDD VSS.t2447 VDD VDD sg13_lv_pmos ad=0.19p pd=1.38u as=0 ps=0 w=1u l=1u
X2060 VSS.t559 VDD VSS.t559 VSS.t609 sg13_lv_nmos ad=79.8f pd=0.8u as=0 ps=0 w=0.42u l=1u
X2061 VSS.t243 sg13g2_inv_1_0.Y sg13g2_a21oi_1_1.Y VSS.t324 sg13_lv_nmos ad=0.2516p pd=2.16u as=0.1406p ps=1.12u w=0.74u l=0.13u
X2062 VDD VSS.t2854 VDD VDD sg13_lv_pmos ad=0.34p pd=2.68u as=0 ps=0 w=1u l=1u
X2063 VSS.t2053 VDD VSS.t2055 VSS.t2054 sg13_lv_nmos ad=79.8f pd=0.8u as=0 ps=0 w=0.42u l=1u
X2064 VDD VSS.t2202 VDD VDD sg13_lv_pmos ad=0.34p pd=2.68u as=0 ps=0 w=1u l=1u
X2065 a_11866_15202# sg13g2_nand2_2_0.A VSS.t137 VSS.t355 sg13_lv_nmos ad=0.1428p pd=1.52u as=79.8f ps=0.8u w=0.42u l=0.13u
X2066 VSS.t1636 VDD VSS.t1638 VSS.t1637 sg13_lv_nmos ad=79.8f pd=0.8u as=0 ps=0 w=0.42u l=1u
X2067 VSS.t2782 VDD VSS.t2783 VSS.t2710 sg13_lv_nmos ad=79.8f pd=0.8u as=0 ps=0 w=0.42u l=1u
X2068 VSS.t1696 VDD VSS.t1698 VSS.t1697 sg13_lv_nmos ad=79.8f pd=0.8u as=0 ps=0 w=0.42u l=1u
X2069 VSS.t3225 VDD VSS.t3227 VSS.t3226 sg13_lv_nmos ad=79.8f pd=0.8u as=0 ps=0 w=0.42u l=1u
X2070 VDD VSS.t559 VDD VDD sg13_lv_pmos ad=0.19p pd=1.38u as=0 ps=0 w=1u l=1u
X2071 VSS.t989 VDD VSS.t988 VSS.t987 sg13_lv_nmos ad=0.1428p pd=1.52u as=0 ps=0 w=0.42u l=1u
X2072 VSS.t1373 VDD VSS.t1372 VSS.t305 sg13_lv_nmos ad=0.1428p pd=1.52u as=0 ps=0 w=0.42u l=1u
X2073 VSS.t729 VDD VSS.t729 VSS.t730 sg13_lv_nmos ad=79.8f pd=0.8u as=0 ps=0 w=0.42u l=1u
X2074 VDD VSS.t1345 VDD VDD sg13_lv_pmos ad=0.19p pd=1.38u as=0 ps=0 w=1u l=1u
X2075 VDD VSS.t1086 VDD VDD sg13_lv_pmos ad=0.19p pd=1.38u as=0 ps=0 w=1u l=1u
X2076 VDD VSS.t1660 VDD VDD sg13_lv_pmos ad=0.34p pd=2.68u as=0 ps=0 w=1u l=1u
X2077 VSS.t210 VDD VSS.t210 VSS.t510 sg13_lv_nmos ad=0.1428p pd=1.52u as=0 ps=0 w=0.42u l=1u
X2078 VDD VSS.t1715 VDD VDD sg13_lv_pmos ad=0.34p pd=2.68u as=0 ps=0 w=1u l=1u
X2079 VSS.t2003 VDD VSS.t2005 VSS.t2004 sg13_lv_nmos ad=79.8f pd=0.8u as=0 ps=0 w=0.42u l=1u
X2080 VSS.t3095 VDD VSS.t3097 VSS.t3096 sg13_lv_nmos ad=79.8f pd=0.8u as=0 ps=0 w=0.42u l=1u
X2081 a_18564_14922# sg13g2_dfrbpq_1_6.D a_18470_14922# VSS.t37 sg13_lv_nmos ad=60.89999f pd=0.71u as=0.1428p ps=1.52u w=0.42u l=0.13u
X2082 VDD VSS.t683 VDD VDD sg13_lv_pmos ad=0.34p pd=2.68u as=0 ps=0 w=1u l=1u
X2083 VDD VSS.t3002 VDD VDD sg13_lv_pmos ad=0.19p pd=1.38u as=0 ps=0 w=1u l=1u
X2084 VDD VSS.t1023 VDD VDD sg13_lv_pmos ad=0.34p pd=2.68u as=0 ps=0 w=1u l=1u
X2085 VSS.t1392 VDD VSS.t1391 VSS.t305 sg13_lv_nmos ad=0.1428p pd=1.52u as=0 ps=0 w=0.42u l=1u
X2086 VSS.t1786 VDD VSS.t1788 VSS.t1787 sg13_lv_nmos ad=79.8f pd=0.8u as=0 ps=0 w=0.42u l=1u
X2087 VDD VSS.t2817 VDD VDD sg13_lv_pmos ad=0.34p pd=2.68u as=0 ps=0 w=1u l=1u
X2088 a_25642_14452# a_26085_14495# a_26025_14531# VDD sg13_lv_pmos ad=79.8f pd=0.8u as=63f ps=0.72u w=0.42u l=0.13u
X2089 VDD VSS.t2404 VDD VDD sg13_lv_pmos ad=0.34p pd=2.68u as=0 ps=0 w=1u l=1u
X2090 sg13g2_nand2_2_0.Y sg13g2_xor2_1_1.A VDD VDD sg13_lv_pmos ad=0.2128p pd=1.5u as=0.4032p ps=2.96u w=1.12u l=0.13u
X2091 VDD a_19173_14495# a_19275_14495# VDD sg13_lv_pmos ad=2.75157p pd=17.885u as=0.3864p ps=2.93u w=1.12u l=0.13u
X2092 VDD VSS.t1389 VDD VDD sg13_lv_pmos ad=0.19p pd=1.38u as=0 ps=0 w=1u l=1u
X2093 VDD sg13g2_a21oi_1_0.Y a_17816_15238# VDD sg13_lv_pmos ad=0.1523p pd=1.38u as=0.1428p ps=1.52u w=0.42u l=0.13u
X2094 VDD a_16078_14484# sg13g2_buf_16_1.X VDD sg13_lv_pmos ad=0.2128p pd=1.5u as=0.2128p ps=1.5u w=1.12u l=0.13u
X2095 VDD sg13g2_dfrbpq_1_7.RESET_B a_18182_13722# VDD sg13_lv_pmos ad=0.36237p pd=2.605u as=79.8f ps=0.8u w=0.42u l=0.13u
X2096 VDD VSS.t2589 VDD VDD sg13_lv_pmos ad=0.34p pd=2.68u as=0 ps=0 w=1u l=1u
X2097 VDD VSS.t1361 VDD VDD sg13_lv_pmos ad=0.34p pd=2.68u as=0 ps=0 w=1u l=1u
X2098 VDD VSS.t2769 VDD VDD sg13_lv_pmos ad=0.19p pd=1.38u as=0 ps=0 w=1u l=1u
X2099 VDD VSS.t2187 VDD VDD sg13_lv_pmos ad=0.34p pd=2.68u as=0 ps=0 w=1u l=1u
X2100 VDD VSS.t2010 VDD VDD sg13_lv_pmos ad=0.19p pd=1.38u as=0 ps=0 w=1u l=1u
X2101 VDD VSS.t3159 VDD VDD sg13_lv_pmos ad=0.34p pd=2.68u as=0 ps=0 w=1u l=1u
X2102 VSS.t2425 VDD VSS.t2424 VSS.t2423 sg13_lv_nmos ad=0.1428p pd=1.52u as=0 ps=0 w=0.42u l=1u
X2103 VDD VSS.t2364 VDD VDD sg13_lv_pmos ad=0.34p pd=2.68u as=0 ps=0 w=1u l=1u
X2104 VDD VSS.t545 VDD VDD sg13_lv_pmos ad=0.34p pd=2.68u as=0 ps=0 w=1u l=1u
X2105 VDD VSS.t639 VDD VDD sg13_lv_pmos ad=0.19p pd=1.38u as=0 ps=0 w=1u l=1u
X2106 VSS.t714 VDD VSS.t714 VSS.t713 sg13_lv_nmos ad=0.1428p pd=1.52u as=0 ps=0 w=0.42u l=1u
X2107 VDD VSS.t146 VDD VDD sg13_lv_pmos ad=0.19p pd=1.38u as=0 ps=0 w=1u l=1u
X2108 VSS.t3210 VDD VSS.t3212 VSS.t3211 sg13_lv_nmos ad=79.8f pd=0.8u as=0 ps=0 w=0.42u l=1u
X2109 VSS.t1064 VDD VSS.t1066 VSS.t1065 sg13_lv_nmos ad=79.8f pd=0.8u as=0 ps=0 w=0.42u l=1u
X2110 VDD VSS.t1326 VDD VDD sg13_lv_pmos ad=0.34p pd=2.68u as=0 ps=0 w=1u l=1u
X2111 VDD VSS.t1693 VDD VDD sg13_lv_pmos ad=0.19p pd=1.38u as=0 ps=0 w=1u l=1u
X2112 VDD VSS.t285 VDD VDD sg13_lv_pmos ad=0.19p pd=1.38u as=0 ps=0 w=1u l=1u
X2113 VSS.t1400 VDD VSS.t1399 VSS.t305 sg13_lv_nmos ad=0.1428p pd=1.52u as=0 ps=0 w=0.42u l=1u
X2114 VDD sg13g2_nand2_2_0.A sg13g2_xor2_1_1.B VDD sg13_lv_pmos ad=0.3808p pd=2.92u as=0.2128p ps=1.5u w=1.12u l=0.13u
X2115 VSS.t1581 VDD VSS.t1583 VSS.t1582 sg13_lv_nmos ad=79.8f pd=0.8u as=0 ps=0 w=0.42u l=1u
X2116 VSS.t2490 VDD VSS.t2492 VSS.t2491 sg13_lv_nmos ad=79.8f pd=0.8u as=0 ps=0 w=0.42u l=1u
X2117 VSS.t924 VDD VSS.t923 VSS.t922 sg13_lv_nmos ad=0.1428p pd=1.52u as=0 ps=0 w=0.42u l=1u
X2118 VDD VSS.t2065 VDD VDD sg13_lv_pmos ad=0.19p pd=1.38u as=0 ps=0 w=1u l=1u
X2119 VDD sg13g2_buf_16_1.X a_12308_15202# VDD sg13_lv_pmos ad=0.3808p pd=2.92u as=0.2128p ps=1.5u w=1.12u l=0.13u
X2120 VDD VSS.t1269 VDD VDD sg13_lv_pmos ad=0.19p pd=1.38u as=0 ps=0 w=1u l=1u
X2121 VSS.t1711 VDD VSS.t1710 VSS.t1709 sg13_lv_nmos ad=0.1428p pd=1.52u as=0 ps=0 w=0.42u l=1u
X2122 VSS.t3240 VDD VSS.t3239 VSS.t3238 sg13_lv_nmos ad=0.1428p pd=1.52u as=0 ps=0 w=0.42u l=1u
X2123 VSS.t39 sg13g2_nor2b_1_1.A sg13g2_nor2b_1_1.Y VSS.t38 sg13_lv_nmos ad=0.2516p pd=2.16u as=0.1406p ps=1.12u w=0.74u l=0.13u
X2124 VDD VSS.t695 VDD VDD sg13_lv_pmos ad=0.19p pd=1.38u as=0 ps=0 w=1u l=1u
X2125 VSS.t1948 VDD VSS.t1950 VSS.t1949 sg13_lv_nmos ad=79.8f pd=0.8u as=0 ps=0 w=0.42u l=1u
X2126 VSS.t3040 VDD VSS.t3042 VSS.t3041 sg13_lv_nmos ad=79.8f pd=0.8u as=0 ps=0 w=0.42u l=1u
X2127 VSS.t52 VDD VSS.t52 VSS.t798 sg13_lv_nmos ad=0.1428p pd=1.52u as=0 ps=0 w=0.42u l=1u
X2128 VDD VSS.t1380 VDD VDD sg13_lv_pmos ad=0.19p pd=1.38u as=0 ps=0 w=1u l=1u
X2129 VDD sg13g2_buf_4_0.X a_22691_14020# VDD sg13_lv_pmos ad=0.3808p pd=2.92u as=0.2464p ps=1.56u w=1.12u l=0.13u
X2130 VDD VSS.t2432 VDD VDD sg13_lv_pmos ad=0.19p pd=1.38u as=0 ps=0 w=1u l=1u
X2131 VDD a_16078_14484# sg13g2_buf_16_1.X VDD sg13_lv_pmos ad=0.2128p pd=1.5u as=0.2128p ps=1.5u w=1.12u l=0.13u
X2132 VDD VSS.t1578 VDD VDD sg13_lv_pmos ad=0.19p pd=1.38u as=0 ps=0 w=1u l=1u
X2133 VDD VSS.t3144 VDD VDD sg13_lv_pmos ad=0.34p pd=2.68u as=0 ps=0 w=1u l=1u
X2134 VDD VSS.t2349 VDD VDD sg13_lv_pmos ad=0.34p pd=2.68u as=0 ps=0 w=1u l=1u
X2135 a_23648_15437# sg13g2_nor2b_1_0.A a_23785_15280# VSS.t3 sg13_lv_nmos ad=0.2176p pd=1.96u as=0.1216p ps=1.02u w=0.64u l=0.13u
X2136 VSS.t1621 VDD VSS.t1623 VSS.t1622 sg13_lv_nmos ad=79.8f pd=0.8u as=0 ps=0 w=0.42u l=1u
X2137 VSS.t1801 VDD VSS.t1800 VSS.t1799 sg13_lv_nmos ad=0.1428p pd=1.52u as=0 ps=0 w=0.42u l=1u
X2138 VSS.t2038 VDD VSS.t2040 VSS.t2039 sg13_lv_nmos ad=79.8f pd=0.8u as=0 ps=0 w=0.42u l=1u
X2139 VSS.t54 sg13g2_buf_1_9.X.t1 a_24334_13764# VSS.t53 sg13_lv_nmos ad=0.17255p pd=1.25u as=0.187p ps=1.78u w=0.55u l=0.13u
X2140 VSS.t2774 VDD VSS.t2775 VSS.t2710 sg13_lv_nmos ad=79.8f pd=0.8u as=0 ps=0 w=0.42u l=1u
X2141 VDD VSS.t2745 VDD VDD sg13_lv_pmos ad=0.19p pd=1.38u as=0 ps=0 w=1u l=1u
X2142 VDD VSS.t1713 VDD VDD sg13_lv_pmos ad=0.19p pd=1.38u as=0 ps=0 w=1u l=1u
X2143 VSS.t705 VDD VSS.t705 VSS.t826 sg13_lv_nmos ad=79.8f pd=0.8u as=0 ps=0 w=0.42u l=1u
X2144 VDD VSS.t3062 VDD VDD sg13_lv_pmos ad=0.19p pd=1.38u as=0 ps=0 w=1u l=1u
X2145 a_19162_15202# sg13g2_dfrbpq_1_6.Q VSS.t103 VSS.t249 sg13_lv_nmos ad=0.1428p pd=1.52u as=79.8f ps=0.8u w=0.42u l=0.13u
X2146 VSS.t454 VDD VSS.t456 VSS.t455 sg13_lv_nmos ad=79.8f pd=0.8u as=0 ps=0 w=0.42u l=1u
X2147 VSS.t671 VDD VSS.t673 VSS.t672 sg13_lv_nmos ad=79.8f pd=0.8u as=0 ps=0 w=0.42u l=1u
X2148 VSS.t884 VDD VSS.t886 VSS.t885 sg13_lv_nmos ad=79.8f pd=0.8u as=0 ps=0 w=0.42u l=1u
X2149 VDD VSS.t2057 VDD VDD sg13_lv_pmos ad=0.34p pd=2.68u as=0 ps=0 w=1u l=1u
X2150 VSS.t2168 VDD VSS.t2167 VSS.t2166 sg13_lv_nmos ad=0.1428p pd=1.52u as=0 ps=0 w=0.42u l=1u
X2151 VDD VSS.t943 VDD VDD sg13_lv_pmos ad=0.34p pd=2.68u as=0 ps=0 w=1u l=1u
X2152 VSS.t1731 VDD VSS.t1730 VSS.t1729 sg13_lv_nmos ad=0.1428p pd=1.52u as=0 ps=0 w=0.42u l=1u
X2153 VSS.t3260 VDD VSS.t3259 VSS.t3258 sg13_lv_nmos ad=0.1428p pd=1.52u as=0 ps=0 w=0.42u l=1u
X2154 VSS.t3080 VDD VSS.t3082 VSS.t3081 sg13_lv_nmos ad=79.8f pd=0.8u as=0 ps=0 w=0.42u l=1u
X2155 VDD VSS.t2845 VDD VDD sg13_lv_pmos ad=0.19p pd=1.38u as=0 ps=0 w=1u l=1u
X2156 VSS.t2445 VDD VSS.t2444 VSS.t2443 sg13_lv_nmos ad=0.1428p pd=1.52u as=0 ps=0 w=0.42u l=1u
X2157 VDD sg13g2_buf_16_1.X a_12308_15202# VDD sg13_lv_pmos ad=0.2128p pd=1.5u as=0.2128p ps=1.5u w=1.12u l=0.13u
X2158 a_17038_15423# a_17153_15424# VDD VDD sg13_lv_pmos ad=0.34p pd=2.68u as=0.2254p ps=1.53u w=1u l=0.5u
X2159 VDD VSS.t1068 VDD VDD sg13_lv_pmos ad=0.34p pd=2.68u as=0 ps=0 w=1u l=1u
X2160 VDD VSS.t1740 VDD VDD sg13_lv_pmos ad=0.34p pd=2.68u as=0 ps=0 w=1u l=1u
X2161 VSS.t1771 VDD VSS.t1773 VSS.t1772 sg13_lv_nmos ad=79.8f pd=0.8u as=0 ps=0 w=0.42u l=1u
X2162 VSS.t1933 VDD VSS.t1935 VSS.t1934 sg13_lv_nmos ad=79.8f pd=0.8u as=0 ps=0 w=0.42u l=1u
X2163 VSS.t2856 VDD VSS.t2857 VSS.t2710 sg13_lv_nmos ad=79.8f pd=0.8u as=0 ps=0 w=0.42u l=1u
X2164 VSS.t2475 VDD VSS.t2477 VSS.t2476 sg13_lv_nmos ad=79.8f pd=0.8u as=0 ps=0 w=0.42u l=1u
X2165 VDD VSS.t2389 VDD VDD sg13_lv_pmos ad=0.34p pd=2.68u as=0 ps=0 w=1u l=1u
X2166 VDD VSS.t2417 VDD VDD sg13_lv_pmos ad=0.19p pd=1.38u as=0 ps=0 w=1u l=1u
X2167 VDD VSS.t705 VDD VDD sg13_lv_pmos ad=0.19p pd=1.38u as=0 ps=0 w=1u l=1u
X2168 VDD VSS.t724 VDD VDD sg13_lv_pmos ad=0.34p pd=2.68u as=0 ps=0 w=1u l=1u
X2169 VDD VSS.t1006 VDD VDD sg13_lv_pmos ad=0.19p pd=1.38u as=0 ps=0 w=1u l=1u
X2170 VSS.t1303 VDD VSS.t1304 VSS.t305 sg13_lv_nmos ad=79.8f pd=0.8u as=0 ps=0 w=0.42u l=1u
X2171 VDD VSS.t1563 VDD VDD sg13_lv_pmos ad=0.19p pd=1.38u as=0 ps=0 w=1u l=1u
X2172 VDD a_16078_14484# sg13g2_buf_16_1.X VDD sg13_lv_pmos ad=0.2128p pd=1.5u as=0.2128p ps=1.5u w=1.12u l=0.13u
X2173 VDD VSS.t1352 VDD VDD sg13_lv_pmos ad=0.34p pd=2.68u as=0 ps=0 w=1u l=1u
X2174 VDD VSS.t2857 VDD VDD sg13_lv_pmos ad=0.34p pd=2.68u as=0 ps=0 w=1u l=1u
X2175 VDD VSS.t2172 VDD VDD sg13_lv_pmos ad=0.34p pd=2.68u as=0 ps=0 w=1u l=1u
X2176 VDD VSS.t639 VDD VDD sg13_lv_pmos ad=0.19p pd=1.38u as=0 ps=0 w=1u l=1u
X2177 VDD a_18374_12972# a_18486_12996# VDD sg13_lv_pmos ad=0.2254p pd=1.53u as=0.34p ps=2.68u w=1u l=0.5u
X2178 VDD VSS.t1396 VDD VDD sg13_lv_pmos ad=0.19p pd=1.38u as=0 ps=0 w=1u l=1u
X2179 VSS.t1641 VDD VSS.t1643 VSS.t1642 sg13_lv_nmos ad=79.8f pd=0.8u as=0 ps=0 w=0.42u l=1u
X2180 VSS.t2023 VDD VSS.t2025 VSS.t2024 sg13_lv_nmos ad=79.8f pd=0.8u as=0 ps=0 w=0.42u l=1u
X2181 VSS.t632 VDD VSS.t631 VSS.t630 sg13_lv_nmos ad=0.1428p pd=1.52u as=0 ps=0 w=0.42u l=1u
X2182 VSS.t1963 VDD VSS.t1962 VSS.t1961 sg13_lv_nmos ad=0.1428p pd=1.52u as=0 ps=0 w=0.42u l=1u
X2183 sg13g2_xnor2_1_0.B sg13g2_buf_1_0.X VDD VDD sg13_lv_pmos ad=0.2128p pd=1.5u as=0.3808p ps=2.92u w=1.12u l=0.13u
X2184 VSS.t1345 VDD VSS.t1345 VSS.t305 sg13_lv_nmos ad=79.8f pd=0.8u as=0 ps=0 w=0.42u l=1u
X2185 VSS.t3055 VDD VSS.t3054 VSS.t3053 sg13_lv_nmos ad=0.1428p pd=1.52u as=0 ps=0 w=0.42u l=1u
X2186 VSS.t74 a_18665_16334# a_18586_16237# VSS.t3269 sg13_lv_nmos ad=5.31717p pd=34.515u as=0.27427p ps=2.28u w=0.795u l=0.13u
X2187 VSS.t71 VDD VSS.t71 VSS.t590 sg13_lv_nmos ad=0.1428p pd=1.52u as=0 ps=0 w=0.42u l=1u
X2188 VSS.t1268 VDD VSS.t1267 VSS.t305 sg13_lv_nmos ad=0.1428p pd=1.52u as=0 ps=0 w=0.42u l=1u
X2189 VSS.t208 VDD VSS.t208 VSS.t482 sg13_lv_nmos ad=0.1428p pd=1.52u as=0 ps=0 w=0.42u l=1u
X2190 VSS.t1039 VDD VSS.t1041 VSS.t1040 sg13_lv_nmos ad=79.8f pd=0.8u as=0 ps=0 w=0.42u l=1u
X2191 VSS.t924 VDD VSS.t923 VSS.t922 sg13_lv_nmos ad=0.1428p pd=1.52u as=0 ps=0 w=0.42u l=1u
X2192 VSS.t1761 VDD VSS.t1763 VSS.t1762 sg13_lv_nmos ad=79.8f pd=0.8u as=0 ps=0 w=0.42u l=1u
X2193 VDD VSS.t1108 VDD VDD sg13_lv_pmos ad=0.34p pd=2.68u as=0 ps=0 w=1u l=1u
X2194 VDD VSS.t1720 VDD VDD sg13_lv_pmos ad=0.34p pd=2.68u as=0 ps=0 w=1u l=1u
X2195 VSS.t2746 VDD VSS.t2747 VSS.t2710 sg13_lv_nmos ad=79.8f pd=0.8u as=0 ps=0 w=0.42u l=1u
X2196 a_11076_14488# a_11595_14495# a_12335_14845# VSS.t88 sg13_lv_nmos ad=0.3473p pd=2.71u as=0.12665p ps=1.145u w=0.74u l=0.13u
X2197 VDD VSS.t784 VDD VDD sg13_lv_pmos ad=0.34p pd=2.68u as=0 ps=0 w=1u l=1u
X2198 VDD VSS.t3007 VDD VDD sg13_lv_pmos ad=0.19p pd=1.38u as=0 ps=0 w=1u l=1u
X2199 VDD a_12308_15202# sg13g2_dfrbpq_1_2.CLK VDD sg13_lv_pmos ad=0.2128p pd=1.5u as=0.2128p ps=1.5u w=1.12u l=0.13u
X2200 VDD VSS.t1725 VDD VDD sg13_lv_pmos ad=0.34p pd=2.68u as=0 ps=0 w=1u l=1u
X2201 VSS.t1756 VDD VSS.t1758 VSS.t1757 sg13_lv_nmos ad=79.8f pd=0.8u as=0 ps=0 w=0.42u l=1u
X2202 VDD VSS.t2819 VDD VDD sg13_lv_pmos ad=0.34p pd=2.68u as=0 ps=0 w=1u l=1u
X2203 VSS.t647 VDD VSS.t646 VSS.t645 sg13_lv_nmos ad=0.1428p pd=1.52u as=0 ps=0 w=0.42u l=1u
X2204 VDD VSS.t2409 VDD VDD sg13_lv_pmos ad=0.34p pd=2.68u as=0 ps=0 w=1u l=1u
X2205 VSS.t167 sg13g2_and2_1_0.B a_2827_14832# VSS.t254 sg13_lv_nmos ad=0.1331p pd=1.12u as=0.1216p ps=1.02u w=0.64u l=0.13u
X2206 VDD VSS.t1280 VDD VDD sg13_lv_pmos ad=0.34p pd=2.68u as=0 ps=0 w=1u l=1u
X2207 VSS.t3025 VDD VSS.t3027 VSS.t3026 sg13_lv_nmos ad=79.8f pd=0.8u as=0 ps=0 w=0.42u l=1u
X2208 VDD VSS.t2067 VDD VDD sg13_lv_pmos ad=0.34p pd=2.68u as=0 ps=0 w=1u l=1u
X2209 VDD VSS.t71 VDD VDD sg13_lv_pmos ad=0.34p pd=2.68u as=0 ps=0 w=1u l=1u
X2210 VDD VSS.t1371 VDD VDD sg13_lv_pmos ad=0.19p pd=1.38u as=0 ps=0 w=1u l=1u
X2211 VDD VSS.t2594 VDD VDD sg13_lv_pmos ad=0.34p pd=2.68u as=0 ps=0 w=1u l=1u
X2212 VDD VSS.t2771 VDD VDD sg13_lv_pmos ad=0.19p pd=1.38u as=0 ps=0 w=1u l=1u
X2213 VDD VSS.t1123 VDD VDD sg13_lv_pmos ad=0.34p pd=2.68u as=0 ps=0 w=1u l=1u
X2214 VSS.t1591 VDD VSS.t1593 VSS.t1592 sg13_lv_nmos ad=79.8f pd=0.8u as=0 ps=0 w=0.42u l=1u
X2215 VSS.t2430 VDD VSS.t2429 VSS.t2428 sg13_lv_nmos ad=0.1428p pd=1.52u as=0 ps=0 w=0.42u l=1u
X2216 VSS.t1786 VDD VSS.t1785 VSS.t1784 sg13_lv_nmos ad=0.1428p pd=1.52u as=0 ps=0 w=0.42u l=1u
X2217 VSS.t2203 VDD VSS.t2202 VSS.t2201 sg13_lv_nmos ad=0.1428p pd=1.52u as=0 ps=0 w=0.42u l=1u
X2218 VSS.t210 VDD VSS.t502 VSS.t506 sg13_lv_nmos ad=0.1428p pd=1.52u as=0 ps=0 w=0.42u l=1u
X2219 a_3204_15234# sg13g2_and2_1_0.X a_3110_15234# VSS.t214 sg13_lv_nmos ad=60.89999f pd=0.71u as=0.1428p ps=1.52u w=0.42u l=0.13u
X2220 VDD VSS.t1698 VDD VDD sg13_lv_pmos ad=0.19p pd=1.38u as=0 ps=0 w=1u l=1u
X2221 sg13g2_dfrbpq_1_7.CLK a_19630_15238# VDD VDD sg13_lv_pmos ad=0.2128p pd=1.5u as=0.2128p ps=1.5u w=1.12u l=0.13u
X2222 VDD VSS.t564 VDD VDD sg13_lv_pmos ad=0.19p pd=1.38u as=0 ps=0 w=1u l=1u
X2223 VSS.t884 VDD VSS.t886 VSS.t885 sg13_lv_nmos ad=79.8f pd=0.8u as=0 ps=0 w=0.42u l=1u
X2224 VSS.t1321 VDD VSS.t1466 VSS.t305 sg13_lv_nmos ad=79.8f pd=0.8u as=0 ps=0 w=0.42u l=1u
X2225 VDD VSS.t1753 VDD VDD sg13_lv_pmos ad=0.19p pd=1.38u as=0 ps=0 w=1u l=1u
X2226 VDD VSS.t3224 VDD VDD sg13_lv_pmos ad=0.34p pd=2.68u as=0 ps=0 w=1u l=1u
X2227 VSS.t1586 VDD VSS.t1588 VSS.t1587 sg13_lv_nmos ad=79.8f pd=0.8u as=0 ps=0 w=0.42u l=1u
X2228 VSS.t2495 VDD VSS.t2497 VSS.t2496 sg13_lv_nmos ad=79.8f pd=0.8u as=0 ps=0 w=0.42u l=1u
X2229 VDD VSS.t167 VDD VDD sg13_lv_pmos ad=0.34p pd=2.68u as=0 ps=0 w=1u l=1u
X2230 VSS.t243 sg13g2_dfrbpq_1_7.RESET_B a_18276_13722# VSS.t242 sg13_lv_nmos ad=0.1626p pd=1.415u as=60.89999f ps=0.71u w=0.42u l=0.13u
X2231 VDD VSS.t1272 VDD VDD sg13_lv_pmos ad=0.19p pd=1.38u as=0 ps=0 w=1u l=1u
X2232 VSS.t1716 VDD VSS.t1715 VSS.t1714 sg13_lv_nmos ad=0.1428p pd=1.52u as=0 ps=0 w=0.42u l=1u
X2233 VSS.t3245 VDD VSS.t3244 VSS.t3243 sg13_lv_nmos ad=0.1428p pd=1.52u as=0 ps=0 w=0.42u l=1u
X2234 VDD VSS.t2837 VDD VDD sg13_lv_pmos ad=0.19p pd=1.38u as=0 ps=0 w=1u l=1u
X2235 VSS.t545 VDD VSS.t545 VSS.t602 sg13_lv_nmos ad=0.1428p pd=1.52u as=0 ps=0 w=0.42u l=1u
X2236 sg13g2_buf_1_0.X a_1192_3900# VDD VDD sg13_lv_pmos ad=0.42p pd=2.99u as=0.2114p ps=1.54u w=1.12u l=0.13u
X2237 VSS.t652 VDD VSS.t651 VSS.t650 sg13_lv_nmos ad=0.1428p pd=1.52u as=0 ps=0 w=0.42u l=1u
X2238 VSS.t1069 VDD VSS.t1071 VSS.t1070 sg13_lv_nmos ad=79.8f pd=0.8u as=0 ps=0 w=0.42u l=1u
X2239 a_17699_16265# sg13g2_nand3_1_1.Y a_17997_16020# VDD sg13_lv_pmos ad=0.34p pd=2.68u as=0.19p ps=1.38u w=1u l=0.13u
X2240 VDD VSS.t1258 VDD VDD sg13_lv_pmos ad=0.19p pd=1.38u as=0 ps=0 w=1u l=1u
X2241 VSS.t394 VDD VSS.t394 VSS.t396 sg13_lv_nmos ad=0.1428p pd=1.52u as=0 ps=0 w=0.42u l=1u
X2242 a_27417_15549# a_26475_15356# a_27215_15311# VDD sg13_lv_pmos ad=93.45f pd=0.865u as=0.2048p ps=1.63u w=0.42u l=0.13u
X2243 VSS.t564 VDD VSS.t569 VSS.t568 sg13_lv_nmos ad=79.8f pd=0.8u as=0 ps=0 w=0.42u l=1u
X2244 VSS.t2525 VDD VSS.t2524 VSS.t2523 sg13_lv_nmos ad=0.1428p pd=1.52u as=0 ps=0 w=0.42u l=1u
X2245 sg13g2_nor4_2_0.Y sg13g2_nor3_1_0.C VSS.t147 VSS.t7 sg13_lv_nmos ad=0.1406p pd=1.12u as=0.2516p ps=2.16u w=0.74u l=0.13u
X2246 a_19929_14037# a_18987_13844# a_19727_13799# VDD sg13_lv_pmos ad=93.45f pd=0.865u as=0.2048p ps=1.63u w=0.42u l=0.13u
X2247 VDD sg13g2_buf_1_9.X.t1 a_24334_13764# VDD sg13_lv_pmos ad=0.2618p pd=1.63u as=0.2856p ps=2.36u w=0.84u l=0.13u
X2248 VDD VSS.t1383 VDD VDD sg13_lv_pmos ad=0.19p pd=1.38u as=0 ps=0 w=1u l=1u
X2249 VSS.t2720 VDD VSS.t2719 VSS.t2710 sg13_lv_nmos ad=0.1428p pd=1.52u as=0 ps=0 w=0.42u l=1u
X2250 VDD VSS.t2767 VDD VDD sg13_lv_pmos ad=0.19p pd=1.38u as=0 ps=0 w=1u l=1u
X2251 sg13g2_nand3_1_1.Y sg13g2_nand2_2_0.A VDD VDD sg13_lv_pmos ad=0.3808p pd=2.92u as=0.2128p ps=1.5u w=1.12u l=0.13u
X2252 VSS.t7 a_11493_14495# a_11595_14495# VSS.t265 sg13_lv_nmos ad=5.1665p pd=33.355u as=0.2516p ps=2.16u w=0.74u l=0.13u
X2253 VDD VSS.t2579 VDD VDD sg13_lv_pmos ad=0.34p pd=2.68u as=0 ps=0 w=1u l=1u
X2254 VDD VSS.t2402 VDD VDD sg13_lv_pmos ad=0.19p pd=1.38u as=0 ps=0 w=1u l=1u
X2255 VSS.t2460 VDD VSS.t2462 VSS.t2461 sg13_lv_nmos ad=79.8f pd=0.8u as=0 ps=0 w=0.42u l=1u
X2256 VDD VSS.t1548 VDD VDD sg13_lv_pmos ad=0.19p pd=1.38u as=0 ps=0 w=1u l=1u
X2257 a_13966_16263# a_14081_16262# VSS.t326 VSS.t365 sg13_lv_nmos ad=0.1428p pd=1.52u as=0.1426p ps=1.16u w=0.42u l=0.5u
X2258 a_20146_13722# sg13g2_dfrbpq_1_7.RESET_B VSS.t238 VSS.t245 sg13_lv_nmos ad=37.8f pd=0.6u as=79.8f ps=0.8u w=0.42u l=0.13u
X2259 VSS.t1626 VDD VSS.t1628 VSS.t1627 sg13_lv_nmos ad=79.8f pd=0.8u as=0 ps=0 w=0.42u l=1u
X2260 VSS.t1806 VDD VSS.t1805 VSS.t1804 sg13_lv_nmos ad=0.1428p pd=1.52u as=0 ps=0 w=0.42u l=1u
X2261 VDD VSS.t2527 VDD VDD sg13_lv_pmos ad=0.19p pd=1.38u as=0 ps=0 w=1u l=1u
X2262 VSS.t2188 VDD VSS.t2187 VSS.t2186 sg13_lv_nmos ad=0.1428p pd=1.52u as=0 ps=0 w=0.42u l=1u
X2263 VDD VSS.t1312 VDD VDD sg13_lv_pmos ad=0.34p pd=2.68u as=0 ps=0 w=1u l=1u
X2264 VSS.t1371 VDD VSS.t1370 VSS.t305 sg13_lv_nmos ad=0.1428p pd=1.52u as=0 ps=0 w=0.42u l=1u
X2265 VSS.t2777 VDD VSS.t2778 VSS.t2710 sg13_lv_nmos ad=79.8f pd=0.8u as=0 ps=0 w=0.42u l=1u
X2266 VSS.t465 VDD VSS.t467 VSS.t466 sg13_lv_nmos ad=79.8f pd=0.8u as=0 ps=0 w=0.42u l=1u
X2267 a_8914_15234# sg13g2_dfrbpq_1_1.RESET_B VSS.t32 VSS.t316 sg13_lv_nmos ad=37.8f pd=0.6u as=79.8f ps=0.8u w=0.42u l=0.13u
X2268 VDD VSS.t545 VDD VDD sg13_lv_pmos ad=0.34p pd=2.68u as=0 ps=0 w=1u l=1u
X2269 VSS.t1039 VDD VSS.t1041 VSS.t1040 sg13_lv_nmos ad=79.8f pd=0.8u as=0 ps=0 w=0.42u l=1u
X2270 VSS.t3040 VDD VSS.t3039 VSS.t3038 sg13_lv_nmos ad=0.1428p pd=1.52u as=0 ps=0 w=0.42u l=1u
X2271 VDD VSS.t513 VDD VDD sg13_lv_pmos ad=0.34p pd=2.68u as=0 ps=0 w=1u l=1u
X2272 VSS.t1084 VDD VSS.t1086 VSS.t1085 sg13_lv_nmos ad=79.8f pd=0.8u as=0 ps=0 w=0.42u l=1u
X2273 VDD VSS.t1398 VDD VDD sg13_lv_pmos ad=0.34p pd=2.68u as=0 ps=0 w=1u l=1u
X2274 VDD VSS.t3067 VDD VDD sg13_lv_pmos ad=0.19p pd=1.38u as=0 ps=0 w=1u l=1u
X2275 VDD VSS.t1930 VDD VDD sg13_lv_pmos ad=0.19p pd=1.38u as=0 ps=0 w=1u l=1u
X2276 a_19630_15238# sg13g2_buf_16_1.X VDD VDD sg13_lv_pmos ad=0.2128p pd=1.5u as=0.2128p ps=1.5u w=1.12u l=0.13u
X2277 VSS.t517 VDD VSS.t516 VSS.t515 sg13_lv_nmos ad=0.1428p pd=1.52u as=0 ps=0 w=0.42u l=1u
X2278 a_27322_13690# sg13g2_dlygate4sd3_1_12.A VDD VDD sg13_lv_pmos ad=0.1428p pd=1.52u as=0.1523p ps=1.38u w=0.42u l=0.13u
X2279 VDD VSS.t2778 VDD VDD sg13_lv_pmos ad=0.34p pd=2.68u as=0 ps=0 w=1u l=1u
X2280 VDD VSS.t2027 VDD VDD sg13_lv_pmos ad=0.34p pd=2.68u as=0 ps=0 w=1u l=1u
X2281 VDD VSS.t1705 VDD VDD sg13_lv_pmos ad=0.34p pd=2.68u as=0 ps=0 w=1u l=1u
X2282 VDD VSS.t2848 VDD VDD sg13_lv_pmos ad=0.19p pd=1.38u as=0 ps=0 w=1u l=1u
X2283 VSS.t179 sg13g2_and2_1_1.B a_6571_14832# VSS.t178 sg13_lv_nmos ad=0.1331p pd=1.12u as=0.1216p ps=1.02u w=0.64u l=0.13u
X2284 VDD VSS.t306 VDD VDD sg13_lv_pmos ad=0.34p pd=2.68u as=0 ps=0 w=1u l=1u
X2285 VDD VSS.t1349 VDD VDD sg13_lv_pmos ad=0.19p pd=1.38u as=0 ps=0 w=1u l=1u
X2286 VDD VSS.t529 VDD VDD sg13_lv_pmos ad=0.34p pd=2.68u as=0 ps=0 w=1u l=1u
X2287 VDD VSS.t1710 VDD VDD sg13_lv_pmos ad=0.34p pd=2.68u as=0 ps=0 w=1u l=1u
X2288 VSS.t545 VDD VSS.t545 VSS.t552 sg13_lv_nmos ad=0.1428p pd=1.52u as=0 ps=0 w=0.42u l=1u
X2289 a_17621_12972# sg13g2_dlygate4sd3_1_3.X VDD VDD sg13_lv_pmos ad=0.2128p pd=1.5u as=0.2128p ps=1.5u w=1.12u l=0.13u
X2290 VSS.t1298 VDD VSS.t1299 VSS.t305 sg13_lv_nmos ad=79.8f pd=0.8u as=0 ps=0 w=0.42u l=1u
X2291 VSS.t1601 VDD VSS.t1600 VSS.t1599 sg13_lv_nmos ad=0.1428p pd=1.52u as=0 ps=0 w=0.42u l=1u
X2292 VSS.t2510 VDD VSS.t2509 VSS.t2508 sg13_lv_nmos ad=0.1428p pd=1.52u as=0 ps=0 w=0.42u l=1u
X2293 VDD VSS.t2394 VDD VDD sg13_lv_pmos ad=0.34p pd=2.68u as=0 ps=0 w=1u l=1u
X2294 sg13g2_nor3_1_0.C sg13g2_or3_1_0.A VDD VDD sg13_lv_pmos ad=0.2128p pd=1.5u as=0.3808p ps=2.92u w=1.12u l=0.13u
X2295 VDD sg13g2_buf_16_1.X a_19630_15238# VDD sg13_lv_pmos ad=0.2128p pd=1.5u as=0.2128p ps=1.5u w=1.12u l=0.13u
X2296 a_25668_14488# a_25642_14452# VSS.t81 VSS.t82 sg13_lv_nmos ad=0.2516p pd=2.16u as=0.1626p ps=1.415u w=0.74u l=0.13u
X2297 VSS.t1385 VDD VSS.t1384 VSS.t305 sg13_lv_nmos ad=0.1428p pd=1.52u as=0 ps=0 w=0.42u l=1u
X2298 VSS.t1576 VDD VSS.t1578 VSS.t1577 sg13_lv_nmos ad=79.8f pd=0.8u as=0 ps=0 w=0.42u l=1u
X2299 a_27346_14922# sg13g2_dfrbpq_1_5.RESET_B VSS.t79 VSS.t78 sg13_lv_nmos ad=37.8f pd=0.6u as=79.8f ps=0.8u w=0.42u l=0.13u
X2300 VDD VSS.t2740 VDD VDD sg13_lv_pmos ad=0.19p pd=1.38u as=0 ps=0 w=1u l=1u
X2301 VSS.t1968 VDD VSS.t1967 VSS.t1966 sg13_lv_nmos ad=0.1428p pd=1.52u as=0 ps=0 w=0.42u l=1u
X2302 VSS.t2138 VDD VSS.t2140 VSS.t2139 sg13_lv_nmos ad=79.8f pd=0.8u as=0 ps=0 w=0.42u l=1u
X2303 VDD VSS.t1287 VDD VDD sg13_lv_pmos ad=0.19p pd=1.38u as=0 ps=0 w=1u l=1u
X2304 VDD VSS.t2095 VDD VDD sg13_lv_pmos ad=0.19p pd=1.38u as=0 ps=0 w=1u l=1u
X2305 VDD VSS.t210 VDD VDD sg13_lv_pmos ad=0.34p pd=2.68u as=0 ps=0 w=1u l=1u
X2306 VDD VSS.t3209 VDD VDD sg13_lv_pmos ad=0.34p pd=2.68u as=0 ps=0 w=1u l=1u
X2307 VDD VSS.t2449 VDD VDD sg13_lv_pmos ad=0.34p pd=2.68u as=0 ps=0 w=1u l=1u
X2308 VSS.t1766 VDD VSS.t1768 VSS.t1767 sg13_lv_nmos ad=79.8f pd=0.8u as=0 ps=0 w=0.42u l=1u
X2309 VSS.t1571 VDD VSS.t1573 VSS.t1572 sg13_lv_nmos ad=79.8f pd=0.8u as=0 ps=0 w=0.42u l=1u
X2310 VSS.t2480 VDD VSS.t2482 VSS.t2481 sg13_lv_nmos ad=79.8f pd=0.8u as=0 ps=0 w=0.42u l=1u
X2311 sg13g2_mux2_1_1.A0 a_24333_15280# VSS.t25 VSS.t3 sg13_lv_nmos ad=0.2516p pd=2.16u as=0.1331p ps=1.12u w=0.74u l=0.13u
X2312 a_11302_14909# sg13g2_dfrbpq_1_2.RESET_B VSS.t98 VSS.t99 sg13_lv_nmos ad=37.8f pd=0.6u as=0.1701p ps=1.65u w=0.42u l=0.13u
X2313 VDD VSS.t434 VDD VDD sg13_lv_pmos ad=0.19p pd=1.38u as=0 ps=0 w=1u l=1u
X2314 VDD VSS.t1330 VDD VDD sg13_lv_pmos ad=0.34p pd=2.68u as=0 ps=0 w=1u l=1u
X2315 VDD VSS.t1690 VDD VDD sg13_lv_pmos ad=0.34p pd=2.68u as=0 ps=0 w=1u l=1u
X2316 VSS.t3070 VDD VSS.t3072 VSS.t3071 sg13_lv_nmos ad=79.8f pd=0.8u as=0 ps=0 w=0.42u l=1u
X2317 VSS.t2058 VDD VSS.t2057 VSS.t2056 sg13_lv_nmos ad=0.1428p pd=1.52u as=0 ps=0 w=0.42u l=1u
X2318 a_18374_12972# a_18104_13013# VSS.t243 VSS.t3270 sg13_lv_nmos ad=0.1428p pd=1.52u as=79.8f ps=0.8u w=0.42u l=0.5u
X2319 VSS.t1069 VDD VSS.t1071 VSS.t1070 sg13_lv_nmos ad=79.8f pd=0.8u as=0 ps=0 w=0.42u l=1u
X2320 VDD VSS.t3012 VDD VDD sg13_lv_pmos ad=0.19p pd=1.38u as=0 ps=0 w=1u l=1u
X2321 VDD VSS.t1043 VDD VDD sg13_lv_pmos ad=0.34p pd=2.68u as=0 ps=0 w=1u l=1u
X2322 VSS.t1281 VDD VSS.t1280 VSS.t305 sg13_lv_nmos ad=0.1428p pd=1.52u as=0 ps=0 w=0.42u l=1u
X2323 VDD VSS.t1608 VDD VDD sg13_lv_pmos ad=0.19p pd=1.38u as=0 ps=0 w=1u l=1u
X2324 a_8697_15549# a_7755_15356# a_8495_15311# VDD sg13_lv_pmos ad=93.45f pd=0.865u as=0.2048p ps=1.63u w=0.42u l=0.13u
X2325 a_3396_15552# a_3370_15457# VDD VDD sg13_lv_pmos ad=0.34p pd=2.68u as=0.36237p ps=2.605u w=1u l=0.13u
X2326 VSS.t79 a_27472_15454# a_27121_15311# VSS.t165 sg13_lv_nmos ad=79.8f pd=0.8u as=0.1428p ps=1.52u w=0.42u l=0.13u
X2327 VSS.t243 sg13g2_dlygate4sd3_1_3.A a_17336_13726# VSS.t289 sg13_lv_nmos ad=79.8f pd=0.8u as=0.1428p ps=1.52u w=0.42u l=0.13u
X2328 VSS.t243 a_17606_13726# a_17718_13790# VSS.t291 sg13_lv_nmos ad=0.1426p pd=1.16u as=0.1428p ps=1.52u w=0.42u l=0.5u
X2329 VDD VSS.t1374 VDD VDD sg13_lv_pmos ad=0.19p pd=1.38u as=0 ps=0 w=1u l=1u
X2330 VDD VSS.t2855 VDD VDD sg13_lv_pmos ad=0.34p pd=2.68u as=0 ps=0 w=1u l=1u
X2331 VDD VSS.t2760 VDD VDD sg13_lv_pmos ad=0.19p pd=1.38u as=0 ps=0 w=1u l=1u
X2332 VDD VSS.t2564 VDD VDD sg13_lv_pmos ad=0.34p pd=2.68u as=0 ps=0 w=1u l=1u
X2333 VDD VSS.t659 VDD VDD sg13_lv_pmos ad=0.19p pd=1.38u as=0 ps=0 w=1u l=1u
X2334 VSS.t869 VDD VSS.t868 VSS.t867 sg13_lv_nmos ad=0.1428p pd=1.52u as=0 ps=0 w=0.42u l=1u
X2335 VSS.t1561 VDD VSS.t1563 VSS.t1562 sg13_lv_nmos ad=79.8f pd=0.8u as=0 ps=0 w=0.42u l=1u
X2336 VDD VSS.t415 VDD VDD sg13_lv_pmos ad=0.19p pd=1.38u as=0 ps=0 w=1u l=1u
X2337 a_10176_14523# sg13g2_xnor2_1_1.A VDD VDD sg13_lv_pmos ad=0.1596p pd=1.22u as=0.4536p ps=2.76u w=0.84u l=0.13u
X2338 VDD VSS.t1338 VDD VDD sg13_lv_pmos ad=0.34p pd=2.68u as=0 ps=0 w=1u l=1u
X2339 VSS.t1791 VDD VSS.t1790 VSS.t1789 sg13_lv_nmos ad=0.1428p pd=1.52u as=0 ps=0 w=0.42u l=1u
X2340 VDD VSS.t20 VDD VDD sg13_lv_pmos ad=0.19p pd=1.38u as=0 ps=0 w=1u l=1u
X2341 VSS.t1084 VDD VSS.t1086 VSS.t1085 sg13_lv_nmos ad=79.8f pd=0.8u as=0 ps=0 w=0.42u l=1u
X2342 a_27472_15454# a_27215_15311# a_27634_15234# VSS.t106 sg13_lv_nmos ad=0.1428p pd=1.52u as=37.8f ps=0.6u w=0.42u l=0.13u
X2343 VSS.t56 VDD VSS.t56 VSS.t778 sg13_lv_nmos ad=0.1428p pd=1.52u as=0 ps=0 w=0.42u l=1u
X2344 VDD VSS.t2080 VDD VDD sg13_lv_pmos ad=0.19p pd=1.38u as=0 ps=0 w=1u l=1u
X2345 a_22508_14484# sg13g2_buf_4_0.X a_22806_14484# VDD sg13_lv_pmos ad=0.3808p pd=2.92u as=0.2128p ps=1.5u w=1.12u l=0.13u
X2346 VDD VSS.t3229 VDD VDD sg13_lv_pmos ad=0.34p pd=2.68u as=0 ps=0 w=1u l=1u
X2347 sg13g2_dlygate4sd3_1_3.X a_17718_13790# VDD VDD sg13_lv_pmos ad=0.4256p pd=3u as=0.2254p ps=1.53u w=1.12u l=0.13u
X2348 VDD VSS.t1763 VDD VDD sg13_lv_pmos ad=0.19p pd=1.38u as=0 ps=0 w=1u l=1u
X2349 VDD VSS.t1375 VDD VDD sg13_lv_pmos ad=0.19p pd=1.38u as=0 ps=0 w=1u l=1u
X2350 VSS.t1257 VDD VSS.t1258 VSS.t305 sg13_lv_nmos ad=79.8f pd=0.8u as=0 ps=0 w=0.42u l=1u
X2351 VDD VSS.t1275 VDD VDD sg13_lv_pmos ad=0.19p pd=1.38u as=0 ps=0 w=1u l=1u
X2352 VSS.t1721 VDD VSS.t1720 VSS.t1719 sg13_lv_nmos ad=0.1428p pd=1.52u as=0 ps=0 w=0.42u l=1u
X2353 VDD VSS.t2840 VDD VDD sg13_lv_pmos ad=0.19p pd=1.38u as=0 ps=0 w=1u l=1u
X2354 VSS.t3215 VDD VSS.t3214 VSS.t3213 sg13_lv_nmos ad=0.1428p pd=1.52u as=0 ps=0 w=0.42u l=1u
X2355 VSS.t673 VDD VSS.t676 VSS.t675 sg13_lv_nmos ad=79.8f pd=0.8u as=0 ps=0 w=0.42u l=1u
X2356 VSS.t1586 VDD VSS.t1585 VSS.t1584 sg13_lv_nmos ad=0.1428p pd=1.52u as=0 ps=0 w=0.42u l=1u
X2357 VSS.t2495 VDD VSS.t2494 VSS.t2493 sg13_lv_nmos ad=0.1428p pd=1.52u as=0 ps=0 w=0.42u l=1u
X2358 a_26926_13911# a_27041_13912# VSS.t351 VSS.t3319 sg13_lv_nmos ad=0.1428p pd=1.52u as=0.1426p ps=1.16u w=0.42u l=0.5u
X2359 VDD VSS.t1073 VDD VDD sg13_lv_pmos ad=0.34p pd=2.68u as=0 ps=0 w=1u l=1u
X2360 VSS.t2814 VDD VSS.t2815 VSS.t2710 sg13_lv_nmos ad=79.8f pd=0.8u as=0 ps=0 w=0.42u l=1u
X2361 VSS.t2465 VDD VSS.t2467 VSS.t2466 sg13_lv_nmos ad=79.8f pd=0.8u as=0 ps=0 w=0.42u l=1u
X2362 VDD VSS.t1553 VDD VDD sg13_lv_pmos ad=0.19p pd=1.38u as=0 ps=0 w=1u l=1u
X2363 VDD VSS.t3024 VDD VDD sg13_lv_pmos ad=0.34p pd=2.68u as=0 ps=0 w=1u l=1u
X2364 VDD VSS.t888 VDD VDD sg13_lv_pmos ad=0.34p pd=2.68u as=0 ps=0 w=1u l=1u
X2365 VDD VSS.t671 VDD VDD sg13_lv_pmos ad=0.34p pd=2.68u as=0 ps=0 w=1u l=1u
X2366 VSS.t760 VDD VSS.t16 VSS.t761 sg13_lv_nmos ad=79.8f pd=0.8u as=0 ps=0 w=0.42u l=1u
X2367 VSS.t2780 VDD VSS.t2781 VSS.t2710 sg13_lv_nmos ad=79.8f pd=0.8u as=0 ps=0 w=0.42u l=1u
X2368 VDD VSS.t2731 VDD VDD sg13_lv_pmos ad=0.19p pd=1.38u as=0 ps=0 w=1u l=1u
X2369 VSS.t1953 VDD VSS.t1952 VSS.t1951 sg13_lv_nmos ad=0.1428p pd=1.52u as=0 ps=0 w=0.42u l=1u
X2370 VSS.t378 VDD VSS.t378 VSS.t377 sg13_lv_nmos ad=0.1428p pd=1.52u as=0 ps=0 w=0.42u l=1u
X2371 VSS.t3045 VDD VSS.t3044 VSS.t3043 sg13_lv_nmos ad=0.1428p pd=1.52u as=0 ps=0 w=0.42u l=1u
X2372 VDD VSS.t1381 VDD VDD sg13_lv_pmos ad=0.34p pd=2.68u as=0 ps=0 w=1u l=1u
X2373 VDD a_18086_15238# a_18198_15302# VDD sg13_lv_pmos ad=0.2254p pd=1.53u as=0.34p ps=2.68u w=1u l=0.5u
X2374 VSS.t2108 VDD VSS.t2110 VSS.t2109 sg13_lv_nmos ad=79.8f pd=0.8u as=0 ps=0 w=0.42u l=1u
X2375 a_18374_12972# a_18104_13013# VDD VDD sg13_lv_pmos ad=0.34p pd=2.68u as=0.1523p ps=1.38u w=1u l=0.5u
X2376 VDD VSS.t2781 VDD VDD sg13_lv_pmos ad=0.34p pd=2.68u as=0 ps=0 w=1u l=1u
X2377 VDD VSS.t2032 VDD VDD sg13_lv_pmos ad=0.34p pd=2.68u as=0 ps=0 w=1u l=1u
X2378 VSS.t1751 VDD VSS.t1753 VSS.t1752 sg13_lv_nmos ad=79.8f pd=0.8u as=0 ps=0 w=0.42u l=1u
X2379 VSS.t540 VDD VSS.t540 VSS.t592 sg13_lv_nmos ad=0.1428p pd=1.52u as=0 ps=0 w=0.42u l=1u
X2380 VDD VSS.t951 VDD VDD sg13_lv_pmos ad=0.19p pd=1.38u as=0 ps=0 w=1u l=1u
X2381 VDD VSS.t1266 VDD VDD sg13_lv_pmos ad=0.19p pd=1.38u as=0 ps=0 w=1u l=1u
X2382 VDD VSS.t2832 VDD VDD sg13_lv_pmos ad=0.19p pd=1.38u as=0 ps=0 w=1u l=1u
X2383 VSS.t2143 VDD VSS.t2142 VSS.t2141 sg13_lv_nmos ad=0.1428p pd=1.52u as=0 ps=0 w=0.42u l=1u
X2384 VSS.t1706 VDD VSS.t1705 VSS.t1704 sg13_lv_nmos ad=0.1428p pd=1.52u as=0 ps=0 w=0.42u l=1u
X2385 VDD VSS.t2997 VDD VDD sg13_lv_pmos ad=0.19p pd=1.38u as=0 ps=0 w=1u l=1u
X2386 VSS.t3235 VDD VSS.t3234 VSS.t3233 sg13_lv_nmos ad=0.1428p pd=1.52u as=0 ps=0 w=0.42u l=1u
X2387 VSS.t3055 VDD VSS.t3057 VSS.t3056 sg13_lv_nmos ad=79.8f pd=0.8u as=0 ps=0 w=0.42u l=1u
X2388 VDD VSS.t1715 VDD VDD sg13_lv_pmos ad=0.34p pd=2.68u as=0 ps=0 w=1u l=1u
X2389 VDD VSS.t1770 VDD VDD sg13_lv_pmos ad=0.34p pd=2.68u as=0 ps=0 w=1u l=1u
X2390 VDD VSS.t540 VDD VDD sg13_lv_pmos ad=0.34p pd=2.68u as=0 ps=0 w=1u l=1u
X2391 VSS.t2515 VDD VSS.t2514 VSS.t2513 sg13_lv_nmos ad=0.1428p pd=1.52u as=0 ps=0 w=0.42u l=1u
X2392 VDD VSS.t2399 VDD VDD sg13_lv_pmos ad=0.34p pd=2.68u as=0 ps=0 w=1u l=1u
X2393 VSS.t344 sg13g2_dlygate4sd3_1_0.A a_7048_15996# VSS.t3314 sg13_lv_nmos ad=0.14875p pd=1.16u as=0.187p ps=1.78u w=0.55u l=0.13u
X2394 a_7653_15213# sg13g2_dfrbpq_1_2.CLK VSS.t7 VSS.t45 sg13_lv_nmos ad=0.2516p pd=2.16u as=4.79747p ps=30.975u w=0.74u l=0.13u
X2395 VDD VSS.t545 VDD VDD sg13_lv_pmos ad=0.19p pd=1.38u as=0 ps=0 w=1u l=1u
X2396 VSS.t869 VDD VSS.t868 VSS.t867 sg13_lv_nmos ad=0.1428p pd=1.52u as=0 ps=0 w=0.42u l=1u
X2397 VDD VSS.t2846 VDD VDD sg13_lv_pmos ad=0.34p pd=2.68u as=0 ps=0 w=1u l=1u
X2398 VDD VSS.t659 VDD VDD sg13_lv_pmos ad=0.19p pd=1.38u as=0 ps=0 w=1u l=1u
X2399 VDD VSS.t705 VDD VDD sg13_lv_pmos ad=0.19p pd=1.38u as=0 ps=0 w=1u l=1u
X2400 VSS.t652 VDD VSS.t651 VSS.t650 sg13_lv_nmos ad=0.1428p pd=1.52u as=0 ps=0 w=0.42u l=1u
X2401 VSS.t700 VDD VSS.t700 VSS.t821 sg13_lv_nmos ad=0.1428p pd=1.52u as=0 ps=0 w=0.42u l=1u
X2402 VDD VSS.t1285 VDD VDD sg13_lv_pmos ad=0.19p pd=1.38u as=0 ps=0 w=1u l=1u
X2403 VSS.t1357 VDD VSS.t1358 VSS.t305 sg13_lv_nmos ad=79.8f pd=0.8u as=0 ps=0 w=0.42u l=1u
X2404 VSS.t1546 VDD VSS.t1548 VSS.t1547 sg13_lv_nmos ad=79.8f pd=0.8u as=0 ps=0 w=0.42u l=1u
X2405 VSS.t1616 VDD VSS.t1618 VSS.t1617 sg13_lv_nmos ad=79.8f pd=0.8u as=0 ps=0 w=0.42u l=1u
X2406 VSS.t423 VDD VSS.t422 VSS.t421 sg13_lv_nmos ad=0.1428p pd=1.52u as=0 ps=0 w=0.42u l=1u
X2407 VDD VSS.t2742 VDD VDD sg13_lv_pmos ad=0.19p pd=1.38u as=0 ps=0 w=1u l=1u
X2408 a_8752_15454# a_8495_15311# a_8914_15234# VSS.t33 sg13_lv_nmos ad=0.1428p pd=1.52u as=37.8f ps=0.6u w=0.42u l=0.13u
X2409 VSS.t1938 VDD VSS.t1937 VSS.t1936 sg13_lv_nmos ad=0.1428p pd=1.52u as=0 ps=0 w=0.42u l=1u
X2410 VSS.t210 a_37484_15960# counter_value_o[7] VSS.t209 sg13_lv_nmos ad=0.14875p pd=1.16u as=0.2886p ps=2.26u w=0.74u l=0.13u
X2411 VDD VSS.t1290 VDD VDD sg13_lv_pmos ad=0.19p pd=1.38u as=0 ps=0 w=1u l=1u
X2412 VDD VSS.t2799 VDD VDD sg13_lv_pmos ad=0.19p pd=1.38u as=0 ps=0 w=1u l=1u
X2413 VSS.t545 VDD VSS.t545 VSS.t551 sg13_lv_nmos ad=79.8f pd=0.8u as=0 ps=0 w=0.42u l=1u
X2414 VDD VSS.t2419 VDD VDD sg13_lv_pmos ad=0.34p pd=2.68u as=0 ps=0 w=1u l=1u
X2415 VSS.t2480 VDD VSS.t2479 VSS.t2478 sg13_lv_nmos ad=0.1428p pd=1.52u as=0 ps=0 w=0.42u l=1u
X2416 VSS.t210 VDD VSS.t210 VSS.t508 sg13_lv_nmos ad=0.1428p pd=1.52u as=0 ps=0 w=0.42u l=1u
X2417 VDD VSS.t686 VDD VDD sg13_lv_pmos ad=0.19p pd=1.38u as=0 ps=0 w=1u l=1u
X2418 VDD VSS.t179 VDD VDD sg13_lv_pmos ad=0.34p pd=2.68u as=0 ps=0 w=1u l=1u
X2419 VDD VSS.t2060 VDD VDD sg13_lv_pmos ad=0.19p pd=1.38u as=0 ps=0 w=1u l=1u
X2420 VSS.t2028 VDD VSS.t2027 VSS.t2026 sg13_lv_nmos ad=0.1428p pd=1.52u as=0 ps=0 w=0.42u l=1u
X2421 VDD a_19162_15202# a_18881_15424# VDD sg13_lv_pmos ad=0.1523p pd=1.38u as=0.34p ps=2.68u w=1u l=0.5u
X2422 a_26085_14495# sg13g2_dfrbpq_1_7.CLK VSS.t7 VSS.t198 sg13_lv_nmos ad=0.2516p pd=2.16u as=4.79747p ps=30.975u w=0.74u l=0.13u
X2423 VSS.t2545 VDD VSS.t2547 VSS.t2546 sg13_lv_nmos ad=79.8f pd=0.8u as=0 ps=0 w=0.42u l=1u
X2424 VSS.t89 a_12308_15202# sg13g2_dfrbpq_1_2.CLK VSS.t195 sg13_lv_nmos ad=0.1406p pd=1.12u as=0.1406p ps=1.12u w=0.74u l=0.13u
X2425 VDD VSS.t1613 VDD VDD sg13_lv_pmos ad=0.19p pd=1.38u as=0 ps=0 w=1u l=1u
X2426 VSS.t2714 VDD VSS.t2713 VSS.t2710 sg13_lv_nmos ad=0.1428p pd=1.52u as=0 ps=0 w=0.42u l=1u
X2427 VSS.t1069 VDD VSS.t1068 VSS.t1067 sg13_lv_nmos ad=0.1428p pd=1.52u as=0 ps=0 w=0.42u l=1u
X2428 VSS.t3105 VDD VSS.t3104 VSS.t3103 sg13_lv_nmos ad=0.1428p pd=1.52u as=0 ps=0 w=0.42u l=1u
X2429 VDD VSS.t2762 VDD VDD sg13_lv_pmos ad=0.19p pd=1.38u as=0 ps=0 w=1u l=1u
X2430 a_10699_13768# sg13g2_buf_1_9.X a_10605_13768# VSS.t50 sg13_lv_nmos ad=0.1216p pd=1.02u as=0.2176p ps=1.96u w=0.64u l=0.13u
X2431 VDD VSS.t1121 VDD VDD sg13_lv_pmos ad=0.19p pd=1.38u as=0 ps=0 w=1u l=1u
X2432 VDD VSS.t3009 VDD VDD sg13_lv_pmos ad=0.34p pd=2.68u as=0 ps=0 w=1u l=1u
X2433 VSS.t399 VDD VSS.t399 VSS.t400 sg13_lv_nmos ad=79.8f pd=0.8u as=0 ps=0 w=0.42u l=1u
X2434 VDD VSS.t673 VDD VDD sg13_lv_pmos ad=0.34p pd=2.68u as=0 ps=0 w=1u l=1u
X2435 VSS.t1566 VDD VSS.t1568 VSS.t1567 sg13_lv_nmos ad=79.8f pd=0.8u as=0 ps=0 w=0.42u l=1u
X2436 VSS.t1761 VDD VSS.t1760 VSS.t1759 sg13_lv_nmos ad=0.1428p pd=1.52u as=0 ps=0 w=0.42u l=1u
X2437 VDD VSS.t1578 VDD VDD sg13_lv_pmos ad=0.19p pd=1.38u as=0 ps=0 w=1u l=1u
X2438 VSS.t2771 VDD VSS.t2772 VSS.t2710 sg13_lv_nmos ad=79.8f pd=0.8u as=0 ps=0 w=0.42u l=1u
X2439 VDD VSS.t2487 VDD VDD sg13_lv_pmos ad=0.19p pd=1.38u as=0 ps=0 w=1u l=1u
X2440 VSS.t2375 VDD VSS.t2377 VSS.t2376 sg13_lv_nmos ad=79.8f pd=0.8u as=0 ps=0 w=0.42u l=1u
X2441 sg13g2_dfrbpq_1_7.CLK a_19630_15238# VSS.t162 VSS.t3 sg13_lv_nmos ad=0.1406p pd=1.12u as=0.1406p ps=1.12u w=0.74u l=0.13u
X2442 VSS.t2093 VDD VSS.t2095 VSS.t2094 sg13_lv_nmos ad=79.8f pd=0.8u as=0 ps=0 w=0.42u l=1u
X2443 VSS.t1374 VDD VSS.t1375 VSS.t305 sg13_lv_nmos ad=79.8f pd=0.8u as=0 ps=0 w=0.42u l=1u
X2444 VDD VSS.t2772 VDD VDD sg13_lv_pmos ad=0.34p pd=2.68u as=0 ps=0 w=1u l=1u
X2445 VSS.t559 VDD VSS.t559 VSS.t610 sg13_lv_nmos ad=0.1428p pd=1.52u as=0 ps=0 w=0.42u l=1u
X2446 VSS.t2048 VDD VSS.t2047 VSS.t2046 sg13_lv_nmos ad=0.1428p pd=1.52u as=0 ps=0 w=0.42u l=1u
X2447 a_27129_14607# a_26187_14495# a_26927_14845# VDD sg13_lv_pmos ad=93.45f pd=0.865u as=0.2048p ps=1.63u w=0.42u l=0.13u
X2448 VDD VSS.t1257 VDD VDD sg13_lv_pmos ad=0.19p pd=1.38u as=0 ps=0 w=1u l=1u
X2449 VDD VSS.t2748 VDD VDD sg13_lv_pmos ad=0.34p pd=2.68u as=0 ps=0 w=1u l=1u
X2450 VSS.t1691 VDD VSS.t1690 VSS.t1689 sg13_lv_nmos ad=0.1428p pd=1.52u as=0 ps=0 w=0.42u l=1u
X2451 VSS.t3220 VDD VSS.t3219 VSS.t3218 sg13_lv_nmos ad=0.1428p pd=1.52u as=0 ps=0 w=0.42u l=1u
X2452 a_11076_14488# a_11050_14452# VSS.t98 VSS.t267 sg13_lv_nmos ad=0.2516p pd=2.16u as=0.1626p ps=1.415u w=0.74u l=0.13u
X2453 VSS.t89 a_12308_15202# sg13g2_dfrbpq_1_2.CLK VSS.t182 sg13_lv_nmos ad=0.1406p pd=1.12u as=0.1406p ps=1.12u w=0.74u l=0.13u
X2454 VDD VSS.t559 VDD VDD sg13_lv_pmos ad=0.34p pd=2.68u as=0 ps=0 w=1u l=1u
X2455 a_7450_14448# sg13g2_xnor2_1_0.Y VDD VDD sg13_lv_pmos ad=0.1428p pd=1.52u as=0.1523p ps=1.38u w=0.42u l=0.13u
X2456 VDD VSS.t351 VDD VDD sg13_lv_pmos ad=0.19p pd=1.38u as=0 ps=0 w=1u l=1u
X2457 VDD VSS.t1755 VDD VDD sg13_lv_pmos ad=0.34p pd=2.68u as=0 ps=0 w=1u l=1u
X2458 VSS.t1606 VDD VSS.t1608 VSS.t1607 sg13_lv_nmos ad=79.8f pd=0.8u as=0 ps=0 w=0.42u l=1u
X2459 VSS.t1591 VDD VSS.t1590 VSS.t1589 sg13_lv_nmos ad=0.1428p pd=1.52u as=0 ps=0 w=0.42u l=1u
X2460 VSS.t2500 VDD VSS.t2499 VSS.t2498 sg13_lv_nmos ad=0.1428p pd=1.52u as=0 ps=0 w=0.42u l=1u
X2461 VSS.t729 VDD VSS.t729 VSS.t731 sg13_lv_nmos ad=0.1428p pd=1.52u as=0 ps=0 w=0.42u l=1u
X2462 VDD VSS.t451 VDD VDD sg13_lv_pmos ad=0.19p pd=1.38u as=0 ps=0 w=1u l=1u
X2463 a_17434_15202# sg13g2_o21ai_1_0.Y VDD VDD sg13_lv_pmos ad=0.1428p pd=1.52u as=0.1523p ps=1.38u w=0.42u l=0.13u
X2464 VDD VSS.t1088 VDD VDD sg13_lv_pmos ad=0.34p pd=2.68u as=0 ps=0 w=1u l=1u
X2465 VSS.t2947 VDD VSS.t2817 VSS.t2710 sg13_lv_nmos ad=79.8f pd=0.8u as=0 ps=0 w=0.42u l=1u
X2466 VSS.t1998 VDD VSS.t1997 VSS.t1996 sg13_lv_nmos ad=0.1428p pd=1.52u as=0 ps=0 w=0.42u l=1u
X2467 VDD VSS.t1558 VDD VDD sg13_lv_pmos ad=0.19p pd=1.38u as=0 ps=0 w=1u l=1u
X2468 VDD VSS.t3029 VDD VDD sg13_lv_pmos ad=0.34p pd=2.68u as=0 ps=0 w=1u l=1u
X2469 VDD VSS.t3202 VDD VDD sg13_lv_pmos ad=0.19p pd=1.38u as=0 ps=0 w=1u l=1u
X2470 a_7653_15213# sg13g2_dfrbpq_1_2.CLK VDD VDD sg13_lv_pmos ad=0.4088p pd=2.97u as=2.35643p ps=14.81u w=1.12u l=0.13u
X2471 VSS.t1601 VDD VSS.t1603 VSS.t1602 sg13_lv_nmos ad=79.8f pd=0.8u as=0 ps=0 w=0.42u l=1u
X2472 VSS.t1781 VDD VSS.t1780 VSS.t1779 sg13_lv_nmos ad=0.1428p pd=1.52u as=0 ps=0 w=0.42u l=1u
X2473 VSS.t177 a_4270_14751# sg13g2_dlygate4sd3_1_2.X VSS.t176 sg13_lv_nmos ad=0.1426p pd=1.16u as=0.2516p ps=2.16u w=0.74u l=0.13u
X2474 VDD sg13g2_nand2_2_0.A sg13g2_nand2_2_0.Y VDD sg13_lv_pmos ad=0.392p pd=2.94u as=0.2128p ps=1.5u w=1.12u l=0.13u
X2475 VDD VSS.t1563 VDD VDD sg13_lv_pmos ad=0.19p pd=1.38u as=0 ps=0 w=1u l=1u
X2476 VSS.t2764 VDD VSS.t2765 VSS.t2710 sg13_lv_nmos ad=79.8f pd=0.8u as=0 ps=0 w=0.42u l=1u
X2477 VDD VSS.t2734 VDD VDD sg13_lv_pmos ad=0.19p pd=1.38u as=0 ps=0 w=1u l=1u
X2478 VDD VSS.t2472 VDD VDD sg13_lv_pmos ad=0.19p pd=1.38u as=0 ps=0 w=1u l=1u
X2479 VSS.t3050 VDD VSS.t3049 VSS.t3048 sg13_lv_nmos ad=0.1428p pd=1.52u as=0 ps=0 w=0.42u l=1u
X2480 VSS.t364 a_17699_16265# sg13g2_a21oi_1_0.A2 VSS.t3311 sg13_lv_nmos ad=0.13395p pd=1.12u as=0.2516p ps=2.16u w=0.74u l=0.13u
X2481 VDD VSS.t1384 VDD VDD sg13_lv_pmos ad=0.34p pd=2.68u as=0 ps=0 w=1u l=1u
X2482 VDD VSS.t521 VDD VDD sg13_lv_pmos ad=0.34p pd=2.68u as=0 ps=0 w=1u l=1u
X2483 VDD VSS.t2597 VDD VDD sg13_lv_pmos ad=0.19p pd=1.38u as=0 ps=0 w=1u l=1u
X2484 VSS.t2078 VDD VSS.t2080 VSS.t2079 sg13_lv_nmos ad=79.8f pd=0.8u as=0 ps=0 w=0.42u l=1u
X2485 sg13g2_dfrbpq_1_7.CLK a_19630_15238# VSS.t158 VSS.t3 sg13_lv_nmos ad=0.1406p pd=1.12u as=0.1406p ps=1.12u w=0.74u l=0.13u
X2486 a_8590_14751# a_8705_14750# VDD VDD sg13_lv_pmos ad=0.34p pd=2.68u as=0.2254p ps=1.53u w=1u l=0.5u
X2487 VSS.t664 VDD VSS.t664 VSS.t663 sg13_lv_nmos ad=0.1428p pd=1.52u as=0 ps=0 w=0.42u l=1u
X2488 VDD VSS.t2783 VDD VDD sg13_lv_pmos ad=0.34p pd=2.68u as=0 ps=0 w=1u l=1u
X2489 VDD VSS.t2037 VDD VDD sg13_lv_pmos ad=0.34p pd=2.68u as=0 ps=0 w=1u l=1u
X2490 VDD VSS.t32 VDD VDD sg13_lv_pmos ad=0.19p pd=1.38u as=0 ps=0 w=1u l=1u
X2491 VDD VSS.t1361 VDD VDD sg13_lv_pmos ad=0.19p pd=1.38u as=0 ps=0 w=1u l=1u
X2492 VSS.t1310 VDD VSS.t1311 VSS.t305 sg13_lv_nmos ad=79.8f pd=0.8u as=0 ps=0 w=0.42u l=1u
X2493 VDD VSS.t1720 VDD VDD sg13_lv_pmos ad=0.34p pd=2.68u as=0 ps=0 w=1u l=1u
X2494 VDD VSS.t1775 VDD VDD sg13_lv_pmos ad=0.34p pd=2.68u as=0 ps=0 w=1u l=1u
X2495 VDD VSS.t1932 VDD VDD sg13_lv_pmos ad=0.34p pd=2.68u as=0 ps=0 w=1u l=1u
X2496 VSS.t1069 VDD VSS.t1068 VSS.t1067 sg13_lv_nmos ad=0.1428p pd=1.52u as=0 ps=0 w=0.42u l=1u
X2497 VDD VSS.t1051 VDD VDD sg13_lv_pmos ad=0.19p pd=1.38u as=0 ps=0 w=1u l=1u
X2498 VDD a_15184_14726# a_15129_14607# VDD sg13_lv_pmos ad=2.75157p pd=17.885u as=93.45f ps=0.865u w=0.42u l=0.13u
X2499 VDD VSS.t2849 VDD VDD sg13_lv_pmos ad=0.34p pd=2.68u as=0 ps=0 w=1u l=1u
X2500 sg13g2_dlygate4sd3_1_3.X a_17718_13790# VSS.t243 VSS.t298 sg13_lv_nmos ad=0.2516p pd=2.16u as=0.1426p ps=1.16u w=0.74u l=0.13u
X2501 sg13g2_dlygate4sd3_1_10.X a_18486_12996# VSS.t243 VSS.t333 sg13_lv_nmos ad=0.2516p pd=2.16u as=0.1426p ps=1.16u w=0.74u l=0.13u
X2502 VSS.t1529 VDD VSS.t1396 VSS.t305 sg13_lv_nmos ad=0.1428p pd=1.52u as=0 ps=0 w=0.42u l=1u
X2503 VSS.t1551 VDD VSS.t1553 VSS.t1552 sg13_lv_nmos ad=79.8f pd=0.8u as=0 ps=0 w=0.42u l=1u
X2504 VDD VSS.t978 VDD VDD sg13_lv_pmos ad=0.34p pd=2.68u as=0 ps=0 w=1u l=1u
X2505 VSS.t71 VDD VSS.t71 VSS.t591 sg13_lv_nmos ad=79.8f pd=0.8u as=0 ps=0 w=0.42u l=1u
X2506 VSS.t3035 VDD VSS.t3034 VSS.t3033 sg13_lv_nmos ad=0.1428p pd=1.52u as=0 ps=0 w=0.42u l=1u
X2507 VSS.t2862 VDD VSS.t2861 VSS.t2710 sg13_lv_nmos ad=0.1428p pd=1.52u as=0 ps=0 w=0.42u l=1u
X2508 VSS.t1943 VDD VSS.t1942 VSS.t1941 sg13_lv_nmos ad=0.1428p pd=1.52u as=0 ps=0 w=0.42u l=1u
X2509 VDD VSS.t1293 VDD VDD sg13_lv_pmos ad=0.19p pd=1.38u as=0 ps=0 w=1u l=1u
X2510 VDD VSS.t2801 VDD VDD sg13_lv_pmos ad=0.19p pd=1.38u as=0 ps=0 w=1u l=1u
X2511 VSS.t2360 VDD VSS.t2362 VSS.t2361 sg13_lv_nmos ad=79.8f pd=0.8u as=0 ps=0 w=0.42u l=1u
X2512 VSS.t2113 VDD VSS.t2115 VSS.t2114 sg13_lv_nmos ad=79.8f pd=0.8u as=0 ps=0 w=0.42u l=1u
X2513 VDD VSS.t2070 VDD VDD sg13_lv_pmos ad=0.19p pd=1.38u as=0 ps=0 w=1u l=1u
X2514 VDD VSS.t2424 VDD VDD sg13_lv_pmos ad=0.34p pd=2.68u as=0 ps=0 w=1u l=1u
X2515 VSS.t2485 VDD VSS.t2484 VSS.t2483 sg13_lv_nmos ad=0.1428p pd=1.52u as=0 ps=0 w=0.42u l=1u
X2516 VDD a_23483_14540# a_23983_14508# VDD sg13_lv_pmos ad=0.2198p pd=1.52u as=0.2975p ps=1.595u w=1u l=0.13u
X2517 VDD VSS.t1570 VDD VDD sg13_lv_pmos ad=0.34p pd=2.68u as=0 ps=0 w=1u l=1u
X2518 a_7151_13726# sg13g2_xnor2_1_0.A VSS.t331 VSS.t332 sg13_lv_nmos ad=0.2516p pd=2.16u as=0.1898p ps=1.36u w=0.74u l=0.13u
X2519 VSS.t781 VDD VSS.t20 VSS.t782 sg13_lv_nmos ad=79.8f pd=0.8u as=0 ps=0 w=0.42u l=1u
X2520 VSS.t1651 VDD VSS.t1650 VSS.t1649 sg13_lv_nmos ad=0.1428p pd=1.52u as=0 ps=0 w=0.42u l=1u
X2521 VDD VSS.t1753 VDD VDD sg13_lv_pmos ad=0.19p pd=1.38u as=0 ps=0 w=1u l=1u
X2522 VSS.t2033 VDD VSS.t2032 VSS.t2031 sg13_lv_nmos ad=0.1428p pd=1.52u as=0 ps=0 w=0.42u l=1u
X2523 sg13g2_buf_4_0.A sg13g2_buf_1_0.X VDD VDD sg13_lv_pmos ad=0.3808p pd=2.92u as=0.2128p ps=1.5u w=1.12u l=0.13u
X2524 VDD VSS.t853 VDD VDD sg13_lv_pmos ad=0.34p pd=2.68u as=0 ps=0 w=1u l=1u
X2525 VSS.t1293 VDD VSS.t1292 VSS.t305 sg13_lv_nmos ad=0.1428p pd=1.52u as=0 ps=0 w=0.42u l=1u
X2526 VDD VSS.t2741 VDD VDD sg13_lv_pmos ad=0.34p pd=2.68u as=0 ps=0 w=1u l=1u
X2527 VSS.t2550 VDD VSS.t2552 VSS.t2551 sg13_lv_nmos ad=79.8f pd=0.8u as=0 ps=0 w=0.42u l=1u
X2528 VDD VSS.t502 VDD VDD sg13_lv_pmos ad=0.34p pd=2.68u as=0 ps=0 w=1u l=1u
X2529 a_3110_15234# a_3915_15356# a_3370_15457# VDD sg13_lv_pmos ad=0.1428p pd=1.52u as=79.8f ps=0.8u w=0.42u l=0.13u
X2530 VDD VSS.t2125 VDD VDD sg13_lv_pmos ad=0.19p pd=1.38u as=0 ps=0 w=1u l=1u
X2531 VDD a_12335_14845# a_13002_14484# VDD sg13_lv_pmos ad=0.2128p pd=1.5u as=0.3864p ps=2.93u w=1.12u l=0.13u
X2532 VSS.t1771 VDD VSS.t1770 VSS.t1769 sg13_lv_nmos ad=0.1428p pd=1.52u as=0 ps=0 w=0.42u l=1u
X2533 VSS.t2716 VDD VSS.t2716 VSS.t2710 sg13_lv_nmos ad=0.1428p pd=1.52u as=0 ps=0 w=0.42u l=1u
X2534 VSS.t889 VDD VSS.t888 VSS.t887 sg13_lv_nmos ad=0.1428p pd=1.52u as=0 ps=0 w=0.42u l=1u
X2535 VSS.t2939 VDD VSS.t2809 VSS.t2710 sg13_lv_nmos ad=79.8f pd=0.8u as=0 ps=0 w=0.42u l=1u
X2536 VDD a_4912_15454# a_4857_15549# VDD sg13_lv_pmos ad=2.4406p pd=15.34u as=93.45f ps=0.865u w=0.42u l=0.13u
X2537 VSS.t1328 VDD VSS.t1329 VSS.t305 sg13_lv_nmos ad=79.8f pd=0.8u as=0 ps=0 w=0.42u l=1u
X2538 VSS.t1410 VDD VSS.t1251 VSS.t305 sg13_lv_nmos ad=79.8f pd=0.8u as=0 ps=0 w=0.42u l=1u
X2539 VDD VSS.t1543 VDD VDD sg13_lv_pmos ad=0.19p pd=1.38u as=0 ps=0 w=1u l=1u
X2540 VDD VSS.t3014 VDD VDD sg13_lv_pmos ad=0.34p pd=2.68u as=0 ps=0 w=1u l=1u
X2541 VSS.t3075 VDD VSS.t3074 VSS.t3073 sg13_lv_nmos ad=0.1428p pd=1.52u as=0 ps=0 w=0.42u l=1u
X2542 VSS.t1766 VDD VSS.t1765 VSS.t1764 sg13_lv_nmos ad=0.1428p pd=1.52u as=0 ps=0 w=0.42u l=1u
X2543 sg13g2_and2_1_2.B sg13g2_buf_4_0.X a_10419_14484# VDD sg13_lv_pmos ad=0.2408p pd=1.55u as=0.1428p ps=1.375u w=1.12u l=0.13u
X2544 a_13894_14909# sg13g2_dfrbpq_1_3.RESET_B VSS.t89 VSS.t3308 sg13_lv_nmos ad=37.8f pd=0.6u as=0.1701p ps=1.65u w=0.42u l=0.13u
X2545 VDD VSS.t1548 VDD VDD sg13_lv_pmos ad=0.19p pd=1.38u as=0 ps=0 w=1u l=1u
X2546 VSS.t2853 VDD VSS.t2852 VSS.t2710 sg13_lv_nmos ad=0.1428p pd=1.52u as=0 ps=0 w=0.42u l=1u
X2547 VSS.t71 VDD VSS.t540 VSS.t539 sg13_lv_nmos ad=79.8f pd=0.8u as=0 ps=0 w=0.42u l=1u
X2548 VSS.t2133 VDD VSS.t2135 VSS.t2134 sg13_lv_nmos ad=79.8f pd=0.8u as=0 ps=0 w=0.42u l=1u
X2549 VSS.t2345 VDD VSS.t2347 VSS.t2346 sg13_lv_nmos ad=79.8f pd=0.8u as=0 ps=0 w=0.42u l=1u
X2550 VDD VSS.t700 VDD VDD sg13_lv_pmos ad=0.19p pd=1.38u as=0 ps=0 w=1u l=1u
X2551 VDD VSS.t3204 VDD VDD sg13_lv_pmos ad=0.34p pd=2.68u as=0 ps=0 w=1u l=1u
X2552 VDD VSS.t2582 VDD VDD sg13_lv_pmos ad=0.19p pd=1.38u as=0 ps=0 w=1u l=1u
X2553 VDD VSS.t2022 VDD VDD sg13_lv_pmos ad=0.34p pd=2.68u as=0 ps=0 w=1u l=1u
X2554 VDD VSS.t285 VDD VDD sg13_lv_pmos ad=0.34p pd=2.68u as=0 ps=0 w=1u l=1u
X2555 VDD VSS.t1008 VDD VDD sg13_lv_pmos ad=0.34p pd=2.68u as=0 ps=0 w=1u l=1u
X2556 VSS.t1269 VDD VSS.t1270 VSS.t305 sg13_lv_nmos ad=79.8f pd=0.8u as=0 ps=0 w=0.42u l=1u
X2557 VSS.t1306 VDD VSS.t1305 VSS.t305 sg13_lv_nmos ad=0.1428p pd=1.52u as=0 ps=0 w=0.42u l=1u
X2558 VSS.t1336 VDD VSS.t1337 VSS.t305 sg13_lv_nmos ad=79.8f pd=0.8u as=0 ps=0 w=0.42u l=1u
X2559 VDD VSS.t1705 VDD VDD sg13_lv_pmos ad=0.34p pd=2.68u as=0 ps=0 w=1u l=1u
X2560 VSS.t427 VDD VSS.t429 VSS.t428 sg13_lv_nmos ad=79.8f pd=0.8u as=0 ps=0 w=0.42u l=1u
X2561 sg13g2_nor3_1_0.Y sg13g2_nand2_2_0.Y VSS.t146 VSS.t274 sg13_lv_nmos ad=0.1694p pd=1.21u as=0.1463p ps=1.15u w=0.77u l=0.13u
X2562 VSS.t1611 VDD VSS.t1613 VSS.t1612 sg13_lv_nmos ad=79.8f pd=0.8u as=0 ps=0 w=0.42u l=1u
X2563 VSS.t1596 VDD VSS.t1595 VSS.t1594 sg13_lv_nmos ad=0.1428p pd=1.52u as=0 ps=0 w=0.42u l=1u
X2564 VSS.t2505 VDD VSS.t2504 VSS.t2503 sg13_lv_nmos ad=0.1428p pd=1.52u as=0 ps=0 w=0.42u l=1u
X2565 VDD VSS.t664 VDD VDD sg13_lv_pmos ad=0.19p pd=1.38u as=0 ps=0 w=1u l=1u
X2566 VDD VSS.t1093 VDD VDD sg13_lv_pmos ad=0.34p pd=2.68u as=0 ps=0 w=1u l=1u
X2567 VSS.t1044 VDD VSS.t1043 VSS.t1042 sg13_lv_nmos ad=0.1428p pd=1.52u as=0 ps=0 w=0.42u l=1u
X2568 VDD VSS.t908 VDD VDD sg13_lv_pmos ad=0.34p pd=2.68u as=0 ps=0 w=1u l=1u
X2569 VSS.t1341 VDD VSS.t1342 VSS.t305 sg13_lv_nmos ad=79.8f pd=0.8u as=0 ps=0 w=0.42u l=1u
X2570 VSS.t2950 VDD VSS.t2820 VSS.t2710 sg13_lv_nmos ad=79.8f pd=0.8u as=0 ps=0 w=0.42u l=1u
X2571 VDD VSS.t2 VDD VDD sg13_lv_pmos ad=0.34p pd=2.68u as=0 ps=0 w=1u l=1u
X2572 VDD VSS.t1276 VDD VDD sg13_lv_pmos ad=0.34p pd=2.68u as=0 ps=0 w=1u l=1u
X2573 VDD VSS.t2999 VDD VDD sg13_lv_pmos ad=0.34p pd=2.68u as=0 ps=0 w=1u l=1u
X2574 VDD VSS.t378 VDD VDD sg13_lv_pmos ad=0.34p pd=2.68u as=0 ps=0 w=1u l=1u
X2575 VSS.t1928 VDD VSS.t1927 VSS.t1926 sg13_lv_nmos ad=0.1428p pd=1.52u as=0 ps=0 w=0.42u l=1u
X2576 VSS.t693 VDD VSS.t690 VSS.t692 sg13_lv_nmos ad=0.1428p pd=1.52u as=0 ps=0 w=0.42u l=1u
X2577 VSS.t1104 VDD VSS.t1106 VSS.t1105 sg13_lv_nmos ad=79.8f pd=0.8u as=0 ps=0 w=0.42u l=1u
X2578 VDD VSS.t1284 VDD VDD sg13_lv_pmos ad=0.19p pd=1.38u as=0 ps=0 w=1u l=1u
X2579 VDD VSS.t1521 VDD VDD sg13_lv_pmos ad=0.34p pd=2.68u as=0 ps=0 w=1u l=1u
X2580 VDD VSS.t2793 VDD VDD sg13_lv_pmos ad=0.19p pd=1.38u as=0 ps=0 w=1u l=1u
X2581 VSS.t3020 VDD VSS.t3019 VSS.t3018 sg13_lv_nmos ad=0.1428p pd=1.52u as=0 ps=0 w=0.42u l=1u
X2582 sg13g2_buf_16_1.X a_16078_14484# VSS.t109 VSS.t37 sg13_lv_nmos ad=0.1406p pd=1.12u as=0.1406p ps=1.12u w=0.74u l=0.13u
X2583 VSS.t2470 VDD VSS.t2469 VSS.t2468 sg13_lv_nmos ad=0.1428p pd=1.52u as=0 ps=0 w=0.42u l=1u
X2584 VSS.t2083 VDD VSS.t2085 VSS.t2084 sg13_lv_nmos ad=79.8f pd=0.8u as=0 ps=0 w=0.42u l=1u
X2585 VSS.t622 VDD VSS.t624 VSS.t623 sg13_lv_nmos ad=79.8f pd=0.8u as=0 ps=0 w=0.42u l=1u
X2586 VDD VSS.t971 VDD VDD sg13_lv_pmos ad=0.19p pd=1.38u as=0 ps=0 w=1u l=1u
X2587 VSS.t1360 VDD VSS.t1361 VSS.t305 sg13_lv_nmos ad=79.8f pd=0.8u as=0 ps=0 w=0.42u l=1u
X2588 VDD VSS.t1555 VDD VDD sg13_lv_pmos ad=0.34p pd=2.68u as=0 ps=0 w=1u l=1u
X2589 VDD VSS.t2767 VDD VDD sg13_lv_pmos ad=0.34p pd=2.68u as=0 ps=0 w=1u l=1u
X2590 a_13476_14922# sg13g2_dfrbpq_1_3.D a_13382_14922# VSS.t88 sg13_lv_nmos ad=60.89999f pd=0.71u as=0.1428p ps=1.52u w=0.42u l=0.13u
X2591 VSS.t2782 VDD VSS.t2782 VSS.t2710 sg13_lv_nmos ad=0.1428p pd=1.52u as=0 ps=0 w=0.42u l=1u
X2592 VDD VSS.t487 VDD VDD sg13_lv_pmos ad=0.19p pd=1.38u as=0 ps=0 w=1u l=1u
X2593 VSS.t2535 VDD VSS.t2537 VSS.t2536 sg13_lv_nmos ad=79.8f pd=0.8u as=0 ps=0 w=0.42u l=1u
X2594 VDD VSS.t1690 VDD VDD sg13_lv_pmos ad=0.34p pd=2.68u as=0 ps=0 w=1u l=1u
X2595 VDD VSS.t554 VDD VDD sg13_lv_pmos ad=0.19p pd=1.38u as=0 ps=0 w=1u l=1u
X2596 VSS.t1581 VDD VSS.t1580 VSS.t1579 sg13_lv_nmos ad=0.1428p pd=1.52u as=0 ps=0 w=0.42u l=1u
X2597 VSS.t2490 VDD VSS.t2489 VSS.t2488 sg13_lv_nmos ad=0.1428p pd=1.52u as=0 ps=0 w=0.42u l=1u
X2598 VSS.t889 VDD VSS.t888 VSS.t887 sg13_lv_nmos ad=0.1428p pd=1.52u as=0 ps=0 w=0.42u l=1u
X2599 VDD VSS.t2110 VDD VDD sg13_lv_pmos ad=0.19p pd=1.38u as=0 ps=0 w=1u l=1u
X2600 VSS.t1119 VDD VSS.t1121 VSS.t1120 sg13_lv_nmos ad=79.8f pd=0.8u as=0 ps=0 w=0.42u l=1u
X2601 VDD VSS.t1608 VDD VDD sg13_lv_pmos ad=0.19p pd=1.38u as=0 ps=0 w=1u l=1u
X2602 VSS.t89 a_12335_14845# a_13002_14484# VSS.t88 sg13_lv_nmos ad=0.1406p pd=1.12u as=0.2516p ps=2.16u w=0.74u l=0.13u
X2603 VDD VSS.t1267 VDD VDD sg13_lv_pmos ad=0.34p pd=2.68u as=0 ps=0 w=1u l=1u
X2604 VDD VSS.t2833 VDD VDD sg13_lv_pmos ad=0.34p pd=2.68u as=0 ps=0 w=1u l=1u
X2605 VDD VSS.t2062 VDD VDD sg13_lv_pmos ad=0.34p pd=2.68u as=0 ps=0 w=1u l=1u
X2606 VSS.t545 VDD VSS.t545 VSS.t596 sg13_lv_nmos ad=0.1428p pd=1.52u as=0 ps=0 w=0.42u l=1u
X2607 VSS.t1556 VDD VSS.t1558 VSS.t1557 sg13_lv_nmos ad=79.8f pd=0.8u as=0 ps=0 w=0.42u l=1u
X2608 VSS.t2776 VDD VSS.t2775 VSS.t2710 sg13_lv_nmos ad=0.1428p pd=1.52u as=0 ps=0 w=0.42u l=1u
X2609 VDD VSS.t1259 VDD VDD sg13_lv_pmos ad=0.34p pd=2.68u as=0 ps=0 w=1u l=1u
X2610 VSS.t306 reset_n_i a_1192_9948# VSS.t305 sg13_lv_nmos ad=0.14875p pd=1.16u as=0.187p ps=1.78u w=0.55u l=0.13u
X2611 VDD VSS.t1126 VDD VDD sg13_lv_pmos ad=0.19p pd=1.38u as=0 ps=0 w=1u l=1u
X2612 VDD VSS.t1296 VDD VDD sg13_lv_pmos ad=0.19p pd=1.38u as=0 ps=0 w=1u l=1u
X2613 VSS.t2118 VDD VSS.t2120 VSS.t2119 sg13_lv_nmos ad=79.8f pd=0.8u as=0 ps=0 w=0.42u l=1u
X2614 VDD VSS.t2075 VDD VDD sg13_lv_pmos ad=0.19p pd=1.38u as=0 ps=0 w=1u l=1u
X2615 VDD VSS.t676 VDD VDD sg13_lv_pmos ad=0.34p pd=2.68u as=0 ps=0 w=1u l=1u
X2616 VDD VSS.t938 VDD VDD sg13_lv_pmos ad=0.34p pd=2.68u as=0 ps=0 w=1u l=1u
X2617 VSS.t2958 VDD VSS.t2826 VSS.t2710 sg13_lv_nmos ad=0.1428p pd=1.52u as=0 ps=0 w=0.42u l=1u
X2618 VDD VSS.t2429 VDD VDD sg13_lv_pmos ad=0.34p pd=2.68u as=0 ps=0 w=1u l=1u
X2619 VSS.t2330 VDD VSS.t2332 VSS.t2331 sg13_lv_nmos ad=79.8f pd=0.8u as=0 ps=0 w=0.42u l=1u
X2620 VDD VSS.t1575 VDD VDD sg13_lv_pmos ad=0.34p pd=2.68u as=0 ps=0 w=1u l=1u
X2621 VDD VSS.t1748 VDD VDD sg13_lv_pmos ad=0.19p pd=1.38u as=0 ps=0 w=1u l=1u
X2622 VSS.t1621 VDD VSS.t1620 VSS.t1619 sg13_lv_nmos ad=0.1428p pd=1.52u as=0 ps=0 w=0.42u l=1u
X2623 VSS.t2038 VDD VSS.t2037 VSS.t2036 sg13_lv_nmos ad=0.1428p pd=1.52u as=0 ps=0 w=0.42u l=1u
X2624 VDD VSS.t540 VDD VDD sg13_lv_pmos ad=0.34p pd=2.68u as=0 ps=0 w=1u l=1u
X2625 VDD VSS.t2743 VDD VDD sg13_lv_pmos ad=0.34p pd=2.68u as=0 ps=0 w=1u l=1u
X2626 VDD VSS.t1001 VDD VDD sg13_lv_pmos ad=0.19p pd=1.38u as=0 ps=0 w=1u l=1u
X2627 VSS.t1044 VDD VSS.t1043 VSS.t1042 sg13_lv_nmos ad=0.1428p pd=1.52u as=0 ps=0 w=0.42u l=1u
X2628 VDD VSS.t2437 VDD VDD sg13_lv_pmos ad=0.19p pd=1.38u as=0 ps=0 w=1u l=1u
X2629 VDD VSS.t2130 VDD VDD sg13_lv_pmos ad=0.19p pd=1.38u as=0 ps=0 w=1u l=1u
X2630 VSS.t564 VDD VSS.t564 VSS.t612 sg13_lv_nmos ad=0.1428p pd=1.52u as=0 ps=0 w=0.42u l=1u
X2631 a_18468_14040# a_18442_13945# VSS.t243 VSS.t242 sg13_lv_nmos ad=0.2516p pd=2.16u as=0.1626p ps=1.415u w=0.74u l=0.13u
X2632 VSS.t1089 VDD VSS.t1088 VSS.t1087 sg13_lv_nmos ad=0.1428p pd=1.52u as=0 ps=0 w=0.42u l=1u
X2633 a_2733_14832# sg13g2_buf_1_9.X VDD VDD sg13_lv_pmos ad=0.1596p pd=1.22u as=0.2856p ps=2.36u w=0.84u l=0.13u
X2634 VSS.t1504 VDD VSS.t1368 VSS.t305 sg13_lv_nmos ad=79.8f pd=0.8u as=0 ps=0 w=0.42u l=1u
X2635 VSS.t1776 VDD VSS.t1775 VSS.t1774 sg13_lv_nmos ad=0.1428p pd=1.52u as=0 ps=0 w=0.42u l=1u
X2636 VSS.t25 sg13g2_buf_1_9.X.t4 a_24427_15280# VSS.t3 sg13_lv_nmos ad=0.1331p pd=1.12u as=0.1216p ps=1.02u w=0.64u l=0.13u
X2637 VSS.t2942 VDD VSS.t2812 VSS.t2710 sg13_lv_nmos ad=79.8f pd=0.8u as=0 ps=0 w=0.42u l=1u
X2638 VDD VSS.t2750 VDD VDD sg13_lv_pmos ad=0.19p pd=1.38u as=0 ps=0 w=1u l=1u
X2639 VDD VSS.t564 VDD VDD sg13_lv_pmos ad=0.34p pd=2.68u as=0 ps=0 w=1u l=1u
X2640 a_25668_14488# a_26187_14495# a_26927_14845# VSS.t283 sg13_lv_nmos ad=0.3473p pd=2.71u as=0.12665p ps=1.145u w=0.74u l=0.13u
X2641 VSS.t3080 VDD VSS.t3079 VSS.t3078 sg13_lv_nmos ad=0.1428p pd=1.52u as=0 ps=0 w=0.42u l=1u
X2642 VSS.t2455 VDD VSS.t2457 VSS.t2456 sg13_lv_nmos ad=79.8f pd=0.8u as=0 ps=0 w=0.42u l=1u
X2643 VSS.t545 VDD VSS.t545 VSS.t546 sg13_lv_nmos ad=0.1428p pd=1.52u as=0 ps=0 w=0.42u l=1u
X2644 VDD VSS.t1350 VDD VDD sg13_lv_pmos ad=0.34p pd=2.68u as=0 ps=0 w=1u l=1u
X2645 VSS.t1541 VDD VSS.t1543 VSS.t1542 sg13_lv_nmos ad=79.8f pd=0.8u as=0 ps=0 w=0.42u l=1u
X2646 VSS.t1104 VDD VSS.t1106 VSS.t1105 sg13_lv_nmos ad=79.8f pd=0.8u as=0 ps=0 w=0.42u l=1u
X2647 VSS.t1290 VDD VSS.t1291 VSS.t305 sg13_lv_nmos ad=79.8f pd=0.8u as=0 ps=0 w=0.42u l=1u
X2648 VDD VSS.t1553 VDD VDD sg13_lv_pmos ad=0.19p pd=1.38u as=0 ps=0 w=1u l=1u
X2649 VDD VSS.t2462 VDD VDD sg13_lv_pmos ad=0.19p pd=1.38u as=0 ps=0 w=1u l=1u
X2650 VSS.t700 VDD VSS.t700 VSS.t703 sg13_lv_nmos ad=79.8f pd=0.8u as=0 ps=0 w=0.42u l=1u
X2651 VDD VSS.t901 VDD VDD sg13_lv_pmos ad=0.19p pd=1.38u as=0 ps=0 w=1u l=1u
X2652 VSS.t1386 VDD VSS.t1387 VSS.t305 sg13_lv_nmos ad=79.8f pd=0.8u as=0 ps=0 w=0.42u l=1u
X2653 VSS.t2350 VDD VSS.t2352 VSS.t2351 sg13_lv_nmos ad=79.8f pd=0.8u as=0 ps=0 w=0.42u l=1u
X2654 VDD VSS.t1016 VDD VDD sg13_lv_pmos ad=0.19p pd=1.38u as=0 ps=0 w=1u l=1u
X2655 VDD VSS.t1377 VDD VDD sg13_lv_pmos ad=0.34p pd=2.68u as=0 ps=0 w=1u l=1u
X2656 VSS.t2068 VDD VSS.t2070 VSS.t2069 sg13_lv_nmos ad=79.8f pd=0.8u as=0 ps=0 w=0.42u l=1u
X2657 VSS.t569 VDD VSS.t569 VSS.t618 sg13_lv_nmos ad=0.1428p pd=1.52u as=0 ps=0 w=0.42u l=1u
X2658 VSS.t2809 VDD VSS.t2810 VSS.t2710 sg13_lv_nmos ad=79.8f pd=0.8u as=0 ps=0 w=0.42u l=1u
X2659 VDD VSS.t2587 VDD VDD sg13_lv_pmos ad=0.19p pd=1.38u as=0 ps=0 w=1u l=1u
X2660 VSS.t1571 VDD VSS.t1570 VSS.t1569 sg13_lv_nmos ad=0.1428p pd=1.52u as=0 ps=0 w=0.42u l=1u
X2661 VDD VSS.t2760 VDD VDD sg13_lv_pmos ad=0.34p pd=2.68u as=0 ps=0 w=1u l=1u
X2662 VDD VSS.t700 VDD VDD sg13_lv_pmos ad=0.19p pd=1.38u as=0 ps=0 w=1u l=1u
X2663 VDD VSS.t1302 VDD VDD sg13_lv_pmos ad=0.34p pd=2.68u as=0 ps=0 w=1u l=1u
X2664 VDD VSS.t2810 VDD VDD sg13_lv_pmos ad=0.34p pd=2.68u as=0 ps=0 w=1u l=1u
X2665 VDD VSS.t2087 VDD VDD sg13_lv_pmos ad=0.34p pd=2.68u as=0 ps=0 w=1u l=1u
X2666 VSS.t1119 VDD VSS.t1121 VSS.t1120 sg13_lv_nmos ad=79.8f pd=0.8u as=0 ps=0 w=0.42u l=1u
X2667 VDD VSS.t1359 VDD VDD sg13_lv_pmos ad=0.34p pd=2.68u as=0 ps=0 w=1u l=1u
X2668 VSS.t1566 VDD VSS.t1565 VSS.t1564 sg13_lv_nmos ad=0.1428p pd=1.52u as=0 ps=0 w=0.42u l=1u
X2669 VSS.t2475 VDD VSS.t2474 VSS.t2473 sg13_lv_nmos ad=0.1428p pd=1.52u as=0 ps=0 w=0.42u l=1u
X2670 VSS.t309 VDD VSS.t309 VSS.t788 sg13_lv_nmos ad=79.8f pd=0.8u as=0 ps=0 w=0.42u l=1u
X2671 VDD VSS.t1770 VDD VDD sg13_lv_pmos ad=0.34p pd=2.68u as=0 ps=0 w=1u l=1u
X2672 VSS.t2934 VDD VSS.t2804 VSS.t2710 sg13_lv_nmos ad=79.8f pd=0.8u as=0 ps=0 w=0.42u l=1u
X2673 VDD VSS.t16 VDD VDD sg13_lv_pmos ad=0.34p pd=2.68u as=0 ps=0 w=1u l=1u
X2674 VDD VSS.t3004 VDD VDD sg13_lv_pmos ad=0.34p pd=2.68u as=0 ps=0 w=1u l=1u
X2675 VDD VSS.t2047 VDD VDD sg13_lv_pmos ad=0.34p pd=2.68u as=0 ps=0 w=1u l=1u
X2676 VSS.t766 VDD VSS.t671 VSS.t767 sg13_lv_nmos ad=79.8f pd=0.8u as=0 ps=0 w=0.42u l=1u
X2677 VSS.t979 VDD VSS.t978 VSS.t977 sg13_lv_nmos ad=0.1428p pd=1.52u as=0 ps=0 w=0.42u l=1u
X2678 VSS.t2390 VDD VSS.t2392 VSS.t2391 sg13_lv_nmos ad=79.8f pd=0.8u as=0 ps=0 w=0.42u l=1u
X2679 VDD VSS.t2382 VDD VDD sg13_lv_pmos ad=0.19p pd=1.38u as=0 ps=0 w=1u l=1u
X2680 VDD VSS.t3177 VDD VDD sg13_lv_pmos ad=0.19p pd=1.38u as=0 ps=0 w=1u l=1u
X2681 a_13956_14909# a_13668_14488# a_13894_14909# VSS.t90 sg13_lv_nmos ad=0.1428p pd=1.52u as=37.8f ps=0.6u w=0.42u l=0.13u
X2682 a_19113_14531# a_18756_14488# VDD VDD sg13_lv_pmos ad=63f pd=0.72u as=0.1563p ps=1.22u w=0.42u l=0.13u
X2683 VDD VSS.t167 VDD VDD sg13_lv_pmos ad=0.19p pd=1.38u as=0 ps=0 w=1u l=1u
X2684 VSS.t2950 VDD VSS.t2818 VSS.t2710 sg13_lv_nmos ad=0.1428p pd=1.52u as=0 ps=0 w=0.42u l=1u
X2685 VDD VSS.t2773 VDD VDD sg13_lv_pmos ad=0.34p pd=2.68u as=0 ps=0 w=1u l=1u
X2686 VDD VSS.t2414 VDD VDD sg13_lv_pmos ad=0.34p pd=2.68u as=0 ps=0 w=1u l=1u
X2687 VDD VSS.t983 VDD VDD sg13_lv_pmos ad=0.34p pd=2.68u as=0 ps=0 w=1u l=1u
X2688 VDD VSS.t1560 VDD VDD sg13_lv_pmos ad=0.34p pd=2.68u as=0 ps=0 w=1u l=1u
X2689 VSS.t7 a_26085_14495# a_26187_14495# VSS.t6 sg13_lv_nmos ad=5.1665p pd=33.355u as=0.2516p ps=2.16u w=0.74u l=0.13u
X2690 VSS.t854 VDD VSS.t853 VSS.t852 sg13_lv_nmos ad=0.1428p pd=1.52u as=0 ps=0 w=0.42u l=1u
X2691 VSS.t2198 VDD VSS.t2200 VSS.t2199 sg13_lv_nmos ad=79.8f pd=0.8u as=0 ps=0 w=0.42u l=1u
X2692 sg13g2_dfrbpq_1_5.RESET_B a_25374_15934# VDD VDD sg13_lv_pmos ad=0.3927p pd=2.99u as=2.4406p ps=15.34u w=1.155u l=0.13u
X2693 VDD VSS.t906 VDD VDD sg13_lv_pmos ad=0.19p pd=1.38u as=0 ps=0 w=1u l=1u
X2694 VDD VSS.t690 VDD VDD sg13_lv_pmos ad=0.34p pd=2.68u as=0 ps=0 w=1u l=1u
X2695 VSS.t2766 VDD VSS.t2766 VSS.t2710 sg13_lv_nmos ad=0.1428p pd=1.52u as=0 ps=0 w=0.42u l=1u
X2696 VDD VSS.t417 VDD VDD sg13_lv_pmos ad=0.34p pd=2.68u as=0 ps=0 w=1u l=1u
X2697 a_6477_14832# sg13g2_buf_1_9.X VDD VDD sg13_lv_pmos ad=0.1596p pd=1.22u as=0.2856p ps=2.36u w=0.84u l=0.13u
X2698 sg13g2_or3_1_0.X a_16681_13726# VSS.t129 VSS.t286 sg13_lv_nmos ad=0.2516p pd=2.16u as=0.13395p ps=1.12u w=0.74u l=0.13u
X2699 VDD VSS.t487 VDD VDD sg13_lv_pmos ad=0.34p pd=2.68u as=0 ps=0 w=1u l=1u
X2700 VSS.t1089 VDD VSS.t1088 VSS.t1087 sg13_lv_nmos ad=0.1428p pd=1.52u as=0 ps=0 w=0.42u l=1u
X2701 VDD VSS.t1750 VDD VDD sg13_lv_pmos ad=0.34p pd=2.68u as=0 ps=0 w=1u l=1u
X2702 VDD a_12308_15202# sg13g2_dfrbpq_1_2.CLK VDD sg13_lv_pmos ad=0.2128p pd=1.5u as=0.2128p ps=1.5u w=1.12u l=0.13u
X2703 VDD VSS.t858 VDD VDD sg13_lv_pmos ad=0.34p pd=2.68u as=0 ps=0 w=1u l=1u
X2704 VDD VSS.t1613 VDD VDD sg13_lv_pmos ad=0.19p pd=1.38u as=0 ps=0 w=1u l=1u
X2705 VSS.t1249 VDD VSS.t1250 VSS.t305 sg13_lv_nmos ad=79.8f pd=0.8u as=0 ps=0 w=0.42u l=1u
X2706 VDD VSS.t1270 VDD VDD sg13_lv_pmos ad=0.34p pd=2.68u as=0 ps=0 w=1u l=1u
X2707 VDD VSS.t2835 VDD VDD sg13_lv_pmos ad=0.34p pd=2.68u as=0 ps=0 w=1u l=1u
X2708 VSS.t423 VDD VSS.t425 VSS.t424 sg13_lv_nmos ad=79.8f pd=0.8u as=0 ps=0 w=0.42u l=1u
X2709 VDD VSS.t714 VDD VDD sg13_lv_pmos ad=0.19p pd=1.38u as=0 ps=0 w=1u l=1u
X2710 VSS.t1286 VDD VSS.t1285 VSS.t305 sg13_lv_nmos ad=0.1428p pd=1.52u as=0 ps=0 w=0.42u l=1u
X2711 VSS.t3065 VDD VSS.t3064 VSS.t3063 sg13_lv_nmos ad=0.1428p pd=1.52u as=0 ps=0 w=0.42u l=1u
X2712 VDD VSS.t1376 VDD VDD sg13_lv_pmos ad=0.34p pd=2.68u as=0 ps=0 w=1u l=1u
X2713 VSS.t894 VDD VSS.t893 VSS.t892 sg13_lv_nmos ad=0.1428p pd=1.52u as=0 ps=0 w=0.42u l=1u
X2714 VSS.t357 a_12524_15960# counter_value_o[2] VSS.t369 sg13_lv_nmos ad=0.14875p pd=1.16u as=0.2886p ps=2.26u w=0.74u l=0.13u
X2715 VDD a_16078_14484# sg13g2_buf_16_1.X VDD sg13_lv_pmos ad=0.2128p pd=1.5u as=0.2128p ps=1.5u w=1.12u l=0.13u
X2716 VSS.t1413 VDD VSS.t1254 VSS.t305 sg13_lv_nmos ad=79.8f pd=0.8u as=0 ps=0 w=0.42u l=1u
X2717 VDD VSS.t2919 VDD VDD sg13_lv_pmos ad=0.19p pd=1.38u as=0 ps=0 w=1u l=1u
X2718 VSS.t2335 VDD VSS.t2337 VSS.t2336 sg13_lv_nmos ad=79.8f pd=0.8u as=0 ps=0 w=0.42u l=1u
X2719 VSS.t2460 VDD VSS.t2459 VSS.t2458 sg13_lv_nmos ad=0.1428p pd=1.52u as=0 ps=0 w=0.42u l=1u
X2720 VSS.t1009 VDD VSS.t1008 VSS.t1007 sg13_lv_nmos ad=0.1428p pd=1.52u as=0 ps=0 w=0.42u l=1u
X2721 sg13g2_dfrbpq_1_7.CLK a_19630_15238# VDD VDD sg13_lv_pmos ad=0.2128p pd=1.5u as=0.2128p ps=1.5u w=1.12u l=0.13u
X2722 VDD VSS.t873 VDD VDD sg13_lv_pmos ad=0.34p pd=2.68u as=0 ps=0 w=1u l=1u
X2723 VDD VSS.t1061 VDD VDD sg13_lv_pmos ad=0.19p pd=1.38u as=0 ps=0 w=1u l=1u
X2724 VSS.t1304 VDD VSS.t1303 VSS.t305 sg13_lv_nmos ad=0.1428p pd=1.52u as=0 ps=0 w=0.42u l=1u
X2725 VDD VSS.t1545 VDD VDD sg13_lv_pmos ad=0.34p pd=2.68u as=0 ps=0 w=1u l=1u
X2726 VSS.t2801 VDD VSS.t2802 VSS.t2710 sg13_lv_nmos ad=79.8f pd=0.8u as=0 ps=0 w=0.42u l=1u
X2727 VSS.t1626 VDD VSS.t1625 VSS.t1624 sg13_lv_nmos ad=0.1428p pd=1.52u as=0 ps=0 w=0.42u l=1u
X2728 VSS.t2183 VDD VSS.t2185 VSS.t2184 sg13_lv_nmos ad=79.8f pd=0.8u as=0 ps=0 w=0.42u l=1u
X2729 VDD VSS.t394 VDD VDD sg13_lv_pmos ad=0.19p pd=1.38u as=0 ps=0 w=1u l=1u
X2730 VSS.t2777 VDD VSS.t2776 VSS.t2710 sg13_lv_nmos ad=0.1428p pd=1.52u as=0 ps=0 w=0.42u l=1u
X2731 sg13g2_dlygate4sd3_1_2.A a_5322_15532# VDD VDD sg13_lv_pmos ad=0.3808p pd=2.92u as=0.2128p ps=1.5u w=1.12u l=0.13u
X2732 VDD VSS.t724 VDD VDD sg13_lv_pmos ad=0.19p pd=1.38u as=0 ps=0 w=1u l=1u
X2733 VDD VSS.t2746 VDD VDD sg13_lv_pmos ad=0.34p pd=2.68u as=0 ps=0 w=1u l=1u
X2734 VSS.t763 VDD VSS.t16 VSS.t762 sg13_lv_nmos ad=0.1428p pd=1.52u as=0 ps=0 w=0.42u l=1u
X2735 VSS.t719 VDD VSS.t719 VSS.t835 sg13_lv_nmos ad=0.1428p pd=1.52u as=0 ps=0 w=0.42u l=1u
X2736 VDD VSS.t1294 VDD VDD sg13_lv_pmos ad=0.34p pd=2.68u as=0 ps=0 w=1u l=1u
X2737 VDD VSS.t2802 VDD VDD sg13_lv_pmos ad=0.34p pd=2.68u as=0 ps=0 w=1u l=1u
X2738 VDD VSS.t2072 VDD VDD sg13_lv_pmos ad=0.34p pd=2.68u as=0 ps=0 w=1u l=1u
X2739 VDD VSS.t2442 VDD VDD sg13_lv_pmos ad=0.19p pd=1.38u as=0 ps=0 w=1u l=1u
X2740 a_7450_14448# sg13g2_xnor2_1_0.Y VSS.t30 VSS.t11 sg13_lv_nmos ad=0.1428p pd=1.52u as=79.8f ps=0.8u w=0.42u l=0.13u
X2741 VSS.t622 VDD VSS.t624 VSS.t623 sg13_lv_nmos ad=79.8f pd=0.8u as=0 ps=0 w=0.42u l=1u
X2742 VSS.t909 VDD VSS.t908 VSS.t907 sg13_lv_nmos ad=0.1428p pd=1.52u as=0 ps=0 w=0.42u l=1u
X2743 VDD VSS.t2100 VDD VDD sg13_lv_pmos ad=0.19p pd=1.38u as=0 ps=0 w=1u l=1u
X2744 VDD a_12308_15202# sg13g2_dfrbpq_1_2.CLK VDD sg13_lv_pmos ad=0.2128p pd=1.5u as=0.2128p ps=1.5u w=1.12u l=0.13u
X2745 VSS.t1339 VDD VSS.t1340 VSS.t305 sg13_lv_nmos ad=79.8f pd=0.8u as=0 ps=0 w=0.42u l=1u
X2746 VSS.t1420 VDD VSS.t1263 VSS.t305 sg13_lv_nmos ad=79.8f pd=0.8u as=0 ps=0 w=0.42u l=1u
X2747 VDD VSS.t936 VDD VDD sg13_lv_pmos ad=0.19p pd=1.38u as=0 ps=0 w=1u l=1u
X2748 VSS.t979 VDD VSS.t978 VSS.t977 sg13_lv_nmos ad=0.1428p pd=1.52u as=0 ps=0 w=0.42u l=1u
X2749 VSS.t2926 VDD VSS.t2796 VSS.t2710 sg13_lv_nmos ad=79.8f pd=0.8u as=0 ps=0 w=0.42u l=1u
X2750 VDD VSS.t1755 VDD VDD sg13_lv_pmos ad=0.34p pd=2.68u as=0 ps=0 w=1u l=1u
X2751 VSS.t3085 VDD VSS.t3084 VSS.t3083 sg13_lv_nmos ad=0.1428p pd=1.52u as=0 ps=0 w=0.42u l=1u
X2752 VDD VSS.t2989 VDD VDD sg13_lv_pmos ad=0.34p pd=2.68u as=0 ps=0 w=1u l=1u
X2753 VSS.t2555 VDD VSS.t2554 VSS.t2553 sg13_lv_nmos ad=0.1428p pd=1.52u as=0 ps=0 w=0.42u l=1u
X2754 VDD VSS.t32 VDD VDD sg13_lv_pmos ad=0.34p pd=2.68u as=0 ps=0 w=1u l=1u
X2755 VDD VSS.t1101 VDD VDD sg13_lv_pmos ad=0.19p pd=1.38u as=0 ps=0 w=1u l=1u
X2756 VDD VSS.t1558 VDD VDD sg13_lv_pmos ad=0.19p pd=1.38u as=0 ps=0 w=1u l=1u
X2757 VSS.t2846 VDD VSS.t2847 VSS.t2710 sg13_lv_nmos ad=79.8f pd=0.8u as=0 ps=0 w=0.42u l=1u
X2758 VDD VSS.t2467 VDD VDD sg13_lv_pmos ad=0.19p pd=1.38u as=0 ps=0 w=1u l=1u
X2759 VDD clock_i a_16078_14484# VDD sg13_lv_pmos ad=0.2128p pd=1.5u as=0.2128p ps=1.5u w=1.12u l=0.13u
X2760 VSS.t700 VDD VSS.t700 VSS.t702 sg13_lv_nmos ad=0.1428p pd=1.52u as=0 ps=0 w=0.42u l=1u
X2761 VSS.t2 VDD VSS.t2 VSS.t776 sg13_lv_nmos ad=0.1428p pd=1.52u as=0 ps=0 w=0.42u l=1u
X2762 VDD a_12592_14726# a_12537_14607# VDD sg13_lv_pmos ad=2.75157p pd=17.885u as=93.45f ps=0.865u w=0.42u l=0.13u
X2763 VSS.t854 VDD VSS.t853 VSS.t852 sg13_lv_nmos ad=0.1428p pd=1.52u as=0 ps=0 w=0.42u l=1u
X2764 VDD VSS.t1028 VDD VDD sg13_lv_pmos ad=0.34p pd=2.68u as=0 ps=0 w=1u l=1u
X2765 VSS.t1318 VDD VSS.t1317 VSS.t305 sg13_lv_nmos ad=0.1428p pd=1.52u as=0 ps=0 w=0.42u l=1u
X2766 VSS.t2073 VDD VSS.t2075 VSS.t2074 sg13_lv_nmos ad=79.8f pd=0.8u as=0 ps=0 w=0.42u l=1u
X2767 a_15184_14726# sg13g2_dfrbpq_1_3.RESET_B VDD VDD sg13_lv_pmos ad=79.8f pd=0.8u as=2.75157p ps=17.885u w=0.42u l=0.13u
X2768 VSS.t2793 VDD VSS.t2794 VSS.t2710 sg13_lv_nmos ad=79.8f pd=0.8u as=0 ps=0 w=0.42u l=1u
X2769 VSS.t1576 VDD VSS.t1575 VSS.t1574 sg13_lv_nmos ad=0.1428p pd=1.52u as=0 ps=0 w=0.42u l=1u
X2770 sg13g2_dfrbpq_1_7.CLK a_19630_15238# VDD VDD sg13_lv_pmos ad=0.2128p pd=1.5u as=0.2128p ps=1.5u w=1.12u l=0.13u
X2771 VDD VSS.t521 VDD VDD sg13_lv_pmos ad=0.34p pd=2.68u as=0 ps=0 w=1u l=1u
X2772 VDD VSS.t661 VDD VDD sg13_lv_pmos ad=0.34p pd=2.68u as=0 ps=0 w=1u l=1u
X2773 VDD VSS.t564 VDD VDD sg13_lv_pmos ad=0.19p pd=1.38u as=0 ps=0 w=1u l=1u
X2774 VDD a_14927_14845# a_15594_14484# VDD sg13_lv_pmos ad=0.2128p pd=1.5u as=0.3864p ps=2.93u w=1.12u l=0.13u
X2775 VSS.t1746 VDD VSS.t1748 VSS.t1747 sg13_lv_nmos ad=79.8f pd=0.8u as=0 ps=0 w=0.42u l=1u
X2776 VSS.t2138 VDD VSS.t2137 VSS.t2136 sg13_lv_nmos ad=0.1428p pd=1.52u as=0 ps=0 w=0.42u l=1u
X2777 VDD VSS.t2092 VDD VDD sg13_lv_pmos ad=0.34p pd=2.68u as=0 ps=0 w=1u l=1u
X2778 VSS.t627 VDD VSS.t629 VSS.t628 sg13_lv_nmos ad=79.8f pd=0.8u as=0 ps=0 w=0.42u l=1u
X2779 VDD VSS.t2794 VDD VDD sg13_lv_pmos ad=0.34p pd=2.68u as=0 ps=0 w=1u l=1u
X2780 a_13382_14922# a_14187_14495# a_13642_14452# VDD sg13_lv_pmos ad=0.1428p pd=1.52u as=79.8f ps=0.8u w=0.42u l=0.13u
X2781 VDD VSS.t1091 VDD VDD sg13_lv_pmos ad=0.19p pd=1.38u as=0 ps=0 w=1u l=1u
X2782 VSS.t1322 VDD VSS.t1321 VSS.t305 sg13_lv_nmos ad=0.1428p pd=1.52u as=0 ps=0 w=0.42u l=1u
X2783 VSS.t1245 VDD VSS.t1244 VSS.t305 sg13_lv_nmos ad=0.1428p pd=1.52u as=0 ps=0 w=0.42u l=1u
X2784 VSS.t1492 VDD VSS.t1354 VSS.t305 sg13_lv_nmos ad=79.8f pd=0.8u as=0 ps=0 w=0.42u l=1u
X2785 VSS.t2320 VDD VSS.t2322 VSS.t2321 sg13_lv_nmos ad=79.8f pd=0.8u as=0 ps=0 w=0.42u l=1u
X2786 VSS.t309 VDD VSS.t238 VSS.t787 sg13_lv_nmos ad=0.1428p pd=1.52u as=0 ps=0 w=0.42u l=1u
X2787 VDD VSS.t1775 VDD VDD sg13_lv_pmos ad=0.34p pd=2.68u as=0 ps=0 w=1u l=1u
X2788 VDD VSS.t1261 VDD VDD sg13_lv_pmos ad=0.34p pd=2.68u as=0 ps=0 w=1u l=1u
X2789 VDD VSS.t2052 VDD VDD sg13_lv_pmos ad=0.34p pd=2.68u as=0 ps=0 w=1u l=1u
X2790 a_18468_14040# a_18442_13945# VDD VDD sg13_lv_pmos ad=0.34p pd=2.68u as=0.36237p ps=2.605u w=1u l=0.13u
X2791 VSS.t2395 VDD VSS.t2397 VSS.t2396 sg13_lv_nmos ad=79.8f pd=0.8u as=0 ps=0 w=0.42u l=1u
X2792 sg13g2_nor4_2_0.Y sg13g2_inv_1_1.Y VSS.t272 VSS.t7 sg13_lv_nmos ad=0.1406p pd=1.12u as=0.3293p ps=1.63u w=0.74u l=0.13u
X2793 VSS.t894 VDD VSS.t893 VSS.t892 sg13_lv_nmos ad=0.1428p pd=1.52u as=0 ps=0 w=0.42u l=1u
X2794 VDD VSS.t3182 VDD VDD sg13_lv_pmos ad=0.19p pd=1.38u as=0 ps=0 w=1u l=1u
X2795 VDD a_20272_14726# a_20217_14607# VDD sg13_lv_pmos ad=2.75157p pd=17.885u as=93.45f ps=0.865u w=0.42u l=0.13u
X2796 VSS.t1009 VDD VSS.t1008 VSS.t1007 sg13_lv_nmos ad=0.1428p pd=1.52u as=0 ps=0 w=0.42u l=1u
X2797 VSS.t1124 VDD VSS.t1126 VSS.t1125 sg13_lv_nmos ad=79.8f pd=0.8u as=0 ps=0 w=0.42u l=1u
X2798 VSS.t92 VDD VSS.t92 VSS.t492 sg13_lv_nmos ad=79.8f pd=0.8u as=0 ps=0 w=0.42u l=1u
X2799 VSS.t545 VDD VSS.t545 VSS.t598 sg13_lv_nmos ad=0.1428p pd=1.52u as=0 ps=0 w=0.42u l=1u
X2800 VSS.t642 VDD VSS.t644 VSS.t643 sg13_lv_nmos ad=79.8f pd=0.8u as=0 ps=0 w=0.42u l=1u
X2801 VSS.t2822 VDD VSS.t2821 VSS.t2710 sg13_lv_nmos ad=0.1428p pd=1.52u as=0 ps=0 w=0.42u l=1u
X2802 VDD VSS.t2758 VDD VDD sg13_lv_pmos ad=0.34p pd=2.68u as=0 ps=0 w=1u l=1u
X2803 VDD VSS.t1106 VDD VDD sg13_lv_pmos ad=0.19p pd=1.38u as=0 ps=0 w=1u l=1u
X2804 VSS.t389 VDD VSS.t391 VSS.t390 sg13_lv_nmos ad=79.8f pd=0.8u as=0 ps=0 w=0.42u l=1u
X2805 VSS.t441 VDD VSS.t441 VSS.t440 sg13_lv_nmos ad=0.1428p pd=1.52u as=0 ps=0 w=0.42u l=1u
X2806 VSS.t580 VDD VSS.t49 VSS.t579 sg13_lv_nmos ad=0.1428p pd=1.52u as=0 ps=0 w=0.42u l=1u
X2807 VDD VSS.t545 VDD VDD sg13_lv_pmos ad=0.34p pd=2.68u as=0 ps=0 w=1u l=1u
X2808 VDD VSS.t1325 VDD VDD sg13_lv_pmos ad=0.19p pd=1.38u as=0 ps=0 w=1u l=1u
X2809 VDD VSS.t2831 VDD VDD sg13_lv_pmos ad=0.19p pd=1.38u as=0 ps=0 w=1u l=1u
X2810 VSS.t2168 VDD VSS.t2170 VSS.t2169 sg13_lv_nmos ad=79.8f pd=0.8u as=0 ps=0 w=0.42u l=1u
X2811 VSS.t530 VDD VSS.t529 VSS.t528 sg13_lv_nmos ad=0.1428p pd=1.52u as=0 ps=0 w=0.42u l=1u
X2812 VSS.t1611 VDD VSS.t1610 VSS.t1609 sg13_lv_nmos ad=0.1428p pd=1.52u as=0 ps=0 w=0.42u l=1u
X2813 VDD VSS.t1570 VDD VDD sg13_lv_pmos ad=0.34p pd=2.68u as=0 ps=0 w=1u l=1u
X2814 VSS.t2769 VDD VSS.t2768 VSS.t2710 sg13_lv_nmos ad=0.1428p pd=1.52u as=0 ps=0 w=0.42u l=1u
X2815 VDD VSS.t2479 VDD VDD sg13_lv_pmos ad=0.34p pd=2.68u as=0 ps=0 w=1u l=1u
X2816 VSS.t2540 VDD VSS.t2539 VSS.t2538 sg13_lv_nmos ad=0.1428p pd=1.52u as=0 ps=0 w=0.42u l=1u
X2817 VSS.t714 VDD VSS.t714 VSS.t716 sg13_lv_nmos ad=0.1428p pd=1.52u as=0 ps=0 w=0.42u l=1u
X2818 VDD VSS.t2738 VDD VDD sg13_lv_pmos ad=0.34p pd=2.68u as=0 ps=0 w=1u l=1u
X2819 VDD VSS.t866 VDD VDD sg13_lv_pmos ad=0.19p pd=1.38u as=0 ps=0 w=1u l=1u
X2820 VSS.t909 VDD VSS.t908 VSS.t907 sg13_lv_nmos ad=0.1428p pd=1.52u as=0 ps=0 w=0.42u l=1u
X2821 VSS.t1477 VDD VSS.t1335 VSS.t305 sg13_lv_nmos ad=0.1428p pd=1.52u as=0 ps=0 w=0.42u l=1u
X2822 VSS.t2088 VDD VSS.t2087 VSS.t2086 sg13_lv_nmos ad=0.1428p pd=1.52u as=0 ps=0 w=0.42u l=1u
X2823 VSS.t1366 VDD VSS.t1367 VSS.t305 sg13_lv_nmos ad=79.8f pd=0.8u as=0 ps=0 w=0.42u l=1u
X2824 VDD VSS.t2427 VDD VDD sg13_lv_pmos ad=0.19p pd=1.38u as=0 ps=0 w=1u l=1u
X2825 VDD VSS.t2085 VDD VDD sg13_lv_pmos ad=0.19p pd=1.38u as=0 ps=0 w=1u l=1u
X2826 VSS.t554 VDD VSS.t554 VSS.t604 sg13_lv_nmos ad=0.1428p pd=1.52u as=0 ps=0 w=0.42u l=1u
X2827 VDD VSS.t1273 VDD VDD sg13_lv_pmos ad=0.34p pd=2.68u as=0 ps=0 w=1u l=1u
X2828 a_26373_15213# sg13g2_dfrbpq_1_7.CLK VSS.t7 VSS.t200 sg13_lv_nmos ad=0.2516p pd=2.16u as=4.79747p ps=30.975u w=0.74u l=0.13u
X2829 VSS.t3070 VDD VSS.t3069 VSS.t3068 sg13_lv_nmos ad=0.1428p pd=1.52u as=0 ps=0 w=0.42u l=1u
X2830 a_18665_16334# a_18789_16033# VDD VDD sg13_lv_pmos ad=0.2442p pd=2.06u as=2.4406p ps=15.34u w=0.66u l=0.13u
X2831 sg13g2_dfrbpq_1_4.D a_25974_16020# VDD VDD sg13_lv_pmos ad=0.4256p pd=3u as=0.2254p ps=1.53u w=1.12u l=0.13u
X2832 VDD VSS.t695 VDD VDD sg13_lv_pmos ad=0.19p pd=1.38u as=0 ps=0 w=1u l=1u
X2833 VSS.t1094 VDD VSS.t1093 VSS.t1092 sg13_lv_nmos ad=0.1428p pd=1.52u as=0 ps=0 w=0.42u l=1u
X2834 VDD VSS.t554 VDD VDD sg13_lv_pmos ad=0.34p pd=2.68u as=0 ps=0 w=1u l=1u
X2835 VDD VSS.t1271 VDD VDD sg13_lv_pmos ad=0.34p pd=2.68u as=0 ps=0 w=1u l=1u
X2836 VSS.t1507 VDD VSS.t1371 VSS.t305 sg13_lv_nmos ad=79.8f pd=0.8u as=0 ps=0 w=0.42u l=1u
X2837 VDD VSS.t690 VDD VDD sg13_lv_pmos ad=0.19p pd=1.38u as=0 ps=0 w=1u l=1u
X2838 VDD VSS.t958 VDD VDD sg13_lv_pmos ad=0.34p pd=2.68u as=0 ps=0 w=1u l=1u
X2839 VDD VSS.t1543 VDD VDD sg13_lv_pmos ad=0.19p pd=1.38u as=0 ps=0 w=1u l=1u
X2840 VSS.t2838 VDD VSS.t2839 VSS.t2710 sg13_lv_nmos ad=79.8f pd=0.8u as=0 ps=0 w=0.42u l=1u
X2841 VSS.t22 a_17434_15202# a_17153_15424# VSS.t21 sg13_lv_nmos ad=79.8f pd=0.8u as=0.1428p ps=1.52u w=0.42u l=0.5u
X2842 sg13g2_dlygate4sd3_1_12.A a_27882_15532# VSS.t71 VSS.t70 sg13_lv_nmos ad=0.2516p pd=2.16u as=0.1406p ps=1.12u w=0.74u l=0.13u
X2843 VSS.t724 VDD VSS.t724 VSS.t723 sg13_lv_nmos ad=0.1428p pd=1.52u as=0 ps=0 w=0.42u l=1u
X2844 VSS.t2814 VDD VSS.t2813 VSS.t2710 sg13_lv_nmos ad=0.1428p pd=1.52u as=0 ps=0 w=0.42u l=1u
X2845 VSS.t2340 VDD VSS.t2342 VSS.t2341 sg13_lv_nmos ad=79.8f pd=0.8u as=0 ps=0 w=0.42u l=1u
X2846 VSS.t77 a_25862_15996# a_25974_16020# VSS.t246 sg13_lv_nmos ad=0.1426p pd=1.16u as=0.1428p ps=1.52u w=0.42u l=0.5u
X2847 VDD VSS.t1550 VDD VDD sg13_lv_pmos ad=0.34p pd=2.68u as=0 ps=0 w=1u l=1u
X2848 VDD VSS.t1723 VDD VDD sg13_lv_pmos ad=0.19p pd=1.38u as=0 ps=0 w=1u l=1u
X2849 VSS.t1631 VDD VSS.t1630 VSS.t1629 sg13_lv_nmos ad=0.1428p pd=1.52u as=0 ps=0 w=0.42u l=1u
X2850 VSS.t1561 VDD VSS.t1560 VSS.t1559 sg13_lv_nmos ad=0.1428p pd=1.52u as=0 ps=0 w=0.42u l=1u
X2851 VDD a_10176_14523# sg13g2_and2_1_2.B VDD sg13_lv_pmos ad=0.3808p pd=2.92u as=0.2408p ps=1.55u w=1.12u l=0.13u
X2852 VDD VSS.t1021 VDD VDD sg13_lv_pmos ad=0.19p pd=1.38u as=0 ps=0 w=1u l=1u
X2853 VDD VSS.t2729 VDD VDD sg13_lv_pmos ad=0.34p pd=2.68u as=0 ps=0 w=1u l=1u
X2854 VSS.t181 a_14927_14845# a_15594_14484# VSS.t37 sg13_lv_nmos ad=0.1406p pd=1.12u as=0.2516p ps=2.16u w=0.74u l=0.13u
X2855 VDD VSS.t1297 VDD VDD sg13_lv_pmos ad=0.34p pd=2.68u as=0 ps=0 w=1u l=1u
X2856 VDD VSS.t2077 VDD VDD sg13_lv_pmos ad=0.34p pd=2.68u as=0 ps=0 w=1u l=1u
X2857 VDD VSS.t2447 VDD VDD sg13_lv_pmos ad=0.19p pd=1.38u as=0 ps=0 w=1u l=1u
X2858 VSS.t459 VDD VSS.t461 VSS.t460 sg13_lv_nmos ad=79.8f pd=0.8u as=0 ps=0 w=0.42u l=1u
X2859 VDD VSS.t2105 VDD VDD sg13_lv_pmos ad=0.19p pd=1.38u as=0 ps=0 w=1u l=1u
X2860 VSS.t35 a_16078_14484# sg13g2_buf_16_1.X VSS.t37 sg13_lv_nmos ad=0.1406p pd=1.12u as=0.1406p ps=1.12u w=0.74u l=0.13u
X2861 VSS.t123 a_16078_14484# sg13g2_buf_16_1.X VSS.t37 sg13_lv_nmos ad=0.2516p pd=2.16u as=0.1406p ps=1.12u w=0.74u l=0.13u
X2862 VSS.t1751 VDD VSS.t1750 VSS.t1749 sg13_lv_nmos ad=0.1428p pd=1.52u as=0 ps=0 w=0.42u l=1u
X2863 VDD VSS.t948 VDD VDD sg13_lv_pmos ad=0.34p pd=2.68u as=0 ps=0 w=1u l=1u
X2864 VSS.t1124 VDD VSS.t1126 VSS.t1125 sg13_lv_nmos ad=79.8f pd=0.8u as=0 ps=0 w=0.42u l=1u
X2865 VDD VSS.t1362 VDD VDD sg13_lv_pmos ad=0.34p pd=2.68u as=0 ps=0 w=1u l=1u
X2866 VSS.t2560 VDD VSS.t2559 VSS.t2558 sg13_lv_nmos ad=0.1428p pd=1.52u as=0 ps=0 w=0.42u l=1u
X2867 VDD VSS.t626 VDD VDD sg13_lv_pmos ad=0.34p pd=2.68u as=0 ps=0 w=1u l=1u
X2868 VDD VSS.t309 VDD VDD sg13_lv_pmos ad=0.34p pd=2.68u as=0 ps=0 w=1u l=1u
X2869 VDD a_32492_15960# counter_value_o[6] VDD sg13_lv_pmos ad=0.2114p pd=1.54u as=0.42p ps=2.99u w=1.12u l=0.13u
X2870 VDD VSS.t1326 VDD VDD sg13_lv_pmos ad=0.19p pd=1.38u as=0 ps=0 w=1u l=1u
X2871 VDD VSS.t2132 VDD VDD sg13_lv_pmos ad=0.34p pd=2.68u as=0 ps=0 w=1u l=1u
X2872 VSS.t984 VDD VSS.t983 VSS.t982 sg13_lv_nmos ad=0.1428p pd=1.52u as=0 ps=0 w=0.42u l=1u
X2873 VDD VSS.t3262 VDD VDD sg13_lv_pmos ad=0.19p pd=1.38u as=0 ps=0 w=1u l=1u
X2874 VSS.t2325 VDD VSS.t2327 VSS.t2326 sg13_lv_nmos ad=79.8f pd=0.8u as=0 ps=0 w=0.42u l=1u
X2875 VSS.t1306 VDD VSS.t1307 VSS.t305 sg13_lv_nmos ad=79.8f pd=0.8u as=0 ps=0 w=0.42u l=1u
X2876 VDD VSS.t2751 VDD VDD sg13_lv_pmos ad=0.34p pd=2.68u as=0 ps=0 w=1u l=1u
X2877 VSS.t2796 VDD VSS.t2797 VSS.t2710 sg13_lv_nmos ad=79.8f pd=0.8u as=0 ps=0 w=0.42u l=1u
X2878 VDD a_13966_16263# sg13g2_dlygate4sd3_1_4.X VDD sg13_lv_pmos ad=0.2254p pd=1.53u as=0.4256p ps=3u w=1.12u l=0.13u
X2879 VDD VSS.t988 VDD VDD sg13_lv_pmos ad=0.34p pd=2.68u as=0 ps=0 w=1u l=1u
X2880 VSS.t1546 VDD VSS.t1545 VSS.t1544 sg13_lv_nmos ad=0.1428p pd=1.52u as=0 ps=0 w=0.42u l=1u
X2881 a_9752_15242# sg13g2_dlygate4sd3_1_0.A a_9650_15242# VSS.t3315 sg13_lv_nmos ad=0.1406p pd=1.12u as=0.1406p ps=1.12u w=0.74u l=0.13u
X2882 VDD VSS.t1555 VDD VDD sg13_lv_pmos ad=0.34p pd=2.68u as=0 ps=0 w=1u l=1u
X2883 VDD VSS.t2464 VDD VDD sg13_lv_pmos ad=0.34p pd=2.68u as=0 ps=0 w=1u l=1u
X2884 VSS.t859 VDD VSS.t858 VSS.t857 sg13_lv_nmos ad=0.1428p pd=1.52u as=0 ps=0 w=0.42u l=1u
X2885 VDD VSS.t1288 VDD VDD sg13_lv_pmos ad=0.34p pd=2.68u as=0 ps=0 w=1u l=1u
X2886 VDD VSS.t2797 VDD VDD sg13_lv_pmos ad=0.34p pd=2.68u as=0 ps=0 w=1u l=1u
X2887 VSS.t2355 VDD VSS.t2354 VSS.t2353 sg13_lv_nmos ad=0.1428p pd=1.52u as=0 ps=0 w=0.42u l=1u
X2888 a_32492_15960# sg13g2_inv_1_1.A VDD VDD sg13_lv_pmos ad=0.2856p pd=2.36u as=0.2114p ps=1.54u w=0.84u l=0.13u
X2889 VDD VSS.t911 VDD VDD sg13_lv_pmos ad=0.19p pd=1.38u as=0 ps=0 w=1u l=1u
X2890 VSS.t2740 VDD VSS.t2741 VSS.t2710 sg13_lv_nmos ad=79.8f pd=0.8u as=0 ps=0 w=0.42u l=1u
X2891 VDD VSS.t2589 VDD VDD sg13_lv_pmos ad=0.34p pd=2.68u as=0 ps=0 w=1u l=1u
X2892 VSS.t108 clock_i a_16078_14484# VSS.t37 sg13_lv_nmos ad=0.1406p pd=1.12u as=0.1406p ps=1.12u w=0.74u l=0.13u
X2893 VSS.t285 VDD VSS.t2 VSS.t775 sg13_lv_nmos ad=79.8f pd=0.8u as=0 ps=0 w=0.42u l=1u
X2894 VSS.t16 a_9269_13726# sg13g2_buf_4_0.X VSS.t15 sg13_lv_nmos ad=0.1406p pd=1.12u as=0.1406p ps=1.12u w=0.74u l=0.13u
X2895 VSS.t1094 VDD VSS.t1093 VSS.t1092 sg13_lv_nmos ad=0.1428p pd=1.52u as=0 ps=0 w=0.42u l=1u
X2896 VSS.t1284 VDD VSS.t1283 VSS.t305 sg13_lv_nmos ad=0.1428p pd=1.52u as=0 ps=0 w=0.42u l=1u
X2897 VSS.t1315 VDD VSS.t1316 VSS.t305 sg13_lv_nmos ad=79.8f pd=0.8u as=0 ps=0 w=0.42u l=1u
X2898 VDD VSS.t1264 VDD VDD sg13_lv_pmos ad=0.34p pd=2.68u as=0 ps=0 w=1u l=1u
X2899 a_13966_16263# a_14081_16262# VDD VDD sg13_lv_pmos ad=0.34p pd=2.68u as=0.2254p ps=1.53u w=1u l=0.5u
X2900 a_16089_13723# sg13g2_xor2_1_1.A VSS.t63 VSS.t64 sg13_lv_nmos ad=0.1404p pd=1.11u as=0.1368p ps=1.1u w=0.72u l=0.13u
X2901 VDD VSS.t719 VDD VDD sg13_lv_pmos ad=0.19p pd=1.38u as=0 ps=0 w=1u l=1u
X2902 sg13g2_dlygate4sd3_1_0.A a_9162_15532# VSS.t32 VSS.t135 sg13_lv_nmos ad=0.2516p pd=2.16u as=0.1406p ps=1.12u w=0.74u l=0.13u
X2903 VDD VSS.t2117 VDD VDD sg13_lv_pmos ad=0.34p pd=2.68u as=0 ps=0 w=1u l=1u
X2904 a_26373_15213# sg13g2_dfrbpq_1_7.CLK VDD VDD sg13_lv_pmos ad=0.4088p pd=2.97u as=2.4406p ps=15.34u w=1.12u l=0.13u
X2905 VSS.t1440 VDD VSS.t1288 VSS.t305 sg13_lv_nmos ad=0.1428p pd=1.52u as=0 ps=0 w=0.42u l=1u
X2906 VSS.t874 VDD VSS.t873 VSS.t872 sg13_lv_nmos ad=0.1428p pd=1.52u as=0 ps=0 w=0.42u l=1u
X2907 VSS.t1059 VDD VSS.t1061 VSS.t1060 sg13_lv_nmos ad=79.8f pd=0.8u as=0 ps=0 w=0.42u l=1u
X2908 VSS.t2806 VDD VSS.t2805 VSS.t2710 sg13_lv_nmos ad=0.1428p pd=1.52u as=0 ps=0 w=0.42u l=1u
X2909 VDD VSS.t2761 VDD VDD sg13_lv_pmos ad=0.34p pd=2.68u as=0 ps=0 w=1u l=1u
X2910 a_2540_15960# sg13g2_dlygate4sd3_1_2.A VDD VDD sg13_lv_pmos ad=0.2856p pd=2.36u as=0.2114p ps=1.54u w=0.84u l=0.13u
X2911 VSS.t1403 VDD VSS.t1243 VSS.t305 sg13_lv_nmos ad=79.8f pd=0.8u as=0 ps=0 w=0.42u l=1u
X2912 VDD VSS.t2065 VDD VDD sg13_lv_pmos ad=0.19p pd=1.38u as=0 ps=0 w=1u l=1u
X2913 VDD VSS.t695 VDD VDD sg13_lv_pmos ad=0.34p pd=2.68u as=0 ps=0 w=1u l=1u
X2914 VDD VSS.t1535 VDD VDD sg13_lv_pmos ad=0.34p pd=2.68u as=0 ps=0 w=1u l=1u
X2915 VSS.t2173 VDD VSS.t2175 VSS.t2174 sg13_lv_nmos ad=79.8f pd=0.8u as=0 ps=0 w=0.42u l=1u
X2916 VDD VSS.t1066 VDD VDD sg13_lv_pmos ad=0.19p pd=1.38u as=0 ps=0 w=1u l=1u
X2917 VSS.t1616 VDD VSS.t1615 VSS.t1614 sg13_lv_nmos ad=0.1428p pd=1.52u as=0 ps=0 w=0.42u l=1u
X2918 VDD VSS.t1575 VDD VDD sg13_lv_pmos ad=0.34p pd=2.68u as=0 ps=0 w=1u l=1u
X2919 VSS.t3265 VDD VSS.t3267 VSS.t3266 sg13_lv_nmos ad=79.8f pd=0.8u as=0 ps=0 w=0.42u l=1u
X2920 VSS.t2771 VDD VSS.t2771 VSS.t2710 sg13_lv_nmos ad=0.1428p pd=1.52u as=0 ps=0 w=0.42u l=1u
X2921 VDD VSS.t2484 VDD VDD sg13_lv_pmos ad=0.34p pd=2.68u as=0 ps=0 w=1u l=1u
X2922 VDD VSS.t1748 VDD VDD sg13_lv_pmos ad=0.19p pd=1.38u as=0 ps=0 w=1u l=1u
X2923 VDD VSS.t878 VDD VDD sg13_lv_pmos ad=0.34p pd=2.68u as=0 ps=0 w=1u l=1u
X2924 VSS.t540 VDD VSS.t540 VSS.t541 sg13_lv_nmos ad=0.1428p pd=1.52u as=0 ps=0 w=0.42u l=1u
X2925 VSS.t2093 VDD VSS.t2092 VSS.t2091 sg13_lv_nmos ad=0.1428p pd=1.52u as=0 ps=0 w=0.42u l=1u
X2926 VDD VSS.t2432 VDD VDD sg13_lv_pmos ad=0.19p pd=1.38u as=0 ps=0 w=1u l=1u
X2927 VDD VSS.t2090 VDD VDD sg13_lv_pmos ad=0.19p pd=1.38u as=0 ps=0 w=1u l=1u
X2928 VDD VSS.t705 VDD VDD sg13_lv_pmos ad=0.34p pd=2.68u as=0 ps=0 w=1u l=1u
X2929 VDD VSS.t724 VDD VDD sg13_lv_pmos ad=0.19p pd=1.38u as=0 ps=0 w=1u l=1u
X2930 VDD VSS.t993 VDD VDD sg13_lv_pmos ad=0.34p pd=2.68u as=0 ps=0 w=1u l=1u
X2931 VSS.t1260 VDD VSS.t1261 VSS.t305 sg13_lv_nmos ad=79.8f pd=0.8u as=0 ps=0 w=0.42u l=1u
X2932 VSS.t1447 VDD VSS.t1297 VSS.t305 sg13_lv_nmos ad=0.1428p pd=1.52u as=0 ps=0 w=0.42u l=1u
X2933 VSS.t293 clock_i a_16078_14484# VSS.t37 sg13_lv_nmos ad=0.1406p pd=1.12u as=0.1406p ps=1.12u w=0.74u l=0.13u
X2934 a_9272_16362# sg13g2_xnor2_1_0.A a_9170_16362# VSS.t329 sg13_lv_nmos ad=0.1406p pd=1.12u as=0.1406p ps=1.12u w=0.74u l=0.13u
X2935 VDD VSS.t626 VDD VDD sg13_lv_pmos ad=0.34p pd=2.68u as=0 ps=0 w=1u l=1u
X2936 VDD VSS.t1388 VDD VDD sg13_lv_pmos ad=0.34p pd=2.68u as=0 ps=0 w=1u l=1u
X2937 VSS.t627 VDD VSS.t629 VSS.t628 sg13_lv_nmos ad=79.8f pd=0.8u as=0 ps=0 w=0.42u l=1u
X2938 VSS.t984 VDD VSS.t983 VSS.t982 sg13_lv_nmos ad=0.1428p pd=1.52u as=0 ps=0 w=0.42u l=1u
X2939 VSS.t1264 VDD VSS.t1266 VSS.t305 sg13_lv_nmos ad=79.8f pd=0.8u as=0 ps=0 w=0.42u l=1u
X2940 VDD VSS.t2724 VDD VDD sg13_lv_pmos ad=0.19p pd=1.38u as=0 ps=0 w=1u l=1u
X2941 VSS.t432 VDD VSS.t431 VSS.t430 sg13_lv_nmos ad=0.1428p pd=1.52u as=0 ps=0 w=0.42u l=1u
X2942 a_27215_15311# a_26373_15213# a_25956_15552# VDD sg13_lv_pmos ad=0.2048p pd=1.63u as=0.34p ps=2.68u w=1u l=0.13u
X2943 VSS.t1029 VDD VSS.t1028 VSS.t1027 sg13_lv_nmos ad=0.1428p pd=1.52u as=0 ps=0 w=0.42u l=1u
X2944 VSS.t1606 VDD VSS.t1605 VSS.t1604 sg13_lv_nmos ad=0.1428p pd=1.52u as=0 ps=0 w=0.42u l=1u
X2945 VSS.t3135 VDD VSS.t3134 VSS.t3133 sg13_lv_nmos ad=0.1428p pd=1.52u as=0 ps=0 w=0.42u l=1u
X2946 VSS.t2340 VDD VSS.t2339 VSS.t2338 sg13_lv_nmos ad=0.1428p pd=1.52u as=0 ps=0 w=0.42u l=1u
X2947 VDD VSS.t893 VDD VDD sg13_lv_pmos ad=0.34p pd=2.68u as=0 ps=0 w=1u l=1u
X2948 VSS.t1333 VDD VSS.t1334 VSS.t305 sg13_lv_nmos ad=79.8f pd=0.8u as=0 ps=0 w=0.42u l=1u
X2949 VDD VSS.t3247 VDD VDD sg13_lv_pmos ad=0.19p pd=1.38u as=0 ps=0 w=1u l=1u
X2950 VSS.t2788 VDD VSS.t2789 VSS.t2710 sg13_lv_nmos ad=79.8f pd=0.8u as=0 ps=0 w=0.42u l=1u
X2951 VDD VSS.t1728 VDD VDD sg13_lv_pmos ad=0.19p pd=1.38u as=0 ps=0 w=1u l=1u
X2952 VDD VSS.t3199 VDD VDD sg13_lv_pmos ad=0.34p pd=2.68u as=0 ps=0 w=1u l=1u
X2953 VSS.t729 VDD VSS.t729 VSS.t843 sg13_lv_nmos ad=0.1428p pd=1.52u as=0 ps=0 w=0.42u l=1u
X2954 VSS.t859 VDD VSS.t858 VSS.t857 sg13_lv_nmos ad=0.1428p pd=1.52u as=0 ps=0 w=0.42u l=1u
X2955 VSS.t470 VDD VSS.t472 VSS.t471 sg13_lv_nmos ad=79.8f pd=0.8u as=0 ps=0 w=0.42u l=1u
X2956 VSS.t642 VDD VSS.t644 VSS.t643 sg13_lv_nmos ad=79.8f pd=0.8u as=0 ps=0 w=0.42u l=1u
X2957 VSS.t1089 VDD VSS.t1091 VSS.t1090 sg13_lv_nmos ad=79.8f pd=0.8u as=0 ps=0 w=0.42u l=1u
X2958 VDD VSS.t2824 VDD VDD sg13_lv_pmos ad=0.19p pd=1.38u as=0 ps=0 w=1u l=1u
X2959 VSS.t2128 VDD VSS.t2127 VSS.t2126 sg13_lv_nmos ad=0.1428p pd=1.52u as=0 ps=0 w=0.42u l=1u
X2960 VDD VSS.t1279 VDD VDD sg13_lv_pmos ad=0.19p pd=1.38u as=0 ps=0 w=1u l=1u
X2961 VDD VSS.t1279 VDD VDD sg13_lv_pmos ad=0.34p pd=2.68u as=0 ps=0 w=1u l=1u
X2962 VDD VSS.t2789 VDD VDD sg13_lv_pmos ad=0.34p pd=2.68u as=0 ps=0 w=1u l=1u
X2963 VSS.t413 VDD VSS.t412 VSS.t411 sg13_lv_nmos ad=0.1428p pd=1.52u as=0 ps=0 w=0.42u l=1u
X2964 VDD VSS.t705 VDD VDD sg13_lv_pmos ad=0.34p pd=2.68u as=0 ps=0 w=1u l=1u
X2965 VDD VSS.t956 VDD VDD sg13_lv_pmos ad=0.19p pd=1.38u as=0 ps=0 w=1u l=1u
X2966 VSS.t1351 VDD VSS.t1352 VSS.t305 sg13_lv_nmos ad=79.8f pd=0.8u as=0 ps=0 w=0.42u l=1u
X2967 VSS.t1274 VDD VSS.t1275 VSS.t305 sg13_lv_nmos ad=79.8f pd=0.8u as=0 ps=0 w=0.42u l=1u
X2968 VDD VSS.t2417 VDD VDD sg13_lv_pmos ad=0.19p pd=1.38u as=0 ps=0 w=1u l=1u
X2969 VSS.t2732 VDD VSS.t2733 VSS.t2710 sg13_lv_nmos ad=79.8f pd=0.8u as=0 ps=0 w=0.42u l=1u
X2970 VDD a_11470_15423# sg13g2_xnor2_1_1.A VDD sg13_lv_pmos ad=0.2254p pd=1.53u as=0.4256p ps=3u w=1.12u l=0.13u
X2971 VSS.t502 VDD VSS.t502 VSS.t505 sg13_lv_nmos ad=79.8f pd=0.8u as=0 ps=0 w=0.42u l=1u
X2972 VSS.t554 VDD VSS.t554 VSS.t555 sg13_lv_nmos ad=0.1428p pd=1.52u as=0 ps=0 w=0.42u l=1u
X2973 a_12754_14922# sg13g2_dfrbpq_1_2.RESET_B VSS.t100 VSS.t88 sg13_lv_nmos ad=37.8f pd=0.6u as=79.8f ps=0.8u w=0.42u l=0.13u
X2974 VSS.t2963 VDD VSS.t2833 VSS.t2710 sg13_lv_nmos ad=79.8f pd=0.8u as=0 ps=0 w=0.42u l=1u
X2975 VDD VSS.t559 VDD VDD sg13_lv_pmos ad=0.34p pd=2.68u as=0 ps=0 w=1u l=1u
X2976 VSS.t874 VDD VSS.t873 VSS.t872 sg13_lv_nmos ad=0.1428p pd=1.52u as=0 ps=0 w=0.42u l=1u
X2977 VSS.t1059 VDD VSS.t1061 VSS.t1060 sg13_lv_nmos ad=79.8f pd=0.8u as=0 ps=0 w=0.42u l=1u
X2978 VDD VSS.t1048 VDD VDD sg13_lv_pmos ad=0.34p pd=2.68u as=0 ps=0 w=1u l=1u
X2979 VDD VSS.t2102 VDD VDD sg13_lv_pmos ad=0.34p pd=2.68u as=0 ps=0 w=1u l=1u
X2980 VSS.t569 VDD VSS.t573 VSS.t619 sg13_lv_nmos ad=79.8f pd=0.8u as=0 ps=0 w=0.42u l=1u
X2981 VDD VSS.t387 VDD VDD sg13_lv_pmos ad=0.34p pd=2.68u as=0 ps=0 w=1u l=1u
X2982 VSS.t4 a_25094_15238# a_25206_15302# VSS.t3 sg13_lv_nmos ad=0.1426p pd=1.16u as=0.1428p ps=1.52u w=0.42u l=0.5u
X2983 VDD VSS.t3232 VDD VDD sg13_lv_pmos ad=0.19p pd=1.38u as=0 ps=0 w=1u l=1u
X2984 VDD VSS.t2753 VDD VDD sg13_lv_pmos ad=0.34p pd=2.68u as=0 ps=0 w=1u l=1u
X2985 VDD VSS.t167 VDD VDD sg13_lv_pmos ad=0.19p pd=1.38u as=0 ps=0 w=1u l=1u
X2986 VDD VSS.t14 VDD VDD sg13_lv_pmos ad=0.34p pd=2.68u as=0 ps=0 w=1u l=1u
X2987 VSS.t364 sg13g2_dlygate4sd3_1_9.A a_17224_15996# VSS.t363 sg13_lv_nmos ad=0.14875p pd=1.16u as=0.187p ps=1.78u w=0.55u l=0.13u
X2988 VSS.t92 VDD VSS.t92 VSS.t494 sg13_lv_nmos ad=79.8f pd=0.8u as=0 ps=0 w=0.42u l=1u
X2989 VSS.t1551 VDD VSS.t1550 VSS.t1549 sg13_lv_nmos ad=0.1428p pd=1.52u as=0 ps=0 w=0.42u l=1u
X2990 VSS.t1721 VDD VSS.t1723 VSS.t1722 sg13_lv_nmos ad=79.8f pd=0.8u as=0 ps=0 w=0.42u l=1u
X2991 VDD VSS.t1560 VDD VDD sg13_lv_pmos ad=0.34p pd=2.68u as=0 ps=0 w=1u l=1u
X2992 VSS.t3250 VDD VSS.t3252 VSS.t3251 sg13_lv_nmos ad=79.8f pd=0.8u as=0 ps=0 w=0.42u l=1u
X2993 VDD VSS.t1111 VDD VDD sg13_lv_pmos ad=0.19p pd=1.38u as=0 ps=0 w=1u l=1u
X2994 VDD VSS.t1251 VDD VDD sg13_lv_pmos ad=0.34p pd=2.68u as=0 ps=0 w=1u l=1u
X2995 VDD VSS.t2469 VDD VDD sg13_lv_pmos ad=0.34p pd=2.68u as=0 ps=0 w=1u l=1u
X2996 VSS.t394 VDD VSS.t394 VSS.t395 sg13_lv_nmos ad=79.8f pd=0.8u as=0 ps=0 w=0.42u l=1u
X2997 VSS.t559 VDD VSS.t559 VSS.t562 sg13_lv_nmos ad=0.1428p pd=1.52u as=0 ps=0 w=0.42u l=1u
X2998 VSS.t522 VDD VSS.t524 VSS.t523 sg13_lv_nmos ad=79.8f pd=0.8u as=0 ps=0 w=0.42u l=1u
X2999 sg13g2_buf_16_1.X a_16078_14484# VDD VDD sg13_lv_pmos ad=0.2128p pd=1.5u as=0.2128p ps=1.5u w=1.12u l=0.13u
X3000 VDD VSS.t923 VDD VDD sg13_lv_pmos ad=0.34p pd=2.68u as=0 ps=0 w=1u l=1u
X3001 VSS.t2360 VDD VSS.t2359 VSS.t2358 sg13_lv_nmos ad=0.1428p pd=1.52u as=0 ps=0 w=0.42u l=1u
X3002 VDD VSS.t2067 VDD VDD sg13_lv_pmos ad=0.34p pd=2.68u as=0 ps=0 w=1u l=1u
X3003 a_25670_15234# a_26475_15356# a_25930_15457# VDD sg13_lv_pmos ad=0.1428p pd=1.52u as=79.8f ps=0.8u w=0.42u l=0.13u
X3004 VSS.t2530 VDD VSS.t2532 VSS.t2531 sg13_lv_nmos ad=79.8f pd=0.8u as=0 ps=0 w=0.42u l=1u
X3005 VDD VSS.t39 VDD VDD sg13_lv_pmos ad=0.34p pd=2.68u as=0 ps=0 w=1u l=1u
X3006 VDD VSS.t2594 VDD VDD sg13_lv_pmos ad=0.34p pd=2.68u as=0 ps=0 w=1u l=1u
X3007 VSS.t2078 VDD VSS.t2077 VSS.t2076 sg13_lv_nmos ad=0.1428p pd=1.52u as=0 ps=0 w=0.42u l=1u
X3008 VSS.t100 a_12308_15202# sg13g2_dfrbpq_1_2.CLK VSS.t182 sg13_lv_nmos ad=0.1406p pd=1.12u as=0.1406p ps=1.12u w=0.74u l=0.13u
X3009 VSS.t2028 VDD VSS.t2030 VSS.t2029 sg13_lv_nmos ad=79.8f pd=0.8u as=0 ps=0 w=0.42u l=1u
X3010 a_20434_14922# sg13g2_dfrbpq_1_6.RESET_B VSS.t126 VSS.t7 sg13_lv_nmos ad=37.8f pd=0.6u as=79.8f ps=0.8u w=0.42u l=0.13u
X3011 VDD VSS.t1750 VDD VDD sg13_lv_pmos ad=0.34p pd=2.68u as=0 ps=0 w=1u l=1u
X3012 VSS.t3120 VDD VSS.t3122 VSS.t3121 sg13_lv_nmos ad=79.8f pd=0.8u as=0 ps=0 w=0.42u l=1u
X3013 a_18825_14113# a_18468_14040# VDD VDD sg13_lv_pmos ad=63f pd=0.72u as=0.1563p ps=1.22u w=0.42u l=0.13u
X3014 VSS.t1368 VDD VSS.t1369 VSS.t305 sg13_lv_nmos ad=79.8f pd=0.8u as=0 ps=0 w=0.42u l=1u
X3015 VSS.t1811 VDD VSS.t1813 VSS.t1812 sg13_lv_nmos ad=79.8f pd=0.8u as=0 ps=0 w=0.42u l=1u
X3016 a_15602_15242# sg13g2_dlygate4sd3_1_9.A VSS.t362 VSS.t21 sg13_lv_nmos ad=0.1406p pd=1.12u as=0.2886p ps=2.26u w=0.74u l=0.13u
X3017 sg13g2_dlygate4sd3_1_11.A a_20394_14020# VSS.t309 VSS.t310 sg13_lv_nmos ad=0.2516p pd=2.16u as=0.1406p ps=1.12u w=0.74u l=0.13u
X3018 VSS.t1029 VDD VSS.t1028 VSS.t1027 sg13_lv_nmos ad=0.1428p pd=1.52u as=0 ps=0 w=0.42u l=1u
X3019 counter_value_o[3] a_17224_15996# VSS.t364 VSS.t370 sg13_lv_nmos ad=0.2886p pd=2.26u as=0.14875p ps=1.16u w=0.74u l=0.13u
X3020 a_8495_15311# a_7653_15213# a_7236_15552# VDD sg13_lv_pmos ad=0.2048p pd=1.63u as=0.34p ps=2.68u w=1u l=0.13u
X3021 VSS.t554 VDD VSS.t554 VSS.t606 sg13_lv_nmos ad=0.1428p pd=1.52u as=0 ps=0 w=0.42u l=1u
X3022 VDD VSS.t2715 VDD VDD sg13_lv_pmos ad=0.19p pd=1.38u as=0 ps=0 w=1u l=1u
X3023 VSS.t2325 VDD VSS.t2324 VSS.t2323 sg13_lv_nmos ad=0.1428p pd=1.52u as=0 ps=0 w=0.42u l=1u
X3024 VDD VSS.t441 VDD VDD sg13_lv_pmos ad=0.34p pd=2.68u as=0 ps=0 w=1u l=1u
X3025 VSS.t522 VDD VSS.t521 VSS.t520 sg13_lv_nmos ad=0.1428p pd=1.52u as=0 ps=0 w=0.42u l=1u
X3026 VSS.t2939 VDD VSS.t2808 VSS.t2710 sg13_lv_nmos ad=0.1428p pd=1.52u as=0 ps=0 w=0.42u l=1u
X3027 VDD VSS.t554 VDD VDD sg13_lv_pmos ad=0.34p pd=2.68u as=0 ps=0 w=1u l=1u
X3028 VSS.t32 VDD VSS.t32 VSS.t527 sg13_lv_nmos ad=79.8f pd=0.8u as=0 ps=0 w=0.42u l=1u
X3029 VDD a_26926_13911# sg13g2_nor2b_1_1.A VDD sg13_lv_pmos ad=0.2254p pd=1.53u as=0.4256p ps=3u w=1.12u l=0.13u
X3030 VSS.t724 VDD VSS.t724 VSS.t726 sg13_lv_nmos ad=0.1428p pd=1.52u as=0 ps=0 w=0.42u l=1u
X3031 VDD VSS.t1341 VDD VDD sg13_lv_pmos ad=0.34p pd=2.68u as=0 ps=0 w=1u l=1u
X3032 VDD VSS.t3184 VDD VDD sg13_lv_pmos ad=0.34p pd=2.68u as=0 ps=0 w=1u l=1u
X3033 VSS.t2178 VDD VSS.t2180 VSS.t2179 sg13_lv_nmos ad=79.8f pd=0.8u as=0 ps=0 w=0.42u l=1u
X3034 sg13g2_dfrbpq_1_7.CLK a_19630_15238# VSS.t125 VSS.t3 sg13_lv_nmos ad=0.1406p pd=1.12u as=0.1406p ps=1.12u w=0.74u l=0.13u
X3035 VSS.t1089 VDD VSS.t1091 VSS.t1090 sg13_lv_nmos ad=79.8f pd=0.8u as=0 ps=0 w=0.42u l=1u
X3036 VDD VSS.t1078 VDD VDD sg13_lv_pmos ad=0.34p pd=2.68u as=0 ps=0 w=1u l=1u
X3037 VSS.t1741 VDD VSS.t1743 VSS.t1742 sg13_lv_nmos ad=79.8f pd=0.8u as=0 ps=0 w=0.42u l=1u
X3038 VDD VSS.t886 VDD VDD sg13_lv_pmos ad=0.19p pd=1.38u as=0 ps=0 w=1u l=1u
X3039 VDD VSS.t1545 VDD VDD sg13_lv_pmos ad=0.34p pd=2.68u as=0 ps=0 w=1u l=1u
X3040 VDD VSS.t1808 VDD VDD sg13_lv_pmos ad=0.19p pd=1.38u as=0 ps=0 w=1u l=1u
X3041 a_16078_14484# clock_i VDD VDD sg13_lv_pmos ad=0.2128p pd=1.5u as=0.2128p ps=1.5u w=1.12u l=0.13u
X3042 VSS.t1377 VDD VSS.t1377 VSS.t305 sg13_lv_nmos ad=79.8f pd=0.8u as=0 ps=0 w=0.42u l=1u
X3043 VDD sg13g2_buf_1_0.X a_2684_15532# VDD sg13_lv_pmos ad=0.2128p pd=1.5u as=0.3808p ps=2.92u w=1.12u l=0.13u
X3044 VSS.t949 VDD VSS.t948 VSS.t947 sg13_lv_nmos ad=0.1428p pd=1.52u as=0 ps=0 w=0.42u l=1u
X3045 VSS.t1681 VDD VSS.t1680 VSS.t1679 sg13_lv_nmos ad=0.1428p pd=1.52u as=0 ps=0 w=0.42u l=1u
X3046 VDD VSS.t2579 VDD VDD sg13_lv_pmos ad=0.34p pd=2.68u as=0 ps=0 w=1u l=1u
X3047 VDD VSS.t2402 VDD VDD sg13_lv_pmos ad=0.19p pd=1.38u as=0 ps=0 w=1u l=1u
X3048 VDD sg13g2_xnor2_1_0.A a_7290_14020# VDD sg13_lv_pmos ad=0.2891p pd=1.695u as=0.1428p ps=1.375u w=1.12u l=0.13u
X3049 VSS.t1286 VDD VSS.t1287 VSS.t305 sg13_lv_nmos ad=79.8f pd=0.8u as=0 ps=0 w=0.42u l=1u
X3050 sg13g2_nor2b_1_0.Y a_23566_13764# VSS.t52 VSS.t312 sg13_lv_nmos ad=0.1406p pd=1.12u as=0.17255p ps=1.25u w=0.74u l=0.13u
X3051 VDD VSS.t695 VDD VDD sg13_lv_pmos ad=0.19p pd=1.38u as=0 ps=0 w=1u l=1u
X3052 VSS.t1381 VDD VSS.t1383 VSS.t305 sg13_lv_nmos ad=79.8f pd=0.8u as=0 ps=0 w=0.42u l=1u
X3053 VDD VSS.t2155 VDD VDD sg13_lv_pmos ad=0.19p pd=1.38u as=0 ps=0 w=1u l=1u
X3054 a_10790_14922# a_11595_14495# a_11050_14452# VDD sg13_lv_pmos ad=0.1428p pd=1.52u as=79.8f ps=0.8u w=0.42u l=0.13u
X3055 VSS.t811 VDD VSS.t175 VSS.t810 sg13_lv_nmos ad=0.1428p pd=1.52u as=0 ps=0 w=0.42u l=1u
X3056 VSS.t104 sg13g2_mux2_1_0.X a_24824_15238# VSS.t3 sg13_lv_nmos ad=79.8f pd=0.8u as=0.1428p ps=1.52u w=0.42u l=0.13u
X3057 VDD sg13g2_or3_1_0.A sg13g2_dlygate4sd3_1_3.A VDD sg13_lv_pmos ad=0.3808p pd=2.92u as=0.2128p ps=1.5u w=1.12u l=0.15u
X3058 VDD VSS.t1930 VDD VDD sg13_lv_pmos ad=0.19p pd=1.38u as=0 ps=0 w=1u l=1u
X3059 VSS.t1973 VDD VSS.t1975 VSS.t1974 sg13_lv_nmos ad=79.8f pd=0.8u as=0 ps=0 w=0.42u l=1u
X3060 VDD VSS.t2457 VDD VDD sg13_lv_pmos ad=0.19p pd=1.38u as=0 ps=0 w=1u l=1u
X3061 VSS.t2515 VDD VSS.t2517 VSS.t2516 sg13_lv_nmos ad=79.8f pd=0.8u as=0 ps=0 w=0.42u l=1u
X3062 a_14362_15960# sg13g2_xor2_1_1.X VDD VDD sg13_lv_pmos ad=0.1428p pd=1.52u as=0.1523p ps=1.38u w=0.42u l=0.13u
X3063 VDD VSS.t631 VDD VDD sg13_lv_pmos ad=0.34p pd=2.68u as=0 ps=0 w=1u l=1u
X3064 VSS.t2791 VDD VSS.t2792 VSS.t2710 sg13_lv_nmos ad=79.8f pd=0.8u as=0 ps=0 w=0.42u l=1u
X3065 VSS.t2063 VDD VSS.t2065 VSS.t2064 sg13_lv_nmos ad=79.8f pd=0.8u as=0 ps=0 w=0.42u l=1u
X3066 a_26244_15247# a_25956_15552# a_26182_15247# VSS.t203 sg13_lv_nmos ad=0.1428p pd=1.52u as=37.8f ps=0.6u w=0.42u l=0.13u
X3067 VDD VSS.t1041 VDD VDD sg13_lv_pmos ad=0.19p pd=1.38u as=0 ps=0 w=1u l=1u
X3068 VSS.t1536 VDD VSS.t1535 VSS.t1534 sg13_lv_nmos ad=0.1428p pd=1.52u as=0 ps=0 w=0.42u l=1u
X3069 a_27500_15960# sg13g2_dfrbpq_1_6.Q VDD VDD sg13_lv_pmos ad=0.2856p pd=2.36u as=0.2114p ps=1.54u w=0.84u l=0.13u
X3070 a_6950_15234# a_7755_15356# a_7210_15457# VDD sg13_lv_pmos ad=0.1428p pd=1.52u as=79.8f ps=0.8u w=0.42u l=0.13u
X3071 VSS.t909 VDD VSS.t911 VSS.t910 sg13_lv_nmos ad=79.8f pd=0.8u as=0 ps=0 w=0.42u l=1u
X3072 VDD VSS.t1282 VDD VDD sg13_lv_pmos ad=0.34p pd=2.68u as=0 ps=0 w=1u l=1u
X3073 VDD VSS.t2792 VDD VDD sg13_lv_pmos ad=0.34p pd=2.68u as=0 ps=0 w=1u l=1u
X3074 VSS.t2345 VDD VSS.t2344 VSS.t2343 sg13_lv_nmos ad=0.1428p pd=1.52u as=0 ps=0 w=0.42u l=1u
X3075 a_16078_14484# clock_i VDD VDD sg13_lv_pmos ad=0.2128p pd=1.5u as=0.3808p ps=2.92u w=1.12u l=0.13u
X3076 VDD VSS.t968 VDD VDD sg13_lv_pmos ad=0.34p pd=2.68u as=0 ps=0 w=1u l=1u
X3077 VDD a_20015_14845# a_20682_14484# VDD sg13_lv_pmos ad=0.2128p pd=1.5u as=0.3864p ps=2.93u w=1.12u l=0.13u
X3078 VSS.t2734 VDD VSS.t2736 VSS.t2710 sg13_lv_nmos ad=79.8f pd=0.8u as=0 ps=0 w=0.42u l=1u
X3079 VSS.t2193 VDD VSS.t2192 VSS.t2191 sg13_lv_nmos ad=0.1428p pd=1.52u as=0 ps=0 w=0.42u l=1u
X3080 VSS.t2013 VDD VSS.t2015 VSS.t2014 sg13_lv_nmos ad=79.8f pd=0.8u as=0 ps=0 w=0.42u l=1u
X3081 VDD VSS.t646 VDD VDD sg13_lv_pmos ad=0.34p pd=2.68u as=0 ps=0 w=1u l=1u
X3082 VDD sg13g2_dlygate4sd3_1_3.A a_17336_13726# VDD sg13_lv_pmos ad=0.1523p pd=1.38u as=0.1428p ps=1.52u w=0.42u l=0.13u
X3083 VDD VSS.t52 VDD VDD sg13_lv_pmos ad=0.34p pd=2.68u as=0 ps=0 w=1u l=1u
X3084 VDD VSS.t3047 VDD VDD sg13_lv_pmos ad=0.19p pd=1.38u as=0 ps=0 w=1u l=1u
X3085 VSS.t3105 VDD VSS.t3107 VSS.t3106 sg13_lv_nmos ad=79.8f pd=0.8u as=0 ps=0 w=0.42u l=1u
X3086 VDD a_8752_15454# a_8697_15549# VDD sg13_lv_pmos ad=2.4406p pd=15.34u as=93.45f ps=0.865u w=0.42u l=0.13u
X3087 VDD sg13g2_dlygate4sd3_1_2.A sg13g2_xnor2_1_0.B VDD sg13_lv_pmos ad=0.3808p pd=2.92u as=0.2128p ps=1.5u w=1.12u l=0.13u
X3088 a_17606_13726# a_17336_13726# VDD VDD sg13_lv_pmos ad=0.34p pd=2.68u as=0.1523p ps=1.38u w=1u l=0.5u
X3089 VSS.t2535 VDD VSS.t2534 VSS.t2533 sg13_lv_nmos ad=0.1428p pd=1.52u as=0 ps=0 w=0.42u l=1u
X3090 VSS.t2 VDD VSS.t2 VSS.t777 sg13_lv_nmos ad=79.8f pd=0.8u as=0 ps=0 w=0.42u l=1u
X3091 VSS.t1796 VDD VSS.t1798 VSS.t1797 sg13_lv_nmos ad=79.8f pd=0.8u as=0 ps=0 w=0.42u l=1u
X3092 a_2513_15288# sg13g2_dlygate4sd3_1_2.X a_2481_15556# VDD sg13_lv_pmos ad=0.34p pd=2.68u as=0.1225p ps=1.245u w=1u l=0.13u
X3093 VDD VSS.t2449 VDD VDD sg13_lv_pmos ad=0.34p pd=2.68u as=0 ps=0 w=1u l=1u
X3094 VDD VSS.t2107 VDD VDD sg13_lv_pmos ad=0.34p pd=2.68u as=0 ps=0 w=1u l=1u
X3095 VSS.t1318 VDD VSS.t1319 VSS.t305 sg13_lv_nmos ad=79.8f pd=0.8u as=0 ps=0 w=0.42u l=1u
X3096 VDD VSS.t3237 VDD VDD sg13_lv_pmos ad=0.19p pd=1.38u as=0 ps=0 w=1u l=1u
X3097 VDD VSS.t2756 VDD VDD sg13_lv_pmos ad=0.34p pd=2.68u as=0 ps=0 w=1u l=1u
X3098 VDD VSS.t705 VDD VDD sg13_lv_pmos ad=0.19p pd=1.38u as=0 ps=0 w=1u l=1u
X3099 VDD VSS.t1368 VDD VDD sg13_lv_pmos ad=0.34p pd=2.68u as=0 ps=0 w=1u l=1u
X3100 VSS.t1251 VDD VSS.t1251 VSS.t305 sg13_lv_nmos ad=0.1428p pd=1.52u as=0 ps=0 w=0.42u l=1u
X3101 VSS.t1666 VDD VSS.t1668 VSS.t1667 sg13_lv_nmos ad=79.8f pd=0.8u as=0 ps=0 w=0.42u l=1u
X3102 VSS.t2163 VDD VSS.t2165 VSS.t2164 sg13_lv_nmos ad=79.8f pd=0.8u as=0 ps=0 w=0.42u l=1u
X3103 VSS.t449 VDD VSS.t448 VSS.t447 sg13_lv_nmos ad=0.1428p pd=1.52u as=0 ps=0 w=0.42u l=1u
X3104 sg13g2_and2_1_0.X a_2733_14832# VSS.t167 VSS.t166 sg13_lv_nmos ad=0.2516p pd=2.16u as=0.1331p ps=1.12u w=0.74u l=0.13u
X3105 VSS.t879 VDD VSS.t878 VSS.t877 sg13_lv_nmos ad=0.1428p pd=1.52u as=0 ps=0 w=0.42u l=1u
X3106 VSS.t1726 VDD VSS.t1728 VSS.t1727 sg13_lv_nmos ad=79.8f pd=0.8u as=0 ps=0 w=0.42u l=1u
X3107 VSS.t2852 VDD VSS.t2851 VSS.t2710 sg13_lv_nmos ad=0.1428p pd=1.52u as=0 ps=0 w=0.42u l=1u
X3108 VSS.t3255 VDD VSS.t3257 VSS.t3256 sg13_lv_nmos ad=79.8f pd=0.8u as=0 ps=0 w=0.42u l=1u
X3109 VSS.t1245 VDD VSS.t1246 VSS.t305 sg13_lv_nmos ad=79.8f pd=0.8u as=0 ps=0 w=0.42u l=1u
X3110 VSS.t949 VDD VSS.t948 VSS.t947 sg13_lv_nmos ad=0.1428p pd=1.52u as=0 ps=0 w=0.42u l=1u
X3111 VSS.t2330 VDD VSS.t2329 VSS.t2328 sg13_lv_nmos ad=0.1428p pd=1.52u as=0 ps=0 w=0.42u l=1u
X3112 VSS.t63 VDD VSS.t129 VSS.t785 sg13_lv_nmos ad=79.8f pd=0.8u as=0 ps=0 w=0.42u l=1u
X3113 VDD VSS.t1793 VDD VDD sg13_lv_pmos ad=0.19p pd=1.38u as=0 ps=0 w=1u l=1u
X3114 VSS.t2726 VDD VSS.t2727 VSS.t2710 sg13_lv_nmos ad=79.8f pd=0.8u as=0 ps=0 w=0.42u l=1u
X3115 VDD VSS.t2564 VDD VDD sg13_lv_pmos ad=0.34p pd=2.68u as=0 ps=0 w=1u l=1u
X3116 VSS.t7 a_26373_15213# a_26475_15356# VSS.t200 sg13_lv_nmos ad=5.1665p pd=33.355u as=0.2516p ps=2.16u w=0.74u l=0.13u
X3117 VDD VSS.t729 VDD VDD sg13_lv_pmos ad=0.19p pd=1.38u as=0 ps=0 w=1u l=1u
X3118 VDD VSS.t1071 VDD VDD sg13_lv_pmos ad=0.19p pd=1.38u as=0 ps=0 w=1u l=1u
X3119 VDD VSS.t1745 VDD VDD sg13_lv_pmos ad=0.34p pd=2.68u as=0 ps=0 w=1u l=1u
X3120 VSS.t2799 VDD VSS.t2798 VSS.t2710 sg13_lv_nmos ad=0.1428p pd=1.52u as=0 ps=0 w=0.42u l=1u
X3121 VSS.t2033 VDD VSS.t2035 VSS.t2034 sg13_lv_nmos ad=79.8f pd=0.8u as=0 ps=0 w=0.42u l=1u
X3122 VDD VSS.t387 VDD VDD sg13_lv_pmos ad=0.19p pd=1.38u as=0 ps=0 w=1u l=1u
X3123 a_18766_15423# a_18881_15424# VDD VDD sg13_lv_pmos ad=0.34p pd=2.68u as=0.2254p ps=1.53u w=1u l=0.5u
X3124 VDD VSS.t664 VDD VDD sg13_lv_pmos ad=0.19p pd=1.38u as=0 ps=0 w=1u l=1u
X3125 VSS.t664 VDD VSS.t664 VSS.t755 sg13_lv_nmos ad=0.1428p pd=1.52u as=0 ps=0 w=0.42u l=1u
X3126 a_16673_15260# sg13g2_a21oi_1_0.A1 sg13g2_a21oi_1_0.Y VSS.t21 sg13_lv_nmos ad=0.1406p pd=1.12u as=0.1406p ps=1.12u w=0.74u l=0.13u
X3127 VDD sg13g2_xnor2_1_0.A a_7116_13912# VDD sg13_lv_pmos ad=0.4536p pd=2.76u as=0.1596p ps=1.22u w=0.84u l=0.13u
X3128 VSS.t1450 VDD VSS.t1299 VSS.t305 sg13_lv_nmos ad=0.1428p pd=1.52u as=0 ps=0 w=0.42u l=1u
X3129 VDD VSS.t1391 VDD VDD sg13_lv_pmos ad=0.34p pd=2.68u as=0 ps=0 w=1u l=1u
X3130 VSS.t3050 VDD VSS.t3052 VSS.t3051 sg13_lv_nmos ad=79.8f pd=0.8u as=0 ps=0 w=0.42u l=1u
X3131 VDD VSS.t631 VDD VDD sg13_lv_pmos ad=0.34p pd=2.68u as=0 ps=0 w=1u l=1u
X3132 a_22589_14020# sg13g2_nor3_1_0.C sg13g2_nor3_1_0.Y VDD sg13_lv_pmos ad=0.2128p pd=1.5u as=0.3808p ps=2.92u w=1.12u l=0.13u
X3133 VDD VSS.t2785 VDD VDD sg13_lv_pmos ad=0.19p pd=1.38u as=0 ps=0 w=1u l=1u
X3134 VSS.t2455 VDD VSS.t2454 VSS.t2453 sg13_lv_nmos ad=0.1428p pd=1.52u as=0 ps=0 w=0.42u l=1u
X3135 VDD VSS.t1086 VDD VDD sg13_lv_pmos ad=0.19p pd=1.38u as=0 ps=0 w=1u l=1u
X3136 VDD VSS.t3189 VDD VDD sg13_lv_pmos ad=0.34p pd=2.68u as=0 ps=0 w=1u l=1u
X3137 VSS.t2148 VDD VSS.t2150 VSS.t2149 sg13_lv_nmos ad=79.8f pd=0.8u as=0 ps=0 w=0.42u l=1u
X3138 VSS.t909 VDD VSS.t911 VSS.t910 sg13_lv_nmos ad=79.8f pd=0.8u as=0 ps=0 w=0.42u l=1u
X3139 VDD VSS.t1550 VDD VDD sg13_lv_pmos ad=0.34p pd=2.68u as=0 ps=0 w=1u l=1u
X3140 VDD VSS.t2459 VDD VDD sg13_lv_pmos ad=0.34p pd=2.68u as=0 ps=0 w=1u l=1u
X3141 VSS.t676 VDD VSS.t673 VSS.t770 sg13_lv_nmos ad=0.1428p pd=1.52u as=0 ps=0 w=0.42u l=1u
X3142 VDD VSS.t1723 VDD VDD sg13_lv_pmos ad=0.19p pd=1.38u as=0 ps=0 w=1u l=1u
X3143 VDD VSS.t1778 VDD VDD sg13_lv_pmos ad=0.19p pd=1.38u as=0 ps=0 w=1u l=1u
X3144 VDD VSS.t1970 VDD VDD sg13_lv_pmos ad=0.19p pd=1.38u as=0 ps=0 w=1u l=1u
X3145 VDD VSS.t714 VDD VDD sg13_lv_pmos ad=0.34p pd=2.68u as=0 ps=0 w=1u l=1u
X3146 VSS.t2068 VDD VSS.t2067 VSS.t2066 sg13_lv_nmos ad=0.1428p pd=1.52u as=0 ps=0 w=0.42u l=1u
X3147 a_18442_13945# a_18885_13701# a_18182_13722# VSS.t242 sg13_lv_nmos ad=79.8f pd=0.8u as=0.1296p ps=1.52u w=0.42u l=0.13u
X3148 VDD VSS.t1399 VDD VDD sg13_lv_pmos ad=0.34p pd=2.68u as=0 ps=0 w=1u l=1u
X3149 VDD VSS.t646 VDD VDD sg13_lv_pmos ad=0.34p pd=2.68u as=0 ps=0 w=1u l=1u
X3150 VSS.t2178 VDD VSS.t2177 VSS.t2176 sg13_lv_nmos ad=0.1428p pd=1.52u as=0 ps=0 w=0.42u l=1u
X3151 VSS.t125 a_20015_14845# a_20682_14484# VSS.t7 sg13_lv_nmos ad=0.1406p pd=1.12u as=0.2516p ps=2.16u w=0.74u l=0.13u
X3152 VSS.t32 a_8590_14751# sg13g2_xnor2_1_0.A VSS.t72 sg13_lv_nmos ad=0.1426p pd=1.16u as=0.2516p ps=2.16u w=0.74u l=0.13u
X3153 a_17112_12952# sg13g2_buf_4_0.X VDD VDD sg13_lv_pmos ad=0.2128p pd=1.5u as=0.3808p ps=2.92u w=1.12u l=0.15u
X3154 VSS.t1049 VDD VSS.t1048 VSS.t1047 sg13_lv_nmos ad=0.1428p pd=1.52u as=0 ps=0 w=0.42u l=1u
X3155 VSS.t1484 VDD VSS.t1345 VSS.t305 sg13_lv_nmos ad=79.8f pd=0.8u as=0 ps=0 w=0.42u l=1u
X3156 VSS.t1978 VDD VSS.t1980 VSS.t1979 sg13_lv_nmos ad=79.8f pd=0.8u as=0 ps=0 w=0.42u l=1u
X3157 VSS.t2958 VDD VSS.t2828 VSS.t2710 sg13_lv_nmos ad=79.8f pd=0.8u as=0 ps=0 w=0.42u l=1u
X3158 VSS.t10 a_7054_14751# sg13g2_and2_1_1.B VSS.t9 sg13_lv_nmos ad=0.1426p pd=1.16u as=0.2516p ps=2.16u w=0.74u l=0.13u
X3159 VSS.t2520 VDD VSS.t2522 VSS.t2521 sg13_lv_nmos ad=79.8f pd=0.8u as=0 ps=0 w=0.42u l=1u
X3160 VDD VSS.t3222 VDD VDD sg13_lv_pmos ad=0.19p pd=1.38u as=0 ps=0 w=1u l=1u
X3161 VSS.t879 VDD VSS.t878 VSS.t877 sg13_lv_nmos ad=0.1428p pd=1.52u as=0 ps=0 w=0.42u l=1u
X3162 VSS.t1651 VDD VSS.t1653 VSS.t1652 sg13_lv_nmos ad=79.8f pd=0.8u as=0 ps=0 w=0.42u l=1u
X3163 VSS.t2390 VDD VSS.t2389 VSS.t2388 sg13_lv_nmos ad=0.1428p pd=1.52u as=0 ps=0 w=0.42u l=1u
X3164 VDD sg13g2_nand2_1_1.A sg13g2_nor3_1_0.C VDD sg13_lv_pmos ad=0.3808p pd=2.92u as=0.2128p ps=1.5u w=1.12u l=0.13u
X3165 VSS.t1109 VDD VSS.t1111 VSS.t1110 sg13_lv_nmos ad=79.8f pd=0.8u as=0 ps=0 w=0.42u l=1u
X3166 a_16571_15532# sg13g2_a21oi_1_0.A2 VDD VDD sg13_lv_pmos ad=0.3808p pd=2.92u as=0.2128p ps=1.5u w=1.12u l=0.13u
X3167 VSS.t49 a_4666_14448# a_4385_14750# VSS.t48 sg13_lv_nmos ad=79.8f pd=0.8u as=0.1428p ps=1.52u w=0.42u l=0.5u
X3168 a_8590_14751# a_8705_14750# VSS.t32 VSS.t31 sg13_lv_nmos ad=0.1428p pd=1.52u as=0.1426p ps=1.16u w=0.42u l=0.5u
X3169 VDD VSS.t3092 VDD VDD sg13_lv_pmos ad=0.19p pd=1.38u as=0 ps=0 w=1u l=1u
X3170 VDD VSS.t1955 VDD VDD sg13_lv_pmos ad=0.19p pd=1.38u as=0 ps=0 w=1u l=1u
X3171 a_10605_13768# sg13g2_buf_1_9.X VDD VDD sg13_lv_pmos ad=0.1596p pd=1.22u as=0.2856p ps=2.36u w=0.84u l=0.13u
X3172 VSS.t1806 VDD VSS.t1808 VSS.t1807 sg13_lv_nmos ad=79.8f pd=0.8u as=0 ps=0 w=0.42u l=1u
X3173 VSS.t2716 VDD VSS.t2718 VSS.t2710 sg13_lv_nmos ad=79.8f pd=0.8u as=0 ps=0 w=0.42u l=1u
X3174 VDD VSS.t1730 VDD VDD sg13_lv_pmos ad=0.34p pd=2.68u as=0 ps=0 w=1u l=1u
X3175 VDD VSS.t2863 VDD VDD sg13_lv_pmos ad=0.19p pd=1.38u as=0 ps=0 w=1u l=1u
X3176 VSS.t2198 VDD VSS.t2197 VSS.t2196 sg13_lv_nmos ad=0.1428p pd=1.52u as=0 ps=0 w=0.42u l=1u
X3177 VSS.t2018 VDD VSS.t2020 VSS.t2019 sg13_lv_nmos ad=79.8f pd=0.8u as=0 ps=0 w=0.42u l=1u
X3178 VSS.t564 VDD VSS.t564 VSS.t565 sg13_lv_nmos ad=0.1428p pd=1.52u as=0 ps=0 w=0.42u l=1u
X3179 VDD VSS.t673 VDD VDD sg13_lv_pmos ad=0.19p pd=1.38u as=0 ps=0 w=1u l=1u
X3180 VSS.t3110 VDD VSS.t3112 VSS.t3111 sg13_lv_nmos ad=79.8f pd=0.8u as=0 ps=0 w=0.42u l=1u
X3181 VSS.t1326 VDD VSS.t1469 VSS.t305 sg13_lv_nmos ad=0.1428p pd=1.52u as=0 ps=0 w=0.42u l=1u
X3182 VDD VSS.t2322 VDD VDD sg13_lv_pmos ad=0.19p pd=1.38u as=0 ps=0 w=1u l=1u
X3183 VDD a_26373_15213# a_26475_15356# VDD sg13_lv_pmos ad=2.4406p pd=15.34u as=0.3864p ps=2.93u w=1.12u l=0.13u
X3184 VDD VSS.t569 VDD VDD sg13_lv_pmos ad=0.34p pd=2.68u as=0 ps=0 w=1u l=1u
X3185 VSS.t1801 VDD VSS.t1803 VSS.t1802 sg13_lv_nmos ad=79.8f pd=0.8u as=0 ps=0 w=0.42u l=1u
X3186 VDD VSS.t2419 VDD VDD sg13_lv_pmos ad=0.34p pd=2.68u as=0 ps=0 w=1u l=1u
X3187 VDD VSS.t2112 VDD VDD sg13_lv_pmos ad=0.34p pd=2.68u as=0 ps=0 w=1u l=1u
X3188 a_19044_14909# a_19275_14495# a_18730_14452# VSS.t144 sg13_lv_nmos ad=0.2373p pd=1.97u as=79.8f ps=0.8u w=0.42u l=0.13u
X3189 VSS.t1928 VDD VSS.t1930 VSS.t1929 sg13_lv_nmos ad=79.8f pd=0.8u as=0 ps=0 w=0.42u l=1u
X3190 VSS.t1368 VDD VSS.t1368 VSS.t305 sg13_lv_nmos ad=0.1428p pd=1.52u as=0 ps=0 w=0.42u l=1u
X3191 VDD VSS.t3242 VDD VDD sg13_lv_pmos ad=0.19p pd=1.38u as=0 ps=0 w=1u l=1u
X3192 a_18470_14922# sg13g2_dfrbpq_1_6.D VDD VDD sg13_lv_pmos ad=79.8f pd=0.8u as=0.1428p ps=1.52u w=0.42u l=0.13u
X3193 VDD VSS.t2060 VDD VDD sg13_lv_pmos ad=0.19p pd=1.38u as=0 ps=0 w=1u l=1u
X3194 VSS.t1079 VDD VSS.t1078 VSS.t1077 sg13_lv_nmos ad=0.1428p pd=1.52u as=0 ps=0 w=0.42u l=1u
X3195 a_11493_14495# sg13g2_dfrbpq_1_2.CLK VDD VDD sg13_lv_pmos ad=0.4088p pd=2.97u as=2.6415p ps=17.17u w=1.12u l=0.13u
X3196 a_18789_16033# a_18789_16033# VSS.t74 VSS.t233 sg13_lv_nmos ad=0.111p pd=1.34u as=5.31717p ps=34.515u w=0.3u l=0.13u
X3197 VDD VSS.t943 VDD VDD sg13_lv_pmos ad=0.34p pd=2.68u as=0 ps=0 w=1u l=1u
X3198 VSS.t1993 VDD VSS.t1992 VSS.t1991 sg13_lv_nmos ad=0.1428p pd=1.52u as=0 ps=0 w=0.42u l=1u
X3199 VDD VSS.t921 VDD VDD sg13_lv_pmos ad=0.19p pd=1.38u as=0 ps=0 w=1u l=1u
X3200 VDD VSS.t1535 VDD VDD sg13_lv_pmos ad=0.34p pd=2.68u as=0 ps=0 w=1u l=1u
X3201 VSS.t2966 VDD VSS.t2834 VSS.t2710 sg13_lv_nmos ad=0.1428p pd=1.52u as=0 ps=0 w=0.42u l=1u
X3202 VSS.t12 a_23483_14540# a_23920_14854# VSS.t7 sg13_lv_nmos ad=0.148p pd=1.14u as=0.3367p ps=1.65u w=0.74u l=0.13u
X3203 VSS.t2335 VDD VSS.t2334 VSS.t2333 sg13_lv_nmos ad=0.1428p pd=1.52u as=0 ps=0 w=0.42u l=1u
X3204 VSS.t1596 VDD VSS.t1598 VSS.t1597 sg13_lv_nmos ad=79.8f pd=0.8u as=0 ps=0 w=0.42u l=1u
X3205 VDD a_27184_14726# a_27129_14607# VDD sg13_lv_pmos ad=2.75157p pd=17.885u as=93.45f ps=0.865u w=0.42u l=0.13u
X3206 VSS.t1791 VDD VSS.t1793 VSS.t1792 sg13_lv_nmos ad=79.8f pd=0.8u as=0 ps=0 w=0.42u l=1u
X3207 VSS.t2505 VDD VSS.t2507 VSS.t2506 sg13_lv_nmos ad=79.8f pd=0.8u as=0 ps=0 w=0.42u l=1u
X3208 VSS.t2801 VDD VSS.t2801 VSS.t2710 sg13_lv_nmos ad=0.1428p pd=1.52u as=0 ps=0 w=0.42u l=1u
X3209 VDD a_26062_13911# sg13g2_nor2b_1_0.A VDD sg13_lv_pmos ad=0.2254p pd=1.53u as=0.4256p ps=3u w=1.12u l=0.13u
X3210 VDD VSS.t3037 VDD VDD sg13_lv_pmos ad=0.19p pd=1.38u as=0 ps=0 w=1u l=1u
X3211 VDD VSS.t1006 VDD VDD sg13_lv_pmos ad=0.19p pd=1.38u as=0 ps=0 w=1u l=1u
X3212 VSS.t1049 VDD VSS.t1048 VSS.t1047 sg13_lv_nmos ad=0.1428p pd=1.52u as=0 ps=0 w=0.42u l=1u
X3213 VSS.t954 VDD VSS.t956 VSS.t955 sg13_lv_nmos ad=79.8f pd=0.8u as=0 ps=0 w=0.42u l=1u
X3214 VDD VSS.t2487 VDD VDD sg13_lv_pmos ad=0.19p pd=1.38u as=0 ps=0 w=1u l=1u
X3215 VDD VSS.t2145 VDD VDD sg13_lv_pmos ad=0.19p pd=1.38u as=0 ps=0 w=1u l=1u
X3216 VSS.t2148 VDD VSS.t2147 VSS.t2146 sg13_lv_nmos ad=0.1428p pd=1.52u as=0 ps=0 w=0.42u l=1u
X3217 VSS.t517 VDD VSS.t167 VSS.t518 sg13_lv_nmos ad=79.8f pd=0.8u as=0 ps=0 w=0.42u l=1u
X3218 VSS.t1963 VDD VSS.t1965 VSS.t1964 sg13_lv_nmos ad=79.8f pd=0.8u as=0 ps=0 w=0.42u l=1u
X3219 VDD VSS.t564 VDD VDD sg13_lv_pmos ad=0.34p pd=2.68u as=0 ps=0 w=1u l=1u
X3220 VSS.t695 VDD VSS.t695 VSS.t814 sg13_lv_nmos ad=79.8f pd=0.8u as=0 ps=0 w=0.42u l=1u
X3221 VDD VSS.t1593 VDD VDD sg13_lv_pmos ad=0.19p pd=1.38u as=0 ps=0 w=1u l=1u
X3222 VSS.t1109 VDD VSS.t1111 VSS.t1110 sg13_lv_nmos ad=79.8f pd=0.8u as=0 ps=0 w=0.42u l=1u
X3223 VDD VSS.t1353 VDD VDD sg13_lv_pmos ad=0.34p pd=2.68u as=0 ps=0 w=1u l=1u
X3224 VDD sg13g2_tiehi_1.L_HI a_3370_15457# VDD sg13_lv_pmos ad=0.1563p pd=1.22u as=0.147p ps=1.54u w=0.42u l=0.13u
X3225 VSS.t2750 VDD VSS.t2751 VSS.t2710 sg13_lv_nmos ad=79.8f pd=0.8u as=0 ps=0 w=0.42u l=1u
X3226 sg13g2_and2_1_0.B sg13g2_dlygate4sd3_1_2.X a_2778_15250# VSS.t340 sg13_lv_nmos ad=0.1628p pd=1.18u as=88.8f ps=0.98u w=0.74u l=0.13u
X3227 VSS.t58 a_23648_15437# sg13g2_mux2_1_0.A0 VSS.t3 sg13_lv_nmos ad=0.1331p pd=1.12u as=0.2516p ps=2.16u w=0.74u l=0.13u
X3228 VDD VSS.t326 VDD VDD sg13_lv_pmos ad=0.34p pd=2.68u as=0 ps=0 w=1u l=1u
X3229 VDD VSS.t1728 VDD VDD sg13_lv_pmos ad=0.19p pd=1.38u as=0 ps=0 w=1u l=1u
X3230 VDD VSS.t1783 VDD VDD sg13_lv_pmos ad=0.19p pd=1.38u as=0 ps=0 w=1u l=1u
X3231 VDD VSS.t3077 VDD VDD sg13_lv_pmos ad=0.19p pd=1.38u as=0 ps=0 w=1u l=1u
X3232 VDD VSS.t3254 VDD VDD sg13_lv_pmos ad=0.34p pd=2.68u as=0 ps=0 w=1u l=1u
X3233 VSS.t2525 VDD VSS.t2527 VSS.t2526 sg13_lv_nmos ad=79.8f pd=0.8u as=0 ps=0 w=0.42u l=1u
X3234 VDD VSS.t1940 VDD VDD sg13_lv_pmos ad=0.19p pd=1.38u as=0 ps=0 w=1u l=1u
X3235 VDD VSS.t2854 VDD VDD sg13_lv_pmos ad=0.19p pd=1.38u as=0 ps=0 w=1u l=1u
X3236 VSS.t2183 VDD VSS.t2182 VSS.t2181 sg13_lv_nmos ad=0.1428p pd=1.52u as=0 ps=0 w=0.42u l=1u
X3237 VSS.t1746 VDD VSS.t1745 VSS.t1744 sg13_lv_nmos ad=0.1428p pd=1.52u as=0 ps=0 w=0.42u l=1u
X3238 a_25894_14909# sg13g2_dfrbpq_1_5.RESET_B VSS.t81 VSS.t80 sg13_lv_nmos ad=37.8f pd=0.6u as=0.1701p ps=1.65u w=0.42u l=0.13u
X3239 VDD VSS.t976 VDD VDD sg13_lv_pmos ad=0.19p pd=1.38u as=0 ps=0 w=1u l=1u
X3240 VDD VSS.t2472 VDD VDD sg13_lv_pmos ad=0.19p pd=1.38u as=0 ps=0 w=1u l=1u
X3241 VDD VSS.t513 VDD VDD sg13_lv_pmos ad=0.19p pd=1.38u as=0 ps=0 w=1u l=1u
X3242 VDD VSS.t651 VDD VDD sg13_lv_pmos ad=0.34p pd=2.68u as=0 ps=0 w=1u l=1u
X3243 VDD VSS.t2097 VDD VDD sg13_lv_pmos ad=0.34p pd=2.68u as=0 ps=0 w=1u l=1u
X3244 VDD VSS.t913 VDD VDD sg13_lv_pmos ad=0.34p pd=2.68u as=0 ps=0 w=1u l=1u
X3245 VSS.t2490 VDD VSS.t2492 VSS.t2491 sg13_lv_nmos ad=79.8f pd=0.8u as=0 ps=0 w=0.42u l=1u
X3246 VDD VSS.t56 VDD VDD sg13_lv_pmos ad=0.34p pd=2.68u as=0 ps=0 w=1u l=1u
X3247 VSS.t1079 VDD VSS.t1078 VSS.t1077 sg13_lv_nmos ad=0.1428p pd=1.52u as=0 ps=0 w=0.42u l=1u
X3248 VDD VSS.t3227 VDD VDD sg13_lv_pmos ad=0.19p pd=1.38u as=0 ps=0 w=1u l=1u
X3249 sg13g2_dfrbpq_1_2.CLK a_12308_15202# VSS.t100 VSS.t182 sg13_lv_nmos ad=0.1406p pd=1.12u as=0.1406p ps=1.12u w=0.74u l=0.13u
X3250 a_12308_15202# sg13g2_buf_16_1.X VSS.t89 VSS.t218 sg13_lv_nmos ad=0.1406p pd=1.12u as=0.1406p ps=1.12u w=0.74u l=0.13u
X3251 VSS.t103 a_19162_15202# a_18881_15424# VSS.t102 sg13_lv_nmos ad=79.8f pd=0.8u as=0.1428p ps=1.52u w=0.42u l=0.5u
X3252 a_14927_14845# a_14085_14495# a_14833_14845# VSS.t37 sg13_lv_nmos ad=0.12665p pd=1.145u as=0.1428p ps=1.52u w=0.42u l=0.13u
X3253 VDD VSS.t851 VDD VDD sg13_lv_pmos ad=0.19p pd=1.38u as=0 ps=0 w=1u l=1u
X3254 VSS.t1656 VDD VSS.t1658 VSS.t1657 sg13_lv_nmos ad=79.8f pd=0.8u as=0 ps=0 w=0.42u l=1u
X3255 VDD VSS.t502 VDD VDD sg13_lv_pmos ad=0.19p pd=1.38u as=0 ps=0 w=1u l=1u
X3256 VDD VSS.t1932 VDD VDD sg13_lv_pmos ad=0.34p pd=2.68u as=0 ps=0 w=1u l=1u
X3257 VSS.t1978 VDD VSS.t1977 VSS.t1976 sg13_lv_nmos ad=0.1428p pd=1.52u as=0 ps=0 w=0.42u l=1u
X3258 VSS.t1279 VDD VSS.t1279 VSS.t305 sg13_lv_nmos ad=0.1428p pd=1.52u as=0 ps=0 w=0.42u l=1u
X3259 VDD VSS.t404 VDD VDD sg13_lv_pmos ad=0.19p pd=1.38u as=0 ps=0 w=1u l=1u
X3260 VDD VSS.t1370 VDD VDD sg13_lv_pmos ad=0.34p pd=2.68u as=0 ps=0 w=1u l=1u
X3261 VSS.t2320 VDD VSS.t2319 VSS.t2318 sg13_lv_nmos ad=0.1428p pd=1.52u as=0 ps=0 w=0.42u l=1u
X3262 VDD VSS.t693 VDD VDD sg13_lv_pmos ad=0.34p pd=2.68u as=0 ps=0 w=1u l=1u
X3263 VSS.t1776 VDD VSS.t1778 VSS.t1777 sg13_lv_nmos ad=79.8f pd=0.8u as=0 ps=0 w=0.42u l=1u
X3264 VSS.t2720 VDD VSS.t2721 VSS.t2710 sg13_lv_nmos ad=79.8f pd=0.8u as=0 ps=0 w=0.42u l=1u
X3265 VDD VSS.t422 VDD VDD sg13_lv_pmos ad=0.34p pd=2.68u as=0 ps=0 w=1u l=1u
X3266 VSS.t954 VDD VSS.t956 VSS.t955 sg13_lv_nmos ad=79.8f pd=0.8u as=0 ps=0 w=0.42u l=1u
X3267 VDD VSS.t1735 VDD VDD sg13_lv_pmos ad=0.34p pd=2.68u as=0 ps=0 w=1u l=1u
X3268 VSS.t2793 VDD VSS.t2793 VSS.t2710 sg13_lv_nmos ad=0.1428p pd=1.52u as=0 ps=0 w=0.42u l=1u
X3269 VSS.t3115 VDD VSS.t3117 VSS.t3116 sg13_lv_nmos ad=79.8f pd=0.8u as=0 ps=0 w=0.42u l=1u
X3270 VDD a_12308_15202# sg13g2_dfrbpq_1_2.CLK VDD sg13_lv_pmos ad=0.2128p pd=1.5u as=0.2128p ps=1.5u w=1.12u l=0.13u
X3271 VDD VSS.t3022 VDD VDD sg13_lv_pmos ad=0.19p pd=1.38u as=0 ps=0 w=1u l=1u
X3272 VSS.t125 a_19630_15238# sg13g2_dfrbpq_1_7.CLK VSS.t3 sg13_lv_nmos ad=0.1406p pd=1.12u as=0.1406p ps=1.12u w=0.74u l=0.13u
X3273 VDD VSS.t2424 VDD VDD sg13_lv_pmos ad=0.34p pd=2.68u as=0 ps=0 w=1u l=1u
X3274 VDD VSS.t16 VDD VDD sg13_lv_pmos ad=0.19p pd=1.38u as=0 ps=0 w=1u l=1u
X3275 VDD VSS.t719 VDD VDD sg13_lv_pmos ad=0.19p pd=1.38u as=0 ps=0 w=1u l=1u
X3276 VDD VSS.t2082 VDD VDD sg13_lv_pmos ad=0.34p pd=2.68u as=0 ps=0 w=1u l=1u
X3277 VDD a_22508_15960# counter_value_o[4] VDD sg13_lv_pmos ad=0.2114p pd=1.54u as=0.42p ps=2.99u w=1.12u l=0.13u
X3278 a_25476_14922# sg13g2_dfrbpq_1_5.D a_25382_14922# VSS.t7 sg13_lv_nmos ad=60.89999f pd=0.71u as=0.1428p ps=1.52u w=0.42u l=0.13u
X3279 VSS.t664 VDD VSS.t664 VSS.t758 sg13_lv_nmos ad=79.8f pd=0.8u as=0 ps=0 w=0.42u l=1u
X3280 VDD VSS.t1299 VDD VDD sg13_lv_pmos ad=0.19p pd=1.38u as=0 ps=0 w=1u l=1u
X3281 VDD VSS.t1400 VDD VDD sg13_lv_pmos ad=0.19p pd=1.38u as=0 ps=0 w=1u l=1u
X3282 VDD VSS.t3212 VDD VDD sg13_lv_pmos ad=0.19p pd=1.38u as=0 ps=0 w=1u l=1u
X3283 VSS.t1263 VDD VSS.t1262 VSS.t305 sg13_lv_nmos ad=0.1428p pd=1.52u as=0 ps=0 w=0.42u l=1u
X3284 sg13g2_dfrbpq_1_2.CLK a_12308_15202# VSS.t137 VSS.t182 sg13_lv_nmos ad=0.1406p pd=1.12u as=0.1406p ps=1.12u w=0.74u l=0.13u
X3285 VSS.t690 VDD VSS.t690 VSS.t691 sg13_lv_nmos ad=79.8f pd=0.8u as=0 ps=0 w=0.42u l=1u
X3286 VDD VSS.t2780 VDD VDD sg13_lv_pmos ad=0.19p pd=1.38u as=0 ps=0 w=1u l=1u
X3287 VSS.t2445 VDD VSS.t2444 VSS.t2443 sg13_lv_nmos ad=0.1428p pd=1.52u as=0 ps=0 w=0.42u l=1u
X3288 VDD VSS.t2000 VDD VDD sg13_lv_pmos ad=0.19p pd=1.38u as=0 ps=0 w=1u l=1u
X3289 VSS.t559 VDD VSS.t564 VSS.t563 sg13_lv_nmos ad=79.8f pd=0.8u as=0 ps=0 w=0.42u l=1u
X3290 VSS.t1256 VDD VSS.t1257 VSS.t305 sg13_lv_nmos ad=79.8f pd=0.8u as=0 ps=0 w=0.42u l=1u
X3291 VSS.t2838 VDD VSS.t2837 VSS.t2710 sg13_lv_nmos ad=0.1428p pd=1.52u as=0 ps=0 w=0.42u l=1u
X3292 VDD VSS.t2125 VDD VDD sg13_lv_pmos ad=0.19p pd=1.38u as=0 ps=0 w=1u l=1u
X3293 sg13g2_dfrbpq_1_7.CLK a_19630_15238# VDD VDD sg13_lv_pmos ad=0.2128p pd=1.5u as=0.2128p ps=1.5u w=1.12u l=0.13u
X3294 VDD VSS.t1768 VDD VDD sg13_lv_pmos ad=0.19p pd=1.38u as=0 ps=0 w=1u l=1u
X3295 VDD VSS.t3239 VDD VDD sg13_lv_pmos ad=0.34p pd=2.68u as=0 ps=0 w=1u l=1u
X3296 VDD VSS.t399 VDD VDD sg13_lv_pmos ad=0.19p pd=1.38u as=0 ps=0 w=1u l=1u
X3297 VDD VSS.t446 VDD VDD sg13_lv_pmos ad=0.19p pd=1.38u as=0 ps=0 w=1u l=1u
X3298 sg13g2_dfrbpq_1_4.D a_25974_16020# VSS.t77 VSS.t248 sg13_lv_nmos ad=0.2516p pd=2.16u as=0.1426p ps=1.16u w=0.74u l=0.13u
X3299 VSS.t2510 VDD VSS.t2512 VSS.t2511 sg13_lv_nmos ad=79.8f pd=0.8u as=0 ps=0 w=0.42u l=1u
X3300 VSS.t2008 VDD VSS.t2010 VSS.t2009 sg13_lv_nmos ad=79.8f pd=0.8u as=0 ps=0 w=0.42u l=1u
X3301 VDD VSS.t1808 VDD VDD sg13_lv_pmos ad=0.19p pd=1.38u as=0 ps=0 w=1u l=1u
X3302 VDD VSS.t3042 VDD VDD sg13_lv_pmos ad=0.19p pd=1.38u as=0 ps=0 w=1u l=1u
X3303 a_10325_14854# sg13g2_buf_4_0.X VSS.t32 VSS.t3278 sg13_lv_nmos ad=0.1406p pd=1.12u as=0.1898p ps=1.36u w=0.74u l=0.13u
X3304 VSS.t152 a_19630_15238# sg13g2_dfrbpq_1_7.CLK VSS.t3 sg13_lv_nmos ad=0.1406p pd=1.12u as=0.1406p ps=1.12u w=0.74u l=0.13u
X3305 VDD VSS.t1638 VDD VDD sg13_lv_pmos ad=0.19p pd=1.38u as=0 ps=0 w=1u l=1u
X3306 VSS.t285 VDD VSS.t285 VSS.t679 sg13_lv_nmos ad=0.1428p pd=1.52u as=0 ps=0 w=0.42u l=1u
X3307 VDD VSS.t651 VDD VDD sg13_lv_pmos ad=0.34p pd=2.68u as=0 ps=0 w=1u l=1u
X3308 VDD VSS.t700 VDD VDD sg13_lv_pmos ad=0.34p pd=2.68u as=0 ps=0 w=1u l=1u
X3309 VDD VSS.t273 VDD VDD sg13_lv_pmos ad=0.19p pd=1.38u as=0 ps=0 w=1u l=1u
X3310 VSS.t276 sg13g2_nand2_2_0.Y sg13g2_nor4_2_0.Y VSS.t7 sg13_lv_nmos ad=0.1406p pd=1.12u as=0.1406p ps=1.12u w=0.74u l=0.13u
X3311 VSS.t1354 VDD VSS.t1353 VSS.t305 sg13_lv_nmos ad=0.1428p pd=1.52u as=0 ps=0 w=0.42u l=1u
X3312 VSS.t2729 VDD VSS.t2728 VSS.t2710 sg13_lv_nmos ad=0.1428p pd=1.52u as=0 ps=0 w=0.42u l=1u
X3313 VSS.t408 VDD VSS.t410 VSS.t409 sg13_lv_nmos ad=79.8f pd=0.8u as=0 ps=0 w=0.42u l=1u
X3314 VDD VSS.t1392 VDD VDD sg13_lv_pmos ad=0.19p pd=1.38u as=0 ps=0 w=1u l=1u
X3315 VDD VSS.t2775 VDD VDD sg13_lv_pmos ad=0.19p pd=1.38u as=0 ps=0 w=1u l=1u
X3316 VDD VSS.t2452 VDD VDD sg13_lv_pmos ad=0.19p pd=1.38u as=0 ps=0 w=1u l=1u
X3317 VSS.t92 VDD VSS.t498 VSS.t497 sg13_lv_nmos ad=79.8f pd=0.8u as=0 ps=0 w=0.42u l=1u
X3318 VSS.t545 VDD VSS.t545 VSS.t548 sg13_lv_nmos ad=0.1428p pd=1.52u as=0 ps=0 w=0.42u l=1u
X3319 VSS.t2753 VDD VSS.t2754 VSS.t2710 sg13_lv_nmos ad=79.8f pd=0.8u as=0 ps=0 w=0.42u l=1u
X3320 VSS.t2785 VDD VSS.t2786 VSS.t2710 sg13_lv_nmos ad=79.8f pd=0.8u as=0 ps=0 w=0.42u l=1u
X3321 a_15610_13690# sg13g2_dlygate4sd3_1_9.A VSS.t20 VSS.t361 sg13_lv_nmos ad=0.1428p pd=1.52u as=79.8f ps=0.8u w=0.42u l=0.13u
X3322 VDD VSS.t545 VDD VDD sg13_lv_pmos ad=0.34p pd=2.68u as=0 ps=0 w=1u l=1u
X3323 VSS.t1948 VDD VSS.t1947 VSS.t1946 sg13_lv_nmos ad=0.1428p pd=1.52u as=0 ps=0 w=0.42u l=1u
X3324 VSS.t1389 VDD VSS.t1390 VSS.t305 sg13_lv_nmos ad=79.8f pd=0.8u as=0 ps=0 w=0.42u l=1u
X3325 VDD VSS.t1788 VDD VDD sg13_lv_pmos ad=0.19p pd=1.38u as=0 ps=0 w=1u l=1u
X3326 VDD VSS.t3082 VDD VDD sg13_lv_pmos ad=0.19p pd=1.38u as=0 ps=0 w=1u l=1u
X3327 VDD VSS.t1945 VDD VDD sg13_lv_pmos ad=0.19p pd=1.38u as=0 ps=0 w=1u l=1u
X3328 VDD VSS.t331 VDD VDD sg13_lv_pmos ad=0.34p pd=2.68u as=0 ps=0 w=1u l=1u
X3329 VDD VSS.t2786 VDD VDD sg13_lv_pmos ad=0.34p pd=2.68u as=0 ps=0 w=1u l=1u
X3330 VSS.t540 VDD VSS.t540 VSS.t595 sg13_lv_nmos ad=79.8f pd=0.8u as=0 ps=0 w=0.42u l=1u
X3331 VDD VSS.t2 VDD VDD sg13_lv_pmos ad=0.34p pd=2.68u as=0 ps=0 w=1u l=1u
X3332 VDD VSS.t2857 VDD VDD sg13_lv_pmos ad=0.19p pd=1.38u as=0 ps=0 w=1u l=1u
X3333 VSS.t3100 VDD VSS.t3102 VSS.t3101 sg13_lv_nmos ad=79.8f pd=0.8u as=0 ps=0 w=0.42u l=1u
X3334 VSS.t2153 VDD VSS.t2152 VSS.t2151 sg13_lv_nmos ad=0.1428p pd=1.52u as=0 ps=0 w=0.42u l=1u
X3335 VSS.t126 sg13g2_buf_16_1.X a_19630_15238# VSS.t3 sg13_lv_nmos ad=0.1406p pd=1.12u as=0.1406p ps=1.12u w=0.74u l=0.13u
X3336 VDD VSS.t545 VDD VDD sg13_lv_pmos ad=0.19p pd=1.38u as=0 ps=0 w=1u l=1u
X3337 VDD VSS.t1113 VDD VDD sg13_lv_pmos ad=0.34p pd=2.68u as=0 ps=0 w=1u l=1u
X3338 VDD VSS.t676 VDD VDD sg13_lv_pmos ad=0.19p pd=1.38u as=0 ps=0 w=1u l=1u
X3339 VSS.t705 VDD VSS.t705 VSS.t712 sg13_lv_nmos ad=79.8f pd=0.8u as=0 ps=0 w=0.42u l=1u
X3340 VSS.t2495 VDD VSS.t2497 VSS.t2496 sg13_lv_nmos ad=79.8f pd=0.8u as=0 ps=0 w=0.42u l=1u
X3341 VSS.t35 a_17038_15423# sg13g2_a21oi_1_0.A1 VSS.t21 sg13_lv_nmos ad=0.1426p pd=1.16u as=0.2516p ps=2.16u w=0.74u l=0.13u
X3342 VSS.t1397 VDD VSS.t1398 VSS.t305 sg13_lv_nmos ad=79.8f pd=0.8u as=0 ps=0 w=0.42u l=1u
X3343 a_11076_14488# a_11050_14452# VDD VDD sg13_lv_pmos ad=0.34p pd=2.68u as=0.36237p ps=2.605u w=1u l=0.13u
X3344 VDD VSS.t1583 VDD VDD sg13_lv_pmos ad=0.19p pd=1.38u as=0 ps=0 w=1u l=1u
X3345 VDD VSS.t3054 VDD VDD sg13_lv_pmos ad=0.34p pd=2.68u as=0 ps=0 w=1u l=1u
X3346 VSS.t1661 VDD VSS.t1663 VSS.t1662 sg13_lv_nmos ad=79.8f pd=0.8u as=0 ps=0 w=0.42u l=1u
X3347 VDD VSS.t2162 VDD VDD sg13_lv_pmos ad=0.34p pd=2.68u as=0 ps=0 w=1u l=1u
X3348 VSS.t919 VDD VSS.t921 VSS.t920 sg13_lv_nmos ad=79.8f pd=0.8u as=0 ps=0 w=0.42u l=1u
X3349 VDD VSS.t2747 VDD VDD sg13_lv_pmos ad=0.19p pd=1.38u as=0 ps=0 w=1u l=1u
X3350 VSS.t1983 VDD VSS.t1982 VSS.t1981 sg13_lv_nmos ad=0.1428p pd=1.52u as=0 ps=0 w=0.42u l=1u
X3351 VDD VSS.t1316 VDD VDD sg13_lv_pmos ad=0.19p pd=1.38u as=0 ps=0 w=1u l=1u
X3352 VSS.t2830 VDD VSS.t2829 VSS.t2710 sg13_lv_nmos ad=0.1428p pd=1.52u as=0 ps=0 w=0.42u l=1u
X3353 VDD VSS.t2110 VDD VDD sg13_lv_pmos ad=0.19p pd=1.38u as=0 ps=0 w=1u l=1u
X3354 a_19630_15238# sg13g2_buf_16_1.X VSS.t103 VSS.t224 sg13_lv_nmos ad=0.1406p pd=1.12u as=0.1406p ps=1.12u w=0.74u l=0.13u
X3355 VSS.t2525 VDD VSS.t2524 VSS.t2523 sg13_lv_nmos ad=0.1428p pd=1.52u as=0 ps=0 w=0.42u l=1u
X3356 VSS.t1781 VDD VSS.t1783 VSS.t1782 sg13_lv_nmos ad=79.8f pd=0.8u as=0 ps=0 w=0.42u l=1u
X3357 VDD VSS.t2062 VDD VDD sg13_lv_pmos ad=0.34p pd=2.68u as=0 ps=0 w=1u l=1u
X3358 VSS.t796 VDD VSS.t173 VSS.t797 sg13_lv_nmos ad=79.8f pd=0.8u as=0 ps=0 w=0.42u l=1u
X3359 VSS.t2173 VDD VSS.t2172 VSS.t2171 sg13_lv_nmos ad=0.1428p pd=1.52u as=0 ps=0 w=0.42u l=1u
X3360 VSS.t1993 VDD VSS.t1995 VSS.t1994 sg13_lv_nmos ad=79.8f pd=0.8u as=0 ps=0 w=0.42u l=1u
X3361 VDD VSS.t1793 VDD VDD sg13_lv_pmos ad=0.19p pd=1.38u as=0 ps=0 w=1u l=1u
X3362 VSS.t3085 VDD VSS.t3087 VSS.t3086 sg13_lv_nmos ad=79.8f pd=0.8u as=0 ps=0 w=0.42u l=1u
X3363 VSS.t66 a_16078_14484# sg13g2_buf_16_1.X VSS.t37 sg13_lv_nmos ad=0.1406p pd=1.12u as=0.1406p ps=1.12u w=0.74u l=0.13u
X3364 a_25956_14909# a_25668_14488# a_25894_14909# VSS.t132 sg13_lv_nmos ad=0.1428p pd=1.52u as=37.8f ps=0.6u w=0.42u l=0.13u
X3365 VDD VSS.t3027 VDD VDD sg13_lv_pmos ad=0.19p pd=1.38u as=0 ps=0 w=1u l=1u
X3366 VSS.t2590 VDD VSS.t2592 VSS.t2591 sg13_lv_nmos ad=79.8f pd=0.8u as=0 ps=0 w=0.42u l=1u
X3367 VDD VSS.t1745 VDD VDD sg13_lv_pmos ad=0.34p pd=2.68u as=0 ps=0 w=1u l=1u
X3368 VDD VSS.t888 VDD VDD sg13_lv_pmos ad=0.34p pd=2.68u as=0 ps=0 w=1u l=1u
X3369 VDD VSS.t1623 VDD VDD sg13_lv_pmos ad=0.19p pd=1.38u as=0 ps=0 w=1u l=1u
X3370 VDD VSS.t1800 VDD VDD sg13_lv_pmos ad=0.34p pd=2.68u as=0 ps=0 w=1u l=1u
X3371 VDD a_8495_15311# a_9162_15532# VDD sg13_lv_pmos ad=0.2128p pd=1.5u as=0.3864p ps=2.93u w=1.12u l=0.13u
X3372 VSS.t1380 VDD VSS.t1379 VSS.t305 sg13_lv_nmos ad=0.1428p pd=1.52u as=0 ps=0 w=0.42u l=1u
X3373 VDD VSS.t2429 VDD VDD sg13_lv_pmos ad=0.34p pd=2.68u as=0 ps=0 w=1u l=1u
X3374 VDD a_9269_13726# sg13g2_buf_4_0.X VDD sg13_lv_pmos ad=0.2128p pd=1.5u as=0.2128p ps=1.5u w=1.12u l=0.13u
X3375 VSS.t179 VDD VSS.t179 VSS.t525 sg13_lv_nmos ad=0.1428p pd=1.52u as=0 ps=0 w=0.42u l=1u
X3376 VSS.t1373 VDD VSS.t1374 VSS.t305 sg13_lv_nmos ad=79.8f pd=0.8u as=0 ps=0 w=0.42u l=1u
X3377 VDD VSS.t2005 VDD VDD sg13_lv_pmos ad=0.19p pd=1.38u as=0 ps=0 w=1u l=1u
X3378 VDD VSS.t569 VDD VDD sg13_lv_pmos ad=0.19p pd=1.38u as=0 ps=0 w=1u l=1u
X3379 VDD VSS.t941 VDD VDD sg13_lv_pmos ad=0.19p pd=1.38u as=0 ps=0 w=1u l=1u
X3380 VDD VSS.t2324 VDD VDD sg13_lv_pmos ad=0.34p pd=2.68u as=0 ps=0 w=1u l=1u
X3381 a_13642_14452# a_14085_14495# a_13382_14922# VSS.t268 sg13_lv_nmos ad=79.8f pd=0.8u as=0.1296p ps=1.52u w=0.42u l=0.13u
X3382 VSS.t2971 VDD VSS.t2840 VSS.t2710 sg13_lv_nmos ad=0.1428p pd=1.52u as=0 ps=0 w=0.42u l=1u
X3383 VDD VSS.t2130 VDD VDD sg13_lv_pmos ad=0.19p pd=1.38u as=0 ps=0 w=1u l=1u
X3384 VDD VSS.t458 VDD VDD sg13_lv_pmos ad=0.34p pd=2.68u as=0 ps=0 w=1u l=1u
X3385 VDD VSS.t1358 VDD VDD sg13_lv_pmos ad=0.19p pd=1.38u as=0 ps=0 w=1u l=1u
X3386 VDD VSS.t1307 VDD VDD sg13_lv_pmos ad=0.19p pd=1.38u as=0 ps=0 w=1u l=1u
X3387 VDD VSS.t2815 VDD VDD sg13_lv_pmos ad=0.19p pd=1.38u as=0 ps=0 w=1u l=1u
X3388 VSS.t2510 VDD VSS.t2509 VSS.t2508 sg13_lv_nmos ad=0.1428p pd=1.52u as=0 ps=0 w=0.42u l=1u
X3389 VSS.t1933 VDD VSS.t1932 VSS.t1931 sg13_lv_nmos ad=0.1428p pd=1.52u as=0 ps=0 w=0.42u l=1u
X3390 a_4912_15454# sg13g2_tiehi_1.L_HI VDD VDD sg13_lv_pmos ad=79.8f pd=0.8u as=2.4406p ps=15.34u w=0.42u l=0.13u
X3391 VDD VSS.t1773 VDD VDD sg13_lv_pmos ad=0.19p pd=1.38u as=0 ps=0 w=1u l=1u
X3392 VDD VSS.t3244 VDD VDD sg13_lv_pmos ad=0.34p pd=2.68u as=0 ps=0 w=1u l=1u
X3393 a_6950_15234# sg13g2_and2_1_1.X VDD VDD sg13_lv_pmos ad=79.8f pd=0.8u as=0.1428p ps=1.52u w=0.42u l=0.13u
X3394 VSS.t2788 VDD VSS.t2787 VSS.t2710 sg13_lv_nmos ad=0.1428p pd=1.52u as=0 ps=0 w=0.42u l=1u
X3395 VSS.t974 VDD VSS.t976 VSS.t975 sg13_lv_nmos ad=79.8f pd=0.8u as=0 ps=0 w=0.42u l=1u
X3396 VDD VSS.t1778 VDD VDD sg13_lv_pmos ad=0.19p pd=1.38u as=0 ps=0 w=1u l=1u
X3397 VDD sg13g2_xor2_1_1.B a_13652_14020# VDD sg13_lv_pmos ad=0.2128p pd=1.5u as=0.2128p ps=1.5u w=1.12u l=0.13u
X3398 VSS.t1736 VDD VSS.t1735 VSS.t1734 sg13_lv_nmos ad=0.1428p pd=1.52u as=0 ps=0 w=0.42u l=1u
X3399 VSS.t3265 VDD VSS.t3264 VSS.t3263 sg13_lv_nmos ad=0.1428p pd=1.52u as=0 ps=0 w=0.42u l=1u
X3400 VSS.t22 a_16078_14484# sg13g2_buf_16_1.X VSS.t37 sg13_lv_nmos ad=0.1406p pd=1.12u as=0.1406p ps=1.12u w=0.74u l=0.13u
X3401 VSS.t2575 VDD VSS.t2577 VSS.t2576 sg13_lv_nmos ad=79.8f pd=0.8u as=0 ps=0 w=0.42u l=1u
X3402 VDD VSS.t2462 VDD VDD sg13_lv_pmos ad=0.19p pd=1.38u as=0 ps=0 w=1u l=1u
X3403 a_22508_15960# sg13g2_dlygate4sd3_1_11.A VSS.t235 VSS.t236 sg13_lv_nmos ad=0.187p pd=1.78u as=0.14875p ps=1.16u w=0.55u l=0.13u
X3404 VSS.t914 VDD VSS.t913 VSS.t912 sg13_lv_nmos ad=0.1428p pd=1.52u as=0 ps=0 w=0.42u l=1u
X3405 VSS.t2732 VDD VSS.t2731 VSS.t2710 sg13_lv_nmos ad=0.1428p pd=1.52u as=0 ps=0 w=0.42u l=1u
X3406 a_14085_14495# sg13g2_dfrbpq_1_2.CLK VDD VDD sg13_lv_pmos ad=0.4088p pd=2.97u as=2.6415p ps=17.17u w=1.12u l=0.13u
X3407 VDD VSS.t2778 VDD VDD sg13_lv_pmos ad=0.19p pd=1.38u as=0 ps=0 w=1u l=1u
X3408 VSS.t2480 VDD VSS.t2482 VSS.t2481 sg13_lv_nmos ad=79.8f pd=0.8u as=0 ps=0 w=0.42u l=1u
X3409 VSS.t2043 VDD VSS.t2042 VSS.t2041 sg13_lv_nmos ad=0.1428p pd=1.52u as=0 ps=0 w=0.42u l=1u
X3410 VSS.t849 VDD VSS.t851 VSS.t850 sg13_lv_nmos ad=79.8f pd=0.8u as=0 ps=0 w=0.42u l=1u
X3411 VSS.t2822 VDD VSS.t2823 VSS.t2710 sg13_lv_nmos ad=79.8f pd=0.8u as=0 ps=0 w=0.42u l=1u
X3412 VSS.t919 VDD VSS.t921 VSS.t920 sg13_lv_nmos ad=79.8f pd=0.8u as=0 ps=0 w=0.42u l=1u
X3413 VSS.t1316 VDD VSS.t1315 VSS.t305 sg13_lv_nmos ad=0.1428p pd=1.52u as=0 ps=0 w=0.42u l=1u
X3414 VDD VSS.t1568 VDD VDD sg13_lv_pmos ad=0.19p pd=1.38u as=0 ps=0 w=1u l=1u
X3415 VDD VSS.t3039 VDD VDD sg13_lv_pmos ad=0.34p pd=2.68u as=0 ps=0 w=1u l=1u
X3416 VDD VSS.t2147 VDD VDD sg13_lv_pmos ad=0.34p pd=2.68u as=0 ps=0 w=1u l=1u
X3417 VSS.t1646 VDD VSS.t1648 VSS.t1647 sg13_lv_nmos ad=79.8f pd=0.8u as=0 ps=0 w=0.42u l=1u
X3418 VDD VSS.t487 VDD VDD sg13_lv_pmos ad=0.19p pd=1.38u as=0 ps=0 w=1u l=1u
X3419 VDD VSS.t2517 VDD VDD sg13_lv_pmos ad=0.19p pd=1.38u as=0 ps=0 w=1u l=1u
X3420 VSS.t669 VDD VSS.t16 VSS.t668 sg13_lv_nmos ad=0.1428p pd=1.52u as=0 ps=0 w=0.42u l=1u
X3421 VDD a_26458_16237# sg13g2_dfrbpq_1_4.RESET_B VDD sg13_lv_pmos ad=2.4406p pd=15.34u as=0.3927p ps=2.99u w=1.155u l=0.13u
X3422 VSS.t1321 VDD VSS.t1320 VSS.t305 sg13_lv_nmos ad=0.1428p pd=1.52u as=0 ps=0 w=0.42u l=1u
X3423 VDD VSS.t1758 VDD VDD sg13_lv_pmos ad=0.19p pd=1.38u as=0 ps=0 w=1u l=1u
X3424 VDD VSS.t1950 VDD VDD sg13_lv_pmos ad=0.19p pd=1.38u as=0 ps=0 w=1u l=1u
X3425 VSS.t2123 VDD VSS.t2125 VSS.t2124 sg13_lv_nmos ad=79.8f pd=0.8u as=0 ps=0 w=0.42u l=1u
X3426 VDD a_4666_14448# a_4385_14750# VDD sg13_lv_pmos ad=0.1523p pd=1.38u as=0.34p ps=2.68u w=1u l=0.5u
X3427 VDD sg13g2_dfrbpq_1_6.RESET_B a_18470_14922# VDD sg13_lv_pmos ad=0.36237p pd=2.605u as=79.8f ps=0.8u w=0.42u l=0.13u
X3428 VSS.t944 VDD VSS.t943 VSS.t942 sg13_lv_nmos ad=0.1428p pd=1.52u as=0 ps=0 w=0.42u l=1u
X3429 VSS.t1243 VDD VSS.t1242 VSS.t305 sg13_lv_nmos ad=0.1428p pd=1.52u as=0 ps=0 w=0.42u l=1u
X3430 VDD VSS.t2047 VDD VDD sg13_lv_pmos ad=0.34p pd=2.68u as=0 ps=0 w=1u l=1u
X3431 VSS.t1283 VDD VSS.t1284 VSS.t305 sg13_lv_nmos ad=79.8f pd=0.8u as=0 ps=0 w=0.42u l=1u
X3432 VSS.t3250 VDD VSS.t3249 VSS.t3248 sg13_lv_nmos ad=0.1428p pd=1.52u as=0 ps=0 w=0.42u l=1u
X3433 VSS.t2158 VDD VSS.t2157 VSS.t2156 sg13_lv_nmos ad=0.1428p pd=1.52u as=0 ps=0 w=0.42u l=1u
X3434 VDD VSS.t1121 VDD VDD sg13_lv_pmos ad=0.19p pd=1.38u as=0 ps=0 w=1u l=1u
X3435 sg13g2_buf_1_9.X.t0 a_1192_9948# VDD VDD sg13_lv_pmos ad=0.42p pd=2.99u as=0.2114p ps=1.54u w=1.12u l=0.13u
X3436 VDD VSS.t1730 VDD VDD sg13_lv_pmos ad=0.34p pd=2.68u as=0 ps=0 w=1u l=1u
X3437 VSS.t807 VDD VSS.t693 VSS.t806 sg13_lv_nmos ad=0.1428p pd=1.52u as=0 ps=0 w=0.42u l=1u
X3438 VSS.t1248 VDD VSS.t1247 VSS.t305 sg13_lv_nmos ad=0.1428p pd=1.52u as=0 ps=0 w=0.42u l=1u
X3439 VDD VSS.t1785 VDD VDD sg13_lv_pmos ad=0.34p pd=2.68u as=0 ps=0 w=1u l=1u
X3440 VSS.t1636 VDD VSS.t1638 VSS.t1637 sg13_lv_nmos ad=79.8f pd=0.8u as=0 ps=0 w=0.42u l=1u
X3441 VSS.t2530 VDD VSS.t2529 VSS.t2528 sg13_lv_nmos ad=0.1428p pd=1.52u as=0 ps=0 w=0.42u l=1u
X3442 VDD VSS.t2414 VDD VDD sg13_lv_pmos ad=0.34p pd=2.68u as=0 ps=0 w=1u l=1u
X3443 VSS.t89 sg13g2_dfrbpq_1_3.RESET_B a_13476_14922# VSS.t3307 sg13_lv_nmos ad=0.1626p pd=1.415u as=60.89999f ps=0.71u w=0.42u l=0.13u
X3444 a_27184_14726# sg13g2_dfrbpq_1_5.RESET_B VDD VDD sg13_lv_pmos ad=79.8f pd=0.8u as=2.75157p ps=17.885u w=0.42u l=0.13u
X3445 VSS.t1004 VDD VSS.t1006 VSS.t1005 sg13_lv_nmos ad=79.8f pd=0.8u as=0 ps=0 w=0.42u l=1u
X3446 VDD VSS.t871 VDD VDD sg13_lv_pmos ad=0.19p pd=1.38u as=0 ps=0 w=1u l=1u
X3447 VSS.t2712 VDD VSS.t2713 VSS.t2710 sg13_lv_nmos ad=79.8f pd=0.8u as=0 ps=0 w=0.42u l=1u
X3448 VDD a_25862_15996# a_25974_16020# VDD sg13_lv_pmos ad=0.2254p pd=1.53u as=0.34p ps=2.68u w=1u l=0.5u
X3449 sg13g2_and2_1_2.X a_10605_13768# VSS.t28 VSS.t27 sg13_lv_nmos ad=0.2516p pd=2.16u as=0.1331p ps=1.12u w=0.74u l=0.13u
X3450 VDD VSS.t729 VDD VDD sg13_lv_pmos ad=0.34p pd=2.68u as=0 ps=0 w=1u l=1u
X3451 VDD VSS.t1588 VDD VDD sg13_lv_pmos ad=0.19p pd=1.38u as=0 ps=0 w=1u l=1u
X3452 VDD a_26927_14845# a_27594_14484# VDD sg13_lv_pmos ad=0.2128p pd=1.5u as=0.3864p ps=2.93u w=1.12u l=0.13u
X3453 VDD VSS.t2167 VDD VDD sg13_lv_pmos ad=0.34p pd=2.68u as=0 ps=0 w=1u l=1u
X3454 VSS.t1631 VDD VSS.t1633 VSS.t1632 sg13_lv_nmos ad=79.8f pd=0.8u as=0 ps=0 w=0.42u l=1u
X3455 VDD VSS.t540 VDD VDD sg13_lv_pmos ad=0.34p pd=2.68u as=0 ps=0 w=1u l=1u
X3456 VSS.t714 VDD VSS.t719 VSS.t834 sg13_lv_nmos ad=79.8f pd=0.8u as=0 ps=0 w=0.42u l=1u
X3457 VSS.t1988 VDD VSS.t1987 VSS.t1986 sg13_lv_nmos ad=0.1428p pd=1.52u as=0 ps=0 w=0.42u l=1u
X3458 a_25382_14922# a_26187_14495# a_25642_14452# VDD sg13_lv_pmos ad=0.1428p pd=1.52u as=79.8f ps=0.8u w=0.42u l=0.13u
X3459 VDD VSS.t1382 VDD VDD sg13_lv_pmos ad=0.34p pd=2.68u as=0 ps=0 w=1u l=1u
X3460 VSS.t1266 VDD VSS.t1265 VSS.t305 sg13_lv_nmos ad=0.1428p pd=1.52u as=0 ps=0 w=0.42u l=1u
X3461 VSS.t2963 VDD VSS.t2832 VSS.t2710 sg13_lv_nmos ad=0.1428p pd=1.52u as=0 ps=0 w=0.42u l=1u
X3462 VDD VSS.t2713 VDD VDD sg13_lv_pmos ad=0.34p pd=2.68u as=0 ps=0 w=1u l=1u
X3463 VSS.t647 VDD VSS.t649 VSS.t648 sg13_lv_nmos ad=79.8f pd=0.8u as=0 ps=0 w=0.42u l=1u
X3464 VDD VSS.t1298 VDD VDD sg13_lv_pmos ad=0.19p pd=1.38u as=0 ps=0 w=1u l=1u
X3465 VDD VSS.t2807 VDD VDD sg13_lv_pmos ad=0.19p pd=1.38u as=0 ps=0 w=1u l=1u
X3466 VDD sg13g2_xor2_1_1.A sg13g2_nand2_2_0.Y VDD sg13_lv_pmos ad=0.2184p pd=1.51u as=0.2128p ps=1.5u w=1.12u l=0.13u
X3467 VSS.t1334 VDD VSS.t1333 VSS.t305 sg13_lv_nmos ad=0.1428p pd=1.52u as=0 ps=0 w=0.42u l=1u
X3468 VSS.t2495 VDD VSS.t2494 VSS.t2493 sg13_lv_nmos ad=0.1428p pd=1.52u as=0 ps=0 w=0.42u l=1u
X3469 sg13g2_inv_1_0.Y sg13g2_buf_1_9.X.t3 VSS.t56 VSS.t55 sg13_lv_nmos ad=0.2516p pd=2.16u as=0.2516p ps=2.16u w=0.74u l=0.13u
X3470 VSS.t974 VDD VSS.t976 VSS.t975 sg13_lv_nmos ad=79.8f pd=0.8u as=0 ps=0 w=0.42u l=1u
X3471 VSS.t1786 VDD VSS.t1788 VSS.t1787 sg13_lv_nmos ad=79.8f pd=0.8u as=0 ps=0 w=0.42u l=1u
X3472 sg13g2_mux2_1_1.X a_24766_14854# VDD VDD sg13_lv_pmos ad=0.6048p pd=3.32u as=0.2198p ps=1.52u w=1.12u l=0.13u
X3473 VDD VSS.t664 VDD VDD sg13_lv_pmos ad=0.34p pd=2.68u as=0 ps=0 w=1u l=1u
X3474 VDD VSS.t1088 VDD VDD sg13_lv_pmos ad=0.34p pd=2.68u as=0 ps=0 w=1u l=1u
X3475 VSS.t914 VDD VSS.t913 VSS.t912 sg13_lv_nmos ad=0.1428p pd=1.52u as=0 ps=0 w=0.42u l=1u
X3476 VSS.t2560 VDD VSS.t2562 VSS.t2561 sg13_lv_nmos ad=79.8f pd=0.8u as=0 ps=0 w=0.42u l=1u
X3477 VDD VSS.t1628 VDD VDD sg13_lv_pmos ad=0.19p pd=1.38u as=0 ps=0 w=1u l=1u
X3478 VSS.t2831 VDD VSS.t2830 VSS.t2710 sg13_lv_nmos ad=0.1428p pd=1.52u as=0 ps=0 w=0.42u l=1u
X3479 VDD VSS.t1962 VDD VDD sg13_lv_pmos ad=0.34p pd=2.68u as=0 ps=0 w=1u l=1u
X3480 VDD a_27322_13690# a_27041_13912# VDD sg13_lv_pmos ad=0.1523p pd=1.38u as=0.34p ps=2.68u w=1u l=0.5u
X3481 VSS.t700 VDD VSS.t700 VSS.t701 sg13_lv_nmos ad=79.8f pd=0.8u as=0 ps=0 w=0.42u l=1u
X3482 VDD VSS.t1311 VDD VDD sg13_lv_pmos ad=0.19p pd=1.38u as=0 ps=0 w=1u l=1u
X3483 VSS.t849 VDD VSS.t851 VSS.t850 sg13_lv_nmos ad=79.8f pd=0.8u as=0 ps=0 w=0.42u l=1u
X3484 VDD VSS.t1026 VDD VDD sg13_lv_pmos ad=0.19p pd=1.38u as=0 ps=0 w=1u l=1u
X3485 VSS.t1275 VDD VSS.t1274 VSS.t305 sg13_lv_nmos ad=0.1428p pd=1.52u as=0 ps=0 w=0.42u l=1u
X3486 a_3396_15552# a_3370_15457# VSS.t258 VSS.t212 sg13_lv_nmos ad=0.2516p pd=2.16u as=0.1626p ps=1.415u w=0.74u l=0.13u
X3487 VSS.t2722 VDD VSS.t2722 VSS.t2710 sg13_lv_nmos ad=0.1428p pd=1.52u as=0 ps=0 w=0.42u l=1u
X3488 VDD VSS.t2770 VDD VDD sg13_lv_pmos ad=0.19p pd=1.38u as=0 ps=0 w=1u l=1u
X3489 VSS.t3120 VDD VSS.t3119 VSS.t3118 sg13_lv_nmos ad=0.1428p pd=1.52u as=0 ps=0 w=0.42u l=1u
X3490 VDD VSS.t42 VDD VDD sg13_lv_pmos ad=0.19p pd=1.38u as=0 ps=0 w=1u l=1u
X3491 VSS.t437 VDD VSS.t436 VSS.t435 sg13_lv_nmos ad=0.1428p pd=1.52u as=0 ps=0 w=0.42u l=1u
X3492 VDD VSS.t469 VDD VDD sg13_lv_pmos ad=0.34p pd=2.68u as=0 ps=0 w=1u l=1u
X3493 VSS.t1581 VDD VSS.t1583 VSS.t1582 sg13_lv_nmos ad=79.8f pd=0.8u as=0 ps=0 w=0.42u l=1u
X3494 VSS.t1811 VDD VSS.t1810 VSS.t1809 sg13_lv_nmos ad=0.1428p pd=1.52u as=0 ps=0 w=0.42u l=1u
X3495 VSS.t1973 VDD VSS.t1972 VSS.t1971 sg13_lv_nmos ad=0.1428p pd=1.52u as=0 ps=0 w=0.42u l=1u
X3496 VDD VSS.t1593 VDD VDD sg13_lv_pmos ad=0.19p pd=1.38u as=0 ps=0 w=1u l=1u
X3497 VDD VSS.t2502 VDD VDD sg13_lv_pmos ad=0.19p pd=1.38u as=0 ps=0 w=1u l=1u
X3498 a_19546_12936# sg13g2_dlygate4sd3_1_11.A VDD VDD sg13_lv_pmos ad=0.1428p pd=1.52u as=0.1523p ps=1.38u w=0.42u l=0.13u
X3499 VSS.t944 VDD VSS.t943 VSS.t942 sg13_lv_nmos ad=0.1428p pd=1.52u as=0 ps=0 w=0.42u l=1u
X3500 VSS.t1487 VDD VSS.t1345 VSS.t305 sg13_lv_nmos ad=0.1428p pd=1.52u as=0 ps=0 w=0.42u l=1u
X3501 VDD VSS.t1310 VDD VDD sg13_lv_pmos ad=0.19p pd=1.38u as=0 ps=0 w=1u l=1u
X3502 VDD VSS.t2817 VDD VDD sg13_lv_pmos ad=0.19p pd=1.38u as=0 ps=0 w=1u l=1u
X3503 VSS.t2515 VDD VSS.t2514 VSS.t2513 sg13_lv_nmos ad=0.1428p pd=1.52u as=0 ps=0 w=0.42u l=1u
X3504 VDD VSS.t2100 VDD VDD sg13_lv_pmos ad=0.19p pd=1.38u as=0 ps=0 w=1u l=1u
X3505 VDD VSS.t3214 VDD VDD sg13_lv_pmos ad=0.34p pd=2.68u as=0 ps=0 w=1u l=1u
X3506 VDD VSS.t2454 VDD VDD sg13_lv_pmos ad=0.34p pd=2.68u as=0 ps=0 w=1u l=1u
X3507 VDD VSS.t1935 VDD VDD sg13_lv_pmos ad=0.19p pd=1.38u as=0 ps=0 w=1u l=1u
X3508 sg13g2_dlygate4sd3_1_3.A sg13g2_or3_1_0.A a_17014_13350# VSS.t130 sg13_lv_nmos ad=0.2516p pd=2.16u as=0.1406p ps=1.12u w=0.74u l=0.15u
X3509 VDD VSS.t1600 VDD VDD sg13_lv_pmos ad=0.34p pd=2.68u as=0 ps=0 w=1u l=1u
X3510 sg13g2_buf_16_1.X a_16078_14484# VDD VDD sg13_lv_pmos ad=0.2128p pd=1.5u as=0.2128p ps=1.5u w=1.12u l=0.13u
X3511 VSS.t475 VDD VSS.t477 VSS.t476 sg13_lv_nmos ad=79.8f pd=0.8u as=0 ps=0 w=0.42u l=1u
X3512 VDD VSS.t1783 VDD VDD sg13_lv_pmos ad=0.19p pd=1.38u as=0 ps=0 w=1u l=1u
X3513 VSS.t2063 VDD VSS.t2062 VSS.t2061 sg13_lv_nmos ad=0.1428p pd=1.52u as=0 ps=0 w=0.42u l=1u
X3514 VSS.t1114 VDD VSS.t1113 VSS.t1112 sg13_lv_nmos ad=0.1428p pd=1.52u as=0 ps=0 w=0.42u l=1u
X3515 VDD VSS.t2467 VDD VDD sg13_lv_pmos ad=0.19p pd=1.38u as=0 ps=0 w=1u l=1u
X3516 VDD VSS.t1292 VDD VDD sg13_lv_pmos ad=0.34p pd=2.68u as=0 ps=0 w=1u l=1u
X3517 VDD a_17699_16265# sg13g2_a21oi_1_0.A2 VDD sg13_lv_pmos ad=0.3822p pd=1.84u as=0.3808p ps=2.92u w=1.12u l=0.13u
X3518 VSS.t1004 VDD VSS.t1006 VSS.t1005 sg13_lv_nmos ad=79.8f pd=0.8u as=0 ps=0 w=0.42u l=1u
X3519 VDD VSS.t978 VDD VDD sg13_lv_pmos ad=0.34p pd=2.68u as=0 ps=0 w=1u l=1u
X3520 VSS.t1621 VDD VSS.t1623 VSS.t1622 sg13_lv_nmos ad=79.8f pd=0.8u as=0 ps=0 w=0.42u l=1u
X3521 VSS.t1801 VDD VSS.t1800 VSS.t1799 sg13_lv_nmos ad=0.1428p pd=1.52u as=0 ps=0 w=0.42u l=1u
X3522 VSS.t2734 VDD VSS.t2734 VSS.t2710 sg13_lv_nmos ad=0.1428p pd=1.52u as=0 ps=0 w=0.42u l=1u
X3523 VDD VSS.t2781 VDD VDD sg13_lv_pmos ad=0.19p pd=1.38u as=0 ps=0 w=1u l=1u
X3524 sg13g2_xor2_1_1.B sg13g2_dlygate4sd3_1_2.A VDD VDD sg13_lv_pmos ad=0.2128p pd=1.5u as=0.3808p ps=2.92u w=1.12u l=0.13u
X3525 VSS.t554 VDD VSS.t554 VSS.t557 sg13_lv_nmos ad=0.1428p pd=1.52u as=0 ps=0 w=0.42u l=1u
X3526 a_23788_14020# a_23566_13764# VDD VDD sg13_lv_pmos ad=0.1176p pd=1.33u as=0.2618p ps=1.63u w=1.12u l=0.13u
X3527 VSS.t2955 VDD VSS.t2825 VSS.t2710 sg13_lv_nmos ad=79.8f pd=0.8u as=0 ps=0 w=0.42u l=1u
X3528 VSS.t2013 VDD VSS.t2012 VSS.t2011 sg13_lv_nmos ad=0.1428p pd=1.52u as=0 ps=0 w=0.42u l=1u
X3529 VDD VSS.t92 VDD VDD sg13_lv_pmos ad=0.34p pd=2.68u as=0 ps=0 w=1u l=1u
X3530 VDD VSS.t545 VDD VDD sg13_lv_pmos ad=0.19p pd=1.38u as=0 ps=0 w=1u l=1u
X3531 VDD VSS.t1573 VDD VDD sg13_lv_pmos ad=0.19p pd=1.38u as=0 ps=0 w=1u l=1u
X3532 VDD VSS.t3044 VDD VDD sg13_lv_pmos ad=0.34p pd=2.68u as=0 ps=0 w=1u l=1u
X3533 sg13g2_dfrbpq_1_2.CLK a_12308_15202# VDD VDD sg13_lv_pmos ad=0.2128p pd=1.5u as=0.2128p ps=1.5u w=1.12u l=0.13u
X3534 a_12308_15202# sg13g2_buf_16_1.X VDD VDD sg13_lv_pmos ad=0.2128p pd=1.5u as=0.2128p ps=1.5u w=1.12u l=0.13u
X3535 VSS.t79 a_26927_14845# a_27594_14484# VSS.t280 sg13_lv_nmos ad=0.1406p pd=1.12u as=0.2516p ps=2.16u w=0.74u l=0.13u
X3536 VSS.t714 VDD VSS.t714 VSS.t715 sg13_lv_nmos ad=79.8f pd=0.8u as=0 ps=0 w=0.42u l=1u
X3537 VDD VSS.t1329 VDD VDD sg13_lv_pmos ad=0.19p pd=1.38u as=0 ps=0 w=1u l=1u
X3538 VSS.t1796 VDD VSS.t1795 VSS.t1794 sg13_lv_nmos ad=0.1428p pd=1.52u as=0 ps=0 w=0.42u l=1u
X3539 VSS.t2545 VDD VSS.t2547 VSS.t2546 sg13_lv_nmos ad=79.8f pd=0.8u as=0 ps=0 w=0.42u l=1u
X3540 VDD VSS.t853 VDD VDD sg13_lv_pmos ad=0.34p pd=2.68u as=0 ps=0 w=1u l=1u
X3541 VSS.t1400 VDD VSS.t1401 VSS.t305 sg13_lv_nmos ad=79.8f pd=0.8u as=0 ps=0 w=0.42u l=1u
X3542 VDD VSS.t2522 VDD VDD sg13_lv_pmos ad=0.19p pd=1.38u as=0 ps=0 w=1u l=1u
X3543 VDD VSS.t167 VDD VDD sg13_lv_pmos ad=0.19p pd=1.38u as=0 ps=0 w=1u l=1u
X3544 VDD VSS.t1393 VDD VDD sg13_lv_pmos ad=0.34p pd=2.68u as=0 ps=0 w=1u l=1u
X3545 VDD VSS.t3057 VDD VDD sg13_lv_pmos ad=0.19p pd=1.38u as=0 ps=0 w=1u l=1u
X3546 VSS.t2128 VDD VSS.t2130 VSS.t2129 sg13_lv_nmos ad=79.8f pd=0.8u as=0 ps=0 w=0.42u l=1u
X3547 a_11364_14909# a_11076_14488# a_11302_14909# VSS.t266 sg13_lv_nmos ad=0.1428p pd=1.52u as=37.8f ps=0.6u w=0.42u l=0.13u
X3548 a_24766_14854# sg13g2_nor2b_1_1.Y a_24669_14854# VSS.t7 sg13_lv_nmos ad=0.1628p pd=1.18u as=0.13135p ps=1.095u w=0.74u l=0.13u
X3549 a_2481_15556# sg13g2_buf_1_0.X VDD VDD sg13_lv_pmos ad=0.1225p pd=1.245u as=0.36p ps=2.72u w=1u l=0.13u
X3550 VSS.t545 VDD VSS.t545 VSS.t603 sg13_lv_nmos ad=79.8f pd=0.8u as=0 ps=0 w=0.42u l=1u
X3551 VSS.t1771 VDD VSS.t1773 VSS.t1772 sg13_lv_nmos ad=79.8f pd=0.8u as=0 ps=0 w=0.42u l=1u
X3552 VDD VSS.t2052 VDD VDD sg13_lv_pmos ad=0.34p pd=2.68u as=0 ps=0 w=1u l=1u
X3553 VSS.t77 sg13g2_mux2_1_1.X a_25592_16037# VSS.t206 sg13_lv_nmos ad=79.8f pd=0.8u as=0.1428p ps=1.52u w=0.42u l=0.13u
X3554 a_10176_14523# sg13g2_buf_4_0.X a_10139_14832# VSS.t3277 sg13_lv_nmos ad=0.2176p pd=1.96u as=78.39999f ps=0.885u w=0.64u l=0.13u
X3555 sg13g2_buf_16_1.X a_16078_14484# VDD VDD sg13_lv_pmos ad=0.2128p pd=1.5u as=0.2128p ps=1.5u w=1.12u l=0.13u
X3556 VDD VSS.t373 VDD VDD sg13_lv_pmos ad=0.34p pd=2.68u as=0 ps=0 w=1u l=1u
X3557 VDD VSS.t554 VDD VDD sg13_lv_pmos ad=0.19p pd=1.38u as=0 ps=0 w=1u l=1u
X3558 VDD VSS.t1270 VDD VDD sg13_lv_pmos ad=0.19p pd=1.38u as=0 ps=0 w=1u l=1u
X3559 VSS.t2755 VDD VSS.t2755 VSS.t2710 sg13_lv_nmos ad=0.1428p pd=1.52u as=0 ps=0 w=0.42u l=1u
X3560 VSS.t129 sg13g2_nand2_2_0.Y a_16681_13726# VSS.t277 sg13_lv_nmos ad=0.1045p pd=0.93u as=0.187p ps=1.78u w=0.55u l=0.13u
X3561 VDD VSS.t1735 VDD VDD sg13_lv_pmos ad=0.34p pd=2.68u as=0 ps=0 w=1u l=1u
X3562 VDD a_19630_15238# sg13g2_dfrbpq_1_7.CLK VDD sg13_lv_pmos ad=0.2128p pd=1.5u as=0.2128p ps=1.5u w=1.12u l=0.13u
X3563 a_25094_15238# a_24824_15238# VDD VDD sg13_lv_pmos ad=0.34p pd=2.68u as=0.1523p ps=1.38u w=1u l=0.5u
X3564 VSS.t719 VDD VSS.t719 VSS.t722 sg13_lv_nmos ad=79.8f pd=0.8u as=0 ps=0 w=0.42u l=1u
X3565 VDD VSS.t1337 VDD VDD sg13_lv_pmos ad=0.19p pd=1.38u as=0 ps=0 w=1u l=1u
X3566 VDD VSS.t1790 VDD VDD sg13_lv_pmos ad=0.34p pd=2.68u as=0 ps=0 w=1u l=1u
X3567 VDD VSS.t1947 VDD VDD sg13_lv_pmos ad=0.34p pd=2.68u as=0 ps=0 w=1u l=1u
X3568 sg13g2_dfrbpq_1_3.D sg13g2_dlygate4sd3_1_4.X VSS.t326 VSS.t328 sg13_lv_nmos ad=0.1406p pd=1.12u as=0.2516p ps=2.16u w=0.74u l=0.13u
X3569 VSS.t1641 VDD VSS.t1643 VSS.t1642 sg13_lv_nmos ad=79.8f pd=0.8u as=0 ps=0 w=0.42u l=1u
X3570 VSS.t3170 VDD VSS.t3172 VSS.t3171 sg13_lv_nmos ad=79.8f pd=0.8u as=0 ps=0 w=0.42u l=1u
X3571 VSS.t2375 VDD VSS.t2377 VSS.t2376 sg13_lv_nmos ad=79.8f pd=0.8u as=0 ps=0 w=0.42u l=1u
X3572 VSS.t339 VDD VSS.t339 VSS.t405 sg13_lv_nmos ad=0.1428p pd=1.52u as=0 ps=0 w=0.42u l=1u
X3573 VDD VSS.t2858 VDD VDD sg13_lv_pmos ad=0.34p pd=2.68u as=0 ps=0 w=1u l=1u
X3574 VSS.t939 VDD VSS.t941 VSS.t940 sg13_lv_nmos ad=79.8f pd=0.8u as=0 ps=0 w=0.42u l=1u
X3575 VDD VSS.t2479 VDD VDD sg13_lv_pmos ad=0.34p pd=2.68u as=0 ps=0 w=1u l=1u
X3576 VDD VSS.t1008 VDD VDD sg13_lv_pmos ad=0.34p pd=2.68u as=0 ps=0 w=1u l=1u
X3577 VSS.t1383 VDD VSS.t1382 VSS.t305 sg13_lv_nmos ad=0.1428p pd=1.52u as=0 ps=0 w=0.42u l=1u
X3578 sg13g2_dfrbpq_1_2.CLK a_12308_15202# VDD VDD sg13_lv_pmos ad=0.2128p pd=1.5u as=0.2128p ps=1.5u w=1.12u l=0.13u
X3579 VSS.t1958 VDD VSS.t1957 VSS.t1956 sg13_lv_nmos ad=0.1428p pd=1.52u as=0 ps=0 w=0.42u l=1u
X3580 VDD VSS.t2716 VDD VDD sg13_lv_pmos ad=0.34p pd=2.68u as=0 ps=0 w=1u l=1u
X3581 sg13g2_nor4_2_0.Y sg13g2_buf_4_0.X VSS.t276 VSS.t7 sg13_lv_nmos ad=0.1406p pd=1.12u as=0.1406p ps=1.12u w=0.74u l=0.13u
X3582 VDD VSS.t1301 VDD VDD sg13_lv_pmos ad=0.19p pd=1.38u as=0 ps=0 w=1u l=1u
X3583 VDD VSS.t2809 VDD VDD sg13_lv_pmos ad=0.19p pd=1.38u as=0 ps=0 w=1u l=1u
X3584 VDD VSS.t2085 VDD VDD sg13_lv_pmos ad=0.19p pd=1.38u as=0 ps=0 w=1u l=1u
X3585 VSS.t690 VDD VSS.t693 VSS.t805 sg13_lv_nmos ad=79.8f pd=0.8u as=0 ps=0 w=0.42u l=1u
X3586 VDD VSS.t2439 VDD VDD sg13_lv_pmos ad=0.34p pd=2.68u as=0 ps=0 w=1u l=1u
X3587 VSS.t2500 VDD VSS.t2499 VSS.t2498 sg13_lv_nmos ad=0.1428p pd=1.52u as=0 ps=0 w=0.42u l=1u
X3588 a_17699_16265# sg13g2_nand2_1_1.A VSS.t364 VSS.t371 sg13_lv_nmos ad=0.198p pd=1.27u as=0.13395p ps=1.12u w=0.55u l=0.13u
X3589 VDD VSS.t946 VDD VDD sg13_lv_pmos ad=0.19p pd=1.38u as=0 ps=0 w=1u l=1u
X3590 VDD VSS.t1585 VDD VDD sg13_lv_pmos ad=0.34p pd=2.68u as=0 ps=0 w=1u l=1u
X3591 VSS.t1756 VDD VSS.t1758 VSS.t1757 sg13_lv_nmos ad=79.8f pd=0.8u as=0 ps=0 w=0.42u l=1u
X3592 VSS.t1114 VDD VSS.t1113 VSS.t1112 sg13_lv_nmos ad=0.1428p pd=1.52u as=0 ps=0 w=0.42u l=1u
X3593 VSS.t1666 VDD VSS.t1665 VSS.t1664 sg13_lv_nmos ad=0.1428p pd=1.52u as=0 ps=0 w=0.42u l=1u
X3594 VDD VSS.t1768 VDD VDD sg13_lv_pmos ad=0.19p pd=1.38u as=0 ps=0 w=1u l=1u
X3595 VDD VSS.t624 VDD VDD sg13_lv_pmos ad=0.19p pd=1.38u as=0 ps=0 w=1u l=1u
X3596 VSS.t705 VDD VSS.t705 VSS.t707 sg13_lv_nmos ad=0.1428p pd=1.52u as=0 ps=0 w=0.42u l=1u
X3597 VDD VSS.t309 VDD VDD sg13_lv_pmos ad=0.19p pd=1.38u as=0 ps=0 w=1u l=1u
X3598 VDD VSS.t908 VDD VDD sg13_lv_pmos ad=0.34p pd=2.68u as=0 ps=0 w=1u l=1u
X3599 sg13g2_buf_1_0.X a_1192_3900# VSS.t2711 VSS.t2710 sg13_lv_nmos ad=0.2886p pd=2.26u as=0.14875p ps=1.16u w=0.74u l=0.13u
X3600 VSS.t2565 VDD VSS.t2567 VSS.t2566 sg13_lv_nmos ad=79.8f pd=0.8u as=0 ps=0 w=0.42u l=1u
X3601 a_13668_14488# a_13642_14452# VDD VDD sg13_lv_pmos ad=0.34p pd=2.68u as=0.36237p ps=2.605u w=1u l=0.13u
X3602 VDD VSS.t671 VDD VDD sg13_lv_pmos ad=0.19p pd=1.38u as=0 ps=0 w=1u l=1u
X3603 VDD VSS.t3104 VDD VDD sg13_lv_pmos ad=0.34p pd=2.68u as=0 ps=0 w=1u l=1u
X3604 VDD VSS.t1967 VDD VDD sg13_lv_pmos ad=0.34p pd=2.68u as=0 ps=0 w=1u l=1u
X3605 VDD VSS.t2140 VDD VDD sg13_lv_pmos ad=0.19p pd=1.38u as=0 ps=0 w=1u l=1u
X3606 VDD a_19630_15238# sg13g2_dfrbpq_1_7.CLK VDD sg13_lv_pmos ad=0.2128p pd=1.5u as=0.2128p ps=1.5u w=1.12u l=0.13u
X3607 VSS.t1786 VDD VSS.t1785 VSS.t1784 sg13_lv_nmos ad=0.1428p pd=1.52u as=0 ps=0 w=0.42u l=1u
X3608 VDD VSS.t1638 VDD VDD sg13_lv_pmos ad=0.19p pd=1.38u as=0 ps=0 w=1u l=1u
X3609 VSS.t2726 VDD VSS.t2725 VSS.t2710 sg13_lv_nmos ad=0.1428p pd=1.52u as=0 ps=0 w=0.42u l=1u
X3610 VDD VSS.t2772 VDD VDD sg13_lv_pmos ad=0.19p pd=1.38u as=0 ps=0 w=1u l=1u
X3611 a_15958_15230# sg13g2_nand3_1_1.Y VSS.t292 VSS.t21 sg13_lv_nmos ad=0.1406p pd=1.12u as=0.1406p ps=1.12u w=0.74u l=0.15u
X3612 VDD VSS.t961 VDD VDD sg13_lv_pmos ad=0.19p pd=1.38u as=0 ps=0 w=1u l=1u
X3613 VSS.t3090 VDD VSS.t3089 VSS.t3088 sg13_lv_nmos ad=0.1428p pd=1.52u as=0 ps=0 w=0.42u l=1u
X3614 VSS.t1586 VDD VSS.t1588 VSS.t1587 sg13_lv_nmos ad=79.8f pd=0.8u as=0 ps=0 w=0.42u l=1u
X3615 VDD VSS.t162 VDD VDD sg13_lv_pmos ad=0.19p pd=1.38u as=0 ps=0 w=1u l=1u
X3616 VSS.t854 VDD VSS.t856 VSS.t855 sg13_lv_nmos ad=79.8f pd=0.8u as=0 ps=0 w=0.42u l=1u
X3617 VSS.t683 VDD VSS.t683 VSS.t791 sg13_lv_nmos ad=0.1428p pd=1.52u as=0 ps=0 w=0.42u l=1u
X3618 VDD VSS.t2105 VDD VDD sg13_lv_pmos ad=0.19p pd=1.38u as=0 ps=0 w=1u l=1u
X3619 VSS.t148 sg13g2_nor3_1_0.C sg13g2_nor4_2_0.Y VSS.t7 sg13_lv_nmos ad=0.3293p pd=1.63u as=0.1406p ps=1.12u w=0.74u l=0.13u
X3620 VSS.t129 sg13g2_buf_4_0.X a_17014_13350# VSS.t3281 sg13_lv_nmos ad=0.1406p pd=1.12u as=0.2516p ps=2.16u w=0.74u l=0.15u
X3621 VDD VSS.t898 VDD VDD sg13_lv_pmos ad=0.34p pd=2.68u as=0 ps=0 w=1u l=1u
X3622 VSS.t1319 VDD VSS.t1318 VSS.t305 sg13_lv_nmos ad=0.1428p pd=1.52u as=0 ps=0 w=0.42u l=1u
X3623 VDD VSS.t3219 VDD VDD sg13_lv_pmos ad=0.34p pd=2.68u as=0 ps=0 w=1u l=1u
X3624 VSS.t2724 VDD VSS.t2722 VSS.t2710 sg13_lv_nmos ad=0.1428p pd=1.52u as=0 ps=0 w=0.42u l=1u
X3625 VDD a_13079_16301# a_13079_16071# VDD sg13_lv_pmos ad=2.4406p pd=15.34u as=0.2442p ps=2.06u w=0.66u l=0.13u
X3626 VDD VSS.t1788 VDD VDD sg13_lv_pmos ad=0.19p pd=1.38u as=0 ps=0 w=1u l=1u
X3627 VDD VSS.t2132 VDD VDD sg13_lv_pmos ad=0.34p pd=2.68u as=0 ps=0 w=1u l=1u
X3628 VSS.t647 VDD VSS.t649 VSS.t648 sg13_lv_nmos ad=79.8f pd=0.8u as=0 ps=0 w=0.42u l=1u
X3629 VSS.t1246 VDD VSS.t1245 VSS.t305 sg13_lv_nmos ad=0.1428p pd=1.52u as=0 ps=0 w=0.42u l=1u
X3630 VSS.t103 sg13g2_buf_16_1.X a_19630_15238# VSS.t3 sg13_lv_nmos ad=0.1406p pd=1.12u as=0.1406p ps=1.12u w=0.74u l=0.13u
X3631 VSS.t1431 VDD VSS.t1278 VSS.t305 sg13_lv_nmos ad=79.8f pd=0.8u as=0 ps=0 w=0.42u l=1u
X3632 VSS.t869 VDD VSS.t871 VSS.t870 sg13_lv_nmos ad=79.8f pd=0.8u as=0 ps=0 w=0.42u l=1u
X3633 VSS.t1626 VDD VSS.t1628 VSS.t1627 sg13_lv_nmos ad=79.8f pd=0.8u as=0 ps=0 w=0.42u l=1u
X3634 VSS.t1806 VDD VSS.t1805 VSS.t1804 sg13_lv_nmos ad=0.1428p pd=1.52u as=0 ps=0 w=0.42u l=1u
X3635 VSS.t3155 VDD VSS.t3157 VSS.t3156 sg13_lv_nmos ad=79.8f pd=0.8u as=0 ps=0 w=0.42u l=1u
X3636 VSS.t2520 VDD VSS.t2519 VSS.t2518 sg13_lv_nmos ad=0.1428p pd=1.52u as=0 ps=0 w=0.42u l=1u
X3637 VSS.t2360 VDD VSS.t2362 VSS.t2361 sg13_lv_nmos ad=79.8f pd=0.8u as=0 ps=0 w=0.42u l=1u
X3638 VDD sg13g2_buf_16_1.X a_19630_15238# VDD sg13_lv_pmos ad=0.2128p pd=1.5u as=0.2128p ps=1.5u w=1.12u l=0.13u
X3639 VDD a_17606_13726# a_17718_13790# VDD sg13_lv_pmos ad=0.2254p pd=1.53u as=0.34p ps=2.68u w=1u l=0.5u
X3640 sg13g2_dlygate4sd3_1_3.A sg13g2_nand2_2_0.Y a_17112_12952# VDD sg13_lv_pmos ad=0.2128p pd=1.5u as=0.2128p ps=1.5u w=1.12u l=0.15u
X3641 VDD VSS.t1126 VDD VDD sg13_lv_pmos ad=0.19p pd=1.38u as=0 ps=0 w=1u l=1u
X3642 VSS.t939 VDD VSS.t941 VSS.t940 sg13_lv_nmos ad=79.8f pd=0.8u as=0 ps=0 w=0.42u l=1u
X3643 VDD VSS.t928 VDD VDD sg13_lv_pmos ad=0.34p pd=2.68u as=0 ps=0 w=1u l=1u
X3644 VSS.t3110 VDD VSS.t3109 VSS.t3108 sg13_lv_nmos ad=0.1428p pd=1.52u as=0 ps=0 w=0.42u l=1u
X3645 VDD VSS.t2765 VDD VDD sg13_lv_pmos ad=0.19p pd=1.38u as=0 ps=0 w=1u l=1u
X3646 VSS.t2018 VDD VSS.t2017 VSS.t2016 sg13_lv_nmos ad=0.1428p pd=1.52u as=0 ps=0 w=0.42u l=1u
X3647 VDD VSS.t3049 VDD VDD sg13_lv_pmos ad=0.34p pd=2.68u as=0 ps=0 w=1u l=1u
X3648 sg13g2_and2_1_1.X a_6477_14832# VSS.t179 VSS.t228 sg13_lv_nmos ad=0.2516p pd=2.16u as=0.1331p ps=1.12u w=0.74u l=0.13u
X3649 VDD VSS.t2464 VDD VDD sg13_lv_pmos ad=0.34p pd=2.68u as=0 ps=0 w=1u l=1u
X3650 VSS.t210 VDD VSS.t210 VSS.t507 sg13_lv_nmos ad=79.8f pd=0.8u as=0 ps=0 w=0.42u l=1u
X3651 VSS.t2550 VDD VSS.t2552 VSS.t2551 sg13_lv_nmos ad=79.8f pd=0.8u as=0 ps=0 w=0.42u l=1u
X3652 VDD VSS.t1583 VDD VDD sg13_lv_pmos ad=0.19p pd=1.38u as=0 ps=0 w=1u l=1u
X3653 VDD VSS.t2492 VDD VDD sg13_lv_pmos ad=0.19p pd=1.38u as=0 ps=0 w=1u l=1u
X3654 sg13g2_a21oi_1_1.Y sg13g2_inv_1_0.Y a_17621_12972# VDD sg13_lv_pmos ad=0.3808p pd=2.92u as=0.2128p ps=1.5u w=1.12u l=0.13u
X3655 VSS.t662 VDD VSS.t331 VSS.t752 sg13_lv_nmos ad=79.8f pd=0.8u as=0 ps=0 w=0.42u l=1u
X3656 VDD VSS.t1291 VDD VDD sg13_lv_pmos ad=0.19p pd=1.38u as=0 ps=0 w=1u l=1u
X3657 VDD VSS.t1396 VDD VDD sg13_lv_pmos ad=0.34p pd=2.68u as=0 ps=0 w=1u l=1u
X3658 a_19630_15238# sg13g2_buf_16_1.X VDD VDD sg13_lv_pmos ad=0.2128p pd=1.5u as=0.2128p ps=1.5u w=1.12u l=0.13u
X3659 VDD VSS.t16 VDD VDD sg13_lv_pmos ad=0.34p pd=2.68u as=0 ps=0 w=1u l=1u
X3660 VDD VSS.t719 VDD VDD sg13_lv_pmos ad=0.34p pd=2.68u as=0 ps=0 w=1u l=1u
X3661 VDD VSS.t991 VDD VDD sg13_lv_pmos ad=0.19p pd=1.38u as=0 ps=0 w=1u l=1u
X3662 VSS.t1254 VDD VSS.t1253 VSS.t305 sg13_lv_nmos ad=0.1428p pd=1.52u as=0 ps=0 w=0.42u l=1u
X3663 VSS.t1363 VDD VSS.t1364 VSS.t305 sg13_lv_nmos ad=79.8f pd=0.8u as=0 ps=0 w=0.42u l=1u
X3664 VSS.t1295 VDD VSS.t1296 VSS.t305 sg13_lv_nmos ad=79.8f pd=0.8u as=0 ps=0 w=0.42u l=1u
X3665 VSS.t1716 VDD VSS.t1718 VSS.t1717 sg13_lv_nmos ad=79.8f pd=0.8u as=0 ps=0 w=0.42u l=1u
X3666 VSS.t2098 VDD VSS.t2100 VSS.t2099 sg13_lv_nmos ad=79.8f pd=0.8u as=0 ps=0 w=0.42u l=1u
X3667 VDD VSS.t2775 VDD VDD sg13_lv_pmos ad=0.34p pd=2.68u as=0 ps=0 w=1u l=1u
X3668 VDD VSS.t624 VDD VDD sg13_lv_pmos ad=0.19p pd=1.38u as=0 ps=0 w=1u l=1u
X3669 VDD VSS.t1387 VDD VDD sg13_lv_pmos ad=0.19p pd=1.38u as=0 ps=0 w=1u l=1u
X3670 VSS.t1601 VDD VSS.t1600 VSS.t1599 sg13_lv_nmos ad=0.1428p pd=1.52u as=0 ps=0 w=0.42u l=1u
X3671 a_11050_14452# a_11493_14495# a_10790_14922# VSS.t264 sg13_lv_nmos ad=79.8f pd=0.8u as=0.1296p ps=1.52u w=0.42u l=0.13u
X3672 VSS.t1259 VDD VSS.t1258 VSS.t305 sg13_lv_nmos ad=0.1428p pd=1.52u as=0 ps=0 w=0.42u l=1u
X3673 VDD VSS.t2117 VDD VDD sg13_lv_pmos ad=0.34p pd=2.68u as=0 ps=0 w=1u l=1u
X3674 VSS.t1024 VDD VSS.t1026 VSS.t1025 sg13_lv_nmos ad=79.8f pd=0.8u as=0 ps=0 w=0.42u l=1u
X3675 VDD VSS.t1952 VDD VDD sg13_lv_pmos ad=0.34p pd=2.68u as=0 ps=0 w=1u l=1u
X3676 VDD a_4655_15311# a_4912_15454# VDD sg13_lv_pmos ad=2.4406p pd=15.34u as=79.8f ps=0.8u w=0.42u l=0.13u
X3677 VDD VSS.t1760 VDD VDD sg13_lv_pmos ad=0.34p pd=2.68u as=0 ps=0 w=1u l=1u
X3678 VSS.t3140 VDD VSS.t3142 VSS.t3141 sg13_lv_nmos ad=79.8f pd=0.8u as=0 ps=0 w=0.42u l=1u
X3679 VSS.t2345 VDD VSS.t2347 VSS.t2346 sg13_lv_nmos ad=79.8f pd=0.8u as=0 ps=0 w=0.42u l=1u
X3680 VDD sg13g2_dfrbpq_1_1.RESET_B a_6950_15234# VDD sg13_lv_pmos ad=0.36237p pd=2.605u as=79.8f ps=0.8u w=0.42u l=0.13u
X3681 a_13382_14922# sg13g2_dfrbpq_1_3.D VDD VDD sg13_lv_pmos ad=79.8f pd=0.8u as=0.1428p ps=1.52u w=0.42u l=0.13u
X3682 a_25862_15996# a_25592_16037# VDD VDD sg13_lv_pmos ad=0.34p pd=2.68u as=0.1523p ps=1.38u w=1u l=0.5u
X3683 VDD VSS.t1623 VDD VDD sg13_lv_pmos ad=0.19p pd=1.38u as=0 ps=0 w=1u l=1u
X3684 VDD VSS.t1800 VDD VDD sg13_lv_pmos ad=0.34p pd=2.68u as=0 ps=0 w=1u l=1u
X3685 VDD VSS.t2861 VDD VDD sg13_lv_pmos ad=0.34p pd=2.68u as=0 ps=0 w=1u l=1u
X3686 a_13652_14020# sg13g2_xor2_1_1.A VDD VDD sg13_lv_pmos ad=0.3808p pd=2.92u as=0.2128p ps=1.5u w=1.12u l=0.13u
X3687 a_26926_13911# a_27041_13912# VDD VDD sg13_lv_pmos ad=0.34p pd=2.68u as=0.2254p ps=1.53u w=1u l=0.5u
X3688 VSS.t724 VDD VSS.t729 VSS.t842 sg13_lv_nmos ad=79.8f pd=0.8u as=0 ps=0 w=0.42u l=1u
X3689 VSS.t2420 VDD VSS.t2422 VSS.t2421 sg13_lv_nmos ad=79.8f pd=0.8u as=0 ps=0 w=0.42u l=1u
X3690 VDD VSS.t2484 VDD VDD sg13_lv_pmos ad=0.34p pd=2.68u as=0 ps=0 w=1u l=1u
X3691 VSS.t854 VDD VSS.t856 VSS.t855 sg13_lv_nmos ad=79.8f pd=0.8u as=0 ps=0 w=0.42u l=1u
X3692 VSS.t1571 VDD VSS.t1573 VSS.t1572 sg13_lv_nmos ad=79.8f pd=0.8u as=0 ps=0 w=0.42u l=1u
X3693 VDD VSS.t2142 VDD VDD sg13_lv_pmos ad=0.34p pd=2.68u as=0 ps=0 w=1u l=1u
X3694 sg13g2_buf_16_1.X a_16078_14484# VSS.t22 VSS.t37 sg13_lv_nmos ad=0.1406p pd=1.12u as=0.1406p ps=1.12u w=0.74u l=0.13u
X3695 sg13g2_and2_1_2.X a_10605_13768# VDD VDD sg13_lv_pmos ad=0.3808p pd=2.92u as=0.1918p ps=1.5u w=1.12u l=0.13u
X3696 a_27634_15234# sg13g2_dfrbpq_1_4.RESET_B VSS.t79 VSS.t252 sg13_lv_nmos ad=37.8f pd=0.6u as=79.8f ps=0.8u w=0.42u l=0.13u
X3697 VSS.t1345 VDD VSS.t1344 VSS.t305 sg13_lv_nmos ad=0.1428p pd=1.52u as=0 ps=0 w=0.42u l=1u
X3698 VDD VSS.t1304 VDD VDD sg13_lv_pmos ad=0.19p pd=1.38u as=0 ps=0 w=1u l=1u
X3699 VDD VSS.t2812 VDD VDD sg13_lv_pmos ad=0.19p pd=1.38u as=0 ps=0 w=1u l=1u
X3700 VDD VSS.t2090 VDD VDD sg13_lv_pmos ad=0.19p pd=1.38u as=0 ps=0 w=1u l=1u
X3701 VDD sg13g2_dfrbpq_1_7.RESET_B a_18442_13945# VDD sg13_lv_pmos ad=0.1563p pd=1.22u as=0.147p ps=1.54u w=0.42u l=0.13u
X3702 a_17606_13726# a_17336_13726# VSS.t243 VSS.t287 sg13_lv_nmos ad=0.1428p pd=1.52u as=79.8f ps=0.8u w=0.42u l=0.5u
X3703 VDD VSS.t2444 VDD VDD sg13_lv_pmos ad=0.34p pd=2.68u as=0 ps=0 w=1u l=1u
X3704 VSS.t2505 VDD VSS.t2504 VSS.t2503 sg13_lv_nmos ad=0.1428p pd=1.52u as=0 ps=0 w=0.42u l=1u
X3705 VDD VSS.t474 VDD VDD sg13_lv_pmos ad=0.34p pd=2.68u as=0 ps=0 w=1u l=1u
X3706 VDD VSS.t1590 VDD VDD sg13_lv_pmos ad=0.34p pd=2.68u as=0 ps=0 w=1u l=1u
X3707 VSS.t2715 VDD VSS.t2714 VSS.t2710 sg13_lv_nmos ad=0.1428p pd=1.52u as=0 ps=0 w=0.42u l=1u
X3708 sg13g2_mux2_1_0.X a_23806_14854# VSS.t12 VSS.t7 sg13_lv_nmos ad=0.4033p pd=2.57u as=0.148p ps=1.14u w=0.74u l=0.13u
X3709 VSS.t1636 VDD VSS.t1635 VSS.t1634 sg13_lv_nmos ad=0.1428p pd=1.52u as=0 ps=0 w=0.42u l=1u
X3710 VDD VSS.t1773 VDD VDD sg13_lv_pmos ad=0.19p pd=1.38u as=0 ps=0 w=1u l=1u
X3711 VSS.t2053 VDD VSS.t2052 VSS.t2051 sg13_lv_nmos ad=0.1428p pd=1.52u as=0 ps=0 w=0.42u l=1u
X3712 VSS.t498 VDD VSS.t498 VSS.t499 sg13_lv_nmos ad=0.1428p pd=1.52u as=0 ps=0 w=0.42u l=1u
X3713 VDD sg13g2_buf_4_0.X a_10176_14523# VDD sg13_lv_pmos ad=0.2891p pd=1.695u as=0.1596p ps=1.22u w=0.84u l=0.13u
X3714 VDD VSS.t238 VDD VDD sg13_lv_pmos ad=0.34p pd=2.68u as=0 ps=0 w=1u l=1u
X3715 VSS.t1350 VDD VSS.t1349 VSS.t305 sg13_lv_nmos ad=0.1428p pd=1.52u as=0 ps=0 w=0.42u l=1u
X3716 VSS.t2570 VDD VSS.t2572 VSS.t2571 sg13_lv_nmos ad=79.8f pd=0.8u as=0 ps=0 w=0.42u l=1u
X3717 VSS.t869 VDD VSS.t871 VSS.t870 sg13_lv_nmos ad=79.8f pd=0.8u as=0 ps=0 w=0.42u l=1u
X3718 VSS.t1380 VDD VSS.t1381 VSS.t305 sg13_lv_nmos ad=79.8f pd=0.8u as=0 ps=0 w=0.42u l=1u
X3719 VDD VSS.t1603 VDD VDD sg13_lv_pmos ad=0.19p pd=1.38u as=0 ps=0 w=1u l=1u
X3720 VDD VSS.t3074 VDD VDD sg13_lv_pmos ad=0.34p pd=2.68u as=0 ps=0 w=1u l=1u
X3721 VDD VSS.t1937 VDD VDD sg13_lv_pmos ad=0.34p pd=2.68u as=0 ps=0 w=1u l=1u
X3722 VDD a_14085_14495# a_14187_14495# VDD sg13_lv_pmos ad=2.75157p pd=17.885u as=0.3864p ps=2.93u w=1.12u l=0.13u
X3723 VSS.t564 VDD VSS.t564 VSS.t614 sg13_lv_nmos ad=0.1428p pd=1.52u as=0 ps=0 w=0.42u l=1u
X3724 VSS.t1791 VDD VSS.t1790 VSS.t1789 sg13_lv_nmos ad=0.1428p pd=1.52u as=0 ps=0 w=0.42u l=1u
X3725 a_26458_13690# sg13g2_inv_1_1.A VSS.t175 VSS.t174 sg13_lv_nmos ad=0.1428p pd=1.52u as=79.8f ps=0.8u w=0.42u l=0.13u
X3726 VDD VSS.t2852 VDD VDD sg13_lv_pmos ad=0.34p pd=2.68u as=0 ps=0 w=1u l=1u
X3727 VDD VSS.t2757 VDD VDD sg13_lv_pmos ad=0.19p pd=1.38u as=0 ps=0 w=1u l=1u
X3728 VSS.t2003 VDD VSS.t2002 VSS.t2001 sg13_lv_nmos ad=0.1428p pd=1.52u as=0 ps=0 w=0.42u l=1u
X3729 VDD VSS.t3034 VDD VDD sg13_lv_pmos ad=0.34p pd=2.68u as=0 ps=0 w=1u l=1u
X3730 VSS.t3095 VDD VSS.t3094 VSS.t3093 sg13_lv_nmos ad=0.1428p pd=1.52u as=0 ps=0 w=0.42u l=1u
X3731 VSS.t637 VDD VSS.t636 VSS.t635 sg13_lv_nmos ad=0.1428p pd=1.52u as=0 ps=0 w=0.42u l=1u
X3732 VDD a_19727_13799# a_20394_14020# VDD sg13_lv_pmos ad=0.2128p pd=1.5u as=0.3864p ps=2.93u w=1.12u l=0.13u
X3733 VDD VSS.t983 VDD VDD sg13_lv_pmos ad=0.34p pd=2.68u as=0 ps=0 w=1u l=1u
X3734 VDD VSS.t1098 VDD VDD sg13_lv_pmos ad=0.34p pd=2.68u as=0 ps=0 w=1u l=1u
X3735 VDD VSS.t1250 VDD VDD sg13_lv_pmos ad=0.19p pd=1.38u as=0 ps=0 w=1u l=1u
X3736 VSS.t385 VDD VSS.t384 VSS.t383 sg13_lv_nmos ad=0.1428p pd=1.52u as=0 ps=0 w=0.42u l=1u
X3737 counter_value_o[1] a_7048_15996# VDD VDD sg13_lv_pmos ad=0.42p pd=2.99u as=0.2114p ps=1.54u w=1.12u l=0.13u
X3738 VSS.t559 VDD VSS.t559 VSS.t561 sg13_lv_nmos ad=79.8f pd=0.8u as=0 ps=0 w=0.42u l=1u
X3739 VSS.t98 sg13g2_dfrbpq_1_2.RESET_B a_10884_14922# VSS.t97 sg13_lv_nmos ad=0.1626p pd=1.415u as=60.89999f ps=0.71u w=0.42u l=0.13u
X3740 sg13g2_buf_16_1.X a_16078_14484# VSS.t35 VSS.t37 sg13_lv_nmos ad=0.1406p pd=1.12u as=0.1406p ps=1.12u w=0.74u l=0.13u
X3741 VDD VSS.t906 VDD VDD sg13_lv_pmos ad=0.19p pd=1.38u as=0 ps=0 w=1u l=1u
X3742 VSS.t1359 VDD VSS.t1358 VSS.t305 sg13_lv_nmos ad=0.1428p pd=1.52u as=0 ps=0 w=0.42u l=1u
X3743 VDD VSS.t1568 VDD VDD sg13_lv_pmos ad=0.19p pd=1.38u as=0 ps=0 w=1u l=1u
X3744 VDD VSS.t2477 VDD VDD sg13_lv_pmos ad=0.19p pd=1.38u as=0 ps=0 w=1u l=1u
X3745 VSS.t2535 VDD VSS.t2537 VSS.t2536 sg13_lv_nmos ad=79.8f pd=0.8u as=0 ps=0 w=0.42u l=1u
X3746 a_24669_14508# sg13g2_nor4_2_0.Y VDD VDD sg13_lv_pmos ad=0.3325p pd=1.665u as=0.253p ps=1.53u w=1u l=0.13u
X3747 VSS.t705 VDD VSS.t705 VSS.t706 sg13_lv_nmos ad=79.8f pd=0.8u as=0 ps=0 w=0.42u l=1u
X3748 VDD VSS.t2804 VDD VDD sg13_lv_pmos ad=0.19p pd=1.38u as=0 ps=0 w=1u l=1u
X3749 VSS.t2365 VDD VSS.t2367 VSS.t2366 sg13_lv_nmos ad=79.8f pd=0.8u as=0 ps=0 w=0.42u l=1u
X3750 VSS.t2490 VDD VSS.t2489 VSS.t2488 sg13_lv_nmos ad=0.1428p pd=1.52u as=0 ps=0 w=0.42u l=1u
X3751 VSS.t1701 VDD VSS.t1703 VSS.t1702 sg13_lv_nmos ad=79.8f pd=0.8u as=0 ps=0 w=0.42u l=1u
X3752 VSS.t2817 VDD VSS.t2818 VSS.t2710 sg13_lv_nmos ad=79.8f pd=0.8u as=0 ps=0 w=0.42u l=1u
X3753 VDD VSS.t858 VDD VDD sg13_lv_pmos ad=0.34p pd=2.68u as=0 ps=0 w=1u l=1u
X3754 VSS.t1586 VDD VSS.t1585 VSS.t1584 sg13_lv_nmos ad=0.1428p pd=1.52u as=0 ps=0 w=0.42u l=1u
X3755 VSS.t1656 VDD VSS.t1655 VSS.t1654 sg13_lv_nmos ad=0.1428p pd=1.52u as=0 ps=0 w=0.42u l=1u
X3756 VDD VSS.t1758 VDD VDD sg13_lv_pmos ad=0.19p pd=1.38u as=0 ps=0 w=1u l=1u
X3757 a_37484_15960# sg13g2_dlygate4sd3_1_12.A VDD VDD sg13_lv_pmos ad=0.2856p pd=2.36u as=0.2114p ps=1.54u w=0.84u l=0.13u
X3758 VDD VSS.t1303 VDD VDD sg13_lv_pmos ad=0.34p pd=2.68u as=0 ps=0 w=1u l=1u
X3759 VSS.t1024 VDD VSS.t1026 VSS.t1025 sg13_lv_nmos ad=79.8f pd=0.8u as=0 ps=0 w=0.42u l=1u
X3760 VSS.t1394 VDD VSS.t1395 VSS.t305 sg13_lv_nmos ad=79.8f pd=0.8u as=0 ps=0 w=0.42u l=1u
X3761 VDD VSS.t1311 VDD VDD sg13_lv_pmos ad=0.34p pd=2.68u as=0 ps=0 w=1u l=1u
X3762 VDD VSS.t2818 VDD VDD sg13_lv_pmos ad=0.34p pd=2.68u as=0 ps=0 w=1u l=1u
X3763 VDD VSS.t2102 VDD VDD sg13_lv_pmos ad=0.34p pd=2.68u as=0 ps=0 w=1u l=1u
X3764 VSS.t2330 VDD VSS.t2332 VSS.t2331 sg13_lv_nmos ad=79.8f pd=0.8u as=0 ps=0 w=0.42u l=1u
X3765 a_22202_14484# sg13g2_nand2_2_0.Y a_22508_14484# VDD sg13_lv_pmos ad=0.2128p pd=1.5u as=0.3808p ps=2.92u w=1.12u l=0.13u
X3766 VDD VSS.t1785 VDD VDD sg13_lv_pmos ad=0.34p pd=2.68u as=0 ps=0 w=1u l=1u
X3767 VSS.t2023 VDD VSS.t2022 VSS.t2021 sg13_lv_nmos ad=0.1428p pd=1.52u as=0 ps=0 w=0.42u l=1u
X3768 VSS.t724 VDD VSS.t724 VSS.t725 sg13_lv_nmos ad=79.8f pd=0.8u as=0 ps=0 w=0.42u l=1u
X3769 VDD VSS.t3019 VDD VDD sg13_lv_pmos ad=0.34p pd=2.68u as=0 ps=0 w=1u l=1u
X3770 VDD VSS.t1340 VDD VDD sg13_lv_pmos ad=0.19p pd=1.38u as=0 ps=0 w=1u l=1u
X3771 VSS.t2585 VDD VSS.t2584 VSS.t2583 sg13_lv_nmos ad=0.1428p pd=1.52u as=0 ps=0 w=0.42u l=1u
X3772 VSS.t2405 VDD VSS.t2407 VSS.t2406 sg13_lv_nmos ad=79.8f pd=0.8u as=0 ps=0 w=0.42u l=1u
X3773 VDD VSS.t2469 VDD VDD sg13_lv_pmos ad=0.34p pd=2.68u as=0 ps=0 w=1u l=1u
X3774 VDD VSS.t873 VDD VDD sg13_lv_pmos ad=0.34p pd=2.68u as=0 ps=0 w=1u l=1u
X3775 VDD VSS.t1061 VDD VDD sg13_lv_pmos ad=0.19p pd=1.38u as=0 ps=0 w=1u l=1u
X3776 VDD VSS.t1650 VDD VDD sg13_lv_pmos ad=0.34p pd=2.68u as=0 ps=0 w=1u l=1u
X3777 VDD VSS.t1588 VDD VDD sg13_lv_pmos ad=0.19p pd=1.38u as=0 ps=0 w=1u l=1u
X3778 VDD VSS.t2497 VDD VDD sg13_lv_pmos ad=0.19p pd=1.38u as=0 ps=0 w=1u l=1u
X3779 VSS.t944 VDD VSS.t946 VSS.t945 sg13_lv_nmos ad=79.8f pd=0.8u as=0 ps=0 w=0.42u l=1u
X3780 VDD VSS.t2782 VDD VDD sg13_lv_pmos ad=0.34p pd=2.68u as=0 ps=0 w=1u l=1u
X3781 VSS.t1686 VDD VSS.t1688 VSS.t1687 sg13_lv_nmos ad=79.8f pd=0.8u as=0 ps=0 w=0.42u l=1u
X3782 VSS.t2103 VDD VSS.t2105 VSS.t2104 sg13_lv_nmos ad=79.8f pd=0.8u as=0 ps=0 w=0.42u l=1u
X3783 VDD VSS.t700 VDD VDD sg13_lv_pmos ad=0.34p pd=2.68u as=0 ps=0 w=1u l=1u
X3784 VSS.t1512 VDD VSS.t1375 VSS.t305 sg13_lv_nmos ad=0.1428p pd=1.52u as=0 ps=0 w=0.42u l=1u
X3785 VSS.t729 VDD VSS.t733 VSS.t732 sg13_lv_nmos ad=79.8f pd=0.8u as=0 ps=0 w=0.42u l=1u
X3786 VSS.t807 VDD VSS.t809 VSS.t808 sg13_lv_nmos ad=79.8f pd=0.8u as=0 ps=0 w=0.42u l=1u
X3787 VDD VSS.t2524 VDD VDD sg13_lv_pmos ad=0.34p pd=2.68u as=0 ps=0 w=1u l=1u
X3788 a_23806_14854# sg13g2_nor2b_1_0.Y a_23709_14854# VSS.t7 sg13_lv_nmos ad=0.1628p pd=1.18u as=0.13135p ps=1.095u w=0.74u l=0.13u
X3789 VSS.t2555 VDD VSS.t2557 VSS.t2556 sg13_lv_nmos ad=79.8f pd=0.8u as=0 ps=0 w=0.42u l=1u
X3790 sg13g2_dfrbpq_1_2.RESET_B a_11166_15486# VDD VDD sg13_lv_pmos ad=0.3927p pd=2.99u as=2.4406p ps=15.34u w=1.155u l=0.13u
X3791 VDD VSS.t3059 VDD VDD sg13_lv_pmos ad=0.34p pd=2.68u as=0 ps=0 w=1u l=1u
X3792 VSS.t1298 VDD VSS.t1298 VSS.t305 sg13_lv_nmos ad=0.1428p pd=1.52u as=0 ps=0 w=0.42u l=1u
X3793 VDD VSS.t1765 VDD VDD sg13_lv_pmos ad=0.34p pd=2.68u as=0 ps=0 w=1u l=1u
X3794 VSS.t1616 VDD VSS.t1618 VSS.t1617 sg13_lv_nmos ad=79.8f pd=0.8u as=0 ps=0 w=0.42u l=1u
X3795 VSS.t3145 VDD VSS.t3147 VSS.t3146 sg13_lv_nmos ad=79.8f pd=0.8u as=0 ps=0 w=0.42u l=1u
X3796 VSS.t2350 VDD VSS.t2352 VSS.t2351 sg13_lv_nmos ad=79.8f pd=0.8u as=0 ps=0 w=0.42u l=1u
X3797 VSS.t2133 VDD VSS.t2132 VSS.t2131 sg13_lv_nmos ad=0.1428p pd=1.52u as=0 ps=0 w=0.42u l=1u
X3798 VDD VSS.t339 VDD VDD sg13_lv_pmos ad=0.34p pd=2.68u as=0 ps=0 w=1u l=1u
X3799 VSS.t959 VDD VSS.t961 VSS.t960 sg13_lv_nmos ad=79.8f pd=0.8u as=0 ps=0 w=0.42u l=1u
X3800 VDD VSS.t1321 VDD VDD sg13_lv_pmos ad=0.34p pd=2.68u as=0 ps=0 w=1u l=1u
X3801 VDD VSS.t1628 VDD VDD sg13_lv_pmos ad=0.19p pd=1.38u as=0 ps=0 w=1u l=1u
X3802 VDD VSS.t2843 VDD VDD sg13_lv_pmos ad=0.34p pd=2.68u as=0 ps=0 w=1u l=1u
X3803 VDD VSS.t1028 VDD VDD sg13_lv_pmos ad=0.34p pd=2.68u as=0 ps=0 w=1u l=1u
X3804 VSS.t2425 VDD VSS.t2427 VSS.t2426 sg13_lv_nmos ad=79.8f pd=0.8u as=0 ps=0 w=0.42u l=1u
X3805 a_26537_16334# a_26661_16033# VDD VDD sg13_lv_pmos ad=0.2442p pd=2.06u as=2.4406p ps=15.34u w=0.66u l=0.13u
X3806 VDD VSS.t524 VDD VDD sg13_lv_pmos ad=0.19p pd=1.38u as=0 ps=0 w=1u l=1u
X3807 sg13g2_dfrbpq_1_2.CLK a_12308_15202# VSS.t89 VSS.t196 sg13_lv_nmos ad=0.1406p pd=1.12u as=0.1406p ps=1.12u w=0.74u l=0.13u
X3808 VSS.t664 VDD VSS.t664 VSS.t665 sg13_lv_nmos ad=79.8f pd=0.8u as=0 ps=0 w=0.42u l=1u
X3809 VSS.t695 VDD VSS.t695 VSS.t816 sg13_lv_nmos ad=79.8f pd=0.8u as=0 ps=0 w=0.42u l=1u
X3810 VSS.t899 VDD VSS.t898 VSS.t897 sg13_lv_nmos ad=0.1428p pd=1.52u as=0 ps=0 w=0.42u l=1u
X3811 a_17908_16020# sg13g2_nand2_1_1.A VDD VDD sg13_lv_pmos ad=0.1575p pd=1.315u as=0.3822p ps=1.84u w=1u l=0.13u
X3812 a_19546_12936# sg13g2_dlygate4sd3_1_11.A VSS.t238 VSS.t237 sg13_lv_nmos ad=0.1428p pd=1.52u as=79.8f ps=0.8u w=0.42u l=0.13u
X3813 VDD VSS.t2796 VDD VDD sg13_lv_pmos ad=0.19p pd=1.38u as=0 ps=0 w=1u l=1u
X3814 VSS.t2475 VDD VSS.t2474 VSS.t2473 sg13_lv_nmos ad=0.1428p pd=1.52u as=0 ps=0 w=0.42u l=1u
X3815 VDD VSS.t1595 VDD VDD sg13_lv_pmos ad=0.34p pd=2.68u as=0 ps=0 w=1u l=1u
X3816 VDD VSS.t644 VDD VDD sg13_lv_pmos ad=0.19p pd=1.38u as=0 ps=0 w=1u l=1u
X3817 VSS.t28 sg13g2_and2_1_2.B a_10699_13768# VSS.t87 sg13_lv_nmos ad=0.1331p pd=1.12u as=0.1216p ps=1.02u w=0.64u l=0.13u
X3818 VDD VSS.t1091 VDD VDD sg13_lv_pmos ad=0.19p pd=1.38u as=0 ps=0 w=1u l=1u
X3819 VSS.t1641 VDD VSS.t1640 VSS.t1639 sg13_lv_nmos ad=0.1428p pd=1.52u as=0 ps=0 w=0.42u l=1u
X3820 VSS.t2390 VDD VSS.t2392 VSS.t2391 sg13_lv_nmos ad=79.8f pd=0.8u as=0 ps=0 w=0.42u l=1u
X3821 VDD VSS.t2155 VDD VDD sg13_lv_pmos ad=0.19p pd=1.38u as=0 ps=0 w=1u l=1u
X3822 VDD VSS.t431 VDD VDD sg13_lv_pmos ad=0.34p pd=2.68u as=0 ps=0 w=1u l=1u
X3823 VDD VSS.t2 VDD VDD sg13_lv_pmos ad=0.19p pd=1.38u as=0 ps=0 w=1u l=1u
X3824 VDD VSS.t1600 VDD VDD sg13_lv_pmos ad=0.34p pd=2.68u as=0 ps=0 w=1u l=1u
X3825 VSS.t2785 VDD VSS.t2784 VSS.t2710 sg13_lv_nmos ad=0.1428p pd=1.52u as=0 ps=0 w=0.42u l=1u
X3826 VDD VSS.t2509 VDD VDD sg13_lv_pmos ad=0.34p pd=2.68u as=0 ps=0 w=1u l=1u
X3827 VSS.t285 VDD VSS.t676 VSS.t772 sg13_lv_nmos ad=0.1428p pd=1.52u as=0 ps=0 w=0.42u l=1u
X3828 VSS.t2540 VDD VSS.t2542 VSS.t2541 sg13_lv_nmos ad=79.8f pd=0.8u as=0 ps=0 w=0.42u l=1u
X3829 VSS.t1275 VDD VSS.t1276 VSS.t305 sg13_lv_nmos ad=79.8f pd=0.8u as=0 ps=0 w=0.42u l=1u
X3830 VDD VSS.t3079 VDD VDD sg13_lv_pmos ad=0.34p pd=2.68u as=0 ps=0 w=1u l=1u
X3831 VDD VSS.t1942 VDD VDD sg13_lv_pmos ad=0.34p pd=2.68u as=0 ps=0 w=1u l=1u
X3832 VDD VSS.t714 VDD VDD sg13_lv_pmos ad=0.34p pd=2.68u as=0 ps=0 w=1u l=1u
X3833 VSS.t1311 VDD VSS.t1311 VSS.t305 sg13_lv_nmos ad=0.1428p pd=1.52u as=0 ps=0 w=0.42u l=1u
X3834 VDD VSS.t2457 VDD VDD sg13_lv_pmos ad=0.19p pd=1.38u as=0 ps=0 w=1u l=1u
X3835 VSS.t2118 VDD VSS.t2117 VSS.t2116 sg13_lv_nmos ad=0.1428p pd=1.52u as=0 ps=0 w=0.42u l=1u
X3836 VSS.t127 a_19630_15238# sg13g2_dfrbpq_1_7.CLK VSS.t3 sg13_lv_nmos ad=0.2516p pd=2.16u as=0.1406p ps=1.12u w=0.74u l=0.13u
X3837 VSS.t929 VDD VSS.t928 VSS.t927 sg13_lv_nmos ad=0.1428p pd=1.52u as=0 ps=0 w=0.42u l=1u
X3838 VDD VSS.t2115 VDD VDD sg13_lv_pmos ad=0.19p pd=1.38u as=0 ps=0 w=1u l=1u
X3839 VSS.t258 VDD VSS.t258 VSS.t176 sg13_lv_nmos ad=0.1428p pd=1.52u as=0 ps=0 w=0.42u l=1u
X3840 VDD VSS.t981 VDD VDD sg13_lv_pmos ad=0.19p pd=1.38u as=0 ps=0 w=1u l=1u
X3841 VSS.t1761 VDD VSS.t1760 VSS.t1759 sg13_lv_nmos ad=0.1428p pd=1.52u as=0 ps=0 w=0.42u l=1u
X3842 VSS.t2008 VDD VSS.t2007 VSS.t2006 sg13_lv_nmos ad=0.1428p pd=1.52u as=0 ps=0 w=0.42u l=1u
X3843 VDD a_27215_15311# a_27882_15532# VDD sg13_lv_pmos ad=0.2128p pd=1.5u as=0.3864p ps=2.93u w=1.12u l=0.13u
X3844 VDD VSS.t1367 VDD VDD sg13_lv_pmos ad=0.19p pd=1.38u as=0 ps=0 w=1u l=1u
X3845 VSS.t3100 VDD VSS.t3099 VSS.t3098 sg13_lv_nmos ad=0.1428p pd=1.52u as=0 ps=0 w=0.42u l=1u
X3846 VSS.t683 VDD VSS.t683 VSS.t682 sg13_lv_nmos ad=0.1428p pd=1.52u as=0 ps=0 w=0.42u l=1u
X3847 VDD VSS.t1106 VDD VDD sg13_lv_pmos ad=0.19p pd=1.38u as=0 ps=0 w=1u l=1u
X3848 VSS.t2570 VDD VSS.t2569 VSS.t2568 sg13_lv_nmos ad=0.1428p pd=1.52u as=0 ps=0 w=0.42u l=1u
X3849 a_16681_13726# sg13g2_buf_4_0.X VSS.t129 VSS.t3280 sg13_lv_nmos ad=0.198p pd=1.27u as=0.1045p ps=0.93u w=0.55u l=0.13u
X3850 VSS.t54 VDD VSS.t52 VSS.t800 sg13_lv_nmos ad=0.1428p pd=1.52u as=0 ps=0 w=0.42u l=1u
X3851 sg13g2_dfrbpq_1_2.CLK a_12308_15202# VSS.t89 VSS.t182 sg13_lv_nmos ad=0.1406p pd=1.12u as=0.1406p ps=1.12u w=0.74u l=0.13u
X3852 sg13g2_or3_1_0.X a_16681_13726# VDD VDD sg13_lv_pmos ad=0.3808p pd=2.92u as=0.3822p ps=1.84u w=1.12u l=0.13u
X3853 VSS.t944 VDD VSS.t946 VSS.t945 sg13_lv_nmos ad=79.8f pd=0.8u as=0 ps=0 w=0.42u l=1u
X3854 VDD VSS.t1573 VDD VDD sg13_lv_pmos ad=0.19p pd=1.38u as=0 ps=0 w=1u l=1u
X3855 VSS.t2855 VDD VSS.t2856 VSS.t2710 sg13_lv_nmos ad=79.8f pd=0.8u as=0 ps=0 w=0.42u l=1u
X3856 VDD VSS.t2482 VDD VDD sg13_lv_pmos ad=0.19p pd=1.38u as=0 ps=0 w=1u l=1u
X3857 VSS.t32 a_8986_14448# a_8705_14750# VSS.t3291 sg13_lv_nmos ad=79.8f pd=0.8u as=0.1428p ps=1.52u w=0.42u l=0.5u
X3858 VSS.t989 VDD VSS.t991 VSS.t990 sg13_lv_nmos ad=79.8f pd=0.8u as=0 ps=0 w=0.42u l=1u
X3859 VSS.t2370 VDD VSS.t2372 VSS.t2371 sg13_lv_nmos ad=79.8f pd=0.8u as=0 ps=0 w=0.42u l=1u
X3860 VDD VSS.t856 VDD VDD sg13_lv_pmos ad=0.19p pd=1.38u as=0 ps=0 w=1u l=1u
X3861 VDD VSS.t724 VDD VDD sg13_lv_pmos ad=0.34p pd=2.68u as=0 ps=0 w=1u l=1u
X3862 a_19150_13239# a_19265_13238# VSS.t334 VSS.t333 sg13_lv_nmos ad=0.1428p pd=1.52u as=0.1426p ps=1.16u w=0.42u l=0.5u
X3863 VSS.t2088 VDD VSS.t2090 VSS.t2089 sg13_lv_nmos ad=79.8f pd=0.8u as=0 ps=0 w=0.42u l=1u
X3864 sg13g2_dfrbpq_1_5.D a_25206_15302# VDD VDD sg13_lv_pmos ad=0.4256p pd=3u as=0.2254p ps=1.53u w=1.12u l=0.13u
X3865 VDD VSS.t569 VDD VDD sg13_lv_pmos ad=0.34p pd=2.68u as=0 ps=0 w=1u l=1u
X3866 VSS.t30 a_7450_14448# a_7169_14750# VSS.t11 sg13_lv_nmos ad=79.8f pd=0.8u as=0.1428p ps=1.52u w=0.42u l=0.5u
X3867 VSS.t2820 VDD VSS.t2821 VSS.t2710 sg13_lv_nmos ad=79.8f pd=0.8u as=0 ps=0 w=0.42u l=1u
X3868 VSS.t1591 VDD VSS.t1590 VSS.t1589 sg13_lv_nmos ad=0.1428p pd=1.52u as=0 ps=0 w=0.42u l=1u
X3869 a_25670_15234# sg13g2_dfrbpq_1_4.D VDD VDD sg13_lv_pmos ad=79.8f pd=0.8u as=0.1428p ps=1.52u w=0.42u l=0.13u
X3870 VSS.t331 VDD VSS.t664 VSS.t754 sg13_lv_nmos ad=79.8f pd=0.8u as=0 ps=0 w=0.42u l=1u
X3871 VSS.t705 VDD VSS.t705 VSS.t828 sg13_lv_nmos ad=79.8f pd=0.8u as=0 ps=0 w=0.42u l=1u
X3872 VDD VSS.t686 VDD VDD sg13_lv_pmos ad=0.34p pd=2.68u as=0 ps=0 w=1u l=1u
X3873 VSS.t1257 VDD VSS.t1256 VSS.t305 sg13_lv_nmos ad=0.1428p pd=1.52u as=0 ps=0 w=0.42u l=1u
X3874 VSS.t632 VDD VSS.t634 VSS.t633 sg13_lv_nmos ad=79.8f pd=0.8u as=0 ps=0 w=0.42u l=1u
X3875 VDD VSS.t1314 VDD VDD sg13_lv_pmos ad=0.34p pd=2.68u as=0 ps=0 w=1u l=1u
X3876 VDD VSS.t2821 VDD VDD sg13_lv_pmos ad=0.34p pd=2.68u as=0 ps=0 w=1u l=1u
X3877 VDD VSS.t2107 VDD VDD sg13_lv_pmos ad=0.34p pd=2.68u as=0 ps=0 w=1u l=1u
X3878 VSS.t272 VDD VSS.t273 VSS.t3 sg13_lv_nmos ad=79.8f pd=0.8u as=0 ps=0 w=0.42u l=1u
X3879 VSS.t959 VDD VSS.t961 VSS.t960 sg13_lv_nmos ad=79.8f pd=0.8u as=0 ps=0 w=0.42u l=1u
X3880 VSS.t2335 VDD VSS.t2337 VSS.t2336 sg13_lv_nmos ad=79.8f pd=0.8u as=0 ps=0 w=0.42u l=1u
X3881 VSS.t160 a_19630_15238# sg13g2_dfrbpq_1_7.CLK VSS.t3 sg13_lv_nmos ad=0.1406p pd=1.12u as=0.1406p ps=1.12u w=0.74u l=0.13u
X3882 VSS.t1601 VDD VSS.t1603 VSS.t1602 sg13_lv_nmos ad=79.8f pd=0.8u as=0 ps=0 w=0.42u l=1u
X3883 VSS.t1781 VDD VSS.t1780 VSS.t1779 sg13_lv_nmos ad=0.1428p pd=1.52u as=0 ps=0 w=0.42u l=1u
X3884 VSS.t3130 VDD VSS.t3132 VSS.t3131 sg13_lv_nmos ad=79.8f pd=0.8u as=0 ps=0 w=0.42u l=1u
X3885 VDD VSS.t92 VDD VDD sg13_lv_pmos ad=0.19p pd=1.38u as=0 ps=0 w=1u l=1u
X3886 VDD VSS.t1790 VDD VDD sg13_lv_pmos ad=0.34p pd=2.68u as=0 ps=0 w=1u l=1u
X3887 VSS.t899 VDD VSS.t898 VSS.t897 sg13_lv_nmos ad=0.1428p pd=1.52u as=0 ps=0 w=0.42u l=1u
X3888 VSS.t1472 VDD VSS.t1329 VSS.t305 sg13_lv_nmos ad=0.1428p pd=1.52u as=0 ps=0 w=0.42u l=1u
X3889 VDD VSS.t3197 VDD VDD sg13_lv_pmos ad=0.19p pd=1.38u as=0 ps=0 w=1u l=1u
X3890 VSS.t2590 VDD VSS.t2589 VSS.t2588 sg13_lv_nmos ad=0.1428p pd=1.52u as=0 ps=0 w=0.42u l=1u
X3891 VSS.t2410 VDD VSS.t2412 VSS.t2411 sg13_lv_nmos ad=79.8f pd=0.8u as=0 ps=0 w=0.42u l=1u
X3892 VDD VSS.t1620 VDD VDD sg13_lv_pmos ad=0.34p pd=2.68u as=0 ps=0 w=1u l=1u
X3893 VDD VSS.t1011 VDD VDD sg13_lv_pmos ad=0.19p pd=1.38u as=0 ps=0 w=1u l=1u
X3894 VDD VSS.t1302 VDD VDD sg13_lv_pmos ad=0.19p pd=1.38u as=0 ps=0 w=1u l=1u
X3895 VDD VSS.t729 VDD VDD sg13_lv_pmos ad=0.34p pd=2.68u as=0 ps=0 w=1u l=1u
X3896 VSS.t1691 VDD VSS.t1693 VSS.t1692 sg13_lv_nmos ad=79.8f pd=0.8u as=0 ps=0 w=0.42u l=1u
X3897 VDD VSS.t2766 VDD VDD sg13_lv_pmos ad=0.34p pd=2.68u as=0 ps=0 w=1u l=1u
X3898 VDD VSS.t644 VDD VDD sg13_lv_pmos ad=0.19p pd=1.38u as=0 ps=0 w=1u l=1u
X3899 VDD VSS.t1580 VDD VDD sg13_lv_pmos ad=0.34p pd=2.68u as=0 ps=0 w=1u l=1u
X3900 VSS.t637 VDD VSS.t636 VSS.t635 sg13_lv_nmos ad=0.1428p pd=1.52u as=0 ps=0 w=0.42u l=1u
X3901 VDD sg13g2_dfrbpq_1_6.RESET_B a_18730_14452# VDD sg13_lv_pmos ad=0.1563p pd=1.22u as=0.147p ps=1.54u w=0.42u l=0.13u
X3902 VSS.t1271 VDD VSS.t1270 VSS.t305 sg13_lv_nmos ad=0.1428p pd=1.52u as=0 ps=0 w=0.42u l=1u
X3903 VDD VSS.t1334 VDD VDD sg13_lv_pmos ad=0.19p pd=1.38u as=0 ps=0 w=1u l=1u
X3904 VDD VSS.t2839 VDD VDD sg13_lv_pmos ad=0.19p pd=1.38u as=0 ps=0 w=1u l=1u
X3905 VSS.t208 VDD VSS.t208 VSS.t484 sg13_lv_nmos ad=0.1428p pd=1.52u as=0 ps=0 w=0.42u l=1u
X3906 VDD VSS.t948 VDD VDD sg13_lv_pmos ad=0.34p pd=2.68u as=0 ps=0 w=1u l=1u
X3907 VDD VSS.t1585 VDD VDD sg13_lv_pmos ad=0.34p pd=2.68u as=0 ps=0 w=1u l=1u
X3908 VDD VSS.t2494 VDD VDD sg13_lv_pmos ad=0.34p pd=2.68u as=0 ps=0 w=1u l=1u
X3909 VSS.t2555 VDD VSS.t2554 VSS.t2553 sg13_lv_nmos ad=0.1428p pd=1.52u as=0 ps=0 w=0.42u l=1u
X3910 VSS.t929 VDD VSS.t928 VSS.t927 sg13_lv_nmos ad=0.1428p pd=1.52u as=0 ps=0 w=0.42u l=1u
X3911 VSS.t1338 VDD VSS.t1337 VSS.t305 sg13_lv_nmos ad=0.1428p pd=1.52u as=0 ps=0 w=0.42u l=1u
X3912 VSS.t540 VDD VSS.t545 VSS.t544 sg13_lv_nmos ad=79.8f pd=0.8u as=0 ps=0 w=0.42u l=1u
X3913 VDD VSS.t3064 VDD VDD sg13_lv_pmos ad=0.34p pd=2.68u as=0 ps=0 w=1u l=1u
X3914 VSS.t2385 VDD VSS.t2384 VSS.t2383 sg13_lv_nmos ad=0.1428p pd=1.52u as=0 ps=0 w=0.42u l=1u
X3915 VDD VSS.t407 VDD VDD sg13_lv_pmos ad=0.34p pd=2.68u as=0 ps=0 w=1u l=1u
X3916 VDD VSS.t1927 VDD VDD sg13_lv_pmos ad=0.34p pd=2.68u as=0 ps=0 w=1u l=1u
X3917 VSS.t2103 VDD VSS.t2102 VSS.t2101 sg13_lv_nmos ad=0.1428p pd=1.52u as=0 ps=0 w=0.42u l=1u
X3918 VSS.t502 VDD VSS.t498 VSS.t501 sg13_lv_nmos ad=0.1428p pd=1.52u as=0 ps=0 w=0.42u l=1u
X3919 VSS.t569 VDD VSS.t569 VSS.t617 sg13_lv_nmos ad=79.8f pd=0.8u as=0 ps=0 w=0.42u l=1u
X3920 VSS.t1099 VDD VSS.t1098 VSS.t1097 sg13_lv_nmos ad=0.1428p pd=1.52u as=0 ps=0 w=0.42u l=1u
X3921 VDD VSS.t1283 VDD VDD sg13_lv_pmos ad=0.34p pd=2.68u as=0 ps=0 w=1u l=1u
X3922 VDD VSS.t2459 VDD VDD sg13_lv_pmos ad=0.34p pd=2.68u as=0 ps=0 w=1u l=1u
X3923 VSS.t989 VDD VSS.t991 VSS.t990 sg13_lv_nmos ad=79.8f pd=0.8u as=0 ps=0 w=0.42u l=1u
X3924 VSS.t1357 VDD VSS.t1356 VSS.t305 sg13_lv_nmos ad=0.1428p pd=1.52u as=0 ps=0 w=0.42u l=1u
X3925 VDD VSS.t1970 VDD VDD sg13_lv_pmos ad=0.19p pd=1.38u as=0 ps=0 w=1u l=1u
X3926 VSS.t173 sg13g2_inv_1_1.A sg13g2_inv_1_1.Y VSS.t172 sg13_lv_nmos ad=0.2516p pd=2.16u as=0.2516p ps=2.16u w=0.74u l=0.13u
X3927 VSS.t1651 VDD VSS.t1650 VSS.t1649 sg13_lv_nmos ad=0.1428p pd=1.52u as=0 ps=0 w=0.42u l=1u
X3928 VDD VSS.t2802 VDD VDD sg13_lv_pmos ad=0.19p pd=1.38u as=0 ps=0 w=1u l=1u
X3929 sg13g2_nand2_2_0.A a_13002_14484# VDD VDD sg13_lv_pmos ad=0.3808p pd=2.92u as=0.2128p ps=1.5u w=1.12u l=0.13u
X3930 VSS.t2355 VDD VSS.t2357 VSS.t2356 sg13_lv_nmos ad=79.8f pd=0.8u as=0 ps=0 w=0.42u l=1u
X3931 VDD VSS.t1565 VDD VDD sg13_lv_pmos ad=0.34p pd=2.68u as=0 ps=0 w=1u l=1u
X3932 VDD VSS.t911 VDD VDD sg13_lv_pmos ad=0.19p pd=1.38u as=0 ps=0 w=1u l=1u
X3933 VSS.t1362 VDD VSS.t1361 VSS.t305 sg13_lv_nmos ad=0.1428p pd=1.52u as=0 ps=0 w=0.42u l=1u
X3934 VSS.t705 VDD VSS.t705 VSS.t708 sg13_lv_nmos ad=79.8f pd=0.8u as=0 ps=0 w=0.42u l=1u
X3935 VSS.t1646 VDD VSS.t1645 VSS.t1644 sg13_lv_nmos ad=0.1428p pd=1.52u as=0 ps=0 w=0.42u l=1u
X3936 VSS.t2395 VDD VSS.t2397 VSS.t2396 sg13_lv_nmos ad=79.8f pd=0.8u as=0 ps=0 w=0.42u l=1u
X3937 VSS.t2203 VDD VSS.t2205 VSS.t2204 sg13_lv_nmos ad=79.8f pd=0.8u as=0 ps=0 w=0.42u l=1u
X3938 VSS.t42 a_4655_15311# a_5322_15532# VSS.t41 sg13_lv_nmos ad=0.1406p pd=1.12u as=0.2516p ps=2.16u w=0.74u l=0.13u
X3939 VSS.t1392 VDD VSS.t1393 VSS.t305 sg13_lv_nmos ad=79.8f pd=0.8u as=0 ps=0 w=0.42u l=1u
X3940 VDD VSS.t564 VDD VDD sg13_lv_pmos ad=0.19p pd=1.38u as=0 ps=0 w=1u l=1u
X3941 VDD VSS.t1305 VDD VDD sg13_lv_pmos ad=0.34p pd=2.68u as=0 ps=0 w=1u l=1u
X3942 VDD VSS.t2813 VDD VDD sg13_lv_pmos ad=0.34p pd=2.68u as=0 ps=0 w=1u l=1u
X3943 VSS.t2123 VDD VSS.t2122 VSS.t2121 sg13_lv_nmos ad=0.1428p pd=1.52u as=0 ps=0 w=0.42u l=1u
X3944 VDD sg13g2_buf_16_1.X a_19630_15238# VDD sg13_lv_pmos ad=0.2128p pd=1.5u as=0.2128p ps=1.5u w=1.12u l=0.13u
X3945 VDD VSS.t2120 VDD VDD sg13_lv_pmos ad=0.19p pd=1.38u as=0 ps=0 w=1u l=1u
X3946 a_11866_15202# sg13g2_nand2_2_0.A VDD VDD sg13_lv_pmos ad=0.1428p pd=1.52u as=0.1523p ps=1.38u w=0.42u l=0.13u
X3947 VSS.t1766 VDD VSS.t1765 VSS.t1764 sg13_lv_nmos ad=0.1428p pd=1.52u as=0 ps=0 w=0.42u l=1u
X3948 VDD VSS.t1261 VDD VDD sg13_lv_pmos ad=0.19p pd=1.38u as=0 ps=0 w=1u l=1u
X3949 VSS.t399 VDD VSS.t394 VSS.t398 sg13_lv_nmos ad=0.1428p pd=1.52u as=0 ps=0 w=0.42u l=1u
X3950 VSS.t569 VDD VSS.t569 VSS.t571 sg13_lv_nmos ad=79.8f pd=0.8u as=0 ps=0 w=0.42u l=1u
X3951 VDD VSS.t1118 VDD VDD sg13_lv_pmos ad=0.34p pd=2.68u as=0 ps=0 w=1u l=1u
X3952 VSS.t2575 VDD VSS.t2574 VSS.t2573 sg13_lv_nmos ad=0.1428p pd=1.52u as=0 ps=0 w=0.42u l=1u
X3953 VSS.t444 VDD VSS.t443 VSS.t442 sg13_lv_nmos ad=0.1428p pd=1.52u as=0 ps=0 w=0.42u l=1u
X3954 VSS.t683 VDD VSS.t686 VSS.t792 sg13_lv_nmos ad=79.8f pd=0.8u as=0 ps=0 w=0.42u l=1u
X3955 VDD VSS.t1605 VDD VDD sg13_lv_pmos ad=0.34p pd=2.68u as=0 ps=0 w=1u l=1u
X3956 VDD VSS.t1955 VDD VDD sg13_lv_pmos ad=0.19p pd=1.38u as=0 ps=0 w=1u l=1u
X3957 VSS.t2858 VDD VSS.t2859 VSS.t2710 sg13_lv_nmos ad=79.8f pd=0.8u as=0 ps=0 w=0.42u l=1u
X3958 VDD VSS.t2794 VDD VDD sg13_lv_pmos ad=0.19p pd=1.38u as=0 ps=0 w=1u l=1u
X3959 VSS.t2073 VDD VSS.t2072 VSS.t2071 sg13_lv_nmos ad=0.1428p pd=1.52u as=0 ps=0 w=0.42u l=1u
X3960 VDD VSS.t878 VDD VDD sg13_lv_pmos ad=0.34p pd=2.68u as=0 ps=0 w=1u l=1u
X3961 VSS.t1676 VDD VSS.t1678 VSS.t1677 sg13_lv_nmos ad=79.8f pd=0.8u as=0 ps=0 w=0.42u l=1u
X3962 VDD a_11866_15202# a_11585_15424# VDD sg13_lv_pmos ad=0.1523p pd=1.38u as=0.34p ps=2.68u w=1u l=0.5u
X3963 a_14927_14845# a_14085_14495# a_13668_14488# VDD sg13_lv_pmos ad=0.2048p pd=1.63u as=0.34p ps=2.68u w=1u l=0.13u
X3964 VSS.t2804 VDD VSS.t2805 VSS.t2710 sg13_lv_nmos ad=79.8f pd=0.8u as=0 ps=0 w=0.42u l=1u
X3965 VDD VSS.t2547 VDD VDD sg13_lv_pmos ad=0.19p pd=1.38u as=0 ps=0 w=1u l=1u
X3966 VDD VSS.t993 VDD VDD sg13_lv_pmos ad=0.34p pd=2.68u as=0 ps=0 w=1u l=1u
X3967 VSS.t1374 VDD VSS.t1373 VSS.t305 sg13_lv_nmos ad=0.1428p pd=1.52u as=0 ps=0 w=0.42u l=1u
X3968 VSS.t1596 VDD VSS.t1595 VSS.t1594 sg13_lv_nmos ad=0.1428p pd=1.52u as=0 ps=0 w=0.42u l=1u
X3969 a_23709_14508# sg13g2_nor3_1_0.Y VDD VDD sg13_lv_pmos ad=0.3325p pd=1.665u as=0.253p ps=1.53u w=1u l=0.13u
X3970 VDD VSS.t2322 VDD VDD sg13_lv_pmos ad=0.19p pd=1.38u as=0 ps=0 w=1u l=1u
X3971 VSS.t2153 VDD VSS.t2155 VSS.t2154 sg13_lv_nmos ad=79.8f pd=0.8u as=0 ps=0 w=0.42u l=1u
X3972 VDD VSS.t1317 VDD VDD sg13_lv_pmos ad=0.34p pd=2.68u as=0 ps=0 w=1u l=1u
X3973 VDD VSS.t2805 VDD VDD sg13_lv_pmos ad=0.34p pd=2.68u as=0 ps=0 w=1u l=1u
X3974 VDD VSS.t2112 VDD VDD sg13_lv_pmos ad=0.34p pd=2.68u as=0 ps=0 w=1u l=1u
X3975 VDD a_19150_13239# sg13g2_or3_1_0.A VDD sg13_lv_pmos ad=0.2254p pd=1.53u as=0.4256p ps=3u w=1.12u l=0.13u
X3976 VSS.t2370 VDD VSS.t2369 VSS.t2368 sg13_lv_nmos ad=0.1428p pd=1.52u as=0 ps=0 w=0.42u l=1u
X3977 a_10884_14922# sg13g2_and2_1_2.X a_10790_14922# VSS.t262 sg13_lv_nmos ad=60.89999f pd=0.71u as=0.1428p ps=1.52u w=0.42u l=0.13u
X3978 VDD VSS.t175 VDD VDD sg13_lv_pmos ad=0.34p pd=2.68u as=0 ps=0 w=1u l=1u
X3979 VDD VSS.t931 VDD VDD sg13_lv_pmos ad=0.19p pd=1.38u as=0 ps=0 w=1u l=1u
X3980 VSS.t2748 VDD VSS.t2749 VSS.t2710 sg13_lv_nmos ad=79.8f pd=0.8u as=0 ps=0 w=0.42u l=1u
X3981 VSS.t2340 VDD VSS.t2342 VSS.t2341 sg13_lv_nmos ad=79.8f pd=0.8u as=0 ps=0 w=0.42u l=1u
X3982 VSS.t3135 VDD VSS.t3137 VSS.t3136 sg13_lv_nmos ad=79.8f pd=0.8u as=0 ps=0 w=0.42u l=1u
X3983 a_26927_14845# a_26085_14495# a_26833_14845# VSS.t8 sg13_lv_nmos ad=0.12665p pd=1.145u as=0.1428p ps=1.52u w=0.42u l=0.13u
X3984 VSS.t1099 VDD VSS.t1098 VSS.t1097 sg13_lv_nmos ad=0.1428p pd=1.52u as=0 ps=0 w=0.42u l=1u
X3985 VDD VSS.t1352 VDD VDD sg13_lv_pmos ad=0.19p pd=1.38u as=0 ps=0 w=1u l=1u
X3986 VDD VSS.t893 VDD VDD sg13_lv_pmos ad=0.34p pd=2.68u as=0 ps=0 w=1u l=1u
X3987 VDD VSS.t1760 VDD VDD sg13_lv_pmos ad=0.34p pd=2.68u as=0 ps=0 w=1u l=1u
X3988 VSS.t1301 VDD VSS.t1302 VSS.t305 sg13_lv_nmos ad=79.8f pd=0.8u as=0 ps=0 w=0.42u l=1u
X3989 VDD a_11493_14495# a_11595_14495# VDD sg13_lv_pmos ad=2.75157p pd=17.885u as=0.3864p ps=2.93u w=1.12u l=0.13u
X3990 VDD VSS.t1625 VDD VDD sg13_lv_pmos ad=0.34p pd=2.68u as=0 ps=0 w=1u l=1u
X3991 VSS.t1983 VDD VSS.t1985 VSS.t1984 sg13_lv_nmos ad=79.8f pd=0.8u as=0 ps=0 w=0.42u l=1u
X3992 VDD VSS.t2768 VDD VDD sg13_lv_pmos ad=0.34p pd=2.68u as=0 ps=0 w=1u l=1u
X3993 sg13g2_nand2_2_0.A a_13002_14484# VSS.t89 VSS.t88 sg13_lv_nmos ad=0.2516p pd=2.16u as=0.1406p ps=1.12u w=0.74u l=0.13u
X3994 VSS.t1522 VDD VSS.t1521 VSS.t305 sg13_lv_nmos ad=0.1428p pd=1.52u as=0 ps=0 w=0.42u l=1u
X3995 a_13782_13738# sg13g2_xor2_1_1.B sg13g2_xor2_1_1.X VSS.t0 sg13_lv_nmos ad=88.8f pd=0.98u as=0.1628p ps=1.18u w=0.74u l=0.13u
X3996 VSS.t904 VDD VSS.t906 VSS.t905 sg13_lv_nmos ad=79.8f pd=0.8u as=0 ps=0 w=0.42u l=1u
X3997 VSS.t1581 VDD VSS.t1580 VSS.t1579 sg13_lv_nmos ad=0.1428p pd=1.52u as=0 ps=0 w=0.42u l=1u
X3998 VDD VSS.t32 VDD VDD sg13_lv_pmos ad=0.34p pd=2.68u as=0 ps=0 w=1u l=1u
X3999 VDD VSS.t963 VDD VDD sg13_lv_pmos ad=0.34p pd=2.68u as=0 ps=0 w=1u l=1u
X4000 VDD VSS.t1336 VDD VDD sg13_lv_pmos ad=0.19p pd=1.38u as=0 ps=0 w=1u l=1u
X4001 VSS.t2188 VDD VSS.t2190 VSS.t2189 sg13_lv_nmos ad=79.8f pd=0.8u as=0 ps=0 w=0.42u l=1u
X4002 VDD VSS.t2145 VDD VDD sg13_lv_pmos ad=0.19p pd=1.38u as=0 ps=0 w=1u l=1u
X4003 VDD VSS.t1590 VDD VDD sg13_lv_pmos ad=0.34p pd=2.68u as=0 ps=0 w=1u l=1u
X4004 VSS.t2780 VDD VSS.t2779 VSS.t2710 sg13_lv_nmos ad=0.1428p pd=1.52u as=0 ps=0 w=0.42u l=1u
X4005 VDD VSS.t2499 VDD VDD sg13_lv_pmos ad=0.34p pd=2.68u as=0 ps=0 w=1u l=1u
X4006 VSS.t2560 VDD VSS.t2559 VSS.t2558 sg13_lv_nmos ad=0.1428p pd=1.52u as=0 ps=0 w=0.42u l=1u
X4007 VDD VSS.t3069 VDD VDD sg13_lv_pmos ad=0.34p pd=2.68u as=0 ps=0 w=1u l=1u
X4008 VSS.t2108 VDD VSS.t2107 VSS.t2106 sg13_lv_nmos ad=0.1428p pd=1.52u as=0 ps=0 w=0.42u l=1u
X4009 VDD VSS.t439 VDD VDD sg13_lv_pmos ad=0.19p pd=1.38u as=0 ps=0 w=1u l=1u
X4010 VSS.t2325 VDD VSS.t2327 VSS.t2326 sg13_lv_nmos ad=79.8f pd=0.8u as=0 ps=0 w=0.42u l=1u
X4011 VSS.t2058 VDD VSS.t2060 VSS.t2059 sg13_lv_nmos ad=79.8f pd=0.8u as=0 ps=0 w=0.42u l=1u
X4012 VDD VSS.t2 VDD VDD sg13_lv_pmos ad=0.19p pd=1.38u as=0 ps=0 w=1u l=1u
X4013 a_19150_13239# a_19265_13238# VDD VDD sg13_lv_pmos ad=0.34p pd=2.68u as=0.2254p ps=1.53u w=1u l=0.5u
X4014 VDD VSS.t1048 VDD VDD sg13_lv_pmos ad=0.34p pd=2.68u as=0 ps=0 w=1u l=1u
X4015 VDD VSS.t1603 VDD VDD sg13_lv_pmos ad=0.19p pd=1.38u as=0 ps=0 w=1u l=1u
X4016 VSS.t74 a_13079_16301# a_13079_16301# VSS.t341 sg13_lv_nmos ad=5.31717p pd=34.515u as=0.111p ps=1.34u w=0.3u l=0.13u
X4017 VSS.t2400 VDD VSS.t2402 VSS.t2401 sg13_lv_nmos ad=79.8f pd=0.8u as=0 ps=0 w=0.42u l=1u
X4018 VDD VSS.t2200 VDD VDD sg13_lv_pmos ad=0.19p pd=1.38u as=0 ps=0 w=1u l=1u
X4019 VDD VSS.t92 VDD VDD sg13_lv_pmos ad=0.34p pd=2.68u as=0 ps=0 w=1u l=1u
X4020 VSS.t632 VDD VSS.t634 VSS.t633 sg13_lv_nmos ad=79.8f pd=0.8u as=0 ps=0 w=0.42u l=1u
X4021 a_19162_15202# sg13g2_dfrbpq_1_6.Q VDD VDD sg13_lv_pmos ad=0.1428p pd=1.52u as=0.1523p ps=1.38u w=0.42u l=0.13u
X4022 VDD VSS.t1940 VDD VDD sg13_lv_pmos ad=0.19p pd=1.38u as=0 ps=0 w=1u l=1u
X4023 VSS.t2849 VDD VSS.t2850 VSS.t2710 sg13_lv_nmos ad=79.8f pd=0.8u as=0 ps=0 w=0.42u l=1u
X4024 VDD VSS.t2733 VDD VDD sg13_lv_pmos ad=0.19p pd=1.38u as=0 ps=0 w=1u l=1u
X4025 a_18885_13701# sg13g2_dfrbpq_1_7.CLK VDD VDD sg13_lv_pmos ad=0.4088p pd=2.97u as=2.6415p ps=17.17u w=1.12u l=0.13u
X4026 VDD VSS.t1369 VDD VDD sg13_lv_pmos ad=0.19p pd=1.38u as=0 ps=0 w=1u l=1u
X4027 VSS.t1621 VDD VSS.t1620 VSS.t1619 sg13_lv_nmos ad=0.1428p pd=1.52u as=0 ps=0 w=0.42u l=1u
X4028 VSS.t3150 VDD VSS.t3149 VSS.t3148 sg13_lv_nmos ad=0.1428p pd=1.52u as=0 ps=0 w=0.42u l=1u
X4029 VSS.t2355 VDD VSS.t2354 VSS.t2353 sg13_lv_nmos ad=0.1428p pd=1.52u as=0 ps=0 w=0.42u l=1u
X4030 VDD sg13g2_and2_1_0.B a_2733_14832# VDD sg13_lv_pmos ad=0.1918p pd=1.5u as=0.1596p ps=1.22u w=0.84u l=0.13u
X4031 VDD VSS.t1111 VDD VDD sg13_lv_pmos ad=0.19p pd=1.38u as=0 ps=0 w=1u l=1u
X4032 VSS.t2955 VDD VSS.t2824 VSS.t2710 sg13_lv_nmos ad=0.1428p pd=1.52u as=0 ps=0 w=0.42u l=1u
X4033 VDD VSS.t420 VDD VDD sg13_lv_pmos ad=0.19p pd=1.38u as=0 ps=0 w=1u l=1u
X4034 VSS.t498 VDD VSS.t498 VSS.t500 sg13_lv_nmos ad=79.8f pd=0.8u as=0 ps=0 w=0.42u l=1u
X4035 VDD VSS.t129 VDD VDD sg13_lv_pmos ad=0.19p pd=1.38u as=0 ps=0 w=1u l=1u
X4036 VDD VSS.t1743 VDD VDD sg13_lv_pmos ad=0.19p pd=1.38u as=0 ps=0 w=1u l=1u
X4037 VSS.t781 VDD VSS.t56 VSS.t780 sg13_lv_nmos ad=0.1428p pd=1.52u as=0 ps=0 w=0.42u l=1u
X4038 VSS.t160 VDD VSS.t158 VSS.t7 sg13_lv_nmos ad=0.1428p pd=1.52u as=0 ps=0 w=0.42u l=1u
X4039 VDD VSS.t724 VDD VDD sg13_lv_pmos ad=0.34p pd=2.68u as=0 ps=0 w=1u l=1u
X4040 VDD VSS.t322 VDD VDD sg13_lv_pmos ad=0.34p pd=2.68u as=0 ps=0 w=1u l=1u
X4041 VSS.t10 sg13g2_dfrbpq_1_1.RESET_B a_7044_15234# VSS.t44 sg13_lv_nmos ad=0.1626p pd=1.415u as=60.89999f ps=0.71u w=0.42u l=0.13u
X4042 VDD VSS.t2097 VDD VDD sg13_lv_pmos ad=0.34p pd=2.68u as=0 ps=0 w=1u l=1u
X4043 VDD VSS.t664 VDD VDD sg13_lv_pmos ad=0.34p pd=2.68u as=0 ps=0 w=1u l=1u
X4044 VDD VSS.t705 VDD VDD sg13_lv_pmos ad=0.34p pd=2.68u as=0 ps=0 w=1u l=1u
X4045 VDD VSS.t71 VDD VDD sg13_lv_pmos ad=0.19p pd=1.38u as=0 ps=0 w=1u l=1u
X4046 a_3753_15625# a_3396_15552# VDD VDD sg13_lv_pmos ad=63f pd=0.72u as=0.1563p ps=1.22u w=0.42u l=0.13u
X4047 VSS.t545 VDD VSS.t545 VSS.t597 sg13_lv_nmos ad=79.8f pd=0.8u as=0 ps=0 w=0.42u l=1u
X4048 VDD VSS.t1377 VDD VDD sg13_lv_pmos ad=0.19p pd=1.38u as=0 ps=0 w=1u l=1u
X4049 VSS.t1410 VDD VSS.t1250 VSS.t305 sg13_lv_nmos ad=0.1428p pd=1.52u as=0 ps=0 w=0.42u l=1u
X4050 VSS.t1359 VDD VSS.t1360 VSS.t305 sg13_lv_nmos ad=79.8f pd=0.8u as=0 ps=0 w=0.42u l=1u
X4051 VSS.t2545 VDD VSS.t2544 VSS.t2543 sg13_lv_nmos ad=0.1428p pd=1.52u as=0 ps=0 w=0.42u l=1u
X4052 VSS.t1009 VDD VSS.t1011 VSS.t1010 sg13_lv_nmos ad=79.8f pd=0.8u as=0 ps=0 w=0.42u l=1u
X4053 VDD VSS.t2362 VDD VDD sg13_lv_pmos ad=0.19p pd=1.38u as=0 ps=0 w=1u l=1u
X4054 VDD VSS.t1610 VDD VDD sg13_lv_pmos ad=0.34p pd=2.68u as=0 ps=0 w=1u l=1u
X4055 VSS.t2971 VDD VSS.t2841 VSS.t2710 sg13_lv_nmos ad=79.8f pd=0.8u as=0 ps=0 w=0.42u l=1u
X4056 VDD VSS.t1078 VDD VDD sg13_lv_pmos ad=0.34p pd=2.68u as=0 ps=0 w=1u l=1u
X4057 VDD VSS.t393 VDD VDD sg13_lv_pmos ad=0.34p pd=2.68u as=0 ps=0 w=1u l=1u
X4058 VSS.t904 VDD VSS.t906 VSS.t905 sg13_lv_nmos ad=79.8f pd=0.8u as=0 ps=0 w=0.42u l=1u
X4059 VDD VSS.t1650 VDD VDD sg13_lv_pmos ad=0.34p pd=2.68u as=0 ps=0 w=1u l=1u
X4060 VSS.t1968 VDD VSS.t1970 VSS.t1969 sg13_lv_nmos ad=79.8f pd=0.8u as=0 ps=0 w=0.42u l=1u
X4061 sg13g2_nor4_2_0.Y sg13g2_nor3_1_0.C a_22202_14484# VDD sg13_lv_pmos ad=0.2128p pd=1.5u as=0.3808p ps=2.92u w=1.12u l=0.13u
X4062 VDD VSS.t673 VDD VDD sg13_lv_pmos ad=0.34p pd=2.68u as=0 ps=0 w=1u l=1u
X4063 VSS.t1681 VDD VSS.t1683 VSS.t1682 sg13_lv_nmos ad=79.8f pd=0.8u as=0 ps=0 w=0.42u l=1u
X4064 VSS.t719 VDD VSS.t719 VSS.t836 sg13_lv_nmos ad=79.8f pd=0.8u as=0 ps=0 w=0.42u l=1u
X4065 VSS.t2807 VDD VSS.t2808 VSS.t2710 sg13_lv_nmos ad=79.8f pd=0.8u as=0 ps=0 w=0.42u l=1u
X4066 VDD VSS.t1328 VDD VDD sg13_lv_pmos ad=0.19p pd=1.38u as=0 ps=0 w=1u l=1u
X4067 VSS.t1566 VDD VSS.t1565 VSS.t1564 sg13_lv_nmos ad=0.1428p pd=1.52u as=0 ps=0 w=0.42u l=1u
X4068 a_12524_15960# sg13g2_nand2_2_0.A VDD VDD sg13_lv_pmos ad=0.2856p pd=2.36u as=0.2114p ps=1.54u w=0.84u l=0.13u
X4069 VSS.t2158 VDD VSS.t2160 VSS.t2159 sg13_lv_nmos ad=79.8f pd=0.8u as=0 ps=0 w=0.42u l=1u
X4070 VDD VSS.t1299 VDD VDD sg13_lv_pmos ad=0.34p pd=2.68u as=0 ps=0 w=1u l=1u
X4071 VDD VSS.t2808 VDD VDD sg13_lv_pmos ad=0.34p pd=2.68u as=0 ps=0 w=1u l=1u
X4072 VDD VSS.t2082 VDD VDD sg13_lv_pmos ad=0.34p pd=2.68u as=0 ps=0 w=1u l=1u
X4073 VSS.t2375 VDD VSS.t2374 VSS.t2373 sg13_lv_nmos ad=0.1428p pd=1.52u as=0 ps=0 w=0.42u l=1u
X4074 VSS.t487 VDD VSS.t208 VSS.t486 sg13_lv_nmos ad=0.1428p pd=1.52u as=0 ps=0 w=0.42u l=1u
X4075 VSS.t2823 VDD VSS.t2822 VSS.t2710 sg13_lv_nmos ad=0.1428p pd=1.52u as=0 ps=0 w=0.42u l=1u
X4076 VDD VSS.t2000 VDD VDD sg13_lv_pmos ad=0.19p pd=1.38u as=0 ps=0 w=1u l=1u
X4077 VSS.t2043 VDD VSS.t2045 VSS.t2044 sg13_lv_nmos ad=79.8f pd=0.8u as=0 ps=0 w=0.42u l=1u
X4078 VSS.t545 VDD VSS.t545 VSS.t547 sg13_lv_nmos ad=79.8f pd=0.8u as=0 ps=0 w=0.42u l=1u
X4079 VSS.t1341 VDD VSS.t1340 VSS.t305 sg13_lv_nmos ad=0.1428p pd=1.52u as=0 ps=0 w=0.42u l=1u
X4080 VDD VSS.t1765 VDD VDD sg13_lv_pmos ad=0.34p pd=2.68u as=0 ps=0 w=1u l=1u
X4081 a_16775_14020# sg13g2_nand2_2_0.Y a_16681_13726# VDD sg13_lv_pmos ad=0.19p pd=1.38u as=0.34p ps=2.68u w=1u l=0.13u
X4082 VSS.t2565 VDD VSS.t2564 VSS.t2563 sg13_lv_nmos ad=0.1428p pd=1.52u as=0 ps=0 w=0.42u l=1u
X4083 VSS.t2385 VDD VSS.t2387 VSS.t2386 sg13_lv_nmos ad=79.8f pd=0.8u as=0 ps=0 w=0.42u l=1u
X4084 VDD sg13g2_and2_1_1.B a_6477_14832# VDD sg13_lv_pmos ad=0.1918p pd=1.5u as=0.1596p ps=1.22u w=0.84u l=0.13u
X4085 VDD VSS.t2347 VDD VDD sg13_lv_pmos ad=0.19p pd=1.38u as=0 ps=0 w=1u l=1u
X4086 VDD VSS.t2185 VDD VDD sg13_lv_pmos ad=0.19p pd=1.38u as=0 ps=0 w=1u l=1u
X4087 VDD VSS.t545 VDD VDD sg13_lv_pmos ad=0.19p pd=1.38u as=0 ps=0 w=1u l=1u
X4088 sg13g2_inv_1_0.Y sg13g2_buf_1_9.X.t3 VDD VDD sg13_lv_pmos ad=0.3808p pd=2.92u as=0.3808p ps=2.92u w=1.12u l=0.13u
X4089 VDD VSS.t2137 VDD VDD sg13_lv_pmos ad=0.34p pd=2.68u as=0 ps=0 w=1u l=1u
X4090 sg13g2_dfrbpq_1_2.CLK a_12308_15202# VDD VDD sg13_lv_pmos ad=0.2128p pd=1.5u as=0.2128p ps=1.5u w=1.12u l=0.13u
X4091 VDD VSS.t524 VDD VDD sg13_lv_pmos ad=0.19p pd=1.38u as=0 ps=0 w=1u l=1u
X4092 VDD VSS.t3267 VDD VDD sg13_lv_pmos ad=0.19p pd=1.38u as=0 ps=0 w=1u l=1u
X4093 VSS.t1953 VDD VSS.t1955 VSS.t1954 sg13_lv_nmos ad=79.8f pd=0.8u as=0 ps=0 w=0.42u l=1u
X4094 a_15610_13690# sg13g2_dlygate4sd3_1_9.A VDD VDD sg13_lv_pmos ad=0.1428p pd=1.52u as=0.1523p ps=1.38u w=0.42u l=0.13u
X4095 VSS.t2947 VDD VSS.t2816 VSS.t2710 sg13_lv_nmos ad=0.1428p pd=1.52u as=0 ps=0 w=0.42u l=1u
X4096 VDD VSS.t2771 VDD VDD sg13_lv_pmos ad=0.34p pd=2.68u as=0 ps=0 w=1u l=1u
X4097 VSS.t622 VDD VSS.t621 VSS.t620 sg13_lv_nmos ad=0.1428p pd=1.52u as=0 ps=0 w=0.42u l=1u
X4098 VDD VSS.t968 VDD VDD sg13_lv_pmos ad=0.34p pd=2.68u as=0 ps=0 w=1u l=1u
X4099 VSS.t2193 VDD VSS.t2195 VSS.t2194 sg13_lv_nmos ad=79.8f pd=0.8u as=0 ps=0 w=0.42u l=1u
X4100 VSS.t545 VDD VSS.t554 VSS.t553 sg13_lv_nmos ad=79.8f pd=0.8u as=0 ps=0 w=0.42u l=1u
X4101 VDD VSS.t1595 VDD VDD sg13_lv_pmos ad=0.34p pd=2.68u as=0 ps=0 w=1u l=1u
X4102 VDD VSS.t2504 VDD VDD sg13_lv_pmos ad=0.34p pd=2.68u as=0 ps=0 w=1u l=1u
X4103 VSS.t89 a_12308_15202# sg13g2_dfrbpq_1_2.CLK VSS.t182 sg13_lv_nmos ad=0.1406p pd=1.12u as=0.1406p ps=1.12u w=0.74u l=0.13u
X4104 sg13g2_buf_16_1.X a_16078_14484# VDD VDD sg13_lv_pmos ad=0.2128p pd=1.5u as=0.2128p ps=1.5u w=1.12u l=0.13u
X4105 VSS.t1696 VDD VSS.t1695 VSS.t1694 sg13_lv_nmos ad=0.1428p pd=1.52u as=0 ps=0 w=0.42u l=1u
X4106 VDD VSS.t2452 VDD VDD sg13_lv_pmos ad=0.19p pd=1.38u as=0 ps=0 w=1u l=1u
X4107 VSS.t2113 VDD VSS.t2112 VSS.t2111 sg13_lv_nmos ad=0.1428p pd=1.52u as=0 ps=0 w=0.42u l=1u
X4108 VDD a_10967_15315# a_10967_15549# VDD sg13_lv_pmos ad=2.4406p pd=15.34u as=0.2442p ps=2.06u w=0.66u l=0.13u
X4109 VSS.t2815 VDD VSS.t2814 VSS.t2710 sg13_lv_nmos ad=0.1428p pd=1.52u as=0 ps=0 w=0.42u l=1u
X4110 VSS.t979 VDD VSS.t981 VSS.t980 sg13_lv_nmos ad=79.8f pd=0.8u as=0 ps=0 w=0.42u l=1u
X4111 VDD a_19630_15238# sg13g2_dfrbpq_1_7.CLK VDD sg13_lv_pmos ad=0.3976p pd=2.95u as=0.2128p ps=1.5u w=1.12u l=0.13u
X4112 VDD VSS.t1295 VDD VDD sg13_lv_pmos ad=0.34p pd=2.68u as=0 ps=0 w=1u l=1u
X4113 VDD sg13g2_dfrbpq_1_4.RESET_B a_25670_15234# VDD sg13_lv_pmos ad=0.36237p pd=2.605u as=79.8f ps=0.8u w=0.42u l=0.13u
X4114 VSS.t1009 VDD VSS.t1011 VSS.t1010 sg13_lv_nmos ad=79.8f pd=0.8u as=0 ps=0 w=0.42u l=1u
X4115 a_25642_14452# a_26085_14495# a_25382_14922# VSS.t5 sg13_lv_nmos ad=79.8f pd=0.8u as=0.1296p ps=1.52u w=0.42u l=0.13u
X4116 VDD VSS.t2170 VDD VDD sg13_lv_pmos ad=0.19p pd=1.38u as=0 ps=0 w=1u l=1u
X4117 VSS.t1988 VDD VSS.t1990 VSS.t1989 sg13_lv_nmos ad=79.8f pd=0.8u as=0 ps=0 w=0.42u l=1u
X4118 VSS.t681 VDD VSS.t2 VSS.t680 sg13_lv_nmos ad=0.1428p pd=1.52u as=0 ps=0 w=0.42u l=1u
X4119 VDD VSS.t1945 VDD VDD sg13_lv_pmos ad=0.19p pd=1.38u as=0 ps=0 w=1u l=1u
X4120 VDD VSS.t2736 VDD VDD sg13_lv_pmos ad=0.19p pd=1.38u as=0 ps=0 w=1u l=1u
X4121 VDD VSS.t2789 VDD VDD sg13_lv_pmos ad=0.19p pd=1.38u as=0 ps=0 w=1u l=1u
X4122 sg13g2_o21ai_1_0.Y sg13g2_nand2_1_1.A a_15958_15230# VSS.t21 sg13_lv_nmos ad=0.2516p pd=2.16u as=0.1406p ps=1.12u w=0.74u l=0.15u
X4123 VSS.t1626 VDD VSS.t1625 VSS.t1624 sg13_lv_nmos ad=0.1428p pd=1.52u as=0 ps=0 w=0.42u l=1u
X4124 VSS.t3155 VDD VSS.t3154 VSS.t3153 sg13_lv_nmos ad=0.1428p pd=1.52u as=0 ps=0 w=0.42u l=1u
X4125 VSS.t2360 VDD VSS.t2359 VSS.t2358 sg13_lv_nmos ad=0.1428p pd=1.52u as=0 ps=0 w=0.42u l=1u
X4126 sg13g2_dfrbpq_1_2.CLK a_12308_15202# VDD VDD sg13_lv_pmos ad=0.2128p pd=1.5u as=0.2128p ps=1.5u w=1.12u l=0.13u
X4127 sg13g2_dfrbpq_1_7.CLK a_19630_15238# VSS.t160 VSS.t3 sg13_lv_nmos ad=0.1406p pd=1.12u as=0.1406p ps=1.12u w=0.74u l=0.13u
X4128 VDD a_8986_14448# a_8705_14750# VDD sg13_lv_pmos ad=0.1523p pd=1.38u as=0.34p ps=2.68u w=1u l=0.5u
X4129 VSS.t2530 VDD VSS.t2532 VSS.t2531 sg13_lv_nmos ad=79.8f pd=0.8u as=0 ps=0 w=0.42u l=1u
X4130 VSS.t257 a_27322_13690# a_27041_13912# VSS.t353 sg13_lv_nmos ad=79.8f pd=0.8u as=0.1428p ps=1.52u w=0.42u l=0.5u
X4131 VSS.t714 VDD VSS.t714 VSS.t717 sg13_lv_nmos ad=79.8f pd=0.8u as=0 ps=0 w=0.42u l=1u
X4132 a_24766_14854# sg13g2_mux2_1_1.A0 a_24669_14508# VDD sg13_lv_pmos ad=0.2225p pd=1.445u as=0.3325p ps=1.665u w=1u l=0.13u
X4133 VDD VSS.t1331 VDD VDD sg13_lv_pmos ad=0.19p pd=1.38u as=0 ps=0 w=1u l=1u
X4134 VSS.t2799 VDD VSS.t2800 VSS.t2710 sg13_lv_nmos ad=79.8f pd=0.8u as=0 ps=0 w=0.42u l=1u
X4135 VDD VSS.t2537 VDD VDD sg13_lv_pmos ad=0.19p pd=1.38u as=0 ps=0 w=1u l=1u
X4136 VSS.t2435 VDD VSS.t2434 VSS.t2433 sg13_lv_nmos ad=0.1428p pd=1.52u as=0 ps=0 w=0.42u l=1u
X4137 VDD a_7450_14448# a_7169_14750# VDD sg13_lv_pmos ad=0.1523p pd=1.38u as=0.34p ps=2.68u w=1u l=0.5u
X4138 a_17014_13350# sg13g2_nand2_2_0.Y VSS.t129 VSS.t278 sg13_lv_nmos ad=0.1406p pd=1.12u as=0.1406p ps=1.12u w=0.74u l=0.15u
X4139 VSS.t1281 VDD VSS.t1282 VSS.t305 sg13_lv_nmos ad=79.8f pd=0.8u as=0 ps=0 w=0.42u l=1u
X4140 VSS.t2143 VDD VSS.t2145 VSS.t2144 sg13_lv_nmos ad=79.8f pd=0.8u as=0 ps=0 w=0.42u l=1u
X4141 a_11470_15423# a_11585_15424# VDD VDD sg13_lv_pmos ad=0.34p pd=2.68u as=0.2254p ps=1.53u w=1u l=0.5u
X4142 VSS.t89 a_12308_15202# sg13g2_dfrbpq_1_2.CLK VSS.t182 sg13_lv_nmos ad=0.1406p pd=1.12u as=0.1406p ps=1.12u w=0.74u l=0.13u
X4143 a_12335_14845# a_11493_14495# a_12241_14845# VSS.t88 sg13_lv_nmos ad=0.12665p pd=1.145u as=0.1428p ps=1.52u w=0.42u l=0.13u
X4144 a_26085_14495# sg13g2_dfrbpq_1_7.CLK VDD VDD sg13_lv_pmos ad=0.4088p pd=2.97u as=2.6415p ps=17.17u w=1.12u l=0.13u
X4145 VDD VSS.t1291 VDD VDD sg13_lv_pmos ad=0.34p pd=2.68u as=0 ps=0 w=1u l=1u
X4146 VDD VSS.t2800 VDD VDD sg13_lv_pmos ad=0.34p pd=2.68u as=0 ps=0 w=1u l=1u
X4147 VSS.t2098 VDD VSS.t2097 VSS.t2096 sg13_lv_nmos ad=0.1428p pd=1.52u as=0 ps=0 w=0.42u l=1u
X4148 a_12592_14726# sg13g2_dfrbpq_1_2.RESET_B VDD VDD sg13_lv_pmos ad=79.8f pd=0.8u as=2.75157p ps=17.885u w=0.42u l=0.13u
X4149 VSS.t2 sg13g2_xor2_1_1.A a_13626_13918# VSS.t61 sg13_lv_nmos ad=0.374p pd=2.46u as=0.17462p ps=1.185u w=0.55u l=0.13u
X4150 VSS.t2743 VDD VSS.t2744 VSS.t2710 sg13_lv_nmos ad=79.8f pd=0.8u as=0 ps=0 w=0.42u l=1u
X4151 VDD a_14927_14845# a_15184_14726# VDD sg13_lv_pmos ad=2.75157p pd=17.885u as=79.8f ps=0.8u w=0.42u l=0.13u
X4152 VSS.t1504 VDD VSS.t1367 VSS.t305 sg13_lv_nmos ad=0.1428p pd=1.52u as=0 ps=0 w=0.42u l=1u
X4153 VDD VSS.t1345 VDD VDD sg13_lv_pmos ad=0.34p pd=2.68u as=0 ps=0 w=1u l=1u
X4154 VDD VSS.t2851 VDD VDD sg13_lv_pmos ad=0.34p pd=2.68u as=0 ps=0 w=1u l=1u
X4155 VDD VSS.t2162 VDD VDD sg13_lv_pmos ad=0.34p pd=2.68u as=0 ps=0 w=1u l=1u
X4156 VDD a_19630_15238# sg13g2_dfrbpq_1_7.CLK VDD sg13_lv_pmos ad=0.2128p pd=1.5u as=0.2128p ps=1.5u w=1.12u l=0.13u
X4157 sg13g2_dlygate4sd3_1_9.A a_15594_14484# VDD VDD sg13_lv_pmos ad=0.3808p pd=2.92u as=0.2128p ps=1.5u w=1.12u l=0.13u
X4158 VSS.t2550 VDD VSS.t2549 VSS.t2548 sg13_lv_nmos ad=0.1428p pd=1.52u as=0 ps=0 w=0.42u l=1u
X4159 VDD VSS.t2332 VDD VDD sg13_lv_pmos ad=0.19p pd=1.38u as=0 ps=0 w=1u l=1u
X4160 VDD VSS.t456 VDD VDD sg13_lv_pmos ad=0.19p pd=1.38u as=0 ps=0 w=1u l=1u
X4161 VDD VSS.t1615 VDD VDD sg13_lv_pmos ad=0.34p pd=2.68u as=0 ps=0 w=1u l=1u
X4162 VSS.t2974 VDD VSS.t2844 VSS.t2710 sg13_lv_nmos ad=79.8f pd=0.8u as=0 ps=0 w=0.42u l=1u
X4163 VDD VSS.t2122 VDD VDD sg13_lv_pmos ad=0.34p pd=2.68u as=0 ps=0 w=1u l=1u
X4164 VDD VSS.t876 VDD VDD sg13_lv_pmos ad=0.19p pd=1.38u as=0 ps=0 w=1u l=1u
X4165 VDD VSS.t3252 VDD VDD sg13_lv_pmos ad=0.19p pd=1.38u as=0 ps=0 w=1u l=1u
X4166 VSS.t1938 VDD VSS.t1940 VSS.t1939 sg13_lv_nmos ad=79.8f pd=0.8u as=0 ps=0 w=0.42u l=1u
X4167 VDD VSS.t1620 VDD VDD sg13_lv_pmos ad=0.34p pd=2.68u as=0 ps=0 w=1u l=1u
X4168 VDD VSS.t2763 VDD VDD sg13_lv_pmos ad=0.34p pd=2.68u as=0 ps=0 w=1u l=1u
X4169 sg13g2_dfrbpq_1_7.CLK a_19630_15238# VSS.t125 VSS.t3 sg13_lv_nmos ad=0.1406p pd=1.12u as=0.1406p ps=1.12u w=0.74u l=0.13u
X4170 VSS.t964 VDD VSS.t963 VSS.t962 sg13_lv_nmos ad=0.1428p pd=1.52u as=0 ps=0 w=0.42u l=1u
X4171 a_26062_13911# a_26177_13912# VSS.t693 VSS.t3312 sg13_lv_nmos ad=0.1428p pd=1.52u as=0.1426p ps=1.16u w=0.42u l=0.5u
X4172 a_26661_16033# a_26661_16033# VSS.t74 VSS.t170 sg13_lv_nmos ad=0.111p pd=1.34u as=5.31717p ps=34.515u w=0.3u l=0.13u
X4173 VSS.t32 sg13g2_xnor2_1_1.A a_10325_14854# VSS.t96 sg13_lv_nmos ad=0.1898p pd=1.36u as=0.2516p ps=2.16u w=0.74u l=0.13u
X4174 VSS.t273 sg13g2_inv_1_1.Y sg13g2_nor4_2_0.Y VSS.t7 sg13_lv_nmos ad=0.2553p pd=2.17u as=0.1406p ps=1.12u w=0.74u l=0.13u
X4175 VDD VSS.t1580 VDD VDD sg13_lv_pmos ad=0.34p pd=2.68u as=0 ps=0 w=1u l=1u
X4176 VSS.t2861 VDD VSS.t2860 VSS.t2710 sg13_lv_nmos ad=0.1428p pd=1.52u as=0 ps=0 w=0.42u l=1u
X4177 VDD VSS.t2489 VDD VDD sg13_lv_pmos ad=0.34p pd=2.68u as=0 ps=0 w=1u l=1u
X4178 a_20272_14726# sg13g2_dfrbpq_1_6.RESET_B VDD VDD sg13_lv_pmos ad=79.8f pd=0.8u as=2.75157p ps=17.885u w=0.42u l=0.13u
X4179 VSS.t81 sg13g2_dfrbpq_1_5.RESET_B a_25476_14922# VSS.t82 sg13_lv_nmos ad=0.1626p pd=1.415u as=60.89999f ps=0.71u w=0.42u l=0.13u
X4180 VSS.t664 VDD VSS.t664 VSS.t666 sg13_lv_nmos ad=0.1428p pd=1.52u as=0 ps=0 w=0.42u l=1u
X4181 VSS.t695 VDD VSS.t695 VSS.t817 sg13_lv_nmos ad=0.1428p pd=1.52u as=0 ps=0 w=0.42u l=1u
X4182 VDD VSS.t700 VDD VDD sg13_lv_pmos ad=0.34p pd=2.68u as=0 ps=0 w=1u l=1u
X4183 VSS.t2380 VDD VSS.t2379 VSS.t2378 sg13_lv_nmos ad=0.1428p pd=1.52u as=0 ps=0 w=0.42u l=1u
X4184 VSS.t979 VDD VSS.t981 VSS.t980 sg13_lv_nmos ad=79.8f pd=0.8u as=0 ps=0 w=0.42u l=1u
X4185 VDD VSS.t629 VDD VDD sg13_lv_pmos ad=0.19p pd=1.38u as=0 ps=0 w=1u l=1u
X4186 a_15214_13911# a_15329_13912# VSS.t56 VSS.t232 sg13_lv_nmos ad=0.1428p pd=1.52u as=0.1426p ps=1.16u w=0.42u l=0.5u
X4187 VSS.t2807 VDD VSS.t2806 VSS.t2710 sg13_lv_nmos ad=0.1428p pd=1.52u as=0 ps=0 w=0.42u l=1u
X4188 VDD VSS.t891 VDD VDD sg13_lv_pmos ad=0.19p pd=1.38u as=0 ps=0 w=1u l=1u
X4189 VDD VSS.t2005 VDD VDD sg13_lv_pmos ad=0.19p pd=1.38u as=0 ps=0 w=1u l=1u
X4190 VSS.t2048 VDD VSS.t2050 VSS.t2049 sg13_lv_nmos ad=79.8f pd=0.8u as=0 ps=0 w=0.42u l=1u
X4191 VDD VSS.t32 VDD VDD sg13_lv_pmos ad=0.19p pd=1.38u as=0 ps=0 w=1u l=1u
X4192 VSS.t1313 VDD VSS.t1314 VSS.t305 sg13_lv_nmos ad=79.8f pd=0.8u as=0 ps=0 w=0.42u l=1u
X4193 VDD VSS.t2324 VDD VDD sg13_lv_pmos ad=0.34p pd=2.68u as=0 ps=0 w=1u l=1u
X4194 VDD VSS.t208 VDD VDD sg13_lv_pmos ad=0.34p pd=2.68u as=0 ps=0 w=1u l=1u
X4195 VDD VSS.t705 VDD VDD sg13_lv_pmos ad=0.34p pd=2.68u as=0 ps=0 w=1u l=1u
X4196 VDD VSS.t516 VDD VDD sg13_lv_pmos ad=0.34p pd=2.68u as=0 ps=0 w=1u l=1u
X4197 VSS.t1278 VDD VSS.t1277 VSS.t305 sg13_lv_nmos ad=0.1428p pd=1.52u as=0 ps=0 w=0.42u l=1u
X4198 VDD VSS.t2727 VDD VDD sg13_lv_pmos ad=0.19p pd=1.38u as=0 ps=0 w=1u l=1u
X4199 VSS.t1611 VDD VSS.t1610 VSS.t1609 sg13_lv_nmos ad=0.1428p pd=1.52u as=0 ps=0 w=0.42u l=1u
X4200 VSS.t3140 VDD VSS.t3139 VSS.t3138 sg13_lv_nmos ad=0.1428p pd=1.52u as=0 ps=0 w=0.42u l=1u
X4201 VSS.t2345 VDD VSS.t2344 VSS.t2343 sg13_lv_nmos ad=0.1428p pd=1.52u as=0 ps=0 w=0.42u l=1u
X4202 VSS.t1958 VDD VSS.t1960 VSS.t1959 sg13_lv_nmos ad=79.8f pd=0.8u as=0 ps=0 w=0.42u l=1u
X4203 VSS.t1240 VDD VSS.t1241 VSS.t305 sg13_lv_nmos ad=79.8f pd=0.8u as=0 ps=0 w=0.42u l=1u
X4204 VSS.t208 VDD VSS.t208 VSS.t485 sg13_lv_nmos ad=79.8f pd=0.8u as=0 ps=0 w=0.42u l=1u
X4205 VSS.t540 VDD VSS.t540 VSS.t593 sg13_lv_nmos ad=79.8f pd=0.8u as=0 ps=0 w=0.42u l=1u
X4206 VSS.t167 a_2513_15288# sg13g2_and2_1_0.B VSS.t211 sg13_lv_nmos ad=0.3108p pd=2.32u as=0.1628p ps=1.18u w=0.74u l=0.13u
X4207 VDD VSS.t1466 VDD VDD sg13_lv_pmos ad=0.19p pd=1.38u as=0 ps=0 w=1u l=1u
X4208 VDD VSS.t2828 VDD VDD sg13_lv_pmos ad=0.19p pd=1.38u as=0 ps=0 w=1u l=1u
X4209 sg13g2_buf_4_0.A sg13g2_dlygate4sd3_1_2.X VDD VDD sg13_lv_pmos ad=0.2128p pd=1.5u as=0.3808p ps=2.92u w=1.12u l=0.13u
X4210 VDD VSS.t1565 VDD VDD sg13_lv_pmos ad=0.34p pd=2.68u as=0 ps=0 w=1u l=1u
X4211 VSS.t2755 VDD VSS.t2756 VSS.t2710 sg13_lv_nmos ad=79.8f pd=0.8u as=0 ps=0 w=0.42u l=1u
X4212 VSS.t2535 VDD VSS.t2534 VSS.t2533 sg13_lv_nmos ad=0.1428p pd=1.52u as=0 ps=0 w=0.42u l=1u
X4213 VDD VSS.t410 VDD VDD sg13_lv_pmos ad=0.19p pd=1.38u as=0 ps=0 w=1u l=1u
X4214 VDD VSS.t2474 VDD VDD sg13_lv_pmos ad=0.34p pd=2.68u as=0 ps=0 w=1u l=1u
X4215 VDD VSS.t540 VDD VDD sg13_lv_pmos ad=0.19p pd=1.38u as=0 ps=0 w=1u l=1u
X4216 VSS.t2365 VDD VSS.t2364 VSS.t2363 sg13_lv_nmos ad=0.1428p pd=1.52u as=0 ps=0 w=0.42u l=1u
X4217 VDD VSS.t1985 VDD VDD sg13_lv_pmos ad=0.19p pd=1.38u as=0 ps=0 w=1u l=1u
X4218 VSS.t994 VDD VSS.t993 VSS.t992 sg13_lv_nmos ad=0.1428p pd=1.52u as=0 ps=0 w=0.42u l=1u
X4219 VSS.t1701 VDD VSS.t1700 VSS.t1699 sg13_lv_nmos ad=0.1428p pd=1.52u as=0 ps=0 w=0.42u l=1u
X4220 VDD VSS.t1046 VDD VDD sg13_lv_pmos ad=0.19p pd=1.38u as=0 ps=0 w=1u l=1u
X4221 VSS.t1296 VDD VSS.t1295 VSS.t305 sg13_lv_nmos ad=0.1428p pd=1.52u as=0 ps=0 w=0.42u l=1u
X4222 VSS.t2817 VDD VSS.t2817 VSS.t2710 sg13_lv_nmos ad=0.1428p pd=1.52u as=0 ps=0 w=0.42u l=1u
X4223 VDD VSS.t2392 VDD VDD sg13_lv_pmos ad=0.19p pd=1.38u as=0 ps=0 w=1u l=1u
X4224 VSS.t2083 VDD VSS.t2082 VSS.t2081 sg13_lv_nmos ad=0.1428p pd=1.52u as=0 ps=0 w=0.42u l=1u
X4225 VDD VSS.t502 VDD VDD sg13_lv_pmos ad=0.34p pd=2.68u as=0 ps=0 w=1u l=1u
X4226 VDD VSS.t1337 VDD VDD sg13_lv_pmos ad=0.34p pd=2.68u as=0 ps=0 w=1u l=1u
X4227 VDD VSS.t2147 VDD VDD sg13_lv_pmos ad=0.34p pd=2.68u as=0 ps=0 w=1u l=1u
X4228 VDD VSS.t2517 VDD VDD sg13_lv_pmos ad=0.19p pd=1.38u as=0 ps=0 w=1u l=1u
X4229 VSS.t1998 VDD VSS.t2000 VSS.t1999 sg13_lv_nmos ad=79.8f pd=0.8u as=0 ps=0 w=0.42u l=1u
X4230 a_11166_15486# a_10967_15549# VSS.t7 VSS.t261 sg13_lv_nmos ad=0.27427p pd=2.28u as=5.1665p ps=33.355u w=0.795u l=0.13u
X4231 VSS.t705 VDD VSS.t705 VSS.t829 sg13_lv_nmos ad=0.1428p pd=1.52u as=0 ps=0 w=0.42u l=1u
X4232 VDD VSS.t2175 VDD VDD sg13_lv_pmos ad=0.19p pd=1.38u as=0 ps=0 w=1u l=1u
X4233 VSS.t292 sg13g2_buf_4_0.X a_15958_15230# VSS.t21 sg13_lv_nmos ad=0.1406p pd=1.12u as=0.2516p ps=2.16u w=0.74u l=0.15u
X4234 sg13g2_dlygate4sd3_1_9.A a_15594_14484# VSS.t181 VSS.t37 sg13_lv_nmos ad=0.2516p pd=2.16u as=0.1406p ps=1.12u w=0.74u l=0.13u
X4235 VDD VSS.t1950 VDD VDD sg13_lv_pmos ad=0.19p pd=1.38u as=0 ps=0 w=1u l=1u
X4236 VSS.t2966 VDD VSS.t2836 VSS.t2710 sg13_lv_nmos ad=79.8f pd=0.8u as=0 ps=0 w=0.42u l=1u
X4237 VDD VSS.t2718 VDD VDD sg13_lv_pmos ad=0.19p pd=1.38u as=0 ps=0 w=1u l=1u
X4238 VDD VSS.t2792 VDD VDD sg13_lv_pmos ad=0.19p pd=1.38u as=0 ps=0 w=1u l=1u
X4239 VSS.t1331 VDD VSS.t1331 VSS.t305 sg13_lv_nmos ad=79.8f pd=0.8u as=0 ps=0 w=0.42u l=1u
X4240 VSS.t1631 VDD VSS.t1630 VSS.t1629 sg13_lv_nmos ad=0.1428p pd=1.52u as=0 ps=0 w=0.42u l=1u
X4241 VSS.t2330 VDD VSS.t2329 VSS.t2328 sg13_lv_nmos ad=0.1428p pd=1.52u as=0 ps=0 w=0.42u l=1u
X4242 VDD VSS.t921 VDD VDD sg13_lv_pmos ad=0.19p pd=1.38u as=0 ps=0 w=1u l=1u
X4243 VSS.t964 VDD VSS.t963 VSS.t962 sg13_lv_nmos ad=0.1428p pd=1.52u as=0 ps=0 w=0.42u l=1u
X4244 VSS.t210 VDD VSS.t210 VSS.t509 sg13_lv_nmos ad=79.8f pd=0.8u as=0 ps=0 w=0.42u l=1u
X4245 a_18730_14452# a_19173_14495# a_19113_14531# VDD sg13_lv_pmos ad=79.8f pd=0.8u as=63f ps=0.72u w=0.42u l=0.13u
X4246 VDD VSS.t1605 VDD VDD sg13_lv_pmos ad=0.34p pd=2.68u as=0 ps=0 w=1u l=1u
X4247 VSS.t2405 VDD VSS.t2404 VSS.t2403 sg13_lv_nmos ad=0.1428p pd=1.52u as=0 ps=0 w=0.42u l=1u
X4248 VDD VSS.t394 VDD VDD sg13_lv_pmos ad=0.34p pd=2.68u as=0 ps=0 w=1u l=1u
X4249 VSS.t326 a_13966_16263# sg13g2_dlygate4sd3_1_4.X VSS.t3317 sg13_lv_nmos ad=0.1426p pd=1.16u as=0.2516p ps=2.16u w=0.74u l=0.13u
X4250 VSS.t2765 VDD VSS.t2766 VSS.t2710 sg13_lv_nmos ad=79.8f pd=0.8u as=0 ps=0 w=0.42u l=1u
X4251 VSS.t695 VDD VSS.t695 VSS.t694 sg13_lv_nmos ad=0.1428p pd=1.52u as=0 ps=0 w=0.42u l=1u
X4252 VDD VSS.t1813 VDD VDD sg13_lv_pmos ad=0.19p pd=1.38u as=0 ps=0 w=1u l=1u
X4253 VDD VSS.t3107 VDD VDD sg13_lv_pmos ad=0.19p pd=1.38u as=0 ps=0 w=1u l=1u
X4254 VSS.t2833 VDD VSS.t2834 VSS.t2710 sg13_lv_nmos ad=79.8f pd=0.8u as=0 ps=0 w=0.42u l=1u
X4255 VDD VSS.t1013 VDD VDD sg13_lv_pmos ad=0.34p pd=2.68u as=0 ps=0 w=1u l=1u
X4256 VSS.t554 VDD VSS.t554 VSS.t605 sg13_lv_nmos ad=79.8f pd=0.8u as=0 ps=0 w=0.42u l=1u
X4257 VDD VSS.t629 VDD VDD sg13_lv_pmos ad=0.19p pd=1.38u as=0 ps=0 w=1u l=1u
X4258 VSS.t622 VDD VSS.t621 VSS.t620 sg13_lv_nmos ad=0.1428p pd=1.52u as=0 ps=0 w=0.42u l=1u
X4259 VSS.t2745 VDD VSS.t2746 VSS.t2710 sg13_lv_nmos ad=79.8f pd=0.8u as=0 ps=0 w=0.42u l=1u
X4260 VDD VSS.t2167 VDD VDD sg13_lv_pmos ad=0.34p pd=2.68u as=0 ps=0 w=1u l=1u
X4261 VDD VSS.t127 VDD VDD sg13_lv_pmos ad=0.34p pd=2.68u as=0 ps=0 w=1u l=1u
X4262 VDD VSS.t554 VDD VDD sg13_lv_pmos ad=0.19p pd=1.38u as=0 ps=0 w=1u l=1u
X4263 VDD VSS.t1329 VDD VDD sg13_lv_pmos ad=0.34p pd=2.68u as=0 ps=0 w=1u l=1u
X4264 VDD VSS.t2834 VDD VDD sg13_lv_pmos ad=0.34p pd=2.68u as=0 ps=0 w=1u l=1u
X4265 VSS.t3125 VDD VSS.t3127 VSS.t3126 sg13_lv_nmos ad=79.8f pd=0.8u as=0 ps=0 w=0.42u l=1u
X4266 VDD VSS.t467 VDD VDD sg13_lv_pmos ad=0.19p pd=1.38u as=0 ps=0 w=1u l=1u
X4267 VDD VSS.t258 VDD VDD sg13_lv_pmos ad=0.34p pd=2.68u as=0 ps=0 w=1u l=1u
X4268 a_9854_15242# sg13g2_buf_1_0.X a_9752_15242# VSS.t349 sg13_lv_nmos ad=0.1406p pd=1.12u as=0.1406p ps=1.12u w=0.74u l=0.13u
X4269 VDD VSS.t2337 VDD VDD sg13_lv_pmos ad=0.19p pd=1.38u as=0 ps=0 w=1u l=1u
X4270 VDD VSS.t1076 VDD VDD sg13_lv_pmos ad=0.19p pd=1.38u as=0 ps=0 w=1u l=1u
X4271 VDD VSS.t2127 VDD VDD sg13_lv_pmos ad=0.34p pd=2.68u as=0 ps=0 w=1u l=1u
X4272 a_7044_15234# sg13g2_and2_1_1.X a_6950_15234# VSS.t43 sg13_lv_nmos ad=60.89999f pd=0.71u as=0.1428p ps=1.52u w=0.42u l=0.13u
X4273 VDD VSS.t3257 VDD VDD sg13_lv_pmos ad=0.19p pd=1.38u as=0 ps=0 w=1u l=1u
X4274 VSS.t1943 VDD VSS.t1945 VSS.t1944 sg13_lv_nmos ad=79.8f pd=0.8u as=0 ps=0 w=0.42u l=1u
X4275 sg13g2_buf_16_1.X a_16078_14484# VSS.t108 VSS.t37 sg13_lv_nmos ad=0.1406p pd=1.12u as=0.1406p ps=1.12u w=0.74u l=0.13u
X4276 VDD VSS.t661 VDD VDD sg13_lv_pmos ad=0.34p pd=2.68u as=0 ps=0 w=1u l=1u
X4277 VDD VSS.t1625 VDD VDD sg13_lv_pmos ad=0.34p pd=2.68u as=0 ps=0 w=1u l=1u
X4278 VSS.t2744 VDD VSS.t2745 VSS.t2710 sg13_lv_nmos ad=79.8f pd=0.8u as=0 ps=0 w=0.42u l=1u
X4279 VSS.t465 VDD VSS.t235 VSS.t464 sg13_lv_nmos ad=0.1428p pd=1.52u as=0 ps=0 w=0.42u l=1u
X4280 a_3622_15247# sg13g2_tiehi_1.L_HI VSS.t258 VSS.t212 sg13_lv_nmos ad=37.8f pd=0.6u as=0.1701p ps=1.65u w=0.42u l=0.13u
X4281 VSS.t559 VDD VSS.t559 VSS.t611 sg13_lv_nmos ad=79.8f pd=0.8u as=0 ps=0 w=0.42u l=1u
X4282 sg13g2_buf_4_0.X a_9269_13726# VSS.t16 VSS.t17 sg13_lv_nmos ad=0.1406p pd=1.12u as=0.1406p ps=1.12u w=0.74u l=0.13u
X4283 VDD VSS.t1962 VDD VDD sg13_lv_pmos ad=0.34p pd=2.68u as=0 ps=0 w=1u l=1u
X4284 VSS.t2974 VDD VSS.t2842 VSS.t2710 sg13_lv_nmos ad=0.1428p pd=1.52u as=0 ps=0 w=0.42u l=1u
X4285 VDD VSS.t2798 VDD VDD sg13_lv_pmos ad=0.34p pd=2.68u as=0 ps=0 w=1u l=1u
X4286 VSS.t74 a_26537_16334# a_26458_16237# VSS.t247 sg13_lv_nmos ad=5.31717p pd=34.515u as=0.27427p ps=2.28u w=0.795u l=0.13u
X4287 VSS.t994 VDD VSS.t993 VSS.t992 sg13_lv_nmos ad=0.1428p pd=1.52u as=0 ps=0 w=0.42u l=1u
X4288 VDD VSS.t976 VDD VDD sg13_lv_pmos ad=0.19p pd=1.38u as=0 ps=0 w=1u l=1u
X4289 VSS.t2350 VDD VSS.t2349 VSS.t2348 sg13_lv_nmos ad=0.1428p pd=1.52u as=0 ps=0 w=0.42u l=1u
X4290 VDD VSS.t1368 VDD VDD sg13_lv_pmos ad=0.19p pd=1.38u as=0 ps=0 w=1u l=1u
X4291 VSS.t1686 VDD VSS.t1685 VSS.t1684 sg13_lv_nmos ad=0.1428p pd=1.52u as=0 ps=0 w=0.42u l=1u
X4292 VSS.t1492 VDD VSS.t1352 VSS.t305 sg13_lv_nmos ad=0.1428p pd=1.52u as=0 ps=0 w=0.42u l=1u
X4293 VSS.t2738 VDD VSS.t2739 VSS.t2710 sg13_lv_nmos ad=79.8f pd=0.8u as=0 ps=0 w=0.42u l=1u
X4294 VSS.t2809 VDD VSS.t2809 VSS.t2710 sg13_lv_nmos ad=0.1428p pd=1.52u as=0 ps=0 w=0.42u l=1u
X4295 VDD VSS.t2554 VDD VDD sg13_lv_pmos ad=0.34p pd=2.68u as=0 ps=0 w=1u l=1u
X4296 VDD VSS.t2751 VDD VDD sg13_lv_pmos ad=0.19p pd=1.38u as=0 ps=0 w=1u l=1u
X4297 VSS.t2053 VDD VSS.t2055 VSS.t2054 sg13_lv_nmos ad=79.8f pd=0.8u as=0 ps=0 w=0.42u l=1u
X4298 VDD VSS.t913 VDD VDD sg13_lv_pmos ad=0.34p pd=2.68u as=0 ps=0 w=1u l=1u
X4299 VDD VSS.t3052 VDD VDD sg13_lv_pmos ad=0.19p pd=1.38u as=0 ps=0 w=1u l=1u
X4300 VSS.t2390 VDD VSS.t2389 VSS.t2388 sg13_lv_nmos ad=0.1428p pd=1.52u as=0 ps=0 w=0.42u l=1u
X4301 VDD VSS.t559 VDD VDD sg13_lv_pmos ad=0.19p pd=1.38u as=0 ps=0 w=1u l=1u
X4302 VSS.t705 VDD VSS.t705 VSS.t709 sg13_lv_nmos ad=0.1428p pd=1.52u as=0 ps=0 w=0.42u l=1u
X4303 VSS.t2163 VDD VSS.t2162 VSS.t2161 sg13_lv_nmos ad=0.1428p pd=1.52u as=0 ps=0 w=0.42u l=1u
X4304 VSS.t1395 VDD VSS.t1394 VSS.t305 sg13_lv_nmos ad=0.1428p pd=1.52u as=0 ps=0 w=0.42u l=1u
X4305 VDD VSS.t2502 VDD VDD sg13_lv_pmos ad=0.19p pd=1.38u as=0 ps=0 w=1u l=1u
X4306 VDD VSS.t2160 VDD VDD sg13_lv_pmos ad=0.19p pd=1.38u as=0 ps=0 w=1u l=1u
X4307 VDD a_18885_13701# a_18987_13844# VDD sg13_lv_pmos ad=2.75157p pd=17.885u as=0.3864p ps=2.93u w=1.12u l=0.13u
X4308 VDD VSS.t851 VDD VDD sg13_lv_pmos ad=0.19p pd=1.38u as=0 ps=0 w=1u l=1u
X4309 VDD VSS.t1935 VDD VDD sg13_lv_pmos ad=0.19p pd=1.38u as=0 ps=0 w=1u l=1u
X4310 VDD VSS.t2454 VDD VDD sg13_lv_pmos ad=0.34p pd=2.68u as=0 ps=0 w=1u l=1u
X4311 VSS.t24 a_18766_15423# sg13g2_nand2_1_1.A VSS.t3286 sg13_lv_nmos ad=0.1426p pd=1.16u as=0.2516p ps=2.16u w=0.74u l=0.13u
X4312 VSS.t1616 VDD VSS.t1615 VSS.t1614 sg13_lv_nmos ad=0.1428p pd=1.52u as=0 ps=0 w=0.42u l=1u
X4313 VSS.t92 VDD VSS.t487 VSS.t491 sg13_lv_nmos ad=0.1428p pd=1.52u as=0 ps=0 w=0.42u l=1u
X4314 a_16078_14484# clock_i VSS.t293 VSS.t37 sg13_lv_nmos ad=0.1406p pd=1.12u as=0.1406p ps=1.12u w=0.74u l=0.13u
X4315 VDD VSS.t966 VDD VDD sg13_lv_pmos ad=0.19p pd=1.38u as=0 ps=0 w=1u l=1u
X4316 sg13g2_buf_4_0.A sg13g2_buf_1_0.X a_9272_16362# VSS.t346 sg13_lv_nmos ad=0.2516p pd=2.16u as=0.1406p ps=1.12u w=0.74u l=0.13u
X4317 VDD VSS.t2030 VDD VDD sg13_lv_pmos ad=0.19p pd=1.38u as=0 ps=0 w=1u l=1u
X4318 VSS.t14 sg13g2_buf_4_0.A a_9269_13726# VSS.t313 sg13_lv_nmos ad=0.3293p pd=1.63u as=0.2516p ps=2.16u w=0.74u l=0.13u
X4319 VDD VSS.t1262 VDD VDD sg13_lv_pmos ad=0.34p pd=2.68u as=0 ps=0 w=1u l=1u
X4320 VDD a_3610_14725# sg13g2_tiehi_1.L_HI VDD sg13_lv_pmos ad=2.75157p pd=17.885u as=0.3927p ps=2.99u w=1.155u l=0.13u
X4321 a_25668_14488# a_25642_14452# VDD VDD sg13_lv_pmos ad=0.34p pd=2.68u as=0.36237p ps=2.605u w=1u l=0.13u
X4322 VDD VSS.t173 VDD VDD sg13_lv_pmos ad=0.19p pd=1.38u as=0 ps=0 w=1u l=1u
X4323 VSS.t2855 VDD VSS.t2854 VSS.t2710 sg13_lv_nmos ad=0.1428p pd=1.52u as=0 ps=0 w=0.42u l=1u
X4324 VSS.t2758 VDD VSS.t2759 VSS.t2710 sg13_lv_nmos ad=79.8f pd=0.8u as=0 ps=0 w=0.42u l=1u
X4325 VDD VSS.t690 VDD VDD sg13_lv_pmos ad=0.19p pd=1.38u as=0 ps=0 w=1u l=1u
X4326 VSS.t686 VDD VSS.t686 VSS.t793 sg13_lv_nmos ad=0.1428p pd=1.52u as=0 ps=0 w=0.42u l=1u
X4327 VDD VSS.t1743 VDD VDD sg13_lv_pmos ad=0.19p pd=1.38u as=0 ps=0 w=1u l=1u
X4328 VDD VSS.t1798 VDD VDD sg13_lv_pmos ad=0.19p pd=1.38u as=0 ps=0 w=1u l=1u
X4329 a_19727_13799# a_18885_13701# a_19633_13799# VSS.t303 sg13_lv_nmos ad=0.12665p pd=1.145u as=0.1428p ps=1.52u w=0.42u l=0.13u
X4330 VDD VSS.t2397 VDD VDD sg13_lv_pmos ad=0.19p pd=1.38u as=0 ps=0 w=1u l=1u
X4331 VDD VSS.t2522 VDD VDD sg13_lv_pmos ad=0.19p pd=1.38u as=0 ps=0 w=1u l=1u
X4332 VSS.t2003 VDD VSS.t2005 VSS.t2004 sg13_lv_nmos ad=79.8f pd=0.8u as=0 ps=0 w=0.42u l=1u
X4333 VDD VSS.t2180 VDD VDD sg13_lv_pmos ad=0.19p pd=1.38u as=0 ps=0 w=1u l=1u
X4334 VSS.t874 VDD VSS.t876 VSS.t875 sg13_lv_nmos ad=79.8f pd=0.8u as=0 ps=0 w=0.42u l=1u
X4335 VDD VSS.t2721 VDD VDD sg13_lv_pmos ad=0.19p pd=1.38u as=0 ps=0 w=1u l=1u
X4336 VDD a_15214_13911# sg13g2_xor2_1_1.A VDD sg13_lv_pmos ad=0.2254p pd=1.53u as=0.4256p ps=3u w=1.12u l=0.13u
X4337 VSS.t3130 VDD VSS.t3129 VSS.t3128 sg13_lv_nmos ad=0.1428p pd=1.52u as=0 ps=0 w=0.42u l=1u
X4338 VSS.t2335 VDD VSS.t2334 VSS.t2333 sg13_lv_nmos ad=0.1428p pd=1.52u as=0 ps=0 w=0.42u l=1u
X4339 VDD VSS.t933 VDD VDD sg13_lv_pmos ad=0.34p pd=2.68u as=0 ps=0 w=1u l=1u
X4340 VSS.t2505 VDD VSS.t2507 VSS.t2506 sg13_lv_nmos ad=79.8f pd=0.8u as=0 ps=0 w=0.42u l=1u
X4341 VDD VSS.t1610 VDD VDD sg13_lv_pmos ad=0.34p pd=2.68u as=0 ps=0 w=1u l=1u
X4342 VSS.t2736 VDD VSS.t2737 VSS.t2710 sg13_lv_nmos ad=79.8f pd=0.8u as=0 ps=0 w=0.42u l=1u
X4343 VSS.t1293 VDD VSS.t1294 VSS.t305 sg13_lv_nmos ad=79.8f pd=0.8u as=0 ps=0 w=0.42u l=1u
X4344 VSS.t2410 VDD VSS.t2409 VSS.t2408 sg13_lv_nmos ad=0.1428p pd=1.52u as=0 ps=0 w=0.42u l=1u
X4345 a_16877_14020# sg13g2_buf_4_0.X a_16775_14020# VDD sg13_lv_pmos ad=0.1575p pd=1.315u as=0.19p ps=1.38u w=1u l=0.13u
X4346 VSS.t1671 VDD VSS.t1673 VSS.t1672 sg13_lv_nmos ad=79.8f pd=0.8u as=0 ps=0 w=0.42u l=1u
X4347 VDD VSS.t1947 VDD VDD sg13_lv_pmos ad=0.34p pd=2.68u as=0 ps=0 w=1u l=1u
X4348 VDD VSS.t2790 VDD VDD sg13_lv_pmos ad=0.34p pd=2.68u as=0 ps=0 w=1u l=1u
X4349 VSS.t969 VDD VSS.t968 VSS.t967 sg13_lv_nmos ad=0.1428p pd=1.52u as=0 ps=0 w=0.42u l=1u
X4350 VDD VSS.t3112 VDD VDD sg13_lv_pmos ad=0.19p pd=1.38u as=0 ps=0 w=1u l=1u
X4351 VSS.t2836 VDD VSS.t2837 VSS.t2710 sg13_lv_nmos ad=79.8f pd=0.8u as=0 ps=0 w=0.42u l=1u
X4352 a_23806_14854# sg13g2_mux2_1_0.A0 a_23709_14508# VDD sg13_lv_pmos ad=0.2225p pd=1.445u as=0.3325p ps=1.665u w=1u l=0.13u
X4353 VSS.t1447 VDD VSS.t1298 VSS.t305 sg13_lv_nmos ad=79.8f pd=0.8u as=0 ps=0 w=0.42u l=1u
X4354 VDD VSS.t1975 VDD VDD sg13_lv_pmos ad=0.19p pd=1.38u as=0 ps=0 w=1u l=1u
X4355 VSS.t889 VDD VSS.t891 VSS.t890 sg13_lv_nmos ad=79.8f pd=0.8u as=0 ps=0 w=0.42u l=1u
X4356 VSS.t2729 VDD VSS.t2730 VSS.t2710 sg13_lv_nmos ad=79.8f pd=0.8u as=0 ps=0 w=0.42u l=1u
X4357 a_7236_15552# a_7210_15457# VDD VDD sg13_lv_pmos ad=0.34p pd=2.68u as=0.36237p ps=2.605u w=1u l=0.13u
X4358 VDD VSS.t2539 VDD VDD sg13_lv_pmos ad=0.34p pd=2.68u as=0 ps=0 w=1u l=1u
X4359 VSS.t2038 VDD VSS.t2040 VSS.t2039 sg13_lv_nmos ad=79.8f pd=0.8u as=0 ps=0 w=0.42u l=1u
X4360 sg13g2_o21ai_1_0.Y sg13g2_nand3_1_1.Y a_16056_15552# VDD sg13_lv_pmos ad=0.2128p pd=1.5u as=0.2128p ps=1.5u w=1.12u l=0.15u
X4361 VSS.t700 VDD VSS.t700 VSS.t819 sg13_lv_nmos ad=0.1428p pd=1.52u as=0 ps=0 w=0.42u l=1u
X4362 VDD VSS.t1331 VDD VDD sg13_lv_pmos ad=0.34p pd=2.68u as=0 ps=0 w=1u l=1u
X4363 VDD VSS.t2837 VDD VDD sg13_lv_pmos ad=0.34p pd=2.68u as=0 ps=0 w=1u l=1u
X4364 VDD VSS.t2342 VDD VDD sg13_lv_pmos ad=0.19p pd=1.38u as=0 ps=0 w=1u l=1u
X4365 VDD a_16078_14484# sg13g2_buf_16_1.X VDD sg13_lv_pmos ad=0.2128p pd=1.5u as=0.2128p ps=1.5u w=1.12u l=0.13u
X4366 VDD a_16078_14484# sg13g2_buf_16_1.X VDD sg13_lv_pmos ad=0.3976p pd=2.95u as=0.2128p ps=1.5u w=1.12u l=0.13u
X4367 VDD VSS.t896 VDD VDD sg13_lv_pmos ad=0.19p pd=1.38u as=0 ps=0 w=1u l=1u
X4368 VDD VSS.t2439 VDD VDD sg13_lv_pmos ad=0.34p pd=2.68u as=0 ps=0 w=1u l=1u
X4369 VSS.t673 VDD VSS.t673 VSS.t769 sg13_lv_nmos ad=79.8f pd=0.8u as=0 ps=0 w=0.42u l=1u
X4370 VDD VSS.t676 VDD VDD sg13_lv_pmos ad=0.19p pd=1.38u as=0 ps=0 w=1u l=1u
X4371 VSS.t2525 VDD VSS.t2527 VSS.t2526 sg13_lv_nmos ad=79.8f pd=0.8u as=0 ps=0 w=0.42u l=1u
X4372 VSS.t1948 VDD VSS.t1950 VSS.t1949 sg13_lv_nmos ad=79.8f pd=0.8u as=0 ps=0 w=0.42u l=1u
X4373 VSS.t2727 VDD VSS.t2728 VSS.t2710 sg13_lv_nmos ad=79.8f pd=0.8u as=0 ps=0 w=0.42u l=1u
X4374 VDD VSS.t705 VDD VDD sg13_lv_pmos ad=0.19p pd=1.38u as=0 ps=0 w=1u l=1u
X4375 VDD VSS.t1398 VDD VDD sg13_lv_pmos ad=0.19p pd=1.38u as=0 ps=0 w=1u l=1u
X4376 VDD VSS.t2192 VDD VDD sg13_lv_pmos ad=0.34p pd=2.68u as=0 ps=0 w=1u l=1u
X4377 VDD VSS.t2015 VDD VDD sg13_lv_pmos ad=0.19p pd=1.38u as=0 ps=0 w=1u l=1u
X4378 VSS.t210 VDD VSS.t210 VSS.t511 sg13_lv_nmos ad=0.1428p pd=1.52u as=0 ps=0 w=0.42u l=1u
X4379 VDD VSS.t1967 VDD VDD sg13_lv_pmos ad=0.34p pd=2.68u as=0 ps=0 w=1u l=1u
X4380 VSS.t2846 VDD VSS.t2845 VSS.t2710 sg13_lv_nmos ad=0.1428p pd=1.52u as=0 ps=0 w=0.42u l=1u
X4381 VDD VSS.t2728 VDD VDD sg13_lv_pmos ad=0.34p pd=2.68u as=0 ps=0 w=1u l=1u
X4382 VDD VSS.t2801 VDD VDD sg13_lv_pmos ad=0.34p pd=2.68u as=0 ps=0 w=1u l=1u
X4383 a_15704_15242# sg13g2_dlygate4sd3_1_11.A a_15602_15242# VSS.t21 sg13_lv_nmos ad=0.1406p pd=1.12u as=0.1406p ps=1.12u w=0.74u l=0.13u
X4384 VSS.t1243 VDD VSS.t1244 VSS.t305 sg13_lv_nmos ad=79.8f pd=0.8u as=0 ps=0 w=0.42u l=1u
X4385 VDD VSS.t2140 VDD VDD sg13_lv_pmos ad=0.19p pd=1.38u as=0 ps=0 w=1u l=1u
X4386 a_25382_14922# sg13g2_dfrbpq_1_5.D VDD VDD sg13_lv_pmos ad=79.8f pd=0.8u as=0.1428p ps=1.52u w=0.42u l=0.13u
X4387 VDD a_2540_15960# counter_value_o[0] VDD sg13_lv_pmos ad=0.2114p pd=1.54u as=0.42p ps=2.99u w=1.12u l=0.13u
X4388 VDD a_12308_15202# sg13g2_dfrbpq_1_2.CLK VDD sg13_lv_pmos ad=0.2128p pd=1.5u as=0.2128p ps=1.5u w=1.12u l=0.13u
X4389 VSS.t1044 VDD VSS.t1046 VSS.t1045 sg13_lv_nmos ad=79.8f pd=0.8u as=0 ps=0 w=0.42u l=1u
X4390 VSS.t2990 VDD VSS.t2992 VSS.t2991 sg13_lv_nmos ad=79.8f pd=0.8u as=0 ps=0 w=0.42u l=1u
X4391 VDD VSS.t1113 VDD VDD sg13_lv_pmos ad=0.34p pd=2.68u as=0 ps=0 w=1u l=1u
X4392 VSS.t1811 VDD VSS.t1813 VSS.t1812 sg13_lv_nmos ad=79.8f pd=0.8u as=0 ps=0 w=0.42u l=1u
X4393 VSS.t2812 VDD VSS.t2811 VSS.t2710 sg13_lv_nmos ad=0.1428p pd=1.52u as=0 ps=0 w=0.42u l=1u
X4394 VDD VSS.t2559 VDD VDD sg13_lv_pmos ad=0.34p pd=2.68u as=0 ps=0 w=1u l=1u
X4395 VSS.t2023 VDD VSS.t2025 VSS.t2024 sg13_lv_nmos ad=79.8f pd=0.8u as=0 ps=0 w=0.42u l=1u
X4396 a_3370_15457# a_3813_15213# a_3110_15234# VSS.t212 sg13_lv_nmos ad=79.8f pd=0.8u as=0.1296p ps=1.52u w=0.42u l=0.13u
X4397 VSS.t2168 VDD VSS.t2167 VSS.t2166 sg13_lv_nmos ad=0.1428p pd=1.52u as=0 ps=0 w=0.42u l=1u
X4398 VSS.t874 VDD VSS.t876 VSS.t875 sg13_lv_nmos ad=79.8f pd=0.8u as=0 ps=0 w=0.42u l=1u
X4399 VDD VSS.t863 VDD VDD sg13_lv_pmos ad=0.34p pd=2.68u as=0 ps=0 w=1u l=1u
X4400 VDD VSS.t2165 VDD VDD sg13_lv_pmos ad=0.19p pd=1.38u as=0 ps=0 w=1u l=1u
R0 VSS.t8 VSS.n886 34841.9
R1 VSS.n873 VSS.n872 6205.48
R2 VSS.t2710 VSS.n749 4108.7
R3 VSS.n753 VSS.n749 4108.7
R4 VSS.n754 VSS.n753 4108.7
R5 VSS.t305 VSS.n754 4108.7
R6 VSS.t305 VSS.n755 4108.7
R7 VSS.n844 VSS.n755 4108.7
R8 VSS.n845 VSS.n844 4108.7
R9 VSS.n887 VSS.t283 2083.33
R10 VSS.t2993 VSS.n102 156.482
R11 VSS.t3011 VSS.n102 157.976
R12 VSS.t3021 VSS.n102 157.976
R13 VSS.n102 VSS.t3041 157.976
R14 VSS.n102 VSS.t3046 157.976
R15 VSS.n102 VSS.t3061 157.976
R16 VSS.n102 VSS.t3081 157.976
R17 VSS.n102 VSS.t3086 157.976
R18 VSS.n102 VSS.t3091 157.976
R19 VSS.n102 VSS.t3111 157.976
R20 VSS.n102 VSS.t3141 157.976
R21 VSS.n102 VSS.t3161 157.976
R22 VSS.n102 VSS.t3166 157.976
R23 VSS.n102 VSS.t3181 157.976
R24 VSS.n102 VSS.t3196 157.976
R25 VSS.n102 VSS.t3231 157.976
R26 VSS.t3246 VSS.n102 157.976
R27 VSS.n102 VSS.t3261 157.976
R28 VSS.t2710 VSS.n102 4425.74
R29 VSS.t519 VSS.n197 15.0018
R30 VSS.n81 VSS.t2323 109.001
R31 VSS.n81 VSS.t2338 108.999
R32 VSS.n81 VSS.t2348 109.001
R33 VSS.t2361 VSS.n81 109.992
R34 VSS.t2366 VSS.n81 109.993
R35 VSS.t2371 VSS.n81 109.992
R36 VSS.t2391 VSS.n81 109.992
R37 VSS.t2406 VSS.n81 109.993
R38 VSS.n81 VSS.t2438 108.999
R39 VSS.n81 VSS.t2443 109.001
R40 VSS.t2481 VSS.n81 109.993
R41 VSS.n81 VSS.t2486 109.993
R42 VSS.t2491 VSS.n81 109.992
R43 VSS.t2511 VSS.n81 109.993
R44 VSS.t2531 VSS.n81 109.992
R45 VSS.n81 VSS.t2556 109.992
R46 VSS.t1931 VSS.n82 109.001
R47 VSS.n82 VSS.t1936 108.999
R48 VSS.n82 VSS.t1951 108.999
R49 VSS.n82 VSS.t1961 109.001
R50 VSS.n82 VSS.t1981 108.999
R51 VSS.t2006 VSS.n82 108.999
R52 VSS.t2016 VSS.n82 108.999
R53 VSS.t2026 VSS.n82 108.999
R54 VSS.n82 VSS.t2031 109.001
R55 VSS.n82 VSS.t2041 109.001
R56 VSS.t2056 VSS.n82 109.001
R57 VSS.n82 VSS.t2104 109.992
R58 VSS.t2119 VSS.n82 109.993
R59 VSS.t2139 VSS.n82 109.993
R60 VSS.n82 VSS.t2144 109.992
R61 VSS.n82 VSS.t2164 109.993
R62 VSS.n82 VSS.t2174 109.992
R63 VSS.t2179 VSS.n82 109.993
R64 VSS.n82 VSS.t2184 109.993
R65 VSS.t2199 VSS.n82 109.992
R66 VSS.n83 VSS.t1537 109.986
R67 VSS.n83 VSS.t1554 108.999
R68 VSS.t1569 VSS.n83 108.999
R69 VSS.t1579 VSS.n83 108.999
R70 VSS.t1589 VSS.n83 108.999
R71 VSS.t1599 VSS.n83 108.999
R72 VSS.t1649 VSS.n83 108.999
R73 VSS.t1669 VSS.n83 108.999
R74 VSS.t1692 VSS.n83 109.992
R75 VSS.t1742 VSS.n83 109.992
R76 VSS.t1757 VSS.n83 109.993
R77 VSS.t1762 VSS.n83 109.992
R78 VSS.t1772 VSS.n83 109.992
R79 VSS.n83 VSS.t1807 109.992
R80 VSS.n80 VSS.t857 108.999
R81 VSS.t870 VSS.n80 109.992
R82 VSS.t890 VSS.n80 109.992
R83 VSS.t900 VSS.n80 109.992
R84 VSS.n80 VSS.t915 109.993
R85 VSS.n80 VSS.t922 108.999
R86 VSS.t937 VSS.n80 108.999
R87 VSS.t947 VSS.n80 109.001
R88 VSS.t970 VSS.n80 109.993
R89 VSS.n80 VSS.t985 109.993
R90 VSS.n80 VSS.t995 109.992
R91 VSS.n80 VSS.t1005 109.993
R92 VSS.t1020 VSS.n80 109.993
R93 VSS.t1050 VSS.n80 109.993
R94 VSS.t1090 VSS.n80 109.992
R95 VSS.t1110 VSS.n80 109.992
R96 VSS.t3319 VSS.t202 136.327
R97 VSS.t625 VSS.t202 109.001
R98 VSS.t202 VSS.n113 96.0268
R99 VSS.t3323 VSS.t7 76.3503
R100 VSS.n81 VSS.n749 427.5
R101 VSS.n753 VSS.n82 427.5
R102 VSS.n754 VSS.n83 427.5
R103 VSS.n80 VSS.n755 427.5
R104 VSS.t53 VSS.n305 88.5605
R105 VSS.t691 VSS.n303 242.846
R106 VSS.n844 VSS.t202 427.5
R107 VSS.t3304 VSS.n723 49.9891
R108 VSS.n302 VSS.t767 242.846
R109 VSS.t769 VSS.n201 242.846
R110 VSS.t771 VSS.n301 242.846
R111 VSS.t773 VSS.n276 242.846
R112 VSS.t1 VSS.n300 71.4177
R113 VSS.n101 VSS.t288 67.7291
R114 VSS.n845 VSS.t7 427.5
R115 VSS.n831 VSS.t62 407.144
R116 VSS.t349 VSS.n788 407.144
R117 VSS.t13 VSS.n815 402.858
R118 VSS.n853 VSS.t95 402.858
R119 VSS.n847 VSS.t94 398.572
R120 VSS.t256 VSS.n61 397.132
R121 VSS.n51 VSS.t352 397.132
R122 VSS.n836 VSS.t301 394.286
R123 VSS.n851 VSS.t3315 390
R124 VSS.t219 VSS.n779 387.5
R125 VSS.n0 VSS.t249 386.526
R126 VSS.t27 VSS.n817 385.714
R127 VSS.t128 VSS.n830 385.714
R128 VSS.n193 VSS.t228 36.4612
R129 VSS.t202 VSS.n117 14.7131
R130 VSS.t174 VSS.n762 381.43
R131 VSS.n832 VSS.t64 381.43
R132 VSS.t289 VSS.n829 381.43
R133 VSS.n853 VSS.t358 381.43
R134 VSS.n799 VSS.t320 381.43
R135 VSS.t3304 VSS.n813 377.144
R136 VSS.t261 VSS.n784 375
R137 VSS.n868 VSS.t223 373.926
R138 VSS.n863 VSS.t220 370.38
R139 VSS.t237 VSS.t299 368.572
R140 VSS.t290 VSS.n828 368.572
R141 VSS.t96 VSS.n786 368.572
R142 VSS.t263 VSS.n5 367.132
R143 VSS.t319 VSS.n790 364.286
R144 VSS.t221 VSS.n0 363.83
R145 VSS.t217 VSS.n781 362.5
R146 VSS.t178 VSS.n794 360
R147 VSS.t1 VSS.n821 355.714
R148 VSS.n811 VSS.t337 355.714
R149 VSS.n79 VSS.t51 58.1269
R150 VSS.n841 VSS.t303 351.43
R151 VSS.t310 VSS.n769 351.43
R152 VSS.t29 VSS.n114 360.111
R153 VSS.t17 VSS.n842 351.43
R154 VSS.t3302 VSS.n875 351.43
R155 VSS.n881 VSS.t134 351.43
R156 VSS.n879 VSS.t70 351.43
R157 VSS.t46 VSS.n846 351.43
R158 VSS.n850 VSS.t135 351.43
R159 VSS.n798 VSS.t260 351.43
R160 VSS.t202 VSS.n121 13.4026
R161 VSS.t312 VSS.n103 350.586
R162 VSS.n892 VSS.t311 347.144
R163 VSS.t165 VSS.n882 347.144
R164 VSS.n849 VSS.t93 347.144
R165 VSS.t65 VSS.n796 347.144
R166 VSS.t2988 VSS.n102 156.288
R167 VSS.t2998 VSS.n102 156.482
R168 VSS.t3023 VSS.n102 156.482
R169 VSS.t3033 VSS.n102 156.482
R170 VSS.t3053 VSS.n102 156.482
R171 VSS.t3063 VSS.n102 156.482
R172 VSS.t3068 VSS.n102 156.482
R173 VSS.t3093 VSS.n102 156.482
R174 VSS.t3103 VSS.n102 156.482
R175 VSS.t3113 VSS.n102 156.482
R176 VSS.t3118 VSS.n102 156.482
R177 VSS.n102 VSS.t3128 156.482
R178 VSS.t3133 VSS.n102 156.482
R179 VSS.t3148 VSS.n102 156.482
R180 VSS.t3173 VSS.n102 156.482
R181 VSS.t3183 VSS.n102 156.482
R182 VSS.t3188 VSS.n102 156.482
R183 VSS.t3203 VSS.n102 156.482
R184 VSS.t3213 VSS.n102 156.482
R185 VSS.t3223 VSS.n102 156.482
R186 VSS.t3233 VSS.n102 156.482
R187 VSS.t3248 VSS.n102 156.482
R188 VSS.t3280 VSS.n830 342.858
R189 VSS.n74 VSS.t18 341.418
R190 VSS.n880 VSS.t107 341.418
R191 VSS.n11 VSS.t41 341.418
R192 VSS.t350 VSS.n761 338.572
R193 VSS.n848 VSS.t72 338.572
R194 VSS.t202 VSS.n188 12.9111
R195 VSS.n103 VSS.t202 12.9088
R196 VSS.t283 VSS.t8 333.334
R197 VSS.n835 VSS.t130 330
R198 VSS.t324 VSS.t298 330
R199 VSS.t254 VSS.t340 330
R200 VSS.n865 VSS.t3292 329.168
R201 VSS.n866 VSS.t3286 329.168
R202 VSS.n772 VSS.t308 325.714
R203 VSS.n893 VSS.t38 321.43
R204 VSS.n194 VSS.t43 77.2374
R205 VSS.n71 VSS.t284 319.99
R206 VSS.n5 VSS.t262 319.99
R207 VSS.t7 VSS.t214 88.4907
R208 VSS.n814 VSS.t3305 312.858
R209 VSS.t3277 VSS.n787 312.858
R210 VSS.t197 VSS.n782 312.5
R211 VSS.t200 VSS.t7 5.27736
R212 VSS.t7 VSS.t224 28.9713
R213 VSS.n858 VSS.t182 305.159
R214 VSS.t304 VSS.n826 304.286
R215 VSS.t274 VSS.n890 300
R216 VSS.t222 VSS.t269 296.562
R217 VSS.t34 VSS.t3316 295.714
R218 VSS.t3312 VSS.n763 291.43
R219 VSS.t232 VSS.n101 304.378
R220 VSS.n837 VSS.t291 291.43
R221 VSS.n848 VSS.t31 291.43
R222 VSS.n53 VSS.t145 289.99
R223 VSS.t2991 VSS.n102 157.972
R224 VSS.t3006 VSS.n102 157.976
R225 VSS.t3026 VSS.n102 157.976
R226 VSS.t3056 VSS.n102 157.976
R227 VSS.t3096 VSS.n102 157.976
R228 VSS.t3121 VSS.n102 157.976
R229 VSS.t3146 VSS.n102 157.976
R230 VSS.t3171 VSS.n102 157.976
R231 VSS.t3176 VSS.n102 157.976
R232 VSS.t3216 VSS.n102 157.976
R233 VSS.t3226 VSS.n102 157.976
R234 VSS.t3241 VSS.n102 157.976
R235 VSS.t3256 VSS.n102 157.976
R236 VSS.t3266 VSS.n102 157.976
R237 VSS.n859 VSS.t196 287.5
R238 VSS.n823 VSS.t60 287.144
R239 VSS.t278 VSS.t286 287.144
R240 VSS.n866 VSS.t23 283.334
R241 VSS.t211 VSS.t166 278.572
R242 VSS.t86 VSS.n778 275.072
R243 VSS.n858 VSS.t85 275.072
R244 VSS.t3263 VSS.n102 156.482
R245 VSS.n102 VSS.t3258 156.482
R246 VSS.t3253 VSS.n102 156.482
R247 VSS.t3251 VSS.n102 157.976
R248 VSS.t3243 VSS.n102 156.482
R249 VSS.n102 VSS.t3238 156.482
R250 VSS.t3236 VSS.n102 157.976
R251 VSS.n102 VSS.t3228 156.482
R252 VSS.n102 VSS.t3218 156.482
R253 VSS.n102 VSS.t3208 156.482
R254 VSS.t3206 VSS.n102 157.976
R255 VSS.n102 VSS.t3198 156.482
R256 VSS.n102 VSS.t3193 156.482
R257 VSS.t3191 VSS.n102 157.976
R258 VSS.t3186 VSS.n102 157.976
R259 VSS.n102 VSS.t3178 156.482
R260 VSS.n102 VSS.t3168 156.482
R261 VSS.n102 VSS.t3163 156.482
R262 VSS.n102 VSS.t3158 156.482
R263 VSS.n102 VSS.t3153 156.482
R264 VSS.t3151 VSS.n102 157.976
R265 VSS.n102 VSS.t3143 156.482
R266 VSS.n102 VSS.t3138 156.482
R267 VSS.t3136 VSS.n102 157.976
R268 VSS.n102 VSS.t3131 157.976
R269 VSS.n102 VSS.t3123 156.482
R270 VSS.t3116 VSS.n102 157.976
R271 VSS.n102 VSS.t3108 156.482
R272 VSS.t3106 VSS.n102 157.976
R273 VSS.n102 VSS.t3098 156.482
R274 VSS.n102 VSS.t3088 156.482
R275 VSS.n102 VSS.t3083 156.482
R276 VSS.n102 VSS.t3078 156.482
R277 VSS.n102 VSS.t3073 156.482
R278 VSS.t3071 VSS.n102 157.976
R279 VSS.t3066 VSS.n102 157.976
R280 VSS.n102 VSS.t3058 156.482
R281 VSS.n102 VSS.t3048 156.482
R282 VSS.n102 VSS.t3043 156.482
R283 VSS.n102 VSS.t3038 156.482
R284 VSS.t3036 VSS.n102 157.976
R285 VSS.n102 VSS.t3028 156.482
R286 VSS.n102 VSS.t3018 156.482
R287 VSS.t3013 VSS.n102 156.482
R288 VSS.n102 VSS.t3008 156.482
R289 VSS.t3003 VSS.n102 156.482
R290 VSS.t3001 VSS.n102 157.976
R291 VSS.n102 VSS.t2996 157.976
R292 VSS.t139 VSS.t7 274.2
R293 VSS.t7 VSS.n91 0.49343
R294 VSS.n184 VSS.t353 94.8677
R295 VSS.n49 VSS.t19 272.846
R296 VSS.t245 VSS.t307 265.714
R297 VSS.t78 VSS.t279 265.714
R298 VSS.t316 VSS.t33 265.714
R299 VSS.t40 VSS.t3320 265.714
R300 VSS.t195 VSS.n783 262.5
R301 VSS.t199 VSS.t224 262.178
R302 VSS.t124 VSS.t240 258.334
R303 VSS.t3308 VSS.t90 258.334
R304 VSS.n856 VSS.t3295 258.334
R305 VSS.t266 VSS.t99 258.334
R306 VSS.n857 VSS.t264 258.334
R307 VSS.n895 VSS.t327 257.144
R308 VSS.t287 VSS.n828 257.144
R309 VSS.t3291 VSS.n791 257.144
R310 VSS.t48 VSS.n797 257.144
R311 VSS.t663 VSS.n120 99.5774
R312 VSS.n119 VSS.t666 99.5774
R313 VSS.n196 VSS.t202 11.6998
R314 VSS.n59 VSS.t789 251.417
R315 VSS.n58 VSS.t682 251.417
R316 VSS.n55 VSS.t685 251.417
R317 VSS.t202 VSS.t800 108.719
R318 VSS.n63 VSS.t689 251.417
R319 VSS.n74 VSS.t762 251.417
R320 VSS.n72 VSS.t768 251.417
R321 VSS.n69 VSS.t770 251.417
R322 VSS.n66 VSS.t772 251.417
R323 VSS.t774 VSS.n70 251.417
R324 VSS.n3 VSS.t584 251.417
R325 VSS.t97 VSS.n785 250.952
R326 VSS.t268 VSS.t218 245.833
R327 VSS.n834 VSS.t3281 244.286
R328 VSS.t805 VSS.n217 100.888
R329 VSS.t202 VSS.n116 9.30721
R330 VSS.t202 VSS.n118 9.30721
R331 VSS.t754 VSS.t202 243.47
R332 VSS.t790 VSS.n57 242.846
R333 VSS.n54 VSS.t792 242.846
R334 VSS.n53 VSS.t794 242.846
R335 VSS.n64 VSS.t803 242.846
R336 VSS.n73 VSS.t672 242.846
R337 VSS.n68 VSS.t675 242.846
R338 VSS.n67 VSS.t678 242.846
R339 VSS.t577 VSS.t7 109.7
R340 VSS.t7 VSS.n14 0.350521
R341 VSS.n778 VSS.t528 236.391
R342 VSS.n81 VSS.t2333 108.999
R343 VSS.n81 VSS.t2373 108.999
R344 VSS.n81 VSS.t2378 109.001
R345 VSS.n81 VSS.t2393 108.999
R346 VSS.n81 VSS.t2408 109.001
R347 VSS.n81 VSS.t2433 108.999
R348 VSS.n81 VSS.t2453 108.999
R349 VSS.t2463 VSS.n81 108.999
R350 VSS.t2503 VSS.n81 108.999
R351 VSS.t2513 VSS.n81 109.001
R352 VSS.t2523 VSS.n81 108.999
R353 VSS.t2533 VSS.n81 108.999
R354 VSS.n81 VSS.t2538 109.001
R355 VSS.n81 VSS.t2558 108.999
R356 VSS.n81 VSS.t2568 109.001
R357 VSS.t2573 VSS.n81 108.999
R358 VSS.n81 VSS.t2578 109.001
R359 VSS.t2583 VSS.n81 108.999
R360 VSS.t1926 VSS.n82 108.722
R361 VSS.t2071 VSS.n82 109.001
R362 VSS.n82 VSS.t2076 108.999
R363 VSS.t2091 VSS.n82 108.999
R364 VSS.n82 VSS.t2096 108.999
R365 VSS.n82 VSS.t2126 109.001
R366 VSS.t2131 VSS.n82 108.999
R367 VSS.n82 VSS.t2146 108.999
R368 VSS.t2151 VSS.n82 109.001
R369 VSS.n82 VSS.t2166 108.999
R370 VSS.n82 VSS.t2186 109.001
R371 VSS.t2191 VSS.n82 108.999
R372 VSS.n83 VSS.t1684 108.999
R373 VSS.n83 VSS.t1694 108.999
R374 VSS.n83 VSS.t1709 108.999
R375 VSS.n83 VSS.t1714 108.999
R376 VSS.n83 VSS.t1719 109.001
R377 VSS.n83 VSS.t1729 108.999
R378 VSS.n83 VSS.t1734 108.999
R379 VSS.n83 VSS.t1744 109.001
R380 VSS.n83 VSS.t1749 108.999
R381 VSS.n83 VSS.t1764 108.999
R382 VSS.n83 VSS.t1779 109.001
R383 VSS.n83 VSS.t1784 108.999
R384 VSS.t1789 VSS.n83 108.999
R385 VSS.n83 VSS.t1809 108.999
R386 VSS.n80 VSS.t847 108.722
R387 VSS.n80 VSS.t872 108.999
R388 VSS.t877 VSS.n80 109.001
R389 VSS.t942 VSS.n80 108.999
R390 VSS.t972 VSS.n80 108.999
R391 VSS.n80 VSS.t977 109.001
R392 VSS.t1012 VSS.n80 108.999
R393 VSS.n80 VSS.t1027 108.999
R394 VSS.n80 VSS.t1037 108.999
R395 VSS.t1042 VSS.n80 109.001
R396 VSS.n80 VSS.t1057 108.999
R397 VSS.n80 VSS.t1067 108.999
R398 VSS.n80 VSS.t1077 108.999
R399 VSS.n80 VSS.t1097 108.999
R400 VSS.t1112 VSS.n80 108.999
R401 VSS.t1122 VSS.n80 108.999
R402 VSS.n287 VSS.t791 251.417
R403 VSS.n306 VSS.t793 251.417
R404 VSS.n891 VSS.t795 235.714
R405 VSS.n893 VSS.t802 235.714
R406 VSS.t804 VSS.n303 251.417
R407 VSS.n762 VSS.t810 235.714
R408 VSS.t813 VSS.n184 241.613
R409 VSS.n156 VSS.t814 236.154
R410 VSS.n151 VSS.t697 105.683
R411 VSS.t699 VSS.n160 105.684
R412 VSS.t704 VSS.n164 105.684
R413 VSS.t824 VSS.n138 106.677
R414 VSS.t709 VSS.n168 105.684
R415 VSS.n135 VSS.t711 105.683
R416 VSS.n173 VSS.t830 106.677
R417 VSS.t718 VSS.n176 105.684
R418 VSS.n129 VSS.t721 105.683
R419 VSS.n178 VSS.t838 106.677
R420 VSS.t728 VSS.n180 105.684
R421 VSS.n123 VSS.t731 105.683
R422 VSS.n120 VSS.t755 242.431
R423 VSS.t757 VSS.n119 242.431
R424 VSS.n117 VSS.t759 237.353
R425 VSS.t765 VSS.n121 238.663
R426 VSS.n302 VSS.t670 251.417
R427 VSS.n201 VSS.t674 251.417
R428 VSS.n301 VSS.t677 251.417
R429 VSS.n825 VSS.t780 235.714
R430 VSS.t783 VSS.n192 99.5774
R431 VSS.t252 VSS.t280 235.714
R432 VSS.n175 VSS.t588 101.781
R433 VSS.n171 VSS.t590 105.683
R434 VSS.n177 VSS.t539 106.677
R435 VSS.n166 VSS.t594 105.683
R436 VSS.t596 VSS.n179 105.684
R437 VSS.n163 VSS.t598 105.683
R438 VSS.n181 VSS.t549 106.677
R439 VSS.n158 VSS.t602 105.683
R440 VSS.t604 VSS.n183 105.684
R441 VSS.n153 VSS.t606 105.683
R442 VSS.t608 VSS.n186 105.684
R443 VSS.n146 VSS.t610 105.683
R444 VSS.n187 VSS.t563 106.677
R445 VSS.t616 VSS.n190 105.684
R446 VSS.t571 VSS.n106 106.677
R447 VSS.n854 VSS.t526 235.714
R448 VSS.t515 VSS.t7 108.722
R449 VSS.n800 VSS.t579 235.714
R450 VSS.n182 VSS.t846 106.159
R451 VSS.t144 VSS.n775 233.333
R452 VSS.n862 VSS.t168 233.333
R453 VSS.n886 VSS.t281 231.429
R454 VSS.t132 VSS.t80 228.782
R455 VSS.n874 VSS.t5 228.782
R456 VSS.n872 VSS.n870 227.56
R457 VSS.n81 VSS.t2321 109.986
R458 VSS.n81 VSS.t2346 109.992
R459 VSS.n81 VSS.t2386 109.993
R460 VSS.n81 VSS.t2401 109.992
R461 VSS.n81 VSS.t2421 109.992
R462 VSS.n82 VSS.t1944 109.992
R463 VSS.n82 VSS.t1949 109.993
R464 VSS.n82 VSS.t1959 109.993
R465 VSS.n82 VSS.t2004 109.992
R466 VSS.n82 VSS.t2024 109.992
R467 VSS.n82 VSS.t2039 109.993
R468 VSS.n82 VSS.t2054 109.992
R469 VSS.n83 VSS.t1542 109.992
R470 VSS.n83 VSS.t1552 109.992
R471 VSS.n83 VSS.t1577 109.992
R472 VSS.n83 VSS.t1597 109.992
R473 VSS.n83 VSS.t1607 109.992
R474 VSS.n83 VSS.t1612 109.993
R475 VSS.n83 VSS.t1617 109.992
R476 VSS.n83 VSS.t1622 109.993
R477 VSS.n83 VSS.t1647 109.992
R478 VSS.n83 VSS.t1667 109.992
R479 VSS.n80 VSS.t855 109.992
R480 VSS.n80 VSS.t920 109.992
R481 VSS.n80 VSS.t935 109.992
R482 VSS.n80 VSS.t965 109.992
R483 VSS.n772 VSS.t788 227.143
R484 VSS.n287 VSS.t684 242.846
R485 VSS.n306 VSS.t687 242.846
R486 VSS.n185 VSS.t797 102.68
R487 VSS.t799 VSS.n765 227.143
R488 VSS.n895 VSS.t808 227.143
R489 VSS.n151 VSS.t816 106.677
R490 VSS.t818 VSS.n160 106.677
R491 VSS.n145 VSS.t820 106.677
R492 VSS.t826 VSS.n168 106.677
R493 VSS.n135 VSS.t828 106.677
R494 VSS.n132 VSS.t832 106.677
R495 VSS.n129 VSS.t836 106.677
R496 VSS.n126 VSS.t840 106.677
R497 VSS.t202 VSS.t633 109.992
R498 VSS.t202 VSS.t638 109.993
R499 VSS.t202 VSS.t643 109.992
R500 VSS.t665 VSS.n118 234.188
R501 VSS.n116 VSS.t667 234.188
R502 VSS.n843 VSS.t761 227.143
R503 VSS.n195 VSS.t777 106.159
R504 VSS.n191 VSS.t782 228.291
R505 VSS.n188 VSS.t785 230.583
R506 VSS.n166 VSS.t542 106.677
R507 VSS.t553 VSS.n183 106.677
R508 VSS.n153 VSS.t556 106.677
R509 VSS.n146 VSS.t561 106.677
R510 VSS.n141 VSS.t566 106.677
R511 VSS.n852 VSS.t585 227.143
R512 VSS.n855 VSS.t527 227.143
R513 VSS.t7 VSS.t518 109.986
R514 VSS.t7 VSS.n107 100.312
R515 VSS.n52 VSS.t688 221.417
R516 VSS.t692 VSS.n65 221.417
R517 VSS.n70 VSS.t679 221.417
R518 VSS.t348 VSS.t3294 210
R519 VSS.t688 VSS.n766 205.714
R520 VSS.t668 VSS.n97 102.626
R521 VSS.n276 VSS.t679 221.417
R522 VSS.n195 VSS.t680 107.195
R523 VSS.n833 VSS.t786 205.714
R524 VSS.t7 VSS.t525 222.065
R525 VSS.t347 VSS.n14 109.96
R526 VSS.t202 VSS.t801 200.613
R527 VSS.t2331 VSS.n81 109.993
R528 VSS.t2356 VSS.n81 109.993
R529 VSS.t2376 VSS.n81 109.993
R530 VSS.t2416 VSS.n81 109.993
R531 VSS.t2426 VSS.n81 109.993
R532 VSS.t2436 VSS.n81 109.993
R533 VSS.t2451 VSS.n81 109.993
R534 VSS.t2461 VSS.n81 109.992
R535 VSS.t2466 VSS.n81 109.993
R536 VSS.t2471 VSS.n81 109.993
R537 VSS.t2496 VSS.n81 109.993
R538 VSS.t2521 VSS.n81 109.993
R539 VSS.t2526 VSS.n81 109.993
R540 VSS.t2546 VSS.n81 109.993
R541 VSS.t2551 VSS.n81 109.993
R542 VSS.t2566 VSS.n81 109.993
R543 VSS.t2596 VSS.n81 109.993
R544 VSS.t1929 VSS.n82 109.986
R545 VSS.t1939 VSS.n82 109.993
R546 VSS.t1969 VSS.n82 109.993
R547 VSS.t1994 VSS.n82 109.993
R548 VSS.t1999 VSS.n82 109.993
R549 VSS.t2049 VSS.n82 109.993
R550 VSS.t2064 VSS.n82 109.993
R551 VSS.t2069 VSS.n82 109.993
R552 VSS.t2079 VSS.n82 109.993
R553 VSS.t2084 VSS.n82 109.993
R554 VSS.t2109 VSS.n82 109.993
R555 VSS.t2134 VSS.n82 109.993
R556 VSS.t2159 VSS.n82 109.993
R557 VSS.t2194 VSS.n82 109.993
R558 VSS.t2204 VSS.n82 109.993
R559 VSS.t1547 VSS.n83 109.993
R560 VSS.t1557 VSS.n83 109.993
R561 VSS.t1562 VSS.n83 109.993
R562 VSS.t1582 VSS.n83 109.993
R563 VSS.t1632 VSS.n83 109.993
R564 VSS.t1642 VSS.n83 109.993
R565 VSS.t1652 VSS.n83 109.993
R566 VSS.t1657 VSS.n83 109.993
R567 VSS.n83 VSS.t1677 109.993
R568 VSS.t1687 VSS.n83 109.993
R569 VSS.t1707 VSS.n83 109.993
R570 VSS.t1727 VSS.n83 109.993
R571 VSS.t1752 VSS.n83 109.993
R572 VSS.t1777 VSS.n83 109.993
R573 VSS.t1802 VSS.n83 109.993
R574 VSS.t1812 VSS.n83 109.993
R575 VSS.t850 VSS.n80 109.986
R576 VSS.t860 VSS.n80 109.993
R577 VSS.t865 VSS.n80 109.993
R578 VSS.t885 VSS.n80 109.993
R579 VSS.t895 VSS.n80 109.993
R580 VSS.t905 VSS.n80 109.993
R581 VSS.t930 VSS.n80 109.993
R582 VSS.t955 VSS.n80 109.993
R583 VSS.t960 VSS.n80 109.993
R584 VSS.t975 VSS.n80 109.993
R585 VSS.t1000 VSS.n80 109.993
R586 VSS.t1030 VSS.n80 109.993
R587 VSS.t1040 VSS.n80 109.993
R588 VSS.t1065 VSS.n80 109.993
R589 VSS.t1070 VSS.n80 109.993
R590 VSS.t1085 VSS.n80 109.993
R591 VSS.t1095 VSS.n80 109.993
R592 VSS.t1100 VSS.n80 109.993
R593 VSS.t1125 VSS.n80 109.993
R594 VSS.n185 VSS.t202 7.31295
R595 VSS.n154 VSS.t696 23.2336
R596 VSS.t698 VSS.n150 23.2336
R597 VSS.t202 VSS.n160 3.31705
R598 VSS.n148 VSS.t701 23.2336
R599 VSS.n145 VSS.t202 3.31704
R600 VSS.t703 VSS.n144 23.2336
R601 VSS.n164 VSS.t822 106.677
R602 VSS.n142 VSS.t706 23.2336
R603 VSS.n139 VSS.t202 86.7547
R604 VSS.t202 VSS.n168 3.31705
R605 VSS.n136 VSS.t710 23.2336
R606 VSS.t712 VSS.n134 23.2336
R607 VSS.t202 VSS.n173 3.31705
R608 VSS.n133 VSS.t715 23.2336
R609 VSS.n132 VSS.t202 3.31704
R610 VSS.t717 VSS.n131 23.2336
R611 VSS.n176 VSS.t834 106.677
R612 VSS.t202 VSS.n130 86.7547
R613 VSS.t722 VSS.n128 23.2336
R614 VSS.t202 VSS.n178 3.31705
R615 VSS.n127 VSS.t725 23.2336
R616 VSS.n126 VSS.t202 3.31704
R617 VSS.t727 VSS.n125 23.2336
R618 VSS.n180 VSS.t842 106.677
R619 VSS.n124 VSS.t730 23.2336
R620 VSS.t844 VSS.n123 106.677
R621 VSS.t732 VSS.n122 23.2336
R622 VSS.n182 VSS.t202 3.83526
R623 VSS.t623 VSS.t202 109.986
R624 VSS.t648 VSS.t202 109.993
R625 VSS.t658 VSS.t202 109.993
R626 VSS.t752 VSS.n114 102.457
R627 VSS.n195 VSS.t202 3.83504
R628 VSS.t779 VSS.t202 109.7
R629 VSS.t7 VSS.n174 86.7547
R630 VSS.t537 VSS.n171 106.677
R631 VSS.t591 VSS.n172 23.2336
R632 VSS.t7 VSS.n177 3.31705
R633 VSS.n170 VSS.t593 23.2336
R634 VSS.t595 VSS.n167 23.2336
R635 VSS.n179 VSS.t544 106.677
R636 VSS.t7 VSS.n165 86.7547
R637 VSS.t547 VSS.n163 106.677
R638 VSS.n162 VSS.t7 86.7547
R639 VSS.t7 VSS.n181 3.31705
R640 VSS.n161 VSS.t601 23.2336
R641 VSS.t551 VSS.n158 106.677
R642 VSS.t603 VSS.n159 23.2336
R643 VSS.t7 VSS.n183 3.31705
R644 VSS.n155 VSS.t605 23.2336
R645 VSS.n152 VSS.t7 86.7547
R646 VSS.n186 VSS.t558 106.677
R647 VSS.t7 VSS.n149 86.7547
R648 VSS.t611 VSS.n147 23.2336
R649 VSS.t7 VSS.n187 3.31705
R650 VSS.n143 VSS.t613 23.2336
R651 VSS.n141 VSS.t7 3.31704
R652 VSS.t615 VSS.n140 23.2336
R653 VSS.n190 VSS.t568 106.677
R654 VSS.t7 VSS.n137 86.7547
R655 VSS.t619 VSS.n107 9.6807
R656 VSS.t7 VSS.t523 109.993
R657 VSS.t788 VSS.n56 199.989
R658 VSS.n57 VSS.t684 199.989
R659 VSS.n54 VSS.t687 199.989
R660 VSS.t691 VSS.n64 199.989
R661 VSS.t808 VSS.n62 199.989
R662 VSS.n61 VSS.t814 199.989
R663 VSS.n75 VSS.t665 199.989
R664 VSS.t667 VSS.n77 199.989
R665 VSS.t764 VSS.t202 109.639
R666 VSS.t767 VSS.n818 199.989
R667 VSS.t769 VSS.n73 199.989
R668 VSS.t771 VSS.n68 199.989
R669 VSS.t773 VSS.n67 199.989
R670 VSS.t0 VSS.t775 197.143
R671 VSS.t753 VSS.t332 192.857
R672 VSS.n81 VSS.t2593 108.999
R673 VSS.t2588 VSS.n81 109.001
R674 VSS.t2586 VSS.n81 109.993
R675 VSS.n81 VSS.t2581 109.992
R676 VSS.t2576 VSS.n81 109.993
R677 VSS.n81 VSS.t2571 109.992
R678 VSS.n81 VSS.t2563 108.999
R679 VSS.n81 VSS.t2561 109.993
R680 VSS.n81 VSS.t2553 109.001
R681 VSS.t2548 VSS.n81 108.999
R682 VSS.n81 VSS.t2543 108.999
R683 VSS.n81 VSS.t2541 109.992
R684 VSS.t2536 VSS.n81 109.993
R685 VSS.t2528 VSS.n81 109.001
R686 VSS.t2518 VSS.n81 108.999
R687 VSS.t2516 VSS.n81 109.992
R688 VSS.t2508 VSS.n81 108.999
R689 VSS.t2506 VSS.n81 109.993
R690 VSS.t2498 VSS.n81 109.001
R691 VSS.n81 VSS.t2493 108.999
R692 VSS.t2488 VSS.n81 109.001
R693 VSS.n81 VSS.t2483 108.999
R694 VSS.t2478 VSS.n81 108.999
R695 VSS.n81 VSS.t2473 109.001
R696 VSS.t2468 VSS.n81 108.999
R697 VSS.n81 VSS.t2456 109.993
R698 VSS.t2448 VSS.n81 108.999
R699 VSS.n81 VSS.t2446 109.992
R700 VSS.n81 VSS.t2441 109.993
R701 VSS.t2428 VSS.n81 109.001
R702 VSS.t2423 VSS.n81 108.999
R703 VSS.t2418 VSS.n81 109.001
R704 VSS.t2413 VSS.n81 108.999
R705 VSS.n81 VSS.t2411 109.992
R706 VSS.t2403 VSS.n81 108.999
R707 VSS.t2398 VSS.n81 109.001
R708 VSS.n81 VSS.t2396 109.993
R709 VSS.t2388 VSS.n81 109.001
R710 VSS.t2383 VSS.n81 108.999
R711 VSS.n81 VSS.t2381 109.992
R712 VSS.t2368 VSS.n81 109.001
R713 VSS.t2363 VSS.n81 108.999
R714 VSS.t2358 VSS.n81 109.001
R715 VSS.t2353 VSS.n81 108.999
R716 VSS.n81 VSS.t2351 109.992
R717 VSS.t2343 VSS.n81 109.001
R718 VSS.n81 VSS.t2341 109.993
R719 VSS.n81 VSS.t2336 109.993
R720 VSS.t2328 VSS.n81 108.999
R721 VSS.n81 VSS.t2326 109.992
R722 VSS.t2318 VSS.n81 108.722
R723 VSS.n81 VSS.t2458 109.001
R724 VSS.n82 VSS.t2201 108.999
R725 VSS.t2196 VSS.n82 109.001
R726 VSS.n82 VSS.t2189 109.992
R727 VSS.n82 VSS.t2181 108.999
R728 VSS.t2176 VSS.n82 108.999
R729 VSS.n82 VSS.t2171 109.001
R730 VSS.n82 VSS.t2169 109.993
R731 VSS.n82 VSS.t2161 108.999
R732 VSS.t2156 VSS.n82 108.999
R733 VSS.t2154 VSS.n82 109.992
R734 VSS.n82 VSS.t2149 109.993
R735 VSS.n82 VSS.t2141 109.001
R736 VSS.t2136 VSS.n82 108.999
R737 VSS.n82 VSS.t2129 109.992
R738 VSS.n82 VSS.t2121 109.001
R739 VSS.t2116 VSS.n82 108.999
R740 VSS.n82 VSS.t2111 109.001
R741 VSS.t2106 VSS.n82 108.999
R742 VSS.n82 VSS.t2101 109.001
R743 VSS.n82 VSS.t2099 109.993
R744 VSS.t2094 VSS.n82 109.993
R745 VSS.t2086 VSS.n82 109.001
R746 VSS.n82 VSS.t2081 108.999
R747 VSS.t2074 VSS.n82 109.992
R748 VSS.n82 VSS.t2061 108.999
R749 VSS.n82 VSS.t2059 109.992
R750 VSS.n82 VSS.t2051 109.001
R751 VSS.t2046 VSS.n82 108.999
R752 VSS.t2044 VSS.n82 109.992
R753 VSS.t2036 VSS.n82 108.999
R754 VSS.t2034 VSS.n82 109.992
R755 VSS.n82 VSS.t2029 109.993
R756 VSS.n82 VSS.t2021 109.001
R757 VSS.n82 VSS.t2019 109.993
R758 VSS.n82 VSS.t2011 109.001
R759 VSS.n82 VSS.t2009 109.993
R760 VSS.n82 VSS.t2001 109.001
R761 VSS.t1996 VSS.n82 108.999
R762 VSS.n82 VSS.t1991 108.999
R763 VSS.t1986 VSS.n82 109.001
R764 VSS.t1984 VSS.n82 109.993
R765 VSS.t1976 VSS.n82 109.001
R766 VSS.n82 VSS.t1971 109.001
R767 VSS.t1966 VSS.n82 108.999
R768 VSS.t1964 VSS.n82 109.992
R769 VSS.n82 VSS.t1956 108.999
R770 VSS.n82 VSS.t1954 109.993
R771 VSS.n82 VSS.t1946 108.999
R772 VSS.t1941 VSS.n82 109.001
R773 VSS.n82 VSS.t1934 109.992
R774 VSS.n82 VSS.t2066 108.999
R775 VSS.n83 VSS.t1804 109.001
R776 VSS.t1799 VSS.n83 108.999
R777 VSS.n83 VSS.t1794 109.001
R778 VSS.t1792 VSS.n83 109.993
R779 VSS.n83 VSS.t1787 109.993
R780 VSS.n83 VSS.t1782 109.992
R781 VSS.t1774 VSS.n83 108.999
R782 VSS.t1769 VSS.n83 109.001
R783 VSS.n83 VSS.t1767 109.993
R784 VSS.t1759 VSS.n83 109.001
R785 VSS.t1754 VSS.n83 108.999
R786 VSS.n83 VSS.t1747 109.992
R787 VSS.t1739 VSS.n83 109.001
R788 VSS.n83 VSS.t1737 109.993
R789 VSS.n83 VSS.t1732 109.993
R790 VSS.t1724 VSS.n83 108.999
R791 VSS.n83 VSS.t1722 109.992
R792 VSS.n83 VSS.t1717 109.993
R793 VSS.n83 VSS.t1712 109.993
R794 VSS.t1704 VSS.n83 108.999
R795 VSS.t1699 VSS.n83 109.001
R796 VSS.n83 VSS.t1697 109.993
R797 VSS.t1689 VSS.n83 109.001
R798 VSS.t1679 VSS.n83 109.001
R799 VSS.n83 VSS.t1672 109.993
R800 VSS.n83 VSS.t1664 109.001
R801 VSS.t1659 VSS.n83 109.001
R802 VSS.n83 VSS.t1654 108.999
R803 VSS.n83 VSS.t1644 109.001
R804 VSS.t1639 VSS.n83 108.999
R805 VSS.n83 VSS.t1634 109.001
R806 VSS.t1629 VSS.n83 108.999
R807 VSS.n83 VSS.t1624 109.001
R808 VSS.t1619 VSS.n83 108.999
R809 VSS.n83 VSS.t1614 109.001
R810 VSS.t1609 VSS.n83 108.999
R811 VSS.n83 VSS.t1604 109.001
R812 VSS.n83 VSS.t1602 109.993
R813 VSS.n83 VSS.t1594 109.001
R814 VSS.n83 VSS.t1592 109.993
R815 VSS.n83 VSS.t1584 109.001
R816 VSS.n83 VSS.t1574 109.001
R817 VSS.n83 VSS.t1572 109.993
R818 VSS.n83 VSS.t1564 109.001
R819 VSS.t1559 VSS.n83 108.999
R820 VSS.t1549 VSS.n83 109.001
R821 VSS.n83 VSS.t1544 108.999
R822 VSS.t1539 VSS.n83 109.001
R823 VSS.n83 VSS.t1534 108.722
R824 VSS.t1674 VSS.n83 108.999
R825 VSS.t1117 VSS.n80 109.001
R826 VSS.t1115 VSS.n80 109.993
R827 VSS.t1107 VSS.n80 109.001
R828 VSS.n80 VSS.t1102 109.001
R829 VSS.n80 VSS.t1092 108.999
R830 VSS.t1087 VSS.n80 109.001
R831 VSS.n80 VSS.t1082 108.999
R832 VSS.n80 VSS.t1080 109.993
R833 VSS.n80 VSS.t1072 109.001
R834 VSS.n80 VSS.t1062 108.999
R835 VSS.n80 VSS.t1060 109.993
R836 VSS.n80 VSS.t1052 109.001
R837 VSS.t1047 VSS.n80 108.999
R838 VSS.t1045 VSS.n80 109.992
R839 VSS.n80 VSS.t1032 109.001
R840 VSS.n80 VSS.t1022 109.001
R841 VSS.t1017 VSS.n80 108.999
R842 VSS.t1015 VSS.n80 109.993
R843 VSS.t1007 VSS.n80 109.001
R844 VSS.n80 VSS.t1002 108.999
R845 VSS.t997 VSS.n80 108.999
R846 VSS.n80 VSS.t992 109.001
R847 VSS.n80 VSS.t982 108.999
R848 VSS.n80 VSS.t980 109.992
R849 VSS.t967 VSS.n80 108.999
R850 VSS.n80 VSS.t962 109.001
R851 VSS.t957 VSS.n80 108.999
R852 VSS.n80 VSS.t952 108.999
R853 VSS.n80 VSS.t950 109.992
R854 VSS.t945 VSS.n80 109.993
R855 VSS.n80 VSS.t940 109.993
R856 VSS.n80 VSS.t932 109.001
R857 VSS.t927 VSS.n80 108.999
R858 VSS.t925 VSS.n80 109.993
R859 VSS.t917 VSS.n80 109.001
R860 VSS.n80 VSS.t912 108.999
R861 VSS.t907 VSS.n80 109.001
R862 VSS.n80 VSS.t902 108.999
R863 VSS.t897 VSS.n80 109.001
R864 VSS.n80 VSS.t892 108.999
R865 VSS.t887 VSS.n80 109.001
R866 VSS.n80 VSS.t882 108.999
R867 VSS.t880 VSS.n80 109.992
R868 VSS.n80 VSS.t875 109.993
R869 VSS.t867 VSS.n80 109.001
R870 VSS.t862 VSS.n80 108.999
R871 VSS.t852 VSS.n80 109.001
R872 VSS.n80 VSS.t987 108.999
R873 VSS.t202 VSS.n122 86.7547
R874 VSS.n123 VSS.t202 3.31704
R875 VSS.n124 VSS.t202 86.7547
R876 VSS.t202 VSS.n125 86.7547
R877 VSS.t726 VSS.n126 105.683
R878 VSS.n127 VSS.t202 86.7547
R879 VSS.n178 VSS.t723 105.684
R880 VSS.t202 VSS.n128 86.7547
R881 VSS.n129 VSS.t202 3.31704
R882 VSS.t835 VSS.n130 22.2411
R883 VSS.t202 VSS.n131 86.7547
R884 VSS.t716 VSS.n132 105.683
R885 VSS.n133 VSS.t202 86.7547
R886 VSS.n173 VSS.t713 105.684
R887 VSS.t202 VSS.n134 86.7547
R888 VSS.n135 VSS.t202 3.31704
R889 VSS.n136 VSS.t202 86.7547
R890 VSS.n139 VSS.t825 22.2411
R891 VSS.t707 VSS.n138 105.683
R892 VSS.n142 VSS.t202 86.7547
R893 VSS.t202 VSS.n164 3.31705
R894 VSS.t202 VSS.n144 86.7547
R895 VSS.t702 VSS.n145 105.683
R896 VSS.n148 VSS.t202 86.7547
R897 VSS.t202 VSS.n150 86.7547
R898 VSS.n151 VSS.t202 3.31704
R899 VSS.n154 VSS.t202 86.7547
R900 VSS.n156 VSS.t694 101.781
R901 VSS.t202 VSS.t776 192.042
R902 VSS.n113 VSS.t751 12.9737
R903 VSS.t655 VSS.t202 108.999
R904 VSS.t202 VSS.t650 109.001
R905 VSS.t645 VSS.t202 108.999
R906 VSS.t202 VSS.t640 109.001
R907 VSS.t635 VSS.t202 108.999
R908 VSS.t202 VSS.t630 109.001
R909 VSS.t202 VSS.t628 109.992
R910 VSS.t202 VSS.t620 108.722
R911 VSS.t618 VSS.n106 105.683
R912 VSS.t570 VSS.n137 22.2411
R913 VSS.t7 VSS.n190 3.31705
R914 VSS.t7 VSS.n140 86.7547
R915 VSS.t614 VSS.n141 105.683
R916 VSS.n143 VSS.t7 86.7547
R917 VSS.n187 VSS.t612 105.684
R918 VSS.t7 VSS.n147 86.7547
R919 VSS.n146 VSS.t7 3.31704
R920 VSS.t560 VSS.n149 22.2411
R921 VSS.t7 VSS.n186 3.31705
R922 VSS.n152 VSS.t557 22.2411
R923 VSS.n153 VSS.t7 3.31704
R924 VSS.n155 VSS.t7 86.7547
R925 VSS.t7 VSS.n159 86.7547
R926 VSS.n158 VSS.t7 3.31704
R927 VSS.n161 VSS.t7 86.7547
R928 VSS.n181 VSS.t600 105.684
R929 VSS.n162 VSS.t548 22.2411
R930 VSS.n163 VSS.t7 3.31704
R931 VSS.t546 VSS.n165 22.2411
R932 VSS.t7 VSS.n167 86.7547
R933 VSS.n166 VSS.t7 3.31704
R934 VSS.n170 VSS.t7 86.7547
R935 VSS.n177 VSS.t592 105.684
R936 VSS.t7 VSS.n172 86.7547
R937 VSS.n171 VSS.t7 3.31704
R938 VSS.t536 VSS.n174 22.2411
R939 VSS.t7 VSS.n175 7.34144
R940 VSS.t520 VSS.t7 108.999
R941 VSS.n197 VSS.t7 96.0268
R942 VSS.t789 VSS.n58 191.417
R943 VSS.t791 VSS.n55 191.417
R944 VSS.t793 VSS.n52 191.417
R945 VSS.t798 VSS.t202 108.635
R946 VSS.t802 VSS.n63 191.417
R947 VSS.n65 VSS.t804 191.417
R948 VSS.t810 VSS.n60 191.417
R949 VSS.n76 VSS.t753 191.417
R950 VSS.t755 VSS.n75 191.417
R951 VSS.n77 VSS.t757 191.417
R952 VSS.n78 VSS.t759 191.417
R953 VSS.t670 VSS.n72 191.417
R954 VSS.n69 VSS.t674 191.417
R955 VSS.n66 VSS.t677 191.417
R956 VSS.n71 VSS.t774 191.417
R957 VSS.t780 VSS.n49 191.417
R958 VSS.t579 VSS.n11 191.417
R959 VSS.n300 VSS.t61 204.274
R960 VSS.n771 VSS.t790 184.286
R961 VSS.t792 VSS.n767 184.286
R962 VSS.t794 VSS.n766 184.286
R963 VSS.n79 VSS.t799 187.073
R964 VSS.t803 VSS.n764 184.286
R965 VSS.t692 VSS.n217 212.758
R966 VSS.t812 VSS.n761 184.286
R967 VSS.t756 VSS.n118 100.883
R968 VSS.t758 VSS.n116 100.883
R969 VSS.t672 VSS.n816 184.286
R970 VSS.t675 VSS.n819 184.286
R971 VSS.t678 VSS.n820 184.286
R972 VSS.t775 VSS.n822 184.286
R973 VSS.t782 VSS.n824 184.286
R974 VSS.t585 VSS.n789 184.286
R975 VSS.t581 VSS.n795 184.286
R976 VSS.n768 VSS.t787 175.714
R977 VSS.t682 VSS.n771 175.714
R978 VSS.t685 VSS.n767 175.714
R979 VSS.t689 VSS.n764 175.714
R980 VSS.t806 VSS.n763 175.714
R981 VSS.n896 VSS.t813 175.714
R982 VSS.t330 VSS.t754 175.714
R983 VSS.t762 VSS.n97 183.584
R984 VSS.t768 VSS.n816 175.714
R985 VSS.t770 VSS.n819 175.714
R986 VSS.t772 VSS.n820 175.714
R987 VSS.t584 VSS.n790 175.714
R988 VSS.t526 VSS.n786 175.714
R989 VSS.t787 VSS.t317 171.429
R990 VSS.n196 VSS.t778 97.296
R991 VSS.t327 VSS.n894 169.989
R992 VSS.n50 VSS.t287 169.989
R993 VSS.n2 VSS.t3291 169.989
R994 VSS.t3281 VSS.t286 167.143
R995 VSS.t3323 VSS.t581 167.143
R996 VSS.t6 VSS.t3298 166.877
R997 VSS.n867 VSS.t144 166.667
R998 VSS.t168 VSS.n780 166.667
R999 VSS.n857 VSS.t140 166.667
R1000 VSS.t3318 VSS.t806 162.857
R1001 VSS.t786 VSS.t277 162.857
R1002 VSS.t141 VSS.n1 157.335
R1003 VSS.t801 VSS.t53 154.286
R1004 VSS.t19 VSS.n824 154.286
R1005 VSS.t3270 VSS.n838 154.286
R1006 VSS.n865 VSS.t239 154.167
R1007 VSS.t3307 VSS.n783 154.167
R1008 VSS.n856 VSS.t97 154.167
R1009 VSS.n4 VSS.t86 153.243
R1010 VSS.t3298 VSS.n870 151.708
R1011 VSS.t761 VSS.t15 150
R1012 VSS.n867 VSS.t102 150
R1013 VSS.t527 VSS.t3278 150
R1014 VSS.n861 VSS.t268 141.667
R1015 VSS.t795 VSS.t3274 141.429
R1016 VSS.t213 VSS.t48 141.429
R1017 VSS.t5 VSS.n13 140.974
R1018 VSS.t3300 VSS.n12 140.974
R1019 VSS.n774 VSS.t199 137.536
R1020 VSS.n890 VSS.t145 137.143
R1021 VSS.t198 VSS.n91 92.8086
R1022 VSS.n871 VSS.t253 136.531
R1023 VSS.n62 VSS.t3312 135.703
R1024 VSS.t136 VSS.t7 132.976
R1025 VSS.t525 VSS.t3293 128.571
R1026 VSS.t87 VSS.t765 124.287
R1027 VSS.t60 VSS.n821 124.287
R1028 VSS.n835 VSS.t278 124.287
R1029 VSS.n811 VSS.t348 124.287
R1030 VSS.n825 VSS.t232 120.001
R1031 VSS.t785 VSS.t359 120.001
R1032 VSS.t291 VSS.n827 120.001
R1033 VSS.t31 VSS.n792 120.001
R1034 VSS.n1 VSS.t124 119.835
R1035 VSS.n8 VSS.t266 119.835
R1036 VSS.t23 VSS.n776 116.668
R1037 VSS.t140 VSS.t136 116.668
R1038 VSS.t251 VSS.t282 114.391
R1039 VSS.t282 VSS.t203 114.391
R1040 VSS.t3305 VSS.n76 114.275
R1041 VSS.t196 VSS.n782 112.501
R1042 VSS.n891 VSS.t274 111.43
R1043 VSS.t44 VSS.t9 111.43
R1044 VSS.t102 VSS.t141 108.334
R1045 VSS.t85 VSS.t355 107.451
R1046 VSS.t333 VSS.n841 107.144
R1047 VSS.t3319 VSS.t812 107.144
R1048 VSS.t284 VSS.n822 107.144
R1049 VSS.n838 VSS.t304 107.144
R1050 VSS.n887 VSS.n875 107.144
R1051 VSS.n846 VSS.t11 107.144
R1052 VSS.t262 VSS.n785 107.144
R1053 VSS.n812 VSS.t211 107.144
R1054 VSS.t176 VSS.n798 107.144
R1055 VSS.t82 VSS.t7 104.168
R1056 VSS.t265 VSS.t139 103.153
R1057 VSS.n886 VSS.t3299 102.858
R1058 VSS.n854 VSS.t3277 98.5719
R1059 VSS.t3311 VSS.n25 91.4034
R1060 VSS.n768 VSS.t245 90.0005
R1061 VSS.n103 VSS.t3287 68.3362
R1062 VSS.t38 VSS.n892 90.0005
R1063 VSS.t360 VSS.n188 68.3487
R1064 VSS.n884 VSS.t78 90.0005
R1065 VSS.n882 VSS.t252 90.0005
R1066 VSS.n849 VSS.t316 90.0005
R1067 VSS.t3320 VSS.n796 90.0005
R1068 VSS.n189 VSS.t375 26.1613
R1069 VSS.n111 VSS.t381 26.1547
R1070 VSS.n115 VSS.t390 26.2522
R1071 VSS.n22 VSS.t403 26.1615
R1072 VSS.t74 VSS.n17 0.219018
R1073 VSS.t74 VSS.n18 0.121827
R1074 VSS.t74 VSS.n19 0.121827
R1075 VSS.n109 VSS.t74 0.121827
R1076 VSS.n110 VSS.t438 26.2522
R1077 VSS.n23 VSS.t445 26.1547
R1078 VSS.t450 VSS.n99 26.2514
R1079 VSS.n104 VSS.t466 26.1544
R1080 VSS.t74 VSS.n16 0.121819
R1081 VSS.t74 VSS.n15 0.121819
R1082 VSS.n60 VSS.t350 88.5605
R1083 VSS.t298 VSS.n51 88.5605
R1084 VSS.t346 VSS.n348 90.5966
R1085 VSS.n860 VSS.t197 87.5005
R1086 VSS.t138 VSS.n8 86.5025
R1087 VSS.t206 VSS.n31 85.7552
R1088 VSS.t308 VSS.n769 85.7148
R1089 VSS.n842 VSS.t18 85.7148
R1090 VSS.t107 VSS.n879 85.7148
R1091 VSS.n850 VSS.t34 85.7148
R1092 VSS.t41 VSS.n795 85.7148
R1093 VSS.n873 VSS.n12 85.6229
R1094 VSS.t3310 VSS.n347 85.7552
R1095 VSS.t338 VSS.n204 6.7658
R1096 VSS.t130 VSS.n829 81.4291
R1097 VSS.n883 VSS.t165 79.9891
R1098 VSS.n13 VSS.t105 78.2429
R1099 VSS.n845 VSS.n294 3692.29
R1100 VSS.n121 VSS.t50 60.8148
R1101 VSS.t3294 VSS.n810 77.1434
R1102 VSS.t3293 VSS.n794 77.1434
R1103 VSS.t328 VSS.n27 76.0726
R1104 VSS.n59 VSS.t310 75.7034
R1105 VSS.t134 VSS.n880 75.7034
R1106 VSS.t135 VSS.n3 75.7034
R1107 VSS.n204 VSS.t329 74.8144
R1108 VSS.n199 VSS.t356 20.3758
R1109 VSS.t202 VSS.t3318 89.2074
R1110 VSS.t72 VSS.n793 72.8576
R1111 VSS.t9 VSS.n194 76.9535
R1112 VSS.n47 VSS.t250 72.8441
R1113 VSS.n42 VSS.t171 72.8441
R1114 VSS.n38 VSS.t255 72.8441
R1115 VSS.n205 VSS.t3306 76.9073
R1116 VSS.n808 VSS.t371 72.6202
R1117 VSS.n804 VSS.t3283 72.6202
R1118 VSS.n807 VSS.t205 72.6202
R1119 VSS.t307 VSS.n56 71.4177
R1120 VSS.t279 VSS.n883 71.4177
R1121 VSS.t337 VSS.n14 71.717
R1122 VSS.t3292 VSS.n777 70.8338
R1123 VSS.t3286 VSS.n777 70.8338
R1124 VSS.n859 VSS.t230 70.8338
R1125 VSS.t3295 VSS.t267 70.8338
R1126 VSS.t267 VSS.n784 70.8338
R1127 VSS.t264 VSS.t138 70.8338
R1128 VSS.n206 VSS.t321 72.8451
R1129 VSS.n345 VSS.t236 72.8451
R1130 VSS.n209 VSS.t336 13.9422
R1131 VSS.n94 VSS.t3314 20.3803
R1132 VSS.n108 VSS.t370 73.1004
R1133 VSS.n105 VSS.t234 13.926
R1134 VSS.n198 VSS.t91 13.9422
R1135 VSS.n210 VSS.t209 13.9422
R1136 VSS.n352 VSS.t3276 23.7532
R1137 VSS.t528 VSS.t21 68.7684
R1138 VSS.n833 VSS.t3280 68.5719
R1139 VSS.t269 VSS.n4 67.2827
R1140 VSS.n9 VSS.t265 67.2827
R1141 VSS.t328 VSS.n89 25.8017
R1142 VSS.t239 VSS.t37 66.6672
R1143 VSS.t230 VSS.t195 66.6672
R1144 VSS.n808 VSS.t3276 64.5513
R1145 VSS.n863 VSS.t222 64.4704
R1146 VSS.t74 VSS.n205 10.0581
R1147 VSS.t317 VSS.t202 80.6121
R1148 VSS.n765 VSS.t312 64.2862
R1149 VSS.n305 VSS.t311 79.9891
R1150 VSS.t359 VSS.n832 64.2862
R1151 VSS.t281 VSS.n885 64.2862
R1152 VSS.t93 VSS.n792 64.2862
R1153 VSS.n799 VSS.t65 64.2862
R1154 VSS.t75 VSS.n32 64.1711
R1155 VSS.t233 VSS.n24 63.9684
R1156 VSS.n90 VSS.t3317 16.4142
R1157 VSS.t248 VSS.n88 16.4133
R1158 VSS.t216 VSS.n781 62.5005
R1159 VSS.n26 VSS.t3268 62.3556
R1160 VSS.n30 VSS.t76 62.3546
R1161 VSS.t345 VSS.n254 63.9693
R1162 VSS.t73 VSS.n255 63.9693
R1163 VSS.t170 VSS.n214 64.171
R1164 VSS.n91 VSS.t6 61.2944
R1165 VSS.n840 VSS.t303 60.0005
R1166 VSS.n813 VSS.t29 60.0005
R1167 VSS.n843 VSS.t17 60.0005
R1168 VSS.n885 VSS.t3302 60.0005
R1169 VSS.t70 VSS.n175 69.0108
R1170 VSS.n847 VSS.t46 60.0005
R1171 VSS.n855 VSS.t263 60.0005
R1172 VSS.t260 VSS.n797 60.0005
R1173 VSS.t277 VSS.t202 59.1836
R1174 VSS.t253 VSS.t82 59.0411
R1175 VSS.n92 VSS.t74 0.12188
R1176 VSS.n46 VSS.t484 58.6622
R1177 VSS.t486 VSS.n34 26.0021
R1178 VSS.n44 VSS.t489 58.6622
R1179 VSS.n86 VSS.t74 0.22519
R1180 VSS.n43 VSS.t493 58.6622
R1181 VSS.n41 VSS.t499 58.6622
R1182 VSS.n48 VSS.t74 0.22519
R1183 VSS.n39 VSS.t504 58.6622
R1184 VSS.n84 VSS.t508 58.6622
R1185 VSS.n36 VSS.t506 26.0019
R1186 VSS.n6 VSS.t96 58.5605
R1187 VSS.t88 VSS.t194 58.3338
R1188 VSS.n47 VSS.t482 58.3211
R1189 VSS.n42 VSS.t496 58.3211
R1190 VSS.n38 VSS.t511 58.3211
R1191 VSS.n37 VSS.t512 26.1611
R1192 VSS.n169 VSS.t74 0.219019
R1193 VSS.t74 VSS.n96 0.121819
R1194 VSS.n93 VSS.t74 0.12182
R1195 VSS.n46 VSS.t483 57.0465
R1196 VSS.t485 VSS.n45 26.1544
R1197 VSS.n44 VSS.t488 57.0465
R1198 VSS.n85 VSS.t74 0.219018
R1199 VSS.n43 VSS.t492 57.0465
R1200 VSS.n41 VSS.t497 57.0465
R1201 VSS.t500 VSS.n40 26.1544
R1202 VSS.n39 VSS.t503 57.0465
R1203 VSS.n84 VSS.t507 57.0465
R1204 VSS.t106 VSS.n881 55.7148
R1205 VSS.t33 VSS.n791 55.7148
R1206 VSS.n800 VSS.t40 55.7148
R1207 VSS.t365 VSS.n90 64.8343
R1208 VSS.t246 VSS.n88 64.8345
R1209 VSS.t99 VSS.n7 53.1692
R1210 VSS.t377 VSS.t74 26.5065
R1211 VSS.n214 VSS.t74 0.203719
R1212 VSS.t405 VSS.t74 26.5042
R1213 VSS.t495 VSS.t74 26.5067
R1214 VSS.t510 VSS.t74 26.5067
R1215 VSS.t74 VSS.n108 11.4438
R1216 VSS.t74 VSS.n105 3.3732
R1217 VSS.n868 VSS.t142 51.5764
R1218 VSS.n154 VSS.t815 22.2411
R1219 VSS.t817 VSS.n150 22.2411
R1220 VSS.n148 VSS.t819 22.2411
R1221 VSS.t821 VSS.n144 22.2411
R1222 VSS.n142 VSS.t823 22.2411
R1223 VSS.n139 VSS.t708 23.2336
R1224 VSS.n136 VSS.t827 22.2411
R1225 VSS.t829 VSS.n134 22.2411
R1226 VSS.n133 VSS.t831 22.2411
R1227 VSS.t833 VSS.n131 22.2411
R1228 VSS.t720 VSS.n130 23.2336
R1229 VSS.t837 VSS.n128 22.2411
R1230 VSS.n127 VSS.t839 22.2411
R1231 VSS.t841 VSS.n125 22.2411
R1232 VSS.n124 VSS.t843 22.2411
R1233 VSS.t845 VSS.n122 22.2411
R1234 VSS.n817 VSS.t87 51.4291
R1235 VSS.t589 VSS.n174 23.2336
R1236 VSS.t538 VSS.n172 22.2411
R1237 VSS.n170 VSS.t541 22.2411
R1238 VSS.t543 VSS.n167 22.2411
R1239 VSS.t597 VSS.n165 23.2336
R1240 VSS.n162 VSS.t599 23.2336
R1241 VSS.n161 VSS.t550 22.2411
R1242 VSS.t552 VSS.n159 22.2411
R1243 VSS.n155 VSS.t555 22.2411
R1244 VSS.n152 VSS.t607 23.2336
R1245 VSS.t609 VSS.n149 23.2336
R1246 VSS.t562 VSS.n147 22.2411
R1247 VSS.n143 VSS.t565 22.2411
R1248 VSS.t567 VSS.n140 22.2411
R1249 VSS.t617 VSS.n137 23.2336
R1250 VSS.n812 VSS.t254 51.4291
R1251 VSS.n193 VSS.t178 66.1728
R1252 VSS.t3274 VSS.t202 50.6131
R1253 VSS.t3278 VSS.n6 49.9891
R1254 VSS.t372 VSS.n189 47.2101
R1255 VSS.t379 VSS.n111 47.2102
R1256 VSS.t386 VSS.n112 26.2524
R1257 VSS.t388 VSS.n115 26.1049
R1258 VSS.n93 VSS.t397 26.2515
R1259 VSS.t400 VSS.n92 26.2635
R1260 VSS.n22 VSS.t401 47.2101
R1261 VSS.t409 VSS.n17 26.1544
R1262 VSS.t414 VSS.n18 26.2522
R1263 VSS.t419 VSS.n19 26.2522
R1264 VSS.n157 VSS.t421 26.105
R1265 VSS.n28 VSS.t426 47.2102
R1266 VSS.t433 VSS.n109 26.2522
R1267 VSS.n110 VSS.t435 26.1051
R1268 VSS.n23 VSS.t442 47.2102
R1269 VSS.t455 VSS.n100 26.2524
R1270 VSS.t460 VSS.n29 26.2524
R1271 VSS.n104 VSS.t464 47.2102
R1272 VSS.t471 VSS.n16 26.2515
R1273 VSS.t476 VSS.n15 26.2515
R1274 VSS.t483 VSS.n33 48.6385
R1275 VSS.t484 VSS.n45 47.2102
R1276 VSS.t488 VSS.n34 48.8187
R1277 VSS.n85 VSS.t490 26.1544
R1278 VSS.t492 VSS.n86 48.8187
R1279 VSS.n21 VSS.t494 26.1613
R1280 VSS.t497 VSS.n35 48.6385
R1281 VSS.t499 VSS.n40 47.2102
R1282 VSS.t503 VSS.n48 48.8187
R1283 VSS.n169 VSS.t505 26.1547
R1284 VSS.t507 VSS.n36 48.8187
R1285 VSS.n20 VSS.t509 26.1613
R1286 VSS.n37 VSS.t511 47.2101
R1287 VSS.t776 VSS.t61 47.1434
R1288 VSS.n851 VSS.t319 47.1434
R1289 VSS.t447 VSS.n99 26.1059
R1290 VSS.n96 VSS.t395 26.2512
R1291 VSS.t396 VSS.n93 26.106
R1292 VSS.t468 VSS.n16 26.1058
R1293 VSS.t473 VSS.n15 26.1058
R1294 VSS.t482 VSS.n33 47.0238
R1295 VSS.n86 VSS.t491 26.0021
R1296 VSS.t496 VSS.n35 47.0238
R1297 VSS.n48 VSS.t501 26.0021
R1298 VSS.t355 VSS.n9 45.7928
R1299 VSS.n894 VSS.t174 45.7034
R1300 VSS.n50 VSS.t289 45.7034
R1301 VSS.t3316 VSS.n2 45.7034
R1302 VSS.t320 VSS.n10 45.7034
R1303 VSS.n294 VSS.t372 56.194
R1304 VSS.n206 VSS.t379 58.3202
R1305 VSS.t74 VSS.n112 0.121827
R1306 VSS.t74 VSS.n115 0.121826
R1307 VSS.n96 VSS.t392 26.1061
R1308 VSS.n254 VSS.t401 58.3202
R1309 VSS.n348 VSS.t406 58.3202
R1310 VSS.n18 VSS.t411 26.1051
R1311 VSS.n19 VSS.t416 26.1051
R1312 VSS.t74 VSS.n157 0.121883
R1313 VSS.n347 VSS.t426 58.3202
R1314 VSS.t74 VSS.n110 0.121827
R1315 VSS.n255 VSS.t442 58.3202
R1316 VSS.t74 VSS.n99 0.121819
R1317 VSS.t74 VSS.n100 0.121827
R1318 VSS.n29 VSS.t457 26.1049
R1319 VSS.t464 VSS.n345 58.3202
R1320 VSS.n723 VSS.t332 58.5605
R1321 VSS.t313 VSS.n117 37.0902
R1322 VSS.n836 VSS.t290 42.8576
R1323 VSS.n157 VSS.t424 26.2643
R1324 VSS.n28 VSS.t428 26.1544
R1325 VSS.n193 VSS.t7 1.60795
R1326 VSS.t90 VSS.t216 41.6672
R1327 VSS.n818 VSS.t27 41.4177
R1328 VSS.t3268 VSS.n809 40.8632
R1329 VSS.t76 VSS.n806 40.8632
R1330 VSS.n7 VSS.t261 40.6692
R1331 VSS.t74 VSS.t440 26.4911
R1332 VSS.t74 VSS.t462 26.4908
R1333 VSS.n32 VSS.t478 26.3208
R1334 VSS.n214 VSS.t480 26.3358
R1335 VSS.t223 VSS.n774 38.6824
R1336 VSS.t240 VSS.n776 37.5005
R1337 VSS.n860 VSS.t3308 37.5005
R1338 VSS.n861 VSS.t217 37.5005
R1339 VSS.t220 VSS.n779 37.5005
R1340 VSS.n30 VSS.t246 36.5352
R1341 VSS.n26 VSS.t365 36.5343
R1342 VSS.t15 VSS.n815 34.2862
R1343 VSS.t80 VSS.n871 33.2108
R1344 VSS.n874 VSS.t251 33.2108
R1345 VSS.n840 VSS.t237 30.0005
R1346 VSS.n896 VSS.t256 30.0005
R1347 VSS.n113 VSS.t660 15.0018
R1348 VSS.n823 VSS.t0 30.0005
R1349 VSS.n191 VSS.t361 26.8307
R1350 VSS.t64 VSS.n831 30.0005
R1351 VSS.t352 VSS.n826 30.0005
R1352 VSS.t242 VSS.t3270 30.0005
R1353 VSS.t280 VSS.t106 30.0005
R1354 VSS.t358 VSS.n788 30.0005
R1355 VSS.n197 VSS.t576 12.9737
R1356 VSS.t340 VSS.n810 30.0005
R1357 VSS.t105 VSS.t132 29.5208
R1358 VSS.t249 VSS.n775 29.1672
R1359 VSS.n10 VSS.t213 28.5605
R1360 VSS.n90 VSS.t74 4.37826
R1361 VSS.t74 VSS.n88 4.37804
R1362 VSS.n95 VSS.t345 38.7878
R1363 VSS.t341 VSS.n205 16.2308
R1364 VSS.n351 VSS.t233 38.7809
R1365 VSS.n804 VSS.t73 27.4346
R1366 VSS.n807 VSS.t75 27.4346
R1367 VSS.n87 VSS.t170 38.7878
R1368 VSS.n834 VSS.t128 25.7148
R1369 VSS.t325 VSS.n89 15.2566
R1370 VSS.n78 VSS.t13 24.2748
R1371 VSS.n352 VSS.t368 14.2952
R1372 VSS.t203 VSS.n873 22.1407
R1373 VSS.n209 VSS.t74 3.37712
R1374 VSS.t207 VSS.n215 13.9422
R1375 VSS.n198 VSS.t74 3.37712
R1376 VSS.n210 VSS.t74 3.37712
R1377 VSS.t74 VSS.n199 2.32983
R1378 VSS.n94 VSS.t343 14.8453
R1379 VSS.t572 VSS.n107 10.7159
R1380 VSS.t3315 VSS.n789 21.4291
R1381 VSS.t370 VSS.n25 21.2035
R1382 VSS.n196 VSS.t55 7.95809
R1383 VSS.n351 VSS.t3269 12.8086
R1384 VSS.n95 VSS.t3272 12.7723
R1385 VSS.n87 VSS.t247 12.7723
R1386 VSS.t3283 VSS.n24 18.7838
R1387 VSS.t3306 VSS.n27 18.7828
R1388 VSS.t205 VSS.n31 18.7828
R1389 VSS.t321 VSS.n209 29.5272
R1390 VSS.n199 VSS.t369 14.8762
R1391 VSS.n108 VSS.t363 12.4927
R1392 VSS.t236 VSS.n105 29.5303
R1393 VSS.t250 VSS.n215 29.5272
R1394 VSS.t171 VSS.n198 29.5272
R1395 VSS.t255 VSS.n210 29.5272
R1396 VSS.n809 VSS.t3310 17.4635
R1397 VSS.n806 VSS.t206 17.4635
R1398 VSS.t301 VSS.n827 17.1434
R1399 VSS.t74 VSS.n294 2.5939
R1400 VSS.n382 VSS.n102 5.6463
R1401 VSS.t74 VSS.n94 2.32502
R1402 VSS.t74 VSS.n95 2.99072
R1403 VSS.t74 VSS.n204 12.9579
R1404 VSS.t74 VSS.n89 3.87347
R1405 VSS.t74 VSS.n347 0.405951
R1406 VSS.t74 VSS.n808 17.0005
R1407 VSS.t74 VSS.n352 3.50286
R1408 VSS.t74 VSS.n351 2.99921
R1409 VSS.t74 VSS.n804 17.0005
R1410 VSS.t74 VSS.n807 17.0005
R1411 VSS.t74 VSS.n87 2.99072
R1412 VSS.t74 VSS.n215 3.37712
R1413 VSS.n349 VSS.t74 5.6463
R1414 VSS.t2710 VSS.n353 17.0005
R1415 VSS.n476 VSS.n81 5.6463
R1416 VSS.n82 VSS.n532 5.6463
R1417 VSS.n588 VSS.n83 5.6463
R1418 VSS.t305 VSS.t1322 17.0005
R1419 VSS.n318 VSS.t305 4.17719
R1420 VSS.n333 VSS.t305 5.61485
R1421 VSS.n80 VSS.n678 5.6463
R1422 VSS.t202 VSS.n768 17.0005
R1423 VSS.t202 VSS.n769 17.0005
R1424 VSS.t202 VSS.n772 17.0005
R1425 VSS.t202 VSS.n891 17.0005
R1426 VSS.n890 VSS.t202 17.0005
R1427 VSS.t202 VSS.n766 17.0005
R1428 VSS.t202 VSS.n306 0.649813
R1429 VSS.t202 VSS.n767 17.0005
R1430 VSS.t202 VSS.n287 0.649813
R1431 VSS.t202 VSS.n771 17.0005
R1432 VSS.t202 VSS.n840 17.0005
R1433 VSS.n841 VSS.t202 17.0005
R1434 VSS.n765 VSS.t202 17.0005
R1435 VSS.n79 VSS.t202 13.5637
R1436 VSS.t202 VSS.n180 3.31705
R1437 VSS.t202 VSS.n176 3.31705
R1438 VSS.t202 VSS.n138 3.31704
R1439 VSS.t202 VSS.n156 7.34144
R1440 VSS.t202 VSS.n896 17.0005
R1441 VSS.t202 VSS.n184 10.4539
R1442 VSS.t202 VSS.n761 17.0005
R1443 VSS.t202 VSS.n762 17.0005
R1444 VSS.t202 VSS.n895 17.0005
R1445 VSS.t202 VSS.n763 17.0005
R1446 VSS.t202 VSS.n217 9.30764
R1447 VSS.t202 VSS.n303 0.649813
R1448 VSS.t202 VSS.n764 17.0005
R1449 VSS.t202 VSS.n893 17.0005
R1450 VSS.n892 VSS.t202 17.0005
R1451 VSS.n305 VSS.t202 0.649813
R1452 VSS.t202 VSS.n838 17.0005
R1453 VSS.t202 VSS.n826 17.0005
R1454 VSS.t202 VSS.n837 17.0005
R1455 VSS.t202 VSS.n827 17.0005
R1456 VSS.t202 VSS.n836 17.0005
R1457 VSS.t202 VSS.n828 17.0005
R1458 VSS.t202 VSS.n829 17.0005
R1459 VSS.t202 VSS.n835 17.0005
R1460 VSS.t202 VSS.t286 17.0005
R1461 VSS.t202 VSS.n834 17.0005
R1462 VSS.t202 VSS.n830 17.0005
R1463 VSS.t202 VSS.n833 17.0005
R1464 VSS.n832 VSS.t202 17.0005
R1465 VSS.n831 VSS.t202 17.0005
R1466 VSS.n192 VSS.t202 9.63482
R1467 VSS.t202 VSS.n824 17.0005
R1468 VSS.t202 VSS.n825 17.0005
R1469 VSS.t202 VSS.n101 3.40169
R1470 VSS.t202 VSS.n300 0.649813
R1471 VSS.t202 VSS.n821 17.0005
R1472 VSS.t202 VSS.n823 17.0005
R1473 VSS.t202 VSS.n822 17.0005
R1474 VSS.t202 VSS.n276 0.649813
R1475 VSS.t202 VSS.n820 17.0005
R1476 VSS.t202 VSS.n301 0.649813
R1477 VSS.t202 VSS.n819 17.0005
R1478 VSS.t202 VSS.n201 0.649813
R1479 VSS.t202 VSS.n816 17.0005
R1480 VSS.n302 VSS.t202 0.649813
R1481 VSS.n817 VSS.t202 17.0005
R1482 VSS.n842 VSS.t202 17.0005
R1483 VSS.t202 VSS.n843 17.0005
R1484 VSS.t202 VSS.n815 17.0005
R1485 VSS.t202 VSS.n119 9.63482
R1486 VSS.t202 VSS.n120 9.63482
R1487 VSS.t202 VSS.n814 17.0005
R1488 VSS.t202 VSS.n723 0.649813
R1489 VSS.t202 VSS.n813 17.0005
R1490 VSS.n114 VSS.t202 7.66905
R1491 VSS.t7 VSS.n774 17.0005
R1492 VSS.t7 VSS.n868 17.0005
R1493 VSS.t7 VSS.n775 17.0005
R1494 VSS.t7 VSS.n867 17.0005
R1495 VSS.t7 VSS.n776 17.0005
R1496 VSS.t7 VSS.n866 17.0005
R1497 VSS.t7 VSS.n777 17.0005
R1498 VSS.t7 VSS.n865 17.0005
R1499 VSS.t68 VSS.n735 0.120486
R1500 VSS.t7 VSS.n870 17.0005
R1501 VSS.t7 VSS.n874 17.0005
R1502 VSS.t7 VSS.n871 17.0005
R1503 VSS.t7 VSS.n106 3.31704
R1504 VSS.t7 VSS.n179 3.31705
R1505 VSS.n879 VSS.t7 17.0005
R1506 VSS.n881 VSS.t7 17.0005
R1507 VSS.n882 VSS.t7 17.0005
R1508 VSS.n884 VSS.t7 17.0005
R1509 VSS.n885 VSS.t7 17.0005
R1510 VSS.n875 VSS.t7 17.0005
R1511 VSS.n778 VSS.t7 17.0005
R1512 VSS.n864 VSS.t7 17.0005
R1513 VSS.t7 VSS.n863 17.0005
R1514 VSS.t7 VSS.n779 17.0005
R1515 VSS.t7 VSS.n862 17.0005
R1516 VSS.t7 VSS.n780 17.0005
R1517 VSS.t7 VSS.n861 17.0005
R1518 VSS.t7 VSS.n781 17.0005
R1519 VSS.t7 VSS.n860 17.0005
R1520 VSS.t7 VSS.n782 17.0005
R1521 VSS.t7 VSS.n859 17.0005
R1522 VSS.t7 VSS.n783 17.0005
R1523 VSS.t7 VSS.n858 17.0005
R1524 VSS.t7 VSS.n857 17.0005
R1525 VSS.t7 VSS.n784 17.0005
R1526 VSS.t7 VSS.n856 17.0005
R1527 VSS.t7 VSS.n785 17.0005
R1528 VSS.t7 VSS.n855 17.0005
R1529 VSS.t7 VSS.n786 17.0005
R1530 VSS.t7 VSS.n854 17.0005
R1531 VSS.t7 VSS.n787 17.0005
R1532 VSS.t7 VSS.n853 17.0005
R1533 VSS.t7 VSS.n788 17.0005
R1534 VSS.t7 VSS.n852 17.0005
R1535 VSS.t7 VSS.n789 17.0005
R1536 VSS.t7 VSS.n851 17.0005
R1537 VSS.t7 VSS.n790 17.0005
R1538 VSS.t7 VSS.n850 17.0005
R1539 VSS.t7 VSS.n791 17.0005
R1540 VSS.t7 VSS.n849 17.0005
R1541 VSS.t7 VSS.n792 17.0005
R1542 VSS.t7 VSS.n848 17.0005
R1543 VSS.t7 VSS.n793 17.0005
R1544 VSS.t7 VSS.n847 17.0005
R1545 VSS.t7 VSS.n846 17.0005
R1546 VSS.n194 VSS.t7 12.2558
R1547 VSS.t7 VSS.n794 17.0005
R1548 VSS.t7 VSS.n795 17.0005
R1549 VSS.t7 VSS.n800 17.0005
R1550 VSS.t7 VSS.n796 17.0005
R1551 VSS.t7 VSS.n799 17.0005
R1552 VSS.t7 VSS.n797 17.0005
R1553 VSS.t7 VSS.n798 17.0005
R1554 VSS.t7 VSS.n812 17.0005
R1555 VSS.t7 VSS.n810 17.0005
R1556 VSS.t7 VSS.n811 17.0005
R1557 VSS.t371 VSS.n803 16.6566
R1558 VSS.t329 VSS.n801 15.8498
R1559 VSS.t142 VSS.t221 12.8945
R1560 VSS.t3299 VSS.n884 12.8576
R1561 VSS.t94 VSS.n793 12.8576
R1562 VSS.n801 VSS.t346 12.6222
R1563 VSS.t218 VSS.n780 12.5005
R1564 VSS.n862 VSS.t219 12.5005
R1565 VSS.n803 VSS.t3311 11.8153
R1566 VSS.t200 VSS.n887 10.4172
R1567 VSS.n814 VSS.t330 8.57193
R1568 VSS.n837 VSS.t324 8.57193
R1569 VSS.t95 VSS.n787 8.57193
R1570 VSS.t305 VSS.t306 8.50663
R1571 VSS.n102 VSS.t3267 8.50199
R1572 VSS.t2597 VSS.n81 8.50198
R1573 VSS.t2205 VSS.n82 8.50198
R1574 VSS.n83 VSS.t1813 8.50198
R1575 VSS.t1126 VSS.n80 8.50198
R1576 VSS.n409 VSS.t3264 0.130189
R1577 VSS.t3262 VSS.n102 8.501
R1578 VSS.n408 VSS.t3259 0.130189
R1579 VSS.t3257 VSS.n102 8.501
R1580 VSS.n407 VSS.t3254 0.130189
R1581 VSS.t3252 VSS.n102 8.501
R1582 VSS.n406 VSS.t3249 0.130189
R1583 VSS.t3247 VSS.n102 8.501
R1584 VSS.n405 VSS.t3244 0.130189
R1585 VSS.t3242 VSS.n102 8.501
R1586 VSS.t3239 VSS.n404 0.130189
R1587 VSS.t3237 VSS.n102 8.501
R1588 VSS.t3234 VSS.n403 0.130189
R1589 VSS.t3232 VSS.n102 8.501
R1590 VSS.t3229 VSS.n402 0.130189
R1591 VSS.t3227 VSS.n102 8.501
R1592 VSS.t3224 VSS.n401 0.130189
R1593 VSS.t3222 VSS.n102 8.501
R1594 VSS.t3219 VSS.n400 0.130189
R1595 VSS.t3217 VSS.n102 8.501
R1596 VSS.t3214 VSS.n399 0.130189
R1597 VSS.t3212 VSS.n102 8.501
R1598 VSS.t3209 VSS.n398 0.130189
R1599 VSS.t3207 VSS.n102 8.501
R1600 VSS.t3204 VSS.n397 0.130189
R1601 VSS.t3202 VSS.n102 8.501
R1602 VSS.t3199 VSS.n396 0.130189
R1603 VSS.t3197 VSS.n102 8.501
R1604 VSS.t3194 VSS.n395 0.130189
R1605 VSS.t3192 VSS.n102 8.501
R1606 VSS.t3189 VSS.n394 0.130189
R1607 VSS.t3187 VSS.n102 8.501
R1608 VSS.t3184 VSS.n393 0.130189
R1609 VSS.t3182 VSS.n102 8.501
R1610 VSS.t3179 VSS.n392 0.130189
R1611 VSS.t3177 VSS.n102 8.501
R1612 VSS.t3174 VSS.n391 0.130189
R1613 VSS.t3172 VSS.n102 8.501
R1614 VSS.t3169 VSS.n390 0.130189
R1615 VSS.t3167 VSS.n102 8.501
R1616 VSS.t3164 VSS.n389 0.130189
R1617 VSS.t3162 VSS.n102 8.501
R1618 VSS.t3159 VSS.n388 0.130189
R1619 VSS.t3157 VSS.n102 8.501
R1620 VSS.t3154 VSS.n387 0.130189
R1621 VSS.t3152 VSS.n102 8.501
R1622 VSS.t3149 VSS.n386 0.130189
R1623 VSS.t3147 VSS.n102 8.501
R1624 VSS.t3144 VSS.n385 0.130189
R1625 VSS.t3142 VSS.n102 8.501
R1626 VSS.t3139 VSS.n384 0.130189
R1627 VSS.t3137 VSS.n102 8.501
R1628 VSS.n383 VSS.t3134 0.130189
R1629 VSS.t3132 VSS.n350 0.0836055
R1630 VSS.t3129 VSS.n382 0.0333775
R1631 VSS.t3127 VSS.n102 8.501
R1632 VSS.t3124 VSS.n381 0.130189
R1633 VSS.t3122 VSS.n102 8.501
R1634 VSS.t3119 VSS.n380 0.130189
R1635 VSS.t3117 VSS.n102 8.501
R1636 VSS.t3114 VSS.n379 0.130189
R1637 VSS.t3112 VSS.n102 8.501
R1638 VSS.t3109 VSS.n378 0.130189
R1639 VSS.t3107 VSS.n102 8.501
R1640 VSS.t3104 VSS.n377 0.130189
R1641 VSS.t3102 VSS.n102 8.501
R1642 VSS.t3099 VSS.n376 0.130189
R1643 VSS.t3097 VSS.n102 8.501
R1644 VSS.t3094 VSS.n375 0.130189
R1645 VSS.t3092 VSS.n102 8.501
R1646 VSS.t3089 VSS.n374 0.130189
R1647 VSS.t3087 VSS.n102 8.501
R1648 VSS.t3084 VSS.n373 0.130189
R1649 VSS.t3082 VSS.n102 8.501
R1650 VSS.t3079 VSS.n372 0.130189
R1651 VSS.t3077 VSS.n102 8.501
R1652 VSS.t3074 VSS.n371 0.130189
R1653 VSS.t3072 VSS.n102 8.501
R1654 VSS.t3069 VSS.n370 0.130189
R1655 VSS.t3067 VSS.n102 8.501
R1656 VSS.t3064 VSS.n369 0.130189
R1657 VSS.t3062 VSS.n102 8.501
R1658 VSS.t3059 VSS.n368 0.130189
R1659 VSS.t3057 VSS.n102 8.501
R1660 VSS.t3054 VSS.n367 0.130189
R1661 VSS.t3052 VSS.n102 8.501
R1662 VSS.t3049 VSS.n366 0.130189
R1663 VSS.t3047 VSS.n102 8.501
R1664 VSS.t3044 VSS.n365 0.130189
R1665 VSS.t3042 VSS.n102 8.501
R1666 VSS.t3039 VSS.n364 0.130189
R1667 VSS.t3037 VSS.n102 8.501
R1668 VSS.t3034 VSS.n363 0.130189
R1669 VSS.t3032 VSS.n102 8.501
R1670 VSS.t3029 VSS.n362 0.130189
R1671 VSS.t3027 VSS.n102 8.501
R1672 VSS.n361 VSS.t3024 0.130189
R1673 VSS.t3022 VSS.n102 8.501
R1674 VSS.n360 VSS.t3019 0.130189
R1675 VSS.t3014 VSS.n359 0.215686
R1676 VSS.t3012 VSS.n102 8.501
R1677 VSS.n358 VSS.t3009 0.130189
R1678 VSS.t3007 VSS.n102 8.501
R1679 VSS.n357 VSS.t3004 0.130189
R1680 VSS.t3002 VSS.n102 8.501
R1681 VSS.n356 VSS.t2999 0.130189
R1682 VSS.t2997 VSS.n102 8.501
R1683 VSS.n355 VSS.t2994 0.130189
R1684 VSS.t2992 VSS.n102 8.501
R1685 VSS.n102 VSS.n354 3.33079
R1686 VSS.t373 VSS.t74 8.501
R1687 VSS.t74 VSS.n746 3.32876
R1688 VSS.n296 VSS.t74 1.22568
R1689 VSS.t74 VSS.n744 3.32876
R1690 VSS.t384 VSS.t74 8.501
R1691 VSS.t74 VSS.n295 2.34915
R1692 VSS.t387 VSS.n295 0.156071
R1693 VSS.t74 VSS.n745 3.32876
R1694 VSS.n349 VSS.t393 0.0333775
R1695 VSS.t344 VSS.n410 0.928064
R1696 VSS.n411 VSS.t74 3.32876
R1697 VSS.t339 VSS.n208 0.516021
R1698 VSS.n208 VSS.t74 1.10099
R1699 VSS.n412 VSS.t74 3.32876
R1700 VSS.t412 VSS.t74 8.501
R1701 VSS.n413 VSS.t74 3.32876
R1702 VSS.t417 VSS.t74 8.501
R1703 VSS.n414 VSS.t74 3.32876
R1704 VSS.t422 VSS.t74 8.501
R1705 VSS.n415 VSS.t74 3.32876
R1706 VSS.t326 VSS.n416 0.933479
R1707 VSS.n417 VSS.t74 3.32876
R1708 VSS.t431 VSS.t74 8.501
R1709 VSS.n418 VSS.t74 3.32876
R1710 VSS.t436 VSS.t74 8.501
R1711 VSS.n419 VSS.t74 3.32876
R1712 VSS.t441 VSS.n346 0.431625
R1713 VSS.t443 VSS.n420 0.708622
R1714 VSS.n421 VSS.t74 3.32876
R1715 VSS.n203 VSS.t74 5.6463
R1716 VSS.n422 VSS.t74 4.20253
R1717 VSS.t74 VSS.t453 8.501
R1718 VSS.n423 VSS.t74 3.32876
R1719 VSS.t458 VSS.t74 8.501
R1720 VSS.n424 VSS.t74 3.32876
R1721 VSS.t463 VSS.n274 0.369422
R1722 VSS.t74 VSS.n274 1.544
R1723 VSS.n425 VSS.t74 3.32876
R1724 VSS.t74 VSS.t469 8.501
R1725 VSS.n426 VSS.t74 3.32876
R1726 VSS.t474 VSS.t74 8.501
R1727 VSS.n427 VSS.t74 3.32876
R1728 VSS.t479 VSS.t74 8.501
R1729 VSS.n428 VSS.t74 0.446866
R1730 VSS.n446 VSS.t2710 4.20253
R1731 VSS.n503 VSS.t2594 0.130189
R1732 VSS.t2592 VSS.n81 8.501
R1733 VSS.n502 VSS.t2589 0.130189
R1734 VSS.t2587 VSS.n81 8.501
R1735 VSS.n501 VSS.t2584 0.130189
R1736 VSS.t2582 VSS.n81 8.501
R1737 VSS.n500 VSS.t2579 0.130189
R1738 VSS.t2577 VSS.n81 8.501
R1739 VSS.n499 VSS.t2574 0.130189
R1740 VSS.t2572 VSS.n81 8.501
R1741 VSS.n498 VSS.t2569 0.130189
R1742 VSS.t2567 VSS.n81 8.501
R1743 VSS.n497 VSS.t2564 0.130189
R1744 VSS.t2562 VSS.n81 8.501
R1745 VSS.n496 VSS.t2559 0.130189
R1746 VSS.t2557 VSS.n81 8.501
R1747 VSS.n495 VSS.t2554 0.130189
R1748 VSS.t2552 VSS.n81 8.501
R1749 VSS.n494 VSS.t2549 0.130189
R1750 VSS.t2547 VSS.n81 8.501
R1751 VSS.n493 VSS.t2544 0.130189
R1752 VSS.t2542 VSS.n81 8.501
R1753 VSS.n492 VSS.t2539 0.130189
R1754 VSS.t2537 VSS.n81 8.501
R1755 VSS.n491 VSS.t2534 0.130189
R1756 VSS.t2532 VSS.n81 8.501
R1757 VSS.n490 VSS.t2529 0.130189
R1758 VSS.t2527 VSS.n81 8.501
R1759 VSS.n489 VSS.t2524 0.130189
R1760 VSS.t2522 VSS.n81 8.501
R1761 VSS.n488 VSS.t2519 0.130189
R1762 VSS.t2517 VSS.n81 8.501
R1763 VSS.n487 VSS.t2514 0.130189
R1764 VSS.t2512 VSS.n81 8.501
R1765 VSS.n486 VSS.t2509 0.130189
R1766 VSS.t2507 VSS.n81 8.501
R1767 VSS.n485 VSS.t2504 0.130189
R1768 VSS.t2502 VSS.n81 8.501
R1769 VSS.n484 VSS.t2499 0.130189
R1770 VSS.t2497 VSS.n81 8.501
R1771 VSS.n483 VSS.t2494 0.130189
R1772 VSS.t2492 VSS.n81 8.501
R1773 VSS.n482 VSS.t2489 0.130189
R1774 VSS.t2487 VSS.n81 8.501
R1775 VSS.n481 VSS.t2484 0.130189
R1776 VSS.t2482 VSS.n81 8.501
R1777 VSS.n480 VSS.t2479 0.130189
R1778 VSS.t2477 VSS.n81 8.501
R1779 VSS.n479 VSS.t2474 0.130189
R1780 VSS.t2472 VSS.n81 8.501
R1781 VSS.n478 VSS.t2469 0.130189
R1782 VSS.t2467 VSS.n81 8.501
R1783 VSS.n477 VSS.t2464 0.130189
R1784 VSS.n476 VSS.t2459 0.0333775
R1785 VSS.n81 VSS.t2457 8.501
R1786 VSS.t2454 VSS.n475 0.130189
R1787 VSS.t2452 VSS.n81 8.501
R1788 VSS.t2449 VSS.n474 0.130189
R1789 VSS.t2447 VSS.n81 8.501
R1790 VSS.t2444 VSS.n473 0.130189
R1791 VSS.t2442 VSS.n81 8.501
R1792 VSS.t2439 VSS.n472 0.130189
R1793 VSS.t2437 VSS.n81 8.501
R1794 VSS.t2434 VSS.n471 0.130189
R1795 VSS.t2432 VSS.n81 8.501
R1796 VSS.t2429 VSS.n470 0.130189
R1797 VSS.t2427 VSS.n81 8.501
R1798 VSS.t2424 VSS.n469 0.130189
R1799 VSS.t2422 VSS.n81 8.501
R1800 VSS.t2419 VSS.n468 0.130189
R1801 VSS.t2417 VSS.n81 8.501
R1802 VSS.t2414 VSS.n467 0.130189
R1803 VSS.t2412 VSS.n81 8.501
R1804 VSS.t2409 VSS.n466 0.130189
R1805 VSS.t2407 VSS.n81 8.501
R1806 VSS.t2404 VSS.n465 0.130189
R1807 VSS.t2402 VSS.n81 8.501
R1808 VSS.t2399 VSS.n464 0.130189
R1809 VSS.t2397 VSS.n81 8.501
R1810 VSS.t2394 VSS.n463 0.130189
R1811 VSS.t2392 VSS.n81 8.501
R1812 VSS.t2389 VSS.n462 0.130189
R1813 VSS.t2387 VSS.n81 8.501
R1814 VSS.t2384 VSS.n461 0.130189
R1815 VSS.t2382 VSS.n81 8.501
R1816 VSS.t2379 VSS.n460 0.130189
R1817 VSS.t2377 VSS.n81 8.501
R1818 VSS.t2374 VSS.n459 0.130189
R1819 VSS.t2372 VSS.n81 8.501
R1820 VSS.t2369 VSS.n458 0.130189
R1821 VSS.t2367 VSS.n81 8.501
R1822 VSS.t2364 VSS.n457 0.130189
R1823 VSS.t2362 VSS.n81 8.501
R1824 VSS.t2359 VSS.n456 0.130189
R1825 VSS.t2357 VSS.n81 8.501
R1826 VSS.t2354 VSS.n455 0.130189
R1827 VSS.t2352 VSS.n81 8.501
R1828 VSS.t2349 VSS.n454 0.130189
R1829 VSS.t2347 VSS.n81 8.501
R1830 VSS.t2344 VSS.n453 0.130189
R1831 VSS.t2342 VSS.n81 8.501
R1832 VSS.t2339 VSS.n452 0.130189
R1833 VSS.t2337 VSS.n81 8.501
R1834 VSS.t2334 VSS.n451 0.130189
R1835 VSS.t2332 VSS.n81 8.501
R1836 VSS.t2329 VSS.n450 0.130189
R1837 VSS.t2327 VSS.n81 8.501
R1838 VSS.t2324 VSS.n449 0.130189
R1839 VSS.t2322 VSS.n81 8.501
R1840 VSS.n448 VSS.n81 3.33079
R1841 VSS.n559 VSS.t2202 0.130189
R1842 VSS.t2200 VSS.n82 8.501
R1843 VSS.n558 VSS.t2197 0.130189
R1844 VSS.t2195 VSS.n82 8.501
R1845 VSS.n557 VSS.t2192 0.130189
R1846 VSS.t2190 VSS.n82 8.501
R1847 VSS.n556 VSS.t2187 0.130189
R1848 VSS.t2185 VSS.n82 8.501
R1849 VSS.n555 VSS.t2182 0.130189
R1850 VSS.t2180 VSS.n82 8.501
R1851 VSS.n554 VSS.t2177 0.130189
R1852 VSS.t2175 VSS.n82 8.501
R1853 VSS.n553 VSS.t2172 0.130189
R1854 VSS.t2170 VSS.n82 8.501
R1855 VSS.n552 VSS.t2167 0.130189
R1856 VSS.t2165 VSS.n82 8.501
R1857 VSS.n551 VSS.t2162 0.130189
R1858 VSS.t2160 VSS.n82 8.501
R1859 VSS.n550 VSS.t2157 0.130189
R1860 VSS.t2155 VSS.n82 8.501
R1861 VSS.n549 VSS.t2152 0.130189
R1862 VSS.t2150 VSS.n82 8.501
R1863 VSS.n548 VSS.t2147 0.130189
R1864 VSS.t2145 VSS.n82 8.501
R1865 VSS.n547 VSS.t2142 0.130189
R1866 VSS.t2140 VSS.n82 8.501
R1867 VSS.n546 VSS.t2137 0.130189
R1868 VSS.t2135 VSS.n82 8.501
R1869 VSS.n545 VSS.t2132 0.130189
R1870 VSS.t2130 VSS.n82 8.501
R1871 VSS.n544 VSS.t2127 0.130189
R1872 VSS.t2125 VSS.n82 8.501
R1873 VSS.n543 VSS.t2122 0.130189
R1874 VSS.t2120 VSS.n82 8.501
R1875 VSS.n542 VSS.t2117 0.130189
R1876 VSS.t2115 VSS.n82 8.501
R1877 VSS.n541 VSS.t2112 0.130189
R1878 VSS.t2110 VSS.n82 8.501
R1879 VSS.n540 VSS.t2107 0.130189
R1880 VSS.t2105 VSS.n82 8.501
R1881 VSS.n539 VSS.t2102 0.130189
R1882 VSS.t2100 VSS.n82 8.501
R1883 VSS.n538 VSS.t2097 0.130189
R1884 VSS.t2095 VSS.n82 8.501
R1885 VSS.n537 VSS.t2092 0.130189
R1886 VSS.t2090 VSS.n82 8.501
R1887 VSS.n536 VSS.t2087 0.130189
R1888 VSS.t2085 VSS.n82 8.501
R1889 VSS.n535 VSS.t2082 0.130189
R1890 VSS.t2080 VSS.n82 8.501
R1891 VSS.n534 VSS.t2077 0.130189
R1892 VSS.t2075 VSS.n82 8.501
R1893 VSS.n533 VSS.t2072 0.130189
R1894 VSS.n532 VSS.t2067 0.0333775
R1895 VSS.t2065 VSS.n82 8.501
R1896 VSS.n531 VSS.t2062 0.130189
R1897 VSS.t2060 VSS.n82 8.501
R1898 VSS.n530 VSS.t2057 0.130189
R1899 VSS.t2055 VSS.n82 8.501
R1900 VSS.n529 VSS.t2052 0.130189
R1901 VSS.t2050 VSS.n82 8.501
R1902 VSS.n528 VSS.t2047 0.130189
R1903 VSS.t2045 VSS.n82 8.501
R1904 VSS.n527 VSS.t2042 0.130189
R1905 VSS.t2040 VSS.n82 8.501
R1906 VSS.n526 VSS.t2037 0.130189
R1907 VSS.t2035 VSS.n82 8.501
R1908 VSS.n525 VSS.t2032 0.130189
R1909 VSS.t2030 VSS.n82 8.501
R1910 VSS.n524 VSS.t2027 0.130189
R1911 VSS.t2025 VSS.n82 8.501
R1912 VSS.n523 VSS.t2022 0.130189
R1913 VSS.t2020 VSS.n82 8.501
R1914 VSS.n522 VSS.t2017 0.130189
R1915 VSS.t2015 VSS.n82 8.501
R1916 VSS.n521 VSS.t2012 0.130189
R1917 VSS.t2010 VSS.n82 8.501
R1918 VSS.n520 VSS.t2007 0.130189
R1919 VSS.t2005 VSS.n82 8.501
R1920 VSS.n519 VSS.t2002 0.130189
R1921 VSS.t2000 VSS.n82 8.501
R1922 VSS.n518 VSS.t1997 0.130189
R1923 VSS.t1995 VSS.n82 8.501
R1924 VSS.n517 VSS.t1992 0.130189
R1925 VSS.t1990 VSS.n82 8.501
R1926 VSS.n516 VSS.t1987 0.130189
R1927 VSS.t1985 VSS.n82 8.501
R1928 VSS.n515 VSS.t1982 0.130189
R1929 VSS.t1980 VSS.n82 8.501
R1930 VSS.n514 VSS.t1977 0.130189
R1931 VSS.t1975 VSS.n82 8.501
R1932 VSS.n513 VSS.t1972 0.130189
R1933 VSS.t1970 VSS.n82 8.501
R1934 VSS.n512 VSS.t1967 0.130189
R1935 VSS.t1965 VSS.n82 8.501
R1936 VSS.n511 VSS.t1962 0.130189
R1937 VSS.t1960 VSS.n82 8.501
R1938 VSS.n510 VSS.t1957 0.130189
R1939 VSS.t1955 VSS.n82 8.501
R1940 VSS.t1952 VSS.n509 0.130189
R1941 VSS.t1950 VSS.n82 8.501
R1942 VSS.n508 VSS.t1947 0.130189
R1943 VSS.t1945 VSS.n82 8.501
R1944 VSS.n507 VSS.t1942 0.130189
R1945 VSS.t1940 VSS.n82 8.501
R1946 VSS.n506 VSS.t1937 0.130189
R1947 VSS.t1935 VSS.n82 8.501
R1948 VSS.n505 VSS.t1932 0.130189
R1949 VSS.t1930 VSS.n82 8.501
R1950 VSS.n82 VSS.n504 3.33079
R1951 VSS.n615 VSS.t1810 0.130189
R1952 VSS.t1808 VSS.n83 8.501
R1953 VSS.n614 VSS.t1805 0.130189
R1954 VSS.t1803 VSS.n83 8.501
R1955 VSS.n613 VSS.t1800 0.130189
R1956 VSS.t1798 VSS.n83 8.501
R1957 VSS.n612 VSS.t1795 0.130189
R1958 VSS.t1793 VSS.n83 8.501
R1959 VSS.n611 VSS.t1790 0.130189
R1960 VSS.t1788 VSS.n83 8.501
R1961 VSS.t1785 VSS.n610 0.130189
R1962 VSS.t1783 VSS.n83 8.501
R1963 VSS.t1780 VSS.n609 0.130189
R1964 VSS.t1778 VSS.n83 8.501
R1965 VSS.t1775 VSS.n608 0.130189
R1966 VSS.t1773 VSS.n83 8.501
R1967 VSS.t1770 VSS.n607 0.130189
R1968 VSS.t1768 VSS.n83 8.501
R1969 VSS.t1765 VSS.n606 0.130189
R1970 VSS.t1763 VSS.n83 8.501
R1971 VSS.t1760 VSS.n605 0.130189
R1972 VSS.t1758 VSS.n83 8.501
R1973 VSS.t1755 VSS.n604 0.130189
R1974 VSS.t1753 VSS.n83 8.501
R1975 VSS.t1750 VSS.n603 0.130189
R1976 VSS.t1748 VSS.n83 8.501
R1977 VSS.t1745 VSS.n602 0.130189
R1978 VSS.t1743 VSS.n83 8.501
R1979 VSS.t1740 VSS.n601 0.130189
R1980 VSS.t1738 VSS.n83 8.501
R1981 VSS.t1735 VSS.n600 0.130189
R1982 VSS.t1733 VSS.n83 8.501
R1983 VSS.t1730 VSS.n599 0.130189
R1984 VSS.t1728 VSS.n83 8.501
R1985 VSS.t1725 VSS.n598 0.130189
R1986 VSS.t1723 VSS.n83 8.501
R1987 VSS.t1720 VSS.n597 0.130189
R1988 VSS.t1718 VSS.n83 8.501
R1989 VSS.t1715 VSS.n596 0.130189
R1990 VSS.t1713 VSS.n83 8.501
R1991 VSS.t1710 VSS.n595 0.130189
R1992 VSS.t1708 VSS.n83 8.501
R1993 VSS.t1705 VSS.n594 0.130189
R1994 VSS.t1703 VSS.n83 8.501
R1995 VSS.t1700 VSS.n593 0.130189
R1996 VSS.t1698 VSS.n83 8.501
R1997 VSS.t1695 VSS.n592 0.130189
R1998 VSS.t1693 VSS.n83 8.501
R1999 VSS.t1690 VSS.n591 0.130189
R2000 VSS.t1688 VSS.n83 8.501
R2001 VSS.t1685 VSS.n590 0.130189
R2002 VSS.t1683 VSS.n83 8.501
R2003 VSS.t1680 VSS.n589 0.130189
R2004 VSS.n588 VSS.t1675 0.0333775
R2005 VSS.t1673 VSS.n83 8.501
R2006 VSS.n587 VSS.t1670 0.130189
R2007 VSS.t1668 VSS.n83 8.501
R2008 VSS.n586 VSS.t1665 0.130189
R2009 VSS.t1663 VSS.n83 8.501
R2010 VSS.n585 VSS.t1660 0.130189
R2011 VSS.t1658 VSS.n83 8.501
R2012 VSS.n584 VSS.t1655 0.130189
R2013 VSS.t1653 VSS.n83 8.501
R2014 VSS.n583 VSS.t1650 0.130189
R2015 VSS.t1648 VSS.n83 8.501
R2016 VSS.n582 VSS.t1645 0.130189
R2017 VSS.t1643 VSS.n83 8.501
R2018 VSS.n581 VSS.t1640 0.130189
R2019 VSS.t1638 VSS.n83 8.501
R2020 VSS.n580 VSS.t1635 0.130189
R2021 VSS.t1633 VSS.n83 8.501
R2022 VSS.n579 VSS.t1630 0.130189
R2023 VSS.t1628 VSS.n83 8.501
R2024 VSS.n578 VSS.t1625 0.130189
R2025 VSS.t1623 VSS.n83 8.501
R2026 VSS.n577 VSS.t1620 0.130189
R2027 VSS.t1618 VSS.n83 8.501
R2028 VSS.n576 VSS.t1615 0.130189
R2029 VSS.t1613 VSS.n83 8.501
R2030 VSS.n575 VSS.t1610 0.130189
R2031 VSS.t1608 VSS.n83 8.501
R2032 VSS.n574 VSS.t1605 0.130189
R2033 VSS.t1603 VSS.n83 8.501
R2034 VSS.n573 VSS.t1600 0.130189
R2035 VSS.t1598 VSS.n83 8.501
R2036 VSS.n572 VSS.t1595 0.130189
R2037 VSS.t1593 VSS.n83 8.501
R2038 VSS.n571 VSS.t1590 0.130189
R2039 VSS.t1588 VSS.n83 8.501
R2040 VSS.n570 VSS.t1585 0.130189
R2041 VSS.t1583 VSS.n83 8.501
R2042 VSS.n569 VSS.t1580 0.130189
R2043 VSS.t1578 VSS.n83 8.501
R2044 VSS.n568 VSS.t1575 0.130189
R2045 VSS.t1573 VSS.n83 8.501
R2046 VSS.n567 VSS.t1570 0.130189
R2047 VSS.t1568 VSS.n83 8.501
R2048 VSS.n566 VSS.t1565 0.130189
R2049 VSS.t1563 VSS.n83 8.501
R2050 VSS.n565 VSS.t1560 0.130189
R2051 VSS.t1558 VSS.n83 8.501
R2052 VSS.n564 VSS.t1555 0.130189
R2053 VSS.t1553 VSS.n83 8.501
R2054 VSS.n563 VSS.t1550 0.130189
R2055 VSS.t1548 VSS.n83 8.501
R2056 VSS.n562 VSS.t1545 0.130189
R2057 VSS.t1543 VSS.n83 8.501
R2058 VSS.n561 VSS.t1540 0.130189
R2059 VSS.t1538 VSS.n83 8.501
R2060 VSS.n83 VSS.n560 3.33079
R2061 VSS.t1401 VSS.t305 8.501
R2062 VSS.n705 VSS.t1123 0.130189
R2063 VSS.t1121 VSS.n80 8.501
R2064 VSS.n704 VSS.t1118 0.130189
R2065 VSS.t1116 VSS.n80 8.501
R2066 VSS.n703 VSS.t1113 0.130189
R2067 VSS.t1111 VSS.n80 8.501
R2068 VSS.n702 VSS.t1108 0.130189
R2069 VSS.t1106 VSS.n80 8.501
R2070 VSS.n701 VSS.t1103 0.130189
R2071 VSS.t1101 VSS.n80 8.501
R2072 VSS.n700 VSS.t1098 0.130189
R2073 VSS.t1096 VSS.n80 8.501
R2074 VSS.n699 VSS.t1093 0.130189
R2075 VSS.t1091 VSS.n80 8.501
R2076 VSS.n698 VSS.t1088 0.130189
R2077 VSS.t1086 VSS.n80 8.501
R2078 VSS.n697 VSS.t1083 0.130189
R2079 VSS.t1081 VSS.n80 8.501
R2080 VSS.n696 VSS.t1078 0.130189
R2081 VSS.t1076 VSS.n80 8.501
R2082 VSS.n695 VSS.t1073 0.130189
R2083 VSS.t1071 VSS.n80 8.501
R2084 VSS.n694 VSS.t1068 0.130189
R2085 VSS.t1066 VSS.n80 8.501
R2086 VSS.n693 VSS.t1063 0.130189
R2087 VSS.t1061 VSS.n80 8.501
R2088 VSS.n692 VSS.t1058 0.130189
R2089 VSS.t1056 VSS.n80 8.501
R2090 VSS.n691 VSS.t1053 0.130189
R2091 VSS.t1051 VSS.n80 8.501
R2092 VSS.n690 VSS.t1048 0.130189
R2093 VSS.t1046 VSS.n80 8.501
R2094 VSS.n689 VSS.t1043 0.130189
R2095 VSS.t1041 VSS.n80 8.501
R2096 VSS.n688 VSS.t1038 0.130189
R2097 VSS.t1036 VSS.n80 8.501
R2098 VSS.n687 VSS.t1033 0.130189
R2099 VSS.t1031 VSS.n80 8.501
R2100 VSS.n686 VSS.t1028 0.130189
R2101 VSS.t1026 VSS.n80 8.501
R2102 VSS.n685 VSS.t1023 0.130189
R2103 VSS.t1021 VSS.n80 8.501
R2104 VSS.n684 VSS.t1018 0.130189
R2105 VSS.t1016 VSS.n80 8.501
R2106 VSS.n683 VSS.t1013 0.130189
R2107 VSS.t1011 VSS.n80 8.501
R2108 VSS.n682 VSS.t1008 0.130189
R2109 VSS.t1006 VSS.n80 8.501
R2110 VSS.n681 VSS.t1003 0.130189
R2111 VSS.t1001 VSS.n80 8.501
R2112 VSS.n680 VSS.t998 0.130189
R2113 VSS.t996 VSS.n80 8.501
R2114 VSS.n679 VSS.t993 0.130189
R2115 VSS.n678 VSS.t988 0.0333775
R2116 VSS.t986 VSS.n80 8.501
R2117 VSS.n677 VSS.t983 0.130189
R2118 VSS.t981 VSS.n80 8.501
R2119 VSS.n676 VSS.t978 0.130189
R2120 VSS.t976 VSS.n80 8.501
R2121 VSS.n675 VSS.t973 0.130189
R2122 VSS.t971 VSS.n80 8.501
R2123 VSS.n674 VSS.t968 0.130189
R2124 VSS.t966 VSS.n80 8.501
R2125 VSS.n673 VSS.t963 0.130189
R2126 VSS.t961 VSS.n80 8.501
R2127 VSS.n672 VSS.t958 0.130189
R2128 VSS.t956 VSS.n80 8.501
R2129 VSS.n671 VSS.t953 0.130189
R2130 VSS.t951 VSS.n80 8.501
R2131 VSS.n670 VSS.t948 0.130189
R2132 VSS.t946 VSS.n80 8.501
R2133 VSS.n669 VSS.t943 0.130189
R2134 VSS.t941 VSS.n80 8.501
R2135 VSS.n668 VSS.t938 0.130189
R2136 VSS.t936 VSS.n80 8.501
R2137 VSS.n667 VSS.t933 0.130189
R2138 VSS.t931 VSS.n80 8.501
R2139 VSS.n666 VSS.t928 0.130189
R2140 VSS.t926 VSS.n80 8.501
R2141 VSS.n665 VSS.t923 0.130189
R2142 VSS.t921 VSS.n80 8.501
R2143 VSS.n664 VSS.t918 0.130189
R2144 VSS.t916 VSS.n80 8.501
R2145 VSS.n663 VSS.t913 0.130189
R2146 VSS.t911 VSS.n80 8.501
R2147 VSS.n662 VSS.t908 0.130189
R2148 VSS.t906 VSS.n80 8.501
R2149 VSS.n661 VSS.t903 0.130189
R2150 VSS.t901 VSS.n80 8.501
R2151 VSS.n660 VSS.t898 0.130189
R2152 VSS.t896 VSS.n80 8.501
R2153 VSS.n659 VSS.t893 0.130189
R2154 VSS.t891 VSS.n80 8.501
R2155 VSS.n658 VSS.t888 0.130189
R2156 VSS.t886 VSS.n80 8.501
R2157 VSS.n657 VSS.t883 0.130189
R2158 VSS.t881 VSS.n80 8.501
R2159 VSS.n656 VSS.t878 0.130189
R2160 VSS.t876 VSS.n80 8.501
R2161 VSS.t873 VSS.n655 0.130189
R2162 VSS.t871 VSS.n80 8.501
R2163 VSS.t868 VSS.n654 0.130189
R2164 VSS.t866 VSS.n80 8.501
R2165 VSS.t863 VSS.n653 0.130189
R2166 VSS.t861 VSS.n80 8.501
R2167 VSS.t858 VSS.n652 0.130189
R2168 VSS.t856 VSS.n80 8.501
R2169 VSS.t853 VSS.n651 0.130189
R2170 VSS.t851 VSS.n80 8.501
R2171 VSS.n650 VSS.n80 3.33079
R2172 VSS.t202 VSS.t173 8.501
R2173 VSS.t146 VSS.n709 0.129991
R2174 VSS.t686 VSS.n708 0.235876
R2175 VSS.t683 VSS.n707 0.235729
R2176 VSS.n706 VSS.t202 4.20468
R2177 VSS.t52 VSS.n304 0.570053
R2178 VSS.n275 VSS.t257 0.0432886
R2179 VSS.n275 VSS.t202 4.23011
R2180 VSS.t175 VSS.n713 0.130189
R2181 VSS.t809 VSS.t202 8.501
R2182 VSS.t693 VSS.n712 0.130189
R2183 VSS.t690 VSS.n711 0.235876
R2184 VSS.t39 VSS.n710 0.235876
R2185 VSS.t202 VSS.n304 0.991834
R2186 VSS.t242 VSS.t202 1.88917
R2187 VSS.n722 VSS.t784 0.129991
R2188 VSS.t20 VSS.t202 8.501
R2189 VSS.n721 VSS.t202 2.31514
R2190 VSS.t2 VSS.n720 0.488114
R2191 VSS.n719 VSS.t202 1.73909
R2192 VSS.t676 VSS.n718 0.235729
R2193 VSS.t673 VSS.n717 0.235729
R2194 VSS.t671 VSS.n716 0.235729
R2195 VSS.n715 VSS.t28 0.129991
R2196 VSS.t669 VSS.t202 8.501
R2197 VSS.n734 VSS.t202 2.31523
R2198 VSS.n733 VSS.t202 3.33079
R2199 VSS.t331 VSS.n98 0.788892
R2200 VSS.n732 VSS.t661 0.123414
R2201 VSS.t659 VSS.t202 8.501
R2202 VSS.n731 VSS.t656 0.130189
R2203 VSS.t654 VSS.t202 8.501
R2204 VSS.n730 VSS.t651 0.130189
R2205 VSS.t649 VSS.t202 8.501
R2206 VSS.n729 VSS.t646 0.130189
R2207 VSS.t644 VSS.t202 8.501
R2208 VSS.n728 VSS.t641 0.130189
R2209 VSS.t639 VSS.t202 8.501
R2210 VSS.n727 VSS.t636 0.130189
R2211 VSS.t634 VSS.t202 8.501
R2212 VSS.n726 VSS.t631 0.130189
R2213 VSS.t629 VSS.t202 8.501
R2214 VSS.n725 VSS.t626 0.130189
R2215 VSS.t624 VSS.t202 8.501
R2216 VSS.t202 VSS.n724 3.33079
R2217 VSS.n293 VSS.t7 4.20253
R2218 VSS.n256 VSS.t127 0.130189
R2219 VSS.n738 VSS.t71 0.805041
R2220 VSS.t7 VSS.t531 8.501
R2221 VSS.n740 VSS.t7 3.33079
R2222 VSS.t32 VSS.n741 0.830309
R2223 VSS.t179 VSS.n288 0.480156
R2224 VSS.t7 VSS.t524 8.501
R2225 VSS.t521 VSS.n742 0.130189
R2226 VSS.t42 VSS.n236 0.188068
R2227 VSS.t7 VSS.n743 3.33079
R2228 VSS.n182 VSS.t734 4.49263
R2229 VSS.n102 VSS.n350 4.20253
R2230 VSS.n422 VSS.t449 0.083315
R2231 VSS.t2788 VSS.t2710 8.47111
R2232 VSS.n218 VSS.t2789 0.119605
R2233 VSS.t2710 VSS.n218 4.177
R2234 VSS.n310 VSS.t2791 0.119605
R2235 VSS.t2923 VSS.n429 0.17801
R2236 VSS.t2710 VSS.n310 4.177
R2237 VSS.n238 VSS.t2710 4.177
R2238 VSS.n238 VSS.t2794 0.119605
R2239 VSS.t2795 VSS.n430 0.119605
R2240 VSS.n430 VSS.t2710 4.177
R2241 VSS.n219 VSS.t2797 0.119605
R2242 VSS.t2710 VSS.n219 4.177
R2243 VSS.n311 VSS.t2799 0.119605
R2244 VSS.t2931 VSS.n431 0.17801
R2245 VSS.t2710 VSS.n311 4.177
R2246 VSS.n239 VSS.t2710 4.177
R2247 VSS.n239 VSS.t2802 0.119605
R2248 VSS.t2803 VSS.n432 0.119605
R2249 VSS.n432 VSS.t2710 4.177
R2250 VSS.n220 VSS.t2805 0.119605
R2251 VSS.t2710 VSS.n220 4.177
R2252 VSS.n312 VSS.t2807 0.119605
R2253 VSS.t2939 VSS.n433 0.17801
R2254 VSS.t2710 VSS.n312 4.177
R2255 VSS.n240 VSS.t2710 4.177
R2256 VSS.n240 VSS.t2810 0.119605
R2257 VSS.t2811 VSS.n434 0.119605
R2258 VSS.n434 VSS.t2710 4.177
R2259 VSS.n221 VSS.t2813 0.119605
R2260 VSS.t2710 VSS.n221 4.177
R2261 VSS.n313 VSS.t2815 0.119605
R2262 VSS.t2947 VSS.n435 0.17801
R2263 VSS.t2710 VSS.n313 4.177
R2264 VSS.n241 VSS.t2710 4.177
R2265 VSS.n241 VSS.t2818 0.119605
R2266 VSS.t2819 VSS.n436 0.119605
R2267 VSS.n436 VSS.t2710 4.177
R2268 VSS.n222 VSS.t2821 0.119605
R2269 VSS.t2710 VSS.n222 4.177
R2270 VSS.n314 VSS.t2823 0.119605
R2271 VSS.t2955 VSS.n437 0.17801
R2272 VSS.t2710 VSS.n314 4.177
R2273 VSS.n242 VSS.t2710 4.177
R2274 VSS.n242 VSS.t2826 0.119605
R2275 VSS.t2827 VSS.n438 0.119605
R2276 VSS.n438 VSS.t2710 4.177
R2277 VSS.n223 VSS.t2829 0.119605
R2278 VSS.t2710 VSS.n223 4.177
R2279 VSS.n315 VSS.t2831 0.119605
R2280 VSS.t2963 VSS.n439 0.17801
R2281 VSS.t2710 VSS.n315 4.177
R2282 VSS.n243 VSS.t2710 4.177
R2283 VSS.n243 VSS.t2834 0.119605
R2284 VSS.t2835 VSS.n440 0.119605
R2285 VSS.n440 VSS.t2710 4.177
R2286 VSS.n224 VSS.t2837 0.119605
R2287 VSS.t2710 VSS.n224 4.177
R2288 VSS.n316 VSS.t2839 0.119605
R2289 VSS.t2971 VSS.n441 0.17801
R2290 VSS.t2710 VSS.n316 4.177
R2291 VSS.n253 VSS.t2710 4.177
R2292 VSS.n253 VSS.t2842 0.119605
R2293 VSS.t2843 VSS.n442 0.119605
R2294 VSS.n442 VSS.t2710 4.177
R2295 VSS.t2710 VSS.t2845 8.47111
R2296 VSS.n443 VSS.t2846 0.119605
R2297 VSS.t2710 VSS.n443 4.177
R2298 VSS.t2978 VSS.t2710 8.47111
R2299 VSS.n284 VSS.t2710 3.30688
R2300 VSS.t2710 VSS.n225 4.177
R2301 VSS.n225 VSS.t2852 0.119605
R2302 VSS.n317 VSS.t2853 0.119605
R2303 VSS.t2855 VSS.n444 0.17801
R2304 VSS.t2710 VSS.n317 4.177
R2305 VSS.n252 VSS.t2710 4.177
R2306 VSS.n252 VSS.t2857 0.119605
R2307 VSS.n445 VSS.t2858 0.360183
R2308 VSS.n445 VSS.t2710 4.177
R2309 VSS.n207 VSS.t2860 0.177814
R2310 VSS.t2862 VSS.n446 0.083315
R2311 VSS.n335 VSS.t2710 4.177
R2312 VSS.t2786 VSS.n335 0.119605
R2313 VSS.n237 VSS.t2710 3.30696
R2314 VSS.t2779 VSS.n336 0.17801
R2315 VSS.t2710 VSS.t2775 8.47111
R2316 VSS.t2710 VSS.n447 4.177
R2317 VSS.n447 VSS.t2773 0.119605
R2318 VSS.n337 VSS.t2768 0.17801
R2319 VSS.n283 VSS.t2763 0.17801
R2320 VSS.t2759 VSS.n338 0.17801
R2321 VSS.t2754 VSS.n282 0.17801
R2322 VSS.t2750 VSS.n339 0.177814
R2323 VSS.t2745 VSS.n340 0.177814
R2324 VSS.t2740 VSS.n281 0.177814
R2325 VSS.n341 VSS.t2736 0.177814
R2326 VSS.n342 VSS.t2730 0.177814
R2327 VSS.n280 VSS.t2724 0.177814
R2328 VSS.n343 VSS.t2719 0.17801
R2329 VSS.t2710 VSS.n262 3.30696
R2330 VSS.n616 VSS.t1323 0.17801
R2331 VSS.t1325 VSS.t305 8.47111
R2332 VSS.t305 VSS.n617 3.30688
R2333 VSS.n251 VSS.t1328 0.119605
R2334 VSS.t1472 VSS.n618 0.119605
R2335 VSS.t305 VSS.n251 4.177
R2336 VSS.n618 VSS.t305 4.177
R2337 VSS.n257 VSS.t1334 0.119605
R2338 VSS.t1477 VSS.n619 0.17801
R2339 VSS.t305 VSS.n257 4.177
R2340 VSS.n264 VSS.t305 3.30688
R2341 VSS.t305 VSS.n620 3.30696
R2342 VSS.t1484 VSS.n216 0.177814
R2343 VSS.n621 VSS.t305 3.30688
R2344 VSS.n309 VSS.t305 4.177
R2345 VSS.t1347 VSS.n309 0.119605
R2346 VSS.t1348 VSS.t305 8.47111
R2347 VSS.t305 VSS.n246 4.177
R2348 VSS.n246 VSS.t1350 0.119605
R2349 VSS.n622 VSS.t1351 0.119605
R2350 VSS.t1492 VSS.t305 8.47111
R2351 VSS.t305 VSS.n622 4.177
R2352 VSS.n623 VSS.t305 3.30688
R2353 VSS.t1495 VSS.n248 0.119605
R2354 VSS.n248 VSS.t305 4.177
R2355 VSS.t1357 VSS.t305 8.47111
R2356 VSS.n624 VSS.t1358 0.119605
R2357 VSS.t305 VSS.n624 4.177
R2358 VSS.t305 VSS.t1360 8.47111
R2359 VSS.t305 VSS.n308 3.30688
R2360 VSS.t305 VSS.t1363 8.47111
R2361 VSS.n625 VSS.t1364 0.17801
R2362 VSS.n250 VSS.t1366 0.119605
R2363 VSS.t1504 VSS.n626 0.17801
R2364 VSS.t305 VSS.n250 4.177
R2365 VSS.n627 VSS.t305 4.177
R2366 VSS.t305 VSS.t1369 8.47111
R2367 VSS.t1370 VSS.n627 0.119605
R2368 VSS.t1371 VSS.t305 8.47111
R2369 VSS.t305 VSS.n628 4.177
R2370 VSS.n628 VSS.t1373 0.119605
R2371 VSS.n629 VSS.t1374 0.119605
R2372 VSS.t1512 VSS.t305 8.47111
R2373 VSS.t305 VSS.n629 4.177
R2374 VSS.n630 VSS.t305 3.30688
R2375 VSS.t1515 VSS.t305 8.47111
R2376 VSS.t1379 VSS.n631 0.119605
R2377 VSS.n631 VSS.t305 4.177
R2378 VSS.t1382 VSS.n319 0.119605
R2379 VSS.n319 VSS.t305 4.177
R2380 VSS.n632 VSS.t1384 0.119605
R2381 VSS.t305 VSS.n632 4.177
R2382 VSS.n334 VSS.t1386 0.119605
R2383 VSS.n247 VSS.t305 4.177
R2384 VSS.t305 VSS.n334 4.177
R2385 VSS.t1388 VSS.n247 0.119605
R2386 VSS.t1389 VSS.t305 8.47111
R2387 VSS.n633 VSS.t1390 0.119605
R2388 VSS.t305 VSS.n633 4.177
R2389 VSS.t305 VSS.t1392 8.47111
R2390 VSS.t305 VSS.n307 3.30688
R2391 VSS.n320 VSS.t1395 0.119605
R2392 VSS.t1529 VSS.n634 0.17801
R2393 VSS.t305 VSS.n320 4.177
R2394 VSS.n212 VSS.t305 4.177
R2395 VSS.n212 VSS.t1398 0.119605
R2396 VSS.n635 VSS.t305 4.177
R2397 VSS.t1400 VSS.n635 0.119605
R2398 VSS.t305 VSS.n636 4.177
R2399 VSS.n636 VSS.t1319 0.119605
R2400 VSS.t305 VSS.n321 3.30688
R2401 VSS.t305 VSS.n637 4.177
R2402 VSS.n637 VSS.t1315 0.119605
R2403 VSS.t305 VSS.n322 4.177
R2404 VSS.t1313 VSS.n322 0.119605
R2405 VSS.t1312 VSS.t305 8.47111
R2406 VSS.t1311 VSS.n202 0.177814
R2407 VSS.n638 VSS.t305 4.177
R2408 VSS.t1457 VSS.n638 0.119605
R2409 VSS.t305 VSS.n323 4.177
R2410 VSS.n323 VSS.t1307 0.119605
R2411 VSS.t305 VSS.n226 4.177
R2412 VSS.n226 VSS.t1305 0.119605
R2413 VSS.t305 VSS.n639 4.177
R2414 VSS.n639 VSS.t1302 0.119605
R2415 VSS.n324 VSS.t305 4.177
R2416 VSS.t1300 VSS.n324 0.119605
R2417 VSS.n227 VSS.t305 4.177
R2418 VSS.n227 VSS.t1299 0.119605
R2419 VSS.n640 VSS.t305 4.177
R2420 VSS.n640 VSS.t1297 0.119605
R2421 VSS.t305 VSS.n325 4.177
R2422 VSS.n325 VSS.t1295 0.119605
R2423 VSS.t305 VSS.n228 4.177
R2424 VSS.t1293 VSS.n228 0.119605
R2425 VSS.t305 VSS.n641 4.177
R2426 VSS.t1290 VSS.n641 0.119605
R2427 VSS.n326 VSS.t305 4.177
R2428 VSS.t1440 VSS.n326 0.119605
R2429 VSS.t305 VSS.n229 4.177
R2430 VSS.n229 VSS.t1287 0.119605
R2431 VSS.t305 VSS.n642 4.177
R2432 VSS.n642 VSS.t1284 0.119605
R2433 VSS.t305 VSS.n327 4.177
R2434 VSS.n327 VSS.t1282 0.119605
R2435 VSS.n230 VSS.t305 4.177
R2436 VSS.t1280 VSS.n230 0.119605
R2437 VSS.n643 VSS.t305 4.177
R2438 VSS.t1277 VSS.n643 0.119605
R2439 VSS.n328 VSS.t305 4.177
R2440 VSS.n328 VSS.t1276 0.119605
R2441 VSS.t305 VSS.n231 4.177
R2442 VSS.n231 VSS.t1274 0.119605
R2443 VSS.t305 VSS.n644 4.177
R2444 VSS.n644 VSS.t1271 0.119605
R2445 VSS.t305 VSS.n645 4.177
R2446 VSS.n645 VSS.t1268 0.119605
R2447 VSS.t305 VSS.n329 4.177
R2448 VSS.t1266 VSS.n329 0.119605
R2449 VSS.n232 VSS.t305 4.177
R2450 VSS.t1264 VSS.n232 0.119605
R2451 VSS.n646 VSS.t305 4.177
R2452 VSS.t1420 VSS.n646 0.119605
R2453 VSS.t305 VSS.n330 4.177
R2454 VSS.n330 VSS.t1260 0.119605
R2455 VSS.t305 VSS.n233 4.177
R2456 VSS.n233 VSS.t1258 0.119605
R2457 VSS.t305 VSS.n647 5.61485
R2458 VSS.t1254 VSS.n333 0.0605362
R2459 VSS.n245 VSS.t305 4.177
R2460 VSS.t1413 VSS.n245 0.119605
R2461 VSS.t305 VSS.n213 3.30696
R2462 VSS.n648 VSS.t305 4.177
R2463 VSS.n648 VSS.t1250 0.119605
R2464 VSS.t305 VSS.n331 4.177
R2465 VSS.n331 VSS.t1248 0.119605
R2466 VSS.t305 VSS.n234 4.177
R2467 VSS.t1246 VSS.n234 0.119605
R2468 VSS.t305 VSS.n649 4.177
R2469 VSS.t1243 VSS.n649 0.119605
R2470 VSS.n332 VSS.t305 4.177
R2471 VSS.t1403 VSS.n332 0.119605
R2472 VSS.t305 VSS.n235 4.177
R2473 VSS.n235 VSS.t1240 0.119605
R2474 VSS.t334 VSS.n714 0.119605
R2475 VSS.n714 VSS.t202 4.177
R2476 VSS.t152 VSS.n279 0.17801
R2477 VSS.n244 VSS.t7 0.662987
R2478 VSS.n297 VSS.t24 0.177814
R2479 VSS.t66 VSS.n277 0.291267
R2480 VSS.t113 VSS.t7 8.47111
R2481 VSS.t35 VSS.n298 0.17801
R2482 VSS.n735 VSS.t7 5.61485
R2483 VSS.t7 VSS.n286 3.30688
R2484 VSS.t272 VSS.n293 0.083315
R2485 VSS.t7 VSS.n263 3.30688
R2486 VSS.t7 VSS.n869 8.47111
R2487 VSS.t7 VSS.n285 2.72093
R2488 VSS.t12 VSS.n736 0.17801
R2489 VSS.n737 VSS.t7 4.177
R2490 VSS.n737 VSS.t131 0.119605
R2491 VSS.t7 VSS.n299 2.72093
R2492 VSS.n299 VSS.t25 0.235242
R2493 VSS.t318 VSS.n739 0.913029
R2494 VSS.t7 VSS.t30 8.47111
R2495 VSS.t7 VSS.n288 1.21604
R2496 VSS VSS.t394 8.36235
R2497 VSS.t502 VSS.n756 8.36235
R2498 VSS.t3242 VSS.n905 8.36235
R2499 VSS.n904 VSS.n747 8.36235
R2500 VSS.n888 VSS.n773 8.36235
R2501 VSS.t194 VSS.t3307 8.33383
R2502 VSS.t649 VSS 8.3005
R2503 VSS VSS.t876 8.3005
R2504 VSS.t1255 VSS 8.3005
R2505 VSS.t1563 VSS 8.3005
R2506 VSS VSS.t1955 8.3005
R2507 VSS.t2347 VSS 8.3005
R2508 VSS.t2728 VSS 8.3005
R2509 VSS VSS.t3017 8.3005
R2510 VSS.t559 VSS.n756 8.3005
R2511 VSS.n897 VSS.t719 8.3005
R2512 VSS.t1101 VSS.n898 8.3005
R2513 VSS.t1387 VSS.n751 8.3005
R2514 VSS.n901 VSS.t1788 8.3005
R2515 VSS.t2180 VSS.n902 8.3005
R2516 VSS.t2572 VSS.n748 8.3005
R2517 VSS.n905 VSS.t2848 8.3005
R2518 VSS.t2919 VSS.n904 8.3005
R2519 VSS.n903 VSS.t2460 8.3005
R2520 VSS.t2068 VSS.n750 8.3005
R2521 VSS.t1676 VSS.n900 8.3005
R2522 VSS.n899 VSS.t1466 8.3005
R2523 VSS.t989 VSS.n752 8.3005
R2524 VSS.t309 VSS.n889 8.3005
R2525 VSS.n888 VSS.t126 8.3005
R2526 VSS.n872 VSS.t3300 7.38057
R2527 VSS.t333 VSS.t201 7.1604
R2528 VSS.t11 VSS.t45 7.1604
R2529 VSS.t176 VSS.t84 7.1604
R2530 VSS.t44 VSS.t7 1.88959
R2531 VSS.t7 VSS.t212 1.71445
R2532 VSS.n102 VSS.n409 3.33079
R2533 VSS.n408 VSS.n102 3.33079
R2534 VSS.n102 VSS.n407 3.33079
R2535 VSS.n406 VSS.n102 3.33079
R2536 VSS.n102 VSS.n405 3.33079
R2537 VSS.n404 VSS.n102 3.33079
R2538 VSS.n403 VSS.n102 3.33079
R2539 VSS.n402 VSS.n102 3.33079
R2540 VSS.n401 VSS.n102 3.33079
R2541 VSS.n400 VSS.n102 3.33079
R2542 VSS.n399 VSS.n102 3.33079
R2543 VSS.n398 VSS.n102 3.33079
R2544 VSS.n397 VSS.n102 3.33079
R2545 VSS.n396 VSS.n102 3.33079
R2546 VSS.n395 VSS.n102 3.33079
R2547 VSS.n394 VSS.n102 3.33079
R2548 VSS.n393 VSS.n102 3.33079
R2549 VSS.n392 VSS.n102 3.33079
R2550 VSS.n391 VSS.n102 3.33079
R2551 VSS.n390 VSS.n102 3.33079
R2552 VSS.n389 VSS.n102 3.33079
R2553 VSS.n388 VSS.n102 3.33079
R2554 VSS.n387 VSS.n102 3.33079
R2555 VSS.n386 VSS.n102 3.33079
R2556 VSS.n385 VSS.n102 3.33079
R2557 VSS.n384 VSS.n102 3.33079
R2558 VSS.n383 VSS.n102 3.33079
R2559 VSS.n381 VSS.n102 3.33079
R2560 VSS.n380 VSS.n102 3.33079
R2561 VSS.n379 VSS.n102 3.33079
R2562 VSS.n378 VSS.n102 3.33079
R2563 VSS.n377 VSS.n102 3.33079
R2564 VSS.n376 VSS.n102 3.33079
R2565 VSS.n375 VSS.n102 3.33079
R2566 VSS.n374 VSS.n102 3.33079
R2567 VSS.n373 VSS.n102 3.33079
R2568 VSS.n372 VSS.n102 3.33079
R2569 VSS.n371 VSS.n102 3.33079
R2570 VSS.n370 VSS.n102 3.33079
R2571 VSS.n369 VSS.n102 3.33079
R2572 VSS.n368 VSS.n102 3.33079
R2573 VSS.n367 VSS.n102 3.33079
R2574 VSS.n366 VSS.n102 3.33079
R2575 VSS.n365 VSS.n102 3.33079
R2576 VSS.n364 VSS.n102 3.33079
R2577 VSS.n363 VSS.n102 3.33079
R2578 VSS.n362 VSS.n102 3.33079
R2579 VSS.n361 VSS.n102 3.33079
R2580 VSS.n102 VSS.n360 3.33079
R2581 VSS.n358 VSS.n102 3.33079
R2582 VSS.n102 VSS.n357 3.33079
R2583 VSS.n356 VSS.n102 3.33079
R2584 VSS.n102 VSS.n355 3.33079
R2585 VSS.t2990 VSS.n354 0.0863258
R2586 VSS.t374 VSS.n746 0.0896992
R2587 VSS.t380 VSS.n744 0.0896992
R2588 VSS.t389 VSS.n745 0.0896992
R2589 VSS.t402 VSS.n411 0.0896992
R2590 VSS.t408 VSS.n412 0.0896992
R2591 VSS.t413 VSS.n413 0.0896992
R2592 VSS.t418 VSS.n414 0.0896992
R2593 VSS.t423 VSS.n415 0.0896992
R2594 VSS.t427 VSS.n417 0.0896992
R2595 VSS.n418 VSS.t432 0.0896992
R2596 VSS.n419 VSS.t437 0.0896992
R2597 VSS.t444 VSS.n421 0.0896992
R2598 VSS.n423 VSS.t454 0.0896992
R2599 VSS.n424 VSS.t459 0.0896992
R2600 VSS.t465 VSS.n425 0.0896992
R2601 VSS.n426 VSS.t470 0.0896992
R2602 VSS.n427 VSS.t475 0.0896992
R2603 VSS.t2710 VSS.n429 3.30688
R2604 VSS.t2710 VSS.n431 3.30688
R2605 VSS.t2710 VSS.n433 3.30688
R2606 VSS.t2710 VSS.n435 3.30688
R2607 VSS.t2710 VSS.n437 3.30688
R2608 VSS.t2710 VSS.n439 3.30688
R2609 VSS.t2710 VSS.n441 3.30688
R2610 VSS.n284 VSS.t2849 0.118323
R2611 VSS.t2710 VSS.n444 3.30688
R2612 VSS.n207 VSS.t2710 3.30696
R2613 VSS.t2785 VSS.t2710 5.61485
R2614 VSS.t2710 VSS.n278 2.7209
R2615 VSS.n278 VSS.t2783 0.175554
R2616 VSS.t2782 VSS.t2710 5.61485
R2617 VSS.n237 VSS.t2781 0.118193
R2618 VSS.t2710 VSS.n336 3.30688
R2619 VSS.n273 VSS.t2777 0.175395
R2620 VSS.n273 VSS.t2710 2.72098
R2621 VSS.t2710 VSS.t2772 5.61485
R2622 VSS.n272 VSS.t2710 2.72082
R2623 VSS.n272 VSS.t2770 0.175714
R2624 VSS.t2710 VSS.t2769 5.61485
R2625 VSS.t2710 VSS.n337 3.30688
R2626 VSS.t2766 VSS.n271 0.175714
R2627 VSS.t2710 VSS.t2764 5.61485
R2628 VSS.t2710 VSS.n283 3.30688
R2629 VSS.t2761 VSS.n258 0.175714
R2630 VSS.t2710 VSS.n258 2.72082
R2631 VSS.t2710 VSS.n338 3.30688
R2632 VSS.n270 VSS.t2757 0.175395
R2633 VSS.n270 VSS.t2710 2.72098
R2634 VSS.t2710 VSS.t2755 5.61485
R2635 VSS.t2710 VSS.n282 3.30688
R2636 VSS.n259 VSS.t2752 0.175395
R2637 VSS.n259 VSS.t2710 2.72098
R2638 VSS.n339 VSS.t2710 3.30696
R2639 VSS.n269 VSS.t2748 0.175554
R2640 VSS.t2710 VSS.n269 2.7209
R2641 VSS.t2746 VSS.t2710 5.61485
R2642 VSS.n340 VSS.t2710 3.30696
R2643 VSS.n268 VSS.t2743 0.175554
R2644 VSS.t2710 VSS.n268 2.7209
R2645 VSS.t2741 VSS.t2710 5.61485
R2646 VSS.n281 VSS.t2710 3.30696
R2647 VSS.n260 VSS.t2738 0.175554
R2648 VSS.t2710 VSS.n260 2.7209
R2649 VSS.n341 VSS.t2710 3.30696
R2650 VSS.t2733 VSS.n267 0.175714
R2651 VSS.t2710 VSS.n267 2.72082
R2652 VSS.t2710 VSS.t2731 5.61485
R2653 VSS.n342 VSS.t2710 3.30696
R2654 VSS.t2727 VSS.n266 0.175714
R2655 VSS.t2710 VSS.n266 2.72082
R2656 VSS.t2710 VSS.t2725 5.61485
R2657 VSS.n280 VSS.t2710 3.30696
R2658 VSS.t2721 VSS.n261 0.175714
R2659 VSS.t2710 VSS.n261 2.72082
R2660 VSS.t2710 VSS.n343 3.30688
R2661 VSS.t2716 VSS.n265 0.175554
R2662 VSS.n265 VSS.t2710 2.7209
R2663 VSS.n262 VSS.t2714 0.118193
R2664 VSS.n344 VSS.t2712 0.106155
R2665 VSS.n503 VSS.n81 3.33079
R2666 VSS.n81 VSS.n502 3.33079
R2667 VSS.n81 VSS.n500 3.33079
R2668 VSS.n499 VSS.n81 3.33079
R2669 VSS.n81 VSS.n498 3.33079
R2670 VSS.n497 VSS.n81 3.33079
R2671 VSS.n81 VSS.n496 3.33079
R2672 VSS.n495 VSS.n81 3.33079
R2673 VSS.n81 VSS.n494 3.33079
R2674 VSS.n493 VSS.n81 3.33079
R2675 VSS.n81 VSS.n492 3.33079
R2676 VSS.n491 VSS.n81 3.33079
R2677 VSS.n81 VSS.n490 3.33079
R2678 VSS.n489 VSS.n81 3.33079
R2679 VSS.n81 VSS.n488 3.33079
R2680 VSS.n487 VSS.n81 3.33079
R2681 VSS.n81 VSS.n486 3.33079
R2682 VSS.n485 VSS.n81 3.33079
R2683 VSS.n81 VSS.n484 3.33079
R2684 VSS.n483 VSS.n81 3.33079
R2685 VSS.n81 VSS.n482 3.33079
R2686 VSS.n481 VSS.n81 3.33079
R2687 VSS.n81 VSS.n480 3.33079
R2688 VSS.n479 VSS.n81 3.33079
R2689 VSS.n81 VSS.n478 3.33079
R2690 VSS.n477 VSS.n81 3.33079
R2691 VSS.n475 VSS.n81 3.33079
R2692 VSS.n474 VSS.n81 3.33079
R2693 VSS.n473 VSS.n81 3.33079
R2694 VSS.n472 VSS.n81 3.33079
R2695 VSS.n471 VSS.n81 3.33079
R2696 VSS.n470 VSS.n81 3.33079
R2697 VSS.n469 VSS.n81 3.33079
R2698 VSS.n468 VSS.n81 3.33079
R2699 VSS.n467 VSS.n81 3.33079
R2700 VSS.n466 VSS.n81 3.33079
R2701 VSS.n465 VSS.n81 3.33079
R2702 VSS.n464 VSS.n81 3.33079
R2703 VSS.n463 VSS.n81 3.33079
R2704 VSS.n462 VSS.n81 3.33079
R2705 VSS.n461 VSS.n81 3.33079
R2706 VSS.n460 VSS.n81 3.33079
R2707 VSS.n459 VSS.n81 3.33079
R2708 VSS.n458 VSS.n81 3.33079
R2709 VSS.n457 VSS.n81 3.33079
R2710 VSS.n456 VSS.n81 3.33079
R2711 VSS.n455 VSS.n81 3.33079
R2712 VSS.n454 VSS.n81 3.33079
R2713 VSS.n453 VSS.n81 3.33079
R2714 VSS.n452 VSS.n81 3.33079
R2715 VSS.n451 VSS.n81 3.33079
R2716 VSS.n450 VSS.n81 3.33079
R2717 VSS.n449 VSS.n81 3.33079
R2718 VSS.t2320 VSS.n448 0.0863258
R2719 VSS.n559 VSS.n82 3.33079
R2720 VSS.n82 VSS.n558 3.33079
R2721 VSS.n82 VSS.n556 3.33079
R2722 VSS.n555 VSS.n82 3.33079
R2723 VSS.n82 VSS.n554 3.33079
R2724 VSS.n553 VSS.n82 3.33079
R2725 VSS.n82 VSS.n552 3.33079
R2726 VSS.n551 VSS.n82 3.33079
R2727 VSS.n82 VSS.n550 3.33079
R2728 VSS.n549 VSS.n82 3.33079
R2729 VSS.n82 VSS.n548 3.33079
R2730 VSS.n547 VSS.n82 3.33079
R2731 VSS.n82 VSS.n546 3.33079
R2732 VSS.n545 VSS.n82 3.33079
R2733 VSS.n82 VSS.n544 3.33079
R2734 VSS.n543 VSS.n82 3.33079
R2735 VSS.n82 VSS.n542 3.33079
R2736 VSS.n541 VSS.n82 3.33079
R2737 VSS.n82 VSS.n540 3.33079
R2738 VSS.n539 VSS.n82 3.33079
R2739 VSS.n82 VSS.n538 3.33079
R2740 VSS.n537 VSS.n82 3.33079
R2741 VSS.n82 VSS.n536 3.33079
R2742 VSS.n535 VSS.n82 3.33079
R2743 VSS.n82 VSS.n534 3.33079
R2744 VSS.n533 VSS.n82 3.33079
R2745 VSS.n531 VSS.n82 3.33079
R2746 VSS.n82 VSS.n530 3.33079
R2747 VSS.n529 VSS.n82 3.33079
R2748 VSS.n82 VSS.n528 3.33079
R2749 VSS.n527 VSS.n82 3.33079
R2750 VSS.n82 VSS.n526 3.33079
R2751 VSS.n525 VSS.n82 3.33079
R2752 VSS.n82 VSS.n524 3.33079
R2753 VSS.n523 VSS.n82 3.33079
R2754 VSS.n82 VSS.n522 3.33079
R2755 VSS.n521 VSS.n82 3.33079
R2756 VSS.n82 VSS.n520 3.33079
R2757 VSS.n519 VSS.n82 3.33079
R2758 VSS.n82 VSS.n518 3.33079
R2759 VSS.n517 VSS.n82 3.33079
R2760 VSS.n82 VSS.n516 3.33079
R2761 VSS.n515 VSS.n82 3.33079
R2762 VSS.n82 VSS.n514 3.33079
R2763 VSS.n513 VSS.n82 3.33079
R2764 VSS.n82 VSS.n512 3.33079
R2765 VSS.n511 VSS.n82 3.33079
R2766 VSS.n82 VSS.n510 3.33079
R2767 VSS.n509 VSS.n82 3.33079
R2768 VSS.n508 VSS.n82 3.33079
R2769 VSS.n82 VSS.n507 3.33079
R2770 VSS.n506 VSS.n82 3.33079
R2771 VSS.n82 VSS.n505 3.33079
R2772 VSS.t1928 VSS.n504 0.0863258
R2773 VSS.n83 VSS.n615 3.33079
R2774 VSS.n614 VSS.n83 3.33079
R2775 VSS.n612 VSS.n83 3.33079
R2776 VSS.n83 VSS.n611 3.33079
R2777 VSS.n610 VSS.n83 3.33079
R2778 VSS.n609 VSS.n83 3.33079
R2779 VSS.n608 VSS.n83 3.33079
R2780 VSS.n607 VSS.n83 3.33079
R2781 VSS.n606 VSS.n83 3.33079
R2782 VSS.n605 VSS.n83 3.33079
R2783 VSS.n604 VSS.n83 3.33079
R2784 VSS.n603 VSS.n83 3.33079
R2785 VSS.n602 VSS.n83 3.33079
R2786 VSS.n601 VSS.n83 3.33079
R2787 VSS.n600 VSS.n83 3.33079
R2788 VSS.n599 VSS.n83 3.33079
R2789 VSS.n598 VSS.n83 3.33079
R2790 VSS.n597 VSS.n83 3.33079
R2791 VSS.n596 VSS.n83 3.33079
R2792 VSS.n595 VSS.n83 3.33079
R2793 VSS.n594 VSS.n83 3.33079
R2794 VSS.n593 VSS.n83 3.33079
R2795 VSS.n592 VSS.n83 3.33079
R2796 VSS.n591 VSS.n83 3.33079
R2797 VSS.n590 VSS.n83 3.33079
R2798 VSS.n589 VSS.n83 3.33079
R2799 VSS.n83 VSS.n587 3.33079
R2800 VSS.n586 VSS.n83 3.33079
R2801 VSS.n83 VSS.n585 3.33079
R2802 VSS.n584 VSS.n83 3.33079
R2803 VSS.n83 VSS.n583 3.33079
R2804 VSS.n582 VSS.n83 3.33079
R2805 VSS.n83 VSS.n581 3.33079
R2806 VSS.n580 VSS.n83 3.33079
R2807 VSS.n83 VSS.n579 3.33079
R2808 VSS.n578 VSS.n83 3.33079
R2809 VSS.n83 VSS.n577 3.33079
R2810 VSS.n576 VSS.n83 3.33079
R2811 VSS.n83 VSS.n575 3.33079
R2812 VSS.n574 VSS.n83 3.33079
R2813 VSS.n83 VSS.n573 3.33079
R2814 VSS.n572 VSS.n83 3.33079
R2815 VSS.n83 VSS.n571 3.33079
R2816 VSS.n570 VSS.n83 3.33079
R2817 VSS.n83 VSS.n569 3.33079
R2818 VSS.n568 VSS.n83 3.33079
R2819 VSS.n83 VSS.n567 3.33079
R2820 VSS.n566 VSS.n83 3.33079
R2821 VSS.n83 VSS.n565 3.33079
R2822 VSS.n564 VSS.n83 3.33079
R2823 VSS.n83 VSS.n563 3.33079
R2824 VSS.n562 VSS.n83 3.33079
R2825 VSS.n83 VSS.n561 3.33079
R2826 VSS.t1536 VSS.n560 0.0863258
R2827 VSS.t305 VSS.n616 3.30688
R2828 VSS.n617 VSS.t1326 0.118323
R2829 VSS.n211 VSS.t1333 0.175554
R2830 VSS.t305 VSS.n619 3.30688
R2831 VSS.t305 VSS.t1337 5.61485
R2832 VSS.t1338 VSS.n264 0.118323
R2833 VSS.t1341 VSS.n620 0.118193
R2834 VSS.t305 VSS.n216 3.30696
R2835 VSS.n621 VSS.t1345 0.118323
R2836 VSS.n623 VSS.t1354 0.118323
R2837 VSS.n308 VSS.t1361 0.118323
R2838 VSS.t305 VSS.n625 3.30688
R2839 VSS.t305 VSS.n626 3.30688
R2840 VSS.n630 VSS.t1377 0.118323
R2841 VSS.t1381 VSS.t305 5.61485
R2842 VSS.n307 VSS.t1393 0.118323
R2843 VSS.t305 VSS.n634 3.30688
R2844 VSS.t1321 VSS.n318 0.0599544
R2845 VSS.n321 VSS.t1317 0.118323
R2846 VSS.n202 VSS.t305 3.30696
R2847 VSS.t305 VSS.t1304 5.61485
R2848 VSS.t1298 VSS.t305 5.61485
R2849 VSS.t305 VSS.t1292 5.61485
R2850 VSS.t1286 VSS.t305 5.61485
R2851 VSS.t305 VSS.t1279 5.61485
R2852 VSS.t305 VSS.t1273 5.61485
R2853 VSS.t305 VSS.t1270 5.61485
R2854 VSS.t1263 VSS.t305 5.61485
R2855 VSS.t305 VSS.t1257 5.61485
R2856 VSS.t1251 VSS.n213 0.118193
R2857 VSS.t305 VSS.t1245 5.61485
R2858 VSS.n705 VSS.n80 3.33079
R2859 VSS.n80 VSS.n704 3.33079
R2860 VSS.n80 VSS.n702 3.33079
R2861 VSS.n701 VSS.n80 3.33079
R2862 VSS.n80 VSS.n700 3.33079
R2863 VSS.n699 VSS.n80 3.33079
R2864 VSS.n80 VSS.n698 3.33079
R2865 VSS.n697 VSS.n80 3.33079
R2866 VSS.n80 VSS.n696 3.33079
R2867 VSS.n695 VSS.n80 3.33079
R2868 VSS.n80 VSS.n694 3.33079
R2869 VSS.n693 VSS.n80 3.33079
R2870 VSS.n80 VSS.n692 3.33079
R2871 VSS.n691 VSS.n80 3.33079
R2872 VSS.n80 VSS.n690 3.33079
R2873 VSS.n689 VSS.n80 3.33079
R2874 VSS.n80 VSS.n688 3.33079
R2875 VSS.n687 VSS.n80 3.33079
R2876 VSS.n80 VSS.n686 3.33079
R2877 VSS.n685 VSS.n80 3.33079
R2878 VSS.n80 VSS.n684 3.33079
R2879 VSS.n683 VSS.n80 3.33079
R2880 VSS.n80 VSS.n682 3.33079
R2881 VSS.n681 VSS.n80 3.33079
R2882 VSS.n80 VSS.n680 3.33079
R2883 VSS.n679 VSS.n80 3.33079
R2884 VSS.n677 VSS.n80 3.33079
R2885 VSS.n80 VSS.n676 3.33079
R2886 VSS.n675 VSS.n80 3.33079
R2887 VSS.n80 VSS.n674 3.33079
R2888 VSS.n673 VSS.n80 3.33079
R2889 VSS.n80 VSS.n672 3.33079
R2890 VSS.n671 VSS.n80 3.33079
R2891 VSS.n80 VSS.n670 3.33079
R2892 VSS.n669 VSS.n80 3.33079
R2893 VSS.n80 VSS.n668 3.33079
R2894 VSS.n667 VSS.n80 3.33079
R2895 VSS.n80 VSS.n666 3.33079
R2896 VSS.n665 VSS.n80 3.33079
R2897 VSS.n80 VSS.n664 3.33079
R2898 VSS.n663 VSS.n80 3.33079
R2899 VSS.n80 VSS.n662 3.33079
R2900 VSS.n661 VSS.n80 3.33079
R2901 VSS.n80 VSS.n660 3.33079
R2902 VSS.n659 VSS.n80 3.33079
R2903 VSS.n80 VSS.n658 3.33079
R2904 VSS.n657 VSS.n80 3.33079
R2905 VSS.n80 VSS.n656 3.33079
R2906 VSS.n655 VSS.n80 3.33079
R2907 VSS.n654 VSS.n80 3.33079
R2908 VSS.n653 VSS.n80 3.33079
R2909 VSS.n652 VSS.n80 3.33079
R2910 VSS.n651 VSS.n80 3.33079
R2911 VSS.t849 VSS.n650 0.0863258
R2912 VSS.t202 VSS.n709 3.33087
R2913 VSS.n713 VSS.t202 3.33079
R2914 VSS.n712 VSS.t202 3.33079
R2915 VSS.n722 VSS.t202 3.33087
R2916 VSS.n715 VSS.t202 3.33087
R2917 VSS.n733 VSS.t760 0.0863258
R2918 VSS.n732 VSS.t202 3.33348
R2919 VSS.t202 VSS.n731 3.33079
R2920 VSS.n730 VSS.t202 3.33079
R2921 VSS.t202 VSS.n729 3.33079
R2922 VSS.n728 VSS.t202 3.33079
R2923 VSS.t202 VSS.n727 3.33079
R2924 VSS.n726 VSS.t202 3.33079
R2925 VSS.t202 VSS.n725 3.33079
R2926 VSS.t622 VSS.n724 0.0863258
R2927 VSS.t7 VSS.t125 5.61485
R2928 VSS.t7 VSS.n279 3.30688
R2929 VSS.n297 VSS.t7 3.30696
R2930 VSS.n277 VSS.t7 2.29766
R2931 VSS.n298 VSS.t7 3.30688
R2932 VSS.n290 VSS.t7 2.72082
R2933 VSS.t293 VSS.n290 0.175714
R2934 VSS.t292 VSS.n289 0.175554
R2935 VSS.n289 VSS.t7 2.7209
R2936 VSS.n286 VSS.t158 0.118323
R2937 VSS.n263 VSS.t148 0.118323
R2938 VSS.n256 VSS.t7 3.33079
R2939 VSS.n736 VSS.t7 3.30688
R2940 VSS.t530 VSS.n740 0.0863258
R2941 VSS.t7 VSS.n742 3.33079
R2942 VSS.n292 VSS.t258 0.81964
R2943 VSS.t517 VSS.n743 0.0863258
R2944 VSS.n185 VSS.t172 12.3671
R2945 VSS.t62 VSS.n192 11.0031
R2946 VSS.n852 VSS.t349 4.28621
R2947 VSS.t2710 VSS.n344 3.31934
R2948 VSS.t202 VSS.t201 4.2505
R2949 VSS.t37 VSS.t7 0.421865
R2950 VSS.t7 VSS.t45 4.2505
R2951 VSS.t7 VSS.t84 4.2505
R2952 VSS.t7 VSS.n291 0.808919
R2953 VSS.t7 VSS.t162 4.20382
R2954 VSS.n81 VSS.t2462 4.20259
R2955 VSS.n82 VSS.t2070 4.20259
R2956 VSS.t1678 VSS.n83 4.20259
R2957 VSS.n80 VSS.t991 4.20259
R2958 VSS.n802 VSS.t74 4.17719
R2959 VSS.t273 VSS.n285 0.39688
R2960 VSS.n236 VSS.t7 2.73998
R2961 VSS.t242 VSS.t333 3.50108
R2962 VSS.t212 VSS.t176 3.50108
R2963 VSS.t11 VSS.t44 3.50108
R2964 VSS.n734 VSS.t763 0.0931939
R2965 VSS.t202 VSS.n707 2.31585
R2966 VSS.n721 VSS.t781 0.0933
R2967 VSS.t202 VSS.n718 2.31585
R2968 VSS.t202 VSS.n717 2.31585
R2969 VSS.t202 VSS.n716 2.31585
R2970 VSS.t202 VSS.n708 2.31581
R2971 VSS.n711 VSS.t202 2.31581
R2972 VSS.n710 VSS.t202 2.31581
R2973 VSS.t74 VSS.n206 0.405951
R2974 VSS.t74 VSS.n254 0.405951
R2975 VSS.t74 VSS.n801 2.59384
R2976 VSS.t74 VSS.n348 0.405951
R2977 VSS.t74 VSS.n809 2.59384
R2978 VSS.t74 VSS.n803 2.59384
R2979 VSS.t74 VSS.n255 0.405951
R2980 VSS.t74 VSS.n345 0.405951
R2981 VSS.t74 VSS.n806 2.59384
R2982 VSS.t182 VSS.t88 2.28014
R2983 VSS.t202 VSS.n839 1.9764
R2984 VSS.n296 VSS.t378 0.469093
R2985 VSS.t74 VSS.n346 1.36065
R2986 VSS.t202 VSS.n770 1.55053
R2987 VSS.n805 VSS.t74 1.5297
R2988 VSS.t202 VSS.n720 1.21465
R2989 VSS.t79 VSS.n200 0.52707
R2990 VSS.t7 VSS.t88 1.21479
R2991 VSS.n291 VSS.t177 0.166042
R2992 VSS.n420 VSS.t364 1.17562
R2993 VSS.t202 VSS.t733 1.11521
R2994 VSS.n249 VSS.t243 0.966041
R2995 VSS.t357 VSS.n416 1.06249
R2996 VSS.n759 VSS.t700 1.09902
R2997 VSS.t137 VSS.t100 1.0986
R2998 VSS.t100 VSS.t89 1.09809
R2999 VSS.t7 VSS.t573 1.09033
R3000 VSS.t399 VSS.n410 0.0347326
R3001 VSS.t98 VSS.t137 1.05494
R3002 VSS.t487 VSS.t92 1.05077
R3003 VSS.t724 VSS.t729 1.05027
R3004 VSS.n760 VSS.t700 1.04972
R3005 VSS.t564 VSS.t559 1.04552
R3006 VSS.n878 VSS.t545 1.0417
R3007 VSS.n759 VSS.t705 1.0417
R3008 VSS.n738 VSS.t540 1.10306
R3009 VSS.n877 VSS.t554 1.03988
R3010 VSS.n758 VSS.t714 1.03988
R3011 VSS.t257 VSS.t695 1.02577
R3012 VSS.t724 VSS.t719 1.01852
R3013 VSS.t167 VSS.n292 0.716466
R3014 VSS.t564 VSS.t569 1.01593
R3015 VSS.t208 VSS.t487 1.00435
R3016 VSS.t92 VSS.t498 1.00301
R3017 VSS.t210 VSS.t502 1.00185
R3018 VSS.t14 VSS.t664 0.999012
R3019 VSS.n878 VSS.t540 0.981234
R3020 VSS.t545 VSS.n877 0.98027
R3021 VSS.t705 VSS.n758 0.98027
R3022 VSS.t77 VSS.t479 0.970325
R3023 VSS.n244 VSS.t103 0.799175
R3024 VSS.t98 VSS.n741 0.0387463
R3025 VSS.n428 VSS.t481 0.812701
R3026 VSS.n757 VSS.t719 0.94919
R3027 VSS.t498 VSS.t502 0.943498
R3028 VSS.n739 VSS.t32 1.00232
R3029 VSS.t664 VSS.n98 0.108019
R3030 VSS.t394 VSS.t399 0.890896
R3031 VSS.t7 VSS.n876 0.882204
R3032 VSS.t129 VSS.n249 0.801186
R3033 VSS.t81 VSS.n200 0.966952
R3034 VSS.n876 VSS.t559 0.834083
R3035 VSS.t513 VSS.t210 0.815879
R3036 VSS.t7 VSS.n292 0.522388
R3037 VSS.n244 VSS.t24 1.04047
R3038 VSS.n757 VSS.t714 0.800272
R3039 VSS.t37 VSS.t21 0.787488
R3040 VSS.t569 VSS.t573 0.767525
R3041 VSS.t7 VSS.n12 0.745378
R3042 VSS.t7 VSS.n13 0.745378
R3043 VSS.t49 VSS.t177 0.70011
R3044 VSS.t74 VSS.n420 0.587337
R3045 VSS.t554 VSS.n876 0.683332
R3046 VSS.t7 VSS.n1 0.666899
R3047 VSS.t7 VSS.n8 0.666899
R3048 VSS.t7 VSS.n7 0.666899
R3049 VSS.t71 VSS.t79 0.666031
R3050 VSS.t202 VSS.n758 0.663193
R3051 VSS.t7 VSS.n877 0.663193
R3052 VSS.t7 VSS.n738 0.557617
R3053 VSS.n757 VSS.t202 0.66315
R3054 VSS.t7 VSS.n0 0.655024
R3055 VSS.t202 VSS.n56 0.649813
R3056 VSS.t202 VSS.n59 0.649813
R3057 VSS.t202 VSS.n53 0.649813
R3058 VSS.t202 VSS.n52 0.649813
R3059 VSS.t202 VSS.n54 0.649813
R3060 VSS.t202 VSS.n55 0.649813
R3061 VSS.t202 VSS.n57 0.649813
R3062 VSS.t202 VSS.n58 0.649813
R3063 VSS.t202 VSS.t299 29.1846
R3064 VSS.t202 VSS.n61 0.649813
R3065 VSS.t202 VSS.n60 0.649813
R3066 VSS.n894 VSS.t202 0.649813
R3067 VSS.t202 VSS.n62 0.649813
R3068 VSS.t202 VSS.n65 0.649813
R3069 VSS.t202 VSS.n64 0.649813
R3070 VSS.t202 VSS.n63 0.649813
R3071 VSS.t202 VSS.n51 0.649813
R3072 VSS.t202 VSS.n50 0.649813
R3073 VSS.n191 VSS.t202 15.2045
R3074 VSS.t202 VSS.n49 0.649813
R3075 VSS.t202 VSS.n71 0.649813
R3076 VSS.t202 VSS.n70 0.649813
R3077 VSS.t202 VSS.n67 0.649813
R3078 VSS.t202 VSS.n66 0.649813
R3079 VSS.t202 VSS.n68 0.649813
R3080 VSS.t202 VSS.n69 0.649813
R3081 VSS.t202 VSS.n73 0.649813
R3082 VSS.t202 VSS.n72 0.649813
R3083 VSS.n818 VSS.t202 0.649813
R3084 VSS.t202 VSS.n97 8.48179
R3085 VSS.t202 VSS.n74 0.649813
R3086 VSS.t202 VSS.n78 0.649813
R3087 VSS.t202 VSS.n77 0.649813
R3088 VSS.t202 VSS.n75 0.649813
R3089 VSS.t202 VSS.n76 0.649813
R3090 VSS.n880 VSS.t7 0.649813
R3091 VSS.n883 VSS.t7 0.649813
R3092 VSS.t7 VSS.n5 0.649813
R3093 VSS.t7 VSS.n6 0.649813
R3094 VSS.t7 VSS.n3 0.649813
R3095 VSS.t7 VSS.n2 0.649813
R3096 VSS.t7 VSS.n11 0.649813
R3097 VSS.t7 VSS.n10 0.649813
R3098 VSS.t7 VSS.t166 41.887
R3099 VSS.t7 VSS.n4 0.648101
R3100 VSS.t7 VSS.n9 0.648101
R3101 VSS.t54 VSS.n304 0.577243
R3102 VSS.t729 VSS.t733 0.618689
R3103 VSS.t681 VSS.t56 0.618218
R3104 VSS.n720 VSS.t681 0.0879427
R3105 VSS.n839 VSS.t334 0.587502
R3106 VSS.t10 VSS.n288 0.537077
R3107 VSS.t481 VSS.n805 0.584297
R3108 VSS.n739 VSS.t7 0.474898
R3109 VSS.n208 VSS.t407 0.528388
R3110 VSS.n770 VSS.t683 0.560609
R3111 VSS.n346 VSS.t364 0.368617
R3112 VSS.t7 VSS.t3 0.504372
R3113 VSS.t77 VSS.n428 0.0509673
R3114 VSS.n770 VSS.t309 0.518891
R3115 VSS.t322 VSS.n296 0.480593
R3116 VSS.n839 VSS.t238 0.510159
R3117 VSS.t208 VSS.n805 0.495063
R3118 VSS.t202 VSS.n760 0.46263
R3119 VSS.t2 VSS.n719 0.545852
R3120 VSS.n719 VSS.t285 0.331967
R3121 VSS.t74 VSS.n416 0.369966
R3122 VSS.t7 VSS.t100 0.423349
R3123 VSS.t7 VSS.t564 0.423327
R3124 VSS.n189 VSS.t74 0.219075
R3125 VSS.n111 VSS.t74 0.219019
R3126 VSS.n112 VSS.t383 26.1049
R3127 VSS.n92 VSS.t398 26.1052
R3128 VSS.t74 VSS.n22 0.219077
R3129 VSS.n17 VSS.t406 47.2102
R3130 VSS.t74 VSS.n27 0.405951
R3131 VSS.t74 VSS.n26 0.405951
R3132 VSS.t74 VSS.n28 0.219018
R3133 VSS.n109 VSS.t430 26.1051
R3134 VSS.t74 VSS.n25 0.405951
R3135 VSS.t74 VSS.n24 0.405951
R3136 VSS.t74 VSS.n23 0.219019
R3137 VSS.n100 VSS.t452 26.1049
R3138 VSS.t74 VSS.n29 0.121827
R3139 VSS.n104 VSS.t74 0.219018
R3140 VSS.t74 VSS.n32 0.203603
R3141 VSS.t74 VSS.n31 0.405951
R3142 VSS.t74 VSS.n30 0.405951
R3143 VSS.t74 VSS.n47 0.405951
R3144 VSS.t74 VSS.n33 0.405951
R3145 VSS.t74 VSS.n45 0.219018
R3146 VSS.t74 VSS.n34 0.22519
R3147 VSS.n85 VSS.t489 47.2102
R3148 VSS.n21 VSS.t493 47.2101
R3149 VSS.t74 VSS.n42 0.405951
R3150 VSS.t74 VSS.n35 0.405951
R3151 VSS.t74 VSS.n40 0.219018
R3152 VSS.n169 VSS.t504 47.2102
R3153 VSS.t74 VSS.n36 0.225189
R3154 VSS.n20 VSS.t508 47.2101
R3155 VSS.t74 VSS.n38 0.405951
R3156 VSS.t74 VSS.n37 0.219073
R3157 VSS.t235 VSS.n274 0.379677
R3158 VSS.t2781 VSS.t2782 0.36115
R3159 VSS.n272 VSS.t2771 0.175714
R3160 VSS.t2765 VSS.n271 0.175714
R3161 VSS.t2760 VSS.n258 0.175714
R3162 VSS.t2755 VSS.t2756 0.36115
R3163 VSS.t2714 VSS.t2715 0.36115
R3164 VSS.t2720 VSS.n261 0.175714
R3165 VSS.t2726 VSS.n266 0.175714
R3166 VSS.t2732 VSS.n267 0.175714
R3167 VSS.t2738 VSS.t2739 0.36115
R3168 VSS.t2743 VSS.t2744 0.36115
R3169 VSS.t2748 VSS.t2749 0.36115
R3170 VSS.t2784 VSS.t2785 0.36115
R3171 VSS.t108 VSS.n290 0.175714
R3172 VSS.t1341 VSS.t1342 0.36115
R3173 VSS.t2715 VSS.n265 0.175554
R3174 VSS.t2721 VSS.t2722 0.360811
R3175 VSS.t2733 VSS.t2734 0.360811
R3176 VSS.t125 VSS.t158 0.360811
R3177 VSS.n289 VSS.t181 0.175554
R3178 VSS.t1338 VSS.t1337 0.360811
R3179 VSS.t1331 VSS.n211 0.175554
R3180 VSS.n278 VSS.t2784 0.175554
R3181 VSS.t2778 VSS.t2777 0.360811
R3182 VSS.t2770 VSS.t2769 0.360811
R3183 VSS.t2765 VSS.t2764 0.360811
R3184 VSS.t2757 VSS.t2758 0.360811
R3185 VSS.t2752 VSS.t2753 0.360811
R3186 VSS.t2747 VSS.n269 0.175554
R3187 VSS.t2742 VSS.n268 0.175554
R3188 VSS.t2737 VSS.n260 0.175554
R3189 VSS.t2731 VSS.t2732 0.360811
R3190 VSS.t2725 VSS.t2726 0.360811
R3191 VSS.n285 VSS.t58 0.235483
R3192 VSS.t147 VSS.t148 0.360471
R3193 VSS.t293 VSS.t292 0.360471
R3194 VSS.t109 VSS.t108 0.360471
R3195 VSS.t1336 VSS.t1337 0.360471
R3196 VSS.t2782 VSS.t2783 0.360471
R3197 VSS.t2776 VSS.n273 0.175395
R3198 VSS.t2771 VSS.t2772 0.360471
R3199 VSS.t2766 VSS.t2767 0.360471
R3200 VSS.t2761 VSS.t2762 0.360471
R3201 VSS.t2756 VSS.n270 0.175395
R3202 VSS.t2751 VSS.n259 0.175395
R3203 VSS.t2746 VSS.t2747 0.360471
R3204 VSS.t2741 VSS.t2742 0.360471
R3205 VSS.t2716 VSS.t2718 0.360471
R3206 VSS.n291 VSS.t258 0.929669
R3207 VSS.t669 VSS.t763 0.344973
R3208 VSS.t20 VSS.t781 0.344562
R3209 VSS.t676 VSS.n717 0.433869
R3210 VSS.n707 VSS.t686 0.433869
R3211 VSS.n708 VSS.t146 0.433709
R3212 VSS.t690 VSS.n710 0.433709
R3213 VSS.t693 VSS.n711 0.433709
R3214 VSS.n721 VSS.t56 0.238281
R3215 VSS.n734 VSS.t16 0.238005
R3216 VSS.n716 VSS.t673 0.433869
R3217 VSS.t285 VSS.n718 0.422619
R3218 VSS.t74 VSS.n410 0.266896
R3219 VSS.n359 VSS.t3015 0.0850573
R3220 VSS.n284 VSS.t2850 0.17801
R3221 VSS.t2740 VSS.t2741 0.301114
R3222 VSS.t2745 VSS.t2746 0.301114
R3223 VSS.t2750 VSS.t2751 0.301114
R3224 VSS.t1410 VSS.t1251 0.301114
R3225 VSS.t123 VSS.t66 0.301114
R3226 VSS.t1447 VSS.t1298 0.301114
R3227 VSS.t1279 VSS.t1280 0.301114
R3228 VSS.n634 VSS.t1397 0.118323
R3229 VSS.t1381 VSS.t1382 0.301114
R3230 VSS.n626 VSS.t1368 0.118323
R3231 VSS.n619 VSS.t1336 0.118323
R3232 VSS.t1469 VSS.n617 0.17801
R3233 VSS.n441 VSS.t2841 0.118323
R3234 VSS.n439 VSS.t2833 0.118323
R3235 VSS.n437 VSS.t2825 0.118323
R3236 VSS.n435 VSS.t2817 0.118323
R3237 VSS.n433 VSS.t2809 0.118323
R3238 VSS.n431 VSS.t2801 0.118323
R3239 VSS.n429 VSS.t2793 0.118323
R3240 VSS.t2778 VSS.n336 0.118323
R3241 VSS.t2861 VSS.t2862 0.301114
R3242 VSS.t2856 VSS.n444 0.118323
R3243 VSS.n736 VSS.t25 0.418597
R3244 VSS.t4 VSS.t81 0.301114
R3245 VSS.t2753 VSS.n282 0.118323
R3246 VSS.t2758 VSS.n338 0.118323
R3247 VSS.t1245 VSS.t1246 0.301114
R3248 VSS.n263 VSS.t276 0.17801
R3249 VSS.t160 VSS.n286 0.17801
R3250 VSS.t181 VSS.t362 0.301114
R3251 VSS.n298 VSS.t109 0.118323
R3252 VSS.t22 VSS.t113 0.301114
R3253 VSS.t1262 VSS.t1263 0.301114
R3254 VSS.t1309 VSS.t1310 0.301114
R3255 VSS.t1320 VSS.t1321 0.301114
R3256 VSS.n321 VSS.t1318 0.17801
R3257 VSS.t1292 VSS.t1293 0.301114
R3258 VSS.t1305 VSS.t1304 0.301114
R3259 VSS.t1285 VSS.t1286 0.301114
R3260 VSS.t1273 VSS.t1274 0.301114
R3261 VSS.t1270 VSS.t1271 0.301114
R3262 VSS.t1258 VSS.t1257 0.301114
R3263 VSS.n307 VSS.t1394 0.17801
R3264 VSS.t1376 VSS.n630 0.17801
R3265 VSS.n625 VSS.t1365 0.118323
R3266 VSS.n308 VSS.t1362 0.17801
R3267 VSS.t1353 VSS.n623 0.17801
R3268 VSS.t1344 VSS.n621 0.17801
R3269 VSS.n264 VSS.t1339 0.17801
R3270 VSS.t1330 VSS.t1331 0.301114
R3271 VSS.n616 VSS.t1324 0.118323
R3272 VSS.t2775 VSS.t2776 0.301114
R3273 VSS.t2772 VSS.t2773 0.301114
R3274 VSS.t2767 VSS.n337 0.118323
R3275 VSS.t2762 VSS.n283 0.118323
R3276 VSS.n343 VSS.t2718 0.118323
R3277 VSS.t2861 VSS.n207 0.118193
R3278 VSS.t2856 VSS.t2857 0.300775
R3279 VSS.t2739 VSS.n281 0.118193
R3280 VSS.t2744 VSS.n340 0.118193
R3281 VSS.t2749 VSS.n339 0.118193
R3282 VSS.t2785 VSS.t2786 0.300775
R3283 VSS.t2722 VSS.n280 0.118193
R3284 VSS.t2729 VSS.n342 0.118193
R3285 VSS.t2734 VSS.n341 0.118193
R3286 VSS.n213 VSS.t1252 0.177814
R3287 VSS.t152 VSS.t125 0.300775
R3288 VSS.n297 VSS.t123 0.118193
R3289 VSS.n277 VSS.t22 0.231997
R3290 VSS.t1263 VSS.t1264 0.300775
R3291 VSS.t1310 VSS.n202 0.118193
R3292 VSS.t1316 VSS.t1317 0.300775
R3293 VSS.t1286 VSS.t1287 0.300775
R3294 VSS.t1298 VSS.t1299 0.300775
R3295 VSS.t1303 VSS.t1304 0.300775
R3296 VSS.t1291 VSS.t1292 0.300775
R3297 VSS.t1278 VSS.t1279 0.300775
R3298 VSS.t1272 VSS.t1273 0.300775
R3299 VSS.t1269 VSS.t1270 0.300775
R3300 VSS.t1256 VSS.t1257 0.300775
R3301 VSS.t1244 VSS.t1245 0.300775
R3302 VSS.t1397 VSS.t1398 0.300775
R3303 VSS.t1392 VSS.t1393 0.300775
R3304 VSS.t1381 VSS.t1380 0.300775
R3305 VSS.t1377 VSS.t1515 0.300775
R3306 VSS.t1368 VSS.t1369 0.300775
R3307 VSS.t1365 VSS.t1366 0.300775
R3308 VSS.t1360 VSS.t1361 0.300775
R3309 VSS.t1354 VSS.t1495 0.300775
R3310 VSS.t1345 VSS.t1487 0.300775
R3311 VSS.t1342 VSS.n216 0.118193
R3312 VSS.n620 VSS.t1340 0.177814
R3313 VSS.t1333 VSS.t1334 0.300775
R3314 VSS.t1326 VSS.t1328 0.300775
R3315 VSS.t1325 VSS.t1324 0.300775
R3316 VSS.t2841 VSS.t2842 0.300775
R3317 VSS.t2833 VSS.t2834 0.300775
R3318 VSS.t2825 VSS.t2826 0.300775
R3319 VSS.t2817 VSS.t2818 0.300775
R3320 VSS.t2809 VSS.t2810 0.300775
R3321 VSS.t2801 VSS.t2802 0.300775
R3322 VSS.t2793 VSS.t2794 0.300775
R3323 VSS.t2780 VSS.n237 0.177814
R3324 VSS.t2768 VSS.t2769 0.300775
R3325 VSS.t2763 VSS.t2764 0.300775
R3326 VSS.t2759 VSS.t2760 0.300775
R3327 VSS.t2754 VSS.t2755 0.300775
R3328 VSS.t2736 VSS.t2737 0.300775
R3329 VSS.t2730 VSS.t2731 0.300775
R3330 VSS.t2724 VSS.t2725 0.300775
R3331 VSS.t2719 VSS.t2720 0.300775
R3332 VSS.t2712 VSS.t2713 0.300775
R3333 VSS.t2713 VSS.n262 0.177814
R3334 VSS.n236 VSS.t580 0.0929153
R3335 VSS.t425 VSS.n802 0.280761
R3336 VSS.n344 VSS.t2711 0.160271
R3337 VSS.n802 VSS.t357 0.25778
R3338 VSS.t162 VSS.t160 0.248068
R3339 VSS.t127 VSS.t162 0.244527
R3340 VSS.t2860 VSS.t2859 0.241078
R3341 VSS.t2851 VSS.t2850 0.241078
R3342 VSS.n335 VSS.t2787 0.119605
R3343 VSS.n332 VSS.t1242 0.119605
R3344 VSS.n245 VSS.t1253 0.119605
R3345 VSS.n646 VSS.t1262 0.119605
R3346 VSS.n232 VSS.t1265 0.119605
R3347 VSS.t1431 VSS.t1277 0.241078
R3348 VSS.n326 VSS.t1289 0.119605
R3349 VSS.t1450 VSS.t1300 0.241078
R3350 VSS.n638 VSS.t1309 0.119605
R3351 VSS.t1311 VSS.t1312 0.241078
R3352 VSS.n618 VSS.t1330 0.119605
R3353 VSS.t1484 VSS.t1344 0.241078
R3354 VSS.t1487 VSS.n309 0.119605
R3355 VSS.t1492 VSS.t1353 0.241078
R3356 VSS.n248 VSS.t1356 0.119605
R3357 VSS.t1507 VSS.n627 0.119605
R3358 VSS.t1512 VSS.t1376 0.241078
R3359 VSS.t1515 VSS.t1379 0.241078
R3360 VSS.t1522 VSS.n247 0.119605
R3361 VSS.t1532 VSS.t1399 0.241078
R3362 VSS.t2926 VSS.t2795 0.241078
R3363 VSS.t2934 VSS.t2803 0.241078
R3364 VSS.t2942 VSS.t2811 0.241078
R3365 VSS.t2950 VSS.t2819 0.241078
R3366 VSS.t2958 VSS.t2827 0.241078
R3367 VSS.t2966 VSS.t2835 0.241078
R3368 VSS.t2974 VSS.t2843 0.241078
R3369 VSS.n869 VSS.t12 0.241078
R3370 VSS.n737 VSS.t4 0.119605
R3371 VSS.t10 VSS.t30 0.241078
R3372 VSS.n445 VSS.t2859 0.119605
R3373 VSS.n252 VSS.t2858 0.119605
R3374 VSS.t2854 VSS.t2855 0.241078
R3375 VSS.n317 VSS.t2854 0.119605
R3376 VSS.t2851 VSS.n225 0.119605
R3377 VSS.t2852 VSS.t2853 0.241078
R3378 VSS.t2779 VSS.t2780 0.241078
R3379 VSS.t1242 VSS.t1243 0.241078
R3380 VSS.t1253 VSS.t1254 0.241078
R3381 VSS.n235 VSS.t1241 0.119605
R3382 VSS.t276 VSS.t272 0.241078
R3383 VSS.t131 VSS.t104 0.241078
R3384 VSS.n299 VSS.t104 0.235599
R3385 VSS.n869 VSS.t58 0.241078
R3386 VSS.t30 VSS.t318 0.241078
R3387 VSS.n714 VSS.t243 0.360183
R3388 VSS.t113 VSS.t35 0.241078
R3389 VSS.t1265 VSS.t1266 0.241078
R3390 VSS.n643 VSS.t1278 0.119605
R3391 VSS.n230 VSS.t1281 0.119605
R3392 VSS.t1289 VSS.t1290 0.241078
R3393 VSS.n324 VSS.t1301 0.119605
R3394 VSS.t1312 VSS.t1313 0.241078
R3395 VSS.n636 VSS.t1320 0.119605
R3396 VSS.t1318 VSS.t1319 0.241078
R3397 VSS.n637 VSS.t1316 0.119605
R3398 VSS.n322 VSS.t1314 0.119605
R3399 VSS.t1314 VSS.t1315 0.241078
R3400 VSS.t1308 VSS.t1457 0.241078
R3401 VSS.n323 VSS.t1308 0.119605
R3402 VSS.t1306 VSS.t1307 0.241078
R3403 VSS.n226 VSS.t1306 0.119605
R3404 VSS.t1301 VSS.t1302 0.241078
R3405 VSS.n639 VSS.t1303 0.119605
R3406 VSS.n227 VSS.t1450 0.119605
R3407 VSS.n640 VSS.t1447 0.119605
R3408 VSS.t1296 VSS.t1297 0.241078
R3409 VSS.n325 VSS.t1296 0.119605
R3410 VSS.n228 VSS.t1294 0.119605
R3411 VSS.t1294 VSS.t1295 0.241078
R3412 VSS.n641 VSS.t1291 0.119605
R3413 VSS.t1288 VSS.t1440 0.241078
R3414 VSS.n229 VSS.t1288 0.119605
R3415 VSS.n642 VSS.t1285 0.119605
R3416 VSS.t1283 VSS.t1284 0.241078
R3417 VSS.t1281 VSS.t1282 0.241078
R3418 VSS.n327 VSS.t1283 0.119605
R3419 VSS.n328 VSS.t1431 0.119605
R3420 VSS.t1275 VSS.t1276 0.241078
R3421 VSS.n231 VSS.t1275 0.119605
R3422 VSS.n644 VSS.t1272 0.119605
R3423 VSS.n645 VSS.t1269 0.119605
R3424 VSS.n329 VSS.t1267 0.119605
R3425 VSS.t1267 VSS.t1268 0.241078
R3426 VSS.t1261 VSS.t1420 0.241078
R3427 VSS.n330 VSS.t1261 0.119605
R3428 VSS.t1259 VSS.t1260 0.241078
R3429 VSS.n233 VSS.t1259 0.119605
R3430 VSS.t1252 VSS.t1413 0.241078
R3431 VSS.n648 VSS.t1410 0.119605
R3432 VSS.t1249 VSS.t1250 0.241078
R3433 VSS.n331 VSS.t1249 0.119605
R3434 VSS.n234 VSS.t1247 0.119605
R3435 VSS.t1247 VSS.t1248 0.241078
R3436 VSS.n649 VSS.t1244 0.119605
R3437 VSS.t1241 VSS.t1403 0.241078
R3438 VSS.t1469 VSS.t1325 0.241078
R3439 VSS.t1347 VSS.t1348 0.241078
R3440 VSS.t1356 VSS.t1357 0.241078
R3441 VSS.t1370 VSS.t1371 0.241078
R3442 VSS.n631 VSS.t1380 0.119605
R3443 VSS.n319 VSS.t1383 0.119605
R3444 VSS.t1388 VSS.t1389 0.241078
R3445 VSS.t1399 VSS.n635 0.119605
R3446 VSS.n212 VSS.t1532 0.119605
R3447 VSS.t1396 VSS.t1529 0.241078
R3448 VSS.n320 VSS.t1396 0.119605
R3449 VSS.t1394 VSS.t1395 0.241078
R3450 VSS.t1391 VSS.t1392 0.241078
R3451 VSS.t1389 VSS.t1390 0.241078
R3452 VSS.n633 VSS.t1391 0.119605
R3453 VSS.n334 VSS.t1521 0.119605
R3454 VSS.t1385 VSS.t1386 0.241078
R3455 VSS.t1383 VSS.t1384 0.241078
R3456 VSS.n632 VSS.t1385 0.119605
R3457 VSS.t1375 VSS.t1512 0.241078
R3458 VSS.n629 VSS.t1375 0.119605
R3459 VSS.t1373 VSS.t1374 0.241078
R3460 VSS.t1371 VSS.t1372 0.241078
R3461 VSS.t1372 VSS.n628 0.119605
R3462 VSS.t1369 VSS.t1507 0.241078
R3463 VSS.t1367 VSS.t1504 0.241078
R3464 VSS.n250 VSS.t1367 0.119605
R3465 VSS.t1363 VSS.t1364 0.241078
R3466 VSS.t1362 VSS.t1363 0.241078
R3467 VSS.t1359 VSS.t1360 0.241078
R3468 VSS.t1357 VSS.t1358 0.241078
R3469 VSS.n624 VSS.t1359 0.119605
R3470 VSS.t1352 VSS.t1492 0.241078
R3471 VSS.n622 VSS.t1352 0.119605
R3472 VSS.t1350 VSS.t1351 0.241078
R3473 VSS.t1348 VSS.t1349 0.241078
R3474 VSS.t1349 VSS.n246 0.119605
R3475 VSS.t1339 VSS.t1340 0.241078
R3476 VSS.t1335 VSS.t1477 0.241078
R3477 VSS.n257 VSS.t1335 0.119605
R3478 VSS.t1329 VSS.t1472 0.241078
R3479 VSS.n251 VSS.t1329 0.119605
R3480 VSS.n430 VSS.t2796 0.119605
R3481 VSS.n432 VSS.t2804 0.119605
R3482 VSS.n434 VSS.t2812 0.119605
R3483 VSS.n436 VSS.t2820 0.119605
R3484 VSS.n438 VSS.t2828 0.119605
R3485 VSS.n440 VSS.t2836 0.119605
R3486 VSS.n442 VSS.t2844 0.119605
R3487 VSS.n443 VSS.t2847 0.119605
R3488 VSS.t2844 VSS.t2845 0.241078
R3489 VSS.t2845 VSS.t2846 0.241078
R3490 VSS.n253 VSS.t2974 0.119605
R3491 VSS.t2840 VSS.t2971 0.241078
R3492 VSS.n316 VSS.t2840 0.119605
R3493 VSS.t2838 VSS.t2839 0.241078
R3494 VSS.t2836 VSS.t2837 0.241078
R3495 VSS.n224 VSS.t2838 0.119605
R3496 VSS.n243 VSS.t2966 0.119605
R3497 VSS.t2832 VSS.t2963 0.241078
R3498 VSS.n315 VSS.t2832 0.119605
R3499 VSS.t2830 VSS.t2831 0.241078
R3500 VSS.t2828 VSS.t2829 0.241078
R3501 VSS.n223 VSS.t2830 0.119605
R3502 VSS.n242 VSS.t2958 0.119605
R3503 VSS.t2824 VSS.t2955 0.241078
R3504 VSS.n314 VSS.t2824 0.119605
R3505 VSS.t2822 VSS.t2823 0.241078
R3506 VSS.t2820 VSS.t2821 0.241078
R3507 VSS.n222 VSS.t2822 0.119605
R3508 VSS.n241 VSS.t2950 0.119605
R3509 VSS.t2816 VSS.t2947 0.241078
R3510 VSS.n313 VSS.t2816 0.119605
R3511 VSS.t2814 VSS.t2815 0.241078
R3512 VSS.t2812 VSS.t2813 0.241078
R3513 VSS.n221 VSS.t2814 0.119605
R3514 VSS.n240 VSS.t2942 0.119605
R3515 VSS.t2808 VSS.t2939 0.241078
R3516 VSS.n312 VSS.t2808 0.119605
R3517 VSS.t2806 VSS.t2807 0.241078
R3518 VSS.t2804 VSS.t2805 0.241078
R3519 VSS.n220 VSS.t2806 0.119605
R3520 VSS.n239 VSS.t2934 0.119605
R3521 VSS.t2800 VSS.t2931 0.241078
R3522 VSS.n311 VSS.t2800 0.119605
R3523 VSS.t2798 VSS.t2799 0.241078
R3524 VSS.t2796 VSS.t2797 0.241078
R3525 VSS.n219 VSS.t2798 0.119605
R3526 VSS.n238 VSS.t2926 0.119605
R3527 VSS.t2792 VSS.t2923 0.241078
R3528 VSS.n310 VSS.t2792 0.119605
R3529 VSS.t2790 VSS.t2791 0.241078
R3530 VSS.t2788 VSS.t2789 0.241078
R3531 VSS.n218 VSS.t2790 0.119605
R3532 VSS.t2847 VSS.t2978 0.241078
R3533 VSS.t2774 VSS.t2775 0.241078
R3534 VSS.n447 VSS.t2774 0.119605
R3535 VSS.t2849 VSS.n353 0.240486
R3536 VSS.t1678 VSS.t1676 0.233225
R3537 VSS.t989 VSS.t991 0.233225
R3538 VSS.t2068 VSS.t2070 0.233225
R3539 VSS.t2462 VSS.t2460 0.233225
R3540 VSS.t391 VSS.n745 0.135296
R3541 VSS.t382 VSS.n744 0.135296
R3542 VSS.t376 VSS.n746 0.135296
R3543 VSS.t331 VSS.t662 0.227075
R3544 VSS.t129 VSS.t63 0.227075
R3545 VSS.n418 VSS.t434 0.135296
R3546 VSS.n419 VSS.t439 0.135296
R3547 VSS.n423 VSS.t456 0.135296
R3548 VSS.n424 VSS.t461 0.135296
R3549 VSS.n425 VSS.t467 0.135296
R3550 VSS.n426 VSS.t472 0.135296
R3551 VSS.n427 VSS.t477 0.135296
R3552 VSS.n421 VSS.t446 0.135296
R3553 VSS.n417 VSS.t429 0.135296
R3554 VSS.n415 VSS.t425 0.135296
R3555 VSS.n414 VSS.t420 0.135296
R3556 VSS.n413 VSS.t415 0.135296
R3557 VSS.n412 VSS.t410 0.135296
R3558 VSS.n411 VSS.t404 0.135296
R3559 VSS.t796 VSS.t173 0.227075
R3560 VSS.t2990 VSS.t2992 0.226736
R3561 VSS.t2997 VSS.t2995 0.226736
R3562 VSS.t3000 VSS.t3002 0.226736
R3563 VSS.t3007 VSS.t3005 0.226736
R3564 VSS.t3010 VSS.t3012 0.226736
R3565 VSS.t3240 VSS.t3242 0.226736
R3566 VSS.t3247 VSS.t3245 0.226736
R3567 VSS.t3250 VSS.t3252 0.226736
R3568 VSS.t3257 VSS.t3255 0.226736
R3569 VSS.t3260 VSS.t3262 0.226736
R3570 VSS.t3267 VSS.t3265 0.226736
R3571 VSS.t3235 VSS.t3237 0.226736
R3572 VSS.t3230 VSS.t3232 0.226736
R3573 VSS.t3225 VSS.t3227 0.226736
R3574 VSS.t3220 VSS.t3222 0.226736
R3575 VSS.t3215 VSS.t3217 0.226736
R3576 VSS.t3210 VSS.t3212 0.226736
R3577 VSS.t3205 VSS.t3207 0.226736
R3578 VSS.t3200 VSS.t3202 0.226736
R3579 VSS.t3195 VSS.t3197 0.226736
R3580 VSS.t3190 VSS.t3192 0.226736
R3581 VSS.t3185 VSS.t3187 0.226736
R3582 VSS.t3180 VSS.t3182 0.226736
R3583 VSS.t3175 VSS.t3177 0.226736
R3584 VSS.t3170 VSS.t3172 0.226736
R3585 VSS.t3165 VSS.t3167 0.226736
R3586 VSS.t3160 VSS.t3162 0.226736
R3587 VSS.t3155 VSS.t3157 0.226736
R3588 VSS.t3150 VSS.t3152 0.226736
R3589 VSS.t3145 VSS.t3147 0.226736
R3590 VSS.t3140 VSS.t3142 0.226736
R3591 VSS.t3135 VSS.t3137 0.226736
R3592 VSS.t3125 VSS.t3127 0.226736
R3593 VSS.t3120 VSS.t3122 0.226736
R3594 VSS.t3115 VSS.t3117 0.226736
R3595 VSS.t3110 VSS.t3112 0.226736
R3596 VSS.t3105 VSS.t3107 0.226736
R3597 VSS.t3100 VSS.t3102 0.226736
R3598 VSS.t3095 VSS.t3097 0.226736
R3599 VSS.t3090 VSS.t3092 0.226736
R3600 VSS.t3085 VSS.t3087 0.226736
R3601 VSS.t3080 VSS.t3082 0.226736
R3602 VSS.t3075 VSS.t3077 0.226736
R3603 VSS.t3070 VSS.t3072 0.226736
R3604 VSS.t3065 VSS.t3067 0.226736
R3605 VSS.t3060 VSS.t3062 0.226736
R3606 VSS.t3055 VSS.t3057 0.226736
R3607 VSS.t3050 VSS.t3052 0.226736
R3608 VSS.t3045 VSS.t3047 0.226736
R3609 VSS.t3040 VSS.t3042 0.226736
R3610 VSS.t3035 VSS.t3037 0.226736
R3611 VSS.t3030 VSS.t3032 0.226736
R3612 VSS.t3025 VSS.t3027 0.226736
R3613 VSS.t3022 VSS.t3020 0.226736
R3614 VSS.t2322 VSS.t2320 0.226736
R3615 VSS.t2327 VSS.t2325 0.226736
R3616 VSS.t2332 VSS.t2330 0.226736
R3617 VSS.t2337 VSS.t2335 0.226736
R3618 VSS.t2342 VSS.t2340 0.226736
R3619 VSS.t2347 VSS.t2345 0.226736
R3620 VSS.t2352 VSS.t2350 0.226736
R3621 VSS.t2357 VSS.t2355 0.226736
R3622 VSS.t2362 VSS.t2360 0.226736
R3623 VSS.t2367 VSS.t2365 0.226736
R3624 VSS.t2372 VSS.t2370 0.226736
R3625 VSS.t2377 VSS.t2375 0.226736
R3626 VSS.t2382 VSS.t2380 0.226736
R3627 VSS.t2387 VSS.t2385 0.226736
R3628 VSS.t2392 VSS.t2390 0.226736
R3629 VSS.t2397 VSS.t2395 0.226736
R3630 VSS.t2402 VSS.t2400 0.226736
R3631 VSS.t2407 VSS.t2405 0.226736
R3632 VSS.t2412 VSS.t2410 0.226736
R3633 VSS.t2417 VSS.t2415 0.226736
R3634 VSS.t2422 VSS.t2420 0.226736
R3635 VSS.t2427 VSS.t2425 0.226736
R3636 VSS.t2432 VSS.t2430 0.226736
R3637 VSS.t2437 VSS.t2435 0.226736
R3638 VSS.t2442 VSS.t2440 0.226736
R3639 VSS.t2447 VSS.t2445 0.226736
R3640 VSS.t2452 VSS.t2450 0.226736
R3641 VSS.t2457 VSS.t2455 0.226736
R3642 VSS.t2465 VSS.t2467 0.226736
R3643 VSS.t2472 VSS.t2470 0.226736
R3644 VSS.t2475 VSS.t2477 0.226736
R3645 VSS.t2482 VSS.t2480 0.226736
R3646 VSS.t2485 VSS.t2487 0.226736
R3647 VSS.t2492 VSS.t2490 0.226736
R3648 VSS.t2495 VSS.t2497 0.226736
R3649 VSS.t2502 VSS.t2500 0.226736
R3650 VSS.t2505 VSS.t2507 0.226736
R3651 VSS.t2512 VSS.t2510 0.226736
R3652 VSS.t2515 VSS.t2517 0.226736
R3653 VSS.t2522 VSS.t2520 0.226736
R3654 VSS.t2525 VSS.t2527 0.226736
R3655 VSS.t2532 VSS.t2530 0.226736
R3656 VSS.t2535 VSS.t2537 0.226736
R3657 VSS.t2542 VSS.t2540 0.226736
R3658 VSS.t2545 VSS.t2547 0.226736
R3659 VSS.t2552 VSS.t2550 0.226736
R3660 VSS.t2555 VSS.t2557 0.226736
R3661 VSS.t2562 VSS.t2560 0.226736
R3662 VSS.t2565 VSS.t2567 0.226736
R3663 VSS.t2572 VSS.t2570 0.226736
R3664 VSS.t2575 VSS.t2577 0.226736
R3665 VSS.t2582 VSS.t2580 0.226736
R3666 VSS.t2585 VSS.t2587 0.226736
R3667 VSS.t2592 VSS.t2590 0.226736
R3668 VSS.t2595 VSS.t2597 0.226736
R3669 VSS.t1928 VSS.t1930 0.226736
R3670 VSS.t1935 VSS.t1933 0.226736
R3671 VSS.t1938 VSS.t1940 0.226736
R3672 VSS.t1945 VSS.t1943 0.226736
R3673 VSS.t1948 VSS.t1950 0.226736
R3674 VSS.t1955 VSS.t1953 0.226736
R3675 VSS.t1960 VSS.t1958 0.226736
R3676 VSS.t1963 VSS.t1965 0.226736
R3677 VSS.t1970 VSS.t1968 0.226736
R3678 VSS.t1973 VSS.t1975 0.226736
R3679 VSS.t1980 VSS.t1978 0.226736
R3680 VSS.t1983 VSS.t1985 0.226736
R3681 VSS.t1990 VSS.t1988 0.226736
R3682 VSS.t1993 VSS.t1995 0.226736
R3683 VSS.t2000 VSS.t1998 0.226736
R3684 VSS.t2003 VSS.t2005 0.226736
R3685 VSS.t2010 VSS.t2008 0.226736
R3686 VSS.t2013 VSS.t2015 0.226736
R3687 VSS.t2020 VSS.t2018 0.226736
R3688 VSS.t2023 VSS.t2025 0.226736
R3689 VSS.t2030 VSS.t2028 0.226736
R3690 VSS.t2033 VSS.t2035 0.226736
R3691 VSS.t2040 VSS.t2038 0.226736
R3692 VSS.t2043 VSS.t2045 0.226736
R3693 VSS.t2050 VSS.t2048 0.226736
R3694 VSS.t2053 VSS.t2055 0.226736
R3695 VSS.t2060 VSS.t2058 0.226736
R3696 VSS.t2063 VSS.t2065 0.226736
R3697 VSS.t2073 VSS.t2075 0.226736
R3698 VSS.t2080 VSS.t2078 0.226736
R3699 VSS.t2083 VSS.t2085 0.226736
R3700 VSS.t2090 VSS.t2088 0.226736
R3701 VSS.t2093 VSS.t2095 0.226736
R3702 VSS.t2100 VSS.t2098 0.226736
R3703 VSS.t2103 VSS.t2105 0.226736
R3704 VSS.t2110 VSS.t2108 0.226736
R3705 VSS.t2113 VSS.t2115 0.226736
R3706 VSS.t2120 VSS.t2118 0.226736
R3707 VSS.t2123 VSS.t2125 0.226736
R3708 VSS.t2130 VSS.t2128 0.226736
R3709 VSS.t2133 VSS.t2135 0.226736
R3710 VSS.t2140 VSS.t2138 0.226736
R3711 VSS.t2143 VSS.t2145 0.226736
R3712 VSS.t2150 VSS.t2148 0.226736
R3713 VSS.t2153 VSS.t2155 0.226736
R3714 VSS.t2160 VSS.t2158 0.226736
R3715 VSS.t2163 VSS.t2165 0.226736
R3716 VSS.t2170 VSS.t2168 0.226736
R3717 VSS.t2173 VSS.t2175 0.226736
R3718 VSS.t2180 VSS.t2178 0.226736
R3719 VSS.t2183 VSS.t2185 0.226736
R3720 VSS.t2190 VSS.t2188 0.226736
R3721 VSS.t2193 VSS.t2195 0.226736
R3722 VSS.t2200 VSS.t2198 0.226736
R3723 VSS.t2203 VSS.t2205 0.226736
R3724 VSS.t1536 VSS.t1538 0.226736
R3725 VSS.t1543 VSS.t1541 0.226736
R3726 VSS.t1546 VSS.t1548 0.226736
R3727 VSS.t1553 VSS.t1551 0.226736
R3728 VSS.t1556 VSS.t1558 0.226736
R3729 VSS.t1563 VSS.t1561 0.226736
R3730 VSS.t1566 VSS.t1568 0.226736
R3731 VSS.t1573 VSS.t1571 0.226736
R3732 VSS.t1576 VSS.t1578 0.226736
R3733 VSS.t1583 VSS.t1581 0.226736
R3734 VSS.t1586 VSS.t1588 0.226736
R3735 VSS.t1593 VSS.t1591 0.226736
R3736 VSS.t1596 VSS.t1598 0.226736
R3737 VSS.t1603 VSS.t1601 0.226736
R3738 VSS.t1606 VSS.t1608 0.226736
R3739 VSS.t1613 VSS.t1611 0.226736
R3740 VSS.t1616 VSS.t1618 0.226736
R3741 VSS.t1623 VSS.t1621 0.226736
R3742 VSS.t1626 VSS.t1628 0.226736
R3743 VSS.t1633 VSS.t1631 0.226736
R3744 VSS.t1636 VSS.t1638 0.226736
R3745 VSS.t1643 VSS.t1641 0.226736
R3746 VSS.t1646 VSS.t1648 0.226736
R3747 VSS.t1653 VSS.t1651 0.226736
R3748 VSS.t1656 VSS.t1658 0.226736
R3749 VSS.t1663 VSS.t1661 0.226736
R3750 VSS.t1666 VSS.t1668 0.226736
R3751 VSS.t1673 VSS.t1671 0.226736
R3752 VSS.t1683 VSS.t1681 0.226736
R3753 VSS.t1688 VSS.t1686 0.226736
R3754 VSS.t1693 VSS.t1691 0.226736
R3755 VSS.t1698 VSS.t1696 0.226736
R3756 VSS.t1703 VSS.t1701 0.226736
R3757 VSS.t1708 VSS.t1706 0.226736
R3758 VSS.t1713 VSS.t1711 0.226736
R3759 VSS.t1718 VSS.t1716 0.226736
R3760 VSS.t1723 VSS.t1721 0.226736
R3761 VSS.t1728 VSS.t1726 0.226736
R3762 VSS.t1733 VSS.t1731 0.226736
R3763 VSS.t1738 VSS.t1736 0.226736
R3764 VSS.t1743 VSS.t1741 0.226736
R3765 VSS.t1748 VSS.t1746 0.226736
R3766 VSS.t1753 VSS.t1751 0.226736
R3767 VSS.t1758 VSS.t1756 0.226736
R3768 VSS.t1763 VSS.t1761 0.226736
R3769 VSS.t1768 VSS.t1766 0.226736
R3770 VSS.t1773 VSS.t1771 0.226736
R3771 VSS.t1778 VSS.t1776 0.226736
R3772 VSS.t1783 VSS.t1781 0.226736
R3773 VSS.t1788 VSS.t1786 0.226736
R3774 VSS.t1793 VSS.t1791 0.226736
R3775 VSS.t1796 VSS.t1798 0.226736
R3776 VSS.t1803 VSS.t1801 0.226736
R3777 VSS.t1806 VSS.t1808 0.226736
R3778 VSS.t1813 VSS.t1811 0.226736
R3779 VSS.t851 VSS.t849 0.226736
R3780 VSS.t856 VSS.t854 0.226736
R3781 VSS.t861 VSS.t859 0.226736
R3782 VSS.t866 VSS.t864 0.226736
R3783 VSS.t871 VSS.t869 0.226736
R3784 VSS.t876 VSS.t874 0.226736
R3785 VSS.t881 VSS.t879 0.226736
R3786 VSS.t884 VSS.t886 0.226736
R3787 VSS.t891 VSS.t889 0.226736
R3788 VSS.t894 VSS.t896 0.226736
R3789 VSS.t901 VSS.t899 0.226736
R3790 VSS.t904 VSS.t906 0.226736
R3791 VSS.t911 VSS.t909 0.226736
R3792 VSS.t914 VSS.t916 0.226736
R3793 VSS.t921 VSS.t919 0.226736
R3794 VSS.t924 VSS.t926 0.226736
R3795 VSS.t931 VSS.t929 0.226736
R3796 VSS.t934 VSS.t936 0.226736
R3797 VSS.t941 VSS.t939 0.226736
R3798 VSS.t944 VSS.t946 0.226736
R3799 VSS.t951 VSS.t949 0.226736
R3800 VSS.t954 VSS.t956 0.226736
R3801 VSS.t961 VSS.t959 0.226736
R3802 VSS.t964 VSS.t966 0.226736
R3803 VSS.t971 VSS.t969 0.226736
R3804 VSS.t974 VSS.t976 0.226736
R3805 VSS.t981 VSS.t979 0.226736
R3806 VSS.t984 VSS.t986 0.226736
R3807 VSS.t994 VSS.t996 0.226736
R3808 VSS.t1001 VSS.t999 0.226736
R3809 VSS.t1004 VSS.t1006 0.226736
R3810 VSS.t1011 VSS.t1009 0.226736
R3811 VSS.t1014 VSS.t1016 0.226736
R3812 VSS.t1021 VSS.t1019 0.226736
R3813 VSS.t1024 VSS.t1026 0.226736
R3814 VSS.t1031 VSS.t1029 0.226736
R3815 VSS.t1034 VSS.t1036 0.226736
R3816 VSS.t1041 VSS.t1039 0.226736
R3817 VSS.t1044 VSS.t1046 0.226736
R3818 VSS.t1051 VSS.t1049 0.226736
R3819 VSS.t1054 VSS.t1056 0.226736
R3820 VSS.t1061 VSS.t1059 0.226736
R3821 VSS.t1064 VSS.t1066 0.226736
R3822 VSS.t1071 VSS.t1069 0.226736
R3823 VSS.t1074 VSS.t1076 0.226736
R3824 VSS.t1081 VSS.t1079 0.226736
R3825 VSS.t1084 VSS.t1086 0.226736
R3826 VSS.t1091 VSS.t1089 0.226736
R3827 VSS.t1094 VSS.t1096 0.226736
R3828 VSS.t1101 VSS.t1099 0.226736
R3829 VSS.t1104 VSS.t1106 0.226736
R3830 VSS.t1111 VSS.t1109 0.226736
R3831 VSS.t1114 VSS.t1116 0.226736
R3832 VSS.t1121 VSS.t1119 0.226736
R3833 VSS.t1124 VSS.t1126 0.226736
R3834 VSS.t809 VSS.t807 0.226736
R3835 VSS.t622 VSS.t624 0.226736
R3836 VSS.t629 VSS.t627 0.226736
R3837 VSS.t632 VSS.t634 0.226736
R3838 VSS.t639 VSS.t637 0.226736
R3839 VSS.t642 VSS.t644 0.226736
R3840 VSS.t649 VSS.t647 0.226736
R3841 VSS.t652 VSS.t654 0.226736
R3842 VSS.t659 VSS.t657 0.226736
R3843 VSS.t524 VSS.t522 0.226736
R3844 VSS.t517 VSS.t167 0.226736
R3845 VSS.t531 VSS.t530 0.226736
R3846 VSS.t16 VSS.t760 0.226736
R3847 VSS.t351 VSS.t811 0.226736
R3848 VSS.t671 VSS.t766 0.224575
R3849 VSS.t385 VSS.n295 0.150915
R3850 VSS.n733 VSS.t14 0.130189
R3851 VSS.n361 VSS.t3025 0.0863258
R3852 VSS.n362 VSS.t3030 0.0863258
R3853 VSS.n363 VSS.t3035 0.0863258
R3854 VSS.n364 VSS.t3040 0.0863258
R3855 VSS.n365 VSS.t3045 0.0863258
R3856 VSS.n366 VSS.t3050 0.0863258
R3857 VSS.n367 VSS.t3055 0.0863258
R3858 VSS.n368 VSS.t3060 0.0863258
R3859 VSS.n369 VSS.t3065 0.0863258
R3860 VSS.n370 VSS.t3070 0.0863258
R3861 VSS.n371 VSS.t3075 0.0863258
R3862 VSS.n372 VSS.t3080 0.0863258
R3863 VSS.n373 VSS.t3085 0.0863258
R3864 VSS.n374 VSS.t3090 0.0863258
R3865 VSS.n375 VSS.t3095 0.0863258
R3866 VSS.n376 VSS.t3100 0.0863258
R3867 VSS.n377 VSS.t3105 0.0863258
R3868 VSS.n378 VSS.t3110 0.0863258
R3869 VSS.n379 VSS.t3115 0.0863258
R3870 VSS.n380 VSS.t3120 0.0863258
R3871 VSS.n381 VSS.t3125 0.0863258
R3872 VSS.n383 VSS.t3135 0.0863258
R3873 VSS.n384 VSS.t3140 0.0863258
R3874 VSS.n385 VSS.t3145 0.0863258
R3875 VSS.n386 VSS.t3150 0.0863258
R3876 VSS.n387 VSS.t3155 0.0863258
R3877 VSS.n388 VSS.t3160 0.0863258
R3878 VSS.n389 VSS.t3165 0.0863258
R3879 VSS.n390 VSS.t3170 0.0863258
R3880 VSS.n391 VSS.t3175 0.0863258
R3881 VSS.n392 VSS.t3180 0.0863258
R3882 VSS.n393 VSS.t3185 0.0863258
R3883 VSS.n394 VSS.t3190 0.0863258
R3884 VSS.n395 VSS.t3195 0.0863258
R3885 VSS.n396 VSS.t3200 0.0863258
R3886 VSS.n397 VSS.t3205 0.0863258
R3887 VSS.n398 VSS.t3210 0.0863258
R3888 VSS.n399 VSS.t3215 0.0863258
R3889 VSS.n400 VSS.t3220 0.0863258
R3890 VSS.n401 VSS.t3225 0.0863258
R3891 VSS.n402 VSS.t3230 0.0863258
R3892 VSS.n403 VSS.t3235 0.0863258
R3893 VSS.n404 VSS.t3240 0.0863258
R3894 VSS.n477 VSS.t2465 0.0863258
R3895 VSS.n479 VSS.t2475 0.0863258
R3896 VSS.n481 VSS.t2485 0.0863258
R3897 VSS.n483 VSS.t2495 0.0863258
R3898 VSS.n485 VSS.t2505 0.0863258
R3899 VSS.n487 VSS.t2515 0.0863258
R3900 VSS.n489 VSS.t2525 0.0863258
R3901 VSS.n491 VSS.t2535 0.0863258
R3902 VSS.n493 VSS.t2545 0.0863258
R3903 VSS.n495 VSS.t2555 0.0863258
R3904 VSS.n497 VSS.t2565 0.0863258
R3905 VSS.n499 VSS.t2575 0.0863258
R3906 VSS.n501 VSS.t2585 0.0863258
R3907 VSS.n503 VSS.t2595 0.0863258
R3908 VSS.t2590 VSS.n502 0.0863258
R3909 VSS.t2580 VSS.n500 0.0863258
R3910 VSS.t2570 VSS.n498 0.0863258
R3911 VSS.t2560 VSS.n496 0.0863258
R3912 VSS.t2550 VSS.n494 0.0863258
R3913 VSS.t2540 VSS.n492 0.0863258
R3914 VSS.t2530 VSS.n490 0.0863258
R3915 VSS.t2520 VSS.n488 0.0863258
R3916 VSS.t2510 VSS.n486 0.0863258
R3917 VSS.t2500 VSS.n484 0.0863258
R3918 VSS.t2490 VSS.n482 0.0863258
R3919 VSS.t2480 VSS.n480 0.0863258
R3920 VSS.t2470 VSS.n478 0.0863258
R3921 VSS.t2455 VSS.n475 0.0863258
R3922 VSS.n448 VSS.t2319 0.130189
R3923 VSS.t2325 VSS.n449 0.0863258
R3924 VSS.t2330 VSS.n450 0.0863258
R3925 VSS.t2335 VSS.n451 0.0863258
R3926 VSS.t2340 VSS.n452 0.0863258
R3927 VSS.t2345 VSS.n453 0.0863258
R3928 VSS.n511 VSS.t1963 0.0863258
R3929 VSS.n513 VSS.t1973 0.0863258
R3930 VSS.n515 VSS.t1983 0.0863258
R3931 VSS.n517 VSS.t1993 0.0863258
R3932 VSS.n519 VSS.t2003 0.0863258
R3933 VSS.n521 VSS.t2013 0.0863258
R3934 VSS.n523 VSS.t2023 0.0863258
R3935 VSS.n525 VSS.t2033 0.0863258
R3936 VSS.n527 VSS.t2043 0.0863258
R3937 VSS.n529 VSS.t2053 0.0863258
R3938 VSS.n531 VSS.t2063 0.0863258
R3939 VSS.n533 VSS.t2073 0.0863258
R3940 VSS.n535 VSS.t2083 0.0863258
R3941 VSS.n537 VSS.t2093 0.0863258
R3942 VSS.n539 VSS.t2103 0.0863258
R3943 VSS.n541 VSS.t2113 0.0863258
R3944 VSS.n543 VSS.t2123 0.0863258
R3945 VSS.n545 VSS.t2133 0.0863258
R3946 VSS.n547 VSS.t2143 0.0863258
R3947 VSS.n549 VSS.t2153 0.0863258
R3948 VSS.n551 VSS.t2163 0.0863258
R3949 VSS.n553 VSS.t2173 0.0863258
R3950 VSS.n612 VSS.t1796 0.0863258
R3951 VSS.n614 VSS.t1806 0.0863258
R3952 VSS.t1811 VSS.n615 0.0863258
R3953 VSS.t1801 VSS.n613 0.0863258
R3954 VSS.t1791 VSS.n611 0.0863258
R3955 VSS.n657 VSS.t884 0.0863258
R3956 VSS.n659 VSS.t894 0.0863258
R3957 VSS.n661 VSS.t904 0.0863258
R3958 VSS.n663 VSS.t914 0.0863258
R3959 VSS.n665 VSS.t924 0.0863258
R3960 VSS.n667 VSS.t934 0.0863258
R3961 VSS.n669 VSS.t944 0.0863258
R3962 VSS.n671 VSS.t954 0.0863258
R3963 VSS.n673 VSS.t964 0.0863258
R3964 VSS.n675 VSS.t974 0.0863258
R3965 VSS.n677 VSS.t984 0.0863258
R3966 VSS.n679 VSS.t994 0.0863258
R3967 VSS.n681 VSS.t1004 0.0863258
R3968 VSS.n683 VSS.t1014 0.0863258
R3969 VSS.n685 VSS.t1024 0.0863258
R3970 VSS.n687 VSS.t1034 0.0863258
R3971 VSS.n689 VSS.t1044 0.0863258
R3972 VSS.n691 VSS.t1054 0.0863258
R3973 VSS.n693 VSS.t1064 0.0863258
R3974 VSS.n695 VSS.t1074 0.0863258
R3975 VSS.n697 VSS.t1084 0.0863258
R3976 VSS.n699 VSS.t1094 0.0863258
R3977 VSS.n256 VSS.t147 0.0863258
R3978 VSS.n740 VSS.t529 0.130189
R3979 VSS.t522 VSS.n742 0.0863258
R3980 VSS.t621 VSS.n724 0.130189
R3981 VSS.n726 VSS.t632 0.0863258
R3982 VSS.n728 VSS.t642 0.0863258
R3983 VSS.n730 VSS.t652 0.0863258
R3984 VSS.t657 VSS.n731 0.0863258
R3985 VSS.t647 VSS.n729 0.0863258
R3986 VSS.t637 VSS.n727 0.0863258
R3987 VSS.t627 VSS.n725 0.0863258
R3988 VSS.t516 VSS.n743 0.130189
R3989 VSS.t807 VSS.n712 0.0863258
R3990 VSS.t811 VSS.n713 0.0863258
R3991 VSS.n701 VSS.t1104 0.0863258
R3992 VSS.n703 VSS.t1114 0.0863258
R3993 VSS.n705 VSS.t1124 0.0863258
R3994 VSS.t1119 VSS.n704 0.0863258
R3995 VSS.t1109 VSS.n702 0.0863258
R3996 VSS.t1099 VSS.n700 0.0863258
R3997 VSS.t1089 VSS.n698 0.0863258
R3998 VSS.t1079 VSS.n696 0.0863258
R3999 VSS.t1069 VSS.n694 0.0863258
R4000 VSS.t1059 VSS.n692 0.0863258
R4001 VSS.t1049 VSS.n690 0.0863258
R4002 VSS.t1039 VSS.n688 0.0863258
R4003 VSS.t1029 VSS.n686 0.0863258
R4004 VSS.t1019 VSS.n684 0.0863258
R4005 VSS.t1009 VSS.n682 0.0863258
R4006 VSS.t999 VSS.n680 0.0863258
R4007 VSS.t979 VSS.n676 0.0863258
R4008 VSS.t969 VSS.n674 0.0863258
R4009 VSS.t959 VSS.n672 0.0863258
R4010 VSS.t949 VSS.n670 0.0863258
R4011 VSS.t939 VSS.n668 0.0863258
R4012 VSS.t929 VSS.n666 0.0863258
R4013 VSS.t919 VSS.n664 0.0863258
R4014 VSS.t909 VSS.n662 0.0863258
R4015 VSS.t899 VSS.n660 0.0863258
R4016 VSS.t889 VSS.n658 0.0863258
R4017 VSS.t879 VSS.n656 0.0863258
R4018 VSS.n650 VSS.t848 0.130189
R4019 VSS.t854 VSS.n651 0.0863258
R4020 VSS.t859 VSS.n652 0.0863258
R4021 VSS.t864 VSS.n653 0.0863258
R4022 VSS.t869 VSS.n654 0.0863258
R4023 VSS.t874 VSS.n655 0.0863258
R4024 VSS.t1927 VSS.n504 0.130189
R4025 VSS.n506 VSS.t1938 0.0863258
R4026 VSS.n508 VSS.t1948 0.0863258
R4027 VSS.t1943 VSS.n507 0.0863258
R4028 VSS.t1933 VSS.n505 0.0863258
R4029 VSS.t1535 VSS.n560 0.130189
R4030 VSS.n562 VSS.t1546 0.0863258
R4031 VSS.n564 VSS.t1556 0.0863258
R4032 VSS.n566 VSS.t1566 0.0863258
R4033 VSS.n568 VSS.t1576 0.0863258
R4034 VSS.n570 VSS.t1586 0.0863258
R4035 VSS.n572 VSS.t1596 0.0863258
R4036 VSS.n574 VSS.t1606 0.0863258
R4037 VSS.n576 VSS.t1616 0.0863258
R4038 VSS.n578 VSS.t1626 0.0863258
R4039 VSS.n580 VSS.t1636 0.0863258
R4040 VSS.n582 VSS.t1646 0.0863258
R4041 VSS.n584 VSS.t1656 0.0863258
R4042 VSS.n586 VSS.t1666 0.0863258
R4043 VSS.t1671 VSS.n587 0.0863258
R4044 VSS.t1661 VSS.n585 0.0863258
R4045 VSS.t1651 VSS.n583 0.0863258
R4046 VSS.t1641 VSS.n581 0.0863258
R4047 VSS.t1631 VSS.n579 0.0863258
R4048 VSS.t1621 VSS.n577 0.0863258
R4049 VSS.t1611 VSS.n575 0.0863258
R4050 VSS.t1601 VSS.n573 0.0863258
R4051 VSS.t1591 VSS.n571 0.0863258
R4052 VSS.t1581 VSS.n569 0.0863258
R4053 VSS.t1571 VSS.n567 0.0863258
R4054 VSS.t1561 VSS.n565 0.0863258
R4055 VSS.t1551 VSS.n563 0.0863258
R4056 VSS.t1541 VSS.n561 0.0863258
R4057 VSS.t1681 VSS.n589 0.0863258
R4058 VSS.t1686 VSS.n590 0.0863258
R4059 VSS.t1691 VSS.n591 0.0863258
R4060 VSS.t1696 VSS.n592 0.0863258
R4061 VSS.t1701 VSS.n593 0.0863258
R4062 VSS.t1706 VSS.n594 0.0863258
R4063 VSS.t1711 VSS.n595 0.0863258
R4064 VSS.t1716 VSS.n596 0.0863258
R4065 VSS.t1721 VSS.n597 0.0863258
R4066 VSS.t1726 VSS.n598 0.0863258
R4067 VSS.t1731 VSS.n599 0.0863258
R4068 VSS.t1736 VSS.n600 0.0863258
R4069 VSS.t1741 VSS.n601 0.0863258
R4070 VSS.t1746 VSS.n602 0.0863258
R4071 VSS.t1751 VSS.n603 0.0863258
R4072 VSS.t1756 VSS.n604 0.0863258
R4073 VSS.t1761 VSS.n605 0.0863258
R4074 VSS.t1766 VSS.n606 0.0863258
R4075 VSS.t1771 VSS.n607 0.0863258
R4076 VSS.t1776 VSS.n608 0.0863258
R4077 VSS.t1781 VSS.n609 0.0863258
R4078 VSS.t1786 VSS.n610 0.0863258
R4079 VSS.n555 VSS.t2183 0.0863258
R4080 VSS.n557 VSS.t2193 0.0863258
R4081 VSS.n559 VSS.t2203 0.0863258
R4082 VSS.t2198 VSS.n558 0.0863258
R4083 VSS.t2188 VSS.n556 0.0863258
R4084 VSS.t2178 VSS.n554 0.0863258
R4085 VSS.t2168 VSS.n552 0.0863258
R4086 VSS.t2158 VSS.n550 0.0863258
R4087 VSS.t2148 VSS.n548 0.0863258
R4088 VSS.t2138 VSS.n546 0.0863258
R4089 VSS.t2128 VSS.n544 0.0863258
R4090 VSS.t2118 VSS.n542 0.0863258
R4091 VSS.t2108 VSS.n540 0.0863258
R4092 VSS.t2098 VSS.n538 0.0863258
R4093 VSS.t2088 VSS.n536 0.0863258
R4094 VSS.t2078 VSS.n534 0.0863258
R4095 VSS.t2058 VSS.n530 0.0863258
R4096 VSS.t2048 VSS.n528 0.0863258
R4097 VSS.t2038 VSS.n526 0.0863258
R4098 VSS.t2028 VSS.n524 0.0863258
R4099 VSS.t2018 VSS.n522 0.0863258
R4100 VSS.t2008 VSS.n520 0.0863258
R4101 VSS.t1998 VSS.n518 0.0863258
R4102 VSS.t1988 VSS.n516 0.0863258
R4103 VSS.t1978 VSS.n514 0.0863258
R4104 VSS.t1968 VSS.n512 0.0863258
R4105 VSS.t1958 VSS.n510 0.0863258
R4106 VSS.n509 VSS.t1953 0.0863258
R4107 VSS.t2350 VSS.n454 0.0863258
R4108 VSS.t2355 VSS.n455 0.0863258
R4109 VSS.t2360 VSS.n456 0.0863258
R4110 VSS.t2365 VSS.n457 0.0863258
R4111 VSS.t2370 VSS.n458 0.0863258
R4112 VSS.t2375 VSS.n459 0.0863258
R4113 VSS.t2380 VSS.n460 0.0863258
R4114 VSS.t2385 VSS.n461 0.0863258
R4115 VSS.t2390 VSS.n462 0.0863258
R4116 VSS.t2395 VSS.n463 0.0863258
R4117 VSS.t2400 VSS.n464 0.0863258
R4118 VSS.t2405 VSS.n465 0.0863258
R4119 VSS.t2410 VSS.n466 0.0863258
R4120 VSS.t2415 VSS.n467 0.0863258
R4121 VSS.t2420 VSS.n468 0.0863258
R4122 VSS.t2425 VSS.n469 0.0863258
R4123 VSS.t2430 VSS.n470 0.0863258
R4124 VSS.t2435 VSS.n471 0.0863258
R4125 VSS.t2440 VSS.n472 0.0863258
R4126 VSS.t2445 VSS.n473 0.0863258
R4127 VSS.t2450 VSS.n474 0.0863258
R4128 VSS.t2989 VSS.n354 0.130189
R4129 VSS.n356 VSS.t3000 0.0863258
R4130 VSS.n358 VSS.t3010 0.0863258
R4131 VSS.t3005 VSS.n357 0.0863258
R4132 VSS.t2995 VSS.n355 0.0863258
R4133 VSS.n406 VSS.t3250 0.0863258
R4134 VSS.n408 VSS.t3260 0.0863258
R4135 VSS.t3265 VSS.n409 0.0863258
R4136 VSS.t3255 VSS.n407 0.0863258
R4137 VSS.t3245 VSS.n405 0.0863258
R4138 VSS.t3020 VSS.n360 0.0863258
R4139 VSS.t389 VSS.t387 0.217986
R4140 VSS.t380 VSS.t322 0.217986
R4141 VSS.t374 VSS.t373 0.217986
R4142 VSS.n722 VSS.t63 0.0861948
R4143 VSS.n715 VSS.t766 0.0861948
R4144 VSS.t385 VSS.t384 0.217986
R4145 VSS.t432 VSS.t431 0.217986
R4146 VSS.t437 VSS.t436 0.217986
R4147 VSS.t454 VSS.t453 0.217986
R4148 VSS.t459 VSS.t458 0.217986
R4149 VSS.t235 VSS.t465 0.217986
R4150 VSS.t470 VSS.t469 0.217986
R4151 VSS.t475 VSS.t474 0.217986
R4152 VSS.t444 VSS.t443 0.217986
R4153 VSS.t427 VSS.t326 0.217986
R4154 VSS.t423 VSS.t422 0.217986
R4155 VSS.t418 VSS.t417 0.217986
R4156 VSS.t413 VSS.t412 0.217986
R4157 VSS.t408 VSS.t407 0.217986
R4158 VSS.t402 VSS.t344 0.217986
R4159 VSS.n709 VSS.t796 0.0861948
R4160 VSS.t2727 VSS.t2728 0.210486
R4161 VSS.t126 VSS.n279 0.328308
R4162 VSS.t580 VSS.t49 0.21028
R4163 VSS.t1240 VSS.t306 0.209938
R4164 VSS.n732 VSS.t662 0.0818513
R4165 VSS.t74 VSS.t210 0.204291
R4166 VSS.t1322 VSS.t1323 0.180789
R4167 VSS.t362 VSS.n735 0.0605362
R4168 VSS.n333 VSS.t1415 0.120486
R4169 VSS.n647 VSS.t1256 0.0605362
R4170 VSS.t2464 VSS.t2462 0.168986
R4171 VSS.t2072 VSS.t2070 0.168986
R4172 VSS.t1680 VSS.t1678 0.168986
R4173 VSS.t993 VSS.t991 0.168986
R4174 VSS.t74 VSS.t498 0.167848
R4175 VSS.n350 VSS.t3130 0.083315
R4176 VSS.n446 VSS.t2863 0.0836055
R4177 VSS.t1400 VSS.t1401 0.167039
R4178 VSS.t451 VSS.n422 0.0836055
R4179 VSS.n293 VSS.t273 0.0836055
R4180 VSS.t74 VSS.t487 0.158304
R4181 VSS.t238 VSS.n706 0.0793054
R4182 VSS.t2728 VSS.t2729 0.150825
R4183 VSS.t449 VSS.n773 0.150789
R4184 VSS.t1521 VSS.t1387 0.150789
R4185 VSS.t2919 VSS.t2788 0.150789
R4186 VSS.t2848 VSS.t2978 0.150789
R4187 VSS.t3130 VSS.n747 0.150789
R4188 VSS.t3017 VSS.t3015 0.135506
R4189 VSS.t529 VSS.n864 0.10425
R4190 VSS.t68 VSS.t531 0.10175
R4191 VSS.t448 VSS.n203 0.0333775
R4192 VSS.t2787 VSS.t2919 0.090789
R4193 VSS.t1387 VSS.t1522 0.090789
R4194 VSS.t126 VSS.t103 0.090789
R4195 VSS.t309 VSS.n706 0.169319
R4196 VSS.t394 VSS.n349 0.155751
R4197 VSS.t1255 VSS.t1415 0.0905
R4198 VSS.t1322 VSS.t1466 0.0905
R4199 VSS.t2992 VSS.t2994 0.0855
R4200 VSS.t2999 VSS.t2997 0.0855
R4201 VSS.t3002 VSS.t3004 0.0855
R4202 VSS.t3009 VSS.t3007 0.0855
R4203 VSS.t3012 VSS.t3014 0.0855
R4204 VSS.t429 VSS.t431 0.0855
R4205 VSS.t434 VSS.t436 0.0855
R4206 VSS.t3242 VSS.t3244 0.0855
R4207 VSS.t3249 VSS.t3247 0.0855
R4208 VSS.t3252 VSS.t3254 0.0855
R4209 VSS.t3259 VSS.t3257 0.0855
R4210 VSS.t3262 VSS.t3264 0.0855
R4211 VSS.t3237 VSS.t3239 0.0855
R4212 VSS.t3232 VSS.t3234 0.0855
R4213 VSS.t3227 VSS.t3229 0.0855
R4214 VSS.t3222 VSS.t3224 0.0855
R4215 VSS.t3217 VSS.t3219 0.0855
R4216 VSS.t3212 VSS.t3214 0.0855
R4217 VSS.t3207 VSS.t3209 0.0855
R4218 VSS.t3202 VSS.t3204 0.0855
R4219 VSS.t3197 VSS.t3199 0.0855
R4220 VSS.t3192 VSS.t3194 0.0855
R4221 VSS.t3187 VSS.t3189 0.0855
R4222 VSS.t3182 VSS.t3184 0.0855
R4223 VSS.t3177 VSS.t3179 0.0855
R4224 VSS.t3172 VSS.t3174 0.0855
R4225 VSS.t3167 VSS.t3169 0.0855
R4226 VSS.t3162 VSS.t3164 0.0855
R4227 VSS.t3157 VSS.t3159 0.0855
R4228 VSS.t3152 VSS.t3154 0.0855
R4229 VSS.t3147 VSS.t3149 0.0855
R4230 VSS.t3142 VSS.t3144 0.0855
R4231 VSS.t3137 VSS.t3139 0.0855
R4232 VSS.t3134 VSS.t3132 0.0855
R4233 VSS.t3127 VSS.t3129 0.0855
R4234 VSS.t3122 VSS.t3124 0.0855
R4235 VSS.t3117 VSS.t3119 0.0855
R4236 VSS.t3112 VSS.t3114 0.0855
R4237 VSS.t3107 VSS.t3109 0.0855
R4238 VSS.t3102 VSS.t3104 0.0855
R4239 VSS.t3097 VSS.t3099 0.0855
R4240 VSS.t3092 VSS.t3094 0.0855
R4241 VSS.t3087 VSS.t3089 0.0855
R4242 VSS.t3082 VSS.t3084 0.0855
R4243 VSS.t3077 VSS.t3079 0.0855
R4244 VSS.t3072 VSS.t3074 0.0855
R4245 VSS.t3067 VSS.t3069 0.0855
R4246 VSS.t3062 VSS.t3064 0.0855
R4247 VSS.t3057 VSS.t3059 0.0855
R4248 VSS.t3052 VSS.t3054 0.0855
R4249 VSS.t3047 VSS.t3049 0.0855
R4250 VSS.t3042 VSS.t3044 0.0855
R4251 VSS.t3037 VSS.t3039 0.0855
R4252 VSS.t3032 VSS.t3034 0.0855
R4253 VSS.t3027 VSS.t3029 0.0855
R4254 VSS.t3024 VSS.t3022 0.0855
R4255 VSS.t3017 VSS.t3019 0.0855
R4256 VSS.t2324 VSS.t2322 0.0855
R4257 VSS.t2329 VSS.t2327 0.0855
R4258 VSS.t2334 VSS.t2332 0.0855
R4259 VSS.t2339 VSS.t2337 0.0855
R4260 VSS.t2344 VSS.t2342 0.0855
R4261 VSS.t2349 VSS.t2347 0.0855
R4262 VSS.t2354 VSS.t2352 0.0855
R4263 VSS.t2359 VSS.t2357 0.0855
R4264 VSS.t2364 VSS.t2362 0.0855
R4265 VSS.t2369 VSS.t2367 0.0855
R4266 VSS.t2374 VSS.t2372 0.0855
R4267 VSS.t2379 VSS.t2377 0.0855
R4268 VSS.t2384 VSS.t2382 0.0855
R4269 VSS.t2389 VSS.t2387 0.0855
R4270 VSS.t2394 VSS.t2392 0.0855
R4271 VSS.t2399 VSS.t2397 0.0855
R4272 VSS.t2404 VSS.t2402 0.0855
R4273 VSS.t2409 VSS.t2407 0.0855
R4274 VSS.t2414 VSS.t2412 0.0855
R4275 VSS.t2419 VSS.t2417 0.0855
R4276 VSS.t2424 VSS.t2422 0.0855
R4277 VSS.t2429 VSS.t2427 0.0855
R4278 VSS.t2434 VSS.t2432 0.0855
R4279 VSS.t2439 VSS.t2437 0.0855
R4280 VSS.t2444 VSS.t2442 0.0855
R4281 VSS.t2449 VSS.t2447 0.0855
R4282 VSS.t2454 VSS.t2452 0.0855
R4283 VSS.t2457 VSS.t2459 0.0855
R4284 VSS.t2467 VSS.t2469 0.0855
R4285 VSS.t2474 VSS.t2472 0.0855
R4286 VSS.t2477 VSS.t2479 0.0855
R4287 VSS.t2484 VSS.t2482 0.0855
R4288 VSS.t2487 VSS.t2489 0.0855
R4289 VSS.t2494 VSS.t2492 0.0855
R4290 VSS.t2497 VSS.t2499 0.0855
R4291 VSS.t2504 VSS.t2502 0.0855
R4292 VSS.t2507 VSS.t2509 0.0855
R4293 VSS.t2514 VSS.t2512 0.0855
R4294 VSS.t2517 VSS.t2519 0.0855
R4295 VSS.t2524 VSS.t2522 0.0855
R4296 VSS.t2527 VSS.t2529 0.0855
R4297 VSS.t2534 VSS.t2532 0.0855
R4298 VSS.t2537 VSS.t2539 0.0855
R4299 VSS.t2544 VSS.t2542 0.0855
R4300 VSS.t2547 VSS.t2549 0.0855
R4301 VSS.t2554 VSS.t2552 0.0855
R4302 VSS.t2557 VSS.t2559 0.0855
R4303 VSS.t2564 VSS.t2562 0.0855
R4304 VSS.t2567 VSS.t2569 0.0855
R4305 VSS.t2574 VSS.t2572 0.0855
R4306 VSS.t2577 VSS.t2579 0.0855
R4307 VSS.t2584 VSS.t2582 0.0855
R4308 VSS.t2587 VSS.t2589 0.0855
R4309 VSS.t2594 VSS.t2592 0.0855
R4310 VSS.t1930 VSS.t1932 0.0855
R4311 VSS.t1937 VSS.t1935 0.0855
R4312 VSS.t1940 VSS.t1942 0.0855
R4313 VSS.t1947 VSS.t1945 0.0855
R4314 VSS.t1950 VSS.t1952 0.0855
R4315 VSS.t1955 VSS.t1957 0.0855
R4316 VSS.t1962 VSS.t1960 0.0855
R4317 VSS.t1965 VSS.t1967 0.0855
R4318 VSS.t1972 VSS.t1970 0.0855
R4319 VSS.t1975 VSS.t1977 0.0855
R4320 VSS.t1982 VSS.t1980 0.0855
R4321 VSS.t1985 VSS.t1987 0.0855
R4322 VSS.t1992 VSS.t1990 0.0855
R4323 VSS.t1995 VSS.t1997 0.0855
R4324 VSS.t2002 VSS.t2000 0.0855
R4325 VSS.t2005 VSS.t2007 0.0855
R4326 VSS.t2012 VSS.t2010 0.0855
R4327 VSS.t2015 VSS.t2017 0.0855
R4328 VSS.t2022 VSS.t2020 0.0855
R4329 VSS.t2025 VSS.t2027 0.0855
R4330 VSS.t2032 VSS.t2030 0.0855
R4331 VSS.t2035 VSS.t2037 0.0855
R4332 VSS.t2042 VSS.t2040 0.0855
R4333 VSS.t2045 VSS.t2047 0.0855
R4334 VSS.t2052 VSS.t2050 0.0855
R4335 VSS.t2055 VSS.t2057 0.0855
R4336 VSS.t2062 VSS.t2060 0.0855
R4337 VSS.t2065 VSS.t2067 0.0855
R4338 VSS.t2075 VSS.t2077 0.0855
R4339 VSS.t2082 VSS.t2080 0.0855
R4340 VSS.t2085 VSS.t2087 0.0855
R4341 VSS.t2092 VSS.t2090 0.0855
R4342 VSS.t2095 VSS.t2097 0.0855
R4343 VSS.t2102 VSS.t2100 0.0855
R4344 VSS.t2105 VSS.t2107 0.0855
R4345 VSS.t2112 VSS.t2110 0.0855
R4346 VSS.t2115 VSS.t2117 0.0855
R4347 VSS.t2122 VSS.t2120 0.0855
R4348 VSS.t2125 VSS.t2127 0.0855
R4349 VSS.t2132 VSS.t2130 0.0855
R4350 VSS.t2135 VSS.t2137 0.0855
R4351 VSS.t2142 VSS.t2140 0.0855
R4352 VSS.t2145 VSS.t2147 0.0855
R4353 VSS.t2152 VSS.t2150 0.0855
R4354 VSS.t2155 VSS.t2157 0.0855
R4355 VSS.t2162 VSS.t2160 0.0855
R4356 VSS.t2165 VSS.t2167 0.0855
R4357 VSS.t2172 VSS.t2170 0.0855
R4358 VSS.t2175 VSS.t2177 0.0855
R4359 VSS.t2182 VSS.t2180 0.0855
R4360 VSS.t2185 VSS.t2187 0.0855
R4361 VSS.t2192 VSS.t2190 0.0855
R4362 VSS.t2195 VSS.t2197 0.0855
R4363 VSS.t2202 VSS.t2200 0.0855
R4364 VSS.t1538 VSS.t1540 0.0855
R4365 VSS.t1545 VSS.t1543 0.0855
R4366 VSS.t1548 VSS.t1550 0.0855
R4367 VSS.t1555 VSS.t1553 0.0855
R4368 VSS.t1558 VSS.t1560 0.0855
R4369 VSS.t1565 VSS.t1563 0.0855
R4370 VSS.t1568 VSS.t1570 0.0855
R4371 VSS.t1575 VSS.t1573 0.0855
R4372 VSS.t1578 VSS.t1580 0.0855
R4373 VSS.t1585 VSS.t1583 0.0855
R4374 VSS.t1588 VSS.t1590 0.0855
R4375 VSS.t1595 VSS.t1593 0.0855
R4376 VSS.t1598 VSS.t1600 0.0855
R4377 VSS.t1605 VSS.t1603 0.0855
R4378 VSS.t1608 VSS.t1610 0.0855
R4379 VSS.t1615 VSS.t1613 0.0855
R4380 VSS.t1618 VSS.t1620 0.0855
R4381 VSS.t1625 VSS.t1623 0.0855
R4382 VSS.t1628 VSS.t1630 0.0855
R4383 VSS.t1635 VSS.t1633 0.0855
R4384 VSS.t1638 VSS.t1640 0.0855
R4385 VSS.t1645 VSS.t1643 0.0855
R4386 VSS.t1648 VSS.t1650 0.0855
R4387 VSS.t1655 VSS.t1653 0.0855
R4388 VSS.t1658 VSS.t1660 0.0855
R4389 VSS.t1665 VSS.t1663 0.0855
R4390 VSS.t1668 VSS.t1670 0.0855
R4391 VSS.t1675 VSS.t1673 0.0855
R4392 VSS.t1685 VSS.t1683 0.0855
R4393 VSS.t1690 VSS.t1688 0.0855
R4394 VSS.t1695 VSS.t1693 0.0855
R4395 VSS.t1700 VSS.t1698 0.0855
R4396 VSS.t1705 VSS.t1703 0.0855
R4397 VSS.t1710 VSS.t1708 0.0855
R4398 VSS.t1715 VSS.t1713 0.0855
R4399 VSS.t1720 VSS.t1718 0.0855
R4400 VSS.t1725 VSS.t1723 0.0855
R4401 VSS.t1730 VSS.t1728 0.0855
R4402 VSS.t1735 VSS.t1733 0.0855
R4403 VSS.t1740 VSS.t1738 0.0855
R4404 VSS.t1745 VSS.t1743 0.0855
R4405 VSS.t1750 VSS.t1748 0.0855
R4406 VSS.t1755 VSS.t1753 0.0855
R4407 VSS.t1760 VSS.t1758 0.0855
R4408 VSS.t1765 VSS.t1763 0.0855
R4409 VSS.t1770 VSS.t1768 0.0855
R4410 VSS.t1775 VSS.t1773 0.0855
R4411 VSS.t1780 VSS.t1778 0.0855
R4412 VSS.t1785 VSS.t1783 0.0855
R4413 VSS.t1788 VSS.t1790 0.0855
R4414 VSS.t1795 VSS.t1793 0.0855
R4415 VSS.t1798 VSS.t1800 0.0855
R4416 VSS.t1805 VSS.t1803 0.0855
R4417 VSS.t1808 VSS.t1810 0.0855
R4418 VSS.t853 VSS.t851 0.0855
R4419 VSS.t858 VSS.t856 0.0855
R4420 VSS.t863 VSS.t861 0.0855
R4421 VSS.t868 VSS.t866 0.0855
R4422 VSS.t873 VSS.t871 0.0855
R4423 VSS.t876 VSS.t878 0.0855
R4424 VSS.t883 VSS.t881 0.0855
R4425 VSS.t886 VSS.t888 0.0855
R4426 VSS.t893 VSS.t891 0.0855
R4427 VSS.t896 VSS.t898 0.0855
R4428 VSS.t903 VSS.t901 0.0855
R4429 VSS.t906 VSS.t908 0.0855
R4430 VSS.t913 VSS.t911 0.0855
R4431 VSS.t916 VSS.t918 0.0855
R4432 VSS.t923 VSS.t921 0.0855
R4433 VSS.t926 VSS.t928 0.0855
R4434 VSS.t933 VSS.t931 0.0855
R4435 VSS.t936 VSS.t938 0.0855
R4436 VSS.t943 VSS.t941 0.0855
R4437 VSS.t946 VSS.t948 0.0855
R4438 VSS.t953 VSS.t951 0.0855
R4439 VSS.t956 VSS.t958 0.0855
R4440 VSS.t963 VSS.t961 0.0855
R4441 VSS.t966 VSS.t968 0.0855
R4442 VSS.t973 VSS.t971 0.0855
R4443 VSS.t976 VSS.t978 0.0855
R4444 VSS.t983 VSS.t981 0.0855
R4445 VSS.t986 VSS.t988 0.0855
R4446 VSS.t996 VSS.t998 0.0855
R4447 VSS.t1003 VSS.t1001 0.0855
R4448 VSS.t1006 VSS.t1008 0.0855
R4449 VSS.t1013 VSS.t1011 0.0855
R4450 VSS.t1016 VSS.t1018 0.0855
R4451 VSS.t1023 VSS.t1021 0.0855
R4452 VSS.t1026 VSS.t1028 0.0855
R4453 VSS.t1033 VSS.t1031 0.0855
R4454 VSS.t1036 VSS.t1038 0.0855
R4455 VSS.t1043 VSS.t1041 0.0855
R4456 VSS.t1046 VSS.t1048 0.0855
R4457 VSS.t1053 VSS.t1051 0.0855
R4458 VSS.t1056 VSS.t1058 0.0855
R4459 VSS.t1063 VSS.t1061 0.0855
R4460 VSS.t1066 VSS.t1068 0.0855
R4461 VSS.t1073 VSS.t1071 0.0855
R4462 VSS.t1076 VSS.t1078 0.0855
R4463 VSS.t1083 VSS.t1081 0.0855
R4464 VSS.t1086 VSS.t1088 0.0855
R4465 VSS.t1093 VSS.t1091 0.0855
R4466 VSS.t1096 VSS.t1098 0.0855
R4467 VSS.t1103 VSS.t1101 0.0855
R4468 VSS.t1106 VSS.t1108 0.0855
R4469 VSS.t1113 VSS.t1111 0.0855
R4470 VSS.t1116 VSS.t1118 0.0855
R4471 VSS.t1123 VSS.t1121 0.0855
R4472 VSS.t54 VSS.t39 0.0855
R4473 VSS.n275 VSS.t351 0.0432886
R4474 VSS.t52 VSS.t173 0.0855
R4475 VSS.t624 VSS.t626 0.0855
R4476 VSS.t631 VSS.t629 0.0855
R4477 VSS.t634 VSS.t636 0.0855
R4478 VSS.t641 VSS.t639 0.0855
R4479 VSS.t644 VSS.t646 0.0855
R4480 VSS.t651 VSS.t649 0.0855
R4481 VSS.t654 VSS.t656 0.0855
R4482 VSS.t28 VSS.t669 0.0855
R4483 VSS.t784 VSS.t20 0.0855
R4484 VSS.t521 VSS.t42 0.0855
R4485 VSS.t453 VSS.t451 0.0855
R4486 VSS.t456 VSS.t458 0.0855
R4487 VSS.t467 VSS.t469 0.0855
R4488 VSS.t472 VSS.t474 0.0855
R4489 VSS.t446 VSS.t448 0.0855
R4490 VSS.t420 VSS.t422 0.0855
R4491 VSS.t415 VSS.t417 0.0855
R4492 VSS.t410 VSS.t412 0.0855
R4493 VSS.t391 VSS.t393 0.0855
R4494 VSS.t382 VSS.t384 0.0855
R4495 VSS.t175 VSS.t809 0.0855
R4496 VSS.t439 VSS.t441 0.07425
R4497 VSS.t661 VSS.t659 0.07425
R4498 VSS.t524 VSS.t179 0.07425
R4499 VSS.t461 VSS.t463 0.07425
R4500 VSS.t477 VSS.t479 0.07425
R4501 VSS.t404 VSS.t339 0.07425
R4502 VSS.t376 VSS.t378 0.07425
R4503 VSS.t74 VSS.n46 0.0643474
R4504 VSS.t74 VSS.n44 0.0643474
R4505 VSS.t74 VSS.n43 0.0643474
R4506 VSS.t74 VSS.n21 0.219075
R4507 VSS.t74 VSS.n41 0.0643474
R4508 VSS.t74 VSS.n20 0.219075
R4509 VSS.n905 VSS.n748 0.0623545
R4510 VSS.n902 VSS.n748 0.0623545
R4511 VSS.n902 VSS.n901 0.0623545
R4512 VSS.n901 VSS.n751 0.0623545
R4513 VSS.n898 VSS.n751 0.0623545
R4514 VSS.n898 VSS.n897 0.0623545
R4515 VSS.n897 VSS.n756 0.0623545
R4516 VSS.n904 VSS.n903 0.0623545
R4517 VSS.n903 VSS.n750 0.0623545
R4518 VSS.n900 VSS.n750 0.0623545
R4519 VSS.n900 VSS.n899 0.0623545
R4520 VSS.n899 VSS.n752 0.0623545
R4521 VSS.n889 VSS.n752 0.0623545
R4522 VSS.n889 VSS.n888 0.0623545
R4523 VSS.n760 VSS.t695 0.0613465
R4524 VSS.n864 VSS.t89 0.038
R4525 VSS.n382 VSS.n747 0.0957512
R4526 VSS.t2848 VSS.n353 0.0305
R4527 VSS.t2460 VSS.n476 0.0957512
R4528 VSS.n532 VSS.t2068 0.0957512
R4529 VSS.t1676 VSS.n588 0.0957512
R4530 VSS.t1466 VSS.n318 0.209511
R4531 VSS.n647 VSS.t1255 0.150486
R4532 VSS.n678 VSS.t989 0.0957512
R4533 VSS.n203 VSS.n773 0.0957512
R4534 VSS.n81 VSS.t2591 109.992
R4535 VSS.n81 VSS.t2501 109.992
R4536 VSS.t2476 VSS.n81 109.992
R4537 VSS.n81 VSS.t2431 109.992
R4538 VSS.t2124 VSS.n82 109.992
R4539 VSS.t2114 VSS.n82 109.992
R4540 VSS.n82 VSS.t2089 109.992
R4541 VSS.t2014 VSS.n82 109.992
R4542 VSS.n82 VSS.t1989 109.992
R4543 VSS.n82 VSS.t1979 109.992
R4544 VSS.t1974 VSS.n82 109.992
R4545 VSS.t1797 VSS.n83 109.992
R4546 VSS.n83 VSS.t1702 109.992
R4547 VSS.n83 VSS.t1682 109.992
R4548 VSS.n83 VSS.t1662 109.992
R4549 VSS.t1637 VSS.n83 109.992
R4550 VSS.t1627 VSS.n83 109.992
R4551 VSS.t1587 VSS.n83 109.992
R4552 VSS.t1567 VSS.n83 109.992
R4553 VSS.n80 VSS.t990 109.993
R4554 VSS.n80 VSS.t1120 109.992
R4555 VSS.t1105 VSS.n80 109.992
R4556 VSS.t1075 VSS.n80 109.992
R4557 VSS.t1055 VSS.n80 109.992
R4558 VSS.t1035 VSS.n80 109.992
R4559 VSS.t1025 VSS.n80 109.992
R4560 VSS.n80 VSS.t1010 109.992
R4561 VSS.n80 VSS.t910 109.992
R4562 VSS.t653 VSS.t202 109.992
R4563 VSS.n102 VSS.t3016 157.976
R4564 VSS.t3221 VSS.n102 157.976
R4565 VSS.t3211 VSS.n102 157.976
R4566 VSS.t3201 VSS.n102 157.976
R4567 VSS.t3156 VSS.n102 157.976
R4568 VSS.t3126 VSS.n102 157.976
R4569 VSS.t3101 VSS.n102 157.976
R4570 VSS.t3076 VSS.n102 157.976
R4571 VSS.t3051 VSS.n102 157.976
R4572 VSS.t3031 VSS.n102 157.976
R4573 VSS.t49 VSS 8.79534
R4574 VSS.n703 VSS.n80 4.29337
R4575 VSS.n501 VSS.n81 4.29336
R4576 VSS.n83 VSS.n613 4.29335
R4577 VSS.n557 VSS.n82 4.29335
R4578 VSS.t305 VSS.n211 3.01411
R4579 VSS.t2710 VSS.n271 2.96934
R4580 VSS.n359 VSS.n102 2.95
R4581 VSS.t202 VSS.t724 1.4358
R4582 VSS.t7 VSS.n878 1.36612
R4583 VSS.t7 VSS.n741 1.15336
R4584 VSS.t202 VSS.n98 1.13449
R4585 VSS.t74 VSS.n39 1.03869
R4586 VSS.n200 VSS.t7 1.03583
R4587 VSS.n249 VSS.t202 1.03036
R4588 VSS.t74 VSS.n84 1.00961
R4589 VSS.t202 VSS.n759 1.00154
R4590 sg13g2_buf_1_9.X sg13g2_buf_1_9.X.n6 30.9917
R4591 sg13g2_buf_1_9.X.n0 sg13g2_buf_1_9.X 28.6186
R4592 sg13g2_buf_1_9.X.n3 sg13g2_buf_1_9.X.n2 28.6127
R4593 sg13g2_buf_1_9.X.n4 sg13g2_buf_1_9.X.n3 27.4487
R4594 sg13g2_buf_1_9.X.n5 sg13g2_buf_1_9.X.n4 20.4881
R4595 sg13g2_buf_1_9.X.n2 sg13g2_buf_1_9.X 18.2001
R4596 sg13g2_buf_1_9.X.n6 sg13g2_buf_1_9.X 18.0218
R4597 sg13g2_buf_1_9.X.n5 sg13g2_buf_1_9.X 18.0218
R4598 sg13g2_buf_1_9.X sg13g2_buf_1_9.X.t0 17.0317
R4599 sg13g2_buf_1_9.X sg13g2_buf_1_9.X.t5 15.0245
R4600 sg13g2_buf_1_9.X sg13g2_buf_1_9.X.t4 15.016
R4601 sg13g2_buf_1_9.X sg13g2_buf_1_9.X.t1 15.0005
R4602 sg13g2_buf_1_9.X sg13g2_buf_1_9.X.t3 15.0005
R4603 sg13g2_buf_1_9.X sg13g2_buf_1_9.X.t2 15.0005
R4604 sg13g2_buf_1_9.X.n2 sg13g2_buf_1_9.X.n1 10.6901
R4605 sg13g2_buf_1_9.X.t0 sg13g2_buf_1_9.X 9.34537
R4606 sg13g2_buf_1_9.X.n1 sg13g2_buf_1_9.X 9.2001
R4607 sg13g2_buf_1_9.X.n0 sg13g2_buf_1_9.X 9.18226
R4608 sg13g2_buf_1_9.X.n4 sg13g2_buf_1_9.X 9.0218
R4609 sg13g2_buf_1_9.X.n3 sg13g2_buf_1_9.X 9.00217
R4610 sg13g2_buf_1_9.X.n6 sg13g2_buf_1_9.X.n5 8.2373
R4611 sg13g2_buf_1_9.X.n1 sg13g2_buf_1_9.X.n0 3.07442
C0 VDD a_15304_15366# 0.15091f
C1 a_11050_14452# a_11076_14488# 0.21121f
C2 sg13g2_dfrbpq_1_2.CLK sg13g2_dfrbpq_1_1.RESET_B 0.03499f
C3 VDD a_25175_16301# 0.08359f
C4 sg13g2_nand2_2_0.Y a_22202_14484# 0.06087f
C5 sg13g2_xnor2_1_0.A a_8200_14570# 0.01039f
C6 a_12335_14845# a_12241_14845# 0.15029f
C7 a_13626_13918# sg13g2_inv_1_0.Y 0.01632f
C8 VDD a_25094_15238# 0.19887f
C9 a_4655_15311# a_4561_15311# 0.15029f
C10 a_26833_14845# a_25668_14488# 0.22369f
C11 a_23483_14540# a_23806_14854# 0.22783f
C12 a_12524_15960# sg13g2_nand2_2_0.A 0.16434f
C13 sg13g2_dfrbpq_1_7.CLK sg13g2_dlygate4sd3_1_11.A 0.12378f
C14 sg13g2_mux2_1_0.A0 a_23483_14540# 0.01947f
C15 sg13g2_buf_1_0.X reset_n_i 0.02184f
C16 sg13g2_nand2_2_0.A sg13g2_buf_1_0.X 0.17544f
C17 sg13g2_buf_4_0.A sg13g2_dlygate4sd3_1_2.X 0.01431f
C18 sg13g2_dfrbpq_1_4.D a_25670_15234# 0.16947f
C19 sg13g2_nand2_2_0.A a_11866_15202# 0.22832f
C20 a_18789_16033# VDD 0.07505f
C21 VDD sg13g2_dlygate4sd3_1_3.A 0.26435f
C22 VDD a_23272_15366# 0.13295f
C23 a_10967_15549# a_11166_15486# 0.08074f
C24 a_10792_15366# a_10967_15315# 0.01744f
C25 a_27041_13912# a_27322_13690# 0.15158f
C26 a_7529_16334# a_7653_16033# 0.06917f
C27 sg13g2_buf_4_0.X sg13g2_xnor2_1_1.A 0.85703f
C28 VDD a_19546_12936# 0.27673f
C29 VDD a_25642_14452# 0.09433f
C30 sg13g2_dfrbpq_1_1.RESET_B a_8495_15311# 0.07586f
C31 sg13g2_buf_1_0.X a_4655_15311# 0.01325f
C32 a_24669_14508# a_24443_14540# 0.02726f
C33 sg13g2_and2_1_0.X sg13g2_buf_1_0.X 0.02181f
C34 sg13g2_nor2b_1_0.A sg13g2_mux2_1_0.X 0.111f
C35 a_17699_16265# a_18280_16082# 0.01027f
C36 sg13g2_dlygate4sd3_1_0.A a_9162_15532# 0.07985f
C37 sg13g2_nand2_1_1.A a_15958_15230# 0.02286f
C38 sg13g2_dlygate4sd3_1_2.X sg13g2_xnor2_1_0.A 0.62687f
C39 sg13g2_dfrbpq_1_3.RESET_B a_14187_14495# 0.21427f
C40 VDD a_19173_14495# 0.25226f
C41 sg13g2_xor2_1_1.X a_14187_14495# 0.04814f
C42 sg13g2_buf_4_0.X sg13g2_dfrbpq_1_7.RESET_B 0.04946f
C43 a_25956_14909# a_25382_14922# 0.16388f
C44 sg13g2_dfrbpq_1_6.RESET_B a_19173_14495# 0.02921f
C45 sg13g2_buf_1_9.X sg13g2_xor2_1_1.B 0.17915f
C46 a_19275_14495# a_20272_14726# 0.01569f
C47 sg13g2_nand2_2_0.A VDD 1.15488f
C48 VDD reset_n_i 0.13142f
C49 sg13g2_dfrbpq_1_5.RESET_B sg13g2_dfrbpq_1_6.Q 0.04133f
C50 sg13g2_dlygate4sd3_1_9.A sg13g2_inv_1_0.Y 0.03439f
C51 a_18987_13844# a_18756_13735# 0.06628f
C52 a_18468_14040# a_19633_13799# 0.22369f
C53 sg13g2_dlygate4sd3_1_2.A a_4385_14750# 0.01215f
C54 a_7529_16334# a_7450_16237# 0.08074f
C55 VDD sg13g2_buf_16_1.X 2.26811f
C56 sg13g2_dlygate4sd3_1_11.A sg13g2_nor4_2_0.Y 0.04884f
C57 VDD a_22806_14484# 0.19277f
C58 sg13g2_buf_1_0.X clock_i 0.03804f
C59 a_18182_13722# a_18885_13701# 0.02454f
C60 sg13g2_nor3_1_0.C a_22202_14484# 0.12913f
C61 VDD a_4655_15311# 0.17941f
C62 sg13g2_and2_1_1.X sg13g2_and2_1_1.B 0.15443f
C63 sg13g2_and2_1_0.X VDD 0.27833f
C64 sg13g2_dfrbpq_1_6.RESET_B sg13g2_buf_16_1.X 0.03882f
C65 sg13g2_inv_1_0.Y a_16078_14484# 0.07938f
C66 VDD a_18766_15423# 0.18309f
C67 sg13g2_dlygate4sd3_1_11.A a_20394_14020# 0.07698f
C68 VDD counter_value_o[1] 0.07636f
C69 sg13g2_nand2_2_0.Y a_18468_14040# 0.02849f
C70 a_19049_16334# a_19173_16033# 0.06917f
C71 sg13g2_dfrbpq_1_6.Q sg13g2_nor3_1_0.Y 0.01077f
C72 a_18766_15423# sg13g2_dfrbpq_1_6.RESET_B 0.06772f
C73 sg13g2_buf_4_0.X a_14927_14845# 0.01724f
C74 a_23648_15437# a_24040_15366# 0.01798f
C75 a_13652_14020# sg13g2_inv_1_0.Y 0.01182f
C76 a_27184_14726# a_27594_14484# 0.05221f
C77 a_4270_14751# a_4385_14750# 0.32411f
C78 a_17038_15423# a_17153_15424# 0.32411f
C79 sg13g2_a21oi_1_0.Y a_16571_15532# 0.08678f
C80 VDD sg13g2_dlygate4sd3_1_12.A 1.92322f
C81 a_37484_15960# sg13g2_dlygate4sd3_1_12.A 0.16368f
C82 a_7116_13912# a_7151_13726# 0.17527f
C83 sg13g2_dfrbpq_1_6.D sg13g2_dfrbpq_1_7.RESET_B 0.24224f
C84 a_25930_15457# sg13g2_dfrbpq_1_4.RESET_B 0.17727f
C85 VDD clock_i 1.50785f
C86 sg13g2_buf_1_9.X a_16681_13726# 0.01339f
C87 a_17699_16265# VDD 0.23963f
C88 sg13g2_buf_4_0.X a_11493_14495# 0.01757f
C89 sg13g2_buf_1_0.X a_7236_15552# 0.03441f
C90 sg13g2_nand2_2_0.Y sg13g2_inv_1_0.Y 0.16123f
C91 sg13g2_nor2b_1_1.Y a_24443_14540# 0.1093f
C92 a_26373_15213# a_26475_15356# 0.26919f
C93 VDD a_18442_13945# 0.11633f
C94 a_25670_15234# sg13g2_dfrbpq_1_5.RESET_B 0.01495f
C95 sg13g2_buf_4_0.X sg13g2_dfrbpq_1_6.Q 0.05034f
C96 sg13g2_a21oi_1_0.A1 sg13g2_a21oi_1_0.Y 0.16294f
C97 sg13g2_nand3_1_1.Y sg13g2_o21ai_1_0.Y 0.02921f
C98 a_10176_14523# sg13g2_xnor2_1_1.A 0.08199f
C99 sg13g2_dfrbpq_1_6.Q a_25668_14488# 0.0376f
C100 sg13g2_nand2_1_1.A sg13g2_dfrbpq_1_7.RESET_B 0.38899f
C101 a_14085_14495# a_13382_14922# 0.02432f
C102 sg13g2_buf_1_0.X sg13g2_xor2_1_1.B 0.05967f
C103 a_3915_15356# sg13g2_buf_1_0.X 0.01525f
C104 sg13g2_dfrbpq_1_7.CLK a_19921_14845# 0.01001f
C105 sg13g2_dfrbpq_1_7.RESET_B sg13g2_dlygate4sd3_1_10.X 0.03971f
C106 sg13g2_dfrbpq_1_2.CLK a_11585_15424# 0.02759f
C107 a_27215_15311# sg13g2_dfrbpq_1_4.RESET_B 0.07656f
C108 VDD a_12992_16082# 0.06256f
C109 sg13g2_buf_1_0.X a_2684_15532# 0.0136f
C110 VDD a_7236_15552# 0.07264f
C111 a_3396_15552# a_4655_15311# 0.01303f
C112 sg13g2_and2_1_2.X sg13g2_dfrbpq_1_2.RESET_B 0.04291f
C113 a_24040_13854# a_24224_13854# 0.0262f
C114 sg13g2_mux2_1_1.X a_25175_16071# 0.03346f
C115 sg13g2_o21ai_1_0.Y sg13g2_a21oi_1_0.A1 0.02238f
C116 a_12335_14845# a_11076_14488# 0.01303f
C117 a_18756_14488# a_19921_14845# 0.22369f
C118 a_26244_15247# a_26373_15213# 0.01562f
C119 sg13g2_buf_1_9.X a_2733_14832# 0.0919f
C120 sg13g2_inv_1_1.Y sg13g2_inv_1_1.A 0.058f
C121 a_23709_14854# a_23806_14854# 0.01625f
C122 VDD a_14362_15960# 0.26826f
C123 a_26537_16334# VDD 0.08988f
C124 sg13g2_nor3_1_0.C sg13g2_nand2_2_0.Y 0.18719f
C125 sg13g2_tiehi_1.L_HI a_3813_15213# 0.02892f
C126 sg13g2_buf_1_9.X a_23272_13854# 0.01021f
C127 VDD sg13g2_xor2_1_1.B 1.07809f
C128 a_3915_15356# VDD 0.21858f
C129 VDD a_38536_3986# 0.13142f
C130 sg13g2_mux2_1_1.X sg13g2_dfrbpq_1_7.CLK 0.02886f
C131 sg13g2_dfrbpq_1_2.CLK sg13g2_xnor2_1_1.A 0.03271f
C132 sg13g2_nor3_1_0.Y a_22508_14484# 0.02899f
C133 VDD a_2684_15532# 0.11896f
C134 sg13g2_dfrbpq_1_3.RESET_B a_13668_14488# 0.23735f
C135 a_22691_14020# sg13g2_nor3_1_0.Y 0.03065f
C136 sg13g2_xor2_1_1.X a_13668_14488# 0.0301f
C137 a_18470_14922# a_19044_14909# 0.16388f
C138 sg13g2_dfrbpq_1_7.CLK a_26373_15213# 0.17152f
C139 sg13g2_dlygate4sd3_1_2.A a_4655_15311# 0.05795f
C140 sg13g2_nand2_1_1.A sg13g2_dfrbpq_1_6.Q 0.12905f
C141 a_26187_14495# sg13g2_dfrbpq_1_6.Q 0.01457f
C142 sg13g2_dfrbpq_1_7.CLK sg13g2_buf_1_9.X 0.42454f
C143 sg13g2_dfrbpq_1_1.RESET_B counter_value_o[1] 0.03551f
C144 VDD a_27322_13690# 0.27081f
C145 sg13g2_buf_4_0.X a_22508_14484# 0.04821f
C146 sg13g2_nor2b_1_1.A sg13g2_nor2b_1_1.Y 0.28361f
C147 sg13g2_mux2_1_0.X a_23806_14854# 0.12973f
C148 sg13g2_xnor2_1_0.A a_7054_14751# 0.02364f
C149 a_7653_15213# a_7524_15247# 0.01562f
C150 sg13g2_nand2_1_1.A a_20015_14845# 0.01467f
C151 sg13g2_nor2b_1_1.A sg13g2_dfrbpq_1_6.Q 0.09639f
C152 sg13g2_and2_1_2.B sg13g2_xor2_1_1.B 0.02823f
C153 sg13g2_xnor2_1_1.A a_10790_14922# 0.0224f
C154 sg13g2_dlygate4sd3_1_2.A clock_i 0.10493f
C155 VDD a_16681_13726# 0.24983f
C156 sg13g2_nand2_1_1.A a_17153_15424# 0.01038f
C157 sg13g2_dlygate4sd3_1_9.A sg13g2_o21ai_1_0.Y 0.54454f
C158 sg13g2_dfrbpq_1_2.CLK sg13g2_dlygate4sd3_1_2.X 0.02609f
C159 sg13g2_dfrbpq_1_2.RESET_B a_11050_14452# 0.13224f
C160 sg13g2_nor2b_1_1.A a_26458_13690# 0.04353f
C161 sg13g2_xor2_1_1.X a_13472_13854# 0.01685f
C162 VDD a_3976_14570# 0.15104f
C163 a_3396_15552# a_3915_15356# 0.18372f
C164 sg13g2_dlygate4sd3_1_2.X sg13g2_and2_1_0.B 0.0714f
C165 a_18280_16082# a_18464_16082# 0.0262f
C166 a_14085_14495# a_14833_14845# 0.01058f
C167 sg13g2_dfrbpq_1_2.CLK a_11493_14495# 0.18555f
C168 a_1192_9948# reset_n_i 0.16635f
C169 VDD counter_value_o[5] 0.10313f
C170 VDD a_26475_15356# 0.20448f
C171 sg13g2_buf_1_9.X sg13g2_nor4_2_0.Y 0.13552f
C172 a_26458_16237# sg13g2_dfrbpq_1_4.RESET_B 0.04175f
C173 a_7054_14751# a_7169_14750# 0.32411f
C174 sg13g2_dlygate4sd3_1_11.A sg13g2_buf_1_9.X 0.36153f
C175 a_17336_13726# a_17606_13726# 0.15158f
C176 sg13g2_dlygate4sd3_1_2.A a_7236_15552# 0.03137f
C177 a_11493_14495# a_11595_14495# 0.27006f
C178 VDD a_38720_14570# 0.07133f
C179 a_2513_15288# sg13g2_and2_1_0.B 0.12279f
C180 sg13g2_a21oi_1_0.Y sg13g2_inv_1_0.Y 0.17269f
C181 sg13g2_tiehi_1.L_HI sg13g2_buf_1_9.X 0.03366f
C182 sg13g2_dlygate4sd3_1_2.X a_8495_15311# 0.01859f
C183 sg13g2_buf_4_0.X a_18470_14922# 0.01794f
C184 a_17699_16265# sg13g2_a21oi_1_0.A2 0.10925f
C185 sg13g2_dfrbpq_1_1.RESET_B a_7236_15552# 0.22207f
C186 VDD a_2733_14832# 0.2653f
C187 a_7210_15457# a_7653_15213# 0.02242f
C188 sg13g2_dlygate4sd3_1_0.A a_7755_15356# 0.01071f
C189 sg13g2_and2_1_1.X a_6477_14832# 0.06176f
C190 sg13g2_nand2_2_0.A a_15958_15230# 0.012f
C191 a_18730_14452# a_18756_14488# 0.21121f
C192 VDD a_23272_13854# 0.13163f
C193 a_3915_15356# sg13g2_dlygate4sd3_1_2.A 0.04778f
C194 a_17224_15996# sg13g2_dlygate4sd3_1_9.A 0.16113f
C195 sg13g2_o21ai_1_0.Y sg13g2_inv_1_0.Y 0.0519f
C196 a_18881_15424# a_19162_15202# 0.15158f
C197 a_27882_15532# sg13g2_dlygate4sd3_1_12.A 0.08276f
C198 a_10790_14922# a_11493_14495# 0.02432f
C199 sg13g2_dlygate4sd3_1_2.A a_2684_15532# 0.02074f
C200 a_8705_14750# sg13g2_buf_1_9.X 0.01629f
C201 VDD a_25175_16071# 0.09608f
C202 sg13g2_xnor2_1_0.A a_8986_14448# 0.02224f
C203 sg13g2_dfrbpq_1_2.CLK a_7210_15457# 0.0122f
C204 sg13g2_dfrbpq_1_2.CLK sg13g2_dfrbpq_1_3.D 0.10001f
C205 sg13g2_or3_1_0.X sg13g2_or3_1_0.A 0.06168f
C206 a_12335_14845# a_13002_14484# 0.06982f
C207 sg13g2_buf_1_9.X sg13g2_dlygate4sd3_1_3.X 0.01085f
C208 VDD a_6368_14570# 0.08037f
C209 sg13g2_dfrbpq_1_4.D a_25930_15457# 0.01176f
C210 sg13g2_nand2_2_0.A a_11585_15424# 0.01032f
C211 a_18464_16082# VDD 0.06475f
C212 sg13g2_dfrbpq_1_6.D a_18470_14922# 0.15379f
C213 VDD sg13g2_dfrbpq_1_7.CLK 2.02523f
C214 a_13668_14488# sg13g2_inv_1_0.Y 0.05301f
C215 VDD a_19150_13239# 0.15703f
C216 VDD a_13382_14922# 0.44656f
C217 sg13g2_dfrbpq_1_7.CLK sg13g2_dfrbpq_1_6.RESET_B 0.04329f
C218 sg13g2_nor2b_1_0.A sg13g2_nor2b_1_1.A 0.02906f
C219 a_17699_16265# a_17997_16020# 0.02085f
C220 VDD a_18756_14488# 0.10421f
C221 sg13g2_nand3_1_1.Y a_18086_15238# 0.02193f
C222 sg13g2_dfrbpq_1_6.RESET_B a_18756_14488# 0.24095f
C223 a_18970_16237# a_19173_16033# 0.01313f
C224 sg13g2_tiehi_1.L_HI sg13g2_buf_1_0.X 0.02664f
C225 a_12232_16082# VDD 0.14523f
C226 a_18885_13701# a_18756_13735# 0.01562f
C227 sg13g2_nand2_2_0.A sg13g2_xnor2_1_1.A 0.04554f
C228 VDD a_12308_15202# 1.60724f
C229 sg13g2_nor4_2_0.Y sg13g2_nor2b_1_0.Y 0.01302f
C230 a_18182_13722# a_18468_14040# 0.21832f
C231 VDD sg13g2_nor4_2_0.Y 0.19511f
C232 sg13g2_nor3_1_0.Y a_23806_14854# 0.07612f
C233 sg13g2_nand2_2_0.Y a_18182_13722# 0.01169f
C234 VDD sg13g2_dlygate4sd3_1_11.A 1.87094f
C235 sg13g2_mux2_1_0.A0 sg13g2_nor3_1_0.Y 0.03978f
C236 a_19984_13942# a_20394_14020# 0.05221f
C237 sg13g2_buf_4_0.X a_15184_14726# 0.01231f
C238 sg13g2_dfrbpq_1_7.RESET_B sg13g2_buf_16_1.X 0.02659f
C239 sg13g2_tiehi_1.L_HI VDD 1.04605f
C240 a_27184_14726# a_26927_14845# 0.20069f
C241 VDD a_20394_14020# 0.245f
C242 sg13g2_buf_4_0.A a_9269_13726# 0.20193f
C243 sg13g2_dfrbpq_1_6.RESET_B sg13g2_dlygate4sd3_1_11.A 0.02669f
C244 sg13g2_buf_4_0.A sg13g2_dlygate4sd3_1_0.A 0.23565f
C245 a_12335_14845# sg13g2_dfrbpq_1_2.RESET_B 0.07576f
C246 a_14187_14495# a_13668_14488# 0.18362f
C247 a_7048_15996# a_6856_16082# 0.01226f
C248 VDD a_37192_16082# 0.15602f
C249 a_7048_15996# sg13g2_dlygate4sd3_1_0.A 0.16621f
C250 sg13g2_dlygate4sd3_1_11.A counter_value_o[4] 0.01613f
C251 a_12524_15960# a_12808_16082# 0.01226f
C252 a_19265_13238# sg13g2_or3_1_0.A 0.02867f
C253 a_17120_16082# VDD 0.08648f
C254 sg13g2_buf_4_0.X a_11076_14488# 0.01557f
C255 sg13g2_buf_1_0.X a_6950_15234# 0.01449f
C256 a_3813_15213# a_4561_15311# 0.01058f
C257 sg13g2_dlygate4sd3_1_0.A sg13g2_xnor2_1_0.A 0.22535f
C258 a_25956_15552# a_26475_15356# 0.18372f
C259 sg13g2_buf_1_0.X a_9752_15242# 0.01435f
C260 sg13g2_buf_4_0.X sg13g2_or3_1_0.X 0.07952f
C261 sg13g2_a21oi_1_0.A1 a_17038_15423# 0.08969f
C262 VDD a_8705_14750# 0.19908f
C263 sg13g2_buf_1_9.X a_4666_14448# 0.01755f
C264 sg13g2_mux2_1_0.A0 a_23456_15366# 0.0171f
C265 sg13g2_nand3_1_1.Y a_16056_15552# 0.01344f
C266 a_3689_14822# a_3813_14521# 0.06917f
C267 a_17621_12972# sg13g2_or3_1_0.X 0.05165f
C268 a_14927_14845# sg13g2_buf_16_1.X 0.01085f
C269 VDD sg13g2_dlygate4sd3_1_3.X 0.20244f
C270 a_3813_15213# sg13g2_buf_1_0.X 0.01328f
C271 sg13g2_buf_4_0.X a_20272_14726# 0.01001f
C272 sg13g2_and2_1_0.X sg13g2_dlygate4sd3_1_2.X 0.03036f
C273 sg13g2_buf_1_0.X a_1192_3900# 0.1456f
C274 sg13g2_o21ai_1_0.Y sg13g2_a21oi_1_0.Y 0.67905f
C275 sg13g2_dfrbpq_1_7.RESET_B a_18442_13945# 0.15991f
C276 sg13g2_nand2_2_0.A counter_value_o[2] 0.01181f
C277 sg13g2_dlygate4sd3_1_4.X sg13g2_inv_1_0.Y 0.14252f
C278 VDD a_12808_16082# 0.12026f
C279 a_9152_13854# a_9269_13726# 0.01011f
C280 VDD a_6950_15234# 0.45034f
C281 sg13g2_and2_1_0.X a_3110_15234# 0.15704f
C282 a_15594_14484# sg13g2_dlygate4sd3_1_11.A 0.06448f
C283 sg13g2_buf_4_0.X sg13g2_nand3_1_1.Y 0.29635f
C284 a_26244_15247# a_25956_15552# 0.22255f
C285 sg13g2_buf_4_0.X a_9269_13726# 0.22987f
C286 VDD a_13966_16263# 0.14531f
C287 a_25974_16020# VDD 0.14234f
C288 sg13g2_buf_16_1.X sg13g2_dfrbpq_1_6.Q 0.11587f
C289 sg13g2_tiehi_1.L_HI a_3396_15552# 0.24217f
C290 sg13g2_buf_1_9.X a_24334_13764# 0.18085f
C291 a_17718_13790# sg13g2_dlygate4sd3_1_3.X 0.11637f
C292 a_3813_15213# VDD 0.25678f
C293 VDD counter_value_o[6] 0.10235f
C294 sg13g2_buf_4_0.X sg13g2_dfrbpq_1_3.RESET_B 0.05826f
C295 VDD a_1192_3900# 0.16521f
C296 sg13g2_buf_4_0.X sg13g2_xor2_1_1.X 0.16208f
C297 sg13g2_dfrbpq_1_4.D a_26458_16237# 0.02837f
C298 sg13g2_xnor2_1_1.A sg13g2_xor2_1_1.B 0.01021f
C299 sg13g2_dfrbpq_1_2.CLK a_11470_15423# 0.01407f
C300 a_10967_15549# sg13g2_dfrbpq_1_2.RESET_B 0.0238f
C301 VDD a_2481_15556# 0.01107f
C302 sg13g2_mux2_1_1.X a_25382_14922# 0.03545f
C303 sg13g2_dfrbpq_1_3.RESET_B a_13642_14452# 0.1587f
C304 sg13g2_xor2_1_1.X a_13642_14452# 0.01404f
C305 sg13g2_xnor2_1_1.A a_11364_14909# 0.01893f
C306 sg13g2_nand2_2_0.A sg13g2_dfrbpq_1_3.D 0.06274f
C307 a_32492_15960# sg13g2_inv_1_1.A 0.16111f
C308 sg13g2_nand2_2_0.Y sg13g2_or3_1_0.A 0.34891f
C309 sg13g2_dfrbpq_1_7.CLK a_25956_15552# 0.08831f
C310 counter_value_o[2] clock_i 0.04044f
C311 a_27215_15311# a_27121_15311# 0.15029f
C312 VDD a_14085_14495# 0.24369f
C313 sg13g2_dfrbpq_1_6.Q sg13g2_dlygate4sd3_1_12.A 0.20505f
C314 sg13g2_dlygate4sd3_1_9.A a_17038_15423# 0.0364f
C315 sg13g2_buf_4_0.X sg13g2_inv_1_1.A 0.01342f
C316 sg13g2_inv_1_0.Y sg13g2_or3_1_0.A 0.59093f
C317 sg13g2_tiehi_1.L_HI sg13g2_dlygate4sd3_1_2.A 0.03888f
C318 sg13g2_dlygate4sd3_1_2.X a_7236_15552# 0.02729f
C319 sg13g2_a21oi_1_1.Y sg13g2_inv_1_0.Y 0.1598f
C320 VDD a_27041_13912# 0.19932f
C321 sg13g2_xor2_1_1.X a_14081_16262# 0.01189f
C322 sg13g2_buf_4_0.X a_22202_14484# 0.01081f
C323 sg13g2_buf_1_9.X sg13g2_xnor2_1_0.Y 0.2995f
C324 VDD a_17816_15238# 0.25328f
C325 a_7236_15552# a_7524_15247# 0.22255f
C326 sg13g2_nand2_1_1.A a_20272_14726# 0.01162f
C327 a_24824_15238# sg13g2_mux2_1_0.X 0.22147f
C328 sg13g2_dfrbpq_1_7.CLK sg13g2_mux2_1_1.A0 0.03564f
C329 VDD a_15968_13854# 0.08264f
C330 a_21946_14854# sg13g2_nor3_1_0.C 0.01579f
C331 sg13g2_nand2_2_0.A sg13g2_xor2_1_1.A 0.02337f
C332 sg13g2_nand2_1_1.A sg13g2_nand3_1_1.Y 1.08839f
C333 a_3915_15356# sg13g2_dlygate4sd3_1_2.X 0.01245f
C334 sg13g2_buf_1_0.X sg13g2_buf_1_9.X 2.05501f
C335 a_26927_14845# sg13g2_dfrbpq_1_5.RESET_B 0.07576f
C336 VDD a_4666_14448# 0.26986f
C337 sg13g2_mux2_1_1.X VDD 0.44239f
C338 sg13g2_dlygate4sd3_1_2.X a_2684_15532# 0.01187f
C339 a_3396_15552# a_3813_15213# 0.22605f
C340 a_3110_15234# a_3915_15356# 0.06896f
C341 sg13g2_dlygate4sd3_1_9.A counter_value_o[3] 0.01008f
C342 a_13956_14909# a_14187_14495# 0.06628f
C343 VDD a_25856_13854# 0.09051f
C344 sg13g2_dfrbpq_1_2.CLK a_11076_14488# 0.0769f
C345 sg13g2_nor3_1_0.C sg13g2_or3_1_0.A 0.1288f
C346 a_8872_16082# VDD 0.15993f
C347 sg13g2_buf_4_0.X sg13g2_dlygate4sd3_1_9.A 0.1257f
C348 VDD a_26373_15213# 0.24785f
C349 a_22806_14484# a_22508_14484# 0.15195f
C350 sg13g2_dlygate4sd3_1_2.A a_6950_15234# 0.01729f
C351 a_11493_14495# a_11364_14909# 0.01562f
C352 a_11076_14488# a_11595_14495# 0.18362f
C353 a_2513_15288# a_2684_15532# 0.19823f
C354 sg13g2_buf_1_9.X sg13g2_nor2b_1_0.Y 0.02518f
C355 a_27500_15960# counter_value_o[5] 0.13339f
C356 sg13g2_buf_4_0.X a_16078_14484# 0.12833f
C357 sg13g2_buf_1_9.X a_19984_13942# 0.01001f
C358 sg13g2_nand2_2_0.Y sg13g2_nor3_1_0.Y 0.45381f
C359 sg13g2_tiehi_1.L_HI a_3370_15457# 0.13398f
C360 sg13g2_nor4_2_0.Y sg13g2_mux2_1_1.A0 0.02759f
C361 sg13g2_dfrbpq_1_4.D sg13g2_dfrbpq_1_4.RESET_B 0.10808f
C362 sg13g2_dfrbpq_1_1.RESET_B a_6950_15234# 0.10026f
C363 VDD sg13g2_buf_1_9.X 3.24576f
C364 a_8752_15454# a_9162_15532# 0.05221f
C365 a_7210_15457# a_7236_15552# 0.21121f
C366 a_18470_14922# a_19173_14495# 0.02432f
C367 VDD a_24334_13764# 0.15884f
C368 a_18665_16334# a_18586_16237# 0.08074f
C369 a_3813_15213# sg13g2_dlygate4sd3_1_2.A 0.02317f
C370 sg13g2_dfrbpq_1_3.RESET_B a_13278_15934# 0.03946f
C371 VDD a_38536_10034# 0.13142f
C372 a_27472_15454# sg13g2_dlygate4sd3_1_12.A 0.01134f
C373 sg13g2_dfrbpq_1_7.CLK a_18987_13844# 0.0335f
C374 a_19630_15238# sg13g2_buf_16_1.X 0.36485f
C375 a_10790_14922# a_11076_14488# 0.21832f
C376 sg13g2_buf_1_0.X sg13g2_xnor2_1_0.Y 0.03253f
C377 sg13g2_xnor2_1_0.A a_8590_14751# 0.09837f
C378 sg13g2_nor2b_1_1.A sg13g2_inv_1_1.A 0.17676f
C379 a_12592_14726# a_13002_14484# 0.05221f
C380 sg13g2_buf_4_0.X sg13g2_nand2_2_0.Y 0.44636f
C381 sg13g2_dfrbpq_1_2.CLK sg13g2_dlygate4sd3_1_0.A 0.03337f
C382 a_18086_15238# a_18198_15302# 0.32411f
C383 sg13g2_dlygate4sd3_1_2.X a_3976_14570# 0.02251f
C384 sg13g2_mux2_1_1.X a_25592_16037# 0.21685f
C385 a_26927_14845# a_25668_14488# 0.01303f
C386 sg13g2_buf_1_9.X a_17718_13790# 0.01055f
C387 sg13g2_buf_4_0.X sg13g2_and2_1_2.X 0.02252f
C388 sg13g2_dfrbpq_1_2.CLK sg13g2_dfrbpq_1_3.RESET_B 0.15889f
C389 sg13g2_dfrbpq_1_2.CLK sg13g2_xor2_1_1.X 0.08234f
C390 sg13g2_buf_4_0.X sg13g2_inv_1_0.Y 0.15443f
C391 a_17336_13726# sg13g2_or3_1_0.X 0.0463f
C392 a_18280_16082# VDD 0.12408f
C393 sg13g2_buf_1_9.X sg13g2_and2_1_2.B 0.42866f
C394 a_17621_12972# sg13g2_inv_1_0.Y 0.01123f
C395 a_26926_13911# a_27041_13912# 0.32411f
C396 a_13642_14452# sg13g2_inv_1_0.Y 0.02841f
C397 VDD a_18374_12972# 0.20376f
C398 VDD a_25382_14922# 0.44639f
C399 VDD sg13g2_xnor2_1_0.Y 0.48052f
C400 a_17699_16265# a_17908_16020# 0.01473f
C401 sg13g2_nor3_1_0.C sg13g2_nor3_1_0.Y 0.08973f
C402 sg13g2_dfrbpq_1_4.D sg13g2_dfrbpq_1_5.D 0.03818f
C403 sg13g2_nand2_1_1.A sg13g2_dlygate4sd3_1_9.A 0.59677f
C404 a_17434_15202# a_17816_15238# 0.03205f
C405 VDD a_18730_14452# 0.11239f
C406 sg13g2_nand3_1_1.Y a_15704_15242# 0.01426f
C407 a_7930_14854# sg13g2_xnor2_1_0.B 0.01562f
C408 sg13g2_xor2_1_1.A sg13g2_xor2_1_1.B 0.09074f
C409 sg13g2_dfrbpq_1_6.RESET_B a_18730_14452# 0.13434f
C410 sg13g2_buf_4_0.X sg13g2_dfrbpq_1_2.RESET_B 0.01628f
C411 sg13g2_xnor2_1_0.A a_9162_15532# 0.06205f
C412 sg13g2_dfrbpq_1_7.CLK sg13g2_dfrbpq_1_7.RESET_B 0.04544f
C413 sg13g2_dfrbpq_1_6.Q counter_value_o[5] 0.01131f
C414 a_26475_15356# sg13g2_dfrbpq_1_6.Q 0.01241f
C415 a_19044_14909# a_19275_14495# 0.06628f
C416 sg13g2_dlygate4sd3_1_11.A a_18987_13844# 0.03757f
C417 a_3813_15213# a_3370_15457# 0.02242f
C418 a_12524_15960# VDD 0.17527f
C419 a_14081_16262# sg13g2_inv_1_0.Y 0.012f
C420 sg13g2_buf_1_0.X VDD 3.19534f
C421 a_18468_14040# a_18756_13735# 0.22255f
C422 sg13g2_dlygate4sd3_1_2.A a_4666_14448# 0.2459f
C423 sg13g2_dfrbpq_1_7.RESET_B a_18756_14488# 0.02181f
C424 VDD a_11866_15202# 0.26504f
C425 a_17715_13320# sg13g2_dlygate4sd3_1_3.X 0.01177f
C426 sg13g2_buf_4_0.X sg13g2_nor3_1_0.C 0.06411f
C427 sg13g2_dfrbpq_1_5.RESET_B sg13g2_dfrbpq_1_4.RESET_B 0.01078f
C428 a_38536_10034# a_38720_10034# 0.0262f
C429 a_13079_16301# a_13278_15934# 0.01313f
C430 a_27594_14484# sg13g2_dlygate4sd3_1_12.A 0.04844f
C431 sg13g2_dlygate4sd3_1_11.A a_19727_13799# 0.03518f
C432 sg13g2_nor3_1_0.Y a_23483_14540# 0.10438f
C433 a_19727_13799# a_20394_14020# 0.06982f
C434 sg13g2_buf_1_9.X a_24333_15280# 0.15484f
C435 sg13g2_buf_4_0.X a_14187_14495# 0.02019f
C436 a_18442_13945# a_18885_13701# 0.02242f
C437 sg13g2_dlygate4sd3_1_10.X a_18468_14040# 0.01412f
C438 VDD sg13g2_nor2b_1_0.Y 0.24213f
C439 a_26187_14495# a_26927_14845# 0.15395f
C440 VDD a_19984_13942# 0.12869f
C441 a_3813_14521# a_3976_14570# 0.01744f
C442 a_12592_14726# sg13g2_dfrbpq_1_2.RESET_B 0.0605f
C443 sg13g2_nand2_2_0.A a_16089_13723# 0.02449f
C444 sg13g2_dlygate4sd3_1_2.A sg13g2_buf_1_9.X 0.05813f
C445 a_13956_14909# a_13668_14488# 0.22255f
C446 VDD a_37484_15960# 0.19704f
C447 sg13g2_nand2_2_0.Y sg13g2_dlygate4sd3_1_10.X 0.03928f
C448 VDD sg13g2_dfrbpq_1_6.RESET_B 1.26682f
C449 sg13g2_buf_1_9.X a_15610_13690# 0.01021f
C450 a_18944_13058# sg13g2_or3_1_0.A 0.01456f
C451 sg13g2_dfrbpq_1_2.CLK a_13002_14484# 0.01236f
C452 sg13g2_dfrbpq_1_7.RESET_B sg13g2_dlygate4sd3_1_11.A 0.06009f
C453 sg13g2_buf_4_0.X a_11050_14452# 0.01896f
C454 a_3396_15552# a_4561_15311# 0.22369f
C455 a_3915_15356# a_3684_15247# 0.06628f
C456 VDD counter_value_o[4] 0.12966f
C457 a_25956_15552# a_26373_15213# 0.22605f
C458 a_25670_15234# a_26475_15356# 0.06896f
C459 a_23709_14508# a_23806_14854# 0.02903f
C460 VDD a_8384_14570# 0.06878f
C461 sg13g2_buf_1_9.X a_4270_14751# 0.01202f
C462 sg13g2_or3_1_0.X sg13g2_dlygate4sd3_1_3.A 0.0895f
C463 sg13g2_mux2_1_0.A0 a_23272_15366# 0.01111f
C464 sg13g2_dfrbpq_1_7.CLK sg13g2_dfrbpq_1_6.Q 0.88242f
C465 a_3689_14822# a_3610_14725# 0.08074f
C466 VDD a_17718_13790# 0.14858f
C467 a_3396_15552# sg13g2_buf_1_0.X 0.02057f
C468 sg13g2_buf_4_0.X a_19275_14495# 0.01746f
C469 sg13g2_inv_1_1.Y sg13g2_nor3_1_0.Y 0.05271f
C470 sg13g2_dfrbpq_1_5.D sg13g2_dfrbpq_1_5.RESET_B 0.30514f
C471 a_13079_16071# VDD 0.07086f
C472 sg13g2_dfrbpq_1_7.CLK a_20015_14845# 0.0117f
C473 a_12232_16082# counter_value_o[2] 0.02118f
C474 sg13g2_nand2_2_0.A a_11076_14488# 0.01297f
C475 sg13g2_mux2_1_1.X sg13g2_mux2_1_1.A0 0.02812f
C476 sg13g2_buf_1_0.X a_2240_15366# 0.01239f
C477 a_14927_14845# sg13g2_dlygate4sd3_1_11.A 0.01786f
C478 VDD sg13g2_and2_1_2.B 0.33911f
C479 sg13g2_tiehi_1.L_HI sg13g2_dlygate4sd3_1_2.X 0.04825f
C480 a_18756_14488# a_20015_14845# 0.01303f
C481 a_26244_15247# a_25670_15234# 0.16388f
C482 a_27472_15454# a_26475_15356# 0.01528f
C483 sg13g2_dlygate4sd3_1_2.A a_4561_15311# 0.0179f
C484 sg13g2_nand2_1_1.A sg13g2_nor3_1_0.C 0.15845f
C485 VDD a_15594_14484# 0.24154f
C486 a_23360_14570# a_23483_14540# 0.01108f
C487 a_25592_16037# VDD 0.24886f
C488 sg13g2_tiehi_1.L_HI a_3110_15234# 0.07703f
C489 sg13g2_buf_4_0.X sg13g2_a21oi_1_0.Y 0.09033f
C490 sg13g2_dfrbpq_1_5.RESET_B a_26085_14495# 0.02866f
C491 sg13g2_dfrbpq_1_3.D a_13382_14922# 0.1668f
C492 sg13g2_xnor2_1_0.A sg13g2_xnor2_1_0.B 0.47151f
C493 a_16056_15552# sg13g2_o21ai_1_0.Y 0.01075f
C494 sg13g2_dfrbpq_1_2.CLK sg13g2_inv_1_0.Y 0.04872f
C495 sg13g2_dfrbpq_1_6.D a_18198_15302# 0.08842f
C496 sg13g2_buf_1_9.X a_23566_13764# 0.1691f
C497 sg13g2_nor4_2_0.Y sg13g2_nor2b_1_1.Y 0.02475f
C498 sg13g2_buf_1_9.X sg13g2_mux2_1_1.A0 0.03905f
C499 a_3396_15552# VDD 0.09247f
C500 a_17606_13726# sg13g2_dlygate4sd3_1_3.X 0.02455f
C501 sg13g2_buf_4_0.X sg13g2_inv_1_1.Y 0.12504f
C502 sg13g2_xnor2_1_0.Y a_7151_13726# 0.02175f
C503 VDD a_38720_10034# 0.0583f
C504 a_26537_16334# a_26661_16033# 0.06917f
C505 sg13g2_nor4_2_0.Y sg13g2_dfrbpq_1_6.Q 0.96731f
C506 a_1192_9948# sg13g2_buf_1_9.X 0.13353f
C507 a_7450_16237# counter_value_o[1] 0.02932f
C508 sg13g2_dlygate4sd3_1_2.A sg13g2_buf_1_0.X 0.27975f
C509 VDD a_2240_15366# 0.09471f
C510 sg13g2_nand3_1_1.Y sg13g2_nand2_2_0.A 0.15777f
C511 sg13g2_dlygate4sd3_1_11.A sg13g2_dfrbpq_1_6.Q 0.03706f
C512 a_25206_15302# sg13g2_dfrbpq_1_5.D 0.09061f
C513 sg13g2_dfrbpq_1_7.CLK a_25670_15234# 0.02201f
C514 sg13g2_buf_4_0.X sg13g2_o21ai_1_0.Y 0.0172f
C515 sg13g2_nand2_2_0.Y a_17014_13350# 0.07208f
C516 sg13g2_dfrbpq_1_2.CLK sg13g2_dfrbpq_1_2.RESET_B 0.0409f
C517 sg13g2_nand2_1_1.A a_18198_15302# 0.01778f
C518 sg13g2_dfrbpq_1_3.D a_12308_15202# 0.05094f
C519 sg13g2_nand2_2_0.A sg13g2_dfrbpq_1_3.RESET_B 0.27383f
C520 sg13g2_nand2_2_0.A sg13g2_xor2_1_1.X 0.03211f
C521 sg13g2_dfrbpq_1_2.RESET_B a_11595_14495# 0.21427f
C522 a_18486_12996# sg13g2_or3_1_0.A 0.0157f
C523 sg13g2_and2_1_2.X a_10790_14922# 0.16471f
C524 VDD a_24333_15280# 0.25716f
C525 VDD a_20682_14484# 0.24009f
C526 a_17336_13726# sg13g2_nand2_2_0.Y 0.01285f
C527 a_24443_14540# a_24766_14854# 0.22783f
C528 VDD a_26926_13911# 0.14651f
C529 sg13g2_dlygate4sd3_1_2.A VDD 1.48394f
C530 sg13g2_xor2_1_1.X sg13g2_buf_16_1.X 0.11842f
C531 sg13g2_buf_1_9.X a_7450_14448# 0.01053f
C532 sg13g2_dlygate4sd3_1_0.A counter_value_o[1] 0.0136f
C533 sg13g2_buf_16_1.X sg13g2_a21oi_1_0.A1 0.01332f
C534 VDD a_17434_15202# 0.25313f
C535 sg13g2_nand2_1_1.A a_19275_14495# 0.01033f
C536 a_6950_15234# a_7524_15247# 0.16388f
C537 a_7755_15356# a_8752_15454# 0.01528f
C538 a_14927_14845# a_14833_14845# 0.15029f
C539 sg13g2_dfrbpq_1_1.RESET_B VDD 1.04854f
C540 sg13g2_buf_4_0.X a_13668_14488# 0.01238f
C541 VDD a_15610_13690# 0.26436f
C542 a_1192_3900# enable_i 0.1635f
C543 sg13g2_nand3_1_1.Y clock_i 0.06904f
C544 sg13g2_dlygate4sd3_1_9.A a_15304_15366# 0.01687f
C545 a_19546_12936# a_19265_13238# 0.15158f
C546 sg13g2_dfrbpq_1_2.CLK a_14187_14495# 0.0184f
C547 sg13g2_dlygate4sd3_1_2.X a_8401_15311# 0.01145f
C548 a_17699_16265# sg13g2_nand3_1_1.Y 0.1639f
C549 a_3813_15213# sg13g2_dlygate4sd3_1_2.X 0.01256f
C550 a_13642_14452# a_13668_14488# 0.21121f
C551 a_15214_13911# sg13g2_buf_1_9.X 0.01239f
C552 a_25668_14488# a_26085_14495# 0.22698f
C553 sg13g2_dfrbpq_1_2.RESET_B a_10790_14922# 0.07347f
C554 a_27184_14726# sg13g2_dfrbpq_1_5.RESET_B 0.0605f
C555 sg13g2_dfrbpq_1_7.CLK sg13g2_nor2b_1_0.A 0.03463f
C556 sg13g2_dlygate4sd3_1_0.A clock_i 0.07657f
C557 VDD a_4270_14751# 0.14831f
C558 sg13g2_buf_1_0.X a_3370_15457# 0.0113f
C559 sg13g2_buf_1_9.X a_18987_13844# 0.01684f
C560 a_3110_15234# a_3813_15213# 0.02454f
C561 a_17224_15996# counter_value_o[3] 0.1437f
C562 sg13g2_nand2_1_1.A sg13g2_a21oi_1_0.Y 0.05463f
C563 sg13g2_xor2_1_1.X clock_i 0.01169f
C564 a_18586_16237# a_18789_16033# 0.01313f
C565 a_19049_16334# a_18970_16237# 0.08074f
C566 VDD a_26062_13911# 0.14457f
C567 counter_value_o[0] clock_i 0.04192f
C568 VDD a_25956_15552# 0.07206f
C569 sg13g2_a21oi_1_0.A2 VDD 0.42705f
C570 sg13g2_buf_1_0.X a_1192_9948# 0.01238f
C571 a_19630_15238# sg13g2_dfrbpq_1_7.CLK 0.97429f
C572 a_6760_15366# sg13g2_and2_1_1.X 0.02955f
C573 a_16681_13726# a_16089_13723# 0.01623f
C574 a_11076_14488# a_11364_14909# 0.22255f
C575 sg13g2_nor4_2_0.Y a_22508_14484# 0.01057f
C576 VDD a_10967_15315# 0.06418f
C577 sg13g2_dlygate4sd3_1_12.A counter_value_o[7] 0.012f
C578 sg13g2_dfrbpq_1_7.CLK a_18470_14922# 0.01371f
C579 sg13g2_dlygate4sd3_1_11.A a_22508_14484# 0.02182f
C580 sg13g2_nand2_1_1.A sg13g2_o21ai_1_0.Y 0.23231f
C581 a_8495_15311# a_9162_15532# 0.06982f
C582 sg13g2_inv_1_1.A sg13g2_dlygate4sd3_1_12.A 0.46375f
C583 a_7210_15457# a_6950_15234# 0.39302f
C584 a_7450_14448# sg13g2_xnor2_1_0.Y 0.2298f
C585 VDD a_3370_15457# 0.11845f
C586 a_23566_13764# sg13g2_nor2b_1_0.Y 0.1345f
C587 sg13g2_buf_1_9.X sg13g2_xnor2_1_1.A 0.17524f
C588 sg13g2_nand2_2_0.A sg13g2_dlygate4sd3_1_9.A 0.24734f
C589 a_18470_14922# a_18756_14488# 0.21832f
C590 VDD a_23566_13764# 0.16445f
C591 sg13g2_nor2b_1_0.A sg13g2_nor4_2_0.Y 0.0241f
C592 sg13g2_a21oi_1_1.Y sg13g2_or3_1_0.A 0.02179f
C593 a_3396_15552# sg13g2_dlygate4sd3_1_2.A 0.03684f
C594 sg13g2_dfrbpq_1_4.D sg13g2_dfrbpq_1_5.RESET_B 0.09026f
C595 sg13g2_dfrbpq_1_6.D a_18368_14570# 0.01657f
C596 VDD sg13g2_mux2_1_1.A0 0.18354f
C597 sg13g2_nand2_2_0.A a_13002_14484# 0.07298f
C598 VDD a_27882_15532# 0.24478f
C599 a_27215_15311# sg13g2_dlygate4sd3_1_12.A 0.01224f
C600 VDD a_1192_9948# 0.16521f
C601 sg13g2_dlygate4sd3_1_9.A sg13g2_buf_16_1.X 0.02657f
C602 sg13g2_dfrbpq_1_7.RESET_B sg13g2_buf_1_9.X 0.0409f
C603 sg13g2_dfrbpq_1_7.CLK a_18885_13701# 0.16139f
C604 a_19162_15202# sg13g2_buf_16_1.X 0.01886f
C605 a_10790_14922# a_11050_14452# 0.39302f
C606 sg13g2_nand2_2_0.A a_16078_14484# 0.0512f
C607 sg13g2_dlygate4sd3_1_0.A sg13g2_xor2_1_1.B 0.06116f
C608 a_12592_14726# a_12335_14845# 0.20069f
C609 sg13g2_dlygate4sd3_1_3.A sg13g2_nand2_2_0.Y 0.24381f
C610 sg13g2_xor2_1_1.X a_14362_15960# 0.23896f
C611 a_4912_15454# a_5322_15532# 0.05221f
C612 sg13g2_buf_16_1.X a_16078_14484# 0.97532f
C613 sg13g2_buf_1_9.X a_17606_13726# 0.01035f
C614 a_26187_14495# a_26085_14495# 0.27006f
C615 sg13g2_nor2b_1_1.A a_24766_14854# 0.01401f
C616 sg13g2_mux2_1_0.X a_24443_14540# 0.06604f
C617 a_18944_13058# sg13g2_dlygate4sd3_1_10.X 0.01277f
C618 sg13g2_dfrbpq_1_3.RESET_B sg13g2_xor2_1_1.B 0.01558f
C619 a_20015_14845# a_19921_14845# 0.15029f
C620 sg13g2_xor2_1_1.X sg13g2_xor2_1_1.B 0.37685f
C621 a_8872_16082# sg13g2_dlygate4sd3_1_2.X 0.01912f
C622 a_16681_13726# sg13g2_or3_1_0.X 0.11028f
C623 sg13g2_dlygate4sd3_1_3.A a_17112_12952# 0.01075f
C624 sg13g2_nor2b_1_1.A a_26085_14495# 0.01312f
C625 sg13g2_dlygate4sd3_1_11.A a_18470_14922# 0.01473f
C626 a_11585_15424# a_11866_15202# 0.15158f
C627 sg13g2_mux2_1_1.X sg13g2_nor2b_1_1.Y 0.02202f
C628 VDD a_7450_14448# 0.26555f
C629 sg13g2_dlygate4sd3_1_9.A clock_i 0.05091f
C630 sg13g2_nand2_2_0.A sg13g2_nand2_2_0.Y 0.23645f
C631 sg13g2_dlygate4sd3_1_2.X sg13g2_buf_1_9.X 0.31656f
C632 sg13g2_mux2_1_1.X sg13g2_dfrbpq_1_6.Q 0.03452f
C633 sg13g2_dlygate4sd3_1_2.A sg13g2_dfrbpq_1_1.RESET_B 0.03843f
C634 a_13626_13918# sg13g2_xor2_1_1.B 0.19127f
C635 a_16078_14484# clock_i 0.35794f
C636 sg13g2_nand2_2_0.A sg13g2_inv_1_0.Y 0.6492f
C637 a_27208_16082# counter_value_o[5] 0.02816f
C638 a_26373_15213# sg13g2_dfrbpq_1_6.Q 0.01327f
C639 sg13g2_dlygate4sd3_1_11.A a_18885_13701# 0.01838f
C640 a_3396_15552# a_3370_15457# 0.21121f
C641 VDD a_15214_13911# 0.1453f
C642 a_18182_13722# a_18756_13735# 0.16388f
C643 a_18987_13844# a_19984_13942# 0.01528f
C644 sg13g2_buf_16_1.X sg13g2_inv_1_0.Y 0.09416f
C645 sg13g2_dfrbpq_1_7.RESET_B a_18730_14452# 0.01243f
C646 sg13g2_buf_1_9.X sg13g2_nor2b_1_1.Y 0.01599f
C647 VDD a_18987_13844# 0.22342f
C648 VDD a_11585_15424# 0.19426f
C649 sg13g2_buf_1_9.X sg13g2_dfrbpq_1_6.Q 0.01839f
C650 sg13g2_dfrbpq_1_2.CLK a_13668_14488# 0.05805f
C651 a_13079_16301# a_12992_16082# 0.01514f
C652 a_26927_14845# sg13g2_dlygate4sd3_1_12.A 0.0212f
C653 sg13g2_nand2_2_0.A sg13g2_dfrbpq_1_2.RESET_B 0.03397f
C654 a_24334_13764# sg13g2_nor2b_1_1.Y 0.13291f
C655 a_19727_13799# a_19984_13942# 0.20069f
C656 sg13g2_dfrbpq_1_2.CLK sg13g2_and2_1_1.X 0.01192f
C657 sg13g2_dlygate4sd3_1_10.X a_18182_13722# 0.15989f
C658 a_18442_13945# a_18468_14040# 0.21121f
C659 a_26187_14495# a_27184_14726# 0.01569f
C660 VDD a_19727_13799# 0.17838f
C661 a_27322_13690# sg13g2_inv_1_1.A 0.01879f
C662 sg13g2_dlygate4sd3_1_2.A a_3370_15457# 0.01536f
C663 sg13g2_buf_4_0.X sg13g2_or3_1_0.A 0.42316f
C664 sg13g2_inv_1_0.Y clock_i 0.03017f
C665 a_24333_15280# sg13g2_mux2_1_1.A0 0.06166f
C666 sg13g2_buf_4_0.A sg13g2_xnor2_1_0.A 0.17585f
C667 VDD sg13g2_xnor2_1_1.A 0.26376f
C668 a_24824_15238# a_25094_15238# 0.15158f
C669 sg13g2_buf_1_9.X a_15329_13912# 0.01027f
C670 sg13g2_dfrbpq_1_2.CLK a_12335_14845# 0.02033f
C671 a_27500_15960# VDD 0.19815f
C672 sg13g2_dfrbpq_1_2.CLK a_5322_15532# 0.01092f
C673 a_3813_15213# a_3684_15247# 0.01562f
C674 sg13g2_buf_1_9.X a_10605_13768# 0.1022f
C675 sg13g2_buf_4_0.X a_18086_15238# 0.02232f
C676 a_10176_14523# a_10325_14854# 0.17527f
C677 sg13g2_dfrbpq_1_7.RESET_B a_19984_13942# 0.06198f
C678 a_17621_12972# sg13g2_a21oi_1_1.Y 0.09044f
C679 a_18486_12996# sg13g2_dlygate4sd3_1_10.X 0.09833f
C680 a_25670_15234# a_26373_15213# 0.02454f
C681 a_12335_14845# a_11595_14495# 0.15395f
C682 sg13g2_buf_1_0.X enable_i 0.02554f
C683 a_23709_14508# a_23483_14540# 0.02726f
C684 VDD sg13g2_dfrbpq_1_7.RESET_B 1.1916f
C685 sg13g2_nor2b_1_1.A sg13g2_mux2_1_0.X 0.34997f
C686 VDD a_8200_14570# 0.13018f
C687 sg13g2_dlygate4sd3_1_2.X sg13g2_buf_1_0.X 3.50945f
C688 sg13g2_dfrbpq_1_7.RESET_B sg13g2_dfrbpq_1_6.RESET_B 0.20236f
C689 sg13g2_dfrbpq_1_7.CLK sg13g2_mux2_1_0.A0 0.03759f
C690 a_14187_14495# sg13g2_buf_16_1.X 0.01936f
C691 sg13g2_dfrbpq_1_6.Q a_25382_14922# 0.01431f
C692 a_13652_14020# sg13g2_xor2_1_1.B 0.03097f
C693 a_25374_15934# sg13g2_dfrbpq_1_5.RESET_B 0.03624f
C694 sg13g2_buf_1_0.X a_7524_15247# 0.02241f
C695 VDD a_17606_13726# 0.20185f
C696 a_3110_15234# sg13g2_buf_1_0.X 0.0163f
C697 a_25206_15302# sg13g2_dfrbpq_1_5.RESET_B 0.03104f
C698 a_12524_15960# counter_value_o[2] 0.13349f
C699 sg13g2_buf_1_0.X a_2513_15288# 0.07546f
C700 a_15184_14726# sg13g2_dlygate4sd3_1_11.A 0.0128f
C701 a_8986_14448# a_8705_14750# 0.15158f
C702 a_8200_14570# a_8384_14570# 0.0262f
C703 sg13g2_buf_4_0.X sg13g2_buf_4_0.A 0.06811f
C704 a_19173_14495# a_19275_14495# 0.27006f
C705 sg13g2_xor2_1_1.A sg13g2_buf_1_9.X 0.94988f
C706 VDD enable_i 0.25103f
C707 a_27215_15311# a_26475_15356# 0.15395f
C708 sg13g2_xnor2_1_1.A sg13g2_and2_1_2.B 0.0109f
C709 sg13g2_xnor2_1_0.B a_7116_13912# 0.19918f
C710 a_13278_15934# sg13g2_dlygate4sd3_1_4.X 0.01847f
C711 VDD a_14927_14845# 0.17347f
C712 a_7653_15213# a_7755_15356# 0.26919f
C713 sg13g2_dlygate4sd3_1_2.X VDD 0.57893f
C714 sg13g2_and2_1_2.X sg13g2_xor2_1_1.B 0.03429f
C715 sg13g2_dfrbpq_1_5.RESET_B a_25668_14488# 0.25823f
C716 sg13g2_nor2b_1_0.A a_25856_13854# 0.01352f
C717 sg13g2_inv_1_0.Y sg13g2_xor2_1_1.B 0.13844f
C718 sg13g2_xnor2_1_0.A a_7169_14750# 0.06636f
C719 sg13g2_inv_1_1.A a_23272_13854# 0.01805f
C720 sg13g2_nor4_2_0.Y a_23806_14854# 0.02544f
C721 a_17606_13726# a_17718_13790# 0.32411f
C722 a_3110_15234# VDD 0.4846f
C723 a_26537_16334# a_26458_16237# 0.08074f
C724 sg13g2_nor4_2_0.Y sg13g2_mux2_1_0.A0 0.03809f
C725 a_10792_15366# a_10967_15549# 0.01214f
C726 VDD a_11493_14495# 0.24417f
C727 VDD counter_value_o[2] 0.09164f
C728 VDD a_2513_15288# 0.17193f
C729 sg13g2_buf_4_0.X sg13g2_nor3_1_0.Y 0.46231f
C730 sg13g2_dfrbpq_1_3.RESET_B a_13382_14922# 0.10397f
C731 sg13g2_xor2_1_1.X a_13382_14922# 0.03759f
C732 sg13g2_nand2_1_1.A sg13g2_or3_1_0.A 0.05027f
C733 sg13g2_dfrbpq_1_2.CLK a_7755_15356# 0.02251f
C734 sg13g2_buf_1_9.X sg13g2_nor2b_1_0.A 0.13711f
C735 VDD sg13g2_nor2b_1_1.Y 0.32892f
C736 sg13g2_dfrbpq_1_7.CLK a_25930_15457# 0.01085f
C737 a_25862_15996# sg13g2_dfrbpq_1_4.D 0.02927f
C738 VDD sg13g2_dfrbpq_1_6.Q 0.78087f
C739 sg13g2_dlygate4sd3_1_10.X sg13g2_or3_1_0.A 0.41227f
C740 sg13g2_dfrbpq_1_2.RESET_B sg13g2_xor2_1_1.B 0.03281f
C741 sg13g2_nand2_1_1.A a_18086_15238# 0.01853f
C742 sg13g2_dfrbpq_1_6.RESET_B sg13g2_dfrbpq_1_6.Q 0.01015f
C743 sg13g2_nor2b_1_0.A a_24334_13764# 0.01553f
C744 a_24943_14508# sg13g2_nor2b_1_1.Y 0.01192f
C745 a_18104_13013# sg13g2_or3_1_0.A 0.01811f
C746 sg13g2_buf_16_1.X sg13g2_a21oi_1_0.Y 0.05802f
C747 VDD a_20015_14845# 0.17379f
C748 a_16681_13726# sg13g2_nand2_2_0.Y 0.16486f
C749 sg13g2_a21oi_1_1.Y a_18104_13013# 0.25638f
C750 sg13g2_nand3_1_1.Y sg13g2_dlygate4sd3_1_11.A 0.09185f
C751 VDD a_26458_13690# 0.25041f
C752 sg13g2_dfrbpq_1_6.RESET_B a_20015_14845# 0.07576f
C753 sg13g2_dfrbpq_1_3.RESET_B a_12308_15202# 0.04437f
C754 sg13g2_xor2_1_1.X a_12308_15202# 0.0142f
C755 a_2248_16082# VDD 0.15815f
C756 sg13g2_buf_1_9.X a_7054_14751# 0.01234f
C757 sg13g2_inv_1_1.Y a_22806_14484# 0.08125f
C758 VDD a_17153_15424# 0.19858f
C759 a_7755_15356# a_8495_15311# 0.15395f
C760 a_14927_14845# a_15594_14484# 0.06982f
C761 sg13g2_nand2_2_0.A sg13g2_o21ai_1_0.Y 0.13541f
C762 a_16681_13726# sg13g2_inv_1_0.Y 0.01465f
C763 sg13g2_buf_4_0.X a_13642_14452# 0.01244f
C764 VDD a_15329_13912# 0.19861f
C765 VDD a_7210_15457# 0.09578f
C766 sg13g2_dfrbpq_1_3.D VDD 0.27692f
C767 sg13g2_or3_1_0.X sg13g2_dlygate4sd3_1_3.X 0.30159f
C768 VDD a_10605_13768# 0.26801f
C769 a_19150_13239# a_19265_13238# 0.32411f
C770 sg13g2_xor2_1_1.X sg13g2_dlygate4sd3_1_11.A 0.01604f
C771 a_3396_15552# sg13g2_dlygate4sd3_1_2.X 0.04537f
C772 sg13g2_tiehi_1.L_HI a_3610_14725# 0.05556f
C773 a_25642_14452# a_26085_14495# 0.02242f
C774 a_26187_14495# sg13g2_dfrbpq_1_5.RESET_B 0.21566f
C775 sg13g2_dlygate4sd3_1_2.A a_8200_14570# 0.01524f
C776 VDD a_3813_14521# 0.08334f
C777 sg13g2_dfrbpq_1_2.CLK a_8752_15454# 0.011f
C778 sg13g2_buf_1_9.X a_18885_13701# 0.01323f
C779 a_3110_15234# a_3396_15552# 0.21832f
C780 sg13g2_nor2b_1_1.A sg13g2_dfrbpq_1_5.RESET_B 0.02906f
C781 a_21728_14570# sg13g2_or3_1_0.A 0.01163f
C782 VDD a_25670_15234# 0.44661f
C783 VDD a_15008_13854# 0.07912f
C784 sg13g2_buf_4_0.X a_12592_14726# 0.01001f
C785 sg13g2_nor4_2_0.Y a_22202_14484# 0.1686f
C786 sg13g2_buf_16_1.X a_13668_14488# 0.03386f
C787 VDD a_11166_15486# 0.09695f
C788 sg13g2_buf_4_0.X sg13g2_dfrbpq_1_6.D 0.01824f
C789 sg13g2_o21ai_1_0.Y clock_i 0.0114f
C790 a_37192_16082# counter_value_o[7] 0.02118f
C791 VDD sg13g2_xor2_1_1.A 0.50848f
C792 sg13g2_dlygate4sd3_1_11.A a_22202_14484# 0.02247f
C793 a_8495_15311# a_8752_15454# 0.20069f
C794 a_7054_14751# sg13g2_xnor2_1_0.Y 0.03936f
C795 sg13g2_dlygate4sd3_1_2.A sg13g2_dlygate4sd3_1_2.X 0.09909f
C796 sg13g2_dlygate4sd3_1_0.A a_6950_15234# 0.0389f
C797 sg13g2_and2_1_2.B a_10605_13768# 0.18407f
C798 VDD a_22508_14484# 0.16674f
C799 a_18470_14922# a_18730_14452# 0.39302f
C800 a_17014_13350# sg13g2_or3_1_0.A 0.04501f
C801 VDD a_22691_14020# 0.01241f
C802 sg13g2_dlygate4sd3_1_2.X sg13g2_dfrbpq_1_1.RESET_B 0.01219f
C803 a_3110_15234# sg13g2_dlygate4sd3_1_2.A 0.03054f
C804 VDD a_24224_15366# 0.06528f
C805 VDD a_27472_15454# 0.12597f
C806 sg13g2_dfrbpq_1_2.CLK sg13g2_buf_4_0.A 0.01566f
C807 VDD a_38720_13058# 0.072f
C808 sg13g2_dfrbpq_1_7.CLK a_18468_14040# 0.04701f
C809 a_18881_15424# sg13g2_buf_16_1.X 0.0117f
C810 sg13g2_nor2b_1_0.A sg13g2_nor2b_1_0.Y 0.3892f
C811 sg13g2_buf_1_9.X sg13g2_and2_1_1.B 0.06507f
C812 a_8986_14448# sg13g2_buf_1_9.X 0.017f
C813 sg13g2_dlygate4sd3_1_2.A a_2513_15288# 0.01329f
C814 sg13g2_nand2_1_1.A sg13g2_buf_4_0.X 2.20058f
C815 sg13g2_dfrbpq_1_6.Q a_20682_14484# 0.07079f
C816 VDD sg13g2_nor2b_1_0.A 0.49648f
C817 sg13g2_dlygate4sd3_1_2.X a_4270_14751# 0.08869f
C818 sg13g2_dfrbpq_1_7.CLK sg13g2_nand2_2_0.Y 0.02022f
C819 a_4655_15311# a_5322_15532# 0.06982f
C820 a_25956_14909# a_26085_14495# 0.01562f
C821 a_26187_14495# a_25668_14488# 0.18362f
C822 a_18766_15423# a_18881_15424# 0.32411f
C823 sg13g2_nor2b_1_1.A a_24443_14540# 0.03638f
C824 sg13g2_buf_4_0.X a_10176_14523# 0.19293f
C825 sg13g2_dfrbpq_1_2.CLK sg13g2_xnor2_1_0.A 0.016f
C826 sg13g2_dlygate4sd3_1_9.A sg13g2_dlygate4sd3_1_11.A 0.39432f
C827 a_20015_14845# a_20682_14484# 0.06982f
C828 a_16681_13726# a_16877_14020# 0.01473f
C829 sg13g2_nor2b_1_1.A a_25668_14488# 0.01524f
C830 VDD a_19630_15238# 1.61356f
C831 a_13382_14922# sg13g2_inv_1_0.Y 0.03736f
C832 sg13g2_dlygate4sd3_1_11.A a_16078_14484# 0.03028f
C833 VDD a_17504_13058# 0.07649f
C834 VDD a_3684_15247# 0.01546f
C835 VDD a_7054_14751# 0.14663f
C836 a_17120_16082# sg13g2_dlygate4sd3_1_9.A 0.0133f
C837 a_17153_15424# a_17434_15202# 0.15158f
C838 sg13g2_dfrbpq_1_3.RESET_B a_14085_14495# 0.02707f
C839 VDD a_18470_14922# 0.47925f
C840 sg13g2_xor2_1_1.X a_14085_14495# 0.05336f
C841 sg13g2_nand3_1_1.Y a_17816_15238# 0.01049f
C842 sg13g2_dlygate4sd3_1_11.A a_19633_13799# 0.0177f
C843 sg13g2_dfrbpq_1_6.RESET_B a_18470_14922# 0.07445f
C844 sg13g2_dlygate4sd3_1_2.A a_7210_15457# 0.01669f
C845 sg13g2_xnor2_1_0.A a_8495_15311# 0.01021f
C846 sg13g2_inv_1_1.A counter_value_o[6] 0.01f
C847 a_25956_15552# sg13g2_dfrbpq_1_6.Q 0.01692f
C848 sg13g2_dlygate4sd3_1_11.A a_18468_14040# 0.0383f
C849 a_3110_15234# a_3370_15457# 0.39302f
C850 sg13g2_nand2_1_1.A sg13g2_dfrbpq_1_6.D 0.08043f
C851 VDD a_14078_14044# 0.01061f
C852 sg13g2_dfrbpq_1_1.RESET_B a_7210_15457# 0.16024f
C853 a_15329_13912# a_15610_13690# 0.15158f
C854 sg13g2_nand2_2_0.Y sg13g2_nor4_2_0.Y 0.08445f
C855 a_18987_13844# a_19727_13799# 0.15395f
C856 sg13g2_and2_1_1.B sg13g2_xnor2_1_0.Y 0.05162f
C857 a_12308_15202# sg13g2_inv_1_0.Y 0.09031f
C858 sg13g2_dfrbpq_1_2.CLK sg13g2_buf_4_0.X 1.43213f
C859 VDD a_18885_13701# 0.25762f
C860 sg13g2_dlygate4sd3_1_11.A sg13g2_nand2_2_0.Y 0.24366f
C861 a_26475_15356# sg13g2_dfrbpq_1_4.RESET_B 0.23058f
C862 sg13g2_buf_1_9.X sg13g2_mux2_1_0.A0 0.01707f
C863 sg13g2_nand2_2_0.Y a_20394_14020# 0.01084f
C864 sg13g2_buf_4_0.X a_11595_14495# 0.02387f
C865 VDD a_27594_14484# 0.24006f
C866 a_27184_14726# sg13g2_dlygate4sd3_1_12.A 0.0285f
C867 a_9272_16362# sg13g2_buf_4_0.A 0.01426f
C868 sg13g2_dlygate4sd3_1_11.A sg13g2_inv_1_0.Y 0.10767f
C869 sg13g2_mux2_1_1.A0 sg13g2_nor2b_1_1.Y 0.22857f
C870 a_18442_13945# a_18182_13722# 0.39302f
C871 sg13g2_dfrbpq_1_7.RESET_B a_18987_13844# 0.21792f
C872 sg13g2_mux2_1_1.A0 sg13g2_dfrbpq_1_6.Q 0.03072f
C873 a_27882_15532# sg13g2_dfrbpq_1_6.Q 0.01243f
C874 a_27041_13912# sg13g2_inv_1_1.A 0.02201f
C875 a_14187_14495# a_13382_14922# 0.06896f
C876 a_23983_14508# sg13g2_nor2b_1_0.Y 0.01192f
C877 a_26187_14495# sg13g2_nor2b_1_1.A 0.01395f
C878 sg13g2_dlygate4sd3_1_3.A sg13g2_or3_1_0.A 0.11404f
C879 VDD a_11470_15423# 0.14499f
C880 sg13g2_buf_4_0.X a_17014_13350# 0.07223f
C881 sg13g2_xor2_1_1.A a_15610_13690# 0.01464f
C882 a_22508_15960# sg13g2_dlygate4sd3_1_11.A 0.17137f
C883 sg13g2_dfrbpq_1_2.CLK a_12592_14726# 0.01376f
C884 a_19546_12936# sg13g2_or3_1_0.A 0.01985f
C885 sg13g2_buf_4_0.X a_10790_14922# 0.02033f
C886 a_26661_16033# VDD 0.06954f
C887 sg13g2_dlygate4sd3_1_0.A sg13g2_buf_1_9.X 0.03867f
C888 a_3396_15552# a_3684_15247# 0.22255f
C889 sg13g2_dfrbpq_1_2.CLK a_4912_15454# 0.01125f
C890 sg13g2_xnor2_1_0.A a_7116_13912# 0.08192f
C891 sg13g2_dfrbpq_1_7.RESET_B a_19727_13799# 0.07574f
C892 sg13g2_nand2_2_0.Y sg13g2_dlygate4sd3_1_3.X 0.02151f
C893 a_18104_13013# sg13g2_dlygate4sd3_1_10.X 0.01746f
C894 a_25670_15234# a_25956_15552# 0.21832f
C895 a_25930_15457# a_26373_15213# 0.02242f
C896 a_12592_14726# a_11595_14495# 0.01569f
C897 sg13g2_dlygate4sd3_1_4.X clock_i 0.05695f
C898 VDD a_19173_16033# 0.07205f
C899 VDD sg13g2_and2_1_1.B 0.19546f
C900 VDD a_8986_14448# 0.26967f
C901 sg13g2_xor2_1_1.X sg13g2_buf_1_9.X 0.0191f
C902 sg13g2_dfrbpq_1_7.CLK a_24824_15238# 0.01476f
C903 a_24880_14854# sg13g2_nor2b_1_1.Y 0.01699f
C904 sg13g2_nor3_1_0.C sg13g2_nor4_2_0.Y 0.19738f
C905 sg13g2_inv_1_0.Y sg13g2_dlygate4sd3_1_3.X 0.05822f
C906 sg13g2_buf_1_9.X a_24224_13854# 0.01381f
C907 VDD a_16089_13723# 0.02051f
C908 sg13g2_dlygate4sd3_1_11.A sg13g2_nor3_1_0.C 0.24768f
C909 sg13g2_dfrbpq_1_7.CLK a_19275_14495# 0.07983f
C910 a_11166_15486# a_10967_15315# 0.01313f
C911 sg13g2_dfrbpq_1_7.CLK sg13g2_dfrbpq_1_4.RESET_B 0.04567f
C912 a_8590_14751# a_8705_14750# 0.32411f
C913 sg13g2_nand3_1_1.Y a_18280_16082# 0.01893f
C914 a_18756_14488# a_19275_14495# 0.18362f
C915 a_19173_14495# a_19044_14909# 0.01562f
C916 sg13g2_buf_16_1.X a_18086_15238# 0.01447f
C917 a_13626_13918# sg13g2_buf_1_9.X 0.01296f
C918 sg13g2_buf_1_9.X sg13g2_inv_1_1.A 0.73268f
C919 sg13g2_inv_1_0.Y a_13966_16263# 0.01954f
C920 VDD a_15184_14726# 0.12714f
C921 sg13g2_dlygate4sd3_1_9.A a_15968_13854# 0.01846f
C922 a_7236_15552# a_7755_15356# 0.18372f
C923 a_7653_16033# VDD 0.06741f
C924 sg13g2_dfrbpq_1_5.RESET_B a_25642_14452# 0.14939f
C925 sg13g2_nor2b_1_0.A a_26062_13911# 0.09562f
C926 sg13g2_nor4_2_0.Y a_23483_14540# 0.01035f
C927 a_25175_16301# a_25374_15934# 0.01313f
C928 sg13g2_nor2b_1_0.Y a_23806_14854# 0.27305f
C929 a_16673_15260# sg13g2_a21oi_1_0.A1 0.0127f
C930 VDD a_11076_14488# 0.07344f
C931 sg13g2_mux2_1_0.A0 sg13g2_nor2b_1_0.Y 0.22492f
C932 a_25094_15238# a_25206_15302# 0.32411f
C933 sg13g2_dfrbpq_1_2.CLK a_7653_15213# 0.15363f
C934 VDD a_23806_14854# 0.10126f
C935 a_15214_13911# a_15329_13912# 0.32411f
C936 a_27472_15454# a_27882_15532# 0.05221f
C937 VDD sg13g2_or3_1_0.X 0.18524f
C938 VDD a_27208_16082# 0.15569f
C939 VDD sg13g2_mux2_1_0.A0 0.20507f
C940 a_7450_16237# VDD 0.09287f
C941 sg13g2_dlygate4sd3_1_0.A sg13g2_buf_1_0.X 0.2252f
C942 sg13g2_dlygate4sd3_1_11.A a_19275_14495# 0.01047f
C943 sg13g2_nor2b_1_0.A a_23566_13764# 0.04028f
C944 sg13g2_dfrbpq_1_7.CLK sg13g2_dfrbpq_1_5.D 0.02365f
C945 a_27500_15960# sg13g2_dfrbpq_1_6.Q 0.16163f
C946 VDD a_20272_14726# 0.12712f
C947 sg13g2_dlygate4sd3_1_9.A sg13g2_buf_1_9.X 0.02776f
C948 sg13g2_dfrbpq_1_6.RESET_B a_20272_14726# 0.0605f
C949 VDD a_26177_13912# 0.19493f
C950 a_2540_15960# VDD 0.20023f
C951 sg13g2_buf_1_9.X a_6477_14832# 0.09257f
C952 a_7048_15996# counter_value_o[1] 0.13349f
C953 VDD a_16571_15532# 0.14039f
C954 a_18789_16033# a_18970_16237# 0.02683f
C955 sg13g2_dfrbpq_1_2.CLK a_11595_14495# 0.03012f
C956 a_15184_14726# a_15594_14484# 0.05221f
C957 a_23272_15366# a_23456_15366# 0.0262f
C958 sg13g2_nand3_1_1.Y VDD 0.78903f
C959 sg13g2_inv_1_1.Y sg13g2_nor4_2_0.Y 0.07258f
C960 a_6856_16082# VDD 0.14152f
C961 sg13g2_buf_4_0.A clock_i 0.01315f
C962 sg13g2_dlygate4sd3_1_0.A VDD 0.79225f
C963 VDD a_9269_13726# 0.43747f
C964 sg13g2_dfrbpq_1_7.CLK a_26085_14495# 0.15479f
C965 sg13g2_buf_4_0.X a_19173_14495# 0.01511f
C966 a_13382_14922# a_13668_14488# 0.21832f
C967 sg13g2_xor2_1_1.A a_15214_13911# 0.11477f
C968 a_25642_14452# a_25668_14488# 0.21121f
C969 VDD a_3610_14725# 0.1202f
C970 sg13g2_dfrbpq_1_2.CLK a_8495_15311# 0.01518f
C971 sg13g2_buf_1_9.X a_18468_14040# 0.012f
C972 sg13g2_dfrbpq_1_3.RESET_B VDD 1.09692f
C973 sg13g2_dlygate4sd3_1_2.X a_2513_15288# 0.1803f
C974 sg13g2_xor2_1_1.X VDD 0.58251f
C975 VDD sg13g2_a21oi_1_0.A1 0.17652f
C976 VDD counter_value_o[0] 0.10352f
C977 sg13g2_buf_4_0.X sg13g2_nand2_2_0.A 0.14418f
C978 a_18665_16334# a_18789_16033# 0.06917f
C979 VDD a_24224_13854# 0.06421f
C980 a_14085_14495# a_14187_14495# 0.27006f
C981 VDD a_25930_15457# 0.09609f
C982 sg13g2_buf_1_9.X sg13g2_nand2_2_0.Y 3.33285f
C983 sg13g2_buf_4_0.X sg13g2_buf_16_1.X 0.58284f
C984 VDD a_38720_15366# 0.08021f
C985 sg13g2_buf_4_0.X a_22806_14484# 0.06892f
C986 a_27121_15311# sg13g2_dlygate4sd3_1_12.A 0.01098f
C987 a_10790_14922# a_11595_14495# 0.06896f
C988 sg13g2_and2_1_2.X sg13g2_buf_1_9.X 0.02701f
C989 sg13g2_nor4_2_0.Y a_24766_14854# 0.08137f
C990 VDD counter_value_o[7] 0.10023f
C991 sg13g2_buf_1_9.X sg13g2_inv_1_0.Y 0.38571f
C992 a_37484_15960# counter_value_o[7] 0.13349f
C993 VDD a_13626_13918# 0.16596f
C994 VDD sg13g2_inv_1_1.A 1.70978f
C995 sg13g2_xnor2_1_1.A a_11166_15486# 0.02872f
C996 VDD a_22202_14484# 0.12554f
C997 VDD a_24040_15366# 0.12769f
C998 sg13g2_xnor2_1_0.A a_7236_15552# 0.01004f
C999 VDD a_27215_15311# 0.17426f
C1000 sg13g2_buf_4_0.A sg13g2_xor2_1_1.B 0.02711f
C1001 VDD a_19265_13238# 0.20498f
C1002 sg13g2_buf_4_0.X clock_i 0.11036f
C1003 a_8590_14751# sg13g2_buf_1_9.X 0.01489f
C1004 a_17699_16265# sg13g2_buf_4_0.X 0.14874f
C1005 a_16681_13726# sg13g2_or3_1_0.A 0.18959f
C1006 a_4655_15311# a_4912_15454# 0.20069f
C1007 a_25956_14909# a_25668_14488# 0.22255f
C1008 sg13g2_dfrbpq_1_6.D sg13g2_buf_16_1.X 0.05424f
C1009 a_20272_14726# a_20682_14484# 0.05221f
C1010 a_16681_13726# a_16775_14020# 0.02085f
C1011 sg13g2_dfrbpq_1_7.CLK sg13g2_mux2_1_0.X 0.08039f
C1012 a_7450_16237# sg13g2_dfrbpq_1_1.RESET_B 0.04209f
C1013 sg13g2_buf_1_9.X sg13g2_nor3_1_0.C 0.02701f
C1014 a_23920_14854# sg13g2_nor2b_1_0.Y 0.01687f
C1015 a_18586_16237# VDD 0.09463f
C1016 sg13g2_nor2b_1_1.A a_25642_14452# 0.0109f
C1017 VDD a_13079_16301# 0.06502f
C1018 sg13g2_dlygate4sd3_1_9.A VDD 0.82463f
C1019 VDD a_19162_15202# 0.28226f
C1020 VDD a_13002_14484# 0.24007f
C1021 a_19162_15202# sg13g2_dfrbpq_1_6.RESET_B 0.01469f
C1022 a_18885_13701# a_18987_13844# 0.26919f
C1023 a_2540_15960# sg13g2_dlygate4sd3_1_2.A 0.16437f
C1024 a_23648_15437# sg13g2_buf_1_9.X 0.16078f
C1025 VDD a_6477_14832# 0.26423f
C1026 a_14081_16262# clock_i 0.01808f
C1027 sg13g2_mux2_1_1.X a_24824_15238# 0.01481f
C1028 VDD a_16078_14484# 1.62104f
C1029 sg13g2_nand2_1_1.A sg13g2_buf_16_1.X 0.12337f
C1030 a_24556_14020# sg13g2_nor2b_1_1.Y 0.01292f
C1031 a_32200_16082# counter_value_o[6] 0.02118f
C1032 sg13g2_dlygate4sd3_1_2.A sg13g2_dlygate4sd3_1_0.A 1.52704f
C1033 sg13g2_nand2_1_1.A a_18766_15423# 0.10344f
C1034 sg13g2_a21oi_1_0.Y a_17816_15238# 0.21695f
C1035 VDD a_13652_14020# 0.1175f
C1036 sg13g2_dfrbpq_1_4.D sg13g2_dfrbpq_1_7.CLK 0.0262f
C1037 a_14833_14845# a_13668_14488# 0.22369f
C1038 sg13g2_dfrbpq_1_3.D a_13612_15996# 0.01369f
C1039 sg13g2_and2_1_1.X a_6950_15234# 0.15045f
C1040 sg13g2_dlygate4sd3_1_0.A sg13g2_dfrbpq_1_1.RESET_B 0.0911f
C1041 sg13g2_buf_4_0.X sg13g2_xor2_1_1.B 0.43187f
C1042 sg13g2_dfrbpq_1_7.RESET_B a_18470_14922# 0.05334f
C1043 VDD a_18468_14040# 0.09241f
C1044 a_13079_16071# a_13079_16301# 0.06917f
C1045 a_26373_15213# sg13g2_dfrbpq_1_4.RESET_B 0.03697f
C1046 a_26177_13912# a_26062_13911# 0.32411f
C1047 sg13g2_nand2_2_0.Y a_19984_13942# 0.01158f
C1048 sg13g2_nor4_2_0.Y sg13g2_mux2_1_0.X 0.02869f
C1049 a_11585_15424# a_11470_15423# 0.32411f
C1050 VDD a_26927_14845# 0.17577f
C1051 VDD sg13g2_nand2_2_0.Y 0.76524f
C1052 sg13g2_a21oi_1_0.A2 a_16571_15532# 0.07921f
C1053 sg13g2_nand2_1_1.A clock_i 0.01105f
C1054 a_17699_16265# sg13g2_nand2_1_1.A 0.17689f
C1055 sg13g2_nand3_1_1.Y sg13g2_a21oi_1_0.A2 0.09171f
C1056 VDD sg13g2_and2_1_2.X 0.39242f
C1057 sg13g2_dfrbpq_1_7.RESET_B a_18885_13701# 0.02969f
C1058 a_25956_14909# a_26187_14495# 0.06628f
C1059 sg13g2_dlygate4sd3_1_9.A a_15594_14484# 0.07706f
C1060 a_27472_15454# sg13g2_dfrbpq_1_6.Q 0.04054f
C1061 a_26926_13911# sg13g2_inv_1_1.A 0.02258f
C1062 a_14081_16262# a_14362_15960# 0.15158f
C1063 sg13g2_nor2b_1_1.A sg13g2_dlygate4sd3_1_12.A 0.01164f
C1064 VDD sg13g2_inv_1_0.Y 1.11999f
C1065 VDD a_17112_12952# 0.01861f
C1066 a_13956_14909# a_13382_14922# 0.16388f
C1067 sg13g2_dfrbpq_1_2.CLK sg13g2_nand2_2_0.A 1.78195f
C1068 a_14085_14495# a_13668_14488# 0.22698f
C1069 sg13g2_dlygate4sd3_1_2.X a_3684_15247# 0.0131f
C1070 sg13g2_dlygate4sd3_1_3.X a_18182_13722# 0.01837f
C1071 sg13g2_nor2b_1_0.A sg13g2_dfrbpq_1_6.Q 0.02389f
C1072 sg13g2_xor2_1_1.A a_15329_13912# 0.02497f
C1073 sg13g2_dfrbpq_1_2.CLK sg13g2_buf_16_1.X 0.06064f
C1074 a_19150_13239# sg13g2_or3_1_0.A 0.10877f
C1075 sg13g2_dlygate4sd3_1_3.A a_17014_13350# 0.05362f
C1076 a_26458_16237# VDD 0.0928f
C1077 a_3110_15234# a_3684_15247# 0.16388f
C1078 a_3915_15356# a_4912_15454# 0.01528f
C1079 sg13g2_dfrbpq_1_2.CLK a_4655_15311# 0.01419f
C1080 sg13g2_a21oi_1_0.A2 sg13g2_a21oi_1_0.A1 0.13011f
C1081 a_11470_15423# sg13g2_xnor2_1_1.A 0.08839f
C1082 a_25930_15457# a_25956_15552# 0.21121f
C1083 a_12241_14845# a_11493_14495# 0.01058f
C1084 VDD a_22508_15960# 0.20386f
C1085 VDD sg13g2_dfrbpq_1_2.RESET_B 0.95023f
C1086 sg13g2_buf_4_0.X a_16681_13726# 0.20222f
C1087 sg13g2_mux2_1_1.X sg13g2_dfrbpq_1_5.D 0.13866f
C1088 VDD a_8590_14751# 0.14255f
C1089 sg13g2_and2_1_0.X sg13g2_and2_1_0.B 0.09191f
C1090 sg13g2_buf_1_9.X sg13g2_inv_1_1.Y 0.0177f
C1091 a_17336_13726# sg13g2_dlygate4sd3_1_3.A 0.23487f
C1092 a_19630_15238# sg13g2_dfrbpq_1_6.Q 0.09423f
C1093 a_2733_14832# a_2536_14570# 0.01798f
C1094 sg13g2_inv_1_1.A a_26062_13911# 0.01569f
C1095 sg13g2_mux2_1_1.X a_24766_14854# 0.12375f
C1096 a_22508_15960# counter_value_o[4] 0.13349f
C1097 sg13g2_xor2_1_1.A a_15008_13854# 0.01509f
C1098 sg13g2_and2_1_2.X sg13g2_and2_1_2.B 0.12088f
C1099 VDD sg13g2_nor3_1_0.C 0.61735f
C1100 sg13g2_dfrbpq_1_2.CLK clock_i 0.0649f
C1101 sg13g2_dlygate4sd3_1_9.A a_17434_15202# 0.01088f
C1102 a_18756_14488# a_19044_14909# 0.22255f
C1103 a_10408_13854# sg13g2_buf_1_9.X 0.01812f
C1104 a_27215_15311# a_25956_15552# 0.01303f
C1105 sg13g2_nand3_1_1.Y a_15958_15230# 0.06763f
C1106 VDD a_23648_15437# 0.25548f
C1107 VDD a_14187_14495# 0.20673f
C1108 sg13g2_dfrbpq_1_7.CLK sg13g2_dfrbpq_1_5.RESET_B 0.05573f
C1109 sg13g2_dlygate4sd3_1_9.A a_15610_13690# 0.23919f
C1110 a_6950_15234# a_7755_15356# 0.06896f
C1111 a_7236_15552# a_7653_15213# 0.22605f
C1112 a_10176_14523# sg13g2_xor2_1_1.B 0.02047f
C1113 sg13g2_dlygate4sd3_1_11.A sg13g2_or3_1_0.A 0.07827f
C1114 sg13g2_buf_1_9.X sg13g2_xnor2_1_0.B 0.01457f
C1115 sg13g2_inv_1_1.A a_23566_13764# 0.01045f
C1116 VDD a_9162_15532# 0.24111f
C1117 a_27594_14484# sg13g2_dfrbpq_1_6.Q 0.01501f
C1118 a_25175_16071# a_25374_15934# 0.08074f
C1119 sg13g2_dlygate4sd3_1_4.X a_13966_16263# 0.08919f
C1120 sg13g2_nor2b_1_0.Y a_23483_14540# 0.08721f
C1121 VDD a_11050_14452# 0.09702f
C1122 VDD a_18198_15302# 0.14989f
C1123 sg13g2_dfrbpq_1_2.CLK a_7236_15552# 0.05867f
C1124 VDD a_23483_14540# 0.51301f
C1125 sg13g2_xnor2_1_1.A a_11076_14488# 0.04475f
C1126 sg13g2_and2_1_1.X sg13g2_buf_1_9.X 0.04352f
C1127 a_25974_16020# sg13g2_dfrbpq_1_4.D 0.10318f
C1128 sg13g2_dlygate4sd3_1_9.A sg13g2_a21oi_1_0.A2 0.08577f
C1129 a_27215_15311# a_27882_15532# 0.06982f
C1130 VDD a_24824_15238# 0.24641f
C1131 VDD a_19275_14495# 0.20895f
C1132 sg13g2_dfrbpq_1_2.CLK sg13g2_xor2_1_1.B 0.01236f
C1133 VDD sg13g2_dfrbpq_1_4.RESET_B 1.05885f
C1134 sg13g2_dfrbpq_1_5.D a_25382_14922# 0.17038f
C1135 sg13g2_dlygate4sd3_1_3.X sg13g2_or3_1_0.A 0.02344f
C1136 a_3915_15356# sg13g2_dfrbpq_1_2.CLK 0.02025f
C1137 sg13g2_dfrbpq_1_6.RESET_B a_19275_14495# 0.21605f
C1138 a_38536_3986# a_38720_3986# 0.0262f
C1139 sg13g2_a21oi_1_1.Y sg13g2_dlygate4sd3_1_3.X 0.0739f
C1140 a_7236_15552# a_8495_15311# 0.01303f
C1141 a_15184_14726# a_14927_14845# 0.20069f
C1142 sg13g2_buf_4_0.X sg13g2_dfrbpq_1_7.CLK 0.03604f
C1143 sg13g2_buf_4_0.X a_13382_14922# 0.01025f
C1144 sg13g2_xnor2_1_0.Y sg13g2_xnor2_1_0.B 0.06675f
C1145 sg13g2_or3_1_0.X a_17606_13726# 0.01843f
C1146 a_11364_14909# a_11595_14495# 0.06628f
C1147 a_7529_16334# VDD 0.08735f
C1148 a_2684_15532# sg13g2_and2_1_0.B 0.05207f
C1149 sg13g2_dfrbpq_1_7.CLK a_25668_14488# 0.0711f
C1150 sg13g2_buf_4_0.X a_18756_14488# 0.0126f
C1151 VDD sg13g2_a21oi_1_0.Y 0.16387f
C1152 sg13g2_nor4_2_0.Y sg13g2_nor3_1_0.Y 0.146f
C1153 sg13g2_inv_1_1.Y sg13g2_nor2b_1_0.Y 0.01249f
C1154 a_13382_14922# a_13642_14452# 0.39302f
C1155 a_25382_14922# a_26085_14495# 0.02432f
C1156 sg13g2_buf_1_9.X a_18182_13722# 0.01725f
C1157 VDD sg13g2_inv_1_1.Y 0.40352f
C1158 sg13g2_nand3_1_1.Y sg13g2_dfrbpq_1_7.RESET_B 0.02335f
C1159 a_24040_13854# sg13g2_nor2b_1_0.Y 0.01028f
C1160 sg13g2_buf_1_0.X sg13g2_xnor2_1_0.B 0.14013f
C1161 a_10790_14922# sg13g2_xor2_1_1.B 0.01671f
C1162 VDD a_24040_13854# 0.12547f
C1163 a_14085_14495# a_13956_14909# 0.01562f
C1164 VDD sg13g2_o21ai_1_0.Y 0.26318f
C1165 a_10790_14922# a_11364_14909# 0.16388f
C1166 a_11076_14488# a_11493_14495# 0.22698f
C1167 sg13g2_nor4_2_0.Y a_24443_14540# 0.09388f
C1168 sg13g2_xnor2_1_0.A a_8705_14750# 0.01854f
C1169 a_23648_15437# a_24333_15280# 0.01013f
C1170 sg13g2_buf_1_9.X sg13g2_mux2_1_0.X 0.20945f
C1171 sg13g2_buf_4_0.X sg13g2_nor4_2_0.Y 0.10878f
C1172 VDD sg13g2_dfrbpq_1_5.D 0.21153f
C1173 sg13g2_buf_1_0.X sg13g2_and2_1_1.X 0.04339f
C1174 VDD a_10408_13854# 0.1585f
C1175 VDD a_32200_16082# 0.158f
C1176 sg13g2_buf_4_0.X sg13g2_dlygate4sd3_1_11.A 0.68275f
C1177 VDD sg13g2_xnor2_1_0.B 0.6074f
C1178 VDD a_24766_14854# 0.10018f
C1179 sg13g2_mux2_1_0.A0 sg13g2_dfrbpq_1_6.Q 0.026f
C1180 sg13g2_nand2_2_0.A sg13g2_buf_16_1.X 0.16379f
C1181 sg13g2_dlygate4sd3_1_0.A sg13g2_dlygate4sd3_1_2.X 0.02577f
C1182 VDD a_18944_13058# 0.08815f
C1183 VDD a_13668_14488# 0.07508f
C1184 VDD a_26085_14495# 0.24181f
C1185 a_24943_14508# a_24766_14854# 0.01057f
C1186 sg13g2_nand2_1_1.A sg13g2_dfrbpq_1_7.CLK 0.08236f
C1187 a_17816_15238# a_18086_15238# 0.15158f
C1188 sg13g2_dfrbpq_1_3.RESET_B a_14927_14845# 0.07576f
C1189 VDD a_18368_14570# 0.08349f
C1190 sg13g2_dfrbpq_1_7.CLK a_26187_14495# 0.01693f
C1191 VDD sg13g2_and2_1_1.X 0.21584f
C1192 sg13g2_xor2_1_1.A a_16089_13723# 0.06293f
C1193 a_18766_15423# sg13g2_buf_16_1.X 0.01011f
C1194 a_20272_14726# a_20015_14845# 0.20069f
C1195 sg13g2_nand2_1_1.A a_18756_14488# 0.05136f
C1196 sg13g2_dfrbpq_1_7.CLK sg13g2_nor2b_1_1.A 0.02283f
C1197 a_19049_16334# VDD 0.10176f
C1198 sg13g2_tiehi_1.L_HI a_4912_15454# 0.06198f
C1199 a_17224_15996# VDD 0.19298f
C1200 VDD a_18881_15424# 0.26104f
C1201 sg13g2_and2_1_0.B a_2733_14832# 0.1471f
C1202 a_26177_13912# a_26458_13690# 0.15158f
C1203 a_18374_12972# a_18486_12996# 0.32411f
C1204 sg13g2_nand2_2_0.A clock_i 0.18788f
C1205 VDD a_12335_14845# 0.17198f
C1206 a_18881_15424# sg13g2_dfrbpq_1_6.RESET_B 0.04659f
C1207 a_17621_12972# sg13g2_dlygate4sd3_1_3.X 0.0247f
C1208 a_18468_14040# a_18987_13844# 0.18372f
C1209 VDD a_5322_15532# 0.24424f
C1210 sg13g2_buf_16_1.X clock_i 0.05538f
C1211 sg13g2_nand2_2_0.Y a_18987_13844# 0.0116f
C1212 a_18586_16237# sg13g2_dfrbpq_1_7.RESET_B 0.03986f
C1213 a_32492_15960# counter_value_o[6] 0.13349f
C1214 sg13g2_buf_1_9.X sg13g2_or3_1_0.A 0.02769f
C1215 a_19727_13799# a_19633_13799# 0.15029f
C1216 a_26927_14845# a_26833_14845# 0.15029f
C1217 sg13g2_nand2_1_1.A sg13g2_nor4_2_0.Y 0.01853f
C1218 counter_value_o[1] clock_i 0.04117f
C1219 VDD a_13472_13854# 0.08605f
C1220 sg13g2_a21oi_1_0.Y a_17434_15202# 0.01232f
C1221 a_18468_14040# a_19727_13799# 0.01303f
C1222 a_7529_16334# sg13g2_dfrbpq_1_1.RESET_B 0.01018f
C1223 sg13g2_and2_1_1.B a_7054_14751# 0.09812f
C1224 VDD a_18182_13722# 0.48979f
C1225 a_2248_16082# counter_value_o[0] 0.02118f
C1226 a_25956_15552# sg13g2_dfrbpq_1_4.RESET_B 0.23808f
C1227 sg13g2_dfrbpq_1_6.Q sg13g2_inv_1_1.A 0.01392f
C1228 sg13g2_nor2b_1_1.A sg13g2_nor4_2_0.Y 0.03745f
C1229 sg13g2_nand2_2_0.Y a_19727_13799# 0.01366f
C1230 sg13g2_dfrbpq_1_2.CLK a_13382_14922# 0.0116f
C1231 sg13g2_buf_1_0.X a_7755_15356# 0.01365f
C1232 sg13g2_mux2_1_1.X sg13g2_dfrbpq_1_5.RESET_B 0.34031f
C1233 VDD a_27184_14726# 0.12675f
C1234 sg13g2_dfrbpq_1_3.D sg13g2_dfrbpq_1_3.RESET_B 0.29886f
C1235 sg13g2_nand2_2_0.A a_9854_15242# 0.01897f
C1236 sg13g2_o21ai_1_0.Y a_17434_15202# 0.22937f
C1237 sg13g2_buf_4_0.X a_14085_14495# 0.01369f
C1238 sg13g2_dfrbpq_1_7.RESET_B a_18468_14040# 0.22146f
C1239 a_24824_15238# sg13g2_mux2_1_1.A0 0.06374f
C1240 a_27215_15311# sg13g2_dfrbpq_1_6.Q 0.03714f
C1241 a_3689_14822# a_3976_14570# 0.01214f
C1242 VDD sg13g2_mux2_1_0.X 0.29325f
C1243 a_3610_14725# a_3813_14521# 0.01313f
C1244 a_26458_13690# sg13g2_inv_1_1.A 0.24055f
C1245 a_14081_16262# a_13966_16263# 0.32411f
C1246 sg13g2_nand2_2_0.A sg13g2_xor2_1_1.B 0.16337f
C1247 sg13g2_and2_1_2.X sg13g2_xnor2_1_1.A 0.01982f
C1248 VDD a_18486_12996# 0.1471f
C1249 a_14085_14495# a_13642_14452# 0.02242f
C1250 sg13g2_nor2b_1_0.A a_23806_14854# 0.03686f
C1251 sg13g2_a21oi_1_0.A2 sg13g2_a21oi_1_0.Y 0.01265f
C1252 sg13g2_buf_4_0.A sg13g2_buf_1_9.X 0.03604f
C1253 sg13g2_dfrbpq_1_7.RESET_B sg13g2_nand2_2_0.Y 0.02746f
C1254 sg13g2_buf_1_9.X a_24427_15280# 0.01083f
C1255 sg13g2_nor2b_1_0.A sg13g2_mux2_1_0.A0 0.04967f
C1256 sg13g2_dlygate4sd3_1_2.A sg13g2_xnor2_1_0.B 0.06731f
C1257 sg13g2_dfrbpq_1_2.CLK a_12308_15202# 0.92946f
C1258 a_18374_12972# sg13g2_or3_1_0.A 0.01664f
C1259 VDD sg13g2_dlygate4sd3_1_4.X 0.19383f
C1260 a_3915_15356# a_4655_15311# 0.15395f
C1261 VDD a_7755_15356# 0.20277f
C1262 sg13g2_buf_4_0.X a_17816_15238# 0.06226f
C1263 sg13g2_mux2_1_1.X a_25374_15934# 0.04499f
C1264 sg13g2_nand2_2_0.Y a_17606_13726# 0.01163f
C1265 a_25930_15457# a_25670_15234# 0.39302f
C1266 a_12241_14845# a_11076_14488# 0.22369f
C1267 a_27121_15311# a_26373_15213# 0.01058f
C1268 sg13g2_dlygate4sd3_1_3.X sg13g2_dlygate4sd3_1_10.X 0.05825f
C1269 VDD a_10967_15549# 0.07524f
C1270 sg13g2_mux2_1_1.X a_25206_15302# 0.05211f
C1271 sg13g2_xnor2_1_0.A sg13g2_buf_1_9.X 1.04087f
C1272 sg13g2_buf_1_9.X a_2536_14570# 0.01304f
C1273 a_19162_15202# sg13g2_dfrbpq_1_6.Q 0.22678f
C1274 sg13g2_dfrbpq_1_4.D VDD 0.3782f
C1275 sg13g2_dfrbpq_1_2.RESET_B sg13g2_xnor2_1_1.A 0.14475f
C1276 a_17504_13058# sg13g2_or3_1_0.X 0.01023f
C1277 sg13g2_a21oi_1_0.A2 sg13g2_o21ai_1_0.Y 0.02178f
C1278 sg13g2_tiehi_1.L_HI sg13g2_dfrbpq_1_2.CLK 0.01216f
C1279 sg13g2_buf_1_9.X sg13g2_nor3_1_0.Y 0.04679f
C1280 a_14362_15960# clock_i 0.01775f
C1281 sg13g2_mux2_1_1.X a_24443_14540# 0.01023f
C1282 a_10325_14854# sg13g2_and2_1_2.B 0.02071f
C1283 sg13g2_dfrbpq_1_1.RESET_B sg13g2_and2_1_1.X 0.03588f
C1284 a_23272_13854# a_23456_13854# 0.0262f
C1285 sg13g2_dlygate4sd3_1_9.A a_17153_15424# 0.02415f
C1286 a_13626_13918# sg13g2_xor2_1_1.A 0.05931f
C1287 sg13g2_dlygate4sd3_1_2.A a_5322_15532# 0.08456f
C1288 sg13g2_dlygate4sd3_1_9.A a_15329_13912# 0.01206f
C1289 a_6950_15234# a_7653_15213# 0.02454f
C1290 sg13g2_dfrbpq_1_5.RESET_B a_25382_14922# 0.07815f
C1291 sg13g2_buf_1_9.X a_24443_14540# 0.05074f
C1292 sg13g2_buf_4_0.X sg13g2_buf_1_9.X 0.23141f
C1293 VDD a_8752_15454# 0.12724f
C1294 a_26927_14845# sg13g2_dfrbpq_1_6.Q 0.01449f
C1295 VDD sg13g2_or3_1_0.A 1.05858f
C1296 a_25175_16071# a_25175_16301# 0.06917f
C1297 sg13g2_xnor2_1_0.Y a_6944_13854# 0.01011f
C1298 a_22202_14484# a_22508_14484# 0.19674f
C1299 VDD sg13g2_a21oi_1_1.Y 0.21081f
C1300 a_27322_13690# sg13g2_dlygate4sd3_1_12.A 0.23897f
C1301 sg13g2_mux2_1_1.A0 a_24766_14854# 0.07894f
C1302 VDD a_18086_15238# 0.20337f
C1303 sg13g2_xnor2_1_0.A sg13g2_xnor2_1_0.Y 0.12948f
C1304 a_7653_15213# a_8401_15311# 0.01058f
C1305 sg13g2_buf_4_0.A sg13g2_buf_1_0.X 0.23589f
C1306 sg13g2_nor2b_1_0.A sg13g2_inv_1_1.A 1.18409f
C1307 a_24040_15366# a_24224_15366# 0.0262f
C1308 sg13g2_xnor2_1_1.A a_11050_14452# 0.01078f
C1309 a_25592_16037# sg13g2_dfrbpq_1_4.D 0.01929f
C1310 a_25974_16020# a_25862_15996# 0.32411f
C1311 a_17224_15996# sg13g2_a21oi_1_0.A2 0.01223f
C1312 a_27215_15311# a_27472_15454# 0.20069f
C1313 sg13g2_nand2_1_1.A a_17816_15238# 0.0317f
C1314 a_15958_15230# sg13g2_o21ai_1_0.Y 0.05226f
C1315 a_23983_14508# a_23806_14854# 0.01057f
C1316 a_24333_15280# sg13g2_mux2_1_0.X 0.03254f
C1317 sg13g2_nor2b_1_0.A a_24040_15366# 0.01337f
C1318 sg13g2_dfrbpq_1_2.RESET_B a_11493_14495# 0.02707f
C1319 sg13g2_dfrbpq_1_7.CLK a_25094_15238# 0.01507f
C1320 sg13g2_dfrbpq_1_7.RESET_B a_18198_15302# 0.01353f
C1321 sg13g2_xnor2_1_0.A sg13g2_buf_1_0.X 0.10286f
C1322 VDD a_19044_14909# 0.01037f
C1323 sg13g2_dlygate4sd3_1_9.A sg13g2_xor2_1_1.A 0.03996f
C1324 a_3813_15213# sg13g2_dfrbpq_1_2.CLK 0.14932f
C1325 sg13g2_and2_1_0.X a_2733_14832# 0.06173f
C1326 a_14187_14495# a_14927_14845# 0.15395f
C1327 sg13g2_buf_4_0.A VDD 0.81643f
C1328 sg13g2_and2_1_2.X a_10605_13768# 0.0723f
C1329 a_24880_14854# a_24766_14854# 0.0308f
C1330 a_15329_13912# sg13g2_inv_1_0.Y 0.01146f
C1331 VDD sg13g2_dfrbpq_1_5.RESET_B 1.03189f
C1332 sg13g2_dfrbpq_1_3.D sg13g2_inv_1_0.Y 0.13311f
C1333 sg13g2_xnor2_1_0.Y a_7169_14750# 0.02831f
C1334 a_7450_14448# sg13g2_xnor2_1_0.B 0.05143f
C1335 sg13g2_dlygate4sd3_1_2.A a_7755_15356# 0.07569f
C1336 a_7048_15996# VDD 0.18066f
C1337 VDD a_6944_13854# 0.09212f
C1338 sg13g2_dfrbpq_1_2.CLK a_14085_14495# 0.14853f
C1339 sg13g2_dlygate4sd3_1_2.X a_9162_15532# 0.02706f
C1340 sg13g2_buf_4_0.X a_18730_14452# 0.01775f
C1341 VDD a_17038_15423# 0.14545f
C1342 sg13g2_xor2_1_1.A a_13652_14020# 0.01008f
C1343 sg13g2_tiehi_1.L_HI a_3689_14822# 0.01683f
C1344 a_25382_14922# a_25668_14488# 0.21832f
C1345 sg13g2_mux2_1_1.X sg13g2_nor2b_1_1.A 0.01713f
C1346 sg13g2_dfrbpq_1_7.CLK a_19173_14495# 0.19225f
C1347 sg13g2_dfrbpq_1_1.RESET_B a_7755_15356# 0.21777f
C1348 sg13g2_nor3_1_0.C sg13g2_dfrbpq_1_6.Q 0.01105f
C1349 a_8495_15311# a_8401_15311# 0.15029f
C1350 sg13g2_xnor2_1_0.A VDD 0.49764f
C1351 VDD a_2536_14570# 0.14733f
C1352 sg13g2_nor3_1_0.Y sg13g2_nor2b_1_0.Y 0.02348f
C1353 a_23788_14020# sg13g2_nor2b_1_0.Y 0.0137f
C1354 a_18756_14488# a_19173_14495# 0.22698f
C1355 a_27594_14484# sg13g2_inv_1_1.A 0.0794f
C1356 VDD sg13g2_nor3_1_0.Y 0.40034f
C1357 sg13g2_dlygate4sd3_1_0.A a_8986_14448# 0.22453f
C1358 sg13g2_xor2_1_1.A sg13g2_nand2_2_0.Y 0.1131f
C1359 a_7450_16237# a_7653_16033# 0.01313f
C1360 a_15008_13854# sg13g2_inv_1_0.Y 0.01181f
C1361 sg13g2_nand2_2_0.A a_13382_14922# 0.02176f
C1362 sg13g2_dfrbpq_1_7.CLK sg13g2_buf_16_1.X 0.04163f
C1363 VDD a_16056_15552# 0.01765f
C1364 a_11050_14452# a_11493_14495# 0.02242f
C1365 a_10176_14523# sg13g2_buf_1_9.X 0.04009f
C1366 VDD a_25374_15934# 0.09689f
C1367 sg13g2_nand2_2_0.Y a_22508_14484# 0.04039f
C1368 sg13g2_xnor2_1_0.A a_8384_14570# 0.01295f
C1369 sg13g2_buf_1_9.X sg13g2_nor2b_1_1.A 0.54171f
C1370 sg13g2_xor2_1_1.A sg13g2_inv_1_0.Y 0.12357f
C1371 VDD a_25206_15302# 0.14631f
C1372 VDD a_9152_13854# 0.08094f
C1373 VDD a_32492_15960# 0.19922f
C1374 sg13g2_buf_16_1.X a_18756_14488# 0.01329f
C1375 a_26833_14845# a_26085_14495# 0.01058f
C1376 VDD counter_value_o[3] 0.07015f
C1377 sg13g2_nor2b_1_1.A a_24334_13764# 0.04336f
C1378 sg13g2_mux2_1_0.A0 a_23806_14854# 0.0932f
C1379 a_19546_12936# sg13g2_dlygate4sd3_1_11.A 0.2349f
C1380 sg13g2_dfrbpq_1_4.D a_25956_15552# 0.0152f
C1381 VDD a_7169_14750# 0.19605f
C1382 VDD a_24443_14540# 0.4959f
C1383 sg13g2_mux2_1_1.A0 sg13g2_mux2_1_0.X 0.06438f
C1384 sg13g2_buf_4_0.X VDD 2.0889f
C1385 sg13g2_nand2_2_0.A a_12308_15202# 0.12436f
C1386 a_25592_16037# sg13g2_dfrbpq_1_5.RESET_B 0.02302f
C1387 a_18970_16237# VDD 0.11274f
C1388 VDD a_23456_15366# 0.06814f
C1389 a_10967_15549# a_10967_15315# 0.06917f
C1390 sg13g2_dfrbpq_1_2.RESET_B a_11166_15486# 0.06061f
C1391 sg13g2_buf_4_0.X sg13g2_dfrbpq_1_6.RESET_B 0.01584f
C1392 sg13g2_dfrbpq_1_7.CLK sg13g2_dlygate4sd3_1_12.A 0.01564f
C1393 a_18970_16237# sg13g2_dfrbpq_1_6.RESET_B 0.03937f
C1394 VDD a_17621_12972# 0.15566f
C1395 VDD a_25668_14488# 0.07212f
C1396 sg13g2_dfrbpq_1_1.RESET_B a_8752_15454# 0.06199f
C1397 VDD a_13642_14452# 0.09574f
C1398 a_24943_14508# a_24443_14540# 0.03308f
C1399 a_24669_14508# a_24766_14854# 0.02903f
C1400 a_12308_15202# sg13g2_buf_16_1.X 0.36135f
C1401 sg13g2_dfrbpq_1_4.RESET_B sg13g2_dfrbpq_1_6.Q 0.04196f
C1402 sg13g2_dfrbpq_1_3.RESET_B a_15184_14726# 0.0605f
C1403 sg13g2_nand2_2_0.A sg13g2_dlygate4sd3_1_11.A 0.06921f
C1404 VDD a_6760_15366# 0.16368f
C1405 a_26187_14495# a_25382_14922# 0.06896f
C1406 sg13g2_nor4_2_0.Y a_22806_14484# 0.01737f
C1407 a_18374_12972# sg13g2_dlygate4sd3_1_10.X 0.01935f
C1408 a_19275_14495# a_20015_14845# 0.15395f
C1409 sg13g2_nand2_1_1.A a_18730_14452# 0.01188f
C1410 sg13g2_dlygate4sd3_1_11.A sg13g2_buf_16_1.X 0.06088f
C1411 a_18885_13701# a_19633_13799# 0.01058f
C1412 sg13g2_buf_1_9.X sg13g2_and2_1_0.B 0.12751f
C1413 a_18665_16334# VDD 0.079f
C1414 sg13g2_nor2b_1_1.A a_25382_14922# 0.02189f
C1415 sg13g2_tiehi_1.L_HI a_4655_15311# 0.07581f
C1416 a_14081_16262# VDD 0.19685f
C1417 sg13g2_tiehi_1.L_HI sg13g2_and2_1_0.X 0.06823f
C1418 a_18374_12972# a_18104_13013# 0.15158f
C1419 a_18665_16334# sg13g2_dfrbpq_1_6.RESET_B 0.02714f
C1420 VDD a_23360_14570# 0.0797f
C1421 VDD a_12592_14726# 0.12552f
C1422 a_18182_13722# a_18987_13844# 0.06896f
C1423 a_18468_14040# a_18885_13701# 0.22605f
C1424 VDD a_4912_15454# 0.12726f
C1425 a_12308_15202# clock_i 0.01441f
C1426 sg13g2_buf_4_0.A sg13g2_dlygate4sd3_1_2.A 0.11261f
C1427 sg13g2_buf_4_0.X sg13g2_and2_1_2.B 0.05399f
C1428 VDD sg13g2_dfrbpq_1_6.D 0.18123f
C1429 sg13g2_nand2_2_0.Y a_18885_13701# 0.01124f
C1430 sg13g2_buf_4_0.X a_15594_14484# 0.01538f
C1431 sg13g2_dfrbpq_1_6.D sg13g2_dfrbpq_1_6.RESET_B 0.03132f
C1432 a_26927_14845# a_27594_14484# 0.06982f
C1433 VDD a_18756_13735# 0.01767f
C1434 a_4666_14448# a_4385_14750# 0.15158f
C1435 sg13g2_dlygate4sd3_1_11.A clock_i 0.0112f
C1436 a_14927_14845# a_13668_14488# 0.01303f
C1437 sg13g2_and2_1_1.B a_6477_14832# 0.15992f
C1438 sg13g2_dlygate4sd3_1_0.A a_6856_16082# 0.01812f
C1439 sg13g2_dlygate4sd3_1_2.A sg13g2_xnor2_1_0.A 0.05278f
C1440 a_2540_15960# counter_value_o[0] 0.13349f
C1441 sg13g2_nand2_2_0.A a_12808_16082# 0.0202f
C1442 a_23648_15437# sg13g2_nor2b_1_0.A 0.07857f
C1443 sg13g2_dfrbpq_1_5.D sg13g2_dfrbpq_1_6.Q 0.0274f
C1444 a_25670_15234# sg13g2_dfrbpq_1_4.RESET_B 0.13248f
C1445 sg13g2_a21oi_1_0.A1 a_16571_15532# 0.05494f
C1446 sg13g2_buf_1_9.X a_17336_13726# 0.01181f
C1447 a_13382_14922# sg13g2_xor2_1_1.B 0.01011f
C1448 sg13g2_nand2_1_1.A VDD 0.65278f
C1449 sg13g2_buf_4_0.X a_10419_14484# 0.01016f
C1450 sg13g2_buf_1_0.X a_7653_15213# 0.01164f
C1451 VDD a_26187_14495# 0.20412f
C1452 sg13g2_dlygate4sd3_1_2.X sg13g2_and2_1_1.X 0.03159f
C1453 sg13g2_nor2b_1_1.Y a_24766_14854# 0.28297f
C1454 sg13g2_xnor2_1_0.A a_7151_13726# 0.0107f
C1455 sg13g2_nand2_1_1.A sg13g2_dfrbpq_1_6.RESET_B 0.19088f
C1456 sg13g2_dfrbpq_1_6.Q a_24766_14854# 0.01821f
C1457 VDD sg13g2_dlygate4sd3_1_10.X 0.23257f
C1458 sg13g2_o21ai_1_0.Y a_17153_15424# 0.01592f
C1459 VDD a_10176_14523# 0.17651f
C1460 sg13g2_dfrbpq_1_7.RESET_B a_18182_13722# 0.10029f
C1461 sg13g2_buf_1_9.X a_4385_14750# 0.01799f
C1462 VDD sg13g2_nor2b_1_1.A 0.71147f
C1463 a_26177_13912# sg13g2_inv_1_1.A 0.02436f
C1464 a_14833_14845# sg13g2_buf_16_1.X 0.0102f
C1465 sg13g2_xor2_1_1.X sg13g2_dfrbpq_1_3.RESET_B 0.02447f
C1466 VDD a_18104_13013# 0.25606f
C1467 a_10325_14854# sg13g2_xnor2_1_1.A 0.01116f
C1468 sg13g2_dfrbpq_1_6.Q a_26085_14495# 0.0124f
C1469 sg13g2_nor2b_1_0.A a_23483_14540# 0.03694f
C1470 sg13g2_a21oi_1_0.A2 a_17038_15423# 0.01001f
C1471 sg13g2_dfrbpq_1_2.CLK sg13g2_buf_1_0.X 2.90219f
C1472 sg13g2_dfrbpq_1_2.CLK a_11866_15202# 0.04964f
C1473 a_27472_15454# sg13g2_dfrbpq_1_4.RESET_B 0.06225f
C1474 a_10408_13854# a_10605_13768# 0.01798f
C1475 VDD a_13278_15934# 0.09594f
C1476 sg13g2_buf_1_0.X sg13g2_and2_1_0.B 0.0229f
C1477 VDD a_7653_15213# 0.25243f
C1478 sg13g2_nand2_2_0.Y a_16089_13723# 0.13313f
C1479 a_19173_14495# a_19921_14845# 0.01058f
C1480 a_27121_15311# a_25956_15552# 0.22369f
C1481 a_26244_15247# a_26475_15356# 0.06628f
C1482 VDD a_10792_15366# 0.14249f
C1483 sg13g2_mux2_1_1.X a_25094_15238# 0.04678f
C1484 a_26458_16237# a_26661_16033# 0.01313f
C1485 sg13g2_xor2_1_1.X a_13626_13918# 0.14459f
C1486 a_23920_14854# a_23806_14854# 0.0308f
C1487 a_25862_15996# VDD 0.19627f
C1488 sg13g2_tiehi_1.L_HI a_3915_15356# 0.21596f
C1489 a_14085_14495# sg13g2_buf_16_1.X 0.01725f
C1490 sg13g2_inv_1_0.Y a_16089_13723# 0.02682f
C1491 sg13g2_buf_1_0.X a_8495_15311# 0.01439f
C1492 sg13g2_dfrbpq_1_5.D a_25670_15234# 0.01718f
C1493 sg13g2_buf_1_9.X a_23456_13854# 0.01283f
C1494 a_13966_16263# clock_i 0.01202f
C1495 sg13g2_dfrbpq_1_2.CLK VDD 1.89625f
C1496 VDD a_38720_3986# 0.0582f
C1497 a_10176_14523# sg13g2_and2_1_2.B 0.11237f
C1498 sg13g2_a21oi_1_0.A2 counter_value_o[3] 0.08003f
C1499 VDD a_21728_14570# 0.08642f
C1500 VDD a_11595_14495# 0.20369f
C1501 VDD sg13g2_and2_1_0.B 0.16206f
C1502 a_13079_16071# a_13278_15934# 0.08074f
C1503 a_18470_14922# a_19275_14495# 0.06896f
C1504 sg13g2_dfrbpq_1_7.CLK a_26475_15356# 0.06273f
C1505 sg13g2_nand3_1_1.Y sg13g2_dlygate4sd3_1_9.A 0.21034f
C1506 sg13g2_dlygate4sd3_1_2.A a_4912_15454# 0.01837f
C1507 a_12808_16082# a_12992_16082# 0.0262f
C1508 a_6950_15234# a_7236_15552# 0.21832f
C1509 sg13g2_nor2b_1_0.A a_24040_13854# 0.02931f
C1510 VDD a_8495_15311# 0.17435f
C1511 sg13g2_xnor2_1_0.Y a_7116_13912# 0.11637f
C1512 sg13g2_or3_1_0.X sg13g2_nand2_2_0.Y 0.19405f
C1513 VDD a_17014_13350# 0.01143f
C1514 sg13g2_dlygate4sd3_1_9.A sg13g2_a21oi_1_0.A1 0.01504f
C1515 a_27041_13912# sg13g2_dlygate4sd3_1_12.A 0.01189f
C1516 VDD a_10790_14922# 0.44662f
C1517 sg13g2_mux2_1_1.A0 a_24443_14540# 0.01449f
C1518 a_7236_15552# a_8401_15311# 0.22369f
C1519 a_7755_15356# a_7524_15247# 0.06628f
C1520 sg13g2_xnor2_1_0.A a_7450_14448# 0.03585f
C1521 sg13g2_nand2_1_1.A a_20682_14484# 0.011f
C1522 sg13g2_mux2_1_0.X sg13g2_dfrbpq_1_6.Q 0.01695f
C1523 sg13g2_or3_1_0.X sg13g2_inv_1_0.Y 0.01647f
C1524 a_25592_16037# a_25862_15996# 0.15158f
C1525 sg13g2_dfrbpq_1_7.CLK a_26244_15247# 0.02267f
C1526 VDD a_17336_13726# 0.25217f
C1527 sg13g2_nand2_1_1.A a_17434_15202# 0.02033f
C1528 sg13g2_buf_1_9.X reset_n_i 0.01017f
C1529 sg13g2_nand2_2_0.A sg13g2_buf_1_9.X 0.05208f
C1530 a_23983_14508# a_23483_14540# 0.03308f
C1531 sg13g2_nor2b_1_1.A a_24333_15280# 0.07522f
C1532 sg13g2_dfrbpq_1_2.RESET_B a_11076_14488# 0.23896f
C1533 sg13g2_dfrbpq_1_7.RESET_B a_18086_15238# 0.01058f
C1534 sg13g2_nor2b_1_1.A a_26926_13911# 0.08936f
C1535 sg13g2_xor2_1_1.X a_13652_14020# 0.07249f
C1536 VDD a_4385_14750# 0.20455f
C1537 a_3813_15213# a_3915_15356# 0.26919f
C1538 a_3396_15552# sg13g2_dfrbpq_1_2.CLK 0.05119f
C1539 sg13g2_nor3_1_0.Y a_22589_14020# 0.02655f
C1540 sg13g2_and2_1_0.X sg13g2_buf_1_9.X 0.0355f
C1541 a_14187_14495# a_15184_14726# 0.01569f
C1542 sg13g2_buf_4_0.X a_15958_15230# 0.08005f
C1543 a_24669_14854# a_24766_14854# 0.01625f
C1544 a_7450_14448# a_7169_14750# 0.15158f
C1545 sg13g2_dlygate4sd3_1_2.A a_7653_15213# 0.05052f
C1546 VDD a_7116_13912# 0.17405f
C1547 sg13g2_and2_1_2.B a_10790_14922# 0.01784f
C1548 sg13g2_dlygate4sd3_1_2.X a_8752_15454# 0.03181f
C1549 a_13626_13918# a_13652_14020# 0.19823f
C1550 a_25382_14922# a_25642_14452# 0.39302f
C1551 sg13g2_nand2_1_1.A sg13g2_a21oi_1_0.A2 0.05698f
C1552 sg13g2_dfrbpq_1_7.CLK a_18756_14488# 0.08536f
C1553 sg13g2_dfrbpq_1_1.RESET_B a_7653_15213# 0.02889f
C1554 sg13g2_dfrbpq_1_3.RESET_B sg13g2_inv_1_0.Y 0.09049f
C1555 sg13g2_xor2_1_1.X sg13g2_inv_1_0.Y 0.12738f
C1556 sg13g2_dfrbpq_1_3.D sg13g2_dlygate4sd3_1_4.X 0.1243f
C1557 VDD a_3689_14822# 0.09858f
C1558 sg13g2_a21oi_1_0.A1 sg13g2_inv_1_0.Y 0.03062f
C1559 a_18730_14452# a_19173_14495# 0.02242f
C1560 a_23648_15437# sg13g2_mux2_1_0.A0 0.06879f
C1561 VDD a_23456_13854# 0.06531f
C1562 sg13g2_dfrbpq_1_2.CLK sg13g2_dlygate4sd3_1_2.A 0.84756f
C1563 sg13g2_buf_1_9.X a_18442_13945# 0.01592f
C1564 counter_value_o[7] VSS 2.3276f
C1565 counter_value_o[6] VSS 1.56553f
C1566 counter_value_o[5] VSS 1.99563f
C1567 counter_value_o[4] VSS 1.90003f
C1568 counter_value_o[3] VSS 1.53751f
C1569 counter_value_o[2] VSS 1.55492f
C1570 counter_value_o[1] VSS 1.54352f
C1571 counter_value_o[0] VSS 1.9106f
C1572 VDD VSS 0.05993f
C1573 a_38720_3986# VSS 0.07631f ; **FLOATING
C1574 a_38536_3986# VSS 0.0891f ; **FLOATING
C1575 a_38720_10034# VSS 0.07628f ; **FLOATING
C1576 a_38536_10034# VSS 0.0891f ; **FLOATING
C1577 a_38720_13058# VSS 0.09073f ; **FLOATING
C1578 a_18944_13058# VSS 0.04428f ; **FLOATING
C1579 a_17621_12972# VSS 0.06076f
C1580 a_18374_12972# VSS 0.20973f
C1581 a_17715_13320# VSS 0.29433f
C1582 a_17504_13058# VSS 0.04352f ; **FLOATING
C1583 sg13g2_a21oi_1_1.Y VSS 0.05629f
C1584 a_17014_13350# VSS 0.15466f
C1585 a_26926_13911# VSS 0.06392f
C1586 a_25856_13854# VSS 0.04594f ; **FLOATING
C1587 a_24224_13854# VSS 0.03545f ; **FLOATING
C1588 a_24040_13854# VSS 0.07508f ; **FLOATING
C1589 a_23456_13854# VSS 0.03495f ; **FLOATING
C1590 a_23272_13854# VSS 0.07695f ; **FLOATING
C1591 a_24334_13764# VSS 0.0933f
C1592 a_22691_14020# VSS 0.48091f
C1593 a_22589_14020# VSS 0.48063f
C1594 a_19633_13799# VSS 0.1317f
C1595 a_18694_13735# VSS 0.71715f
C1596 a_18756_13735# VSS 0.58649f
C1597 a_19929_14037# VSS 0.08664f
C1598 a_18825_14113# VSS 0.32243f
C1599 a_18182_13722# VSS 0.30767f
C1600 sg13g2_dlygate4sd3_1_10.X VSS 0.11395f
C1601 sg13g2_dlygate4sd3_1_3.X VSS 0.11346f
C1602 a_17718_13790# VSS 0.08843f
C1603 a_16089_13723# VSS 0.2318f
C1604 sg13g2_or3_1_0.X VSS 0.15783f
C1605 a_15968_13854# VSS 0.0446f ; **FLOATING
C1606 a_15008_13854# VSS 0.04377f ; **FLOATING
C1607 a_13782_13738# VSS 0.41947f
C1608 a_14078_14044# VSS 0.75149f
C1609 a_13472_13854# VSS 0.04318f ; **FLOATING
C1610 a_10699_13768# VSS 0.10566f
C1611 a_10408_13854# VSS 0.08503f ; **FLOATING
C1612 a_9152_13854# VSS 0.05351f ; **FLOATING
C1613 a_7572_13768# VSS 0.49666f
C1614 a_7151_13726# VSS 0.21542f
C1615 a_9269_13726# VSS 0.0696f
C1616 a_6944_13854# VSS 0.04406f ; **FLOATING
C1617 a_7116_13912# VSS 0.15058f
C1618 a_38720_14570# VSS 0.08985f ; **FLOATING
C1619 a_26025_14531# VSS 0.44805f
C1620 a_26833_14845# VSS 0.19654f
C1621 a_25956_14909# VSS 0.31302f
C1622 a_25894_14909# VSS 0.10802f
C1623 a_24943_14508# VSS 0.19456f
C1624 a_24669_14508# VSS 0.04667f
C1625 a_23983_14508# VSS 0.41453f
C1626 a_23709_14508# VSS 0.10118f
C1627 a_25476_14922# VSS 0.18664f
C1628 a_25382_14922# VSS 0.58433f
C1629 a_24880_14854# VSS 0.28519f
C1630 a_24669_14854# VSS 0.47458f
C1631 a_23920_14854# VSS 0.16482f
C1632 a_23709_14854# VSS 0.26086f
C1633 a_23360_14570# VSS 0.04363f ; **FLOATING
C1634 a_22806_14484# VSS 0.12978f
C1635 a_22202_14484# VSS 0.22366f
C1636 a_24766_14854# VSS 0.0706f
C1637 a_23806_14854# VSS 0.14381f
C1638 a_21946_14854# VSS 0.79777f
C1639 a_21728_14570# VSS 0.05147f ; **FLOATING
C1640 a_20217_14607# VSS 0.78768f
C1641 sg13g2_or3_1_0.A VSS 0.07478f
C1642 a_20434_14922# VSS 0.3172f
C1643 a_19921_14845# VSS 0.22913f
C1644 a_19044_14909# VSS 0.51701f
C1645 a_18982_14909# VSS 0.80403f
C1646 a_18368_14570# VSS 0.04003f ; **FLOATING
C1647 a_15129_14607# VSS 0.06598f
C1648 a_18564_14922# VSS 0.17989f
C1649 a_18470_14922# VSS 0.3016f
C1650 a_14025_14531# VSS 0.66935f
C1651 a_15346_14922# VSS 0.16634f
C1652 a_14833_14845# VSS 0.13067f
C1653 a_13956_14909# VSS 0.2329f
C1654 a_13894_14909# VSS 0.09984f
C1655 a_12537_14607# VSS 0.05507f
C1656 a_13476_14922# VSS 0.25517f
C1657 a_13382_14922# VSS 0.69296f
C1658 a_11433_14531# VSS 0.67596f
C1659 a_12754_14922# VSS 0.11343f
C1660 a_12241_14845# VSS 0.19638f
C1661 a_12592_14726# VSS 0.01398f
C1662 a_11364_14909# VSS 0.27985f
C1663 a_11302_14909# VSS 0.14543f
C1664 a_10419_14484# VSS 0.03757f
C1665 a_10884_14922# VSS 0.05675f
C1666 a_10790_14922# VSS 0.29926f
C1667 a_10325_14854# VSS 0.21116f
C1668 a_10139_14832# VSS 0.24861f
C1669 a_8705_14750# VSS 0.1289f
C1670 a_8384_14570# VSS 0.039f ; **FLOATING
C1671 a_8200_14570# VSS 0.07759f ; **FLOATING
C1672 a_7169_14750# VSS 0.20605f
C1673 a_6571_14832# VSS 0.1685f
C1674 a_6368_14570# VSS 0.0541f ; **FLOATING
C1675 a_4385_14750# VSS 0.15781f
C1676 a_3976_14570# VSS 0.07907f ; **FLOATING
C1677 a_2827_14832# VSS 4.84845f
C1678 a_2536_14570# VSS 0.09439f ; **FLOATING
C1679 a_38720_15366# VSS 0.08189f ; **FLOATING
C1680 a_27634_15234# VSS 0.01795f
C1681 a_27121_15311# VSS 0.1496f
C1682 a_26182_15247# VSS 0.12462f
C1683 a_26244_15247# VSS 0.16133f
C1684 a_27417_15549# VSS 0.07296f
C1685 a_25764_15234# VSS 0.38333f
C1686 a_24427_15280# VSS 0.04369f
C1687 a_26313_15625# VSS 0.44789f
C1688 a_25670_15234# VSS 0.53712f
C1689 a_25094_15238# VSS 0.157f
C1690 sg13g2_mux2_1_0.X VSS 0.0817f
C1691 a_24224_15366# VSS 0.03748f ; **FLOATING
C1692 a_24040_15366# VSS 0.07876f ; **FLOATING
C1693 a_23785_15280# VSS 0.14725f
C1694 a_23456_15366# VSS 0.0395f ; **FLOATING
C1695 a_23272_15366# VSS 0.09158f ; **FLOATING
C1696 sg13g2_nor2b_1_1.A VSS 0.03913f
C1697 a_16673_15260# VSS 0.17831f
C1698 a_15958_15230# VSS 0.12601f
C1699 a_18198_15302# VSS 0.09186f
C1700 a_15602_15242# VSS 0.01203f
C1701 a_17816_15238# VSS 0.26128f
C1702 a_16571_15532# VSS 1.0488f
C1703 sg13g2_a21oi_1_0.A1 VSS 0.0642f
C1704 a_16056_15552# VSS 0.11791f
C1705 a_15304_15366# VSS 0.09601f ; **FLOATING
C1706 a_11470_15423# VSS 0.01107f
C1707 a_10792_15366# VSS 0.09272f ; **FLOATING
C1708 a_9854_15242# VSS 0.62356f
C1709 a_9650_15242# VSS 0.01189f
C1710 a_11166_15486# VSS 0.05449f
C1711 a_8401_15311# VSS 0.32199f
C1712 a_7462_15247# VSS 0.14075f
C1713 a_7524_15247# VSS 0.16276f
C1714 a_7593_15625# VSS 0.44826f
C1715 a_6950_15234# VSS 0.56152f
C1716 a_6760_15366# VSS 0.08567f ; **FLOATING
C1717 a_5074_15234# VSS 0.3273f
C1718 a_4561_15311# VSS 0.1492f
C1719 a_3622_15247# VSS 0.74576f
C1720 a_3684_15247# VSS 0.78247f
C1721 a_3753_15625# VSS 0.02097f
C1722 a_3110_15234# VSS 0.32825f
C1723 sg13g2_and2_1_0.X VSS 2.06203f
C1724 sg13g2_tiehi_1.L_HI VSS 0.07498f
C1725 a_2684_15532# VSS 1.63582f
C1726 a_2240_15366# VSS 0.04519f ; **FLOATING
C1727 a_37192_16082# VSS 0.08963f ; **FLOATING
C1728 a_32200_16082# VSS 0.08977f ; **FLOATING
C1729 a_32492_15960# VSS 0.04613f
C1730 a_27208_16082# VSS 0.08904f ; **FLOATING
C1731 a_26458_16237# VSS 0.08962f
C1732 a_25862_15996# VSS 0.18017f
C1733 a_18970_16237# VSS 0.08921f
C1734 a_18464_16082# VSS 0.03894f ; **FLOATING
C1735 a_18280_16082# VSS 0.08005f ; **FLOATING
C1736 a_17997_16020# VSS 0.05166f
C1737 a_17908_16020# VSS 0.05166f
C1738 a_18586_16237# VSS 0.05365f
C1739 a_18665_16334# VSS 0.05f
C1740 sg13g2_nand2_1_1.A VSS 0.03177f
C1741 a_17120_16082# VSS 0.04515f ; **FLOATING
C1742 a_13612_15996# VSS 0.18361f
C1743 sg13g2_dlygate4sd3_1_9.A VSS 0.08873f
C1744 a_14362_15960# VSS 0.22355f
C1745 a_12992_16082# VSS 0.03371f ; **FLOATING
C1746 a_12808_16082# VSS 0.07893f ; **FLOATING
C1747 a_13079_16071# VSS 0.05093f
C1748 a_12232_16082# VSS 0.09968f ; **FLOATING
C1749 a_9170_16362# VSS 0.07156f
C1750 a_8872_16082# VSS 0.08711f ; **FLOATING
C1751 sg13g2_xnor2_1_0.A VSS 0.04051f
C1752 a_7450_16237# VSS 0.08946f
C1753 a_6856_16082# VSS 0.10012f ; **FLOATING
C1754 sg13g2_dlygate4sd3_1_0.A VSS 0.02459f
C1755 a_2248_16082# VSS 0.08925f ; **FLOATING
C1756 sg13g2_buf_1_9.X.n0 VSS 0.63855f
C1757 sg13g2_buf_1_9.X.n1 VSS 0.4124f
C1758 sg13g2_buf_1_9.X.n2 VSS 3.00802f
C1759 sg13g2_buf_1_9.X.n3 VSS 2.44209f
C1760 sg13g2_buf_1_9.X.n4 VSS 1.94592f
C1761 sg13g2_buf_1_9.X.n5 VSS 2.37871f
C1762 sg13g2_buf_1_9.X.n6 VSS 2.41423f
C1763 sg13g2_buf_1_9.X.t0 VSS 0.32881f
C1764 VSS.t7 VSS 5.58967f
C1765 VSS.t74 VSS 0.46053f
C1766 VSS.t331 VSS 0.07161f
C1767 VSS.t662 VSS 0.0348f
C1768 VSS.t3050 VSS 0.06112f
C1769 VSS.t3060 VSS 0.09619f
C1770 VSS.t3070 VSS 0.21378f
C1771 VSS.t3080 VSS 0.07181f
C1772 VSS.t3105 VSS 0.06058f
C1773 VSS.t3115 VSS 0.14365f
C1774 VSS.t3125 VSS 0.40899f
C1775 VSS.t3165 VSS 0.01465f
C1776 VSS.t2741 VSS 0.02306f
C1777 VSS.t2749 VSS 0.02339f
C1778 VSS.t2748 VSS 0.02339f
C1779 VSS.t2754 VSS 0.0224f
C1780 VSS.t2756 VSS 0.01393f
C1781 VSS.t2755 VSS 0.01393f
C1782 VSS.t2764 VSS 0.04658f
C1783 VSS.t2776 VSS 0.03882f
C1784 VSS.t2791 VSS 0.11177f
C1785 VSS.t2788 VSS 0.1402f
C1786 VSS.t2926 VSS 0.11858f
C1787 VSS.t2799 VSS 0.06927f
C1788 VSS.t2804 VSS 0.01107f
C1789 VSS.t2824 VSS 0.04134f
C1790 VSS.t2955 VSS 0.04134f
C1791 VSS.t2833 VSS 0.03029f
C1792 VSS.t2974 VSS 0.02405f
C1793 VSS.t2844 VSS 0.02405f
C1794 VSS.t2460 VSS 0.01554f
C1795 VSS.t2440 VSS 0.01941f
C1796 VSS.t2427 VSS 0.03697f
C1797 VSS.t2425 VSS 0.32393f
C1798 VSS.t2420 VSS 0.37302f
C1799 VSS.t2405 VSS 0.01824f
C1800 VSS.t2395 VSS 1.30179f
C1801 VSS.t2389 VSS 0.15604f
C1802 VSS.t2390 VSS 0.15604f
C1803 VSS.t2369 VSS 0.04293f
C1804 VSS.t2370 VSS 0.04293f
C1805 VSS.t2357 VSS 0.04429f
C1806 VSS.t2355 VSS 0.04429f
C1807 VSS.t1953 VSS 0.55971f
C1808 VSS.t1958 VSS 0.09449f
C1809 VSS.t1960 VSS 0.09449f
C1810 VSS.t1977 VSS 0.03566f
C1811 VSS.t1978 VSS 0.03566f
C1812 VSS.t1988 VSS 0.08381f
C1813 VSS.t1990 VSS 0.08381f
C1814 VSS.t2013 VSS 0.06865f
C1815 VSS.t2012 VSS 0.06865f
C1816 VSS.t2023 VSS 0.03008f
C1817 VSS.t2022 VSS 0.02765f
C1818 VSS.t2027 VSS 0.15818f
C1819 VSS.t2028 VSS 0.15818f
C1820 VSS.t2038 VSS 0.04663f
C1821 VSS.t2043 VSS 0.28636f
C1822 VSS.t2040 VSS 0.04663f
C1823 VSS.t2042 VSS 0.18273f
C1824 VSS.t2067 VSS 0.06806f
C1825 VSS.t2068 VSS 0.24287f
C1826 VSS.t2073 VSS 0.10295f
C1827 VSS.t2088 VSS 0.20824f
C1828 VSS.t2090 VSS 0.09192f
C1829 VSS.t2103 VSS 0.1138f
C1830 VSS.t2102 VSS 0.1138f
C1831 VSS.t2108 VSS 0.04593f
C1832 VSS.t2113 VSS 0.0422f
C1833 VSS.t2118 VSS 0.49345f
C1834 VSS.t2123 VSS 0.0642f
C1835 VSS.t2128 VSS 1.17463f
C1836 VSS.t2130 VSS 1.03102f
C1837 VSS.t2148 VSS 0.09468f
C1838 VSS.t2153 VSS 0.10255f
C1839 VSS.t2150 VSS 0.09468f
C1840 VSS.t2163 VSS 0.05993f
C1841 VSS.t2168 VSS 0.16763f
C1842 VSS.t2173 VSS 0.01308f
C1843 VSS.t2178 VSS 0.01865f
C1844 VSS.t2188 VSS 0.097f
C1845 VSS.t2190 VSS 0.097f
C1846 VSS.t1786 VSS 0.05531f
C1847 VSS.t1781 VSS 0.29291f
C1848 VSS.t1776 VSS 0.27681f
C1849 VSS.t1771 VSS 0.0642f
C1850 VSS.t1766 VSS 0.26887f
C1851 VSS.t1761 VSS 0.37873f
C1852 VSS.t1756 VSS 0.22395f
C1853 VSS.t1736 VSS 0.15993f
C1854 VSS.t1726 VSS 0.13854f
C1855 VSS.t1721 VSS 0.04033f
C1856 VSS.t1716 VSS 1.54892f
C1857 VSS.t1711 VSS 0.26404f
C1858 VSS.t1706 VSS 0.11206f
C1859 VSS.t1693 VSS 0.09779f
C1860 VSS.t1695 VSS 0.26801f
C1861 VSS.t1696 VSS 0.26801f
C1862 VSS.t1691 VSS 0.55371f
C1863 VSS.t1676 VSS 0.36546f
C1864 VSS.t1322 VSS 0.12137f
C1865 VSS.t1324 VSS 0.05895f
C1866 VSS.t1342 VSS 0.03731f
C1867 VSS.t1351 VSS 0.01393f
C1868 VSS.t1350 VSS 0.10194f
C1869 VSS.t1349 VSS 0.10194f
C1870 VSS.t1374 VSS 0.03177f
C1871 VSS.t1373 VSS 0.03177f
C1872 VSS.t1375 VSS 0.06392f
C1873 VSS.t1512 VSS 0.06392f
C1874 VSS.t1383 VSS 0.0392f
C1875 VSS.t1382 VSS 0.0392f
C1876 VSS.t1521 VSS 0.11944f
C1877 VSS.t1522 VSS 0.13594f
C1878 VSS.t1529 VSS 0.03299f
C1879 VSS.t1400 VSS 0.01377f
C1880 VSS.t1401 VSS 0.01377f
C1881 VSS.t1536 VSS 0.02617f
C1882 VSS.t1541 VSS 0.05176f
C1883 VSS.t1546 VSS 0.09066f
C1884 VSS.t1571 VSS 0.014f
C1885 VSS.t1576 VSS 0.10174f
C1886 VSS.t1581 VSS 0.01418f
C1887 VSS.t1591 VSS 0.10895f
C1888 VSS.t1606 VSS 0.2763f
C1889 VSS.t1616 VSS 0.07008f
C1890 VSS.t1615 VSS 0.07008f
C1891 VSS.t1621 VSS 0.07608f
C1892 VSS.t1630 VSS 0.02017f
C1893 VSS.t1631 VSS 0.02017f
C1894 VSS.t1641 VSS 0.07038f
C1895 VSS.t1643 VSS 0.07038f
C1896 VSS.t1651 VSS 0.03478f
C1897 VSS.t1661 VSS 0.2873f
C1898 VSS.t1928 VSS 0.2276f
C1899 VSS.t1943 VSS 0.0211f
C1900 VSS.t1948 VSS 0.1284f
C1901 VSS.t1945 VSS 0.0211f
C1902 VSS.t1403 VSS 0.05447f
C1903 VSS.t1243 VSS 0.05447f
C1904 VSS.t1250 VSS 0.04533f
C1905 VSS.t1410 VSS 0.04533f
C1906 VSS.t1251 VSS 0.05042f
C1907 VSS.t1253 VSS 0.27822f
C1908 VSS.t1254 VSS 0.27822f
C1909 VSS.t1258 VSS 0.05673f
C1910 VSS.t1260 VSS 1.02279f
C1911 VSS.t1431 VSS 0.04334f
C1912 VSS.t1440 VSS 0.16086f
C1913 VSS.t1288 VSS 0.16086f
C1914 VSS.t1293 VSS 0.0696f
C1915 VSS.t1298 VSS 0.02796f
C1916 VSS.t1450 VSS 0.04479f
C1917 VSS.t1309 VSS 0.04972f
C1918 VSS.t1313 VSS 0.01783f
C1919 VSS.t1314 VSS 0.01783f
C1920 VSS.t1320 VSS 0.01466f
C1921 VSS.t1311 VSS 1.45436f
C1922 VSS.t868 VSS 0.38754f
C1923 VSS.t869 VSS 0.38754f
C1924 VSS.t864 VSS 0.28135p
C1925 VSS.t854 VSS 0.02753f
C1926 VSS.t849 VSS 0.14017f
C1927 VSS.t884 VSS 0.27707f
C1928 VSS.t894 VSS 0.04207f
C1929 VSS.t904 VSS 0.03591f
C1930 VSS.t909 VSS 0.14056p
C1931 VSS.t914 VSS 0.25097f
C1932 VSS.t918 VSS 0.3446f
C1933 VSS.t919 VSS 0.3446f
C1934 VSS.t934 VSS 0.03648f
C1935 VSS.t939 VSS 0.07768f
C1936 VSS.t944 VSS 0.02574f
C1937 VSS.t941 VSS 0.06716f
C1938 VSS.t943 VSS 0.02574f
C1939 VSS.t954 VSS 0.06646f
C1940 VSS.t959 VSS 0.02977f
C1941 VSS.t964 VSS 0.03589f
C1942 VSS.t961 VSS 0.02977f
C1943 VSS.t963 VSS 0.03589f
C1944 VSS.t974 VSS 0.46609f
C1945 VSS.t984 VSS 0.03596f
C1946 VSS.t994 VSS 0.03463f
C1947 VSS.t993 VSS 0.03463f
C1948 VSS.t999 VSS 0.08885f
C1949 VSS.t1004 VSS 0.0348f
C1950 VSS.t1009 VSS 0.09147f
C1951 VSS.t1014 VSS 0.10744f
C1952 VSS.t1011 VSS 0.01308f
C1953 VSS.t1024 VSS 0.70859f
C1954 VSS.t1029 VSS 0.15273f
C1955 VSS.t1031 VSS 0.15273f
C1956 VSS.t1039 VSS 0.0311f
C1957 VSS.t1044 VSS 0.19224f
C1958 VSS.t1043 VSS 0.04051f
C1959 VSS.t1054 VSS 0.04331f
C1960 VSS.t1079 VSS 0.25672f
C1961 VSS.t1084 VSS 0.22181f
C1962 VSS.t1081 VSS 0.18489f
C1963 VSS.t1094 VSS 0.06264f
C1964 VSS.t1093 VSS 0.06264f
C1965 VSS.t1109 VSS 0.11363f
C1966 VSS.t1119 VSS 0.27165f
C1967 VSS.t1124 VSS 0.2179f
C1968 VSS.t811 VSS 0.04678f
C1969 VSS.t693 VSS 0.10713f
C1970 VSS.t807 VSS 0.08473f
C1971 VSS.t54 VSS 0.16935f
C1972 VSS.t146 VSS 0.03591f
C1973 VSS.t686 VSS 0.0224f
C1974 VSS.t126 VSS 0.15357f
C1975 VSS.t24 VSS 0.55722f
C1976 VSS.t66 VSS 1.99148f
C1977 VSS.t22 VSS 0.27229f
C1978 VSS.t35 VSS 0.1449f
C1979 VSS.t109 VSS 0.16712f
C1980 VSS.t68 VSS 0.10385f
C1981 VSS.t89 VSS 1.38428f
C1982 VSS.t100 VSS 0.73074f
C1983 VSS.t137 VSS 0.34378f
C1984 VSS.t98 VSS 0.29087f
C1985 VSS.t30 VSS 0.20605f
C1986 VSS.t10 VSS 0.16845f
C1987 VSS.t49 VSS 0.52718f
C1988 VSS.t399 VSS 0.01794f
C1989 VSS.t402 VSS 0.56217p
C1990 VSS.t413 VSS 0.02436f
C1991 VSS.t326 VSS 0.09066f
C1992 VSS.t427 VSS 0.03627f
C1993 VSS.t364 VSS 1.73178f
C1994 VSS.t77 VSS 0.51065f
C1995 VSS.t498 VSS 0.06112f
C1996 VSS.t210 VSS 0.76288f
C1997 VSS.t454 VSS 0.10182f
C1998 VSS.t436 VSS 0.04712f
C1999 VSS.t437 VSS 0.04712f
C2000 VSS.t389 VSS 0.62127f
C2001 VSS.t384 VSS 0.01798f
C2002 VSS.t385 VSS 0.01798f
C2003 VSS.t380 VSS 0.55414f
C2004 VSS.t622 VSS 0.01308f
C2005 VSS.t636 VSS 0.04314f
C2006 VSS.t637 VSS 0.04314f
C2007 VSS.t647 VSS 0.02546f
C2008 VSS.t652 VSS 0.22938f
C2009 VSS.t649 VSS 0.02546f
C2010 VSS.t657 VSS 0.1568f
C2011 VSS.t14 VSS 0.0696f
C2012 VSS.t760 VSS 0.11791f
C2013 VSS.t763 VSS 0.11669f
C2014 VSS.t766 VSS 0.14731f
C2015 VSS.t28 VSS 0.19673f
C2016 VSS.t673 VSS 0.16644f
C2017 VSS.t285 VSS 0.16882f
C2018 VSS.t56 VSS 0.2102f
C2019 VSS.t781 VSS 0.13983f
C2020 VSS.t20 VSS 0.04221f
C2021 VSS.t243 VSS 1.20948f
C2022 VSS.t334 VSS 0.22439f
C2023 VSS.t654 VSS 0.09017f
C2024 VSS.t148 VSS 0.0282f
C2025 VSS.t58 VSS 0.27022f
C2026 VSS.t12 VSS 0.0817f
C2027 VSS.t25 VSS 0.50129f
C2028 VSS.t104 VSS 0.28703f
C2029 VSS.t4 VSS 0.14338f
C2030 VSS.t131 VSS 0.39697f
C2031 VSS.t81 VSS 0.53893f
C2032 VSS.t79 VSS 0.24501f
C2033 VSS.t1056 VSS 0.02228f
C2034 VSS.t1046 VSS 0.02724f
C2035 VSS.t1026 VSS 0.53602f
C2036 VSS.t1006 VSS 0.0348f
C2037 VSS.t906 VSS 0.03591f
C2038 VSS.t1791 VSS 0.06384f
C2039 VSS.t1801 VSS 0.03591f
C2040 VSS.t1806 VSS 0.16882f
C2041 VSS.t1803 VSS 0.03591f
C2042 VSS.t2125 VSS 0.0642f
C2043 VSS.t2045 VSS 0.10363f
C2044 VSS.t1955 VSS 0.55971f
C2045 VSS.t2344 VSS 0.05589f
C2046 VSS.t2345 VSS 0.05589f
C2047 VSS.t2339 VSS 0.01622f
C2048 VSS.t2340 VSS 0.01622f
C2049 VSS.t2320 VSS 0.07183f
C2050 VSS.t2480 VSS 0.18651f
C2051 VSS.t2485 VSS 0.14348f
C2052 VSS.t2490 VSS 0.0696f
C2053 VSS.t2500 VSS 0.06118f
C2054 VSS.t2505 VSS 0.53602f
C2055 VSS.t2510 VSS 0.04697f
C2056 VSS.t2515 VSS 0.87461f
C2057 VSS.t2514 VSS 0.87461f
C2058 VSS.t2525 VSS 0.46851f
C2059 VSS.t2535 VSS 0.08843f
C2060 VSS.t2534 VSS 0.08843f
C2061 VSS.t2540 VSS 0.09325f
C2062 VSS.t2545 VSS 0.06354f
C2063 VSS.t2549 VSS 0.04436f
C2064 VSS.t2550 VSS 0.27741f
C2065 VSS.t2552 VSS 0.23304f
C2066 VSS.t2565 VSS 70.46817f
C2067 VSS.t2564 VSS 0.13444f
C2068 VSS.t2575 VSS 0.12046f
C2069 VSS.t2574 VSS 0.12046f
C2070 VSS.t2585 VSS 0.34562f
C2071 VSS.t2567 VSS 70.28207f
C2072 VSS.t2527 VSS 0.46851f
C2073 VSS.t2787 VSS 0.1402f
C2074 VSS.t2740 VSS 0.02306f
C2075 VSS.t2854 VSS 0.03749f
C2076 VSS.t2855 VSS 0.03749f
C2077 VSS.t3127 VSS 0.40899f
C2078 VSS.t3072 VSS 0.21378f
.ends

* PEX produced on Mon Aug 24 02:44:27 PM CEST 2026 using /foss/tools/sak/sak-pex.sh with m=3 and s=1 (extresist threshold=10000 mOhm, minres=1000 mOhm, mindelay=1 ps)
* NGSPICE file created from counter_top_pex.ext - technology: ihp-sg13g2

.subckt counter_top_pex VDD VSS clock_i reset_n_i enable_i counter_value_o[0]
+ counter_value_o[1] counter_value_o[2] counter_value_o[3] counter_value_o[4]
+ counter_value_o[5] counter_value_o[6] counter_value_o[7]
X0 VSS.t355 VDD VSS.t355 VSS.t463 sg13_lv_nmos ad=0.1428p pd=1.52u as=0 ps=0 w=0.42u l=1u
X1 sg13g2_o21ai_1_2.Y sg13g2_o21ai_1_2.B1 a_23638_14862# VSS.t25 sg13_lv_nmos ad=0.2516p pd=2.16u as=0.1406p ps=1.12u w=0.74u l=0.15u
X2 VDD VSS.t1696 VDD VDD sg13_lv_pmos ad=0.19p pd=1.38u as=3.18405n ps=0.01242 w=1u l=1u
X3 VSS.t707 VDD VSS.t712 VSS.t711 sg13_lv_nmos ad=79.8f pd=0.8u as=0 ps=0 w=0.42u l=1u
X4 VDD VSS.t245 VDD VDD sg13_lv_pmos ad=0.34p pd=2.68u as=0 ps=0 w=1u l=1u
X5 a_18874_13690# sg13g2_dfrbpq_1_2.Q VDD VDD sg13_lv_pmos ad=0.1428p pd=1.52u as=0.1523p ps=1.38u w=0.42u l=0.13u
X6 VSS.t1301 VDD VSS.t1302 VSS.t311 sg13_lv_nmos ad=79.8f pd=0.8u as=0 ps=0 w=0.42u l=1u
X7 VSS.t2363 VDD VSS.t2362 VSS.t2361 sg13_lv_nmos ad=0.1428p pd=1.52u as=0 ps=0 w=0.42u l=1u
X8 VSS.t1976 VDD VSS.t1978 VSS.t1977 sg13_lv_nmos ad=79.8f pd=0.8u as=0 ps=0 w=0.42u l=1u
X9 VDD VSS.t1428 VDD VDD sg13_lv_pmos ad=0.34p pd=2.68u as=0 ps=0 w=1u l=1u
X10 VSS.t768 VDD VSS.t766 VSS.t767 sg13_lv_nmos ad=0.1428p pd=1.52u as=0 ps=0 w=0.42u l=1u
X11 VDD VSS.t1301 VDD VDD sg13_lv_pmos ad=0.19p pd=1.38u as=0 ps=0 w=1u l=1u
X12 VSS.t2438 VDD VSS.t2437 VSS.t2436 sg13_lv_nmos ad=0.1428p pd=1.52u as=0 ps=0 w=0.42u l=1u
X13 VSS.t1724 VDD VSS.t1723 VSS.t1722 sg13_lv_nmos ad=0.1428p pd=1.52u as=0 ps=0 w=0.42u l=1u
X14 VSS.t3248 VDD VSS.t3247 VSS.t3246 sg13_lv_nmos ad=0.1428p pd=1.52u as=0 ps=0 w=0.42u l=1u
X15 VDD VSS.t2397 VDD VDD sg13_lv_pmos ad=0.34p pd=2.68u as=0 ps=0 w=1u l=1u
X16 a_1965_14832# sg13g2_buf_1_10.X VDD VDD sg13_lv_pmos ad=0.1596p pd=1.22u as=0.2856p ps=2.36u w=0.84u l=0.13u
X17 VSS.t1018 VDD VSS.t1017 VSS.t1016 sg13_lv_nmos ad=0.1428p pd=1.52u as=0 ps=0 w=0.42u l=1u
X18 VSS.t2803 VDD VSS.t2805 VSS.t392 sg13_lv_nmos ad=79.8f pd=0.8u as=0 ps=0 w=0.42u l=1u
X19 a_25094_15238# a_24824_15238# VSS.t46 VSS.t24 sg13_lv_nmos ad=0.1428p pd=1.52u as=79.8f ps=0.8u w=0.42u l=0.5u
X20 VSS.t1063 VDD VSS.t1062 VSS.t1061 sg13_lv_nmos ad=0.1428p pd=1.52u as=0 ps=0 w=0.42u l=1u
X21 VSS.t938 VDD VSS.t940 VSS.t939 sg13_lv_nmos ad=79.8f pd=0.8u as=0 ps=0 w=0.42u l=1u
X22 VSS.t1372 VDD VSS.t1373 VSS.t311 sg13_lv_nmos ad=79.8f pd=0.8u as=0 ps=0 w=0.42u l=1u
X23 VSS.t2873 VDD VSS.t2873 VSS.t392 sg13_lv_nmos ad=79.8f pd=0.8u as=0 ps=0 w=0.42u l=1u
X24 VSS.t2006 VDD VSS.t2005 VSS.t2004 sg13_lv_nmos ad=0.1428p pd=1.52u as=0 ps=0 w=0.42u l=1u
X25 VDD VSS.t1846 VDD VDD sg13_lv_pmos ad=0.19p pd=1.38u as=0 ps=0 w=1u l=1u
X26 VDD VSS.t3135 VDD VDD sg13_lv_pmos ad=0.19p pd=1.38u as=0 ps=0 w=1u l=1u
X27 VDD VSS.t2003 VDD VDD sg13_lv_pmos ad=0.19p pd=1.38u as=0 ps=0 w=1u l=1u
X28 VDD sg13g2_dfrbpq_1_2.RESET_B a_15782_13722# VDD sg13_lv_pmos ad=0.36237p pd=2.605u as=79.8f ps=0.8u w=0.42u l=0.13u
X29 VSS.t1719 VDD VSS.t1718 VSS.t1717 sg13_lv_nmos ad=0.1428p pd=1.52u as=0 ps=0 w=0.42u l=1u
X30 VSS.t172 sg13g2_or3_1_1.A a_24841_13726# VSS.t203 sg13_lv_nmos ad=0.13395p pd=1.12u as=0.198p ps=1.27u w=0.55u l=0.13u
X31 VSS.t2849 VDD VSS.t2848 VSS.t392 sg13_lv_nmos ad=0.1428p pd=1.52u as=0 ps=0 w=0.42u l=1u
X32 VSS.t2246 VDD VSS.t2245 VSS.t2244 sg13_lv_nmos ad=0.1428p pd=1.52u as=0 ps=0 w=0.42u l=1u
X33 VDD VSS.t1371 VDD VDD sg13_lv_pmos ad=0.34p pd=2.68u as=0 ps=0 w=1u l=1u
X34 VDD VSS.t2873 VDD VDD sg13_lv_pmos ad=0.34p pd=2.68u as=0 ps=0 w=1u l=1u
X35 VDD sg13g2_a21oi_1_3.A2 a_25109_12972# VDD sg13_lv_pmos ad=0.2128p pd=1.5u as=0.3808p ps=2.92u w=1.12u l=0.13u
X36 VSS.t1123 VDD VSS.t1125 VSS.t1124 sg13_lv_nmos ad=79.8f pd=0.8u as=0 ps=0 w=0.42u l=1u
X37 VDD VSS.t2535 VDD VDD sg13_lv_pmos ad=0.19p pd=1.38u as=0 ps=0 w=1u l=1u
X38 VDD VSS.t2193 VDD VDD sg13_lv_pmos ad=0.19p pd=1.38u as=0 ps=0 w=1u l=1u
X39 VDD VSS.t2370 VDD VDD sg13_lv_pmos ad=0.19p pd=1.38u as=0 ps=0 w=1u l=1u
X40 a_18021_14495# sg13g2_buf_16_2.X VDD VDD sg13_lv_pmos ad=0.4088p pd=2.97u as=2.3367p ps=15.135u w=1.12u l=0.13u
X41 VDD VSS.t990 VDD VDD sg13_lv_pmos ad=0.19p pd=1.38u as=0 ps=0 w=1u l=1u
X42 VSS.t1391 VDD VSS.t1392 VSS.t311 sg13_lv_nmos ad=79.8f pd=0.8u as=0 ps=0 w=0.42u l=1u
X43 VSS.t2789 VDD VSS.t2788 VSS.t392 sg13_lv_nmos ad=0.1428p pd=1.52u as=0 ps=0 w=0.42u l=1u
X44 VSS.t2553 VDD VSS.t2555 VSS.t2554 sg13_lv_nmos ad=79.8f pd=0.8u as=0 ps=0 w=0.42u l=1u
X45 VDD VSS.t1641 VDD VDD sg13_lv_pmos ad=0.19p pd=1.38u as=0 ps=0 w=1u l=1u
X46 VDD VSS.t1658 VDD VDD sg13_lv_pmos ad=0.34p pd=2.68u as=0 ps=0 w=1u l=1u
X47 VSS.t2759 VDD VSS.t2760 VSS.t392 sg13_lv_nmos ad=79.8f pd=0.8u as=0 ps=0 w=0.42u l=1u
X48 VDD VSS.t481 VDD VDD sg13_lv_pmos ad=0.19p pd=1.38u as=0 ps=0 w=1u l=1u
X49 a_10703_15311# a_9861_15213# a_9444_15552# VDD sg13_lv_pmos ad=0.2048p pd=1.63u as=0.34p ps=2.68u w=1u l=0.13u
X50 VSS.t2458 VDD VSS.t2457 VSS.t2456 sg13_lv_nmos ad=0.1428p pd=1.52u as=0 ps=0 w=0.42u l=1u
X51 VDD VSS.t246 VDD VDD sg13_lv_pmos ad=0.34p pd=2.68u as=0 ps=0 w=1u l=1u
X52 a_15022_14484# clock_i VSS.t18 VSS.t298 sg13_lv_nmos ad=0.1406p pd=1.12u as=0.1406p ps=1.12u w=0.74u l=0.13u
X53 VDD VSS.t2220 VDD VDD sg13_lv_pmos ad=0.34p pd=2.68u as=0 ps=0 w=1u l=1u
X54 a_16068_14040# a_16042_13945# VSS.t290 VSS.t289 sg13_lv_nmos ad=0.2516p pd=2.16u as=0.1626p ps=1.415u w=0.74u l=0.13u
X55 VSS.t1093 VDD VSS.t1095 VSS.t1094 sg13_lv_nmos ad=79.8f pd=0.8u as=0 ps=0 w=0.42u l=1u
X56 VDD VSS.t1082 VDD VDD sg13_lv_pmos ad=0.34p pd=2.68u as=0 ps=0 w=1u l=1u
X57 VDD VSS.t1363 VDD VDD sg13_lv_pmos ad=0.34p pd=2.68u as=0 ps=0 w=1u l=1u
X58 VDD VSS.t1995 VDD VDD sg13_lv_pmos ad=0.34p pd=2.68u as=0 ps=0 w=1u l=1u
X59 VDD VSS.t2837 VDD VDD sg13_lv_pmos ad=0.34p pd=2.68u as=0 ps=0 w=1u l=1u
X60 a_10960_15454# a_10703_15311# a_11122_15234# VSS.t34 sg13_lv_nmos ad=0.1428p pd=1.52u as=37.8f ps=0.6u w=0.42u l=0.13u
X61 VDD VSS.t2760 VDD VDD sg13_lv_pmos ad=0.34p pd=2.68u as=0 ps=0 w=1u l=1u
X62 VDD VSS.t3155 VDD VDD sg13_lv_pmos ad=0.19p pd=1.38u as=0 ps=0 w=1u l=1u
X63 VDD VSS.t2023 VDD VDD sg13_lv_pmos ad=0.19p pd=1.38u as=0 ps=0 w=1u l=1u
X64 VSS.t1839 VDD VSS.t1841 VSS.t1840 sg13_lv_nmos ad=79.8f pd=0.8u as=0 ps=0 w=0.42u l=1u
X65 VDD VSS.t619 VDD VDD sg13_lv_pmos ad=0.19p pd=1.38u as=0 ps=0 w=1u l=1u
X66 VSS.t2231 VDD VSS.t2230 VSS.t2229 sg13_lv_nmos ad=0.1428p pd=1.52u as=0 ps=0 w=0.42u l=1u
X67 VDD VSS.t2185 VDD VDD sg13_lv_pmos ad=0.34p pd=2.68u as=0 ps=0 w=1u l=1u
X68 VDD VSS.t1291 VDD VDD sg13_lv_pmos ad=0.34p pd=2.68u as=0 ps=0 w=1u l=1u
X69 VDD sg13g2_or3_1_1.A sg13g2_o21ai_1_3.Y VDD sg13_lv_pmos ad=0.3808p pd=2.92u as=0.2128p ps=1.5u w=1.12u l=0.15u
X70 VDD VSS.t1145 VDD VDD sg13_lv_pmos ad=0.19p pd=1.38u as=0 ps=0 w=1u l=1u
X71 VSS.t1405 VDD VSS.t1406 VSS.t311 sg13_lv_nmos ad=79.8f pd=0.8u as=0 ps=0 w=0.42u l=1u
X72 VSS.t45 sg13g2_dfrbpq_1_3.RESET_B a_17412_14922# VSS.t228 sg13_lv_nmos ad=0.1626p pd=1.415u as=60.89999f ps=0.71u w=0.42u l=0.13u
X73 VSS.t1709 VDD VSS.t1711 VSS.t1710 sg13_lv_nmos ad=79.8f pd=0.8u as=0 ps=0 w=0.42u l=1u
X74 VDD VSS.t2487 VDD VDD sg13_lv_pmos ad=0.34p pd=2.68u as=0 ps=0 w=1u l=1u
X75 VSS.t1013 VDD VSS.t1015 VSS.t1014 sg13_lv_nmos ad=79.8f pd=0.8u as=0 ps=0 w=0.42u l=1u
X76 VSS.t1579 VDD VSS.t1581 VSS.t1580 sg13_lv_nmos ad=79.8f pd=0.8u as=0 ps=0 w=0.42u l=1u
X77 a_17900_15960# sg13g2_dfrbpq_1_2.Q VDD VDD sg13_lv_pmos ad=0.2856p pd=2.36u as=0.2114p ps=1.54u w=0.84u l=0.13u
X78 VSS.t90 a_32492_15960# counter_value_o[6] VSS.t248 sg13_lv_nmos ad=0.14875p pd=1.16u as=0.2886p ps=2.26u w=0.74u l=0.13u
X79 VSS.t2769 VDD VSS.t2770 VSS.t392 sg13_lv_nmos ad=79.8f pd=0.8u as=0 ps=0 w=0.42u l=1u
X80 a_21070_15423# a_21185_15424# VSS.t21 VSS.t20 sg13_lv_nmos ad=0.1428p pd=1.52u as=0.1426p ps=1.16u w=0.42u l=0.5u
X81 VDD VSS.t571 VDD VDD sg13_lv_pmos ad=0.34p pd=2.68u as=0 ps=0 w=1u l=1u
X82 VDD VSS.t861 VDD VDD sg13_lv_pmos ad=0.19p pd=1.38u as=0 ps=0 w=1u l=1u
X83 sg13g2_and2_1_2.B a_8694_15302# VDD VDD sg13_lv_pmos ad=0.4256p pd=3u as=0.2254p ps=1.53u w=1.12u l=0.13u
X84 VDD VSS.t1292 VDD VDD sg13_lv_pmos ad=0.19p pd=1.38u as=0 ps=0 w=1u l=1u
X85 VDD VSS.t2063 VDD VDD sg13_lv_pmos ad=0.19p pd=1.38u as=0 ps=0 w=1u l=1u
X86 VSS.t1063 VDD VSS.t1062 VSS.t1061 sg13_lv_nmos ad=0.1428p pd=1.52u as=0 ps=0 w=0.42u l=1u
X87 VDD VSS.t2382 VDD VDD sg13_lv_pmos ad=0.34p pd=2.68u as=0 ps=0 w=1u l=1u
X88 a_7923_15532# sg13g2_dlygate4sd3_1_8.X VDD VDD sg13_lv_pmos ad=0.1428p pd=1.375u as=0.2891p ps=1.695u w=1.12u l=0.13u
X89 VDD VSS.t1980 VDD VDD sg13_lv_pmos ad=0.34p pd=2.68u as=0 ps=0 w=1u l=1u
X90 VSS.t2893 VDD VSS.t3015 VSS.t392 sg13_lv_nmos ad=0.1428p pd=1.52u as=0 ps=0 w=0.42u l=1u
X91 VDD VSS.t2770 VDD VDD sg13_lv_pmos ad=0.34p pd=2.68u as=0 ps=0 w=1u l=1u
X92 VDD VSS.t2867 VDD VDD sg13_lv_pmos ad=0.19p pd=1.38u as=0 ps=0 w=1u l=1u
X93 VDD VSS.t599 VDD VDD sg13_lv_pmos ad=0.34p pd=2.68u as=0 ps=0 w=1u l=1u
X94 VDD sg13g2_o21ai_1_2.B1 a_24365_14508# VDD sg13_lv_pmos ad=0.3822p pd=1.84u as=0.1575p ps=1.315u w=1u l=0.13u
X95 VSS.t172 sg13g2_a21oi_1_0.B1 sg13g2_a21oi_1_3.Y VSS.t205 sg13_lv_nmos ad=0.2516p pd=2.16u as=0.1406p ps=1.12u w=0.74u l=0.13u
X96 VDD VSS.t3297 VDD VDD sg13_lv_pmos ad=0.34p pd=2.68u as=0 ps=0 w=1u l=1u
X97 a_27502_15423# a_27617_15424# VDD VDD sg13_lv_pmos ad=0.34p pd=2.68u as=0.2254p ps=1.53u w=1u l=0.5u
X98 VDD VSS.t693 VDD VDD sg13_lv_pmos ad=0.19p pd=1.38u as=0 ps=0 w=1u l=1u
X99 VDD VSS.t589 VDD VDD sg13_lv_pmos ad=0.19p pd=1.38u as=0 ps=0 w=1u l=1u
X100 VDD VSS.t768 VDD VDD sg13_lv_pmos ad=0.34p pd=2.68u as=0 ps=0 w=1u l=1u
X101 VSS.t2841 VDD VSS.t2840 VSS.t392 sg13_lv_nmos ad=0.1428p pd=1.52u as=0 ps=0 w=0.42u l=1u
X102 a_32492_15960# sg13g2_dfrbpq_1_7.Q VSS.t90 VSS.t89 sg13_lv_nmos ad=0.187p pd=1.78u as=0.14875p ps=1.16u w=0.55u l=0.13u
X103 VDD a_27034_15202# a_26753_15424# VDD sg13_lv_pmos ad=0.1523p pd=1.38u as=0.34p ps=2.68u w=1u l=0.5u
X104 VSS.t1123 VDD VSS.t1125 VSS.t1124 sg13_lv_nmos ad=79.8f pd=0.8u as=0 ps=0 w=0.42u l=1u
X105 VDD VSS.t1112 VDD VDD sg13_lv_pmos ad=0.34p pd=2.68u as=0 ps=0 w=1u l=1u
X106 VDD VSS.t1381 VDD VDD sg13_lv_pmos ad=0.34p pd=2.68u as=0 ps=0 w=1u l=1u
X107 VDD VSS.t920 VDD VDD sg13_lv_pmos ad=0.19p pd=1.38u as=0 ps=0 w=1u l=1u
X108 VSS.t1799 VDD VSS.t1798 VSS.t1797 sg13_lv_nmos ad=0.1428p pd=1.52u as=0 ps=0 w=0.42u l=1u
X109 VSS.t265 sg13g2_or3_1_2.B a_23638_14862# VSS.t25 sg13_lv_nmos ad=0.1406p pd=1.12u as=0.2516p ps=2.16u w=0.74u l=0.15u
X110 VSS.t349 VDD VSS.t349 VSS.t864 sg13_lv_nmos ad=0.1428p pd=1.52u as=0 ps=0 w=0.42u l=1u
X111 VSS.t2793 VDD VSS.t2794 VSS.t392 sg13_lv_nmos ad=79.8f pd=0.8u as=0 ps=0 w=0.42u l=1u
X112 VDD VSS.t2520 VDD VDD sg13_lv_pmos ad=0.19p pd=1.38u as=0 ps=0 w=1u l=1u
X113 VSS.t360 VDD VSS.t360 VSS.t441 sg13_lv_nmos ad=79.8f pd=0.8u as=0 ps=0 w=0.42u l=1u
X114 VDD a_14357_15238# sg13g2_or3_1_1.B VDD sg13_lv_pmos ad=0.3808p pd=2.92u as=0.2128p ps=1.5u w=1.12u l=0.13u
X115 VDD VSS.t1701 VDD VDD sg13_lv_pmos ad=0.19p pd=1.38u as=0 ps=0 w=1u l=1u
X116 VDD VSS.t2035 VDD VDD sg13_lv_pmos ad=0.34p pd=2.68u as=0 ps=0 w=1u l=1u
X117 VSS.t983 VDD VSS.t982 VSS.t981 sg13_lv_nmos ad=0.1428p pd=1.52u as=0 ps=0 w=0.42u l=1u
X118 VDD a_10960_15454# a_10905_15549# VDD sg13_lv_pmos ad=2.8961p pd=18.25u as=93.45f ps=0.865u w=0.42u l=0.13u
X119 VSS.t2779 VDD VSS.t2779 VSS.t392 sg13_lv_nmos ad=0.1428p pd=1.52u as=0 ps=0 w=0.42u l=1u
X120 VSS.t363 VDD VSS.t363 VSS.t479 sg13_lv_nmos ad=79.8f pd=0.8u as=0 ps=0 w=0.42u l=1u
X121 VSS.t13 VDD VSS.t13 VSS.t647 sg13_lv_nmos ad=79.8f pd=0.8u as=0 ps=0 w=0.42u l=1u
X122 VDD VSS.t1035 VDD VDD sg13_lv_pmos ad=0.19p pd=1.38u as=0 ps=0 w=1u l=1u
X123 VDD VSS.t2831 VDD VDD sg13_lv_pmos ad=0.19p pd=1.38u as=0 ps=0 w=1u l=1u
X124 VSS.t2101 VDD VSS.t2100 VSS.t2099 sg13_lv_nmos ad=0.1428p pd=1.52u as=0 ps=0 w=0.42u l=1u
X125 VDD VSS.t1322 VDD VDD sg13_lv_pmos ad=0.34p pd=2.68u as=0 ps=0 w=1u l=1u
X126 VSS.t2443 VDD VSS.t2442 VSS.t2441 sg13_lv_nmos ad=0.1428p pd=1.52u as=0 ps=0 w=0.42u l=1u
X127 VSS.t45 a_18106_15202# a_17825_15424# VSS.t201 sg13_lv_nmos ad=79.8f pd=0.8u as=0.1428p ps=1.52u w=0.42u l=0.5u
X128 VSS.t768 VDD VSS.t771 VSS.t889 sg13_lv_nmos ad=79.8f pd=0.8u as=0 ps=0 w=0.42u l=1u
X129 VDD VSS.t2402 VDD VDD sg13_lv_pmos ad=0.34p pd=2.68u as=0 ps=0 w=1u l=1u
X130 a_2540_15960# sg13g2_dlygate4sd3_1_3.A VSS.t360 VSS.t359 sg13_lv_nmos ad=0.187p pd=1.78u as=0.14875p ps=1.16u w=0.55u l=0.13u
X131 VSS.t2807 VDD VSS.t2808 VSS.t392 sg13_lv_nmos ad=79.8f pd=0.8u as=0 ps=0 w=0.42u l=1u
X132 VDD VSS.t2575 VDD VDD sg13_lv_pmos ad=0.19p pd=1.38u as=0 ps=0 w=1u l=1u
X133 VSS.t2633 VDD VSS.t2635 VSS.t2634 sg13_lv_nmos ad=79.8f pd=0.8u as=0 ps=0 w=0.42u l=1u
X134 VDD VSS.t910 VDD VDD sg13_lv_pmos ad=0.19p pd=1.38u as=0 ps=0 w=1u l=1u
X135 VSS.t2011 VDD VSS.t2010 VSS.t2009 sg13_lv_nmos ad=0.1428p pd=1.52u as=0 ps=0 w=0.42u l=1u
X136 VDD VSS.t745 VDD VDD sg13_lv_pmos ad=0.19p pd=1.38u as=0 ps=0 w=1u l=1u
X137 VSS.t1344 VDD VSS.t1345 VSS.t311 sg13_lv_nmos ad=79.8f pd=0.8u as=0 ps=0 w=0.42u l=1u
X138 VDD VSS.t3140 VDD VDD sg13_lv_pmos ad=0.19p pd=1.38u as=0 ps=0 w=1u l=1u
X139 VDD VSS.t2008 VDD VDD sg13_lv_pmos ad=0.19p pd=1.38u as=0 ps=0 w=1u l=1u
X140 VSS.t2181 VDD VSS.t2183 VSS.t2182 sg13_lv_nmos ad=79.8f pd=0.8u as=0 ps=0 w=0.42u l=1u
X141 VSS.t585 VDD VSS.t586 VSS.t9 sg13_lv_nmos ad=79.8f pd=0.8u as=0 ps=0 w=0.42u l=1u
X142 VDD VSS.t1075 VDD VDD sg13_lv_pmos ad=0.19p pd=1.38u as=0 ps=0 w=1u l=1u
X143 VDD VSS.t1856 VDD VDD sg13_lv_pmos ad=0.19p pd=1.38u as=0 ps=0 w=1u l=1u
X144 VDD VSS.t1374 VDD VDD sg13_lv_pmos ad=0.34p pd=2.68u as=0 ps=0 w=1u l=1u
X145 VDD VSS.t2876 VDD VDD sg13_lv_pmos ad=0.34p pd=2.68u as=0 ps=0 w=1u l=1u
X146 VDD VSS.t2540 VDD VDD sg13_lv_pmos ad=0.19p pd=1.38u as=0 ps=0 w=1u l=1u
X147 VDD a_27500_15960# counter_value_o[5] VDD sg13_lv_pmos ad=0.2114p pd=1.54u as=0.42p ps=2.99u w=1.12u l=0.13u
X148 VSS.t943 VDD VSS.t945 VSS.t944 sg13_lv_nmos ad=79.8f pd=0.8u as=0 ps=0 w=0.42u l=1u
X149 VDD sg13g2_nand4_1_0.Y a_14357_15238# VDD sg13_lv_pmos ad=0.203p pd=1.5u as=0.1596p ps=1.22u w=0.84u l=0.13u
X150 VDD VSS.t607 VDD VDD sg13_lv_pmos ad=0.19p pd=1.38u as=0 ps=0 w=1u l=1u
X151 VSS.t1013 VDD VSS.t1015 VSS.t1014 sg13_lv_nmos ad=79.8f pd=0.8u as=0 ps=0 w=0.42u l=1u
X152 VDD VSS.t1002 VDD VDD sg13_lv_pmos ad=0.34p pd=2.68u as=0 ps=0 w=1u l=1u
X153 VSS.t3048 VDD VSS.t3047 VSS.t3046 sg13_lv_nmos ad=0.1428p pd=1.52u as=0 ps=0 w=0.42u l=1u
X154 a_26436_13735# a_26667_13844# a_26122_13945# VSS.t365 sg13_lv_nmos ad=0.2373p pd=1.97u as=79.8f ps=0.8u w=0.42u l=0.13u
X155 a_26374_13735# sg13g2_dfrbpq_1_5.RESET_B VSS.t174 VSS.t173 sg13_lv_nmos ad=37.8f pd=0.6u as=0.1701p ps=1.65u w=0.42u l=0.13u
X156 VSS.t1694 VDD VSS.t1696 VSS.t1695 sg13_lv_nmos ad=79.8f pd=0.8u as=0 ps=0 w=0.42u l=1u
X157 VSS.t290 sg13g2_dfrbpq_1_2.RESET_B a_15876_13722# VSS.t387 sg13_lv_nmos ad=0.1626p pd=1.415u as=60.89999f ps=0.71u w=0.42u l=0.13u
X158 VDD VSS.t754 VDD VDD sg13_lv_pmos ad=0.19p pd=1.38u as=0 ps=0 w=1u l=1u
X159 VSS.t1353 VDD VSS.t1354 VSS.t311 sg13_lv_nmos ad=79.8f pd=0.8u as=0 ps=0 w=0.42u l=1u
X160 VSS.t2761 VDD VSS.t2762 VSS.t392 sg13_lv_nmos ad=79.8f pd=0.8u as=0 ps=0 w=0.42u l=1u
X161 VSS.t471 VDD VSS.t471 VSS.t476 sg13_lv_nmos ad=79.8f pd=0.8u as=0 ps=0 w=0.42u l=1u
X162 VSS.t28 a_27472_14726# a_27121_14845# VSS.t9 sg13_lv_nmos ad=79.8f pd=0.8u as=0.1428p ps=1.52u w=0.42u l=0.13u
X163 VSS.t748 VDD VSS.t748 VSS.t876 sg13_lv_nmos ad=0.1428p pd=1.52u as=0 ps=0 w=0.42u l=1u
X164 VDD VSS.t2567 VDD VDD sg13_lv_pmos ad=0.34p pd=2.68u as=0 ps=0 w=1u l=1u
X165 VDD VSS.t2225 VDD VDD sg13_lv_pmos ad=0.34p pd=2.68u as=0 ps=0 w=1u l=1u
X166 a_8582_15238# a_8312_15238# VSS.t60 VSS.t59 sg13_lv_nmos ad=0.1428p pd=1.52u as=79.8f ps=0.8u w=0.42u l=0.5u
X167 VSS.t707 VDD VSS.t712 VSS.t711 sg13_lv_nmos ad=79.8f pd=0.8u as=0 ps=0 w=0.42u l=1u
X168 VSS.t2618 VDD VSS.t2620 VSS.t2619 sg13_lv_nmos ad=79.8f pd=0.8u as=0 ps=0 w=0.42u l=1u
X169 VSS.t1317 VDD VSS.t1316 VSS.t311 sg13_lv_nmos ad=0.1428p pd=1.52u as=0 ps=0 w=0.42u l=1u
X170 VSS.t1505 VDD VSS.t1358 VSS.t311 sg13_lv_nmos ad=79.8f pd=0.8u as=0 ps=0 w=0.42u l=1u
X171 VDD VSS.t2762 VDD VDD sg13_lv_pmos ad=0.34p pd=2.68u as=0 ps=0 w=1u l=1u
X172 VDD VSS.t1449 VDD VDD sg13_lv_pmos ad=0.19p pd=1.38u as=0 ps=0 w=1u l=1u
X173 VDD VSS.t3125 VDD VDD sg13_lv_pmos ad=0.19p pd=1.38u as=0 ps=0 w=1u l=1u
X174 VDD VSS.t693 VDD VDD sg13_lv_pmos ad=0.19p pd=1.38u as=0 ps=0 w=1u l=1u
X175 a_27472_14726# a_27215_14845# a_27634_14922# VSS.t9 sg13_lv_nmos ad=0.1428p pd=1.52u as=37.8f ps=0.6u w=0.42u l=0.13u
X176 VSS.t1844 VDD VSS.t1846 VSS.t1845 sg13_lv_nmos ad=79.8f pd=0.8u as=0 ps=0 w=0.42u l=1u
X177 VSS.t913 VDD VSS.t912 VSS.t911 sg13_lv_nmos ad=0.1428p pd=1.52u as=0 ps=0 w=0.42u l=1u
X178 VSS.t2815 VDD VSS.t2815 VSS.t392 sg13_lv_nmos ad=0.1428p pd=1.52u as=0 ps=0 w=0.42u l=1u
X179 VSS.t983 VDD VSS.t982 VSS.t981 sg13_lv_nmos ad=0.1428p pd=1.52u as=0 ps=0 w=0.42u l=1u
X180 VDD VSS.t1686 VDD VDD sg13_lv_pmos ad=0.19p pd=1.38u as=0 ps=0 w=1u l=1u
X181 VSS.t2883 VDD VSS.t2883 VSS.t392 sg13_lv_nmos ad=0.1428p pd=1.52u as=0 ps=0 w=0.42u l=1u
X182 VDD VSS.t2020 VDD VDD sg13_lv_pmos ad=0.34p pd=2.68u as=0 ps=0 w=1u l=1u
X183 VSS.t2151 VDD VSS.t2153 VSS.t2152 sg13_lv_nmos ad=79.8f pd=0.8u as=0 ps=0 w=0.42u l=1u
X184 a_26122_13945# a_26565_13701# a_26505_14113# VDD sg13_lv_pmos ad=79.8f pd=0.8u as=63f ps=0.72u w=0.42u l=0.13u
X185 VDD VSS.t1080 VDD VDD sg13_lv_pmos ad=0.19p pd=1.38u as=0 ps=0 w=1u l=1u
X186 VSS.t1335 VDD VSS.t1334 VSS.t311 sg13_lv_nmos ad=0.1428p pd=1.52u as=0 ps=0 w=0.42u l=1u
X187 a_21827_13690# sg13g2_or3_1_2.C a_22125_14020# VDD sg13_lv_pmos ad=0.34p pd=2.68u as=0.19p ps=1.38u w=1u l=0.13u
X188 VDD sg13g2_buf_16_2.A a_12020_15202# VDD sg13_lv_pmos ad=0.2128p pd=1.5u as=0.2128p ps=1.5u w=1.12u l=0.13u
X189 VDD VSS.t2552 VDD VDD sg13_lv_pmos ad=0.34p pd=2.68u as=0 ps=0 w=1u l=1u
X190 VSS.t1339 VDD VSS.t1339 VSS.t311 sg13_lv_nmos ad=0.1428p pd=1.52u as=0 ps=0 w=0.42u l=1u
X191 VSS.t1639 VDD VSS.t1641 VSS.t1640 sg13_lv_nmos ad=79.8f pd=0.8u as=0 ps=0 w=0.42u l=1u
X192 VDD VSS.t2387 VDD VDD sg13_lv_pmos ad=0.34p pd=2.68u as=0 ps=0 w=1u l=1u
X193 VDD VSS.t1985 VDD VDD sg13_lv_pmos ad=0.34p pd=2.68u as=0 ps=0 w=1u l=1u
X194 VDD VSS.t2832 VDD VDD sg13_lv_pmos ad=0.34p pd=2.68u as=0 ps=0 w=1u l=1u
X195 VDD VSS.t18 VDD VDD sg13_lv_pmos ad=0.34p pd=2.68u as=0 ps=0 w=1u l=1u
X196 VSS.t1370 VDD VSS.t1371 VSS.t311 sg13_lv_nmos ad=79.8f pd=0.8u as=0 ps=0 w=0.42u l=1u
X197 VDD VSS.t2870 VDD VDD sg13_lv_pmos ad=0.19p pd=1.38u as=0 ps=0 w=1u l=1u
X198 VDD VSS.t2158 VDD VDD sg13_lv_pmos ad=0.19p pd=1.38u as=0 ps=0 w=1u l=1u
X199 VDD sg13g2_dfrbpq_1_0.RESET_B a_2890_15457# VDD sg13_lv_pmos ad=0.1563p pd=1.22u as=0.147p ps=1.54u w=0.42u l=0.13u
X200 VDD VSS.t1367 VDD VDD sg13_lv_pmos ad=0.19p pd=1.38u as=0 ps=0 w=1u l=1u
X201 VSS.t2573 VDD VSS.t2572 VSS.t2571 sg13_lv_nmos ad=0.1428p pd=1.52u as=0 ps=0 w=0.42u l=1u
X202 VSS.t1996 VDD VSS.t1995 VSS.t1994 sg13_lv_nmos ad=0.1428p pd=1.52u as=0 ps=0 w=0.42u l=1u
X203 VSS.t105 sg13g2_tiehi_1.L_HI a_9252_15234# VSS.t106 sg13_lv_nmos ad=0.1626p pd=1.415u as=60.89999f ps=0.71u w=0.42u l=0.13u
X204 a_16068_14040# a_16042_13945# VDD VDD sg13_lv_pmos ad=0.34p pd=2.68u as=0.36237p ps=2.605u w=1u l=0.13u
X205 VSS.t771 VDD VSS.t768 VSS.t770 sg13_lv_nmos ad=0.1428p pd=1.52u as=0 ps=0 w=0.42u l=1u
X206 VDD VSS.t3302 VDD VDD sg13_lv_pmos ad=0.34p pd=2.68u as=0 ps=0 w=1u l=1u
X207 a_18478_13911# a_18593_13912# VSS.t307 VSS.t343 sg13_lv_nmos ad=0.1428p pd=1.52u as=0.1426p ps=1.16u w=0.42u l=0.5u
X208 VSS.t1068 VDD VSS.t1067 VSS.t1066 sg13_lv_nmos ad=0.1428p pd=1.52u as=0 ps=0 w=0.42u l=1u
X209 VDD VSS.t2577 VDD VDD sg13_lv_pmos ad=0.34p pd=2.68u as=0 ps=0 w=1u l=1u
X210 VSS.t943 VDD VSS.t945 VSS.t944 sg13_lv_nmos ad=79.8f pd=0.8u as=0 ps=0 w=0.42u l=1u
X211 VSS.t1375 VDD VSS.t1376 VSS.t311 sg13_lv_nmos ad=79.8f pd=0.8u as=0 ps=0 w=0.42u l=1u
X212 VDD VSS.t1841 VDD VDD sg13_lv_pmos ad=0.19p pd=1.38u as=0 ps=0 w=1u l=1u
X213 VSS.t2638 VDD VSS.t2640 VSS.t2639 sg13_lv_nmos ad=79.8f pd=0.8u as=0 ps=0 w=0.42u l=1u
X214 VSS.t2796 VDD VSS.t2797 VSS.t392 sg13_lv_nmos ad=79.8f pd=0.8u as=0 ps=0 w=0.42u l=1u
X215 VDD VSS.t2525 VDD VDD sg13_lv_pmos ad=0.19p pd=1.38u as=0 ps=0 w=1u l=1u
X216 VSS.t2186 VDD VSS.t2185 VSS.t2184 sg13_lv_nmos ad=0.1428p pd=1.52u as=0 ps=0 w=0.42u l=1u
X217 VDD VSS.t1047 VDD VDD sg13_lv_pmos ad=0.34p pd=2.68u as=0 ps=0 w=1u l=1u
X218 VDD VSS.t1706 VDD VDD sg13_lv_pmos ad=0.19p pd=1.38u as=0 ps=0 w=1u l=1u
X219 VSS.t3033 VDD VSS.t3032 VSS.t3031 sg13_lv_nmos ad=0.1428p pd=1.52u as=0 ps=0 w=0.42u l=1u
X220 VSS.t2782 VDD VSS.t2782 VSS.t392 sg13_lv_nmos ad=0.1428p pd=1.52u as=0 ps=0 w=0.42u l=1u
X221 VSS.t2071 VDD VSS.t2070 VSS.t2069 sg13_lv_nmos ad=0.1428p pd=1.52u as=0 ps=0 w=0.42u l=1u
X222 VDD a_12020_15202# sg13g2_dfrbpq_1_2.CLK VDD sg13_lv_pmos ad=0.2128p pd=1.5u as=0.2128p ps=1.5u w=1.12u l=0.13u
X223 VDD VSS.t598 VDD VDD sg13_lv_pmos ad=0.19p pd=1.38u as=0 ps=0 w=1u l=1u
X224 VDD VSS.t2797 VDD VDD sg13_lv_pmos ad=0.34p pd=2.68u as=0 ps=0 w=1u l=1u
X225 VSS.t521 VDD VSS.t523 VSS.t522 sg13_lv_nmos ad=79.8f pd=0.8u as=0 ps=0 w=0.42u l=1u
X226 a_25930_14452# a_26373_14495# a_26313_14531# VDD sg13_lv_pmos ad=79.8f pd=0.8u as=63f ps=0.72u w=0.42u l=0.13u
X227 VDD VSS.t995 VDD VDD sg13_lv_pmos ad=0.19p pd=1.38u as=0 ps=0 w=1u l=1u
X228 VSS.t1083 VDD VSS.t1082 VSS.t1081 sg13_lv_nmos ad=0.1428p pd=1.52u as=0 ps=0 w=0.42u l=1u
X229 VDD VSS.t2372 VDD VDD sg13_lv_pmos ad=0.34p pd=2.68u as=0 ps=0 w=1u l=1u
X230 VSS.t2603 VDD VSS.t2605 VSS.t2604 sg13_lv_nmos ad=79.8f pd=0.8u as=0 ps=0 w=0.42u l=1u
X231 a_21348_14909# a_21060_14488# a_21286_14909# VSS.t65 sg13_lv_nmos ad=0.1428p pd=1.52u as=37.8f ps=0.6u w=0.42u l=0.13u
X232 VSS.t594 VDD VSS.t593 VSS.t9 sg13_lv_nmos ad=0.1428p pd=1.52u as=0 ps=0 w=0.42u l=1u
X233 VSS.t1384 VDD VSS.t1385 VSS.t311 sg13_lv_nmos ad=79.8f pd=0.8u as=0 ps=0 w=0.42u l=1u
X234 VSS.t1599 VDD VSS.t1598 VSS.t1597 sg13_lv_nmos ad=0.1428p pd=1.52u as=0 ps=0 w=0.42u l=1u
X235 VSS.t2508 VDD VSS.t2507 VSS.t2506 sg13_lv_nmos ad=0.1428p pd=1.52u as=0 ps=0 w=0.42u l=1u
X236 VDD VSS.t3110 VDD VDD sg13_lv_pmos ad=0.19p pd=1.38u as=0 ps=0 w=1u l=1u
X237 VDD VSS.t3287 VDD VDD sg13_lv_pmos ad=0.34p pd=2.68u as=0 ps=0 w=1u l=1u
X238 VSS.t1981 VDD VSS.t1980 VSS.t1979 sg13_lv_nmos ad=0.1428p pd=1.52u as=0 ps=0 w=0.42u l=1u
X239 sg13g2_dfrbpq_1_2.CLK a_12020_15202# VSS.t188 VSS.t195 sg13_lv_nmos ad=0.1406p pd=1.12u as=0.1406p ps=1.12u w=0.74u l=0.13u
X240 VSS.t913 VDD VSS.t912 VSS.t911 sg13_lv_nmos ad=0.1428p pd=1.52u as=0 ps=0 w=0.42u l=1u
X241 VDD VSS.t1366 VDD VDD sg13_lv_pmos ad=0.34p pd=2.68u as=0 ps=0 w=1u l=1u
X242 VSS.t11 a_6682_13690# a_6401_13912# VSS.t10 sg13_lv_nmos ad=79.8f pd=0.8u as=0.1428p ps=1.52u w=0.42u l=0.5u
X243 VSS.t54 VDD VSS.t54 VSS.t698 sg13_lv_nmos ad=0.1428p pd=1.52u as=0 ps=0 w=0.42u l=1u
X244 VSS.t1143 VDD VSS.t1145 VSS.t1144 sg13_lv_nmos ad=79.8f pd=0.8u as=0 ps=0 w=0.42u l=1u
X245 VDD VSS.t1321 VDD VDD sg13_lv_pmos ad=0.19p pd=1.38u as=0 ps=0 w=1u l=1u
X246 VSS.t2807 VDD VSS.t2806 VSS.t392 sg13_lv_nmos ad=0.1428p pd=1.52u as=0 ps=0 w=0.42u l=1u
X247 VDD enable_i a_1192_3900# VDD sg13_lv_pmos ad=0.2114p pd=1.54u as=0.2856p ps=2.36u w=0.84u l=0.13u
X248 VSS.t48 a_4432_15454# a_4081_15311# VSS.t47 sg13_lv_nmos ad=79.8f pd=0.8u as=0.1428p ps=1.52u w=0.42u l=0.13u
X249 VDD VSS.t1010 VDD VDD sg13_lv_pmos ad=0.19p pd=1.38u as=0 ps=0 w=1u l=1u
X250 VDD VSS.t2755 VDD VDD sg13_lv_pmos ad=0.19p pd=1.38u as=0 ps=0 w=1u l=1u
X251 VDD VSS.t1848 VDD VDD sg13_lv_pmos ad=0.34p pd=2.68u as=0 ps=0 w=1u l=1u
X252 VSS.t2136 VDD VSS.t2138 VSS.t2137 sg13_lv_nmos ad=79.8f pd=0.8u as=0 ps=0 w=0.42u l=1u
X253 VDD sg13g2_and2_1_2.B a_8685_14832# VDD sg13_lv_pmos ad=0.1918p pd=1.5u as=0.1596p ps=1.22u w=0.84u l=0.13u
X254 VDD a_19438_13726# sg13g2_buf_16_2.X VDD sg13_lv_pmos ad=0.2128p pd=1.5u as=0.2128p ps=1.5u w=1.12u l=0.13u
X255 VDD VSS.t723 VDD VDD sg13_lv_pmos ad=0.34p pd=2.68u as=0 ps=0 w=1u l=1u
X256 VSS.t1699 VDD VSS.t1701 VSS.t1700 sg13_lv_nmos ad=79.8f pd=0.8u as=0 ps=0 w=0.42u l=1u
X257 VSS.t3223 VDD VSS.t3225 VSS.t3224 sg13_lv_nmos ad=79.8f pd=0.8u as=0 ps=0 w=0.42u l=1u
X258 VDD VSS.t1294 VDD VDD sg13_lv_pmos ad=0.34p pd=2.68u as=0 ps=0 w=1u l=1u
X259 VSS.t2091 VDD VSS.t2090 VSS.t2089 sg13_lv_nmos ad=0.1428p pd=1.52u as=0 ps=0 w=0.42u l=1u
X260 VDD VSS.t947 VDD VDD sg13_lv_pmos ad=0.34p pd=2.68u as=0 ps=0 w=1u l=1u
X261 VSS.t2764 VDD VSS.t2765 VSS.t392 sg13_lv_nmos ad=79.8f pd=0.8u as=0 ps=0 w=0.42u l=1u
X262 VSS.t1434 VDD VSS.t1434 VSS.t311 sg13_lv_nmos ad=0.1428p pd=1.52u as=0 ps=0 w=0.42u l=1u
X263 VDD VSS.t2537 VDD VDD sg13_lv_pmos ad=0.34p pd=2.68u as=0 ps=0 w=1u l=1u
X264 VDD VSS.t2195 VDD VDD sg13_lv_pmos ad=0.34p pd=2.68u as=0 ps=0 w=1u l=1u
X265 VDD VSS.t1970 VDD VDD sg13_lv_pmos ad=0.34p pd=2.68u as=0 ps=0 w=1u l=1u
X266 VDD VSS.t2765 VDD VDD sg13_lv_pmos ad=0.34p pd=2.68u as=0 ps=0 w=1u l=1u
X267 VSS.t1068 VDD VSS.t1067 VSS.t1066 sg13_lv_nmos ad=0.1428p pd=1.52u as=0 ps=0 w=0.42u l=1u
X268 VDD VSS.t712 VDD VDD sg13_lv_pmos ad=0.34p pd=2.68u as=0 ps=0 w=1u l=1u
X269 VSS.t1113 VDD VSS.t1112 VSS.t1111 sg13_lv_nmos ad=0.1428p pd=1.52u as=0 ps=0 w=0.42u l=1u
X270 VDD VSS.t1303 VDD VDD sg13_lv_pmos ad=0.34p pd=2.68u as=0 ps=0 w=1u l=1u
X271 VDD VSS.t1412 VDD VDD sg13_lv_pmos ad=0.19p pd=1.38u as=0 ps=0 w=1u l=1u
X272 a_27500_15960# sg13g2_dfrbpq_1_6.Q VSS.t88 VSS.t87 sg13_lv_nmos ad=0.187p pd=1.78u as=0.14875p ps=1.16u w=0.55u l=0.13u
X273 VDD VSS.t977 VDD VDD sg13_lv_pmos ad=0.34p pd=2.68u as=0 ps=0 w=1u l=1u
X274 VDD VSS.t1165 VDD VDD sg13_lv_pmos ad=0.19p pd=1.38u as=0 ps=0 w=1u l=1u
X275 VSS.t2818 VDD VSS.t2817 VSS.t392 sg13_lv_nmos ad=0.1428p pd=1.52u as=0 ps=0 w=0.42u l=1u
X276 VDD sg13g2_xnor2_1_2.A sg13g2_nand4_1_0.Y VDD sg13_lv_pmos ad=0.2128p pd=1.5u as=0.2128p ps=1.5u w=1.12u l=0.13u
X277 VSS.t328 a_19438_13726# sg13g2_buf_16_2.X VSS.t327 sg13_lv_nmos ad=0.1406p pd=1.12u as=0.1406p ps=1.12u w=0.74u l=0.13u
X278 VDD a_27407_13799# a_27664_13942# VDD sg13_lv_pmos ad=2.42015p pd=15.68u as=79.8f ps=0.8u w=0.42u l=0.13u
X279 a_19450_15202# sg13g2_dfrbpq_1_3.Q VSS.t1 VSS.t0 sg13_lv_nmos ad=0.1428p pd=1.52u as=79.8f ps=0.8u w=0.42u l=0.13u
X280 VSS.t2623 VDD VSS.t2625 VSS.t2624 sg13_lv_nmos ad=79.8f pd=0.8u as=0 ps=0 w=0.42u l=1u
X281 VDD VSS.t774 VDD VDD sg13_lv_pmos ad=0.19p pd=1.38u as=0 ps=0 w=1u l=1u
X282 VDD VSS.t1691 VDD VDD sg13_lv_pmos ad=0.19p pd=1.38u as=0 ps=0 w=1u l=1u
X283 VDD VSS.t3157 VDD VDD sg13_lv_pmos ad=0.34p pd=2.68u as=0 ps=0 w=1u l=1u
X284 VSS.t2886 VDD VSS.t2885 VSS.t392 sg13_lv_nmos ad=0.1428p pd=1.52u as=0 ps=0 w=0.42u l=1u
X285 VDD VSS.t2025 VDD VDD sg13_lv_pmos ad=0.34p pd=2.68u as=0 ps=0 w=1u l=1u
X286 VSS.t2121 VDD VSS.t2123 VSS.t2122 sg13_lv_nmos ad=79.8f pd=0.8u as=0 ps=0 w=0.42u l=1u
X287 a_26436_13735# a_26148_14040# a_26374_13735# VSS.t344 sg13_lv_nmos ad=0.1428p pd=1.52u as=37.8f ps=0.6u w=0.42u l=0.13u
X288 VSS.t1033 VDD VSS.t1035 VSS.t1034 sg13_lv_nmos ad=79.8f pd=0.8u as=0 ps=0 w=0.42u l=1u
X289 VDD VSS.t1696 VDD VDD sg13_lv_pmos ad=0.19p pd=1.38u as=0 ps=0 w=1u l=1u
X290 VSS.t2756 VDD VSS.t2757 VSS.t392 sg13_lv_nmos ad=79.8f pd=0.8u as=0 ps=0 w=0.42u l=1u
X291 VSS.t1083 VDD VSS.t1082 VSS.t1081 sg13_lv_nmos ad=0.1428p pd=1.52u as=0 ps=0 w=0.42u l=1u
X292 VSS.t1447 VDD VSS.t1446 VSS.t311 sg13_lv_nmos ad=0.1428p pd=1.52u as=0 ps=0 w=0.42u l=1u
X293 VSS.t2493 VDD VSS.t2495 VSS.t2494 sg13_lv_nmos ad=79.8f pd=0.8u as=0 ps=0 w=0.42u l=1u
X294 VDD VSS.t1040 VDD VDD sg13_lv_pmos ad=0.19p pd=1.38u as=0 ps=0 w=1u l=1u
X295 VDD VSS.t2038 VDD VDD sg13_lv_pmos ad=0.19p pd=1.38u as=0 ps=0 w=1u l=1u
X296 VSS.t2041 VDD VSS.t2040 VSS.t2039 sg13_lv_nmos ad=0.1428p pd=1.52u as=0 ps=0 w=0.42u l=1u
X297 VSS.t908 VDD VSS.t910 VSS.t909 sg13_lv_nmos ad=79.8f pd=0.8u as=0 ps=0 w=0.42u l=1u
X298 VDD VSS.t2163 VDD VDD sg13_lv_pmos ad=0.19p pd=1.38u as=0 ps=0 w=1u l=1u
X299 VDD VSS.t611 VDD VDD sg13_lv_pmos ad=0.34p pd=2.68u as=0 ps=0 w=1u l=1u
X300 VDD VSS.t967 VDD VDD sg13_lv_pmos ad=0.34p pd=2.68u as=0 ps=0 w=1u l=1u
X301 VSS.t1584 VDD VSS.t1583 VSS.t1582 sg13_lv_nmos ad=0.1428p pd=1.52u as=0 ps=0 w=0.42u l=1u
X302 a_17412_14922# sg13g2_dfrbpq_1_3.D a_17318_14922# VSS.t19 sg13_lv_nmos ad=60.89999f pd=0.71u as=0.1428p ps=1.52u w=0.42u l=0.13u
X303 VDD VSS.t3272 VDD VDD sg13_lv_pmos ad=0.34p pd=2.68u as=0 ps=0 w=1u l=1u
X304 VSS.t2772 VDD VSS.t2771 VSS.t392 sg13_lv_nmos ad=0.1428p pd=1.52u as=0 ps=0 w=0.42u l=1u
X305 VDD a_25774_15423# sg13g2_dfrbpq_1_7.D VDD sg13_lv_pmos ad=0.2254p pd=1.53u as=0.4256p ps=3u w=1.12u l=0.13u
X306 VSS.t1143 VDD VSS.t1145 VSS.t1144 sg13_lv_nmos ad=79.8f pd=0.8u as=0 ps=0 w=0.42u l=1u
X307 VDD VSS.t1393 VDD VDD sg13_lv_pmos ad=0.34p pd=2.68u as=0 ps=0 w=1u l=1u
X308 VSS.t2964 VDD VSS.t2835 VSS.t392 sg13_lv_nmos ad=79.8f pd=0.8u as=0 ps=0 w=0.42u l=1u
X309 VDD VSS.t1846 VDD VDD sg13_lv_pmos ad=0.19p pd=1.38u as=0 ps=0 w=1u l=1u
X310 VDD a_18021_14495# a_18123_14495# VDD sg13_lv_pmos ad=2.42015p pd=15.68u as=0.3864p ps=2.93u w=1.12u l=0.13u
X311 VSS.t319 a_19438_13726# sg13g2_buf_16_2.X VSS.t323 sg13_lv_nmos ad=0.1406p pd=1.12u as=0.1406p ps=1.12u w=0.74u l=0.13u
X312 VSS.t1003 VDD VSS.t1002 VSS.t1001 sg13_lv_nmos ad=0.1428p pd=1.52u as=0 ps=0 w=0.42u l=1u
X313 VDD a_22319_14845# a_22986_14484# VDD sg13_lv_pmos ad=0.2128p pd=1.5u as=0.3864p ps=2.93u w=1.12u l=0.13u
X314 VSS.t1489 VDD VSS.t1338 VSS.t311 sg13_lv_nmos ad=79.8f pd=0.8u as=0 ps=0 w=0.42u l=1u
X315 VDD VSS.t1676 VDD VDD sg13_lv_pmos ad=0.19p pd=1.38u as=0 ps=0 w=1u l=1u
X316 VSS.t572 VDD VSS.t571 VSS.t570 sg13_lv_nmos ad=0.1428p pd=1.52u as=0 ps=0 w=0.42u l=1u
X317 VDD VSS.t471 VDD VDD sg13_lv_pmos ad=0.34p pd=2.68u as=0 ps=0 w=1u l=1u
X318 VDD VSS.t1430 VDD VDD sg13_lv_pmos ad=0.19p pd=1.38u as=0 ps=0 w=1u l=1u
X319 VSS.t2785 VDD VSS.t2785 VSS.t392 sg13_lv_nmos ad=0.1428p pd=1.52u as=0 ps=0 w=0.42u l=1u
X320 VDD VSS.t2590 VDD VDD sg13_lv_pmos ad=0.19p pd=1.38u as=0 ps=0 w=1u l=1u
X321 VSS.t2076 VDD VSS.t2075 VSS.t2074 sg13_lv_nmos ad=0.1428p pd=1.52u as=0 ps=0 w=0.42u l=1u
X322 VSS.t3163 VDD VSS.t3162 VSS.t3161 sg13_lv_nmos ad=0.1428p pd=1.52u as=0 ps=0 w=0.42u l=1u
X323 VSS.t460 VDD VSS.t460 VSS.t462 sg13_lv_nmos ad=0.1428p pd=1.52u as=0 ps=0 w=0.42u l=1u
X324 VDD VSS.t2377 VDD VDD sg13_lv_pmos ad=0.34p pd=2.68u as=0 ps=0 w=1u l=1u
X325 VSS.t2608 VDD VSS.t2610 VSS.t2609 sg13_lv_nmos ad=79.8f pd=0.8u as=0 ps=0 w=0.42u l=1u
X326 VSS.t588 VDD VSS.t589 VSS.t9 sg13_lv_nmos ad=79.8f pd=0.8u as=0 ps=0 w=0.42u l=1u
X327 VDD VSS.t681 VDD VDD sg13_lv_pmos ad=0.34p pd=2.68u as=0 ps=0 w=1u l=1u
X328 VDD VSS.t930 VDD VDD sg13_lv_pmos ad=0.19p pd=1.38u as=0 ps=0 w=1u l=1u
X329 VDD VSS.t1641 VDD VDD sg13_lv_pmos ad=0.19p pd=1.38u as=0 ps=0 w=1u l=1u
X330 VDD VSS.t2550 VDD VDD sg13_lv_pmos ad=0.19p pd=1.38u as=0 ps=0 w=1u l=1u
X331 VDD VSS.t246 VDD VDD sg13_lv_pmos ad=0.34p pd=2.68u as=0 ps=0 w=1u l=1u
X332 VSS.t1113 VDD VSS.t1112 VSS.t1111 sg13_lv_nmos ad=0.1428p pd=1.52u as=0 ps=0 w=0.42u l=1u
X333 VSS.t1774 VDD VSS.t1776 VSS.t1775 sg13_lv_nmos ad=79.8f pd=0.8u as=0 ps=0 w=0.42u l=1u
X334 VSS.t1986 VDD VSS.t1985 VSS.t1984 sg13_lv_nmos ad=0.1428p pd=1.52u as=0 ps=0 w=0.42u l=1u
X335 VDD VSS.t712 VDD VDD sg13_lv_pmos ad=0.34p pd=2.68u as=0 ps=0 w=1u l=1u
X336 VSS.t2156 VDD VSS.t2158 VSS.t2157 sg13_lv_nmos ad=79.8f pd=0.8u as=0 ps=0 w=0.42u l=1u
X337 VDD VSS.t1438 VDD VDD sg13_lv_pmos ad=0.19p pd=1.38u as=0 ps=0 w=1u l=1u
X338 VSS.t1320 VDD VSS.t1321 VSS.t311 sg13_lv_nmos ad=79.8f pd=0.8u as=0 ps=0 w=0.42u l=1u
X339 VDD VSS.t2085 VDD VDD sg13_lv_pmos ad=0.34p pd=2.68u as=0 ps=0 w=1u l=1u
X340 VSS.t81 a_26633_16334# a_26554_16237# VSS.t239 sg13_lv_nmos ad=5.24677p pd=34.365u as=0.27427p ps=2.28u w=0.795u l=0.13u
X341 sg13g2_nor2_1_0.B a_16044_15424# VDD VDD sg13_lv_pmos ad=0.2408p pd=1.55u as=0.3808p ps=2.92u w=1.12u l=0.13u
X342 VSS.t2809 VDD VSS.t2809 VSS.t392 sg13_lv_nmos ad=0.1428p pd=1.52u as=0 ps=0 w=0.42u l=1u
X343 a_2516_14484# a_2490_14447# sg13g2_and2_1_0.B VDD sg13_lv_pmos ad=0.2128p pd=1.5u as=0.3808p ps=2.92u w=1.12u l=0.13u
X344 VSS.t1033 VDD VSS.t1035 VSS.t1034 sg13_lv_nmos ad=79.8f pd=0.8u as=0 ps=0 w=0.42u l=1u
X345 VDD VSS.t619 VDD VDD sg13_lv_pmos ad=0.19p pd=1.38u as=0 ps=0 w=1u l=1u
X346 VDD VSS.t1022 VDD VDD sg13_lv_pmos ad=0.34p pd=2.68u as=0 ps=0 w=1u l=1u
X347 VSS.t319 a_19438_13726# sg13g2_buf_16_2.X VSS.t318 sg13_lv_nmos ad=0.1406p pd=1.12u as=0.1406p ps=1.12u w=0.74u l=0.13u
X348 VDD VSS.t1853 VDD VDD sg13_lv_pmos ad=0.34p pd=2.68u as=0 ps=0 w=1u l=1u
X349 VSS.t748 VDD VSS.t745 VSS.t747 sg13_lv_nmos ad=0.1428p pd=1.52u as=0 ps=0 w=0.42u l=1u
X350 VDD VSS.t1147 VDD VDD sg13_lv_pmos ad=0.34p pd=2.68u as=0 ps=0 w=1u l=1u
X351 VSS.t1704 VDD VSS.t1706 VSS.t1705 sg13_lv_nmos ad=79.8f pd=0.8u as=0 ps=0 w=0.42u l=1u
X352 VSS.t3228 VDD VSS.t3230 VSS.t3229 sg13_lv_nmos ad=79.8f pd=0.8u as=0 ps=0 w=0.42u l=1u
X353 VDD a_3130_16237# sg13g2_dfrbpq_1_0.RESET_B VDD sg13_lv_pmos ad=2.8961p pd=18.25u as=0.3927p ps=2.99u w=1.155u l=0.13u
X354 VDD a_18478_13911# sg13g2_dlygate4sd3_1_4.X VDD sg13_lv_pmos ad=0.2254p pd=1.53u as=0.4256p ps=3u w=1.12u l=0.13u
X355 VSS.t763 VDD VSS.t760 VSS.t884 sg13_lv_nmos ad=0.1428p pd=1.52u as=0 ps=0 w=0.42u l=1u
X356 VSS.t2478 VDD VSS.t2480 VSS.t2479 sg13_lv_nmos ad=79.8f pd=0.8u as=0 ps=0 w=0.42u l=1u
X357 VSS.t908 VDD VSS.t910 VSS.t909 sg13_lv_nmos ad=79.8f pd=0.8u as=0 ps=0 w=0.42u l=1u
X358 VDD VSS.t897 VDD VDD sg13_lv_pmos ad=0.34p pd=2.68u as=0 ps=0 w=1u l=1u
X359 VDD VSS.t2542 VDD VDD sg13_lv_pmos ad=0.34p pd=2.68u as=0 ps=0 w=1u l=1u
X360 VDD VSS.t2200 VDD VDD sg13_lv_pmos ad=0.34p pd=2.68u as=0 ps=0 w=1u l=1u
X361 VDD VSS.t1085 VDD VDD sg13_lv_pmos ad=0.19p pd=1.38u as=0 ps=0 w=1u l=1u
X362 VSS.t702 VDD VSS.t702 VSS.t704 sg13_lv_nmos ad=79.8f pd=0.8u as=0 ps=0 w=0.42u l=1u
X363 VDD VSS.t553 VDD VDD sg13_lv_pmos ad=0.34p pd=2.68u as=0 ps=0 w=1u l=1u
X364 VDD sg13g2_dlygate4sd3_1_0.X a_5613_14832# VDD sg13_lv_pmos ad=0.1918p pd=1.5u as=0.1596p ps=1.22u w=0.84u l=0.13u
X365 VDD VSS.t54 VDD VDD sg13_lv_pmos ad=0.19p pd=1.38u as=0 ps=0 w=1u l=1u
X366 VDD VSS.t1361 VDD VDD sg13_lv_pmos ad=0.19p pd=1.38u as=0 ps=0 w=1u l=1u
X367 VDD VSS.t2865 VDD VDD sg13_lv_pmos ad=0.19p pd=1.38u as=0 ps=0 w=1u l=1u
X368 VSS.t2563 VDD VSS.t2562 VSS.t2561 sg13_lv_nmos ad=0.1428p pd=1.52u as=0 ps=0 w=0.42u l=1u
X369 VSS.t2176 VDD VSS.t2178 VSS.t2177 sg13_lv_nmos ad=79.8f pd=0.8u as=0 ps=0 w=0.42u l=1u
X370 VSS.t62 a_17030_15238# a_17142_15302# VSS.t415 sg13_lv_nmos ad=0.1426p pd=1.16u as=0.1428p ps=1.52u w=0.42u l=0.5u
X371 VDD VSS.t2243 VDD VDD sg13_lv_pmos ad=0.19p pd=1.38u as=0 ps=0 w=1u l=1u
X372 VSS.t606 VDD VSS.t607 VSS.t9 sg13_lv_nmos ad=79.8f pd=0.8u as=0 ps=0 w=0.42u l=1u
X373 sg13g2_buf_16_2.A a_15022_14484# VDD VDD sg13_lv_pmos ad=0.2128p pd=1.5u as=0.2128p ps=1.5u w=1.12u l=0.13u
X374 VDD VSS.t599 VDD VDD sg13_lv_pmos ad=0.34p pd=2.68u as=0 ps=0 w=1u l=1u
X375 VSS.t1003 VDD VSS.t1002 VSS.t1001 sg13_lv_nmos ad=0.1428p pd=1.52u as=0 ps=0 w=0.42u l=1u
X376 VSS.t1297 VDD VSS.t1298 VSS.t311 sg13_lv_nmos ad=79.8f pd=0.8u as=0 ps=0 w=0.42u l=1u
X377 VDD VSS.t543 VDD VDD sg13_lv_pmos ad=0.19p pd=1.38u as=0 ps=0 w=1u l=1u
X378 VSS.t1048 VDD VSS.t1047 VSS.t1046 sg13_lv_nmos ad=0.1428p pd=1.52u as=0 ps=0 w=0.42u l=1u
X379 VSS.t2801 VDD VSS.t2800 VSS.t392 sg13_lv_nmos ad=0.1428p pd=1.52u as=0 ps=0 w=0.42u l=1u
X380 VSS.t2628 VDD VSS.t2630 VSS.t2629 sg13_lv_nmos ad=79.8f pd=0.8u as=0 ps=0 w=0.42u l=1u
X381 a_27407_13799# a_26565_13701# a_26148_14040# VDD sg13_lv_pmos ad=0.2048p pd=1.63u as=0.34p ps=2.68u w=1u l=0.13u
X382 VDD VSS.t1661 VDD VDD sg13_lv_pmos ad=0.19p pd=1.38u as=0 ps=0 w=1u l=1u
X383 VDD VSS.t1838 VDD VDD sg13_lv_pmos ad=0.34p pd=2.68u as=0 ps=0 w=1u l=1u
X384 VDD VSS.t3127 VDD VDD sg13_lv_pmos ad=0.34p pd=2.68u as=0 ps=0 w=1u l=1u
X385 VDD VSS.t2030 VDD VDD sg13_lv_pmos ad=0.34p pd=2.68u as=0 ps=0 w=1u l=1u
X386 VSS.t2126 VDD VSS.t2128 VSS.t2127 sg13_lv_nmos ad=79.8f pd=0.8u as=0 ps=0 w=0.42u l=1u
X387 VDD VSS.t452 VDD VDD sg13_lv_pmos ad=0.19p pd=1.38u as=0 ps=0 w=1u l=1u
X388 VSS.t66 a_22319_14845# a_22986_14484# VSS.t25 sg13_lv_nmos ad=0.1406p pd=1.12u as=0.2516p ps=2.16u w=0.74u l=0.13u
X389 VSS.t2776 VDD VSS.t2776 VSS.t392 sg13_lv_nmos ad=0.1428p pd=1.52u as=0 ps=0 w=0.42u l=1u
X390 VSS.t54 VDD VSS.t54 VSS.t698 sg13_lv_nmos ad=0.1428p pd=1.52u as=0 ps=0 w=0.42u l=1u
X391 VDD VSS.t1701 VDD VDD sg13_lv_pmos ad=0.19p pd=1.38u as=0 ps=0 w=1u l=1u
X392 VDD VSS.t2828 VDD VDD sg13_lv_pmos ad=0.19p pd=1.38u as=0 ps=0 w=1u l=1u
X393 VDD VSS.t1052 VDD VDD sg13_lv_pmos ad=0.34p pd=2.68u as=0 ps=0 w=1u l=1u
X394 VDD VSS.t1346 VDD VDD sg13_lv_pmos ad=0.34p pd=2.68u as=0 ps=0 w=1u l=1u
X395 a_17892_14909# a_17604_14488# a_17830_14909# VSS.t2 sg13_lv_nmos ad=0.1428p pd=1.52u as=37.8f ps=0.6u w=0.42u l=0.13u
X396 VDD VSS.t723 VDD VDD sg13_lv_pmos ad=0.34p pd=2.68u as=0 ps=0 w=1u l=1u
X397 VDD VSS.t681 VDD VDD sg13_lv_pmos ad=0.34p pd=2.68u as=0 ps=0 w=1u l=1u
X398 VSS.t1382 VDD VSS.t1382 VSS.t311 sg13_lv_nmos ad=79.8f pd=0.8u as=0 ps=0 w=0.42u l=1u
X399 VDD VSS.t2362 VDD VDD sg13_lv_pmos ad=0.34p pd=2.68u as=0 ps=0 w=1u l=1u
X400 VSS.t2423 VDD VSS.t2425 VSS.t2424 sg13_lv_nmos ad=79.8f pd=0.8u as=0 ps=0 w=0.42u l=1u
X401 VSS.t2775 VDD VSS.t2773 VSS.t392 sg13_lv_nmos ad=0.1428p pd=1.52u as=0 ps=0 w=0.42u l=1u
X402 VSS.t1971 VDD VSS.t1970 VSS.t1969 sg13_lv_nmos ad=0.1428p pd=1.52u as=0 ps=0 w=0.42u l=1u
X403 a_16425_14113# a_16068_14040# VDD VDD sg13_lv_pmos ad=63f pd=0.72u as=0.1563p ps=1.22u w=0.42u l=0.13u
X404 VSS.t2870 VDD VSS.t2871 VSS.t392 sg13_lv_nmos ad=79.8f pd=0.8u as=0 ps=0 w=0.42u l=1u
X405 VSS.t1387 VDD VSS.t1388 VSS.t311 sg13_lv_nmos ad=79.8f pd=0.8u as=0 ps=0 w=0.42u l=1u
X406 VDD a_17584_13942# a_17529_14037# VDD sg13_lv_pmos ad=2.42015p pd=15.68u as=93.45f ps=0.865u w=0.42u l=0.13u
X407 VSS.t1714 VDD VSS.t1713 VSS.t1712 sg13_lv_nmos ad=0.1428p pd=1.52u as=0 ps=0 w=0.42u l=1u
X408 VSS.t2463 VDD VSS.t2465 VSS.t2464 sg13_lv_nmos ad=79.8f pd=0.8u as=0 ps=0 w=0.42u l=1u
X409 VDD VSS.t2405 VDD VDD sg13_lv_pmos ad=0.19p pd=1.38u as=0 ps=0 w=1u l=1u
X410 VDD VSS.t1067 VDD VDD sg13_lv_pmos ad=0.34p pd=2.68u as=0 ps=0 w=1u l=1u
X411 VDD VSS.t3195 VDD VDD sg13_lv_pmos ad=0.19p pd=1.38u as=0 ps=0 w=1u l=1u
X412 VDD VSS.t1368 VDD VDD sg13_lv_pmos ad=0.34p pd=2.68u as=0 ps=0 w=1u l=1u
X413 VDD VSS.t2871 VDD VDD sg13_lv_pmos ad=0.34p pd=2.68u as=0 ps=0 w=1u l=1u
X414 VDD VSS.t1324 VDD VDD sg13_lv_pmos ad=0.19p pd=1.38u as=0 ps=0 w=1u l=1u
X415 VSS.t1689 VDD VSS.t1691 VSS.t1690 sg13_lv_nmos ad=79.8f pd=0.8u as=0 ps=0 w=0.42u l=1u
X416 VSS.t2081 VDD VSS.t2080 VSS.t2079 sg13_lv_nmos ad=0.1428p pd=1.52u as=0 ps=0 w=0.42u l=1u
X417 a_9252_15234# sg13g2_and2_1_2.X a_9158_15234# VSS.t107 sg13_lv_nmos ad=60.89999f pd=0.71u as=0.1428p ps=1.52u w=0.42u l=0.13u
X418 VSS.t627 VDD VSS.t626 VSS.t9 sg13_lv_nmos ad=0.1428p pd=1.52u as=0 ps=0 w=0.42u l=1u
X419 VSS.t328 VDD VSS.t328 VSS.t839 sg13_lv_nmos ad=79.8f pd=0.8u as=0 ps=0 w=0.42u l=1u
X420 VDD VSS.t1130 VDD VDD sg13_lv_pmos ad=0.19p pd=1.38u as=0 ps=0 w=1u l=1u
X421 VSS.t1396 VDD VSS.t1397 VSS.t311 sg13_lv_nmos ad=79.8f pd=0.8u as=0 ps=0 w=0.42u l=1u
X422 VDD VSS.t1708 VDD VDD sg13_lv_pmos ad=0.34p pd=2.68u as=0 ps=0 w=1u l=1u
X423 VSS.t2613 VDD VSS.t2615 VSS.t2614 sg13_lv_nmos ad=79.8f pd=0.8u as=0 ps=0 w=0.42u l=1u
X424 VDD VSS.t2555 VDD VDD sg13_lv_pmos ad=0.19p pd=1.38u as=0 ps=0 w=1u l=1u
X425 VDD VSS.t751 VDD VDD sg13_lv_pmos ad=0.19p pd=1.38u as=0 ps=0 w=1u l=1u
X426 VSS.t1779 VDD VSS.t1781 VSS.t1780 sg13_lv_nmos ad=79.8f pd=0.8u as=0 ps=0 w=0.42u l=1u
X427 VSS.t2161 VDD VSS.t2163 VSS.t2162 sg13_lv_nmos ad=79.8f pd=0.8u as=0 ps=0 w=0.42u l=1u
X428 VDD VSS.t471 VDD VDD sg13_lv_pmos ad=0.19p pd=1.38u as=0 ps=0 w=1u l=1u
X429 VSS.t1163 VDD VSS.t1165 VSS.t1164 sg13_lv_nmos ad=79.8f pd=0.8u as=0 ps=0 w=0.42u l=1u
X430 VDD VSS.t2055 VDD VDD sg13_lv_pmos ad=0.34p pd=2.68u as=0 ps=0 w=1u l=1u
X431 VSS.t1048 VDD VSS.t1047 VSS.t1046 sg13_lv_nmos ad=0.1428p pd=1.52u as=0 ps=0 w=0.42u l=1u
X432 VDD VSS.t2228 VDD VDD sg13_lv_pmos ad=0.19p pd=1.38u as=0 ps=0 w=1u l=1u
X433 VSS.t180 a_4078_14751# sg13g2_xor2_1_0.B VSS.t179 sg13_lv_nmos ad=0.1426p pd=1.16u as=0.2516p ps=2.16u w=0.74u l=0.13u
X434 VDD VSS.t1030 VDD VDD sg13_lv_pmos ad=0.19p pd=1.38u as=0 ps=0 w=1u l=1u
X435 VDD VSS.t3180 VDD VDD sg13_lv_pmos ad=0.19p pd=1.38u as=0 ps=0 w=1u l=1u
X436 VDD VSS.t2390 VDD VDD sg13_lv_pmos ad=0.19p pd=1.38u as=0 ps=0 w=1u l=1u
X437 VSS.t2791 VDD VSS.t2791 VSS.t392 sg13_lv_nmos ad=0.1428p pd=1.52u as=0 ps=0 w=0.42u l=1u
X438 VDD VSS.t2180 VDD VDD sg13_lv_pmos ad=0.34p pd=2.68u as=0 ps=0 w=1u l=1u
X439 VDD VSS.t590 VDD VDD sg13_lv_pmos ad=0.34p pd=2.68u as=0 ps=0 w=1u l=1u
X440 VDD VSS.t1306 VDD VDD sg13_lv_pmos ad=0.34p pd=2.68u as=0 ps=0 w=1u l=1u
X441 VDD VSS.t1823 VDD VDD sg13_lv_pmos ad=0.34p pd=2.68u as=0 ps=0 w=1u l=1u
X442 VDD VSS.t2015 VDD VDD sg13_lv_pmos ad=0.34p pd=2.68u as=0 ps=0 w=1u l=1u
X443 VSS.t2111 VDD VSS.t2113 VSS.t2112 sg13_lv_nmos ad=79.8f pd=0.8u as=0 ps=0 w=0.42u l=1u
X444 VSS.t621 VDD VSS.t620 VSS.t9 sg13_lv_nmos ad=0.1428p pd=1.52u as=0 ps=0 w=0.42u l=1u
X445 VDD VSS.t681 VDD VDD sg13_lv_pmos ad=0.19p pd=1.38u as=0 ps=0 w=1u l=1u
X446 VSS.t1674 VDD VSS.t1676 VSS.t1675 sg13_lv_nmos ad=79.8f pd=0.8u as=0 ps=0 w=0.42u l=1u
X447 VSS.t3198 VDD VSS.t3200 VSS.t3199 sg13_lv_nmos ad=79.8f pd=0.8u as=0 ps=0 w=0.42u l=1u
X448 VSS.t2408 VDD VSS.t2410 VSS.t2409 sg13_lv_nmos ad=79.8f pd=0.8u as=0 ps=0 w=0.42u l=1u
X449 VDD sg13g2_xnor2_1_2.A a_6714_12972# VDD sg13_lv_pmos ad=0.2891p pd=1.695u as=0.1428p ps=1.375u w=1.12u l=0.13u
X450 VDD VSS.t1372 VDD VDD sg13_lv_pmos ad=0.34p pd=2.68u as=0 ps=0 w=1u l=1u
X451 VSS.t1364 VDD VSS.t1365 VSS.t311 sg13_lv_nmos ad=79.8f pd=0.8u as=0 ps=0 w=0.42u l=1u
X452 VDD VSS.t1686 VDD VDD sg13_lv_pmos ad=0.19p pd=1.38u as=0 ps=0 w=1u l=1u
X453 a_10905_15549# a_9963_15356# a_10703_15311# VDD sg13_lv_pmos ad=93.45f pd=0.865u as=0.2048p ps=1.63u w=0.42u l=0.13u
X454 VDD VSS.t905 VDD VDD sg13_lv_pmos ad=0.19p pd=1.38u as=0 ps=0 w=1u l=1u
X455 VSS.t2483 VDD VSS.t2485 VSS.t2484 sg13_lv_nmos ad=79.8f pd=0.8u as=0 ps=0 w=0.42u l=1u
X456 VSS.t188 a_12020_15202# sg13g2_dfrbpq_1_2.CLK VSS.t194 sg13_lv_nmos ad=0.1406p pd=1.12u as=0.1406p ps=1.12u w=0.74u l=0.13u
X457 VDD VSS.t2547 VDD VDD sg13_lv_pmos ad=0.34p pd=2.68u as=0 ps=0 w=1u l=1u
X458 a_22426_15202# sg13g2_dfrbpq_1_6.Q VSS.t86 VSS.t24 sg13_lv_nmos ad=0.1428p pd=1.52u as=79.8f ps=0.8u w=0.42u l=0.13u
X459 VDD VSS.t2756 VDD VDD sg13_lv_pmos ad=0.34p pd=2.68u as=0 ps=0 w=1u l=1u
X460 a_19120_14726# sg13g2_dfrbpq_1_3.RESET_B VDD VDD sg13_lv_pmos ad=79.8f pd=0.8u as=2.42015p ps=15.68u w=0.42u l=0.13u
X461 VDD sg13g2_o21ai_1_2.B1 sg13g2_or3_1_1.C VDD sg13_lv_pmos ad=0.3808p pd=2.92u as=0.2128p ps=1.5u w=1.12u l=0.13u
X462 a_23480_15242# sg13g2_dfrbpq_1_3.Q a_23378_15242# VSS.t24 sg13_lv_nmos ad=0.1406p pd=1.12u as=0.1406p ps=1.12u w=0.74u l=0.13u
X463 VDD VSS.t1314 VDD VDD sg13_lv_pmos ad=0.34p pd=2.68u as=0 ps=0 w=1u l=1u
X464 VSS.t2766 VDD VSS.t2766 VSS.t392 sg13_lv_nmos ad=0.1428p pd=1.52u as=0 ps=0 w=0.42u l=1u
X465 VSS.t481 VDD VSS.t363 VSS.t480 sg13_lv_nmos ad=0.1428p pd=1.52u as=0 ps=0 w=0.42u l=1u
X466 VSS.t1413 VDD VSS.t1414 VSS.t311 sg13_lv_nmos ad=79.8f pd=0.8u as=0 ps=0 w=0.42u l=1u
X467 VDD a_21562_15960# a_21281_16262# VDD sg13_lv_pmos ad=0.1523p pd=1.38u as=0.34p ps=2.68u w=1u l=0.5u
X468 VDD sg13g2_o21ai_1_2.Y a_24824_15238# VDD sg13_lv_pmos ad=0.1523p pd=1.38u as=0.1428p ps=1.52u w=0.42u l=0.13u
X469 VDD a_18863_14845# a_19530_14484# VDD sg13_lv_pmos ad=0.2128p pd=1.5u as=0.3864p ps=2.93u w=1.12u l=0.13u
X470 a_20603_15532# sg13g2_a21oi_1_0.B1 sg13g2_a21oi_1_1.Y VDD sg13_lv_pmos ad=0.2128p pd=1.5u as=0.3808p ps=2.92u w=1.12u l=0.13u
X471 VDD VSS.t975 VDD VDD sg13_lv_pmos ad=0.19p pd=1.38u as=0 ps=0 w=1u l=1u
X472 VDD VSS.t1400 VDD VDD sg13_lv_pmos ad=0.19p pd=1.38u as=0 ps=0 w=1u l=1u
X473 VDD VSS.t2899 VDD VDD sg13_lv_pmos ad=0.19p pd=1.38u as=0 ps=0 w=1u l=1u
X474 VSS.t2628 VDD VSS.t2627 VSS.t2626 sg13_lv_nmos ad=0.1428p pd=1.52u as=0 ps=0 w=0.42u l=1u
X475 VSS.t2448 VDD VSS.t2450 VSS.t2449 sg13_lv_nmos ad=79.8f pd=0.8u as=0 ps=0 w=0.42u l=1u
X476 VDD VSS.t2213 VDD VDD sg13_lv_pmos ad=0.19p pd=1.38u as=0 ps=0 w=1u l=1u
X477 VSS.t2803 VDD VSS.t2803 VSS.t392 sg13_lv_nmos ad=0.1428p pd=1.52u as=0 ps=0 w=0.42u l=1u
X478 VDD VSS.t3132 VDD VDD sg13_lv_pmos ad=0.34p pd=2.68u as=0 ps=0 w=1u l=1u
X479 VSS.t2873 VDD VSS.t2872 VSS.t392 sg13_lv_nmos ad=0.1428p pd=1.52u as=0 ps=0 w=0.42u l=1u
X480 VDD VSS.t2000 VDD VDD sg13_lv_pmos ad=0.34p pd=2.68u as=0 ps=0 w=1u l=1u
X481 VSS.t1854 VDD VSS.t1853 VSS.t1852 sg13_lv_nmos ad=0.1428p pd=1.52u as=0 ps=0 w=0.42u l=1u
X482 VSS.t588 VDD VSS.t587 VSS.t9 sg13_lv_nmos ad=0.1428p pd=1.52u as=0 ps=0 w=0.42u l=1u
X483 VDD VSS.t1060 VDD VDD sg13_lv_pmos ad=0.19p pd=1.38u as=0 ps=0 w=1u l=1u
X484 VDD VSS.t1706 VDD VDD sg13_lv_pmos ad=0.19p pd=1.38u as=0 ps=0 w=1u l=1u
X485 VDD VSS.t2580 VDD VDD sg13_lv_pmos ad=0.19p pd=1.38u as=0 ps=0 w=1u l=1u
X486 VSS.t3153 VDD VSS.t3152 VSS.t3151 sg13_lv_nmos ad=0.1428p pd=1.52u as=0 ps=0 w=0.42u l=1u
X487 VSS.t501 VDD VSS.t503 VSS.t502 sg13_lv_nmos ad=79.8f pd=0.8u as=0 ps=0 w=0.42u l=1u
X488 VDD VSS.t466 VDD VDD sg13_lv_pmos ad=0.34p pd=2.68u as=0 ps=0 w=1u l=1u
X489 VSS.t231 a_22508_15960# counter_value_o[4] VSS.t230 sg13_lv_nmos ad=0.14875p pd=1.16u as=0.2886p ps=2.26u w=0.74u l=0.13u
X490 sg13g2_buf_16_2.A a_15022_14484# VSS.t62 VSS.t145 sg13_lv_nmos ad=0.1406p pd=1.12u as=0.1406p ps=1.12u w=0.74u l=0.13u
X491 VDD VSS.t2863 VDD VDD sg13_lv_pmos ad=0.19p pd=1.38u as=0 ps=0 w=1u l=1u
X492 VSS.t2598 VDD VSS.t2600 VSS.t2599 sg13_lv_nmos ad=79.8f pd=0.8u as=0 ps=0 w=0.42u l=1u
X493 VDD VSS.t598 VDD VDD sg13_lv_pmos ad=0.19p pd=1.38u as=0 ps=0 w=1u l=1u
X494 VDD VSS.t1405 VDD VDD sg13_lv_pmos ad=0.34p pd=2.68u as=0 ps=0 w=1u l=1u
X495 VDD VSS.t317 VDD VDD sg13_lv_pmos ad=0.19p pd=1.38u as=0 ps=0 w=1u l=1u
X496 VSS.t1163 VDD VSS.t1165 VSS.t1164 sg13_lv_nmos ad=79.8f pd=0.8u as=0 ps=0 w=0.42u l=1u
X497 VSS.t2759 VDD VSS.t2758 VSS.t392 sg13_lv_nmos ad=0.1428p pd=1.52u as=0 ps=0 w=0.42u l=1u
X498 VDD VSS.t2635 VDD VDD sg13_lv_pmos ad=0.19p pd=1.38u as=0 ps=0 w=1u l=1u
X499 VSS.t1356 VDD VSS.t1355 VSS.t311 sg13_lv_nmos ad=0.1428p pd=1.52u as=0 ps=0 w=0.42u l=1u
X500 sg13g2_dfrbpq_1_2.CLK a_12020_15202# VDD VDD sg13_lv_pmos ad=0.2128p pd=1.5u as=0.2128p ps=1.5u w=1.12u l=0.13u
X501 VSS.t702 VDD VSS.t702 VSS.t704 sg13_lv_nmos ad=79.8f pd=0.8u as=0 ps=0 w=0.42u l=1u
X502 VSS.t2468 VDD VSS.t2470 VSS.t2469 sg13_lv_nmos ad=79.8f pd=0.8u as=0 ps=0 w=0.42u l=1u
X503 VDD VSS.t2040 VDD VDD sg13_lv_pmos ad=0.34p pd=2.68u as=0 ps=0 w=1u l=1u
X504 VSS.t1023 VDD VSS.t1022 VSS.t1021 sg13_lv_nmos ad=0.1428p pd=1.52u as=0 ps=0 w=0.42u l=1u
X505 VDD VSS.t2375 VDD VDD sg13_lv_pmos ad=0.19p pd=1.38u as=0 ps=0 w=1u l=1u
X506 VSS.t2241 VDD VSS.t2243 VSS.t2242 sg13_lv_nmos ad=79.8f pd=0.8u as=0 ps=0 w=0.42u l=1u
X507 VDD sg13g2_dlygate4sd3_1_17.A a_24824_14525# VDD sg13_lv_pmos ad=0.1523p pd=1.38u as=0.1428p ps=1.52u w=0.42u l=0.13u
X508 VSS.t1498 VDD VSS.t1350 VSS.t311 sg13_lv_nmos ad=79.8f pd=0.8u as=0 ps=0 w=0.42u l=1u
X509 VDD VSS.t1440 VDD VDD sg13_lv_pmos ad=0.19p pd=1.38u as=0 ps=0 w=1u l=1u
X510 VDD VSS.t2165 VDD VDD sg13_lv_pmos ad=0.34p pd=2.68u as=0 ps=0 w=1u l=1u
X511 VDD VSS.t681 VDD VDD sg13_lv_pmos ad=0.19p pd=1.38u as=0 ps=0 w=1u l=1u
X512 VSS.t1839 VDD VSS.t1838 VSS.t1837 sg13_lv_nmos ad=0.1428p pd=1.52u as=0 ps=0 w=0.42u l=1u
X513 VDD a_19450_15202# a_19169_15424# VDD sg13_lv_pmos ad=0.1523p pd=1.38u as=0.34p ps=2.68u w=1u l=0.5u
X514 a_26373_14495# sg13g2_buf_16_2.X VSS.t9 VSS.t151 sg13_lv_nmos ad=0.2516p pd=2.16u as=5.01922p ps=33.275u w=0.74u l=0.13u
X515 VDD VSS.t460 VDD VDD sg13_lv_pmos ad=0.34p pd=2.68u as=0 ps=0 w=1u l=1u
X516 a_26170_15202# sg13g2_a21oi_1_3.Y VSS.t5 VSS.t27 sg13_lv_nmos ad=0.1428p pd=1.52u as=79.8f ps=0.8u w=0.42u l=0.13u
X517 VSS.t78 a_21827_13690# sg13g2_or3_1_2.X VSS.t304 sg13_lv_nmos ad=0.13395p pd=1.12u as=0.2516p ps=2.16u w=0.74u l=0.13u
X518 VSS.t898 VDD VSS.t897 VSS.t896 sg13_lv_nmos ad=0.1428p pd=1.52u as=0 ps=0 w=0.42u l=1u
X519 VDD VSS.t1848 VDD VDD sg13_lv_pmos ad=0.34p pd=2.68u as=0 ps=0 w=1u l=1u
X520 VSS.t1083 VDD VSS.t1085 VSS.t1084 sg13_lv_nmos ad=79.8f pd=0.8u as=0 ps=0 w=0.42u l=1u
X521 VSS.t26 sg13g2_or3_1_2.B a_24310_15230# VSS.t24 sg13_lv_nmos ad=0.1406p pd=1.12u as=0.2516p ps=2.16u w=0.74u l=0.15u
X522 VDD VSS.t2532 VDD VDD sg13_lv_pmos ad=0.34p pd=2.68u as=0 ps=0 w=1u l=1u
X523 VDD VSS.t1678 VDD VDD sg13_lv_pmos ad=0.34p pd=2.68u as=0 ps=0 w=1u l=1u
X524 sg13g2_buf_16_2.A a_15022_14484# VSS.t62 VSS.t141 sg13_lv_nmos ad=0.1406p pd=1.12u as=0.1406p ps=1.12u w=0.74u l=0.13u
X525 a_16042_13945# a_16485_13701# a_15782_13722# VSS.t292 sg13_lv_nmos ad=79.8f pd=0.8u as=0.1296p ps=1.52u w=0.42u l=0.13u
X526 VSS.t2583 VDD VSS.t2585 VSS.t2584 sg13_lv_nmos ad=79.8f pd=0.8u as=0 ps=0 w=0.42u l=1u
X527 VSS.t606 VDD VSS.t605 VSS.t9 sg13_lv_nmos ad=0.1428p pd=1.52u as=0 ps=0 w=0.42u l=1u
X528 VDD VSS.t712 VDD VDD sg13_lv_pmos ad=0.34p pd=2.68u as=0 ps=0 w=1u l=1u
X529 VSS.t1749 VDD VSS.t1751 VSS.t1750 sg13_lv_nmos ad=79.8f pd=0.8u as=0 ps=0 w=0.42u l=1u
X530 VDD VSS.t2060 VDD VDD sg13_lv_pmos ad=0.34p pd=2.68u as=0 ps=0 w=1u l=1u
X531 VDD VSS.t557 VDD VDD sg13_lv_pmos ad=0.19p pd=1.38u as=0 ps=0 w=1u l=1u
X532 VSS.t1331 VDD VSS.t1330 VSS.t311 sg13_lv_nmos ad=0.1428p pd=1.52u as=0 ps=0 w=0.42u l=1u
X533 VDD VSS.t1290 VDD VDD sg13_lv_pmos ad=0.34p pd=2.68u as=0 ps=0 w=1u l=1u
X534 a_19120_14726# a_18863_14845# a_19282_14922# VSS.t76 sg13_lv_nmos ad=0.1428p pd=1.52u as=37.8f ps=0.6u w=0.42u l=0.13u
X535 VSS.t1 a_18863_14845# a_19530_14484# VSS.t76 sg13_lv_nmos ad=0.1406p pd=1.12u as=0.2516p ps=2.16u w=0.74u l=0.13u
X536 VDD VSS.t1391 VDD VDD sg13_lv_pmos ad=0.19p pd=1.38u as=0 ps=0 w=1u l=1u
X537 VDD VSS.t2891 VDD VDD sg13_lv_pmos ad=0.19p pd=1.38u as=0 ps=0 w=1u l=1u
X538 VDD VSS.t1422 VDD VDD sg13_lv_pmos ad=0.34p pd=2.68u as=0 ps=0 w=1u l=1u
X539 VSS.t2795 VDD VSS.t2794 VSS.t392 sg13_lv_nmos ad=0.1428p pd=1.52u as=0 ps=0 w=0.42u l=1u
X540 VSS.t2613 VDD VSS.t2612 VSS.t2611 sg13_lv_nmos ad=0.1428p pd=1.52u as=0 ps=0 w=0.42u l=1u
X541 VSS.t2226 VDD VSS.t2228 VSS.t2227 sg13_lv_nmos ad=79.8f pd=0.8u as=0 ps=0 w=0.42u l=1u
X542 VDD VSS.t58 VDD VDD sg13_lv_pmos ad=0.34p pd=2.68u as=0 ps=0 w=1u l=1u
X543 VDD VSS.t1167 VDD VDD sg13_lv_pmos ad=0.34p pd=2.68u as=0 ps=0 w=1u l=1u
X544 VSS.t760 VDD VSS.t757 VSS.t759 sg13_lv_nmos ad=0.1428p pd=1.52u as=0 ps=0 w=0.42u l=1u
X545 VSS.t1373 VDD VSS.t1372 VSS.t311 sg13_lv_nmos ad=0.1428p pd=1.52u as=0 ps=0 w=0.42u l=1u
X546 VSS.t2116 VDD VSS.t2118 VSS.t2117 sg13_lv_nmos ad=79.8f pd=0.8u as=0 ps=0 w=0.42u l=1u
X547 VSS.t3203 VDD VSS.t3205 VSS.t3204 sg13_lv_nmos ad=79.8f pd=0.8u as=0 ps=0 w=0.42u l=1u
X548 VSS.t2413 VDD VSS.t2415 VSS.t2414 sg13_lv_nmos ad=79.8f pd=0.8u as=0 ps=0 w=0.42u l=1u
X549 VSS.t557 VDD VSS.t557 VSS.t559 sg13_lv_nmos ad=0.1428p pd=1.52u as=0 ps=0 w=0.42u l=1u
X550 VSS.t615 VDD VSS.t614 VSS.t9 sg13_lv_nmos ad=0.1428p pd=1.52u as=0 ps=0 w=0.42u l=1u
X551 VSS.t1053 VDD VSS.t1052 VSS.t1051 sg13_lv_nmos ad=0.1428p pd=1.52u as=0 ps=0 w=0.42u l=1u
X552 VDD VSS.t1691 VDD VDD sg13_lv_pmos ad=0.19p pd=1.38u as=0 ps=0 w=1u l=1u
X553 VSS.t582 VDD VSS.t246 VSS.t9 sg13_lv_nmos ad=0.1428p pd=1.52u as=0 ps=0 w=0.42u l=1u
X554 VDD VSS.t1105 VDD VDD sg13_lv_pmos ad=0.19p pd=1.38u as=0 ps=0 w=1u l=1u
X555 VDD VSS.t1746 VDD VDD sg13_lv_pmos ad=0.19p pd=1.38u as=0 ps=0 w=1u l=1u
X556 VSS.t2488 VDD VSS.t2490 VSS.t2489 sg13_lv_nmos ad=79.8f pd=0.8u as=0 ps=0 w=0.42u l=1u
X557 VDD VSS.t455 VDD VDD sg13_lv_pmos ad=0.19p pd=1.38u as=0 ps=0 w=1u l=1u
X558 VDD VSS.t2517 VDD VDD sg13_lv_pmos ad=0.34p pd=2.68u as=0 ps=0 w=1u l=1u
X559 a_27034_15202# sg13g2_dfrbpq_1_7.Q VDD VDD sg13_lv_pmos ad=0.1428p pd=1.52u as=0.1523p ps=1.38u w=0.42u l=0.13u
X560 VSS.t2793 VDD VSS.t2791 VSS.t392 sg13_lv_nmos ad=0.1428p pd=1.52u as=0 ps=0 w=0.42u l=1u
X561 VDD VSS.t736 VDD VDD sg13_lv_pmos ad=0.19p pd=1.38u as=0 ps=0 w=1u l=1u
X562 VDD VSS.t2028 VDD VDD sg13_lv_pmos ad=0.19p pd=1.38u as=0 ps=0 w=1u l=1u
X563 VDD VSS.t2855 VDD VDD sg13_lv_pmos ad=0.19p pd=1.38u as=0 ps=0 w=1u l=1u
X564 VSS.t1709 VDD VSS.t1708 VSS.t1707 sg13_lv_nmos ad=0.1428p pd=1.52u as=0 ps=0 w=0.42u l=1u
X565 VSS.t3233 VDD VSS.t3232 VSS.t3231 sg13_lv_nmos ad=0.1428p pd=1.52u as=0 ps=0 w=0.42u l=1u
X566 sg13g2_buf_16_2.A a_15022_14484# VSS.t62 VSS.t137 sg13_lv_nmos ad=0.1406p pd=1.12u as=0.1406p ps=1.12u w=0.74u l=0.13u
X567 VDD VSS.t2435 VDD VDD sg13_lv_pmos ad=0.19p pd=1.38u as=0 ps=0 w=1u l=1u
X568 VDD VSS.t2829 VDD VDD sg13_lv_pmos ad=0.34p pd=2.68u as=0 ps=0 w=1u l=1u
X569 VSS.t1023 VDD VSS.t1022 VSS.t1021 sg13_lv_nmos ad=0.1428p pd=1.52u as=0 ps=0 w=0.42u l=1u
X570 a_25390_16263# a_25505_16262# VDD VDD sg13_lv_pmos ad=0.34p pd=2.68u as=0.2254p ps=1.53u w=1u l=0.5u
X571 VSS.t618 VDD VSS.t619 VSS.t9 sg13_lv_nmos ad=79.8f pd=0.8u as=0 ps=0 w=0.42u l=1u
X572 VDD VSS.t611 VDD VDD sg13_lv_pmos ad=0.34p pd=2.68u as=0 ps=0 w=1u l=1u
X573 VDD VSS.t980 VDD VDD sg13_lv_pmos ad=0.19p pd=1.38u as=0 ps=0 w=1u l=1u
X574 VDD VSS.t2620 VDD VDD sg13_lv_pmos ad=0.19p pd=1.38u as=0 ps=0 w=1u l=1u
X575 VDD VSS.t1403 VDD VDD sg13_lv_pmos ad=0.19p pd=1.38u as=0 ps=0 w=1u l=1u
X576 VSS.t1704 VDD VSS.t1703 VSS.t1702 sg13_lv_nmos ad=0.1428p pd=1.52u as=0 ps=0 w=0.42u l=1u
X577 VDD VSS.t2902 VDD VDD sg13_lv_pmos ad=0.19p pd=1.38u as=0 ps=0 w=1u l=1u
X578 VSS.t2633 VDD VSS.t2632 VSS.t2631 sg13_lv_nmos ad=0.1428p pd=1.52u as=0 ps=0 w=0.42u l=1u
X579 VSS.t2453 VDD VSS.t2455 VSS.t2454 sg13_lv_nmos ad=79.8f pd=0.8u as=0 ps=0 w=0.42u l=1u
X580 VDD VSS.t2218 VDD VDD sg13_lv_pmos ad=0.19p pd=1.38u as=0 ps=0 w=1u l=1u
X581 VDD VSS.t2572 VDD VDD sg13_lv_pmos ad=0.34p pd=2.68u as=0 ps=0 w=1u l=1u
X582 VDD VSS.t3137 VDD VDD sg13_lv_pmos ad=0.34p pd=2.68u as=0 ps=0 w=1u l=1u
X583 VDD VSS.t2178 VDD VDD sg13_lv_pmos ad=0.19p pd=1.38u as=0 ps=0 w=1u l=1u
X584 VSS.t2181 VDD VSS.t2180 VSS.t2179 sg13_lv_nmos ad=0.1428p pd=1.52u as=0 ps=0 w=0.42u l=1u
X585 VSS.t898 VDD VSS.t897 VSS.t896 sg13_lv_nmos ad=0.1428p pd=1.52u as=0 ps=0 w=0.42u l=1u
X586 VSS.t1083 VDD VSS.t1085 VSS.t1084 sg13_lv_nmos ad=79.8f pd=0.8u as=0 ps=0 w=0.42u l=1u
X587 VDD VSS.t1358 VDD VDD sg13_lv_pmos ad=0.34p pd=2.68u as=0 ps=0 w=1u l=1u
X588 VDD VSS.t1676 VDD VDD sg13_lv_pmos ad=0.19p pd=1.38u as=0 ps=0 w=1u l=1u
X589 VDD VSS.t1731 VDD VDD sg13_lv_pmos ad=0.19p pd=1.38u as=0 ps=0 w=1u l=1u
X590 VDD a_8218_13690# a_7937_13912# VDD sg13_lv_pmos ad=0.1523p pd=1.38u as=0.34p ps=2.68u w=1u l=0.5u
X591 sg13g2_dfrbpq_1_2.Q a_17994_14020# VDD VDD sg13_lv_pmos ad=0.3808p pd=2.92u as=0.2128p ps=1.5u w=1.12u l=0.13u
X592 VDD VSS.t2790 VDD VDD sg13_lv_pmos ad=0.19p pd=1.38u as=0 ps=0 w=1u l=1u
X593 VDD VSS.t2865 VDD VDD sg13_lv_pmos ad=0.19p pd=1.38u as=0 ps=0 w=1u l=1u
X594 VSS.t2131 VDD VSS.t2130 VSS.t2129 sg13_lv_nmos ad=0.1428p pd=1.52u as=0 ps=0 w=0.42u l=1u
X595 VDD VSS.t58 VDD VDD sg13_lv_pmos ad=0.34p pd=2.68u as=0 ps=0 w=1u l=1u
X596 VDD VSS.t333 VDD VDD sg13_lv_pmos ad=0.34p pd=2.68u as=0 ps=0 w=1u l=1u
X597 VDD VSS.t1012 VDD VDD sg13_lv_pmos ad=0.34p pd=2.68u as=0 ps=0 w=1u l=1u
X598 VSS.t3218 VDD VSS.t3217 VSS.t3216 sg13_lv_nmos ad=0.1428p pd=1.52u as=0 ps=0 w=0.42u l=1u
X599 VSS.t2428 VDD VSS.t2427 VSS.t2426 sg13_lv_nmos ad=0.1428p pd=1.52u as=0 ps=0 w=0.42u l=1u
X600 VDD VSS.t486 VDD VDD sg13_lv_pmos ad=0.19p pd=1.38u as=0 ps=0 w=1u l=1u
X601 a_23960_15242# sg13g2_dfrbpq_1_3.Q a_23858_15242# VSS.t24 sg13_lv_nmos ad=0.1406p pd=1.12u as=0.1406p ps=1.12u w=0.74u l=0.13u
X602 VSS.t600 VDD VSS.t599 VSS.t9 sg13_lv_nmos ad=0.1428p pd=1.52u as=0 ps=0 w=0.42u l=1u
X603 VDD sg13g2_dlygate4sd3_1_4.X sg13g2_xnor2_1_1.A VDD sg13_lv_pmos ad=0.3808p pd=2.92u as=0.3808p ps=2.92u w=1.12u l=0.13u
X604 a_7680_15549# sg13g2_dlygate4sd3_1_8.X VDD VDD sg13_lv_pmos ad=0.1596p pd=1.22u as=0.4536p ps=2.76u w=0.84u l=0.13u
X605 VDD sg13g2_xnor2_1_0.Y a_8312_15238# VDD sg13_lv_pmos ad=0.1523p pd=1.38u as=0.1428p ps=1.52u w=0.42u l=0.13u
X606 VSS.t2761 VDD VSS.t2761 VSS.t392 sg13_lv_nmos ad=0.1428p pd=1.52u as=0 ps=0 w=0.42u l=1u
X607 a_24923_15996# sg13g2_or3_1_1.X VDD VDD sg13_lv_pmos ad=0.3808p pd=2.92u as=0.2128p ps=1.5u w=1.12u l=0.13u
X608 VSS.t2857 VDD VSS.t2857 VSS.t392 sg13_lv_nmos ad=79.8f pd=0.8u as=0 ps=0 w=0.42u l=1u
X609 VDD VSS.t2605 VDD VDD sg13_lv_pmos ad=0.19p pd=1.38u as=0 ps=0 w=1u l=1u
X610 VDD VSS.t754 VDD VDD sg13_lv_pmos ad=0.19p pd=1.38u as=0 ps=0 w=1u l=1u
X611 VDD VSS.t2045 VDD VDD sg13_lv_pmos ad=0.34p pd=2.68u as=0 ps=0 w=1u l=1u
X612 VDD VSS.t3170 VDD VDD sg13_lv_pmos ad=0.19p pd=1.38u as=0 ps=0 w=1u l=1u
X613 VDD VSS.t2380 VDD VDD sg13_lv_pmos ad=0.19p pd=1.38u as=0 ps=0 w=1u l=1u
X614 VDD VSS.t13 VDD VDD sg13_lv_pmos ad=0.19p pd=1.38u as=0 ps=0 w=1u l=1u
X615 a_20868_14922# sg13g2_dfrbpq_1_6.D a_20774_14922# VSS.t76 sg13_lv_nmos ad=60.89999f pd=0.71u as=0.1428p ps=1.52u w=0.42u l=0.13u
X616 VSS.t2211 VDD VSS.t2213 VSS.t2212 sg13_lv_nmos ad=79.8f pd=0.8u as=0 ps=0 w=0.42u l=1u
X617 VSS.t317 sg13g2_buf_16_2.A a_19438_13726# VSS.t410 sg13_lv_nmos ad=0.1406p pd=1.12u as=0.1406p ps=1.12u w=0.74u l=0.13u
X618 VDD VSS.t2170 VDD VDD sg13_lv_pmos ad=0.34p pd=2.68u as=0 ps=0 w=1u l=1u
X619 VSS.t1053 VDD VSS.t1052 VSS.t1051 sg13_lv_nmos ad=0.1428p pd=1.52u as=0 ps=0 w=0.42u l=1u
X620 VSS.t1431 VDD VSS.t1430 VSS.t311 sg13_lv_nmos ad=0.1428p pd=1.52u as=0 ps=0 w=0.42u l=1u
X621 VSS.t536 VDD VSS.t538 VSS.t537 sg13_lv_nmos ad=79.8f pd=0.8u as=0 ps=0 w=0.42u l=1u
X622 VDD VSS.t702 VDD VDD sg13_lv_pmos ad=0.34p pd=2.68u as=0 ps=0 w=1u l=1u
X623 VSS.t3188 VDD VSS.t3190 VSS.t3189 sg13_lv_nmos ad=79.8f pd=0.8u as=0 ps=0 w=0.42u l=1u
X624 VSS.t2398 VDD VSS.t2400 VSS.t2399 sg13_lv_nmos ad=79.8f pd=0.8u as=0 ps=0 w=0.42u l=1u
X625 a_21562_15960# sg13g2_a21oi_1_1.Y VSS.t386 VSS.t395 sg13_lv_nmos ad=0.1428p pd=1.52u as=79.8f ps=0.8u w=0.42u l=0.13u
X626 VDD sg13g2_dlygate4sd3_1_1.A sg13g2_nand3_1_0.Y VDD sg13_lv_pmos ad=0.2128p pd=1.5u as=0.2128p ps=1.5u w=1.12u l=0.13u
X627 VDD a_21477_14495# a_21579_14495# VDD sg13_lv_pmos ad=2.42015p pd=15.68u as=0.3864p ps=2.93u w=1.12u l=0.13u
X628 VDD VSS.t1853 VDD VDD sg13_lv_pmos ad=0.34p pd=2.68u as=0 ps=0 w=1u l=1u
X629 VDD a_15022_14484# sg13g2_buf_16_2.A VDD sg13_lv_pmos ad=0.2128p pd=1.5u as=0.2128p ps=1.5u w=1.12u l=0.13u
X630 a_16218_15532# sg13g2_or3_1_2.B sg13g2_nor2_1_0.B VDD sg13_lv_pmos ad=0.1428p pd=1.375u as=0.2408p ps=1.55u w=1.12u l=0.13u
X631 VSS.t1759 VDD VSS.t1761 VSS.t1760 sg13_lv_nmos ad=79.8f pd=0.8u as=0 ps=0 w=0.42u l=1u
X632 VSS.t2473 VDD VSS.t2475 VSS.t2474 sg13_lv_nmos ad=79.8f pd=0.8u as=0 ps=0 w=0.42u l=1u
X633 a_17830_14909# sg13g2_dfrbpq_1_3.RESET_B VSS.t45 VSS.t229 sg13_lv_nmos ad=37.8f pd=0.6u as=0.1701p ps=1.65u w=0.42u l=0.13u
X634 VDD VSS.t766 VDD VDD sg13_lv_pmos ad=0.19p pd=1.38u as=0 ps=0 w=1u l=1u
X635 VDD VSS.t1683 VDD VDD sg13_lv_pmos ad=0.34p pd=2.68u as=0 ps=0 w=1u l=1u
X636 VDD VSS.t2597 VDD VDD sg13_lv_pmos ad=0.34p pd=2.68u as=0 ps=0 w=1u l=1u
X637 VSS.t1754 VDD VSS.t1756 VSS.t1755 sg13_lv_nmos ad=79.8f pd=0.8u as=0 ps=0 w=0.42u l=1u
X638 VDD VSS.t2821 VDD VDD sg13_lv_pmos ad=0.34p pd=2.68u as=0 ps=0 w=1u l=1u
X639 VSS.t973 VDD VSS.t975 VSS.t974 sg13_lv_nmos ad=79.8f pd=0.8u as=0 ps=0 w=0.42u l=1u
X640 VSS.t2867 VDD VSS.t2868 VSS.t392 sg13_lv_nmos ad=79.8f pd=0.8u as=0 ps=0 w=0.42u l=1u
X641 a_26565_13701# sg13g2_buf_16_2.X VSS.t155 VSS.t154 sg13_lv_nmos ad=0.2516p pd=2.16u as=15.10457p ps=99.59499u w=0.74u l=0.13u
X642 VDD VSS.t1293 VDD VDD sg13_lv_pmos ad=0.34p pd=2.68u as=0 ps=0 w=1u l=1u
X643 VDD VSS.t1394 VDD VDD sg13_lv_pmos ad=0.19p pd=1.38u as=0 ps=0 w=1u l=1u
X644 VDD VSS.t2894 VDD VDD sg13_lv_pmos ad=0.19p pd=1.38u as=0 ps=0 w=1u l=1u
X645 VDD VSS.t2203 VDD VDD sg13_lv_pmos ad=0.19p pd=1.38u as=0 ps=0 w=1u l=1u
X646 VDD VSS.t2557 VDD VDD sg13_lv_pmos ad=0.34p pd=2.68u as=0 ps=0 w=1u l=1u
X647 VSS.t2618 VDD VSS.t2617 VSS.t2616 sg13_lv_nmos ad=0.1428p pd=1.52u as=0 ps=0 w=0.42u l=1u
X648 VDD VSS.t2868 VDD VDD sg13_lv_pmos ad=0.34p pd=2.68u as=0 ps=0 w=1u l=1u
X649 VDD VSS.t224 VDD VDD sg13_lv_pmos ad=0.19p pd=1.38u as=0 ps=0 w=1u l=1u
X650 VDD VSS.t3122 VDD VDD sg13_lv_pmos ad=0.34p pd=2.68u as=0 ps=0 w=1u l=1u
X651 VSS.t405 sg13g2_buf_16_2.A a_19438_13726# VSS.t406 sg13_lv_nmos ad=0.1406p pd=1.12u as=0.1406p ps=1.12u w=0.74u l=0.13u
X652 VSS.t1784 VDD VSS.t1783 VSS.t1782 sg13_lv_nmos ad=0.1428p pd=1.52u as=0 ps=0 w=0.42u l=1u
X653 sg13g2_o21ai_1_3.Y sg13g2_or3_1_1.C a_24408_15552# VDD sg13_lv_pmos ad=0.2128p pd=1.5u as=0.2128p ps=1.5u w=1.12u l=0.15u
X654 a_27664_13942# a_27407_13799# a_27826_13722# VSS.t432 sg13_lv_nmos ad=0.1428p pd=1.52u as=37.8f ps=0.6u w=0.42u l=0.13u
X655 VDD VSS.t2073 VDD VDD sg13_lv_pmos ad=0.19p pd=1.38u as=0 ps=0 w=1u l=1u
X656 VDD VSS.t500 VDD VDD sg13_lv_pmos ad=0.34p pd=2.68u as=0 ps=0 w=1u l=1u
X657 VDD VSS.t1661 VDD VDD sg13_lv_pmos ad=0.19p pd=1.38u as=0 ps=0 w=1u l=1u
X658 VDD VSS.t1838 VDD VDD sg13_lv_pmos ad=0.34p pd=2.68u as=0 ps=0 w=1u l=1u
X659 a_17584_13942# sg13g2_dfrbpq_1_2.RESET_B VDD VDD sg13_lv_pmos ad=79.8f pd=0.8u as=2.42015p ps=15.68u w=0.42u l=0.13u
X660 VDD a_15022_14484# sg13g2_buf_16_2.A VDD sg13_lv_pmos ad=0.2128p pd=1.5u as=0.2128p ps=1.5u w=1.12u l=0.13u
X661 VDD VSS.t742 VDD VDD sg13_lv_pmos ad=0.34p pd=2.68u as=0 ps=0 w=1u l=1u
X662 VSS.t2458 VDD VSS.t2460 VSS.t2459 sg13_lv_nmos ad=79.8f pd=0.8u as=0 ps=0 w=0.42u l=1u
X663 VDD a_25786_15960# a_25505_16262# VDD sg13_lv_pmos ad=0.1523p pd=1.38u as=0.34p ps=2.68u w=1u l=0.5u
X664 VSS.t62 sg13g2_or3_1_2.B a_16079_15238# VSS.t369 sg13_lv_nmos ad=0.1898p pd=1.36u as=0.1406p ps=1.12u w=0.74u l=0.13u
X665 VSS.t1304 VDD VSS.t1305 VSS.t311 sg13_lv_nmos ad=79.8f pd=0.8u as=0 ps=0 w=0.42u l=1u
X666 VDD VSS.t2781 VDD VDD sg13_lv_pmos ad=0.19p pd=1.38u as=0 ps=0 w=1u l=1u
X667 VSS.t2413 VDD VSS.t2412 VSS.t2411 sg13_lv_nmos ad=0.1428p pd=1.52u as=0 ps=0 w=0.42u l=1u
X668 VSS.t1679 VDD VSS.t1678 VSS.t1677 sg13_lv_nmos ad=0.1428p pd=1.52u as=0 ps=0 w=0.42u l=1u
X669 VSS.t3203 VDD VSS.t3202 VSS.t3201 sg13_lv_nmos ad=0.1428p pd=1.52u as=0 ps=0 w=0.42u l=1u
X670 VDD VSS.t2440 VDD VDD sg13_lv_pmos ad=0.19p pd=1.38u as=0 ps=0 w=1u l=1u
X671 a_21466_15202# sg13g2_o21ai_1_1.Y VSS.t21 VSS.t161 sg13_lv_nmos ad=0.1428p pd=1.52u as=79.8f ps=0.8u w=0.42u l=0.13u
X672 VSS.t2754 VDD VSS.t393 VSS.t392 sg13_lv_nmos ad=0.1428p pd=1.52u as=0 ps=0 w=0.42u l=1u
X673 VDD VSS.t2886 VDD VDD sg13_lv_pmos ad=0.19p pd=1.38u as=0 ps=0 w=1u l=1u
X674 VDD VSS.t2223 VDD VDD sg13_lv_pmos ad=0.19p pd=1.38u as=0 ps=0 w=1u l=1u
X675 VDD VSS.t681 VDD VDD sg13_lv_pmos ad=0.34p pd=2.68u as=0 ps=0 w=1u l=1u
X676 a_3209_16334# a_3333_16033# VDD VDD sg13_lv_pmos ad=0.2442p pd=2.06u as=2.8961p ps=18.25u w=0.66u l=0.13u
X677 VDD VSS.t932 VDD VDD sg13_lv_pmos ad=0.34p pd=2.68u as=0 ps=0 w=1u l=1u
X678 VSS.t1358 VDD VSS.t1358 VSS.t311 sg13_lv_nmos ad=0.1428p pd=1.52u as=0 ps=0 w=0.42u l=1u
X679 VSS.t712 VDD VSS.t712 VSS.t720 sg13_lv_nmos ad=79.8f pd=0.8u as=0 ps=0 w=0.42u l=1u
X680 VDD VSS.t702 VDD VDD sg13_lv_pmos ad=0.34p pd=2.68u as=0 ps=0 w=1u l=1u
X681 VSS.t1769 VDD VSS.t1768 VSS.t1767 sg13_lv_nmos ad=0.1428p pd=1.52u as=0 ps=0 w=0.42u l=1u
X682 VSS.t1312 VDD VSS.t1313 VSS.t311 sg13_lv_nmos ad=79.8f pd=0.8u as=0 ps=0 w=0.42u l=1u
X683 VDD a_25094_14484# a_25206_14508# VDD sg13_lv_pmos ad=0.2254p pd=1.53u as=0.34p ps=2.68u w=1u l=0.5u
X684 VSS.t1744 VDD VSS.t1746 VSS.t1745 sg13_lv_nmos ad=79.8f pd=0.8u as=0 ps=0 w=0.42u l=1u
X685 VDD VSS.t2420 VDD VDD sg13_lv_pmos ad=0.19p pd=1.38u as=0 ps=0 w=1u l=1u
X686 VSS.t2638 VDD VSS.t2637 VSS.t2636 sg13_lv_nmos ad=0.1428p pd=1.52u as=0 ps=0 w=0.42u l=1u
X687 VSS.t1473 VDD VSS.t1317 VSS.t311 sg13_lv_nmos ad=79.8f pd=0.8u as=0 ps=0 w=0.42u l=1u
X688 VDD VSS.t2018 VDD VDD sg13_lv_pmos ad=0.19p pd=1.38u as=0 ps=0 w=1u l=1u
X689 VSS.t2136 VDD VSS.t2135 VSS.t2134 sg13_lv_nmos ad=0.1428p pd=1.52u as=0 ps=0 w=0.42u l=1u
X690 a_19054_15423# a_19169_15424# VDD VDD sg13_lv_pmos ad=0.34p pd=2.68u as=0.2254p ps=1.53u w=1u l=0.5u
X691 VSS.t1699 VDD VSS.t1698 VSS.t1697 sg13_lv_nmos ad=0.1428p pd=1.52u as=0 ps=0 w=0.42u l=1u
X692 VSS.t3223 VDD VSS.t3222 VSS.t3221 sg13_lv_nmos ad=0.1428p pd=1.52u as=0 ps=0 w=0.42u l=1u
X693 VDD VSS.t2849 VDD VDD sg13_lv_pmos ad=0.19p pd=1.38u as=0 ps=0 w=1u l=1u
X694 a_18377_16334# a_18501_16033# VDD VDD sg13_lv_pmos ad=0.2442p pd=2.06u as=2.8961p ps=18.25u w=0.66u l=0.13u
X695 VDD VSS.t580 VDD VDD sg13_lv_pmos ad=0.34p pd=2.68u as=0 ps=0 w=1u l=1u
X696 VSS.t973 VDD VSS.t975 VSS.t974 sg13_lv_nmos ad=79.8f pd=0.8u as=0 ps=0 w=0.42u l=1u
X697 VDD VSS.t1708 VDD VDD sg13_lv_pmos ad=0.34p pd=2.68u as=0 ps=0 w=1u l=1u
X698 VDD VSS.t2582 VDD VDD sg13_lv_pmos ad=0.34p pd=2.68u as=0 ps=0 w=1u l=1u
X699 VSS.t1739 VDD VSS.t1741 VSS.t1740 sg13_lv_nmos ad=79.8f pd=0.8u as=0 ps=0 w=0.42u l=1u
X700 VDD VSS.t584 VDD VDD sg13_lv_pmos ad=0.34p pd=2.68u as=0 ps=0 w=1u l=1u
X701 VSS.t2859 VDD VSS.t2860 VSS.t392 sg13_lv_nmos ad=79.8f pd=0.8u as=0 ps=0 w=0.42u l=1u
X702 VDD VSS.t2610 VDD VDD sg13_lv_pmos ad=0.19p pd=1.38u as=0 ps=0 w=1u l=1u
X703 VDD VSS.t2050 VDD VDD sg13_lv_pmos ad=0.34p pd=2.68u as=0 ps=0 w=1u l=1u
X704 VDD VSS.t3175 VDD VDD sg13_lv_pmos ad=0.19p pd=1.38u as=0 ps=0 w=1u l=1u
X705 VSS.t2443 VDD VSS.t2445 VSS.t2444 sg13_lv_nmos ad=79.8f pd=0.8u as=0 ps=0 w=0.42u l=1u
X706 VDD VSS.t2385 VDD VDD sg13_lv_pmos ad=0.19p pd=1.38u as=0 ps=0 w=1u l=1u
X707 a_9801_15625# a_9444_15552# VDD VDD sg13_lv_pmos ad=63f pd=0.72u as=0.1563p ps=1.22u w=0.42u l=0.13u
X708 VDD VSS.t224 VDD VDD sg13_lv_pmos ad=0.19p pd=1.38u as=0 ps=0 w=1u l=1u
X709 VDD VSS.t1087 VDD VDD sg13_lv_pmos ad=0.34p pd=2.68u as=0 ps=0 w=1u l=1u
X710 VSS.t2216 VDD VSS.t2218 VSS.t2217 sg13_lv_nmos ad=79.8f pd=0.8u as=0 ps=0 w=0.42u l=1u
X711 VSS.t702 VDD VSS.t702 VSS.t705 sg13_lv_nmos ad=0.1428p pd=1.52u as=0 ps=0 w=0.42u l=1u
X712 VDD VSS.t1330 VDD VDD sg13_lv_pmos ad=0.19p pd=1.38u as=0 ps=0 w=1u l=1u
X713 VDD VSS.t1357 VDD VDD sg13_lv_pmos ad=0.34p pd=2.68u as=0 ps=0 w=1u l=1u
X714 VDD VSS.t2860 VDD VDD sg13_lv_pmos ad=0.34p pd=2.68u as=0 ps=0 w=1u l=1u
X715 VSS.t1403 VDD VSS.t1404 VSS.t311 sg13_lv_nmos ad=79.8f pd=0.8u as=0 ps=0 w=0.42u l=1u
X716 VDD a_25094_15238# a_25206_15302# VDD sg13_lv_pmos ad=0.2254p pd=1.53u as=0.34p ps=2.68u w=1u l=0.5u
X717 VDD VSS.t1823 VDD VDD sg13_lv_pmos ad=0.34p pd=2.68u as=0 ps=0 w=1u l=1u
X718 VDD VSS.t2235 VDD VDD sg13_lv_pmos ad=0.34p pd=2.68u as=0 ps=0 w=1u l=1u
X719 VDD VSS.t2058 VDD VDD sg13_lv_pmos ad=0.19p pd=1.38u as=0 ps=0 w=1u l=1u
X720 VDD VSS.t590 VDD VDD sg13_lv_pmos ad=0.34p pd=2.68u as=0 ps=0 w=1u l=1u
X721 VSS.t1729 VDD VSS.t1731 VSS.t1730 sg13_lv_nmos ad=79.8f pd=0.8u as=0 ps=0 w=0.42u l=1u
X722 VSS.t3253 VDD VSS.t3255 VSS.t3254 sg13_lv_nmos ad=79.8f pd=0.8u as=0 ps=0 w=0.42u l=1u
X723 VSS.t2623 VDD VSS.t2622 VSS.t2621 sg13_lv_nmos ad=0.1428p pd=1.52u as=0 ps=0 w=0.42u l=1u
X724 VSS.t618 VDD VSS.t617 VSS.t9 sg13_lv_nmos ad=0.1428p pd=1.52u as=0 ps=0 w=0.42u l=1u
X725 VDD VSS.t303 VDD VDD sg13_lv_pmos ad=0.34p pd=2.68u as=0 ps=0 w=1u l=1u
X726 VDD VSS.t1688 VDD VDD sg13_lv_pmos ad=0.34p pd=2.68u as=0 ps=0 w=1u l=1u
X727 VDD a_21946_16237# sg13g2_dfrbpq_1_6.RESET_B VDD sg13_lv_pmos ad=2.8961p pd=18.25u as=0.3927p ps=2.99u w=1.155u l=0.13u
X728 VDD a_12020_15202# sg13g2_dfrbpq_1_2.CLK VDD sg13_lv_pmos ad=0.2128p pd=1.5u as=0.2128p ps=1.5u w=1.12u l=0.13u
X729 VSS.t3024 VDD VSS.t2905 VSS.t392 sg13_lv_nmos ad=79.8f pd=0.8u as=0 ps=0 w=0.42u l=1u
X730 VDD VSS.t1102 VDD VDD sg13_lv_pmos ad=0.34p pd=2.68u as=0 ps=0 w=1u l=1u
X731 VDD VSS.t2602 VDD VDD sg13_lv_pmos ad=0.34p pd=2.68u as=0 ps=0 w=1u l=1u
X732 a_17428_16020# sg13g2_dlygate4sd3_1_6.X VDD VDD sg13_lv_pmos ad=0.1575p pd=1.315u as=0.3822p ps=1.84u w=1u l=0.13u
X733 VDD VSS.t2824 VDD VDD sg13_lv_pmos ad=0.34p pd=2.68u as=0 ps=0 w=1u l=1u
X734 sg13g2_dfrbpq_1_2.CLK a_12020_15202# VSS.t188 VSS.t191 sg13_lv_nmos ad=0.1406p pd=1.12u as=0.1406p ps=1.12u w=0.74u l=0.13u
X735 VSS.t693 VDD VSS.t224 VSS.t695 sg13_lv_nmos ad=79.8f pd=0.8u as=0 ps=0 w=0.42u l=1u
X736 VDD VSS.t681 VDD VDD sg13_lv_pmos ad=0.34p pd=2.68u as=0 ps=0 w=1u l=1u
X737 VDD VSS.t1397 VDD VDD sg13_lv_pmos ad=0.19p pd=1.38u as=0 ps=0 w=1u l=1u
X738 VDD VSS.t2878 VDD VDD sg13_lv_pmos ad=0.19p pd=1.38u as=0 ps=0 w=1u l=1u
X739 VDD VSS.t2208 VDD VDD sg13_lv_pmos ad=0.19p pd=1.38u as=0 ps=0 w=1u l=1u
X740 VSS.t774 VDD VSS.t771 VSS.t773 sg13_lv_nmos ad=0.1428p pd=1.52u as=0 ps=0 w=0.42u l=1u
X741 VDD VSS.t2562 VDD VDD sg13_lv_pmos ad=0.34p pd=2.68u as=0 ps=0 w=1u l=1u
X742 VSS.t2588 VDD VSS.t2587 VSS.t2586 sg13_lv_nmos ad=0.1428p pd=1.52u as=0 ps=0 w=0.42u l=1u
X743 VSS.t224 a_6286_13911# sg13g2_dlygate4sd3_1_0.X VSS.t288 sg13_lv_nmos ad=0.1426p pd=1.16u as=0.2516p ps=2.16u w=0.74u l=0.13u
X744 VSS.t1385 VDD VSS.t1384 VSS.t311 sg13_lv_nmos ad=0.1428p pd=1.52u as=0 ps=0 w=0.42u l=1u
X745 VSS.t455 VDD VSS.t455 VSS.t458 sg13_lv_nmos ad=79.8f pd=0.8u as=0 ps=0 w=0.42u l=1u
X746 VSS.t491 VDD VSS.t493 VSS.t492 sg13_lv_nmos ad=79.8f pd=0.8u as=0 ps=0 w=0.42u l=1u
X747 VSS.t3083 VDD VSS.t3085 VSS.t3084 sg13_lv_nmos ad=79.8f pd=0.8u as=0 ps=0 w=0.42u l=1u
X748 VSS.t1754 VDD VSS.t1753 VSS.t1752 sg13_lv_nmos ad=0.1428p pd=1.52u as=0 ps=0 w=0.42u l=1u
X749 VSS.t2171 VDD VSS.t2170 VSS.t2169 sg13_lv_nmos ad=0.1428p pd=1.52u as=0 ps=0 w=0.42u l=1u
X750 VSS.t1378 VDD VSS.t1379 VSS.t311 sg13_lv_nmos ad=79.8f pd=0.8u as=0 ps=0 w=0.42u l=1u
X751 VDD VSS.t363 VDD VDD sg13_lv_pmos ad=0.34p pd=2.68u as=0 ps=0 w=1u l=1u
X752 a_26638_15423# a_26753_15424# VDD VDD sg13_lv_pmos ad=0.34p pd=2.68u as=0.2254p ps=1.53u w=1u l=0.5u
X753 VDD a_19438_13726# sg13g2_buf_16_2.X VDD sg13_lv_pmos ad=0.2128p pd=1.5u as=0.2128p ps=1.5u w=1.12u l=0.13u
X754 VDD VSS.t739 VDD VDD sg13_lv_pmos ad=0.19p pd=1.38u as=0 ps=0 w=1u l=1u
X755 VDD VSS.t925 VDD VDD sg13_lv_pmos ad=0.19p pd=1.38u as=0 ps=0 w=1u l=1u
X756 VDD VSS.t1721 VDD VDD sg13_lv_pmos ad=0.19p pd=1.38u as=0 ps=0 w=1u l=1u
X757 VDD VSS.t3187 VDD VDD sg13_lv_pmos ad=0.34p pd=2.68u as=0 ps=0 w=1u l=1u
X758 VDD VSS.t2397 VDD VDD sg13_lv_pmos ad=0.34p pd=2.68u as=0 ps=0 w=1u l=1u
X759 VSS.t733 VDD VSS.t733 VSS.t866 sg13_lv_nmos ad=0.1428p pd=1.52u as=0 ps=0 w=0.42u l=1u
X760 VDD a_26170_15202# a_25889_15424# VDD sg13_lv_pmos ad=0.1523p pd=1.38u as=0.34p ps=2.68u w=1u l=0.5u
X761 VDD VSS.t1362 VDD VDD sg13_lv_pmos ad=0.19p pd=1.38u as=0 ps=0 w=1u l=1u
X762 VSS.t1420 VDD VSS.t1420 VSS.t311 sg13_lv_nmos ad=79.8f pd=0.8u as=0 ps=0 w=0.42u l=1u
X763 VDD VSS.t2003 VDD VDD sg13_lv_pmos ad=0.19p pd=1.38u as=0 ps=0 w=1u l=1u
X764 VDD VSS.t2784 VDD VDD sg13_lv_pmos ad=0.19p pd=1.38u as=0 ps=0 w=1u l=1u
X765 VDD VSS.t2841 VDD VDD sg13_lv_pmos ad=0.19p pd=1.38u as=0 ps=0 w=1u l=1u
X766 VSS.t2418 VDD VSS.t2417 VSS.t2416 sg13_lv_nmos ad=0.1428p pd=1.52u as=0 ps=0 w=0.42u l=1u
X767 VSS.t2121 VDD VSS.t2120 VSS.t2119 sg13_lv_nmos ad=0.1428p pd=1.52u as=0 ps=0 w=0.42u l=1u
X768 VSS.t572 VDD VSS.t574 VSS.t573 sg13_lv_nmos ad=79.8f pd=0.8u as=0 ps=0 w=0.42u l=1u
X769 a_6789_14495# sg13g2_dfrbpq_1_2.CLK VSS.t9 VSS.t94 sg13_lv_nmos ad=0.2516p pd=2.16u as=5.01922p ps=33.275u w=0.74u l=0.13u
X770 VSS.t1684 VDD VSS.t1683 VSS.t1682 sg13_lv_nmos ad=0.1428p pd=1.52u as=0 ps=0 w=0.42u l=1u
X771 VSS.t3208 VDD VSS.t3207 VSS.t3206 sg13_lv_nmos ad=0.1428p pd=1.52u as=0 ps=0 w=0.42u l=1u
X772 VDD VSS.t1325 VDD VDD sg13_lv_pmos ad=0.34p pd=2.68u as=0 ps=0 w=1u l=1u
X773 VDD VSS.t78 VDD VDD sg13_lv_pmos ad=0.34p pd=2.68u as=0 ps=0 w=1u l=1u
X774 VDD VSS.t2595 VDD VDD sg13_lv_pmos ad=0.19p pd=1.38u as=0 ps=0 w=1u l=1u
X775 VSS.t2493 VDD VSS.t2492 VSS.t2491 sg13_lv_nmos ad=0.1428p pd=1.52u as=0 ps=0 w=0.42u l=1u
X776 VDD VSS.t1132 VDD VDD sg13_lv_pmos ad=0.34p pd=2.68u as=0 ps=0 w=1u l=1u
X777 VDD VSS.t1290 VDD VDD sg13_lv_pmos ad=0.19p pd=1.38u as=0 ps=0 w=1u l=1u
X778 VDD VSS.t1388 VDD VDD sg13_lv_pmos ad=0.19p pd=1.38u as=0 ps=0 w=1u l=1u
X779 VDD VSS.t2889 VDD VDD sg13_lv_pmos ad=0.19p pd=1.38u as=0 ps=0 w=1u l=1u
X780 VDD VSS.t2193 VDD VDD sg13_lv_pmos ad=0.19p pd=1.38u as=0 ps=0 w=1u l=1u
X781 VSS.t46 sg13g2_dlygate4sd3_1_17.A a_24824_14525# VSS.t25 sg13_lv_nmos ad=79.8f pd=0.8u as=0.1428p ps=1.52u w=0.42u l=0.13u
X782 VDD VSS.t940 VDD VDD sg13_lv_pmos ad=0.19p pd=1.38u as=0 ps=0 w=1u l=1u
X783 VSS.t2608 VDD VSS.t2607 VSS.t2606 sg13_lv_nmos ad=0.1428p pd=1.52u as=0 ps=0 w=0.42u l=1u
X784 VSS.t2428 VDD VSS.t2430 VSS.t2429 sg13_lv_nmos ad=79.8f pd=0.8u as=0 ps=0 w=0.42u l=1u
X785 VDD VSS.t2370 VDD VDD sg13_lv_pmos ad=0.19p pd=1.38u as=0 ps=0 w=1u l=1u
X786 sg13g2_dfrbpq_1_2.CLK a_12020_15202# VSS.t184 VSS.t186 sg13_lv_nmos ad=0.1406p pd=1.12u as=0.1406p ps=1.12u w=0.74u l=0.13u
X787 a_22576_14726# sg13g2_dfrbpq_1_6.RESET_B VDD VDD sg13_lv_pmos ad=79.8f pd=0.8u as=2.42015p ps=15.68u w=0.42u l=0.13u
X788 a_27609_14037# a_26667_13844# a_27407_13799# VDD sg13_lv_pmos ad=93.45f pd=0.865u as=0.2048p ps=1.63u w=0.42u l=0.13u
X789 VSS.t2902 VDD VSS.t2902 VSS.t392 sg13_lv_nmos ad=79.8f pd=0.8u as=0 ps=0 w=0.42u l=1u
X790 VSS.t9 a_26373_14495# a_26475_14495# VSS.t30 sg13_lv_nmos ad=5.4375p pd=36.05u as=0.2516p ps=2.16u w=0.74u l=0.13u
X791 VSS.t1774 VDD VSS.t1773 VSS.t1772 sg13_lv_nmos ad=0.1428p pd=1.52u as=0 ps=0 w=0.42u l=1u
X792 VDD VSS.t2465 VDD VDD sg13_lv_pmos ad=0.19p pd=1.38u as=0 ps=0 w=1u l=1u
X793 VDD VSS.t172 VDD VDD sg13_lv_pmos ad=0.34p pd=2.68u as=0 ps=0 w=1u l=1u
X794 VDD a_37484_15960# counter_value_o[7] VDD sg13_lv_pmos ad=0.2114p pd=1.54u as=0.42p ps=2.99u w=1.12u l=0.13u
X795 VDD sg13g2_dfrbpq_1_1.RESET_B a_6086_14922# VDD sg13_lv_pmos ad=0.36237p pd=2.605u as=79.8f ps=0.8u w=0.42u l=0.13u
X796 VSS.t1168 VDD VSS.t1167 VSS.t1166 sg13_lv_nmos ad=0.1428p pd=1.52u as=0 ps=0 w=0.42u l=1u
X797 VDD VSS.t1404 VDD VDD sg13_lv_pmos ad=0.34p pd=2.68u as=0 ps=0 w=1u l=1u
X798 VDD VSS.t2902 VDD VDD sg13_lv_pmos ad=0.34p pd=2.68u as=0 ps=0 w=1u l=1u
X799 VDD VSS.t2220 VDD VDD sg13_lv_pmos ad=0.34p pd=2.68u as=0 ps=0 w=1u l=1u
X800 a_20774_14922# a_21579_14495# a_21034_14452# VDD sg13_lv_pmos ad=0.1428p pd=1.52u as=79.8f ps=0.8u w=0.42u l=0.13u
X801 VDD a_19438_13726# sg13g2_buf_16_2.X VDD sg13_lv_pmos ad=0.2128p pd=1.5u as=0.2128p ps=1.5u w=1.12u l=0.13u
X802 VSS.t1563 VDD VSS.t1434 VSS.t311 sg13_lv_nmos ad=79.8f pd=0.8u as=0 ps=0 w=0.42u l=1u
X803 VDD VSS.t2248 VDD VDD sg13_lv_pmos ad=0.19p pd=1.38u as=0 ps=0 w=1u l=1u
X804 VSS.t2071 VDD VSS.t2073 VSS.t2072 sg13_lv_nmos ad=79.8f pd=0.8u as=0 ps=0 w=0.42u l=1u
X805 VDD VSS.t707 VDD VDD sg13_lv_pmos ad=0.19p pd=1.38u as=0 ps=0 w=1u l=1u
X806 VDD VSS.t728 VDD VDD sg13_lv_pmos ad=0.34p pd=2.68u as=0 ps=0 w=1u l=1u
X807 VDD VSS.t1673 VDD VDD sg13_lv_pmos ad=0.34p pd=2.68u as=0 ps=0 w=1u l=1u
X808 VDD VSS.t2023 VDD VDD sg13_lv_pmos ad=0.19p pd=1.38u as=0 ps=0 w=1u l=1u
X809 VSS.t612 VDD VSS.t611 VSS.t9 sg13_lv_nmos ad=0.1428p pd=1.52u as=0 ps=0 w=0.42u l=1u
X810 VSS.t2895 VDD VSS.t2896 VSS.t392 sg13_lv_nmos ad=79.8f pd=0.8u as=0 ps=0 w=0.42u l=1u
X811 VDD VSS.t2852 VDD VDD sg13_lv_pmos ad=0.19p pd=1.38u as=0 ps=0 w=1u l=1u
X812 sg13g2_dlygate4sd3_1_17.A sg13g2_a21oi_1_0.B1 VSS.t208 VSS.t207 sg13_lv_nmos ad=0.1406p pd=1.12u as=0.2516p ps=2.16u w=0.74u l=0.13u
X813 VDD VSS.t757 VDD VDD sg13_lv_pmos ad=0.19p pd=1.38u as=0 ps=0 w=1u l=1u
X814 VSS.t1356 VDD VSS.t1357 VSS.t311 sg13_lv_nmos ad=79.8f pd=0.8u as=0 ps=0 w=0.42u l=1u
X815 VDD VSS.t1678 VDD VDD sg13_lv_pmos ad=0.34p pd=2.68u as=0 ps=0 w=1u l=1u
X816 a_18106_15202# sg13g2_dlygate4sd3_1_5.A VSS.t45 VSS.t419 sg13_lv_nmos ad=0.1428p pd=1.52u as=79.8f ps=0.8u w=0.42u l=0.13u
X817 VDD VSS.t768 VDD VDD sg13_lv_pmos ad=0.19p pd=1.38u as=0 ps=0 w=1u l=1u
X818 VSS.t213 sg13g2_buf_1_0.X a_2490_14447# VSS.t259 sg13_lv_nmos ad=0.374p pd=2.46u as=0.17462p ps=1.185u w=0.55u l=0.13u
X819 VDD VSS.t2615 VDD VDD sg13_lv_pmos ad=0.19p pd=1.38u as=0 ps=0 w=1u l=1u
X820 VDD VSS.t1095 VDD VDD sg13_lv_pmos ad=0.19p pd=1.38u as=0 ps=0 w=1u l=1u
X821 VDD VSS.t2867 VDD VDD sg13_lv_pmos ad=0.34p pd=2.68u as=0 ps=0 w=1u l=1u
X822 VSS.t1804 VDD VSS.t1806 VSS.t1805 sg13_lv_nmos ad=79.8f pd=0.8u as=0 ps=0 w=0.42u l=1u
X823 VSS.t2221 VDD VSS.t2223 VSS.t2222 sg13_lv_nmos ad=79.8f pd=0.8u as=0 ps=0 w=0.42u l=1u
X824 VSS.t978 VDD VSS.t980 VSS.t979 sg13_lv_nmos ad=79.8f pd=0.8u as=0 ps=0 w=0.42u l=1u
X825 VSS.t2894 VDD VSS.t2895 VSS.t392 sg13_lv_nmos ad=79.8f pd=0.8u as=0 ps=0 w=0.42u l=1u
X826 VSS.t3068 VDD VSS.t3070 VSS.t3069 sg13_lv_nmos ad=79.8f pd=0.8u as=0 ps=0 w=0.42u l=1u
X827 a_2916_15552# a_3435_15356# a_4175_15311# VSS.t215 sg13_lv_nmos ad=0.3473p pd=2.71u as=0.12665p ps=1.145u w=0.74u l=0.13u
X828 VSS.t2106 VDD VSS.t2108 VSS.t2107 sg13_lv_nmos ad=79.8f pd=0.8u as=0 ps=0 w=0.42u l=1u
X829 VDD a_22030_15423# sg13g2_or3_1_2.A VDD sg13_lv_pmos ad=0.2254p pd=1.53u as=0.4256p ps=3u w=1.12u l=0.13u
X830 VDD VSS.t2799 VDD VDD sg13_lv_pmos ad=0.19p pd=1.38u as=0 ps=0 w=1u l=1u
X831 VSS.t2478 VDD VSS.t2477 VSS.t2476 sg13_lv_nmos ad=0.1428p pd=1.52u as=0 ps=0 w=0.42u l=1u
X832 VDD VSS.t2063 VDD VDD sg13_lv_pmos ad=0.19p pd=1.38u as=0 ps=0 w=1u l=1u
X833 VDD VSS.t777 VDD VDD sg13_lv_pmos ad=0.19p pd=1.38u as=0 ps=0 w=1u l=1u
X834 VDD VSS.t3172 VDD VDD sg13_lv_pmos ad=0.34p pd=2.68u as=0 ps=0 w=1u l=1u
X835 VDD VSS.t2382 VDD VDD sg13_lv_pmos ad=0.34p pd=2.68u as=0 ps=0 w=1u l=1u
X836 VSS.t1734 VDD VSS.t1736 VSS.t1735 sg13_lv_nmos ad=79.8f pd=0.8u as=0 ps=0 w=0.42u l=1u
X837 VSS.t3258 VDD VSS.t3260 VSS.t3259 sg13_lv_nmos ad=79.8f pd=0.8u as=0 ps=0 w=0.42u l=1u
X838 VDD a_19438_13726# sg13g2_buf_16_2.X VDD sg13_lv_pmos ad=0.2128p pd=1.5u as=0.2128p ps=1.5u w=1.12u l=0.13u
X839 VDD VSS.t2410 VDD VDD sg13_lv_pmos ad=0.19p pd=1.38u as=0 ps=0 w=1u l=1u
X840 a_7532_15960# sg13g2_dlygate4sd3_1_1.A VDD VDD sg13_lv_pmos ad=0.2856p pd=2.36u as=0.2114p ps=1.54u w=0.84u l=0.13u
X841 a_4175_15311# a_3333_15213# a_2916_15552# VDD sg13_lv_pmos ad=0.2048p pd=1.63u as=0.34p ps=2.68u w=1u l=0.13u
X842 VSS.t712 VDD VSS.t712 VSS.t720 sg13_lv_nmos ad=79.8f pd=0.8u as=0 ps=0 w=0.42u l=1u
X843 VSS.t1338 VDD VSS.t1337 VSS.t311 sg13_lv_nmos ad=0.1428p pd=1.52u as=0 ps=0 w=0.42u l=1u
X844 VDD VSS.t1746 VDD VDD sg13_lv_pmos ad=0.19p pd=1.38u as=0 ps=0 w=1u l=1u
X845 a_26182_14909# sg13g2_dfrbpq_1_7.RESET_B VSS.t5 VSS.t156 sg13_lv_nmos ad=37.8f pd=0.6u as=0.1701p ps=1.65u w=0.42u l=0.13u
X846 VSS.t1634 VDD VSS.t1636 VSS.t1635 sg13_lv_nmos ad=79.8f pd=0.8u as=0 ps=0 w=0.42u l=1u
X847 VSS.t2543 VDD VSS.t2545 VSS.t2544 sg13_lv_nmos ad=79.8f pd=0.8u as=0 ps=0 w=0.42u l=1u
X848 VSS.t2016 VDD VSS.t2018 VSS.t2017 sg13_lv_nmos ad=79.8f pd=0.8u as=0 ps=0 w=0.42u l=1u
X849 VDD VSS.t1062 VDD VDD sg13_lv_pmos ad=0.34p pd=2.68u as=0 ps=0 w=1u l=1u
X850 VSS.t90 VDD VSS.t550 VSS.t549 sg13_lv_nmos ad=0.1428p pd=1.52u as=0 ps=0 w=0.42u l=1u
X851 VDD VSS.t1379 VDD VDD sg13_lv_pmos ad=0.19p pd=1.38u as=0 ps=0 w=1u l=1u
X852 VDD VSS.t2035 VDD VDD sg13_lv_pmos ad=0.34p pd=2.68u as=0 ps=0 w=1u l=1u
X853 VDD VSS.t2881 VDD VDD sg13_lv_pmos ad=0.19p pd=1.38u as=0 ps=0 w=1u l=1u
X854 VSS.t933 VDD VSS.t932 VSS.t931 sg13_lv_nmos ad=0.1428p pd=1.52u as=0 ps=0 w=0.42u l=1u
X855 VSS.t2826 VDD VSS.t2827 VSS.t392 sg13_lv_nmos ad=79.8f pd=0.8u as=0 ps=0 w=0.42u l=1u
X856 VDD VSS.t2859 VDD VDD sg13_lv_pmos ad=0.34p pd=2.68u as=0 ps=0 w=1u l=1u
X857 VSS.t2593 VDD VSS.t2592 VSS.t2591 sg13_lv_nmos ad=0.1428p pd=1.52u as=0 ps=0 w=0.42u l=1u
X858 a_17318_14922# a_18123_14495# a_17578_14452# VDD sg13_lv_pmos ad=0.1428p pd=1.52u as=79.8f ps=0.8u w=0.42u l=0.13u
X859 VSS.t615 VDD VSS.t616 VSS.t9 sg13_lv_nmos ad=79.8f pd=0.8u as=0 ps=0 w=0.42u l=1u
X860 VSS.t3055 VDD VSS.t3053 VSS.t3054 sg13_lv_nmos ad=79.8f pd=0.8u as=0 ps=0 w=0.42u l=1u
X861 VSS.t1168 VDD VSS.t1167 VSS.t1166 sg13_lv_nmos ad=0.1428p pd=1.52u as=0 ps=0 w=0.42u l=1u
X862 VSS.t1759 VDD VSS.t1758 VSS.t1757 sg13_lv_nmos ad=0.1428p pd=1.52u as=0 ps=0 w=0.42u l=1u
X863 VDD VSS.t1125 VDD VDD sg13_lv_pmos ad=0.19p pd=1.38u as=0 ps=0 w=1u l=1u
X864 VSS.t2870 VDD VSS.t2869 VSS.t392 sg13_lv_nmos ad=0.1428p pd=1.52u as=0 ps=0 w=0.42u l=1u
X865 VDD VSS.t2627 VDD VDD sg13_lv_pmos ad=0.34p pd=2.68u as=0 ps=0 w=1u l=1u
X866 VDD VSS.t2450 VDD VDD sg13_lv_pmos ad=0.19p pd=1.38u as=0 ps=0 w=1u l=1u
X867 VDD VSS.t707 VDD VDD sg13_lv_pmos ad=0.19p pd=1.38u as=0 ps=0 w=1u l=1u
X868 VDD VSS.t1726 VDD VDD sg13_lv_pmos ad=0.19p pd=1.38u as=0 ps=0 w=1u l=1u
X869 VDD VSS.t3192 VDD VDD sg13_lv_pmos ad=0.34p pd=2.68u as=0 ps=0 w=1u l=1u
X870 VDD VSS.t2402 VDD VDD sg13_lv_pmos ad=0.34p pd=2.68u as=0 ps=0 w=1u l=1u
X871 VSS.t702 VDD VSS.t702 VSS.t705 sg13_lv_nmos ad=0.1428p pd=1.52u as=0 ps=0 w=0.42u l=1u
X872 VDD VSS.t2575 VDD VDD sg13_lv_pmos ad=0.19p pd=1.38u as=0 ps=0 w=1u l=1u
X873 VSS.t2236 VDD VSS.t2235 VSS.t2234 sg13_lv_nmos ad=0.1428p pd=1.52u as=0 ps=0 w=0.42u l=1u
X874 VSS.t2056 VDD VSS.t2058 VSS.t2057 sg13_lv_nmos ad=79.8f pd=0.8u as=0 ps=0 w=0.42u l=1u
X875 VSS.t1314 VDD VSS.t1315 VSS.t311 sg13_lv_nmos ad=79.8f pd=0.8u as=0 ps=0 w=0.42u l=1u
X876 VDD VSS.t2233 VDD VDD sg13_lv_pmos ad=0.19p pd=1.38u as=0 ps=0 w=1u l=1u
X877 VSS.t1352 VDD VSS.t1351 VSS.t311 sg13_lv_nmos ad=0.1428p pd=1.52u as=0 ps=0 w=0.42u l=1u
X878 VDD VSS.t1731 VDD VDD sg13_lv_pmos ad=0.19p pd=1.38u as=0 ps=0 w=1u l=1u
X879 a_4175_15311# a_3333_15213# a_4081_15311# VSS.t251 sg13_lv_nmos ad=0.12665p pd=1.145u as=0.1428p ps=1.52u w=0.42u l=0.13u
X880 VDD VSS.t1441 VDD VDD sg13_lv_pmos ad=0.34p pd=2.68u as=0 ps=0 w=1u l=1u
X881 VDD VSS.t2008 VDD VDD sg13_lv_pmos ad=0.19p pd=1.38u as=0 ps=0 w=1u l=1u
X882 VDD VSS.t2787 VDD VDD sg13_lv_pmos ad=0.19p pd=1.38u as=0 ps=0 w=1u l=1u
X883 VDD VSS.t2844 VDD VDD sg13_lv_pmos ad=0.19p pd=1.38u as=0 ps=0 w=1u l=1u
X884 VSS.t2423 VDD VSS.t2422 VSS.t2421 sg13_lv_nmos ad=0.1428p pd=1.52u as=0 ps=0 w=0.42u l=1u
X885 VSS.t1689 VDD VSS.t1688 VSS.t1687 sg13_lv_nmos ad=0.1428p pd=1.52u as=0 ps=0 w=0.42u l=1u
X886 VSS.t3213 VDD VSS.t3212 VSS.t3211 sg13_lv_nmos ad=0.1428p pd=1.52u as=0 ps=0 w=0.42u l=1u
X887 VSS.t347 a_16556_15960# sg13g2_or3_1_2.B VSS.t346 sg13_lv_nmos ad=0.14875p pd=1.16u as=0.2886p ps=2.26u w=0.74u l=0.13u
X888 VSS.t742 VDD VSS.t742 VSS.t743 sg13_lv_nmos ad=79.8f pd=0.8u as=0 ps=0 w=0.42u l=1u
X889 VDD VSS.t2600 VDD VDD sg13_lv_pmos ad=0.19p pd=1.38u as=0 ps=0 w=1u l=1u
X890 VSS.t2463 VDD VSS.t2462 VSS.t2461 sg13_lv_nmos ad=0.1428p pd=1.52u as=0 ps=0 w=0.42u l=1u
X891 VSS.t39 a_7888_14726# a_7537_14845# VSS.t181 sg13_lv_nmos ad=79.8f pd=0.8u as=0.1428p ps=1.52u w=0.42u l=0.13u
X892 VSS.t1088 VDD VSS.t1087 VSS.t1086 sg13_lv_nmos ad=0.1428p pd=1.52u as=0 ps=0 w=0.42u l=1u
X893 VSS.t978 VDD VSS.t980 VSS.t979 sg13_lv_nmos ad=79.8f pd=0.8u as=0 ps=0 w=0.42u l=1u
X894 VDD VSS.t952 VDD VDD sg13_lv_pmos ad=0.34p pd=2.68u as=0 ps=0 w=1u l=1u
X895 VSS.t2818 VDD VSS.t2819 VSS.t392 sg13_lv_nmos ad=79.8f pd=0.8u as=0 ps=0 w=0.42u l=1u
X896 VSS.t597 VDD VSS.t596 VSS.t9 sg13_lv_nmos ad=0.1428p pd=1.52u as=0 ps=0 w=0.42u l=1u
X897 VSS.t2206 VDD VSS.t2208 VSS.t2207 sg13_lv_nmos ad=79.8f pd=0.8u as=0 ps=0 w=0.42u l=1u
X898 VSS.t2886 VDD VSS.t2887 VSS.t392 sg13_lv_nmos ad=79.8f pd=0.8u as=0 ps=0 w=0.42u l=1u
X899 VDD VSS.t553 VDD VDD sg13_lv_pmos ad=0.19p pd=1.38u as=0 ps=0 w=1u l=1u
X900 a_27826_13722# sg13g2_dfrbpq_1_5.RESET_B VSS.t176 VSS.t175 sg13_lv_nmos ad=37.8f pd=0.6u as=79.8f ps=0.8u w=0.42u l=0.13u
X901 VSS.t693 VDD VSS.t224 VSS.t695 sg13_lv_nmos ad=79.8f pd=0.8u as=0 ps=0 w=0.42u l=1u
X902 VDD VSS.t1407 VDD VDD sg13_lv_pmos ad=0.34p pd=2.68u as=0 ps=0 w=1u l=1u
X903 VDD VSS.t2887 VDD VDD sg13_lv_pmos ad=0.34p pd=2.68u as=0 ps=0 w=1u l=1u
X904 VDD VSS.t2225 VDD VDD sg13_lv_pmos ad=0.34p pd=2.68u as=0 ps=0 w=1u l=1u
X905 VDD VSS.t513 VDD VDD sg13_lv_pmos ad=0.19p pd=1.38u as=0 ps=0 w=1u l=1u
X906 VSS.t1298 VDD VSS.t1297 VSS.t311 sg13_lv_nmos ad=0.1428p pd=1.52u as=0 ps=0 w=0.42u l=1u
X907 VSS.t2076 VDD VSS.t2078 VSS.t2077 sg13_lv_nmos ad=79.8f pd=0.8u as=0 ps=0 w=0.42u l=1u
X908 VDD VSS.t1015 VDD VDD sg13_lv_pmos ad=0.19p pd=1.38u as=0 ps=0 w=1u l=1u
X909 VSS.t1103 VDD VSS.t1102 VSS.t1101 sg13_lv_nmos ad=0.1428p pd=1.52u as=0 ps=0 w=0.42u l=1u
X910 VSS.t1719 VDD VSS.t1721 VSS.t1720 sg13_lv_nmos ad=79.8f pd=0.8u as=0 ps=0 w=0.42u l=1u
X911 VSS.t3243 VDD VSS.t3245 VSS.t3244 sg13_lv_nmos ad=79.8f pd=0.8u as=0 ps=0 w=0.42u l=1u
X912 VDD VSS.t2395 VDD VDD sg13_lv_pmos ad=0.19p pd=1.38u as=0 ps=0 w=1u l=1u
X913 sg13g2_a21oi_1_3.A1 a_25206_15302# VSS.t55 VSS.t24 sg13_lv_nmos ad=0.2516p pd=2.16u as=0.1426p ps=1.16u w=0.74u l=0.13u
X914 VDD VSS.t2778 VDD VDD sg13_lv_pmos ad=0.19p pd=1.38u as=0 ps=0 w=1u l=1u
X915 VSS.t2111 VDD VSS.t2110 VSS.t2109 sg13_lv_nmos ad=0.1428p pd=1.52u as=0 ps=0 w=0.42u l=1u
X916 VSS.t3198 VDD VSS.t3197 VSS.t3196 sg13_lv_nmos ad=0.1428p pd=1.52u as=0 ps=0 w=0.42u l=1u
X917 VSS.t2408 VDD VSS.t2407 VSS.t2406 sg13_lv_nmos ad=0.1428p pd=1.52u as=0 ps=0 w=0.42u l=1u
X918 VSS.t1619 VDD VSS.t1621 VSS.t1620 sg13_lv_nmos ad=79.8f pd=0.8u as=0 ps=0 w=0.42u l=1u
X919 VDD VSS.t1683 VDD VDD sg13_lv_pmos ad=0.34p pd=2.68u as=0 ps=0 w=1u l=1u
X920 VSS.t2528 VDD VSS.t2530 VSS.t2529 sg13_lv_nmos ad=79.8f pd=0.8u as=0 ps=0 w=0.42u l=1u
X921 a_6729_14531# a_6372_14488# VDD VDD sg13_lv_pmos ad=63f pd=0.72u as=0.1563p ps=1.22u w=0.42u l=0.13u
X922 VDD VSS.t1738 VDD VDD sg13_lv_pmos ad=0.34p pd=2.68u as=0 ps=0 w=1u l=1u
X923 VSS.t28 a_27034_15202# a_26753_15424# VSS.t418 sg13_lv_nmos ad=79.8f pd=0.8u as=0.1428p ps=1.52u w=0.42u l=0.5u
X924 VSS.t933 VDD VSS.t932 VSS.t931 sg13_lv_nmos ad=0.1428p pd=1.52u as=0 ps=0 w=0.42u l=1u
X925 VDD VSS.t2585 VDD VDD sg13_lv_pmos ad=0.19p pd=1.38u as=0 ps=0 w=1u l=1u
X926 VSS.t2483 VDD VSS.t2482 VSS.t2481 sg13_lv_nmos ad=0.1428p pd=1.52u as=0 ps=0 w=0.42u l=1u
X927 VDD VSS.t1107 VDD VDD sg13_lv_pmos ad=0.34p pd=2.68u as=0 ps=0 w=1u l=1u
X928 VSS.t712 VDD VSS.t712 VSS.t715 sg13_lv_nmos ad=0.1428p pd=1.52u as=0 ps=0 w=0.42u l=1u
X929 VDD VSS.t1045 VDD VDD sg13_lv_pmos ad=0.19p pd=1.38u as=0 ps=0 w=1u l=1u
X930 VDD VSS.t1342 VDD VDD sg13_lv_pmos ad=0.19p pd=1.38u as=0 ps=0 w=1u l=1u
X931 VSS.t1809 VDD VSS.t1811 VSS.t1810 sg13_lv_nmos ad=79.8f pd=0.8u as=0 ps=0 w=0.42u l=1u
X932 VDD VSS.t2020 VDD VDD sg13_lv_pmos ad=0.34p pd=2.68u as=0 ps=0 w=1u l=1u
X933 VDD VSS.t2851 VDD VDD sg13_lv_pmos ad=0.34p pd=2.68u as=0 ps=0 w=1u l=1u
X934 VSS.t2191 VDD VSS.t2193 VSS.t2192 sg13_lv_nmos ad=79.8f pd=0.8u as=0 ps=0 w=0.42u l=1u
X935 VSS.t3038 VDD VSS.t3040 VSS.t3039 sg13_lv_nmos ad=79.8f pd=0.8u as=0 ps=0 w=0.42u l=1u
X936 a_37484_15960# sg13g2_dfrbpq_1_5.Q VSS.t245 VSS.t244 sg13_lv_nmos ad=0.187p pd=1.78u as=0.14875p ps=1.16u w=0.55u l=0.13u
X937 VDD VSS.t1426 VDD VDD sg13_lv_pmos ad=0.19p pd=1.38u as=0 ps=0 w=1u l=1u
X938 VDD VSS.t2612 VDD VDD sg13_lv_pmos ad=0.34p pd=2.68u as=0 ps=0 w=1u l=1u
X939 VDD a_26170_16237# sg13g2_dfrbpq_1_7.RESET_B VDD sg13_lv_pmos ad=2.8961p pd=18.25u as=0.3927p ps=2.99u w=1.155u l=0.13u
X940 VSS.t1388 VDD VSS.t1387 VSS.t311 sg13_lv_nmos ad=0.1428p pd=1.52u as=0 ps=0 w=0.42u l=1u
X941 VSS.t1467 VDD VSS.t1311 VSS.t311 sg13_lv_nmos ad=0.1428p pd=1.52u as=0 ps=0 w=0.42u l=1u
X942 VDD VSS.t2802 VDD VDD sg13_lv_pmos ad=0.19p pd=1.38u as=0 ps=0 w=1u l=1u
X943 VDD sg13g2_tiehi_1.L_HI a_9158_15234# VDD sg13_lv_pmos ad=0.36237p pd=2.605u as=79.8f ps=0.8u w=0.42u l=0.13u
X944 sg13g2_and2_1_0.X a_1965_14832# VSS.t7 VSS.t6 sg13_lv_nmos ad=0.2516p pd=2.16u as=0.1331p ps=1.12u w=0.74u l=0.13u
X945 VDD VSS.t982 VDD VDD sg13_lv_pmos ad=0.34p pd=2.68u as=0 ps=0 w=1u l=1u
X946 VDD VSS.t3177 VDD VDD sg13_lv_pmos ad=0.34p pd=2.68u as=0 ps=0 w=1u l=1u
X947 VSS.t2448 VDD VSS.t2447 VSS.t2446 sg13_lv_nmos ad=0.1428p pd=1.52u as=0 ps=0 w=0.42u l=1u
X948 VDD VSS.t2387 VDD VDD sg13_lv_pmos ad=0.34p pd=2.68u as=0 ps=0 w=1u l=1u
X949 VSS.t2221 VDD VSS.t2220 VSS.t2219 sg13_lv_nmos ad=0.1428p pd=1.52u as=0 ps=0 w=0.42u l=1u
X950 a_27898_15202# sg13g2_dfrbpq_1_5.Q VSS.t246 VSS.t9 sg13_lv_nmos ad=0.1428p pd=1.52u as=79.8f ps=0.8u w=0.42u l=0.13u
X951 VDD VSS.t2415 VDD VDD sg13_lv_pmos ad=0.19p pd=1.38u as=0 ps=0 w=1u l=1u
X952 a_17030_15238# a_16760_15238# VDD VDD sg13_lv_pmos ad=0.34p pd=2.68u as=0.1523p ps=1.38u w=1u l=0.5u
X953 a_26633_16334# a_26757_16033# VDD VDD sg13_lv_pmos ad=0.2442p pd=2.06u as=2.8961p ps=18.25u w=0.66u l=0.13u
X954 VSS.t1604 VDD VSS.t1606 VSS.t1605 sg13_lv_nmos ad=79.8f pd=0.8u as=0 ps=0 w=0.42u l=1u
X955 VSS.t2513 VDD VSS.t2515 VSS.t2514 sg13_lv_nmos ad=79.8f pd=0.8u as=0 ps=0 w=0.42u l=1u
X956 VSS.t2021 VDD VSS.t2023 VSS.t2022 sg13_lv_nmos ad=79.8f pd=0.8u as=0 ps=0 w=0.42u l=1u
X957 a_18863_14845# a_18021_14495# a_18769_14845# VSS.t76 sg13_lv_nmos ad=0.12665p pd=1.145u as=0.1428p ps=1.52u w=0.42u l=0.13u
X958 VSS.t1088 VDD VSS.t1087 VSS.t1086 sg13_lv_nmos ad=0.1428p pd=1.52u as=0 ps=0 w=0.42u l=1u
X959 VDD VSS.t2577 VDD VDD sg13_lv_pmos ad=0.34p pd=2.68u as=0 ps=0 w=1u l=1u
X960 VDD VSS.t2088 VDD VDD sg13_lv_pmos ad=0.19p pd=1.38u as=0 ps=0 w=1u l=1u
X961 a_3204_15247# a_2916_15552# a_3142_15247# VSS.t252 sg13_lv_nmos ad=0.1428p pd=1.52u as=37.8f ps=0.6u w=0.42u l=0.13u
X962 VDD VSS.t723 VDD VDD sg13_lv_pmos ad=0.34p pd=2.68u as=0 ps=0 w=1u l=1u
X963 VSS.t1133 VDD VSS.t1132 VSS.t1131 sg13_lv_nmos ad=0.1428p pd=1.52u as=0 ps=0 w=0.42u l=1u
X964 VSS.t1397 VDD VSS.t1396 VSS.t311 sg13_lv_nmos ad=0.1428p pd=1.52u as=0 ps=0 w=0.42u l=1u
X965 a_10960_15454# sg13g2_tiehi_1.L_HI VDD VDD sg13_lv_pmos ad=79.8f pd=0.8u as=2.8961p ps=18.25u w=0.42u l=0.13u
X966 VSS.t1971 VDD VSS.t1973 VSS.t1972 sg13_lv_nmos ad=79.8f pd=0.8u as=0 ps=0 w=0.42u l=1u
X967 VSS.t3058 VDD VSS.t3060 VSS.t3059 sg13_lv_nmos ad=79.8f pd=0.8u as=0 ps=0 w=0.42u l=1u
X968 sg13g2_nand4_1_0.Y sg13g2_dlygate4sd3_1_8.X a_7262_15242# VSS.t125 sg13_lv_nmos ad=0.2516p pd=2.16u as=0.1406p ps=1.12u w=0.74u l=0.13u
X969 VSS.t1764 VDD VSS.t1763 VSS.t1762 sg13_lv_nmos ad=0.1428p pd=1.52u as=0 ps=0 w=0.42u l=1u
X970 VDD VSS.t945 VDD VDD sg13_lv_pmos ad=0.19p pd=1.38u as=0 ps=0 w=1u l=1u
X971 VDD VSS.t2455 VDD VDD sg13_lv_pmos ad=0.19p pd=1.38u as=0 ps=0 w=1u l=1u
X972 VDD VSS.t745 VDD VDD sg13_lv_pmos ad=0.19p pd=1.38u as=0 ps=0 w=1u l=1u
X973 VSS.t1103 VDD VSS.t1102 VSS.t1101 sg13_lv_nmos ad=0.1428p pd=1.52u as=0 ps=0 w=0.42u l=1u
X974 VSS.t1432 VDD VSS.t1433 VSS.t311 sg13_lv_nmos ad=79.8f pd=0.8u as=0 ps=0 w=0.42u l=1u
X975 VDD VSS.t1398 VDD VDD sg13_lv_pmos ad=0.34p pd=2.68u as=0 ps=0 w=1u l=1u
X976 VDD VSS.t2372 VDD VDD sg13_lv_pmos ad=0.34p pd=2.68u as=0 ps=0 w=1u l=1u
X977 VDD VSS.t36 VDD VDD sg13_lv_pmos ad=0.19p pd=1.38u as=0 ps=0 w=1u l=1u
X978 VSS.t2241 VDD VSS.t2240 VSS.t2239 sg13_lv_nmos ad=0.1428p pd=1.52u as=0 ps=0 w=0.42u l=1u
X979 VSS.t2061 VDD VSS.t2063 VSS.t2062 sg13_lv_nmos ad=79.8f pd=0.8u as=0 ps=0 w=0.42u l=1u
X980 VDD VSS.t2238 VDD VDD sg13_lv_pmos ad=0.19p pd=1.38u as=0 ps=0 w=1u l=1u
X981 VDD VSS.t2769 VDD VDD sg13_lv_pmos ad=0.19p pd=1.38u as=0 ps=0 w=1u l=1u
X982 VDD VSS.t623 VDD VDD sg13_lv_pmos ad=0.34p pd=2.68u as=0 ps=0 w=1u l=1u
X983 VSS.t3183 VDD VSS.t3182 VSS.t3181 sg13_lv_nmos ad=0.1428p pd=1.52u as=0 ps=0 w=0.42u l=1u
X984 VSS.t2393 VDD VSS.t2392 VSS.t2391 sg13_lv_nmos ad=0.1428p pd=1.52u as=0 ps=0 w=0.42u l=1u
X985 VDD VSS.t1302 VDD VDD sg13_lv_pmos ad=0.19p pd=1.38u as=0 ps=0 w=1u l=1u
X986 VSS.t450 VDD VSS.t449 VSS.t448 sg13_lv_nmos ad=0.1428p pd=1.52u as=0 ps=0 w=0.42u l=1u
X987 VDD VSS.t1152 VDD VDD sg13_lv_pmos ad=0.34p pd=2.68u as=0 ps=0 w=1u l=1u
X988 VDD VSS.t1723 VDD VDD sg13_lv_pmos ad=0.34p pd=2.68u as=0 ps=0 w=1u l=1u
X989 VSS.t3098 VDD VSS.t3100 VSS.t3099 sg13_lv_nmos ad=79.8f pd=0.8u as=0 ps=0 w=0.42u l=1u
X990 VDD VSS.t2879 VDD VDD sg13_lv_pmos ad=0.19p pd=1.38u as=0 ps=0 w=1u l=1u
X991 VSS.t2468 VDD VSS.t2467 VSS.t2466 sg13_lv_nmos ad=0.1428p pd=1.52u as=0 ps=0 w=0.42u l=1u
X992 VSS.t2191 VDD VSS.t2190 VSS.t2189 sg13_lv_nmos ad=0.1428p pd=1.52u as=0 ps=0 w=0.42u l=1u
X993 VDD VSS.t2427 VDD VDD sg13_lv_pmos ad=0.34p pd=2.68u as=0 ps=0 w=1u l=1u
X994 VSS.t2821 VDD VSS.t2822 VSS.t392 sg13_lv_nmos ad=79.8f pd=0.8u as=0 ps=0 w=0.42u l=1u
X995 VDD VSS.t584 VDD VDD sg13_lv_pmos ad=0.34p pd=2.68u as=0 ps=0 w=1u l=1u
X996 VDD VSS.t766 VDD VDD sg13_lv_pmos ad=0.34p pd=2.68u as=0 ps=0 w=1u l=1u
X997 VSS.t1794 VDD VSS.t1796 VSS.t1795 sg13_lv_nmos ad=79.8f pd=0.8u as=0 ps=0 w=0.42u l=1u
X998 VDD VSS.t3165 VDD VDD sg13_lv_pmos ad=0.19p pd=1.38u as=0 ps=0 w=1u l=1u
X999 VSS.t2889 VDD VSS.t2889 VSS.t392 sg13_lv_nmos ad=79.8f pd=0.8u as=0 ps=0 w=0.42u l=1u
X1000 VDD VSS.t2033 VDD VDD sg13_lv_pmos ad=0.19p pd=1.38u as=0 ps=0 w=1u l=1u
X1001 VSS.t2036 VDD VSS.t2035 VSS.t2034 sg13_lv_nmos ad=0.1428p pd=1.52u as=0 ps=0 w=0.42u l=1u
X1002 VSS.t9 a_3333_15213# a_3435_15356# VSS.t250 sg13_lv_nmos ad=5.4375p pd=36.05u as=0.2516p ps=2.16u w=0.74u l=0.13u
X1003 VDD VSS.t349 VDD VDD sg13_lv_pmos ad=0.34p pd=2.68u as=0 ps=0 w=1u l=1u
X1004 VDD VSS.t912 VDD VDD sg13_lv_pmos ad=0.34p pd=2.68u as=0 ps=0 w=1u l=1u
X1005 VSS.t1749 VDD VSS.t1748 VSS.t1747 sg13_lv_nmos ad=0.1428p pd=1.52u as=0 ps=0 w=0.42u l=1u
X1006 VSS.t1414 VDD VSS.t1413 VSS.t311 sg13_lv_nmos ad=0.1428p pd=1.52u as=0 ps=0 w=0.42u l=1u
X1007 VSS.t1444 VDD VSS.t1445 VSS.t311 sg13_lv_nmos ad=79.8f pd=0.8u as=0 ps=0 w=0.42u l=1u
X1008 VDD VSS.t1389 VDD VDD sg13_lv_pmos ad=0.34p pd=2.68u as=0 ps=0 w=1u l=1u
X1009 VDD VSS.t2889 VDD VDD sg13_lv_pmos ad=0.34p pd=2.68u as=0 ps=0 w=1u l=1u
X1010 VDD VSS.t2195 VDD VDD sg13_lv_pmos ad=0.34p pd=2.68u as=0 ps=0 w=1u l=1u
X1011 VSS.t188 VDD VSS.t188 VSS.t644 sg13_lv_nmos ad=0.1428p pd=1.52u as=0 ps=0 w=0.42u l=1u
X1012 VSS.t1724 VDD VSS.t1726 VSS.t1725 sg13_lv_nmos ad=79.8f pd=0.8u as=0 ps=0 w=0.42u l=1u
X1013 VDD VSS.t2400 VDD VDD sg13_lv_pmos ad=0.19p pd=1.38u as=0 ps=0 w=1u l=1u
X1014 VDD VSS.t965 VDD VDD sg13_lv_pmos ad=0.19p pd=1.38u as=0 ps=0 w=1u l=1u
X1015 VSS.t1367 VDD VSS.t1368 VSS.t311 sg13_lv_nmos ad=79.8f pd=0.8u as=0 ps=0 w=0.42u l=1u
X1016 a_2890_15457# a_3333_15213# a_3273_15625# VDD sg13_lv_pmos ad=79.8f pd=0.8u as=63f ps=0.72u w=0.42u l=0.13u
X1017 VDD VSS.t771 VDD VDD sg13_lv_pmos ad=0.19p pd=1.38u as=0 ps=0 w=1u l=1u
X1018 VSS.t1133 VDD VSS.t1132 VSS.t1131 sg13_lv_nmos ad=0.1428p pd=1.52u as=0 ps=0 w=0.42u l=1u
X1019 VDD VSS.t1392 VDD VDD sg13_lv_pmos ad=0.19p pd=1.38u as=0 ps=0 w=1u l=1u
X1020 VSS.t1589 VDD VSS.t1591 VSS.t1590 sg13_lv_nmos ad=79.8f pd=0.8u as=0 ps=0 w=0.42u l=1u
X1021 VDD VSS.t1688 VDD VDD sg13_lv_pmos ad=0.34p pd=2.68u as=0 ps=0 w=1u l=1u
X1022 VSS.t2006 VDD VSS.t2008 VSS.t2007 sg13_lv_nmos ad=79.8f pd=0.8u as=0 ps=0 w=0.42u l=1u
X1023 VDD VSS.t1743 VDD VDD sg13_lv_pmos ad=0.34p pd=2.68u as=0 ps=0 w=1u l=1u
X1024 VSS.t1295 VDD VSS.t1296 VSS.t311 sg13_lv_nmos ad=79.8f pd=0.8u as=0 ps=0 w=0.42u l=1u
X1025 VDD VSS.t2025 VDD VDD sg13_lv_pmos ad=0.34p pd=2.68u as=0 ps=0 w=1u l=1u
X1026 VDD VSS.t2853 VDD VDD sg13_lv_pmos ad=0.34p pd=2.68u as=0 ps=0 w=1u l=1u
X1027 sg13g2_dfrbpq_1_2.CLK a_12020_15202# VDD VDD sg13_lv_pmos ad=0.2128p pd=1.5u as=0.2128p ps=1.5u w=1.12u l=0.13u
X1028 VDD VSS.t466 VDD VDD sg13_lv_pmos ad=0.19p pd=1.38u as=0 ps=0 w=1u l=1u
X1029 VSS.t481 VDD VSS.t481 VSS.t483 sg13_lv_nmos ad=0.1428p pd=1.52u as=0 ps=0 w=0.42u l=1u
X1030 VSS.t3043 VDD VSS.t3045 VSS.t3044 sg13_lv_nmos ad=79.8f pd=0.8u as=0 ps=0 w=0.42u l=1u
X1031 VSS.t1428 VDD VSS.t1427 VSS.t311 sg13_lv_nmos ad=0.1428p pd=1.52u as=0 ps=0 w=0.42u l=1u
X1032 VSS.t2865 VDD VSS.t2864 VSS.t392 sg13_lv_nmos ad=0.1428p pd=1.52u as=0 ps=0 w=0.42u l=1u
X1033 VDD VSS.t2617 VDD VDD sg13_lv_pmos ad=0.34p pd=2.68u as=0 ps=0 w=1u l=1u
X1034 VSS.t774 VDD VSS.t774 VSS.t892 sg13_lv_nmos ad=0.1428p pd=1.52u as=0 ps=0 w=0.42u l=1u
X1035 VDD VSS.t2038 VDD VDD sg13_lv_pmos ad=0.19p pd=1.38u as=0 ps=0 w=1u l=1u
X1036 VDD VSS.t2805 VDD VDD sg13_lv_pmos ad=0.19p pd=1.38u as=0 ps=0 w=1u l=1u
X1037 VSS.t2453 VDD VSS.t2452 VSS.t2451 sg13_lv_nmos ad=0.1428p pd=1.52u as=0 ps=0 w=0.42u l=1u
X1038 VSS.t824 VDD VSS.t303 VSS.t825 sg13_lv_nmos ad=79.8f pd=0.8u as=0 ps=0 w=0.42u l=1u
X1039 VSS.t2226 VDD VSS.t2225 VSS.t2224 sg13_lv_nmos ad=0.1428p pd=1.52u as=0 ps=0 w=0.42u l=1u
X1040 VDD VSS.t748 VDD VDD sg13_lv_pmos ad=0.34p pd=2.68u as=0 ps=0 w=1u l=1u
X1041 VDD VSS.t917 VDD VDD sg13_lv_pmos ad=0.34p pd=2.68u as=0 ps=0 w=1u l=1u
X1042 VSS.t1350 VDD VSS.t1349 VSS.t311 sg13_lv_nmos ad=0.1428p pd=1.52u as=0 ps=0 w=0.42u l=1u
X1043 a_3333_16033# a_3333_16033# VSS.t81 VSS.t345 sg13_lv_nmos ad=0.111p pd=1.34u as=5.24677p ps=34.365u w=0.3u l=0.13u
X1044 VSS.t471 VDD VSS.t471 VSS.t473 sg13_lv_nmos ad=0.1428p pd=1.52u as=0 ps=0 w=0.42u l=1u
X1045 VSS.t9 a_6789_14495# a_6891_14495# VSS.t274 sg13_lv_nmos ad=5.4375p pd=36.05u as=0.2516p ps=2.16u w=0.74u l=0.13u
X1046 VSS.t43 a_10222_14751# sg13g2_dlygate4sd3_1_8.X VSS.t79 sg13_lv_nmos ad=0.1426p pd=1.16u as=0.2516p ps=2.16u w=0.74u l=0.13u
X1047 VSS.t712 VDD VSS.t712 VSS.t714 sg13_lv_nmos ad=79.8f pd=0.8u as=0 ps=0 w=0.42u l=1u
X1048 VDD VSS.t1721 VDD VDD sg13_lv_pmos ad=0.19p pd=1.38u as=0 ps=0 w=1u l=1u
X1049 VDD a_21070_15423# sg13g2_dlygate4sd3_1_11.X VDD sg13_lv_pmos ad=0.2254p pd=1.53u as=0.4256p ps=3u w=1.12u l=0.13u
X1050 VSS.t723 VDD VSS.t723 VSS.t725 sg13_lv_nmos ad=0.1428p pd=1.52u as=0 ps=0 w=0.42u l=1u
X1051 VDD VSS.t1082 VDD VDD sg13_lv_pmos ad=0.34p pd=2.68u as=0 ps=0 w=1u l=1u
X1052 VSS.t1609 VDD VSS.t1611 VSS.t1610 sg13_lv_nmos ad=79.8f pd=0.8u as=0 ps=0 w=0.42u l=1u
X1053 VSS.t2518 VDD VSS.t2520 VSS.t2519 sg13_lv_nmos ad=79.8f pd=0.8u as=0 ps=0 w=0.42u l=1u
X1054 VDD VSS.t2093 VDD VDD sg13_lv_pmos ad=0.19p pd=1.38u as=0 ps=0 w=1u l=1u
X1055 VDD VSS.t550 VDD VDD sg13_lv_pmos ad=0.34p pd=2.68u as=0 ps=0 w=1u l=1u
X1056 VSS.t953 VDD VSS.t952 VSS.t951 sg13_lv_nmos ad=0.1428p pd=1.52u as=0 ps=0 w=0.42u l=1u
X1057 VDD VSS.t1310 VDD VDD sg13_lv_pmos ad=0.19p pd=1.38u as=0 ps=0 w=1u l=1u
X1058 VSS.t1309 VDD VSS.t1310 VSS.t311 sg13_lv_nmos ad=79.8f pd=0.8u as=0 ps=0 w=0.42u l=1u
X1059 VSS.t1739 VDD VSS.t1738 VSS.t1737 sg13_lv_nmos ad=0.1428p pd=1.52u as=0 ps=0 w=0.42u l=1u
X1060 VSS.t3263 VDD VSS.t3262 VSS.t3261 sg13_lv_nmos ad=0.1428p pd=1.52u as=0 ps=0 w=0.42u l=1u
X1061 VDD VSS.t2412 VDD VDD sg13_lv_pmos ad=0.34p pd=2.68u as=0 ps=0 w=1u l=1u
X1062 VSS.t2813 VDD VSS.t2814 VSS.t392 sg13_lv_nmos ad=79.8f pd=0.8u as=0 ps=0 w=0.42u l=1u
X1063 a_9418_15457# a_9861_15213# a_9158_15234# VSS.t106 sg13_lv_nmos ad=79.8f pd=0.8u as=0.1296p ps=1.52u w=0.42u l=0.13u
X1064 sg13g2_dfrbpq_1_2.CLK a_12020_15202# VDD VDD sg13_lv_pmos ad=0.2128p pd=1.5u as=0.2128p ps=1.5u w=1.12u l=0.13u
X1065 VDD VSS.t1145 VDD VDD sg13_lv_pmos ad=0.19p pd=1.38u as=0 ps=0 w=1u l=1u
X1066 VSS.t2021 VDD VSS.t2020 VSS.t2019 sg13_lv_nmos ad=0.1428p pd=1.52u as=0 ps=0 w=0.42u l=1u
X1067 a_18501_16033# a_18501_16033# VSS.t81 VSS.t80 sg13_lv_nmos ad=0.111p pd=1.34u as=5.24677p ps=34.365u w=0.3u l=0.13u
X1068 VSS.t745 VDD VSS.t745 VSS.t746 sg13_lv_nmos ad=79.8f pd=0.8u as=0 ps=0 w=0.42u l=1u
X1069 VDD VSS.t523 VDD VDD sg13_lv_pmos ad=0.19p pd=1.38u as=0 ps=0 w=1u l=1u
X1070 VSS.t1734 VDD VSS.t1733 VSS.t1732 sg13_lv_nmos ad=0.1428p pd=1.52u as=0 ps=0 w=0.42u l=1u
X1071 VSS.t712 VDD VSS.t712 VSS.t715 sg13_lv_nmos ad=0.1428p pd=1.52u as=0 ps=0 w=0.42u l=1u
X1072 VDD VSS.t2377 VDD VDD sg13_lv_pmos ad=0.34p pd=2.68u as=0 ps=0 w=1u l=1u
X1073 VDD a_3333_15213# a_3435_15356# VDD sg13_lv_pmos ad=2.8961p pd=18.25u as=0.3864p ps=2.93u w=1.12u l=0.13u
X1074 VDD VSS.t1072 VDD VDD sg13_lv_pmos ad=0.34p pd=2.68u as=0 ps=0 w=1u l=1u
X1075 VSS.t1363 VDD VSS.t1362 VSS.t311 sg13_lv_nmos ad=0.1428p pd=1.52u as=0 ps=0 w=0.42u l=1u
X1076 VSS.t1649 VDD VSS.t1651 VSS.t1650 sg13_lv_nmos ad=79.8f pd=0.8u as=0 ps=0 w=0.42u l=1u
X1077 VDD VSS.t3167 VDD VDD sg13_lv_pmos ad=0.34p pd=2.68u as=0 ps=0 w=1u l=1u
X1078 VDD sg13g2_dfrbpq_1_2.RESET_B a_16042_13945# VDD sg13_lv_pmos ad=0.1563p pd=1.22u as=0.147p ps=1.54u w=0.42u l=0.13u
X1079 VSS.t2811 VDD VSS.t2812 VSS.t392 sg13_lv_nmos ad=79.8f pd=0.8u as=0 ps=0 w=0.42u l=1u
X1080 VDD VSS.t2776 VDD VDD sg13_lv_pmos ad=0.19p pd=1.38u as=0 ps=0 w=1u l=1u
X1081 VDD VSS.t2550 VDD VDD sg13_lv_pmos ad=0.19p pd=1.38u as=0 ps=0 w=1u l=1u
X1082 VDD VSS.t208 VDD VDD sg13_lv_pmos ad=0.19p pd=1.38u as=0 ps=0 w=1u l=1u
X1083 sg13g2_buf_16_2.X a_19438_13726# VSS.t333 VSS.t334 sg13_lv_nmos ad=0.1406p pd=1.12u as=0.1406p ps=1.12u w=0.74u l=0.13u
X1084 VDD VSS.t2085 VDD VDD sg13_lv_pmos ad=0.34p pd=2.68u as=0 ps=0 w=1u l=1u
X1085 VSS.t336 VDD VSS.t78 VSS.t841 sg13_lv_nmos ad=79.8f pd=0.8u as=0 ps=0 w=0.42u l=1u
X1086 VSS.t1108 VDD VSS.t1107 VSS.t1106 sg13_lv_nmos ad=0.1428p pd=1.52u as=0 ps=0 w=0.42u l=1u
X1087 VDD VSS.t1673 VDD VDD sg13_lv_pmos ad=0.34p pd=2.68u as=0 ps=0 w=1u l=1u
X1088 sg13g2_buf_16_2.A a_15022_14484# VSS.t62 VSS.t133 sg13_lv_nmos ad=0.1406p pd=1.12u as=0.1406p ps=1.12u w=0.74u l=0.13u
X1089 VSS.t1451 VDD VSS.t1290 VSS.t311 sg13_lv_nmos ad=0.1428p pd=1.52u as=0 ps=0 w=0.42u l=1u
X1090 VSS.t1398 VDD VSS.t1400 VSS.t311 sg13_lv_nmos ad=79.8f pd=0.8u as=0 ps=0 w=0.42u l=1u
X1091 VDD VSS.t1728 VDD VDD sg13_lv_pmos ad=0.34p pd=2.68u as=0 ps=0 w=1u l=1u
X1092 VSS.t3103 VDD VSS.t3105 VSS.t3104 sg13_lv_nmos ad=79.8f pd=0.8u as=0 ps=0 w=0.42u l=1u
X1093 VSS.t2473 VDD VSS.t2472 VSS.t2471 sg13_lv_nmos ad=0.1428p pd=1.52u as=0 ps=0 w=0.42u l=1u
X1094 VSS.t609 VDD VSS.t608 VSS.t9 sg13_lv_nmos ad=0.1428p pd=1.52u as=0 ps=0 w=0.42u l=1u
X1095 VSS.t1043 VDD VSS.t1045 VSS.t1044 sg13_lv_nmos ad=79.8f pd=0.8u as=0 ps=0 w=0.42u l=1u
X1096 VSS.t2823 VDD VSS.t2824 VSS.t392 sg13_lv_nmos ad=79.8f pd=0.8u as=0 ps=0 w=0.42u l=1u
X1097 VDD VSS.t1112 VDD VDD sg13_lv_pmos ad=0.34p pd=2.68u as=0 ps=0 w=1u l=1u
X1098 VDD VSS.t2788 VDD VDD sg13_lv_pmos ad=0.34p pd=2.68u as=0 ps=0 w=1u l=1u
X1099 VSS.t2891 VDD VSS.t2892 VSS.t392 sg13_lv_nmos ad=79.8f pd=0.8u as=0 ps=0 w=0.42u l=1u
X1100 VSS.t54 VDD VSS.t54 VSS.t797 sg13_lv_nmos ad=79.8f pd=0.8u as=0 ps=0 w=0.42u l=1u
X1101 VDD VSS.t1345 VDD VDD sg13_lv_pmos ad=0.19p pd=1.38u as=0 ps=0 w=1u l=1u
X1102 VSS.t681 VDD VSS.t681 VSS.t688 sg13_lv_nmos ad=79.8f pd=0.8u as=0 ps=0 w=0.42u l=1u
X1103 VDD VSS.t1035 VDD VDD sg13_lv_pmos ad=0.19p pd=1.38u as=0 ps=0 w=1u l=1u
X1104 VDD VSS.t1392 VDD VDD sg13_lv_pmos ad=0.34p pd=2.68u as=0 ps=0 w=1u l=1u
X1105 VDD VSS.t2796 VDD VDD sg13_lv_pmos ad=0.19p pd=1.38u as=0 ps=0 w=1u l=1u
X1106 VDD VSS.t3015 VDD VDD sg13_lv_pmos ad=0.34p pd=2.68u as=0 ps=0 w=1u l=1u
X1107 VDD VSS.t2200 VDD VDD sg13_lv_pmos ad=0.34p pd=2.68u as=0 ps=0 w=1u l=1u
X1108 VDD a_12524_15960# counter_value_o[2] VDD sg13_lv_pmos ad=0.2114p pd=1.54u as=0.42p ps=2.99u w=1.12u l=0.13u
X1109 VSS.t723 VDD VSS.t728 VSS.t847 sg13_lv_nmos ad=79.8f pd=0.8u as=0 ps=0 w=0.42u l=1u
X1110 VSS.t2438 VDD VSS.t2437 VSS.t2436 sg13_lv_nmos ad=0.1428p pd=1.52u as=0 ps=0 w=0.42u l=1u
X1111 VSS.t2051 VDD VSS.t2053 VSS.t2052 sg13_lv_nmos ad=79.8f pd=0.8u as=0 ps=0 w=0.42u l=1u
X1112 VDD sg13g2_buf_16_2.A a_19438_13726# VDD sg13_lv_pmos ad=0.2128p pd=1.5u as=0.2128p ps=1.5u w=1.12u l=0.13u
X1113 VSS.t1376 VDD VSS.t1375 VSS.t311 sg13_lv_nmos ad=0.1428p pd=1.52u as=0 ps=0 w=0.42u l=1u
X1114 VSS.t1991 VDD VSS.t1990 VSS.t1989 sg13_lv_nmos ad=0.1428p pd=1.52u as=0 ps=0 w=0.42u l=1u
X1115 VSS.t445 VDD VSS.t447 VSS.t446 sg13_lv_nmos ad=79.8f pd=0.8u as=0 ps=0 w=0.42u l=1u
X1116 sg13g2_o21ai_1_2.A2 sg13g2_dfrbpq_1_2.Q VDD VDD sg13_lv_pmos ad=0.2128p pd=1.5u as=0.3808p ps=2.92u w=1.12u l=0.13u
X1117 VSS.t48 a_4474_14448# a_4193_14750# VSS.t219 sg13_lv_nmos ad=79.8f pd=0.8u as=0.1428p ps=1.52u w=0.42u l=0.5u
X1118 VDD VSS.t2767 VDD VDD sg13_lv_pmos ad=0.19p pd=1.38u as=0 ps=0 w=1u l=1u
X1119 a_24263_14508# sg13g2_o21ai_1_2.A2 a_24169_14508# VDD sg13_lv_pmos ad=0.19p pd=1.38u as=0.34p ps=2.68u w=1u l=0.13u
X1120 a_21060_14488# a_21034_14452# VDD VDD sg13_lv_pmos ad=0.34p pd=2.68u as=0.36237p ps=2.605u w=1u l=0.13u
X1121 a_17057_13320# sg13g2_a21oi_1_0.A1 sg13g2_a21oi_1_0.Y VSS.t110 sg13_lv_nmos ad=0.1406p pd=1.12u as=0.1406p ps=1.12u w=0.74u l=0.13u
X1122 VSS.t1594 VDD VSS.t1596 VSS.t1595 sg13_lv_nmos ad=79.8f pd=0.8u as=0 ps=0 w=0.42u l=1u
X1123 VSS.t2503 VDD VSS.t2505 VSS.t2504 sg13_lv_nmos ad=79.8f pd=0.8u as=0 ps=0 w=0.42u l=1u
X1124 VSS.t45 a_17710_15423# sg13g2_a21oi_1_0.A1 VSS.t44 sg13_lv_nmos ad=0.1426p pd=1.16u as=0.2516p ps=2.16u w=0.74u l=0.13u
X1125 sg13g2_buf_16_2.X a_19438_13726# VSS.t328 VSS.t329 sg13_lv_nmos ad=0.1406p pd=1.12u as=0.1406p ps=1.12u w=0.74u l=0.13u
X1126 VDD VSS.t910 VDD VDD sg13_lv_pmos ad=0.19p pd=1.38u as=0 ps=0 w=1u l=1u
X1127 VSS.t953 VDD VSS.t952 VSS.t951 sg13_lv_nmos ad=0.1428p pd=1.52u as=0 ps=0 w=0.42u l=1u
X1128 VSS.t1380 VDD VSS.t1380 VSS.t311 sg13_lv_nmos ad=0.1428p pd=1.52u as=0 ps=0 w=0.42u l=1u
X1129 VSS.t2778 VDD VSS.t2779 VSS.t392 sg13_lv_nmos ad=79.8f pd=0.8u as=0 ps=0 w=0.42u l=1u
X1130 VDD VSS.t1354 VDD VDD sg13_lv_pmos ad=0.19p pd=1.38u as=0 ps=0 w=1u l=1u
X1131 VDD VSS.t3030 VDD VDD sg13_lv_pmos ad=0.19p pd=1.38u as=0 ps=0 w=1u l=1u
X1132 VDD VSS.t2078 VDD VDD sg13_lv_pmos ad=0.19p pd=1.38u as=0 ps=0 w=1u l=1u
X1133 VDD VSS.t2030 VDD VDD sg13_lv_pmos ad=0.34p pd=2.68u as=0 ps=0 w=1u l=1u
X1134 VSS.t2901 VDD VSS.t2900 VSS.t392 sg13_lv_nmos ad=0.1428p pd=1.52u as=0 ps=0 w=0.42u l=1u
X1135 VDD VSS.t2779 VDD VDD sg13_lv_pmos ad=0.34p pd=2.68u as=0 ps=0 w=1u l=1u
X1136 VDD VSS.t2856 VDD VDD sg13_lv_pmos ad=0.34p pd=2.68u as=0 ps=0 w=1u l=1u
X1137 VSS.t188 VDD VSS.t188 VSS.t643 sg13_lv_nmos ad=79.8f pd=0.8u as=0 ps=0 w=0.42u l=1u
X1138 VDD VSS.t1316 VDD VDD sg13_lv_pmos ad=0.34p pd=2.68u as=0 ps=0 w=1u l=1u
X1139 sg13g2_buf_1_10.X a_1192_9948# VSS.t312 VSS.t311 sg13_lv_nmos ad=0.2886p pd=2.26u as=0.14875p ps=1.16u w=0.74u l=0.13u
X1140 VSS.t3048 VDD VSS.t3050 VSS.t3049 sg13_lv_nmos ad=79.8f pd=0.8u as=0 ps=0 w=0.42u l=1u
X1141 VSS.t1322 VDD VSS.t1321 VSS.t311 sg13_lv_nmos ad=0.1428p pd=1.52u as=0 ps=0 w=0.42u l=1u
X1142 sg13g2_dfrbpq_1_5.Q a_28074_14020# VSS.t349 VSS.t348 sg13_lv_nmos ad=0.2516p pd=2.16u as=0.1406p ps=1.12u w=0.74u l=0.13u
X1143 VDD VSS.t1002 VDD VDD sg13_lv_pmos ad=0.34p pd=2.68u as=0 ps=0 w=1u l=1u
X1144 VDD VSS.t2808 VDD VDD sg13_lv_pmos ad=0.19p pd=1.38u as=0 ps=0 w=1u l=1u
X1145 VDD VSS.t2587 VDD VDD sg13_lv_pmos ad=0.34p pd=2.68u as=0 ps=0 w=1u l=1u
X1146 VDD VSS.t1117 VDD VDD sg13_lv_pmos ad=0.34p pd=2.68u as=0 ps=0 w=1u l=1u
X1147 VSS.t2831 VDD VSS.t2831 VSS.t392 sg13_lv_nmos ad=0.1428p pd=1.52u as=0 ps=0 w=0.42u l=1u
X1148 VSS.t2458 VDD VSS.t2457 VSS.t2456 sg13_lv_nmos ad=0.1428p pd=1.52u as=0 ps=0 w=0.42u l=1u
X1149 VSS.t1814 VDD VSS.t1813 VSS.t1812 sg13_lv_nmos ad=0.1428p pd=1.52u as=0 ps=0 w=0.42u l=1u
X1150 VDD VSS.t2362 VDD VDD sg13_lv_pmos ad=0.34p pd=2.68u as=0 ps=0 w=1u l=1u
X1151 VDD VSS.t1716 VDD VDD sg13_lv_pmos ad=0.19p pd=1.38u as=0 ps=0 w=1u l=1u
X1152 VSS.t2899 VDD VSS.t2898 VSS.t392 sg13_lv_nmos ad=0.1428p pd=1.52u as=0 ps=0 w=0.42u l=1u
X1153 VSS.t2802 VDD VSS.t2803 VSS.t392 sg13_lv_nmos ad=79.8f pd=0.8u as=0 ps=0 w=0.42u l=1u
X1154 VSS.t2196 VDD VSS.t2195 VSS.t2194 sg13_lv_nmos ad=0.1428p pd=1.52u as=0 ps=0 w=0.42u l=1u
X1155 VDD a_7680_15549# sg13g2_xnor2_1_0.Y VDD sg13_lv_pmos ad=0.3808p pd=2.92u as=0.2408p ps=1.55u w=1.12u l=0.13u
X1156 VSS.t18 VDD VSS.t18 VSS.t578 sg13_lv_nmos ad=0.1428p pd=1.52u as=0 ps=0 w=0.42u l=1u
X1157 VDD sg13g2_buf_16_2.A a_19438_13726# VDD sg13_lv_pmos ad=0.2128p pd=1.5u as=0.2128p ps=1.5u w=1.12u l=0.13u
X1158 VDD VSS.t1726 VDD VDD sg13_lv_pmos ad=0.19p pd=1.38u as=0 ps=0 w=1u l=1u
X1159 VSS.t81 a_3209_16334# a_3130_16237# VSS.t352 sg13_lv_nmos ad=5.24677p pd=34.365u as=0.27427p ps=2.28u w=0.795u l=0.13u
X1160 VSS.t1108 VDD VSS.t1107 VSS.t1106 sg13_lv_nmos ad=0.1428p pd=1.52u as=0 ps=0 w=0.42u l=1u
X1161 VSS.t1153 VDD VSS.t1152 VSS.t1151 sg13_lv_nmos ad=0.1428p pd=1.52u as=0 ps=0 w=0.42u l=1u
X1162 VSS.t1043 VDD VSS.t1045 VSS.t1044 sg13_lv_nmos ad=79.8f pd=0.8u as=0 ps=0 w=0.42u l=1u
X1163 VDD VSS.t1334 VDD VDD sg13_lv_pmos ad=0.34p pd=2.68u as=0 ps=0 w=1u l=1u
X1164 VSS.t1425 VDD VSS.t1426 VSS.t311 sg13_lv_nmos ad=79.8f pd=0.8u as=0 ps=0 w=0.42u l=1u
X1165 VDD VSS.t2098 VDD VDD sg13_lv_pmos ad=0.19p pd=1.38u as=0 ps=0 w=1u l=1u
X1166 VDD VSS.t1312 VDD VDD sg13_lv_pmos ad=0.19p pd=1.38u as=0 ps=0 w=1u l=1u
X1167 VDD VSS.t2873 VDD VDD sg13_lv_pmos ad=0.19p pd=1.38u as=0 ps=0 w=1u l=1u
X1168 a_27215_14845# a_26373_14495# a_27121_14845# VSS.t9 sg13_lv_nmos ad=0.12665p pd=1.145u as=0.1428p ps=1.52u w=0.42u l=0.13u
X1169 VSS.t1744 VDD VSS.t1743 VSS.t1742 sg13_lv_nmos ad=0.1428p pd=1.52u as=0 ps=0 w=0.42u l=1u
X1170 VSS.t3268 VDD VSS.t3267 VSS.t3266 sg13_lv_nmos ad=0.1428p pd=1.52u as=0 ps=0 w=0.42u l=1u
X1171 VDD VSS.t2417 VDD VDD sg13_lv_pmos ad=0.34p pd=2.68u as=0 ps=0 w=1u l=1u
X1172 VSS.t2815 VDD VSS.t2816 VSS.t392 sg13_lv_nmos ad=79.8f pd=0.8u as=0 ps=0 w=0.42u l=1u
X1173 VDD VSS.t748 VDD VDD sg13_lv_pmos ad=0.19p pd=1.38u as=0 ps=0 w=1u l=1u
X1174 VDD VSS.t1157 VDD VDD sg13_lv_pmos ad=0.34p pd=2.68u as=0 ps=0 w=1u l=1u
X1175 VSS.t2883 VDD VSS.t2884 VSS.t392 sg13_lv_nmos ad=79.8f pd=0.8u as=0 ps=0 w=0.42u l=1u
X1176 VSS.t2026 VDD VSS.t2025 VSS.t2024 sg13_lv_nmos ad=0.1428p pd=1.52u as=0 ps=0 w=0.42u l=1u
X1177 VSS.t3033 VDD VSS.t3035 VSS.t3034 sg13_lv_nmos ad=79.8f pd=0.8u as=0 ps=0 w=0.42u l=1u
X1178 VDD VSS.t1371 VDD VDD sg13_lv_pmos ad=0.19p pd=1.38u as=0 ps=0 w=1u l=1u
X1179 VSS.t1442 VDD VSS.t1443 VSS.t311 sg13_lv_nmos ad=79.8f pd=0.8u as=0 ps=0 w=0.42u l=1u
X1180 VDD VSS.t2430 VDD VDD sg13_lv_pmos ad=0.19p pd=1.38u as=0 ps=0 w=1u l=1u
X1181 VSS.t723 VDD VSS.t723 VSS.t724 sg13_lv_nmos ad=79.8f pd=0.8u as=0 ps=0 w=0.42u l=1u
X1182 VDD VSS.t1080 VDD VDD sg13_lv_pmos ad=0.19p pd=1.38u as=0 ps=0 w=1u l=1u
X1183 VDD VSS.t1382 VDD VDD sg13_lv_pmos ad=0.34p pd=2.68u as=0 ps=0 w=1u l=1u
X1184 VSS.t1654 VDD VSS.t1656 VSS.t1655 sg13_lv_nmos ad=79.8f pd=0.8u as=0 ps=0 w=0.42u l=1u
X1185 VDD VSS.t2884 VDD VDD sg13_lv_pmos ad=0.34p pd=2.68u as=0 ps=0 w=1u l=1u
X1186 VSS.t2216 VDD VSS.t2215 VSS.t2214 sg13_lv_nmos ad=0.1428p pd=1.52u as=0 ps=0 w=0.42u l=1u
X1187 VSS.t2036 VDD VSS.t2038 VSS.t2037 sg13_lv_nmos ad=79.8f pd=0.8u as=0 ps=0 w=0.42u l=1u
X1188 VSS.t963 VDD VSS.t965 VSS.t964 sg13_lv_nmos ad=79.8f pd=0.8u as=0 ps=0 w=0.42u l=1u
X1189 VSS.t2814 VDD VSS.t2815 VSS.t392 sg13_lv_nmos ad=79.8f pd=0.8u as=0 ps=0 w=0.42u l=1u
X1190 VDD VSS.t2555 VDD VDD sg13_lv_pmos ad=0.19p pd=1.38u as=0 ps=0 w=1u l=1u
X1191 VSS.t1447 VDD VSS.t1448 VSS.t311 sg13_lv_nmos ad=79.8f pd=0.8u as=0 ps=0 w=0.42u l=1u
X1192 VSS.t3063 VDD VSS.t3062 VSS.t3061 sg13_lv_nmos ad=0.1428p pd=1.52u as=0 ps=0 w=0.42u l=1u
X1193 VDD VSS.t2760 VDD VDD sg13_lv_pmos ad=0.19p pd=1.38u as=0 ps=0 w=1u l=1u
X1194 VSS.t1976 VDD VSS.t1975 VSS.t1974 sg13_lv_nmos ad=0.1428p pd=1.52u as=0 ps=0 w=0.42u l=1u
X1195 a_21417_14531# a_21060_14488# VDD VDD sg13_lv_pmos ad=63f pd=0.72u as=0.1563p ps=1.22u w=0.42u l=0.13u
X1196 VDD VSS.t1438 VDD VDD sg13_lv_pmos ad=0.34p pd=2.68u as=0 ps=0 w=1u l=1u
X1197 VDD a_15022_14484# sg13g2_buf_16_2.A VDD sg13_lv_pmos ad=0.2128p pd=1.5u as=0.2128p ps=1.5u w=1.12u l=0.13u
X1198 VDD a_15022_14484# sg13g2_buf_16_2.A VDD sg13_lv_pmos ad=0.3976p pd=2.95u as=0.2128p ps=1.5u w=1.12u l=0.13u
X1199 VDD VSS.t1172 VDD VDD sg13_lv_pmos ad=0.34p pd=2.68u as=0 ps=0 w=1u l=1u
X1200 VDD VSS.t2815 VDD VDD sg13_lv_pmos ad=0.34p pd=2.68u as=0 ps=0 w=1u l=1u
X1201 VDD VSS.t2055 VDD VDD sg13_lv_pmos ad=0.34p pd=2.68u as=0 ps=0 w=1u l=1u
X1202 a_3204_15247# a_3435_15356# a_2890_15457# VSS.t214 sg13_lv_nmos ad=0.2373p pd=1.97u as=79.8f ps=0.8u w=0.42u l=0.13u
X1203 a_3142_15247# sg13g2_dfrbpq_1_0.RESET_B VSS.t213 VSS.t340 sg13_lv_nmos ad=37.8f pd=0.6u as=0.1701p ps=1.65u w=0.42u l=0.13u
X1204 VDD VSS.t2240 VDD VDD sg13_lv_pmos ad=0.34p pd=2.68u as=0 ps=0 w=1u l=1u
X1205 sg13g2_or3_1_1.B a_14357_15238# VSS.t13 VSS.t12 sg13_lv_nmos ad=0.1406p pd=1.12u as=0.3293p ps=1.63u w=0.74u l=0.13u
X1206 VSS.t712 VDD VSS.t712 VSS.t714 sg13_lv_nmos ad=79.8f pd=0.8u as=0 ps=0 w=0.42u l=1u
X1207 sg13g2_dfrbpq_1_3.D a_17142_15302# VSS.t62 VSS.t412 sg13_lv_nmos ad=0.2516p pd=2.16u as=0.1426p ps=1.16u w=0.74u l=0.13u
X1208 VSS.t54 a_8218_13690# a_7937_13912# VSS.t305 sg13_lv_nmos ad=79.8f pd=0.8u as=0.1428p ps=1.52u w=0.42u l=0.5u
X1209 a_22036_14020# sg13g2_or3_1_2.A VDD VDD sg13_lv_pmos ad=0.1575p pd=1.315u as=0.3822p ps=1.84u w=1u l=0.13u
X1210 VDD VSS.t1738 VDD VDD sg13_lv_pmos ad=0.34p pd=2.68u as=0 ps=0 w=1u l=1u
X1211 VDD VSS.t2015 VDD VDD sg13_lv_pmos ad=0.34p pd=2.68u as=0 ps=0 w=1u l=1u
X1212 VDD VSS.t2848 VDD VDD sg13_lv_pmos ad=0.34p pd=2.68u as=0 ps=0 w=1u l=1u
X1213 VSS.t2875 VDD VSS.t2876 VSS.t392 sg13_lv_nmos ad=79.8f pd=0.8u as=0 ps=0 w=0.42u l=1u
X1214 VDD VSS.t1047 VDD VDD sg13_lv_pmos ad=0.34p pd=2.68u as=0 ps=0 w=1u l=1u
X1215 VDD VSS.t466 VDD VDD sg13_lv_pmos ad=0.19p pd=1.38u as=0 ps=0 w=1u l=1u
X1216 VSS.t2823 VDD VSS.t2823 VSS.t392 sg13_lv_nmos ad=0.1428p pd=1.52u as=0 ps=0 w=0.42u l=1u
X1217 VSS.t2443 VDD VSS.t2442 VSS.t2441 sg13_lv_nmos ad=0.1428p pd=1.52u as=0 ps=0 w=0.42u l=1u
X1218 VDD sg13g2_dfrbpq_1_1.RESET_B a_6346_14452# VDD sg13_lv_pmos ad=0.1563p pd=1.22u as=0.147p ps=1.54u w=0.42u l=0.13u
X1219 VDD VSS.t54 VDD VDD sg13_lv_pmos ad=0.34p pd=2.68u as=0 ps=0 w=1u l=1u
X1220 VSS.t2891 VDD VSS.t2891 VSS.t392 sg13_lv_nmos ad=0.1428p pd=1.52u as=0 ps=0 w=0.42u l=1u
X1221 VSS.t2166 VDD VSS.t2168 VSS.t2167 sg13_lv_nmos ad=79.8f pd=0.8u as=0 ps=0 w=0.42u l=1u
X1222 VSS.t1153 VDD VSS.t1152 VSS.t1151 sg13_lv_nmos ad=0.1428p pd=1.52u as=0 ps=0 w=0.42u l=1u
X1223 VDD VSS.t2477 VDD VDD sg13_lv_pmos ad=0.34p pd=2.68u as=0 ps=0 w=1u l=1u
X1224 VDD clock_i a_15022_14484# VDD sg13_lv_pmos ad=0.2128p pd=1.5u as=0.2128p ps=1.5u w=1.12u l=0.13u
X1225 VSS.t1599 VDD VSS.t1601 VSS.t1600 sg13_lv_nmos ad=79.8f pd=0.8u as=0 ps=0 w=0.42u l=1u
X1226 VSS.t2508 VDD VSS.t2510 VSS.t2509 sg13_lv_nmos ad=79.8f pd=0.8u as=0 ps=0 w=0.42u l=1u
X1227 VSS.t2781 VDD VSS.t2782 VSS.t392 sg13_lv_nmos ad=79.8f pd=0.8u as=0 ps=0 w=0.42u l=1u
X1228 a_17517_16020# sg13g2_xnor2_1_1.A a_17428_16020# VDD sg13_lv_pmos ad=0.19p pd=1.38u as=0.1575p ps=1.315u w=1u l=0.13u
X1229 VSS.t585 VDD VSS.t584 VSS.t9 sg13_lv_nmos ad=0.1428p pd=1.52u as=0 ps=0 w=0.42u l=1u
X1230 a_6575_13342# a_6540_13238# sg13g2_dlygate4sd3_1_0.A VSS.t367 sg13_lv_nmos ad=0.1406p pd=1.12u as=0.2516p ps=2.16u w=0.74u l=0.13u
X1231 VDD VSS.t1718 VDD VDD sg13_lv_pmos ad=0.34p pd=2.68u as=0 ps=0 w=1u l=1u
X1232 VSS.t2086 VDD VSS.t2085 VSS.t2084 sg13_lv_nmos ad=0.1428p pd=1.52u as=0 ps=0 w=0.42u l=1u
X1233 VDD VSS.t1304 VDD VDD sg13_lv_pmos ad=0.19p pd=1.38u as=0 ps=0 w=1u l=1u
X1234 VDD VSS.t2083 VDD VDD sg13_lv_pmos ad=0.19p pd=1.38u as=0 ps=0 w=1u l=1u
X1235 sg13g2_o21ai_1_1.Y sg13g2_or3_1_2.C a_20376_14464# VDD sg13_lv_pmos ad=0.2128p pd=1.5u as=0.2128p ps=1.5u w=1.12u l=0.15u
X1236 VSS.t1343 VDD VSS.t1342 VSS.t311 sg13_lv_nmos ad=0.1428p pd=1.52u as=0 ps=0 w=0.42u l=1u
X1237 VSS.t1729 VDD VSS.t1728 VSS.t1727 sg13_lv_nmos ad=0.1428p pd=1.52u as=0 ps=0 w=0.42u l=1u
X1238 VDD VSS.t1434 VDD VDD sg13_lv_pmos ad=0.34p pd=2.68u as=0 ps=0 w=1u l=1u
X1239 VDD VSS.t2000 VDD VDD sg13_lv_pmos ad=0.34p pd=2.68u as=0 ps=0 w=1u l=1u
X1240 VDD VSS.t2782 VDD VDD sg13_lv_pmos ad=0.34p pd=2.68u as=0 ps=0 w=1u l=1u
X1241 VDD VSS.t2840 VDD VDD sg13_lv_pmos ad=0.34p pd=2.68u as=0 ps=0 w=1u l=1u
X1242 a_12020_15202# sg13g2_buf_16_2.A VSS.t13 VSS.t400 sg13_lv_nmos ad=0.1406p pd=1.12u as=0.1406p ps=1.12u w=0.74u l=0.13u
X1243 a_12524_15960# sg13g2_dlygate4sd3_1_8.A VSS.t363 VSS.t362 sg13_lv_nmos ad=0.187p pd=1.78u as=0.14875p ps=1.16u w=0.55u l=0.13u
X1244 VDD VSS.t1414 VDD VDD sg13_lv_pmos ad=0.19p pd=1.38u as=0 ps=0 w=1u l=1u
X1245 VDD VSS.t2794 VDD VDD sg13_lv_pmos ad=0.19p pd=1.38u as=0 ps=0 w=1u l=1u
X1246 VSS.t1073 VDD VSS.t1072 VSS.t1071 sg13_lv_nmos ad=0.1428p pd=1.52u as=0 ps=0 w=0.42u l=1u
X1247 VDD VSS.t2592 VDD VDD sg13_lv_pmos ad=0.34p pd=2.68u as=0 ps=0 w=1u l=1u
X1248 sg13g2_or3_1_1.C sg13g2_dfrbpq_1_2.Q VDD VDD sg13_lv_pmos ad=0.2128p pd=1.5u as=0.3808p ps=2.92u w=1.12u l=0.13u
X1249 VSS.t963 VDD VSS.t965 VSS.t964 sg13_lv_nmos ad=79.8f pd=0.8u as=0 ps=0 w=0.42u l=1u
X1250 VSS.t1361 VDD VSS.t1360 VSS.t311 sg13_lv_nmos ad=0.1428p pd=1.52u as=0 ps=0 w=0.42u l=1u
X1251 a_24408_15552# sg13g2_or3_1_2.B VDD VDD sg13_lv_pmos ad=0.2128p pd=1.5u as=0.3808p ps=2.92u w=1.12u l=0.15u
X1252 VDD VSS.t760 VDD VDD sg13_lv_pmos ad=0.34p pd=2.68u as=0 ps=0 w=1u l=1u
X1253 VSS.t1819 VDD VSS.t1818 VSS.t1817 sg13_lv_nmos ad=0.1428p pd=1.52u as=0 ps=0 w=0.42u l=1u
X1254 VSS.t28 a_27502_15423# sg13g2_or3_1_1.A VSS.t9 sg13_lv_nmos ad=0.1426p pd=1.16u as=0.2516p ps=2.16u w=0.74u l=0.13u
X1255 VSS.t2902 VDD VSS.t2901 VSS.t392 sg13_lv_nmos ad=0.1428p pd=1.52u as=0 ps=0 w=0.42u l=1u
X1256 VSS.t2805 VDD VSS.t2806 VSS.t392 sg13_lv_nmos ad=79.8f pd=0.8u as=0 ps=0 w=0.42u l=1u
X1257 VSS.t2201 VDD VSS.t2200 VSS.t2199 sg13_lv_nmos ad=0.1428p pd=1.52u as=0 ps=0 w=0.42u l=1u
X1258 VSS.t1584 VDD VSS.t1586 VSS.t1585 sg13_lv_nmos ad=79.8f pd=0.8u as=0 ps=0 w=0.42u l=1u
X1259 VDD VSS.t2635 VDD VDD sg13_lv_pmos ad=0.19p pd=1.38u as=0 ps=0 w=1u l=1u
X1260 VSS.t245 VDD VSS.t568 VSS.t567 sg13_lv_nmos ad=79.8f pd=0.8u as=0 ps=0 w=0.42u l=1u
X1261 a_7058_15242# sg13g2_xor2_1_0.B VSS.t39 VSS.t253 sg13_lv_nmos ad=0.1406p pd=1.12u as=0.2516p ps=2.16u w=0.74u l=0.13u
X1262 VSS.t681 VDD VSS.t681 VSS.t688 sg13_lv_nmos ad=79.8f pd=0.8u as=0 ps=0 w=0.42u l=1u
X1263 VDD VSS.t2040 VDD VDD sg13_lv_pmos ad=0.34p pd=2.68u as=0 ps=0 w=1u l=1u
X1264 VDD VSS.t2806 VDD VDD sg13_lv_pmos ad=0.34p pd=2.68u as=0 ps=0 w=1u l=1u
X1265 VDD VSS.t553 VDD VDD sg13_lv_pmos ad=0.34p pd=2.68u as=0 ps=0 w=1u l=1u
X1266 VSS.t1289 VDD VSS.t312 VSS.t311 sg13_lv_nmos ad=0.1428p pd=1.52u as=0 ps=0 w=0.42u l=1u
X1267 VSS.t1397 VDD VSS.t1398 VSS.t311 sg13_lv_nmos ad=79.8f pd=0.8u as=0 ps=0 w=0.42u l=1u
X1268 VSS.t1319 VDD VSS.t1320 VSS.t311 sg13_lv_nmos ad=79.8f pd=0.8u as=0 ps=0 w=0.42u l=1u
X1269 VDD VSS.t623 VDD VDD sg13_lv_pmos ad=0.34p pd=2.68u as=0 ps=0 w=1u l=1u
X1270 a_7822_13911# a_7937_13912# VDD VDD sg13_lv_pmos ad=0.34p pd=2.68u as=0.2254p ps=1.53u w=1u l=0.5u
X1271 a_25862_13722# sg13g2_dfrbpq_1_5.D VDD VDD sg13_lv_pmos ad=79.8f pd=0.8u as=0.1428p ps=1.52u w=0.42u l=0.13u
X1272 VDD VSS.t1295 VDD VDD sg13_lv_pmos ad=0.19p pd=1.38u as=0 ps=0 w=1u l=1u
X1273 VDD VSS.t2068 VDD VDD sg13_lv_pmos ad=0.19p pd=1.38u as=0 ps=0 w=1u l=1u
X1274 VDD VSS.t2422 VDD VDD sg13_lv_pmos ad=0.34p pd=2.68u as=0 ps=0 w=1u l=1u
X1275 a_26249_16334# a_26373_16033# VDD VDD sg13_lv_pmos ad=0.2442p pd=2.06u as=2.8961p ps=18.25u w=0.66u l=0.13u
X1276 a_6286_13911# a_6401_13912# VDD VDD sg13_lv_pmos ad=0.34p pd=2.68u as=0.2254p ps=1.53u w=1u l=0.5u
X1277 VSS.t757 VDD VSS.t757 VSS.t758 sg13_lv_nmos ad=79.8f pd=0.8u as=0 ps=0 w=0.42u l=1u
X1278 VDD VSS.t1165 VDD VDD sg13_lv_pmos ad=0.19p pd=1.38u as=0 ps=0 w=1u l=1u
X1279 VDD VSS.t1723 VDD VDD sg13_lv_pmos ad=0.34p pd=2.68u as=0 ps=0 w=1u l=1u
X1280 VSS.t1614 VDD VSS.t1613 VSS.t1612 sg13_lv_nmos ad=0.1428p pd=1.52u as=0 ps=0 w=0.42u l=1u
X1281 VDD VSS.t3160 VDD VDD sg13_lv_pmos ad=0.19p pd=1.38u as=0 ps=0 w=1u l=1u
X1282 VSS.t2523 VDD VSS.t2522 VSS.t2521 sg13_lv_nmos ad=0.1428p pd=1.52u as=0 ps=0 w=0.42u l=1u
X1283 VSS.t2031 VDD VSS.t2030 VSS.t2029 sg13_lv_nmos ad=0.1428p pd=1.52u as=0 ps=0 w=0.42u l=1u
X1284 VSS.t557 VDD VSS.t557 VSS.t558 sg13_lv_nmos ad=79.8f pd=0.8u as=0 ps=0 w=0.42u l=1u
X1285 sg13g2_dfrbpq_1_2.CLK a_12020_15202# VSS.t188 VSS.t199 sg13_lv_nmos ad=0.1406p pd=1.12u as=0.1406p ps=1.12u w=0.74u l=0.13u
X1286 VSS.t612 VDD VSS.t613 VSS.t9 sg13_lv_nmos ad=79.8f pd=0.8u as=0 ps=0 w=0.42u l=1u
X1287 VSS.t2790 VDD VSS.t2789 VSS.t392 sg13_lv_nmos ad=0.1428p pd=1.52u as=0 ps=0 w=0.42u l=1u
X1288 VSS.t290 VDD VSS.t290 VSS.t821 sg13_lv_nmos ad=0.1428p pd=1.52u as=0 ps=0 w=0.42u l=1u
X1289 VSS.t2978 VDD VSS.t2851 VSS.t392 sg13_lv_nmos ad=79.8f pd=0.8u as=0 ps=0 w=0.42u l=1u
X1290 VDD VSS.t1092 VDD VDD sg13_lv_pmos ad=0.34p pd=2.68u as=0 ps=0 w=1u l=1u
X1291 VDD VSS.t1581 VDD VDD sg13_lv_pmos ad=0.19p pd=1.38u as=0 ps=0 w=1u l=1u
X1292 VDD VSS.t444 VDD VDD sg13_lv_pmos ad=0.34p pd=2.68u as=0 ps=0 w=1u l=1u
X1293 VSS.t355 VDD VSS.t355 VSS.t464 sg13_lv_nmos ad=79.8f pd=0.8u as=0 ps=0 w=0.42u l=1u
X1294 VSS.t707 VDD VSS.t707 VSS.t708 sg13_lv_nmos ad=0.1428p pd=1.52u as=0 ps=0 w=0.42u l=1u
X1295 a_9737_14822# a_9861_14521# VDD VDD sg13_lv_pmos ad=0.2442p pd=2.06u as=2.42015p ps=15.68u w=0.66u l=0.13u
X1296 VDD VSS.t54 VDD VDD sg13_lv_pmos ad=0.34p pd=2.68u as=0 ps=0 w=1u l=1u
X1297 a_17604_14488# a_17578_14452# VDD VDD sg13_lv_pmos ad=0.34p pd=2.68u as=0.36237p ps=2.605u w=1u l=0.13u
X1298 VDD a_27472_14726# a_27417_14607# VDD sg13_lv_pmos ad=2.42015p pd=15.68u as=93.45f ps=0.865u w=0.42u l=0.13u
X1299 VSS.t3068 VDD VSS.t3067 VSS.t3066 sg13_lv_nmos ad=0.1428p pd=1.52u as=0 ps=0 w=0.42u l=1u
X1300 VDD VSS.t2762 VDD VDD sg13_lv_pmos ad=0.19p pd=1.38u as=0 ps=0 w=1u l=1u
X1301 VSS.t728 VDD VSS.t164 VSS.t849 sg13_lv_nmos ad=79.8f pd=0.8u as=0 ps=0 w=0.42u l=1u
X1302 VDD VSS.t1420 VDD VDD sg13_lv_pmos ad=0.34p pd=2.68u as=0 ps=0 w=1u l=1u
X1303 VSS.t1714 VDD VSS.t1716 VSS.t1715 sg13_lv_nmos ad=79.8f pd=0.8u as=0 ps=0 w=0.42u l=1u
X1304 VSS.t3238 VDD VSS.t3240 VSS.t3239 sg13_lv_nmos ad=79.8f pd=0.8u as=0 ps=0 w=0.42u l=1u
X1305 VSS.t1379 VDD VSS.t1378 VSS.t311 sg13_lv_nmos ad=0.1428p pd=1.52u as=0 ps=0 w=0.42u l=1u
X1306 VSS.t1460 VDD VSS.t1302 VSS.t311 sg13_lv_nmos ad=0.1428p pd=1.52u as=0 ps=0 w=0.42u l=1u
X1307 VSS.t1544 VDD VSS.t1411 VSS.t311 sg13_lv_nmos ad=79.8f pd=0.8u as=0 ps=0 w=0.42u l=1u
X1308 VSS.t2106 VDD VSS.t2105 VSS.t2104 sg13_lv_nmos ad=0.1428p pd=1.52u as=0 ps=0 w=0.42u l=1u
X1309 VDD VSS.t2060 VDD VDD sg13_lv_pmos ad=0.34p pd=2.68u as=0 ps=0 w=1u l=1u
X1310 VDD VSS.t967 VDD VDD sg13_lv_pmos ad=0.34p pd=2.68u as=0 ps=0 w=1u l=1u
X1311 VSS.t2772 VDD VSS.t2773 VSS.t392 sg13_lv_nmos ad=79.8f pd=0.8u as=0 ps=0 w=0.42u l=1u
X1312 VDD VSS.t2245 VDD VDD sg13_lv_pmos ad=0.34p pd=2.68u as=0 ps=0 w=1u l=1u
X1313 VSS.t2638 VDD VSS.t2640 VSS.t2639 sg13_lv_nmos ad=79.8f pd=0.8u as=0 ps=0 w=0.42u l=1u
X1314 VDD VSS.t490 VDD VDD sg13_lv_pmos ad=0.34p pd=2.68u as=0 ps=0 w=1u l=1u
X1315 VDD VSS.t1743 VDD VDD sg13_lv_pmos ad=0.34p pd=2.68u as=0 ps=0 w=1u l=1u
X1316 VDD VSS.t2773 VDD VDD sg13_lv_pmos ad=0.34p pd=2.68u as=0 ps=0 w=1u l=1u
X1317 VDD a_18874_13690# a_18593_13912# VDD sg13_lv_pmos ad=0.1523p pd=1.38u as=0.34p ps=2.68u w=1u l=0.5u
X1318 VSS.t176 VDD VSS.t349 VSS.t863 sg13_lv_nmos ad=79.8f pd=0.8u as=0 ps=0 w=0.42u l=1u
X1319 VSS.t2016 VDD VSS.t2015 VSS.t2014 sg13_lv_nmos ad=0.1428p pd=1.52u as=0 ps=0 w=0.42u l=1u
X1320 VSS.t1073 VDD VSS.t1072 VSS.t1071 sg13_lv_nmos ad=0.1428p pd=1.52u as=0 ps=0 w=0.42u l=1u
X1321 a_26757_16033# a_26757_16033# VSS.t81 VSS.t243 sg13_lv_nmos ad=0.111p pd=1.34u as=5.24677p ps=34.365u w=0.3u l=0.13u
X1322 VDD VSS.t2883 VDD VDD sg13_lv_pmos ad=0.34p pd=2.68u as=0 ps=0 w=1u l=1u
X1323 a_17219_16265# sg13g2_or3_1_2.B VSS.t347 VSS.t370 sg13_lv_nmos ad=0.187p pd=1.78u as=0.1045p ps=0.93u w=0.55u l=0.13u
X1324 VSS.t496 VDD VSS.t498 VSS.t497 sg13_lv_nmos ad=79.8f pd=0.8u as=0 ps=0 w=0.42u l=1u
X1325 VSS.t2826 VDD VSS.t2825 VSS.t392 sg13_lv_nmos ad=0.1428p pd=1.52u as=0 ps=0 w=0.42u l=1u
X1326 VSS.t11 VDD VSS.t11 VSS.t696 sg13_lv_nmos ad=0.1428p pd=1.52u as=0 ps=0 w=0.42u l=1u
X1327 VDD VSS.t328 VDD VDD sg13_lv_pmos ad=0.19p pd=1.38u as=0 ps=0 w=1u l=1u
X1328 VSS.t2894 VDD VSS.t2893 VSS.t392 sg13_lv_nmos ad=0.1428p pd=1.52u as=0 ps=0 w=0.42u l=1u
X1329 VDD VSS.t363 VDD VDD sg13_lv_pmos ad=0.34p pd=2.68u as=0 ps=0 w=1u l=1u
X1330 VSS.t319 VDD VSS.t317 VSS.t836 sg13_lv_nmos ad=0.1428p pd=1.52u as=0 ps=0 w=0.42u l=1u
X1331 VDD VSS.t1329 VDD VDD sg13_lv_pmos ad=0.19p pd=1.38u as=0 ps=0 w=1u l=1u
X1332 VDD VSS.t2835 VDD VDD sg13_lv_pmos ad=0.19p pd=1.38u as=0 ps=0 w=1u l=1u
X1333 VSS.t2171 VDD VSS.t2173 VSS.t2172 sg13_lv_nmos ad=79.8f pd=0.8u as=0 ps=0 w=0.42u l=1u
X1334 VDD VSS.t930 VDD VDD sg13_lv_pmos ad=0.19p pd=1.38u as=0 ps=0 w=1u l=1u
X1335 VDD VSS.t1122 VDD VDD sg13_lv_pmos ad=0.34p pd=2.68u as=0 ps=0 w=1u l=1u
X1336 VSS.t1393 VDD VSS.t1392 VSS.t311 sg13_lv_nmos ad=0.1428p pd=1.52u as=0 ps=0 w=0.42u l=1u
X1337 VSS.t2508 VDD VSS.t2507 VSS.t2506 sg13_lv_nmos ad=0.1428p pd=1.52u as=0 ps=0 w=0.42u l=1u
X1338 VDD VSS.t2447 VDD VDD sg13_lv_pmos ad=0.34p pd=2.68u as=0 ps=0 w=1u l=1u
X1339 VDD VSS.t2620 VDD VDD sg13_lv_pmos ad=0.19p pd=1.38u as=0 ps=0 w=1u l=1u
X1340 VDD VSS.t1365 VDD VDD sg13_lv_pmos ad=0.19p pd=1.38u as=0 ps=0 w=1u l=1u
X1341 VDD VSS.t745 VDD VDD sg13_lv_pmos ad=0.34p pd=2.68u as=0 ps=0 w=1u l=1u
X1342 VSS.t2056 VDD VSS.t2055 VSS.t2054 sg13_lv_nmos ad=0.1428p pd=1.52u as=0 ps=0 w=0.42u l=1u
X1343 VDD VSS.t2572 VDD VDD sg13_lv_pmos ad=0.34p pd=2.68u as=0 ps=0 w=1u l=1u
X1344 VDD VSS.t2230 VDD VDD sg13_lv_pmos ad=0.34p pd=2.68u as=0 ps=0 w=1u l=1u
X1345 VDD VSS.t2053 VDD VDD sg13_lv_pmos ad=0.19p pd=1.38u as=0 ps=0 w=1u l=1u
X1346 VDD VSS.t640 VDD VDD sg13_lv_pmos ad=0.34p pd=2.68u as=0 ps=0 w=1u l=1u
X1347 VDD VSS.t2407 VDD VDD sg13_lv_pmos ad=0.34p pd=2.68u as=0 ps=0 w=1u l=1u
X1348 VSS.t1158 VDD VSS.t1157 VSS.t1156 sg13_lv_nmos ad=0.1428p pd=1.52u as=0 ps=0 w=0.42u l=1u
X1349 VDD VSS.t2785 VDD VDD sg13_lv_pmos ad=0.34p pd=2.68u as=0 ps=0 w=1u l=1u
X1350 VSS.t1428 VDD VSS.t1429 VSS.t311 sg13_lv_nmos ad=79.8f pd=0.8u as=0 ps=0 w=0.42u l=1u
X1351 VDD VSS.t2178 VDD VDD sg13_lv_pmos ad=0.19p pd=1.38u as=0 ps=0 w=1u l=1u
X1352 VDD VSS.t702 VDD VDD sg13_lv_pmos ad=0.19p pd=1.38u as=0 ps=0 w=1u l=1u
X1353 VDD VSS.t1022 VDD VDD sg13_lv_pmos ad=0.34p pd=2.68u as=0 ps=0 w=1u l=1u
X1354 VSS.t58 a_4175_15311# a_4842_15532# VSS.t57 sg13_lv_nmos ad=0.1406p pd=1.12u as=0.2516p ps=2.16u w=0.74u l=0.13u
X1355 sg13g2_xnor2_1_0.Y sg13g2_nand3_1_0.Y a_7923_15532# VDD sg13_lv_pmos ad=0.2408p pd=1.55u as=0.1428p ps=1.375u w=1.12u l=0.13u
X1356 VSS.t1 a_19450_15202# a_19169_15424# VSS.t0 sg13_lv_nmos ad=79.8f pd=0.8u as=0.1428p ps=1.52u w=0.42u l=0.5u
X1357 VDD VSS.t1000 VDD VDD sg13_lv_pmos ad=0.19p pd=1.38u as=0 ps=0 w=1u l=1u
X1358 VDD VSS.t1293 VDD VDD sg13_lv_pmos ad=0.19p pd=1.38u as=0 ps=0 w=1u l=1u
X1359 VSS.t2781 VDD VSS.t2779 VSS.t392 sg13_lv_nmos ad=0.1428p pd=1.52u as=0 ps=0 w=0.42u l=1u
X1360 VSS.t2971 VDD VSS.t2843 VSS.t392 sg13_lv_nmos ad=79.8f pd=0.8u as=0 ps=0 w=0.42u l=1u
X1361 VDD VSS.t2797 VDD VDD sg13_lv_pmos ad=0.19p pd=1.38u as=0 ps=0 w=1u l=1u
X1362 VDD a_8582_15238# a_8694_15302# VDD sg13_lv_pmos ad=0.2254p pd=1.53u as=0.34p ps=2.68u w=1u l=0.5u
X1363 VSS.t62 a_15022_14484# sg13g2_buf_16_2.A VSS.t134 sg13_lv_nmos ad=0.1406p pd=1.12u as=0.1406p ps=1.12u w=0.74u l=0.13u
X1364 VDD VSS.t3032 VDD VDD sg13_lv_pmos ad=0.34p pd=2.68u as=0 ps=0 w=1u l=1u
X1365 sg13g2_a21oi_1_0.Y sg13g2_a21oi_1_0.B1 VSS.t211 VSS.t210 sg13_lv_nmos ad=0.1406p pd=1.12u as=0.2516p ps=2.16u w=0.74u l=0.13u
X1366 VDD sg13g2_and2_1_0.B a_1965_14832# VDD sg13_lv_pmos ad=0.1918p pd=1.5u as=0.1596p ps=1.22u w=0.84u l=0.13u
X1367 VSS.t745 VDD VSS.t748 VSS.t875 sg13_lv_nmos ad=79.8f pd=0.8u as=0 ps=0 w=0.42u l=1u
X1368 a_17318_14922# sg13g2_dfrbpq_1_3.D VDD VDD sg13_lv_pmos ad=79.8f pd=0.8u as=0.1428p ps=1.52u w=0.42u l=0.13u
X1369 VDD VSS.t897 VDD VDD sg13_lv_pmos ad=0.34p pd=2.68u as=0 ps=0 w=1u l=1u
X1370 VDD VSS.t1085 VDD VDD sg13_lv_pmos ad=0.19p pd=1.38u as=0 ps=0 w=1u l=1u
X1371 VSS.t1173 VDD VSS.t1172 VSS.t1171 sg13_lv_nmos ad=0.1428p pd=1.52u as=0 ps=0 w=0.42u l=1u
X1372 VSS.t3053 VDD VSS.t3052 VSS.t3051 sg13_lv_nmos ad=0.1428p pd=1.52u as=0 ps=0 w=0.42u l=1u
X1373 VSS.t1436 VDD VSS.t1437 VSS.t311 sg13_lv_nmos ad=79.8f pd=0.8u as=0 ps=0 w=0.42u l=1u
X1374 VSS.t55 a_25094_14484# a_25206_14508# VSS.t25 sg13_lv_nmos ad=0.1426p pd=1.16u as=0.1428p ps=1.52u w=0.42u l=0.5u
X1375 sg13g2_or3_1_1.X a_24841_13726# VSS.t172 VSS.t339 sg13_lv_nmos ad=0.2516p pd=2.16u as=0.13395p ps=1.12u w=0.74u l=0.13u
X1376 VDD VSS.t2045 VDD VDD sg13_lv_pmos ad=0.34p pd=2.68u as=0 ps=0 w=1u l=1u
X1377 VDD VSS.t2809 VDD VDD sg13_lv_pmos ad=0.34p pd=2.68u as=0 ps=0 w=1u l=1u
X1378 VDD VSS.t2605 VDD VDD sg13_lv_pmos ad=0.19p pd=1.38u as=0 ps=0 w=1u l=1u
X1379 VSS.t637 VDD VSS.t43 VSS.t636 sg13_lv_nmos ad=0.1428p pd=1.52u as=0 ps=0 w=0.42u l=1u
X1380 VDD VSS.t1298 VDD VDD sg13_lv_pmos ad=0.19p pd=1.38u as=0 ps=0 w=1u l=1u
X1381 VSS.t1719 VDD VSS.t1718 VSS.t1717 sg13_lv_nmos ad=0.1428p pd=1.52u as=0 ps=0 w=0.42u l=1u
X1382 VSS.t3243 VDD VSS.t3242 VSS.t3241 sg13_lv_nmos ad=0.1428p pd=1.52u as=0 ps=0 w=0.42u l=1u
X1383 VDD VSS.t2392 VDD VDD sg13_lv_pmos ad=0.34p pd=2.68u as=0 ps=0 w=1u l=1u
X1384 a_25109_12972# sg13g2_a21oi_1_3.A1 VDD VDD sg13_lv_pmos ad=0.2128p pd=1.5u as=0.2128p ps=1.5u w=1.12u l=0.13u
X1385 VSS.t2623 VDD VSS.t2625 VSS.t2624 sg13_lv_nmos ad=79.8f pd=0.8u as=0 ps=0 w=0.42u l=1u
X1386 VDD VSS.t681 VDD VDD sg13_lv_pmos ad=0.34p pd=2.68u as=0 ps=0 w=1u l=1u
X1387 VDD VSS.t1728 VDD VDD sg13_lv_pmos ad=0.34p pd=2.68u as=0 ps=0 w=1u l=1u
X1388 VDD VSS.t1382 VDD VDD sg13_lv_pmos ad=0.19p pd=1.38u as=0 ps=0 w=1u l=1u
X1389 VSS.t1619 VDD VSS.t1618 VSS.t1617 sg13_lv_nmos ad=0.1428p pd=1.52u as=0 ps=0 w=0.42u l=1u
X1390 VSS.t2528 VDD VSS.t2527 VSS.t2526 sg13_lv_nmos ad=0.1428p pd=1.52u as=0 ps=0 w=0.42u l=1u
X1391 VSS.t2001 VDD VSS.t2000 VSS.t1999 sg13_lv_nmos ad=0.1428p pd=1.52u as=0 ps=0 w=0.42u l=1u
X1392 VSS.t1789 VDD VSS.t1791 VSS.t1790 sg13_lv_nmos ad=79.8f pd=0.8u as=0 ps=0 w=0.42u l=1u
X1393 VSS.t1332 VDD VSS.t1333 VSS.t311 sg13_lv_nmos ad=79.8f pd=0.8u as=0 ps=0 w=0.42u l=1u
X1394 VDD VSS.t2875 VDD VDD sg13_lv_pmos ad=0.34p pd=2.68u as=0 ps=0 w=1u l=1u
X1395 VDD VSS.t2100 VDD VDD sg13_lv_pmos ad=0.34p pd=2.68u as=0 ps=0 w=1u l=1u
X1396 VSS.t18 clock_i a_15022_14484# VSS.t299 sg13_lv_nmos ad=0.1406p pd=1.12u as=0.1406p ps=1.12u w=0.74u l=0.13u
X1397 VDD VSS.t3225 VDD VDD sg13_lv_pmos ad=0.19p pd=1.38u as=0 ps=0 w=1u l=1u
X1398 VSS.t2493 VDD VSS.t2495 VSS.t2494 sg13_lv_nmos ad=79.8f pd=0.8u as=0 ps=0 w=0.42u l=1u
X1399 a_16485_13701# sg13g2_dfrbpq_1_2.CLK VDD VDD sg13_lv_pmos ad=0.4088p pd=2.97u as=2.3367p ps=15.135u w=1.12u l=0.13u
X1400 VDD VSS.t1052 VDD VDD sg13_lv_pmos ad=0.34p pd=2.68u as=0 ps=0 w=1u l=1u
X1401 VSS.t2799 VDD VSS.t2800 VSS.t392 sg13_lv_nmos ad=79.8f pd=0.8u as=0 ps=0 w=0.42u l=1u
X1402 VDD VSS.t2765 VDD VDD sg13_lv_pmos ad=0.19p pd=1.38u as=0 ps=0 w=1u l=1u
X1403 VDD a_4474_14448# a_4193_14750# VDD sg13_lv_pmos ad=0.1523p pd=1.38u as=0.34p ps=2.68u w=1u l=0.5u
X1404 VSS.t1551 VDD VSS.t1418 VSS.t311 sg13_lv_nmos ad=0.1428p pd=1.52u as=0 ps=0 w=0.42u l=1u
X1405 VSS.t3038 VDD VSS.t3037 VSS.t3036 sg13_lv_nmos ad=0.1428p pd=1.52u as=0 ps=0 w=0.42u l=1u
X1406 VDD VSS.t1424 VDD VDD sg13_lv_pmos ad=0.34p pd=2.68u as=0 ps=0 w=1u l=1u
X1407 VDD VSS.t2432 VDD VDD sg13_lv_pmos ad=0.34p pd=2.68u as=0 ps=0 w=1u l=1u
X1408 VDD VSS.t2800 VDD VDD sg13_lv_pmos ad=0.34p pd=2.68u as=0 ps=0 w=1u l=1u
X1409 VDD sg13g2_buf_1_0.X a_2942_14484# VDD sg13_lv_pmos ad=0.36p pd=2.72u as=0.1225p ps=1.245u w=1u l=0.13u
X1410 a_6540_13238# sg13g2_xnor2_1_2.B VDD VDD sg13_lv_pmos ad=0.1596p pd=1.22u as=0.2891p ps=1.695u w=0.84u l=0.13u
X1411 VDD VSS.t739 VDD VDD sg13_lv_pmos ad=0.34p pd=2.68u as=0 ps=0 w=1u l=1u
X1412 VSS.t1158 VDD VSS.t1157 VSS.t1156 sg13_lv_nmos ad=0.1428p pd=1.52u as=0 ps=0 w=0.42u l=1u
X1413 VDD VSS.t2557 VDD VDD sg13_lv_pmos ad=0.34p pd=2.68u as=0 ps=0 w=1u l=1u
X1414 VDD VSS.t2215 VDD VDD sg13_lv_pmos ad=0.34p pd=2.68u as=0 ps=0 w=1u l=1u
X1415 VDD VSS.t2776 VDD VDD sg13_lv_pmos ad=0.34p pd=2.68u as=0 ps=0 w=1u l=1u
X1416 VDD VSS.t702 VDD VDD sg13_lv_pmos ad=0.19p pd=1.38u as=0 ps=0 w=1u l=1u
X1417 VDD VSS.t1067 VDD VDD sg13_lv_pmos ad=0.34p pd=2.68u as=0 ps=0 w=1u l=1u
X1418 a_21034_14452# a_21477_14495# a_20774_14922# VSS.t51 sg13_lv_nmos ad=79.8f pd=0.8u as=0.1296p ps=1.52u w=0.42u l=0.13u
X1419 VDD VSS.t1462 VDD VDD sg13_lv_pmos ad=0.34p pd=2.68u as=0 ps=0 w=1u l=1u
X1420 VDD VSS.t2885 VDD VDD sg13_lv_pmos ad=0.34p pd=2.68u as=0 ps=0 w=1u l=1u
X1421 VSS.t2829 VDD VSS.t2828 VSS.t392 sg13_lv_nmos ad=0.1428p pd=1.52u as=0 ps=0 w=0.42u l=1u
X1422 VSS.t1579 VDD VSS.t1581 VSS.t1580 sg13_lv_nmos ad=79.8f pd=0.8u as=0 ps=0 w=0.42u l=1u
X1423 sg13g2_a21oi_1_3.A2 a_24169_14508# VSS.t26 VSS.t25 sg13_lv_nmos ad=0.2516p pd=2.16u as=0.13395p ps=1.12u w=0.74u l=0.13u
X1424 VDD VSS.t1130 VDD VDD sg13_lv_pmos ad=0.19p pd=1.38u as=0 ps=0 w=1u l=1u
X1425 VSS.t1173 VDD VSS.t1172 VSS.t1171 sg13_lv_nmos ad=0.1428p pd=1.52u as=0 ps=0 w=0.42u l=1u
X1426 VDD reset_n_i a_1192_9948# VDD sg13_lv_pmos ad=0.2114p pd=1.54u as=0.2856p ps=2.36u w=0.84u l=0.13u
X1427 VSS.t1078 VDD VSS.t1080 VSS.t1079 sg13_lv_nmos ad=79.8f pd=0.8u as=0 ps=0 w=0.42u l=1u
X1428 VDD VSS.t1711 VDD VDD sg13_lv_pmos ad=0.19p pd=1.38u as=0 ps=0 w=1u l=1u
X1429 VSS.t2878 VDD VSS.t2877 VSS.t392 sg13_lv_nmos ad=0.1428p pd=1.52u as=0 ps=0 w=0.42u l=1u
X1430 VSS.t2141 VDD VSS.t2143 VSS.t2142 sg13_lv_nmos ad=79.8f pd=0.8u as=0 ps=0 w=0.42u l=1u
X1431 VSS.t591 VDD VSS.t592 VSS.t9 sg13_lv_nmos ad=79.8f pd=0.8u as=0 ps=0 w=0.42u l=1u
X1432 VDD VSS.t1716 VDD VDD sg13_lv_pmos ad=0.19p pd=1.38u as=0 ps=0 w=1u l=1u
X1433 VDD VSS.t2452 VDD VDD sg13_lv_pmos ad=0.34p pd=2.68u as=0 ps=0 w=1u l=1u
X1434 VDD VSS.t525 VDD VDD sg13_lv_pmos ad=0.34p pd=2.68u as=0 ps=0 w=1u l=1u
X1435 VSS.t707 VDD VSS.t707 VSS.t708 sg13_lv_nmos ad=0.1428p pd=1.52u as=0 ps=0 w=0.42u l=1u
X1436 VSS.t2061 VDD VSS.t2060 VSS.t2059 sg13_lv_nmos ad=0.1428p pd=1.52u as=0 ps=0 w=0.42u l=1u
X1437 a_25774_15423# a_25889_15424# VDD VDD sg13_lv_pmos ad=0.34p pd=2.68u as=0.2254p ps=1.53u w=1u l=0.5u
X1438 VDD VSS.t681 VDD VDD sg13_lv_pmos ad=0.34p pd=2.68u as=0 ps=0 w=1u l=1u
X1439 VDD VSS.t1444 VDD VDD sg13_lv_pmos ad=0.34p pd=2.68u as=0 ps=0 w=1u l=1u
X1440 VDD VSS.t2771 VDD VDD sg13_lv_pmos ad=0.34p pd=2.68u as=0 ps=0 w=1u l=1u
X1441 VSS.t1604 VDD VSS.t1603 VSS.t1602 sg13_lv_nmos ad=0.1428p pd=1.52u as=0 ps=0 w=0.42u l=1u
X1442 VSS.t2513 VDD VSS.t2512 VSS.t2511 sg13_lv_nmos ad=0.1428p pd=1.52u as=0 ps=0 w=0.42u l=1u
X1443 VSS.t531 VDD VSS.t533 VSS.t532 sg13_lv_nmos ad=79.8f pd=0.8u as=0 ps=0 w=0.42u l=1u
X1444 VSS.t1799 VDD VSS.t1798 VSS.t1797 sg13_lv_nmos ad=0.1428p pd=1.52u as=0 ps=0 w=0.42u l=1u
X1445 VSS.t2784 VDD VSS.t2783 VSS.t392 sg13_lv_nmos ad=0.1428p pd=1.52u as=0 ps=0 w=0.42u l=1u
X1446 VDD VSS.t58 VDD VDD sg13_lv_pmos ad=0.19p pd=1.38u as=0 ps=0 w=1u l=1u
X1447 VSS.t2845 VDD VSS.t2846 VSS.t392 sg13_lv_nmos ad=79.8f pd=0.8u as=0 ps=0 w=0.42u l=1u
X1448 a_22319_14845# a_21477_14495# a_21060_14488# VDD sg13_lv_pmos ad=0.2048p pd=1.63u as=0.34p ps=2.68u w=1u l=0.13u
X1449 VSS.t3098 VDD VSS.t3097 VSS.t3096 sg13_lv_nmos ad=0.1428p pd=1.52u as=0 ps=0 w=0.42u l=1u
X1450 VDD VSS.t3210 VDD VDD sg13_lv_pmos ad=0.19p pd=1.38u as=0 ps=0 w=1u l=1u
X1451 VSS.t2478 VDD VSS.t2480 VSS.t2479 sg13_lv_nmos ad=79.8f pd=0.8u as=0 ps=0 w=0.42u l=1u
X1452 VDD VSS.t2420 VDD VDD sg13_lv_pmos ad=0.19p pd=1.38u as=0 ps=0 w=1u l=1u
X1453 VSS.t15 a_14357_15238# sg13g2_or3_1_1.B VSS.t14 sg13_lv_nmos ad=0.1406p pd=1.12u as=0.1406p ps=1.12u w=0.74u l=0.13u
X1454 a_24062_15242# sg13g2_dfrbpq_1_6.Q a_23960_15242# VSS.t24 sg13_lv_nmos ad=0.1406p pd=1.12u as=0.1406p ps=1.12u w=0.74u l=0.13u
X1455 VSS.t1794 VDD VSS.t1793 VSS.t1792 sg13_lv_nmos ad=0.1428p pd=1.52u as=0 ps=0 w=0.42u l=1u
X1456 VSS.t2790 VDD VSS.t2791 VSS.t392 sg13_lv_nmos ad=79.8f pd=0.8u as=0 ps=0 w=0.42u l=1u
X1457 a_8779_14832# sg13g2_buf_1_10.X a_8685_14832# VSS.t269 sg13_lv_nmos ad=0.1216p pd=1.02u as=0.2176p ps=1.96u w=0.64u l=0.13u
X1458 VDD VSS.t1100 VDD VDD sg13_lv_pmos ad=0.19p pd=1.38u as=0 ps=0 w=1u l=1u
X1459 VDD VSS.t3162 VDD VDD sg13_lv_pmos ad=0.34p pd=2.68u as=0 ps=0 w=1u l=1u
X1460 VSS.t2889 VDD VSS.t2888 VSS.t392 sg13_lv_nmos ad=0.1428p pd=1.52u as=0 ps=0 w=0.42u l=1u
X1461 VDD VSS.t2757 VDD VDD sg13_lv_pmos ad=0.19p pd=1.38u as=0 ps=0 w=1u l=1u
X1462 VDD VSS.t1336 VDD VDD sg13_lv_pmos ad=0.19p pd=1.38u as=0 ps=0 w=1u l=1u
X1463 VDD VSS.t1415 VDD VDD sg13_lv_pmos ad=0.34p pd=2.68u as=0 ps=0 w=1u l=1u
X1464 VDD VSS.t2610 VDD VDD sg13_lv_pmos ad=0.19p pd=1.38u as=0 ps=0 w=1u l=1u
X1465 VSS.t2096 VDD VSS.t2095 VSS.t2094 sg13_lv_nmos ad=0.1428p pd=1.52u as=0 ps=0 w=0.42u l=1u
X1466 VDD VSS.t2050 VDD VDD sg13_lv_pmos ad=0.34p pd=2.68u as=0 ps=0 w=1u l=1u
X1467 VDD VSS.t2791 VDD VDD sg13_lv_pmos ad=0.34p pd=2.68u as=0 ps=0 w=1u l=1u
X1468 VSS.t21 sg13g2_dfrbpq_1_6.RESET_B a_20868_14922# VSS.t237 sg13_lv_nmos ad=0.1626p pd=1.415u as=60.89999f ps=0.71u w=0.42u l=0.13u
X1469 VSS.t681 VDD VSS.t681 VSS.t689 sg13_lv_nmos ad=0.1428p pd=1.52u as=0 ps=0 w=0.42u l=1u
X1470 a_17578_14452# a_18021_14495# a_17318_14922# VSS.t149 sg13_lv_nmos ad=79.8f pd=0.8u as=0.1296p ps=1.52u w=0.42u l=0.13u
X1471 VSS.t2628 VDD VSS.t2630 VSS.t2629 sg13_lv_nmos ad=79.8f pd=0.8u as=0 ps=0 w=0.42u l=1u
X1472 sg13g2_or3_1_1.B a_14357_15238# VDD VDD sg13_lv_pmos ad=0.2128p pd=1.5u as=0.203p ps=1.5u w=1.12u l=0.13u
X1473 a_25956_14488# a_25930_14452# VSS.t5 VSS.t169 sg13_lv_nmos ad=0.2516p pd=2.16u as=0.1626p ps=1.415u w=0.74u l=0.13u
X1474 VSS.t624 VDD VSS.t625 VSS.t9 sg13_lv_nmos ad=79.8f pd=0.8u as=0 ps=0 w=0.42u l=1u
X1475 VDD VSS.t975 VDD VDD sg13_lv_pmos ad=0.19p pd=1.38u as=0 ps=0 w=1u l=1u
X1476 VDD VSS.t2570 VDD VDD sg13_lv_pmos ad=0.19p pd=1.38u as=0 ps=0 w=1u l=1u
X1477 VSS.t1589 VDD VSS.t1588 VSS.t1587 sg13_lv_nmos ad=0.1428p pd=1.52u as=0 ps=0 w=0.42u l=1u
X1478 VSS.t519 VDD VSS.t519 VSS.t518 sg13_lv_nmos ad=0.1428p pd=1.52u as=0 ps=0 w=0.42u l=1u
X1479 VSS.t1372 VDD VSS.t1371 VSS.t311 sg13_lv_nmos ad=0.1428p pd=1.52u as=0 ps=0 w=0.42u l=1u
X1480 a_6372_14488# a_6891_14495# a_7631_14845# VSS.t116 sg13_lv_nmos ad=0.3473p pd=2.71u as=0.12665p ps=1.145u w=0.74u l=0.13u
X1481 VSS.t2837 VDD VSS.t2838 VSS.t392 sg13_lv_nmos ad=79.8f pd=0.8u as=0 ps=0 w=0.42u l=1u
X1482 VDD VSS.t455 VDD VDD sg13_lv_pmos ad=0.34p pd=2.68u as=0 ps=0 w=1u l=1u
X1483 VDD VSS.t495 VDD VDD sg13_lv_pmos ad=0.34p pd=2.68u as=0 ps=0 w=1u l=1u
X1484 a_27634_14922# sg13g2_dfrbpq_1_7.RESET_B VSS.t28 VSS.t9 sg13_lv_nmos ad=37.8f pd=0.6u as=79.8f ps=0.8u w=0.42u l=0.13u
X1485 VSS.t11 sg13g2_xnor2_1_2.B a_6575_13342# VSS.t40 sg13_lv_nmos ad=0.1898p pd=1.36u as=0.1406p ps=1.12u w=0.74u l=0.13u
X1486 VDD VSS.t2070 VDD VDD sg13_lv_pmos ad=0.34p pd=2.68u as=0 ps=0 w=1u l=1u
X1487 VDD VSS.t180 VDD VDD sg13_lv_pmos ad=0.19p pd=1.38u as=0 ps=0 w=1u l=1u
X1488 a_20278_14862# sg13g2_or3_1_2.C VSS.t368 VSS.t76 sg13_lv_nmos ad=0.1406p pd=1.12u as=0.1406p ps=1.12u w=0.74u l=0.15u
X1489 a_18478_13911# a_18593_13912# VDD VDD sg13_lv_pmos ad=0.34p pd=2.68u as=0.2254p ps=1.53u w=1u l=0.5u
X1490 VSS.t349 VDD VSS.t733 VSS.t865 sg13_lv_nmos ad=79.8f pd=0.8u as=0 ps=0 w=0.42u l=1u
X1491 VDD VSS.t1296 VDD VDD sg13_lv_pmos ad=0.34p pd=2.68u as=0 ps=0 w=1u l=1u
X1492 VDD VSS.t3230 VDD VDD sg13_lv_pmos ad=0.19p pd=1.38u as=0 ps=0 w=1u l=1u
X1493 VSS.t1078 VDD VSS.t1080 VSS.t1079 sg13_lv_nmos ad=79.8f pd=0.8u as=0 ps=0 w=0.42u l=1u
X1494 VDD VSS.t1355 VDD VDD sg13_lv_pmos ad=0.34p pd=2.68u as=0 ps=0 w=1u l=1u
X1495 VSS.t1123 VDD VSS.t1122 VSS.t1121 sg13_lv_nmos ad=0.1428p pd=1.52u as=0 ps=0 w=0.42u l=1u
X1496 VSS.t1470 VDD VSS.t1313 VSS.t311 sg13_lv_nmos ad=0.1428p pd=1.52u as=0 ps=0 w=0.42u l=1u
X1497 VSS.t3043 VDD VSS.t3042 VSS.t3041 sg13_lv_nmos ad=0.1428p pd=1.52u as=0 ps=0 w=0.42u l=1u
X1498 VSS.t624 VDD VSS.t623 VSS.t9 sg13_lv_nmos ad=0.1428p pd=1.52u as=0 ps=0 w=0.42u l=1u
X1499 a_7888_14726# a_7631_14845# a_8050_14922# VSS.t221 sg13_lv_nmos ad=0.1428p pd=1.52u as=37.8f ps=0.6u w=0.42u l=0.13u
X1500 VSS.t3213 VDD VSS.t3215 VSS.t3214 sg13_lv_nmos ad=79.8f pd=0.8u as=0 ps=0 w=0.42u l=1u
X1501 VSS.t2423 VDD VSS.t2425 VSS.t2424 sg13_lv_nmos ad=79.8f pd=0.8u as=0 ps=0 w=0.42u l=1u
X1502 VDD VSS.t610 VDD VDD sg13_lv_pmos ad=0.19p pd=1.38u as=0 ps=0 w=1u l=1u
X1503 VDD VSS.t2437 VDD VDD sg13_lv_pmos ad=0.34p pd=2.68u as=0 ps=0 w=1u l=1u
X1504 VDD VSS.t1583 VDD VDD sg13_lv_pmos ad=0.34p pd=2.68u as=0 ps=0 w=1u l=1u
X1505 VDD a_10703_15311# a_11370_15532# VDD sg13_lv_pmos ad=0.2128p pd=1.5u as=0.3864p ps=2.93u w=1.12u l=0.13u
X1506 VSS.t2498 VDD VSS.t2500 VSS.t2499 sg13_lv_nmos ad=79.8f pd=0.8u as=0 ps=0 w=0.42u l=1u
X1507 VSS.t2819 VDD VSS.t2818 VSS.t392 sg13_lv_nmos ad=0.1428p pd=1.52u as=0 ps=0 w=0.42u l=1u
X1508 VDD VSS.t2562 VDD VDD sg13_lv_pmos ad=0.34p pd=2.68u as=0 ps=0 w=1u l=1u
X1509 VSS.t2046 VDD VSS.t2045 VSS.t2044 sg13_lv_nmos ad=0.1428p pd=1.52u as=0 ps=0 w=0.42u l=1u
X1510 VDD VSS.t2763 VDD VDD sg13_lv_pmos ad=0.34p pd=2.68u as=0 ps=0 w=1u l=1u
X1511 VSS.t62 sg13g2_a21oi_1_0.Y a_16760_15238# VSS.t411 sg13_lv_nmos ad=79.8f pd=0.8u as=0.1428p ps=1.52u w=0.42u l=0.13u
X1512 VDD VSS.t1718 VDD VDD sg13_lv_pmos ad=0.34p pd=2.68u as=0 ps=0 w=1u l=1u
X1513 VSS.t511 VDD VSS.t510 VSS.t509 sg13_lv_nmos ad=0.1428p pd=1.52u as=0 ps=0 w=0.42u l=1u
X1514 a_25862_13722# a_26667_13844# a_26122_13945# VDD sg13_lv_pmos ad=0.1428p pd=1.52u as=79.8f ps=0.8u w=0.42u l=0.13u
X1515 VSS.t998 VDD VSS.t1000 VSS.t999 sg13_lv_nmos ad=79.8f pd=0.8u as=0 ps=0 w=0.42u l=1u
X1516 VDD VSS.t2138 VDD VDD sg13_lv_pmos ad=0.19p pd=1.38u as=0 ps=0 w=1u l=1u
X1517 a_12020_15202# sg13g2_buf_16_2.A VDD VDD sg13_lv_pmos ad=0.2128p pd=1.5u as=0.2128p ps=1.5u w=1.12u l=0.13u
X1518 VDD VSS.t188 VDD VDD sg13_lv_pmos ad=0.34p pd=2.68u as=0 ps=0 w=1u l=1u
X1519 a_15022_14484# clock_i VDD VDD sg13_lv_pmos ad=0.2128p pd=1.5u as=0.2128p ps=1.5u w=1.12u l=0.13u
X1520 VSS.t105 VDD VSS.t105 VSS.t106 sg13_lv_nmos ad=0.1428p pd=1.52u as=0 ps=0 w=0.42u l=1u
X1521 VDD VSS.t1308 VDD VDD sg13_lv_pmos ad=0.34p pd=2.68u as=0 ps=0 w=1u l=1u
X1522 VDD VSS.t1408 VDD VDD sg13_lv_pmos ad=0.19p pd=1.38u as=0 ps=0 w=1u l=1u
X1523 VDD a_27664_13942# a_27609_14037# VDD sg13_lv_pmos ad=2.42015p pd=15.68u as=93.45f ps=0.865u w=0.42u l=0.13u
X1524 VSS.t2813 VDD VSS.t2812 VSS.t392 sg13_lv_nmos ad=0.1428p pd=1.52u as=0 ps=0 w=0.42u l=1u
X1525 VDD VSS.t1142 VDD VDD sg13_lv_pmos ad=0.34p pd=2.68u as=0 ps=0 w=1u l=1u
X1526 VDD VSS.t3147 VDD VDD sg13_lv_pmos ad=0.34p pd=2.68u as=0 ps=0 w=1u l=1u
X1527 VSS.t2881 VDD VSS.t2880 VSS.t392 sg13_lv_nmos ad=0.1428p pd=1.52u as=0 ps=0 w=0.42u l=1u
X1528 VSS.t2146 VDD VSS.t2148 VSS.t2147 sg13_lv_nmos ad=79.8f pd=0.8u as=0 ps=0 w=0.42u l=1u
X1529 sg13g2_and2_1_2.B a_8694_15302# VSS.t105 VSS.t262 sg13_lv_nmos ad=0.2516p pd=2.16u as=0.1426p ps=1.16u w=0.74u l=0.13u
X1530 VSS.t13 a_12020_15202# sg13g2_dfrbpq_1_2.CLK VSS.t200 sg13_lv_nmos ad=0.1406p pd=1.12u as=0.1406p ps=1.12u w=0.74u l=0.13u
X1531 VSS.t303 a_17327_13799# a_17994_14020# VSS.t310 sg13_lv_nmos ad=0.1406p pd=1.12u as=0.2516p ps=2.16u w=0.74u l=0.13u
X1532 VSS.t3233 VDD VSS.t3235 VSS.t3234 sg13_lv_nmos ad=79.8f pd=0.8u as=0 ps=0 w=0.42u l=1u
X1533 VDD VSS.t757 VDD VDD sg13_lv_pmos ad=0.34p pd=2.68u as=0 ps=0 w=1u l=1u
X1534 VSS.t1445 VDD VSS.t1444 VSS.t311 sg13_lv_nmos ad=0.1428p pd=1.52u as=0 ps=0 w=0.42u l=1u
X1535 VDD VSS.t2595 VDD VDD sg13_lv_pmos ad=0.19p pd=1.38u as=0 ps=0 w=1u l=1u
X1536 VDD VSS.t1776 VDD VDD sg13_lv_pmos ad=0.19p pd=1.38u as=0 ps=0 w=1u l=1u
X1537 VSS.t2066 VDD VSS.t2065 VSS.t2064 sg13_lv_nmos ad=0.1428p pd=1.52u as=0 ps=0 w=0.42u l=1u
X1538 VSS.t854 VDD VSS.t174 VSS.t853 sg13_lv_nmos ad=0.1428p pd=1.52u as=0 ps=0 w=0.42u l=1u
X1539 VSS.t1649 VDD VSS.t1648 VSS.t1647 sg13_lv_nmos ad=0.1428p pd=1.52u as=0 ps=0 w=0.42u l=1u
X1540 VSS.t81 a_22025_16334# a_21946_16237# VSS.t204 sg13_lv_nmos ad=5.24677p pd=34.365u as=0.27427p ps=2.28u w=0.795u l=0.13u
X1541 VSS.t1568 VDD VSS.t1439 VSS.t311 sg13_lv_nmos ad=79.8f pd=0.8u as=0 ps=0 w=0.42u l=1u
X1542 VDD VSS.t2773 VDD VDD sg13_lv_pmos ad=0.34p pd=2.68u as=0 ps=0 w=1u l=1u
X1543 VSS.t546 VDD VSS.t545 VSS.t544 sg13_lv_nmos ad=0.1428p pd=1.52u as=0 ps=0 w=0.42u l=1u
X1544 VSS.t968 VDD VSS.t967 VSS.t966 sg13_lv_nmos ad=0.1428p pd=1.52u as=0 ps=0 w=0.42u l=1u
X1545 VDD VSS.t2871 VDD VDD sg13_lv_pmos ad=0.19p pd=1.38u as=0 ps=0 w=1u l=1u
X1546 VSS.t2176 VDD VSS.t2175 VSS.t2174 sg13_lv_nmos ad=0.1428p pd=1.52u as=0 ps=0 w=0.42u l=1u
X1547 VDD VSS.t1020 VDD VDD sg13_lv_pmos ad=0.19p pd=1.38u as=0 ps=0 w=1u l=1u
X1548 VDD VSS.t2465 VDD VDD sg13_lv_pmos ad=0.19p pd=1.38u as=0 ps=0 w=1u l=1u
X1549 VDD VSS.t2123 VDD VDD sg13_lv_pmos ad=0.19p pd=1.38u as=0 ps=0 w=1u l=1u
X1550 VDD a_27215_14845# a_27882_14484# VDD sg13_lv_pmos ad=0.2128p pd=1.5u as=0.3864p ps=2.93u w=1.12u l=0.13u
X1551 VSS.t2787 VDD VSS.t2785 VSS.t392 sg13_lv_nmos ad=0.1428p pd=1.52u as=0 ps=0 w=0.42u l=1u
X1552 sg13g2_dfrbpq_1_2.CLK a_12020_15202# VDD VDD sg13_lv_pmos ad=0.2128p pd=1.5u as=0.2128p ps=1.5u w=1.12u l=0.13u
X1553 VSS.t757 VDD VSS.t760 VSS.t883 sg13_lv_nmos ad=79.8f pd=0.8u as=0 ps=0 w=0.42u l=1u
X1554 VDD VSS.t2248 VDD VDD sg13_lv_pmos ad=0.19p pd=1.38u as=0 ps=0 w=1u l=1u
X1555 VSS.t360 a_2540_15960# counter_value_o[0] VSS.t423 sg13_lv_nmos ad=0.14875p pd=1.16u as=0.2886p ps=2.26u w=0.74u l=0.13u
X1556 a_25670_14922# a_26475_14495# a_25930_14452# VDD sg13_lv_pmos ad=0.1428p pd=1.52u as=79.8f ps=0.8u w=0.42u l=0.13u
X1557 VSS.t1123 VDD VSS.t1122 VSS.t1121 sg13_lv_nmos ad=0.1428p pd=1.52u as=0 ps=0 w=0.42u l=1u
X1558 VSS.t2483 VDD VSS.t2485 VSS.t2484 sg13_lv_nmos ad=79.8f pd=0.8u as=0 ps=0 w=0.42u l=1u
X1559 VDD VSS.t164 VDD VDD sg13_lv_pmos ad=0.34p pd=2.68u as=0 ps=0 w=1u l=1u
X1560 VDD VSS.t1105 VDD VDD sg13_lv_pmos ad=0.19p pd=1.38u as=0 ps=0 w=1u l=1u
X1561 VDD VSS.t1581 VDD VDD sg13_lv_pmos ad=0.19p pd=1.38u as=0 ps=0 w=1u l=1u
X1562 VSS.t393 enable_i a_1192_3900# VSS.t392 sg13_lv_nmos ad=0.14875p pd=1.16u as=0.187p ps=1.78u w=0.55u l=0.13u
X1563 VSS.t1335 VDD VSS.t1336 VSS.t311 sg13_lv_nmos ad=79.8f pd=0.8u as=0 ps=0 w=0.42u l=1u
X1564 VSS.t360 VDD VSS.t360 VSS.t440 sg13_lv_nmos ad=0.1428p pd=1.52u as=0 ps=0 w=0.42u l=1u
X1565 VSS.t58 VDD VSS.t58 VSS.t577 sg13_lv_nmos ad=0.1428p pd=1.52u as=0 ps=0 w=0.42u l=1u
X1566 VSS.t3028 VDD VSS.t3027 VSS.t3026 sg13_lv_nmos ad=0.1428p pd=1.52u as=0 ps=0 w=0.42u l=1u
X1567 VDD VSS.t553 VDD VDD sg13_lv_pmos ad=0.19p pd=1.38u as=0 ps=0 w=1u l=1u
X1568 VSS.t188 a_12020_15202# sg13g2_dfrbpq_1_2.CLK VSS.t196 sg13_lv_nmos ad=0.1406p pd=1.12u as=0.1406p ps=1.12u w=0.74u l=0.13u
X1569 sg13g2_dfrbpq_1_5.D a_25206_14508# VDD VDD sg13_lv_pmos ad=0.4256p pd=3u as=0.2254p ps=1.53u w=1.12u l=0.13u
X1570 VDD sg13g2_or3_1_1.A a_25037_14020# VDD sg13_lv_pmos ad=0.3822p pd=1.84u as=0.1575p ps=1.315u w=1u l=0.13u
X1571 VDD VSS.t1418 VDD VDD sg13_lv_pmos ad=0.34p pd=2.68u as=0 ps=0 w=1u l=1u
X1572 VDD VSS.t2615 VDD VDD sg13_lv_pmos ad=0.19p pd=1.38u as=0 ps=0 w=1u l=1u
X1573 VSS.t26 sg13g2_o21ai_1_2.B1 a_24169_14508# VSS.t25 sg13_lv_nmos ad=0.13395p pd=1.12u as=0.198p ps=1.27u w=0.55u l=0.13u
X1574 VDD VSS.t2794 VDD VDD sg13_lv_pmos ad=0.34p pd=2.68u as=0 ps=0 w=1u l=1u
X1575 VSS.t1599 VDD VSS.t1598 VSS.t1597 sg13_lv_nmos ad=0.1428p pd=1.52u as=0 ps=0 w=0.42u l=1u
X1576 VSS.t928 VDD VSS.t930 VSS.t929 sg13_lv_nmos ad=79.8f pd=0.8u as=0 ps=0 w=0.42u l=1u
X1577 VSS.t998 VDD VSS.t1000 VSS.t999 sg13_lv_nmos ad=79.8f pd=0.8u as=0 ps=0 w=0.42u l=1u
X1578 VDD VSS.t987 VDD VDD sg13_lv_pmos ad=0.34p pd=2.68u as=0 ps=0 w=1u l=1u
X1579 VSS.t2161 VDD VSS.t2160 VSS.t2159 sg13_lv_nmos ad=0.1428p pd=1.52u as=0 ps=0 w=0.42u l=1u
X1580 a_4594_15234# sg13g2_dfrbpq_1_0.RESET_B VSS.t48 VSS.t341 sg13_lv_nmos ad=37.8f pd=0.6u as=79.8f ps=0.8u w=0.42u l=0.13u
X1581 a_5707_14832# sg13g2_buf_1_10.X a_5613_14832# VSS.t268 sg13_lv_nmos ad=0.1216p pd=1.02u as=0.2176p ps=1.96u w=0.64u l=0.13u
X1582 sg13g2_and2_1_2.X a_8685_14832# VDD VDD sg13_lv_pmos ad=0.3808p pd=2.92u as=0.1918p ps=1.5u w=1.12u l=0.13u
X1583 sg13g2_buf_16_2.X a_19438_13726# VDD VDD sg13_lv_pmos ad=0.2128p pd=1.5u as=0.2128p ps=1.5u w=1.12u l=0.13u
X1584 VSS.t1594 VDD VSS.t1593 VSS.t1592 sg13_lv_nmos ad=0.1428p pd=1.52u as=0 ps=0 w=0.42u l=1u
X1585 a_6598_14909# sg13g2_dfrbpq_1_1.RESET_B VSS.t58 VSS.t70 sg13_lv_nmos ad=37.8f pd=0.6u as=0.1701p ps=1.65u w=0.42u l=0.13u
X1586 VSS.t2778 VDD VSS.t2777 VSS.t392 sg13_lv_nmos ad=0.1428p pd=1.52u as=0 ps=0 w=0.42u l=1u
X1587 VSS.t2503 VDD VSS.t2502 VSS.t2501 sg13_lv_nmos ad=0.1428p pd=1.52u as=0 ps=0 w=0.42u l=1u
X1588 VSS.t739 VDD VSS.t739 VSS.t870 sg13_lv_nmos ad=0.1428p pd=1.52u as=0 ps=0 w=0.42u l=1u
X1589 VSS.t1764 VDD VSS.t1766 VSS.t1765 sg13_lv_nmos ad=79.8f pd=0.8u as=0 ps=0 w=0.42u l=1u
X1590 VDD VSS.t245 VDD VDD sg13_lv_pmos ad=0.19p pd=1.38u as=0 ps=0 w=1u l=1u
X1591 VDD VSS.t2075 VDD VDD sg13_lv_pmos ad=0.34p pd=2.68u as=0 ps=0 w=1u l=1u
X1592 VDD VSS.t1299 VDD VDD sg13_lv_pmos ad=0.34p pd=2.68u as=0 ps=0 w=1u l=1u
X1593 a_9444_15552# a_9418_15457# VDD VDD sg13_lv_pmos ad=0.34p pd=2.68u as=0.36237p ps=2.605u w=1u l=0.13u
X1594 VSS.t5 a_26170_15202# a_25889_15424# VSS.t413 sg13_lv_nmos ad=79.8f pd=0.8u as=0.1428p ps=1.52u w=0.42u l=0.5u
X1595 VDD VSS.t1050 VDD VDD sg13_lv_pmos ad=0.19p pd=1.38u as=0 ps=0 w=1u l=1u
X1596 VSS.t1310 VDD VSS.t1309 VSS.t311 sg13_lv_nmos ad=0.1428p pd=1.52u as=0 ps=0 w=0.42u l=1u
X1597 VDD VSS.t3200 VDD VDD sg13_lv_pmos ad=0.19p pd=1.38u as=0 ps=0 w=1u l=1u
X1598 VDD VSS.t2410 VDD VDD sg13_lv_pmos ad=0.19p pd=1.38u as=0 ps=0 w=1u l=1u
X1599 VSS.t2131 VDD VSS.t2133 VSS.t2132 sg13_lv_nmos ad=79.8f pd=0.8u as=0 ps=0 w=0.42u l=1u
X1600 VSS.t2856 VDD VSS.t2855 VSS.t392 sg13_lv_nmos ad=0.1428p pd=1.52u as=0 ps=0 w=0.42u l=1u
X1601 VSS.t3218 VDD VSS.t3220 VSS.t3219 sg13_lv_nmos ad=79.8f pd=0.8u as=0 ps=0 w=0.42u l=1u
X1602 VDD VSS.t2442 VDD VDD sg13_lv_pmos ad=0.34p pd=2.68u as=0 ps=0 w=1u l=1u
X1603 VDD VSS.t1761 VDD VDD sg13_lv_pmos ad=0.19p pd=1.38u as=0 ps=0 w=1u l=1u
X1604 VSS.t968 VDD VSS.t967 VSS.t966 sg13_lv_nmos ad=0.1428p pd=1.52u as=0 ps=0 w=0.42u l=1u
X1605 VDD VSS.t950 VDD VDD sg13_lv_pmos ad=0.19p pd=1.38u as=0 ps=0 w=1u l=1u
X1606 VSS.t2051 VDD VSS.t2050 VSS.t2049 sg13_lv_nmos ad=0.1428p pd=1.52u as=0 ps=0 w=0.42u l=1u
X1607 sg13g2_nand4_1_0.Y sg13g2_buf_1_0.X VDD VDD sg13_lv_pmos ad=0.2128p pd=1.5u as=0.2128p ps=1.5u w=1.12u l=0.13u
X1608 a_6578_15242# sg13g2_dlygate4sd3_1_3.A VSS.t58 VSS.t356 sg13_lv_nmos ad=0.1406p pd=1.12u as=0.2886p ps=2.26u w=0.74u l=0.13u
X1609 VSS.t594 VDD VSS.t595 VSS.t9 sg13_lv_nmos ad=79.8f pd=0.8u as=0 ps=0 w=0.42u l=1u
X1610 VDD VSS.t1713 VDD VDD sg13_lv_pmos ad=0.34p pd=2.68u as=0 ps=0 w=1u l=1u
X1611 VSS.t2802 VDD VSS.t2801 VSS.t392 sg13_lv_nmos ad=0.1428p pd=1.52u as=0 ps=0 w=0.42u l=1u
X1612 VDD VSS.t2766 VDD VDD sg13_lv_pmos ad=0.34p pd=2.68u as=0 ps=0 w=1u l=1u
X1613 VDD VSS.t530 VDD VDD sg13_lv_pmos ad=0.34p pd=2.68u as=0 ps=0 w=1u l=1u
X1614 VDD VSS.t1065 VDD VDD sg13_lv_pmos ad=0.19p pd=1.38u as=0 ps=0 w=1u l=1u
X1615 VSS.t1505 VDD VSS.t1357 VSS.t311 sg13_lv_nmos ad=0.1428p pd=1.52u as=0 ps=0 w=0.42u l=1u
X1616 a_18863_14845# a_18021_14495# a_17604_14488# VDD sg13_lv_pmos ad=0.2048p pd=1.63u as=0.34p ps=2.68u w=1u l=0.13u
X1617 sg13g2_buf_16_2.X a_19438_13726# VDD VDD sg13_lv_pmos ad=0.2128p pd=1.5u as=0.2128p ps=1.5u w=1.12u l=0.13u
X1618 VSS.t1784 VDD VSS.t1786 VSS.t1785 sg13_lv_nmos ad=79.8f pd=0.8u as=0 ps=0 w=0.42u l=1u
X1619 VDD VSS.t2627 VDD VDD sg13_lv_pmos ad=0.34p pd=2.68u as=0 ps=0 w=1u l=1u
X1620 VDD VSS.t2450 VDD VDD sg13_lv_pmos ad=0.19p pd=1.38u as=0 ps=0 w=1u l=1u
X1621 VSS.t681 VDD VSS.t681 VSS.t689 sg13_lv_nmos ad=0.1428p pd=1.52u as=0 ps=0 w=0.42u l=1u
X1622 VDD VSS.t2872 VDD VDD sg13_lv_pmos ad=0.34p pd=2.68u as=0 ps=0 w=1u l=1u
X1623 VSS.t246 a_27215_14845# a_27882_14484# VSS.t9 sg13_lv_nmos ad=0.1406p pd=1.12u as=0.2516p ps=2.16u w=0.74u l=0.13u
X1624 VSS.t1400 VDD VSS.t1399 VSS.t311 sg13_lv_nmos ad=0.1428p pd=1.52u as=0 ps=0 w=0.42u l=1u
X1625 VDD VSS.t1411 VDD VDD sg13_lv_pmos ad=0.19p pd=1.38u as=0 ps=0 w=1u l=1u
X1626 VDD VSS.t2233 VDD VDD sg13_lv_pmos ad=0.19p pd=1.38u as=0 ps=0 w=1u l=1u
X1627 VSS.t11 VDD VSS.t54 VSS.t697 sg13_lv_nmos ad=79.8f pd=0.8u as=0 ps=0 w=0.42u l=1u
X1628 VSS.t748 VDD VSS.t748 VSS.t749 sg13_lv_nmos ad=79.8f pd=0.8u as=0 ps=0 w=0.42u l=1u
X1629 sg13g2_a21oi_1_3.Y sg13g2_a21oi_1_0.B1 a_25109_12972# VDD sg13_lv_pmos ad=0.3808p pd=2.92u as=0.2128p ps=1.5u w=1.12u l=0.13u
X1630 VSS.t1098 VDD VSS.t1100 VSS.t1099 sg13_lv_nmos ad=79.8f pd=0.8u as=0 ps=0 w=0.42u l=1u
X1631 a_26373_16033# a_26373_16033# VSS.t81 VSS.t85 sg13_lv_nmos ad=0.111p pd=1.34u as=5.24677p ps=34.365u w=0.3u l=0.13u
X1632 a_4377_15549# a_3435_15356# a_4175_15311# VDD sg13_lv_pmos ad=93.45f pd=0.865u as=0.2048p ps=1.63u w=0.42u l=0.13u
X1633 VSS.t603 VDD VSS.t604 VSS.t9 sg13_lv_nmos ad=79.8f pd=0.8u as=0 ps=0 w=0.42u l=1u
X1634 VDD VSS.t3152 VDD VDD sg13_lv_pmos ad=0.34p pd=2.68u as=0 ps=0 w=1u l=1u
X1635 VSS.t2363 VDD VSS.t2365 VSS.t2364 sg13_lv_nmos ad=79.8f pd=0.8u as=0 ps=0 w=0.42u l=1u
X1636 VSS.t928 VDD VSS.t930 VSS.t929 sg13_lv_nmos ad=79.8f pd=0.8u as=0 ps=0 w=0.42u l=1u
X1637 VDD VSS.t2600 VDD VDD sg13_lv_pmos ad=0.19p pd=1.38u as=0 ps=0 w=1u l=1u
X1638 VDD VSS.t1781 VDD VDD sg13_lv_pmos ad=0.19p pd=1.38u as=0 ps=0 w=1u l=1u
X1639 VSS.t466 VDD VSS.t355 VSS.t465 sg13_lv_nmos ad=0.1428p pd=1.52u as=0 ps=0 w=0.42u l=1u
X1640 VDD VSS.t184 VDD VDD sg13_lv_pmos ad=0.19p pd=1.38u as=0 ps=0 w=1u l=1u
X1641 VSS.t1584 VDD VSS.t1583 VSS.t1582 sg13_lv_nmos ad=0.1428p pd=1.52u as=0 ps=0 w=0.42u l=1u
X1642 VSS.t1408 VDD VSS.t1408 VSS.t311 sg13_lv_nmos ad=0.1428p pd=1.52u as=0 ps=0 w=0.42u l=1u
X1643 VDD VSS.t2758 VDD VDD sg13_lv_pmos ad=0.34p pd=2.68u as=0 ps=0 w=1u l=1u
X1644 a_17900_15960# sg13g2_dfrbpq_1_2.Q VSS.t378 VSS.t435 sg13_lv_nmos ad=0.187p pd=1.78u as=0.14875p ps=1.16u w=0.55u l=0.13u
X1645 a_7680_15549# sg13g2_nand3_1_0.Y a_7643_15280# VSS.t37 sg13_lv_nmos ad=0.2176p pd=1.96u as=78.39999f ps=0.885u w=0.64u l=0.13u
X1646 sg13g2_dfrbpq_1_6.Q a_22986_14484# VDD VDD sg13_lv_pmos ad=0.3808p pd=2.92u as=0.2128p ps=1.5u w=1.12u l=0.13u
X1647 sg13g2_buf_16_2.X a_19438_13726# VSS.t319 VSS.t324 sg13_lv_nmos ad=0.1406p pd=1.12u as=0.1406p ps=1.12u w=0.74u l=0.13u
X1648 VSS.t2146 VDD VSS.t2145 VSS.t2144 sg13_lv_nmos ad=0.1428p pd=1.52u as=0 ps=0 w=0.42u l=1u
X1649 VDD VSS.t1333 VDD VDD sg13_lv_pmos ad=0.34p pd=2.68u as=0 ps=0 w=1u l=1u
X1650 VDD VSS.t1305 VDD VDD sg13_lv_pmos ad=0.19p pd=1.38u as=0 ps=0 w=1u l=1u
X1651 VSS.t1579 VDD VSS.t1578 VSS.t1577 sg13_lv_nmos ad=0.1428p pd=1.52u as=0 ps=0 w=0.42u l=1u
X1652 VSS.t1413 VDD VSS.t1412 VSS.t311 sg13_lv_nmos ad=0.1428p pd=1.52u as=0 ps=0 w=0.42u l=1u
X1653 VSS.t2769 VDD VSS.t2768 VSS.t392 sg13_lv_nmos ad=0.1428p pd=1.52u as=0 ps=0 w=0.42u l=1u
X1654 VSS.t455 VDD VSS.t454 VSS.t453 sg13_lv_nmos ad=0.1428p pd=1.52u as=0 ps=0 w=0.42u l=1u
X1655 VSS.t2831 VDD VSS.t2962 VSS.t392 sg13_lv_nmos ad=79.8f pd=0.8u as=0 ps=0 w=0.42u l=1u
X1656 VSS.t2583 VDD VSS.t2582 VSS.t2581 sg13_lv_nmos ad=0.1428p pd=1.52u as=0 ps=0 w=0.42u l=1u
X1657 VSS.t2488 VDD VSS.t2490 VSS.t2489 sg13_lv_nmos ad=79.8f pd=0.8u as=0 ps=0 w=0.42u l=1u
X1658 VDD VSS.t3185 VDD VDD sg13_lv_pmos ad=0.19p pd=1.38u as=0 ps=0 w=1u l=1u
X1659 VDD VSS.t2395 VDD VDD sg13_lv_pmos ad=0.19p pd=1.38u as=0 ps=0 w=1u l=1u
X1660 a_9444_15552# a_9418_15457# VSS.t105 VSS.t106 sg13_lv_nmos ad=0.2516p pd=2.16u as=0.1626p ps=1.415u w=0.74u l=0.13u
X1661 VSS.t172 VDD VSS.t172 VSS.t852 sg13_lv_nmos ad=79.8f pd=0.8u as=0 ps=0 w=0.42u l=1u
X1662 VSS.t580 VDD VSS.t66 VSS.t24 sg13_lv_nmos ad=0.1428p pd=1.52u as=0 ps=0 w=0.42u l=1u
X1663 VDD VSS.t733 VDD VDD sg13_lv_pmos ad=0.34p pd=2.68u as=0 ps=0 w=1u l=1u
X1664 VSS.t2848 VDD VSS.t2847 VSS.t392 sg13_lv_nmos ad=0.1428p pd=1.52u as=0 ps=0 w=0.42u l=1u
X1665 sg13g2_a21oi_1_0.B1 sg13g2_buf_1_10.X VSS.t13 VSS.t270 sg13_lv_nmos ad=0.2516p pd=2.16u as=0.2516p ps=2.16u w=0.74u l=0.13u
X1666 VDD VSS.t712 VDD VDD sg13_lv_pmos ad=0.19p pd=1.38u as=0 ps=0 w=1u l=1u
X1667 VDD VSS.t2585 VDD VDD sg13_lv_pmos ad=0.19p pd=1.38u as=0 ps=0 w=1u l=1u
X1668 VSS.t1128 VDD VSS.t1130 VSS.t1129 sg13_lv_nmos ad=79.8f pd=0.8u as=0 ps=0 w=0.42u l=1u
X1669 VDD VSS.t1313 VDD VDD sg13_lv_pmos ad=0.19p pd=1.38u as=0 ps=0 w=1u l=1u
X1670 a_20774_14922# sg13g2_dfrbpq_1_6.D VDD VDD sg13_lv_pmos ad=79.8f pd=0.8u as=0.1428p ps=1.52u w=0.42u l=0.13u
X1671 VDD sg13g2_xor2_1_0.B a_2516_14484# VDD sg13_lv_pmos ad=0.2128p pd=1.5u as=0.2128p ps=1.5u w=1.12u l=0.13u
X1672 VSS.t1774 VDD VSS.t1776 VSS.t1775 sg13_lv_nmos ad=79.8f pd=0.8u as=0 ps=0 w=0.42u l=1u
X1673 VSS.t3298 VDD VSS.t3300 VSS.t3299 sg13_lv_nmos ad=79.8f pd=0.8u as=0 ps=0 w=0.42u l=1u
X1674 a_17327_13799# a_16485_13701# a_17233_13799# VSS.t294 sg13_lv_nmos ad=0.12665p pd=1.145u as=0.1428p ps=1.52u w=0.42u l=0.13u
X1675 VDD VSS.t1698 VDD VDD sg13_lv_pmos ad=0.34p pd=2.68u as=0 ps=0 w=1u l=1u
X1676 VSS.t2166 VDD VSS.t2165 VSS.t2164 sg13_lv_nmos ad=0.1428p pd=1.52u as=0 ps=0 w=0.42u l=1u
X1677 sg13g2_buf_16_2.X a_19438_13726# VSS.t319 VSS.t320 sg13_lv_nmos ad=0.1406p pd=1.12u as=0.1406p ps=1.12u w=0.74u l=0.13u
X1678 VDD VSS.t519 VDD VDD sg13_lv_pmos ad=0.34p pd=2.68u as=0 ps=0 w=1u l=1u
X1679 VDD VSS.t932 VDD VDD sg13_lv_pmos ad=0.34p pd=2.68u as=0 ps=0 w=1u l=1u
X1680 VDD VSS.t2612 VDD VDD sg13_lv_pmos ad=0.34p pd=2.68u as=0 ps=0 w=1u l=1u
X1681 VSS.t1769 VDD VSS.t1771 VSS.t1770 sg13_lv_nmos ad=79.8f pd=0.8u as=0 ps=0 w=0.42u l=1u
X1682 VSS.t1426 VDD VSS.t1425 VSS.t311 sg13_lv_nmos ad=0.1428p pd=1.52u as=0 ps=0 w=0.42u l=1u
X1683 VDD VSS.t2640 VDD VDD sg13_lv_pmos ad=0.19p pd=1.38u as=0 ps=0 w=1u l=1u
X1684 VDD VSS.t2080 VDD VDD sg13_lv_pmos ad=0.34p pd=2.68u as=0 ps=0 w=1u l=1u
X1685 VSS.t386 a_21562_15960# a_21281_16262# VSS.t385 sg13_lv_nmos ad=79.8f pd=0.8u as=0.1428p ps=1.52u w=0.42u l=0.5u
X1686 a_2490_14447# sg13g2_xor2_1_0.B VSS.t213 VSS.t255 sg13_lv_nmos ad=0.17462p pd=1.185u as=0.15245p ps=1.17u w=0.55u l=0.13u
X1687 VSS.t1098 VDD VSS.t1100 VSS.t1099 sg13_lv_nmos ad=79.8f pd=0.8u as=0 ps=0 w=0.42u l=1u
X1688 VDD VSS.t1302 VDD VDD sg13_lv_pmos ad=0.34p pd=2.68u as=0 ps=0 w=1u l=1u
X1689 VSS.t516 VDD VSS.t515 VSS.t514 sg13_lv_nmos ad=0.1428p pd=1.52u as=0 ps=0 w=0.42u l=1u
X1690 VDD VSS.t3205 VDD VDD sg13_lv_pmos ad=0.19p pd=1.38u as=0 ps=0 w=1u l=1u
X1691 VDD VSS.t2415 VDD VDD sg13_lv_pmos ad=0.19p pd=1.38u as=0 ps=0 w=1u l=1u
X1692 VSS.t2246 VDD VSS.t2248 VSS.t2247 sg13_lv_nmos ad=79.8f pd=0.8u as=0 ps=0 w=0.42u l=1u
X1693 VSS.t486 VDD VSS.t481 VSS.t485 sg13_lv_nmos ad=0.1428p pd=1.52u as=0 ps=0 w=0.42u l=1u
X1694 VDD VSS.t622 VDD VDD sg13_lv_pmos ad=0.19p pd=1.38u as=0 ps=0 w=1u l=1u
X1695 sg13g2_and2_1_1.X a_5613_14832# VDD VDD sg13_lv_pmos ad=0.3808p pd=2.92u as=0.1918p ps=1.5u w=1.12u l=0.13u
X1696 VDD VSS.t985 VDD VDD sg13_lv_pmos ad=0.19p pd=1.38u as=0 ps=0 w=1u l=1u
X1697 VDD VSS.t1404 VDD VDD sg13_lv_pmos ad=0.19p pd=1.38u as=0 ps=0 w=1u l=1u
X1698 VSS.t2840 VDD VSS.t2839 VSS.t392 sg13_lv_nmos ad=0.1428p pd=1.52u as=0 ps=0 w=0.42u l=1u
X1699 VDD VSS.t2088 VDD VDD sg13_lv_pmos ad=0.19p pd=1.38u as=0 ps=0 w=1u l=1u
X1700 VSS.t88 a_27500_15960# counter_value_o[5] VSS.t242 sg13_lv_nmos ad=0.14875p pd=1.16u as=0.2886p ps=2.26u w=0.74u l=0.13u
X1701 VDD VSS.t1150 VDD VDD sg13_lv_pmos ad=0.19p pd=1.38u as=0 ps=0 w=1u l=1u
X1702 VDD VSS.t1711 VDD VDD sg13_lv_pmos ad=0.19p pd=1.38u as=0 ps=0 w=1u l=1u
X1703 VDD VSS.t3232 VDD VDD sg13_lv_pmos ad=0.34p pd=2.68u as=0 ps=0 w=1u l=1u
X1704 VSS.t2196 VDD VSS.t2198 VSS.t2197 sg13_lv_nmos ad=79.8f pd=0.8u as=0 ps=0 w=0.42u l=1u
X1705 VSS.t3283 VDD VSS.t3285 VSS.t3284 sg13_lv_nmos ad=79.8f pd=0.8u as=0 ps=0 w=0.42u l=1u
X1706 a_4432_15454# a_4175_15311# a_4594_15234# VSS.t56 sg13_lv_nmos ad=0.1428p pd=1.52u as=37.8f ps=0.6u w=0.42u l=0.13u
X1707 VSS.t2805 VDD VSS.t2803 VSS.t392 sg13_lv_nmos ad=0.1428p pd=1.52u as=0 ps=0 w=0.42u l=1u
X1708 VSS.t1018 VDD VSS.t1020 VSS.t1019 sg13_lv_nmos ad=79.8f pd=0.8u as=0 ps=0 w=0.42u l=1u
X1709 a_6202_15238# sg13g2_dlygate4sd3_1_3.A VSS.t58 VSS.t358 sg13_lv_nmos ad=0.1406p pd=1.12u as=0.2516p ps=2.16u w=0.74u l=0.13u
X1710 sg13g2_dfrbpq_1_6.Q a_22986_14484# VSS.t66 VSS.t25 sg13_lv_nmos ad=0.2516p pd=2.16u as=0.1406p ps=1.12u w=0.74u l=0.13u
X1711 VDD VSS.t1087 VDD VDD sg13_lv_pmos ad=0.34p pd=2.68u as=0 ps=0 w=1u l=1u
X1712 a_7829_15238# sg13g2_nand3_1_0.Y VSS.t39 VSS.t38 sg13_lv_nmos ad=0.1406p pd=1.12u as=0.1898p ps=1.36u w=0.74u l=0.13u
X1713 VSS.t43 a_10618_14448# a_10337_14750# VSS.t64 sg13_lv_nmos ad=79.8f pd=0.8u as=0.1428p ps=1.52u w=0.42u l=0.5u
X1714 VDD VSS.t2455 VDD VDD sg13_lv_pmos ad=0.19p pd=1.38u as=0 ps=0 w=1u l=1u
X1715 VDD VSS.t2113 VDD VDD sg13_lv_pmos ad=0.19p pd=1.38u as=0 ps=0 w=1u l=1u
X1716 VSS.t2116 VDD VSS.t2115 VSS.t2114 sg13_lv_nmos ad=0.1428p pd=1.52u as=0 ps=0 w=0.42u l=1u
X1717 VDD sg13g2_or3_1_2.A sg13g2_o21ai_1_1.Y VDD sg13_lv_pmos ad=0.3808p pd=2.92u as=0.2128p ps=1.5u w=1.12u l=0.15u
X1718 VSS.t1568 VDD VSS.t1438 VSS.t311 sg13_lv_nmos ad=0.1428p pd=1.52u as=0 ps=0 w=0.42u l=1u
X1719 a_2630_15234# sg13g2_and2_1_0.X VDD VDD sg13_lv_pmos ad=79.8f pd=0.8u as=0.1428p ps=1.52u w=0.42u l=0.13u
X1720 VDD VSS.t2238 VDD VDD sg13_lv_pmos ad=0.19p pd=1.38u as=0 ps=0 w=1u l=1u
X1721 VSS.t2473 VDD VSS.t2475 VSS.t2474 sg13_lv_nmos ad=79.8f pd=0.8u as=0 ps=0 w=0.42u l=1u
X1722 a_6372_14488# a_6346_14452# VSS.t58 VSS.t100 sg13_lv_nmos ad=0.2516p pd=2.16u as=0.1626p ps=1.415u w=0.74u l=0.13u
X1723 VSS.t2026 VDD VSS.t2028 VSS.t2027 sg13_lv_nmos ad=79.8f pd=0.8u as=0 ps=0 w=0.42u l=1u
X1724 VDD VSS.t602 VDD VDD sg13_lv_pmos ad=0.34p pd=2.68u as=0 ps=0 w=1u l=1u
X1725 VSS.t2999 VDD VSS.t2875 VSS.t392 sg13_lv_nmos ad=79.8f pd=0.8u as=0 ps=0 w=0.42u l=1u
X1726 VDD a_14357_15238# sg13g2_or3_1_1.B VDD sg13_lv_pmos ad=0.2128p pd=1.5u as=0.2128p ps=1.5u w=1.12u l=0.13u
X1727 VDD VSS.t771 VDD VDD sg13_lv_pmos ad=0.34p pd=2.68u as=0 ps=0 w=1u l=1u
X1728 VDD VSS.t528 VDD VDD sg13_lv_pmos ad=0.19p pd=1.38u as=0 ps=0 w=1u l=1u
X1729 VSS.t1128 VDD VSS.t1130 VSS.t1129 sg13_lv_nmos ad=79.8f pd=0.8u as=0 ps=0 w=0.42u l=1u
X1730 VDD VSS.t1384 VDD VDD sg13_lv_pmos ad=0.34p pd=2.68u as=0 ps=0 w=1u l=1u
X1731 VSS.t81 a_26249_16334# a_26170_16237# VSS.t240 sg13_lv_nmos ad=5.24677p pd=34.365u as=0.27427p ps=2.28u w=0.795u l=0.13u
X1732 a_8050_14922# sg13g2_dfrbpq_1_1.RESET_B VSS.t39 VSS.t71 sg13_lv_nmos ad=37.8f pd=0.6u as=79.8f ps=0.8u w=0.42u l=0.13u
X1733 VDD VSS.t712 VDD VDD sg13_lv_pmos ad=0.19p pd=1.38u as=0 ps=0 w=1u l=1u
X1734 VDD VSS.t1102 VDD VDD sg13_lv_pmos ad=0.34p pd=2.68u as=0 ps=0 w=1u l=1u
X1735 VDD VSS.t1751 VDD VDD sg13_lv_pmos ad=0.19p pd=1.38u as=0 ps=0 w=1u l=1u
X1736 VDD VSS.t3217 VDD VDD sg13_lv_pmos ad=0.34p pd=2.68u as=0 ps=0 w=1u l=1u
X1737 VDD VSS.t2427 VDD VDD sg13_lv_pmos ad=0.34p pd=2.68u as=0 ps=0 w=1u l=1u
X1738 VSS.t988 VDD VSS.t987 VSS.t986 sg13_lv_nmos ad=0.1428p pd=1.52u as=0 ps=0 w=0.42u l=1u
X1739 VSS.t1327 VDD VSS.t1329 VSS.t311 sg13_lv_nmos ad=79.8f pd=0.8u as=0 ps=0 w=0.42u l=1u
X1740 VDD VSS.t2761 VDD VDD sg13_lv_pmos ad=0.34p pd=2.68u as=0 ps=0 w=1u l=1u
X1741 VDD VSS.t2033 VDD VDD sg13_lv_pmos ad=0.19p pd=1.38u as=0 ps=0 w=1u l=1u
X1742 VDD VSS.t2857 VDD VDD sg13_lv_pmos ad=0.19p pd=1.38u as=0 ps=0 w=1u l=1u
X1743 VSS.t2151 VDD VSS.t2150 VSS.t2149 sg13_lv_nmos ad=0.1428p pd=1.52u as=0 ps=0 w=0.42u l=1u
X1744 VDD VSS.t1420 VDD VDD sg13_lv_pmos ad=0.19p pd=1.38u as=0 ps=0 w=1u l=1u
X1745 VSS.t1714 VDD VSS.t1713 VSS.t1712 sg13_lv_nmos ad=0.1428p pd=1.52u as=0 ps=0 w=0.42u l=1u
X1746 VSS.t3238 VDD VSS.t3237 VSS.t3236 sg13_lv_nmos ad=0.1428p pd=1.52u as=0 ps=0 w=0.42u l=1u
X1747 VSS.t771 VDD VSS.t774 VSS.t891 sg13_lv_nmos ad=79.8f pd=0.8u as=0 ps=0 w=0.42u l=1u
X1748 sg13g2_dlygate4sd3_1_8.A a_11370_15532# VDD VDD sg13_lv_pmos ad=0.3808p pd=2.92u as=0.2128p ps=1.5u w=1.12u l=0.13u
X1749 sg13g2_a21oi_1_1.Y sg13g2_a21oi_1_0.B1 VSS.t209 VSS.t0 sg13_lv_nmos ad=0.1406p pd=1.12u as=0.2516p ps=2.16u w=0.74u l=0.13u
X1750 VDD VSS.t2625 VDD VDD sg13_lv_pmos ad=0.19p pd=1.38u as=0 ps=0 w=1u l=1u
X1751 VDD VSS.t2065 VDD VDD sg13_lv_pmos ad=0.34p pd=2.68u as=0 ps=0 w=1u l=1u
X1752 VSS.t1048 VDD VSS.t1050 VSS.t1049 sg13_lv_nmos ad=79.8f pd=0.8u as=0 ps=0 w=0.42u l=1u
X1753 VSS.t2458 VDD VSS.t2460 VSS.t2459 sg13_lv_nmos ad=79.8f pd=0.8u as=0 ps=0 w=0.42u l=1u
X1754 VDD VSS.t915 VDD VDD sg13_lv_pmos ad=0.19p pd=1.38u as=0 ps=0 w=1u l=1u
X1755 VSS.t1849 VDD VSS.t1851 VSS.t1850 sg13_lv_nmos ad=79.8f pd=0.8u as=0 ps=0 w=0.42u l=1u
X1756 VDD VSS.t3190 VDD VDD sg13_lv_pmos ad=0.19p pd=1.38u as=0 ps=0 w=1u l=1u
X1757 VDD VSS.t2400 VDD VDD sg13_lv_pmos ad=0.19p pd=1.38u as=0 ps=0 w=1u l=1u
X1758 VSS.t471 VDD VSS.t471 VSS.t472 sg13_lv_nmos ad=79.8f pd=0.8u as=0 ps=0 w=0.42u l=1u
X1759 a_17030_15238# a_16760_15238# VSS.t62 VSS.t61 sg13_lv_nmos ad=0.1428p pd=1.52u as=79.8f ps=0.8u w=0.42u l=0.5u
X1760 VSS.t2231 VDD VSS.t2233 VSS.t2232 sg13_lv_nmos ad=79.8f pd=0.8u as=0 ps=0 w=0.42u l=1u
X1761 VDD VSS.t245 VDD VDD sg13_lv_pmos ad=0.19p pd=1.38u as=0 ps=0 w=1u l=1u
X1762 VSS.t948 VDD VSS.t950 VSS.t949 sg13_lv_nmos ad=79.8f pd=0.8u as=0 ps=0 w=0.42u l=1u
X1763 VSS.t2101 VDD VSS.t2103 VSS.t2102 sg13_lv_nmos ad=79.8f pd=0.8u as=0 ps=0 w=0.42u l=1u
X1764 VSS.t1018 VDD VSS.t1020 VSS.t1019 sg13_lv_nmos ad=79.8f pd=0.8u as=0 ps=0 w=0.42u l=1u
X1765 VDD VSS.t610 VDD VDD sg13_lv_pmos ad=0.19p pd=1.38u as=0 ps=0 w=1u l=1u
X1766 VDD VSS.t1007 VDD VDD sg13_lv_pmos ad=0.34p pd=2.68u as=0 ps=0 w=1u l=1u
X1767 VSS.t1779 VDD VSS.t1781 VSS.t1780 sg13_lv_nmos ad=79.8f pd=0.8u as=0 ps=0 w=0.42u l=1u
X1768 VSS.t3268 VDD VSS.t3270 VSS.t3269 sg13_lv_nmos ad=79.8f pd=0.8u as=0 ps=0 w=0.42u l=1u
X1769 VSS.t1063 VDD VSS.t1065 VSS.t1064 sg13_lv_nmos ad=79.8f pd=0.8u as=0 ps=0 w=0.42u l=1u
X1770 VDD VSS.t1703 VDD VDD sg13_lv_pmos ad=0.34p pd=2.68u as=0 ps=0 w=1u l=1u
X1771 VDD VSS.t1583 VDD VDD sg13_lv_pmos ad=0.34p pd=2.68u as=0 ps=0 w=1u l=1u
X1772 VSS.t2796 VDD VSS.t2795 VSS.t392 sg13_lv_nmos ad=0.1428p pd=1.52u as=0 ps=0 w=0.42u l=1u
X1773 a_15022_14484# clock_i VSS.t18 VSS.t296 sg13_lv_nmos ad=0.1406p pd=1.12u as=0.2516p ps=2.16u w=0.74u l=0.13u
X1774 VDD VSS.t1132 VDD VDD sg13_lv_pmos ad=0.34p pd=2.68u as=0 ps=0 w=1u l=1u
X1775 VSS.t2383 VDD VSS.t2382 VSS.t2381 sg13_lv_nmos ad=0.1428p pd=1.52u as=0 ps=0 w=0.42u l=1u
X1776 VSS.t751 VDD VSS.t751 VSS.t878 sg13_lv_nmos ad=0.1428p pd=1.52u as=0 ps=0 w=0.42u l=1u
X1777 VDD a_22426_15202# a_22145_15424# VDD sg13_lv_pmos ad=0.1523p pd=1.38u as=0.34p ps=2.68u w=1u l=0.5u
X1778 VDD VSS.t2617 VDD VDD sg13_lv_pmos ad=0.34p pd=2.68u as=0 ps=0 w=1u l=1u
X1779 a_22508_15960# sg13g2_dfrbpq_1_3.Q VDD VDD sg13_lv_pmos ad=0.2856p pd=2.36u as=0.2114p ps=1.54u w=0.84u l=0.13u
X1780 VDD VSS.t1357 VDD VDD sg13_lv_pmos ad=0.19p pd=1.38u as=0 ps=0 w=1u l=1u
X1781 VSS.t1320 VDD VSS.t1319 VSS.t311 sg13_lv_nmos ad=0.1428p pd=1.52u as=0 ps=0 w=0.42u l=1u
X1782 VDD VSS.t172 VDD VDD sg13_lv_pmos ad=0.34p pd=2.68u as=0 ps=0 w=1u l=1u
X1783 VDD VSS.t1070 VDD VDD sg13_lv_pmos ad=0.19p pd=1.38u as=0 ps=0 w=1u l=1u
X1784 VSS.t1508 VDD VSS.t1361 VSS.t311 sg13_lv_nmos ad=79.8f pd=0.8u as=0 ps=0 w=0.42u l=1u
X1785 VDD VSS.t1406 VDD VDD sg13_lv_pmos ad=0.19p pd=1.38u as=0 ps=0 w=1u l=1u
X1786 VDD VSS.t2905 VDD VDD sg13_lv_pmos ad=0.19p pd=1.38u as=0 ps=0 w=1u l=1u
X1787 VSS.t2638 VDD VSS.t2637 VSS.t2636 sg13_lv_nmos ad=0.1428p pd=1.52u as=0 ps=0 w=0.42u l=1u
X1788 VSS.t1834 VDD VSS.t1836 VSS.t1835 sg13_lv_nmos ad=79.8f pd=0.8u as=0 ps=0 w=0.42u l=1u
X1789 VSS.t2011 VDD VSS.t2013 VSS.t2012 sg13_lv_nmos ad=79.8f pd=0.8u as=0 ps=0 w=0.42u l=1u
X1790 VDD VSS.t231 VDD VDD sg13_lv_pmos ad=0.34p pd=2.68u as=0 ps=0 w=1u l=1u
X1791 VSS.t1480 VDD VSS.t1324 VSS.t311 sg13_lv_nmos ad=0.1428p pd=1.52u as=0 ps=0 w=0.42u l=1u
X1792 VSS.t536 VDD VSS.t535 VSS.t534 sg13_lv_nmos ad=0.1428p pd=1.52u as=0 ps=0 w=0.42u l=1u
X1793 a_20218_15238# sg13g2_dfrbpq_1_2.Q VSS.t436 VSS.t0 sg13_lv_nmos ad=0.1406p pd=1.12u as=0.2516p ps=2.16u w=0.74u l=0.13u
X1794 sg13g2_o21ai_1_2.A2 sg13g2_dfrbpq_1_6.Q a_23480_15242# VSS.t24 sg13_lv_nmos ad=0.2516p pd=2.16u as=0.1406p ps=1.12u w=0.74u l=0.13u
X1795 VDD a_18863_14845# a_19120_14726# VDD sg13_lv_pmos ad=2.42015p pd=15.68u as=79.8f ps=0.8u w=0.42u l=0.13u
X1796 VSS.t1103 VDD VSS.t1105 VSS.t1104 sg13_lv_nmos ad=79.8f pd=0.8u as=0 ps=0 w=0.42u l=1u
X1797 VSS.t2971 VDD VSS.t2841 VSS.t392 sg13_lv_nmos ad=0.1428p pd=1.52u as=0 ps=0 w=0.42u l=1u
X1798 VDD VSS.t2093 VDD VDD sg13_lv_pmos ad=0.19p pd=1.38u as=0 ps=0 w=1u l=1u
X1799 VDD a_12020_15202# sg13g2_dfrbpq_1_2.CLK VDD sg13_lv_pmos ad=0.2128p pd=1.5u as=0.2128p ps=1.5u w=1.12u l=0.13u
X1800 VDD VSS.t583 VDD VDD sg13_lv_pmos ad=0.19p pd=1.38u as=0 ps=0 w=1u l=1u
X1801 VSS.t597 VDD VSS.t598 VSS.t9 sg13_lv_nmos ad=79.8f pd=0.8u as=0 ps=0 w=0.42u l=1u
X1802 VSS.t988 VDD VSS.t987 VSS.t986 sg13_lv_nmos ad=0.1428p pd=1.52u as=0 ps=0 w=0.42u l=1u
X1803 VDD VSS.t1736 VDD VDD sg13_lv_pmos ad=0.19p pd=1.38u as=0 ps=0 w=1u l=1u
X1804 VDD VSS.t3202 VDD VDD sg13_lv_pmos ad=0.34p pd=2.68u as=0 ps=0 w=1u l=1u
X1805 VDD VSS.t2412 VDD VDD sg13_lv_pmos ad=0.34p pd=2.68u as=0 ps=0 w=1u l=1u
X1806 VSS.t2201 VDD VSS.t2203 VSS.t2202 sg13_lv_nmos ad=79.8f pd=0.8u as=0 ps=0 w=0.42u l=1u
X1807 VDD sg13g2_dlygate4sd3_1_11.X a_20603_15532# VDD sg13_lv_pmos ad=0.2128p pd=1.5u as=0.2128p ps=1.5u w=1.12u l=0.13u
X1808 VSS.t2808 VDD VSS.t2807 VSS.t392 sg13_lv_nmos ad=0.1428p pd=1.52u as=0 ps=0 w=0.42u l=1u
X1809 VDD VSS.t393 VDD VDD sg13_lv_pmos ad=0.34p pd=2.68u as=0 ps=0 w=1u l=1u
X1810 VDD VSS.t1776 VDD VDD sg13_lv_pmos ad=0.19p pd=1.38u as=0 ps=0 w=1u l=1u
X1811 a_20376_14464# sg13g2_or3_1_2.B VDD VDD sg13_lv_pmos ad=0.2128p pd=1.5u as=0.3808p ps=2.92u w=1.12u l=0.15u
X1812 VDD VSS.t2118 VDD VDD sg13_lv_pmos ad=0.19p pd=1.38u as=0 ps=0 w=1u l=1u
X1813 sg13g2_dfrbpq_1_5.D a_25206_14508# VSS.t55 VSS.t25 sg13_lv_nmos ad=0.2516p pd=2.16u as=0.1426p ps=1.16u w=0.74u l=0.13u
X1814 VSS.t1048 VDD VSS.t1050 VSS.t1049 sg13_lv_nmos ad=79.8f pd=0.8u as=0 ps=0 w=0.42u l=1u
X1815 VDD VSS.t1037 VDD VDD sg13_lv_pmos ad=0.34p pd=2.68u as=0 ps=0 w=1u l=1u
X1816 VDD VSS.t1337 VDD VDD sg13_lv_pmos ad=0.34p pd=2.68u as=0 ps=0 w=1u l=1u
X1817 VSS.t1411 VDD VSS.t1410 VSS.t311 sg13_lv_nmos ad=0.1428p pd=1.52u as=0 ps=0 w=0.42u l=1u
X1818 VSS.t681 VDD VSS.t681 VSS.t683 sg13_lv_nmos ad=0.1428p pd=1.52u as=0 ps=0 w=0.42u l=1u
X1819 VSS.t1373 VDD VSS.t1374 VSS.t311 sg13_lv_nmos ad=79.8f pd=0.8u as=0 ps=0 w=0.42u l=1u
X1820 VDD VSS.t2896 VDD VDD sg13_lv_pmos ad=0.19p pd=1.38u as=0 ps=0 w=1u l=1u
X1821 VSS.t62 a_15022_14484# sg13g2_buf_16_2.A VSS.t146 sg13_lv_nmos ad=0.1406p pd=1.12u as=0.1406p ps=1.12u w=0.74u l=0.13u
X1822 VSS.t2623 VDD VSS.t2622 VSS.t2621 sg13_lv_nmos ad=0.1428p pd=1.52u as=0 ps=0 w=0.42u l=1u
X1823 VDD VSS.t540 VDD VDD sg13_lv_pmos ad=0.34p pd=2.68u as=0 ps=0 w=1u l=1u
X1824 VSS.t1996 VDD VSS.t1998 VSS.t1997 sg13_lv_nmos ad=79.8f pd=0.8u as=0 ps=0 w=0.42u l=1u
X1825 VDD a_27407_13799# a_28074_14020# VDD sg13_lv_pmos ad=0.2128p pd=1.5u as=0.3864p ps=2.93u w=1.12u l=0.13u
X1826 VSS.t1789 VDD VSS.t1788 VSS.t1787 sg13_lv_nmos ad=0.1428p pd=1.52u as=0 ps=0 w=0.42u l=1u
X1827 VSS.t948 VDD VSS.t950 VSS.t949 sg13_lv_nmos ad=79.8f pd=0.8u as=0 ps=0 w=0.42u l=1u
X1828 VDD VSS.t2480 VDD VDD sg13_lv_pmos ad=0.19p pd=1.38u as=0 ps=0 w=1u l=1u
X1829 VDD a_12020_15202# sg13g2_dfrbpq_1_2.CLK VDD sg13_lv_pmos ad=0.2128p pd=1.5u as=0.2128p ps=1.5u w=1.12u l=0.13u
X1830 VSS.t854 VDD VSS.t856 VSS.t855 sg13_lv_nmos ad=79.8f pd=0.8u as=0 ps=0 w=0.42u l=1u
X1831 VSS.t1063 VDD VSS.t1065 VSS.t1064 sg13_lv_nmos ad=79.8f pd=0.8u as=0 ps=0 w=0.42u l=1u
X1832 VDD VSS.t1412 VDD VDD sg13_lv_pmos ad=0.34p pd=2.68u as=0 ps=0 w=1u l=1u
X1833 VDD VSS.t1756 VDD VDD sg13_lv_pmos ad=0.19p pd=1.38u as=0 ps=0 w=1u l=1u
X1834 VSS.t2086 VDD VSS.t2088 VSS.t2087 sg13_lv_nmos ad=79.8f pd=0.8u as=0 ps=0 w=0.42u l=1u
X1835 VDD VSS.t2860 VDD VDD sg13_lv_pmos ad=0.19p pd=1.38u as=0 ps=0 w=1u l=1u
X1836 VSS.t2156 VDD VSS.t2155 VSS.t2154 sg13_lv_nmos ad=0.1428p pd=1.52u as=0 ps=0 w=0.42u l=1u
X1837 VDD VSS.t1315 VDD VDD sg13_lv_pmos ad=0.19p pd=1.38u as=0 ps=0 w=1u l=1u
X1838 VSS.t2368 VDD VSS.t2367 VSS.t2366 sg13_lv_nmos ad=0.1428p pd=1.52u as=0 ps=0 w=0.42u l=1u
X1839 VDD VSS.t601 VDD VDD sg13_lv_pmos ad=0.19p pd=1.38u as=0 ps=0 w=1u l=1u
X1840 VSS.t2763 VDD VSS.t2764 VSS.t392 sg13_lv_nmos ad=79.8f pd=0.8u as=0 ps=0 w=0.42u l=1u
X1841 a_21827_13690# sg13g2_or3_1_2.A VSS.t78 VSS.t77 sg13_lv_nmos ad=0.198p pd=1.27u as=0.13395p ps=1.12u w=0.55u l=0.13u
X1842 VDD VSS.t1783 VDD VDD sg13_lv_pmos ad=0.34p pd=2.68u as=0 ps=0 w=1u l=1u
X1843 VSS.t45 a_19054_15423# sg13g2_dlygate4sd3_1_6.X VSS.t0 sg13_lv_nmos ad=0.1426p pd=1.16u as=0.2516p ps=2.16u w=0.74u l=0.13u
X1844 VDD VSS.t1115 VDD VDD sg13_lv_pmos ad=0.19p pd=1.38u as=0 ps=0 w=1u l=1u
X1845 VDD VSS.t2630 VDD VDD sg13_lv_pmos ad=0.19p pd=1.38u as=0 ps=0 w=1u l=1u
X1846 VSS.t62 a_15022_14484# sg13g2_buf_16_2.A VSS.t142 sg13_lv_nmos ad=0.1406p pd=1.12u as=0.1406p ps=1.12u w=0.74u l=0.13u
X1847 a_16356_13735# a_16587_13844# a_16042_13945# VSS.t286 sg13_lv_nmos ad=0.2373p pd=1.97u as=79.8f ps=0.8u w=0.42u l=0.13u
X1848 a_16294_13735# sg13g2_dfrbpq_1_2.RESET_B VSS.t290 VSS.t388 sg13_lv_nmos ad=37.8f pd=0.6u as=0.1701p ps=1.65u w=0.42u l=0.13u
X1849 a_25956_13722# sg13g2_dfrbpq_1_5.D a_25862_13722# VSS.t168 sg13_lv_nmos ad=60.89999f pd=0.71u as=0.1428p ps=1.52u w=0.42u l=0.13u
X1850 VDD VSS.t742 VDD VDD sg13_lv_pmos ad=0.19p pd=1.38u as=0 ps=0 w=1u l=1u
X1851 VSS.t1819 VDD VSS.t1821 VSS.t1820 sg13_lv_nmos ad=79.8f pd=0.8u as=0 ps=0 w=0.42u l=1u
X1852 VSS.t2236 VDD VSS.t2238 VSS.t2237 sg13_lv_nmos ad=79.8f pd=0.8u as=0 ps=0 w=0.42u l=1u
X1853 VSS.t983 VDD VSS.t985 VSS.t984 sg13_lv_nmos ad=79.8f pd=0.8u as=0 ps=0 w=0.42u l=1u
X1854 VDD VSS.t2130 VDD VDD sg13_lv_pmos ad=0.34p pd=2.68u as=0 ps=0 w=1u l=1u
X1855 VSS.t1103 VDD VSS.t1105 VSS.t1104 sg13_lv_nmos ad=79.8f pd=0.8u as=0 ps=0 w=0.42u l=1u
X1856 VSS.t54 VDD VSS.t54 VSS.t700 sg13_lv_nmos ad=0.1428p pd=1.52u as=0 ps=0 w=0.42u l=1u
X1857 VSS.t1148 VDD VSS.t1150 VSS.t1149 sg13_lv_nmos ad=79.8f pd=0.8u as=0 ps=0 w=0.42u l=1u
X1858 VDD VSS.t3255 VDD VDD sg13_lv_pmos ad=0.19p pd=1.38u as=0 ps=0 w=1u l=1u
X1859 VSS.t2964 VDD VSS.t2833 VSS.t392 sg13_lv_nmos ad=0.1428p pd=1.52u as=0 ps=0 w=0.42u l=1u
X1860 VDD VSS.t2078 VDD VDD sg13_lv_pmos ad=0.19p pd=1.38u as=0 ps=0 w=1u l=1u
X1861 VSS.t631 VDD VSS.t213 VSS.t630 sg13_lv_nmos ad=0.1428p pd=1.52u as=0 ps=0 w=0.42u l=1u
X1862 VDD VSS.t2827 VDD VDD sg13_lv_pmos ad=0.19p pd=1.38u as=0 ps=0 w=1u l=1u
X1863 VSS.t2493 VDD VSS.t2492 VSS.t2491 sg13_lv_nmos ad=0.1428p pd=1.52u as=0 ps=0 w=0.42u l=1u
X1864 VSS.t2186 VDD VSS.t2188 VSS.t2187 sg13_lv_nmos ad=79.8f pd=0.8u as=0 ps=0 w=0.42u l=1u
X1865 VSS.t1749 VDD VSS.t1751 VSS.t1750 sg13_lv_nmos ad=79.8f pd=0.8u as=0 ps=0 w=0.42u l=1u
X1866 VSS.t3273 VDD VSS.t3275 VSS.t3274 sg13_lv_nmos ad=79.8f pd=0.8u as=0 ps=0 w=0.42u l=1u
X1867 VDD VSS.t2425 VDD VDD sg13_lv_pmos ad=0.19p pd=1.38u as=0 ps=0 w=1u l=1u
X1868 VDD VSS.t1297 VDD VDD sg13_lv_pmos ad=0.34p pd=2.68u as=0 ps=0 w=1u l=1u
X1869 VSS.t2799 VDD VSS.t2797 VSS.t392 sg13_lv_nmos ad=0.1428p pd=1.52u as=0 ps=0 w=0.42u l=1u
X1870 VSS.t2141 VDD VSS.t2140 VSS.t2139 sg13_lv_nmos ad=0.1428p pd=1.52u as=0 ps=0 w=0.42u l=1u
X1871 VDD VSS.t1761 VDD VDD sg13_lv_pmos ad=0.19p pd=1.38u as=0 ps=0 w=1u l=1u
X1872 VSS.t83 a_25786_15960# a_25505_16262# VSS.t82 sg13_lv_nmos ad=79.8f pd=0.8u as=0.1428p ps=1.52u w=0.42u l=0.5u
X1873 VDD VSS.t952 VDD VDD sg13_lv_pmos ad=0.34p pd=2.68u as=0 ps=0 w=1u l=1u
X1874 VSS.t2558 VDD VSS.t2560 VSS.t2559 sg13_lv_nmos ad=79.8f pd=0.8u as=0 ps=0 w=0.42u l=1u
X1875 VSS.t2031 VDD VSS.t2033 VSS.t2032 sg13_lv_nmos ad=79.8f pd=0.8u as=0 ps=0 w=0.42u l=1u
X1876 VSS.t1437 VDD VSS.t1436 VSS.t311 sg13_lv_nmos ad=0.1428p pd=1.52u as=0 ps=0 w=0.42u l=1u
X1877 VDD VSS.t1713 VDD VDD sg13_lv_pmos ad=0.34p pd=2.68u as=0 ps=0 w=1u l=1u
X1878 VDD VSS.t2587 VDD VDD sg13_lv_pmos ad=0.34p pd=2.68u as=0 ps=0 w=1u l=1u
X1879 VDD VSS.t1768 VDD VDD sg13_lv_pmos ad=0.34p pd=2.68u as=0 ps=0 w=1u l=1u
X1880 a_8218_13690# sg13g2_dlygate4sd3_1_1.A VSS.t54 VSS.t424 sg13_lv_nmos ad=0.1428p pd=1.52u as=79.8f ps=0.8u w=0.42u l=0.13u
X1881 a_16042_13945# a_16485_13701# a_16425_14113# VDD sg13_lv_pmos ad=79.8f pd=0.8u as=63f ps=0.72u w=0.42u l=0.13u
X1882 VSS.t1571 VDD VSS.t1440 VSS.t311 sg13_lv_nmos ad=0.1428p pd=1.52u as=0 ps=0 w=0.42u l=1u
X1883 VDD VSS.t712 VDD VDD sg13_lv_pmos ad=0.34p pd=2.68u as=0 ps=0 w=1u l=1u
X1884 VDD VSS.t1005 VDD VDD sg13_lv_pmos ad=0.19p pd=1.38u as=0 ps=0 w=1u l=1u
X1885 VSS.t1981 VDD VSS.t1983 VSS.t1982 sg13_lv_nmos ad=79.8f pd=0.8u as=0 ps=0 w=0.42u l=1u
X1886 VSS.t62 a_15022_14484# sg13g2_buf_16_2.A VSS.t138 sg13_lv_nmos ad=0.1406p pd=1.12u as=0.1406p ps=1.12u w=0.74u l=0.13u
X1887 VDD VSS.t1442 VDD VDD sg13_lv_pmos ad=0.19p pd=1.38u as=0 ps=0 w=1u l=1u
X1888 VSS.t338 a_18874_13690# a_18593_13912# VSS.t337 sg13_lv_nmos ad=79.8f pd=0.8u as=0.1428p ps=1.52u w=0.42u l=0.5u
X1889 VSS.t748 VDD VSS.t751 VSS.t877 sg13_lv_nmos ad=79.8f pd=0.8u as=0 ps=0 w=0.42u l=1u
X1890 VSS.t2845 VDD VSS.t2844 VSS.t392 sg13_lv_nmos ad=0.1428p pd=1.52u as=0 ps=0 w=0.42u l=1u
X1891 VDD VSS.t2098 VDD VDD sg13_lv_pmos ad=0.19p pd=1.38u as=0 ps=0 w=1u l=1u
X1892 VDD VSS.t245 VDD VDD sg13_lv_pmos ad=0.34p pd=2.68u as=0 ps=0 w=1u l=1u
X1893 VDD VSS.t2819 VDD VDD sg13_lv_pmos ad=0.19p pd=1.38u as=0 ps=0 w=1u l=1u
X1894 VDD VSS.t1741 VDD VDD sg13_lv_pmos ad=0.19p pd=1.38u as=0 ps=0 w=1u l=1u
X1895 VDD VSS.t3207 VDD VDD sg13_lv_pmos ad=0.34p pd=2.68u as=0 ps=0 w=1u l=1u
X1896 VDD VSS.t2417 VDD VDD sg13_lv_pmos ad=0.34p pd=2.68u as=0 ps=0 w=1u l=1u
X1897 a_16500_15280# sg13g2_or3_1_2.B a_16044_15424# VSS.t371 sg13_lv_nmos ad=78.39999f pd=0.885u as=0.2176p ps=1.96u w=0.64u l=0.13u
X1898 VSS.t1326 VDD VSS.t1327 VSS.t311 sg13_lv_nmos ad=79.8f pd=0.8u as=0 ps=0 w=0.42u l=1u
X1899 VDD VSS.t7 VDD VDD sg13_lv_pmos ad=0.34p pd=2.68u as=0 ps=0 w=1u l=1u
X1900 VDD VSS.t1107 VDD VDD sg13_lv_pmos ad=0.34p pd=2.68u as=0 ps=0 w=1u l=1u
X1901 VDD VSS.t1781 VDD VDD sg13_lv_pmos ad=0.19p pd=1.38u as=0 ps=0 w=1u l=1u
X1902 VSS.t28 a_26638_15423# sg13g2_o21ai_1_2.B1 VSS.t416 sg13_lv_nmos ad=0.1426p pd=1.16u as=0.2516p ps=2.16u w=0.74u l=0.13u
X1903 VSS.t1704 VDD VSS.t1703 VSS.t1702 sg13_lv_nmos ad=0.1428p pd=1.52u as=0 ps=0 w=0.42u l=1u
X1904 VSS.t3228 VDD VSS.t3227 VSS.t3226 sg13_lv_nmos ad=0.1428p pd=1.52u as=0 ps=0 w=0.42u l=1u
X1905 VDD VSS.t1045 VDD VDD sg13_lv_pmos ad=0.19p pd=1.38u as=0 ps=0 w=1u l=1u
X1906 VDD VSS.t2430 VDD VDD sg13_lv_pmos ad=0.19p pd=1.38u as=0 ps=0 w=1u l=1u
X1907 VSS.t2755 VDD VSS.t2756 VSS.t392 sg13_lv_nmos ad=79.8f pd=0.8u as=0 ps=0 w=0.42u l=1u
X1908 VDD VSS.t2902 VDD VDD sg13_lv_pmos ad=0.19p pd=1.38u as=0 ps=0 w=1u l=1u
X1909 VDD VSS.t355 VDD VDD sg13_lv_pmos ad=0.34p pd=2.68u as=0 ps=0 w=1u l=1u
X1910 VSS.t913 VDD VSS.t915 VSS.t914 sg13_lv_nmos ad=79.8f pd=0.8u as=0 ps=0 w=0.42u l=1u
X1911 VSS.t983 VDD VSS.t985 VSS.t984 sg13_lv_nmos ad=79.8f pd=0.8u as=0 ps=0 w=0.42u l=1u
X1912 VDD VSS.t972 VDD VDD sg13_lv_pmos ad=0.34p pd=2.68u as=0 ps=0 w=1u l=1u
X1913 VDD VSS.t105 VDD VDD sg13_lv_pmos ad=0.34p pd=2.68u as=0 ps=0 w=1u l=1u
X1914 VDD VSS.t774 VDD VDD sg13_lv_pmos ad=0.34p pd=2.68u as=0 ps=0 w=1u l=1u
X1915 VSS.t319 a_19438_13726# sg13g2_buf_16_2.X VSS.t321 sg13_lv_nmos ad=0.1406p pd=1.12u as=0.1406p ps=1.12u w=0.74u l=0.13u
X1916 VDD VSS.t1396 VDD VDD sg13_lv_pmos ad=0.34p pd=2.68u as=0 ps=0 w=1u l=1u
X1917 VSS.t2001 VDD VSS.t2003 VSS.t2002 sg13_lv_nmos ad=79.8f pd=0.8u as=0 ps=0 w=0.42u l=1u
X1918 VDD VSS.t303 VDD VDD sg13_lv_pmos ad=0.19p pd=1.38u as=0 ps=0 w=1u l=1u
X1919 VSS.t1148 VDD VSS.t1150 VSS.t1149 sg13_lv_nmos ad=79.8f pd=0.8u as=0 ps=0 w=0.42u l=1u
X1920 VDD VSS.t2115 VDD VDD sg13_lv_pmos ad=0.34p pd=2.68u as=0 ps=0 w=1u l=1u
X1921 VSS.t733 VDD VSS.t349 VSS.t732 sg13_lv_nmos ad=0.1428p pd=1.52u as=0 ps=0 w=0.42u l=1u
X1922 VSS.t2543 VDD VSS.t2545 VSS.t2544 sg13_lv_nmos ad=79.8f pd=0.8u as=0 ps=0 w=0.42u l=1u
X1923 VDD sg13g2_nand3_1_0.Y a_7680_15549# VDD sg13_lv_pmos ad=0.2891p pd=1.695u as=0.1596p ps=1.22u w=0.84u l=0.13u
X1924 VDD VSS.t2485 VDD VDD sg13_lv_pmos ad=0.19p pd=1.38u as=0 ps=0 w=1u l=1u
X1925 VSS.t582 VDD VSS.t583 VSS.t9 sg13_lv_nmos ad=79.8f pd=0.8u as=0 ps=0 w=0.42u l=1u
X1926 sg13g2_dfrbpq_1_2.D sg13g2_a21oi_1_0.B1 VSS.t62 VSS.t206 sg13_lv_nmos ad=0.1406p pd=1.12u as=0.2516p ps=2.16u w=0.74u l=0.13u
X1927 VSS.t1008 VDD VSS.t1007 VSS.t1006 sg13_lv_nmos ad=0.1428p pd=1.52u as=0 ps=0 w=0.42u l=1u
X1928 VSS.t2091 VDD VSS.t2093 VSS.t2092 sg13_lv_nmos ad=79.8f pd=0.8u as=0 ps=0 w=0.42u l=1u
X1929 VDD VSS.t2240 VDD VDD sg13_lv_pmos ad=0.34p pd=2.68u as=0 ps=0 w=1u l=1u
X1930 VSS.t1339 VDD VSS.t1341 VSS.t311 sg13_lv_nmos ad=79.8f pd=0.8u as=0 ps=0 w=0.42u l=1u
X1931 VDD VSS.t1433 VDD VDD sg13_lv_pmos ad=0.19p pd=1.38u as=0 ps=0 w=1u l=1u
X1932 VSS.t771 VDD VSS.t771 VSS.t772 sg13_lv_nmos ad=79.8f pd=0.8u as=0 ps=0 w=0.42u l=1u
X1933 VSS.t2126 VDD VSS.t2125 VSS.t2124 sg13_lv_nmos ad=0.1428p pd=1.52u as=0 ps=0 w=0.42u l=1u
X1934 VSS.t1306 VDD VSS.t1462 VSS.t311 sg13_lv_nmos ad=0.1428p pd=1.52u as=0 ps=0 w=0.42u l=1u
X1935 sg13g2_nand3_1_0.Y sg13g2_buf_1_0.X VDD VDD sg13_lv_pmos ad=0.3808p pd=2.92u as=0.2128p ps=1.5u w=1.12u l=0.13u
X1936 VDD VSS.t1698 VDD VDD sg13_lv_pmos ad=0.34p pd=2.68u as=0 ps=0 w=1u l=1u
X1937 VSS.t831 VDD VSS.t830 VSS.t829 sg13_lv_nmos ad=0.1428p pd=1.52u as=0 ps=0 w=0.42u l=1u
X1938 VSS.t1068 VDD VSS.t1070 VSS.t1069 sg13_lv_nmos ad=79.8f pd=0.8u as=0 ps=0 w=0.42u l=1u
X1939 VDD VSS.t1753 VDD VDD sg13_lv_pmos ad=0.34p pd=2.68u as=0 ps=0 w=1u l=1u
X1940 VSS.t2041 VDD VSS.t2043 VSS.t2042 sg13_lv_nmos ad=79.8f pd=0.8u as=0 ps=0 w=0.42u l=1u
X1941 sg13g2_buf_16_2.A a_15022_14484# VDD VDD sg13_lv_pmos ad=0.2128p pd=1.5u as=0.2128p ps=1.5u w=1.12u l=0.13u
X1942 VDD VSS.t935 VDD VDD sg13_lv_pmos ad=0.19p pd=1.38u as=0 ps=0 w=1u l=1u
X1943 VDD VSS.t3070 VDD VDD sg13_lv_pmos ad=0.19p pd=1.38u as=0 ps=0 w=1u l=1u
X1944 VSS.t3128 VDD VSS.t3130 VSS.t3129 sg13_lv_nmos ad=79.8f pd=0.8u as=0 ps=0 w=0.42u l=1u
X1945 VSS.t2498 VDD VSS.t2497 VSS.t2496 sg13_lv_nmos ad=0.1428p pd=1.52u as=0 ps=0 w=0.42u l=1u
X1946 a_22030_15423# a_22145_15424# VDD VDD sg13_lv_pmos ad=0.34p pd=2.68u as=0.2254p ps=1.53u w=1u l=0.5u
X1947 VDD VSS.t712 VDD VDD sg13_lv_pmos ad=0.34p pd=2.68u as=0 ps=0 w=1u l=1u
X1948 VSS.t1824 VDD VSS.t1826 VSS.t1825 sg13_lv_nmos ad=79.8f pd=0.8u as=0 ps=0 w=0.42u l=1u
X1949 VSS.t2905 VDD VSS.t2906 VSS.t392 sg13_lv_nmos ad=79.8f pd=0.8u as=0 ps=0 w=0.42u l=1u
X1950 VDD VSS.t2477 VDD VDD sg13_lv_pmos ad=0.34p pd=2.68u as=0 ps=0 w=1u l=1u
X1951 VDD VSS.t2135 VDD VDD sg13_lv_pmos ad=0.34p pd=2.68u as=0 ps=0 w=1u l=1u
X1952 sg13g2_o21ai_1_1.Y sg13g2_or3_1_2.A a_20278_14862# VSS.t76 sg13_lv_nmos ad=0.2516p pd=2.16u as=0.1406p ps=1.12u w=0.74u l=0.15u
X1953 VSS.t681 VDD VSS.t681 VSS.t683 sg13_lv_nmos ad=0.1428p pd=1.52u as=0 ps=0 w=0.42u l=1u
X1954 VDD VSS.t1434 VDD VDD sg13_lv_pmos ad=0.19p pd=1.38u as=0 ps=0 w=1u l=1u
X1955 VSS.t1391 VDD VSS.t1390 VSS.t311 sg13_lv_nmos ad=0.1428p pd=1.52u as=0 ps=0 w=0.42u l=1u
X1956 VSS.t2837 VDD VSS.t2836 VSS.t392 sg13_lv_nmos ad=0.1428p pd=1.52u as=0 ps=0 w=0.42u l=1u
X1957 VDD VSS.t2083 VDD VDD sg13_lv_pmos ad=0.19p pd=1.38u as=0 ps=0 w=1u l=1u
X1958 VSS.t486 VDD VSS.t486 VSS.t488 sg13_lv_nmos ad=0.1428p pd=1.52u as=0 ps=0 w=0.42u l=1u
X1959 VDD VSS.t622 VDD VDD sg13_lv_pmos ad=0.19p pd=1.38u as=0 ps=0 w=1u l=1u
X1960 VDD VSS.t2811 VDD VDD sg13_lv_pmos ad=0.19p pd=1.38u as=0 ps=0 w=1u l=1u
X1961 VDD VSS.t1413 VDD VDD sg13_lv_pmos ad=0.34p pd=2.68u as=0 ps=0 w=1u l=1u
X1962 VSS.t2463 VDD VSS.t2462 VSS.t2461 sg13_lv_nmos ad=0.1428p pd=1.52u as=0 ps=0 w=0.42u l=1u
X1963 VDD VSS.t78 VDD VDD sg13_lv_pmos ad=0.19p pd=1.38u as=0 ps=0 w=1u l=1u
X1964 VDD VSS.t1152 VDD VDD sg13_lv_pmos ad=0.34p pd=2.68u as=0 ps=0 w=1u l=1u
X1965 VSS.t1754 VDD VSS.t1756 VSS.t1755 sg13_lv_nmos ad=79.8f pd=0.8u as=0 ps=0 w=0.42u l=1u
X1966 VSS.t3278 VDD VSS.t3280 VSS.t3279 sg13_lv_nmos ad=79.8f pd=0.8u as=0 ps=0 w=0.42u l=1u
X1967 VSS.t751 VDD VSS.t748 VSS.t750 sg13_lv_nmos ad=0.1428p pd=1.52u as=0 ps=0 w=0.42u l=1u
X1968 VDD VSS.t586 VDD VDD sg13_lv_pmos ad=0.19p pd=1.38u as=0 ps=0 w=1u l=1u
X1969 VSS.t90 VDD VSS.t90 VSS.t551 sg13_lv_nmos ad=0.1428p pd=1.52u as=0 ps=0 w=0.42u l=1u
X1970 a_19438_13726# sg13g2_buf_16_2.A VSS.t405 VSS.t407 sg13_lv_nmos ad=0.1406p pd=1.12u as=0.1406p ps=1.12u w=0.74u l=0.13u
X1971 VSS.t2563 VDD VSS.t2565 VSS.t2564 sg13_lv_nmos ad=79.8f pd=0.8u as=0 ps=0 w=0.42u l=1u
X1972 VSS.t1038 VDD VSS.t1037 VSS.t1036 sg13_lv_nmos ad=0.1428p pd=1.52u as=0 ps=0 w=0.42u l=1u
X1973 VDD VSS.t1368 VDD VDD sg13_lv_pmos ad=0.19p pd=1.38u as=0 ps=0 w=1u l=1u
X1974 VDD VSS.t2592 VDD VDD sg13_lv_pmos ad=0.34p pd=2.68u as=0 ps=0 w=1u l=1u
X1975 sg13g2_xnor2_1_2.B sg13g2_dlygate4sd3_1_3.A VDD VDD sg13_lv_pmos ad=0.2128p pd=1.5u as=0.3808p ps=2.92u w=1.12u l=0.13u
X1976 VDD a_10618_14448# a_10337_14750# VDD sg13_lv_pmos ad=0.1523p pd=1.38u as=0.34p ps=2.68u w=1u l=0.5u
X1977 VSS.t913 VDD VSS.t915 VSS.t914 sg13_lv_nmos ad=79.8f pd=0.8u as=0 ps=0 w=0.42u l=1u
X1978 VDD VSS.t1090 VDD VDD sg13_lv_pmos ad=0.19p pd=1.38u as=0 ps=0 w=1u l=1u
X1979 VSS.t2835 VDD VSS.t2835 VSS.t392 sg13_lv_nmos ad=0.1428p pd=1.52u as=0 ps=0 w=0.42u l=1u
X1980 VDD a_17900_15960# counter_value_o[3] VDD sg13_lv_pmos ad=0.2114p pd=1.54u as=0.42p ps=2.99u w=1.12u l=0.13u
X1981 VDD a_17327_13799# a_17584_13942# VDD sg13_lv_pmos ad=2.42015p pd=15.68u as=79.8f ps=0.8u w=0.42u l=0.13u
X1982 VDD VSS.t2895 VDD VDD sg13_lv_pmos ad=0.19p pd=1.38u as=0 ps=0 w=1u l=1u
X1983 VSS.t1784 VDD VSS.t1783 VSS.t1782 sg13_lv_nmos ad=0.1428p pd=1.52u as=0 ps=0 w=0.42u l=1u
X1984 VDD VSS.t3055 VDD VDD sg13_lv_pmos ad=0.19p pd=1.38u as=0 ps=0 w=1u l=1u
X1985 sg13g2_buf_16_2.A a_15022_14484# VDD VDD sg13_lv_pmos ad=0.2128p pd=1.5u as=0.2128p ps=1.5u w=1.12u l=0.13u
X1986 VSS.t54 VDD VSS.t11 VSS.t794 sg13_lv_nmos ad=0.1428p pd=1.52u as=0 ps=0 w=0.42u l=1u
X1987 VDD VSS.t54 VDD VDD sg13_lv_pmos ad=0.19p pd=1.38u as=0 ps=0 w=1u l=1u
X1988 VDD VSS.t2869 VDD VDD sg13_lv_pmos ad=0.34p pd=2.68u as=0 ps=0 w=1u l=1u
X1989 VDD a_21466_15202# a_21185_15424# VDD sg13_lv_pmos ad=0.1523p pd=1.38u as=0.34p ps=2.68u w=1u l=0.5u
X1990 a_16356_13735# a_16068_14040# a_16294_13735# VSS.t295 sg13_lv_nmos ad=0.1428p pd=1.52u as=37.8f ps=0.6u w=0.42u l=0.13u
X1991 VDD VSS.t728 VDD VDD sg13_lv_pmos ad=0.19p pd=1.38u as=0 ps=0 w=1u l=1u
X1992 VSS.t1986 VDD VSS.t1988 VSS.t1987 sg13_lv_nmos ad=79.8f pd=0.8u as=0 ps=0 w=0.42u l=1u
X1993 VSS.t681 VDD VSS.t681 VSS.t685 sg13_lv_nmos ad=0.1428p pd=1.52u as=0 ps=0 w=0.42u l=1u
X1994 VSS.t723 VDD VSS.t723 VSS.t844 sg13_lv_nmos ad=0.1428p pd=1.52u as=0 ps=0 w=0.42u l=1u
X1995 VDD VSS.t1296 VDD VDD sg13_lv_pmos ad=0.19p pd=1.38u as=0 ps=0 w=1u l=1u
X1996 VSS.t3073 VDD VSS.t3075 VSS.t3074 sg13_lv_nmos ad=79.8f pd=0.8u as=0 ps=0 w=0.42u l=1u
X1997 VSS.t1008 VDD VSS.t1007 VSS.t1006 sg13_lv_nmos ad=0.1428p pd=1.52u as=0 ps=0 w=0.42u l=1u
X1998 VSS.t1405 VDD VSS.t1404 VSS.t311 sg13_lv_nmos ad=0.1428p pd=1.52u as=0 ps=0 w=0.42u l=1u
X1999 VDD VSS.t1445 VDD VDD sg13_lv_pmos ad=0.19p pd=1.38u as=0 ps=0 w=1u l=1u
X2000 VSS.t1779 VDD VSS.t1778 VSS.t1777 sg13_lv_nmos ad=0.1428p pd=1.52u as=0 ps=0 w=0.42u l=1u
X2001 VSS.t2528 VDD VSS.t2530 VSS.t2529 sg13_lv_nmos ad=79.8f pd=0.8u as=0 ps=0 w=0.42u l=1u
X2002 VSS.t609 VDD VSS.t610 VSS.t9 sg13_lv_nmos ad=79.8f pd=0.8u as=0 ps=0 w=0.42u l=1u
X2003 VDD VSS.t602 VDD VDD sg13_lv_pmos ad=0.34p pd=2.68u as=0 ps=0 w=1u l=1u
X2004 VDD VSS.t965 VDD VDD sg13_lv_pmos ad=0.19p pd=1.38u as=0 ps=0 w=1u l=1u
X2005 VDD VSS.t2470 VDD VDD sg13_lv_pmos ad=0.19p pd=1.38u as=0 ps=0 w=1u l=1u
X2006 VDD VSS.t2822 VDD VDD sg13_lv_pmos ad=0.19p pd=1.38u as=0 ps=0 w=1u l=1u
X2007 VSS.t2483 VDD VSS.t2482 VSS.t2481 sg13_lv_nmos ad=0.1428p pd=1.52u as=0 ps=0 w=0.42u l=1u
X2008 VDD VSS.t2068 VDD VDD sg13_lv_pmos ad=0.19p pd=1.38u as=0 ps=0 w=1u l=1u
X2009 VDD VSS.t3212 VDD VDD sg13_lv_pmos ad=0.34p pd=2.68u as=0 ps=0 w=1u l=1u
X2010 VDD VSS.t2422 VDD VDD sg13_lv_pmos ad=0.34p pd=2.68u as=0 ps=0 w=1u l=1u
X2011 VDD VSS.t858 VDD VDD sg13_lv_pmos ad=0.34p pd=2.68u as=0 ps=0 w=1u l=1u
X2012 VDD VSS.t1751 VDD VDD sg13_lv_pmos ad=0.19p pd=1.38u as=0 ps=0 w=1u l=1u
X2013 VDD a_7888_14726# a_7833_14607# VDD sg13_lv_pmos ad=2.42015p pd=15.68u as=93.45f ps=0.865u w=0.42u l=0.13u
X2014 VSS.t54 VDD VSS.t54 VSS.t700 sg13_lv_nmos ad=0.1428p pd=1.52u as=0 ps=0 w=0.42u l=1u
X2015 VSS.t1068 VDD VSS.t1070 VSS.t1069 sg13_lv_nmos ad=79.8f pd=0.8u as=0 ps=0 w=0.42u l=1u
X2016 VDD VSS.t1349 VDD VDD sg13_lv_pmos ad=0.34p pd=2.68u as=0 ps=0 w=1u l=1u
X2017 VDD VSS.t1806 VDD VDD sg13_lv_pmos ad=0.19p pd=1.38u as=0 ps=0 w=1u l=1u
X2018 VSS.t568 VDD VSS.t568 VSS.t81 sg13_lv_nmos ad=0.1428p pd=1.52u as=0 ps=0 w=0.42u l=1u
X2019 VDD VSS.t712 VDD VDD sg13_lv_pmos ad=0.19p pd=1.38u as=0 ps=0 w=1u l=1u
X2020 VSS.t681 VDD VSS.t681 VSS.t691 sg13_lv_nmos ad=0.1428p pd=1.52u as=0 ps=0 w=0.42u l=1u
X2021 VSS.t1113 VDD VSS.t1115 VSS.t1114 sg13_lv_nmos ad=79.8f pd=0.8u as=0 ps=0 w=0.42u l=1u
X2022 VDD VSS.t1326 VDD VDD sg13_lv_pmos ad=0.19p pd=1.38u as=0 ps=0 w=1u l=1u
X2023 VSS.t2206 VDD VSS.t2205 VSS.t2204 sg13_lv_nmos ad=0.1428p pd=1.52u as=0 ps=0 w=0.42u l=1u
X2024 VSS.t1769 VDD VSS.t1768 VSS.t1767 sg13_lv_nmos ad=0.1428p pd=1.52u as=0 ps=0 w=0.42u l=1u
X2025 VSS.t3293 VDD VSS.t3292 VSS.t3291 sg13_lv_nmos ad=0.1428p pd=1.52u as=0 ps=0 w=0.42u l=1u
X2026 VSS.t3113 VDD VSS.t3115 VSS.t3114 sg13_lv_nmos ad=79.8f pd=0.8u as=0 ps=0 w=0.42u l=1u
X2027 VDD VSS.t2887 VDD VDD sg13_lv_pmos ad=0.19p pd=1.38u as=0 ps=0 w=1u l=1u
X2028 VDD VSS.t360 VDD VDD sg13_lv_pmos ad=0.19p pd=1.38u as=0 ps=0 w=1u l=1u
X2029 a_6346_14452# a_6789_14495# a_6729_14531# VDD sg13_lv_pmos ad=79.8f pd=0.8u as=63f ps=0.72u w=0.42u l=0.13u
X2030 sg13g2_buf_16_2.A a_15022_14484# VDD VDD sg13_lv_pmos ad=0.2128p pd=1.5u as=0.2128p ps=1.5u w=1.12u l=0.13u
X2031 VSS.t2829 VDD VSS.t2830 VSS.t392 sg13_lv_nmos ad=79.8f pd=0.8u as=0 ps=0 w=0.42u l=1u
X2032 VDD VSS.t363 VDD VDD sg13_lv_pmos ad=0.19p pd=1.38u as=0 ps=0 w=1u l=1u
X2033 VSS.t591 VDD VSS.t590 VSS.t9 sg13_lv_nmos ad=0.1428p pd=1.52u as=0 ps=0 w=0.42u l=1u
X2034 VDD VSS.t917 VDD VDD sg13_lv_pmos ad=0.34p pd=2.68u as=0 ps=0 w=1u l=1u
X2035 VDD VSS.t1120 VDD VDD sg13_lv_pmos ad=0.19p pd=1.38u as=0 ps=0 w=1u l=1u
X2036 VSS.t2896 VDD VSS.t2897 VSS.t392 sg13_lv_nmos ad=79.8f pd=0.8u as=0 ps=0 w=0.42u l=1u
X2037 VDD VSS.t2120 VDD VDD sg13_lv_pmos ad=0.34p pd=2.68u as=0 ps=0 w=1u l=1u
X2038 VSS.t2513 VDD VSS.t2515 VSS.t2514 sg13_lv_nmos ad=79.8f pd=0.8u as=0 ps=0 w=0.42u l=1u
X2039 VSS.t733 VDD VSS.t736 VSS.t867 sg13_lv_nmos ad=79.8f pd=0.8u as=0 ps=0 w=0.42u l=1u
X2040 VDD VSS.t3245 VDD VDD sg13_lv_pmos ad=0.19p pd=1.38u as=0 ps=0 w=1u l=1u
X2041 VDD VSS.t2490 VDD VDD sg13_lv_pmos ad=0.19p pd=1.38u as=0 ps=0 w=1u l=1u
X2042 VDD VSS.t2897 VDD VDD sg13_lv_pmos ad=0.34p pd=2.68u as=0 ps=0 w=1u l=1u
X2043 VSS.t2096 VDD VSS.t2098 VSS.t2097 sg13_lv_nmos ad=79.8f pd=0.8u as=0 ps=0 w=0.42u l=1u
X2044 VDD VSS.t2245 VDD VDD sg13_lv_pmos ad=0.34p pd=2.68u as=0 ps=0 w=1u l=1u
X2045 VSS.t1679 VDD VSS.t1681 VSS.t1680 sg13_lv_nmos ad=79.8f pd=0.8u as=0 ps=0 w=0.42u l=1u
X2046 VSS.t2827 VDD VSS.t2828 VSS.t392 sg13_lv_nmos ad=79.8f pd=0.8u as=0 ps=0 w=0.42u l=1u
X2047 VSS.t13 VDD VSS.t13 VSS.t646 sg13_lv_nmos ad=0.1428p pd=1.52u as=0 ps=0 w=0.42u l=1u
X2048 VSS.t1739 VDD VSS.t1741 VSS.t1740 sg13_lv_nmos ad=79.8f pd=0.8u as=0 ps=0 w=0.42u l=1u
X2049 VSS.t3263 VDD VSS.t3265 VSS.t3264 sg13_lv_nmos ad=79.8f pd=0.8u as=0 ps=0 w=0.42u l=1u
X2050 VDD VSS.t613 VDD VDD sg13_lv_pmos ad=0.19p pd=1.38u as=0 ps=0 w=1u l=1u
X2051 VSS.t1038 VDD VSS.t1037 VSS.t1036 sg13_lv_nmos ad=0.1428p pd=1.52u as=0 ps=0 w=0.42u l=1u
X2052 VSS.t1554 VDD VSS.t1420 VSS.t311 sg13_lv_nmos ad=0.1428p pd=1.52u as=0 ps=0 w=0.42u l=1u
X2053 a_26244_14909# a_25956_14488# a_26182_14909# VSS.t3 sg13_lv_nmos ad=0.1428p pd=1.52u as=37.8f ps=0.6u w=0.42u l=0.13u
X2054 VDD VSS.t1395 VDD VDD sg13_lv_pmos ad=0.19p pd=1.38u as=0 ps=0 w=1u l=1u
X2055 VDD VSS.t1135 VDD VDD sg13_lv_pmos ad=0.19p pd=1.38u as=0 ps=0 w=1u l=1u
X2056 VDD VSS.t1703 VDD VDD sg13_lv_pmos ad=0.34p pd=2.68u as=0 ps=0 w=1u l=1u
X2057 VSS.t245 VDD VSS.t245 VSS.t565 sg13_lv_nmos ad=0.1428p pd=1.52u as=0 ps=0 w=0.42u l=1u
X2058 VDD VSS.t1758 VDD VDD sg13_lv_pmos ad=0.34p pd=2.68u as=0 ps=0 w=1u l=1u
X2059 VSS.t2046 VDD VSS.t2048 VSS.t2047 sg13_lv_nmos ad=79.8f pd=0.8u as=0 ps=0 w=0.42u l=1u
X2060 a_19450_15202# sg13g2_dfrbpq_1_3.Q VDD VDD sg13_lv_pmos ad=0.1428p pd=1.52u as=0.1523p ps=1.38u w=0.42u l=0.13u
X2061 VSS.t3133 VDD VSS.t3135 VSS.t3134 sg13_lv_nmos ad=79.8f pd=0.8u as=0 ps=0 w=0.42u l=1u
X2062 a_20603_15532# sg13g2_or3_1_2.X VDD VDD sg13_lv_pmos ad=0.3808p pd=2.92u as=0.2128p ps=1.5u w=1.12u l=0.13u
X2063 VDD VSS.t3040 VDD VDD sg13_lv_pmos ad=0.19p pd=1.38u as=0 ps=0 w=1u l=1u
X2064 VDD VSS.t1072 VDD VDD sg13_lv_pmos ad=0.34p pd=2.68u as=0 ps=0 w=1u l=1u
X2065 VSS.t1439 VDD VSS.t1439 VSS.t311 sg13_lv_nmos ad=0.1428p pd=1.52u as=0 ps=0 w=0.42u l=1u
X2066 VSS.t1829 VDD VSS.t1831 VSS.t1830 sg13_lv_nmos ad=79.8f pd=0.8u as=0 ps=0 w=0.42u l=1u
X2067 VDD VSS.t2861 VDD VDD sg13_lv_pmos ad=0.34p pd=2.68u as=0 ps=0 w=1u l=1u
X2068 VDD VSS.t188 VDD VDD sg13_lv_pmos ad=0.34p pd=2.68u as=0 ps=0 w=1u l=1u
X2069 VSS.t368 sg13g2_or3_1_2.B a_20278_14862# VSS.t76 sg13_lv_nmos ad=0.1406p pd=1.12u as=0.2516p ps=2.16u w=0.74u l=0.15u
X2070 VDD VSS.t2447 VDD VDD sg13_lv_pmos ad=0.34p pd=2.68u as=0 ps=0 w=1u l=1u
X2071 VDD VSS.t471 VDD VDD sg13_lv_pmos ad=0.19p pd=1.38u as=0 ps=0 w=1u l=1u
X2072 VDD VSS.t1437 VDD VDD sg13_lv_pmos ad=0.19p pd=1.38u as=0 ps=0 w=1u l=1u
X2073 VDD VSS.t2632 VDD VDD sg13_lv_pmos ad=0.34p pd=2.68u as=0 ps=0 w=1u l=1u
X2074 sg13g2_or3_1_2.C sg13g2_dfrbpq_1_2.Q VDD VDD sg13_lv_pmos ad=0.2128p pd=1.5u as=0.3808p ps=2.92u w=1.12u l=0.13u
X2075 VDD VSS.t1409 VDD VDD sg13_lv_pmos ad=0.34p pd=2.68u as=0 ps=0 w=1u l=1u
X2076 VDD VSS.t2814 VDD VDD sg13_lv_pmos ad=0.19p pd=1.38u as=0 ps=0 w=1u l=1u
X2077 VDD VSS.t2230 VDD VDD sg13_lv_pmos ad=0.34p pd=2.68u as=0 ps=0 w=1u l=1u
X2078 VDD VSS.t2053 VDD VDD sg13_lv_pmos ad=0.19p pd=1.38u as=0 ps=0 w=1u l=1u
X2079 VSS.t188 a_12020_15202# sg13g2_dfrbpq_1_2.CLK VSS.t192 sg13_lv_nmos ad=0.1406p pd=1.12u as=0.1406p ps=1.12u w=0.74u l=0.13u
X2080 VDD VSS.t3197 VDD VDD sg13_lv_pmos ad=0.34p pd=2.68u as=0 ps=0 w=1u l=1u
X2081 VSS.t2468 VDD VSS.t2467 VSS.t2466 sg13_lv_nmos ad=0.1428p pd=1.52u as=0 ps=0 w=0.42u l=1u
X2082 VDD VSS.t2407 VDD VDD sg13_lv_pmos ad=0.34p pd=2.68u as=0 ps=0 w=1u l=1u
X2083 VDD VSS.t593 VDD VDD sg13_lv_pmos ad=0.34p pd=2.68u as=0 ps=0 w=1u l=1u
X2084 a_16044_15424# sg13g2_or3_1_2.B VDD VDD sg13_lv_pmos ad=0.1596p pd=1.22u as=0.2891p ps=1.695u w=0.84u l=0.13u
X2085 VDD VSS.t583 VDD VDD sg13_lv_pmos ad=0.19p pd=1.38u as=0 ps=0 w=1u l=1u
X2086 VDD VSS.t681 VDD VDD sg13_lv_pmos ad=0.19p pd=1.38u as=0 ps=0 w=1u l=1u
X2087 VSS.t3248 VDD VSS.t3250 VSS.t3249 sg13_lv_nmos ad=79.8f pd=0.8u as=0 ps=0 w=0.42u l=1u
X2088 VSS.t1113 VDD VSS.t1115 VSS.t1114 sg13_lv_nmos ad=79.8f pd=0.8u as=0 ps=0 w=0.42u l=1u
X2089 VDD VSS.t1375 VDD VDD sg13_lv_pmos ad=0.34p pd=2.68u as=0 ps=0 w=1u l=1u
X2090 VDD VSS.t1736 VDD VDD sg13_lv_pmos ad=0.19p pd=1.38u as=0 ps=0 w=1u l=1u
X2091 VDD VSS.t712 VDD VDD sg13_lv_pmos ad=0.19p pd=1.38u as=0 ps=0 w=1u l=1u
X2092 VSS.t1448 VDD VSS.t1447 VSS.t311 sg13_lv_nmos ad=0.1428p pd=1.52u as=0 ps=0 w=0.42u l=1u
X2093 VSS.t728 VDD VSS.t728 VSS.t727 sg13_lv_nmos ad=0.1428p pd=1.52u as=0 ps=0 w=0.42u l=1u
X2094 VSS.t1624 VDD VSS.t1626 VSS.t1625 sg13_lv_nmos ad=79.8f pd=0.8u as=0 ps=0 w=0.42u l=1u
X2095 VSS.t2533 VDD VSS.t2535 VSS.t2534 sg13_lv_nmos ad=79.8f pd=0.8u as=0 ps=0 w=0.42u l=1u
X2096 VSS.t973 VDD VSS.t972 VSS.t971 sg13_lv_nmos ad=0.1428p pd=1.52u as=0 ps=0 w=0.42u l=1u
X2097 VDD VSS.t2108 VDD VDD sg13_lv_pmos ad=0.19p pd=1.38u as=0 ps=0 w=1u l=1u
X2098 VDD VSS.t1317 VDD VDD sg13_lv_pmos ad=0.19p pd=1.38u as=0 ps=0 w=1u l=1u
X2099 VSS.t1754 VDD VSS.t1753 VSS.t1752 sg13_lv_nmos ad=0.1428p pd=1.52u as=0 ps=0 w=0.42u l=1u
X2100 VSS.t3278 VDD VSS.t3277 VSS.t3276 sg13_lv_nmos ad=0.1428p pd=1.52u as=0 ps=0 w=0.42u l=1u
X2101 a_17327_13799# a_16485_13701# a_16068_14040# VDD sg13_lv_pmos ad=0.2048p pd=1.63u as=0.34p ps=2.68u w=1u l=0.13u
X2102 VSS.t1991 VDD VSS.t1993 VSS.t1992 sg13_lv_nmos ad=79.8f pd=0.8u as=0 ps=0 w=0.42u l=1u
X2103 VSS.t3078 VDD VSS.t3080 VSS.t3079 sg13_lv_nmos ad=79.8f pd=0.8u as=0 ps=0 w=0.42u l=1u
X2104 VDD sg13g2_dfrbpq_1_5.RESET_B a_25862_13722# VDD sg13_lv_pmos ad=0.36237p pd=2.605u as=79.8f ps=0.8u w=0.42u l=0.13u
X2105 VDD VSS.t1429 VDD VDD sg13_lv_pmos ad=0.19p pd=1.38u as=0 ps=0 w=1u l=1u
X2106 VDD VSS.t2475 VDD VDD sg13_lv_pmos ad=0.19p pd=1.38u as=0 ps=0 w=1u l=1u
X2107 VDD VSS.t1621 VDD VDD sg13_lv_pmos ad=0.19p pd=1.38u as=0 ps=0 w=1u l=1u
X2108 VDD VSS.t3182 VDD VDD sg13_lv_pmos ad=0.34p pd=2.68u as=0 ps=0 w=1u l=1u
X2109 VDD VSS.t2392 VDD VDD sg13_lv_pmos ad=0.34p pd=2.68u as=0 ps=0 w=1u l=1u
X2110 a_25094_14484# a_24824_14525# VSS.t46 VSS.t25 sg13_lv_nmos ad=0.1428p pd=1.52u as=79.8f ps=0.8u w=0.42u l=0.5u
X2111 VSS.t736 VDD VSS.t733 VSS.t735 sg13_lv_nmos ad=0.1428p pd=1.52u as=0 ps=0 w=0.42u l=1u
X2112 VSS.t1664 VDD VSS.t1666 VSS.t1665 sg13_lv_nmos ad=79.8f pd=0.8u as=0 ps=0 w=0.42u l=1u
X2113 VSS.t1844 VDD VSS.t1843 VSS.t1842 sg13_lv_nmos ad=0.1428p pd=1.52u as=0 ps=0 w=0.42u l=1u
X2114 VSS.t2081 VDD VSS.t2083 VSS.t2082 sg13_lv_nmos ad=79.8f pd=0.8u as=0 ps=0 w=0.42u l=1u
X2115 VSS.t188 a_12020_15202# sg13g2_dfrbpq_1_2.CLK VSS.t187 sg13_lv_nmos ad=0.1406p pd=1.12u as=0.1406p ps=1.12u w=0.74u l=0.13u
X2116 VDD a_22319_14845# a_22576_14726# VDD sg13_lv_pmos ad=2.42015p pd=15.68u as=79.8f ps=0.8u w=0.42u l=0.13u
X2117 VSS.t2819 VDD VSS.t2820 VSS.t392 sg13_lv_nmos ad=79.8f pd=0.8u as=0 ps=0 w=0.42u l=1u
X2118 VDD VSS.t2785 VDD VDD sg13_lv_pmos ad=0.19p pd=1.38u as=0 ps=0 w=1u l=1u
X2119 VDD VSS.t1756 VDD VDD sg13_lv_pmos ad=0.19p pd=1.38u as=0 ps=0 w=1u l=1u
X2120 VDD VSS.t3100 VDD VDD sg13_lv_pmos ad=0.19p pd=1.38u as=0 ps=0 w=1u l=1u
X2121 VSS.t933 VDD VSS.t935 VSS.t934 sg13_lv_nmos ad=79.8f pd=0.8u as=0 ps=0 w=0.42u l=1u
X2122 VDD VSS.t2100 VDD VDD sg13_lv_pmos ad=0.34p pd=2.68u as=0 ps=0 w=1u l=1u
X2123 VSS.t2211 VDD VSS.t2210 VSS.t2209 sg13_lv_nmos ad=0.1428p pd=1.52u as=0 ps=0 w=0.42u l=1u
X2124 VDD VSS.t601 VDD VDD sg13_lv_pmos ad=0.19p pd=1.38u as=0 ps=0 w=1u l=1u
X2125 VDD VSS.t992 VDD VDD sg13_lv_pmos ad=0.34p pd=2.68u as=0 ps=0 w=1u l=1u
X2126 VSS.t1774 VDD VSS.t1773 VSS.t1772 sg13_lv_nmos ad=0.1428p pd=1.52u as=0 ps=0 w=0.42u l=1u
X2127 VSS.t3298 VDD VSS.t3297 VSS.t3296 sg13_lv_nmos ad=0.1428p pd=1.52u as=0 ps=0 w=0.42u l=1u
X2128 VSS.t3118 VDD VSS.t3120 VSS.t3119 sg13_lv_nmos ad=79.8f pd=0.8u as=0 ps=0 w=0.42u l=1u
X2129 VDD VSS.t2889 VDD VDD sg13_lv_pmos ad=0.19p pd=1.38u as=0 ps=0 w=1u l=1u
X2130 VSS.t2488 VDD VSS.t2487 VSS.t2486 sg13_lv_nmos ad=0.1428p pd=1.52u as=0 ps=0 w=0.42u l=1u
X2131 sg13g2_buf_16_2.X a_19438_13726# VDD VDD sg13_lv_pmos ad=0.2128p pd=1.5u as=0.2128p ps=1.5u w=1.12u l=0.13u
X2132 VDD a_16485_13701# a_16587_13844# VDD sg13_lv_pmos ad=2.42015p pd=15.68u as=0.3864p ps=2.93u w=1.12u l=0.13u
X2133 VDD VSS.t1117 VDD VDD sg13_lv_pmos ad=0.34p pd=2.68u as=0 ps=0 w=1u l=1u
X2134 VDD VSS.t1783 VDD VDD sg13_lv_pmos ad=0.34p pd=2.68u as=0 ps=0 w=1u l=1u
X2135 a_10618_14448# sg13g2_dlygate4sd3_1_8.A VDD VDD sg13_lv_pmos ad=0.1428p pd=1.52u as=0.1523p ps=1.38u w=0.42u l=0.13u
X2136 VSS.t834 VDD VSS.t405 VSS.t833 sg13_lv_nmos ad=0.1428p pd=1.52u as=0 ps=0 w=0.42u l=1u
X2137 VSS.t742 VDD VSS.t742 VSS.t872 sg13_lv_nmos ad=0.1428p pd=1.52u as=0 ps=0 w=0.42u l=1u
X2138 VSS.t1814 VDD VSS.t1816 VSS.t1815 sg13_lv_nmos ad=79.8f pd=0.8u as=0 ps=0 w=0.42u l=1u
X2139 VSS.t1976 VDD VSS.t1978 VSS.t1977 sg13_lv_nmos ad=79.8f pd=0.8u as=0 ps=0 w=0.42u l=1u
X2140 a_25025_16344# sg13g2_dlygate4sd3_1_12.X sg13g2_dlygate4sd3_1_17.A VSS.t84 sg13_lv_nmos ad=0.1406p pd=1.12u as=0.1406p ps=1.12u w=0.74u l=0.13u
X2141 VSS.t2899 VDD VSS.t2900 VSS.t392 sg13_lv_nmos ad=79.8f pd=0.8u as=0 ps=0 w=0.42u l=1u
X2142 VSS.t712 VDD VSS.t712 VSS.t719 sg13_lv_nmos ad=0.1428p pd=1.52u as=0 ps=0 w=0.42u l=1u
X2143 VSS.t2518 VDD VSS.t2520 VSS.t2519 sg13_lv_nmos ad=79.8f pd=0.8u as=0 ps=0 w=0.42u l=1u
X2144 VDD VSS.t2432 VDD VDD sg13_lv_pmos ad=0.34p pd=2.68u as=0 ps=0 w=1u l=1u
X2145 VDD VSS.t2460 VDD VDD sg13_lv_pmos ad=0.19p pd=1.38u as=0 ps=0 w=1u l=1u
X2146 VDD VSS.t1055 VDD VDD sg13_lv_pmos ad=0.19p pd=1.38u as=0 ps=0 w=1u l=1u
X2147 VSS.t1352 VDD VSS.t1353 VSS.t311 sg13_lv_nmos ad=79.8f pd=0.8u as=0 ps=0 w=0.42u l=1u
X2148 VDD VSS.t1606 VDD VDD sg13_lv_pmos ad=0.19p pd=1.38u as=0 ps=0 w=1u l=1u
X2149 a_22025_16334# a_22149_16033# VDD VDD sg13_lv_pmos ad=0.2442p pd=2.06u as=2.8961p ps=18.25u w=0.66u l=0.13u
X2150 VDD VSS.t1401 VDD VDD sg13_lv_pmos ad=0.34p pd=2.68u as=0 ps=0 w=1u l=1u
X2151 VDD VSS.t2900 VDD VDD sg13_lv_pmos ad=0.34p pd=2.68u as=0 ps=0 w=1u l=1u
X2152 VDD VSS.t2215 VDD VDD sg13_lv_pmos ad=0.34p pd=2.68u as=0 ps=0 w=1u l=1u
X2153 VDD VSS.t681 VDD VDD sg13_lv_pmos ad=0.19p pd=1.38u as=0 ps=0 w=1u l=1u
X2154 VDD VSS.t1443 VDD VDD sg13_lv_pmos ad=0.19p pd=1.38u as=0 ps=0 w=1u l=1u
X2155 VSS.t1684 VDD VSS.t1686 VSS.t1685 sg13_lv_nmos ad=79.8f pd=0.8u as=0 ps=0 w=0.42u l=1u
X2156 VSS.t2066 VDD VSS.t2068 VSS.t2067 sg13_lv_nmos ad=79.8f pd=0.8u as=0 ps=0 w=0.42u l=1u
X2157 a_17710_15423# a_17825_15424# VSS.t45 VSS.t160 sg13_lv_nmos ad=0.1428p pd=1.52u as=0.1426p ps=1.16u w=0.42u l=0.5u
X2158 VDD VSS.t723 VDD VDD sg13_lv_pmos ad=0.19p pd=1.38u as=0 ps=0 w=1u l=1u
X2159 VSS.t681 VDD VSS.t681 VSS.t685 sg13_lv_nmos ad=0.1428p pd=1.52u as=0 ps=0 w=0.42u l=1u
X2160 VSS.t2006 VDD VSS.t2005 VSS.t2004 sg13_lv_nmos ad=0.1428p pd=1.52u as=0 ps=0 w=0.42u l=1u
X2161 VSS.t1394 VDD VSS.t1395 VSS.t311 sg13_lv_nmos ad=79.8f pd=0.8u as=0 ps=0 w=0.42u l=1u
X2162 VSS.t3093 VDD VSS.t3092 VSS.t3091 sg13_lv_nmos ad=0.1428p pd=1.52u as=0 ps=0 w=0.42u l=1u
X2163 sg13g2_buf_16_2.A a_15022_14484# VSS.t62 VSS.t139 sg13_lv_nmos ad=0.1406p pd=1.12u as=0.1406p ps=1.12u w=0.74u l=0.13u
X2164 VSS.t1473 VDD VSS.t1315 VSS.t311 sg13_lv_nmos ad=0.1428p pd=1.52u as=0 ps=0 w=0.42u l=1u
X2165 VSS.t521 VDD VSS.t88 VSS.t520 sg13_lv_nmos ad=0.1428p pd=1.52u as=0 ps=0 w=0.42u l=1u
X2166 VSS.t1088 VDD VSS.t1090 VSS.t1089 sg13_lv_nmos ad=79.8f pd=0.8u as=0 ps=0 w=0.42u l=1u
X2167 VSS.t973 VDD VSS.t972 VSS.t971 sg13_lv_nmos ad=0.1428p pd=1.52u as=0 ps=0 w=0.42u l=1u
X2168 VSS.t1804 VDD VSS.t1806 VSS.t1805 sg13_lv_nmos ad=79.8f pd=0.8u as=0 ps=0 w=0.42u l=1u
X2169 a_25930_14452# a_26373_14495# a_25670_14922# VSS.t29 sg13_lv_nmos ad=79.8f pd=0.8u as=0.1296p ps=1.52u w=0.42u l=0.13u
X2170 VDD VSS.t1157 VDD VDD sg13_lv_pmos ad=0.34p pd=2.68u as=0 ps=0 w=1u l=1u
X2171 VDD VSS.t1763 VDD VDD sg13_lv_pmos ad=0.34p pd=2.68u as=0 ps=0 w=1u l=1u
X2172 VSS.t2787 VDD VSS.t2788 VSS.t392 sg13_lv_nmos ad=79.8f pd=0.8u as=0 ps=0 w=0.42u l=1u
X2173 VDD VSS.t290 VDD VDD sg13_lv_pmos ad=0.34p pd=2.68u as=0 ps=0 w=1u l=1u
X2174 VDD VSS.t3045 VDD VDD sg13_lv_pmos ad=0.19p pd=1.38u as=0 ps=0 w=1u l=1u
X2175 sg13g2_buf_16_2.X a_19438_13726# VDD VDD sg13_lv_pmos ad=0.2128p pd=1.5u as=0.2128p ps=1.5u w=1.12u l=0.13u
X2176 VDD VSS.t1768 VDD VDD sg13_lv_pmos ad=0.34p pd=2.68u as=0 ps=0 w=1u l=1u
X2177 VDD a_27502_15423# sg13g2_or3_1_1.A VDD sg13_lv_pmos ad=0.2254p pd=1.53u as=0.4256p ps=3u w=1.12u l=0.13u
X2178 VSS.t1799 VDD VSS.t1801 VSS.t1800 sg13_lv_nmos ad=79.8f pd=0.8u as=0 ps=0 w=0.42u l=1u
X2179 VDD VSS.t2864 VDD VDD sg13_lv_pmos ad=0.34p pd=2.68u as=0 ps=0 w=1u l=1u
X2180 VSS.t54 VDD VSS.t702 VSS.t701 sg13_lv_nmos ad=79.8f pd=0.8u as=0 ps=0 w=0.42u l=1u
X2181 VSS.t681 VDD VSS.t681 VSS.t691 sg13_lv_nmos ad=0.1428p pd=1.52u as=0 ps=0 w=0.42u l=1u
X2182 VDD VSS.t2452 VDD VDD sg13_lv_pmos ad=0.34p pd=2.68u as=0 ps=0 w=1u l=1u
X2183 a_16556_15960# sg13g2_or3_1_1.B VDD VDD sg13_lv_pmos ad=0.2856p pd=2.36u as=0.2114p ps=1.54u w=0.84u l=0.13u
X2184 VSS.t266 sg13g2_o21ai_1_2.A2 a_24169_14508# VSS.t25 sg13_lv_nmos ad=0.1045p pd=0.93u as=0.187p ps=1.78u w=0.55u l=0.13u
X2185 VDD VSS.t1328 VDD VDD sg13_lv_pmos ad=0.34p pd=2.68u as=0 ps=0 w=1u l=1u
X2186 VSS.t3063 VDD VSS.t3065 VSS.t3064 sg13_lv_nmos ad=79.8f pd=0.8u as=0 ps=0 w=0.42u l=1u
X2187 VDD VSS.t2110 VDD VDD sg13_lv_pmos ad=0.34p pd=2.68u as=0 ps=0 w=1u l=1u
X2188 VDD VSS.t1420 VDD VDD sg13_lv_pmos ad=0.19p pd=1.38u as=0 ps=0 w=1u l=1u
X2189 VDD VSS.t486 VDD VDD sg13_lv_pmos ad=0.34p pd=2.68u as=0 ps=0 w=1u l=1u
X2190 VDD VSS.t2637 VDD VDD sg13_lv_pmos ad=0.34p pd=2.68u as=0 ps=0 w=1u l=1u
X2191 a_3333_15213# sg13g2_dfrbpq_1_2.CLK VSS.t9 VSS.t92 sg13_lv_nmos ad=0.2516p pd=2.16u as=5.01922p ps=33.275u w=0.74u l=0.13u
X2192 a_21070_15423# a_21185_15424# VDD VDD sg13_lv_pmos ad=0.34p pd=2.68u as=0.2254p ps=1.53u w=1u l=0.5u
X2193 VDD VSS.t164 VDD VDD sg13_lv_pmos ad=0.19p pd=1.38u as=0 ps=0 w=1u l=1u
X2194 VDD VSS.t2816 VDD VDD sg13_lv_pmos ad=0.19p pd=1.38u as=0 ps=0 w=1u l=1u
X2195 sg13g2_dfrbpq_1_3.Q a_19530_14484# VDD VDD sg13_lv_pmos ad=0.3808p pd=2.92u as=0.2128p ps=1.5u w=1.12u l=0.13u
X2196 VSS.t764 VDD VSS.t763 VSS.t762 sg13_lv_nmos ad=0.1428p pd=1.52u as=0 ps=0 w=0.42u l=1u
X2197 VDD VSS.t1172 VDD VDD sg13_lv_pmos ad=0.34p pd=2.68u as=0 ps=0 w=1u l=1u
X2198 VSS.t1634 VDD VSS.t1636 VSS.t1635 sg13_lv_nmos ad=79.8f pd=0.8u as=0 ps=0 w=0.42u l=1u
X2199 VSS.t2473 VDD VSS.t2472 VSS.t2471 sg13_lv_nmos ad=0.1428p pd=1.52u as=0 ps=0 w=0.42u l=1u
X2200 a_26373_14495# sg13g2_buf_16_2.X VDD VDD sg13_lv_pmos ad=0.4088p pd=2.97u as=2.3367p ps=15.135u w=1.12u l=0.13u
X2201 VSS.t1829 VDD VSS.t1828 VSS.t1827 sg13_lv_nmos ad=0.1428p pd=1.52u as=0 ps=0 w=0.42u l=1u
X2202 VSS.t2246 VDD VSS.t2245 VSS.t2244 sg13_lv_nmos ad=0.1428p pd=1.52u as=0 ps=0 w=0.42u l=1u
X2203 VSS.t245 VDD VSS.t557 VSS.t561 sg13_lv_nmos ad=0.1428p pd=1.52u as=0 ps=0 w=0.42u l=1u
X2204 sg13g2_dlygate4sd3_1_3.A a_4842_15532# VSS.t58 VSS.t68 sg13_lv_nmos ad=0.2516p pd=2.16u as=0.1406p ps=1.12u w=0.74u l=0.13u
X2205 VDD VSS.t1741 VDD VDD sg13_lv_pmos ad=0.19p pd=1.38u as=0 ps=0 w=1u l=1u
X2206 VSS.t933 VDD VSS.t935 VSS.t934 sg13_lv_nmos ad=79.8f pd=0.8u as=0 ps=0 w=0.42u l=1u
X2207 VSS.t1368 VDD VSS.t1370 VSS.t311 sg13_lv_nmos ad=79.8f pd=0.8u as=0 ps=0 w=0.42u l=1u
X2208 VDD VSS.t1796 VDD VDD sg13_lv_pmos ad=0.19p pd=1.38u as=0 ps=0 w=1u l=1u
X2209 VDD VSS.t3262 VDD VDD sg13_lv_pmos ad=0.34p pd=2.68u as=0 ps=0 w=1u l=1u
X2210 VSS.t1629 VDD VSS.t1631 VSS.t1630 sg13_lv_nmos ad=79.8f pd=0.8u as=0 ps=0 w=0.42u l=1u
X2211 VSS.t2538 VDD VSS.t2540 VSS.t2539 sg13_lv_nmos ad=79.8f pd=0.8u as=0 ps=0 w=0.42u l=1u
X2212 VSS.t859 VDD VSS.t858 VSS.t857 sg13_lv_nmos ad=0.1428p pd=1.52u as=0 ps=0 w=0.42u l=1u
X2213 VDD VSS.t349 VDD VDD sg13_lv_pmos ad=0.19p pd=1.38u as=0 ps=0 w=1u l=1u
X2214 VSS.t54 a_7822_13911# sg13g2_xnor2_1_2.A VSS.t53 sg13_lv_nmos ad=0.1426p pd=1.16u as=0.2516p ps=2.16u w=0.74u l=0.13u
X2215 VDD VSS.t1320 VDD VDD sg13_lv_pmos ad=0.19p pd=1.38u as=0 ps=0 w=1u l=1u
X2216 VSS.t1759 VDD VSS.t1758 VSS.t1757 sg13_lv_nmos ad=0.1428p pd=1.52u as=0 ps=0 w=0.42u l=1u
X2217 VSS.t3283 VDD VSS.t3282 VSS.t3281 sg13_lv_nmos ad=0.1428p pd=1.52u as=0 ps=0 w=0.42u l=1u
X2218 VDD VSS.t2881 VDD VDD sg13_lv_pmos ad=0.19p pd=1.38u as=0 ps=0 w=1u l=1u
X2219 sg13g2_buf_1_0.X a_1192_3900# VDD VDD sg13_lv_pmos ad=0.42p pd=2.99u as=0.2114p ps=1.54u w=1.12u l=0.13u
X2220 VSS.t693 VDD VSS.t693 VSS.t694 sg13_lv_nmos ad=0.1428p pd=1.52u as=0 ps=0 w=0.42u l=1u
X2221 VSS.t1118 VDD VSS.t1120 VSS.t1119 sg13_lv_nmos ad=79.8f pd=0.8u as=0 ps=0 w=0.42u l=1u
X2222 VDD VSS.t1308 VDD VDD sg13_lv_pmos ad=0.19p pd=1.38u as=0 ps=0 w=1u l=1u
X2223 VSS.t455 VDD VSS.t455 VSS.t457 sg13_lv_nmos ad=0.1428p pd=1.52u as=0 ps=0 w=0.42u l=1u
X2224 VSS.t621 VDD VSS.t622 VSS.t9 sg13_lv_nmos ad=79.8f pd=0.8u as=0 ps=0 w=0.42u l=1u
X2225 VSS.t2568 VDD VSS.t2567 VSS.t2566 sg13_lv_nmos ad=0.1428p pd=1.52u as=0 ps=0 w=0.42u l=1u
X2226 VDD VSS.t1432 VDD VDD sg13_lv_pmos ad=0.19p pd=1.38u as=0 ps=0 w=1u l=1u
X2227 VSS.t2760 VDD VSS.t2760 VSS.t392 sg13_lv_nmos ad=0.1428p pd=1.52u as=0 ps=0 w=0.42u l=1u
X2228 VDD VSS.t2812 VDD VDD sg13_lv_pmos ad=0.19p pd=1.38u as=0 ps=0 w=1u l=1u
X2229 a_9418_15457# a_9861_15213# a_9801_15625# VDD sg13_lv_pmos ad=79.8f pd=0.8u as=63f ps=0.72u w=0.42u l=0.13u
X2230 VDD VSS.t317 VDD VDD sg13_lv_pmos ad=0.34p pd=2.68u as=0 ps=0 w=1u l=1u
X2231 VDD VSS.t2622 VDD VDD sg13_lv_pmos ad=0.34p pd=2.68u as=0 ps=0 w=1u l=1u
X2232 VDD VSS.t2445 VDD VDD sg13_lv_pmos ad=0.19p pd=1.38u as=0 ps=0 w=1u l=1u
X2233 VSS.t2503 VDD VSS.t2505 VSS.t2504 sg13_lv_nmos ad=79.8f pd=0.8u as=0 ps=0 w=0.42u l=1u
X2234 VDD VSS.t1591 VDD VDD sg13_lv_pmos ad=0.19p pd=1.38u as=0 ps=0 w=1u l=1u
X2235 a_15722_15532# sg13g2_a21oi_1_0.B1 VDD VDD sg13_lv_pmos ad=0.1176p pd=1.33u as=0.4032p ps=2.96u w=1.12u l=0.13u
X2236 VSS.t5 sg13g2_dfrbpq_1_7.RESET_B a_25764_14922# VSS.t158 sg13_lv_nmos ad=0.1626p pd=1.415u as=60.89999f ps=0.71u w=0.42u l=0.13u
X2237 VSS.t1669 VDD VSS.t1671 VSS.t1670 sg13_lv_nmos ad=79.8f pd=0.8u as=0 ps=0 w=0.42u l=1u
X2238 VSS.t1849 VDD VSS.t1848 VSS.t1847 sg13_lv_nmos ad=0.1428p pd=1.52u as=0 ps=0 w=0.42u l=1u
X2239 VDD VSS.t2570 VDD VDD sg13_lv_pmos ad=0.19p pd=1.38u as=0 ps=0 w=1u l=1u
X2240 VSS.t2231 VDD VSS.t2230 VSS.t2229 sg13_lv_nmos ad=0.1428p pd=1.52u as=0 ps=0 w=0.42u l=1u
X2241 VDD VSS.t1360 VDD VDD sg13_lv_pmos ad=0.34p pd=2.68u as=0 ps=0 w=1u l=1u
X2242 VSS.t1420 VDD VSS.t1419 VSS.t311 sg13_lv_nmos ad=0.1428p pd=1.52u as=0 ps=0 w=0.42u l=1u
X2243 VSS.t2822 VDD VSS.t2823 VSS.t392 sg13_lv_nmos ad=79.8f pd=0.8u as=0 ps=0 w=0.42u l=1u
X2244 VSS.t506 VDD VSS.t508 VSS.t507 sg13_lv_nmos ad=79.8f pd=0.8u as=0 ps=0 w=0.42u l=1u
X2245 VSS.t1088 VDD VSS.t1090 VSS.t1089 sg13_lv_nmos ad=79.8f pd=0.8u as=0 ps=0 w=0.42u l=1u
X2246 VSS.t3078 VDD VSS.t3077 VSS.t3076 sg13_lv_nmos ad=0.1428p pd=1.52u as=0 ps=0 w=0.42u l=1u
X2247 VDD VSS.t568 VDD VDD sg13_lv_pmos ad=0.34p pd=2.68u as=0 ps=0 w=1u l=1u
X2248 VSS.t1133 VDD VSS.t1135 VSS.t1134 sg13_lv_nmos ad=79.8f pd=0.8u as=0 ps=0 w=0.42u l=1u
X2249 VDD VSS.t1446 VDD VDD sg13_lv_pmos ad=0.34p pd=2.68u as=0 ps=0 w=1u l=1u
X2250 VDD VSS.t3105 VDD VDD sg13_lv_pmos ad=0.19p pd=1.38u as=0 ps=0 w=1u l=1u
X2251 VDD VSS.t1973 VDD VDD sg13_lv_pmos ad=0.19p pd=1.38u as=0 ps=0 w=1u l=1u
X2252 VSS.t481 VDD VSS.t481 VSS.t482 sg13_lv_nmos ad=79.8f pd=0.8u as=0 ps=0 w=0.42u l=1u
X2253 VSS.t572 VDD VSS.t571 VSS.t570 sg13_lv_nmos ad=0.1428p pd=1.52u as=0 ps=0 w=0.42u l=1u
X2254 VSS.t172 sg13g2_dfrbpq_1_5.RESET_B a_25956_13722# VSS.t171 sg13_lv_nmos ad=0.1626p pd=1.415u as=60.89999f ps=0.71u w=0.42u l=0.13u
X2255 VDD VSS.t2823 VDD VDD sg13_lv_pmos ad=0.34p pd=2.68u as=0 ps=0 w=1u l=1u
X2256 VDD VSS.t2070 VDD VDD sg13_lv_pmos ad=0.34p pd=2.68u as=0 ps=0 w=1u l=1u
X2257 VDD VSS.t1748 VDD VDD sg13_lv_pmos ad=0.34p pd=2.68u as=0 ps=0 w=1u l=1u
X2258 VDD VSS.t2892 VDD VDD sg13_lv_pmos ad=0.19p pd=1.38u as=0 ps=0 w=1u l=1u
X2259 VDD VSS.t312 VDD VDD sg13_lv_pmos ad=0.34p pd=2.68u as=0 ps=0 w=1u l=1u
X2260 VDD VSS.t1398 VDD VDD sg13_lv_pmos ad=0.19p pd=1.38u as=0 ps=0 w=1u l=1u
X2261 VSS.t627 VDD VSS.t626 VSS.t9 sg13_lv_nmos ad=0.1428p pd=1.52u as=0 ps=0 w=0.42u l=1u
X2262 VDD VSS.t1753 VDD VDD sg13_lv_pmos ad=0.34p pd=2.68u as=0 ps=0 w=1u l=1u
X2263 VSS.t603 VDD VSS.t602 VSS.t9 sg13_lv_nmos ad=0.1428p pd=1.52u as=0 ps=0 w=0.42u l=1u
X2264 VSS.t733 VDD VSS.t733 VSS.t734 sg13_lv_nmos ad=79.8f pd=0.8u as=0 ps=0 w=0.42u l=1u
X2265 VSS.t1347 VDD VSS.t1348 VSS.t311 sg13_lv_nmos ad=79.8f pd=0.8u as=0 ps=0 w=0.42u l=1u
X2266 VSS.t1644 VDD VSS.t1643 VSS.t1642 sg13_lv_nmos ad=0.1428p pd=1.52u as=0 ps=0 w=0.42u l=1u
X2267 VSS.t2553 VDD VSS.t2552 VSS.t2551 sg13_lv_nmos ad=0.1428p pd=1.52u as=0 ps=0 w=0.42u l=1u
X2268 VDD VSS.t2437 VDD VDD sg13_lv_pmos ad=0.34p pd=2.68u as=0 ps=0 w=1u l=1u
X2269 VSS.t588 VDD VSS.t589 VSS.t9 sg13_lv_nmos ad=79.8f pd=0.8u as=0 ps=0 w=0.42u l=1u
X2270 VDD VSS.t757 VDD VDD sg13_lv_pmos ad=0.19p pd=1.38u as=0 ps=0 w=1u l=1u
X2271 VDD sg13g2_xnor2_1_2.A a_6540_13238# VDD sg13_lv_pmos ad=0.4536p pd=2.76u as=0.1596p ps=1.22u w=0.84u l=0.13u
X2272 a_22426_15202# sg13g2_dfrbpq_1_6.Q VDD VDD sg13_lv_pmos ad=0.1428p pd=1.52u as=0.1523p ps=1.38u w=0.42u l=0.13u
X2273 VDD VSS.t13 VDD VDD sg13_lv_pmos ad=0.19p pd=1.38u as=0 ps=0 w=1u l=1u
X2274 VSS.t1563 VDD VSS.t1433 VSS.t311 sg13_lv_nmos ad=0.1428p pd=1.52u as=0 ps=0 w=0.42u l=1u
X2275 VSS.t1619 VDD VSS.t1621 VSS.t1620 sg13_lv_nmos ad=79.8f pd=0.8u as=0 ps=0 w=0.42u l=1u
X2276 sg13g2_dfrbpq_1_3.Q a_19530_14484# VSS.t1 VSS.t76 sg13_lv_nmos ad=0.2516p pd=2.16u as=0.1406p ps=1.12u w=0.74u l=0.13u
X2277 VDD VSS.t707 VDD VDD sg13_lv_pmos ad=0.34p pd=2.68u as=0 ps=0 w=1u l=1u
X2278 VDD VSS.t2779 VDD VDD sg13_lv_pmos ad=0.19p pd=1.38u as=0 ps=0 w=1u l=1u
X2279 VSS.t2011 VDD VSS.t2010 VSS.t2009 sg13_lv_nmos ad=0.1428p pd=1.52u as=0 ps=0 w=0.42u l=1u
X2280 VSS.t2181 VDD VSS.t2183 VSS.t2182 sg13_lv_nmos ad=79.8f pd=0.8u as=0 ps=0 w=0.42u l=1u
X2281 a_3333_15213# sg13g2_dfrbpq_1_2.CLK VDD VDD sg13_lv_pmos ad=0.4088p pd=2.97u as=2.77542p ps=17.49u w=1.12u l=0.13u
X2282 VDD VSS.t1335 VDD VDD sg13_lv_pmos ad=0.19p pd=1.38u as=0 ps=0 w=1u l=1u
X2283 VDD VSS.t2138 VDD VDD sg13_lv_pmos ad=0.19p pd=1.38u as=0 ps=0 w=1u l=1u
X2284 VDD VSS.t245 VDD VDD sg13_lv_pmos ad=0.34p pd=2.68u as=0 ps=0 w=1u l=1u
X2285 VDD VSS.t3247 VDD VDD sg13_lv_pmos ad=0.34p pd=2.68u as=0 ps=0 w=1u l=1u
X2286 VDD VSS.t2492 VDD VDD sg13_lv_pmos ad=0.34p pd=2.68u as=0 ps=0 w=1u l=1u
X2287 VSS.t78 sg13g2_or3_1_2.B a_21827_13690# VSS.t376 sg13_lv_nmos ad=0.1045p pd=0.93u as=0.198p ps=1.27u w=0.55u l=0.13u
X2288 VSS.t1809 VDD VSS.t1811 VSS.t1810 sg13_lv_nmos ad=79.8f pd=0.8u as=0 ps=0 w=0.42u l=1u
X2289 VSS.t1614 VDD VSS.t1616 VSS.t1615 sg13_lv_nmos ad=79.8f pd=0.8u as=0 ps=0 w=0.42u l=1u
X2290 VSS.t2523 VDD VSS.t2525 VSS.t2524 sg13_lv_nmos ad=79.8f pd=0.8u as=0 ps=0 w=0.42u l=1u
X2291 VDD VSS.t586 VDD VDD sg13_lv_pmos ad=0.19p pd=1.38u as=0 ps=0 w=1u l=1u
X2292 VDD VSS.t1378 VDD VDD sg13_lv_pmos ad=0.34p pd=2.68u as=0 ps=0 w=1u l=1u
X2293 VDD VSS.t1733 VDD VDD sg13_lv_pmos ad=0.34p pd=2.68u as=0 ps=0 w=1u l=1u
X2294 VSS.t3108 VDD VSS.t3110 VSS.t3109 sg13_lv_nmos ad=79.8f pd=0.8u as=0 ps=0 w=0.42u l=1u
X2295 VSS.t2101 VDD VSS.t2100 VSS.t2099 sg13_lv_nmos ad=0.1428p pd=1.52u as=0 ps=0 w=0.42u l=1u
X2296 VSS.t1118 VDD VSS.t1120 VSS.t1119 sg13_lv_nmos ad=79.8f pd=0.8u as=0 ps=0 w=0.42u l=1u
X2297 VDD VSS.t3050 VDD VDD sg13_lv_pmos ad=0.19p pd=1.38u as=0 ps=0 w=1u l=1u
X2298 VDD a_7532_15960# counter_value_o[1] VDD sg13_lv_pmos ad=0.2114p pd=1.54u as=0.42p ps=2.99u w=1.12u l=0.13u
X2299 VDD VSS.t1092 VDD VDD sg13_lv_pmos ad=0.34p pd=2.68u as=0 ps=0 w=1u l=1u
X2300 VSS.t1329 VDD VSS.t1328 VSS.t311 sg13_lv_nmos ad=0.1428p pd=1.52u as=0 ps=0 w=0.42u l=1u
X2301 VDD VSS.t1651 VDD VDD sg13_lv_pmos ad=0.19p pd=1.38u as=0 ps=0 w=1u l=1u
X2302 a_27502_15423# a_27617_15424# VSS.t28 VSS.t9 sg13_lv_nmos ad=0.1428p pd=1.52u as=0.1426p ps=1.16u w=0.42u l=0.5u
X2303 VDD VSS.t1423 VDD VDD sg13_lv_pmos ad=0.19p pd=1.38u as=0 ps=0 w=1u l=1u
X2304 VSS.t43 a_10960_15454# a_10609_15311# VSS.t42 sg13_lv_nmos ad=79.8f pd=0.8u as=0.1428p ps=1.52u w=0.42u l=0.13u
X2305 VDD VSS.t2898 VDD VDD sg13_lv_pmos ad=0.34p pd=2.68u as=0 ps=0 w=1u l=1u
X2306 VDD VSS.t2803 VDD VDD sg13_lv_pmos ad=0.19p pd=1.38u as=0 ps=0 w=1u l=1u
X2307 VDD VSS.t2607 VDD VDD sg13_lv_pmos ad=0.34p pd=2.68u as=0 ps=0 w=1u l=1u
X2308 VSS.t918 VDD VSS.t917 VSS.t916 sg13_lv_nmos ad=0.1428p pd=1.52u as=0 ps=0 w=0.42u l=1u
X2309 VSS.t1604 VDD VSS.t1606 VSS.t1605 sg13_lv_nmos ad=79.8f pd=0.8u as=0 ps=0 w=0.42u l=1u
X2310 VDD a_10703_15311# a_10960_15454# VDD sg13_lv_pmos ad=2.8961p pd=18.25u as=79.8f ps=0.8u w=0.42u l=0.13u
X2311 a_6086_14922# a_6891_14495# a_6346_14452# VDD sg13_lv_pmos ad=0.1428p pd=1.52u as=79.8f ps=0.8u w=0.42u l=0.13u
X2312 VSS.t45 a_19120_14726# a_18769_14845# VSS.t76 sg13_lv_nmos ad=79.8f pd=0.8u as=0.1428p ps=1.52u w=0.42u l=0.13u
X2313 VDD VSS.t1387 VDD VDD sg13_lv_pmos ad=0.34p pd=2.68u as=0 ps=0 w=1u l=1u
X2314 VSS.t1834 VDD VSS.t1833 VSS.t1832 sg13_lv_nmos ad=0.1428p pd=1.52u as=0 ps=0 w=0.42u l=1u
X2315 VSS.t606 VDD VSS.t607 VSS.t9 sg13_lv_nmos ad=79.8f pd=0.8u as=0 ps=0 w=0.42u l=1u
X2316 VDD VSS.t820 VDD VDD sg13_lv_pmos ad=0.19p pd=1.38u as=0 ps=0 w=1u l=1u
X2317 VSS.t1133 VDD VSS.t1135 VSS.t1134 sg13_lv_nmos ad=79.8f pd=0.8u as=0 ps=0 w=0.42u l=1u
X2318 VDD VSS.t224 VDD VDD sg13_lv_pmos ad=0.34p pd=2.68u as=0 ps=0 w=1u l=1u
X2319 VSS.t712 VDD VSS.t712 VSS.t719 sg13_lv_nmos ad=0.1428p pd=1.52u as=0 ps=0 w=0.42u l=1u
X2320 VDD VSS.t2123 VDD VDD sg13_lv_pmos ad=0.19p pd=1.38u as=0 ps=0 w=1u l=1u
X2321 VDD VSS.t3267 VDD VDD sg13_lv_pmos ad=0.34p pd=2.68u as=0 ps=0 w=1u l=1u
X2322 VDD VSS.t11 VDD VDD sg13_lv_pmos ad=0.34p pd=2.68u as=0 ps=0 w=1u l=1u
X2323 VSS.t164 VDD VSS.t164 VSS.t730 sg13_lv_nmos ad=0.1428p pd=1.52u as=0 ps=0 w=0.42u l=1u
X2324 VDD VSS.t1806 VDD VDD sg13_lv_pmos ad=0.19p pd=1.38u as=0 ps=0 w=1u l=1u
X2325 VDD VSS.t1424 VDD VDD sg13_lv_pmos ad=0.19p pd=1.38u as=0 ps=0 w=1u l=1u
X2326 VSS.t1307 VDD VSS.t1308 VSS.t311 sg13_lv_nmos ad=79.8f pd=0.8u as=0 ps=0 w=0.42u l=1u
X2327 VDD VSS.t1323 VDD VDD sg13_lv_pmos ad=0.19p pd=1.38u as=0 ps=0 w=1u l=1u
X2328 VSS.t1764 VDD VSS.t1763 VSS.t1762 sg13_lv_nmos ad=0.1428p pd=1.52u as=0 ps=0 w=0.42u l=1u
X2329 VDD VSS.t2884 VDD VDD sg13_lv_pmos ad=0.19p pd=1.38u as=0 ps=0 w=1u l=1u
X2330 VSS.t3253 VDD VSS.t3252 VSS.t3251 sg13_lv_nmos ad=0.1428p pd=1.52u as=0 ps=0 w=0.42u l=1u
X2331 a_26170_15202# sg13g2_a21oi_1_3.Y VDD VDD sg13_lv_pmos ad=0.1428p pd=1.52u as=0.1523p ps=1.38u w=0.42u l=0.13u
X2332 VSS.t213 sg13g2_dfrbpq_1_0.RESET_B a_2724_15234# VSS.t342 sg13_lv_nmos ad=0.1626p pd=1.415u as=60.89999f ps=0.71u w=0.42u l=0.13u
X2333 VSS.t1629 VDD VSS.t1628 VSS.t1627 sg13_lv_nmos ad=0.1428p pd=1.52u as=0 ps=0 w=0.42u l=1u
X2334 VSS.t2538 VDD VSS.t2537 VSS.t2536 sg13_lv_nmos ad=0.1428p pd=1.52u as=0 ps=0 w=0.42u l=1u
X2335 VDD VSS.t1122 VDD VDD sg13_lv_pmos ad=0.34p pd=2.68u as=0 ps=0 w=1u l=1u
X2336 VSS.t2985 VDD VSS.t2859 VSS.t392 sg13_lv_nmos ad=79.8f pd=0.8u as=0 ps=0 w=0.42u l=1u
X2337 VSS.t2508 VDD VSS.t2510 VSS.t2509 sg13_lv_nmos ad=79.8f pd=0.8u as=0 ps=0 w=0.42u l=1u
X2338 VDD VSS.t1596 VDD VDD sg13_lv_pmos ad=0.19p pd=1.38u as=0 ps=0 w=1u l=1u
X2339 VDD VSS.t3062 VDD VDD sg13_lv_pmos ad=0.34p pd=2.68u as=0 ps=0 w=1u l=1u
X2340 VSS.t58 VDD VSS.t58 VSS.t633 sg13_lv_nmos ad=0.1428p pd=1.52u as=0 ps=0 w=0.42u l=1u
X2341 VDD VSS.t937 VDD VDD sg13_lv_pmos ad=0.34p pd=2.68u as=0 ps=0 w=1u l=1u
X2342 VDD VSS.t707 VDD VDD sg13_lv_pmos ad=0.34p pd=2.68u as=0 ps=0 w=1u l=1u
X2343 VSS.t54 VDD VSS.t702 VSS.t701 sg13_lv_nmos ad=79.8f pd=0.8u as=0 ps=0 w=0.42u l=1u
X2344 VSS.t2824 VDD VSS.t2825 VSS.t392 sg13_lv_nmos ad=79.8f pd=0.8u as=0 ps=0 w=0.42u l=1u
X2345 VDD VSS.t2770 VDD VDD sg13_lv_pmos ad=0.19p pd=1.38u as=0 ps=0 w=1u l=1u
X2346 VSS.t1996 VDD VSS.t1995 VSS.t1994 sg13_lv_nmos ad=0.1428p pd=1.52u as=0 ps=0 w=0.42u l=1u
X2347 VSS.t360 VDD VSS.t360 VSS.t442 sg13_lv_nmos ad=0.1428p pd=1.52u as=0 ps=0 w=0.42u l=1u
X2348 VSS.t3083 VDD VSS.t3082 VSS.t3081 sg13_lv_nmos ad=0.1428p pd=1.52u as=0 ps=0 w=0.42u l=1u
X2349 VDD VSS.t1430 VDD VDD sg13_lv_pmos ad=0.34p pd=2.68u as=0 ps=0 w=1u l=1u
X2350 VSS.t2151 VDD VSS.t2153 VSS.t2152 sg13_lv_nmos ad=79.8f pd=0.8u as=0 ps=0 w=0.42u l=1u
X2351 VDD VSS.t613 VDD VDD sg13_lv_pmos ad=0.19p pd=1.38u as=0 ps=0 w=1u l=1u
X2352 VDD VSS.t2825 VDD VDD sg13_lv_pmos ad=0.34p pd=2.68u as=0 ps=0 w=1u l=1u
X2353 VDD VSS.t2075 VDD VDD sg13_lv_pmos ad=0.34p pd=2.68u as=0 ps=0 w=1u l=1u
X2354 VSS.t1794 VDD VSS.t1796 VSS.t1795 sg13_lv_nmos ad=79.8f pd=0.8u as=0 ps=0 w=0.42u l=1u
X2355 VDD VSS.t1000 VDD VDD sg13_lv_pmos ad=0.19p pd=1.38u as=0 ps=0 w=1u l=1u
X2356 VDD VSS.t1314 VDD VDD sg13_lv_pmos ad=0.19p pd=1.38u as=0 ps=0 w=1u l=1u
X2357 VDD VSS.t2876 VDD VDD sg13_lv_pmos ad=0.19p pd=1.38u as=0 ps=0 w=1u l=1u
X2358 VSS.t2186 VDD VSS.t2185 VSS.t2184 sg13_lv_nmos ad=0.1428p pd=1.52u as=0 ps=0 w=0.42u l=1u
X2359 a_24923_15996# sg13g2_a21oi_1_0.B1 sg13g2_dlygate4sd3_1_17.A VDD sg13_lv_pmos ad=0.2128p pd=1.5u as=0.3808p ps=2.92u w=1.12u l=0.13u
X2360 a_12020_15202# sg13g2_buf_16_2.A VSS.t13 VSS.t402 sg13_lv_nmos ad=0.1406p pd=1.12u as=0.1406p ps=1.12u w=0.74u l=0.13u
X2361 VSS.t742 VDD VSS.t739 VSS.t741 sg13_lv_nmos ad=0.1428p pd=1.52u as=0 ps=0 w=0.42u l=1u
X2362 VSS.t1749 VDD VSS.t1748 VSS.t1747 sg13_lv_nmos ad=0.1428p pd=1.52u as=0 ps=0 w=0.42u l=1u
X2363 VDD VSS.t3035 VDD VDD sg13_lv_pmos ad=0.19p pd=1.38u as=0 ps=0 w=1u l=1u
X2364 VSS.t3273 VDD VSS.t3272 VSS.t3271 sg13_lv_nmos ad=0.1428p pd=1.52u as=0 ps=0 w=0.42u l=1u
X2365 VSS.t3093 VDD VSS.t3095 VSS.t3094 sg13_lv_nmos ad=79.8f pd=0.8u as=0 ps=0 w=0.42u l=1u
X2366 VDD VSS.t1758 VDD VDD sg13_lv_pmos ad=0.34p pd=2.68u as=0 ps=0 w=1u l=1u
X2367 VDD VSS.t1813 VDD VDD sg13_lv_pmos ad=0.34p pd=2.68u as=0 ps=0 w=1u l=1u
X2368 a_2630_15234# a_3435_15356# a_2890_15457# VDD sg13_lv_pmos ad=0.1428p pd=1.52u as=79.8f ps=0.8u w=0.42u l=0.13u
X2369 VDD VSS.t587 VDD VDD sg13_lv_pmos ad=0.34p pd=2.68u as=0 ps=0 w=1u l=1u
X2370 VSS.t2558 VDD VSS.t2557 VSS.t2556 sg13_lv_nmos ad=0.1428p pd=1.52u as=0 ps=0 w=0.42u l=1u
X2371 VDD VSS.t2442 VDD VDD sg13_lv_pmos ad=0.34p pd=2.68u as=0 ps=0 w=1u l=1u
X2372 VSS.t918 VDD VSS.t917 VSS.t916 sg13_lv_nmos ad=0.1428p pd=1.52u as=0 ps=0 w=0.42u l=1u
X2373 VDD VSS.t2891 VDD VDD sg13_lv_pmos ad=0.34p pd=2.68u as=0 ps=0 w=1u l=1u
X2374 a_25956_14488# a_25930_14452# VDD VDD sg13_lv_pmos ad=0.34p pd=2.68u as=0.36237p ps=2.605u w=1u l=0.13u
X2375 VDD a_4432_15454# a_4377_15549# VDD sg13_lv_pmos ad=2.8961p pd=18.25u as=93.45f ps=0.865u w=0.42u l=0.13u
X2376 VSS.t693 VDD VSS.t693 VSS.t694 sg13_lv_nmos ad=0.1428p pd=1.52u as=0 ps=0 w=0.42u l=1u
X2377 VDD VSS.t1333 VDD VDD sg13_lv_pmos ad=0.19p pd=1.38u as=0 ps=0 w=1u l=1u
X2378 VSS.t1406 VDD VSS.t1407 VSS.t311 sg13_lv_nmos ad=79.8f pd=0.8u as=0 ps=0 w=0.42u l=1u
X2379 VSS.t1589 VDD VSS.t1591 VSS.t1590 sg13_lv_nmos ad=79.8f pd=0.8u as=0 ps=0 w=0.42u l=1u
X2380 VSS.t1659 VDD VSS.t1661 VSS.t1660 sg13_lv_nmos ad=79.8f pd=0.8u as=0 ps=0 w=0.42u l=1u
X2381 VDD VSS.t2782 VDD VDD sg13_lv_pmos ad=0.19p pd=1.38u as=0 ps=0 w=1u l=1u
X2382 VDD a_12020_15202# sg13g2_dfrbpq_1_2.CLK VDD sg13_lv_pmos ad=0.2128p pd=1.5u as=0.2128p ps=1.5u w=1.12u l=0.13u
X2383 VSS.t1981 VDD VSS.t1980 VSS.t1979 sg13_lv_nmos ad=0.1428p pd=1.52u as=0 ps=0 w=0.42u l=1u
X2384 VSS.t245 a_37484_15960# counter_value_o[7] VSS.t247 sg13_lv_nmos ad=0.14875p pd=1.16u as=0.2886p ps=2.26u w=0.74u l=0.13u
X2385 VDD VSS.t1338 VDD VDD sg13_lv_pmos ad=0.19p pd=1.38u as=0 ps=0 w=1u l=1u
X2386 VDD VSS.t2843 VDD VDD sg13_lv_pmos ad=0.19p pd=1.38u as=0 ps=0 w=1u l=1u
X2387 VSS.t600 VDD VSS.t601 VSS.t9 sg13_lv_nmos ad=79.8f pd=0.8u as=0 ps=0 w=0.42u l=1u
X2388 VDD VSS.t593 VDD VDD sg13_lv_pmos ad=0.34p pd=2.68u as=0 ps=0 w=1u l=1u
X2389 VDD VSS.t2462 VDD VDD sg13_lv_pmos ad=0.34p pd=2.68u as=0 ps=0 w=1u l=1u
X2390 VSS.t2523 VDD VSS.t2522 VSS.t2521 sg13_lv_nmos ad=0.1428p pd=1.52u as=0 ps=0 w=0.42u l=1u
X2391 VSS.t303 a_17584_13942# a_17233_13799# VSS.t308 sg13_lv_nmos ad=79.8f pd=0.8u as=0.1428p ps=1.52u w=0.42u l=0.13u
X2392 VSS.t471 VDD VSS.t471 VSS.t477 sg13_lv_nmos ad=0.1428p pd=1.52u as=0 ps=0 w=0.42u l=1u
X2393 VSS.t245 VDD VSS.t245 VSS.t563 sg13_lv_nmos ad=0.1428p pd=1.52u as=0 ps=0 w=0.42u l=1u
X2394 a_7833_14607# a_6891_14495# a_7631_14845# VDD sg13_lv_pmos ad=93.45f pd=0.865u as=0.2048p ps=1.63u w=0.42u l=0.13u
X2395 VSS.t621 VDD VSS.t620 VSS.t9 sg13_lv_nmos ad=0.1428p pd=1.52u as=0 ps=0 w=0.42u l=1u
X2396 a_16485_13701# sg13g2_dfrbpq_1_2.CLK VSS.t96 VSS.t95 sg13_lv_nmos ad=0.2516p pd=2.16u as=15.10457p ps=99.59499u w=0.74u l=0.13u
X2397 VDD VSS.t2103 VDD VDD sg13_lv_pmos ad=0.19p pd=1.38u as=0 ps=0 w=1u l=1u
X2398 VSS.t2071 VDD VSS.t2070 VSS.t2069 sg13_lv_nmos ad=0.1428p pd=1.52u as=0 ps=0 w=0.42u l=1u
X2399 VSS.t2588 VDD VSS.t2590 VSS.t2589 sg13_lv_nmos ad=79.8f pd=0.8u as=0 ps=0 w=0.42u l=1u
X2400 VDD VSS.t1656 VDD VDD sg13_lv_pmos ad=0.19p pd=1.38u as=0 ps=0 w=1u l=1u
X2401 a_17584_13942# a_17327_13799# a_17746_13722# VSS.t309 sg13_lv_nmos ad=0.1428p pd=1.52u as=37.8f ps=0.6u w=0.42u l=0.13u
X2402 VSS.t2755 VDD VSS.t2755 VSS.t392 sg13_lv_nmos ad=0.1428p pd=1.52u as=0 ps=0 w=0.42u l=1u
X2403 VSS.t1118 VDD VSS.t1117 VSS.t1116 sg13_lv_nmos ad=0.1428p pd=1.52u as=0 ps=0 w=0.42u l=1u
X2404 VSS.t3143 VDD VSS.t3142 VSS.t3141 sg13_lv_nmos ad=0.1428p pd=1.52u as=0 ps=0 w=0.42u l=1u
X2405 VDD VSS.t2806 VDD VDD sg13_lv_pmos ad=0.19p pd=1.38u as=0 ps=0 w=1u l=1u
X2406 VDD VSS.t1170 VDD VDD sg13_lv_pmos ad=0.19p pd=1.38u as=0 ps=0 w=1u l=1u
X2407 VDD VSS.t3047 VDD VDD sg13_lv_pmos ad=0.34p pd=2.68u as=0 ps=0 w=1u l=1u
X2408 VSS.t460 VDD VSS.t460 VSS.t461 sg13_lv_nmos ad=79.8f pd=0.8u as=0 ps=0 w=0.42u l=1u
X2409 VSS.t1609 VDD VSS.t1611 VSS.t1610 sg13_lv_nmos ad=79.8f pd=0.8u as=0 ps=0 w=0.42u l=1u
X2410 VSS.t1804 VDD VSS.t1803 VSS.t1802 sg13_lv_nmos ad=0.1428p pd=1.52u as=0 ps=0 w=0.42u l=1u
X2411 a_25094_14484# a_24824_14525# VDD VDD sg13_lv_pmos ad=0.34p pd=2.68u as=0.1523p ps=1.38u w=1u l=0.5u
X2412 sg13g2_dfrbpq_1_7.Q a_27882_14484# VDD VDD sg13_lv_pmos ad=0.3808p pd=2.92u as=0.2128p ps=1.5u w=1.12u l=0.13u
X2413 VDD VSS.t1621 VDD VDD sg13_lv_pmos ad=0.19p pd=1.38u as=0 ps=0 w=1u l=1u
X2414 VSS.t2816 VDD VSS.t2817 VSS.t392 sg13_lv_nmos ad=79.8f pd=0.8u as=0 ps=0 w=0.42u l=1u
X2415 VDD VSS.t2530 VDD VDD sg13_lv_pmos ad=0.19p pd=1.38u as=0 ps=0 w=1u l=1u
X2416 a_9732_15247# a_9963_15356# a_9418_15457# VSS.t106 sg13_lv_nmos ad=0.2373p pd=1.97u as=79.8f ps=0.8u w=0.42u l=0.13u
X2417 a_9670_15247# sg13g2_tiehi_1.L_HI VSS.t105 VSS.t106 sg13_lv_nmos ad=37.8f pd=0.6u as=0.1701p ps=1.65u w=0.42u l=0.13u
X2418 VDD a_12020_15202# sg13g2_dfrbpq_1_2.CLK VDD sg13_lv_pmos ad=0.2128p pd=1.5u as=0.2128p ps=1.5u w=1.12u l=0.13u
X2419 VSS.t2418 VDD VSS.t2420 VSS.t2419 sg13_lv_nmos ad=79.8f pd=0.8u as=0 ps=0 w=0.42u l=1u
X2420 VSS.t2136 VDD VSS.t2138 VSS.t2137 sg13_lv_nmos ad=79.8f pd=0.8u as=0 ps=0 w=0.42u l=1u
X2421 VSS.t736 VDD VSS.t736 VSS.t868 sg13_lv_nmos ad=0.1428p pd=1.52u as=0 ps=0 w=0.42u l=1u
X2422 VSS.t1423 VDD VSS.t1424 VSS.t311 sg13_lv_nmos ad=79.8f pd=0.8u as=0 ps=0 w=0.42u l=1u
X2423 VDD VSS.t2817 VDD VDD sg13_lv_pmos ad=0.34p pd=2.68u as=0 ps=0 w=1u l=1u
X2424 a_7532_15960# sg13g2_dlygate4sd3_1_1.A VSS.t355 VSS.t425 sg13_lv_nmos ad=0.187p pd=1.78u as=0.14875p ps=1.16u w=0.55u l=0.13u
X2425 VSS.t2091 VDD VSS.t2090 VSS.t2089 sg13_lv_nmos ad=0.1428p pd=1.52u as=0 ps=0 w=0.42u l=1u
X2426 VDD VSS.t1307 VDD VDD sg13_lv_pmos ad=0.19p pd=1.38u as=0 ps=0 w=1u l=1u
X2427 VDD VSS.t2789 VDD VDD sg13_lv_pmos ad=0.34p pd=2.68u as=0 ps=0 w=1u l=1u
X2428 VSS.t1734 VDD VSS.t1733 VSS.t1732 sg13_lv_nmos ad=0.1428p pd=1.52u as=0 ps=0 w=0.42u l=1u
X2429 VSS.t3258 VDD VSS.t3257 VSS.t3256 sg13_lv_nmos ad=0.1428p pd=1.52u as=0 ps=0 w=0.42u l=1u
X2430 VSS.t481 VDD VSS.t481 VSS.t484 sg13_lv_nmos ad=79.8f pd=0.8u as=0 ps=0 w=0.42u l=1u
X2431 sg13g2_dfrbpq_1_2.CLK a_12020_15202# VSS.t184 VSS.t183 sg13_lv_nmos ad=0.1406p pd=1.12u as=0.2516p ps=2.16u w=0.74u l=0.13u
X2432 a_10618_14448# sg13g2_dlygate4sd3_1_8.A VSS.t43 VSS.t361 sg13_lv_nmos ad=0.1428p pd=1.52u as=79.8f ps=0.8u w=0.42u l=0.13u
X2433 VDD VSS.t614 VDD VDD sg13_lv_pmos ad=0.34p pd=2.68u as=0 ps=0 w=1u l=1u
X2434 VDD VSS.t1798 VDD VDD sg13_lv_pmos ad=0.34p pd=2.68u as=0 ps=0 w=1u l=1u
X2435 VSS.t1649 VDD VSS.t1651 VSS.t1650 sg13_lv_nmos ad=79.8f pd=0.8u as=0 ps=0 w=0.42u l=1u
X2436 VSS.t1634 VDD VSS.t1633 VSS.t1632 sg13_lv_nmos ad=0.1428p pd=1.52u as=0 ps=0 w=0.42u l=1u
X2437 VSS.t2543 VDD VSS.t2542 VSS.t2541 sg13_lv_nmos ad=0.1428p pd=1.52u as=0 ps=0 w=0.42u l=1u
X2438 VSS.t336 a_19438_13726# sg13g2_buf_16_2.X VSS.t335 sg13_lv_nmos ad=0.2516p pd=2.16u as=0.1406p ps=1.12u w=0.74u l=0.13u
X2439 VDD VSS.t503 VDD VDD sg13_lv_pmos ad=0.19p pd=1.38u as=0 ps=0 w=1u l=1u
X2440 VDD VSS.t1137 VDD VDD sg13_lv_pmos ad=0.34p pd=2.68u as=0 ps=0 w=1u l=1u
X2441 VSS.t2861 VDD VSS.t2862 VSS.t392 sg13_lv_nmos ad=79.8f pd=0.8u as=0 ps=0 w=0.42u l=1u
X2442 VSS.t2041 VDD VSS.t2040 VSS.t2039 sg13_lv_nmos ad=0.1428p pd=1.52u as=0 ps=0 w=0.42u l=1u
X2443 VDD VSS.t1601 VDD VDD sg13_lv_pmos ad=0.19p pd=1.38u as=0 ps=0 w=1u l=1u
X2444 VDD VSS.t3067 VDD VDD sg13_lv_pmos ad=0.34p pd=2.68u as=0 ps=0 w=1u l=1u
X2445 VSS.t307 a_18478_13911# sg13g2_dlygate4sd3_1_4.X VSS.t306 sg13_lv_nmos ad=0.1426p pd=1.16u as=0.2516p ps=2.16u w=0.74u l=0.13u
X2446 VDD VSS.t3240 VDD VDD sg13_lv_pmos ad=0.19p pd=1.38u as=0 ps=0 w=1u l=1u
X2447 VDD a_19438_13726# sg13g2_buf_16_2.X VDD sg13_lv_pmos ad=0.2128p pd=1.5u as=0.2128p ps=1.5u w=1.12u l=0.13u
X2448 VSS.t1644 VDD VSS.t1646 VSS.t1645 sg13_lv_nmos ad=79.8f pd=0.8u as=0 ps=0 w=0.42u l=1u
X2449 VSS.t1824 VDD VSS.t1823 VSS.t1822 sg13_lv_nmos ad=0.1428p pd=1.52u as=0 ps=0 w=0.42u l=1u
X2450 VDD VSS.t1606 VDD VDD sg13_lv_pmos ad=0.19p pd=1.38u as=0 ps=0 w=1u l=1u
X2451 VSS.t2808 VDD VSS.t2809 VSS.t392 sg13_lv_nmos ad=79.8f pd=0.8u as=0 ps=0 w=0.42u l=1u
X2452 VDD VSS.t2773 VDD VDD sg13_lv_pmos ad=0.19p pd=1.38u as=0 ps=0 w=1u l=1u
X2453 VDD VSS.t2515 VDD VDD sg13_lv_pmos ad=0.19p pd=1.38u as=0 ps=0 w=1u l=1u
X2454 VSS.t7 VDD VSS.t7 VSS.t575 sg13_lv_nmos ad=0.1428p pd=1.52u as=0 ps=0 w=0.42u l=1u
X2455 VSS.t3088 VDD VSS.t3087 VSS.t3086 sg13_lv_nmos ad=0.1428p pd=1.52u as=0 ps=0 w=0.42u l=1u
X2456 VDD VSS.t174 VDD VDD sg13_lv_pmos ad=0.34p pd=2.68u as=0 ps=0 w=1u l=1u
X2457 VDD VSS.t1433 VDD VDD sg13_lv_pmos ad=0.34p pd=2.68u as=0 ps=0 w=1u l=1u
X2458 VDD VSS.t2640 VDD VDD sg13_lv_pmos ad=0.19p pd=1.38u as=0 ps=0 w=1u l=1u
X2459 VSS.t2121 VDD VSS.t2123 VSS.t2122 sg13_lv_nmos ad=79.8f pd=0.8u as=0 ps=0 w=0.42u l=1u
X2460 VDD a_9658_14725# sg13g2_tiehi_1.L_HI VDD sg13_lv_pmos ad=2.42015p pd=15.68u as=0.3927p ps=2.99u w=1.155u l=0.13u
X2461 VDD VSS.t2828 VDD VDD sg13_lv_pmos ad=0.34p pd=2.68u as=0 ps=0 w=1u l=1u
X2462 VDD VSS.t2080 VDD VDD sg13_lv_pmos ad=0.34p pd=2.68u as=0 ps=0 w=1u l=1u
X2463 a_6789_14495# sg13g2_dfrbpq_1_2.CLK VDD VDD sg13_lv_pmos ad=0.4088p pd=2.97u as=2.3367p ps=15.135u w=1.12u l=0.13u
X2464 VDD VSS.t1409 VDD VDD sg13_lv_pmos ad=0.19p pd=1.38u as=0 ps=0 w=1u l=1u
X2465 VDD sg13g2_dfrbpq_1_3.Q sg13g2_o21ai_1_2.A2 VDD sg13_lv_pmos ad=0.2128p pd=1.5u as=0.2128p ps=1.5u w=1.12u l=0.13u
X2466 VSS.t1358 VDD VSS.t1359 VSS.t311 sg13_lv_nmos ad=79.8f pd=0.8u as=0 ps=0 w=0.42u l=1u
X2467 VDD VSS.t1763 VDD VDD sg13_lv_pmos ad=0.34p pd=2.68u as=0 ps=0 w=1u l=1u
X2468 a_25764_14922# sg13g2_dfrbpq_1_7.D a_25670_14922# VSS.t25 sg13_lv_nmos ad=60.89999f pd=0.71u as=0.1428p ps=1.52u w=0.42u l=0.13u
X2469 a_24365_14508# sg13g2_or3_1_2.B a_24263_14508# VDD sg13_lv_pmos ad=0.1575p pd=1.315u as=0.19p ps=1.38u w=1u l=0.13u
X2470 VDD VSS.t760 VDD VDD sg13_lv_pmos ad=0.19p pd=1.38u as=0 ps=0 w=1u l=1u
X2471 VDD VSS.t1818 VDD VDD sg13_lv_pmos ad=0.34p pd=2.68u as=0 ps=0 w=1u l=1u
X2472 VDD VSS.t1975 VDD VDD sg13_lv_pmos ad=0.34p pd=2.68u as=0 ps=0 w=1u l=1u
X2473 VSS.t754 VDD VSS.t754 VSS.t880 sg13_lv_nmos ad=0.1428p pd=1.52u as=0 ps=0 w=0.42u l=1u
X2474 VSS.t1118 VDD VSS.t1117 VSS.t1116 sg13_lv_nmos ad=0.1428p pd=1.52u as=0 ps=0 w=0.42u l=1u
X2475 VDD VSS.t1100 VDD VDD sg13_lv_pmos ad=0.19p pd=1.38u as=0 ps=0 w=1u l=1u
X2476 VSS.t430 sg13g2_a21oi_1_0.A2 a_17057_13320# VSS.t429 sg13_lv_nmos ad=0.2516p pd=2.16u as=0.1406p ps=1.12u w=0.74u l=0.13u
X2477 VSS.t328 a_19438_13726# sg13g2_buf_16_2.X VSS.t330 sg13_lv_nmos ad=0.1406p pd=1.12u as=0.1406p ps=1.12u w=0.74u l=0.13u
X2478 sg13g2_or3_1_1.X a_24841_13726# VDD VDD sg13_lv_pmos ad=0.3808p pd=2.92u as=0.3822p ps=1.84u w=1.12u l=0.13u
X2479 VDD VSS.t2893 VDD VDD sg13_lv_pmos ad=0.34p pd=2.68u as=0 ps=0 w=1u l=1u
X2480 VDD a_26373_14495# a_26475_14495# VDD sg13_lv_pmos ad=2.42015p pd=15.68u as=0.3864p ps=2.93u w=1.12u l=0.13u
X2481 VSS.t1444 VDD VSS.t1443 VSS.t311 sg13_lv_nmos ad=0.1428p pd=1.52u as=0 ps=0 w=0.42u l=1u
X2482 VDD VSS.t712 VDD VDD sg13_lv_pmos ad=0.34p pd=2.68u as=0 ps=0 w=1u l=1u
X2483 VSS.t1594 VDD VSS.t1596 VSS.t1595 sg13_lv_nmos ad=79.8f pd=0.8u as=0 ps=0 w=0.42u l=1u
X2484 VDD VSS.t1027 VDD VDD sg13_lv_pmos ad=0.34p pd=2.68u as=0 ps=0 w=1u l=1u
X2485 VSS.t3073 VDD VSS.t3072 VSS.t3071 sg13_lv_nmos ad=0.1428p pd=1.52u as=0 ps=0 w=0.42u l=1u
X2486 VSS.t2905 VDD VSS.t2904 VSS.t392 sg13_lv_nmos ad=0.1428p pd=1.52u as=0 ps=0 w=0.42u l=1u
X2487 VSS.t1986 VDD VSS.t1985 VSS.t1984 sg13_lv_nmos ad=0.1428p pd=1.52u as=0 ps=0 w=0.42u l=1u
X2488 a_21466_15202# sg13g2_o21ai_1_1.Y VDD VDD sg13_lv_pmos ad=0.1428p pd=1.52u as=0.1523p ps=1.38u w=0.42u l=0.13u
X2489 VDD VSS.t1341 VDD VDD sg13_lv_pmos ad=0.19p pd=1.38u as=0 ps=0 w=1u l=1u
X2490 VDD VSS.t2846 VDD VDD sg13_lv_pmos ad=0.19p pd=1.38u as=0 ps=0 w=1u l=1u
X2491 VSS.t2403 VDD VSS.t2405 VSS.t2404 sg13_lv_nmos ad=79.8f pd=0.8u as=0 ps=0 w=0.42u l=1u
X2492 VSS.t2156 VDD VSS.t2158 VSS.t2157 sg13_lv_nmos ad=79.8f pd=0.8u as=0 ps=0 w=0.42u l=1u
X2493 VDD VSS.t2113 VDD VDD sg13_lv_pmos ad=0.19p pd=1.38u as=0 ps=0 w=1u l=1u
X2494 sg13g2_dfrbpq_1_7.Q a_27882_14484# VSS.t246 VSS.t9 sg13_lv_nmos ad=0.2516p pd=2.16u as=0.1406p ps=1.12u w=0.74u l=0.13u
X2495 VDD VSS.t2467 VDD VDD sg13_lv_pmos ad=0.34p pd=2.68u as=0 ps=0 w=1u l=1u
X2496 VSS.t2528 VDD VSS.t2527 VSS.t2526 sg13_lv_nmos ad=0.1428p pd=1.52u as=0 ps=0 w=0.42u l=1u
X2497 VDD sg13g2_tiehi_1.L_HI a_9418_15457# VDD sg13_lv_pmos ad=0.1563p pd=1.22u as=0.147p ps=1.54u w=0.42u l=0.13u
X2498 VDD a_17030_15238# a_17142_15302# VDD sg13_lv_pmos ad=0.2254p pd=1.53u as=0.34p ps=2.68u w=1u l=0.5u
X2499 VSS.t766 VDD VSS.t766 VSS.t886 sg13_lv_nmos ad=0.1428p pd=1.52u as=0 ps=0 w=0.42u l=1u
X2500 VDD VSS.t1613 VDD VDD sg13_lv_pmos ad=0.34p pd=2.68u as=0 ps=0 w=1u l=1u
X2501 VSS.t712 VDD VSS.t820 VSS.t819 sg13_lv_nmos ad=79.8f pd=0.8u as=0 ps=0 w=0.42u l=1u
X2502 VSS.t1694 VDD VSS.t1693 VSS.t1692 sg13_lv_nmos ad=0.1428p pd=1.52u as=0 ps=0 w=0.42u l=1u
X2503 VDD VSS.t1796 VDD VDD sg13_lv_pmos ad=0.19p pd=1.38u as=0 ps=0 w=1u l=1u
X2504 VSS.t2076 VDD VSS.t2075 VSS.t2074 sg13_lv_nmos ad=0.1428p pd=1.52u as=0 ps=0 w=0.42u l=1u
X2505 VDD VSS.t902 VDD VDD sg13_lv_pmos ad=0.34p pd=2.68u as=0 ps=0 w=1u l=1u
X2506 VSS.t1341 VDD VSS.t1340 VSS.t311 sg13_lv_nmos ad=0.1428p pd=1.52u as=0 ps=0 w=0.42u l=1u
X2507 VSS.t582 VDD VSS.t246 VSS.t9 sg13_lv_nmos ad=0.1428p pd=1.52u as=0 ps=0 w=0.42u l=1u
X2508 VSS.t702 VDD VSS.t707 VSS.t706 sg13_lv_nmos ad=79.8f pd=0.8u as=0 ps=0 w=0.42u l=1u
X2509 VDD VSS.t2779 VDD VDD sg13_lv_pmos ad=0.34p pd=2.68u as=0 ps=0 w=1u l=1u
X2510 VSS.t2593 VDD VSS.t2595 VSS.t2594 sg13_lv_nmos ad=79.8f pd=0.8u as=0 ps=0 w=0.42u l=1u
X2511 VDD VSS.t557 VDD VDD sg13_lv_pmos ad=0.34p pd=2.68u as=0 ps=0 w=1u l=1u
X2512 a_19438_13726# sg13g2_buf_16_2.A VDD VDD sg13_lv_pmos ad=0.2128p pd=1.5u as=0.2128p ps=1.5u w=1.12u l=0.13u
X2513 VDD VSS.t2168 VDD VDD sg13_lv_pmos ad=0.19p pd=1.38u as=0 ps=0 w=1u l=1u
X2514 a_25786_15960# sg13g2_o21ai_1_3.Y VDD VDD sg13_lv_pmos ad=0.1428p pd=1.52u as=0.1523p ps=1.38u w=0.42u l=0.13u
X2515 VSS.t1814 VDD VSS.t1813 VSS.t1812 sg13_lv_nmos ad=0.1428p pd=1.52u as=0 ps=0 w=0.42u l=1u
X2516 VSS.t2758 VDD VSS.t2757 VSS.t392 sg13_lv_nmos ad=0.1428p pd=1.52u as=0 ps=0 w=0.42u l=1u
X2517 VSS.t938 VDD VSS.t937 VSS.t936 sg13_lv_nmos ad=0.1428p pd=1.52u as=0 ps=0 w=0.42u l=1u
X2518 VSS.t2853 VDD VSS.t2854 VSS.t392 sg13_lv_nmos ad=79.8f pd=0.8u as=0 ps=0 w=0.42u l=1u
X2519 VSS.t1376 VDD VSS.t1377 VSS.t311 sg13_lv_nmos ad=79.8f pd=0.8u as=0 ps=0 w=0.42u l=1u
X2520 VSS.t1300 VDD VSS.t1301 VSS.t311 sg13_lv_nmos ad=79.8f pd=0.8u as=0 ps=0 w=0.42u l=1u
X2521 VDD VSS.t1586 VDD VDD sg13_lv_pmos ad=0.19p pd=1.38u as=0 ps=0 w=1u l=1u
X2522 VDD VSS.t3052 VDD VDD sg13_lv_pmos ad=0.34p pd=2.68u as=0 ps=0 w=1u l=1u
X2523 VSS.t3113 VDD VSS.t3112 VSS.t3111 sg13_lv_nmos ad=0.1428p pd=1.52u as=0 ps=0 w=0.42u l=1u
X2524 VSS.t618 VDD VSS.t619 VSS.t9 sg13_lv_nmos ad=79.8f pd=0.8u as=0 ps=0 w=0.42u l=1u
X2525 VSS.t1809 VDD VSS.t1808 VSS.t1807 sg13_lv_nmos ad=0.1428p pd=1.52u as=0 ps=0 w=0.42u l=1u
X2526 a_21477_14495# sg13g2_buf_16_2.X VSS.t9 VSS.t152 sg13_lv_nmos ad=0.2516p pd=2.16u as=5.01922p ps=33.275u w=0.74u l=0.13u
X2527 VDD VSS.t1591 VDD VDD sg13_lv_pmos ad=0.19p pd=1.38u as=0 ps=0 w=1u l=1u
X2528 VSS.t2896 VDD VSS.t2896 VSS.t392 sg13_lv_nmos ad=0.1428p pd=1.52u as=0 ps=0 w=0.42u l=1u
X2529 VSS.t585 VDD VSS.t586 VSS.t9 sg13_lv_nmos ad=79.8f pd=0.8u as=0 ps=0 w=0.42u l=1u
X2530 VSS.t2176 VDD VSS.t2178 VSS.t2177 sg13_lv_nmos ad=79.8f pd=0.8u as=0 ps=0 w=0.42u l=1u
X2531 VSS.t2388 VDD VSS.t2390 VSS.t2389 sg13_lv_nmos ad=79.8f pd=0.8u as=0 ps=0 w=0.42u l=1u
X2532 VDD VSS.t3242 VDD VDD sg13_lv_pmos ad=0.34p pd=2.68u as=0 ps=0 w=1u l=1u
X2533 VDD VSS.t2625 VDD VDD sg13_lv_pmos ad=0.19p pd=1.38u as=0 ps=0 w=1u l=1u
X2534 VDD VSS.t2065 VDD VDD sg13_lv_pmos ad=0.34p pd=2.68u as=0 ps=0 w=1u l=1u
X2535 VDD VSS.t1057 VDD VDD sg13_lv_pmos ad=0.34p pd=2.68u as=0 ps=0 w=1u l=1u
X2536 VSS.t1317 VDD VSS.t1318 VSS.t311 sg13_lv_nmos ad=79.8f pd=0.8u as=0 ps=0 w=0.42u l=1u
X2537 VSS.t1355 VDD VSS.t1354 VSS.t311 sg13_lv_nmos ad=0.1428p pd=1.52u as=0 ps=0 w=0.42u l=1u
X2538 a_22149_16033# a_22149_16033# VSS.t81 VSS.t396 sg13_lv_nmos ad=0.111p pd=1.34u as=5.24677p ps=34.365u w=0.3u l=0.13u
X2539 VSS.t1385 VDD VSS.t1386 VSS.t311 sg13_lv_nmos ad=79.8f pd=0.8u as=0 ps=0 w=0.42u l=1u
X2540 VDD VSS.t1748 VDD VDD sg13_lv_pmos ad=0.34p pd=2.68u as=0 ps=0 w=1u l=1u
X2541 VSS.t1654 VDD VSS.t1656 VSS.t1655 sg13_lv_nmos ad=79.8f pd=0.8u as=0 ps=0 w=0.42u l=1u
X2542 VSS.t1639 VDD VSS.t1638 VSS.t1637 sg13_lv_nmos ad=0.1428p pd=1.52u as=0 ps=0 w=0.42u l=1u
X2543 VSS.t2548 VDD VSS.t2547 VSS.t2546 sg13_lv_nmos ad=0.1428p pd=1.52u as=0 ps=0 w=0.42u l=1u
X2544 VDD VSS.t1142 VDD VDD sg13_lv_pmos ad=0.34p pd=2.68u as=0 ps=0 w=1u l=1u
X2545 VSS.t1093 VDD VSS.t1092 VSS.t1091 sg13_lv_nmos ad=0.1428p pd=1.52u as=0 ps=0 w=0.42u l=1u
X2546 VDD VSS.t957 VDD VDD sg13_lv_pmos ad=0.34p pd=2.68u as=0 ps=0 w=1u l=1u
X2547 VSS.t1390 VDD VSS.t1391 VSS.t311 sg13_lv_nmos ad=79.8f pd=0.8u as=0 ps=0 w=0.42u l=1u
X2548 VSS.t2864 VDD VSS.t2865 VSS.t392 sg13_lv_nmos ad=79.8f pd=0.8u as=0 ps=0 w=0.42u l=1u
X2549 VSS.t62 sg13g2_xnor2_1_1.A a_16500_15280# VSS.t383 sg13_lv_nmos ad=0.2272p pd=1.99u as=78.39999f ps=0.885u w=0.64u l=0.13u
X2550 VSS.t600 VDD VSS.t599 VSS.t9 sg13_lv_nmos ad=0.1428p pd=1.52u as=0 ps=0 w=0.42u l=1u
X2551 VDD VSS.t712 VDD VDD sg13_lv_pmos ad=0.34p pd=2.68u as=0 ps=0 w=1u l=1u
X2552 VDD VSS.t1324 VDD VDD sg13_lv_pmos ad=0.34p pd=2.68u as=0 ps=0 w=1u l=1u
X2553 VDD VSS.t3037 VDD VDD sg13_lv_pmos ad=0.34p pd=2.68u as=0 ps=0 w=1u l=1u
X2554 VDD VSS.t360 VDD VDD sg13_lv_pmos ad=0.34p pd=2.68u as=0 ps=0 w=1u l=1u
X2555 VSS.t1971 VDD VSS.t1970 VSS.t1969 sg13_lv_nmos ad=0.1428p pd=1.52u as=0 ps=0 w=0.42u l=1u
X2556 VSS.t702 VDD VSS.t702 VSS.t703 sg13_lv_nmos ad=0.1428p pd=1.52u as=0 ps=0 w=0.42u l=1u
X2557 VSS.t172 VDD VSS.t172 VSS.t731 sg13_lv_nmos ad=0.1428p pd=1.52u as=0 ps=0 w=0.42u l=1u
X2558 VSS.t1153 VDD VSS.t1155 VSS.t1154 sg13_lv_nmos ad=79.8f pd=0.8u as=0 ps=0 w=0.42u l=1u
X2559 VDD VSS.t1332 VDD VDD sg13_lv_pmos ad=0.19p pd=1.38u as=0 ps=0 w=1u l=1u
X2560 VDD VSS.t1565 VDD VDD sg13_lv_pmos ad=0.34p pd=2.68u as=0 ps=0 w=1u l=1u
X2561 VDD VSS.t2838 VDD VDD sg13_lv_pmos ad=0.19p pd=1.38u as=0 ps=0 w=1u l=1u
X2562 VSS.t3058 VDD VSS.t3057 VSS.t3056 sg13_lv_nmos ad=0.1428p pd=1.52u as=0 ps=0 w=0.42u l=1u
X2563 VSS.t2513 VDD VSS.t2512 VSS.t2511 sg13_lv_nmos ad=0.1428p pd=1.52u as=0 ps=0 w=0.42u l=1u
X2564 VSS.t2126 VDD VSS.t2128 VSS.t2127 sg13_lv_nmos ad=79.8f pd=0.8u as=0 ps=0 w=0.42u l=1u
X2565 a_2724_15234# sg13g2_and2_1_0.X a_2630_15234# VSS.t216 sg13_lv_nmos ad=60.89999f pd=0.71u as=0.1428p ps=1.52u w=0.42u l=0.13u
X2566 VSS.t681 VDD VSS.t681 VSS.t682 sg13_lv_nmos ad=79.8f pd=0.8u as=0 ps=0 w=0.42u l=1u
X2567 VDD VSS.t723 VDD VDD sg13_lv_pmos ad=0.19p pd=1.38u as=0 ps=0 w=1u l=1u
X2568 VDD VSS.t1020 VDD VDD sg13_lv_pmos ad=0.19p pd=1.38u as=0 ps=0 w=1u l=1u
X2569 VSS.t1408 VDD VSS.t1409 VSS.t311 sg13_lv_nmos ad=79.8f pd=0.8u as=0 ps=0 w=0.42u l=1u
X2570 VDD VSS.t1598 VDD VDD sg13_lv_pmos ad=0.34p pd=2.68u as=0 ps=0 w=1u l=1u
X2571 VDD VSS.t2812 VDD VDD sg13_lv_pmos ad=0.34p pd=2.68u as=0 ps=0 w=1u l=1u
X2572 VSS.t2827 VDD VSS.t2826 VSS.t392 sg13_lv_nmos ad=0.1428p pd=1.52u as=0 ps=0 w=0.42u l=1u
X2573 VDD VSS.t538 VDD VDD sg13_lv_pmos ad=0.19p pd=1.38u as=0 ps=0 w=1u l=1u
X2574 VSS.t2578 VDD VSS.t2580 VSS.t2579 sg13_lv_nmos ad=79.8f pd=0.8u as=0 ps=0 w=0.42u l=1u
X2575 VDD VSS.t1733 VDD VDD sg13_lv_pmos ad=0.34p pd=2.68u as=0 ps=0 w=1u l=1u
X2576 VSS.t1624 VDD VSS.t1623 VSS.t1622 sg13_lv_nmos ad=0.1428p pd=1.52u as=0 ps=0 w=0.42u l=1u
X2577 VSS.t2533 VDD VSS.t2532 VSS.t2531 sg13_lv_nmos ad=0.1428p pd=1.52u as=0 ps=0 w=0.42u l=1u
X2578 sg13g2_buf_16_2.A a_15022_14484# VDD VDD sg13_lv_pmos ad=0.2128p pd=1.5u as=0.2128p ps=1.5u w=1.12u l=0.13u
X2579 VSS.t938 VDD VSS.t937 VSS.t936 sg13_lv_nmos ad=0.1428p pd=1.52u as=0 ps=0 w=0.42u l=1u
X2580 VDD VSS.t2153 VDD VDD sg13_lv_pmos ad=0.19p pd=1.38u as=0 ps=0 w=1u l=1u
X2581 VSS.t9 a_9861_15213# a_9963_15356# VSS.t93 sg13_lv_nmos ad=5.4375p pd=36.05u as=0.2516p ps=2.16u w=0.74u l=0.13u
X2582 VSS.t712 VDD VSS.t712 VSS.t717 sg13_lv_nmos ad=0.1428p pd=1.52u as=0 ps=0 w=0.42u l=1u
X2583 VDD VSS.t172 VDD VDD sg13_lv_pmos ad=0.19p pd=1.38u as=0 ps=0 w=1u l=1u
X2584 VSS.t1168 VDD VSS.t1170 VSS.t1169 sg13_lv_nmos ad=79.8f pd=0.8u as=0 ps=0 w=0.42u l=1u
X2585 VDD VSS.t1651 VDD VDD sg13_lv_pmos ad=0.19p pd=1.38u as=0 ps=0 w=1u l=1u
X2586 a_17219_16265# sg13g2_or3_1_2.B a_17517_16020# VDD sg13_lv_pmos ad=0.34p pd=2.68u as=0.19p ps=1.38u w=1u l=0.13u
X2587 VDD VSS.t1315 VDD VDD sg13_lv_pmos ad=0.34p pd=2.68u as=0 ps=0 w=1u l=1u
X2588 VDD VSS.t2877 VDD VDD sg13_lv_pmos ad=0.34p pd=2.68u as=0 ps=0 w=1u l=1u
X2589 VDD VSS.t2105 VDD VDD sg13_lv_pmos ad=0.34p pd=2.68u as=0 ps=0 w=1u l=1u
X2590 a_2059_14832# sg13g2_buf_1_10.X a_1965_14832# VSS.t267 sg13_lv_nmos ad=0.1216p pd=1.02u as=0.2176p ps=1.96u w=0.64u l=0.13u
X2591 VSS.t1599 VDD VSS.t1601 VSS.t1600 sg13_lv_nmos ad=79.8f pd=0.8u as=0 ps=0 w=0.42u l=1u
X2592 VSS.t2821 VDD VSS.t2820 VSS.t392 sg13_lv_nmos ad=0.1428p pd=1.52u as=0 ps=0 w=0.42u l=1u
X2593 VDD VSS.t1309 VDD VDD sg13_lv_pmos ad=0.34p pd=2.68u as=0 ps=0 w=1u l=1u
X2594 VSS.t312 reset_n_i a_1192_9948# VSS.t311 sg13_lv_nmos ad=0.14875p pd=1.16u as=0.187p ps=1.78u w=0.55u l=0.13u
X2595 VSS.t13 sg13g2_buf_16_2.A a_12020_15202# VSS.t401 sg13_lv_nmos ad=0.1406p pd=1.12u as=0.1406p ps=1.12u w=0.74u l=0.13u
X2596 VDD VSS.t1175 VDD VDD sg13_lv_pmos ad=0.19p pd=1.38u as=0 ps=0 w=1u l=1u
X2597 VDD VSS.t1344 VDD VDD sg13_lv_pmos ad=0.19p pd=1.38u as=0 ps=0 w=1u l=1u
X2598 VSS.t2161 VDD VSS.t2163 VSS.t2162 sg13_lv_nmos ad=79.8f pd=0.8u as=0 ps=0 w=0.42u l=1u
X2599 VDD VSS.t2118 VDD VDD sg13_lv_pmos ad=0.19p pd=1.38u as=0 ps=0 w=1u l=1u
X2600 VDD VSS.t987 VDD VDD sg13_lv_pmos ad=0.34p pd=2.68u as=0 ps=0 w=1u l=1u
X2601 VSS.t2872 VDD VSS.t2871 VSS.t392 sg13_lv_nmos ad=0.1428p pd=1.52u as=0 ps=0 w=0.42u l=1u
X2602 VDD VSS.t2472 VDD VDD sg13_lv_pmos ad=0.34p pd=2.68u as=0 ps=0 w=1u l=1u
X2603 VSS.t2373 VDD VSS.t2375 VSS.t2374 sg13_lv_nmos ad=79.8f pd=0.8u as=0 ps=0 w=0.42u l=1u
X2604 VDD VSS.t471 VDD VDD sg13_lv_pmos ad=0.34p pd=2.68u as=0 ps=0 w=1u l=1u
X2605 VDD VSS.t1618 VDD VDD sg13_lv_pmos ad=0.34p pd=2.68u as=0 ps=0 w=1u l=1u
X2606 VDD VSS.t493 VDD VDD sg13_lv_pmos ad=0.19p pd=1.38u as=0 ps=0 w=1u l=1u
X2607 VDD VSS.t1791 VDD VDD sg13_lv_pmos ad=0.19p pd=1.38u as=0 ps=0 w=1u l=1u
X2608 VSS.t1664 VDD VSS.t1663 VSS.t1662 sg13_lv_nmos ad=0.1428p pd=1.52u as=0 ps=0 w=0.42u l=1u
X2609 VSS.t2081 VDD VSS.t2080 VSS.t2079 sg13_lv_nmos ad=0.1428p pd=1.52u as=0 ps=0 w=0.42u l=1u
X2610 VDD sg13g2_dfrbpq_1_3.Q sg13g2_or3_1_1.C VDD sg13_lv_pmos ad=0.2128p pd=1.5u as=0.2128p ps=1.5u w=1.12u l=0.13u
X2611 VDD VSS.t2783 VDD VDD sg13_lv_pmos ad=0.34p pd=2.68u as=0 ps=0 w=1u l=1u
X2612 VDD VSS.t1050 VDD VDD sg13_lv_pmos ad=0.19p pd=1.38u as=0 ps=0 w=1u l=1u
X2613 VSS.t1093 VDD VSS.t1092 VSS.t1091 sg13_lv_nmos ad=0.1428p pd=1.52u as=0 ps=0 w=0.42u l=1u
X2614 VDD VSS.t2480 VDD VDD sg13_lv_pmos ad=0.19p pd=1.38u as=0 ps=0 w=1u l=1u
X2615 VDD VSS.t2173 VDD VDD sg13_lv_pmos ad=0.19p pd=1.38u as=0 ps=0 w=1u l=1u
X2616 VSS.t1138 VDD VSS.t1137 VSS.t1136 sg13_lv_nmos ad=0.1428p pd=1.52u as=0 ps=0 w=0.42u l=1u
X2617 a_7160_15242# sg13g2_xnor2_1_2.A a_7058_15242# VSS.t72 sg13_lv_nmos ad=0.1406p pd=1.12u as=0.1406p ps=1.12u w=0.74u l=0.13u
X2618 VSS.t5 a_25774_15423# sg13g2_dfrbpq_1_7.D VSS.t24 sg13_lv_nmos ad=0.1426p pd=1.16u as=0.2516p ps=2.16u w=0.74u l=0.13u
X2619 VSS.t1416 VDD VSS.t1417 VSS.t311 sg13_lv_nmos ad=79.8f pd=0.8u as=0 ps=0 w=0.42u l=1u
X2620 VSS.t1819 VDD VSS.t1818 VSS.t1817 sg13_lv_nmos ad=0.1428p pd=1.52u as=0 ps=0 w=0.42u l=1u
X2621 VSS.t2856 VDD VSS.t2857 VSS.t392 sg13_lv_nmos ad=79.8f pd=0.8u as=0 ps=0 w=0.42u l=1u
X2622 VDD VSS.t2791 VDD VDD sg13_lv_pmos ad=0.19p pd=1.38u as=0 ps=0 w=1u l=1u
X2623 VDD VSS.t617 VDD VDD sg13_lv_pmos ad=0.34p pd=2.68u as=0 ps=0 w=1u l=1u
X2624 VSS.t3118 VDD VSS.t3117 VSS.t3116 sg13_lv_nmos ad=0.1428p pd=1.52u as=0 ps=0 w=0.42u l=1u
X2625 VSS.t2498 VDD VSS.t2500 VSS.t2499 sg13_lv_nmos ad=79.8f pd=0.8u as=0 ps=0 w=0.42u l=1u
X2626 VSS.t594 VDD VSS.t593 VSS.t9 sg13_lv_nmos ad=0.1428p pd=1.52u as=0 ps=0 w=0.42u l=1u
X2627 VDD VSS.t1399 VDD VDD sg13_lv_pmos ad=0.34p pd=2.68u as=0 ps=0 w=1u l=1u
X2628 VSS.t1584 VDD VSS.t1586 VSS.t1585 sg13_lv_nmos ad=79.8f pd=0.8u as=0 ps=0 w=0.42u l=1u
X2629 a_21166_16263# a_21281_16262# VSS.t226 VSS.t225 sg13_lv_nmos ad=0.1428p pd=1.52u as=0.1426p ps=1.16u w=0.42u l=0.5u
X2630 a_18106_15202# sg13g2_dlygate4sd3_1_5.A VDD VDD sg13_lv_pmos ad=0.1428p pd=1.52u as=0.1523p ps=1.38u w=0.42u l=0.13u
X2631 VSS.t1153 VDD VSS.t1155 VSS.t1154 sg13_lv_nmos ad=79.8f pd=0.8u as=0 ps=0 w=0.42u l=1u
X2632 VSS.t1338 VDD VSS.t1339 VSS.t311 sg13_lv_nmos ad=79.8f pd=0.8u as=0 ps=0 w=0.42u l=1u
X2633 VDD VSS.t1596 VDD VDD sg13_lv_pmos ad=0.19p pd=1.38u as=0 ps=0 w=1u l=1u
X2634 VDD VSS.t2505 VDD VDD sg13_lv_pmos ad=0.19p pd=1.38u as=0 ps=0 w=1u l=1u
X2635 VSS.t86 a_22426_15202# a_22145_15424# VSS.t24 sg13_lv_nmos ad=79.8f pd=0.8u as=0.1428p ps=1.52u w=0.42u l=0.5u
X2636 VDD VSS.t54 VDD VDD sg13_lv_pmos ad=0.19p pd=1.38u as=0 ps=0 w=1u l=1u
X2637 VDD VSS.t748 VDD VDD sg13_lv_pmos ad=0.19p pd=1.38u as=0 ps=0 w=1u l=1u
X2638 VDD VSS.t950 VDD VDD sg13_lv_pmos ad=0.19p pd=1.38u as=0 ps=0 w=1u l=1u
X2639 VSS.t1434 VDD VSS.t1435 VSS.t311 sg13_lv_nmos ad=79.8f pd=0.8u as=0 ps=0 w=0.42u l=1u
X2640 VSS.t2393 VDD VSS.t2395 VSS.t2394 sg13_lv_nmos ad=79.8f pd=0.8u as=0 ps=0 w=0.42u l=1u
X2641 VDD VSS.t1065 VDD VDD sg13_lv_pmos ad=0.19p pd=1.38u as=0 ps=0 w=1u l=1u
X2642 VDD VSS.t1427 VDD VDD sg13_lv_pmos ad=0.34p pd=2.68u as=0 ps=0 w=1u l=1u
X2643 VSS.t2111 VDD VSS.t2113 VSS.t2112 sg13_lv_nmos ad=79.8f pd=0.8u as=0 ps=0 w=0.42u l=1u
X2644 VSS.t86 a_22576_14726# a_22225_14845# VSS.t25 sg13_lv_nmos ad=79.8f pd=0.8u as=0.1428p ps=1.52u w=0.42u l=0.13u
X2645 VSS.t2854 VDD VSS.t2855 VSS.t392 sg13_lv_nmos ad=79.8f pd=0.8u as=0 ps=0 w=0.42u l=1u
X2646 VDD VSS.t2630 VDD VDD sg13_lv_pmos ad=0.19p pd=1.38u as=0 ps=0 w=1u l=1u
X2647 VSS.t1614 VDD VSS.t1613 VSS.t1612 sg13_lv_nmos ad=0.1428p pd=1.52u as=0 ps=0 w=0.42u l=1u
X2648 VDD VSS.t2803 VDD VDD sg13_lv_pmos ad=0.34p pd=2.68u as=0 ps=0 w=1u l=1u
X2649 a_12020_15202# sg13g2_buf_16_2.A VDD VDD sg13_lv_pmos ad=0.2128p pd=1.5u as=0.2128p ps=1.5u w=1.12u l=0.13u
X2650 VDD VSS.t1351 VDD VDD sg13_lv_pmos ad=0.34p pd=2.68u as=0 ps=0 w=1u l=1u
X2651 VDD VSS.t2855 VDD VDD sg13_lv_pmos ad=0.34p pd=2.68u as=0 ps=0 w=1u l=1u
X2652 VDD VSS.t2130 VDD VDD sg13_lv_pmos ad=0.34p pd=2.68u as=0 ps=0 w=1u l=1u
X2653 a_27472_14726# sg13g2_dfrbpq_1_7.RESET_B VDD VDD sg13_lv_pmos ad=79.8f pd=0.8u as=2.42015p ps=15.68u w=0.42u l=0.13u
X2654 a_8218_13690# sg13g2_dlygate4sd3_1_1.A VDD VDD sg13_lv_pmos ad=0.1428p pd=1.52u as=0.1523p ps=1.38u w=0.42u l=0.13u
X2655 a_26148_14040# a_26122_13945# VSS.t172 VSS.t439 sg13_lv_nmos ad=0.2516p pd=2.16u as=0.1626p ps=1.415u w=0.74u l=0.13u
X2656 VSS.t1168 VDD VSS.t1170 VSS.t1169 sg13_lv_nmos ad=79.8f pd=0.8u as=0 ps=0 w=0.42u l=1u
X2657 VDD VSS.t1408 VDD VDD sg13_lv_pmos ad=0.34p pd=2.68u as=0 ps=0 w=1u l=1u
X2658 VSS.t1609 VDD VSS.t1608 VSS.t1607 sg13_lv_nmos ad=0.1428p pd=1.52u as=0 ps=0 w=0.42u l=1u
X2659 VSS.t2518 VDD VSS.t2517 VSS.t2516 sg13_lv_nmos ad=0.1428p pd=1.52u as=0 ps=0 w=0.42u l=1u
X2660 a_17746_13722# sg13g2_dfrbpq_1_2.RESET_B VSS.t303 VSS.t389 sg13_lv_nmos ad=37.8f pd=0.6u as=79.8f ps=0.8u w=0.42u l=0.13u
X2661 VDD VSS.t1813 VDD VDD sg13_lv_pmos ad=0.34p pd=2.68u as=0 ps=0 w=1u l=1u
X2662 VSS.t2848 VDD VSS.t2849 VSS.t392 sg13_lv_nmos ad=79.8f pd=0.8u as=0 ps=0 w=0.42u l=1u
X2663 VDD VSS.t587 VDD VDD sg13_lv_pmos ad=0.34p pd=2.68u as=0 ps=0 w=1u l=1u
X2664 VDD VSS.t3042 VDD VDD sg13_lv_pmos ad=0.34p pd=2.68u as=0 ps=0 w=1u l=1u
X2665 VDD VSS.t2090 VDD VDD sg13_lv_pmos ad=0.34p pd=2.68u as=0 ps=0 w=1u l=1u
X2666 a_2916_15552# a_2890_15457# VDD VDD sg13_lv_pmos ad=0.34p pd=2.68u as=0.36237p ps=2.605u w=1u l=0.13u
X2667 VSS.t18 clock_i a_15022_14484# VSS.t297 sg13_lv_nmos ad=0.1406p pd=1.12u as=0.1406p ps=1.12u w=0.74u l=0.13u
X2668 VSS.t702 VDD VSS.t707 VSS.t706 sg13_lv_nmos ad=79.8f pd=0.8u as=0 ps=0 w=0.42u l=1u
X2669 VSS.t1028 VDD VSS.t1027 VSS.t1026 sg13_lv_nmos ad=0.1428p pd=1.52u as=0 ps=0 w=0.42u l=1u
X2670 VSS.t2433 VDD VSS.t2435 VSS.t2434 sg13_lv_nmos ad=79.8f pd=0.8u as=0 ps=0 w=0.42u l=1u
X2671 VDD VSS.t2425 VDD VDD sg13_lv_pmos ad=0.19p pd=1.38u as=0 ps=0 w=1u l=1u
X2672 VDD VSS.t3215 VDD VDD sg13_lv_pmos ad=0.19p pd=1.38u as=0 ps=0 w=1u l=1u
X2673 VDD a_9861_15213# a_9963_15356# VDD sg13_lv_pmos ad=2.8961p pd=18.25u as=0.3864p ps=2.93u w=1.12u l=0.13u
X2674 VDD VSS.t574 VDD VDD sg13_lv_pmos ad=0.19p pd=1.38u as=0 ps=0 w=1u l=1u
X2675 a_22521_14607# a_21579_14495# a_22319_14845# VDD sg13_lv_pmos ad=93.45f pd=0.865u as=0.2048p ps=1.63u w=0.42u l=0.13u
X2676 a_4078_14751# a_4193_14750# VDD VDD sg13_lv_pmos ad=0.34p pd=2.68u as=0.2254p ps=1.53u w=1u l=0.5u
X2677 VSS.t2864 VDD VSS.t2863 VSS.t392 sg13_lv_nmos ad=0.1428p pd=1.52u as=0 ps=0 w=0.42u l=1u
X2678 VDD VSS.t2818 VDD VDD sg13_lv_pmos ad=0.34p pd=2.68u as=0 ps=0 w=1u l=1u
X2679 VDD VSS.t2457 VDD VDD sg13_lv_pmos ad=0.34p pd=2.68u as=0 ps=0 w=1u l=1u
X2680 VDD VSS.t1032 VDD VDD sg13_lv_pmos ad=0.34p pd=2.68u as=0 ps=0 w=1u l=1u
X2681 VDD VSS.t1603 VDD VDD sg13_lv_pmos ad=0.34p pd=2.68u as=0 ps=0 w=1u l=1u
X2682 VSS.t903 VDD VSS.t902 VSS.t901 sg13_lv_nmos ad=0.1428p pd=1.52u as=0 ps=0 w=0.42u l=1u
X2683 VSS.t2241 VDD VSS.t2243 VSS.t2242 sg13_lv_nmos ad=79.8f pd=0.8u as=0 ps=0 w=0.42u l=1u
X2684 VDD VSS.t955 VDD VDD sg13_lv_pmos ad=0.19p pd=1.38u as=0 ps=0 w=1u l=1u
X2685 VDD VSS.t774 VDD VDD sg13_lv_pmos ad=0.19p pd=1.38u as=0 ps=0 w=1u l=1u
X2686 VSS.t2811 VDD VSS.t2809 VSS.t392 sg13_lv_nmos ad=0.1428p pd=1.52u as=0 ps=0 w=0.42u l=1u
X2687 VDD sg13g2_a21oi_1_0.A1 a_16955_12972# VDD sg13_lv_pmos ad=0.2128p pd=1.5u as=0.2128p ps=1.5u w=1.12u l=0.13u
X2688 VSS.t768 VDD VSS.t768 VSS.t888 sg13_lv_nmos ad=0.1428p pd=1.52u as=0 ps=0 w=0.42u l=1u
X2689 VDD VSS.t535 VDD VDD sg13_lv_pmos ad=0.34p pd=2.68u as=0 ps=0 w=1u l=1u
X2690 VSS.t1138 VDD VSS.t1137 VSS.t1136 sg13_lv_nmos ad=0.1428p pd=1.52u as=0 ps=0 w=0.42u l=1u
X2691 VDD VSS.t1793 VDD VDD sg13_lv_pmos ad=0.34p pd=2.68u as=0 ps=0 w=1u l=1u
X2692 VDD VSS.t626 VDD VDD sg13_lv_pmos ad=0.34p pd=2.68u as=0 ps=0 w=1u l=1u
X2693 VDD VSS.t907 VDD VDD sg13_lv_pmos ad=0.34p pd=2.68u as=0 ps=0 w=1u l=1u
X2694 VDD VSS.t1656 VDD VDD sg13_lv_pmos ad=0.19p pd=1.38u as=0 ps=0 w=1u l=1u
X2695 VSS.t1298 VDD VSS.t1299 VSS.t311 sg13_lv_nmos ad=79.8f pd=0.8u as=0 ps=0 w=0.42u l=1u
X2696 VDD VSS.t1318 VDD VDD sg13_lv_pmos ad=0.34p pd=2.68u as=0 ps=0 w=1u l=1u
X2697 VDD VSS.t2880 VDD VDD sg13_lv_pmos ad=0.34p pd=2.68u as=0 ps=0 w=1u l=1u
X2698 a_18021_14495# sg13g2_buf_16_2.X VSS.t9 VSS.t153 sg13_lv_nmos ad=0.2516p pd=2.16u as=5.01922p ps=33.275u w=0.74u l=0.13u
X2699 VSS.t1334 VDD VSS.t1333 VSS.t311 sg13_lv_nmos ad=0.1428p pd=1.52u as=0 ps=0 w=0.42u l=1u
X2700 VSS.t3103 VDD VSS.t3102 VSS.t3101 sg13_lv_nmos ad=0.1428p pd=1.52u as=0 ps=0 w=0.42u l=1u
X2701 VDD VSS.t1425 VDD VDD sg13_lv_pmos ad=0.34p pd=2.68u as=0 ps=0 w=1u l=1u
X2702 VSS.t943 VDD VSS.t942 VSS.t941 sg13_lv_nmos ad=0.1428p pd=1.52u as=0 ps=0 w=0.42u l=1u
X2703 VSS.t363 a_12524_15960# counter_value_o[2] VSS.t364 sg13_lv_nmos ad=0.14875p pd=1.16u as=0.2886p ps=2.26u w=0.74u l=0.13u
X2704 VSS.t1460 VDD VSS.t1304 VSS.t311 sg13_lv_nmos ad=79.8f pd=0.8u as=0 ps=0 w=0.42u l=1u
X2705 VDD VSS.t2962 VDD VDD sg13_lv_pmos ad=0.19p pd=1.38u as=0 ps=0 w=1u l=1u
X2706 VSS.t2378 VDD VSS.t2380 VSS.t2379 sg13_lv_nmos ad=79.8f pd=0.8u as=0 ps=0 w=0.42u l=1u
X2707 VSS.t2503 VDD VSS.t2502 VSS.t2501 sg13_lv_nmos ad=0.1428p pd=1.52u as=0 ps=0 w=0.42u l=1u
X2708 VSS.t827 VDD VSS.t307 VSS.t828 sg13_lv_nmos ad=79.8f pd=0.8u as=0 ps=0 w=0.42u l=1u
X2709 VSS.t1058 VDD VSS.t1057 VSS.t1056 sg13_lv_nmos ad=0.1428p pd=1.52u as=0 ps=0 w=0.42u l=1u
X2710 sg13g2_buf_16_2.A a_15022_14484# VSS.t62 VSS.t135 sg13_lv_nmos ad=0.1406p pd=1.12u as=0.1406p ps=1.12u w=0.74u l=0.13u
X2711 sg13g2_buf_16_2.A a_15022_14484# VSS.t62 VSS.t147 sg13_lv_nmos ad=0.1406p pd=1.12u as=0.1406p ps=1.12u w=0.74u l=0.13u
X2712 VDD VSS.t922 VDD VDD sg13_lv_pmos ad=0.34p pd=2.68u as=0 ps=0 w=1u l=1u
X2713 VDD VSS.t1110 VDD VDD sg13_lv_pmos ad=0.19p pd=1.38u as=0 ps=0 w=1u l=1u
X2714 VSS.t1353 VDD VSS.t1352 VSS.t311 sg13_lv_nmos ad=0.1428p pd=1.52u as=0 ps=0 w=0.42u l=1u
X2715 VDD VSS.t1588 VDD VDD sg13_lv_pmos ad=0.34p pd=2.68u as=0 ps=0 w=1u l=1u
X2716 VSS.t2846 VDD VSS.t2847 VSS.t392 sg13_lv_nmos ad=79.8f pd=0.8u as=0 ps=0 w=0.42u l=1u
X2717 VSS.t471 VDD VSS.t471 VSS.t475 sg13_lv_nmos ad=0.1428p pd=1.52u as=0 ps=0 w=0.42u l=1u
X2718 VSS.t712 VDD VSS.t712 VSS.t716 sg13_lv_nmos ad=79.8f pd=0.8u as=0 ps=0 w=0.42u l=1u
X2719 VDD VSS.t751 VDD VDD sg13_lv_pmos ad=0.34p pd=2.68u as=0 ps=0 w=1u l=1u
X2720 VSS.t1669 VDD VSS.t1668 VSS.t1667 sg13_lv_nmos ad=0.1428p pd=1.52u as=0 ps=0 w=0.42u l=1u
X2721 VSS.t2226 VDD VSS.t2228 VSS.t2227 sg13_lv_nmos ad=79.8f pd=0.8u as=0 ps=0 w=0.42u l=1u
X2722 VDD VSS.t455 VDD VDD sg13_lv_pmos ad=0.19p pd=1.38u as=0 ps=0 w=1u l=1u
X2723 sg13g2_and2_1_0.X a_1965_14832# VDD VDD sg13_lv_pmos ad=0.3808p pd=2.92u as=0.1918p ps=1.5u w=1.12u l=0.13u
X2724 VDD VSS.t164 VDD VDD sg13_lv_pmos ad=0.34p pd=2.68u as=0 ps=0 w=1u l=1u
X2725 VSS.t2822 VDD VSS.t2821 VSS.t392 sg13_lv_nmos ad=0.1428p pd=1.52u as=0 ps=0 w=0.42u l=1u
X2726 a_16079_15238# sg13g2_xnor2_1_1.A VSS.t62 VSS.t380 sg13_lv_nmos ad=0.2516p pd=2.16u as=0.1898p ps=1.36u w=0.74u l=0.13u
X2727 VDD VSS.t2785 VDD VDD sg13_lv_pmos ad=0.34p pd=2.68u as=0 ps=0 w=1u l=1u
X2728 VDD sg13g2_dfrbpq_1_3.RESET_B a_17318_14922# VDD sg13_lv_pmos ad=0.36237p pd=2.605u as=79.8f ps=0.8u w=0.42u l=0.13u
X2729 VSS.t702 VDD VSS.t702 VSS.t703 sg13_lv_nmos ad=0.1428p pd=1.52u as=0 ps=0 w=0.42u l=1u
X2730 VDD VSS.t1342 VDD VDD sg13_lv_pmos ad=0.34p pd=2.68u as=0 ps=0 w=1u l=1u
X2731 VDD VSS.t2847 VDD VDD sg13_lv_pmos ad=0.34p pd=2.68u as=0 ps=0 w=1u l=1u
X2732 VDD VSS.t2115 VDD VDD sg13_lv_pmos ad=0.34p pd=2.68u as=0 ps=0 w=1u l=1u
X2733 VDD VSS.t2485 VDD VDD sg13_lv_pmos ad=0.19p pd=1.38u as=0 ps=0 w=1u l=1u
X2734 sg13g2_dfrbpq_1_2.CLK a_12020_15202# VDD VDD sg13_lv_pmos ad=0.2128p pd=1.5u as=0.3976p ps=2.95u w=1.12u l=0.13u
X2735 VSS.t681 VDD VSS.t681 VSS.t682 sg13_lv_nmos ad=79.8f pd=0.8u as=0 ps=0 w=0.42u l=1u
X2736 VSS.t958 VDD VSS.t957 VSS.t956 sg13_lv_nmos ad=0.1428p pd=1.52u as=0 ps=0 w=0.42u l=1u
X2737 VDD VSS.t2143 VDD VDD sg13_lv_pmos ad=0.19p pd=1.38u as=0 ps=0 w=1u l=1u
X2738 VSS.t1388 VDD VSS.t1389 VSS.t311 sg13_lv_nmos ad=79.8f pd=0.8u as=0 ps=0 w=0.42u l=1u
X2739 VSS.t1467 VDD VSS.t1312 VSS.t311 sg13_lv_nmos ad=79.8f pd=0.8u as=0 ps=0 w=0.42u l=1u
X2740 VDD VSS.t614 VDD VDD sg13_lv_pmos ad=0.34p pd=2.68u as=0 ps=0 w=1u l=1u
X2741 VDD VSS.t985 VDD VDD sg13_lv_pmos ad=0.19p pd=1.38u as=0 ps=0 w=1u l=1u
X2742 VSS.t1028 VDD VSS.t1027 VSS.t1026 sg13_lv_nmos ad=0.1428p pd=1.52u as=0 ps=0 w=0.42u l=1u
X2743 VSS.t2840 VDD VSS.t2841 VSS.t392 sg13_lv_nmos ad=79.8f pd=0.8u as=0 ps=0 w=0.42u l=1u
X2744 VDD VSS.t1798 VDD VDD sg13_lv_pmos ad=0.34p pd=2.68u as=0 ps=0 w=1u l=1u
X2745 VSS.t3123 VDD VSS.t3122 VSS.t3121 sg13_lv_nmos ad=0.1428p pd=1.52u as=0 ps=0 w=0.42u l=1u
X2746 VDD VSS.t3027 VDD VDD sg13_lv_pmos ad=0.34p pd=2.68u as=0 ps=0 w=1u l=1u
X2747 VSS.t2598 VDD VSS.t2597 VSS.t2596 sg13_lv_nmos ad=0.1428p pd=1.52u as=0 ps=0 w=0.42u l=1u
X2748 a_6180_14922# sg13g2_and2_1_1.X a_6086_14922# VSS.t272 sg13_lv_nmos ad=60.89999f pd=0.71u as=0.1428p ps=1.52u w=0.42u l=0.13u
X2749 VDD VSS.t1150 VDD VDD sg13_lv_pmos ad=0.19p pd=1.38u as=0 ps=0 w=1u l=1u
X2750 VDD VSS.t1601 VDD VDD sg13_lv_pmos ad=0.19p pd=1.38u as=0 ps=0 w=1u l=1u
X2751 VSS.t3013 VDD VSS.t2891 VSS.t392 sg13_lv_nmos ad=79.8f pd=0.8u as=0 ps=0 w=0.42u l=1u
X2752 VDD VSS.t2510 VDD VDD sg13_lv_pmos ad=0.19p pd=1.38u as=0 ps=0 w=1u l=1u
X2753 VSS.t712 VDD VSS.t712 VSS.t717 sg13_lv_nmos ad=0.1428p pd=1.52u as=0 ps=0 w=0.42u l=1u
X2754 VSS.t903 VDD VSS.t902 VSS.t901 sg13_lv_nmos ad=0.1428p pd=1.52u as=0 ps=0 w=0.42u l=1u
X2755 VDD VSS.t1077 VDD VDD sg13_lv_pmos ad=0.34p pd=2.68u as=0 ps=0 w=1u l=1u
X2756 VSS.t1366 VDD VSS.t1365 VSS.t311 sg13_lv_nmos ad=0.1428p pd=1.52u as=0 ps=0 w=0.42u l=1u
X2757 VSS.t2116 VDD VSS.t2118 VSS.t2117 sg13_lv_nmos ad=79.8f pd=0.8u as=0 ps=0 w=0.42u l=1u
X2758 VDD a_6789_14495# a_6891_14495# VDD sg13_lv_pmos ad=2.42015p pd=15.68u as=0.3864p ps=2.93u w=1.12u l=0.13u
X2759 VSS.t2838 VDD VSS.t2839 VSS.t392 sg13_lv_nmos ad=79.8f pd=0.8u as=0 ps=0 w=0.42u l=1u
X2760 VSS.t1619 VDD VSS.t1618 VSS.t1617 sg13_lv_nmos ad=0.1428p pd=1.52u as=0 ps=0 w=0.42u l=1u
X2761 VSS.t226 VDD VSS.t226 VSS.t504 sg13_lv_nmos ad=0.1428p pd=1.52u as=0 ps=0 w=0.42u l=1u
X2762 VDD a_21166_16263# sg13g2_dfrbpq_1_6.D VDD sg13_lv_pmos ad=0.2254p pd=1.53u as=0.4256p ps=3u w=1.12u l=0.13u
X2763 a_15022_14484# clock_i VSS.t18 VSS.t300 sg13_lv_nmos ad=0.1406p pd=1.12u as=0.1406p ps=1.12u w=0.74u l=0.13u
X2764 VDD VSS.t616 VDD VDD sg13_lv_pmos ad=0.19p pd=1.38u as=0 ps=0 w=1u l=1u
X2765 VSS.t1789 VDD VSS.t1791 VSS.t1790 sg13_lv_nmos ad=79.8f pd=0.8u as=0 ps=0 w=0.42u l=1u
X2766 VSS.t2181 VDD VSS.t2180 VSS.t2179 sg13_lv_nmos ad=0.1428p pd=1.52u as=0 ps=0 w=0.42u l=1u
X2767 VDD VSS.t2135 VDD VDD sg13_lv_pmos ad=0.34p pd=2.68u as=0 ps=0 w=1u l=1u
X2768 VSS.t681 VDD VSS.t681 VSS.t684 sg13_lv_nmos ad=79.8f pd=0.8u as=0 ps=0 w=0.42u l=1u
X2769 VSS.t723 VDD VSS.t723 VSS.t843 sg13_lv_nmos ad=79.8f pd=0.8u as=0 ps=0 w=0.42u l=1u
X2770 VDD VSS.t2839 VDD VDD sg13_lv_pmos ad=0.34p pd=2.68u as=0 ps=0 w=1u l=1u
X2771 sg13g2_dlygate4sd3_1_5.A sg13g2_dlygate4sd3_1_6.X a_18454_15230# VSS.t0 sg13_lv_nmos ad=0.2516p pd=2.16u as=0.1406p ps=1.12u w=0.74u l=0.15u
X2772 VDD VSS.t1140 VDD VDD sg13_lv_pmos ad=0.19p pd=1.38u as=0 ps=0 w=1u l=1u
X2773 VSS.t1370 VDD VSS.t1368 VSS.t311 sg13_lv_nmos ad=0.1428p pd=1.52u as=0 ps=0 w=0.42u l=1u
X2774 VSS.t1293 VDD VSS.t1293 VSS.t311 sg13_lv_nmos ad=0.1428p pd=1.52u as=0 ps=0 w=0.42u l=1u
X2775 VSS.t1402 VDD VSS.t1403 VSS.t311 sg13_lv_nmos ad=79.8f pd=0.8u as=0 ps=0 w=0.42u l=1u
X2776 VSS.t612 VDD VSS.t611 VSS.t9 sg13_lv_nmos ad=0.1428p pd=1.52u as=0 ps=0 w=0.42u l=1u
X2777 VSS.t2363 VDD VSS.t2365 VSS.t2364 sg13_lv_nmos ad=79.8f pd=0.8u as=0 ps=0 w=0.42u l=1u
X2778 VDD VSS.t1818 VDD VDD sg13_lv_pmos ad=0.34p pd=2.68u as=0 ps=0 w=1u l=1u
X2779 a_27898_15202# sg13g2_dfrbpq_1_5.Q VDD VDD sg13_lv_pmos ad=0.1428p pd=1.52u as=0.1523p ps=1.38u w=0.42u l=0.13u
X2780 VDD VSS.t1311 VDD VDD sg13_lv_pmos ad=0.34p pd=2.68u as=0 ps=0 w=1u l=1u
X2781 VDD VSS.t2095 VDD VDD sg13_lv_pmos ad=0.34p pd=2.68u as=0 ps=0 w=1u l=1u
X2782 VSS.t2438 VDD VSS.t2440 VSS.t2439 sg13_lv_nmos ad=79.8f pd=0.8u as=0 ps=0 w=0.42u l=1u
X2783 VSS.t943 VDD VSS.t942 VSS.t941 sg13_lv_nmos ad=0.1428p pd=1.52u as=0 ps=0 w=0.42u l=1u
X2784 VDD VSS.t3220 VDD VDD sg13_lv_pmos ad=0.19p pd=1.38u as=0 ps=0 w=1u l=1u
X2785 VDD VSS.t856 VDD VDD sg13_lv_pmos ad=0.19p pd=1.38u as=0 ps=0 w=1u l=1u
X2786 VSS.t1058 VDD VSS.t1057 VSS.t1056 sg13_lv_nmos ad=0.1428p pd=1.52u as=0 ps=0 w=0.42u l=1u
X2787 VSS.t1173 VDD VSS.t1175 VSS.t1174 sg13_lv_nmos ad=79.8f pd=0.8u as=0 ps=0 w=0.42u l=1u
X2788 VSS.t541 VDD VSS.t543 VSS.t542 sg13_lv_nmos ad=79.8f pd=0.8u as=0 ps=0 w=0.42u l=1u
X2789 VSS.t681 VDD VSS.t681 VSS.t690 sg13_lv_nmos ad=79.8f pd=0.8u as=0 ps=0 w=0.42u l=1u
X2790 VSS.t2992 VDD VSS.t2865 VSS.t392 sg13_lv_nmos ad=0.1428p pd=1.52u as=0 ps=0 w=0.42u l=1u
X2791 VDD VSS.t2801 VDD VDD sg13_lv_pmos ad=0.34p pd=2.68u as=0 ps=0 w=1u l=1u
X2792 a_21348_14909# a_21579_14495# a_21034_14452# VSS.t414 sg13_lv_nmos ad=0.2373p pd=1.97u as=79.8f ps=0.8u w=0.42u l=0.13u
X2793 VDD VSS.t1155 VDD VDD sg13_lv_pmos ad=0.19p pd=1.38u as=0 ps=0 w=1u l=1u
X2794 VSS.t450 VDD VSS.t452 VSS.t451 sg13_lv_nmos ad=79.8f pd=0.8u as=0 ps=0 w=0.42u l=1u
X2795 VDD a_27898_15202# a_27617_15424# VDD sg13_lv_pmos ad=0.1523p pd=1.38u as=0.34p ps=2.68u w=1u l=0.5u
X2796 VDD VSS.t596 VDD VDD sg13_lv_pmos ad=0.34p pd=2.68u as=0 ps=0 w=1u l=1u
X2797 VDD VSS.t1373 VDD VDD sg13_lv_pmos ad=0.19p pd=1.38u as=0 ps=0 w=1u l=1u
X2798 VDD VSS.t2875 VDD VDD sg13_lv_pmos ad=0.19p pd=1.38u as=0 ps=0 w=1u l=1u
X2799 VSS.t2211 VDD VSS.t2213 VSS.t2212 sg13_lv_nmos ad=79.8f pd=0.8u as=0 ps=0 w=0.42u l=1u
X2800 VSS.t1654 VDD VSS.t1653 VSS.t1652 sg13_lv_nmos ad=0.1428p pd=1.52u as=0 ps=0 w=0.42u l=1u
X2801 VDD VSS.t1613 VDD VDD sg13_lv_pmos ad=0.34p pd=2.68u as=0 ps=0 w=1u l=1u
X2802 VSS.t2814 VDD VSS.t2813 VSS.t392 sg13_lv_nmos ad=0.1428p pd=1.52u as=0 ps=0 w=0.42u l=1u
X2803 VDD VSS.t2522 VDD VDD sg13_lv_pmos ad=0.34p pd=2.68u as=0 ps=0 w=1u l=1u
X2804 VSS.t2583 VDD VSS.t2582 VSS.t2581 sg13_lv_nmos ad=0.1428p pd=1.52u as=0 ps=0 w=0.42u l=1u
X2805 VDD VSS.t2777 VDD VDD sg13_lv_pmos ad=0.34p pd=2.68u as=0 ps=0 w=1u l=1u
X2806 VDD VSS.t915 VDD VDD sg13_lv_pmos ad=0.19p pd=1.38u as=0 ps=0 w=1u l=1u
X2807 VSS.t958 VDD VSS.t957 VSS.t956 sg13_lv_nmos ad=0.1428p pd=1.52u as=0 ps=0 w=0.42u l=1u
X2808 VSS.t1384 VDD VSS.t1382 VSS.t311 sg13_lv_nmos ad=0.1428p pd=1.52u as=0 ps=0 w=0.42u l=1u
X2809 a_22125_14020# sg13g2_or3_1_2.B a_22036_14020# VDD sg13_lv_pmos ad=0.19p pd=1.38u as=0.1575p ps=1.315u w=1u l=0.13u
X2810 VDD VSS.t733 VDD VDD sg13_lv_pmos ad=0.19p pd=1.38u as=0 ps=0 w=1u l=1u
X2811 VSS.t2131 VDD VSS.t2130 VSS.t2129 sg13_lv_nmos ad=0.1428p pd=1.52u as=0 ps=0 w=0.42u l=1u
X2812 VSS.t176 VDD VSS.t176 VSS.t862 sg13_lv_nmos ad=0.1428p pd=1.52u as=0 ps=0 w=0.42u l=1u
X2813 VSS.t1414 VDD VSS.t1415 VSS.t311 sg13_lv_nmos ad=79.8f pd=0.8u as=0 ps=0 w=0.42u l=1u
X2814 VDD VSS.t2470 VDD VDD sg13_lv_pmos ad=0.19p pd=1.38u as=0 ps=0 w=1u l=1u
X2815 VDD VSS.t2128 VDD VDD sg13_lv_pmos ad=0.19p pd=1.38u as=0 ps=0 w=1u l=1u
X2816 a_26148_14040# a_26122_13945# VDD VDD sg13_lv_pmos ad=0.34p pd=2.68u as=0.36237p ps=2.605u w=1u l=0.13u
X2817 VDD VSS.t1321 VDD VDD sg13_lv_pmos ad=0.34p pd=2.68u as=0 ps=0 w=1u l=1u
X2818 VSS.t3108 VDD VSS.t3107 VSS.t3106 sg13_lv_nmos ad=0.1428p pd=1.52u as=0 ps=0 w=0.42u l=1u
X2819 VSS.t188 VDD VSS.t13 VSS.t645 sg13_lv_nmos ad=79.8f pd=0.8u as=0 ps=0 w=0.42u l=1u
X2820 VSS.t1143 VDD VSS.t1142 VSS.t1141 sg13_lv_nmos ad=0.1428p pd=1.52u as=0 ps=0 w=0.42u l=1u
X2821 VDD VSS.t605 VDD VDD sg13_lv_pmos ad=0.34p pd=2.68u as=0 ps=0 w=1u l=1u
X2822 VDD VSS.t1319 VDD VDD sg13_lv_pmos ad=0.34p pd=2.68u as=0 ps=0 w=1u l=1u
X2823 VSS.t1551 VDD VSS.t1420 VSS.t311 sg13_lv_nmos ad=79.8f pd=0.8u as=0 ps=0 w=0.42u l=1u
X2824 VDD VSS.t1007 VDD VDD sg13_lv_pmos ad=0.34p pd=2.68u as=0 ps=0 w=1u l=1u
X2825 VDD VSS.t1586 VDD VDD sg13_lv_pmos ad=0.19p pd=1.38u as=0 ps=0 w=1u l=1u
X2826 VSS.t3006 VDD VSS.t2883 VSS.t392 sg13_lv_nmos ad=79.8f pd=0.8u as=0 ps=0 w=0.42u l=1u
X2827 VSS.t766 VDD VSS.t768 VSS.t887 sg13_lv_nmos ad=79.8f pd=0.8u as=0 ps=0 w=0.42u l=1u
X2828 VSS.t2985 VDD VSS.t2857 VSS.t392 sg13_lv_nmos ad=0.1428p pd=1.52u as=0 ps=0 w=0.42u l=1u
X2829 VSS.t2383 VDD VSS.t2385 VSS.t2384 sg13_lv_nmos ad=79.8f pd=0.8u as=0 ps=0 w=0.42u l=1u
X2830 VDD VSS.t1593 VDD VDD sg13_lv_pmos ad=0.34p pd=2.68u as=0 ps=0 w=1u l=1u
X2831 VDD VSS.t1766 VDD VDD sg13_lv_pmos ad=0.19p pd=1.38u as=0 ps=0 w=1u l=1u
X2832 VSS.t1674 VDD VSS.t1673 VSS.t1672 sg13_lv_nmos ad=0.1428p pd=1.52u as=0 ps=0 w=0.42u l=1u
X2833 sg13g2_or3_1_1.B a_14357_15238# VSS.t15 VSS.t16 sg13_lv_nmos ad=0.1406p pd=1.12u as=0.1406p ps=1.12u w=0.74u l=0.13u
X2834 sg13g2_or3_1_1.C sg13g2_o21ai_1_2.B1 a_24062_15242# VSS.t24 sg13_lv_nmos ad=0.2516p pd=2.16u as=0.1406p ps=1.12u w=0.74u l=0.13u
X2835 VSS.t1604 VDD VSS.t1603 VSS.t1602 sg13_lv_nmos ad=0.1428p pd=1.52u as=0 ps=0 w=0.42u l=1u
X2836 VDD VSS.t1070 VDD VDD sg13_lv_pmos ad=0.19p pd=1.38u as=0 ps=0 w=1u l=1u
X2837 VDD VSS.t2768 VDD VDD sg13_lv_pmos ad=0.34p pd=2.68u as=0 ps=0 w=1u l=1u
X2838 VDD VSS.t1345 VDD VDD sg13_lv_pmos ad=0.34p pd=2.68u as=0 ps=0 w=1u l=1u
X2839 VDD VSS.t2120 VDD VDD sg13_lv_pmos ad=0.34p pd=2.68u as=0 ps=0 w=1u l=1u
X2840 VSS.t105 sg13g2_and2_1_2.B a_8779_14832# VSS.t261 sg13_lv_nmos ad=0.1331p pd=1.12u as=0.1216p ps=1.02u w=0.64u l=0.13u
X2841 a_27407_13799# a_26565_13701# a_27313_13799# VSS.t315 sg13_lv_nmos ad=0.12665p pd=1.145u as=0.1428p ps=1.52u w=0.42u l=0.13u
X2842 VDD VSS.t2490 VDD VDD sg13_lv_pmos ad=0.19p pd=1.38u as=0 ps=0 w=1u l=1u
X2843 a_6660_14909# a_6372_14488# a_6598_14909# VSS.t276 sg13_lv_nmos ad=0.1428p pd=1.52u as=37.8f ps=0.6u w=0.42u l=0.13u
X2844 VDD VSS.t2148 VDD VDD sg13_lv_pmos ad=0.19p pd=1.38u as=0 ps=0 w=1u l=1u
X2845 a_25203_13320# sg13g2_a21oi_1_3.A2 VSS.t172 VSS.t280 sg13_lv_nmos ad=0.1406p pd=1.12u as=0.2516p ps=2.16u w=0.74u l=0.13u
X2846 VSS.t1794 VDD VSS.t1793 VSS.t1792 sg13_lv_nmos ad=0.1428p pd=1.52u as=0 ps=0 w=0.42u l=1u
X2847 VDD VSS.t997 VDD VDD sg13_lv_pmos ad=0.34p pd=2.68u as=0 ps=0 w=1u l=1u
X2848 VSS.t1173 VDD VSS.t1175 VSS.t1174 sg13_lv_nmos ad=79.8f pd=0.8u as=0 ps=0 w=0.42u l=1u
X2849 VDD VSS.t1410 VDD VDD sg13_lv_pmos ad=0.34p pd=2.68u as=0 ps=0 w=1u l=1u
X2850 VSS.t2603 VDD VSS.t2602 VSS.t2601 sg13_lv_nmos ad=0.1428p pd=1.52u as=0 ps=0 w=0.42u l=1u
X2851 a_17892_14909# a_18123_14495# a_17578_14452# VSS.t279 sg13_lv_nmos ad=0.2373p pd=1.97u as=79.8f ps=0.8u w=0.42u l=0.13u
X2852 a_17961_14531# a_17604_14488# VDD VDD sg13_lv_pmos ad=63f pd=0.72u as=0.1563p ps=1.22u w=0.42u l=0.13u
X2853 VDD VSS.t681 VDD VDD sg13_lv_pmos ad=0.34p pd=2.68u as=0 ps=0 w=1u l=1u
X2854 VDD VSS.t751 VDD VDD sg13_lv_pmos ad=0.19p pd=1.38u as=0 ps=0 w=1u l=1u
X2855 VDD a_32492_15960# counter_value_o[6] VDD sg13_lv_pmos ad=0.2114p pd=1.54u as=0.42p ps=2.99u w=1.12u l=0.13u
X2856 VSS.t745 VDD VSS.t745 VSS.t874 sg13_lv_nmos ad=0.1428p pd=1.52u as=0 ps=0 w=0.42u l=1u
X2857 VDD VSS.t1374 VDD VDD sg13_lv_pmos ad=0.19p pd=1.38u as=0 ps=0 w=1u l=1u
X2858 VDD VSS.t2175 VDD VDD sg13_lv_pmos ad=0.34p pd=2.68u as=0 ps=0 w=1u l=1u
X2859 VDD a_15022_14484# sg13g2_buf_16_2.A VDD sg13_lv_pmos ad=0.2128p pd=1.5u as=0.2128p ps=1.5u w=1.12u l=0.13u
X2860 VSS.t723 VDD VSS.t723 VSS.t726 sg13_lv_nmos ad=79.8f pd=0.8u as=0 ps=0 w=0.42u l=1u
X2861 VSS.t1033 VDD VSS.t1032 VSS.t1031 sg13_lv_nmos ad=0.1428p pd=1.52u as=0 ps=0 w=0.42u l=1u
X2862 VDD VSS.t3300 VDD VDD sg13_lv_pmos ad=0.19p pd=1.38u as=0 ps=0 w=1u l=1u
X2863 VSS.t2368 VDD VSS.t2370 VSS.t2369 sg13_lv_nmos ad=79.8f pd=0.8u as=0 ps=0 w=0.42u l=1u
X2864 VSS.t1355 VDD VSS.t1356 VSS.t311 sg13_lv_nmos ad=79.8f pd=0.8u as=0 ps=0 w=0.42u l=1u
X2865 VDD VSS.t2791 VDD VDD sg13_lv_pmos ad=0.34p pd=2.68u as=0 ps=0 w=1u l=1u
X2866 VSS.t2841 VDD VSS.t2841 VSS.t392 sg13_lv_nmos ad=79.8f pd=0.8u as=0 ps=0 w=0.42u l=1u
X2867 VDD VSS.t1037 VDD VDD sg13_lv_pmos ad=0.34p pd=2.68u as=0 ps=0 w=1u l=1u
X2868 VSS.t1589 VDD VSS.t1588 VSS.t1587 sg13_lv_nmos ad=0.1428p pd=1.52u as=0 ps=0 w=0.42u l=1u
X2869 VSS.t13 sg13g2_nand4_1_0.Y a_14357_15238# VSS.t102 sg13_lv_nmos ad=0.3293p pd=1.63u as=0.2516p ps=2.16u w=0.74u l=0.13u
X2870 VSS.t21 a_21466_15202# a_21185_15424# VSS.t31 sg13_lv_nmos ad=79.8f pd=0.8u as=0.1428p ps=1.52u w=0.42u l=0.5u
X2871 VDD VSS.t1598 VDD VDD sg13_lv_pmos ad=0.34p pd=2.68u as=0 ps=0 w=1u l=1u
X2872 VDD VSS.t2507 VDD VDD sg13_lv_pmos ad=0.34p pd=2.68u as=0 ps=0 w=1u l=1u
X2873 VSS.t45 sg13g2_xnor2_1_1.A a_18454_15230# VSS.t382 sg13_lv_nmos ad=0.1406p pd=1.12u as=0.2516p ps=2.16u w=0.74u l=0.15u
X2874 VSS.t908 VDD VSS.t907 VSS.t906 sg13_lv_nmos ad=0.1428p pd=1.52u as=0 ps=0 w=0.42u l=1u
X2875 VDD VSS.t1336 VDD VDD sg13_lv_pmos ad=0.34p pd=2.68u as=0 ps=0 w=1u l=1u
X2876 VDD VSS.t2841 VDD VDD sg13_lv_pmos ad=0.34p pd=2.68u as=0 ps=0 w=1u l=1u
X2877 VSS.t2398 VDD VSS.t2397 VSS.t2396 sg13_lv_nmos ad=0.1428p pd=1.52u as=0 ps=0 w=0.42u l=1u
X2878 a_32492_15960# sg13g2_dfrbpq_1_7.Q VDD VDD sg13_lv_pmos ad=0.2856p pd=2.36u as=0.2114p ps=1.54u w=0.84u l=0.13u
X2879 VDD VSS.t960 VDD VDD sg13_lv_pmos ad=0.19p pd=1.38u as=0 ps=0 w=1u l=1u
X2880 VSS.t2779 VDD VSS.t2781 VSS.t392 sg13_lv_nmos ad=79.8f pd=0.8u as=0 ps=0 w=0.42u l=1u
X2881 VDD VSS.t2632 VDD VDD sg13_lv_pmos ad=0.34p pd=2.68u as=0 ps=0 w=1u l=1u
X2882 VSS.t712 VDD VSS.t712 VSS.t716 sg13_lv_nmos ad=79.8f pd=0.8u as=0 ps=0 w=0.42u l=1u
X2883 VSS.t1143 VDD VSS.t1142 VSS.t1141 sg13_lv_nmos ad=0.1428p pd=1.52u as=0 ps=0 w=0.42u l=1u
X2884 VSS.t1332 VDD VSS.t1331 VSS.t311 sg13_lv_nmos ad=0.1428p pd=1.52u as=0 ps=0 w=0.42u l=1u
X2885 VSS.t1363 VDD VSS.t1364 VSS.t311 sg13_lv_nmos ad=79.8f pd=0.8u as=0 ps=0 w=0.42u l=1u
X2886 VDD VSS.t1313 VDD VDD sg13_lv_pmos ad=0.34p pd=2.68u as=0 ps=0 w=1u l=1u
X2887 VDD VSS.t2160 VDD VDD sg13_lv_pmos ad=0.34p pd=2.68u as=0 ps=0 w=1u l=1u
X2888 VSS.t1489 VDD VSS.t1336 VSS.t311 sg13_lv_nmos ad=0.1428p pd=1.52u as=0 ps=0 w=0.42u l=1u
X2889 VDD sg13g2_buf_16_2.A a_12020_15202# VDD sg13_lv_pmos ad=0.2128p pd=1.5u as=0.2128p ps=1.5u w=1.12u l=0.13u
X2890 VSS.t923 VDD VSS.t922 VSS.t921 sg13_lv_nmos ad=0.1428p pd=1.52u as=0 ps=0 w=0.42u l=1u
X2891 VSS.t1108 VDD VSS.t1110 VSS.t1109 sg13_lv_nmos ad=79.8f pd=0.8u as=0 ps=0 w=0.42u l=1u
X2892 VSS.t2978 VDD VSS.t2849 VSS.t392 sg13_lv_nmos ad=0.1428p pd=1.52u as=0 ps=0 w=0.42u l=1u
X2893 VDD VSS.t2803 VDD VDD sg13_lv_pmos ad=0.34p pd=2.68u as=0 ps=0 w=1u l=1u
X2894 a_2540_15960# sg13g2_dlygate4sd3_1_3.A VDD VDD sg13_lv_pmos ad=0.2856p pd=2.36u as=0.2114p ps=1.54u w=0.84u l=0.13u
X2895 VDD clock_i a_15022_14484# VDD sg13_lv_pmos ad=0.2128p pd=1.5u as=0.2128p ps=1.5u w=1.12u l=0.13u
X2896 VSS.t1451 VDD VSS.t1292 VSS.t311 sg13_lv_nmos ad=79.8f pd=0.8u as=0 ps=0 w=0.42u l=1u
X2897 VDD VSS.t2108 VDD VDD sg13_lv_pmos ad=0.19p pd=1.38u as=0 ps=0 w=1u l=1u
X2898 VDD VSS.t54 VDD VDD sg13_lv_pmos ad=0.34p pd=2.68u as=0 ps=0 w=1u l=1u
X2899 VDD VSS.t1578 VDD VDD sg13_lv_pmos ad=0.34p pd=2.68u as=0 ps=0 w=1u l=1u
X2900 VSS.t2216 VDD VSS.t2218 VSS.t2217 sg13_lv_nmos ad=79.8f pd=0.8u as=0 ps=0 w=0.42u l=1u
X2901 VDD VSS.t830 VDD VDD sg13_lv_pmos ad=0.34p pd=2.68u as=0 ps=0 w=1u l=1u
X2902 VDD VSS.t1115 VDD VDD sg13_lv_pmos ad=0.19p pd=1.38u as=0 ps=0 w=1u l=1u
X2903 VSS.t1659 VDD VSS.t1658 VSS.t1657 sg13_lv_nmos ad=0.1428p pd=1.52u as=0 ps=0 w=0.42u l=1u
X2904 VDD VSS.t1618 VDD VDD sg13_lv_pmos ad=0.34p pd=2.68u as=0 ps=0 w=1u l=1u
X2905 VSS.t3303 VDD VSS.t3305 VSS.t3304 sg13_lv_nmos ad=79.8f pd=0.8u as=0 ps=0 w=0.42u l=1u
X2906 VSS.t2816 VDD VSS.t2816 VSS.t392 sg13_lv_nmos ad=0.1428p pd=1.52u as=0 ps=0 w=0.42u l=1u
X2907 VDD VSS.t2527 VDD VDD sg13_lv_pmos ad=0.34p pd=2.68u as=0 ps=0 w=1u l=1u
X2908 VDD VSS.t1791 VDD VDD sg13_lv_pmos ad=0.19p pd=1.38u as=0 ps=0 w=1u l=1u
X2909 VDD VSS.t927 VDD VDD sg13_lv_pmos ad=0.34p pd=2.68u as=0 ps=0 w=1u l=1u
X2910 VSS.t471 VDD VSS.t466 VSS.t470 sg13_lv_nmos ad=0.1428p pd=1.52u as=0 ps=0 w=0.42u l=1u
X2911 a_12020_15202# sg13g2_buf_16_2.A VSS.t13 VSS.t398 sg13_lv_nmos ad=0.1406p pd=1.12u as=0.1406p ps=1.12u w=0.74u l=0.13u
X2912 VSS.t588 VDD VSS.t587 VSS.t9 sg13_lv_nmos ad=0.1428p pd=1.52u as=0 ps=0 w=0.42u l=1u
X2913 sg13g2_and2_1_0.B a_2490_14447# VSS.t99 VSS.t98 sg13_lv_nmos ad=0.1628p pd=1.18u as=0.3108p ps=2.32u w=0.74u l=0.13u
X2914 sg13g2_dfrbpq_1_2.Q a_17994_14020# VSS.t303 VSS.t302 sg13_lv_nmos ad=0.2516p pd=2.16u as=0.1406p ps=1.12u w=0.74u l=0.13u
X2915 VSS.t2136 VDD VSS.t2135 VSS.t2134 sg13_lv_nmos ad=0.1428p pd=1.52u as=0 ps=0 w=0.42u l=1u
X2916 VSS.t712 VDD VSS.t712 VSS.t718 sg13_lv_nmos ad=79.8f pd=0.8u as=0 ps=0 w=0.42u l=1u
X2917 VDD VSS.t2475 VDD VDD sg13_lv_pmos ad=0.19p pd=1.38u as=0 ps=0 w=1u l=1u
X2918 VDD VSS.t2133 VDD VDD sg13_lv_pmos ad=0.19p pd=1.38u as=0 ps=0 w=1u l=1u
X2919 VDD VSS.t1042 VDD VDD sg13_lv_pmos ad=0.34p pd=2.68u as=0 ps=0 w=1u l=1u
X2920 VSS.t1310 VDD VSS.t1311 VSS.t311 sg13_lv_nmos ad=79.8f pd=0.8u as=0 ps=0 w=0.42u l=1u
X2921 VSS.t1346 VDD VSS.t1345 VSS.t311 sg13_lv_nmos ad=0.1428p pd=1.52u as=0 ps=0 w=0.42u l=1u
X2922 VDD VSS.t681 VDD VDD sg13_lv_pmos ad=0.34p pd=2.68u as=0 ps=0 w=1u l=1u
X2923 VDD VSS.t1436 VDD VDD sg13_lv_pmos ad=0.34p pd=2.68u as=0 ps=0 w=1u l=1u
X2924 a_9444_15552# a_9963_15356# a_10703_15311# VSS.t218 sg13_lv_nmos ad=0.3473p pd=2.71u as=0.12665p ps=1.145u w=0.74u l=0.13u
X2925 a_7888_14726# sg13g2_dfrbpq_1_1.RESET_B VDD VDD sg13_lv_pmos ad=79.8f pd=0.8u as=2.42015p ps=15.68u w=0.42u l=0.13u
X2926 VSS.t777 VDD VSS.t774 VSS.t776 sg13_lv_nmos ad=0.1428p pd=1.52u as=0 ps=0 w=0.42u l=1u
X2927 VSS.t681 VDD VSS.t681 VSS.t684 sg13_lv_nmos ad=79.8f pd=0.8u as=0 ps=0 w=0.42u l=1u
X2928 VDD a_27215_14845# a_27472_14726# VDD sg13_lv_pmos ad=2.42015p pd=15.68u as=79.8f ps=0.8u w=0.42u l=0.13u
X2929 VDD VSS.t617 VDD VDD sg13_lv_pmos ad=0.34p pd=2.68u as=0 ps=0 w=1u l=1u
X2930 VSS.t1033 VDD VSS.t1032 VSS.t1031 sg13_lv_nmos ad=0.1428p pd=1.52u as=0 ps=0 w=0.42u l=1u
X2931 VSS.t1470 VDD VSS.t1314 VSS.t311 sg13_lv_nmos ad=79.8f pd=0.8u as=0 ps=0 w=0.42u l=1u
X2932 VDD VSS.t2764 VDD VDD sg13_lv_pmos ad=0.19p pd=1.38u as=0 ps=0 w=1u l=1u
X2933 VDD a_7631_14845# a_8298_14484# VDD sg13_lv_pmos ad=0.2128p pd=1.5u as=0.3864p ps=2.93u w=1.12u l=0.13u
X2934 VSS.t1078 VDD VSS.t1077 VSS.t1076 sg13_lv_nmos ad=0.1428p pd=1.52u as=0 ps=0 w=0.42u l=1u
X2935 VSS.t1649 VDD VSS.t1648 VSS.t1647 sg13_lv_nmos ad=0.1428p pd=1.52u as=0 ps=0 w=0.42u l=1u
X2936 VSS.t3173 VDD VSS.t3172 VSS.t3171 sg13_lv_nmos ad=0.1428p pd=1.52u as=0 ps=0 w=0.42u l=1u
X2937 VSS.t2383 VDD VSS.t2382 VSS.t2381 sg13_lv_nmos ad=0.1428p pd=1.52u as=0 ps=0 w=0.42u l=1u
X2938 a_16955_12972# sg13g2_a21oi_1_0.B1 sg13g2_a21oi_1_0.Y VDD sg13_lv_pmos ad=0.2128p pd=1.5u as=0.3808p ps=2.92u w=1.12u l=0.13u
X2939 VDD VSS.t942 VDD VDD sg13_lv_pmos ad=0.34p pd=2.68u as=0 ps=0 w=1u l=1u
X2940 VSS.t1380 VDD VSS.t1382 VSS.t311 sg13_lv_nmos ad=79.8f pd=0.8u as=0 ps=0 w=0.42u l=1u
X2941 VDD VSS.t3285 VDD VDD sg13_lv_pmos ad=0.19p pd=1.38u as=0 ps=0 w=1u l=1u
X2942 VSS.t2833 VDD VSS.t2833 VSS.t392 sg13_lv_nmos ad=79.8f pd=0.8u as=0 ps=0 w=0.42u l=1u
X2943 VDD VSS.t1771 VDD VDD sg13_lv_pmos ad=0.19p pd=1.38u as=0 ps=0 w=1u l=1u
X2944 VDD VSS.t3237 VDD VDD sg13_lv_pmos ad=0.34p pd=2.68u as=0 ps=0 w=1u l=1u
X2945 VSS.t908 VDD VSS.t907 VSS.t906 sg13_lv_nmos ad=0.1428p pd=1.52u as=0 ps=0 w=0.42u l=1u
X2946 VSS.t511 VDD VSS.t513 VSS.t512 sg13_lv_nmos ad=79.8f pd=0.8u as=0 ps=0 w=0.42u l=1u
X2947 a_19054_15423# a_19169_15424# VSS.t45 VSS.t0 sg13_lv_nmos ad=0.1428p pd=1.52u as=0.1426p ps=1.16u w=0.42u l=0.5u
X2948 VSS.t681 VDD VSS.t681 VSS.t690 sg13_lv_nmos ad=79.8f pd=0.8u as=0 ps=0 w=0.42u l=1u
X2949 VSS.t1138 VDD VSS.t1140 VSS.t1139 sg13_lv_nmos ad=79.8f pd=0.8u as=0 ps=0 w=0.42u l=1u
X2950 VDD VSS.t2868 VDD VDD sg13_lv_pmos ad=0.19p pd=1.38u as=0 ps=0 w=1u l=1u
X2951 VSS.t2171 VDD VSS.t2170 VSS.t2169 sg13_lv_nmos ad=0.1428p pd=1.52u as=0 ps=0 w=0.42u l=1u
X2952 VDD VSS.t1327 VDD VDD sg13_lv_pmos ad=0.19p pd=1.38u as=0 ps=0 w=1u l=1u
X2953 VDD VSS.t1327 VDD VDD sg13_lv_pmos ad=0.34p pd=2.68u as=0 ps=0 w=1u l=1u
X2954 VDD VSS.t2833 VDD VDD sg13_lv_pmos ad=0.34p pd=2.68u as=0 ps=0 w=1u l=1u
X2955 sg13g2_dfrbpq_1_2.CLK a_12020_15202# VSS.t188 VSS.t197 sg13_lv_nmos ad=0.1406p pd=1.12u as=0.1406p ps=1.12u w=0.74u l=0.13u
X2956 VDD VSS.t1005 VDD VDD sg13_lv_pmos ad=0.19p pd=1.38u as=0 ps=0 w=1u l=1u
X2957 VSS.t1400 VDD VSS.t1401 VSS.t311 sg13_lv_nmos ad=79.8f pd=0.8u as=0 ps=0 w=0.42u l=1u
X2958 VSS.t1322 VDD VSS.t1323 VSS.t311 sg13_lv_nmos ad=79.8f pd=0.8u as=0 ps=0 w=0.42u l=1u
X2959 VDD VSS.t2460 VDD VDD sg13_lv_pmos ad=0.19p pd=1.38u as=0 ps=0 w=1u l=1u
X2960 VSS.t2770 VDD VSS.t2772 VSS.t392 sg13_lv_nmos ad=79.8f pd=0.8u as=0 ps=0 w=0.42u l=1u
X2961 VDD VSS.t723 VDD VDD sg13_lv_pmos ad=0.34p pd=2.68u as=0 ps=0 w=1u l=1u
X2962 VSS.t557 VDD VSS.t557 VSS.t560 sg13_lv_nmos ad=79.8f pd=0.8u as=0 ps=0 w=0.42u l=1u
X2963 sg13g2_dfrbpq_1_1.RESET_B a_5886_15486# VDD VDD sg13_lv_pmos ad=0.3927p pd=2.99u as=2.8961p ps=18.25u w=1.155u l=0.13u
X2964 VSS.t606 VDD VSS.t605 VSS.t9 sg13_lv_nmos ad=0.1428p pd=1.52u as=0 ps=0 w=0.42u l=1u
X2965 VSS.t58 sg13g2_dlygate4sd3_1_0.X a_5707_14832# VSS.t97 sg13_lv_nmos ad=0.1331p pd=1.12u as=0.1216p ps=1.02u w=0.64u l=0.13u
X2966 VSS.t2877 VDD VSS.t2878 VSS.t392 sg13_lv_nmos ad=79.8f pd=0.8u as=0 ps=0 w=0.42u l=1u
X2967 VDD a_19438_13726# sg13g2_buf_16_2.X VDD sg13_lv_pmos ad=0.3976p pd=2.95u as=0.2128p ps=1.5u w=1.12u l=0.13u
X2968 VSS.t923 VDD VSS.t922 VSS.t921 sg13_lv_nmos ad=0.1428p pd=1.52u as=0 ps=0 w=0.42u l=1u
X2969 VSS.t1108 VDD VSS.t1110 VSS.t1109 sg13_lv_nmos ad=79.8f pd=0.8u as=0 ps=0 w=0.42u l=1u
X2970 VDD VSS.t1097 VDD VDD sg13_lv_pmos ad=0.34p pd=2.68u as=0 ps=0 w=1u l=1u
X2971 VDD VSS.t2145 VDD VDD sg13_lv_pmos ad=0.34p pd=2.68u as=0 ps=0 w=1u l=1u
X2972 VDD a_25390_16263# sg13g2_dlygate4sd3_1_12.X VDD sg13_lv_pmos ad=0.2254p pd=1.53u as=0.4256p ps=3u w=1.12u l=0.13u
X2973 VSS.t707 VDD VSS.t707 VSS.t710 sg13_lv_nmos ad=0.1428p pd=1.52u as=0 ps=0 w=0.42u l=1u
X2974 VDD VSS.t449 VDD VDD sg13_lv_pmos ad=0.34p pd=2.68u as=0 ps=0 w=1u l=1u
X2975 VSS.t55 a_25094_15238# a_25206_15302# VSS.t24 sg13_lv_nmos ad=0.1426p pd=1.16u as=0.1428p ps=1.52u w=0.42u l=0.5u
X2976 VDD VSS.t3270 VDD VDD sg13_lv_pmos ad=0.19p pd=1.38u as=0 ps=0 w=1u l=1u
X2977 VDD VSS.t2795 VDD VDD sg13_lv_pmos ad=0.34p pd=2.68u as=0 ps=0 w=1u l=1u
X2978 VDD VSS.t574 VDD VDD sg13_lv_pmos ad=0.19p pd=1.38u as=0 ps=0 w=1u l=1u
X2979 a_9861_14521# a_9861_14521# VSS.t9 VSS.t118 sg13_lv_nmos ad=0.111p pd=1.34u as=5.4375p ps=36.05u w=0.3u l=0.13u
X2980 VDD VSS.t349 VDD VDD sg13_lv_pmos ad=0.34p pd=2.68u as=0 ps=0 w=1u l=1u
X2981 VDD VSS.t54 VDD VDD sg13_lv_pmos ad=0.34p pd=2.68u as=0 ps=0 w=1u l=1u
X2982 VDD VSS.t226 VDD VDD sg13_lv_pmos ad=0.34p pd=2.68u as=0 ps=0 w=1u l=1u
X2983 a_10703_15311# a_9861_15213# a_10609_15311# VSS.t264 sg13_lv_nmos ad=0.12665p pd=1.145u as=0.1428p ps=1.52u w=0.42u l=0.13u
X2984 VSS.t546 VDD VSS.t548 VSS.t547 sg13_lv_nmos ad=79.8f pd=0.8u as=0 ps=0 w=0.42u l=1u
X2985 VSS.t1594 VDD VSS.t1593 VSS.t1592 sg13_lv_nmos ad=0.1428p pd=1.52u as=0 ps=0 w=0.42u l=1u
X2986 VSS.t1764 VDD VSS.t1766 VSS.t1765 sg13_lv_nmos ad=79.8f pd=0.8u as=0 ps=0 w=0.42u l=1u
X2987 VDD VSS.t1603 VDD VDD sg13_lv_pmos ad=0.34p pd=2.68u as=0 ps=0 w=1u l=1u
X2988 VSS.t3288 VDD VSS.t3290 VSS.t3289 sg13_lv_nmos ad=79.8f pd=0.8u as=0 ps=0 w=0.42u l=1u
X2989 VDD VSS.t1160 VDD VDD sg13_lv_pmos ad=0.19p pd=1.38u as=0 ps=0 w=1u l=1u
X2990 VDD VSS.t1300 VDD VDD sg13_lv_pmos ad=0.34p pd=2.68u as=0 ps=0 w=1u l=1u
X2991 VDD VSS.t2512 VDD VDD sg13_lv_pmos ad=0.34p pd=2.68u as=0 ps=0 w=1u l=1u
X2992 VSS.t455 VDD VSS.t455 VSS.t456 sg13_lv_nmos ad=79.8f pd=0.8u as=0 ps=0 w=0.42u l=1u
X2993 VSS.t615 VDD VSS.t614 VSS.t9 sg13_lv_nmos ad=0.1428p pd=1.52u as=0 ps=0 w=0.42u l=1u
X2994 VDD VSS.t972 VDD VDD sg13_lv_pmos ad=0.34p pd=2.68u as=0 ps=0 w=1u l=1u
X2995 VSS.t2403 VDD VSS.t2402 VSS.t2401 sg13_lv_nmos ad=0.1428p pd=1.52u as=0 ps=0 w=0.42u l=1u
X2996 VDD VSS.t2110 VDD VDD sg13_lv_pmos ad=0.34p pd=2.68u as=0 ps=0 w=1u l=1u
X2997 VSS.t2573 VDD VSS.t2575 VSS.t2574 sg13_lv_nmos ad=79.8f pd=0.8u as=0 ps=0 w=0.42u l=1u
X2998 VDD VSS.t771 VDD VDD sg13_lv_pmos ad=0.19p pd=1.38u as=0 ps=0 w=1u l=1u
X2999 VDD VSS.t2637 VDD VDD sg13_lv_pmos ad=0.34p pd=2.68u as=0 ps=0 w=1u l=1u
X3000 VSS.t2121 VDD VSS.t2120 VSS.t2119 sg13_lv_nmos ad=0.1428p pd=1.52u as=0 ps=0 w=0.42u l=1u
X3001 VSS.t9 a_18021_14495# a_18123_14495# VSS.t150 sg13_lv_nmos ad=5.4375p pd=36.05u as=0.2516p ps=2.16u w=0.74u l=0.13u
X3002 VSS.t2071 VDD VSS.t2073 VSS.t2072 sg13_lv_nmos ad=79.8f pd=0.8u as=0 ps=0 w=0.42u l=1u
X3003 VDD sg13g2_dfrbpq_1_6.RESET_B a_21034_14452# VDD sg13_lv_pmos ad=0.1563p pd=1.22u as=0.147p ps=1.54u w=0.42u l=0.13u
X3004 VDD VSS.t1793 VDD VDD sg13_lv_pmos ad=0.34p pd=2.68u as=0 ps=0 w=1u l=1u
X3005 VSS.t3158 VDD VSS.t3160 VSS.t3159 sg13_lv_nmos ad=79.8f pd=0.8u as=0 ps=0 w=0.42u l=1u
X3006 VDD VSS.t736 VDD VDD sg13_lv_pmos ad=0.19p pd=1.38u as=0 ps=0 w=1u l=1u
X3007 VDD sg13g2_dlygate4sd3_1_8.X sg13g2_nand4_1_0.Y VDD sg13_lv_pmos ad=0.3808p pd=2.92u as=0.2128p ps=1.5u w=1.12u l=0.13u
X3008 a_6680_15242# sg13g2_dlygate4sd3_1_1.A a_6578_15242# VSS.t426 sg13_lv_nmos ad=0.1406p pd=1.12u as=0.1406p ps=1.12u w=0.74u l=0.13u
X3009 VSS.t1417 VDD VSS.t1418 VSS.t311 sg13_lv_nmos ad=79.8f pd=0.8u as=0 ps=0 w=0.42u l=1u
X3010 VSS.t1854 VDD VSS.t1856 VSS.t1855 sg13_lv_nmos ad=79.8f pd=0.8u as=0 ps=0 w=0.42u l=1u
X3011 VSS.t1078 VDD VSS.t1077 VSS.t1076 sg13_lv_nmos ad=0.1428p pd=1.52u as=0 ps=0 w=0.42u l=1u
X3012 VDD VSS.t2756 VDD VDD sg13_lv_pmos ad=0.19p pd=1.38u as=0 ps=0 w=1u l=1u
X3013 VSS.t2368 VDD VSS.t2367 VSS.t2366 sg13_lv_nmos ad=0.1428p pd=1.52u as=0 ps=0 w=0.42u l=1u
X3014 VSS.t60 a_7631_14845# a_8298_14484# VSS.t222 sg13_lv_nmos ad=0.1406p pd=1.12u as=0.2516p ps=2.16u w=0.74u l=0.13u
X3015 VDD a_19438_13726# sg13g2_buf_16_2.X VDD sg13_lv_pmos ad=0.2128p pd=1.5u as=0.2128p ps=1.5u w=1.12u l=0.13u
X3016 VSS.t2853 VDD VSS.t2852 VSS.t392 sg13_lv_nmos ad=0.1428p pd=1.52u as=0 ps=0 w=0.42u l=1u
X3017 VDD VSS.t608 VDD VDD sg13_lv_pmos ad=0.34p pd=2.68u as=0 ps=0 w=1u l=1u
X3018 a_26638_15423# a_26753_15424# VSS.t28 VSS.t32 sg13_lv_nmos ad=0.1428p pd=1.52u as=0.1426p ps=1.16u w=0.42u l=0.5u
X3019 a_16068_14040# a_16587_13844# a_17327_13799# VSS.t287 sg13_lv_nmos ad=0.3473p pd=2.71u as=0.12665p ps=1.145u w=0.74u l=0.13u
X3020 VDD VSS.t1390 VDD VDD sg13_lv_pmos ad=0.34p pd=2.68u as=0 ps=0 w=1u l=1u
X3021 VDD VSS.t3222 VDD VDD sg13_lv_pmos ad=0.34p pd=2.68u as=0 ps=0 w=1u l=1u
X3022 VSS.t2221 VDD VSS.t2223 VSS.t2222 sg13_lv_nmos ad=79.8f pd=0.8u as=0 ps=0 w=0.42u l=1u
X3023 VDD VSS.t481 VDD VDD sg13_lv_pmos ad=0.34p pd=2.68u as=0 ps=0 w=1u l=1u
X3024 VSS.t1138 VDD VSS.t1140 VSS.t1139 sg13_lv_nmos ad=79.8f pd=0.8u as=0 ps=0 w=0.42u l=1u
X3025 VDD VSS.t1127 VDD VDD sg13_lv_pmos ad=0.34p pd=2.68u as=0 ps=0 w=1u l=1u
X3026 VSS.t1784 VDD VSS.t1786 VSS.t1785 sg13_lv_nmos ad=79.8f pd=0.8u as=0 ps=0 w=0.42u l=1u
X3027 VDD VSS.t935 VDD VDD sg13_lv_pmos ad=0.19p pd=1.38u as=0 ps=0 w=1u l=1u
X3028 VDD VSS.t1588 VDD VDD sg13_lv_pmos ad=0.34p pd=2.68u as=0 ps=0 w=1u l=1u
X3029 VDD VSS.t1851 VDD VDD sg13_lv_pmos ad=0.19p pd=1.38u as=0 ps=0 w=1u l=1u
X3030 VDD sg13g2_xnor2_1_1.A a_16218_15532# VDD sg13_lv_pmos ad=0.2891p pd=1.695u as=0.1428p ps=1.375u w=1.12u l=0.13u
X3031 VDD VSS.t748 VDD VDD sg13_lv_pmos ad=0.34p pd=2.68u as=0 ps=0 w=1u l=1u
X3032 VSS.t1426 VDD VSS.t1427 VSS.t311 sg13_lv_nmos ad=79.8f pd=0.8u as=0 ps=0 w=0.42u l=1u
X3033 VSS.t998 VDD VSS.t997 VSS.t996 sg13_lv_nmos ad=0.1428p pd=1.52u as=0 ps=0 w=0.42u l=1u
X3034 VSS.t1724 VDD VSS.t1723 VSS.t1722 sg13_lv_nmos ad=0.1428p pd=1.52u as=0 ps=0 w=0.42u l=1u
X3035 VDD VSS.t2622 VDD VDD sg13_lv_pmos ad=0.34p pd=2.68u as=0 ps=0 w=1u l=1u
X3036 VDD VSS.t2445 VDD VDD sg13_lv_pmos ad=0.19p pd=1.38u as=0 ps=0 w=1u l=1u
X3037 VSS.t1334 VDD VSS.t1335 VSS.t311 sg13_lv_nmos ad=79.8f pd=0.8u as=0 ps=0 w=0.42u l=1u
X3038 VDD a_6286_13911# sg13g2_dlygate4sd3_1_0.X VDD sg13_lv_pmos ad=0.2254p pd=1.53u as=0.4256p ps=3u w=1.12u l=0.13u
X3039 a_26505_14113# a_26148_14040# VDD VDD sg13_lv_pmos ad=63f pd=0.72u as=0.1563p ps=1.22u w=0.42u l=0.13u
X3040 VDD VSS.t471 VDD VDD sg13_lv_pmos ad=0.34p pd=2.68u as=0 ps=0 w=1u l=1u
X3041 VDD VSS.t54 VDD VDD sg13_lv_pmos ad=0.19p pd=1.38u as=0 ps=0 w=1u l=1u
X3042 VSS.t1431 VDD VSS.t1432 VSS.t311 sg13_lv_nmos ad=79.8f pd=0.8u as=0 ps=0 w=0.42u l=1u
X3043 VDD VSS.t2198 VDD VDD sg13_lv_pmos ad=0.19p pd=1.38u as=0 ps=0 w=1u l=1u
X3044 VSS.t319 a_19438_13726# sg13g2_buf_16_2.X VSS.t325 sg13_lv_nmos ad=0.1406p pd=1.12u as=0.1406p ps=1.12u w=0.74u l=0.13u
X3045 VDD a_16055_16301# a_16055_16071# VDD sg13_lv_pmos ad=2.8961p pd=18.25u as=0.2442p ps=2.06u w=0.66u l=0.13u
X3046 VSS.t46 sg13g2_o21ai_1_2.Y a_24824_15238# VSS.t24 sg13_lv_nmos ad=79.8f pd=0.8u as=0.1428p ps=1.52u w=0.42u l=0.13u
X3047 VDD VSS.t1973 VDD VDD sg13_lv_pmos ad=0.19p pd=1.38u as=0 ps=0 w=1u l=1u
X3048 VSS.t2016 VDD VSS.t2018 VSS.t2017 sg13_lv_nmos ad=79.8f pd=0.8u as=0 ps=0 w=0.42u l=1u
X3049 VDD VSS.t2500 VDD VDD sg13_lv_pmos ad=0.19p pd=1.38u as=0 ps=0 w=1u l=1u
X3050 VSS.t2558 VDD VSS.t2560 VSS.t2559 sg13_lv_nmos ad=79.8f pd=0.8u as=0 ps=0 w=0.42u l=1u
X3051 VDD VSS.t681 VDD VDD sg13_lv_pmos ad=0.34p pd=2.68u as=0 ps=0 w=1u l=1u
X3052 a_15782_13722# sg13g2_dfrbpq_1_2.D VDD VDD sg13_lv_pmos ad=79.8f pd=0.8u as=0.1428p ps=1.52u w=0.42u l=0.13u
X3053 VSS.t2835 VDD VSS.t2836 VSS.t392 sg13_lv_nmos ad=79.8f pd=0.8u as=0 ps=0 w=0.42u l=1u
X3054 VSS.t2106 VDD VSS.t2108 VSS.t2107 sg13_lv_nmos ad=79.8f pd=0.8u as=0 ps=0 w=0.42u l=1u
X3055 a_4474_14448# sg13g2_dlygate4sd3_1_3.A VDD VDD sg13_lv_pmos ad=0.1428p pd=1.52u as=0.1523p ps=1.38u w=0.42u l=0.13u
X3056 VSS.t728 VDD VSS.t728 VSS.t729 sg13_lv_nmos ad=79.8f pd=0.8u as=0 ps=0 w=0.42u l=1u
X3057 VDD VSS.t1090 VDD VDD sg13_lv_pmos ad=0.19p pd=1.38u as=0 ps=0 w=1u l=1u
X3058 VSS.t1579 VDD VSS.t1578 VSS.t1577 sg13_lv_nmos ad=0.1428p pd=1.52u as=0 ps=0 w=0.42u l=1u
X3059 a_27500_15960# sg13g2_dfrbpq_1_6.Q VDD VDD sg13_lv_pmos ad=0.2856p pd=2.36u as=0.2114p ps=1.54u w=0.84u l=0.13u
X3060 VSS.t958 VDD VSS.t960 VSS.t959 sg13_lv_nmos ad=79.8f pd=0.8u as=0 ps=0 w=0.42u l=1u
X3061 VDD VSS.t1330 VDD VDD sg13_lv_pmos ad=0.34p pd=2.68u as=0 ps=0 w=1u l=1u
X3062 VDD VSS.t2836 VDD VDD sg13_lv_pmos ad=0.34p pd=2.68u as=0 ps=0 w=1u l=1u
X3063 VSS.t2388 VDD VSS.t2387 VSS.t2386 sg13_lv_nmos ad=0.1428p pd=1.52u as=0 ps=0 w=0.42u l=1u
X3064 VDD VSS.t616 VDD VDD sg13_lv_pmos ad=0.19p pd=1.38u as=0 ps=0 w=1u l=1u
X3065 VDD VSS.t1017 VDD VDD sg13_lv_pmos ad=0.34p pd=2.68u as=0 ps=0 w=1u l=1u
X3066 VSS.t2773 VDD VSS.t2775 VSS.t392 sg13_lv_nmos ad=79.8f pd=0.8u as=0 ps=0 w=0.42u l=1u
X3067 VSS.t2236 VDD VSS.t2235 VSS.t2234 sg13_lv_nmos ad=0.1428p pd=1.52u as=0 ps=0 w=0.42u l=1u
X3068 VSS.t2056 VDD VSS.t2058 VSS.t2057 sg13_lv_nmos ad=79.8f pd=0.8u as=0 ps=0 w=0.42u l=1u
X3069 VDD sg13g2_dfrbpq_1_6.RESET_B a_20774_14922# VDD sg13_lv_pmos ad=0.36237p pd=2.605u as=79.8f ps=0.8u w=0.42u l=0.13u
X3070 VDD VSS.t681 VDD VDD sg13_lv_pmos ad=0.34p pd=2.68u as=0 ps=0 w=1u l=1u
X3071 VDD VSS.t766 VDD VDD sg13_lv_pmos ad=0.19p pd=1.38u as=0 ps=0 w=1u l=1u
X3072 VDD VSS.t3085 VDD VDD sg13_lv_pmos ad=0.19p pd=1.38u as=0 ps=0 w=1u l=1u
X3073 VSS.t3143 VDD VSS.t3145 VSS.t3144 sg13_lv_nmos ad=79.8f pd=0.8u as=0 ps=0 w=0.42u l=1u
X3074 a_2516_14484# sg13g2_buf_1_0.X VDD VDD sg13_lv_pmos ad=0.3808p pd=2.92u as=0.2128p ps=1.5u w=1.12u l=0.13u
X3075 VSS.t757 VDD VSS.t757 VSS.t882 sg13_lv_nmos ad=0.1428p pd=1.52u as=0 ps=0 w=0.42u l=1u
X3076 VSS.t2578 VDD VSS.t2577 VSS.t2576 sg13_lv_nmos ad=0.1428p pd=1.52u as=0 ps=0 w=0.42u l=1u
X3077 VSS.t712 VDD VSS.t712 VSS.t718 sg13_lv_nmos ad=79.8f pd=0.8u as=0 ps=0 w=0.42u l=1u
X3078 VSS.t1839 VDD VSS.t1841 VSS.t1840 sg13_lv_nmos ad=79.8f pd=0.8u as=0 ps=0 w=0.42u l=1u
X3079 VDD VSS.t2492 VDD VDD sg13_lv_pmos ad=0.34p pd=2.68u as=0 ps=0 w=1u l=1u
X3080 VDD VSS.t2150 VDD VDD sg13_lv_pmos ad=0.34p pd=2.68u as=0 ps=0 w=1u l=1u
X3081 a_26313_14531# a_25956_14488# VDD VDD sg13_lv_pmos ad=63f pd=0.72u as=0.1563p ps=1.22u w=0.42u l=0.13u
X3082 VSS.t1366 VDD VSS.t1367 VSS.t311 sg13_lv_nmos ad=79.8f pd=0.8u as=0 ps=0 w=0.42u l=1u
X3083 VDD VSS.t3275 VDD VDD sg13_lv_pmos ad=0.19p pd=1.38u as=0 ps=0 w=1u l=1u
X3084 VDD VSS.t2797 VDD VDD sg13_lv_pmos ad=0.34p pd=2.68u as=0 ps=0 w=1u l=1u
X3085 VDD VSS.t1416 VDD VDD sg13_lv_pmos ad=0.34p pd=2.68u as=0 ps=0 w=1u l=1u
X3086 VSS.t1301 VDD VSS.t1300 VSS.t311 sg13_lv_nmos ad=0.1428p pd=1.52u as=0 ps=0 w=0.42u l=1u
X3087 VSS.t1709 VDD VSS.t1711 VSS.t1710 sg13_lv_nmos ad=79.8f pd=0.8u as=0 ps=0 w=0.42u l=1u
X3088 VSS.t9 a_9737_14822# a_9658_14725# VSS.t75 sg13_lv_nmos ad=5.4375p pd=36.05u as=0.27427p ps=2.28u w=0.795u l=0.13u
X3089 VSS.t2206 VDD VSS.t2208 VSS.t2207 sg13_lv_nmos ad=79.8f pd=0.8u as=0 ps=0 w=0.42u l=1u
X3090 VSS.t501 VDD VSS.t500 VSS.t499 sg13_lv_nmos ad=0.1428p pd=1.52u as=0 ps=0 w=0.42u l=1u
X3091 VSS.t928 VDD VSS.t927 VSS.t926 sg13_lv_nmos ad=0.1428p pd=1.52u as=0 ps=0 w=0.42u l=1u
X3092 VSS.t1769 VDD VSS.t1771 VSS.t1770 sg13_lv_nmos ad=79.8f pd=0.8u as=0 ps=0 w=0.42u l=1u
X3093 VSS.t2895 VDD VSS.t2895 VSS.t392 sg13_lv_nmos ad=0.1428p pd=1.52u as=0 ps=0 w=0.42u l=1u
X3094 VSS.t3293 VDD VSS.t3295 VSS.t3294 sg13_lv_nmos ad=79.8f pd=0.8u as=0 ps=0 w=0.42u l=1u
X3095 VSS.t1293 VDD VSS.t1295 VSS.t311 sg13_lv_nmos ad=79.8f pd=0.8u as=0 ps=0 w=0.42u l=1u
X3096 VDD VSS.t596 VDD VDD sg13_lv_pmos ad=0.34p pd=2.68u as=0 ps=0 w=1u l=1u
X3097 VSS.t998 VDD VSS.t997 VSS.t996 sg13_lv_nmos ad=0.1428p pd=1.52u as=0 ps=0 w=0.42u l=1u
X3098 VSS.t2373 VDD VSS.t2372 VSS.t2371 sg13_lv_nmos ad=0.1428p pd=1.52u as=0 ps=0 w=0.42u l=1u
X3099 VSS.t290 VDD VSS.t211 VSS.t822 sg13_lv_nmos ad=79.8f pd=0.8u as=0 ps=0 w=0.42u l=1u
X3100 VDD VSS.t1836 VDD VDD sg13_lv_pmos ad=0.19p pd=1.38u as=0 ps=0 w=1u l=1u
X3101 VSS.t2765 VDD VSS.t2766 VSS.t392 sg13_lv_nmos ad=79.8f pd=0.8u as=0 ps=0 w=0.42u l=1u
X3102 VDD VSS.t2607 VDD VDD sg13_lv_pmos ad=0.34p pd=2.68u as=0 ps=0 w=1u l=1u
X3103 VDD VSS.t405 VDD VDD sg13_lv_pmos ad=0.34p pd=2.68u as=0 ps=0 w=1u l=1u
X3104 VDD VSS.t742 VDD VDD sg13_lv_pmos ad=0.34p pd=2.68u as=0 ps=0 w=1u l=1u
X3105 VDD VSS.t1120 VDD VDD sg13_lv_pmos ad=0.19p pd=1.38u as=0 ps=0 w=1u l=1u
X3106 VDD VSS.t1788 VDD VDD sg13_lv_pmos ad=0.34p pd=2.68u as=0 ps=0 w=1u l=1u
X3107 VSS.t2843 VDD VSS.t2843 VSS.t392 sg13_lv_nmos ad=0.1428p pd=1.52u as=0 ps=0 w=0.42u l=1u
X3108 VSS.t2076 VDD VSS.t2078 VSS.t2077 sg13_lv_nmos ad=79.8f pd=0.8u as=0 ps=0 w=0.42u l=1u
X3109 VDD VSS.t447 VDD VDD sg13_lv_pmos ad=0.19p pd=1.38u as=0 ps=0 w=1u l=1u
X3110 VDD VSS.t54 VDD VDD sg13_lv_pmos ad=0.19p pd=1.38u as=0 ps=0 w=1u l=1u
X3111 VSS.t54 VDD VSS.t54 VSS.t796 sg13_lv_nmos ad=0.1428p pd=1.52u as=0 ps=0 w=0.42u l=1u
X3112 VSS.t1498 VDD VSS.t1348 VSS.t311 sg13_lv_nmos ad=0.1428p pd=1.52u as=0 ps=0 w=0.42u l=1u
X3113 sg13g2_xnor2_1_2.B sg13g2_buf_1_0.X a_6202_15238# VSS.t256 sg13_lv_nmos ad=0.2516p pd=2.16u as=0.1406p ps=1.12u w=0.74u l=0.13u
X3114 sg13g2_xnor2_1_0.Y a_7680_15549# a_7829_15238# VSS.t124 sg13_lv_nmos ad=0.2516p pd=2.16u as=0.1406p ps=1.12u w=0.74u l=0.13u
X3115 VDD VSS.t1439 VDD VDD sg13_lv_pmos ad=0.34p pd=2.68u as=0 ps=0 w=1u l=1u
X3116 VSS.t3088 VDD VSS.t3090 VSS.t3089 sg13_lv_nmos ad=79.8f pd=0.8u as=0 ps=0 w=0.42u l=1u
X3117 VDD VSS.t605 VDD VDD sg13_lv_pmos ad=0.34p pd=2.68u as=0 ps=0 w=1u l=1u
X3118 VDD VSS.t681 VDD VDD sg13_lv_pmos ad=0.34p pd=2.68u as=0 ps=0 w=1u l=1u
X3119 sg13g2_a21oi_1_0.B1 sg13g2_buf_1_10.X VDD VDD sg13_lv_pmos ad=0.3808p pd=2.92u as=0.3808p ps=2.92u w=1.12u l=0.13u
X3120 VDD VSS.t2830 VDD VDD sg13_lv_pmos ad=0.19p pd=1.38u as=0 ps=0 w=1u l=1u
X3121 VSS.t2498 VDD VSS.t2497 VSS.t2496 sg13_lv_nmos ad=0.1428p pd=1.52u as=0 ps=0 w=0.42u l=1u
X3122 VSS.t739 VDD VSS.t739 VSS.t740 sg13_lv_nmos ad=79.8f pd=0.8u as=0 ps=0 w=0.42u l=1u
X3123 VDD VSS.t1135 VDD VDD sg13_lv_pmos ad=0.19p pd=1.38u as=0 ps=0 w=1u l=1u
X3124 VDD VSS.t3227 VDD VDD sg13_lv_pmos ad=0.34p pd=2.68u as=0 ps=0 w=1u l=1u
X3125 VSS.t2191 VDD VSS.t2193 VSS.t2192 sg13_lv_nmos ad=79.8f pd=0.8u as=0 ps=0 w=0.42u l=1u
X3126 VSS.t958 VDD VSS.t960 VSS.t959 sg13_lv_nmos ad=79.8f pd=0.8u as=0 ps=0 w=0.42u l=1u
X3127 VDD VSS.t712 VDD VDD sg13_lv_pmos ad=0.34p pd=2.68u as=0 ps=0 w=1u l=1u
X3128 VDD VSS.t1593 VDD VDD sg13_lv_pmos ad=0.34p pd=2.68u as=0 ps=0 w=1u l=1u
X3129 VDD VSS.t2502 VDD VDD sg13_lv_pmos ad=0.34p pd=2.68u as=0 ps=0 w=1u l=1u
X3130 sg13g2_or3_1_1.B a_14357_15238# VDD VDD sg13_lv_pmos ad=0.2128p pd=1.5u as=0.2128p ps=1.5u w=1.12u l=0.13u
X3131 VSS.t707 VDD VSS.t707 VSS.t710 sg13_lv_nmos ad=0.1428p pd=1.52u as=0 ps=0 w=0.42u l=1u
X3132 VDD VSS.t1766 VDD VDD sg13_lv_pmos ad=0.19p pd=1.38u as=0 ps=0 w=1u l=1u
X3133 a_27034_15202# sg13g2_dfrbpq_1_7.Q VSS.t28 VSS.t9 sg13_lv_nmos ad=0.1428p pd=1.52u as=79.8f ps=0.8u w=0.42u l=0.13u
X3134 VDD VSS.t1821 VDD VDD sg13_lv_pmos ad=0.19p pd=1.38u as=0 ps=0 w=1u l=1u
X3135 VDD VSS.t2013 VDD VDD sg13_lv_pmos ad=0.19p pd=1.38u as=0 ps=0 w=1u l=1u
X3136 VSS.t2111 VDD VSS.t2110 VSS.t2109 sg13_lv_nmos ad=0.1428p pd=1.52u as=0 ps=0 w=0.42u l=1u
X3137 VDD VSS.t1447 VDD VDD sg13_lv_pmos ad=0.34p pd=2.68u as=0 ps=0 w=1u l=1u
X3138 VSS.t54 VDD VSS.t54 VSS.t699 sg13_lv_nmos ad=79.8f pd=0.8u as=0 ps=0 w=0.42u l=1u
X3139 VDD VSS.t728 VDD VDD sg13_lv_pmos ad=0.34p pd=2.68u as=0 ps=0 w=1u l=1u
X3140 VDD VSS.t681 VDD VDD sg13_lv_pmos ad=0.34p pd=2.68u as=0 ps=0 w=1u l=1u
X3141 VSS.t2221 VDD VSS.t2220 VSS.t2219 sg13_lv_nmos ad=0.1428p pd=1.52u as=0 ps=0 w=0.42u l=1u
X3142 VSS.t319 VDD VSS.t319 VSS.t837 sg13_lv_nmos ad=79.8f pd=0.8u as=0 ps=0 w=0.42u l=1u
X3143 VSS.t1098 VDD VSS.t1097 VSS.t1096 sg13_lv_nmos ad=0.1428p pd=1.52u as=0 ps=0 w=0.42u l=1u
X3144 VSS.t1393 VDD VSS.t1394 VSS.t311 sg13_lv_nmos ad=79.8f pd=0.8u as=0 ps=0 w=0.42u l=1u
X3145 VSS.t2021 VDD VSS.t2023 VSS.t2022 sg13_lv_nmos ad=79.8f pd=0.8u as=0 ps=0 w=0.42u l=1u
X3146 VSS.t2872 VDD VSS.t2873 VSS.t392 sg13_lv_nmos ad=79.8f pd=0.8u as=0 ps=0 w=0.42u l=1u
X3147 VSS.t2563 VDD VSS.t2565 VSS.t2564 sg13_lv_nmos ad=79.8f pd=0.8u as=0 ps=0 w=0.42u l=1u
X3148 VDD VSS.t3260 VDD VDD sg13_lv_pmos ad=0.19p pd=1.38u as=0 ps=0 w=1u l=1u
X3149 a_20705_15260# sg13g2_dlygate4sd3_1_11.X sg13g2_a21oi_1_1.Y VSS.t0 sg13_lv_nmos ad=0.1406p pd=1.12u as=0.1406p ps=1.12u w=0.74u l=0.13u
X3150 VSS.t928 VDD VSS.t927 VSS.t926 sg13_lv_nmos ad=0.1428p pd=1.52u as=0 ps=0 w=0.42u l=1u
X3151 VSS.t1694 VDD VSS.t1696 VSS.t1695 sg13_lv_nmos ad=79.8f pd=0.8u as=0 ps=0 w=0.42u l=1u
X3152 VSS.t2433 VDD VSS.t2432 VSS.t2431 sg13_lv_nmos ad=0.1428p pd=1.52u as=0 ps=0 w=0.42u l=1u
X3153 VSS.t1158 VDD VSS.t1160 VSS.t1159 sg13_lv_nmos ad=79.8f pd=0.8u as=0 ps=0 w=0.42u l=1u
X3154 VDD VSS.t733 VDD VDD sg13_lv_pmos ad=0.34p pd=2.68u as=0 ps=0 w=1u l=1u
X3155 a_14357_15238# sg13g2_nand4_1_0.Y VDD VDD sg13_lv_pmos ad=0.1596p pd=1.22u as=0.2856p ps=2.36u w=0.84u l=0.13u
X3156 VDD VSS.t3130 VDD VDD sg13_lv_pmos ad=0.19p pd=1.38u as=0 ps=0 w=1u l=1u
X3157 VDD VSS.t1998 VDD VDD sg13_lv_pmos ad=0.19p pd=1.38u as=0 ps=0 w=1u l=1u
X3158 VDD sg13g2_dfrbpq_1_3.RESET_B a_17578_14452# VDD sg13_lv_pmos ad=0.1563p pd=1.22u as=0.147p ps=1.54u w=0.42u l=0.13u
X3159 a_26122_13945# a_26565_13701# a_25862_13722# VSS.t313 sg13_lv_nmos ad=79.8f pd=0.8u as=0.1296p ps=1.52u w=0.42u l=0.13u
X3160 VSS.t1849 VDD VSS.t1851 VSS.t1850 sg13_lv_nmos ad=79.8f pd=0.8u as=0 ps=0 w=0.42u l=1u
X3161 VSS.t2758 VDD VSS.t2759 VSS.t392 sg13_lv_nmos ad=79.8f pd=0.8u as=0 ps=0 w=0.42u l=1u
X3162 VDD VSS.t1773 VDD VDD sg13_lv_pmos ad=0.34p pd=2.68u as=0 ps=0 w=1u l=1u
X3163 VDD VSS.t2906 VDD VDD sg13_lv_pmos ad=0.19p pd=1.38u as=0 ps=0 w=1u l=1u
X3164 VSS.t2241 VDD VSS.t2240 VSS.t2239 sg13_lv_nmos ad=0.1428p pd=1.52u as=0 ps=0 w=0.42u l=1u
X3165 VSS.t2061 VDD VSS.t2063 VSS.t2062 sg13_lv_nmos ad=79.8f pd=0.8u as=0 ps=0 w=0.42u l=1u
X3166 VSS.t618 VDD VSS.t617 VSS.t9 sg13_lv_nmos ad=0.1428p pd=1.52u as=0 ps=0 w=0.42u l=1u
X3167 VSS.t3148 VDD VSS.t3150 VSS.t3149 sg13_lv_nmos ad=79.8f pd=0.8u as=0 ps=0 w=0.42u l=1u
X3168 VSS.t60 sg13g2_xnor2_1_0.Y a_8312_15238# VSS.t103 sg13_lv_nmos ad=79.8f pd=0.8u as=0.1428p ps=1.52u w=0.42u l=0.13u
X3169 sg13g2_a21oi_1_3.A2 a_24169_14508# VDD VDD sg13_lv_pmos ad=0.3808p pd=2.92u as=0.3822p ps=1.84u w=1.12u l=0.13u
X3170 VSS.t1375 VDD VSS.t1374 VSS.t311 sg13_lv_nmos ad=0.1428p pd=1.52u as=0 ps=0 w=0.42u l=1u
X3171 VDD VSS.t2365 VDD VDD sg13_lv_pmos ad=0.19p pd=1.38u as=0 ps=0 w=1u l=1u
X3172 VSS.t1844 VDD VSS.t1846 VSS.t1845 sg13_lv_nmos ad=79.8f pd=0.8u as=0 ps=0 w=0.42u l=1u
X3173 VDD VSS.t2462 VDD VDD sg13_lv_pmos ad=0.34p pd=2.68u as=0 ps=0 w=1u l=1u
X3174 VDD VSS.t2155 VDD VDD sg13_lv_pmos ad=0.34p pd=2.68u as=0 ps=0 w=1u l=1u
X3175 VSS.t1971 VDD VSS.t1973 VSS.t1972 sg13_lv_nmos ad=79.8f pd=0.8u as=0 ps=0 w=0.42u l=1u
X3176 VSS.t1417 VDD VSS.t1416 VSS.t311 sg13_lv_nmos ad=0.1428p pd=1.52u as=0 ps=0 w=0.42u l=1u
X3177 VDD VSS.t3280 VDD VDD sg13_lv_pmos ad=0.19p pd=1.38u as=0 ps=0 w=1u l=1u
X3178 VDD a_17710_15423# sg13g2_a21oi_1_0.A1 VDD sg13_lv_pmos ad=0.2254p pd=1.53u as=0.4256p ps=3u w=1.12u l=0.13u
X3179 VSS.t23 a_22030_15423# sg13g2_or3_1_2.A VSS.t113 sg13_lv_nmos ad=0.1426p pd=1.16u as=0.2516p ps=2.16u w=0.74u l=0.13u
X3180 VDD VSS.t2103 VDD VDD sg13_lv_pmos ad=0.19p pd=1.38u as=0 ps=0 w=1u l=1u
X3181 VDD VSS.t712 VDD VDD sg13_lv_pmos ad=0.34p pd=2.68u as=0 ps=0 w=1u l=1u
X3182 VSS.t96 a_16485_13701# a_16587_13844# VSS.t293 sg13_lv_nmos ad=15.10457p pd=99.59499u as=0.2516p ps=2.16u w=0.74u l=0.13u
X3183 VSS.t224 VDD VSS.t224 VSS.t793 sg13_lv_nmos ad=0.1428p pd=1.52u as=0 ps=0 w=0.42u l=1u
X3184 VSS.t1128 VDD VSS.t1127 VSS.t1126 sg13_lv_nmos ad=0.1428p pd=1.52u as=0 ps=0 w=0.42u l=1u
X3185 VSS.t363 VDD VSS.t363 VSS.t478 sg13_lv_nmos ad=0.1428p pd=1.52u as=0 ps=0 w=0.42u l=1u
X3186 VDD VSS.t992 VDD VDD sg13_lv_pmos ad=0.34p pd=2.68u as=0 ps=0 w=1u l=1u
X3187 VSS.t2036 VDD VSS.t2035 VSS.t2034 sg13_lv_nmos ad=0.1428p pd=1.52u as=0 ps=0 w=0.42u l=1u
X3188 VDD VSS.t970 VDD VDD sg13_lv_pmos ad=0.19p pd=1.38u as=0 ps=0 w=1u l=1u
X3189 VDD VSS.t1578 VDD VDD sg13_lv_pmos ad=0.34p pd=2.68u as=0 ps=0 w=1u l=1u
X3190 VSS.t2880 VDD VSS.t2879 VSS.t392 sg13_lv_nmos ad=0.1428p pd=1.52u as=0 ps=0 w=0.42u l=1u
X3191 a_11122_15234# sg13g2_tiehi_1.L_HI VSS.t43 VSS.t128 sg13_lv_nmos ad=37.8f pd=0.6u as=79.8f ps=0.8u w=0.42u l=0.13u
X3192 VSS.t2378 VDD VSS.t2377 VSS.t2376 sg13_lv_nmos ad=0.1428p pd=1.52u as=0 ps=0 w=0.42u l=1u
X3193 VSS.t1639 VDD VSS.t1641 VSS.t1640 sg13_lv_nmos ad=79.8f pd=0.8u as=0 ps=0 w=0.42u l=1u
X3194 sg13g2_or3_1_2.C sg13g2_dfrbpq_1_3.Q a_20218_15238# VSS.t0 sg13_lv_nmos ad=0.2516p pd=2.16u as=0.1406p ps=1.12u w=0.74u l=0.13u
X3195 VSS.t1834 VDD VSS.t1836 VSS.t1835 sg13_lv_nmos ad=79.8f pd=0.8u as=0 ps=0 w=0.42u l=1u
X3196 VSS.t2548 VDD VSS.t2550 VSS.t2549 sg13_lv_nmos ad=79.8f pd=0.8u as=0 ps=0 w=0.42u l=1u
X3197 a_12020_15202# sg13g2_buf_16_2.A VDD VDD sg13_lv_pmos ad=0.2128p pd=1.5u as=0.2128p ps=1.5u w=1.12u l=0.13u
X3198 VSS.t2846 VDD VSS.t2845 VSS.t392 sg13_lv_nmos ad=0.1428p pd=1.52u as=0 ps=0 w=0.42u l=1u
X3199 VDD VSS.t3075 VDD VDD sg13_lv_pmos ad=0.19p pd=1.38u as=0 ps=0 w=1u l=1u
X3200 VSS.t585 VDD VSS.t584 VSS.t9 sg13_lv_nmos ad=0.1428p pd=1.52u as=0 ps=0 w=0.42u l=1u
X3201 VDD VSS.t1055 VDD VDD sg13_lv_pmos ad=0.19p pd=1.38u as=0 ps=0 w=1u l=1u
X3202 VSS.t1098 VDD VSS.t1097 VSS.t1096 sg13_lv_nmos ad=0.1428p pd=1.52u as=0 ps=0 w=0.42u l=1u
X3203 VSS.t1003 VDD VSS.t1005 VSS.t1004 sg13_lv_nmos ad=79.8f pd=0.8u as=0 ps=0 w=0.42u l=1u
X3204 VDD VSS.t2530 VDD VDD sg13_lv_pmos ad=0.19p pd=1.38u as=0 ps=0 w=1u l=1u
X3205 VDD VSS.t2188 VDD VDD sg13_lv_pmos ad=0.19p pd=1.38u as=0 ps=0 w=1u l=1u
X3206 VSS.t2191 VDD VSS.t2190 VSS.t2189 sg13_lv_nmos ad=0.1428p pd=1.52u as=0 ps=0 w=0.42u l=1u
X3207 VSS.t572 VDD VSS.t574 VSS.t573 sg13_lv_nmos ad=79.8f pd=0.8u as=0 ps=0 w=0.42u l=1u
X3208 VSS.t2006 VDD VSS.t2008 VSS.t2007 sg13_lv_nmos ad=79.8f pd=0.8u as=0 ps=0 w=0.42u l=1u
X3209 VDD VSS.t620 VDD VDD sg13_lv_pmos ad=0.34p pd=2.68u as=0 ps=0 w=1u l=1u
X3210 VDD VSS.t702 VDD VDD sg13_lv_pmos ad=0.19p pd=1.38u as=0 ps=0 w=1u l=1u
X3211 VDD a_4175_15311# a_4842_15532# VDD sg13_lv_pmos ad=0.2128p pd=1.5u as=0.3864p ps=2.93u w=1.12u l=0.13u
X3212 VDD VSS.t1636 VDD VDD sg13_lv_pmos ad=0.19p pd=1.38u as=0 ps=0 w=1u l=1u
X3213 VDD a_10222_14751# sg13g2_dlygate4sd3_1_8.X VDD sg13_lv_pmos ad=0.2254p pd=1.53u as=0.4256p ps=3u w=1.12u l=0.13u
X3214 VSS.t1158 VDD VSS.t1160 VSS.t1159 sg13_lv_nmos ad=79.8f pd=0.8u as=0 ps=0 w=0.42u l=1u
X3215 VDD VSS.t1402 VDD VDD sg13_lv_pmos ad=0.34p pd=2.68u as=0 ps=0 w=1u l=1u
X3216 VSS.t2791 VDD VSS.t2793 VSS.t392 sg13_lv_nmos ad=79.8f pd=0.8u as=0 ps=0 w=0.42u l=1u
X3217 VDD VSS.t763 VDD VDD sg13_lv_pmos ad=0.34p pd=2.68u as=0 ps=0 w=1u l=1u
X3218 VDD VSS.t1771 VDD VDD sg13_lv_pmos ad=0.19p pd=1.38u as=0 ps=0 w=1u l=1u
X3219 sg13g2_dfrbpq_1_5.Q a_28074_14020# VDD VDD sg13_lv_pmos ad=0.3808p pd=2.92u as=0.2128p ps=1.5u w=1.12u l=0.13u
X3220 VDD VSS.t1826 VDD VDD sg13_lv_pmos ad=0.19p pd=1.38u as=0 ps=0 w=1u l=1u
X3221 VDD VSS.t3115 VDD VDD sg13_lv_pmos ad=0.19p pd=1.38u as=0 ps=0 w=1u l=1u
X3222 VDD VSS.t3292 VDD VDD sg13_lv_pmos ad=0.34p pd=2.68u as=0 ps=0 w=1u l=1u
X3223 VSS.t2568 VDD VSS.t2570 VSS.t2569 sg13_lv_nmos ad=79.8f pd=0.8u as=0 ps=0 w=0.42u l=1u
X3224 VDD VSS.t1983 VDD VDD sg13_lv_pmos ad=0.19p pd=1.38u as=0 ps=0 w=1u l=1u
X3225 sg13g2_dfrbpq_1_2.CLK a_12020_15202# VDD VDD sg13_lv_pmos ad=0.2128p pd=1.5u as=0.2128p ps=1.5u w=1.12u l=0.13u
X3226 VDD VSS.t2897 VDD VDD sg13_lv_pmos ad=0.19p pd=1.38u as=0 ps=0 w=1u l=1u
X3227 VSS.t2226 VDD VSS.t2225 VSS.t2224 sg13_lv_nmos ad=0.1428p pd=1.52u as=0 ps=0 w=0.42u l=1u
X3228 VSS.t1789 VDD VSS.t1788 VSS.t1787 sg13_lv_nmos ad=0.1428p pd=1.52u as=0 ps=0 w=0.42u l=1u
X3229 VDD VSS.t1025 VDD VDD sg13_lv_pmos ad=0.19p pd=1.38u as=0 ps=0 w=1u l=1u
X3230 VDD VSS.t2515 VDD VDD sg13_lv_pmos ad=0.19p pd=1.38u as=0 ps=0 w=1u l=1u
X3231 VDD VSS.t568 VDD VDD sg13_lv_pmos ad=0.19p pd=1.38u as=0 ps=0 w=1u l=1u
X3232 VDD VSS.t693 VDD VDD sg13_lv_pmos ad=0.34p pd=2.68u as=0 ps=0 w=1u l=1u
X3233 VDD VSS.t2140 VDD VDD sg13_lv_pmos ad=0.34p pd=2.68u as=0 ps=0 w=1u l=1u
X3234 VSS.t763 VDD VSS.t766 VSS.t885 sg13_lv_nmos ad=79.8f pd=0.8u as=0 ps=0 w=0.42u l=1u
X3235 VDD VSS.t962 VDD VDD sg13_lv_pmos ad=0.34p pd=2.68u as=0 ps=0 w=1u l=1u
X3236 VSS.t2533 VDD VSS.t2535 VSS.t2534 sg13_lv_nmos ad=79.8f pd=0.8u as=0 ps=0 w=0.42u l=1u
X3237 VDD VSS.t712 VDD VDD sg13_lv_pmos ad=0.34p pd=2.68u as=0 ps=0 w=1u l=1u
X3238 VSS.t1128 VDD VSS.t1127 VSS.t1126 sg13_lv_nmos ad=0.1428p pd=1.52u as=0 ps=0 w=0.42u l=1u
X3239 VDD VSS.t3265 VDD VDD sg13_lv_pmos ad=0.19p pd=1.38u as=0 ps=0 w=1u l=1u
X3240 VDD VSS.t99 VDD VDD sg13_lv_pmos ad=0.19p pd=1.38u as=0 ps=0 w=1u l=1u
X3241 VDD VSS.t900 VDD VDD sg13_lv_pmos ad=0.19p pd=1.38u as=0 ps=0 w=1u l=1u
X3242 VSS.t1699 VDD VSS.t1701 VSS.t1700 sg13_lv_nmos ad=79.8f pd=0.8u as=0 ps=0 w=0.42u l=1u
X3243 VDD VSS.t557 VDD VDD sg13_lv_pmos ad=0.19p pd=1.38u as=0 ps=0 w=1u l=1u
X3244 VDD VSS.t1975 VDD VDD sg13_lv_pmos ad=0.34p pd=2.68u as=0 ps=0 w=1u l=1u
X3245 VSS.t2021 VDD VSS.t2020 VSS.t2019 sg13_lv_nmos ad=0.1428p pd=1.52u as=0 ps=0 w=0.42u l=1u
X3246 sg13g2_buf_16_2.A a_15022_14484# VSS.t62 VSS.t143 sg13_lv_nmos ad=0.1406p pd=1.12u as=0.1406p ps=1.12u w=0.74u l=0.13u
X3247 sg13g2_dlygate4sd3_1_0.A a_6540_13238# VDD VDD sg13_lv_pmos ad=0.2408p pd=1.55u as=0.3808p ps=2.92u w=1.12u l=0.13u
X3248 VSS.t1327 VDD VSS.t1327 VSS.t311 sg13_lv_nmos ad=0.1428p pd=1.52u as=0 ps=0 w=0.42u l=1u
X3249 VDD VSS.t355 VDD VDD sg13_lv_pmos ad=0.19p pd=1.38u as=0 ps=0 w=1u l=1u
X3250 a_8685_14832# sg13g2_buf_1_10.X VDD VDD sg13_lv_pmos ad=0.1596p pd=1.22u as=0.2856p ps=2.36u w=0.84u l=0.13u
X3251 a_21060_14488# a_21579_14495# a_22319_14845# VSS.t25 sg13_lv_nmos ad=0.3473p pd=2.71u as=0.12665p ps=1.145u w=0.74u l=0.13u
X3252 VDD VSS.t1419 VDD VDD sg13_lv_pmos ad=0.34p pd=2.68u as=0 ps=0 w=1u l=1u
X3253 VSS.t2363 VDD VSS.t2362 VSS.t2361 sg13_lv_nmos ad=0.1428p pd=1.52u as=0 ps=0 w=0.42u l=1u
X3254 VSS.t757 VDD VSS.t754 VSS.t756 sg13_lv_nmos ad=0.1428p pd=1.52u as=0 ps=0 w=0.42u l=1u
X3255 VSS.t1819 VDD VSS.t1821 VSS.t1820 sg13_lv_nmos ad=79.8f pd=0.8u as=0 ps=0 w=0.42u l=1u
X3256 VSS.t2760 VDD VSS.t2761 VSS.t392 sg13_lv_nmos ad=79.8f pd=0.8u as=0 ps=0 w=0.42u l=1u
X3257 VDD a_18298_16237# sg13g2_dfrbpq_1_3.RESET_B VDD sg13_lv_pmos ad=2.8961p pd=18.25u as=0.3927p ps=2.99u w=1.155u l=0.13u
X3258 VSS.t1003 VDD VSS.t1005 VSS.t1004 sg13_lv_nmos ad=79.8f pd=0.8u as=0 ps=0 w=0.42u l=1u
X3259 VDD VSS.t1778 VDD VDD sg13_lv_pmos ad=0.34p pd=2.68u as=0 ps=0 w=1u l=1u
X3260 VSS.t2838 VDD VSS.t2837 VSS.t392 sg13_lv_nmos ad=0.1428p pd=1.52u as=0 ps=0 w=0.42u l=1u
X3261 VSS.t3153 VDD VSS.t3155 VSS.t3154 sg13_lv_nmos ad=79.8f pd=0.8u as=0 ps=0 w=0.42u l=1u
X3262 VDD VSS.t3060 VDD VDD sg13_lv_pmos ad=0.19p pd=1.38u as=0 ps=0 w=1u l=1u
X3263 a_21166_16263# a_21281_16262# VDD VDD sg13_lv_pmos ad=0.34p pd=2.68u as=0.2254p ps=1.53u w=1u l=0.5u
X3264 VDD a_5687_15315# a_5687_15549# VDD sg13_lv_pmos ad=2.8961p pd=18.25u as=0.2442p ps=2.06u w=0.66u l=0.13u
X3265 VDD VSS.t2467 VDD VDD sg13_lv_pmos ad=0.34p pd=2.68u as=0 ps=0 w=1u l=1u
X3266 VDD VSS.t702 VDD VDD sg13_lv_pmos ad=0.19p pd=1.38u as=0 ps=0 w=1u l=1u
X3267 VDD VSS.t2125 VDD VDD sg13_lv_pmos ad=0.34p pd=2.68u as=0 ps=0 w=1u l=1u
X3268 VDD a_22508_15960# counter_value_o[4] VDD sg13_lv_pmos ad=0.2114p pd=1.54u as=0.42p ps=2.99u w=1.12u l=0.13u
X3269 VDD VSS.t733 VDD VDD sg13_lv_pmos ad=0.19p pd=1.38u as=0 ps=0 w=1u l=1u
X3270 VSS.t54 VDD VSS.t54 VSS.t699 sg13_lv_nmos ad=79.8f pd=0.8u as=0 ps=0 w=0.42u l=1u
X3271 VDD VSS.t1348 VDD VDD sg13_lv_pmos ad=0.19p pd=1.38u as=0 ps=0 w=1u l=1u
X3272 VDD VSS.t1448 VDD VDD sg13_lv_pmos ad=0.19p pd=1.38u as=0 ps=0 w=1u l=1u
X3273 VDD VSS.t3250 VDD VDD sg13_lv_pmos ad=0.19p pd=1.38u as=0 ps=0 w=1u l=1u
X3274 VSS.t1312 VDD VSS.t1312 VSS.t311 sg13_lv_nmos ad=0.1428p pd=1.52u as=0 ps=0 w=0.42u l=1u
X3275 VDD VSS.t2824 VDD VDD sg13_lv_pmos ad=0.19p pd=1.38u as=0 ps=0 w=1u l=1u
X3276 VSS.t2488 VDD VSS.t2487 VSS.t2486 sg13_lv_nmos ad=0.1428p pd=1.52u as=0 ps=0 w=0.42u l=1u
X3277 VDD VSS.t2043 VDD VDD sg13_lv_pmos ad=0.19p pd=1.38u as=0 ps=0 w=1u l=1u
X3278 a_27664_13942# sg13g2_dfrbpq_1_5.RESET_B VDD VDD sg13_lv_pmos ad=79.8f pd=0.8u as=2.42015p ps=15.68u w=0.42u l=0.13u
X3279 a_16254_15934# a_16055_16071# VSS.t81 VSS.t353 sg13_lv_nmos ad=0.27427p pd=2.28u as=5.24677p ps=34.365u w=0.795u l=0.13u
X3280 sg13g2_nand4_1_0.Y sg13g2_xor2_1_0.B VDD VDD sg13_lv_pmos ad=0.2128p pd=1.5u as=0.3808p ps=2.92u w=1.12u l=0.13u
X3281 VSS.t615 VDD VSS.t616 VSS.t9 sg13_lv_nmos ad=79.8f pd=0.8u as=0 ps=0 w=0.42u l=1u
X3282 VDD VSS.t608 VDD VDD sg13_lv_pmos ad=0.34p pd=2.68u as=0 ps=0 w=1u l=1u
X3283 a_15782_13722# a_16587_13844# a_16042_13945# VDD sg13_lv_pmos ad=0.1428p pd=1.52u as=79.8f ps=0.8u w=0.42u l=0.13u
X3284 sg13g2_buf_16_2.X a_19438_13726# VSS.t319 VSS.t326 sg13_lv_nmos ad=0.1406p pd=1.12u as=0.1406p ps=1.12u w=0.74u l=0.13u
X3285 VSS.t1306 VDD VSS.t1307 VSS.t311 sg13_lv_nmos ad=79.8f pd=0.8u as=0 ps=0 w=0.42u l=1u
X3286 VSS.t3006 VDD VSS.t2881 VSS.t392 sg13_lv_nmos ad=0.1428p pd=1.52u as=0 ps=0 w=0.42u l=1u
X3287 VDD VSS.t2168 VDD VDD sg13_lv_pmos ad=0.19p pd=1.38u as=0 ps=0 w=1u l=1u
X3288 sg13g2_dfrbpq_1_2.D sg13g2_nor2_1_0.B a_15722_15532# VDD sg13_lv_pmos ad=0.3808p pd=2.92u as=0.1176p ps=1.33u w=1.12u l=0.13u
X3289 VDD VSS.t1811 VDD VDD sg13_lv_pmos ad=0.19p pd=1.38u as=0 ps=0 w=1u l=1u
X3290 VDD VSS.t3277 VDD VDD sg13_lv_pmos ad=0.34p pd=2.68u as=0 ps=0 w=1u l=1u
X3291 VDD VSS.t460 VDD VDD sg13_lv_pmos ad=0.19p pd=1.38u as=0 ps=0 w=1u l=1u
X3292 VDD VSS.t498 VDD VDD sg13_lv_pmos ad=0.19p pd=1.38u as=0 ps=0 w=1u l=1u
X3293 VSS.t2553 VDD VSS.t2555 VSS.t2554 sg13_lv_nmos ad=79.8f pd=0.8u as=0 ps=0 w=0.42u l=1u
X3294 VSS.t2051 VDD VSS.t2053 VSS.t2052 sg13_lv_nmos ad=79.8f pd=0.8u as=0 ps=0 w=0.42u l=1u
X3295 a_10222_14751# a_10337_14750# VDD VDD sg13_lv_pmos ad=0.34p pd=2.68u as=0.2254p ps=1.53u w=1u l=0.5u
X3296 VDD VSS.t1851 VDD VDD sg13_lv_pmos ad=0.19p pd=1.38u as=0 ps=0 w=1u l=1u
X3297 VDD VSS.t3080 VDD VDD sg13_lv_pmos ad=0.19p pd=1.38u as=0 ps=0 w=1u l=1u
X3298 a_15022_14484# clock_i VDD VDD sg13_lv_pmos ad=0.2128p pd=1.5u as=0.3808p ps=2.92u w=1.12u l=0.13u
X3299 VDD VSS.t1681 VDD VDD sg13_lv_pmos ad=0.19p pd=1.38u as=0 ps=0 w=1u l=1u
X3300 VSS.t9 a_21477_14495# a_21579_14495# VSS.t52 sg13_lv_nmos ad=5.4375p pd=36.05u as=0.2516p ps=2.16u w=0.74u l=0.13u
X3301 VDD a_26565_13701# a_26667_13844# VDD sg13_lv_pmos ad=2.42015p pd=15.68u as=0.3864p ps=2.93u w=1.12u l=0.13u
X3302 VDD VSS.t693 VDD VDD sg13_lv_pmos ad=0.34p pd=2.68u as=0 ps=0 w=1u l=1u
X3303 VSS.t1403 VDD VSS.t1402 VSS.t311 sg13_lv_nmos ad=0.1428p pd=1.52u as=0 ps=0 w=0.42u l=1u
X3304 VSS.t2768 VDD VSS.t2917 VSS.t392 sg13_lv_nmos ad=0.1428p pd=1.52u as=0 ps=0 w=0.42u l=1u
X3305 VDD VSS.t319 VDD VDD sg13_lv_pmos ad=0.34p pd=2.68u as=0 ps=0 w=1u l=1u
X3306 VDD VSS.t1439 VDD VDD sg13_lv_pmos ad=0.19p pd=1.38u as=0 ps=0 w=1u l=1u
X3307 VDD VSS.t2820 VDD VDD sg13_lv_pmos ad=0.19p pd=1.38u as=0 ps=0 w=1u l=1u
X3308 VDD VSS.t2495 VDD VDD sg13_lv_pmos ad=0.19p pd=1.38u as=0 ps=0 w=1u l=1u
X3309 VSS.t90 VDD VSS.t553 VSS.t552 sg13_lv_nmos ad=79.8f pd=0.8u as=0 ps=0 w=0.42u l=1u
X3310 VSS.t597 VDD VSS.t596 VSS.t9 sg13_lv_nmos ad=0.1428p pd=1.52u as=0 ps=0 w=0.42u l=1u
X3311 a_4474_14448# sg13g2_dlygate4sd3_1_3.A VSS.t48 VSS.t357 sg13_lv_nmos ad=0.1428p pd=1.52u as=79.8f ps=0.8u w=0.42u l=0.13u
X3312 VSS.t2795 VDD VSS.t2796 VSS.t392 sg13_lv_nmos ad=79.8f pd=0.8u as=0 ps=0 w=0.42u l=1u
X3313 VSS.t2830 VDD VSS.t2831 VSS.t392 sg13_lv_nmos ad=79.8f pd=0.8u as=0 ps=0 w=0.42u l=1u
X3314 sg13g2_buf_16_2.X a_19438_13726# VSS.t319 VSS.t322 sg13_lv_nmos ad=0.1406p pd=1.12u as=0.1406p ps=1.12u w=0.74u l=0.13u
X3315 VSS.t1991 VDD VSS.t1990 VSS.t1989 sg13_lv_nmos ad=0.1428p pd=1.52u as=0 ps=0 w=0.42u l=1u
X3316 VSS.t1437 VDD VSS.t1438 VSS.t311 sg13_lv_nmos ad=79.8f pd=0.8u as=0 ps=0 w=0.42u l=1u
X3317 VDD VSS.t1831 VDD VDD sg13_lv_pmos ad=0.19p pd=1.38u as=0 ps=0 w=1u l=1u
X3318 VDD VSS.t3120 VDD VDD sg13_lv_pmos ad=0.19p pd=1.38u as=0 ps=0 w=1u l=1u
X3319 VDD VSS.t1988 VDD VDD sg13_lv_pmos ad=0.19p pd=1.38u as=0 ps=0 w=1u l=1u
X3320 VSS.t466 VDD VSS.t466 VSS.t468 sg13_lv_nmos ad=0.1428p pd=1.52u as=0 ps=0 w=0.42u l=1u
X3321 VDD VSS.t188 VDD VDD sg13_lv_pmos ad=0.19p pd=1.38u as=0 ps=0 w=1u l=1u
X3322 VDD VSS.t11 VDD VDD sg13_lv_pmos ad=0.34p pd=2.68u as=0 ps=0 w=1u l=1u
X3323 VDD VSS.t2831 VDD VDD sg13_lv_pmos ad=0.34p pd=2.68u as=0 ps=0 w=1u l=1u
X3324 VSS.t62 sg13g2_nor2_1_0.B sg13g2_dfrbpq_1_2.D VSS.t109 sg13_lv_nmos ad=0.2516p pd=2.16u as=0.1406p ps=1.12u w=0.74u l=0.13u
X3325 VDD VSS.t2900 VDD VDD sg13_lv_pmos ad=0.19p pd=1.38u as=0 ps=0 w=1u l=1u
X3326 a_27215_14845# a_26373_14495# a_25956_14488# VDD sg13_lv_pmos ad=0.2048p pd=1.63u as=0.34p ps=2.68u w=1u l=0.13u
X3327 VSS.t3138 VDD VSS.t3140 VSS.t3139 sg13_lv_nmos ad=79.8f pd=0.8u as=0 ps=0 w=0.42u l=1u
X3328 VSS.t2196 VDD VSS.t2195 VSS.t2194 sg13_lv_nmos ad=0.1428p pd=1.52u as=0 ps=0 w=0.42u l=1u
X3329 VSS.t723 VDD VSS.t723 VSS.t845 sg13_lv_nmos ad=79.8f pd=0.8u as=0 ps=0 w=0.42u l=1u
X3330 VDD VSS.t592 VDD VDD sg13_lv_pmos ad=0.19p pd=1.38u as=0 ps=0 w=1u l=1u
X3331 VDD VSS.t1162 VDD VDD sg13_lv_pmos ad=0.34p pd=2.68u as=0 ps=0 w=1u l=1u
X3332 VDD VSS.t760 VDD VDD sg13_lv_pmos ad=0.19p pd=1.38u as=0 ps=0 w=1u l=1u
X3333 VSS.t2538 VDD VSS.t2540 VSS.t2539 sg13_lv_nmos ad=79.8f pd=0.8u as=0 ps=0 w=0.42u l=1u
X3334 VSS.t1445 VDD VSS.t1446 VSS.t311 sg13_lv_nmos ad=79.8f pd=0.8u as=0 ps=0 w=0.42u l=1u
X3335 VDD sg13g2_a21oi_1_0.Y a_16760_15238# VDD sg13_lv_pmos ad=0.1523p pd=1.38u as=0.1428p ps=1.52u w=0.42u l=0.13u
X3336 VDD a_15022_14484# sg13g2_buf_16_2.A VDD sg13_lv_pmos ad=0.2128p pd=1.5u as=0.2128p ps=1.5u w=1.12u l=0.13u
X3337 VDD VSS.t1626 VDD VDD sg13_lv_pmos ad=0.19p pd=1.38u as=0 ps=0 w=1u l=1u
X3338 VDD VSS.t3092 VDD VDD sg13_lv_pmos ad=0.34p pd=2.68u as=0 ps=0 w=1u l=1u
X3339 VSS.t1704 VDD VSS.t1706 VSS.t1705 sg13_lv_nmos ad=79.8f pd=0.8u as=0 ps=0 w=0.42u l=1u
X3340 VDD VSS.t2205 VDD VDD sg13_lv_pmos ad=0.34p pd=2.68u as=0 ps=0 w=1u l=1u
X3341 VDD VSS.t736 VDD VDD sg13_lv_pmos ad=0.34p pd=2.68u as=0 ps=0 w=1u l=1u
X3342 a_4078_14751# a_4193_14750# VSS.t180 VSS.t220 sg13_lv_nmos ad=0.1428p pd=1.52u as=0.1426p ps=1.16u w=0.42u l=0.5u
X3343 VSS.t968 VDD VSS.t970 VSS.t969 sg13_lv_nmos ad=79.8f pd=0.8u as=0 ps=0 w=0.42u l=1u
X3344 VDD VSS.t2788 VDD VDD sg13_lv_pmos ad=0.19p pd=1.38u as=0 ps=0 w=1u l=1u
X3345 VSS.t2026 VDD VSS.t2025 VSS.t2024 sg13_lv_nmos ad=0.1428p pd=1.52u as=0 ps=0 w=0.42u l=1u
X3346 VDD VSS.t1364 VDD VDD sg13_lv_pmos ad=0.19p pd=1.38u as=0 ps=0 w=1u l=1u
X3347 VSS.t2999 VDD VSS.t2873 VSS.t392 sg13_lv_nmos ad=0.1428p pd=1.52u as=0 ps=0 w=0.42u l=1u
X3348 VDD VSS.t2153 VDD VDD sg13_lv_pmos ad=0.19p pd=1.38u as=0 ps=0 w=1u l=1u
X3349 a_21286_14909# sg13g2_dfrbpq_1_6.RESET_B VSS.t21 VSS.t236 sg13_lv_nmos ad=37.8f pd=0.6u as=0.1701p ps=1.65u w=0.42u l=0.13u
X3350 sg13g2_buf_16_2.X a_19438_13726# VSS.t317 VSS.t316 sg13_lv_nmos ad=0.1406p pd=1.12u as=0.1406p ps=1.12u w=0.74u l=0.13u
X3351 VSS.t2568 VDD VSS.t2567 VSS.t2566 sg13_lv_nmos ad=0.1428p pd=1.52u as=0 ps=0 w=0.42u l=1u
X3352 VSS.t1824 VDD VSS.t1826 VSS.t1825 sg13_lv_nmos ad=79.8f pd=0.8u as=0 ps=0 w=0.42u l=1u
X3353 VDD VSS.t2105 VDD VDD sg13_lv_pmos ad=0.34p pd=2.68u as=0 ps=0 w=1u l=1u
X3354 VSS.t2216 VDD VSS.t2215 VSS.t2214 sg13_lv_nmos ad=0.1428p pd=1.52u as=0 ps=0 w=0.42u l=1u
X3355 VSS.t2036 VDD VSS.t2038 VSS.t2037 sg13_lv_nmos ad=79.8f pd=0.8u as=0 ps=0 w=0.42u l=1u
X3356 a_18454_15230# sg13g2_or3_1_2.B VSS.t45 VSS.t372 sg13_lv_nmos ad=0.1406p pd=1.12u as=0.1406p ps=1.12u w=0.74u l=0.15u
X3357 VDD VSS.t1836 VDD VDD sg13_lv_pmos ad=0.19p pd=1.38u as=0 ps=0 w=1u l=1u
X3358 VSS.t3123 VDD VSS.t3125 VSS.t3124 sg13_lv_nmos ad=79.8f pd=0.8u as=0 ps=0 w=0.42u l=1u
X3359 VDD VSS.t3065 VDD VDD sg13_lv_pmos ad=0.19p pd=1.38u as=0 ps=0 w=1u l=1u
X3360 VSS.t2633 VDD VSS.t2635 VSS.t2634 sg13_lv_nmos ad=79.8f pd=0.8u as=0 ps=0 w=0.42u l=1u
X3361 VDD VSS.t1788 VDD VDD sg13_lv_pmos ad=0.34p pd=2.68u as=0 ps=0 w=1u l=1u
X3362 a_2942_14484# sg13g2_xor2_1_0.B a_2490_14447# VDD sg13_lv_pmos ad=0.1225p pd=1.245u as=0.34p ps=2.68u w=1u l=0.13u
X3363 VDD VSS.t739 VDD VDD sg13_lv_pmos ad=0.34p pd=2.68u as=0 ps=0 w=1u l=1u
X3364 VDD VSS.t937 VDD VDD sg13_lv_pmos ad=0.34p pd=2.68u as=0 ps=0 w=1u l=1u
X3365 VDD VSS.t1666 VDD VDD sg13_lv_pmos ad=0.19p pd=1.38u as=0 ps=0 w=1u l=1u
X3366 VDD VSS.t1843 VDD VDD sg13_lv_pmos ad=0.34p pd=2.68u as=0 ps=0 w=1u l=1u
X3367 a_5613_14832# sg13g2_buf_1_10.X VDD VDD sg13_lv_pmos ad=0.1596p pd=1.22u as=0.2856p ps=2.36u w=0.84u l=0.13u
X3368 VSS.t317 sg13g2_buf_16_2.A a_19438_13726# VSS.t408 sg13_lv_nmos ad=0.1406p pd=1.12u as=0.1406p ps=1.12u w=0.74u l=0.13u
X3369 VSS.t1429 VDD VSS.t1428 VSS.t311 sg13_lv_nmos ad=0.1428p pd=1.52u as=0 ps=0 w=0.42u l=1u
X3370 VDD VSS.t2472 VDD VDD sg13_lv_pmos ad=0.34p pd=2.68u as=0 ps=0 w=1u l=1u
X3371 VDD a_17219_16265# sg13g2_a21oi_1_0.A2 VDD sg13_lv_pmos ad=0.3822p pd=1.84u as=0.3808p ps=2.92u w=1.12u l=0.13u
X3372 VDD sg13g2_buf_1_0.X sg13g2_xnor2_1_2.B VDD sg13_lv_pmos ad=0.3808p pd=2.92u as=0.2128p ps=1.5u w=1.12u l=0.13u
X3373 VDD VSS.t777 VDD VDD sg13_lv_pmos ad=0.34p pd=2.68u as=0 ps=0 w=1u l=1u
X3374 VSS.t7 VDD VSS.t99 VSS.t576 sg13_lv_nmos ad=79.8f pd=0.8u as=0 ps=0 w=0.42u l=1u
X3375 a_5886_15486# a_5687_15549# VSS.t9 VSS.t49 sg13_lv_nmos ad=0.27427p pd=2.28u as=5.4375p ps=36.05u w=0.795u l=0.13u
X3376 VSS.t1554 VDD VSS.t1423 VSS.t311 sg13_lv_nmos ad=79.8f pd=0.8u as=0 ps=0 w=0.42u l=1u
X3377 VDD VSS.t2048 VDD VDD sg13_lv_pmos ad=0.19p pd=1.38u as=0 ps=0 w=1u l=1u
X3378 VDD VSS.t625 VDD VDD sg13_lv_pmos ad=0.19p pd=1.38u as=0 ps=0 w=1u l=1u
X3379 VDD a_15022_14484# sg13g2_buf_16_2.A VDD sg13_lv_pmos ad=0.2128p pd=1.5u as=0.2128p ps=1.5u w=1.12u l=0.13u
X3380 VDD VSS.t990 VDD VDD sg13_lv_pmos ad=0.19p pd=1.38u as=0 ps=0 w=1u l=1u
X3381 VDD VSS.t2367 VDD VDD sg13_lv_pmos ad=0.34p pd=2.68u as=0 ps=0 w=1u l=1u
X3382 VSS.t2885 VDD VSS.t2884 VSS.t392 sg13_lv_nmos ad=0.1428p pd=1.52u as=0 ps=0 w=0.42u l=1u
X3383 VDD VSS.t2173 VDD VDD sg13_lv_pmos ad=0.19p pd=1.38u as=0 ps=0 w=1u l=1u
X3384 VSS.t81 a_16055_16301# a_16055_16301# VSS.t351 sg13_lv_nmos ad=5.24677p pd=34.365u as=0.111p ps=1.34u w=0.3u l=0.13u
X3385 VSS.t21 a_21070_15423# sg13g2_dlygate4sd3_1_11.X VSS.t112 sg13_lv_nmos ad=0.1426p pd=1.16u as=0.2516p ps=2.16u w=0.74u l=0.13u
X3386 VDD VSS.t1407 VDD VDD sg13_lv_pmos ad=0.19p pd=1.38u as=0 ps=0 w=1u l=1u
X3387 VDD VSS.t1356 VDD VDD sg13_lv_pmos ad=0.19p pd=1.38u as=0 ps=0 w=1u l=1u
X3388 VDD VSS.t2859 VDD VDD sg13_lv_pmos ad=0.19p pd=1.38u as=0 ps=0 w=1u l=1u
X3389 VSS.t2553 VDD VSS.t2552 VSS.t2551 sg13_lv_nmos ad=0.1428p pd=1.52u as=0 ps=0 w=0.42u l=1u
X3390 VSS.t1976 VDD VSS.t1975 VSS.t1974 sg13_lv_nmos ad=0.1428p pd=1.52u as=0 ps=0 w=0.42u l=1u
X3391 VDD a_7822_13911# sg13g2_xnor2_1_2.A VDD sg13_lv_pmos ad=0.2254p pd=1.53u as=0.4256p ps=3u w=1.12u l=0.13u
X3392 VDD VSS.t1816 VDD VDD sg13_lv_pmos ad=0.19p pd=1.38u as=0 ps=0 w=1u l=1u
X3393 VDD VSS.t3282 VDD VDD sg13_lv_pmos ad=0.34p pd=2.68u as=0 ps=0 w=1u l=1u
X3394 VSS.t831 VDD VSS.t338 VSS.t832 sg13_lv_nmos ad=79.8f pd=0.8u as=0 ps=0 w=0.42u l=1u
X3395 VSS.t739 VDD VSS.t742 VSS.t871 sg13_lv_nmos ad=79.8f pd=0.8u as=0 ps=0 w=0.42u l=1u
X3396 VSS.t2833 VDD VSS.t2832 VSS.t392 sg13_lv_nmos ad=0.1428p pd=1.52u as=0 ps=0 w=0.42u l=1u
X3397 VSS.t21 sg13g2_or3_1_2.X a_20705_15260# VSS.t0 sg13_lv_nmos ad=0.2516p pd=2.16u as=0.1406p ps=1.12u w=0.74u l=0.13u
X3398 VSS.t1023 VDD VSS.t1025 VSS.t1024 sg13_lv_nmos ad=79.8f pd=0.8u as=0 ps=0 w=0.42u l=1u
X3399 VDD VSS.t1821 VDD VDD sg13_lv_pmos ad=0.19p pd=1.38u as=0 ps=0 w=1u l=1u
X3400 VSS.t1779 VDD VSS.t1778 VSS.t1777 sg13_lv_nmos ad=0.1428p pd=1.52u as=0 ps=0 w=0.42u l=1u
X3401 VSS.t3303 VDD VSS.t3302 VSS.t3301 sg13_lv_nmos ad=0.1428p pd=1.52u as=0 ps=0 w=0.42u l=1u
X3402 VSS.t2618 VDD VSS.t2620 VSS.t2619 sg13_lv_nmos ad=79.8f pd=0.8u as=0 ps=0 w=0.42u l=1u
X3403 VDD VSS.t2505 VDD VDD sg13_lv_pmos ad=0.19p pd=1.38u as=0 ps=0 w=1u l=1u
X3404 a_22508_15960# sg13g2_dfrbpq_1_3.Q VSS.t231 VSS.t235 sg13_lv_nmos ad=0.187p pd=1.78u as=0.14875p ps=1.16u w=0.55u l=0.13u
X3405 a_7631_14845# a_6789_14495# a_7537_14845# VSS.t275 sg13_lv_nmos ad=0.12665p pd=1.145u as=0.1428p ps=1.52u w=0.42u l=0.13u
X3406 VSS.t963 VDD VSS.t962 VSS.t961 sg13_lv_nmos ad=0.1428p pd=1.52u as=0 ps=0 w=0.42u l=1u
X3407 VSS.t2770 VDD VSS.t2770 VSS.t392 sg13_lv_nmos ad=0.1428p pd=1.52u as=0 ps=0 w=0.42u l=1u
X3408 VDD VSS.t2823 VDD VDD sg13_lv_pmos ad=0.19p pd=1.38u as=0 ps=0 w=1u l=1u
X3409 VSS.t2523 VDD VSS.t2525 VSS.t2524 sg13_lv_nmos ad=79.8f pd=0.8u as=0 ps=0 w=0.42u l=1u
X3410 VSS.t2086 VDD VSS.t2085 VSS.t2084 sg13_lv_nmos ad=0.1428p pd=1.52u as=0 ps=0 w=0.42u l=1u
X3411 VSS.t898 VDD VSS.t900 VSS.t899 sg13_lv_nmos ad=79.8f pd=0.8u as=0 ps=0 w=0.42u l=1u
X3412 VSS.t2992 VDD VSS.t2867 VSS.t392 sg13_lv_nmos ad=79.8f pd=0.8u as=0 ps=0 w=0.42u l=1u
X3413 VSS.t968 VDD VSS.t970 VSS.t969 sg13_lv_nmos ad=79.8f pd=0.8u as=0 ps=0 w=0.42u l=1u
X3414 VSS.t1364 VDD VSS.t1363 VSS.t311 sg13_lv_nmos ad=0.1428p pd=1.52u as=0 ps=0 w=0.42u l=1u
X3415 VDD VSS.t1611 VDD VDD sg13_lv_pmos ad=0.19p pd=1.38u as=0 ps=0 w=1u l=1u
X3416 VDD VSS.t3077 VDD VDD sg13_lv_pmos ad=0.34p pd=2.68u as=0 ps=0 w=1u l=1u
X3417 a_21562_15960# sg13g2_a21oi_1_1.Y VDD VDD sg13_lv_pmos ad=0.1428p pd=1.52u as=0.1523p ps=1.38u w=0.42u l=0.13u
X3418 VDD VSS.t766 VDD VDD sg13_lv_pmos ad=0.34p pd=2.68u as=0 ps=0 w=1u l=1u
X3419 VDD VSS.t2190 VDD VDD sg13_lv_pmos ad=0.34p pd=2.68u as=0 ps=0 w=1u l=1u
X3420 VDD a_15022_14484# sg13g2_buf_16_2.A VDD sg13_lv_pmos ad=0.2128p pd=1.5u as=0.2128p ps=1.5u w=1.12u l=0.13u
X3421 a_17604_14488# a_18123_14495# a_18863_14845# VSS.t76 sg13_lv_nmos ad=0.3473p pd=2.71u as=0.12665p ps=1.145u w=0.74u l=0.13u
X3422 VSS.t1689 VDD VSS.t1691 VSS.t1690 sg13_lv_nmos ad=79.8f pd=0.8u as=0 ps=0 w=0.42u l=1u
X3423 VSS.t83 sg13g2_or3_1_1.X a_25025_16344# VSS.t233 sg13_lv_nmos ad=0.2516p pd=2.16u as=0.1406p ps=1.12u w=0.74u l=0.13u
X3424 VDD VSS.t533 VDD VDD sg13_lv_pmos ad=0.19p pd=1.38u as=0 ps=0 w=1u l=1u
X3425 VDD VSS.t2560 VDD VDD sg13_lv_pmos ad=0.19p pd=1.38u as=0 ps=0 w=1u l=1u
X3426 VSS.t1368 VDD VSS.t1368 VSS.t311 sg13_lv_nmos ad=0.1428p pd=1.52u as=0 ps=0 w=0.42u l=1u
X3427 VDD VSS.t1801 VDD VDD sg13_lv_pmos ad=0.19p pd=1.38u as=0 ps=0 w=1u l=1u
X3428 VDD VSS.t1993 VDD VDD sg13_lv_pmos ad=0.19p pd=1.38u as=0 ps=0 w=1u l=1u
X3429 VSS.t2166 VDD VSS.t2168 VSS.t2167 sg13_lv_nmos ad=79.8f pd=0.8u as=0 ps=0 w=0.42u l=1u
X3430 VSS.t993 VDD VSS.t992 VSS.t991 sg13_lv_nmos ad=0.1428p pd=1.52u as=0 ps=0 w=0.42u l=1u
X3431 VSS.t1292 VDD VSS.t1291 VSS.t311 sg13_lv_nmos ad=0.1428p pd=1.52u as=0 ps=0 w=0.42u l=1u
X3432 VDD VSS.t2090 VDD VDD sg13_lv_pmos ad=0.34p pd=2.68u as=0 ps=0 w=1u l=1u
X3433 a_17219_16265# sg13g2_dlygate4sd3_1_6.X VSS.t347 VSS.t379 sg13_lv_nmos ad=0.198p pd=1.27u as=0.13395p ps=1.12u w=0.55u l=0.13u
X3434 VSS.t1331 VDD VSS.t1332 VSS.t311 sg13_lv_nmos ad=79.8f pd=0.8u as=0 ps=0 w=0.42u l=1u
X3435 VSS.t3288 VDD VSS.t3287 VSS.t3286 sg13_lv_nmos ad=0.1428p pd=1.52u as=0 ps=0 w=0.42u l=1u
X3436 VSS.t2201 VDD VSS.t2200 VSS.t2199 sg13_lv_nmos ad=0.1428p pd=1.52u as=0 ps=0 w=0.42u l=1u
X3437 VSS.t760 VDD VSS.t760 VSS.t761 sg13_lv_nmos ad=79.8f pd=0.8u as=0 ps=0 w=0.42u l=1u
X3438 VDD VSS.t1170 VDD VDD sg13_lv_pmos ad=0.19p pd=1.38u as=0 ps=0 w=1u l=1u
X3439 sg13g2_buf_1_10.X a_1192_9948# VDD VDD sg13_lv_pmos ad=0.42p pd=2.99u as=0.2114p ps=1.54u w=1.12u l=0.13u
X3440 VDD VSS.t1773 VDD VDD sg13_lv_pmos ad=0.34p pd=2.68u as=0 ps=0 w=1u l=1u
X3441 VSS.t774 VDD VSS.t777 VSS.t893 sg13_lv_nmos ad=79.8f pd=0.8u as=0 ps=0 w=0.42u l=1u
X3442 VSS.t1297 VDD VSS.t1296 VSS.t311 sg13_lv_nmos ad=0.1428p pd=1.52u as=0 ps=0 w=0.42u l=1u
X3443 VDD VSS.t1828 VDD VDD sg13_lv_pmos ad=0.34p pd=2.68u as=0 ps=0 w=1u l=1u
X3444 VSS.t1679 VDD VSS.t1681 VSS.t1680 sg13_lv_nmos ad=79.8f pd=0.8u as=0 ps=0 w=0.42u l=1u
X3445 VSS.t2573 VDD VSS.t2572 VSS.t2571 sg13_lv_nmos ad=0.1428p pd=1.52u as=0 ps=0 w=0.42u l=1u
X3446 VDD VSS.t2457 VDD VDD sg13_lv_pmos ad=0.34p pd=2.68u as=0 ps=0 w=1u l=1u
X3447 a_27417_14607# a_26475_14495# a_27215_14845# VDD sg13_lv_pmos ad=93.45f pd=0.865u as=0.2048p ps=1.63u w=0.42u l=0.13u
X3448 VDD VSS.t430 VDD VDD sg13_lv_pmos ad=0.34p pd=2.68u as=0 ps=0 w=1u l=1u
X3449 VSS.t1053 VDD VSS.t1055 VSS.t1054 sg13_lv_nmos ad=79.8f pd=0.8u as=0 ps=0 w=0.42u l=1u
X3450 VDD VSS.t920 VDD VDD sg13_lv_pmos ad=0.19p pd=1.38u as=0 ps=0 w=1u l=1u
X3451 VSS.t2754 VDD VSS.t2755 VSS.t392 sg13_lv_nmos ad=79.8f pd=0.8u as=0 ps=0 w=0.42u l=1u
X3452 VSS.t466 VDD VSS.t466 VSS.t467 sg13_lv_nmos ad=79.8f pd=0.8u as=0 ps=0 w=0.42u l=1u
X3453 VDD VSS.t1631 VDD VDD sg13_lv_pmos ad=0.19p pd=1.38u as=0 ps=0 w=1u l=1u
X3454 VDD VSS.t2210 VDD VDD sg13_lv_pmos ad=0.34p pd=2.68u as=0 ps=0 w=1u l=1u
X3455 VSS.t1674 VDD VSS.t1676 VSS.t1675 sg13_lv_nmos ad=79.8f pd=0.8u as=0 ps=0 w=0.42u l=1u
X3456 VSS.t2031 VDD VSS.t2030 VSS.t2029 sg13_lv_nmos ad=0.1428p pd=1.52u as=0 ps=0 w=0.42u l=1u
X3457 VDD VSS.t1431 VDD VDD sg13_lv_pmos ad=0.34p pd=2.68u as=0 ps=0 w=1u l=1u
X3458 VSS.t1314 VDD VSS.t1314 VSS.t311 sg13_lv_nmos ad=0.1428p pd=1.52u as=0 ps=0 w=0.42u l=1u
X3459 VSS.t2877 VDD VSS.t2876 VSS.t392 sg13_lv_nmos ad=0.1428p pd=1.52u as=0 ps=0 w=0.42u l=1u
X3460 VDD VSS.t2755 VDD VDD sg13_lv_pmos ad=0.34p pd=2.68u as=0 ps=0 w=1u l=1u
X3461 VSS.t681 VDD VSS.t693 VSS.t692 sg13_lv_nmos ad=79.8f pd=0.8u as=0 ps=0 w=0.42u l=1u
X3462 VDD VSS.t1347 VDD VDD sg13_lv_pmos ad=0.19p pd=1.38u as=0 ps=0 w=1u l=1u
X3463 VDD VSS.t2851 VDD VDD sg13_lv_pmos ad=0.19p pd=1.38u as=0 ps=0 w=1u l=1u
X3464 VSS.t1382 VDD VSS.t1381 VSS.t311 sg13_lv_nmos ad=0.1428p pd=1.52u as=0 ps=0 w=0.42u l=1u
X3465 VSS.t2538 VDD VSS.t2537 VSS.t2536 sg13_lv_nmos ad=0.1428p pd=1.52u as=0 ps=0 w=0.42u l=1u
X3466 VSS.t1023 VDD VSS.t1025 VSS.t1024 sg13_lv_nmos ad=79.8f pd=0.8u as=0 ps=0 w=0.42u l=1u
X3467 VSS.t1829 VDD VSS.t1831 VSS.t1830 sg13_lv_nmos ad=79.8f pd=0.8u as=0 ps=0 w=0.42u l=1u
X3468 VDD sg13g2_dfrbpq_1_3.Q sg13g2_or3_1_2.C VDD sg13_lv_pmos ad=0.3808p pd=2.92u as=0.2128p ps=1.5u w=1.12u l=0.13u
X3469 VSS.t624 VDD VSS.t623 VSS.t9 sg13_lv_nmos ad=0.1428p pd=1.52u as=0 ps=0 w=0.42u l=1u
X3470 sg13g2_dfrbpq_1_2.CLK a_12020_15202# VSS.t188 VSS.t193 sg13_lv_nmos ad=0.1406p pd=1.12u as=0.1406p ps=1.12u w=0.74u l=0.13u
X3471 VDD VSS.t1137 VDD VDD sg13_lv_pmos ad=0.34p pd=2.68u as=0 ps=0 w=1u l=1u
X3472 VDD sg13g2_xnor2_1_1.A a_16044_15424# VDD sg13_lv_pmos ad=0.4536p pd=2.76u as=0.1596p ps=1.22u w=0.84u l=0.13u
X3473 VSS.t963 VDD VSS.t962 VSS.t961 sg13_lv_nmos ad=0.1428p pd=1.52u as=0 ps=0 w=0.42u l=1u
X3474 VSS.t2603 VDD VSS.t2605 VSS.t2604 sg13_lv_nmos ad=79.8f pd=0.8u as=0 ps=0 w=0.42u l=1u
X3475 VDD VSS.t1671 VDD VDD sg13_lv_pmos ad=0.19p pd=1.38u as=0 ps=0 w=1u l=1u
X3476 VSS.t2875 VDD VSS.t2875 VSS.t392 sg13_lv_nmos ad=0.1428p pd=1.52u as=0 ps=0 w=0.42u l=1u
X3477 VDD VSS.t2005 VDD VDD sg13_lv_pmos ad=0.34p pd=2.68u as=0 ps=0 w=1u l=1u
X3478 VDD VSS.t1359 VDD VDD sg13_lv_pmos ad=0.19p pd=1.38u as=0 ps=0 w=1u l=1u
X3479 VDD a_19120_14726# a_19065_14607# VDD sg13_lv_pmos ad=2.42015p pd=15.68u as=93.45f ps=0.865u w=0.42u l=0.13u
X3480 a_24841_13726# sg13g2_or3_1_1.B VSS.t164 VSS.t427 sg13_lv_nmos ad=0.198p pd=1.27u as=0.1045p ps=0.93u w=0.55u l=0.13u
X3481 VSS.t898 VDD VSS.t900 VSS.t899 sg13_lv_nmos ad=79.8f pd=0.8u as=0 ps=0 w=0.42u l=1u
X3482 VDD VSS.t1075 VDD VDD sg13_lv_pmos ad=0.19p pd=1.38u as=0 ps=0 w=1u l=1u
X3483 VSS.t1323 VDD VSS.t1322 VSS.t311 sg13_lv_nmos ad=0.1428p pd=1.52u as=0 ps=0 w=0.42u l=1u
X3484 sg13g2_or3_1_1.C sg13g2_dfrbpq_1_6.Q VDD VDD sg13_lv_pmos ad=0.2128p pd=1.5u as=0.2128p ps=1.5u w=1.12u l=0.13u
X3485 a_23378_15242# sg13g2_dfrbpq_1_2.Q VSS.t438 VSS.t24 sg13_lv_nmos ad=0.1406p pd=1.12u as=0.2886p ps=2.26u w=0.74u l=0.13u
X3486 VSS.t2763 VDD VSS.t2762 VSS.t392 sg13_lv_nmos ad=0.1428p pd=1.52u as=0 ps=0 w=0.42u l=1u
X3487 VDD VSS.t2815 VDD VDD sg13_lv_pmos ad=0.19p pd=1.38u as=0 ps=0 w=1u l=1u
X3488 VSS.t3158 VDD VSS.t3157 VSS.t3156 sg13_lv_nmos ad=0.1428p pd=1.52u as=0 ps=0 w=0.42u l=1u
X3489 VDD sg13g2_dfrbpq_1_0.RESET_B a_2630_15234# VDD sg13_lv_pmos ad=0.36237p pd=2.605u as=79.8f ps=0.8u w=0.42u l=0.13u
X3490 VDD VSS.t510 VDD VDD sg13_lv_pmos ad=0.34p pd=2.68u as=0 ps=0 w=1u l=1u
X3491 VDD VSS.t620 VDD VDD sg13_lv_pmos ad=0.34p pd=2.68u as=0 ps=0 w=1u l=1u
X3492 VSS.t1624 VDD VSS.t1626 VSS.t1625 sg13_lv_nmos ad=79.8f pd=0.8u as=0 ps=0 w=0.42u l=1u
X3493 VSS.t1854 VDD VSS.t1853 VSS.t1852 sg13_lv_nmos ad=0.1428p pd=1.52u as=0 ps=0 w=0.42u l=1u
X3494 VSS.t2016 VDD VSS.t2015 VSS.t2014 sg13_lv_nmos ad=0.1428p pd=1.52u as=0 ps=0 w=0.42u l=1u
X3495 VSS.t328 VDD VSS.t319 VSS.t838 sg13_lv_nmos ad=0.1428p pd=1.52u as=0 ps=0 w=0.42u l=1u
X3496 VDD VSS.t1636 VDD VDD sg13_lv_pmos ad=0.19p pd=1.38u as=0 ps=0 w=1u l=1u
X3497 VDD VSS.t2545 VDD VDD sg13_lv_pmos ad=0.19p pd=1.38u as=0 ps=0 w=1u l=1u
X3498 VSS.t993 VDD VSS.t992 VSS.t991 sg13_lv_nmos ad=0.1428p pd=1.52u as=0 ps=0 w=0.42u l=1u
X3499 VSS.t1396 VDD VSS.t1395 VSS.t311 sg13_lv_nmos ad=0.1428p pd=1.52u as=0 ps=0 w=0.42u l=1u
X3500 VDD VSS.t1358 VDD VDD sg13_lv_pmos ad=0.19p pd=1.38u as=0 ps=0 w=1u l=1u
X3501 VDD VSS.t2862 VDD VDD sg13_lv_pmos ad=0.19p pd=1.38u as=0 ps=0 w=1u l=1u
X3502 VSS.t2558 VDD VSS.t2557 VSS.t2556 sg13_lv_nmos ad=0.1428p pd=1.52u as=0 ps=0 w=0.42u l=1u
X3503 VDD VSS.t2143 VDD VDD sg13_lv_pmos ad=0.19p pd=1.38u as=0 ps=0 w=1u l=1u
X3504 VDD sg13g2_dlygate4sd3_1_6.X sg13g2_dlygate4sd3_1_5.A VDD sg13_lv_pmos ad=0.3808p pd=2.92u as=0.2128p ps=1.5u w=1.12u l=0.15u
X3505 VDD VSS.t3252 VDD VDD sg13_lv_pmos ad=0.34p pd=2.68u as=0 ps=0 w=1u l=1u
X3506 VDD VSS.t2497 VDD VDD sg13_lv_pmos ad=0.34p pd=2.68u as=0 ps=0 w=1u l=1u
X3507 VDD VSS.t1978 VDD VDD sg13_lv_pmos ad=0.19p pd=1.38u as=0 ps=0 w=1u l=1u
X3508 VDD VSS.t1643 VDD VDD sg13_lv_pmos ad=0.34p pd=2.68u as=0 ps=0 w=1u l=1u
X3509 VSS.t516 VDD VSS.t208 VSS.t517 sg13_lv_nmos ad=79.8f pd=0.8u as=0 ps=0 w=0.42u l=1u
X3510 a_21060_14488# a_21034_14452# VSS.t21 VSS.t166 sg13_lv_nmos ad=0.2516p pd=2.16u as=0.1626p ps=1.415u w=0.74u l=0.13u
X3511 VDD VSS.t1826 VDD VDD sg13_lv_pmos ad=0.19p pd=1.38u as=0 ps=0 w=1u l=1u
X3512 VSS.t2106 VDD VSS.t2105 VSS.t2104 sg13_lv_nmos ad=0.1428p pd=1.52u as=0 ps=0 w=0.42u l=1u
X3513 sg13g2_dfrbpq_1_2.CLK a_12020_15202# VSS.t188 VSS.t189 sg13_lv_nmos ad=0.1406p pd=1.12u as=0.1406p ps=1.12u w=0.74u l=0.13u
X3514 VSS.t1163 VDD VSS.t1162 VSS.t1161 sg13_lv_nmos ad=0.1428p pd=1.52u as=0 ps=0 w=0.42u l=1u
X3515 VDD VSS.t2510 VDD VDD sg13_lv_pmos ad=0.19p pd=1.38u as=0 ps=0 w=1u l=1u
X3516 VSS.t62 a_15022_14484# sg13g2_buf_16_2.A VSS.t144 sg13_lv_nmos ad=0.1406p pd=1.12u as=0.1406p ps=1.12u w=0.74u l=0.13u
X3517 VDD VSS.t1340 VDD VDD sg13_lv_pmos ad=0.34p pd=2.68u as=0 ps=0 w=1u l=1u
X3518 VDD VSS.t707 VDD VDD sg13_lv_pmos ad=0.19p pd=1.38u as=0 ps=0 w=1u l=1u
X3519 VSS.t1053 VDD VSS.t1055 VSS.t1054 sg13_lv_nmos ad=79.8f pd=0.8u as=0 ps=0 w=0.42u l=1u
X3520 VDD VSS.t1027 VDD VDD sg13_lv_pmos ad=0.34p pd=2.68u as=0 ps=0 w=1u l=1u
X3521 VSS.t1664 VDD VSS.t1666 VSS.t1665 sg13_lv_nmos ad=79.8f pd=0.8u as=0 ps=0 w=0.42u l=1u
X3522 VSS.t1844 VDD VSS.t1843 VSS.t1842 sg13_lv_nmos ad=0.1428p pd=1.52u as=0 ps=0 w=0.42u l=1u
X3523 VSS.t2773 VDD VSS.t2773 VSS.t392 sg13_lv_nmos ad=0.1428p pd=1.52u as=0 ps=0 w=0.42u l=1u
X3524 a_6682_13690# sg13g2_dlygate4sd3_1_0.A VSS.t11 VSS.t67 sg13_lv_nmos ad=0.1428p pd=1.52u as=79.8f ps=0.8u w=0.42u l=0.13u
X3525 VDD VSS.t2825 VDD VDD sg13_lv_pmos ad=0.19p pd=1.38u as=0 ps=0 w=1u l=1u
X3526 VSS.t609 VDD VSS.t608 VSS.t9 sg13_lv_nmos ad=0.1428p pd=1.52u as=0 ps=0 w=0.42u l=1u
X3527 VSS.t2869 VDD VSS.t2870 VSS.t392 sg13_lv_nmos ad=79.8f pd=0.8u as=0 ps=0 w=0.42u l=1u
X3528 VSS.t2056 VDD VSS.t2055 VSS.t2054 sg13_lv_nmos ad=0.1428p pd=1.52u as=0 ps=0 w=0.42u l=1u
X3529 VDD VSS.t545 VDD VDD sg13_lv_pmos ad=0.34p pd=2.68u as=0 ps=0 w=1u l=1u
X3530 VDD VSS.t595 VDD VDD sg13_lv_pmos ad=0.19p pd=1.38u as=0 ps=0 w=1u l=1u
X3531 VDD VSS.t1616 VDD VDD sg13_lv_pmos ad=0.19p pd=1.38u as=0 ps=0 w=1u l=1u
X3532 VDD VSS.t3082 VDD VDD sg13_lv_pmos ad=0.34p pd=2.68u as=0 ps=0 w=1u l=1u
X3533 VDD a_19438_13726# sg13g2_buf_16_2.X VDD sg13_lv_pmos ad=0.2128p pd=1.5u as=0.2128p ps=1.5u w=1.12u l=0.13u
X3534 VDD VSS.t1377 VDD VDD sg13_lv_pmos ad=0.19p pd=1.38u as=0 ps=0 w=1u l=1u
X3535 VSS.t1839 VDD VSS.t1838 VSS.t1837 sg13_lv_nmos ad=0.1428p pd=1.52u as=0 ps=0 w=0.42u l=1u
X3536 VSS.t2588 VDD VSS.t2590 VSS.t2589 sg13_lv_nmos ad=79.8f pd=0.8u as=0 ps=0 w=0.42u l=1u
X3537 VDD VSS.t902 VDD VDD sg13_lv_pmos ad=0.34p pd=2.68u as=0 ps=0 w=1u l=1u
X3538 VSS.t1448 VDD VSS.t1449 VSS.t311 sg13_lv_nmos ad=79.8f pd=0.8u as=0 ps=0 w=0.42u l=1u
X3539 VDD VSS.t2565 VDD VDD sg13_lv_pmos ad=0.19p pd=1.38u as=0 ps=0 w=1u l=1u
X3540 VSS.t859 VDD VSS.t861 VSS.t860 sg13_lv_nmos ad=79.8f pd=0.8u as=0 ps=0 w=0.42u l=1u
X3541 VDD VSS.t1440 VDD VDD sg13_lv_pmos ad=0.34p pd=2.68u as=0 ps=0 w=1u l=1u
X3542 VDD VSS.t3095 VDD VDD sg13_lv_pmos ad=0.19p pd=1.38u as=0 ps=0 w=1u l=1u
X3543 VSS.t2171 VDD VSS.t2173 VSS.t2172 sg13_lv_nmos ad=79.8f pd=0.8u as=0 ps=0 w=0.42u l=1u
X3544 VSS.t176 a_27664_13942# a_27313_13799# VSS.t350 sg13_lv_nmos ad=79.8f pd=0.8u as=0.1428p ps=1.52u w=0.42u l=0.13u
X3545 VSS.t1814 VDD VSS.t1816 VSS.t1815 sg13_lv_nmos ad=79.8f pd=0.8u as=0 ps=0 w=0.42u l=1u
X3546 VDD VSS.t2095 VDD VDD sg13_lv_pmos ad=0.34p pd=2.68u as=0 ps=0 w=1u l=1u
X3547 VSS.t184 VDD VSS.t640 VSS.t639 sg13_lv_nmos ad=0.1428p pd=1.52u as=0 ps=0 w=0.42u l=1u
X3548 VDD VSS.t360 VDD VDD sg13_lv_pmos ad=0.34p pd=2.68u as=0 ps=0 w=1u l=1u
X3549 VDD VSS.t604 VDD VDD sg13_lv_pmos ad=0.19p pd=1.38u as=0 ps=0 w=1u l=1u
X3550 VDD VSS.t1318 VDD VDD sg13_lv_pmos ad=0.19p pd=1.38u as=0 ps=0 w=1u l=1u
X3551 VSS.t2797 VDD VSS.t2797 VSS.t392 sg13_lv_nmos ad=0.1428p pd=1.52u as=0 ps=0 w=0.42u l=1u
X3552 VDD VSS.t1778 VDD VDD sg13_lv_pmos ad=0.34p pd=2.68u as=0 ps=0 w=1u l=1u
X3553 a_25094_15238# a_24824_15238# VDD VDD sg13_lv_pmos ad=0.34p pd=2.68u as=0.1523p ps=1.38u w=1u l=0.5u
X3554 VSS.t62 a_15022_14484# sg13g2_buf_16_2.A VSS.t140 sg13_lv_nmos ad=0.1406p pd=1.12u as=0.1406p ps=1.12u w=0.74u l=0.13u
X3555 a_6714_12972# sg13g2_xnor2_1_2.B sg13g2_dlygate4sd3_1_0.A VDD sg13_lv_pmos ad=0.1428p pd=1.375u as=0.2408p ps=1.55u w=1.12u l=0.13u
X3556 VDD VSS.t1386 VDD VDD sg13_lv_pmos ad=0.19p pd=1.38u as=0 ps=0 w=1u l=1u
X3557 VDD VSS.t1833 VDD VDD sg13_lv_pmos ad=0.34p pd=2.68u as=0 ps=0 w=1u l=1u
X3558 VDD VSS.t1990 VDD VDD sg13_lv_pmos ad=0.34p pd=2.68u as=0 ps=0 w=1u l=1u
X3559 VSS.t1684 VDD VSS.t1686 VSS.t1685 sg13_lv_nmos ad=79.8f pd=0.8u as=0 ps=0 w=0.42u l=1u
X3560 VSS.t3208 VDD VSS.t3210 VSS.t3209 sg13_lv_nmos ad=79.8f pd=0.8u as=0 ps=0 w=0.42u l=1u
X3561 VSS.t2418 VDD VSS.t2420 VSS.t2419 sg13_lv_nmos ad=79.8f pd=0.8u as=0 ps=0 w=0.42u l=1u
X3562 a_6575_13342# sg13g2_xnor2_1_2.A VSS.t11 VSS.t74 sg13_lv_nmos ad=0.2516p pd=2.16u as=0.1898p ps=1.36u w=0.74u l=0.13u
X3563 a_26244_14909# a_26475_14495# a_25930_14452# VSS.t8 sg13_lv_nmos ad=0.2373p pd=1.97u as=79.8f ps=0.8u w=0.42u l=0.13u
X3564 VDD VSS.t2901 VDD VDD sg13_lv_pmos ad=0.34p pd=2.68u as=0 ps=0 w=1u l=1u
X3565 VSS.t988 VDD VSS.t990 VSS.t989 sg13_lv_nmos ad=79.8f pd=0.8u as=0 ps=0 w=0.42u l=1u
X3566 VDD VSS.t2522 VDD VDD sg13_lv_pmos ad=0.34p pd=2.68u as=0 ps=0 w=1u l=1u
X3567 a_25670_14922# sg13g2_dfrbpq_1_7.D VDD VDD sg13_lv_pmos ad=79.8f pd=0.8u as=0.1428p ps=1.52u w=0.42u l=0.13u
X3568 VDD VSS.t1057 VDD VDD sg13_lv_pmos ad=0.34p pd=2.68u as=0 ps=0 w=1u l=1u
X3569 VSS.t1432 VDD VSS.t1431 VSS.t311 sg13_lv_nmos ad=0.1428p pd=1.52u as=0 ps=0 w=0.42u l=1u
X3570 VDD VSS.t43 VDD VDD sg13_lv_pmos ad=0.34p pd=2.68u as=0 ps=0 w=1u l=1u
X3571 VSS.t2001 VDD VSS.t2000 VSS.t1999 sg13_lv_nmos ad=0.1428p pd=1.52u as=0 ps=0 w=0.42u l=1u
X3572 VDD VSS.t2757 VDD VDD sg13_lv_pmos ad=0.34p pd=2.68u as=0 ps=0 w=1u l=1u
X3573 a_24169_14508# sg13g2_or3_1_2.B VSS.t266 VSS.t25 sg13_lv_nmos ad=0.198p pd=1.27u as=0.1045p ps=0.93u w=0.55u l=0.13u
X3574 VDD VSS.t1350 VDD VDD sg13_lv_pmos ad=0.19p pd=1.38u as=0 ps=0 w=1u l=1u
X3575 VDD VSS.t2854 VDD VDD sg13_lv_pmos ad=0.19p pd=1.38u as=0 ps=0 w=1u l=1u
X3576 VDD VSS.t2128 VDD VDD sg13_lv_pmos ad=0.19p pd=1.38u as=0 ps=0 w=1u l=1u
X3577 VSS.t164 VDD VSS.t164 VSS.t850 sg13_lv_nmos ad=0.1428p pd=1.52u as=0 ps=0 w=0.42u l=1u
X3578 VDD VSS.t2482 VDD VDD sg13_lv_pmos ad=0.34p pd=2.68u as=0 ps=0 w=1u l=1u
X3579 VSS.t2543 VDD VSS.t2542 VSS.t2541 sg13_lv_nmos ad=0.1428p pd=1.52u as=0 ps=0 w=0.42u l=1u
X3580 VDD VSS.t702 VDD VDD sg13_lv_pmos ad=0.34p pd=2.68u as=0 ps=0 w=1u l=1u
X3581 VDD VSS.t995 VDD VDD sg13_lv_pmos ad=0.19p pd=1.38u as=0 ps=0 w=1u l=1u
X3582 VDD VSS.t1628 VDD VDD sg13_lv_pmos ad=0.34p pd=2.68u as=0 ps=0 w=1u l=1u
X3583 VSS.t1799 VDD VSS.t1801 VSS.t1800 sg13_lv_nmos ad=79.8f pd=0.8u as=0 ps=0 w=0.42u l=1u
X3584 VSS.t1163 VDD VSS.t1162 VSS.t1161 sg13_lv_nmos ad=0.1428p pd=1.52u as=0 ps=0 w=0.42u l=1u
X3585 VSS.t1709 VDD VSS.t1708 VSS.t1707 sg13_lv_nmos ad=0.1428p pd=1.52u as=0 ps=0 w=0.42u l=1u
X3586 VDD VSS.t1811 VDD VDD sg13_lv_pmos ad=0.19p pd=1.38u as=0 ps=0 w=1u l=1u
X3587 VDD VSS.t681 VDD VDD sg13_lv_pmos ad=0.19p pd=1.38u as=0 ps=0 w=1u l=1u
X3588 VDD VSS.t751 VDD VDD sg13_lv_pmos ad=0.34p pd=2.68u as=0 ps=0 w=1u l=1u
X3589 a_6996_13320# sg13g2_xnor2_1_2.B a_6540_13238# VSS.t41 sg13_lv_nmos ad=78.39999f pd=0.885u as=0.2176p ps=1.96u w=0.64u l=0.13u
X3590 VDD VSS.t957 VDD VDD sg13_lv_pmos ad=0.34p pd=2.68u as=0 ps=0 w=1u l=1u
X3591 sg13g2_buf_1_0.X a_1192_3900# VSS.t393 VSS.t392 sg13_lv_nmos ad=0.2886p pd=2.26u as=0.14875p ps=1.16u w=0.74u l=0.13u
X3592 VSS.t742 VDD VSS.t745 VSS.t873 sg13_lv_nmos ad=79.8f pd=0.8u as=0 ps=0 w=0.42u l=1u
X3593 VSS.t2608 VDD VSS.t2610 VSS.t2609 sg13_lv_nmos ad=79.8f pd=0.8u as=0 ps=0 w=0.42u l=1u
X3594 VDD VSS.t707 VDD VDD sg13_lv_pmos ad=0.19p pd=1.38u as=0 ps=0 w=1u l=1u
X3595 VDD VSS.t3142 VDD VDD sg13_lv_pmos ad=0.34p pd=2.68u as=0 ps=0 w=1u l=1u
X3596 VDD VSS.t2010 VDD VDD sg13_lv_pmos ad=0.34p pd=2.68u as=0 ps=0 w=1u l=1u
X3597 VDD VSS.t2183 VDD VDD sg13_lv_pmos ad=0.19p pd=1.38u as=0 ps=0 w=1u l=1u
X3598 VSS.t1829 VDD VSS.t1828 VSS.t1827 sg13_lv_nmos ad=0.1428p pd=1.52u as=0 ps=0 w=0.42u l=1u
X3599 VDD VSS.t1681 VDD VDD sg13_lv_pmos ad=0.19p pd=1.38u as=0 ps=0 w=1u l=1u
X3600 VSS.t2765 VDD VSS.t2765 VSS.t392 sg13_lv_nmos ad=0.1428p pd=1.52u as=0 ps=0 w=0.42u l=1u
X3601 VDD VSS.t2817 VDD VDD sg13_lv_pmos ad=0.19p pd=1.38u as=0 ps=0 w=1u l=1u
X3602 VSS.t105 a_8582_15238# a_8694_15302# VSS.t104 sg13_lv_nmos ad=0.1426p pd=1.16u as=0.1428p ps=1.52u w=0.42u l=0.5u
X3603 VDD VSS.t1010 VDD VDD sg13_lv_pmos ad=0.19p pd=1.38u as=0 ps=0 w=1u l=1u
X3604 VSS.t3128 VDD VSS.t3127 VSS.t3126 sg13_lv_nmos ad=0.1428p pd=1.52u as=0 ps=0 w=0.42u l=1u
X3605 VSS.t1629 VDD VSS.t1631 VSS.t1630 sg13_lv_nmos ad=79.8f pd=0.8u as=0 ps=0 w=0.42u l=1u
X3606 VSS.t903 VDD VSS.t905 VSS.t904 sg13_lv_nmos ad=79.8f pd=0.8u as=0 ps=0 w=0.42u l=1u
X3607 a_18552_15552# sg13g2_xnor2_1_1.A VDD VDD sg13_lv_pmos ad=0.2128p pd=1.5u as=0.3808p ps=2.92u w=1.12u l=0.15u
X3608 VSS.t751 VDD VSS.t754 VSS.t879 sg13_lv_nmos ad=79.8f pd=0.8u as=0 ps=0 w=0.42u l=1u
X3609 VDD VSS.t2148 VDD VDD sg13_lv_pmos ad=0.19p pd=1.38u as=0 ps=0 w=1u l=1u
X3610 VDD VSS.t768 VDD VDD sg13_lv_pmos ad=0.34p pd=2.68u as=0 ps=0 w=1u l=1u
X3611 VDD VSS.t947 VDD VDD sg13_lv_pmos ad=0.34p pd=2.68u as=0 ps=0 w=1u l=1u
X3612 VSS.t1367 VDD VSS.t1366 VSS.t311 sg13_lv_nmos ad=0.1428p pd=1.52u as=0 ps=0 w=0.42u l=1u
X3613 VDD VSS.t3257 VDD VDD sg13_lv_pmos ad=0.34p pd=2.68u as=0 ps=0 w=1u l=1u
X3614 VSS.t2764 VDD VSS.t2763 VSS.t392 sg13_lv_nmos ad=0.1428p pd=1.52u as=0 ps=0 w=0.42u l=1u
X3615 a_9158_15234# a_9963_15356# a_9418_15457# VDD sg13_lv_pmos ad=0.1428p pd=1.52u as=79.8f ps=0.8u w=0.42u l=0.13u
X3616 VSS.t58 sg13g2_dfrbpq_1_1.RESET_B a_6180_14922# VSS.t69 sg13_lv_nmos ad=0.1626p pd=1.415u as=60.89999f ps=0.71u w=0.42u l=0.13u
X3617 sg13g2_o21ai_1_2.Y sg13g2_o21ai_1_2.A2 a_23736_14464# VDD sg13_lv_pmos ad=0.2128p pd=1.5u as=0.2128p ps=1.5u w=1.12u l=0.15u
X3618 VDD VSS.t1831 VDD VDD sg13_lv_pmos ad=0.19p pd=1.38u as=0 ps=0 w=1u l=1u
X3619 VDD VSS.t2175 VDD VDD sg13_lv_pmos ad=0.34p pd=2.68u as=0 ps=0 w=1u l=1u
X3620 VDD a_17327_13799# a_17994_14020# VDD sg13_lv_pmos ad=0.2128p pd=1.5u as=0.3864p ps=2.93u w=1.12u l=0.13u
X3621 VSS.t681 VDD VSS.t693 VSS.t692 sg13_lv_nmos ad=79.8f pd=0.8u as=0 ps=0 w=0.42u l=1u
X3622 VSS.t1295 VDD VSS.t1294 VSS.t311 sg13_lv_nmos ad=0.1428p pd=1.52u as=0 ps=0 w=0.42u l=1u
X3623 VSS.t378 a_17900_15960# counter_value_o[3] VSS.t377 sg13_lv_nmos ad=0.14875p pd=1.16u as=0.2886p ps=2.26u w=0.74u l=0.13u
X3624 VSS.t1480 VDD VSS.t1326 VSS.t311 sg13_lv_nmos ad=79.8f pd=0.8u as=0 ps=0 w=0.42u l=1u
X3625 a_23858_15242# sg13g2_dfrbpq_1_2.Q VSS.t265 VSS.t24 sg13_lv_nmos ad=0.1406p pd=1.12u as=0.2516p ps=2.16u w=0.74u l=0.13u
X3626 VSS.t918 VDD VSS.t920 VSS.t919 sg13_lv_nmos ad=79.8f pd=0.8u as=0 ps=0 w=0.42u l=1u
X3627 VSS.t1669 VDD VSS.t1671 VSS.t1670 sg13_lv_nmos ad=79.8f pd=0.8u as=0 ps=0 w=0.42u l=1u
X3628 VSS.t1849 VDD VSS.t1848 VSS.t1847 sg13_lv_nmos ad=0.1428p pd=1.52u as=0 ps=0 w=0.42u l=1u
X3629 VSS.t3193 VDD VSS.t3195 VSS.t3194 sg13_lv_nmos ad=79.8f pd=0.8u as=0 ps=0 w=0.42u l=1u
X3630 VSS.t2563 VDD VSS.t2562 VSS.t2561 sg13_lv_nmos ad=0.1428p pd=1.52u as=0 ps=0 w=0.42u l=1u
X3631 VSS.t2403 VDD VSS.t2405 VSS.t2404 sg13_lv_nmos ad=79.8f pd=0.8u as=0 ps=0 w=0.42u l=1u
X3632 VDD VSS.t355 VDD VDD sg13_lv_pmos ad=0.34p pd=2.68u as=0 ps=0 w=1u l=1u
X3633 a_7643_15280# sg13g2_dlygate4sd3_1_8.X VSS.t39 VSS.t127 sg13_lv_nmos ad=78.39999f pd=0.885u as=0.2272p ps=1.99u w=0.64u l=0.13u
X3634 VSS.t246 a_27898_15202# a_27617_15424# VSS.t9 sg13_lv_nmos ad=79.8f pd=0.8u as=0.1428p ps=1.52u w=0.42u l=0.5u
X3635 VDD VSS.t592 VDD VDD sg13_lv_pmos ad=0.19p pd=1.38u as=0 ps=0 w=1u l=1u
X3636 VDD VSS.t1175 VDD VDD sg13_lv_pmos ad=0.19p pd=1.38u as=0 ps=0 w=1u l=1u
X3637 VSS.t988 VDD VSS.t990 VSS.t989 sg13_lv_nmos ad=79.8f pd=0.8u as=0 ps=0 w=0.42u l=1u
X3638 VDD VSS.t977 VDD VDD sg13_lv_pmos ad=0.34p pd=2.68u as=0 ps=0 w=1u l=1u
X3639 VSS.t3148 VDD VSS.t3147 VSS.t3146 sg13_lv_nmos ad=0.1428p pd=1.52u as=0 ps=0 w=0.42u l=1u
X3640 VDD VSS.t2809 VDD VDD sg13_lv_pmos ad=0.19p pd=1.38u as=0 ps=0 w=1u l=1u
X3641 VSS.t2061 VDD VSS.t2060 VSS.t2059 sg13_lv_nmos ad=0.1428p pd=1.52u as=0 ps=0 w=0.42u l=1u
X3642 VDD VSS.t3087 VDD VDD sg13_lv_pmos ad=0.34p pd=2.68u as=0 ps=0 w=1u l=1u
X3643 VDD VSS.t2507 VDD VDD sg13_lv_pmos ad=0.34p pd=2.68u as=0 ps=0 w=1u l=1u
X3644 VSS.t245 VDD VSS.t245 VSS.t562 sg13_lv_nmos ad=79.8f pd=0.8u as=0 ps=0 w=0.42u l=1u
X3645 a_18874_13690# sg13g2_dfrbpq_1_2.Q VSS.t338 VSS.t434 sg13_lv_nmos ad=0.1428p pd=1.52u as=79.8f ps=0.8u w=0.42u l=0.13u
X3646 VSS.t824 VDD VSS.t430 VSS.t823 sg13_lv_nmos ad=0.1428p pd=1.52u as=0 ps=0 w=0.42u l=1u
X3647 VDD VSS.t307 VDD VDD sg13_lv_pmos ad=0.19p pd=1.38u as=0 ps=0 w=1u l=1u
X3648 VSS.t2593 VDD VSS.t2595 VSS.t2594 sg13_lv_nmos ad=79.8f pd=0.8u as=0 ps=0 w=0.42u l=1u
X3649 VDD VSS.t1626 VDD VDD sg13_lv_pmos ad=0.19p pd=1.38u as=0 ps=0 w=1u l=1u
X3650 VDD VSS.t2535 VDD VDD sg13_lv_pmos ad=0.19p pd=1.38u as=0 ps=0 w=1u l=1u
X3651 VSS.t466 VDD VSS.t466 VSS.t469 sg13_lv_nmos ad=79.8f pd=0.8u as=0 ps=0 w=0.42u l=1u
X3652 a_19438_13726# sg13g2_buf_16_2.A VSS.t317 VSS.t409 sg13_lv_nmos ad=0.1406p pd=1.12u as=0.1406p ps=1.12u w=0.74u l=0.13u
X3653 a_25956_14488# a_26475_14495# a_27215_14845# VSS.t9 sg13_lv_nmos ad=0.3473p pd=2.71u as=0.12665p ps=1.145u w=0.74u l=0.13u
X3654 VSS.t712 VDD VSS.t712 VSS.t713 sg13_lv_nmos ad=0.1428p pd=1.52u as=0 ps=0 w=0.42u l=1u
X3655 VDD VSS.t1339 VDD VDD sg13_lv_pmos ad=0.19p pd=1.38u as=0 ps=0 w=1u l=1u
X3656 VDD VSS.t1443 VDD VDD sg13_lv_pmos ad=0.34p pd=2.68u as=0 ps=0 w=1u l=1u
X3657 sg13g2_nand3_1_0.Y sg13g2_dlygate4sd3_1_3.A VDD VDD sg13_lv_pmos ad=0.2128p pd=1.5u as=0.3808p ps=2.92u w=1.12u l=0.13u
X3658 VDD VSS.t702 VDD VDD sg13_lv_pmos ad=0.34p pd=2.68u as=0 ps=0 w=1u l=1u
X3659 VDD VSS.t1040 VDD VDD sg13_lv_pmos ad=0.19p pd=1.38u as=0 ps=0 w=1u l=1u
X3660 VSS.t1304 VDD VSS.t1303 VSS.t311 sg13_lv_nmos ad=0.1428p pd=1.52u as=0 ps=0 w=0.42u l=1u
X3661 VSS.t1411 VDD VSS.t1412 VSS.t311 sg13_lv_nmos ad=79.8f pd=0.8u as=0 ps=0 w=0.42u l=1u
X3662 VSS.t1343 VDD VSS.t1344 VSS.t311 sg13_lv_nmos ad=79.8f pd=0.8u as=0 ps=0 w=0.42u l=1u
X3663 VSS.t1759 VDD VSS.t1761 VSS.t1760 sg13_lv_nmos ad=79.8f pd=0.8u as=0 ps=0 w=0.42u l=1u
X3664 VSS.t2141 VDD VSS.t2143 VSS.t2142 sg13_lv_nmos ad=79.8f pd=0.8u as=0 ps=0 w=0.42u l=1u
X3665 VDD VSS.t2820 VDD VDD sg13_lv_pmos ad=0.34p pd=2.68u as=0 ps=0 w=1u l=1u
X3666 VDD VSS.t681 VDD VDD sg13_lv_pmos ad=0.19p pd=1.38u as=0 ps=0 w=1u l=1u
X3667 VDD VSS.t1435 VDD VDD sg13_lv_pmos ad=0.19p pd=1.38u as=0 ps=0 w=1u l=1u
X3668 VSS.t1644 VDD VSS.t1643 VSS.t1642 sg13_lv_nmos ad=0.1428p pd=1.52u as=0 ps=0 w=0.42u l=1u
X3669 a_15876_13722# sg13g2_dfrbpq_1_2.D a_15782_13722# VSS.t50 sg13_lv_nmos ad=60.89999f pd=0.71u as=0.1428p ps=1.52u w=0.42u l=0.13u
X3670 VSS.t774 VDD VSS.t774 VSS.t775 sg13_lv_nmos ad=79.8f pd=0.8u as=0 ps=0 w=0.42u l=1u
X3671 VDD a_18106_15202# a_17825_15424# VDD sg13_lv_pmos ad=0.1523p pd=1.38u as=0.34p ps=2.68u w=1u l=0.5u
X3672 VSS.t1309 VDD VSS.t1308 VSS.t311 sg13_lv_nmos ad=0.1428p pd=1.52u as=0 ps=0 w=0.42u l=1u
X3673 VDD VSS.t2160 VDD VDD sg13_lv_pmos ad=0.34p pd=2.68u as=0 ps=0 w=1u l=1u
X3674 VSS.t1073 VDD VSS.t1075 VSS.t1074 sg13_lv_nmos ad=79.8f pd=0.8u as=0 ps=0 w=0.42u l=1u
X3675 VDD VSS.t1995 VDD VDD sg13_lv_pmos ad=0.34p pd=2.68u as=0 ps=0 w=1u l=1u
X3676 VDD VSS.t1803 VDD VDD sg13_lv_pmos ad=0.34p pd=2.68u as=0 ps=0 w=1u l=1u
X3677 VSS.t3178 VDD VSS.t3180 VSS.t3179 sg13_lv_nmos ad=79.8f pd=0.8u as=0 ps=0 w=0.42u l=1u
X3678 VSS.t2388 VDD VSS.t2390 VSS.t2389 sg13_lv_nmos ad=79.8f pd=0.8u as=0 ps=0 w=0.42u l=1u
X3679 VSS.t58 VDD VSS.t58 VSS.t634 sg13_lv_nmos ad=79.8f pd=0.8u as=0 ps=0 w=0.42u l=1u
X3680 VDD VSS.t1666 VDD VDD sg13_lv_pmos ad=0.19p pd=1.38u as=0 ps=0 w=1u l=1u
X3681 VDD VSS.t1843 VDD VDD sg13_lv_pmos ad=0.34p pd=2.68u as=0 ps=0 w=1u l=1u
X3682 VDD VSS.t2904 VDD VDD sg13_lv_pmos ad=0.34p pd=2.68u as=0 ps=0 w=1u l=1u
X3683 VSS.t2463 VDD VSS.t2465 VSS.t2464 sg13_lv_nmos ad=79.8f pd=0.8u as=0 ps=0 w=0.42u l=1u
X3684 VDD VSS.t2527 VDD VDD sg13_lv_pmos ad=0.34p pd=2.68u as=0 ps=0 w=1u l=1u
X3685 VSS.t903 VDD VSS.t905 VSS.t904 sg13_lv_nmos ad=79.8f pd=0.8u as=0 ps=0 w=0.42u l=1u
X3686 VSS.t1614 VDD VSS.t1616 VSS.t1615 sg13_lv_nmos ad=79.8f pd=0.8u as=0 ps=0 w=0.42u l=1u
X3687 VDD VSS.t2185 VDD VDD sg13_lv_pmos ad=0.34p pd=2.68u as=0 ps=0 w=1u l=1u
X3688 VDD a_16556_15960# sg13g2_or3_1_2.B VDD sg13_lv_pmos ad=0.2114p pd=1.54u as=0.42p ps=2.99u w=1.12u l=0.13u
X3689 a_9732_15247# a_9444_15552# a_9670_15247# VSS.t106 sg13_lv_nmos ad=0.1428p pd=1.52u as=37.8f ps=0.6u w=0.42u l=0.13u
X3690 VSS.t1394 VDD VSS.t1393 VSS.t311 sg13_lv_nmos ad=0.1428p pd=1.52u as=0 ps=0 w=0.42u l=1u
X3691 VDD VSS.t1353 VDD VDD sg13_lv_pmos ad=0.19p pd=1.38u as=0 ps=0 w=1u l=1u
X3692 VDD VSS.t2857 VDD VDD sg13_lv_pmos ad=0.19p pd=1.38u as=0 ps=0 w=1u l=1u
X3693 VDD VSS.t2133 VDD VDD sg13_lv_pmos ad=0.19p pd=1.38u as=0 ps=0 w=1u l=1u
X3694 a_17604_14488# a_17578_14452# VSS.t45 VSS.t119 sg13_lv_nmos ad=0.2516p pd=2.16u as=0.1626p ps=1.415u w=0.74u l=0.13u
X3695 VDD VSS.t625 VDD VDD sg13_lv_pmos ad=0.19p pd=1.38u as=0 ps=0 w=1u l=1u
X3696 a_19438_13726# sg13g2_buf_16_2.A VSS.t405 VSS.t404 sg13_lv_nmos ad=0.1406p pd=1.12u as=0.2516p ps=2.16u w=0.74u l=0.13u
X3697 VDD VSS.t2487 VDD VDD sg13_lv_pmos ad=0.34p pd=2.68u as=0 ps=0 w=1u l=1u
X3698 VSS.t2548 VDD VSS.t2547 VSS.t2546 sg13_lv_nmos ad=0.1428p pd=1.52u as=0 ps=0 w=0.42u l=1u
X3699 VDD VSS.t515 VDD VDD sg13_lv_pmos ad=0.34p pd=2.68u as=0 ps=0 w=1u l=1u
X3700 VDD VSS.t1633 VDD VDD sg13_lv_pmos ad=0.34p pd=2.68u as=0 ps=0 w=1u l=1u
X3701 VSS.t2756 VDD VSS.t2756 VSS.t392 sg13_lv_nmos ad=0.1428p pd=1.52u as=0 ps=0 w=0.42u l=1u
X3702 VSS.t754 VDD VSS.t751 VSS.t753 sg13_lv_nmos ad=0.1428p pd=1.52u as=0 ps=0 w=0.42u l=1u
X3703 VDD VSS.t481 VDD VDD sg13_lv_pmos ad=0.34p pd=2.68u as=0 ps=0 w=1u l=1u
X3704 a_22319_14845# a_21477_14495# a_22225_14845# VSS.t25 sg13_lv_nmos ad=0.12665p pd=1.145u as=0.1428p ps=1.52u w=0.42u l=0.13u
X3705 VSS.t1679 VDD VSS.t1678 VSS.t1677 sg13_lv_nmos ad=0.1428p pd=1.52u as=0 ps=0 w=0.42u l=1u
X3706 VDD VSS.t1816 VDD VDD sg13_lv_pmos ad=0.19p pd=1.38u as=0 ps=0 w=1u l=1u
X3707 VSS.t2096 VDD VSS.t2095 VSS.t2094 sg13_lv_nmos ad=0.1428p pd=1.52u as=0 ps=0 w=0.42u l=1u
X3708 VSS.t553 VDD VSS.t553 VSS.t554 sg13_lv_nmos ad=0.1428p pd=1.52u as=0 ps=0 w=0.42u l=1u
X3709 a_25774_15423# a_25889_15424# VSS.t5 VSS.t4 sg13_lv_nmos ad=0.1428p pd=1.52u as=0.1426p ps=1.16u w=0.42u l=0.5u
X3710 sg13g2_buf_16_2.A a_15022_14484# VDD VDD sg13_lv_pmos ad=0.2128p pd=1.5u as=0.2128p ps=1.5u w=1.12u l=0.13u
X3711 a_19282_14922# sg13g2_dfrbpq_1_3.RESET_B VSS.t45 VSS.t76 sg13_lv_nmos ad=37.8f pd=0.6u as=79.8f ps=0.8u w=0.42u l=0.13u
X3712 VSS.t1398 VDD VSS.t1398 VSS.t311 sg13_lv_nmos ad=0.1428p pd=1.52u as=0 ps=0 w=0.42u l=1u
X3713 VSS.t2613 VDD VSS.t2615 VSS.t2614 sg13_lv_nmos ad=79.8f pd=0.8u as=0 ps=0 w=0.42u l=1u
X3714 a_8582_15238# a_8312_15238# VDD VDD sg13_lv_pmos ad=0.34p pd=2.68u as=0.1523p ps=1.38u w=1u l=0.5u
X3715 VDD a_21827_13690# sg13g2_or3_1_2.X VDD sg13_lv_pmos ad=0.3822p pd=1.84u as=0.3808p ps=2.92u w=1.12u l=0.13u
X3716 VSS.t918 VDD VSS.t920 VSS.t919 sg13_lv_nmos ad=79.8f pd=0.8u as=0 ps=0 w=0.42u l=1u
X3717 VSS.t1429 VDD VSS.t1430 VSS.t311 sg13_lv_nmos ad=79.8f pd=0.8u as=0 ps=0 w=0.42u l=1u
X3718 VDD VSS.t1646 VDD VDD sg13_lv_pmos ad=0.19p pd=1.38u as=0 ps=0 w=1u l=1u
X3719 VDD VSS.t3112 VDD VDD sg13_lv_pmos ad=0.34p pd=2.68u as=0 ps=0 w=1u l=1u
X3720 VDD VSS.t1980 VDD VDD sg13_lv_pmos ad=0.34p pd=2.68u as=0 ps=0 w=1u l=1u
X3721 a_16079_15238# a_16044_15424# sg13g2_nor2_1_0.B VSS.t159 sg13_lv_nmos ad=0.1406p pd=1.12u as=0.2516p ps=2.16u w=0.74u l=0.13u
X3722 VDD a_4078_14751# sg13g2_xor2_1_0.B VDD sg13_lv_pmos ad=0.2254p pd=1.53u as=0.4256p ps=3u w=1.12u l=0.13u
X3723 VSS.t1834 VDD VSS.t1833 VSS.t1832 sg13_lv_nmos ad=0.1428p pd=1.52u as=0 ps=0 w=0.42u l=1u
X3724 VSS.t631 VDD VSS.t180 VSS.t632 sg13_lv_nmos ad=79.8f pd=0.8u as=0 ps=0 w=0.42u l=1u
X3725 VDD VSS.t2896 VDD VDD sg13_lv_pmos ad=0.34p pd=2.68u as=0 ps=0 w=1u l=1u
X3726 VDD VSS.t2800 VDD VDD sg13_lv_pmos ad=0.19p pd=1.38u as=0 ps=0 w=1u l=1u
X3727 VSS.t2046 VDD VSS.t2045 VSS.t2044 sg13_lv_nmos ad=0.1428p pd=1.52u as=0 ps=0 w=0.42u l=1u
X3728 VDD VSS.t3072 VDD VDD sg13_lv_pmos ad=0.34p pd=2.68u as=0 ps=0 w=1u l=1u
X3729 VSS.t3133 VDD VSS.t3132 VSS.t3131 sg13_lv_nmos ad=0.1428p pd=1.52u as=0 ps=0 w=0.42u l=1u
X3730 VSS.t681 VDD VSS.t681 VSS.t687 sg13_lv_nmos ad=0.1428p pd=1.52u as=0 ps=0 w=0.42u l=1u
X3731 VSS.t723 VDD VSS.t723 VSS.t846 sg13_lv_nmos ad=0.1428p pd=1.52u as=0 ps=0 w=0.42u l=1u
X3732 VDD VSS.t1032 VDD VDD sg13_lv_pmos ad=0.34p pd=2.68u as=0 ps=0 w=1u l=1u
X3733 sg13g2_o21ai_1_3.Y sg13g2_or3_1_1.A a_24310_15230# VSS.t24 sg13_lv_nmos ad=0.2516p pd=2.16u as=0.1406p ps=1.12u w=0.74u l=0.15u
X3734 VDD VSS.t1147 VDD VDD sg13_lv_pmos ad=0.34p pd=2.68u as=0 ps=0 w=1u l=1u
X3735 VDD VSS.t1299 VDD VDD sg13_lv_pmos ad=0.19p pd=1.38u as=0 ps=0 w=1u l=1u
X3736 VSS.t445 VDD VSS.t444 VSS.t443 sg13_lv_nmos ad=0.1428p pd=1.52u as=0 ps=0 w=0.42u l=1u
X3737 VSS.t612 VDD VSS.t613 VSS.t9 sg13_lv_nmos ad=79.8f pd=0.8u as=0 ps=0 w=0.42u l=1u
X3738 VDD VSS.t955 VDD VDD sg13_lv_pmos ad=0.19p pd=1.38u as=0 ps=0 w=1u l=1u
X3739 VSS.t1541 VDD VSS.t1407 VSS.t311 sg13_lv_nmos ad=0.1428p pd=1.52u as=0 ps=0 w=0.42u l=1u
X3740 VDD VSS.t1611 VDD VDD sg13_lv_pmos ad=0.19p pd=1.38u as=0 ps=0 w=1u l=1u
X3741 VDD VSS.t2520 VDD VDD sg13_lv_pmos ad=0.19p pd=1.38u as=0 ps=0 w=1u l=1u
X3742 VSS.t2578 VDD VSS.t2580 VSS.t2579 sg13_lv_nmos ad=79.8f pd=0.8u as=0 ps=0 w=0.42u l=1u
X3743 VDD sg13g2_dfrbpq_1_5.RESET_B a_26122_13945# VDD sg13_lv_pmos ad=0.1563p pd=1.22u as=0.147p ps=1.54u w=0.42u l=0.13u
X3744 VSS.t11 sg13g2_xnor2_1_2.A a_6996_13320# VSS.t73 sg13_lv_nmos ad=0.2272p pd=1.99u as=78.39999f ps=0.885u w=0.64u l=0.13u
X3745 VDD VSS.t2849 VDD VDD sg13_lv_pmos ad=0.19p pd=1.38u as=0 ps=0 w=1u l=1u
X3746 VSS.t2408 VDD VSS.t2410 VSS.t2409 sg13_lv_nmos ad=79.8f pd=0.8u as=0 ps=0 w=0.42u l=1u
X3747 VSS.t2533 VDD VSS.t2532 VSS.t2531 sg13_lv_nmos ad=0.1428p pd=1.52u as=0 ps=0 w=0.42u l=1u
X3748 VSS.t1744 VDD VSS.t1746 VSS.t1745 sg13_lv_nmos ad=79.8f pd=0.8u as=0 ps=0 w=0.42u l=1u
X3749 VSS.t2862 VDD VSS.t2863 VSS.t392 sg13_lv_nmos ad=79.8f pd=0.8u as=0 ps=0 w=0.42u l=1u
X3750 VSS.t164 sg13g2_or3_1_1.C a_24841_13726# VSS.t163 sg13_lv_nmos ad=0.1045p pd=0.93u as=0.187p ps=1.78u w=0.55u l=0.13u
X3751 VDD VSS.t176 VDD VDD sg13_lv_pmos ad=0.34p pd=2.68u as=0 ps=0 w=1u l=1u
X3752 VDD VSS.t907 VDD VDD sg13_lv_pmos ad=0.34p pd=2.68u as=0 ps=0 w=1u l=1u
X3753 VSS.t1629 VDD VSS.t1628 VSS.t1627 sg13_lv_nmos ad=0.1428p pd=1.52u as=0 ps=0 w=0.42u l=1u
X3754 VSS.t1699 VDD VSS.t1698 VSS.t1697 sg13_lv_nmos ad=0.1428p pd=1.52u as=0 ps=0 w=0.42u l=1u
X3755 VDD VSS.t1801 VDD VDD sg13_lv_pmos ad=0.19p pd=1.38u as=0 ps=0 w=1u l=1u
X3756 a_37484_15960# sg13g2_dfrbpq_1_5.Q VDD VDD sg13_lv_pmos ad=0.2856p pd=2.36u as=0.2114p ps=1.54u w=0.84u l=0.13u
X3757 VDD VSS.t1352 VDD VDD sg13_lv_pmos ad=0.34p pd=2.68u as=0 ps=0 w=1u l=1u
X3758 VSS.t1073 VDD VSS.t1075 VSS.t1074 sg13_lv_nmos ad=79.8f pd=0.8u as=0 ps=0 w=0.42u l=1u
X3759 VSS.t1571 VDD VSS.t1442 VSS.t311 sg13_lv_nmos ad=79.8f pd=0.8u as=0 ps=0 w=0.42u l=1u
X3760 VDD VSS.t712 VDD VDD sg13_lv_pmos ad=0.19p pd=1.38u as=0 ps=0 w=1u l=1u
X3761 VDD VSS.t1359 VDD VDD sg13_lv_pmos ad=0.34p pd=2.68u as=0 ps=0 w=1u l=1u
X3762 VDD VSS.t2863 VDD VDD sg13_lv_pmos ad=0.34p pd=2.68u as=0 ps=0 w=1u l=1u
X3763 VDD VSS.t2145 VDD VDD sg13_lv_pmos ad=0.34p pd=2.68u as=0 ps=0 w=1u l=1u
X3764 VSS.t491 VDD VSS.t490 VSS.t489 sg13_lv_nmos ad=0.1428p pd=1.52u as=0 ps=0 w=0.42u l=1u
X3765 VSS.t188 VDD VSS.t188 VSS.t642 sg13_lv_nmos ad=0.1428p pd=1.52u as=0 ps=0 w=0.42u l=1u
X3766 VSS.t2373 VDD VSS.t2375 VSS.t2374 sg13_lv_nmos ad=79.8f pd=0.8u as=0 ps=0 w=0.42u l=1u
X3767 VDD VSS.t768 VDD VDD sg13_lv_pmos ad=0.19p pd=1.38u as=0 ps=0 w=1u l=1u
X3768 VDD VSS.t1828 VDD VDD sg13_lv_pmos ad=0.34p pd=2.68u as=0 ps=0 w=1u l=1u
X3769 VSS.t2066 VDD VSS.t2065 VSS.t2064 sg13_lv_nmos ad=0.1428p pd=1.52u as=0 ps=0 w=0.42u l=1u
X3770 VDD VSS.t3057 VDD VDD sg13_lv_pmos ad=0.34p pd=2.68u as=0 ps=0 w=1u l=1u
X3771 VDD sg13g2_dlygate4sd3_1_12.X a_24923_15996# VDD sg13_lv_pmos ad=0.2128p pd=1.5u as=0.2128p ps=1.5u w=1.12u l=0.13u
X3772 VSS.t13 sg13g2_buf_16_2.A a_12020_15202# VSS.t403 sg13_lv_nmos ad=0.2516p pd=2.16u as=0.1406p ps=1.12u w=0.74u l=0.13u
X3773 VDD VSS.t1389 VDD VDD sg13_lv_pmos ad=0.19p pd=1.38u as=0 ps=0 w=1u l=1u
X3774 VSS.t2628 VDD VSS.t2627 VSS.t2626 sg13_lv_nmos ad=0.1428p pd=1.52u as=0 ps=0 w=0.42u l=1u
X3775 VSS.t2448 VDD VSS.t2450 VSS.t2449 sg13_lv_nmos ad=79.8f pd=0.8u as=0 ps=0 w=0.42u l=1u
X3776 VDD VSS.t2512 VDD VDD sg13_lv_pmos ad=0.34p pd=2.68u as=0 ps=0 w=1u l=1u
X3777 VDD VSS.t922 VDD VDD sg13_lv_pmos ad=0.34p pd=2.68u as=0 ps=0 w=1u l=1u
X3778 VDD VSS.t1110 VDD VDD sg13_lv_pmos ad=0.19p pd=1.38u as=0 ps=0 w=1u l=1u
X3779 VDD VSS.t1693 VDD VDD sg13_lv_pmos ad=0.34p pd=2.68u as=0 ps=0 w=1u l=1u
X3780 VDD VSS.t1631 VDD VDD sg13_lv_pmos ad=0.19p pd=1.38u as=0 ps=0 w=1u l=1u
X3781 VDD VSS.t2540 VDD VDD sg13_lv_pmos ad=0.19p pd=1.38u as=0 ps=0 w=1u l=1u
X3782 VSS.t993 VDD VSS.t995 VSS.t994 sg13_lv_nmos ad=79.8f pd=0.8u as=0 ps=0 w=0.42u l=1u
X3783 VDD VSS.t2826 VDD VDD sg13_lv_pmos ad=0.34p pd=2.68u as=0 ps=0 w=1u l=1u
X3784 VSS.t1729 VDD VSS.t1731 VSS.t1730 sg13_lv_nmos ad=79.8f pd=0.8u as=0 ps=0 w=0.42u l=1u
X3785 VSS.t2146 VDD VSS.t2148 VSS.t2147 sg13_lv_nmos ad=79.8f pd=0.8u as=0 ps=0 w=0.42u l=1u
X3786 a_6372_14488# a_6346_14452# VDD VDD sg13_lv_pmos ad=0.34p pd=2.68u as=0.36237p ps=2.605u w=1u l=0.13u
X3787 VDD VSS.t471 VDD VDD sg13_lv_pmos ad=0.19p pd=1.38u as=0 ps=0 w=1u l=1u
X3788 VSS.t1425 VDD VSS.t1424 VSS.t311 sg13_lv_nmos ad=0.1428p pd=1.52u as=0 ps=0 w=0.42u l=1u
X3789 a_4432_15454# sg13g2_dfrbpq_1_0.RESET_B VDD VDD sg13_lv_pmos ad=79.8f pd=0.8u as=2.8961p ps=18.25u w=0.42u l=0.13u
X3790 VDD sg13g2_dfrbpq_1_7.RESET_B a_25930_14452# VDD sg13_lv_pmos ad=0.1563p pd=1.22u as=0.147p ps=1.54u w=0.42u l=0.13u
X3791 VDD VSS.t2567 VDD VDD sg13_lv_pmos ad=0.34p pd=2.68u as=0 ps=0 w=1u l=1u
X3792 sg13g2_dfrbpq_1_2.CLK a_12020_15202# VDD VDD sg13_lv_pmos ad=0.2128p pd=1.5u as=0.2128p ps=1.5u w=1.12u l=0.13u
X3793 VSS.t2598 VDD VSS.t2600 VSS.t2599 sg13_lv_nmos ad=79.8f pd=0.8u as=0 ps=0 w=0.42u l=1u
X3794 VDD VSS.t3097 VDD VDD sg13_lv_pmos ad=0.34p pd=2.68u as=0 ps=0 w=1u l=1u
X3795 VSS.t1347 VDD VSS.t1346 VSS.t311 sg13_lv_nmos ad=0.1428p pd=1.52u as=0 ps=0 w=0.42u l=1u
X3796 VDD VSS.t1808 VDD VDD sg13_lv_pmos ad=0.34p pd=2.68u as=0 ps=0 w=1u l=1u
X3797 VSS.t1659 VDD VSS.t1661 VSS.t1660 sg13_lv_nmos ad=79.8f pd=0.8u as=0 ps=0 w=0.42u l=1u
X3798 VSS.t3183 VDD VSS.t3185 VSS.t3184 sg13_lv_nmos ad=79.8f pd=0.8u as=0 ps=0 w=0.42u l=1u
X3799 VSS.t2393 VDD VSS.t2395 VSS.t2394 sg13_lv_nmos ad=79.8f pd=0.8u as=0 ps=0 w=0.42u l=1u
X3800 VSS.t2176 VDD VSS.t2175 VSS.t2174 sg13_lv_nmos ad=0.1428p pd=1.52u as=0 ps=0 w=0.42u l=1u
X3801 a_22576_14726# a_22319_14845# a_22738_14922# VSS.t25 sg13_lv_nmos ad=0.1428p pd=1.52u as=37.8f ps=0.6u w=0.42u l=0.13u
X3802 VDD VSS.t745 VDD VDD sg13_lv_pmos ad=0.34p pd=2.68u as=0 ps=0 w=1u l=1u
X3803 VSS.t1008 VDD VSS.t1010 VSS.t1009 sg13_lv_nmos ad=79.8f pd=0.8u as=0 ps=0 w=0.42u l=1u
X3804 VDD VSS.t1368 VDD VDD sg13_lv_pmos ad=0.34p pd=2.68u as=0 ps=0 w=1u l=1u
X3805 VDD VSS.t1671 VDD VDD sg13_lv_pmos ad=0.19p pd=1.38u as=0 ps=0 w=1u l=1u
X3806 VDD VSS.t2888 VDD VDD sg13_lv_pmos ad=0.34p pd=2.68u as=0 ps=0 w=1u l=1u
X3807 VSS.t723 VDD VSS.t723 VSS.t722 sg13_lv_nmos ad=0.1428p pd=1.52u as=0 ps=0 w=0.42u l=1u
X3808 VDD VSS.t1077 VDD VDD sg13_lv_pmos ad=0.34p pd=2.68u as=0 ps=0 w=1u l=1u
X3809 VSS.t2468 VDD VSS.t2470 VSS.t2469 sg13_lv_nmos ad=79.8f pd=0.8u as=0 ps=0 w=0.42u l=1u
X3810 VSS.t188 a_12020_15202# sg13g2_dfrbpq_1_2.CLK VSS.t190 sg13_lv_nmos ad=0.1406p pd=1.12u as=0.1406p ps=1.12u w=0.74u l=0.13u
X3811 VSS.t948 VDD VSS.t947 VSS.t946 sg13_lv_nmos ad=0.1428p pd=1.52u as=0 ps=0 w=0.42u l=1u
X3812 VDD VSS.t2841 VDD VDD sg13_lv_pmos ad=0.19p pd=1.38u as=0 ps=0 w=1u l=1u
X3813 VSS.t2518 VDD VSS.t2517 VSS.t2516 sg13_lv_nmos ad=0.1428p pd=1.52u as=0 ps=0 w=0.42u l=1u
X3814 VDD VSS.t1638 VDD VDD sg13_lv_pmos ad=0.34p pd=2.68u as=0 ps=0 w=1u l=1u
X3815 VDD VSS.t681 VDD VDD sg13_lv_pmos ad=0.19p pd=1.38u as=0 ps=0 w=1u l=1u
X3816 VDD VSS.t754 VDD VDD sg13_lv_pmos ad=0.34p pd=2.68u as=0 ps=0 w=1u l=1u
X3817 VDD VSS.t1140 VDD VDD sg13_lv_pmos ad=0.19p pd=1.38u as=0 ps=0 w=1u l=1u
X3818 sg13g2_buf_16_2.X a_19438_13726# VDD VDD sg13_lv_pmos ad=0.2128p pd=1.5u as=0.2128p ps=1.5u w=1.12u l=0.13u
X3819 VSS.t1684 VDD VSS.t1683 VSS.t1682 sg13_lv_nmos ad=0.1428p pd=1.52u as=0 ps=0 w=0.42u l=1u
X3820 VSS.t2433 VDD VSS.t2435 VSS.t2434 sg13_lv_nmos ad=79.8f pd=0.8u as=0 ps=0 w=0.42u l=1u
X3821 VDD VSS.t2198 VDD VDD sg13_lv_pmos ad=0.19p pd=1.38u as=0 ps=0 w=1u l=1u
X3822 VSS.t597 VDD VSS.t598 VSS.t9 sg13_lv_nmos ad=79.8f pd=0.8u as=0 ps=0 w=0.42u l=1u
X3823 VDD VSS.t712 VDD VDD sg13_lv_pmos ad=0.19p pd=1.38u as=0 ps=0 w=1u l=1u
X3824 VDD VSS.t1643 VDD VDD sg13_lv_pmos ad=0.34p pd=2.68u as=0 ps=0 w=1u l=1u
X3825 VSS.t2830 VDD VSS.t2829 VSS.t392 sg13_lv_nmos ad=0.1428p pd=1.52u as=0 ps=0 w=0.42u l=1u
X3826 VDD VSS.t2552 VDD VDD sg13_lv_pmos ad=0.34p pd=2.68u as=0 ps=0 w=1u l=1u
X3827 VSS.t347 sg13g2_dlygate4sd3_1_4.X sg13g2_xnor2_1_1.A VSS.t431 sg13_lv_nmos ad=0.2516p pd=2.16u as=0.2516p ps=2.16u w=0.74u l=0.13u
X3828 VSS.t712 VDD VSS.t712 VSS.t713 sg13_lv_nmos ad=0.1428p pd=1.52u as=0 ps=0 w=0.42u l=1u
X3829 VSS.t2583 VDD VSS.t2585 VSS.t2584 sg13_lv_nmos ad=79.8f pd=0.8u as=0 ps=0 w=0.42u l=1u
X3830 VSS.t1323 VDD VSS.t1324 VSS.t311 sg13_lv_nmos ad=79.8f pd=0.8u as=0 ps=0 w=0.42u l=1u
X3831 VDD VSS.t3117 VDD VDD sg13_lv_pmos ad=0.34p pd=2.68u as=0 ps=0 w=1u l=1u
X3832 VDD VSS.t1985 VDD VDD sg13_lv_pmos ad=0.34p pd=2.68u as=0 ps=0 w=1u l=1u
X3833 sg13g2_dfrbpq_1_2.CLK a_12020_15202# VDD VDD sg13_lv_pmos ad=0.2128p pd=1.5u as=0.2128p ps=1.5u w=1.12u l=0.13u
X3834 VSS.t1508 VDD VSS.t1359 VSS.t311 sg13_lv_nmos ad=0.1428p pd=1.52u as=0 ps=0 w=0.42u l=1u
X3835 VDD VSS.t2500 VDD VDD sg13_lv_pmos ad=0.19p pd=1.38u as=0 ps=0 w=1u l=1u
X3836 VSS.t2161 VDD VSS.t2160 VSS.t2159 sg13_lv_nmos ad=0.1428p pd=1.52u as=0 ps=0 w=0.42u l=1u
X3837 VSS.t978 VDD VSS.t977 VSS.t976 sg13_lv_nmos ad=0.1428p pd=1.52u as=0 ps=0 w=0.42u l=1u
X3838 VDD VSS.t2158 VDD VDD sg13_lv_pmos ad=0.19p pd=1.38u as=0 ps=0 w=1u l=1u
X3839 VDD VSS.t1030 VDD VDD sg13_lv_pmos ad=0.19p pd=1.38u as=0 ps=0 w=1u l=1u
X3840 VSS.t1804 VDD VSS.t1803 VSS.t1802 sg13_lv_nmos ad=0.1428p pd=1.52u as=0 ps=0 w=0.42u l=1u
X3841 VSS.t2051 VDD VSS.t2050 VSS.t2049 sg13_lv_nmos ad=0.1428p pd=1.52u as=0 ps=0 w=0.42u l=1u
X3842 a_16556_15960# sg13g2_or3_1_1.B VSS.t347 VSS.t428 sg13_lv_nmos ad=0.187p pd=1.78u as=0.14875p ps=1.16u w=0.55u l=0.13u
X3843 a_9861_15213# sg13g2_dfrbpq_1_2.CLK VSS.t9 VSS.t93 sg13_lv_nmos ad=0.2516p pd=2.16u as=5.01922p ps=33.275u w=0.74u l=0.13u
X3844 VDD VSS.t1415 VDD VDD sg13_lv_pmos ad=0.19p pd=1.38u as=0 ps=0 w=1u l=1u
X3845 VSS.t3138 VDD VSS.t3137 VSS.t3136 sg13_lv_nmos ad=0.1428p pd=1.52u as=0 ps=0 w=0.42u l=1u
X3846 VSS.t751 VDD VSS.t751 VSS.t752 sg13_lv_nmos ad=79.8f pd=0.8u as=0 ps=0 w=0.42u l=1u
X3847 VDD VSS.t1155 VDD VDD sg13_lv_pmos ad=0.19p pd=1.38u as=0 ps=0 w=1u l=1u
X3848 VSS.t2613 VDD VSS.t2612 VSS.t2611 sg13_lv_nmos ad=0.1428p pd=1.52u as=0 ps=0 w=0.42u l=1u
X3849 VSS.t184 a_12020_15202# sg13g2_dfrbpq_1_2.CLK VSS.t185 sg13_lv_nmos ad=0.1406p pd=1.12u as=0.1406p ps=1.12u w=0.74u l=0.13u
X3850 VDD a_22576_14726# a_22521_14607# VDD sg13_lv_pmos ad=2.42015p pd=15.68u as=93.45f ps=0.865u w=0.42u l=0.13u
X3851 VDD VSS.t595 VDD VDD sg13_lv_pmos ad=0.19p pd=1.38u as=0 ps=0 w=1u l=1u
X3852 VSS.t993 VDD VSS.t995 VSS.t994 sg13_lv_nmos ad=79.8f pd=0.8u as=0 ps=0 w=0.42u l=1u
X3853 VDD VSS.t1616 VDD VDD sg13_lv_pmos ad=0.19p pd=1.38u as=0 ps=0 w=1u l=1u
X3854 VSS.t2898 VDD VSS.t2899 VSS.t392 sg13_lv_nmos ad=79.8f pd=0.8u as=0 ps=0 w=0.42u l=1u
X3855 VDD VSS.t2525 VDD VDD sg13_lv_pmos ad=0.19p pd=1.38u as=0 ps=0 w=1u l=1u
X3856 VSS.t1038 VDD VSS.t1040 VSS.t1039 sg13_lv_nmos ad=79.8f pd=0.8u as=0 ps=0 w=0.42u l=1u
X3857 VSS.t2413 VDD VSS.t2415 VSS.t2414 sg13_lv_nmos ad=79.8f pd=0.8u as=0 ps=0 w=0.42u l=1u
X3858 VDD VSS.t905 VDD VDD sg13_lv_pmos ad=0.19p pd=1.38u as=0 ps=0 w=1u l=1u
X3859 VSS.t347 a_17219_16265# sg13g2_a21oi_1_0.A2 VSS.t384 sg13_lv_nmos ad=0.13395p pd=1.12u as=0.2516p ps=2.16u w=0.74u l=0.13u
X3860 VSS.t1 VDD VSS.t648 VSS.t76 sg13_lv_nmos ad=0.1428p pd=1.52u as=0 ps=0 w=0.42u l=1u
X3861 VSS.t2131 VDD VSS.t2133 VSS.t2132 sg13_lv_nmos ad=79.8f pd=0.8u as=0 ps=0 w=0.42u l=1u
X3862 sg13g2_a21oi_1_3.A1 a_25206_15302# VDD VDD sg13_lv_pmos ad=0.4256p pd=3u as=0.2254p ps=1.53u w=1.12u l=0.13u
X3863 VDD VSS.t626 VDD VDD sg13_lv_pmos ad=0.34p pd=2.68u as=0 ps=0 w=1u l=1u
X3864 VSS.t2865 VDD VSS.t2865 VSS.t392 sg13_lv_nmos ad=79.8f pd=0.8u as=0 ps=0 w=0.42u l=1u
X3865 a_6086_14922# sg13g2_and2_1_1.X VDD VDD sg13_lv_pmos ad=79.8f pd=0.8u as=0.1428p ps=1.52u w=0.42u l=0.13u
X3866 a_21034_14452# a_21477_14495# a_21417_14531# VDD sg13_lv_pmos ad=79.8f pd=0.8u as=63f ps=0.72u w=0.42u l=0.13u
X3867 VSS.t1634 VDD VSS.t1633 VSS.t1632 sg13_lv_nmos ad=0.1428p pd=1.52u as=0 ps=0 w=0.42u l=1u
X3868 VDD sg13g2_dfrbpq_1_7.RESET_B a_25670_14922# VDD sg13_lv_pmos ad=0.36237p pd=2.605u as=79.8f ps=0.8u w=0.42u l=0.13u
X3869 sg13g2_buf_16_2.X a_19438_13726# VDD VDD sg13_lv_pmos ad=0.2128p pd=1.5u as=0.2128p ps=1.5u w=1.12u l=0.13u
X3870 VSS.t54 VDD VSS.t54 VSS.t795 sg13_lv_nmos ad=79.8f pd=0.8u as=0 ps=0 w=0.42u l=1u
X3871 VSS.t1307 VDD VSS.t1306 VSS.t311 sg13_lv_nmos ad=0.1428p pd=1.52u as=0 ps=0 w=0.42u l=1u
X3872 VSS.t681 VDD VSS.t681 VSS.t686 sg13_lv_nmos ad=79.8f pd=0.8u as=0 ps=0 w=0.42u l=1u
X3873 VDD VSS.t1362 VDD VDD sg13_lv_pmos ad=0.34p pd=2.68u as=0 ps=0 w=1u l=1u
X3874 VDD VSS.t2865 VDD VDD sg13_lv_pmos ad=0.34p pd=2.68u as=0 ps=0 w=1u l=1u
X3875 VDD VSS.t2150 VDD VDD sg13_lv_pmos ad=0.34p pd=2.68u as=0 ps=0 w=1u l=1u
X3876 VDD VSS.t604 VDD VDD sg13_lv_pmos ad=0.19p pd=1.38u as=0 ps=0 w=1u l=1u
X3877 VSS.t1008 VDD VSS.t1010 VSS.t1009 sg13_lv_nmos ad=79.8f pd=0.8u as=0 ps=0 w=0.42u l=1u
X3878 VSS.t2378 VDD VSS.t2380 VSS.t2379 sg13_lv_nmos ad=79.8f pd=0.8u as=0 ps=0 w=0.42u l=1u
X3879 VSS.t777 VDD VSS.t777 VSS.t778 sg13_lv_nmos ad=79.8f pd=0.8u as=0 ps=0 w=0.42u l=1u
X3880 VSS.t1644 VDD VSS.t1646 VSS.t1645 sg13_lv_nmos ad=79.8f pd=0.8u as=0 ps=0 w=0.42u l=1u
X3881 VSS.t1824 VDD VSS.t1823 VSS.t1822 sg13_lv_nmos ad=0.1428p pd=1.52u as=0 ps=0 w=0.42u l=1u
X3882 VSS.t3168 VDD VSS.t3170 VSS.t3169 sg13_lv_nmos ad=79.8f pd=0.8u as=0 ps=0 w=0.42u l=1u
X3883 VDD VSS.t548 VDD VDD sg13_lv_pmos ad=0.19p pd=1.38u as=0 ps=0 w=1u l=1u
X3884 VDD VSS.t1833 VDD VDD sg13_lv_pmos ad=0.34p pd=2.68u as=0 ps=0 w=1u l=1u
X3885 a_19065_14607# a_18123_14495# a_18863_14845# VDD sg13_lv_pmos ad=93.45f pd=0.865u as=0.2048p ps=1.63u w=0.42u l=0.13u
X3886 VSS.t948 VDD VSS.t947 VSS.t946 sg13_lv_nmos ad=0.1428p pd=1.52u as=0 ps=0 w=0.42u l=1u
X3887 VSS.t1378 VDD VSS.t1377 VSS.t311 sg13_lv_nmos ad=0.1428p pd=1.52u as=0 ps=0 w=0.42u l=1u
X3888 VDD VSS.t3235 VDD VDD sg13_lv_pmos ad=0.19p pd=1.38u as=0 ps=0 w=1u l=1u
X3889 VSS.t2633 VDD VSS.t2632 VSS.t2631 sg13_lv_nmos ad=0.1428p pd=1.52u as=0 ps=0 w=0.42u l=1u
X3890 VSS.t2453 VDD VSS.t2455 VSS.t2454 sg13_lv_nmos ad=79.8f pd=0.8u as=0 ps=0 w=0.42u l=1u
X3891 a_2916_15552# a_2890_15457# VSS.t213 VSS.t212 sg13_lv_nmos ad=0.2516p pd=2.16u as=0.1626p ps=1.415u w=0.74u l=0.13u
X3892 sg13g2_o21ai_1_2.A2 sg13g2_dfrbpq_1_6.Q VDD VDD sg13_lv_pmos ad=0.3808p pd=2.92u as=0.2128p ps=1.5u w=1.12u l=0.13u
X3893 VDD VSS.t1663 VDD VDD sg13_lv_pmos ad=0.34p pd=2.68u as=0 ps=0 w=1u l=1u
X3894 VDD VSS.t1060 VDD VDD sg13_lv_pmos ad=0.19p pd=1.38u as=0 ps=0 w=1u l=1u
X3895 VDD VSS.t1351 VDD VDD sg13_lv_pmos ad=0.19p pd=1.38u as=0 ps=0 w=1u l=1u
X3896 VSS.t1734 VDD VSS.t1736 VSS.t1735 sg13_lv_nmos ad=79.8f pd=0.8u as=0 ps=0 w=0.42u l=1u
X3897 VDD VSS.t2809 VDD VDD sg13_lv_pmos ad=0.34p pd=2.68u as=0 ps=0 w=1u l=1u
X3898 VSS.t184 VDD VSS.t184 VSS.t641 sg13_lv_nmos ad=79.8f pd=0.8u as=0 ps=0 w=0.42u l=1u
X3899 VDD VSS.t723 VDD VDD sg13_lv_pmos ad=0.19p pd=1.38u as=0 ps=0 w=1u l=1u
X3900 sg13g2_buf_16_2.X a_19438_13726# VSS.t328 VSS.t331 sg13_lv_nmos ad=0.1406p pd=1.12u as=0.1406p ps=1.12u w=0.74u l=0.13u
X3901 VDD VSS.t681 VDD VDD sg13_lv_pmos ad=0.19p pd=1.38u as=0 ps=0 w=1u l=1u
X3902 VDD VSS.t1623 VDD VDD sg13_lv_pmos ad=0.34p pd=2.68u as=0 ps=0 w=1u l=1u
X3903 VSS.t681 VDD VSS.t681 VSS.t687 sg13_lv_nmos ad=0.1428p pd=1.52u as=0 ps=0 w=0.42u l=1u
X3904 VSS.t1319 VDD VSS.t1318 VSS.t311 sg13_lv_nmos ad=0.1428p pd=1.52u as=0 ps=0 w=0.42u l=1u
X3905 VDD VSS.t1382 VDD VDD sg13_lv_pmos ad=0.19p pd=1.38u as=0 ps=0 w=1u l=1u
X3906 VDD VSS.t2883 VDD VDD sg13_lv_pmos ad=0.19p pd=1.38u as=0 ps=0 w=1u l=1u
X3907 VSS.t526 VDD VSS.t525 VSS.t524 sg13_lv_nmos ad=0.1428p pd=1.52u as=0 ps=0 w=0.42u l=1u
X3908 VDD VSS.t997 VDD VDD sg13_lv_pmos ad=0.34p pd=2.68u as=0 ps=0 w=1u l=1u
X3909 VDD VSS.t1628 VDD VDD sg13_lv_pmos ad=0.34p pd=2.68u as=0 ps=0 w=1u l=1u
X3910 VDD VSS.t2537 VDD VDD sg13_lv_pmos ad=0.34p pd=2.68u as=0 ps=0 w=1u l=1u
X3911 VSS.t2598 VDD VSS.t2597 VSS.t2596 sg13_lv_nmos ad=0.1428p pd=1.52u as=0 ps=0 w=0.42u l=1u
X3912 a_2646_14842# sg13g2_xor2_1_0.B sg13g2_and2_1_0.B VSS.t254 sg13_lv_nmos ad=88.8f pd=0.98u as=0.1628p ps=1.18u w=0.74u l=0.13u
X3913 sg13g2_buf_16_2.X a_19438_13726# VDD VDD sg13_lv_pmos ad=0.2128p pd=1.5u as=0.2128p ps=1.5u w=1.12u l=0.13u
X3914 VSS.t978 VDD VSS.t977 VSS.t976 sg13_lv_nmos ad=0.1428p pd=1.52u as=0 ps=0 w=0.42u l=1u
X3915 VSS.t1387 VDD VSS.t1386 VSS.t311 sg13_lv_nmos ad=0.1428p pd=1.52u as=0 ps=0 w=0.42u l=1u
X3916 VSS.t591 VDD VSS.t592 VSS.t9 sg13_lv_nmos ad=79.8f pd=0.8u as=0 ps=0 w=0.42u l=1u
X3917 VDD VSS.t3102 VDD VDD sg13_lv_pmos ad=0.34p pd=2.68u as=0 ps=0 w=1u l=1u
X3918 VSS.t2428 VDD VSS.t2427 VSS.t2426 sg13_lv_nmos ad=0.1428p pd=1.52u as=0 ps=0 w=0.42u l=1u
X3919 VDD VSS.t1970 VDD VDD sg13_lv_pmos ad=0.34p pd=2.68u as=0 ps=0 w=1u l=1u
X3920 VSS.t2146 VDD VSS.t2145 VSS.t2144 sg13_lv_nmos ad=0.1428p pd=1.52u as=0 ps=0 w=0.42u l=1u
X3921 VSS.t557 VDD VSS.t553 VSS.t556 sg13_lv_nmos ad=0.1428p pd=1.52u as=0 ps=0 w=0.42u l=1u
X3922 a_23638_14862# sg13g2_o21ai_1_2.A2 VSS.t265 VSS.t25 sg13_lv_nmos ad=0.1406p pd=1.12u as=0.1406p ps=1.12u w=0.74u l=0.15u
X3923 VSS.t712 VDD VSS.t712 VSS.t721 sg13_lv_nmos ad=0.1428p pd=1.52u as=0 ps=0 w=0.42u l=1u
X3924 a_3273_15625# a_2916_15552# VDD VDD sg13_lv_pmos ad=63f pd=0.72u as=0.1563p ps=1.22u w=0.42u l=0.13u
X3925 VSS.t1148 VDD VSS.t1147 VSS.t1146 sg13_lv_nmos ad=0.1428p pd=1.52u as=0 ps=0 w=0.42u l=1u
X3926 VDD VSS.t1331 VDD VDD sg13_lv_pmos ad=0.34p pd=2.68u as=0 ps=0 w=1u l=1u
X3927 VDD VSS.t2502 VDD VDD sg13_lv_pmos ad=0.34p pd=2.68u as=0 ps=0 w=1u l=1u
X3928 VDD sg13g2_buf_16_2.A a_19438_13726# VDD sg13_lv_pmos ad=0.2128p pd=1.5u as=0.2128p ps=1.5u w=1.12u l=0.13u
X3929 VSS.t1038 VDD VSS.t1040 VSS.t1039 sg13_lv_nmos ad=79.8f pd=0.8u as=0 ps=0 w=0.42u l=1u
X3930 VSS.t1406 VDD VSS.t1405 VSS.t311 sg13_lv_nmos ad=0.1428p pd=1.52u as=0 ps=0 w=0.42u l=1u
X3931 VDD VSS.t2013 VDD VDD sg13_lv_pmos ad=0.19p pd=1.38u as=0 ps=0 w=1u l=1u
X3932 a_17578_14452# a_18021_14495# a_17961_14531# VDD sg13_lv_pmos ad=79.8f pd=0.8u as=63f ps=0.72u w=0.42u l=0.13u
X3933 VSS.t1694 VDD VSS.t1693 VSS.t1692 sg13_lv_nmos ad=0.1428p pd=1.52u as=0 ps=0 w=0.42u l=1u
X3934 VDD VSS.t2847 VDD VDD sg13_lv_pmos ad=0.19p pd=1.38u as=0 ps=0 w=1u l=1u
X3935 a_9861_15213# sg13g2_dfrbpq_1_2.CLK VDD VDD sg13_lv_pmos ad=0.4088p pd=2.97u as=2.77542p ps=17.49u w=1.12u l=0.13u
X3936 VSS.t2398 VDD VSS.t2400 VSS.t2399 sg13_lv_nmos ad=79.8f pd=0.8u as=0 ps=0 w=0.42u l=1u
X3937 VSS.t728 VDD VSS.t728 VSS.t848 sg13_lv_nmos ad=0.1428p pd=1.52u as=0 ps=0 w=0.42u l=1u
X3938 VDD VSS.t1608 VDD VDD sg13_lv_pmos ad=0.34p pd=2.68u as=0 ps=0 w=1u l=1u
X3939 VDD VSS.t960 VDD VDD sg13_lv_pmos ad=0.19p pd=1.38u as=0 ps=0 w=1u l=1u
X3940 VSS.t1544 VDD VSS.t1409 VSS.t311 sg13_lv_nmos ad=0.1428p pd=1.52u as=0 ps=0 w=0.42u l=1u
X3941 VSS.t1689 VDD VSS.t1688 VSS.t1687 sg13_lv_nmos ad=0.1428p pd=1.52u as=0 ps=0 w=0.42u l=1u
X3942 VSS.t2438 VDD VSS.t2440 VSS.t2439 sg13_lv_nmos ad=79.8f pd=0.8u as=0 ps=0 w=0.42u l=1u
X3943 VSS.t2246 VDD VSS.t2248 VSS.t2247 sg13_lv_nmos ad=79.8f pd=0.8u as=0 ps=0 w=0.42u l=1u
X3944 VDD a_26554_16237# sg13g2_dfrbpq_1_5.RESET_B VDD sg13_lv_pmos ad=2.8961p pd=18.25u as=0.3927p ps=2.99u w=1.155u l=0.13u
X3945 VSS.t1439 VDD VSS.t1440 VSS.t311 sg13_lv_nmos ad=79.8f pd=0.8u as=0 ps=0 w=0.42u l=1u
X3946 VDD VSS.t1354 VDD VDD sg13_lv_pmos ad=0.34p pd=2.68u as=0 ps=0 w=1u l=1u
X3947 VDD VSS.t2857 VDD VDD sg13_lv_pmos ad=0.34p pd=2.68u as=0 ps=0 w=1u l=1u
X3948 VSS.t2166 VDD VSS.t2165 VSS.t2164 sg13_lv_nmos ad=0.1428p pd=1.52u as=0 ps=0 w=0.42u l=1u
X3949 VSS.t355 a_7532_15960# counter_value_o[1] VSS.t354 sg13_lv_nmos ad=0.14875p pd=1.16u as=0.2886p ps=2.26u w=0.74u l=0.13u
X3950 VDD VSS.t2163 VDD VDD sg13_lv_pmos ad=0.19p pd=1.38u as=0 ps=0 w=1u l=1u
X3951 VSS.t1809 VDD VSS.t1808 VSS.t1807 sg13_lv_nmos ad=0.1428p pd=1.52u as=0 ps=0 w=0.42u l=1u
X3952 VDD VSS.t712 VDD VDD sg13_lv_pmos ad=0.19p pd=1.38u as=0 ps=0 w=1u l=1u
X3953 VDD VSS.t1311 VDD VDD sg13_lv_pmos ad=0.19p pd=1.38u as=0 ps=0 w=1u l=1u
X3954 VSS.t460 VDD VSS.t455 VSS.t459 sg13_lv_nmos ad=0.1428p pd=1.52u as=0 ps=0 w=0.42u l=1u
X3955 VSS.t624 VDD VSS.t625 VSS.t9 sg13_lv_nmos ad=79.8f pd=0.8u as=0 ps=0 w=0.42u l=1u
X3956 VDD VSS.t1167 VDD VDD sg13_lv_pmos ad=0.34p pd=2.68u as=0 ps=0 w=1u l=1u
X3957 VSS.t2618 VDD VSS.t2617 VSS.t2616 sg13_lv_nmos ad=0.1428p pd=1.52u as=0 ps=0 w=0.42u l=1u
X3958 VSS.t496 VDD VSS.t495 VSS.t494 sg13_lv_nmos ad=0.1428p pd=1.52u as=0 ps=0 w=0.42u l=1u
X3959 VDD VSS.t1648 VDD VDD sg13_lv_pmos ad=0.34p pd=2.68u as=0 ps=0 w=1u l=1u
X3960 VDD VSS.t1998 VDD VDD sg13_lv_pmos ad=0.19p pd=1.38u as=0 ps=0 w=1u l=1u
X3961 VSS.t2901 VDD VSS.t2902 VSS.t392 sg13_lv_nmos ad=79.8f pd=0.8u as=0 ps=0 w=0.42u l=1u
X3962 VDD VSS.t2839 VDD VDD sg13_lv_pmos ad=0.19p pd=1.38u as=0 ps=0 w=1u l=1u
X3963 VSS.t2116 VDD VSS.t2115 VSS.t2114 sg13_lv_nmos ad=0.1428p pd=1.52u as=0 ps=0 w=0.42u l=1u
X3964 VDD VSS.t774 VDD VDD sg13_lv_pmos ad=0.34p pd=2.68u as=0 ps=0 w=1u l=1u
X3965 VDD VSS.t927 VDD VDD sg13_lv_pmos ad=0.34p pd=2.68u as=0 ps=0 w=1u l=1u
X3966 VSS.t1719 VDD VSS.t1721 VSS.t1720 sg13_lv_nmos ad=79.8f pd=0.8u as=0 ps=0 w=0.42u l=1u
X3967 VSS.t2849 VDD VSS.t2849 VSS.t392 sg13_lv_nmos ad=79.8f pd=0.8u as=0 ps=0 w=0.42u l=1u
X3968 VDD VSS.t2590 VDD VDD sg13_lv_pmos ad=0.19p pd=1.38u as=0 ps=0 w=1u l=1u
X3969 VDD a_19054_15423# sg13g2_dlygate4sd3_1_6.X VDD sg13_lv_pmos ad=0.2254p pd=1.53u as=0.4256p ps=3u w=1.12u l=0.13u
X3970 VSS.t582 VDD VSS.t583 VSS.t9 sg13_lv_nmos ad=79.8f pd=0.8u as=0 ps=0 w=0.42u l=1u
X3971 VDD VSS.t1042 VDD VDD sg13_lv_pmos ad=0.34p pd=2.68u as=0 ps=0 w=1u l=1u
X3972 VSS.t1423 VDD VSS.t1422 VSS.t311 sg13_lv_nmos ad=0.1428p pd=1.52u as=0 ps=0 w=0.42u l=1u
X3973 VSS.t1639 VDD VSS.t1638 VSS.t1637 sg13_lv_nmos ad=0.1428p pd=1.52u as=0 ps=0 w=0.42u l=1u
X3974 VDD VSS.t2365 VDD VDD sg13_lv_pmos ad=0.19p pd=1.38u as=0 ps=0 w=1u l=1u
X3975 VSS.t2196 VDD VSS.t2198 VSS.t2197 sg13_lv_nmos ad=79.8f pd=0.8u as=0 ps=0 w=0.42u l=1u
X3976 VDD VSS.t1365 VDD VDD sg13_lv_pmos ad=0.34p pd=2.68u as=0 ps=0 w=1u l=1u
X3977 VDD VSS.t2849 VDD VDD sg13_lv_pmos ad=0.34p pd=2.68u as=0 ps=0 w=1u l=1u
X3978 VDD VSS.t2155 VDD VDD sg13_lv_pmos ad=0.34p pd=2.68u as=0 ps=0 w=1u l=1u
X3979 VSS.t2413 VDD VSS.t2412 VSS.t2411 sg13_lv_nmos ad=0.1428p pd=1.52u as=0 ps=0 w=0.42u l=1u
X3980 VSS.t9 a_5687_15315# a_5687_15315# VSS.t217 sg13_lv_nmos ad=5.4375p pd=36.05u as=0.111p ps=1.34u w=0.3u l=0.13u
X3981 VDD VSS.t980 VDD VDD sg13_lv_pmos ad=0.19p pd=1.38u as=0 ps=0 w=1u l=1u
X3982 VSS.t2789 VDD VSS.t2790 VSS.t392 sg13_lv_nmos ad=79.8f pd=0.8u as=0 ps=0 w=0.42u l=1u
X3983 VSS.t2383 VDD VSS.t2385 VSS.t2384 sg13_lv_nmos ad=79.8f pd=0.8u as=0 ps=0 w=0.42u l=1u
X3984 VSS.t3173 VDD VSS.t3175 VSS.t3174 sg13_lv_nmos ad=79.8f pd=0.8u as=0 ps=0 w=0.42u l=1u
X3985 VSS.t1148 VDD VSS.t1147 VSS.t1146 sg13_lv_nmos ad=0.1428p pd=1.52u as=0 ps=0 w=0.42u l=1u
X3986 VDD VSS.t1401 VDD VDD sg13_lv_pmos ad=0.19p pd=1.38u as=0 ps=0 w=1u l=1u
X3987 VDD VSS.t942 VDD VDD sg13_lv_pmos ad=0.34p pd=2.68u as=0 ps=0 w=1u l=1u
X3988 VDD VSS.t1803 VDD VDD sg13_lv_pmos ad=0.34p pd=2.68u as=0 ps=0 w=1u l=1u
X3989 VSS.t736 VDD VSS.t736 VSS.t737 sg13_lv_nmos ad=79.8f pd=0.8u as=0 ps=0 w=0.42u l=1u
X3990 VSS.t1350 VDD VSS.t1351 VSS.t311 sg13_lv_nmos ad=79.8f pd=0.8u as=0 ps=0 w=0.42u l=1u
X3991 VSS.t471 VDD VSS.t471 VSS.t474 sg13_lv_nmos ad=79.8f pd=0.8u as=0 ps=0 w=0.42u l=1u
X3992 VDD VSS.t1668 VDD VDD sg13_lv_pmos ad=0.34p pd=2.68u as=0 ps=0 w=1u l=1u
X3993 VSS.t2026 VDD VSS.t2028 VSS.t2027 sg13_lv_nmos ad=79.8f pd=0.8u as=0 ps=0 w=0.42u l=1u
X3994 VDD VSS.t2813 VDD VDD sg13_lv_pmos ad=0.34p pd=2.68u as=0 ps=0 w=1u l=1u
X3995 VSS.t1436 VDD VSS.t1565 VSS.t311 sg13_lv_nmos ad=0.1428p pd=1.52u as=0 ps=0 w=0.42u l=1u
X3996 a_9158_15234# sg13g2_and2_1_2.X VDD VDD sg13_lv_pmos ad=79.8f pd=0.8u as=0.1428p ps=1.52u w=0.42u l=0.13u
X3997 VSS.t7 sg13g2_and2_1_0.B a_2059_14832# VSS.t417 sg13_lv_nmos ad=0.1331p pd=1.12u as=0.1216p ps=1.02u w=0.64u l=0.13u
X3998 VDD VSS.t707 VDD VDD sg13_lv_pmos ad=0.34p pd=2.68u as=0 ps=0 w=1u l=1u
X3999 VSS.t953 VDD VSS.t955 VSS.t954 sg13_lv_nmos ad=79.8f pd=0.8u as=0 ps=0 w=0.42u l=1u
X4000 VSS.t1624 VDD VSS.t1623 VSS.t1622 sg13_lv_nmos ad=0.1428p pd=1.52u as=0 ps=0 w=0.42u l=1u
X4001 VDD VSS.t1012 VDD VDD sg13_lv_pmos ad=0.34p pd=2.68u as=0 ps=0 w=1u l=1u
X4002 VDD VSS.t1385 VDD VDD sg13_lv_pmos ad=0.19p pd=1.38u as=0 ps=0 w=1u l=1u
X4003 VSS.t2231 VDD VSS.t2233 VSS.t2232 sg13_lv_nmos ad=79.8f pd=0.8u as=0 ps=0 w=0.42u l=1u
X4004 VDD VSS.t2188 VDD VDD sg13_lv_pmos ad=0.19p pd=1.38u as=0 ps=0 w=1u l=1u
X4005 VDD VSS.t1633 VDD VDD sg13_lv_pmos ad=0.34p pd=2.68u as=0 ps=0 w=1u l=1u
X4006 VSS.t2824 VDD VSS.t2824 VSS.t392 sg13_lv_nmos ad=0.1428p pd=1.52u as=0 ps=0 w=0.42u l=1u
X4007 VDD VSS.t2542 VDD VDD sg13_lv_pmos ad=0.34p pd=2.68u as=0 ps=0 w=1u l=1u
X4008 VSS.t2603 VDD VSS.t2602 VSS.t2601 sg13_lv_nmos ad=0.1428p pd=1.52u as=0 ps=0 w=0.42u l=1u
X4009 VSS.t834 VDD VSS.t317 VSS.t835 sg13_lv_nmos ad=79.8f pd=0.8u as=0 ps=0 w=0.42u l=1u
X4010 VDD VSS.t757 VDD VDD sg13_lv_pmos ad=0.34p pd=2.68u as=0 ps=0 w=1u l=1u
X4011 VDD VSS.t3107 VDD VDD sg13_lv_pmos ad=0.34p pd=2.68u as=0 ps=0 w=1u l=1u
X4012 a_10222_14751# a_10337_14750# VSS.t43 VSS.t79 sg13_lv_nmos ad=0.1428p pd=1.52u as=0.1426p ps=1.16u w=0.42u l=0.5u
X4013 VSS.t2151 VDD VSS.t2150 VSS.t2149 sg13_lv_nmos ad=0.1428p pd=1.52u as=0 ps=0 w=0.42u l=1u
X4014 VSS.t2368 VDD VSS.t2370 VSS.t2369 sg13_lv_nmos ad=79.8f pd=0.8u as=0 ps=0 w=0.42u l=1u
X4015 VSS.t2101 VDD VSS.t2103 VSS.t2102 sg13_lv_nmos ad=79.8f pd=0.8u as=0 ps=0 w=0.42u l=1u
X4016 VDD VSS.t712 VDD VDD sg13_lv_pmos ad=0.19p pd=1.38u as=0 ps=0 w=1u l=1u
X4017 VDD VSS.t1097 VDD VDD sg13_lv_pmos ad=0.34p pd=2.68u as=0 ps=0 w=1u l=1u
X4018 VDD VSS.t1646 VDD VDD sg13_lv_pmos ad=0.19p pd=1.38u as=0 ps=0 w=1u l=1u
X4019 VSS.t2443 VDD VSS.t2445 VSS.t2444 sg13_lv_nmos ad=79.8f pd=0.8u as=0 ps=0 w=0.42u l=1u
X4020 VDD VSS.t2243 VDD VDD sg13_lv_pmos ad=0.19p pd=1.38u as=0 ps=0 w=1u l=1u
X4021 VDD VSS.t90 VDD VDD sg13_lv_pmos ad=0.34p pd=2.68u as=0 ps=0 w=1u l=1u
X4022 VSS.t681 VDD VSS.t681 VSS.t686 sg13_lv_nmos ad=79.8f pd=0.8u as=0 ps=0 w=0.42u l=1u
X4023 a_25037_14020# sg13g2_or3_1_1.B a_24935_14020# VDD sg13_lv_pmos ad=0.1575p pd=1.315u as=0.19p ps=1.38u w=1u l=0.13u
X4024 VDD VSS.t1983 VDD VDD sg13_lv_pmos ad=0.19p pd=1.38u as=0 ps=0 w=1u l=1u
X4025 VSS.t2893 VDD VSS.t2894 VSS.t392 sg13_lv_nmos ad=79.8f pd=0.8u as=0 ps=0 w=0.42u l=1u
X4026 VDD VSS.t2772 VDD VDD sg13_lv_pmos ad=0.19p pd=1.38u as=0 ps=0 w=1u l=1u
X4027 VDD a_26638_15423# sg13g2_o21ai_1_2.B1 VDD sg13_lv_pmos ad=0.2254p pd=1.53u as=0.4256p ps=3u w=1.12u l=0.13u
X4028 VDD VSS.t1418 VDD VDD sg13_lv_pmos ad=0.19p pd=1.38u as=0 ps=0 w=1u l=1u
X4029 VSS.t1664 VDD VSS.t1663 VSS.t1662 sg13_lv_nmos ad=0.1428p pd=1.52u as=0 ps=0 w=0.42u l=1u
X4030 VSS.t3188 VDD VSS.t3187 VSS.t3186 sg13_lv_nmos ad=0.1428p pd=1.52u as=0 ps=0 w=0.42u l=1u
X4031 VSS.t2398 VDD VSS.t2397 VSS.t2396 sg13_lv_nmos ad=0.1428p pd=1.52u as=0 ps=0 w=0.42u l=1u
X4032 a_7262_15242# sg13g2_buf_1_0.X a_7160_15242# VSS.t258 sg13_lv_nmos ad=0.1406p pd=1.12u as=0.1406p ps=1.12u w=0.74u l=0.13u
X4033 VDD a_6682_13690# a_6401_13912# VDD sg13_lv_pmos ad=0.1523p pd=1.38u as=0.34p ps=2.68u w=1u l=0.5u
X4034 VSS.t754 VDD VSS.t754 VSS.t755 sg13_lv_nmos ad=79.8f pd=0.8u as=0 ps=0 w=0.42u l=1u
X4035 VDD VSS.t1160 VDD VDD sg13_lv_pmos ad=0.19p pd=1.38u as=0 ps=0 w=1u l=1u
X4036 VSS.t2869 VDD VSS.t2868 VSS.t392 sg13_lv_nmos ad=0.1428p pd=1.52u as=0 ps=0 w=0.42u l=1u
X4037 VSS.t609 VDD VSS.t610 VSS.t9 sg13_lv_nmos ad=79.8f pd=0.8u as=0 ps=0 w=0.42u l=1u
X4038 VSS.t553 VDD VSS.t553 VSS.t555 sg13_lv_nmos ad=79.8f pd=0.8u as=0 ps=0 w=0.42u l=1u
X4039 VDD VSS.t211 VDD VDD sg13_lv_pmos ad=0.19p pd=1.38u as=0 ps=0 w=1u l=1u
X4040 VDD VSS.t1786 VDD VDD sg13_lv_pmos ad=0.19p pd=1.38u as=0 ps=0 w=1u l=1u
X4041 VSS.t712 VDD VSS.t712 VSS.t818 sg13_lv_nmos ad=0.1428p pd=1.52u as=0 ps=0 w=0.42u l=1u
X4042 VDD VSS.t2140 VDD VDD sg13_lv_pmos ad=0.34p pd=2.68u as=0 ps=0 w=1u l=1u
X4043 VDD VSS.t54 VDD VDD sg13_lv_pmos ad=0.34p pd=2.68u as=0 ps=0 w=1u l=1u
X4044 VDD VSS.t1427 VDD VDD sg13_lv_pmos ad=0.19p pd=1.38u as=0 ps=0 w=1u l=1u
X4045 a_22738_14922# sg13g2_dfrbpq_1_6.RESET_B VSS.t86 VSS.t25 sg13_lv_nmos ad=37.8f pd=0.6u as=79.8f ps=0.8u w=0.42u l=0.13u
X4046 VDD a_4175_15311# a_4432_15454# VDD sg13_lv_pmos ad=2.8961p pd=18.25u as=79.8f ps=0.8u w=0.42u l=0.13u
X4047 VSS.t764 VDD VSS.t766 VSS.t765 sg13_lv_nmos ad=79.8f pd=0.8u as=0 ps=0 w=0.42u l=1u
X4048 VSS.t1300 VDD VSS.t1299 VSS.t311 sg13_lv_nmos ad=0.1428p pd=1.52u as=0 ps=0 w=0.42u l=1u
X4049 VSS.t1541 VDD VSS.t1408 VSS.t311 sg13_lv_nmos ad=79.8f pd=0.8u as=0 ps=0 w=0.42u l=1u
X4050 VSS.t2588 VDD VSS.t2587 VSS.t2586 sg13_lv_nmos ad=0.1428p pd=1.52u as=0 ps=0 w=0.42u l=1u
X4051 VSS.t1058 VDD VSS.t1060 VSS.t1059 sg13_lv_nmos ad=79.8f pd=0.8u as=0 ps=0 w=0.42u l=1u
X4052 VDD VSS.t2405 VDD VDD sg13_lv_pmos ad=0.19p pd=1.38u as=0 ps=0 w=1u l=1u
X4053 VDD sg13g2_buf_16_2.A a_12020_15202# VDD sg13_lv_pmos ad=0.3808p pd=2.92u as=0.2128p ps=1.5u w=1.12u l=0.13u
X4054 a_26565_13701# sg13g2_buf_16_2.X VDD VDD sg13_lv_pmos ad=0.4088p pd=2.97u as=2.3367p ps=15.135u w=1.12u l=0.13u
X4055 VDD VSS.t1653 VDD VDD sg13_lv_pmos ad=0.34p pd=2.68u as=0 ps=0 w=1u l=1u
X4056 VSS.t2885 VDD VSS.t2886 VSS.t392 sg13_lv_nmos ad=79.8f pd=0.8u as=0 ps=0 w=0.42u l=1u
X4057 VDD VSS.t1127 VDD VDD sg13_lv_pmos ad=0.34p pd=2.68u as=0 ps=0 w=1u l=1u
X4058 VDD VSS.t454 VDD VDD sg13_lv_pmos ad=0.34p pd=2.68u as=0 ps=0 w=1u l=1u
X4059 VSS.t953 VDD VSS.t955 VSS.t954 sg13_lv_nmos ad=79.8f pd=0.8u as=0 ps=0 w=0.42u l=1u
X4060 VDD VSS.t1693 VDD VDD sg13_lv_pmos ad=0.34p pd=2.68u as=0 ps=0 w=1u l=1u
X4061 VSS.t2011 VDD VSS.t2013 VSS.t2012 sg13_lv_nmos ad=79.8f pd=0.8u as=0 ps=0 w=0.42u l=1u
X4062 VSS.t591 VDD VSS.t590 VSS.t9 sg13_lv_nmos ad=0.1428p pd=1.52u as=0 ps=0 w=0.42u l=1u
X4063 VDD VSS.t707 VDD VDD sg13_lv_pmos ad=0.34p pd=2.68u as=0 ps=0 w=1u l=1u
X4064 VSS.t1724 VDD VSS.t1726 VSS.t1725 sg13_lv_nmos ad=79.8f pd=0.8u as=0 ps=0 w=0.42u l=1u
X4065 VSS.t2851 VDD VSS.t2852 VSS.t392 sg13_lv_nmos ad=79.8f pd=0.8u as=0 ps=0 w=0.42u l=1u
X4066 VDD VSS.t1376 VDD VDD sg13_lv_pmos ad=0.19p pd=1.38u as=0 ps=0 w=1u l=1u
X4067 VSS.t1609 VDD VSS.t1608 VSS.t1607 sg13_lv_nmos ad=0.1428p pd=1.52u as=0 ps=0 w=0.42u l=1u
X4068 a_12524_15960# sg13g2_dlygate4sd3_1_8.A VDD VDD sg13_lv_pmos ad=0.2856p pd=2.36u as=0.2114p ps=1.54u w=0.84u l=0.13u
X4069 a_17529_14037# a_16587_13844# a_17327_13799# VDD sg13_lv_pmos ad=93.45f pd=0.865u as=0.2048p ps=1.63u w=0.42u l=0.13u
X4070 VSS.t2201 VDD VSS.t2203 VSS.t2202 sg13_lv_nmos ad=79.8f pd=0.8u as=0 ps=0 w=0.42u l=1u
X4071 VDD VSS.t728 VDD VDD sg13_lv_pmos ad=0.19p pd=1.38u as=0 ps=0 w=1u l=1u
X4072 VDD VSS.t1348 VDD VDD sg13_lv_pmos ad=0.34p pd=2.68u as=0 ps=0 w=1u l=1u
X4073 VDD VSS.t2852 VDD VDD sg13_lv_pmos ad=0.34p pd=2.68u as=0 ps=0 w=1u l=1u
X4074 VDD VSS.t2125 VDD VDD sg13_lv_pmos ad=0.34p pd=2.68u as=0 ps=0 w=1u l=1u
X4075 VSS.t2418 VDD VSS.t2417 VSS.t2416 sg13_lv_nmos ad=0.1428p pd=1.52u as=0 ps=0 w=0.42u l=1u
X4076 VDD VSS.t319 VDD VDD sg13_lv_pmos ad=0.19p pd=1.38u as=0 ps=0 w=1u l=1u
X4077 VSS.t531 VDD VSS.t530 VSS.t529 sg13_lv_nmos ad=0.1428p pd=1.52u as=0 ps=0 w=0.42u l=1u
X4078 VSS.t745 VDD VSS.t742 VSS.t744 sg13_lv_nmos ad=0.1428p pd=1.52u as=0 ps=0 w=0.42u l=1u
X4079 VSS.t2867 VDD VSS.t2867 VSS.t392 sg13_lv_nmos ad=0.1428p pd=1.52u as=0 ps=0 w=0.42u l=1u
X4080 VSS.t36 a_10703_15311# a_11370_15532# VSS.t35 sg13_lv_nmos ad=0.1406p pd=1.12u as=0.2516p ps=2.16u w=0.74u l=0.13u
X4081 a_21827_13690# sg13g2_or3_1_2.C VSS.t78 VSS.t422 sg13_lv_nmos ad=0.187p pd=1.78u as=0.1045p ps=0.93u w=0.55u l=0.13u
X4082 VDD VSS.t2043 VDD VDD sg13_lv_pmos ad=0.19p pd=1.38u as=0 ps=0 w=1u l=1u
X4083 VSS.t2086 VDD VSS.t2088 VSS.t2087 sg13_lv_nmos ad=79.8f pd=0.8u as=0 ps=0 w=0.42u l=1u
X4084 VSS.t594 VDD VSS.t595 VSS.t9 sg13_lv_nmos ad=79.8f pd=0.8u as=0 ps=0 w=0.42u l=1u
X4085 a_6346_14452# a_6789_14495# a_6086_14922# VSS.t115 sg13_lv_nmos ad=79.8f pd=0.8u as=0.1296p ps=1.52u w=0.42u l=0.13u
X4086 VSS.t1390 VDD VSS.t1389 VSS.t311 sg13_lv_nmos ad=0.1428p pd=1.52u as=0 ps=0 w=0.42u l=1u
X4087 VDD VSS.t1808 VDD VDD sg13_lv_pmos ad=0.34p pd=2.68u as=0 ps=0 w=1u l=1u
X4088 VSS.t2608 VDD VSS.t2607 VSS.t2606 sg13_lv_nmos ad=0.1428p pd=1.52u as=0 ps=0 w=0.42u l=1u
X4089 VSS.t2428 VDD VSS.t2430 VSS.t2429 sg13_lv_nmos ad=79.8f pd=0.8u as=0 ps=0 w=0.42u l=1u
X4090 a_16955_12972# sg13g2_a21oi_1_0.A2 VDD VDD sg13_lv_pmos ad=0.3808p pd=2.92u as=0.2128p ps=1.5u w=1.12u l=0.13u
X4091 VDD VSS.t2390 VDD VDD sg13_lv_pmos ad=0.19p pd=1.38u as=0 ps=0 w=1u l=1u
X4092 VDD VSS.t2228 VDD VDD sg13_lv_pmos ad=0.19p pd=1.38u as=0 ps=0 w=1u l=1u
X4093 VDD a_12020_15202# sg13g2_dfrbpq_1_2.CLK VDD sg13_lv_pmos ad=0.2128p pd=1.5u as=0.2128p ps=1.5u w=1.12u l=0.13u
X4094 VDD VSS.t2180 VDD VDD sg13_lv_pmos ad=0.34p pd=2.68u as=0 ps=0 w=1u l=1u
X4095 VDD VSS.t3305 VDD VDD sg13_lv_pmos ad=0.19p pd=1.38u as=0 ps=0 w=1u l=1u
X4096 VSS.t1996 VDD VSS.t1998 VSS.t1997 sg13_lv_nmos ad=79.8f pd=0.8u as=0 ps=0 w=0.42u l=1u
X4097 VSS.t2861 VDD VSS.t2860 VSS.t392 sg13_lv_nmos ad=0.1428p pd=1.52u as=0 ps=0 w=0.42u l=1u
X4098 VDD VSS.t2816 VDD VDD sg13_lv_pmos ad=0.34p pd=2.68u as=0 ps=0 w=1u l=1u
X4099 VSS.t681 VDD VSS.t681 VSS.t680 sg13_lv_nmos ad=0.1428p pd=1.52u as=0 ps=0 w=0.42u l=1u
X4100 VSS.t336 VDD VSS.t333 VSS.t840 sg13_lv_nmos ad=0.1428p pd=1.52u as=0 ps=0 w=0.42u l=1u
X4101 VDD VSS.t1017 VDD VDD sg13_lv_pmos ad=0.34p pd=2.68u as=0 ps=0 w=1u l=1u
X4102 VSS.t2236 VDD VSS.t2238 VSS.t2237 sg13_lv_nmos ad=79.8f pd=0.8u as=0 ps=0 w=0.42u l=1u
X4103 VSS.t603 VDD VSS.t604 VSS.t9 sg13_lv_nmos ad=79.8f pd=0.8u as=0 ps=0 w=0.42u l=1u
X4104 VDD VSS.t1638 VDD VDD sg13_lv_pmos ad=0.34p pd=2.68u as=0 ps=0 w=1u l=1u
X4105 VDD VSS.t2547 VDD VDD sg13_lv_pmos ad=0.34p pd=2.68u as=0 ps=0 w=1u l=1u
X4106 sg13g2_dlygate4sd3_1_3.A a_4842_15532# VDD VDD sg13_lv_pmos ad=0.3808p pd=2.92u as=0.2128p ps=1.5u w=1.12u l=0.13u
X4107 VSS.t1739 VDD VSS.t1738 VSS.t1737 sg13_lv_nmos ad=0.1428p pd=1.52u as=0 ps=0 w=0.42u l=1u
X4108 VDD VSS.t2495 VDD VDD sg13_lv_pmos ad=0.19p pd=1.38u as=0 ps=0 w=1u l=1u
X4109 VSS.t2156 VDD VSS.t2155 VSS.t2154 sg13_lv_nmos ad=0.1428p pd=1.52u as=0 ps=0 w=0.42u l=1u
X4110 VSS.t81 a_18377_16334# a_18298_16237# VSS.t390 sg13_lv_nmos ad=5.24677p pd=34.365u as=0.27427p ps=2.28u w=0.795u l=0.13u
X4111 VSS.t2859 VDD VSS.t2859 VSS.t392 sg13_lv_nmos ad=0.1428p pd=1.52u as=0 ps=0 w=0.42u l=1u
X4112 VSS.t62 a_15022_14484# sg13g2_buf_16_2.A VSS.t136 sg13_lv_nmos ad=0.1406p pd=1.12u as=0.1406p ps=1.12u w=0.74u l=0.13u
X4113 VSS.t1028 VDD VSS.t1030 VSS.t1029 sg13_lv_nmos ad=79.8f pd=0.8u as=0 ps=0 w=0.42u l=1u
X4114 VSS.t62 a_15022_14484# sg13g2_buf_16_2.A VSS.t148 sg13_lv_nmos ad=0.2516p pd=2.16u as=0.1406p ps=1.12u w=0.74u l=0.13u
X4115 VDD VSS.t1343 VDD VDD sg13_lv_pmos ad=0.34p pd=2.68u as=0 ps=0 w=1u l=1u
X4116 VDD VSS.t213 VDD VDD sg13_lv_pmos ad=0.34p pd=2.68u as=0 ps=0 w=1u l=1u
X4117 VSS.t1058 VDD VSS.t1060 VSS.t1059 sg13_lv_nmos ad=79.8f pd=0.8u as=0 ps=0 w=0.42u l=1u
X4118 a_7631_14845# a_6789_14495# a_6372_14488# VDD sg13_lv_pmos ad=0.2048p pd=1.63u as=0.34p ps=2.68u w=1u l=0.13u
X4119 VDD VSS.t2213 VDD VDD sg13_lv_pmos ad=0.19p pd=1.38u as=0 ps=0 w=1u l=1u
X4120 VSS.t2031 VDD VSS.t2033 VSS.t2032 sg13_lv_nmos ad=79.8f pd=0.8u as=0 ps=0 w=0.42u l=1u
X4121 VDD VSS.t1988 VDD VDD sg13_lv_pmos ad=0.19p pd=1.38u as=0 ps=0 w=1u l=1u
X4122 VDD VSS.t2775 VDD VDD sg13_lv_pmos ad=0.19p pd=1.38u as=0 ps=0 w=1u l=1u
X4123 VDD VSS.t2833 VDD VDD sg13_lv_pmos ad=0.19p pd=1.38u as=0 ps=0 w=1u l=1u
X4124 VDD a_12020_15202# sg13g2_dfrbpq_1_2.CLK VDD sg13_lv_pmos ad=0.2128p pd=1.5u as=0.2128p ps=1.5u w=1.12u l=0.13u
X4125 VSS.t1669 VDD VSS.t1668 VSS.t1667 sg13_lv_nmos ad=0.1428p pd=1.52u as=0 ps=0 w=0.42u l=1u
X4126 VSS.t3193 VDD VSS.t3192 VSS.t3191 sg13_lv_nmos ad=0.1428p pd=1.52u as=0 ps=0 w=0.42u l=1u
X4127 VSS.t2403 VDD VSS.t2402 VSS.t2401 sg13_lv_nmos ad=0.1428p pd=1.52u as=0 ps=0 w=0.42u l=1u
X4128 VSS.t2573 VDD VSS.t2575 VSS.t2574 sg13_lv_nmos ad=79.8f pd=0.8u as=0 ps=0 w=0.42u l=1u
X4129 VDD VSS.t1380 VDD VDD sg13_lv_pmos ad=0.19p pd=1.38u as=0 ps=0 w=1u l=1u
X4130 VSS.t2843 VDD VSS.t2844 VSS.t392 sg13_lv_nmos ad=79.8f pd=0.8u as=0 ps=0 w=0.42u l=1u
X4131 VDD VSS.t2580 VDD VDD sg13_lv_pmos ad=0.19p pd=1.38u as=0 ps=0 w=1u l=1u
X4132 VSS.t2478 VDD VSS.t2477 VSS.t2476 sg13_lv_nmos ad=0.1428p pd=1.52u as=0 ps=0 w=0.42u l=1u
X4133 sg13g2_dlygate4sd3_1_5.A sg13g2_or3_1_2.B a_18552_15552# VDD sg13_lv_pmos ad=0.2128p pd=1.5u as=0.2128p ps=1.5u w=1.12u l=0.15u
X4134 VSS.t226 a_21166_16263# sg13g2_dfrbpq_1_6.D VSS.t391 sg13_lv_nmos ad=0.1426p pd=1.16u as=0.2516p ps=2.16u w=0.74u l=0.13u
X4135 VSS.t1329 VDD VSS.t1330 VSS.t311 sg13_lv_nmos ad=79.8f pd=0.8u as=0 ps=0 w=0.42u l=1u
X4136 a_25786_15960# sg13g2_o21ai_1_3.Y VSS.t83 VSS.t241 sg13_lv_nmos ad=0.1428p pd=1.52u as=79.8f ps=0.8u w=0.42u l=0.13u
X4137 VDD VSS.t739 VDD VDD sg13_lv_pmos ad=0.19p pd=1.38u as=0 ps=0 w=1u l=1u
X4138 VSS.t2186 VDD VSS.t2188 VSS.t2187 sg13_lv_nmos ad=79.8f pd=0.8u as=0 ps=0 w=0.42u l=1u
X4139 VDD sg13g2_o21ai_1_2.B1 sg13g2_o21ai_1_2.Y VDD sg13_lv_pmos ad=0.3808p pd=2.92u as=0.2128p ps=1.5u w=1.12u l=0.15u
X4140 VDD VSS.t1339 VDD VDD sg13_lv_pmos ad=0.34p pd=2.68u as=0 ps=0 w=1u l=1u
X4141 VDD VSS.t2844 VDD VDD sg13_lv_pmos ad=0.34p pd=2.68u as=0 ps=0 w=1u l=1u
X4142 VSS.t2141 VDD VSS.t2140 VSS.t2139 sg13_lv_nmos ad=0.1428p pd=1.52u as=0 ps=0 w=0.42u l=1u
X4143 sg13g2_dfrbpq_1_3.D a_17142_15302# VDD VDD sg13_lv_pmos ad=0.4256p pd=3u as=0.2254p ps=1.53u w=1.12u l=0.13u
X4144 VSS.t333 a_19438_13726# sg13g2_buf_16_2.X VSS.t332 sg13_lv_nmos ad=0.1406p pd=1.12u as=0.1406p ps=1.12u w=0.74u l=0.13u
X4145 VSS.t2782 VDD VSS.t2784 VSS.t392 sg13_lv_nmos ad=79.8f pd=0.8u as=0 ps=0 w=0.42u l=1u
X4146 VSS.t486 VDD VSS.t486 VSS.t487 sg13_lv_nmos ad=79.8f pd=0.8u as=0 ps=0 w=0.42u l=1u
X4147 VSS.t1416 VDD VSS.t1415 VSS.t311 sg13_lv_nmos ad=0.1428p pd=1.52u as=0 ps=0 w=0.42u l=1u
X4148 VDD VSS.t1395 VDD VDD sg13_lv_pmos ad=0.34p pd=2.68u as=0 ps=0 w=1u l=1u
X4149 VDD VSS.t2895 VDD VDD sg13_lv_pmos ad=0.34p pd=2.68u as=0 ps=0 w=1u l=1u
X4150 VDD VSS.t2205 VDD VDD sg13_lv_pmos ad=0.34p pd=2.68u as=0 ps=0 w=1u l=1u
X4151 VSS.t62 clock_i a_15022_14484# VSS.t301 sg13_lv_nmos ad=0.1406p pd=1.12u as=0.1406p ps=1.12u w=0.74u l=0.13u
X4152 VSS.t2593 VDD VSS.t2592 VSS.t2591 sg13_lv_nmos ad=0.1428p pd=1.52u as=0 ps=0 w=0.42u l=1u
X4153 VDD VSS.t2375 VDD VDD sg13_lv_pmos ad=0.19p pd=1.38u as=0 ps=0 w=1u l=1u
X4154 VDD VSS.t1658 VDD VDD sg13_lv_pmos ad=0.34p pd=2.68u as=0 ps=0 w=1u l=1u
X4155 VSS.t2888 VDD VSS.t2889 VSS.t392 sg13_lv_nmos ad=79.8f pd=0.8u as=0 ps=0 w=0.42u l=1u
X4156 VDD VSS.t2165 VDD VDD sg13_lv_pmos ad=0.34p pd=2.68u as=0 ps=0 w=1u l=1u
X4157 VDD VSS.t925 VDD VDD sg13_lv_pmos ad=0.19p pd=1.38u as=0 ps=0 w=1u l=1u
X4158 VDD VSS.t3290 VDD VDD sg13_lv_pmos ad=0.19p pd=1.38u as=0 ps=0 w=1u l=1u
X4159 VSS.t1981 VDD VSS.t1983 VSS.t1982 sg13_lv_nmos ad=79.8f pd=0.8u as=0 ps=0 w=0.42u l=1u
X4160 VDD VSS.t1663 VDD VDD sg13_lv_pmos ad=0.34p pd=2.68u as=0 ps=0 w=1u l=1u
X4161 VDD VSS.t2807 VDD VDD sg13_lv_pmos ad=0.34p pd=2.68u as=0 ps=0 w=1u l=1u
X4162 VSS.t1013 VDD VSS.t1012 VSS.t1011 sg13_lv_nmos ad=0.1428p pd=1.52u as=0 ps=0 w=0.42u l=1u
X4163 a_26148_14040# a_26667_13844# a_27407_13799# VSS.t366 sg13_lv_nmos ad=0.3473p pd=2.71u as=0.12665p ps=1.145u w=0.74u l=0.13u
X4164 a_19438_13726# sg13g2_buf_16_2.A VDD VDD sg13_lv_pmos ad=0.2128p pd=1.5u as=0.2128p ps=1.5u w=1.12u l=0.13u
X4165 VDD VSS.t1623 VDD VDD sg13_lv_pmos ad=0.34p pd=2.68u as=0 ps=0 w=1u l=1u
X4166 VSS.t3024 VDD VSS.t2902 VSS.t392 sg13_lv_nmos ad=0.1428p pd=1.52u as=0 ps=0 w=0.42u l=1u
X4167 VDD VSS.t2532 VDD VDD sg13_lv_pmos ad=0.34p pd=2.68u as=0 ps=0 w=1u l=1u
X4168 VSS.t2423 VDD VSS.t2422 VSS.t2421 sg13_lv_nmos ad=0.1428p pd=1.52u as=0 ps=0 w=0.42u l=1u
X4169 VSS.t1028 VDD VSS.t1030 VSS.t1029 sg13_lv_nmos ad=79.8f pd=0.8u as=0 ps=0 w=0.42u l=1u
X4170 VDD VSS.t681 VDD VDD sg13_lv_pmos ad=0.19p pd=1.38u as=0 ps=0 w=1u l=1u
X4171 VSS.t2851 VDD VSS.t2851 VSS.t392 sg13_lv_nmos ad=0.1428p pd=1.52u as=0 ps=0 w=0.42u l=1u
X4172 VDD VSS.t940 VDD VDD sg13_lv_pmos ad=0.19p pd=1.38u as=0 ps=0 w=1u l=1u
X4173 VDD VSS.t2048 VDD VDD sg13_lv_pmos ad=0.19p pd=1.38u as=0 ps=0 w=1u l=1u
X4174 VSS.t2091 VDD VSS.t2093 VSS.t2092 sg13_lv_nmos ad=79.8f pd=0.8u as=0 ps=0 w=0.42u l=1u
X4175 VSS.t1361 VDD VSS.t1362 VSS.t311 sg13_lv_nmos ad=79.8f pd=0.8u as=0 ps=0 w=0.42u l=1u
X4176 VDD VSS.t2367 VDD VDD sg13_lv_pmos ad=0.34p pd=2.68u as=0 ps=0 w=1u l=1u
X4177 VDD VSS.t88 VDD VDD sg13_lv_pmos ad=0.34p pd=2.68u as=0 ps=0 w=1u l=1u
X4178 VDD VSS.t571 VDD VDD sg13_lv_pmos ad=0.34p pd=2.68u as=0 ps=0 w=1u l=1u
X4179 VSS.t1326 VDD VSS.t1325 VSS.t311 sg13_lv_nmos ad=0.1428p pd=1.52u as=0 ps=0 w=0.42u l=1u
X4180 VDD VSS.t2766 VDD VDD sg13_lv_pmos ad=0.19p pd=1.38u as=0 ps=0 w=1u l=1u
X4181 VSS.t1654 VDD VSS.t1653 VSS.t1652 sg13_lv_nmos ad=0.1428p pd=1.52u as=0 ps=0 w=0.42u l=1u
X4182 VSS.t3178 VDD VSS.t3177 VSS.t3176 sg13_lv_nmos ad=0.1428p pd=1.52u as=0 ps=0 w=0.42u l=1u
X4183 VSS.t2388 VDD VSS.t2387 VSS.t2386 sg13_lv_nmos ad=0.1428p pd=1.52u as=0 ps=0 w=0.42u l=1u
X4184 VSS.t2001 VDD VSS.t2003 VSS.t2002 sg13_lv_nmos ad=79.8f pd=0.8u as=0 ps=0 w=0.42u l=1u
X4185 VDD clock_i a_15022_14484# VDD sg13_lv_pmos ad=0.2128p pd=1.5u as=0.2128p ps=1.5u w=1.12u l=0.13u
X4186 VSS.t1289 VDD VSS.t1290 VSS.t311 sg13_lv_nmos ad=79.8f pd=0.8u as=0 ps=0 w=0.42u l=1u
X4187 VSS.t349 a_27407_13799# a_28074_14020# VSS.t433 sg13_lv_nmos ad=0.1406p pd=1.12u as=0.2516p ps=2.16u w=0.74u l=0.13u
X4188 VSS.t526 VDD VSS.t528 VSS.t527 sg13_lv_nmos ad=79.8f pd=0.8u as=0 ps=0 w=0.42u l=1u
X4189 VSS.t39 sg13g2_dlygate4sd3_1_8.X a_7829_15238# VSS.t126 sg13_lv_nmos ad=0.1898p pd=1.36u as=0.2516p ps=2.16u w=0.74u l=0.13u
X4190 VDD VSS.t1370 VDD VDD sg13_lv_pmos ad=0.19p pd=1.38u as=0 ps=0 w=1u l=1u
X4191 VDD VSS.t2873 VDD VDD sg13_lv_pmos ad=0.19p pd=1.38u as=0 ps=0 w=1u l=1u
X4192 VDD VSS.t771 VDD VDD sg13_lv_pmos ad=0.34p pd=2.68u as=0 ps=0 w=1u l=1u
X4193 VDD VSS.t1608 VDD VDD sg13_lv_pmos ad=0.34p pd=2.68u as=0 ps=0 w=1u l=1u
X4194 VSS.t2797 VDD VSS.t2799 VSS.t392 sg13_lv_nmos ad=79.8f pd=0.8u as=0 ps=0 w=0.42u l=1u
X4195 VSS.t2578 VDD VSS.t2577 VSS.t2576 sg13_lv_nmos ad=0.1428p pd=1.52u as=0 ps=0 w=0.42u l=1u
X4196 VDD VSS.t2517 VDD VDD sg13_lv_pmos ad=0.34p pd=2.68u as=0 ps=0 w=1u l=1u
X4197 VDD VSS.t589 VDD VDD sg13_lv_pmos ad=0.19p pd=1.38u as=0 ps=0 w=1u l=1u
X4198 a_19438_13726# sg13g2_buf_16_2.A VDD VDD sg13_lv_pmos ad=0.2128p pd=1.5u as=0.3808p ps=2.92u w=1.12u l=0.13u
X4199 VSS.t2408 VDD VSS.t2407 VSS.t2406 sg13_lv_nmos ad=0.1428p pd=1.52u as=0 ps=0 w=0.42u l=1u
X4200 VDD VSS.t2028 VDD VDD sg13_lv_pmos ad=0.19p pd=1.38u as=0 ps=0 w=1u l=1u
X4201 VSS.t1043 VDD VSS.t1042 VSS.t1041 sg13_lv_nmos ad=0.1428p pd=1.52u as=0 ps=0 w=0.42u l=1u
X4202 VSS.t1744 VDD VSS.t1743 VSS.t1742 sg13_lv_nmos ad=0.1428p pd=1.52u as=0 ps=0 w=0.42u l=1u
X4203 VDD VSS.t1095 VDD VDD sg13_lv_pmos ad=0.19p pd=1.38u as=0 ps=0 w=1u l=1u
X4204 VSS.t1344 VDD VSS.t1343 VSS.t311 sg13_lv_nmos ad=0.1428p pd=1.52u as=0 ps=0 w=0.42u l=1u
X4205 VSS.t2862 VDD VSS.t2861 VSS.t392 sg13_lv_nmos ad=0.1428p pd=1.52u as=0 ps=0 w=0.42u l=1u
X4206 VDD VSS.t2435 VDD VDD sg13_lv_pmos ad=0.19p pd=1.38u as=0 ps=0 w=1u l=1u
X4207 VSS.t2126 VDD VSS.t2125 VSS.t2124 sg13_lv_nmos ad=0.1428p pd=1.52u as=0 ps=0 w=0.42u l=1u
X4208 VSS.t707 VDD VSS.t707 VSS.t709 sg13_lv_nmos ad=79.8f pd=0.8u as=0 ps=0 w=0.42u l=1u
X4209 VDD VSS.t557 VDD VDD sg13_lv_pmos ad=0.34p pd=2.68u as=0 ps=0 w=1u l=1u
X4210 VDD VSS.t1386 VDD VDD sg13_lv_pmos ad=0.34p pd=2.68u as=0 ps=0 w=1u l=1u
X4211 VDD VSS.t2190 VDD VDD sg13_lv_pmos ad=0.34p pd=2.68u as=0 ps=0 w=1u l=1u
X4212 VSS.t18 a_14357_15238# sg13g2_or3_1_1.B VSS.t17 sg13_lv_nmos ad=0.2516p pd=2.16u as=0.1406p ps=1.12u w=0.74u l=0.13u
X4213 VDD VSS.t2560 VDD VDD sg13_lv_pmos ad=0.19p pd=1.38u as=0 ps=0 w=1u l=1u
X4214 VSS.t2041 VDD VSS.t2043 VSS.t2042 sg13_lv_nmos ad=79.8f pd=0.8u as=0 ps=0 w=0.42u l=1u
X4215 VDD VSS.t2218 VDD VDD sg13_lv_pmos ad=0.19p pd=1.38u as=0 ps=0 w=1u l=1u
X4216 VDD VSS.t466 VDD VDD sg13_lv_pmos ad=0.34p pd=2.68u as=0 ps=0 w=1u l=1u
X4217 sg13g2_and2_1_2.X a_8685_14832# VSS.t105 VSS.t117 sg13_lv_nmos ad=0.2516p pd=2.16u as=0.1331p ps=1.12u w=0.74u l=0.13u
X4218 VDD VSS.t1993 VDD VDD sg13_lv_pmos ad=0.19p pd=1.38u as=0 ps=0 w=1u l=1u
X4219 VSS.t2880 VDD VSS.t2881 VSS.t392 sg13_lv_nmos ad=79.8f pd=0.8u as=0 ps=0 w=0.42u l=1u
X4220 VDD VSS.t2759 VDD VDD sg13_lv_pmos ad=0.19p pd=1.38u as=0 ps=0 w=1u l=1u
X4221 VDD VSS.t2836 VDD VDD sg13_lv_pmos ad=0.19p pd=1.38u as=0 ps=0 w=1u l=1u
X4222 VSS.t768 VDD VSS.t768 VSS.t769 sg13_lv_nmos ad=79.8f pd=0.8u as=0 ps=0 w=0.42u l=1u
X4223 VSS.t1379 VDD VSS.t1380 VSS.t311 sg13_lv_nmos ad=79.8f pd=0.8u as=0 ps=0 w=0.42u l=1u
X4224 VSS.t1674 VDD VSS.t1673 VSS.t1672 sg13_lv_nmos ad=0.1428p pd=1.52u as=0 ps=0 w=0.42u l=1u
X4225 VSS.t2373 VDD VSS.t2372 VSS.t2371 sg13_lv_nmos ad=0.1428p pd=1.52u as=0 ps=0 w=0.42u l=1u
X4226 sg13g2_a21oi_1_3.Y sg13g2_a21oi_1_3.A1 a_25203_13320# VSS.t178 sg13_lv_nmos ad=0.1406p pd=1.12u as=0.1406p ps=1.12u w=0.74u l=0.13u
X4227 VDD VSS.t970 VDD VDD sg13_lv_pmos ad=0.19p pd=1.38u as=0 ps=0 w=1u l=1u
X4228 VSS.t1013 VDD VSS.t1012 VSS.t1011 sg13_lv_nmos ad=0.1428p pd=1.52u as=0 ps=0 w=0.42u l=1u
X4229 VSS.t245 VDD VSS.t245 VSS.t564 sg13_lv_nmos ad=79.8f pd=0.8u as=0 ps=0 w=0.42u l=1u
X4230 VSS.t621 VDD VSS.t622 VSS.t9 sg13_lv_nmos ad=79.8f pd=0.8u as=0 ps=0 w=0.42u l=1u
X4231 VDD VSS.t338 VDD VDD sg13_lv_pmos ad=0.19p pd=1.38u as=0 ps=0 w=1u l=1u
X4232 VDD VSS.t1648 VDD VDD sg13_lv_pmos ad=0.34p pd=2.68u as=0 ps=0 w=1u l=1u
X4233 VSS.t827 VDD VSS.t303 VSS.t826 sg13_lv_nmos ad=0.1428p pd=1.52u as=0 ps=0 w=0.42u l=1u
X4234 VSS.t2448 VDD VSS.t2447 VSS.t2446 sg13_lv_nmos ad=0.1428p pd=1.52u as=0 ps=0 w=0.42u l=1u
X4235 VDD VSS.t455 VDD VDD sg13_lv_pmos ad=0.34p pd=2.68u as=0 ps=0 w=1u l=1u
X4236 VSS.t2809 VDD VSS.t2811 VSS.t392 sg13_lv_nmos ad=79.8f pd=0.8u as=0 ps=0 w=0.42u l=1u
X4237 a_23736_14464# sg13g2_or3_1_2.B VDD VDD sg13_lv_pmos ad=0.2128p pd=1.5u as=0.3808p ps=2.92u w=1.12u l=0.15u
X4238 VDD VSS.t736 VDD VDD sg13_lv_pmos ad=0.34p pd=2.68u as=0 ps=0 w=1u l=1u
X4239 VDD VSS.t1856 VDD VDD sg13_lv_pmos ad=0.19p pd=1.38u as=0 ps=0 w=1u l=1u
X4240 VDD VSS.t3145 VDD VDD sg13_lv_pmos ad=0.19p pd=1.38u as=0 ps=0 w=1u l=1u
X4241 VSS.t2878 VDD VSS.t2879 VSS.t392 sg13_lv_nmos ad=79.8f pd=0.8u as=0 ps=0 w=0.42u l=1u
X4242 sg13g2_buf_16_2.A a_15022_14484# VDD VDD sg13_lv_pmos ad=0.2128p pd=1.5u as=0.2128p ps=1.5u w=1.12u l=0.13u
X4243 VDD VSS.t1062 VDD VDD sg13_lv_pmos ad=0.34p pd=2.68u as=0 ps=0 w=1u l=1u
X4244 sg13g2_buf_16_2.A a_15022_14484# VDD VDD sg13_lv_pmos ad=0.2128p pd=1.5u as=0.2128p ps=1.5u w=1.12u l=0.13u
X4245 VDD VSS.t681 VDD VDD sg13_lv_pmos ad=0.19p pd=1.38u as=0 ps=0 w=1u l=1u
X4246 a_24935_14020# sg13g2_or3_1_1.C a_24841_13726# VDD sg13_lv_pmos ad=0.19p pd=1.38u as=0.34p ps=2.68u w=1u l=0.13u
X4247 VSS.t681 VDD VSS.t681 VSS.t680 sg13_lv_nmos ad=0.1428p pd=1.52u as=0 ps=0 w=0.42u l=1u
X4248 VSS.t2785 VDD VSS.t2787 VSS.t392 sg13_lv_nmos ad=79.8f pd=0.8u as=0 ps=0 w=0.42u l=1u
X4249 VDD VSS.t2210 VDD VDD sg13_lv_pmos ad=0.34p pd=2.68u as=0 ps=0 w=1u l=1u
X4250 VDD VSS.t607 VDD VDD sg13_lv_pmos ad=0.19p pd=1.38u as=0 ps=0 w=1u l=1u
X4251 VDD VSS.t1377 VDD VDD sg13_lv_pmos ad=0.34p pd=2.68u as=0 ps=0 w=1u l=1u
X4252 VDD VSS.t2879 VDD VDD sg13_lv_pmos ad=0.34p pd=2.68u as=0 ps=0 w=1u l=1u
X4253 VSS.t3163 VDD VSS.t3165 VSS.t3164 sg13_lv_nmos ad=79.8f pd=0.8u as=0 ps=0 w=0.42u l=1u
X4254 sg13g2_dfrbpq_1_2.RESET_B a_16254_15934# VDD VDD sg13_lv_pmos ad=0.3927p pd=2.99u as=2.8961p ps=18.25u w=1.155u l=0.13u
X4255 VDD VSS.t508 VDD VDD sg13_lv_pmos ad=0.19p pd=1.38u as=0 ps=0 w=1u l=1u
X4256 a_2890_15457# a_3333_15213# a_2630_15234# VSS.t249 sg13_lv_nmos ad=79.8f pd=0.8u as=0.1296p ps=1.52u w=0.42u l=0.13u
X4257 a_22030_15423# a_22145_15424# VSS.t23 VSS.t22 sg13_lv_nmos ad=0.1428p pd=1.52u as=0.1426p ps=1.16u w=0.42u l=0.5u
X4258 VSS.t777 VDD VSS.t895 VSS.t894 sg13_lv_nmos ad=0.1428p pd=1.52u as=0 ps=0 w=0.42u l=1u
X4259 VDD VSS.t2380 VDD VDD sg13_lv_pmos ad=0.19p pd=1.38u as=0 ps=0 w=1u l=1u
X4260 VDD VSS.t481 VDD VDD sg13_lv_pmos ad=0.19p pd=1.38u as=0 ps=0 w=1u l=1u
X4261 VDD VSS.t1125 VDD VDD sg13_lv_pmos ad=0.19p pd=1.38u as=0 ps=0 w=1u l=1u
X4262 VSS.t603 VDD VSS.t602 VSS.t9 sg13_lv_nmos ad=0.1428p pd=1.52u as=0 ps=0 w=0.42u l=1u
X4263 VDD VSS.t2170 VDD VDD sg13_lv_pmos ad=0.34p pd=2.68u as=0 ps=0 w=1u l=1u
X4264 VSS.t736 VDD VSS.t739 VSS.t869 sg13_lv_nmos ad=79.8f pd=0.8u as=0 ps=0 w=0.42u l=1u
X4265 VDD VSS.t3295 VDD VDD sg13_lv_pmos ad=0.19p pd=1.38u as=0 ps=0 w=1u l=1u
X4266 VSS.t1986 VDD VSS.t1988 VSS.t1987 sg13_lv_nmos ad=79.8f pd=0.8u as=0 ps=0 w=0.42u l=1u
X4267 a_21477_14495# sg13g2_buf_16_2.X VDD VDD sg13_lv_pmos ad=0.4088p pd=2.97u as=2.3367p ps=15.135u w=1.12u l=0.13u
X4268 VDD VSS.t1668 VDD VDD sg13_lv_pmos ad=0.34p pd=2.68u as=0 ps=0 w=1u l=1u
X4269 VSS.t2784 VDD VSS.t2785 VSS.t392 sg13_lv_nmos ad=79.8f pd=0.8u as=0 ps=0 w=0.42u l=1u
X4270 VSS.t506 VDD VSS.t231 VSS.t505 sg13_lv_nmos ad=0.1428p pd=1.52u as=0 ps=0 w=0.42u l=1u
X4271 VDD VSS.t1 VDD VDD sg13_lv_pmos ad=0.34p pd=2.68u as=0 ps=0 w=1u l=1u
X4272 VDD VSS.t2005 VDD VDD sg13_lv_pmos ad=0.34p pd=2.68u as=0 ps=0 w=1u l=1u
X4273 VSS.t2888 VDD VSS.t2887 VSS.t392 sg13_lv_nmos ad=0.1428p pd=1.52u as=0 ps=0 w=0.42u l=1u
X4274 VDD VSS.t2843 VDD VDD sg13_lv_pmos ad=0.34p pd=2.68u as=0 ps=0 w=1u l=1u
X4275 VSS.t1043 VDD VSS.t1042 VSS.t1041 sg13_lv_nmos ad=0.1428p pd=1.52u as=0 ps=0 w=0.42u l=1u
X4276 VDD VSS.t723 VDD VDD sg13_lv_pmos ad=0.19p pd=1.38u as=0 ps=0 w=1u l=1u
X4277 VDD VSS.t1025 VDD VDD sg13_lv_pmos ad=0.19p pd=1.38u as=0 ps=0 w=1u l=1u
X4278 VSS.t2393 VDD VSS.t2392 VSS.t2391 sg13_lv_nmos ad=0.1428p pd=1.52u as=0 ps=0 w=0.42u l=1u
X4279 VSS.t723 VDD VSS.t78 VSS.t842 sg13_lv_nmos ad=0.1428p pd=1.52u as=0 ps=0 w=0.42u l=1u
X4280 VDD VSS.t1417 VDD VDD sg13_lv_pmos ad=0.19p pd=1.38u as=0 ps=0 w=1u l=1u
X4281 VSS.t1729 VDD VSS.t1728 VSS.t1727 sg13_lv_nmos ad=0.1428p pd=1.52u as=0 ps=0 w=0.42u l=1u
X4282 a_15022_14484# clock_i VDD VDD sg13_lv_pmos ad=0.2128p pd=1.5u as=0.2128p ps=1.5u w=1.12u l=0.13u
X4283 VSS.t1402 VDD VSS.t1401 VSS.t311 sg13_lv_nmos ad=0.1428p pd=1.52u as=0 ps=0 w=0.42u l=1u
X4284 VSS.t2776 VDD VSS.t2778 VSS.t392 sg13_lv_nmos ad=79.8f pd=0.8u as=0 ps=0 w=0.42u l=1u
X4285 VSS.t2854 VDD VSS.t2853 VSS.t392 sg13_lv_nmos ad=0.1428p pd=1.52u as=0 ps=0 w=0.42u l=1u
X4286 VDD VSS.t2597 VDD VDD sg13_lv_pmos ad=0.34p pd=2.68u as=0 ps=0 w=1u l=1u
X4287 VDD VSS.t2793 VDD VDD sg13_lv_pmos ad=0.19p pd=1.38u as=0 ps=0 w=1u l=1u
X4288 VSS.t2096 VDD VSS.t2098 VSS.t2097 sg13_lv_nmos ad=79.8f pd=0.8u as=0 ps=0 w=0.42u l=1u
X4289 VDD VSS.t962 VDD VDD sg13_lv_pmos ad=0.34p pd=2.68u as=0 ps=0 w=1u l=1u
X4290 VDD VSS.t3090 VDD VDD sg13_lv_pmos ad=0.19p pd=1.38u as=0 ps=0 w=1u l=1u
X4291 VSS.t2433 VDD VSS.t2432 VSS.t2431 sg13_lv_nmos ad=0.1428p pd=1.52u as=0 ps=0 w=0.42u l=1u
X4292 a_6682_13690# sg13g2_dlygate4sd3_1_0.A VDD VDD sg13_lv_pmos ad=0.1428p pd=1.52u as=0.1523p ps=1.38u w=0.42u l=0.13u
X4293 VDD VSS.t754 VDD VDD sg13_lv_pmos ad=0.34p pd=2.68u as=0 ps=0 w=1u l=1u
X4294 VSS.t2206 VDD VSS.t2205 VSS.t2204 sg13_lv_nmos ad=0.1428p pd=1.52u as=0 ps=0 w=0.42u l=1u
X4295 VSS.t1442 VDD VSS.t1441 VSS.t311 sg13_lv_nmos ad=0.1428p pd=1.52u as=0 ps=0 w=0.42u l=1u
X4296 VDD VSS.t2545 VDD VDD sg13_lv_pmos ad=0.19p pd=1.38u as=0 ps=0 w=1u l=1u
X4297 VDD VSS.t2203 VDD VDD sg13_lv_pmos ad=0.19p pd=1.38u as=0 ps=0 w=1u l=1u
X4298 VDD VSS.t13 VDD VDD sg13_lv_pmos ad=0.34p pd=2.68u as=0 ps=0 w=1u l=1u
X4299 VDD VSS.t900 VDD VDD sg13_lv_pmos ad=0.19p pd=1.38u as=0 ps=0 w=1u l=1u
X4300 VSS.t13 sg13g2_buf_16_2.A a_12020_15202# VSS.t399 sg13_lv_nmos ad=0.1406p pd=1.12u as=0.1406p ps=1.12u w=0.74u l=0.13u
X4301 VSS.t172 VDD VSS.t172 VSS.t851 sg13_lv_nmos ad=0.1428p pd=1.52u as=0 ps=0 w=0.42u l=1u
X4302 VDD VSS.t1978 VDD VDD sg13_lv_pmos ad=0.19p pd=1.38u as=0 ps=0 w=1u l=1u
X4303 VDD VSS.t2497 VDD VDD sg13_lv_pmos ad=0.34p pd=2.68u as=0 ps=0 w=1u l=1u
X4304 VSS.t1659 VDD VSS.t1658 VSS.t1657 sg13_lv_nmos ad=0.1428p pd=1.52u as=0 ps=0 w=0.42u l=1u
X4305 VSS.t541 VDD VSS.t540 VSS.t539 sg13_lv_nmos ad=0.1428p pd=1.52u as=0 ps=0 w=0.42u l=1u
X4306 VDD VSS.t712 VDD VDD sg13_lv_pmos ad=0.19p pd=1.38u as=0 ps=0 w=1u l=1u
X4307 VDD VSS.t1015 VDD VDD sg13_lv_pmos ad=0.19p pd=1.38u as=0 ps=0 w=1u l=1u
X4308 VSS.t637 VDD VSS.t36 VSS.t638 sg13_lv_nmos ad=79.8f pd=0.8u as=0 ps=0 w=0.42u l=1u
X4309 VDD VSS.t2073 VDD VDD sg13_lv_pmos ad=0.19p pd=1.38u as=0 ps=0 w=1u l=1u
X4310 VDD VSS.t1312 VDD VDD sg13_lv_pmos ad=0.34p pd=2.68u as=0 ps=0 w=1u l=1u
X4311 VDD a_7631_14845# a_7888_14726# VDD sg13_lv_pmos ad=2.42015p pd=15.68u as=79.8f ps=0.8u w=0.42u l=0.13u
X4312 VSS.t2898 VDD VSS.t2897 VSS.t392 sg13_lv_nmos ad=0.1428p pd=1.52u as=0 ps=0 w=0.42u l=1u
X4313 VSS.t2801 VDD VSS.t2802 VSS.t392 sg13_lv_nmos ad=79.8f pd=0.8u as=0 ps=0 w=0.42u l=1u
X4314 VSS.t754 VDD VSS.t757 VSS.t881 sg13_lv_nmos ad=79.8f pd=0.8u as=0 ps=0 w=0.42u l=1u
X4315 sg13g2_dlygate4sd3_1_1.A a_8298_14484# VDD VDD sg13_lv_pmos ad=0.3808p pd=2.92u as=0.2128p ps=1.5u w=1.12u l=0.13u
X4316 VDD VSS.t1786 VDD VDD sg13_lv_pmos ad=0.19p pd=1.38u as=0 ps=0 w=1u l=1u
X4317 VDD VSS.t1841 VDD VDD sg13_lv_pmos ad=0.19p pd=1.38u as=0 ps=0 w=1u l=1u
X4318 VDD VSS.t2440 VDD VDD sg13_lv_pmos ad=0.19p pd=1.38u as=0 ps=0 w=1u l=1u
X4319 VDD VSS.t2565 VDD VDD sg13_lv_pmos ad=0.19p pd=1.38u as=0 ps=0 w=1u l=1u
X4320 VSS.t2046 VDD VSS.t2048 VSS.t2047 sg13_lv_nmos ad=79.8f pd=0.8u as=0 ps=0 w=0.42u l=1u
X4321 VDD VSS.t2223 VDD VDD sg13_lv_pmos ad=0.19p pd=1.38u as=0 ps=0 w=1u l=1u
X4322 VSS.t923 VDD VSS.t925 VSS.t924 sg13_lv_nmos ad=79.8f pd=0.8u as=0 ps=0 w=0.42u l=1u
X4323 VDD VSS.t2761 VDD VDD sg13_lv_pmos ad=0.19p pd=1.38u as=0 ps=0 w=1u l=1u
X4324 VSS.t83 a_25390_16263# sg13g2_dlygate4sd3_1_12.X VSS.t232 sg13_lv_nmos ad=0.1426p pd=1.16u as=0.2516p ps=2.16u w=0.74u l=0.13u
X4325 VSS.t3168 VDD VSS.t3167 VSS.t3166 sg13_lv_nmos ad=0.1428p pd=1.52u as=0 ps=0 w=0.42u l=1u
X4326 VSS.t2378 VDD VSS.t2377 VSS.t2376 sg13_lv_nmos ad=0.1428p pd=1.52u as=0 ps=0 w=0.42u l=1u
X4327 VSS.t188 a_12020_15202# sg13g2_dfrbpq_1_2.CLK VSS.t198 sg13_lv_nmos ad=0.1406p pd=1.12u as=0.1406p ps=1.12u w=0.74u l=0.13u
X4328 a_24310_15230# sg13g2_or3_1_1.C VSS.t26 VSS.t24 sg13_lv_nmos ad=0.1406p pd=1.12u as=0.1406p ps=1.12u w=0.74u l=0.15u
X4329 VDD VSS.t982 VDD VDD sg13_lv_pmos ad=0.34p pd=2.68u as=0 ps=0 w=1u l=1u
X4330 VSS.t2548 VDD VSS.t2550 VSS.t2549 sg13_lv_nmos ad=79.8f pd=0.8u as=0 ps=0 w=0.42u l=1u
X4331 sg13g2_dlygate4sd3_1_8.A a_11370_15532# VSS.t36 VSS.t131 sg13_lv_nmos ad=0.2516p pd=2.16u as=0.1406p ps=1.12u w=0.74u l=0.13u
X4332 VDD VSS.t1653 VDD VDD sg13_lv_pmos ad=0.34p pd=2.68u as=0 ps=0 w=1u l=1u
X4333 VSS.t2775 VDD VSS.t2776 VSS.t392 sg13_lv_nmos ad=79.8f pd=0.8u as=0 ps=0 w=0.42u l=1u
X4334 VSS.t213 sg13g2_buf_1_0.X a_2646_14842# VSS.t260 sg13_lv_nmos ad=0.15245p pd=1.17u as=88.8f ps=0.98u w=0.74u l=0.13u
X4335 a_6660_14909# a_6891_14495# a_6346_14452# VSS.t115 sg13_lv_nmos ad=0.2373p pd=1.97u as=79.8f ps=0.8u w=0.42u l=0.13u
X4336 VSS.t1341 VDD VSS.t1342 VSS.t311 sg13_lv_nmos ad=79.8f pd=0.8u as=0 ps=0 w=0.42u l=1u
X4337 VSS.t2453 VDD VSS.t2452 VSS.t2451 sg13_lv_nmos ad=0.1428p pd=1.52u as=0 ps=0 w=0.42u l=1u
X4338 VSS.t155 a_26565_13701# a_26667_13844# VSS.t314 sg13_lv_nmos ad=15.10457p pd=99.59499u as=0.2516p ps=2.16u w=0.74u l=0.13u
X4339 VDD VSS.t742 VDD VDD sg13_lv_pmos ad=0.19p pd=1.38u as=0 ps=0 w=1u l=1u
X4340 VSS.t1714 VDD VSS.t1716 VSS.t1715 sg13_lv_nmos ad=79.8f pd=0.8u as=0 ps=0 w=0.42u l=1u
X4341 VSS.t739 VDD VSS.t736 VSS.t738 sg13_lv_nmos ad=0.1428p pd=1.52u as=0 ps=0 w=0.42u l=1u
X4342 sg13g2_and2_1_1.X a_5613_14832# VSS.t58 VSS.t49 sg13_lv_nmos ad=0.2516p pd=2.16u as=0.1331p ps=1.12u w=0.74u l=0.13u
X4343 VDD VSS.t1990 VDD VDD sg13_lv_pmos ad=0.34p pd=2.68u as=0 ps=0 w=1u l=1u
X4344 VDD VSS.t2835 VDD VDD sg13_lv_pmos ad=0.34p pd=2.68u as=0 ps=0 w=1u l=1u
X4345 VSS.t1018 VDD VSS.t1017 VSS.t1016 sg13_lv_nmos ad=0.1428p pd=1.52u as=0 ps=0 w=0.42u l=1u
X4346 VDD VSS.t3150 VDD VDD sg13_lv_pmos ad=0.19p pd=1.38u as=0 ps=0 w=1u l=1u
X4347 VSS.t2881 VDD VSS.t2881 VSS.t392 sg13_lv_nmos ad=79.8f pd=0.8u as=0 ps=0 w=0.42u l=1u
X4348 VSS.t1346 VDD VSS.t1347 VSS.t311 sg13_lv_nmos ad=79.8f pd=0.8u as=0 ps=0 w=0.42u l=1u
X4349 VDD VSS.t2018 VDD VDD sg13_lv_pmos ad=0.19p pd=1.38u as=0 ps=0 w=1u l=1u
X4350 VSS.t938 VDD VSS.t940 VSS.t939 sg13_lv_nmos ad=79.8f pd=0.8u as=0 ps=0 w=0.42u l=1u
X4351 VSS.t2768 VDD VSS.t2769 VSS.t392 sg13_lv_nmos ad=79.8f pd=0.8u as=0 ps=0 w=0.42u l=1u
X4352 a_25390_16263# a_25505_16262# VSS.t83 VSS.t170 sg13_lv_nmos ad=0.1428p pd=1.52u as=0.1426p ps=1.16u w=0.42u l=0.5u
X4353 VDD VSS.t2582 VDD VDD sg13_lv_pmos ad=0.34p pd=2.68u as=0 ps=0 w=1u l=1u
X4354 VSS.t2081 VDD VSS.t2083 VSS.t2082 sg13_lv_nmos ad=79.8f pd=0.8u as=0 ps=0 w=0.42u l=1u
X4355 VDD VSS.t1380 VDD VDD sg13_lv_pmos ad=0.34p pd=2.68u as=0 ps=0 w=1u l=1u
X4356 VDD VSS.t2881 VDD VDD sg13_lv_pmos ad=0.34p pd=2.68u as=0 ps=0 w=1u l=1u
X4357 a_17710_15423# a_17825_15424# VDD VDD sg13_lv_pmos ad=0.34p pd=2.68u as=0.2254p ps=1.53u w=1u l=0.5u
X4358 VDD VSS.t2385 VDD VDD sg13_lv_pmos ad=0.19p pd=1.38u as=0 ps=0 w=1u l=1u
X4359 VDD VSS.t945 VDD VDD sg13_lv_pmos ad=0.19p pd=1.38u as=0 ps=0 w=1u l=1u
X4360 VDD VSS.t2482 VDD VDD sg13_lv_pmos ad=0.34p pd=2.68u as=0 ps=0 w=1u l=1u
X4361 VSS.t707 VDD VSS.t707 VSS.t709 sg13_lv_nmos ad=79.8f pd=0.8u as=0 ps=0 w=0.42u l=1u
X4362 VDD VSS.t712 VDD VDD sg13_lv_pmos ad=0.19p pd=1.38u as=0 ps=0 w=1u l=1u
X4363 VSS.t2568 VDD VSS.t2570 VSS.t2569 sg13_lv_nmos ad=79.8f pd=0.8u as=0 ps=0 w=0.42u l=1u
X4364 VSS.t1991 VDD VSS.t1993 VSS.t1992 sg13_lv_nmos ad=79.8f pd=0.8u as=0 ps=0 w=0.42u l=1u
X4365 a_7822_13911# a_7937_13912# VSS.t54 VSS.t291 sg13_lv_nmos ad=0.1428p pd=1.52u as=0.1426p ps=1.16u w=0.42u l=0.5u
X4366 VSS.t2766 VDD VSS.t2767 VSS.t392 sg13_lv_nmos ad=79.8f pd=0.8u as=0 ps=0 w=0.42u l=1u
X4367 VDD VSS.t1446 VDD VDD sg13_lv_pmos ad=0.19p pd=1.38u as=0 ps=0 w=1u l=1u
X4368 VDD VSS.t2235 VDD VDD sg13_lv_pmos ad=0.34p pd=2.68u as=0 ps=0 w=1u l=1u
X4369 VDD VSS.t2058 VDD VDD sg13_lv_pmos ad=0.19p pd=1.38u as=0 ps=0 w=1u l=1u
X4370 VSS.t347 sg13g2_xnor2_1_1.A a_17219_16265# VSS.t381 sg13_lv_nmos ad=0.1045p pd=0.93u as=0.198p ps=1.27u w=0.55u l=0.13u
X4371 sg13g2_nand3_1_0.Y sg13g2_buf_1_0.X a_6680_15242# VSS.t257 sg13_lv_nmos ad=0.2516p pd=2.16u as=0.1406p ps=1.12u w=0.74u l=0.13u
X4372 a_6286_13911# a_6401_13912# VSS.t224 VSS.t223 sg13_lv_nmos ad=0.1428p pd=1.52u as=0.1426p ps=1.16u w=0.42u l=0.5u
X4373 VSS.t245 VDD VSS.t245 VSS.t566 sg13_lv_nmos ad=0.1428p pd=1.52u as=0 ps=0 w=0.42u l=1u
X4374 VDD VSS.t2010 VDD VDD sg13_lv_pmos ad=0.34p pd=2.68u as=0 ps=0 w=1u l=1u
X4375 VSS.t3013 VDD VSS.t2889 VSS.t392 sg13_lv_nmos ad=0.1428p pd=1.52u as=0 ps=0 w=0.42u l=1u
X4376 VDD VSS.t2917 VDD VDD sg13_lv_pmos ad=0.34p pd=2.68u as=0 ps=0 w=1u l=1u
X4377 VDD VSS.t2845 VDD VDD sg13_lv_pmos ad=0.34p pd=2.68u as=0 ps=0 w=1u l=1u
X4378 VSS.t1292 VDD VSS.t1293 VSS.t311 sg13_lv_nmos ad=79.8f pd=0.8u as=0 ps=0 w=0.42u l=1u
X4379 VDD VSS.t2183 VDD VDD sg13_lv_pmos ad=0.19p pd=1.38u as=0 ps=0 w=1u l=1u
X4380 VDD a_2540_15960# counter_value_o[0] VDD sg13_lv_pmos ad=0.2114p pd=1.54u as=0.42p ps=2.99u w=1.12u l=0.13u
X4381 sg13g2_buf_16_2.X a_19438_13726# VDD VDD sg13_lv_pmos ad=0.2128p pd=1.5u as=0.2128p ps=1.5u w=1.12u l=0.13u
X4382 VSS.t1093 VDD VSS.t1095 VSS.t1094 sg13_lv_nmos ad=79.8f pd=0.8u as=0 ps=0 w=0.42u l=1u
X4383 VSS.t3028 VDD VSS.t3030 VSS.t3029 sg13_lv_nmos ad=79.8f pd=0.8u as=0 ps=0 w=0.42u l=1u
X4384 sg13g2_dlygate4sd3_1_1.A a_8298_14484# VSS.t60 VSS.t182 sg13_lv_nmos ad=0.2516p pd=2.16u as=0.1406p ps=1.12u w=0.74u l=0.13u
X4385 VSS.t600 VDD VSS.t601 VSS.t9 sg13_lv_nmos ad=79.8f pd=0.8u as=0 ps=0 w=0.42u l=1u
X4386 VDD VSS.t777 VDD VDD sg13_lv_pmos ad=0.19p pd=1.38u as=0 ps=0 w=1u l=1u
X4387 VDD VSS.t1162 VDD VDD sg13_lv_pmos ad=0.34p pd=2.68u as=0 ps=0 w=1u l=1u
X4388 VSS.t1854 VDD VSS.t1856 VSS.t1855 sg13_lv_nmos ad=79.8f pd=0.8u as=0 ps=0 w=0.42u l=1u
X4389 VSS.t2857 VDD VSS.t2856 VSS.t392 sg13_lv_nmos ad=0.1428p pd=1.52u as=0 ps=0 w=0.42u l=1u
X4390 VDD VSS.t2602 VDD VDD sg13_lv_pmos ad=0.34p pd=2.68u as=0 ps=0 w=1u l=1u
X4391 VSS.t771 VDD VSS.t771 VSS.t890 sg13_lv_nmos ad=0.1428p pd=1.52u as=0 ps=0 w=0.42u l=1u
X4392 VSS.t2066 VDD VSS.t2068 VSS.t2067 sg13_lv_nmos ad=79.8f pd=0.8u as=0 ps=0 w=0.42u l=1u
X4393 VSS.t2211 VDD VSS.t2210 VSS.t2209 sg13_lv_nmos ad=0.1428p pd=1.52u as=0 ps=0 w=0.42u l=1u
X4394 VSS.t923 VDD VSS.t925 VSS.t924 sg13_lv_nmos ad=79.8f pd=0.8u as=0 ps=0 w=0.42u l=1u
X4395 VDD VSS.t912 VDD VDD sg13_lv_pmos ad=0.34p pd=2.68u as=0 ps=0 w=1u l=1u
X4396 VDD VSS.t2208 VDD VDD sg13_lv_pmos ad=0.19p pd=1.38u as=0 ps=0 w=1u l=1u
R0 VSS.t115 VSS.n1006 2.277e+06
R1 VSS.t118 VSS.n1016 1.34743e+06
R2 VSS.t392 VSS.n851 4108.7
R3 VSS.n866 VSS.n851 4108.7
R4 VSS.n867 VSS.n866 4108.7
R5 VSS.t311 VSS.n867 4108.7
R6 VSS.t311 VSS.n868 4108.7
R7 VSS.n1002 VSS.n868 4108.7
R8 VSS.n1003 VSS.n1002 4108.7
R9 VSS.n1004 VSS.n1003 3692.29
R10 VSS.t3044 VSS.n79 157.976
R11 VSS.n79 VSS.t3051 156.482
R12 VSS.n79 VSS.t3069 157.976
R13 VSS.n79 VSS.t3079 157.976
R14 VSS.n79 VSS.t3089 157.976
R15 VSS.n79 VSS.t3094 157.976
R16 VSS.n79 VSS.t3099 157.976
R17 VSS.n79 VSS.t3119 157.976
R18 VSS.n79 VSS.t3139 157.976
R19 VSS.n79 VSS.t3144 157.976
R20 VSS.n79 VSS.t3159 157.976
R21 VSS.n79 VSS.t3164 157.976
R22 VSS.t3169 VSS.n79 157.976
R23 VSS.n79 VSS.t3189 157.976
R24 VSS.n79 VSS.t3229 157.976
R25 VSS.n79 VSS.t3234 157.976
R26 VSS.n79 VSS.t3249 157.976
R27 VSS.n79 VSS.t3259 157.976
R28 VSS.n79 VSS.t3269 157.976
R29 VSS.t3284 VSS.n79 157.976
R30 VSS.n79 VSS.t3299 157.976
R31 VSS.t79 VSS.t75 612.602
R32 VSS.t392 VSS.n79 4425.74
R33 VSS.t2364 VSS.n69 109.986
R34 VSS.t2414 VSS.n69 109.992
R35 VSS.n69 VSS.t2446 109.001
R36 VSS.n69 VSS.t2461 109.001
R37 VSS.n69 VSS.t2476 109.001
R38 VSS.t2494 VSS.n69 109.992
R39 VSS.n69 VSS.t2516 108.999
R40 VSS.n69 VSS.t2536 108.999
R41 VSS.t2541 VSS.n69 108.999
R42 VSS.n69 VSS.t2556 108.999
R43 VSS.n69 VSS.t2579 109.992
R44 VSS.n69 VSS.t2606 108.999
R45 VSS.n71 VSS.t2017 109.992
R46 VSS.n71 VSS.t2027 109.993
R47 VSS.n71 VSS.t2097 109.992
R48 VSS.n71 VSS.t2124 108.999
R49 VSS.t2129 VSS.n71 108.999
R50 VSS.n71 VSS.t2134 108.999
R51 VSS.t2139 VSS.n71 108.999
R52 VSS.n71 VSS.t2184 108.999
R53 VSS.n71 VSS.t2217 109.992
R54 VSS.t1602 VSS.n75 109.001
R55 VSS.t1725 VSS.n75 109.992
R56 VSS.n75 VSS.t1757 108.999
R57 VSS.t1820 VSS.n75 109.992
R58 VSS.t936 VSS.n73 109.001
R59 VSS.n73 VSS.t951 109.001
R60 VSS.t976 VSS.n73 109.001
R61 VSS.t1056 VSS.n73 108.999
R62 VSS.t1066 VSS.n73 108.999
R63 VSS.n73 VSS.t1071 108.999
R64 VSS.t1086 VSS.n73 108.999
R65 VSS.n73 VSS.t1121 108.999
R66 VSS.n73 VSS.t1141 108.999
R67 VSS.n73 VSS.t1151 108.999
R68 VSS.t1156 VSS.n73 108.999
R69 VSS.n889 VSS.n885 427.132
R70 VSS.n992 VSS.n991 427.132
R71 VSS.n986 VSS.n985 427.132
R72 VSS.n1002 VSS.n1001 427.132
R73 VSS.n86 VSS.t9 2.91846
R74 VSS.n40 VSS.t257 424.017
R75 VSS.t270 VSS.n49 422.846
R76 VSS.n1129 VSS.t894 419.293
R77 VSS.n686 VSS.t205 418.56
R78 VSS.n1100 VSS.n1099 415.692
R79 VSS.n697 VSS.n892 415.67
R80 VSS.n69 VSS.n851 427.885
R81 VSS.n866 VSS.n72 427.885
R82 VSS.n867 VSS.n76 427.885
R83 VSS.n74 VSS.n868 427.885
R84 VSS.n1104 VSS.n1103 411.43
R85 VSS.n1106 VSS.n1105 411.43
R86 VSS.n1108 VSS.n1107 411.43
R87 VSS.n1110 VSS.n1109 411.43
R88 VSS.n1112 VSS.n1111 411.43
R89 VSS.n1114 VSS.n1113 411.43
R90 VSS.n1116 VSS.n1115 411.43
R91 VSS.n1118 VSS.n1117 411.43
R92 VSS.n1120 VSS.n1119 411.43
R93 VSS.n1122 VSS.n1121 411.43
R94 VSS.n1124 VSS.n1123 411.43
R95 VSS.n1137 VSS.n1136 411.43
R96 VSS.n1135 VSS.n1134 411.43
R97 VSS.n1133 VSS.n1132 411.43
R98 VSS.n1131 VSS.n1130 411.43
R99 VSS.n988 VSS.n987 411.43
R100 VSS.t304 VSS.n900 411.43
R101 VSS.n1003 VSS.n93 427.5
R102 VSS.t258 VSS.n928 408.31
R103 VSS.t73 VSS.n999 402.858
R104 VSS.t12 VSS.n910 402.858
R105 VSS.t252 VSS.n115 119.835
R106 VSS.n890 VSS.t366 398.572
R107 VSS.n994 VSS.t287 398.572
R108 VSS.t407 VSS.n982 398.572
R109 VSS.n1085 VSS.t331 398.572
R110 VSS.n1090 VSS.t332 398.572
R111 VSS.t218 VSS.n921 398.572
R112 VSS.t186 VSS.n1019 398.572
R113 VSS.n1021 VSS.t187 398.572
R114 VSS.t401 VSS.n911 398.572
R115 VSS.n1076 VSS.t298 398.572
R116 VSS.t299 VSS.n1073 398.572
R117 VSS.n42 VSS.t357 398.228
R118 VSS.t424 VSS.n793 397.755
R119 VSS.t361 VSS.n51 397.132
R120 VSS.n894 VSS.t178 394.286
R121 VSS.n1010 VSS.t72 391.118
R122 VSS.t49 VSS.n91 36.5344
R123 VSS.n55 VSS.t161 386.526
R124 VSS.n1091 VSS.t77 385.714
R125 VSS.n956 VSS.t6 385.714
R126 VSS.n46 VSS.t126 385.334
R127 VSS.t102 VSS.n50 384.274
R128 VSS.t67 VSS.n962 381.43
R129 VSS.n1059 VSS.t411 381.43
R130 VSS.t254 VSS.n957 381.43
R131 VSS.n45 VSS.t356 381.036
R132 VSS.t253 VSS.n40 381.036
R133 VSS.t419 VSS.n1046 378.714
R134 VSS.n814 VSS.t293 377.351
R135 VSS.t40 VSS.n964 377.144
R136 VSS.n1031 VSS.t14 377.144
R137 VSS.t314 VSS.n1100 376.724
R138 VSS.n55 VSS.t52 376.724
R139 VSS.t409 VSS.n904 372.858
R140 VSS.t399 VSS.n912 372.858
R141 VSS.t297 VSS.n909 372.858
R142 VSS.t300 VSS.n1072 372.858
R143 VSS.n1060 VSS.t144 372.858
R144 VSS.t147 VSS.n1056 372.858
R145 VSS.t429 VSS.n977 369.32
R146 VSS.t163 VSS.n895 368.572
R147 VSS.n1095 VSS.t280 368.572
R148 VSS.n968 VSS.t74 368.572
R149 VSS.t275 VSS.n39 368.142
R150 VSS.n38 VSS.t124 368.142
R151 VSS.n985 VSS.t404 362.846
R152 VSS.n683 VSS.t335 362.846
R153 VSS.n47 VSS.t183 363.127
R154 VSS.t403 VSS.n50 362.846
R155 VSS.n1046 VSS.t150 361.033
R156 VSS.n961 VSS.t250 361.033
R157 VSS.t274 VSS.n929 361.033
R158 VSS.t417 VSS.n955 360
R159 VSS.t315 VSS.n888 351.43
R160 VSS.n883 VSS.t348 351.43
R161 VSS.t294 VSS.n977 351.43
R162 VSS.n966 VSS.t367 351.43
R163 VSS.n86 VSS.t131 60.3116
R164 VSS.n1032 VSS.t16 351.43
R165 VSS.t269 VSS.n37 350.95
R166 VSS.n1013 VSS.t181 348.139
R167 VSS.t308 VSS.n979 347.144
R168 VSS.n905 VSS.t410 347.144
R169 VSS.t329 VSS.n1084 347.144
R170 VSS.t42 VSS.n920 347.144
R171 VSS.n1022 VSS.t190 347.144
R172 VSS.n1027 VSS.t398 347.144
R173 VSS.t301 VSS.n1071 347.144
R174 VSS.t148 VSS.n1055 347.144
R175 VSS.t3061 VSS.n79 156.482
R176 VSS.t3071 VSS.n79 156.482
R177 VSS.t3101 VSS.n79 156.482
R178 VSS.t3111 VSS.n79 156.482
R179 VSS.t3121 VSS.n79 156.482
R180 VSS.t3131 VSS.n79 156.482
R181 VSS.t3146 VSS.n79 156.482
R182 VSS.t3151 VSS.n79 156.482
R183 VSS.t3181 VSS.n79 156.482
R184 VSS.t3191 VSS.n79 156.482
R185 VSS.t3201 VSS.n79 156.482
R186 VSS.t3211 VSS.n79 156.482
R187 VSS.t3216 VSS.n79 156.482
R188 VSS.t3236 VSS.n79 156.482
R189 VSS.t3241 VSS.n79 156.482
R190 VSS.t3271 VSS.n79 156.482
R191 VSS.t3286 VSS.n79 156.482
R192 VSS.n79 VSS.t3301 156.482
R193 VSS.n1091 VSS.t376 342.858
R194 VSS.n1095 VSS.t427 342.858
R195 VSS.t57 VSS.n42 342.354
R196 VSS.n38 VSS.t222 342.354
R197 VSS.n991 VSS.t310 341.418
R198 VSS.t262 VSS.n923 339.543
R199 VSS.t306 VSS.n989 338.572
R200 VSS.t288 VSS.n965 338.572
R201 VSS.t53 VSS.n970 338.572
R202 VSS.t383 VSS.t143 338.572
R203 VSS.t416 VSS.n1039 337.046
R204 VSS.t268 VSS.n1007 335.245
R205 VSS.n79 VSS.t3049 157.976
R206 VSS.n1097 VSS.t439 329.168
R207 VSS.t289 VSS.n975 329.168
R208 VSS.n1042 VSS.t166 329.168
R209 VSS.n1037 VSS.t112 329.168
R210 VSS.n1052 VSS.t119 329.168
R211 VSS.t44 VSS.n1050 329.168
R212 VSS.n959 VSS.t212 329.168
R213 VSS.t256 VSS.t100 326.649
R214 VSS.n1102 VSS.t433 325.714
R215 VSS.t9 VSS.t272 321.486
R216 VSS.t9 VSS.n92 12.2567
R217 VSS.t316 VSS.n903 321.43
R218 VSS.t327 VSS.n1083 321.43
R219 VSS.t191 VSS.n917 321.43
R220 VSS.t200 VSS.n913 321.43
R221 VSS.t133 VSS.n1070 321.43
R222 VSS.n696 VSS.t168 319.99
R223 VSS.t98 VSS.n36 319.99
R224 VSS.n1012 VSS.t37 313.755
R225 VSS.n1016 VSS.t182 313.755
R226 VSS.n1000 VSS.t41 312.858
R227 VSS.t860 VSS.n887 305.159
R228 VSS.n1043 VSS.t0 305.159
R229 VSS.n1006 VSS.n934 305.159
R230 VSS.n998 VSS.t50 304.286
R231 VSS.n1054 VSS.t19 304.286
R232 VSS.t134 VSS.n1069 295.714
R233 VSS.n1063 VSS.t141 295.714
R234 VSS.t32 VSS.n1039 292.264
R235 VSS.t22 VSS.n1033 292.264
R236 VSS.n935 VSS.t220 292.264
R237 VSS.n989 VSS.t343 291.43
R238 VSS.t223 VSS.n965 291.43
R239 VSS.t291 VSS.n970 291.43
R240 VSS.t415 VSS.n1054 291.43
R241 VSS.n39 VSS.t94 290.779
R242 VSS.t3029 VSS.n79 157.972
R243 VSS.t3039 VSS.n79 157.976
R244 VSS.t3054 VSS.n79 157.976
R245 VSS.t3104 VSS.n79 157.976
R246 VSS.t3154 VSS.n79 157.976
R247 VSS.t3174 VSS.n79 157.976
R248 VSS.t3184 VSS.n79 157.976
R249 VSS.t3199 VSS.n79 157.976
R250 VSS.t3224 VSS.n79 157.976
R251 VSS.t3254 VSS.n79 157.976
R252 VSS.t3264 VSS.n79 157.976
R253 VSS.t3279 VSS.n79 157.976
R254 VSS.t3289 VSS.n79 157.976
R255 VSS.t3294 VSS.n79 157.976
R256 VSS.t3304 VSS.n79 157.976
R257 VSS.n958 VSS.t260 287.144
R258 VSS.n1041 VSS.t4 283.334
R259 VSS.n1037 VSS.t20 283.334
R260 VSS.t251 VSS.t179 279.37
R261 VSS.n887 VSS.t154 275.072
R262 VSS.n978 VSS.t95 275.072
R263 VSS.t152 VSS.n1033 275.072
R264 VSS.n934 VSS.t92 275.072
R265 VSS.n79 VSS.t3296 156.482
R266 VSS.t3291 VSS.n79 156.482
R267 VSS.t3281 VSS.n79 156.482
R268 VSS.n79 VSS.t3276 156.482
R269 VSS.t3274 VSS.n79 157.976
R270 VSS.n79 VSS.t3266 156.482
R271 VSS.n79 VSS.t3261 156.482
R272 VSS.n79 VSS.t3256 156.482
R273 VSS.n79 VSS.t3251 156.482
R274 VSS.n79 VSS.t3246 156.482
R275 VSS.t3244 VSS.n79 157.976
R276 VSS.t3239 VSS.n79 157.976
R277 VSS.n79 VSS.t3231 156.482
R278 VSS.n79 VSS.t3226 156.482
R279 VSS.n79 VSS.t3221 156.482
R280 VSS.t3219 VSS.n79 157.976
R281 VSS.t3214 VSS.n79 157.976
R282 VSS.n79 VSS.t3206 156.482
R283 VSS.t3204 VSS.n79 157.976
R284 VSS.n79 VSS.t3196 156.482
R285 VSS.t3194 VSS.n79 157.976
R286 VSS.n79 VSS.t3186 156.482
R287 VSS.n79 VSS.t3176 156.482
R288 VSS.n79 VSS.t3171 156.482
R289 VSS.t3166 VSS.n79 156.482
R290 VSS.n79 VSS.t3161 156.482
R291 VSS.n79 VSS.t3156 156.482
R292 VSS.t3149 VSS.n79 157.976
R293 VSS.n79 VSS.t3141 156.482
R294 VSS.n79 VSS.t3136 156.482
R295 VSS.t3134 VSS.n79 157.976
R296 VSS.n79 VSS.t3126 156.482
R297 VSS.t3124 VSS.n79 157.976
R298 VSS.n79 VSS.t3116 156.482
R299 VSS.t3114 VSS.n79 157.976
R300 VSS.n79 VSS.t3106 156.482
R301 VSS.n79 VSS.t3096 156.482
R302 VSS.n79 VSS.t3091 156.482
R303 VSS.n79 VSS.t3086 156.482
R304 VSS.n79 VSS.t3081 156.482
R305 VSS.n79 VSS.t3076 156.482
R306 VSS.t3074 VSS.n79 157.976
R307 VSS.n79 VSS.t3066 156.482
R308 VSS.t3064 VSS.n79 157.976
R309 VSS.n79 VSS.t3056 156.482
R310 VSS.n79 VSS.t3046 156.482
R311 VSS.t3041 VSS.n79 156.482
R312 VSS.n79 VSS.t3036 156.482
R313 VSS.t3031 VSS.n79 156.482
R314 VSS.n79 VSS.t3026 156.288
R315 VSS.n37 VSS.t59 273.587
R316 VSS.n794 VSS.t305 272.846
R317 VSS.t320 VSS.n902 270
R318 VSS.t325 VSS.n1081 270
R319 VSS.t193 VSS.n916 270
R320 VSS.t198 VSS.n914 270
R321 VSS.t135 VSS.n1068 270
R322 VSS.t341 VSS.t56 266.476
R323 VSS.n1008 VSS.t217 266.476
R324 VSS.t276 VSS.t70 266.476
R325 VSS.t71 VSS.t221 266.476
R326 VSS.t432 VSS.t175 265.714
R327 VSS.t17 VSS.t296 261.43
R328 VSS.t313 VSS.n891 258.334
R329 VSS.t388 VSS.t295 258.334
R330 VSS.t292 VSS.n995 258.334
R331 VSS.n1040 VSS.t29 258.334
R332 VSS.t65 VSS.t236 258.334
R333 VSS.t149 VSS.n1048 258.334
R334 VSS.t252 VSS.t340 258.334
R335 VSS.n70 VSS.t151 288.68
R336 VSS.n961 VSS.t632 257.88
R337 VSS.t337 VSS.n981 257.144
R338 VSS.n967 VSS.t10 257.144
R339 VSS.n1017 VSS.t64 257.144
R340 VSS.t61 VSS.n1057 257.144
R341 VSS.t69 VSS.n931 253.583
R342 VSS.n776 VSS.t683 252.065
R343 VSS.t685 VSS.n774 252.065
R344 VSS.n778 VSS.t687 252.065
R345 VSS.t689 VSS.n772 252.065
R346 VSS.n780 VSS.t691 252.065
R347 VSS.t694 VSS.n770 252.065
R348 VSS.n792 VSS.t700 252.065
R349 VSS.t703 VSS.n799 252.065
R350 VSS.n790 VSS.t705 252.065
R351 VSS.t708 VSS.n801 252.065
R352 VSS.n788 VSS.t710 252.065
R353 VSS.t713 VSS.n803 252.065
R354 VSS.n786 VSS.t715 252.065
R355 VSS.t717 VSS.n805 252.065
R356 VSS.n784 VSS.t719 252.065
R357 VSS.t698 VSS.n793 252.041
R358 VSS.n709 VSS.t732 251.417
R359 VSS.n713 VSS.t735 251.417
R360 VSS.n717 VSS.t738 251.417
R361 VSS.n721 VSS.t741 251.417
R362 VSS.n725 VSS.t744 251.417
R363 VSS.n729 VSS.t747 251.417
R364 VSS.n733 VSS.t750 251.417
R365 VSS.n737 VSS.t753 251.417
R366 VSS.n741 VSS.t756 251.417
R367 VSS.n745 VSS.t759 251.417
R368 VSS.n749 VSS.t762 251.417
R369 VSS.n753 VSS.t767 251.417
R370 VSS.n757 VSS.t770 251.417
R371 VSS.n761 VSS.t773 251.417
R372 VSS.n765 VSS.t776 251.417
R373 VSS.n1001 VSS.t680 251.417
R374 VSS.t794 VSS.n797 251.417
R375 VSS.n997 VSS.t387 250.952
R376 VSS.n1053 VSS.t228 250.952
R377 VSS.t342 VSS.n953 250.952
R378 VSS.n814 VSS.t286 249.643
R379 VSS.t8 VSS.n34 249.002
R380 VSS.n52 VSS.t214 249.002
R381 VSS.t229 VSS.t160 245.833
R382 VSS.n1045 VSS.t382 244.987
R383 VSS.n1088 VSS.t321 244.286
R384 VSS.t324 VSS.n1080 244.286
R385 VSS.n1024 VSS.t194 244.286
R386 VSS.n1025 VSS.t197 244.286
R387 VSS.t136 VSS.n1067 244.286
R388 VSS.n1065 VSS.t139 244.286
R389 VSS.t115 VSS.n44 243.5
R390 VSS.t682 VSS.n776 243.494
R391 VSS.n774 VSS.t684 243.494
R392 VSS.t686 VSS.n778 243.494
R393 VSS.n772 VSS.t688 243.494
R394 VSS.t690 VSS.n780 243.494
R395 VSS.n770 VSS.t692 243.494
R396 VSS.t695 VSS.n782 243.494
R397 VSS.t699 VSS.n792 243.494
R398 VSS.n799 VSS.t701 243.494
R399 VSS.t704 VSS.n790 243.494
R400 VSS.n801 VSS.t706 243.494
R401 VSS.t709 VSS.n788 243.494
R402 VSS.n803 VSS.t711 243.494
R403 VSS.t714 VSS.n786 243.494
R404 VSS.n805 VSS.t716 243.494
R405 VSS.t718 VSS.n784 243.494
R406 VSS.n807 VSS.t720 243.494
R407 VSS.n708 VSS.t865 242.846
R408 VSS.n712 VSS.t867 242.846
R409 VSS.n716 VSS.t869 242.846
R410 VSS.n720 VSS.t871 242.846
R411 VSS.n724 VSS.t873 242.846
R412 VSS.n728 VSS.t875 242.846
R413 VSS.n732 VSS.t877 242.846
R414 VSS.n736 VSS.t879 242.846
R415 VSS.n740 VSS.t881 242.846
R416 VSS.n744 VSS.t883 242.846
R417 VSS.n748 VSS.t885 242.846
R418 VSS.n752 VSS.t887 242.846
R419 VSS.n756 VSS.t889 242.846
R420 VSS.n760 VSS.t891 242.846
R421 VSS.n764 VSS.t893 242.846
R422 VSS.t697 VSS.n796 242.846
R423 VSS.t795 VSS.n795 242.846
R424 VSS.n36 VSS.t576 242.846
R425 VSS.t104 VSS.t261 240.689
R426 VSS.n1101 VSS.t857 236.391
R427 VSS.n937 VSS.t633 236.391
R428 VSS.n69 VSS.t2371 108.999
R429 VSS.n69 VSS.t2376 108.999
R430 VSS.n69 VSS.t2381 108.999
R431 VSS.n69 VSS.t2396 108.999
R432 VSS.n69 VSS.t2416 108.999
R433 VSS.n69 VSS.t2421 108.999
R434 VSS.n69 VSS.t2431 108.999
R435 VSS.n69 VSS.t2441 108.999
R436 VSS.n69 VSS.t2456 108.999
R437 VSS.n69 VSS.t2481 108.999
R438 VSS.n69 VSS.t2486 108.999
R439 VSS.t2506 VSS.n69 109.001
R440 VSS.n69 VSS.t2571 109.001
R441 VSS.n69 VSS.t2611 109.001
R442 VSS.n69 VSS.t2631 109.001
R443 VSS.t2636 VSS.n69 108.999
R444 VSS.t1969 VSS.n72 108.556
R445 VSS.t1989 VSS.n71 108.999
R446 VSS.n71 VSS.t1994 108.999
R447 VSS.n71 VSS.t2019 108.999
R448 VSS.n71 VSS.t2029 108.999
R449 VSS.n71 VSS.t2039 108.999
R450 VSS.t2044 VSS.n71 108.999
R451 VSS.n71 VSS.t2059 108.999
R452 VSS.t2064 VSS.n71 108.999
R453 VSS.n71 VSS.t2069 108.999
R454 VSS.n71 VSS.t2099 108.999
R455 VSS.t2104 VSS.n71 108.999
R456 VSS.t2109 VSS.n71 108.999
R457 VSS.t2164 VSS.n71 109.001
R458 VSS.n71 VSS.t2229 109.001
R459 VSS.t2234 VSS.n71 109.001
R460 VSS.t1577 VSS.n76 108.556
R461 VSS.n75 VSS.t1582 108.999
R462 VSS.t1627 VSS.n75 108.999
R463 VSS.n75 VSS.t1632 108.999
R464 VSS.t1637 VSS.n75 108.999
R465 VSS.n75 VSS.t1652 108.999
R466 VSS.t1657 VSS.n75 108.999
R467 VSS.n75 VSS.t1662 108.999
R468 VSS.n75 VSS.t1702 108.999
R469 VSS.n75 VSS.t1717 108.999
R470 VSS.n75 VSS.t1732 109.001
R471 VSS.n75 VSS.t1762 109.001
R472 VSS.n75 VSS.t1827 109.001
R473 VSS.n75 VSS.t1852 108.999
R474 VSS.n74 VSS.t896 108.556
R475 VSS.n73 VSS.t901 108.999
R476 VSS.n73 VSS.t921 108.999
R477 VSS.t926 VSS.n73 108.999
R478 VSS.t941 VSS.n73 108.999
R479 VSS.n73 VSS.t946 108.999
R480 VSS.t971 VSS.n73 108.999
R481 VSS.n73 VSS.t996 108.999
R482 VSS.t1011 VSS.n73 108.999
R483 VSS.t1036 VSS.n73 108.999
R484 VSS.t1041 VSS.n73 109.001
R485 VSS.n73 VSS.t1046 109.001
R486 VSS.t1061 VSS.n73 109.001
R487 VSS.n73 VSS.t1106 109.001
R488 VSS.n1104 VSS.t864 235.714
R489 VSS.n1106 VSS.t866 235.714
R490 VSS.n1108 VSS.t868 235.714
R491 VSS.n1110 VSS.t870 235.714
R492 VSS.n1112 VSS.t872 235.714
R493 VSS.n1114 VSS.t874 235.714
R494 VSS.n1116 VSS.t876 235.714
R495 VSS.n1118 VSS.t878 235.714
R496 VSS.n1120 VSS.t880 235.714
R497 VSS.n1122 VSS.t882 235.714
R498 VSS.n1124 VSS.t884 235.714
R499 VSS.n1136 VSS.t886 235.714
R500 VSS.n1134 VSS.t888 235.714
R501 VSS.n1132 VSS.t890 235.714
R502 VSS.n1130 VSS.t892 235.714
R503 VSS.n993 VSS.t823 235.714
R504 VSS.n980 VSS.t826 235.714
R505 VSS.n987 VSS.t829 235.714
R506 VSS.n983 VSS.t833 235.714
R507 VSS.t838 VSS.n1082 235.714
R508 VSS.t842 VSS.n899 235.714
R509 VSS.t722 VSS.n898 235.714
R510 VSS.n1092 VSS.t725 235.714
R511 VSS.t727 VSS.n897 235.714
R512 VSS.n1096 VSS.t851 235.714
R513 VSS.n999 VSS.t696 235.714
R514 VSS.n972 VSS.t796 235.714
R515 VSS.n47 VSS.t639 108.635
R516 VSS.n1028 VSS.t646 235.714
R517 VSS.t9 VSS.t575 252.065
R518 VSS.t414 VSS.n1034 233.333
R519 VSS.n35 VSS.t259 232.335
R520 VSS.n976 VSS.t821 229.167
R521 VSS.n88 VSS.t634 102.749
R522 VSS.n69 VSS.t2389 109.992
R523 VSS.n69 VSS.t2394 109.992
R524 VSS.n69 VSS.t2439 109.992
R525 VSS.n69 VSS.t2454 109.993
R526 VSS.n69 VSS.t2469 109.992
R527 VSS.n69 VSS.t2514 109.993
R528 VSS.n69 VSS.t2529 109.992
R529 VSS.n69 VSS.t2534 109.993
R530 VSS.n69 VSS.t2554 109.992
R531 VSS.n69 VSS.t2594 109.992
R532 VSS.n69 VSS.t2599 109.992
R533 VSS.n71 VSS.t2007 109.993
R534 VSS.n71 VSS.t2012 109.992
R535 VSS.n71 VSS.t2082 109.993
R536 VSS.n71 VSS.t2087 109.993
R537 VSS.n71 VSS.t2092 109.992
R538 VSS.n71 VSS.t2117 109.992
R539 VSS.n71 VSS.t2157 109.992
R540 VSS.n71 VSS.t2182 109.993
R541 VSS.n71 VSS.t2207 109.993
R542 VSS.n71 VSS.t2212 109.992
R543 VSS.n71 VSS.t2242 109.993
R544 VSS.n75 VSS.t1590 109.992
R545 VSS.n75 VSS.t1600 109.992
R546 VSS.n75 VSS.t1610 109.992
R547 VSS.n75 VSS.t1615 109.992
R548 VSS.n75 VSS.t1675 109.992
R549 VSS.n75 VSS.t1680 109.992
R550 VSS.n75 VSS.t1685 109.992
R551 VSS.n75 VSS.t1755 109.992
R552 VSS.n75 VSS.t1780 109.992
R553 VSS.n75 VSS.t1800 109.992
R554 VSS.n75 VSS.t1805 109.993
R555 VSS.n75 VSS.t1810 109.993
R556 VSS.n73 VSS.t914 109.993
R557 VSS.n73 VSS.t969 109.992
R558 VSS.n73 VSS.t984 109.992
R559 VSS.n73 VSS.t989 109.992
R560 VSS.n73 VSS.t1019 109.992
R561 VSS.n73 VSS.t1024 109.992
R562 VSS.n73 VSS.t1084 109.992
R563 VSS.n73 VSS.t1094 109.993
R564 VSS.n73 VSS.t1114 109.992
R565 VSS.n73 VSS.t1119 109.992
R566 VSS.n73 VSS.t1129 109.993
R567 VSS.n73 VSS.t1139 109.992
R568 VSS.n1102 VSS.t863 227.143
R569 VSS.n1105 VSS.t734 227.143
R570 VSS.n1107 VSS.t737 227.143
R571 VSS.n1109 VSS.t740 227.143
R572 VSS.n1111 VSS.t743 227.143
R573 VSS.n1113 VSS.t746 227.143
R574 VSS.n1115 VSS.t749 227.143
R575 VSS.n1117 VSS.t752 227.143
R576 VSS.n1119 VSS.t755 227.143
R577 VSS.n1121 VSS.t758 227.143
R578 VSS.n1123 VSS.t761 227.143
R579 VSS.n1137 VSS.t765 227.143
R580 VSS.n1135 VSS.t769 227.143
R581 VSS.n1133 VSS.t772 227.143
R582 VSS.n1131 VSS.t775 227.143
R583 VSS.n1129 VSS.t778 227.143
R584 VSS.n990 VSS.t828 227.143
R585 VSS.n986 VSS.t832 227.143
R586 VSS.n984 VSS.t835 227.143
R587 VSS.t304 VSS.t841 227.143
R588 VSS.t843 VSS.n898 227.143
R589 VSS.n1092 VSS.t845 227.143
R590 VSS.t847 VSS.n897 227.143
R591 VSS.n1093 VSS.t849 227.143
R592 VSS.n973 VSS.t797 227.143
R593 VSS.n998 VSS.t819 227.143
R594 VSS.n1023 VSS.t643 227.143
R595 VSS.n1029 VSS.t647 227.143
R596 VSS.t380 VSS.t140 227.143
R597 VSS.t9 VSS.t573 109.986
R598 VSS.t371 VSS.t142 222.857
R599 VSS.t793 VSS.n782 222.065
R600 VSS.t721 VSS.n807 222.065
R601 VSS.t730 VSS.n694 222.042
R602 VSS.n768 VSS.t793 222.042
R603 VSS.t850 VSS.n694 222.041
R604 VSS.t577 VSS.n44 222.011
R605 VSS.t731 VSS.n686 221.417
R606 VSS.n1099 VSS.t855 220.833
R607 VSS.n996 VSS.t822 220.833
R608 VSS.t322 VSS.n1087 218.571
R609 VSS.n1087 VSS.t323 218.571
R610 VSS.t195 VSS.n915 218.571
R611 VSS.t196 VSS.n915 218.571
R612 VSS.n1066 VSS.t138 218.571
R613 VSS.t413 VSS.t156 212.5
R614 VSS.n88 VSS.t577 214.988
R615 VSS.n1093 VSS.t730 205.714
R616 VSS.n1094 VSS.t850 205.714
R617 VSS.n1096 VSS.t731 205.714
R618 VSS.n1075 VSS.t578 205.714
R619 VSS.t578 VSS.n1074 205.714
R620 VSS.n88 VSS.t9 7.66894
R621 VSS.t2369 VSS.n69 109.993
R622 VSS.t2379 VSS.n69 109.993
R623 VSS.t2404 VSS.n69 109.993
R624 VSS.t2409 VSS.n69 109.993
R625 VSS.t2424 VSS.n69 109.993
R626 VSS.t2429 VSS.n69 109.993
R627 VSS.t2474 VSS.n69 109.993
R628 VSS.t2489 VSS.n69 109.993
R629 VSS.n69 VSS.t2499 109.993
R630 VSS.t2504 VSS.n69 109.992
R631 VSS.t2519 VSS.n69 109.993
R632 VSS.t2524 VSS.n69 109.993
R633 VSS.t2544 VSS.n69 109.993
R634 VSS.t2559 VSS.n69 109.993
R635 VSS.t2564 VSS.n69 109.993
R636 VSS.t2639 VSS.n69 109.993
R637 VSS.t1972 VSS.n71 109.986
R638 VSS.t1977 VSS.n71 109.993
R639 VSS.t1982 VSS.n71 109.993
R640 VSS.t1987 VSS.n71 109.993
R641 VSS.t2002 VSS.n71 109.993
R642 VSS.t2037 VSS.n71 109.993
R643 VSS.t2042 VSS.n71 109.993
R644 VSS.t2047 VSS.n71 109.993
R645 VSS.t2052 VSS.n71 109.993
R646 VSS.t2057 VSS.n71 109.993
R647 VSS.t2072 VSS.n71 109.993
R648 VSS.t2077 VSS.n71 109.993
R649 VSS.t2122 VSS.n71 109.993
R650 VSS.t2142 VSS.n71 109.993
R651 VSS.t2227 VSS.n71 109.993
R652 VSS.t2247 VSS.n71 109.993
R653 VSS.t1585 VSS.n75 109.993
R654 VSS.t1625 VSS.n75 109.993
R655 VSS.t1630 VSS.n75 109.993
R656 VSS.t1640 VSS.n75 109.993
R657 VSS.t1645 VSS.n75 109.993
R658 VSS.t1650 VSS.n75 109.993
R659 VSS.t1665 VSS.n75 109.993
R660 VSS.t1705 VSS.n75 109.993
R661 VSS.t1715 VSS.n75 109.993
R662 VSS.n75 VSS.t1720 109.993
R663 VSS.t1760 VSS.n75 109.993
R664 VSS.t1785 VSS.n75 109.993
R665 VSS.t1855 VSS.n75 109.993
R666 VSS.t899 VSS.n73 109.986
R667 VSS.t909 VSS.n73 109.993
R668 VSS.t934 VSS.n73 109.993
R669 VSS.t959 VSS.n73 109.993
R670 VSS.t1029 VSS.n73 109.993
R671 VSS.t1034 VSS.n73 109.993
R672 VSS.t1059 VSS.n73 109.993
R673 VSS.t1074 VSS.n73 109.993
R674 VSS.t1099 VSS.n73 109.993
R675 VSS.t1124 VSS.n73 109.993
R676 VSS.t1134 VSS.n73 109.993
R677 VSS.t1144 VSS.n73 109.993
R678 VSS.t1174 VSS.n73 109.993
R679 VSS.t828 VSS.n670 200.613
R680 VSS.n690 VSS.t843 200.613
R681 VSS.n689 VSS.t724 200.613
R682 VSS.t845 VSS.n691 200.613
R683 VSS.t726 VSS.n692 200.613
R684 VSS.n688 VSS.t847 200.613
R685 VSS.n687 VSS.t729 200.613
R686 VSS.t849 VSS.n693 200.613
R687 VSS.n775 VSS.t682 200.613
R688 VSS.t684 VSS.n777 200.613
R689 VSS.n773 VSS.t686 200.613
R690 VSS.t688 VSS.n779 200.613
R691 VSS.n771 VSS.t690 200.613
R692 VSS.t692 VSS.n781 200.613
R693 VSS.n769 VSS.t695 200.613
R694 VSS.n798 VSS.t699 200.613
R695 VSS.t701 VSS.n791 200.613
R696 VSS.n800 VSS.t704 200.613
R697 VSS.t706 VSS.n789 200.613
R698 VSS.n802 VSS.t709 200.613
R699 VSS.t711 VSS.n787 200.613
R700 VSS.n804 VSS.t714 200.613
R701 VSS.t716 VSS.n785 200.613
R702 VSS.n806 VSS.t718 200.613
R703 VSS.t720 VSS.n783 200.613
R704 VSS.t819 VSS.n808 200.613
R705 VSS.t638 VSS.t9 200.613
R706 VSS.t863 VSS.n705 199.989
R707 VSS.n708 VSS.t734 199.989
R708 VSS.n712 VSS.t737 199.989
R709 VSS.n716 VSS.t740 199.989
R710 VSS.n720 VSS.t743 199.989
R711 VSS.n724 VSS.t746 199.989
R712 VSS.n728 VSS.t749 199.989
R713 VSS.n732 VSS.t752 199.989
R714 VSS.n736 VSS.t755 199.989
R715 VSS.n740 VSS.t758 199.989
R716 VSS.n744 VSS.t761 199.989
R717 VSS.t765 VSS.n748 199.989
R718 VSS.t769 VSS.n752 199.989
R719 VSS.t772 VSS.n756 199.989
R720 VSS.t775 VSS.n760 199.989
R721 VSS.t778 VSS.n764 199.989
R722 VSS.t841 VSS.n683 199.989
R723 VSS.n796 VSS.t795 199.989
R724 VSS.t334 VSS.t840 197.143
R725 VSS.t189 VSS.t642 197.143
R726 VSS.t219 VSS.t47 193.411
R727 VSS.t323 VSS.n1080 192.857
R728 VSS.n1024 VSS.t195 192.857
R729 VSS.n1067 VSS.t137 192.857
R730 VSS.n69 VSS.t2634 109.992
R731 VSS.n69 VSS.t2626 109.001
R732 VSS.t2621 VSS.n69 109.001
R733 VSS.n69 VSS.t2616 109.001
R734 VSS.n69 VSS.t2614 109.992
R735 VSS.t2609 VSS.n69 109.993
R736 VSS.t2601 VSS.n69 109.001
R737 VSS.n69 VSS.t2596 109.001
R738 VSS.t2591 VSS.n69 109.001
R739 VSS.n69 VSS.t2586 109.001
R740 VSS.t2581 VSS.n69 109.001
R741 VSS.n69 VSS.t2576 109.001
R742 VSS.n69 VSS.t2574 109.992
R743 VSS.n69 VSS.t2566 109.001
R744 VSS.t2561 VSS.n69 108.999
R745 VSS.t2551 VSS.n69 109.001
R746 VSS.n69 VSS.t2546 109.001
R747 VSS.t2539 VSS.n69 109.993
R748 VSS.t2531 VSS.n69 108.999
R749 VSS.n69 VSS.t2526 109.001
R750 VSS.t2521 VSS.n69 108.999
R751 VSS.t2511 VSS.n69 108.999
R752 VSS.t2509 VSS.n69 109.992
R753 VSS.t2496 VSS.n69 108.999
R754 VSS.t2491 VSS.n69 109.001
R755 VSS.n69 VSS.t2484 109.993
R756 VSS.n69 VSS.t2479 109.992
R757 VSS.t2471 VSS.n69 108.999
R758 VSS.t2466 VSS.n69 109.001
R759 VSS.n69 VSS.t2464 109.992
R760 VSS.n69 VSS.t2459 109.993
R761 VSS.t2451 VSS.n69 108.999
R762 VSS.n69 VSS.t2449 109.992
R763 VSS.n69 VSS.t2444 109.993
R764 VSS.t2436 VSS.n69 109.001
R765 VSS.n69 VSS.t2434 109.993
R766 VSS.t2426 VSS.n69 108.999
R767 VSS.n69 VSS.t2419 109.993
R768 VSS.t2411 VSS.n69 109.001
R769 VSS.t2406 VSS.n69 108.999
R770 VSS.t2401 VSS.n69 108.999
R771 VSS.n69 VSS.t2399 109.993
R772 VSS.t2391 VSS.n69 109.001
R773 VSS.t2386 VSS.n69 109.001
R774 VSS.n69 VSS.t2384 109.993
R775 VSS.n69 VSS.t2374 109.993
R776 VSS.t2366 VSS.n69 108.999
R777 VSS.t2361 VSS.n69 108.556
R778 VSS.n69 VSS.t2501 109.001
R779 VSS.n71 VSS.t2244 108.999
R780 VSS.t2239 VSS.n71 108.999
R781 VSS.t2237 VSS.n71 109.992
R782 VSS.n71 VSS.t2232 109.992
R783 VSS.n71 VSS.t2224 108.999
R784 VSS.t2219 VSS.n71 109.001
R785 VSS.n71 VSS.t2214 109.001
R786 VSS.t2209 VSS.n71 109.001
R787 VSS.n71 VSS.t2204 108.999
R788 VSS.t2199 VSS.n71 109.001
R789 VSS.n71 VSS.t2194 109.001
R790 VSS.t2189 VSS.n71 109.001
R791 VSS.t2187 VSS.n71 109.993
R792 VSS.t2179 VSS.n71 108.999
R793 VSS.n71 VSS.t2174 109.001
R794 VSS.t2169 VSS.n71 109.001
R795 VSS.t2167 VSS.n71 109.992
R796 VSS.t2159 VSS.n71 108.999
R797 VSS.n71 VSS.t2154 109.001
R798 VSS.t2149 VSS.n71 109.001
R799 VSS.n71 VSS.t2144 109.001
R800 VSS.t2137 VSS.n71 109.993
R801 VSS.n71 VSS.t2132 109.993
R802 VSS.t2127 VSS.n71 109.993
R803 VSS.t2119 VSS.n71 108.999
R804 VSS.n71 VSS.t2114 109.001
R805 VSS.t2107 VSS.n71 109.993
R806 VSS.n71 VSS.t2102 109.993
R807 VSS.n71 VSS.t2094 109.001
R808 VSS.t2089 VSS.n71 109.001
R809 VSS.n71 VSS.t2084 108.999
R810 VSS.t2079 VSS.n71 108.999
R811 VSS.n71 VSS.t2074 108.999
R812 VSS.t2067 VSS.n71 109.993
R813 VSS.n71 VSS.t2062 109.993
R814 VSS.n71 VSS.t2054 108.999
R815 VSS.t2049 VSS.n71 108.999
R816 VSS.n71 VSS.t2034 108.999
R817 VSS.n71 VSS.t2032 109.993
R818 VSS.n71 VSS.t2024 108.999
R819 VSS.n71 VSS.t2022 109.993
R820 VSS.n71 VSS.t2014 109.001
R821 VSS.t2009 VSS.n71 109.001
R822 VSS.n71 VSS.t2004 108.999
R823 VSS.n71 VSS.t1999 108.999
R824 VSS.n71 VSS.t1997 109.993
R825 VSS.t1992 VSS.n71 109.993
R826 VSS.t1984 VSS.n71 108.999
R827 VSS.n71 VSS.t1979 108.999
R828 VSS.t1974 VSS.n71 108.999
R829 VSS.n71 VSS.n72 0.575538
R830 VSS.t2112 VSS.n71 109.993
R831 VSS.n75 VSS.t1847 109.001
R832 VSS.t1842 VSS.n75 109.001
R833 VSS.n75 VSS.t1837 109.001
R834 VSS.n75 VSS.t1832 109.001
R835 VSS.n75 VSS.t1830 109.992
R836 VSS.t1822 VSS.n75 109.001
R837 VSS.t1817 VSS.n75 109.001
R838 VSS.t1812 VSS.n75 109.001
R839 VSS.t1807 VSS.n75 108.999
R840 VSS.t1802 VSS.n75 108.999
R841 VSS.t1797 VSS.n75 109.001
R842 VSS.t1792 VSS.n75 109.001
R843 VSS.t1787 VSS.n75 109.001
R844 VSS.t1782 VSS.n75 108.999
R845 VSS.t1777 VSS.n75 109.001
R846 VSS.t1772 VSS.n75 109.001
R847 VSS.t1767 VSS.n75 109.001
R848 VSS.n75 VSS.t1765 109.992
R849 VSS.t1752 VSS.n75 109.001
R850 VSS.t1747 VSS.n75 109.001
R851 VSS.t1742 VSS.n75 109.001
R852 VSS.t1737 VSS.n75 109.001
R853 VSS.n75 VSS.t1735 109.992
R854 VSS.t1727 VSS.n75 109.001
R855 VSS.t1722 VSS.n75 109.001
R856 VSS.t1712 VSS.n75 108.999
R857 VSS.n75 VSS.t1707 108.999
R858 VSS.n75 VSS.t1697 109.001
R859 VSS.t1692 VSS.n75 109.001
R860 VSS.n75 VSS.t1687 109.001
R861 VSS.t1682 VSS.n75 109.001
R862 VSS.n75 VSS.t1677 109.001
R863 VSS.t1672 VSS.n75 109.001
R864 VSS.n75 VSS.t1667 109.001
R865 VSS.t1660 VSS.n75 109.993
R866 VSS.n75 VSS.t1655 109.993
R867 VSS.n75 VSS.t1647 108.999
R868 VSS.t1642 VSS.n75 108.999
R869 VSS.n75 VSS.t1635 109.993
R870 VSS.t1622 VSS.n75 108.999
R871 VSS.n75 VSS.t1617 109.001
R872 VSS.t1612 VSS.n75 109.001
R873 VSS.n75 VSS.t1607 109.001
R874 VSS.n75 VSS.t1605 109.992
R875 VSS.n75 VSS.t1597 109.001
R876 VSS.t1592 VSS.n75 109.001
R877 VSS.n75 VSS.t1587 109.001
R878 VSS.n75 VSS.n76 0.575467
R879 VSS.n73 VSS.t1171 108.999
R880 VSS.t1166 VSS.n73 109.001
R881 VSS.n73 VSS.t1161 109.001
R882 VSS.n73 VSS.t1159 109.993
R883 VSS.t1154 VSS.n73 109.993
R884 VSS.t1146 VSS.n73 109.001
R885 VSS.t1136 VSS.n73 109.001
R886 VSS.n73 VSS.t1131 108.999
R887 VSS.t1126 VSS.n73 108.999
R888 VSS.t1116 VSS.n73 109.001
R889 VSS.n73 VSS.t1111 109.001
R890 VSS.n73 VSS.t1109 109.992
R891 VSS.n73 VSS.t1101 109.001
R892 VSS.t1096 VSS.n73 108.999
R893 VSS.n73 VSS.t1091 108.999
R894 VSS.n73 VSS.t1089 109.993
R895 VSS.n73 VSS.t1081 109.001
R896 VSS.t1076 VSS.n73 109.001
R897 VSS.n73 VSS.t1069 109.993
R898 VSS.t1064 VSS.n73 109.992
R899 VSS.n73 VSS.t1051 109.001
R900 VSS.n73 VSS.t1049 109.992
R901 VSS.t1044 VSS.n73 109.992
R902 VSS.n73 VSS.t1031 108.999
R903 VSS.t1026 VSS.n73 108.999
R904 VSS.n73 VSS.t1021 109.001
R905 VSS.t1016 VSS.n73 109.001
R906 VSS.t1014 VSS.n73 109.993
R907 VSS.t1006 VSS.n73 109.001
R908 VSS.n73 VSS.t1001 109.001
R909 VSS.n73 VSS.t999 109.993
R910 VSS.n73 VSS.t991 108.999
R911 VSS.t986 VSS.n73 109.001
R912 VSS.n73 VSS.t981 109.001
R913 VSS.n73 VSS.t979 109.992
R914 VSS.t974 VSS.n73 109.993
R915 VSS.t966 VSS.n73 109.001
R916 VSS.n73 VSS.t961 109.001
R917 VSS.t956 VSS.n73 108.999
R918 VSS.t954 VSS.n73 109.992
R919 VSS.n73 VSS.t949 109.993
R920 VSS.t944 VSS.n73 109.993
R921 VSS.n73 VSS.t939 109.992
R922 VSS.n73 VSS.t931 108.999
R923 VSS.t929 VSS.n73 109.993
R924 VSS.n73 VSS.t924 109.993
R925 VSS.t916 VSS.n73 109.001
R926 VSS.t911 VSS.n73 108.999
R927 VSS.t906 VSS.n73 108.999
R928 VSS.n73 VSS.t904 109.993
R929 VSS.n74 VSS.n73 0.575509
R930 VSS.t1039 VSS.n73 109.993
R931 VSS.t848 VSS.n693 192.042
R932 VSS.n687 VSS.t727 192.042
R933 VSS.n688 VSS.t846 192.042
R934 VSS.t725 VSS.n692 192.042
R935 VSS.t844 VSS.n691 192.042
R936 VSS.n689 VSS.t722 192.042
R937 VSS.n808 VSS.t818 192.042
R938 VSS.t719 VSS.n783 192.042
R939 VSS.n806 VSS.t717 192.042
R940 VSS.t715 VSS.n785 192.042
R941 VSS.n804 VSS.t713 192.042
R942 VSS.t710 VSS.n787 192.042
R943 VSS.n802 VSS.t708 192.042
R944 VSS.t705 VSS.n789 192.042
R945 VSS.n800 VSS.t703 192.042
R946 VSS.t700 VSS.n791 192.042
R947 VSS.n798 VSS.t698 192.042
R948 VSS.n769 VSS.t694 192.042
R949 VSS.t691 VSS.n781 192.042
R950 VSS.n771 VSS.t689 192.042
R951 VSS.t687 VSS.n779 192.042
R952 VSS.n773 VSS.t685 192.042
R953 VSS.t683 VSS.n777 192.042
R954 VSS.n775 VSS.t680 192.042
R955 VSS.n93 VSS.t570 108.722
R956 VSS.t173 VSS.t853 191.667
R957 VSS.t864 VSS.n709 191.417
R958 VSS.t866 VSS.n713 191.417
R959 VSS.t868 VSS.n717 191.417
R960 VSS.t870 VSS.n721 191.417
R961 VSS.t872 VSS.n725 191.417
R962 VSS.t874 VSS.n729 191.417
R963 VSS.t876 VSS.n733 191.417
R964 VSS.t878 VSS.n737 191.417
R965 VSS.t880 VSS.n741 191.417
R966 VSS.t882 VSS.n745 191.417
R967 VSS.t884 VSS.n749 191.417
R968 VSS.n753 VSS.t886 191.417
R969 VSS.n757 VSS.t888 191.417
R970 VSS.n761 VSS.t890 191.417
R971 VSS.n765 VSS.t892 191.417
R972 VSS.n665 VSS.t823 191.417
R973 VSS.t851 VSS.n696 191.417
R974 VSS.n797 VSS.t696 191.417
R975 VSS.t796 VSS.n794 191.417
R976 VSS.t839 VSS.t330 188.571
R977 VSS.t641 VSS.t185 188.571
R978 VSS.t821 VSS.n811 186.502
R979 VSS.n1007 VSS.t115 184.815
R980 VSS.n92 VSS.t106 188.911
R981 VSS.t865 VSS.n882 184.286
R982 VSS.t867 VSS.n881 184.286
R983 VSS.t869 VSS.n880 184.286
R984 VSS.t871 VSS.n879 184.286
R985 VSS.t873 VSS.n878 184.286
R986 VSS.t875 VSS.n877 184.286
R987 VSS.t877 VSS.n876 184.286
R988 VSS.t879 VSS.n875 184.286
R989 VSS.t881 VSS.n874 184.286
R990 VSS.t883 VSS.n873 184.286
R991 VSS.t885 VSS.n872 184.286
R992 VSS.t887 VSS.n1125 184.286
R993 VSS.t889 VSS.n1126 184.286
R994 VSS.t891 VSS.n1127 184.286
R995 VSS.t893 VSS.n1128 184.286
R996 VSS.n1088 VSS.t837 184.286
R997 VSS.n1086 VSS.t839 184.286
R998 VSS.t852 VSS.n893 184.286
R999 VSS.n971 VSS.t697 184.286
R1000 VSS.t797 VSS.n969 184.286
R1001 VSS.n919 VSS.t641 184.286
R1002 VSS.n1026 VSS.t645 184.286
R1003 VSS.t576 VSS.n954 184.286
R1004 VSS.t259 VSS.n952 183.333
R1005 VSS.t822 VSS.n974 179.167
R1006 VSS.t857 VSS.n886 176.219
R1007 VSS.t862 VSS.n884 175.714
R1008 VSS.t732 VSS.n882 175.714
R1009 VSS.t735 VSS.n881 175.714
R1010 VSS.t738 VSS.n880 175.714
R1011 VSS.t741 VSS.n879 175.714
R1012 VSS.t744 VSS.n878 175.714
R1013 VSS.t747 VSS.n877 175.714
R1014 VSS.t750 VSS.n876 175.714
R1015 VSS.t753 VSS.n875 175.714
R1016 VSS.t756 VSS.n874 175.714
R1017 VSS.t759 VSS.n873 175.714
R1018 VSS.t762 VSS.n872 175.714
R1019 VSS.t767 VSS.n1125 175.714
R1020 VSS.t770 VSS.n1126 175.714
R1021 VSS.t773 VSS.n1127 175.714
R1022 VSS.t776 VSS.n1128 175.714
R1023 VSS.n981 VSS.t829 175.714
R1024 VSS.n1079 VSS.t836 175.714
R1025 VSS.t840 VSS.n901 175.714
R1026 VSS.n971 VSS.t794 175.714
R1027 VSS.t642 VSS.n918 175.714
R1028 VSS.n1025 VSS.t644 175.714
R1029 VSS.t75 VSS.t118 171.53
R1030 VSS.t350 VSS.t862 171.429
R1031 VSS.t309 VSS.t825 171.429
R1032 VSS.t835 VSS.t408 171.429
R1033 VSS.n960 VSS.t630 170.833
R1034 VSS.n674 VSS.t337 169.989
R1035 VSS.t382 VSS.n1044 167.623
R1036 VSS.t321 VSS.n902 167.143
R1037 VSS.n1081 VSS.t324 167.143
R1038 VSS.t194 VSS.n916 167.143
R1039 VSS.t197 VSS.n914 167.143
R1040 VSS.n1068 VSS.t136 167.143
R1041 VSS.t139 VSS.n1064 167.143
R1042 VSS.n891 VSS.t365 166.667
R1043 VSS.n995 VSS.t286 166.667
R1044 VSS.n1040 VSS.t8 166.667
R1045 VSS.n1038 VSS.t414 166.667
R1046 VSS.n1048 VSS.t279 166.667
R1047 VSS.t214 VSS.n960 166.667
R1048 VSS.t201 VSS.n1047 165.669
R1049 VSS.t632 VSS.n52 165.669
R1050 VSS.t646 VSS.t400 162.857
R1051 VSS.n1009 VSS.t69 159.026
R1052 VSS.t137 VSS.t159 158.571
R1053 VSS.t138 VSS.t369 158.571
R1054 VSS.n699 VSS.t313 157.335
R1055 VSS.t51 VSS.n54 157.335
R1056 VSS.n1049 VSS.t149 157.335
R1057 VSS.n936 VSS.t219 154.728
R1058 VSS.t59 VSS.n924 154.728
R1059 VSS.t832 VSS.t434 154.286
R1060 VSS.t10 VSS.n963 154.286
R1061 VSS.t305 VSS.n969 154.286
R1062 VSS.n1097 VSS.t171 154.167
R1063 VSS.n975 VSS.t387 154.167
R1064 VSS.t158 VSS.n1041 154.167
R1065 VSS.t237 VSS.n1042 154.167
R1066 VSS.t228 VSS.n1052 154.167
R1067 VSS.t151 VSS.n32 153.243
R1068 VSS.t92 VSS.n43 153.243
R1069 VSS.t153 VSS.t372 150.43
R1070 VSS.n1038 VSS.t31 150
R1071 VSS.t128 VSS.t636 145.714
R1072 VSS.t647 VSS.t402 145.714
R1073 VSS.n996 VSS.t292 141.667
R1074 VSS.n115 VSS.t249 157.335
R1075 VSS.n1079 VSS.t320 141.429
R1076 VSS.n1082 VSS.t325 141.429
R1077 VSS.t35 VSS.t638 141.429
R1078 VSS.n1023 VSS.t193 141.429
R1079 VSS.n1026 VSS.t198 141.429
R1080 VSS.t140 VSS.n1063 141.429
R1081 VSS.t146 VSS.t61 141.429
R1082 VSS.t154 VSS.n886 137.536
R1083 VSS.n1044 VSS.t153 137.536
R1084 VSS.t833 VSS.t406 137.143
R1085 VSS.t422 VSS.t842 132.857
R1086 VSS.t372 VSS.n1043 124.642
R1087 VSS.t95 VSS.t110 120.344
R1088 VSS.n1014 VSS.t104 120.344
R1089 VSS.n988 VSS.t343 120.001
R1090 VSS.t836 VSS.t318 120.001
R1091 VSS.n966 VSS.t223 120.001
R1092 VSS.n972 VSS.t291 120.001
R1093 VSS.t636 VSS.t34 120.001
R1094 VSS.n1055 VSS.t415 120.001
R1095 VSS.t344 VSS.n699 119.835
R1096 VSS.n33 VSS.t3 119.835
R1097 VSS.n54 VSS.t65 119.835
R1098 VSS.t2 VSS.n1049 119.835
R1099 VSS.t20 VSS.n1035 116.668
R1100 VSS.t633 VSS.t68 116.046
R1101 VSS.t826 VSS.t302 115.715
R1102 VSS.t318 VSS.n903 115.715
R1103 VSS.n1083 VSS.t326 115.715
R1104 VSS.t192 VSS.n917 115.715
R1105 VSS.t199 VSS.n913 115.715
R1106 VSS.t141 VSS.n1062 115.715
R1107 VSS.t29 VSS.t27 112.501
R1108 VSS.t645 VSS.t199 111.43
R1109 VSS.t31 VSS.t51 108.334
R1110 VSS.n1006 VSS.n933 107.451
R1111 VSS.t220 VSS.t215 107.451
R1112 VSS.t94 VSS.t125 107.451
R1113 VSS.t107 VSS.n92 77.4642
R1114 VSS.n888 VSS.t860 107.144
R1115 VSS.t168 VSS.n893 107.144
R1116 VSS.t50 VSS.n997 107.144
R1117 VSS.n1017 VSS.t79 107.144
R1118 VSS.n957 VSS.t98 107.144
R1119 VSS.t216 VSS.n953 107.144
R1120 VSS.t295 VSS.n974 104.168
R1121 VSS.t255 VSS.t342 100.001
R1122 VSS.t41 VSS.n962 98.5719
R1123 VSS.n1062 VSS.t371 98.5719
R1124 VSS.t267 VSS.t575 98.5719
R1125 VSS.t217 VSS.t97 94.5564
R1126 VSS.t272 VSS.t358 94.5564
R1127 VSS.t825 VSS.t389 94.2862
R1128 VSS.t64 VSS.t264 94.2862
R1129 VSS.n936 VSS.t341 90.2584
R1130 VSS.t175 VSS.n884 90.0005
R1131 VSS.t389 VSS.n979 90.0005
R1132 VSS.n905 VSS.t316 90.0005
R1133 VSS.n1084 VSS.t327 90.0005
R1134 VSS.n920 VSS.t128 90.0005
R1135 VSS.n1022 VSS.t191 90.0005
R1136 VSS.n1027 VSS.t200 90.0005
R1137 VSS.n1071 VSS.t133 90.0005
R1138 VSS.t142 VSS.n1061 90.0005
R1139 VSS.t446 VSS.n89 26.1544
R1140 VSS.t453 VSS.n77 26.1061
R1141 VSS.t384 VSS.n939 89.2763
R1142 VSS.n9 VSS.t492 26.1547
R1143 VSS.t81 VSS.n3 0.121827
R1144 VSS.n85 VSS.t81 0.121819
R1145 VSS.n83 VSS.t81 0.121819
R1146 VSS.n83 VSS.t512 26.2515
R1147 VSS.t207 VSS.n124 89.7897
R1148 VSS.n81 VSS.t522 26.1547
R1149 VSS.t81 VSS.n2 0.121819
R1150 VSS.t81 VSS.n1 0.121819
R1151 VSS.t81 VSS.n0 0.121819
R1152 VSS.n80 VSS.t542 26.2517
R1153 VSS.n768 VSS.t288 89.1836
R1154 VSS.n53 VSS.t113 88.7727
R1155 VSS.t100 VSS.n45 88.7727
R1156 VSS.n795 VSS.t53 88.5605
R1157 VSS.n939 VSS.t431 88.4694
R1158 VSS.t630 VSS.t249 87.5005
R1159 VSS.t9 VSS.t169 87.1423
R1160 VSS.t439 VSS.n697 86.5025
R1161 VSS.n34 VSS.t416 86.5025
R1162 VSS.t119 VSS.n1051 86.5025
R1163 VSS.n1051 VSS.t44 86.5025
R1164 VSS.n937 VSS.t57 85.9604
R1165 VSS.t426 VSS.t276 85.9604
R1166 VSS.t37 VSS.t116 85.9604
R1167 VSS.t395 VSS.n10 85.7543
R1168 VSS.n14 VSS.t241 85.7543
R1169 VSS.t433 VSS.n883 85.7148
R1170 VSS.n980 VSS.t310 85.7148
R1171 VSS.n86 VSS.t35 99.148
R1172 VSS.n1032 VSS.t17 85.7148
R1173 VSS.t279 VSS.t201 83.3338
R1174 VSS.t233 VSS.n17 83.3336
R1175 VSS.n1069 VSS.t109 81.4291
R1176 VSS.t47 VSS.t9 80.7982
R1177 VSS.n665 VSS.t308 79.9891
R1178 VSS.n51 VSS.t42 79.9891
R1179 VSS.n1008 VSS.t268 77.3644
R1180 VSS.n1014 VSS.t269 77.3644
R1181 VSS.n955 VSS.t267 77.1434
R1182 VSS.t68 VSS.t9 76.5012
R1183 VSS.t302 VSS.n670 76.3274
R1184 VSS.n947 VSS.t84 74.234
R1185 VSS.t435 VSS.n64 20.3746
R1186 VSS.t179 VSS.n933 73.0664
R1187 VSS.n990 VSS.t306 72.8576
R1188 VSS.t412 VSS.n1053 72.8576
R1189 VSS.t425 VSS.n8 72.8441
R1190 VSS.t362 VSS.n7 72.8441
R1191 VSS.t428 VSS.n6 72.8441
R1192 VSS.n18 VSS.t89 72.8441
R1193 VSS.n24 VSS.t244 72.8441
R1194 VSS.t352 VSS.n107 12.8073
R1195 VSS.t353 VSS.n67 13.8636
R1196 VSS.n951 VSS.t379 72.6202
R1197 VSS.n65 VSS.t390 12.7723
R1198 VSS.n949 VSS.t204 72.6202
R1199 VSS.t240 VSS.n944 72.6202
R1200 VSS.t239 VSS.n945 72.6202
R1201 VSS.t34 VSS.t9 72.0417
R1202 VSS.n705 VSS.t432 71.4177
R1203 VSS.n976 VSS.t289 70.8338
R1204 VSS.n1036 VSS.t166 70.8338
R1205 VSS.t112 VSS.n1036 70.8338
R1206 VSS.t212 VSS.n952 70.8338
R1207 VSS.t235 VSS.n176 72.8451
R1208 VSS.n141 VSS.t87 72.8451
R1209 VSS.n106 VSS.t423 14.8812
R1210 VSS.t364 VSS.n112 13.9422
R1211 VSS.t346 VSS.n68 13.9092
R1212 VSS.t377 VSS.n64 14.8475
R1213 VSS.n948 VSS.t230 70.1995
R1214 VSS.n113 VSS.t248 13.9422
R1215 VSS.n66 VSS.t381 23.7595
R1216 VSS.t30 VSS.t32 68.7684
R1217 VSS.t376 VSS.n899 68.5719
R1218 VSS.t427 VSS.n895 68.5719
R1219 VSS.t643 VSS.t192 68.5719
R1220 VSS.n32 VSS.t30 67.2827
R1221 VSS.t52 VSS.n53 67.2827
R1222 VSS.t250 VSS.n43 67.2827
R1223 VSS.t171 VSS.t852 66.6672
R1224 VSS.t853 VSS.t344 66.6672
R1225 VSS.t25 VSS.t158 66.6672
R1226 VSS.t76 VSS.t237 66.6672
R1227 VSS.n951 VSS.t381 64.5513
R1228 VSS.t113 VSS.t152 64.4704
R1229 VSS.t181 VSS.n926 64.4704
R1230 VSS.n67 VSS.t351 23.5225
R1231 VSS.t396 VSS.n11 64.3085
R1232 VSS.n885 VSS.t350 64.2862
R1233 VSS.n983 VSS.t404 64.2862
R1234 VSS.t410 VSS.n904 64.2862
R1235 VSS.n1086 VSS.t329 64.2862
R1236 VSS.t335 VSS.n901 64.2862
R1237 VSS.t183 VSS.n919 64.2862
R1238 VSS.t190 VSS.n918 64.2862
R1239 VSS.t398 VSS.n912 64.2862
R1240 VSS.n1029 VSS.t403 64.2862
R1241 VSS.t296 VSS.n909 64.2862
R1242 VSS.n1072 VSS.t301 64.2862
R1243 VSS.t143 VSS.n1060 64.2862
R1244 VSS.n1056 VSS.t148 64.2862
R1245 VSS.n15 VSS.t85 63.9684
R1246 VSS.n946 VSS.t232 63.7444
R1247 VSS.n12 VSS.t385 62.3556
R1248 VSS.t82 VSS.n16 62.3556
R1249 VSS.n109 VSS.t345 63.9693
R1250 VSS.t80 VSS.n126 63.9693
R1251 VSS.n98 VSS.t243 64.171
R1252 VSS.n935 VSS.t251 60.1724
R1253 VSS.t124 VSS.n925 60.1724
R1254 VSS.n924 VSS.t182 60.1724
R1255 VSS.n890 VSS.t315 60.0005
R1256 VSS.n1103 VSS.t348 60.0005
R1257 VSS.n994 VSS.t294 60.0005
R1258 VSS.t326 VSS.t838 60.0005
R1259 VSS.t367 VSS.n964 60.0005
R1260 VSS.t264 VSS.n921 60.0005
R1261 VSS.t16 VSS.n1031 60.0005
R1262 VSS.t206 VSS.t134 60.0005
R1263 VSS.t109 VSS.t135 60.0005
R1264 VSS.t159 VSS.n1066 60.0005
R1265 VSS.n690 VSS.t422 59.1846
R1266 VSS.t81 VSS.n78 0.22519
R1267 VSS.t459 VSS.n56 58.6622
R1268 VSS.n31 VSS.t81 0.121828
R1269 VSS.t81 VSS.n58 0.12182
R1270 VSS.n57 VSS.t81 0.121828
R1271 VSS.n60 VSS.t473 26.106
R1272 VSS.t475 VSS.n59 26.1052
R1273 VSS.t480 VSS.n61 26.1053
R1274 VSS.n63 VSS.t483 26.106
R1275 VSS.t485 VSS.n62 26.1052
R1276 VSS.n19 VSS.t554 58.6622
R1277 VSS.t556 VSS.n27 58.6622
R1278 VSS.n21 VSS.t559 58.6622
R1279 VSS.n23 VSS.t563 58.6622
R1280 VSS.t81 VSS.n90 0.225189
R1281 VSS.n49 VSS.t102 58.5605
R1282 VSS.t463 VSS.n8 58.3211
R1283 VSS.t478 VSS.n7 58.3211
R1284 VSS.n18 VSS.t551 58.3211
R1285 VSS.n24 VSS.t566 58.3211
R1286 VSS.n25 VSS.t567 26.1611
R1287 VSS.t560 VSS.n22 26.1547
R1288 VSS.t81 VSS.n77 0.121819
R1289 VSS.t458 VSS.n56 57.0465
R1290 VSS.t81 VSS.n96 0.219075
R1291 VSS.n30 VSS.t81 0.219018
R1292 VSS.n31 VSS.t467 26.2522
R1293 VSS.t469 VSS.n58 26.2515
R1294 VSS.n57 VSS.t472 26.2522
R1295 VSS.n60 VSS.t81 0.12182
R1296 VSS.t81 VSS.n59 0.12186
R1297 VSS.t479 VSS.n5 26.1544
R1298 VSS.t81 VSS.n61 0.121828
R1299 VSS.n63 VSS.t81 0.12182
R1300 VSS.t81 VSS.n62 0.12186
R1301 VSS.n19 VSS.t552 57.0465
R1302 VSS.t555 VSS.n27 57.0465
R1303 VSS.n21 VSS.t558 57.0465
R1304 VSS.n23 VSS.t562 57.0465
R1305 VSS.n94 VSS.t81 0.219075
R1306 VSS.t440 VSS.n1004 56.194
R1307 VSS.t56 VSS.n932 55.8744
R1308 VSS.t38 VSS.t71 55.8744
R1309 VSS.t221 VSS.n925 55.8744
R1310 VSS.t222 VSS.t103 55.8744
R1311 VSS.n992 VSS.t309 55.7148
R1312 VSS.n1070 VSS.t206 55.7148
R1313 VSS.t225 VSS.n82 64.8314
R1314 VSS.n946 VSS.t170 54.8687
R1315 VSS.n959 VSS.t255 54.1672
R1316 VSS.t156 VSS.t9 53.8079
R1317 VSS.n811 VSS.t388 53.1692
R1318 VSS.t340 VSS.n35 53.1692
R1319 VSS.t462 VSS.t81 26.5067
R1320 VSS.t477 VSS.t81 26.5067
R1321 VSS.t81 VSS.t565 26.5067
R1322 VSS.t488 VSS.t81 26.5047
R1323 VSS.n98 VSS.t81 0.203703
R1324 VSS.t442 VSS.t81 26.5067
R1325 VSS.t391 VSS.n82 16.4283
R1326 VSS.n1101 VSS.t314 51.5764
R1327 VSS.t150 VSS.n1045 51.5764
R1328 VSS.t97 VSS.n91 66.3233
R1329 VSS.n1011 VSS.t274 51.5764
R1330 VSS.t127 VSS.t275 51.5764
R1331 VSS.t261 VSS.n923 51.5764
R1332 VSS.t724 VSS.t844 51.4291
R1333 VSS.t846 VSS.t726 51.4291
R1334 VSS.t729 VSS.t848 51.4291
R1335 VSS.n956 VSS.t417 51.4291
R1336 VSS.n4 VSS.t441 26.1613
R1337 VSS.t443 VSS.n89 47.2102
R1338 VSS.n78 VSS.t458 48.8187
R1339 VSS.t461 VSS.n96 26.1613
R1340 VSS.n30 VSS.t464 26.1544
R1341 VSS.n31 VSS.t465 26.1053
R1342 VSS.n57 VSS.t470 26.1053
R1343 VSS.n60 VSS.t474 26.2515
R1344 VSS.t476 VSS.n59 26.2591
R1345 VSS.t478 VSS.n5 47.2102
R1346 VSS.t482 VSS.n61 26.2522
R1347 VSS.n63 VSS.t484 26.2515
R1348 VSS.t487 VSS.n62 26.2591
R1349 VSS.n9 VSS.t489 47.2102
R1350 VSS.t497 VSS.n3 26.2524
R1351 VSS.t507 VSS.n84 26.1544
R1352 VSS.t517 VSS.n13 48.8187
R1353 VSS.n81 VSS.t520 47.2102
R1354 VSS.t527 VSS.n2 26.2517
R1355 VSS.t532 VSS.n1 26.2517
R1356 VSS.t537 VSS.n0 26.2517
R1357 VSS.t547 VSS.n29 26.2593
R1358 VSS.t552 VSS.n28 48.6385
R1359 VSS.n20 VSS.t555 48.6385
R1360 VSS.t558 VSS.n26 48.6385
R1361 VSS.t559 VSS.n22 47.2102
R1362 VSS.t562 VSS.n90 48.8187
R1363 VSS.n94 VSS.t564 26.1613
R1364 VSS.n25 VSS.t566 47.2101
R1365 VSS.n70 VSS.t418 37.8459
R1366 VSS.t356 VSS.n930 47.2784
R1367 VSS.n1010 VSS.t253 47.2784
R1368 VSS.t117 VSS.t262 47.2784
R1369 VSS.n85 VSS.t502 26.2514
R1370 VSS.n77 VSS.t456 26.2512
R1371 VSS.t448 VSS.n87 26.1058
R1372 VSS.t457 VSS.n78 26.0021
R1373 VSS.t468 VSS.n58 26.106
R1374 VSS.t509 VSS.n83 26.1058
R1375 VSS.t529 VSS.n1 26.1056
R1376 VSS.t539 VSS.n80 26.1056
R1377 VSS.t551 VSS.n28 47.0238
R1378 VSS.t554 VSS.n20 47.0238
R1379 VSS.n26 VSS.t556 47.0238
R1380 VSS.t561 VSS.n90 26.0019
R1381 VSS.t169 VSS.t4 45.8338
R1382 VSS.t3 VSS.t413 45.8338
R1383 VSS.t434 VSS.n674 45.7034
R1384 VSS.t27 VSS.n33 44.8359
R1385 VSS.n1047 VSS.t419 44.8359
R1386 VSS.n109 VSS.t443 58.3202
R1387 VSS.t81 VSS.n87 0.121819
R1388 VSS.n126 VSS.t489 58.3202
R1389 VSS.n3 VSS.t494 26.1049
R1390 VSS.n85 VSS.t499 26.1059
R1391 VSS.n176 VSS.t505 58.3202
R1392 VSS.n13 VSS.t514 26.0019
R1393 VSS.t520 VSS.n141 58.3202
R1394 VSS.n2 VSS.t524 26.1056
R1395 VSS.n0 VSS.t534 26.1056
R1396 VSS.t81 VSS.n80 0.121819
R1397 VSS.n29 VSS.t544 26.1049
R1398 VSS.t293 VSS.t210 42.9804
R1399 VSS.n978 VSS.t429 42.9804
R1400 VSS.t126 VSS.n926 42.9804
R1401 VSS.n1094 VSS.t163 42.8576
R1402 VSS.t74 VSS.n963 42.8576
R1403 VSS.n1064 VSS.t380 42.8576
R1404 VSS.t451 VSS.n87 26.2515
R1405 VSS.t81 VSS.n84 0.219018
R1406 VSS.n124 VSS.t517 56.7064
R1407 VSS.t9 VSS.n91 1.60658
R1408 VSS.t9 VSS.t117 42.1172
R1409 VSS.t385 VSS.n950 40.8632
R1410 VSS.n943 VSS.t82 40.8632
R1411 VSS.t81 VSS.t504 26.4908
R1412 VSS.n98 VSS.t518 26.3338
R1413 VSS.t81 VSS.t549 26.5063
R1414 VSS.t70 VSS.n930 38.6824
R1415 VSS.n1016 VSS.n1015 38.6824
R1416 VSS.t406 VSS.n982 38.5719
R1417 VSS.n984 VSS.t409 38.5719
R1418 VSS.t330 VSS.n1085 38.5719
R1419 VSS.n1090 VSS.t334 38.5719
R1420 VSS.n1019 VSS.t185 38.5719
R1421 VSS.n1021 VSS.t189 38.5719
R1422 VSS.n1028 VSS.t399 38.5719
R1423 VSS.t402 VSS.n911 38.5719
R1424 VSS.n1076 VSS.t297 38.5719
R1425 VSS.n1073 VSS.t300 38.5719
R1426 VSS.t144 VSS.n1059 38.5719
R1427 VSS.n1057 VSS.t147 38.5719
R1428 VSS.n892 VSS.t173 37.5005
R1429 VSS.t236 VSS.n1035 37.5005
R1430 VSS.n1050 VSS.t229 37.5005
R1431 VSS.n41 VSS.t426 37.1968
R1432 VSS.n12 VSS.t225 36.5343
R1433 VSS.t170 VSS.n16 36.5343
R1434 VSS.n1013 VSS.t38 34.3845
R1435 VSS.n967 VSS.t40 34.2862
R1436 VSS.t14 VSS.n910 34.2862
R1437 VSS.t369 VSS.n1065 34.2862
R1438 VSS.t19 VSS.t412 34.2862
R1439 VSS.t110 VSS.n813 32.8988
R1440 VSS.t357 VSS.n932 30.0865
R1441 VSS.t125 VSS.n928 30.0865
R1442 VSS.n1015 VSS.t103 30.0865
R1443 VSS.n968 VSS.t67 30.0005
R1444 VSS.n973 VSS.t424 30.0005
R1445 VSS.t818 VSS.t721 30.0005
R1446 VSS.n1018 VSS.t361 30.0005
R1447 VSS.n958 VSS.t254 30.0005
R1448 VSS.t215 VSS.t9 29.2233
R1449 VSS.t161 VSS.n1034 29.1672
R1450 VSS.t116 VSS.n46 28.6008
R1451 VSS.t366 VSS.n889 28.5605
R1452 VSS.n678 VSS.t407 28.5605
R1453 VSS.t408 VSS.n678 28.5605
R1454 VSS.n1089 VSS.t331 28.5605
R1455 VSS.t332 VSS.n1089 28.5605
R1456 VSS.n1020 VSS.t186 28.5605
R1457 VSS.t187 VSS.n1020 28.5605
R1458 VSS.t400 VSS.n48 28.5605
R1459 VSS.n48 VSS.t401 28.5605
R1460 VSS.t145 VSS.n1058 28.5605
R1461 VSS.n1058 VSS.t146 28.5605
R1462 VSS.t232 VSS.n17 27.6595
R1463 VSS.t345 VSS.n107 38.7811
R1464 VSS.n65 VSS.t80 38.7878
R1465 VSS.n949 VSS.t396 27.4346
R1466 VSS.t85 VSS.n944 27.4346
R1467 VSS.t243 VSS.n945 27.4346
R1468 VSS.t77 VSS.n900 25.7148
R1469 VSS.t203 VSS.n894 25.7148
R1470 VSS.t6 VSS.n954 25.7148
R1471 VSS.t210 VSS.n813 24.3028
R1472 VSS.t205 VSS.n695 24.2748
R1473 VSS.n66 VSS.t370 14.2633
R1474 VSS.n106 VSS.t81 2.33071
R1475 VSS.n119 VSS.t354 13.9422
R1476 VSS.t81 VSS.n112 3.37712
R1477 VSS.n113 VSS.t81 3.37712
R1478 VSS.t247 VSS.n120 13.9422
R1479 VSS.t242 VSS.n99 13.9374
R1480 VSS.t81 VSS.n68 3.36914
R1481 VSS.t81 VSS.n64 2.32488
R1482 VSS.t230 VSS.n11 21.5455
R1483 VSS.t72 VSS.n929 21.4905
R1484 VSS.t257 VSS.n41 20.0048
R1485 VSS.t81 VSS.n107 2.99891
R1486 VSS.n65 VSS.t81 2.99072
R1487 VSS.t81 VSS.n67 1.8139
R1488 VSS.t204 VSS.n10 18.7838
R1489 VSS.n14 VSS.t240 18.7838
R1490 VSS.n15 VSS.t239 18.7838
R1491 VSS.t359 VSS.n106 20.3759
R1492 VSS.n119 VSS.t425 29.5272
R1493 VSS.n112 VSS.t362 29.5272
R1494 VSS.n68 VSS.t428 29.5336
R1495 VSS.n948 VSS.t235 18.5589
R1496 VSS.t87 VSS.n99 29.5281
R1497 VSS.t89 VSS.n113 29.5272
R1498 VSS.t244 VSS.n120 29.5272
R1499 VSS.n950 VSS.t395 17.4635
R1500 VSS.t241 VSS.n943 17.4635
R1501 VSS.t280 VSS.t203 17.1434
R1502 VSS.t178 VSS.t339 17.1434
R1503 VSS.t644 VSS.t196 17.1434
R1504 VSS.t411 VSS.t145 17.1434
R1505 VSS.t260 VSS.t216 17.1434
R1506 VSS.n93 VSS.t9 0.281794
R1507 VSS.n208 VSS.n79 5.6463
R1508 VSS.t81 VSS.n119 3.37712
R1509 VSS.t81 VSS.n951 17.0005
R1510 VSS.t81 VSS.n66 3.49504
R1511 VSS.t81 VSS.n82 4.38202
R1512 VSS.t81 VSS.n949 17.0005
R1513 VSS.t81 VSS.n948 17.0005
R1514 VSS.t81 VSS.n176 0.405951
R1515 VSS.t81 VSS.n947 17.0005
R1516 VSS.t81 VSS.n946 17.0005
R1517 VSS.t81 VSS.n944 17.0005
R1518 VSS.t81 VSS.n945 17.0005
R1519 VSS.t81 VSS.n99 3.37595
R1520 VSS.n141 VSS.t81 0.405951
R1521 VSS.t81 VSS.n120 3.37712
R1522 VSS.n177 VSS.t81 5.6463
R1523 VSS.t392 VSS.n148 4.17719
R1524 VSS.n290 VSS.n69 5.6463
R1525 VSS.n71 VSS.n346 5.6463
R1526 VSS.n402 VSS.n75 5.6463
R1527 VSS.n501 VSS.n869 17.0005
R1528 VSS.n502 VSS.n501 5.61485
R1529 VSS.n73 VSS.n637 5.6463
R1530 VSS.n677 VSS.n1088 17.0005
R1531 VSS.n677 VSS.n902 17.0005
R1532 VSS.n677 VSS.n1079 17.0005
R1533 VSS.n677 VSS.n1080 17.0005
R1534 VSS.n677 VSS.n1087 17.0005
R1535 VSS.n677 VSS.n1086 17.0005
R1536 VSS.n677 VSS.n1084 17.0005
R1537 VSS.n677 VSS.n1083 17.0005
R1538 VSS.n677 VSS.n1082 17.0005
R1539 VSS.n677 VSS.n1081 17.0005
R1540 VSS.n677 VSS.n1085 17.0005
R1541 VSS.t155 VSS.n1101 17.0005
R1542 VSS.n1099 VSS.n685 17.0005
R1543 VSS.n685 VSS.n891 17.0005
R1544 VSS.n685 VSS.n892 17.0005
R1545 VSS.n1098 VSS.n682 17.0005
R1546 VSS.n682 VSS.n1097 17.0005
R1547 VSS.n682 VSS.n893 17.0005
R1548 VSS.n682 VSS.n1096 17.0005
R1549 VSS.n682 VSS.n894 17.0005
R1550 VSS.n682 VSS.n1095 17.0005
R1551 VSS.n682 VSS.n895 17.0005
R1552 VSS.n682 VSS.n1094 17.0005
R1553 VSS.n682 VSS.n1093 17.0005
R1554 VSS.n682 VSS.n897 17.0005
R1555 VSS.n682 VSS.n1092 17.0005
R1556 VSS.n682 VSS.n898 17.0005
R1557 VSS.n682 VSS.n899 17.0005
R1558 VSS.n682 VSS.n1091 17.0005
R1559 VSS.n682 VSS.n900 17.0005
R1560 VSS.n680 VSS.t304 17.0005
R1561 VSS.n680 VSS.n901 17.0005
R1562 VSS.n680 VSS.n1090 17.0005
R1563 VSS.n677 VSS.n903 17.0005
R1564 VSS.n677 VSS.n905 17.0005
R1565 VSS.n677 VSS.n904 17.0005
R1566 VSS.n676 VSS.n984 17.0005
R1567 VSS.n676 VSS.n982 17.0005
R1568 VSS.n676 VSS.n983 17.0005
R1569 VSS.n672 VSS.n986 17.0005
R1570 VSS.n672 VSS.n981 17.0005
R1571 VSS.n987 VSS.n672 17.0005
R1572 VSS.n669 VSS.n988 17.0005
R1573 VSS.n989 VSS.n669 17.0005
R1574 VSS.n666 VSS.n990 17.0005
R1575 VSS.n666 VSS.n980 17.0005
R1576 VSS.n667 VSS.n992 17.0005
R1577 VSS.n667 VSS.n979 17.0005
R1578 VSS.n993 VSS.n667 17.0005
R1579 VSS.t96 VSS.n994 17.0005
R1580 VSS.t96 VSS.n977 17.0005
R1581 VSS.t96 VSS.n978 17.0005
R1582 VSS.t155 VSS.n886 17.0005
R1583 VSS.n759 VSS.n1129 17.0005
R1584 VSS.n759 VSS.n1128 17.0005
R1585 VSS.n1130 VSS.n759 17.0005
R1586 VSS.n755 VSS.n1131 17.0005
R1587 VSS.n755 VSS.n1127 17.0005
R1588 VSS.n1132 VSS.n755 17.0005
R1589 VSS.n751 VSS.n1133 17.0005
R1590 VSS.n751 VSS.n1126 17.0005
R1591 VSS.n1134 VSS.n751 17.0005
R1592 VSS.n747 VSS.n1135 17.0005
R1593 VSS.n747 VSS.n1125 17.0005
R1594 VSS.n1136 VSS.n747 17.0005
R1595 VSS.n743 VSS.n1137 17.0005
R1596 VSS.n743 VSS.n872 17.0005
R1597 VSS.n743 VSS.n1124 17.0005
R1598 VSS.n1123 VSS.n739 17.0005
R1599 VSS.n739 VSS.n873 17.0005
R1600 VSS.n739 VSS.n1122 17.0005
R1601 VSS.n1121 VSS.n735 17.0005
R1602 VSS.n735 VSS.n874 17.0005
R1603 VSS.n735 VSS.n1120 17.0005
R1604 VSS.n1119 VSS.n731 17.0005
R1605 VSS.n731 VSS.n875 17.0005
R1606 VSS.n731 VSS.n1118 17.0005
R1607 VSS.n1117 VSS.n727 17.0005
R1608 VSS.n727 VSS.n876 17.0005
R1609 VSS.n727 VSS.n1116 17.0005
R1610 VSS.n1115 VSS.n723 17.0005
R1611 VSS.n723 VSS.n877 17.0005
R1612 VSS.n723 VSS.n1114 17.0005
R1613 VSS.n1113 VSS.n719 17.0005
R1614 VSS.n719 VSS.n878 17.0005
R1615 VSS.n719 VSS.n1112 17.0005
R1616 VSS.n1111 VSS.n715 17.0005
R1617 VSS.n715 VSS.n879 17.0005
R1618 VSS.n715 VSS.n1110 17.0005
R1619 VSS.n1109 VSS.n711 17.0005
R1620 VSS.n711 VSS.n880 17.0005
R1621 VSS.n711 VSS.n1108 17.0005
R1622 VSS.n1107 VSS.n707 17.0005
R1623 VSS.n707 VSS.n881 17.0005
R1624 VSS.n707 VSS.n1106 17.0005
R1625 VSS.n1105 VSS.n704 17.0005
R1626 VSS.n704 VSS.n882 17.0005
R1627 VSS.n704 VSS.n1104 17.0005
R1628 VSS.n1103 VSS.n702 17.0005
R1629 VSS.n702 VSS.n883 17.0005
R1630 VSS.n702 VSS.n1102 17.0005
R1631 VSS.n702 VSS.n884 17.0005
R1632 VSS.n702 VSS.n885 17.0005
R1633 VSS.t155 VSS.n890 17.0005
R1634 VSS.t155 VSS.n888 17.0005
R1635 VSS.t155 VSS.n887 17.0005
R1636 VSS.n995 VSS.t96 17.0005
R1637 VSS.n809 VSS.n996 17.0005
R1638 VSS.n809 VSS.n974 17.0005
R1639 VSS.n809 VSS.n976 17.0005
R1640 VSS.n809 VSS.n975 17.0005
R1641 VSS.n997 VSS.n809 17.0005
R1642 VSS.t681 VSS.n998 17.0005
R1643 VSS.t681 VSS.n973 17.0005
R1644 VSS.t681 VSS.n969 17.0005
R1645 VSS.t681 VSS.n972 17.0005
R1646 VSS.t681 VSS.n970 17.0005
R1647 VSS.t681 VSS.n971 17.0005
R1648 VSS.n999 VSS.t681 17.0005
R1649 VSS.t681 VSS.n1000 17.0005
R1650 VSS.t681 VSS.n962 17.0005
R1651 VSS.t681 VSS.n968 17.0005
R1652 VSS.t681 VSS.n963 17.0005
R1653 VSS.t681 VSS.n967 17.0005
R1654 VSS.t681 VSS.n964 17.0005
R1655 VSS.t681 VSS.n966 17.0005
R1656 VSS.t681 VSS.n965 17.0005
R1657 VSS.t9 VSS.n1033 17.0005
R1658 VSS.t9 VSS.n1034 17.0005
R1659 VSS.t9 VSS.n1038 17.0005
R1660 VSS.t9 VSS.n1035 17.0005
R1661 VSS.t9 VSS.n1037 17.0005
R1662 VSS.t9 VSS.n1036 17.0005
R1663 VSS.n1042 VSS.t9 17.0005
R1664 VSS.t9 VSS.n1039 17.0005
R1665 VSS.t9 VSS.n1040 17.0005
R1666 VSS.n1041 VSS.t9 17.0005
R1667 VSS.t9 VSS.n70 2.49582
R1668 VSS.n1043 VSS.t9 17.0005
R1669 VSS.n1044 VSS.t9 17.0005
R1670 VSS.n1045 VSS.t9 17.0005
R1671 VSS.n1046 VSS.t9 17.0005
R1672 VSS.n1048 VSS.t9 17.0005
R1673 VSS.n1050 VSS.t9 17.0005
R1674 VSS.n1052 VSS.t9 17.0005
R1675 VSS.n1053 VSS.t9 17.0005
R1676 VSS.n1054 VSS.t9 17.0005
R1677 VSS.n1055 VSS.t9 17.0005
R1678 VSS.n1056 VSS.t9 17.0005
R1679 VSS.n1057 VSS.t9 17.0005
R1680 VSS.n1059 VSS.t9 17.0005
R1681 VSS.n1060 VSS.t9 17.0005
R1682 VSS.n1061 VSS.t9 17.0005
R1683 VSS.n1062 VSS.t9 17.0005
R1684 VSS.n1063 VSS.t9 17.0005
R1685 VSS.n1064 VSS.t9 17.0005
R1686 VSS.n1065 VSS.t9 17.0005
R1687 VSS.n1066 VSS.t9 17.0005
R1688 VSS.n1067 VSS.t9 17.0005
R1689 VSS.n1068 VSS.t9 17.0005
R1690 VSS.n1069 VSS.t9 17.0005
R1691 VSS.n1070 VSS.t9 17.0005
R1692 VSS.n1071 VSS.t9 17.0005
R1693 VSS.n1072 VSS.t9 17.0005
R1694 VSS.n1073 VSS.t9 17.0005
R1695 VSS.n1074 VSS.t9 17.0005
R1696 VSS.n1075 VSS.t9 17.0005
R1697 VSS.t9 VSS.n1076 17.0005
R1698 VSS.t9 VSS.n909 17.0005
R1699 VSS.t9 VSS.n1032 17.0005
R1700 VSS.t9 VSS.n1031 17.0005
R1701 VSS.t9 VSS.n910 17.0005
R1702 VSS.t9 VSS.n1030 17.0005
R1703 VSS.t9 VSS.n1029 17.0005
R1704 VSS.t9 VSS.n911 17.0005
R1705 VSS.t9 VSS.n1028 17.0005
R1706 VSS.t9 VSS.n912 17.0005
R1707 VSS.t9 VSS.n1027 17.0005
R1708 VSS.t9 VSS.n913 17.0005
R1709 VSS.t9 VSS.n1026 17.0005
R1710 VSS.t9 VSS.n914 17.0005
R1711 VSS.t9 VSS.n1025 17.0005
R1712 VSS.t9 VSS.n915 17.0005
R1713 VSS.t9 VSS.n1024 17.0005
R1714 VSS.t9 VSS.n916 17.0005
R1715 VSS.t9 VSS.n1023 17.0005
R1716 VSS.t9 VSS.n917 17.0005
R1717 VSS.t9 VSS.n1022 17.0005
R1718 VSS.t9 VSS.n918 17.0005
R1719 VSS.t9 VSS.n1021 17.0005
R1720 VSS.n1019 VSS.t9 17.0005
R1721 VSS.t9 VSS.n919 17.0005
R1722 VSS.t9 VSS.n920 17.0005
R1723 VSS.t9 VSS.n1018 17.0005
R1724 VSS.t9 VSS.n921 17.0005
R1725 VSS.t9 VSS.n1017 17.0005
R1726 VSS.t9 VSS.n923 17.0005
R1727 VSS.t9 VSS.n1014 17.0005
R1728 VSS.t9 VSS.n924 17.0005
R1729 VSS.n1015 VSS.t9 17.0005
R1730 VSS.t9 VSS.n925 17.0005
R1731 VSS.t9 VSS.n1013 17.0005
R1732 VSS.t9 VSS.n926 17.0005
R1733 VSS.t9 VSS.n1012 17.0005
R1734 VSS.t9 VSS.n928 17.0005
R1735 VSS.t9 VSS.n1011 17.0005
R1736 VSS.t9 VSS.n929 17.0005
R1737 VSS.t9 VSS.n1010 17.0005
R1738 VSS.t9 VSS.n930 17.0005
R1739 VSS.t9 VSS.n1009 17.0005
R1740 VSS.t9 VSS.n931 17.0005
R1741 VSS.t9 VSS.n1008 17.0005
R1742 VSS.t9 VSS.n1007 17.0005
R1743 VSS.t9 VSS.n937 17.0005
R1744 VSS.t9 VSS.n932 17.0005
R1745 VSS.t9 VSS.n936 17.0005
R1746 VSS.t9 VSS.n935 17.0005
R1747 VSS.t9 VSS.n933 17.0005
R1748 VSS.t9 VSS.n934 17.0005
R1749 VSS.t9 VSS.n961 17.0005
R1750 VSS.t9 VSS.n960 17.0005
R1751 VSS.t9 VSS.n115 0.666899
R1752 VSS.t9 VSS.n952 17.0005
R1753 VSS.t9 VSS.n959 17.0005
R1754 VSS.t9 VSS.n953 17.0005
R1755 VSS.t9 VSS.n958 17.0005
R1756 VSS.t9 VSS.n957 17.0005
R1757 VSS.t9 VSS.n954 17.0005
R1758 VSS.t9 VSS.n956 17.0005
R1759 VSS.t9 VSS.n955 17.0005
R1760 VSS.t379 VSS.n940 16.6566
R1761 VSS.t339 VSS.n695 15.7034
R1762 VSS.t84 VSS.n942 15.0429
R1763 VSS.t431 VSS.n6 14.7493
R1764 VSS.n942 VSS.t207 13.4291
R1765 VSS.t24 VSS.t22 12.8945
R1766 VSS.t358 VSS.n931 12.8945
R1767 VSS.n1009 VSS.t256 12.8945
R1768 VSS.t287 VSS.n993 12.8576
R1769 VSS.n1018 VSS.t218 12.8576
R1770 VSS.t298 VSS.n1075 12.8576
R1771 VSS.n1074 VSS.t299 12.8576
R1772 VSS.t365 VSS.t855 12.5005
R1773 VSS.t160 VSS.t2 12.5005
R1774 VSS.n940 VSS.t384 11.8153
R1775 VSS.n1012 VSS.t127 8.59649
R1776 VSS.t837 VSS.t322 8.57193
R1777 VSS.n1000 VSS.t73 8.57193
R1778 VSS.n1030 VSS.t12 8.57193
R1779 VSS.n1061 VSS.t383 8.57193
R1780 VSS.t392 VSS.n179 3.31921
R1781 VSS.n510 VSS.t312 8.50588
R1782 VSS.n79 VSS.t3305 8.50199
R1783 VSS.t2640 VSS.n69 8.50198
R1784 VSS.t2248 VSS.n71 8.50198
R1785 VSS.n75 VSS.t1856 8.50198
R1786 VSS.t1175 VSS.n73 8.50198
R1787 VSS.n235 VSS.t3302 0.130189
R1788 VSS.t3300 VSS.n79 8.501
R1789 VSS.n234 VSS.t3297 0.130189
R1790 VSS.t3295 VSS.n79 8.501
R1791 VSS.n233 VSS.t3292 0.130189
R1792 VSS.t3290 VSS.n79 8.501
R1793 VSS.n232 VSS.t3287 0.130189
R1794 VSS.t3285 VSS.n79 8.501
R1795 VSS.n231 VSS.t3282 0.130189
R1796 VSS.t3280 VSS.n79 8.501
R1797 VSS.t3277 VSS.n230 0.130189
R1798 VSS.t3275 VSS.n79 8.501
R1799 VSS.t3272 VSS.n229 0.130189
R1800 VSS.t3270 VSS.n79 8.501
R1801 VSS.t3267 VSS.n228 0.130189
R1802 VSS.t3265 VSS.n79 8.501
R1803 VSS.t3262 VSS.n227 0.130189
R1804 VSS.t3260 VSS.n79 8.501
R1805 VSS.t3257 VSS.n226 0.130189
R1806 VSS.t3255 VSS.n79 8.501
R1807 VSS.t3252 VSS.n225 0.130189
R1808 VSS.t3250 VSS.n79 8.501
R1809 VSS.t3247 VSS.n224 0.130189
R1810 VSS.t3245 VSS.n79 8.501
R1811 VSS.t3242 VSS.n223 0.130189
R1812 VSS.t3240 VSS.n79 8.501
R1813 VSS.t3237 VSS.n222 0.130189
R1814 VSS.t3235 VSS.n79 8.501
R1815 VSS.t3232 VSS.n221 0.130189
R1816 VSS.t3230 VSS.n79 8.501
R1817 VSS.t3227 VSS.n220 0.130189
R1818 VSS.t3225 VSS.n79 8.501
R1819 VSS.t3222 VSS.n219 0.130189
R1820 VSS.t3220 VSS.n79 8.501
R1821 VSS.t3217 VSS.n218 0.130189
R1822 VSS.t3215 VSS.n79 8.501
R1823 VSS.t3212 VSS.n217 0.130189
R1824 VSS.t3210 VSS.n79 8.501
R1825 VSS.t3207 VSS.n216 0.130189
R1826 VSS.t3205 VSS.n79 8.501
R1827 VSS.t3202 VSS.n215 0.130189
R1828 VSS.t3200 VSS.n79 8.501
R1829 VSS.t3197 VSS.n214 0.130189
R1830 VSS.t3195 VSS.n79 8.501
R1831 VSS.t3192 VSS.n213 0.130189
R1832 VSS.t3190 VSS.n79 8.501
R1833 VSS.t3187 VSS.n212 0.130189
R1834 VSS.t3185 VSS.n79 8.501
R1835 VSS.t3182 VSS.n211 0.130189
R1836 VSS.t3180 VSS.n79 8.501
R1837 VSS.t3177 VSS.n210 0.130189
R1838 VSS.t3175 VSS.n79 8.501
R1839 VSS.n209 VSS.t3172 0.130189
R1840 VSS.t3170 VSS.n178 0.0836055
R1841 VSS.t3167 VSS.n208 0.0333775
R1842 VSS.t3165 VSS.n79 8.501
R1843 VSS.t3162 VSS.n207 0.130189
R1844 VSS.t3160 VSS.n79 8.501
R1845 VSS.t3157 VSS.n206 0.130189
R1846 VSS.t3155 VSS.n79 8.501
R1847 VSS.t3152 VSS.n205 0.130189
R1848 VSS.t3150 VSS.n79 8.501
R1849 VSS.t3147 VSS.n204 0.130189
R1850 VSS.t3145 VSS.n79 8.501
R1851 VSS.t3142 VSS.n203 0.130189
R1852 VSS.t3140 VSS.n79 8.501
R1853 VSS.t3137 VSS.n202 0.130189
R1854 VSS.t3135 VSS.n79 8.501
R1855 VSS.t3132 VSS.n201 0.130189
R1856 VSS.t3130 VSS.n79 8.501
R1857 VSS.t3127 VSS.n200 0.130189
R1858 VSS.t3125 VSS.n79 8.501
R1859 VSS.t3122 VSS.n199 0.130189
R1860 VSS.t3120 VSS.n79 8.501
R1861 VSS.t3117 VSS.n198 0.130189
R1862 VSS.t3115 VSS.n79 8.501
R1863 VSS.t3112 VSS.n197 0.130189
R1864 VSS.t3110 VSS.n79 8.501
R1865 VSS.t3107 VSS.n196 0.130189
R1866 VSS.t3105 VSS.n79 8.501
R1867 VSS.t3102 VSS.n195 0.130189
R1868 VSS.t3100 VSS.n79 8.501
R1869 VSS.t3097 VSS.n194 0.130189
R1870 VSS.t3095 VSS.n79 8.501
R1871 VSS.t3092 VSS.n193 0.130189
R1872 VSS.t3090 VSS.n79 8.501
R1873 VSS.t3087 VSS.n192 0.130189
R1874 VSS.t3085 VSS.n79 8.501
R1875 VSS.t3082 VSS.n191 0.130189
R1876 VSS.t3080 VSS.n79 8.501
R1877 VSS.t3077 VSS.n190 0.130189
R1878 VSS.t3075 VSS.n79 8.501
R1879 VSS.t3072 VSS.n189 0.130189
R1880 VSS.t3070 VSS.n79 8.501
R1881 VSS.t3067 VSS.n188 0.130189
R1882 VSS.t3065 VSS.n79 8.501
R1883 VSS.n187 VSS.t3062 0.130189
R1884 VSS.t3060 VSS.n79 8.501
R1885 VSS.n186 VSS.t3057 0.130189
R1886 VSS.t3052 VSS.n185 0.215686
R1887 VSS.t3050 VSS.n79 8.501
R1888 VSS.n184 VSS.t3047 0.130189
R1889 VSS.t3045 VSS.n79 8.501
R1890 VSS.n183 VSS.t3042 0.130189
R1891 VSS.t3040 VSS.n79 8.501
R1892 VSS.n182 VSS.t3037 0.130189
R1893 VSS.t3035 VSS.n79 8.501
R1894 VSS.n181 VSS.t3032 0.130189
R1895 VSS.t3030 VSS.n79 8.501
R1896 VSS.n79 VSS.n180 3.33079
R1897 VSS.n845 VSS.t81 0.338438
R1898 VSS.n846 VSS.t81 3.32876
R1899 VSS.t449 VSS.t81 8.501
R1900 VSS.t81 VSS.n847 3.32876
R1901 VSS.n177 VSS.t454 0.0333775
R1902 VSS.t490 VSS.n236 0.743924
R1903 VSS.n237 VSS.t81 3.32876
R1904 VSS.t495 VSS.t81 8.501
R1905 VSS.n238 VSS.t81 3.32876
R1906 VSS.n125 VSS.t81 5.6463
R1907 VSS.n239 VSS.t81 4.20253
R1908 VSS.t81 VSS.t226 8.501
R1909 VSS.n240 VSS.t81 0.440816
R1910 VSS.n241 VSS.t81 3.32876
R1911 VSS.t510 VSS.t81 8.501
R1912 VSS.n242 VSS.t81 3.32876
R1913 VSS.t515 VSS.t81 8.501
R1914 VSS.n243 VSS.t81 3.32876
R1915 VSS.n244 VSS.t81 0.642426
R1916 VSS.t81 VSS.n245 1.73631
R1917 VSS.n246 VSS.t81 3.32876
R1918 VSS.t81 VSS.t525 8.501
R1919 VSS.n247 VSS.t81 3.32876
R1920 VSS.t530 VSS.t81 8.501
R1921 VSS.n248 VSS.t81 3.32876
R1922 VSS.t535 VSS.t81 8.501
R1923 VSS.n249 VSS.t81 3.32876
R1924 VSS.t540 VSS.t81 8.501
R1925 VSS.n250 VSS.t81 3.32876
R1926 VSS.t545 VSS.t81 8.501
R1927 VSS.n251 VSS.t81 3.32876
R1928 VSS.t550 VSS.t81 8.501
R1929 VSS.n317 VSS.t2637 0.130189
R1930 VSS.t2635 VSS.n69 8.501
R1931 VSS.n316 VSS.t2632 0.130189
R1932 VSS.t2630 VSS.n69 8.501
R1933 VSS.n315 VSS.t2627 0.130189
R1934 VSS.t2625 VSS.n69 8.501
R1935 VSS.n314 VSS.t2622 0.130189
R1936 VSS.t2620 VSS.n69 8.501
R1937 VSS.n313 VSS.t2617 0.130189
R1938 VSS.t2615 VSS.n69 8.501
R1939 VSS.n312 VSS.t2612 0.130189
R1940 VSS.t2610 VSS.n69 8.501
R1941 VSS.n311 VSS.t2607 0.130189
R1942 VSS.t2605 VSS.n69 8.501
R1943 VSS.n310 VSS.t2602 0.130189
R1944 VSS.t2600 VSS.n69 8.501
R1945 VSS.n309 VSS.t2597 0.130189
R1946 VSS.t2595 VSS.n69 8.501
R1947 VSS.n308 VSS.t2592 0.130189
R1948 VSS.t2590 VSS.n69 8.501
R1949 VSS.n307 VSS.t2587 0.130189
R1950 VSS.t2585 VSS.n69 8.501
R1951 VSS.n306 VSS.t2582 0.130189
R1952 VSS.t2580 VSS.n69 8.501
R1953 VSS.n305 VSS.t2577 0.130189
R1954 VSS.t2575 VSS.n69 8.501
R1955 VSS.n304 VSS.t2572 0.130189
R1956 VSS.t2570 VSS.n69 8.501
R1957 VSS.n303 VSS.t2567 0.130189
R1958 VSS.t2565 VSS.n69 8.501
R1959 VSS.n302 VSS.t2562 0.130189
R1960 VSS.t2560 VSS.n69 8.501
R1961 VSS.n301 VSS.t2557 0.130189
R1962 VSS.t2555 VSS.n69 8.501
R1963 VSS.n300 VSS.t2552 0.130189
R1964 VSS.t2550 VSS.n69 8.501
R1965 VSS.n299 VSS.t2547 0.130189
R1966 VSS.t2545 VSS.n69 8.501
R1967 VSS.n298 VSS.t2542 0.130189
R1968 VSS.t2540 VSS.n69 8.501
R1969 VSS.n297 VSS.t2537 0.130189
R1970 VSS.t2535 VSS.n69 8.501
R1971 VSS.n296 VSS.t2532 0.130189
R1972 VSS.t2530 VSS.n69 8.501
R1973 VSS.n295 VSS.t2527 0.130189
R1974 VSS.t2525 VSS.n69 8.501
R1975 VSS.n294 VSS.t2522 0.130189
R1976 VSS.t2520 VSS.n69 8.501
R1977 VSS.n293 VSS.t2517 0.130189
R1978 VSS.t2515 VSS.n69 8.501
R1979 VSS.n292 VSS.t2512 0.130189
R1980 VSS.t2510 VSS.n69 8.501
R1981 VSS.n291 VSS.t2507 0.130189
R1982 VSS.n290 VSS.t2502 0.0333775
R1983 VSS.n69 VSS.t2500 8.501
R1984 VSS.t2497 VSS.n289 0.130189
R1985 VSS.t2495 VSS.n69 8.501
R1986 VSS.t2492 VSS.n288 0.130189
R1987 VSS.t2490 VSS.n69 8.501
R1988 VSS.t2487 VSS.n287 0.130189
R1989 VSS.t2485 VSS.n69 8.501
R1990 VSS.t2482 VSS.n286 0.130189
R1991 VSS.t2480 VSS.n69 8.501
R1992 VSS.t2477 VSS.n285 0.130189
R1993 VSS.t2475 VSS.n69 8.501
R1994 VSS.t2472 VSS.n284 0.130189
R1995 VSS.t2470 VSS.n69 8.501
R1996 VSS.t2467 VSS.n283 0.130189
R1997 VSS.t2465 VSS.n69 8.501
R1998 VSS.t2462 VSS.n282 0.130189
R1999 VSS.t2460 VSS.n69 8.501
R2000 VSS.t2457 VSS.n281 0.130189
R2001 VSS.t2455 VSS.n69 8.501
R2002 VSS.t2452 VSS.n280 0.130189
R2003 VSS.t2450 VSS.n69 8.501
R2004 VSS.t2447 VSS.n279 0.130189
R2005 VSS.t2445 VSS.n69 8.501
R2006 VSS.t2442 VSS.n278 0.130189
R2007 VSS.t2440 VSS.n69 8.501
R2008 VSS.t2437 VSS.n277 0.130189
R2009 VSS.t2435 VSS.n69 8.501
R2010 VSS.t2432 VSS.n276 0.130189
R2011 VSS.t2430 VSS.n69 8.501
R2012 VSS.t2427 VSS.n275 0.130189
R2013 VSS.t2425 VSS.n69 8.501
R2014 VSS.t2422 VSS.n274 0.130189
R2015 VSS.t2420 VSS.n69 8.501
R2016 VSS.t2417 VSS.n273 0.130189
R2017 VSS.t2415 VSS.n69 8.501
R2018 VSS.t2412 VSS.n272 0.130189
R2019 VSS.t2410 VSS.n69 8.501
R2020 VSS.t2407 VSS.n271 0.130189
R2021 VSS.t2405 VSS.n69 8.501
R2022 VSS.t2402 VSS.n270 0.130189
R2023 VSS.t2400 VSS.n69 8.501
R2024 VSS.t2397 VSS.n269 0.130189
R2025 VSS.t2395 VSS.n69 8.501
R2026 VSS.t2392 VSS.n268 0.130189
R2027 VSS.t2390 VSS.n69 8.501
R2028 VSS.t2387 VSS.n267 0.130189
R2029 VSS.t2385 VSS.n69 8.501
R2030 VSS.t2382 VSS.n266 0.130189
R2031 VSS.t2380 VSS.n69 8.501
R2032 VSS.t2377 VSS.n265 0.130189
R2033 VSS.t2375 VSS.n69 8.501
R2034 VSS.t2372 VSS.n264 0.130189
R2035 VSS.t2370 VSS.n69 8.501
R2036 VSS.t2367 VSS.n263 0.130189
R2037 VSS.t2365 VSS.n69 8.501
R2038 VSS.n373 VSS.t2245 0.130189
R2039 VSS.t2243 VSS.n71 8.501
R2040 VSS.n372 VSS.t2240 0.130189
R2041 VSS.t2238 VSS.n71 8.501
R2042 VSS.n371 VSS.t2235 0.130189
R2043 VSS.t2233 VSS.n71 8.501
R2044 VSS.n370 VSS.t2230 0.130189
R2045 VSS.t2228 VSS.n71 8.501
R2046 VSS.n369 VSS.t2225 0.130189
R2047 VSS.t2223 VSS.n71 8.501
R2048 VSS.n368 VSS.t2220 0.130189
R2049 VSS.t2218 VSS.n71 8.501
R2050 VSS.n367 VSS.t2215 0.130189
R2051 VSS.t2213 VSS.n71 8.501
R2052 VSS.n366 VSS.t2210 0.130189
R2053 VSS.t2208 VSS.n71 8.501
R2054 VSS.n365 VSS.t2205 0.130189
R2055 VSS.t2203 VSS.n71 8.501
R2056 VSS.n364 VSS.t2200 0.130189
R2057 VSS.t2198 VSS.n71 8.501
R2058 VSS.n363 VSS.t2195 0.130189
R2059 VSS.t2193 VSS.n71 8.501
R2060 VSS.n362 VSS.t2190 0.130189
R2061 VSS.t2188 VSS.n71 8.501
R2062 VSS.n361 VSS.t2185 0.130189
R2063 VSS.t2183 VSS.n71 8.501
R2064 VSS.n360 VSS.t2180 0.130189
R2065 VSS.t2178 VSS.n71 8.501
R2066 VSS.n359 VSS.t2175 0.130189
R2067 VSS.t2173 VSS.n71 8.501
R2068 VSS.n358 VSS.t2170 0.130189
R2069 VSS.t2168 VSS.n71 8.501
R2070 VSS.n357 VSS.t2165 0.130189
R2071 VSS.t2163 VSS.n71 8.501
R2072 VSS.n356 VSS.t2160 0.130189
R2073 VSS.t2158 VSS.n71 8.501
R2074 VSS.n355 VSS.t2155 0.130189
R2075 VSS.t2153 VSS.n71 8.501
R2076 VSS.n354 VSS.t2150 0.130189
R2077 VSS.t2148 VSS.n71 8.501
R2078 VSS.n353 VSS.t2145 0.130189
R2079 VSS.t2143 VSS.n71 8.501
R2080 VSS.n352 VSS.t2140 0.130189
R2081 VSS.t2138 VSS.n71 8.501
R2082 VSS.n351 VSS.t2135 0.130189
R2083 VSS.t2133 VSS.n71 8.501
R2084 VSS.n350 VSS.t2130 0.130189
R2085 VSS.t2128 VSS.n71 8.501
R2086 VSS.n349 VSS.t2125 0.130189
R2087 VSS.t2123 VSS.n71 8.501
R2088 VSS.n348 VSS.t2120 0.130189
R2089 VSS.t2118 VSS.n71 8.501
R2090 VSS.n347 VSS.t2115 0.130189
R2091 VSS.n346 VSS.t2110 0.0333775
R2092 VSS.t2108 VSS.n71 8.501
R2093 VSS.n345 VSS.t2105 0.130189
R2094 VSS.t2103 VSS.n71 8.501
R2095 VSS.n344 VSS.t2100 0.130189
R2096 VSS.t2098 VSS.n71 8.501
R2097 VSS.n343 VSS.t2095 0.130189
R2098 VSS.t2093 VSS.n71 8.501
R2099 VSS.n342 VSS.t2090 0.130189
R2100 VSS.t2088 VSS.n71 8.501
R2101 VSS.n341 VSS.t2085 0.130189
R2102 VSS.t2083 VSS.n71 8.501
R2103 VSS.n340 VSS.t2080 0.130189
R2104 VSS.t2078 VSS.n71 8.501
R2105 VSS.n339 VSS.t2075 0.130189
R2106 VSS.t2073 VSS.n71 8.501
R2107 VSS.n338 VSS.t2070 0.130189
R2108 VSS.t2068 VSS.n71 8.501
R2109 VSS.n337 VSS.t2065 0.130189
R2110 VSS.t2063 VSS.n71 8.501
R2111 VSS.n336 VSS.t2060 0.130189
R2112 VSS.t2058 VSS.n71 8.501
R2113 VSS.n335 VSS.t2055 0.130189
R2114 VSS.t2053 VSS.n71 8.501
R2115 VSS.n334 VSS.t2050 0.130189
R2116 VSS.t2048 VSS.n71 8.501
R2117 VSS.n333 VSS.t2045 0.130189
R2118 VSS.t2043 VSS.n71 8.501
R2119 VSS.n332 VSS.t2040 0.130189
R2120 VSS.t2038 VSS.n71 8.501
R2121 VSS.n331 VSS.t2035 0.130189
R2122 VSS.t2033 VSS.n71 8.501
R2123 VSS.n330 VSS.t2030 0.130189
R2124 VSS.t2028 VSS.n71 8.501
R2125 VSS.n329 VSS.t2025 0.130189
R2126 VSS.t2023 VSS.n71 8.501
R2127 VSS.n328 VSS.t2020 0.130189
R2128 VSS.t2018 VSS.n71 8.501
R2129 VSS.n327 VSS.t2015 0.130189
R2130 VSS.t2013 VSS.n71 8.501
R2131 VSS.n326 VSS.t2010 0.130189
R2132 VSS.t2008 VSS.n71 8.501
R2133 VSS.n325 VSS.t2005 0.130189
R2134 VSS.t2003 VSS.n71 8.501
R2135 VSS.n324 VSS.t2000 0.130189
R2136 VSS.t1998 VSS.n71 8.501
R2137 VSS.t1995 VSS.n323 0.130189
R2138 VSS.t1993 VSS.n71 8.501
R2139 VSS.n322 VSS.t1990 0.130189
R2140 VSS.t1988 VSS.n71 8.501
R2141 VSS.n321 VSS.t1985 0.130189
R2142 VSS.t1983 VSS.n71 8.501
R2143 VSS.n320 VSS.t1980 0.130189
R2144 VSS.t1978 VSS.n71 8.501
R2145 VSS.n319 VSS.t1975 0.130189
R2146 VSS.t1973 VSS.n71 8.501
R2147 VSS.n71 VSS.n318 3.33079
R2148 VSS.n429 VSS.t1853 0.130189
R2149 VSS.t1851 VSS.n75 8.501
R2150 VSS.n428 VSS.t1848 0.130189
R2151 VSS.t1846 VSS.n75 8.501
R2152 VSS.n427 VSS.t1843 0.130189
R2153 VSS.t1841 VSS.n75 8.501
R2154 VSS.n426 VSS.t1838 0.130189
R2155 VSS.t1836 VSS.n75 8.501
R2156 VSS.n425 VSS.t1833 0.130189
R2157 VSS.t1831 VSS.n75 8.501
R2158 VSS.t1828 VSS.n424 0.130189
R2159 VSS.t1826 VSS.n75 8.501
R2160 VSS.t1823 VSS.n423 0.130189
R2161 VSS.t1821 VSS.n75 8.501
R2162 VSS.t1818 VSS.n422 0.130189
R2163 VSS.t1816 VSS.n75 8.501
R2164 VSS.t1813 VSS.n421 0.130189
R2165 VSS.t1811 VSS.n75 8.501
R2166 VSS.t1808 VSS.n420 0.130189
R2167 VSS.t1806 VSS.n75 8.501
R2168 VSS.t1803 VSS.n419 0.130189
R2169 VSS.t1801 VSS.n75 8.501
R2170 VSS.t1798 VSS.n418 0.130189
R2171 VSS.t1796 VSS.n75 8.501
R2172 VSS.t1793 VSS.n417 0.130189
R2173 VSS.t1791 VSS.n75 8.501
R2174 VSS.t1788 VSS.n416 0.130189
R2175 VSS.t1786 VSS.n75 8.501
R2176 VSS.t1783 VSS.n415 0.130189
R2177 VSS.t1781 VSS.n75 8.501
R2178 VSS.t1778 VSS.n414 0.130189
R2179 VSS.t1776 VSS.n75 8.501
R2180 VSS.t1773 VSS.n413 0.130189
R2181 VSS.t1771 VSS.n75 8.501
R2182 VSS.t1768 VSS.n412 0.130189
R2183 VSS.t1766 VSS.n75 8.501
R2184 VSS.t1763 VSS.n411 0.130189
R2185 VSS.t1761 VSS.n75 8.501
R2186 VSS.t1758 VSS.n410 0.130189
R2187 VSS.t1756 VSS.n75 8.501
R2188 VSS.t1753 VSS.n409 0.130189
R2189 VSS.t1751 VSS.n75 8.501
R2190 VSS.t1748 VSS.n408 0.130189
R2191 VSS.t1746 VSS.n75 8.501
R2192 VSS.t1743 VSS.n407 0.130189
R2193 VSS.t1741 VSS.n75 8.501
R2194 VSS.t1738 VSS.n406 0.130189
R2195 VSS.t1736 VSS.n75 8.501
R2196 VSS.t1733 VSS.n405 0.130189
R2197 VSS.t1731 VSS.n75 8.501
R2198 VSS.t1728 VSS.n404 0.130189
R2199 VSS.t1726 VSS.n75 8.501
R2200 VSS.t1723 VSS.n403 0.130189
R2201 VSS.n402 VSS.t1718 0.0333775
R2202 VSS.t1716 VSS.n75 8.501
R2203 VSS.n401 VSS.t1713 0.130189
R2204 VSS.t1711 VSS.n75 8.501
R2205 VSS.n400 VSS.t1708 0.130189
R2206 VSS.t1706 VSS.n75 8.501
R2207 VSS.n399 VSS.t1703 0.130189
R2208 VSS.t1701 VSS.n75 8.501
R2209 VSS.n398 VSS.t1698 0.130189
R2210 VSS.t1696 VSS.n75 8.501
R2211 VSS.n397 VSS.t1693 0.130189
R2212 VSS.t1691 VSS.n75 8.501
R2213 VSS.n396 VSS.t1688 0.130189
R2214 VSS.t1686 VSS.n75 8.501
R2215 VSS.n395 VSS.t1683 0.130189
R2216 VSS.t1681 VSS.n75 8.501
R2217 VSS.n394 VSS.t1678 0.130189
R2218 VSS.t1676 VSS.n75 8.501
R2219 VSS.n393 VSS.t1673 0.130189
R2220 VSS.t1671 VSS.n75 8.501
R2221 VSS.n392 VSS.t1668 0.130189
R2222 VSS.t1666 VSS.n75 8.501
R2223 VSS.n391 VSS.t1663 0.130189
R2224 VSS.t1661 VSS.n75 8.501
R2225 VSS.n390 VSS.t1658 0.130189
R2226 VSS.t1656 VSS.n75 8.501
R2227 VSS.n389 VSS.t1653 0.130189
R2228 VSS.t1651 VSS.n75 8.501
R2229 VSS.n388 VSS.t1648 0.130189
R2230 VSS.t1646 VSS.n75 8.501
R2231 VSS.n387 VSS.t1643 0.130189
R2232 VSS.t1641 VSS.n75 8.501
R2233 VSS.n386 VSS.t1638 0.130189
R2234 VSS.t1636 VSS.n75 8.501
R2235 VSS.n385 VSS.t1633 0.130189
R2236 VSS.t1631 VSS.n75 8.501
R2237 VSS.n384 VSS.t1628 0.130189
R2238 VSS.t1626 VSS.n75 8.501
R2239 VSS.n383 VSS.t1623 0.130189
R2240 VSS.t1621 VSS.n75 8.501
R2241 VSS.n382 VSS.t1618 0.130189
R2242 VSS.t1616 VSS.n75 8.501
R2243 VSS.n381 VSS.t1613 0.130189
R2244 VSS.t1611 VSS.n75 8.501
R2245 VSS.n380 VSS.t1608 0.130189
R2246 VSS.t1606 VSS.n75 8.501
R2247 VSS.n379 VSS.t1603 0.130189
R2248 VSS.t1601 VSS.n75 8.501
R2249 VSS.n378 VSS.t1598 0.130189
R2250 VSS.t1596 VSS.n75 8.501
R2251 VSS.n377 VSS.t1593 0.130189
R2252 VSS.t1591 VSS.n75 8.501
R2253 VSS.n376 VSS.t1588 0.130189
R2254 VSS.t1586 VSS.n75 8.501
R2255 VSS.n375 VSS.t1583 0.130189
R2256 VSS.t1581 VSS.n75 8.501
R2257 VSS.n75 VSS.n374 3.33079
R2258 VSS.n122 VSS.n564 0.00173723
R2259 VSS.n565 VSS.n566 0.00172462
R2260 VSS.n564 VSS.n565 0.00173273
R2261 VSS.n566 VSS.n567 0.00170812
R2262 VSS.n567 VSS.n568 0.00166658
R2263 VSS.t311 VSS.n570 2.83428
R2264 VSS.t311 VSS.n433 2.12588
R2265 VSS.t311 VSS.n103 0.392154
R2266 VSS.n103 VSS.n102 0.00601191
R2267 VSS.n572 VSS.n573 0.00166658
R2268 VSS.t311 VSS.n574 2.42951
R2269 VSS.n574 VSS.n575 0.00257133
R2270 VSS.n577 VSS.n576 0.00170812
R2271 VSS.t311 VSS.n577 2.12569
R2272 VSS.n576 VSS.n578 0.00166658
R2273 VSS.t311 VSS.n579 2.42956
R2274 VSS.t311 VSS.n446 8.501
R2275 VSS.t311 VSS.n582 3.40102
R2276 VSS.t311 VSS.n584 2.83428
R2277 VSS.n584 VSS.n449 0.00249992
R2278 VSS.t311 VSS.n585 4.251
R2279 VSS.t311 VSS.n586 2.83428
R2280 VSS.n586 VSS.n455 0.00249992
R2281 VSS.t311 VSS.n588 2.12569
R2282 VSS.n588 VSS.n587 0.00170812
R2283 VSS.n587 VSS.n589 0.00166658
R2284 VSS.t311 VSS.n590 2.42951
R2285 VSS.n590 VSS.n591 0.00257133
R2286 VSS.n593 VSS.n592 0.00166658
R2287 VSS.t311 VSS.n593 2.83417
R2288 VSS.t311 VSS.n594 1.88985
R2289 VSS.t311 VSS.n597 3.40102
R2290 VSS.t311 VSS.n599 1.88985
R2291 VSS.t311 VSS.n602 2.42956
R2292 VSS.t311 VSS.n466 8.501
R2293 VSS.t311 VSS.n605 3.40102
R2294 VSS.t311 VSS.n607 2.12578
R2295 VSS.n607 VSS.n608 0.00274975
R2296 VSS.n562 VSS.n563 0.00166658
R2297 VSS.n561 VSS.n562 0.00170812
R2298 VSS.n560 VSS.n561 0.00172462
R2299 VSS.n559 VSS.n560 0.00173273
R2300 VSS.n476 VSS.n559 0.00209843
R2301 VSS.n557 VSS.n558 0.00166658
R2302 VSS.n556 VSS.n557 0.00170812
R2303 VSS.n555 VSS.n556 0.00172462
R2304 VSS.n554 VSS.n555 0.00173273
R2305 VSS.n479 VSS.n554 0.00209843
R2306 VSS.n552 VSS.n553 0.00166658
R2307 VSS.n551 VSS.n552 0.00170812
R2308 VSS.n550 VSS.n551 0.00172462
R2309 VSS.n549 VSS.n550 0.00173273
R2310 VSS.n482 VSS.n549 0.00209843
R2311 VSS.n547 VSS.n548 0.00166658
R2312 VSS.n546 VSS.n547 0.00170812
R2313 VSS.n545 VSS.n546 0.00172462
R2314 VSS.n544 VSS.n545 0.00173273
R2315 VSS.n485 VSS.n544 0.00209843
R2316 VSS.n542 VSS.n543 0.00166658
R2317 VSS.n541 VSS.n542 0.00170812
R2318 VSS.n540 VSS.n541 0.00172462
R2319 VSS.n539 VSS.n540 0.00173273
R2320 VSS.n488 VSS.n539 0.00209843
R2321 VSS.n537 VSS.n538 0.00166658
R2322 VSS.n536 VSS.n537 0.00170812
R2323 VSS.n535 VSS.n536 0.00172462
R2324 VSS.n534 VSS.n535 0.00173273
R2325 VSS.n491 VSS.n534 0.00209843
R2326 VSS.n532 VSS.n533 0.00166658
R2327 VSS.n531 VSS.n532 0.00170812
R2328 VSS.n530 VSS.n531 0.00172462
R2329 VSS.n529 VSS.n530 0.00173273
R2330 VSS.n494 VSS.n529 0.00209843
R2331 VSS.n497 VSS.n528 0.00199975
R2332 VSS.n526 VSS.n527 0.00166658
R2333 VSS.n525 VSS.n526 0.00170812
R2334 VSS.n524 VSS.n525 0.00172462
R2335 VSS.n523 VSS.n524 0.00173273
R2336 VSS.n500 VSS.n523 0.00209843
R2337 VSS.n521 VSS.n522 0.00166658
R2338 VSS.n520 VSS.n521 0.00170812
R2339 VSS.n519 VSS.n520 0.00172462
R2340 VSS.n518 VSS.n519 0.00173273
R2341 VSS.n503 VSS.n518 0.00209843
R2342 VSS.n516 VSS.n517 0.00166658
R2343 VSS.n515 VSS.n516 0.00170812
R2344 VSS.n514 VSS.n515 0.00172462
R2345 VSS.n513 VSS.n514 0.00173273
R2346 VSS.n506 VSS.n513 0.00209843
R2347 VSS.n511 VSS.n512 0.00166658
R2348 VSS.n509 VSS.n511 0.00170812
R2349 VSS.n510 VSS.n509 0.00198797
R2350 VSS.n664 VSS.t1172 0.130189
R2351 VSS.t1170 VSS.n73 8.501
R2352 VSS.n663 VSS.t1167 0.130189
R2353 VSS.t1165 VSS.n73 8.501
R2354 VSS.n662 VSS.t1162 0.130189
R2355 VSS.t1160 VSS.n73 8.501
R2356 VSS.n661 VSS.t1157 0.130189
R2357 VSS.t1155 VSS.n73 8.501
R2358 VSS.n660 VSS.t1152 0.130189
R2359 VSS.t1150 VSS.n73 8.501
R2360 VSS.n659 VSS.t1147 0.130189
R2361 VSS.t1145 VSS.n73 8.501
R2362 VSS.n658 VSS.t1142 0.130189
R2363 VSS.t1140 VSS.n73 8.501
R2364 VSS.n657 VSS.t1137 0.130189
R2365 VSS.t1135 VSS.n73 8.501
R2366 VSS.n656 VSS.t1132 0.130189
R2367 VSS.t1130 VSS.n73 8.501
R2368 VSS.n655 VSS.t1127 0.130189
R2369 VSS.t1125 VSS.n73 8.501
R2370 VSS.n654 VSS.t1122 0.130189
R2371 VSS.t1120 VSS.n73 8.501
R2372 VSS.n653 VSS.t1117 0.130189
R2373 VSS.t1115 VSS.n73 8.501
R2374 VSS.n652 VSS.t1112 0.130189
R2375 VSS.t1110 VSS.n73 8.501
R2376 VSS.n651 VSS.t1107 0.130189
R2377 VSS.t1105 VSS.n73 8.501
R2378 VSS.n650 VSS.t1102 0.130189
R2379 VSS.t1100 VSS.n73 8.501
R2380 VSS.n649 VSS.t1097 0.130189
R2381 VSS.t1095 VSS.n73 8.501
R2382 VSS.n648 VSS.t1092 0.130189
R2383 VSS.t1090 VSS.n73 8.501
R2384 VSS.n647 VSS.t1087 0.130189
R2385 VSS.t1085 VSS.n73 8.501
R2386 VSS.n646 VSS.t1082 0.130189
R2387 VSS.t1080 VSS.n73 8.501
R2388 VSS.n645 VSS.t1077 0.130189
R2389 VSS.t1075 VSS.n73 8.501
R2390 VSS.n644 VSS.t1072 0.130189
R2391 VSS.t1070 VSS.n73 8.501
R2392 VSS.n643 VSS.t1067 0.130189
R2393 VSS.t1065 VSS.n73 8.501
R2394 VSS.n642 VSS.t1062 0.130189
R2395 VSS.t1060 VSS.n73 8.501
R2396 VSS.n641 VSS.t1057 0.130189
R2397 VSS.t1055 VSS.n73 8.501
R2398 VSS.n640 VSS.t1052 0.130189
R2399 VSS.t1050 VSS.n73 8.501
R2400 VSS.n639 VSS.t1047 0.130189
R2401 VSS.t1045 VSS.n73 8.501
R2402 VSS.n638 VSS.t1042 0.130189
R2403 VSS.n637 VSS.t1037 0.0333775
R2404 VSS.t1035 VSS.n73 8.501
R2405 VSS.n636 VSS.t1032 0.130189
R2406 VSS.t1030 VSS.n73 8.501
R2407 VSS.n635 VSS.t1027 0.130189
R2408 VSS.t1025 VSS.n73 8.501
R2409 VSS.n634 VSS.t1022 0.130189
R2410 VSS.t1020 VSS.n73 8.501
R2411 VSS.n633 VSS.t1017 0.130189
R2412 VSS.t1015 VSS.n73 8.501
R2413 VSS.n632 VSS.t1012 0.130189
R2414 VSS.t1010 VSS.n73 8.501
R2415 VSS.n631 VSS.t1007 0.130189
R2416 VSS.t1005 VSS.n73 8.501
R2417 VSS.n630 VSS.t1002 0.130189
R2418 VSS.t1000 VSS.n73 8.501
R2419 VSS.n629 VSS.t997 0.130189
R2420 VSS.t995 VSS.n73 8.501
R2421 VSS.n628 VSS.t992 0.130189
R2422 VSS.t990 VSS.n73 8.501
R2423 VSS.n627 VSS.t987 0.130189
R2424 VSS.t985 VSS.n73 8.501
R2425 VSS.n626 VSS.t982 0.130189
R2426 VSS.t980 VSS.n73 8.501
R2427 VSS.n625 VSS.t977 0.130189
R2428 VSS.t975 VSS.n73 8.501
R2429 VSS.n624 VSS.t972 0.130189
R2430 VSS.t970 VSS.n73 8.501
R2431 VSS.n623 VSS.t967 0.130189
R2432 VSS.t965 VSS.n73 8.501
R2433 VSS.n622 VSS.t962 0.130189
R2434 VSS.t960 VSS.n73 8.501
R2435 VSS.n621 VSS.t957 0.130189
R2436 VSS.t955 VSS.n73 8.501
R2437 VSS.n620 VSS.t952 0.130189
R2438 VSS.t950 VSS.n73 8.501
R2439 VSS.n619 VSS.t947 0.130189
R2440 VSS.t945 VSS.n73 8.501
R2441 VSS.n618 VSS.t942 0.130189
R2442 VSS.t940 VSS.n73 8.501
R2443 VSS.n617 VSS.t937 0.130189
R2444 VSS.t935 VSS.n73 8.501
R2445 VSS.n616 VSS.t932 0.130189
R2446 VSS.t930 VSS.n73 8.501
R2447 VSS.n615 VSS.t927 0.130189
R2448 VSS.t925 VSS.n73 8.501
R2449 VSS.t922 VSS.n614 0.130189
R2450 VSS.t920 VSS.n73 8.501
R2451 VSS.t917 VSS.n613 0.130189
R2452 VSS.t915 VSS.n73 8.501
R2453 VSS.t912 VSS.n612 0.130189
R2454 VSS.t910 VSS.n73 8.501
R2455 VSS.t907 VSS.n611 0.130189
R2456 VSS.t905 VSS.n73 8.501
R2457 VSS.t902 VSS.n610 0.130189
R2458 VSS.t900 VSS.n73 8.501
R2459 VSS.n609 VSS.n73 3.33079
R2460 VSS.t858 VSS.n701 0.130189
R2461 VSS.n698 VSS.t856 8.501
R2462 VSS.t174 VSS.n700 0.130189
R2463 VSS.t78 VSS.n682 8.501
R2464 VSS.t333 VSS.n684 0.129991
R2465 VSS.t317 VSS.n681 0.13218
R2466 VSS.n679 VSS.t405 0.129991
R2467 VSS.t338 VSS.n673 8.501
R2468 VSS.t830 VSS.n675 0.130189
R2469 VSS.t307 VSS.n669 8.501
R2470 VSS.t303 VSS.n671 0.238005
R2471 VSS.n668 VSS.n667 3.33079
R2472 VSS.t777 VSS.n767 0.096752
R2473 VSS.t774 VSS.n766 0.235729
R2474 VSS.t771 VSS.n762 0.235729
R2475 VSS.t768 VSS.n758 0.235729
R2476 VSS.t766 VSS.n754 0.235729
R2477 VSS.n750 VSS.n743 4.20468
R2478 VSS.t757 VSS.n746 0.235729
R2479 VSS.t754 VSS.n742 0.235729
R2480 VSS.t751 VSS.n738 0.235729
R2481 VSS.t748 VSS.n734 0.235729
R2482 VSS.t745 VSS.n730 0.235729
R2483 VSS.t742 VSS.n726 0.235729
R2484 VSS.t739 VSS.n722 0.235729
R2485 VSS.t736 VSS.n718 0.235729
R2486 VSS.t733 VSS.n714 0.235729
R2487 VSS.t349 VSS.n710 0.235729
R2488 VSS.t176 VSS.n706 0.235736
R2489 VSS.t861 VSS.n703 8.501
R2490 VSS.t211 VSS.n815 0.343184
R2491 VSS.t820 VSS.n812 0.153062
R2492 VSS.n810 VSS.t681 0.252351
R2493 VSS.t9 VSS.t25 0.415374
R2494 VSS.t626 VSS.n834 0.096752
R2495 VSS.t9 VSS.t625 8.501
R2496 VSS.t623 VSS.n833 0.130189
R2497 VSS.t9 VSS.t622 8.501
R2498 VSS.t620 VSS.n832 0.130189
R2499 VSS.t9 VSS.t619 8.501
R2500 VSS.t617 VSS.n831 0.130189
R2501 VSS.t9 VSS.t616 8.501
R2502 VSS.t614 VSS.n830 0.130189
R2503 VSS.t9 VSS.n133 5.64438
R2504 VSS.t611 VSS.t612 0.0793054
R2505 VSS.t9 VSS.t610 8.501
R2506 VSS.t608 VSS.n827 0.130189
R2507 VSS.t9 VSS.t607 8.501
R2508 VSS.t605 VSS.n826 0.130189
R2509 VSS.t9 VSS.t604 8.501
R2510 VSS.t602 VSS.n825 0.130189
R2511 VSS.t9 VSS.t601 8.501
R2512 VSS.t599 VSS.n824 0.130189
R2513 VSS.t9 VSS.t598 8.501
R2514 VSS.t596 VSS.n823 0.130189
R2515 VSS.t9 VSS.t595 8.501
R2516 VSS.t593 VSS.n822 0.130189
R2517 VSS.t9 VSS.t592 8.501
R2518 VSS.t590 VSS.n821 0.130189
R2519 VSS.t9 VSS.t589 8.501
R2520 VSS.t587 VSS.n820 0.130189
R2521 VSS.t9 VSS.t586 8.501
R2522 VSS.n819 VSS.t584 0.130189
R2523 VSS.t583 VSS.t9 8.501
R2524 VSS.n818 VSS.t246 0.130189
R2525 VSS.n840 VSS.t1 0.0737702
R2526 VSS.t18 VSS.n839 0.175383
R2527 VSS.n838 VSS.t9 1.53018
R2528 VSS.n837 VSS.t9 0.610396
R2529 VSS.t9 VSS.n123 2.33234
R2530 VSS.t640 VSS.n123 0.216275
R2531 VSS.t36 VSS.t9 8.501
R2532 VSS.t43 VSS.n836 0.130189
R2533 VSS.n835 VSS.t9 0.574066
R2534 VSS.n844 VSS.t9 0.889835
R2535 VSS.n843 VSS.t9 3.33079
R2536 VSS.n842 VSS.t7 0.570079
R2537 VSS.t574 VSS.t9 8.501
R2538 VSS.t9 VSS.n841 3.33079
R2539 VSS.t894 VSS.n763 8.48858
R2540 VSS.n79 VSS.n178 4.20253
R2541 VSS.n239 VSS.t501 0.083315
R2542 VSS.t2964 VSS.n166 0.17801
R2543 VSS.n165 VSS.t2836 0.17801
R2544 VSS.t392 VSS.n252 3.30696
R2545 VSS.t2971 VSS.n164 0.17801
R2546 VSS.n163 VSS.t2844 0.17801
R2547 VSS.t392 VSS.n253 3.30696
R2548 VSS.t2978 VSS.n162 0.17801
R2549 VSS.n161 VSS.t2852 0.17801
R2550 VSS.t392 VSS.n254 3.30696
R2551 VSS.t2985 VSS.n160 0.17801
R2552 VSS.n159 VSS.t2860 0.17801
R2553 VSS.t392 VSS.n255 3.30696
R2554 VSS.t2992 VSS.n158 0.17801
R2555 VSS.n157 VSS.t2868 0.17801
R2556 VSS.t392 VSS.n256 3.30696
R2557 VSS.t2999 VSS.n156 0.17801
R2558 VSS.n155 VSS.t2876 0.17801
R2559 VSS.t392 VSS.n257 3.30696
R2560 VSS.t3006 VSS.n154 0.17801
R2561 VSS.n153 VSS.t2884 0.17801
R2562 VSS.t392 VSS.n258 3.30696
R2563 VSS.t3013 VSS.n152 0.17801
R2564 VSS.t3015 VSS.t392 8.47111
R2565 VSS.t2895 VSS.n151 0.17801
R2566 VSS.n150 VSS.t2897 0.17801
R2567 VSS.t392 VSS.n259 3.30696
R2568 VSS.t3024 VSS.n100 0.177814
R2569 VSS.t2904 VSS.n260 0.119605
R2570 VSS.n260 VSS.t392 4.177
R2571 VSS.n149 VSS.t392 4.177
R2572 VSS.t2831 VSS.n149 0.119605
R2573 VSS.n121 VSS.t2828 0.177814
R2574 VSS.t2827 VSS.n167 0.17801
R2575 VSS.n127 VSS.t2821 0.177814
R2576 VSS.t392 VSS.n261 4.177
R2577 VSS.t2819 VSS.n261 0.119605
R2578 VSS.t2815 VSS.n147 0.177814
R2579 VSS.n168 VSS.t2811 0.177814
R2580 VSS.n169 VSS.t2805 0.177814
R2581 VSS.n146 VSS.t2799 0.177814
R2582 VSS.n170 VSS.t2794 0.17801
R2583 VSS.n145 VSS.t2788 0.17801
R2584 VSS.t2783 VSS.n171 0.17801
R2585 VSS.t2777 VSS.n172 0.17801
R2586 VSS.t2771 VSS.n144 0.17801
R2587 VSS.n173 VSS.t2917 0.177814
R2588 VSS.n174 VSS.t2762 0.177814
R2589 VSS.n175 VSS.t2757 0.177814
R2590 VSS.n565 VSS.n856 8.47111
R2591 VSS.n566 VSS.t1371 8.47111
R2592 VSS.n567 VSS.t1372 8.47111
R2593 VSS.n568 VSS.t1373 8.47111
R2594 VSS.n432 VSS.t1374 0.17801
R2595 VSS.n569 VSS.t1377 8.47111
R2596 VSS.n435 VSS.t1378 0.177814
R2597 VSS.n438 VSS.n437 3.30688
R2598 VSS.n439 VSS.t1386 0.119605
R2599 VSS.n102 VSS.n439 4.177
R2600 VSS.n440 VSS.t1389 0.119605
R2601 VSS.n102 VSS.n440 4.177
R2602 VSS.n102 VSS.t1391 8.47111
R2603 VSS.n102 VSS.n117 3.30688
R2604 VSS.n118 VSS.t1394 0.177814
R2605 VSS.n143 VSS.n102 3.30688
R2606 VSS.t1399 VSS.n572 8.47111
R2607 VSS.t1400 VSS.n573 8.47111
R2608 VSS.n443 VSS.t1401 0.119605
R2609 VSS.n442 VSS.n443 4.177
R2610 VSS.n441 VSS.t1403 8.47111
R2611 VSS.n863 VSS.t1405 8.47111
R2612 VSS.n576 VSS.t1406 8.47111
R2613 VSS.t1541 VSS.n445 0.17801
R2614 VSS.n578 VSS.t1407 8.47111
R2615 VSS.n448 VSS.n447 4.177
R2616 VSS.n580 VSS.t1409 8.47111
R2617 VSS.t1410 VSS.n448 0.119605
R2618 VSS.t1411 VSS.n446 8.47111
R2619 VSS.n581 VSS.t1412 8.47111
R2620 VSS.t1414 VSS.n583 8.47111
R2621 VSS.n449 VSS.n450 4.177
R2622 VSS.n450 VSS.t1416 0.119605
R2623 VSS.n453 VSS.t1417 0.119605
R2624 VSS.t1551 VSS.n451 8.47111
R2625 VSS.n452 VSS.n453 4.177
R2626 VSS.n456 VSS.n455 3.30688
R2627 VSS.t1554 VSS.n861 8.47111
R2628 VSS.t1422 VSS.n587 8.47111
R2629 VSS.t1423 VSS.n589 8.47111
R2630 VSS.n459 VSS.t1424 0.119605
R2631 VSS.n458 VSS.n459 4.177
R2632 VSS.n457 VSS.t1426 8.47111
R2633 VSS.n860 VSS.t1428 8.47111
R2634 VSS.n592 VSS.t1429 8.47111
R2635 VSS.n461 VSS.t1430 0.17801
R2636 VSS.n595 VSS.t1432 8.47111
R2637 VSS.t1563 VSS.n463 0.17801
R2638 VSS.n596 VSS.t1433 8.47111
R2639 VSS.n598 VSS.t1565 8.47111
R2640 VSS.n600 VSS.t1437 8.47111
R2641 VSS.t1568 VSS.n465 0.17801
R2642 VSS.n601 VSS.t1438 8.47111
R2643 VSS.n468 VSS.n467 4.177
R2644 VSS.n603 VSS.t1440 8.47111
R2645 VSS.t1441 VSS.n468 0.119605
R2646 VSS.t1442 VSS.n466 8.47111
R2647 VSS.n604 VSS.t1443 8.47111
R2648 VSS.t1445 VSS.n606 8.47111
R2649 VSS.n608 VSS.t1446 8.47111
R2650 VSS.n471 VSS.t1447 0.119605
R2651 VSS.n470 VSS.n471 4.177
R2652 VSS.n857 VSS.n564 8.47111
R2653 VSS.n110 VSS.n472 4.177
R2654 VSS.n472 VSS.t1365 0.119605
R2655 VSS.n110 VSS.n473 4.177
R2656 VSS.n473 VSS.t1362 0.119605
R2657 VSS.n116 VSS.n110 4.177
R2658 VSS.t1360 VSS.n116 0.119605
R2659 VSS.n114 VSS.n110 4.177
R2660 VSS.n114 VSS.t1359 0.119605
R2661 VSS.n475 VSS.n474 4.177
R2662 VSS.n475 VSS.t1357 0.119605
R2663 VSS.n563 VSS.t1356 8.47111
R2664 VSS.n562 VSS.t1355 8.47111
R2665 VSS.n561 VSS.t1354 8.47111
R2666 VSS.t1353 VSS.n560 8.47111
R2667 VSS.n477 VSS.n478 4.177
R2668 VSS.t1350 VSS.n478 0.119605
R2669 VSS.t1349 VSS.n558 8.47111
R2670 VSS.t1498 VSS.n557 8.47111
R2671 VSS.n556 VSS.t1348 8.47111
R2672 VSS.n555 VSS.t1347 8.47111
R2673 VSS.n480 VSS.n481 4.177
R2674 VSS.n481 VSS.t1344 0.119605
R2675 VSS.n553 VSS.t1343 8.47111
R2676 VSS.n552 VSS.t1342 8.47111
R2677 VSS.t1341 VSS.n551 8.47111
R2678 VSS.t1340 VSS.n550 8.47111
R2679 VSS.n484 VSS.n483 4.177
R2680 VSS.t1337 VSS.n484 0.119605
R2681 VSS.t1489 VSS.n548 8.47111
R2682 VSS.n547 VSS.t1336 8.47111
R2683 VSS.n546 VSS.t1335 8.47111
R2684 VSS.n545 VSS.t1334 8.47111
R2685 VSS.n486 VSS.n487 4.177
R2686 VSS.n487 VSS.t1331 0.119605
R2687 VSS.n543 VSS.t1330 8.47111
R2688 VSS.t1329 VSS.n542 8.47111
R2689 VSS.t1328 VSS.n541 8.47111
R2690 VSS.t1327 VSS.n540 8.47111
R2691 VSS.n490 VSS.n489 4.177
R2692 VSS.t1480 VSS.n490 0.119605
R2693 VSS.n538 VSS.t1324 8.47111
R2694 VSS.n537 VSS.t1323 8.47111
R2695 VSS.n536 VSS.t1322 8.47111
R2696 VSS.n535 VSS.t1321 8.47111
R2697 VSS.n492 VSS.n493 4.177
R2698 VSS.n493 VSS.t1318 0.119605
R2699 VSS.t1317 VSS.n533 8.47111
R2700 VSS.t1316 VSS.n532 8.47111
R2701 VSS.t1473 VSS.n531 8.47111
R2702 VSS.n530 VSS.t1315 8.47111
R2703 VSS.n496 VSS.n495 4.177
R2704 VSS.n496 VSS.t1313 0.119605
R2705 VSS.n499 VSS.n498 4.177
R2706 VSS.n499 VSS.t1311 0.119605
R2707 VSS.n527 VSS.t1310 8.47111
R2708 VSS.n526 VSS.t1309 8.47111
R2709 VSS.n525 VSS.t1308 8.47111
R2710 VSS.t1307 VSS.n524 8.47111
R2711 VSS.t1304 VSS.n502 0.0605362
R2712 VSS.t1303 VSS.n522 8.47111
R2713 VSS.t1460 VSS.n521 8.47111
R2714 VSS.n520 VSS.t1302 8.47111
R2715 VSS.n519 VSS.t1301 8.47111
R2716 VSS.n504 VSS.n505 4.177
R2717 VSS.n505 VSS.t1298 0.119605
R2718 VSS.n517 VSS.t1297 8.47111
R2719 VSS.n516 VSS.t1296 8.47111
R2720 VSS.t1295 VSS.n515 8.47111
R2721 VSS.t1294 VSS.n514 8.47111
R2722 VSS.n508 VSS.n507 4.177
R2723 VSS.t1291 VSS.n508 0.119605
R2724 VSS.t1451 VSS.n512 8.47111
R2725 VSS.n511 VSS.t1290 8.47111
R2726 VSS.n509 VSS.t1289 8.47111
R2727 VSS.t763 VSS.n750 0.07903
R2728 VSS.n816 VSS.t86 0.143892
R2729 VSS.n101 VSS.t9 0.605306
R2730 VSS.t21 VSS.n101 0.833822
R2731 VSS.n104 VSS.t9 4.177
R2732 VSS.n104 VSS.t368 0.119605
R2733 VSS.n840 VSS.t9 4.20744
R2734 VSS.t438 VSS.n817 0.119605
R2735 VSS.t9 VSS.n817 4.177
R2736 VSS.t5 VSS.t9 1.06748
R2737 VSS.n108 VSS.t9 1.97616
R2738 VSS.t46 VSS.n108 0.346365
R2739 VSS.n105 VSS.t9 4.177
R2740 VSS.t26 VSS.n105 0.119605
R2741 VSS.n97 VSS.t266 0.235242
R2742 VSS.n97 VSS.t9 2.72093
R2743 VSS.t9 VSS.t612 4.20468
R2744 VSS.n1005 VSS.t455 8.36235
R2745 VSS.t557 VSS.n828 8.36235
R2746 VSS.t3280 VSS.n1150 8.36235
R2747 VSS.n1149 VSS.n849 8.36235
R2748 VSS.n1077 VSS.n906 8.36235
R2749 VSS.t58 VSS.n1005 8.3005
R2750 VSS.t693 VSS.n870 8.3005
R2751 VSS.n1140 VSS.t925 8.3005
R2752 VSS.t1305 VSS.n1141 8.3005
R2753 VSS.t1606 VSS.n853 8.3005
R2754 VSS.n1146 VSS.t1998 8.3005
R2755 VSS.t2390 VSS.n1147 8.3005
R2756 VSS.t2767 VSS.n848 8.3005
R2757 VSS.n1151 VSS.t3055 8.3005
R2758 VSS.n829 VSS.n828 8.3005
R2759 VSS.n1138 VSS.n871 8.3005
R2760 VSS.t1150 VSS.n1139 8.3005
R2761 VSS.t1435 VSS.n854 8.3005
R2762 VSS.n1144 VSS.t1831 8.3005
R2763 VSS.t2223 VSS.n1145 8.3005
R2764 VSS.t2615 VSS.n850 8.3005
R2765 VSS.n1150 VSS.t2892 8.3005
R2766 VSS.t2962 VSS.n1149 8.3005
R2767 VSS.n1148 VSS.t2503 8.3005
R2768 VSS.t2111 VSS.n852 8.3005
R2769 VSS.t1719 VSS.n1143 8.3005
R2770 VSS.n1142 VSS.t1370 8.3005
R2771 VSS.t1038 VSS.n855 8.3005
R2772 VSS.t319 VSS.n1078 8.3005
R2773 VSS.n1077 VSS.t648 8.3005
R2774 VSS.n947 VSS.t233 8.06935
R2775 VSS.t79 VSS.t93 7.1604
R2776 VSS.t311 VSS.n436 5.66778
R2777 VSS.n102 VSS.n572 0.00889512
R2778 VSS.n574 VSS.n441 0.00242827
R2779 VSS.n579 VSS.n444 0.00249991
R2780 VSS.n582 VSS.n862 0.00229996
R2781 VSS.t311 VSS.n454 5.66778
R2782 VSS.n590 VSS.n457 0.00242827
R2783 VSS.n594 VSS.n460 0.00261099
R2784 VSS.n597 VSS.n462 0.00229996
R2785 VSS.n599 VSS.n859 0.00261099
R2786 VSS.n602 VSS.n464 0.00249991
R2787 VSS.n605 VSS.n858 0.00229996
R2788 VSS.n111 VSS.n122 0.0136823
R2789 VSS.t311 VSS.n111 0.400484
R2790 VSS.n111 VSS.n110 0.0143974
R2791 VSS.t311 VSS.n476 1.13344
R2792 VSS.t311 VSS.n479 1.13344
R2793 VSS.t311 VSS.n482 1.13344
R2794 VSS.t311 VSS.n485 1.13344
R2795 VSS.t311 VSS.n488 1.13344
R2796 VSS.t311 VSS.n491 1.13344
R2797 VSS.t311 VSS.n494 1.13344
R2798 VSS.t311 VSS.n497 2.42928
R2799 VSS.t311 VSS.n500 1.13344
R2800 VSS.t311 VSS.n503 1.13344
R2801 VSS.t311 VSS.n506 1.13344
R2802 VSS.t311 VSS.n510 1.54587
R2803 VSS.n763 VSS.n767 3.35999
R2804 VSS.n816 VSS.t9 3.33195
R2805 VSS.t1449 VSS.n469 5.6449
R2806 VSS.n79 VSS.n235 3.33079
R2807 VSS.n234 VSS.n79 3.33079
R2808 VSS.n79 VSS.n233 3.33079
R2809 VSS.n232 VSS.n79 3.33079
R2810 VSS.n79 VSS.n231 3.33079
R2811 VSS.n230 VSS.n79 3.33079
R2812 VSS.n229 VSS.n79 3.33079
R2813 VSS.n228 VSS.n79 3.33079
R2814 VSS.n227 VSS.n79 3.33079
R2815 VSS.n226 VSS.n79 3.33079
R2816 VSS.n225 VSS.n79 3.33079
R2817 VSS.n224 VSS.n79 3.33079
R2818 VSS.n223 VSS.n79 3.33079
R2819 VSS.n222 VSS.n79 3.33079
R2820 VSS.n221 VSS.n79 3.33079
R2821 VSS.n220 VSS.n79 3.33079
R2822 VSS.n219 VSS.n79 3.33079
R2823 VSS.n218 VSS.n79 3.33079
R2824 VSS.n217 VSS.n79 3.33079
R2825 VSS.n216 VSS.n79 3.33079
R2826 VSS.n215 VSS.n79 3.33079
R2827 VSS.n214 VSS.n79 3.33079
R2828 VSS.n213 VSS.n79 3.33079
R2829 VSS.n212 VSS.n79 3.33079
R2830 VSS.n211 VSS.n79 3.33079
R2831 VSS.n210 VSS.n79 3.33079
R2832 VSS.n209 VSS.n79 3.33079
R2833 VSS.n207 VSS.n79 3.33079
R2834 VSS.n206 VSS.n79 3.33079
R2835 VSS.n205 VSS.n79 3.33079
R2836 VSS.n204 VSS.n79 3.33079
R2837 VSS.n203 VSS.n79 3.33079
R2838 VSS.n202 VSS.n79 3.33079
R2839 VSS.n201 VSS.n79 3.33079
R2840 VSS.n200 VSS.n79 3.33079
R2841 VSS.n199 VSS.n79 3.33079
R2842 VSS.n198 VSS.n79 3.33079
R2843 VSS.n197 VSS.n79 3.33079
R2844 VSS.n196 VSS.n79 3.33079
R2845 VSS.n195 VSS.n79 3.33079
R2846 VSS.n194 VSS.n79 3.33079
R2847 VSS.n193 VSS.n79 3.33079
R2848 VSS.n192 VSS.n79 3.33079
R2849 VSS.n191 VSS.n79 3.33079
R2850 VSS.n190 VSS.n79 3.33079
R2851 VSS.n189 VSS.n79 3.33079
R2852 VSS.n188 VSS.n79 3.33079
R2853 VSS.n187 VSS.n79 3.33079
R2854 VSS.n79 VSS.n186 3.33079
R2855 VSS.n184 VSS.n79 3.33079
R2856 VSS.n79 VSS.n183 3.33079
R2857 VSS.n182 VSS.n79 3.33079
R2858 VSS.n79 VSS.n181 3.33079
R2859 VSS.t3028 VSS.n180 0.0863258
R2860 VSS.t445 VSS.n846 0.0896992
R2861 VSS.t450 VSS.n847 0.0896992
R2862 VSS.t491 VSS.n237 0.0896992
R2863 VSS.t496 VSS.n238 0.0896992
R2864 VSS.t506 VSS.n241 0.0896992
R2865 VSS.n242 VSS.t511 0.0896992
R2866 VSS.n243 VSS.t516 0.0896992
R2867 VSS.t521 VSS.n246 0.0896992
R2868 VSS.n247 VSS.t526 0.0896992
R2869 VSS.n248 VSS.t531 0.0896992
R2870 VSS.n249 VSS.t536 0.0896992
R2871 VSS.n250 VSS.t541 0.0896992
R2872 VSS.n251 VSS.t546 0.0896992
R2873 VSS.t392 VSS.t2833 5.61485
R2874 VSS.t392 VSS.n166 3.30688
R2875 VSS.t392 VSS.n165 3.30688
R2876 VSS.t2838 VSS.t392 5.61485
R2877 VSS.t2840 VSS.n252 0.118193
R2878 VSS.t392 VSS.t2841 5.61485
R2879 VSS.t392 VSS.n164 3.30688
R2880 VSS.t392 VSS.n163 3.30688
R2881 VSS.t2846 VSS.t392 5.61485
R2882 VSS.t2848 VSS.n253 0.118193
R2883 VSS.t392 VSS.t2849 5.61485
R2884 VSS.t392 VSS.n162 3.30688
R2885 VSS.t392 VSS.n161 3.30688
R2886 VSS.t2854 VSS.t392 5.61485
R2887 VSS.t2856 VSS.n254 0.118193
R2888 VSS.t392 VSS.t2857 5.61485
R2889 VSS.t392 VSS.n160 3.30688
R2890 VSS.t392 VSS.n159 3.30688
R2891 VSS.t2862 VSS.t392 5.61485
R2892 VSS.t2864 VSS.n255 0.118193
R2893 VSS.t392 VSS.t2865 5.61485
R2894 VSS.t392 VSS.n158 3.30688
R2895 VSS.t392 VSS.n157 3.30688
R2896 VSS.t2870 VSS.t392 5.61485
R2897 VSS.t2872 VSS.n256 0.118193
R2898 VSS.t392 VSS.t2873 5.61485
R2899 VSS.t392 VSS.n156 3.30688
R2900 VSS.t392 VSS.n155 3.30688
R2901 VSS.t2878 VSS.t392 5.61485
R2902 VSS.t2880 VSS.n257 0.118193
R2903 VSS.t392 VSS.t2881 5.61485
R2904 VSS.t392 VSS.n154 3.30688
R2905 VSS.t392 VSS.n153 3.30688
R2906 VSS.t2886 VSS.t392 5.61485
R2907 VSS.t2888 VSS.n258 0.118193
R2908 VSS.t392 VSS.t2889 5.61485
R2909 VSS.t392 VSS.n152 3.30688
R2910 VSS.t2893 VSS.n148 0.0599544
R2911 VSS.t392 VSS.t2894 5.61485
R2912 VSS.t392 VSS.n151 3.30688
R2913 VSS.t392 VSS.n150 3.30688
R2914 VSS.t2899 VSS.t392 5.61485
R2915 VSS.t2901 VSS.n259 0.118193
R2916 VSS.t392 VSS.n100 3.30696
R2917 VSS.t2830 VSS.t392 5.61485
R2918 VSS.t392 VSS.n121 3.30696
R2919 VSS.t392 VSS.n167 3.30688
R2920 VSS.n142 VSS.t2825 0.175395
R2921 VSS.n142 VSS.t392 2.72098
R2922 VSS.t392 VSS.t2823 5.61485
R2923 VSS.t392 VSS.n127 3.30696
R2924 VSS.t392 VSS.t2818 5.61485
R2925 VSS.n128 VSS.t2817 0.175395
R2926 VSS.n128 VSS.t392 2.72098
R2927 VSS.n147 VSS.t392 3.30696
R2928 VSS.n129 VSS.t2813 0.175554
R2929 VSS.t392 VSS.n129 2.7209
R2930 VSS.n168 VSS.t392 3.30696
R2931 VSS.t2808 VSS.n140 0.175714
R2932 VSS.t392 VSS.n140 2.72082
R2933 VSS.t392 VSS.t2806 5.61485
R2934 VSS.n169 VSS.t392 3.30696
R2935 VSS.t2802 VSS.n139 0.175714
R2936 VSS.t392 VSS.n139 2.72082
R2937 VSS.t392 VSS.t2800 5.61485
R2938 VSS.n146 VSS.t392 3.30696
R2939 VSS.t2796 VSS.n130 0.175714
R2940 VSS.t392 VSS.n170 3.30688
R2941 VSS.t2791 VSS.n138 0.175554
R2942 VSS.n138 VSS.t392 2.7209
R2943 VSS.t392 VSS.t2789 5.61485
R2944 VSS.t392 VSS.n145 3.30688
R2945 VSS.t2785 VSS.n131 0.175554
R2946 VSS.n131 VSS.t392 2.7209
R2947 VSS.t392 VSS.n171 3.30688
R2948 VSS.n137 VSS.t2781 0.175395
R2949 VSS.n137 VSS.t392 2.72098
R2950 VSS.t2778 VSS.t392 5.61485
R2951 VSS.t392 VSS.n172 3.30688
R2952 VSS.n136 VSS.t2775 0.175395
R2953 VSS.n136 VSS.t392 2.72098
R2954 VSS.t2772 VSS.t392 5.61485
R2955 VSS.t392 VSS.n144 3.30688
R2956 VSS.n132 VSS.t2769 0.175395
R2957 VSS.n132 VSS.t392 2.72098
R2958 VSS.n173 VSS.t392 3.30696
R2959 VSS.n135 VSS.t2765 0.175554
R2960 VSS.t392 VSS.n135 2.7209
R2961 VSS.t2763 VSS.t392 5.61485
R2962 VSS.n174 VSS.t392 3.30696
R2963 VSS.n134 VSS.t2760 0.175554
R2964 VSS.t392 VSS.n134 2.7209
R2965 VSS.t2758 VSS.t392 5.61485
R2966 VSS.n175 VSS.t392 3.30696
R2967 VSS.t392 VSS.t2755 5.61485
R2968 VSS.n179 VSS.t2754 0.106161
R2969 VSS.n317 VSS.n69 3.33079
R2970 VSS.n69 VSS.n316 3.33079
R2971 VSS.n315 VSS.n69 3.33079
R2972 VSS.n69 VSS.n314 3.33079
R2973 VSS.n313 VSS.n69 3.33079
R2974 VSS.n69 VSS.n312 3.33079
R2975 VSS.n311 VSS.n69 3.33079
R2976 VSS.n69 VSS.n310 3.33079
R2977 VSS.n309 VSS.n69 3.33079
R2978 VSS.n69 VSS.n308 3.33079
R2979 VSS.n307 VSS.n69 3.33079
R2980 VSS.n69 VSS.n306 3.33079
R2981 VSS.n305 VSS.n69 3.33079
R2982 VSS.n69 VSS.n304 3.33079
R2983 VSS.n303 VSS.n69 3.33079
R2984 VSS.n69 VSS.n302 3.33079
R2985 VSS.n301 VSS.n69 3.33079
R2986 VSS.n69 VSS.n300 3.33079
R2987 VSS.n299 VSS.n69 3.33079
R2988 VSS.n69 VSS.n298 3.33079
R2989 VSS.n297 VSS.n69 3.33079
R2990 VSS.n69 VSS.n296 3.33079
R2991 VSS.n295 VSS.n69 3.33079
R2992 VSS.n69 VSS.n294 3.33079
R2993 VSS.n293 VSS.n69 3.33079
R2994 VSS.n69 VSS.n292 3.33079
R2995 VSS.n291 VSS.n69 3.33079
R2996 VSS.n289 VSS.n69 3.33079
R2997 VSS.n288 VSS.n69 3.33079
R2998 VSS.n287 VSS.n69 3.33079
R2999 VSS.n286 VSS.n69 3.33079
R3000 VSS.n285 VSS.n69 3.33079
R3001 VSS.n284 VSS.n69 3.33079
R3002 VSS.n283 VSS.n69 3.33079
R3003 VSS.n282 VSS.n69 3.33079
R3004 VSS.n281 VSS.n69 3.33079
R3005 VSS.n280 VSS.n69 3.33079
R3006 VSS.n279 VSS.n69 3.33079
R3007 VSS.n278 VSS.n69 3.33079
R3008 VSS.n277 VSS.n69 3.33079
R3009 VSS.n276 VSS.n69 3.33079
R3010 VSS.n275 VSS.n69 3.33079
R3011 VSS.n274 VSS.n69 3.33079
R3012 VSS.n273 VSS.n69 3.33079
R3013 VSS.n272 VSS.n69 3.33079
R3014 VSS.n271 VSS.n69 3.33079
R3015 VSS.n270 VSS.n69 3.33079
R3016 VSS.n269 VSS.n69 3.33079
R3017 VSS.n268 VSS.n69 3.33079
R3018 VSS.n267 VSS.n69 3.33079
R3019 VSS.n266 VSS.n69 3.33079
R3020 VSS.n265 VSS.n69 3.33079
R3021 VSS.n264 VSS.n69 3.33079
R3022 VSS.n263 VSS.n69 3.33079
R3023 VSS.t2363 VSS.n262 0.0863258
R3024 VSS.n373 VSS.n71 3.33079
R3025 VSS.n71 VSS.n372 3.33079
R3026 VSS.n371 VSS.n71 3.33079
R3027 VSS.n71 VSS.n370 3.33079
R3028 VSS.n369 VSS.n71 3.33079
R3029 VSS.n71 VSS.n368 3.33079
R3030 VSS.n367 VSS.n71 3.33079
R3031 VSS.n71 VSS.n366 3.33079
R3032 VSS.n365 VSS.n71 3.33079
R3033 VSS.n71 VSS.n364 3.33079
R3034 VSS.n363 VSS.n71 3.33079
R3035 VSS.n71 VSS.n362 3.33079
R3036 VSS.n361 VSS.n71 3.33079
R3037 VSS.n71 VSS.n360 3.33079
R3038 VSS.n359 VSS.n71 3.33079
R3039 VSS.n71 VSS.n358 3.33079
R3040 VSS.n357 VSS.n71 3.33079
R3041 VSS.n71 VSS.n356 3.33079
R3042 VSS.n355 VSS.n71 3.33079
R3043 VSS.n71 VSS.n354 3.33079
R3044 VSS.n353 VSS.n71 3.33079
R3045 VSS.n71 VSS.n352 3.33079
R3046 VSS.n351 VSS.n71 3.33079
R3047 VSS.n71 VSS.n350 3.33079
R3048 VSS.n349 VSS.n71 3.33079
R3049 VSS.n71 VSS.n348 3.33079
R3050 VSS.n347 VSS.n71 3.33079
R3051 VSS.n345 VSS.n71 3.33079
R3052 VSS.n71 VSS.n344 3.33079
R3053 VSS.n343 VSS.n71 3.33079
R3054 VSS.n71 VSS.n342 3.33079
R3055 VSS.n341 VSS.n71 3.33079
R3056 VSS.n71 VSS.n340 3.33079
R3057 VSS.n339 VSS.n71 3.33079
R3058 VSS.n71 VSS.n338 3.33079
R3059 VSS.n337 VSS.n71 3.33079
R3060 VSS.n71 VSS.n336 3.33079
R3061 VSS.n335 VSS.n71 3.33079
R3062 VSS.n71 VSS.n334 3.33079
R3063 VSS.n333 VSS.n71 3.33079
R3064 VSS.n71 VSS.n332 3.33079
R3065 VSS.n331 VSS.n71 3.33079
R3066 VSS.n71 VSS.n330 3.33079
R3067 VSS.n329 VSS.n71 3.33079
R3068 VSS.n71 VSS.n328 3.33079
R3069 VSS.n327 VSS.n71 3.33079
R3070 VSS.n71 VSS.n326 3.33079
R3071 VSS.n325 VSS.n71 3.33079
R3072 VSS.n71 VSS.n324 3.33079
R3073 VSS.n323 VSS.n71 3.33079
R3074 VSS.n322 VSS.n71 3.33079
R3075 VSS.n71 VSS.n321 3.33079
R3076 VSS.n320 VSS.n71 3.33079
R3077 VSS.n71 VSS.n319 3.33079
R3078 VSS.t1971 VSS.n318 0.0863258
R3079 VSS.n75 VSS.n429 3.33079
R3080 VSS.n428 VSS.n75 3.33079
R3081 VSS.n75 VSS.n427 3.33079
R3082 VSS.n426 VSS.n75 3.33079
R3083 VSS.n75 VSS.n425 3.33079
R3084 VSS.n424 VSS.n75 3.33079
R3085 VSS.n423 VSS.n75 3.33079
R3086 VSS.n422 VSS.n75 3.33079
R3087 VSS.n421 VSS.n75 3.33079
R3088 VSS.n420 VSS.n75 3.33079
R3089 VSS.n419 VSS.n75 3.33079
R3090 VSS.n418 VSS.n75 3.33079
R3091 VSS.n417 VSS.n75 3.33079
R3092 VSS.n416 VSS.n75 3.33079
R3093 VSS.n415 VSS.n75 3.33079
R3094 VSS.n414 VSS.n75 3.33079
R3095 VSS.n413 VSS.n75 3.33079
R3096 VSS.n412 VSS.n75 3.33079
R3097 VSS.n411 VSS.n75 3.33079
R3098 VSS.n410 VSS.n75 3.33079
R3099 VSS.n409 VSS.n75 3.33079
R3100 VSS.n408 VSS.n75 3.33079
R3101 VSS.n407 VSS.n75 3.33079
R3102 VSS.n406 VSS.n75 3.33079
R3103 VSS.n405 VSS.n75 3.33079
R3104 VSS.n404 VSS.n75 3.33079
R3105 VSS.n403 VSS.n75 3.33079
R3106 VSS.n75 VSS.n401 3.33079
R3107 VSS.n400 VSS.n75 3.33079
R3108 VSS.n75 VSS.n399 3.33079
R3109 VSS.n398 VSS.n75 3.33079
R3110 VSS.n75 VSS.n397 3.33079
R3111 VSS.n396 VSS.n75 3.33079
R3112 VSS.n75 VSS.n395 3.33079
R3113 VSS.n394 VSS.n75 3.33079
R3114 VSS.n75 VSS.n393 3.33079
R3115 VSS.n392 VSS.n75 3.33079
R3116 VSS.n75 VSS.n391 3.33079
R3117 VSS.n390 VSS.n75 3.33079
R3118 VSS.n75 VSS.n389 3.33079
R3119 VSS.n388 VSS.n75 3.33079
R3120 VSS.n75 VSS.n387 3.33079
R3121 VSS.n386 VSS.n75 3.33079
R3122 VSS.n75 VSS.n385 3.33079
R3123 VSS.n384 VSS.n75 3.33079
R3124 VSS.n75 VSS.n383 3.33079
R3125 VSS.n382 VSS.n75 3.33079
R3126 VSS.n75 VSS.n381 3.33079
R3127 VSS.n380 VSS.n75 3.33079
R3128 VSS.n75 VSS.n379 3.33079
R3129 VSS.n378 VSS.n75 3.33079
R3130 VSS.n75 VSS.n377 3.33079
R3131 VSS.n376 VSS.n75 3.33079
R3132 VSS.n75 VSS.n375 3.33079
R3133 VSS.t1579 VSS.n374 0.0863258
R3134 VSS.n431 VSS.n432 3.30688
R3135 VSS.t1376 VSS.n865 5.61485
R3136 VSS.n435 VSS.n434 3.30696
R3137 VSS.t1380 VSS.n571 5.61485
R3138 VSS.n438 VSS.t1382 0.118323
R3139 VSS.n864 VSS.t1384 5.61485
R3140 VSS.t1385 VSS.n102 5.61485
R3141 VSS.t1388 VSS.n102 5.61485
R3142 VSS.n117 VSS.t1392 0.118323
R3143 VSS.n102 VSS.n118 3.30696
R3144 VSS.t1396 VSS.n143 0.118323
R3145 VSS.t1398 VSS.n102 5.61485
R3146 VSS.n575 VSS.t1404 5.61485
R3147 VSS.n444 VSS.n445 3.30688
R3148 VSS.t1413 VSS.n862 5.61485
R3149 VSS.n456 VSS.t1420 0.118323
R3150 VSS.n591 VSS.t1427 5.61485
R3151 VSS.n460 VSS.n461 3.30688
R3152 VSS.n462 VSS.n463 3.30688
R3153 VSS.n859 VSS.t1436 5.61485
R3154 VSS.n464 VSS.n465 3.30688
R3155 VSS.t1444 VSS.n858 5.61485
R3156 VSS.t1368 VSS.n122 5.61485
R3157 VSS.n110 VSS.t1367 5.61485
R3158 VSS.n110 VSS.t1364 5.61485
R3159 VSS.t1358 VSS.n110 5.61485
R3160 VSS.n559 VSS.t1352 5.61485
R3161 VSS.t1346 VSS.n554 5.61485
R3162 VSS.n549 VSS.t1339 5.61485
R3163 VSS.n544 VSS.t1333 5.61485
R3164 VSS.t1326 VSS.n539 5.61485
R3165 VSS.n534 VSS.t1320 5.61485
R3166 VSS.t1314 VSS.n529 5.61485
R3167 VSS.t1312 VSS.n528 5.61485
R3168 VSS.n523 VSS.t1306 5.61485
R3169 VSS.t1300 VSS.n518 5.61485
R3170 VSS.n513 VSS.t1293 5.61485
R3171 VSS.n664 VSS.n73 3.33079
R3172 VSS.n73 VSS.n663 3.33079
R3173 VSS.n662 VSS.n73 3.33079
R3174 VSS.n73 VSS.n661 3.33079
R3175 VSS.n660 VSS.n73 3.33079
R3176 VSS.n73 VSS.n659 3.33079
R3177 VSS.n658 VSS.n73 3.33079
R3178 VSS.n73 VSS.n657 3.33079
R3179 VSS.n656 VSS.n73 3.33079
R3180 VSS.n73 VSS.n655 3.33079
R3181 VSS.n654 VSS.n73 3.33079
R3182 VSS.n73 VSS.n653 3.33079
R3183 VSS.n652 VSS.n73 3.33079
R3184 VSS.n73 VSS.n651 3.33079
R3185 VSS.n650 VSS.n73 3.33079
R3186 VSS.n73 VSS.n649 3.33079
R3187 VSS.n648 VSS.n73 3.33079
R3188 VSS.n73 VSS.n647 3.33079
R3189 VSS.n646 VSS.n73 3.33079
R3190 VSS.n73 VSS.n645 3.33079
R3191 VSS.n644 VSS.n73 3.33079
R3192 VSS.n73 VSS.n643 3.33079
R3193 VSS.n642 VSS.n73 3.33079
R3194 VSS.n73 VSS.n641 3.33079
R3195 VSS.n640 VSS.n73 3.33079
R3196 VSS.n73 VSS.n639 3.33079
R3197 VSS.n638 VSS.n73 3.33079
R3198 VSS.n636 VSS.n73 3.33079
R3199 VSS.n73 VSS.n635 3.33079
R3200 VSS.n634 VSS.n73 3.33079
R3201 VSS.n73 VSS.n633 3.33079
R3202 VSS.n632 VSS.n73 3.33079
R3203 VSS.n73 VSS.n631 3.33079
R3204 VSS.n630 VSS.n73 3.33079
R3205 VSS.n73 VSS.n629 3.33079
R3206 VSS.n628 VSS.n73 3.33079
R3207 VSS.n73 VSS.n627 3.33079
R3208 VSS.n626 VSS.n73 3.33079
R3209 VSS.n73 VSS.n625 3.33079
R3210 VSS.n624 VSS.n73 3.33079
R3211 VSS.n73 VSS.n623 3.33079
R3212 VSS.n622 VSS.n73 3.33079
R3213 VSS.n73 VSS.n621 3.33079
R3214 VSS.n620 VSS.n73 3.33079
R3215 VSS.n73 VSS.n619 3.33079
R3216 VSS.n618 VSS.n73 3.33079
R3217 VSS.n73 VSS.n617 3.33079
R3218 VSS.n616 VSS.n73 3.33079
R3219 VSS.n73 VSS.n615 3.33079
R3220 VSS.n614 VSS.n73 3.33079
R3221 VSS.n613 VSS.n73 3.33079
R3222 VSS.n612 VSS.n73 3.33079
R3223 VSS.n611 VSS.n73 3.33079
R3224 VSS.n610 VSS.n73 3.33079
R3225 VSS.t898 VSS.n609 0.0863258
R3226 VSS.n677 VSS.n681 3.33
R3227 VSS.n685 VSS.n700 3.33079
R3228 VSS.n680 VSS.n684 3.33087
R3229 VSS.n679 VSS.n676 3.33087
R3230 VSS.n672 VSS.n675 3.33079
R3231 VSS.n668 VSS.t824 0.0863258
R3232 VSS.n743 VSS.t764 5.61485
R3233 VSS.t155 VSS.n701 3.33079
R3234 VSS.n95 VSS.t9 3.30688
R3235 VSS.t9 VSS.n833 3.33079
R3236 VSS.t9 VSS.n832 3.33079
R3237 VSS.t9 VSS.n831 3.33079
R3238 VSS.t9 VSS.n830 3.33079
R3239 VSS.t9 VSS.n827 3.33079
R3240 VSS.t9 VSS.n826 3.33079
R3241 VSS.t9 VSS.n825 3.33079
R3242 VSS.t9 VSS.n824 3.33079
R3243 VSS.t9 VSS.n823 3.33079
R3244 VSS.t9 VSS.n822 3.33079
R3245 VSS.t9 VSS.n821 3.33079
R3246 VSS.t9 VSS.n820 3.33079
R3247 VSS.t9 VSS.n819 3.33079
R3248 VSS.n818 VSS.t9 3.33079
R3249 VSS.n836 VSS.t9 3.33079
R3250 VSS.n843 VSS.t631 0.0863258
R3251 VSS.t572 VSS.n841 0.0863258
R3252 VSS.n1011 VSS.t258 4.29849
R3253 VSS.n1030 VSS.t270 4.28621
R3254 VSS.t311 VSS.n430 4.25113
R3255 VSS.n103 VSS.n864 0.025627
R3256 VSS.t311 VSS.n469 4.251
R3257 VSS.n834 VSS.t9 3.36082
R3258 VSS.t9 VSS.t93 4.2505
R3259 VSS.n69 VSS.t2505 4.20259
R3260 VSS.n71 VSS.t2113 4.20259
R3261 VSS.t1721 VSS.n75 4.20259
R3262 VSS.n73 VSS.t1040 4.20259
R3263 VSS.n839 VSS.t9 2.74413
R3264 VSS.t79 VSS.n922 3.50108
R3265 VSS.t106 VSS.n922 3.50108
R3266 VSS.n809 VSS.n812 2.35097
R3267 VSS.n666 VSS.n671 2.31523
R3268 VSS.n759 VSS.n766 2.31585
R3269 VSS.n755 VSS.n762 2.31585
R3270 VSS.n751 VSS.n758 2.31585
R3271 VSS.n747 VSS.n754 2.31585
R3272 VSS.n739 VSS.n746 2.31585
R3273 VSS.n735 VSS.n742 2.31585
R3274 VSS.n731 VSS.n738 2.31585
R3275 VSS.n727 VSS.n734 2.31585
R3276 VSS.n723 VSS.n730 2.31585
R3277 VSS.n719 VSS.n726 2.31585
R3278 VSS.n715 VSS.n722 2.31585
R3279 VSS.n711 VSS.n718 2.31585
R3280 VSS.n707 VSS.n714 2.31585
R3281 VSS.n704 VSS.n710 2.31585
R3282 VSS.n702 VSS.n706 2.31573
R3283 VSS.t81 VSS.n1004 2.59384
R3284 VSS.t81 VSS.n109 0.405951
R3285 VSS.t81 VSS.n939 2.59384
R3286 VSS.t81 VSS.n940 2.59384
R3287 VSS.t81 VSS.n126 0.405951
R3288 VSS.t81 VSS.n950 2.59384
R3289 VSS.t81 VSS.n124 0.405951
R3290 VSS.t81 VSS.n942 2.59384
R3291 VSS.t81 VSS.n943 2.59384
R3292 VSS.t519 VSS.n245 0.531244
R3293 VSS.n941 VSS.t81 2.29778
R3294 VSS.t96 VSS.n815 1.73657
R3295 VSS.t15 VSS.n838 0.092308
R3296 VSS.t9 VSS.n922 1.88939
R3297 VSS.t0 VSS.t76 1.37665
R3298 VSS.n677 VSS.t328 1.35824
R3299 VSS.t76 VSS.t9 0.73982
R3300 VSS.t9 VSS.n842 0.991912
R3301 VSS.t246 VSS.t28 1.19244
R3302 VSS.n927 VSS.t39 1.15047
R3303 VSS.t820 VSS.t712 1.14623
R3304 VSS.t702 VSS.t707 1.13744
R3305 VSS.t553 VSS.t90 1.1135
R3306 VSS.t355 VSS.t460 1.1131
R3307 VSS.t363 VSS.t481 1.111
R3308 VSS.t466 VSS.t471 1.10982
R3309 VSS.t11 VSS.n810 0.952798
R3310 VSS.t58 VSS.n927 1.10098
R3311 VSS.n844 VSS.t48 0.0801996
R3312 VSS.t1 VSS.n907 1.08133
R3313 VSS.t45 VSS.n908 1.07711
R3314 VSS.t11 VSS.t54 1.07052
R3315 VSS.n896 VSS.t728 1.05022
R3316 VSS.n845 VSS.t444 0.893724
R3317 VSS.n908 VSS.t62 1.03277
R3318 VSS.t78 VSS.t723 1.02913
R3319 VSS.t226 VSS.t386 1.02354
R3320 VSS.n907 VSS.t45 1.02265
R3321 VSS.t164 VSS.t172 1.02116
R3322 VSS.t486 VSS.t347 1.02018
R3323 VSS.n240 VSS.t231 0.86307
R3324 VSS.t728 VSS.t164 1.01648
R3325 VSS.t245 VSS.t557 1.00185
R3326 VSS.t13 VSS.n837 0.995711
R3327 VSS.t471 VSS.t363 0.928205
R3328 VSS.n101 VSS.t23 0.83493
R3329 VSS.t188 VSS.n837 0.771979
R3330 VSS.t553 VSS.t557 0.919999
R3331 VSS.t712 VSS.t707 0.916576
R3332 VSS.t347 VSS.t378 0.903814
R3333 VSS.t105 VSS.n835 0.752903
R3334 VSS.t378 VSS.n236 0.059721
R3335 VSS.t105 VSS.t60 0.876684
R3336 VSS.t39 VSS.t60 0.852391
R3337 VSS.t25 VSS.t24 0.829229
R3338 VSS.t568 VSS.t245 0.815879
R3339 VSS.t455 VSS.n938 0.806717
R3340 VSS.t9 VSS.t60 0.800406
R3341 VSS.n244 VSS.t519 0.666026
R3342 VSS.n244 VSS.t83 1.07725
R3343 VSS.t180 VSS.n844 0.623747
R3344 VSS.t48 VSS.t58 0.74696
R3345 VSS.t99 VSS.n842 0.0822487
R3346 VSS.t43 VSS.n835 1.00067
R3347 VSS.t81 VSS.n236 0.569247
R3348 VSS.n685 VSS.n699 0.666899
R3349 VSS.n682 VSS.n697 0.666899
R3350 VSS.n809 VSS.n811 0.666899
R3351 VSS.t9 VSS.n54 0.666899
R3352 VSS.t9 VSS.n34 0.666899
R3353 VSS.t9 VSS.n33 0.666899
R3354 VSS.n1047 VSS.t9 0.666899
R3355 VSS.n1049 VSS.t9 0.666899
R3356 VSS.n1051 VSS.t9 0.666899
R3357 VSS.t9 VSS.n52 0.666899
R3358 VSS.t9 VSS.n35 0.666899
R3359 VSS.n1100 VSS.n698 0.655024
R3360 VSS.t9 VSS.n55 0.655024
R3361 VSS.n69 VSS.t2589 109.992
R3362 VSS.t2584 VSS.n69 109.992
R3363 VSS.t2172 VSS.n71 109.992
R3364 VSS.t2162 VSS.n71 109.993
R3365 VSS.n75 VSS.t1850 109.992
R3366 VSS.t1825 VSS.n75 109.992
R3367 VSS.t1795 VSS.n75 109.992
R3368 VSS.t1730 VSS.n75 109.992
R3369 VSS.n75 VSS.t1710 109.993
R3370 VSS.n75 VSS.t1580 109.986
R3371 VSS.n73 VSS.t1164 109.992
R3372 VSS.n73 VSS.t994 109.993
R3373 VSS.t919 VSS.n73 109.992
R3374 VSS.n682 VSS.n696 0.649813
R3375 VSS.n682 VSS.n686 0.649813
R3376 VSS.n682 VSS.n695 0.649813
R3377 VSS.n680 VSS.n683 0.649813
R3378 VSS.n1089 VSS.n677 0.649813
R3379 VSS.n676 VSS.n678 0.649813
R3380 VSS.n985 VSS.n673 0.649813
R3381 VSS.n672 VSS.n674 0.649813
R3382 VSS.n991 VSS.n666 0.649813
R3383 VSS.n667 VSS.n665 0.649813
R3384 VSS.n759 VSS.n764 0.649813
R3385 VSS.n759 VSS.n765 0.649813
R3386 VSS.n755 VSS.n760 0.649813
R3387 VSS.n755 VSS.n761 0.649813
R3388 VSS.n751 VSS.n756 0.649813
R3389 VSS.n751 VSS.n757 0.649813
R3390 VSS.n747 VSS.n752 0.649813
R3391 VSS.n747 VSS.n753 0.649813
R3392 VSS.n743 VSS.n748 0.649813
R3393 VSS.n743 VSS.n749 0.649813
R3394 VSS.n739 VSS.n744 0.649813
R3395 VSS.n739 VSS.n745 0.649813
R3396 VSS.n735 VSS.n740 0.649813
R3397 VSS.n735 VSS.n741 0.649813
R3398 VSS.n731 VSS.n736 0.649813
R3399 VSS.n731 VSS.n737 0.649813
R3400 VSS.n727 VSS.n732 0.649813
R3401 VSS.n727 VSS.n733 0.649813
R3402 VSS.n723 VSS.n728 0.649813
R3403 VSS.n723 VSS.n729 0.649813
R3404 VSS.n719 VSS.n724 0.649813
R3405 VSS.n719 VSS.n725 0.649813
R3406 VSS.n715 VSS.n720 0.649813
R3407 VSS.n715 VSS.n721 0.649813
R3408 VSS.n711 VSS.n716 0.649813
R3409 VSS.n711 VSS.n717 0.649813
R3410 VSS.n707 VSS.n712 0.649813
R3411 VSS.n707 VSS.n713 0.649813
R3412 VSS.n704 VSS.n708 0.649813
R3413 VSS.n704 VSS.n709 0.649813
R3414 VSS.n702 VSS.n705 0.649813
R3415 VSS.n889 VSS.n703 0.649813
R3416 VSS.t681 VSS.n794 0.649813
R3417 VSS.t681 VSS.n795 0.649813
R3418 VSS.t681 VSS.n796 0.649813
R3419 VSS.t681 VSS.n797 0.649813
R3420 VSS.n1001 VSS.t681 0.649813
R3421 VSS.n1058 VSS.t9 0.649813
R3422 VSS.t9 VSS.n49 0.649813
R3423 VSS.t9 VSS.n50 0.649813
R3424 VSS.t9 VSS.n48 0.649813
R3425 VSS.n1020 VSS.t9 0.649813
R3426 VSS.t9 VSS.n47 0.369499
R3427 VSS.t9 VSS.n51 0.649813
R3428 VSS.t9 VSS.n36 0.649813
R3429 VSS.n938 VSS.t460 0.648185
R3430 VSS.t96 VSS.n813 0.648101
R3431 VSS.t9 VSS.n53 0.648101
R3432 VSS.t9 VSS.n32 0.648101
R3433 VSS.t9 VSS.n37 0.648101
R3434 VSS.t9 VSS.n38 0.648101
R3435 VSS.t9 VSS.n46 0.648101
R3436 VSS.t9 VSS.n39 0.648101
R3437 VSS.t9 VSS.n40 0.648101
R3438 VSS.t9 VSS.n41 0.648101
R3439 VSS.t9 VSS.n45 0.648101
R3440 VSS.t9 VSS.n44 0.648101
R3441 VSS.t9 VSS.n42 0.648101
R3442 VSS.t9 VSS.n43 0.648101
R3443 VSS.t328 VSS.t319 0.640136
R3444 VSS.t355 VSS.t466 0.611475
R3445 VSS.t99 VSS.t213 0.600657
R3446 VSS.t328 VSS.t333 0.533029
R3447 VSS.n240 VSS.t386 0.0536702
R3448 VSS.t81 VSS.t355 0.508724
R3449 VSS.n838 VSS.t13 0.393805
R3450 VSS.n682 VSS.t164 0.504946
R3451 VSS.t18 VSS.t15 0.499297
R3452 VSS.n908 VSS.t9 0.463818
R3453 VSS.n682 VSS.n896 0.462435
R3454 VSS.n907 VSS.t9 0.462279
R3455 VSS.t88 VSS.n245 0.345153
R3456 VSS.t430 VSS.n815 0.54843
R3457 VSS.t208 VSS.n941 0.452661
R3458 VSS.t81 VSS.n938 0.40979
R3459 VSS.n4 VSS.t440 47.2101
R3460 VSS.n89 VSS.t81 0.219018
R3461 VSS.n96 VSS.t459 47.2101
R3462 VSS.t81 VSS.n8 0.405951
R3463 VSS.n30 VSS.t463 47.2102
R3464 VSS.t81 VSS.n7 0.405951
R3465 VSS.t81 VSS.n5 0.219018
R3466 VSS.t81 VSS.n6 0.405951
R3467 VSS.t81 VSS.n9 0.219019
R3468 VSS.t81 VSS.n12 0.405951
R3469 VSS.t81 VSS.n10 0.405951
R3470 VSS.n84 VSS.t505 47.2102
R3471 VSS.t81 VSS.n13 0.225189
R3472 VSS.t81 VSS.n17 0.405951
R3473 VSS.t81 VSS.n16 0.405951
R3474 VSS.t81 VSS.n14 0.405951
R3475 VSS.t81 VSS.n15 0.405951
R3476 VSS.n81 VSS.t81 0.219019
R3477 VSS.t81 VSS.n29 0.121859
R3478 VSS.t81 VSS.n18 0.405951
R3479 VSS.t81 VSS.n28 0.405951
R3480 VSS.t81 VSS.n20 0.405951
R3481 VSS.t81 VSS.n26 0.405951
R3482 VSS.t81 VSS.n22 0.219019
R3483 VSS.n94 VSS.t563 47.2101
R3484 VSS.t81 VSS.n24 0.405951
R3485 VSS.t81 VSS.n25 0.219073
R3486 VSS.t360 VSS.n845 0.042434
R3487 VSS.t2823 VSS.t2824 0.36115
R3488 VSS.t2765 VSS.t2766 0.36115
R3489 VSS.t2760 VSS.t2761 0.36115
R3490 VSS.t2755 VSS.t2756 0.36115
R3491 VSS.t2894 VSS.t2893 0.36115
R3492 VSS.t2789 VSS.t2790 0.36115
R3493 VSS.t2795 VSS.n130 0.175714
R3494 VSS.t2801 VSS.n139 0.175714
R3495 VSS.t2807 VSS.n140 0.175714
R3496 VSS.t2813 VSS.t2814 0.36115
R3497 VSS.t2829 VSS.t2830 0.36115
R3498 VSS.t2888 VSS.t2889 0.36115
R3499 VSS.t2880 VSS.t2881 0.36115
R3500 VSS.t2872 VSS.t2873 0.36115
R3501 VSS.t2864 VSS.t2865 0.36115
R3502 VSS.t2856 VSS.t2857 0.36115
R3503 VSS.t2848 VSS.t2849 0.36115
R3504 VSS.t2840 VSS.t2841 0.36115
R3505 VSS.t2901 VSS.t2902 0.36115
R3506 VSS.t2772 VSS.t2773 0.360811
R3507 VSS.t2778 VSS.t2779 0.360811
R3508 VSS.t2784 VSS.n131 0.175554
R3509 VSS.t2790 VSS.n138 0.175554
R3510 VSS.t2796 VSS.t2797 0.360811
R3511 VSS.t2802 VSS.t2803 0.360811
R3512 VSS.t2808 VSS.t2809 0.360811
R3513 VSS.t1396 VSS.t1395 0.360811
R3514 VSS.t1382 VSS.t1384 0.360811
R3515 VSS.t1380 VSS.t1379 0.360811
R3516 VSS.t1368 VSS.t1367 0.360811
R3517 VSS.t2825 VSS.t2826 0.360811
R3518 VSS.t2823 VSS.t2822 0.360811
R3519 VSS.t2817 VSS.t2818 0.360811
R3520 VSS.t2812 VSS.n129 0.175554
R3521 VSS.t2806 VSS.t2807 0.360811
R3522 VSS.t2800 VSS.t2801 0.360811
R3523 VSS.t2782 VSS.t2781 0.360811
R3524 VSS.t2776 VSS.t2775 0.360811
R3525 VSS.t2770 VSS.t2769 0.360811
R3526 VSS.n135 VSS.t2764 0.175554
R3527 VSS.n134 VSS.t2759 0.175554
R3528 VSS.t1385 VSS.t1384 0.360471
R3529 VSS.t1376 VSS.t1375 0.360471
R3530 VSS.t2886 VSS.t2885 0.360471
R3531 VSS.t2878 VSS.t2877 0.360471
R3532 VSS.t2870 VSS.t2869 0.360471
R3533 VSS.t2862 VSS.t2861 0.360471
R3534 VSS.t2854 VSS.t2853 0.360471
R3535 VSS.t2846 VSS.t2845 0.360471
R3536 VSS.t2838 VSS.t2837 0.360471
R3537 VSS.t2824 VSS.n142 0.175395
R3538 VSS.t2816 VSS.n128 0.175395
R3539 VSS.t2791 VSS.t2793 0.360471
R3540 VSS.t2785 VSS.t2787 0.360471
R3541 VSS.t2779 VSS.n137 0.175395
R3542 VSS.t2773 VSS.n136 0.175395
R3543 VSS.t2768 VSS.n132 0.175395
R3544 VSS.t2763 VSS.t2764 0.360471
R3545 VSS.t2758 VSS.t2759 0.360471
R3546 VSS.t2754 VSS.t2755 0.360471
R3547 VSS.t2899 VSS.t2898 0.360471
R3548 VSS.t307 VSS.t827 0.344973
R3549 VSS.t774 VSS.n762 0.433869
R3550 VSS.t771 VSS.n758 0.433869
R3551 VSS.t768 VSS.n754 0.433869
R3552 VSS.n710 VSS.t733 0.433869
R3553 VSS.n714 VSS.t736 0.433869
R3554 VSS.n718 VSS.t739 0.433869
R3555 VSS.n722 VSS.t742 0.433869
R3556 VSS.n726 VSS.t745 0.433869
R3557 VSS.n730 VSS.t748 0.433869
R3558 VSS.n734 VSS.t751 0.433869
R3559 VSS.n738 VSS.t754 0.433869
R3560 VSS.n742 VSS.t757 0.433869
R3561 VSS.n746 VSS.t760 0.433869
R3562 VSS.n706 VSS.t349 0.433862
R3563 VSS.t827 VSS.n671 0.0931939
R3564 VSS.t777 VSS.n766 0.422619
R3565 VSS.t693 VSS.t224 0.322119
R3566 VSS.t290 VSS.t211 0.312745
R3567 VSS.t9 VSS.n927 0.309283
R3568 VSS.n185 VSS.t3053 0.0850573
R3569 VSS.t2815 VSS.t2816 0.301114
R3570 VSS.t1467 VSS.t1312 0.301114
R3571 VSS.t1470 VSS.t1314 0.301114
R3572 VSS.t1505 VSS.t1358 0.301114
R3573 VSS.t1339 VSS.t1340 0.301114
R3574 VSS.t1293 VSS.t1294 0.301114
R3575 VSS.n465 VSS.t1439 0.118323
R3576 VSS.n463 VSS.t1434 0.118323
R3577 VSS.n445 VSS.t1408 0.118323
R3578 VSS.t1398 VSS.t1399 0.301114
R3579 VSS.t1380 VSS.t1381 0.301114
R3580 VSS.n152 VSS.t2891 0.118323
R3581 VSS.n154 VSS.t2883 0.118323
R3582 VSS.n156 VSS.t2875 0.118323
R3583 VSS.n158 VSS.t2867 0.118323
R3584 VSS.n160 VSS.t2859 0.118323
R3585 VSS.n162 VSS.t2851 0.118323
R3586 VSS.n164 VSS.t2843 0.118323
R3587 VSS.n166 VSS.t2835 0.118323
R3588 VSS.t2782 VSS.n171 0.118323
R3589 VSS.t2776 VSS.n172 0.118323
R3590 VSS.t2770 VSS.n144 0.118323
R3591 VSS.n151 VSS.t2896 0.118323
R3592 VSS.t2771 VSS.t2772 0.301114
R3593 VSS.t2777 VSS.t2778 0.301114
R3594 VSS.t2783 VSS.t2784 0.301114
R3595 VSS.t1325 VSS.t1326 0.301114
R3596 VSS.t2818 VSS.t2819 0.301114
R3597 VSS.t2826 VSS.n167 0.118323
R3598 VSS.t1306 VSS.t1307 0.301114
R3599 VSS.t1352 VSS.t1353 0.301114
R3600 VSS.t1365 VSS.t1364 0.301114
R3601 VSS.t1345 VSS.t1346 0.301114
R3602 VSS.t1333 VSS.t1334 0.301114
R3603 VSS.t1321 VSS.t1320 0.301114
R3604 VSS.t1299 VSS.t1300 0.301114
R3605 VSS.n143 VSS.t1397 0.17801
R3606 VSS.t1413 VSS.t1414 0.301114
R3607 VSS.t1444 VSS.t1445 0.301114
R3608 VSS.n461 VSS.t1431 0.118323
R3609 VSS.t1427 VSS.t1428 0.301114
R3610 VSS.t1419 VSS.n456 0.17801
R3611 VSS.t1404 VSS.t1405 0.301114
R3612 VSS.n117 VSS.t1393 0.17801
R3613 VSS.t1388 VSS.t1389 0.301114
R3614 VSS.t1385 VSS.t1386 0.301114
R3615 VSS.t1381 VSS.n438 0.17801
R3616 VSS.t1376 VSS.t1377 0.301114
R3617 VSS.n432 VSS.t1375 0.118323
R3618 VSS.n857 VSS.t1368 0.301114
R3619 VSS.t2886 VSS.t2887 0.301114
R3620 VSS.n153 VSS.t2885 0.118323
R3621 VSS.t2878 VSS.t2879 0.301114
R3622 VSS.n155 VSS.t2877 0.118323
R3623 VSS.t2870 VSS.t2871 0.301114
R3624 VSS.n157 VSS.t2869 0.118323
R3625 VSS.t2862 VSS.t2863 0.301114
R3626 VSS.n159 VSS.t2861 0.118323
R3627 VSS.t2854 VSS.t2855 0.301114
R3628 VSS.n161 VSS.t2853 0.118323
R3629 VSS.t2846 VSS.t2847 0.301114
R3630 VSS.n163 VSS.t2845 0.118323
R3631 VSS.t2838 VSS.t2839 0.301114
R3632 VSS.n165 VSS.t2837 0.118323
R3633 VSS.n170 VSS.t2793 0.118323
R3634 VSS.n145 VSS.t2787 0.118323
R3635 VSS.t2762 VSS.t2763 0.301114
R3636 VSS.t2757 VSS.t2758 0.301114
R3637 VSS.t2899 VSS.t2900 0.301114
R3638 VSS.n150 VSS.t2898 0.118323
R3639 VSS.t2814 VSS.n147 0.118193
R3640 VSS.t2830 VSS.t2831 0.300775
R3641 VSS.n95 VSS.t265 0.418597
R3642 VSS.t1326 VSS.t1327 0.300775
R3643 VSS.t1366 VSS.t1367 0.300775
R3644 VSS.t2756 VSS.n175 0.118193
R3645 VSS.t2761 VSS.n174 0.118193
R3646 VSS.t2766 VSS.n173 0.118193
R3647 VSS.t2797 VSS.n146 0.118193
R3648 VSS.t2803 VSS.n169 0.118193
R3649 VSS.t2809 VSS.n168 0.118193
R3650 VSS.t1300 VSS.t1301 0.300775
R3651 VSS.t1312 VSS.t1313 0.300775
R3652 VSS.t1314 VSS.t1315 0.300775
R3653 VSS.t1346 VSS.t1347 0.300775
R3654 VSS.t1358 VSS.t1359 0.300775
R3655 VSS.t1363 VSS.t1364 0.300775
R3656 VSS.t1351 VSS.t1352 0.300775
R3657 VSS.t1338 VSS.t1339 0.300775
R3658 VSS.t1332 VSS.t1333 0.300775
R3659 VSS.t1319 VSS.t1320 0.300775
R3660 VSS.t1292 VSS.t1293 0.300775
R3661 VSS.t1444 VSS.t1443 0.300775
R3662 VSS.t1439 VSS.t1440 0.300775
R3663 VSS.t1436 VSS.t1437 0.300775
R3664 VSS.t1434 VSS.t1565 0.300775
R3665 VSS.t1431 VSS.t1432 0.300775
R3666 VSS.t1426 VSS.t1427 0.300775
R3667 VSS.t1420 VSS.t1554 0.300775
R3668 VSS.t1413 VSS.t1412 0.300775
R3669 VSS.t1408 VSS.t1409 0.300775
R3670 VSS.t1403 VSS.t1404 0.300775
R3671 VSS.t1398 VSS.t1397 0.300775
R3672 VSS.n118 VSS.t1395 0.118193
R3673 VSS.t1391 VSS.t1392 0.300775
R3674 VSS.t1388 VSS.t1387 0.300775
R3675 VSS.t1379 VSS.n435 0.118193
R3676 VSS.t2889 VSS.t3013 0.300775
R3677 VSS.n258 VSS.t2887 0.177814
R3678 VSS.t2883 VSS.t2884 0.300775
R3679 VSS.t2881 VSS.t3006 0.300775
R3680 VSS.n257 VSS.t2879 0.177814
R3681 VSS.t2875 VSS.t2876 0.300775
R3682 VSS.t2873 VSS.t2999 0.300775
R3683 VSS.n256 VSS.t2871 0.177814
R3684 VSS.t2867 VSS.t2868 0.300775
R3685 VSS.t2865 VSS.t2992 0.300775
R3686 VSS.n255 VSS.t2863 0.177814
R3687 VSS.t2859 VSS.t2860 0.300775
R3688 VSS.t2857 VSS.t2985 0.300775
R3689 VSS.n254 VSS.t2855 0.177814
R3690 VSS.t2851 VSS.t2852 0.300775
R3691 VSS.t2849 VSS.t2978 0.300775
R3692 VSS.n253 VSS.t2847 0.177814
R3693 VSS.t2843 VSS.t2844 0.300775
R3694 VSS.t2841 VSS.t2971 0.300775
R3695 VSS.n252 VSS.t2839 0.177814
R3696 VSS.t2835 VSS.t2836 0.300775
R3697 VSS.t2833 VSS.t2964 0.300775
R3698 VSS.n121 VSS.t2829 0.118193
R3699 VSS.t2891 VSS.t3015 0.300775
R3700 VSS.n127 VSS.t2822 0.118193
R3701 VSS.t2811 VSS.t2812 0.300775
R3702 VSS.t2805 VSS.t2806 0.300775
R3703 VSS.t2799 VSS.t2800 0.300775
R3704 VSS.t2794 VSS.t2795 0.300775
R3705 VSS.t2788 VSS.t2789 0.300775
R3706 VSS.t2894 VSS.t2895 0.300775
R3707 VSS.t2902 VSS.n100 0.118193
R3708 VSS.n259 VSS.t2900 0.177814
R3709 VSS.t2896 VSS.t2897 0.300775
R3710 VSS.n810 VSS.t224 0.0337838
R3711 VSS.n179 VSS.t393 0.160265
R3712 VSS.t62 VSS.n839 0.338704
R3713 VSS.t1448 VSS.t1449 0.251828
R3714 VSS.n816 VSS.t580 0.0962547
R3715 VSS.n149 VSS.t2832 0.119605
R3716 VSS.t1451 VSS.t1291 0.241078
R3717 VSS.t1460 VSS.t1303 0.241078
R3718 VSS.t1473 VSS.t1316 0.241078
R3719 VSS.n490 VSS.t1325 0.119605
R3720 VSS.t1327 VSS.t1328 0.241078
R3721 VSS.t1489 VSS.t1337 0.241078
R3722 VSS.t1498 VSS.t1349 0.241078
R3723 VSS.t1508 VSS.t1360 0.241078
R3724 VSS.t1544 VSS.n448 0.119605
R3725 VSS.t1551 VSS.t1419 0.241078
R3726 VSS.t1554 VSS.t1422 0.241078
R3727 VSS.t1571 VSS.n468 0.119605
R3728 VSS.t3024 VSS.t2904 0.241078
R3729 VSS.t21 VSS.t209 0.241078
R3730 VSS.t23 VSS.t86 0.241078
R3731 VSS.t265 VSS.n97 0.235599
R3732 VSS.t55 VSS.n108 0.346659
R3733 VSS.t5 VSS.t55 0.241078
R3734 VSS.n508 VSS.t1292 0.119605
R3735 VSS.t1294 VSS.t1295 0.241078
R3736 VSS.t1303 VSS.t1304 0.241078
R3737 VSS.t1289 VSS.t1290 0.241078
R3738 VSS.t438 VSS.n95 0.418588
R3739 VSS.t46 VSS.n105 0.360183
R3740 VSS.t26 VSS.t266 0.241078
R3741 VSS.t66 VSS.n817 0.119605
R3742 VSS.t209 VSS.n104 0.119605
R3743 VSS.t1316 VSS.t1317 0.241078
R3744 VSS.t1328 VSS.t1329 0.241078
R3745 VSS.n484 VSS.t1338 0.119605
R3746 VSS.t1340 VSS.t1341 0.241078
R3747 VSS.t1349 VSS.t1350 0.241078
R3748 VSS.n116 VSS.t1361 0.119605
R3749 VSS.n472 VSS.t1366 0.119605
R3750 VSS.t1361 VSS.t1362 0.241078
R3751 VSS.n473 VSS.t1363 0.119605
R3752 VSS.n114 VSS.t1508 0.119605
R3753 VSS.n475 VSS.t1505 0.119605
R3754 VSS.t1356 VSS.t1357 0.241078
R3755 VSS.t1355 VSS.t1356 0.241078
R3756 VSS.t1353 VSS.t1354 0.241078
R3757 VSS.t1354 VSS.t1355 0.241078
R3758 VSS.n478 VSS.t1351 0.119605
R3759 VSS.t1348 VSS.t1498 0.241078
R3760 VSS.t1347 VSS.t1348 0.241078
R3761 VSS.n481 VSS.t1345 0.119605
R3762 VSS.t1343 VSS.t1344 0.241078
R3763 VSS.t1341 VSS.t1342 0.241078
R3764 VSS.t1342 VSS.t1343 0.241078
R3765 VSS.t1336 VSS.t1489 0.241078
R3766 VSS.t1335 VSS.t1336 0.241078
R3767 VSS.t1334 VSS.t1335 0.241078
R3768 VSS.n487 VSS.t1332 0.119605
R3769 VSS.t1329 VSS.t1330 0.241078
R3770 VSS.t1330 VSS.t1331 0.241078
R3771 VSS.t1324 VSS.t1480 0.241078
R3772 VSS.t1323 VSS.t1324 0.241078
R3773 VSS.t1322 VSS.t1323 0.241078
R3774 VSS.t1321 VSS.t1322 0.241078
R3775 VSS.t1317 VSS.t1318 0.241078
R3776 VSS.n493 VSS.t1319 0.119605
R3777 VSS.t1315 VSS.t1473 0.241078
R3778 VSS.n496 VSS.t1470 0.119605
R3779 VSS.n499 VSS.t1467 0.119605
R3780 VSS.t1310 VSS.t1311 0.241078
R3781 VSS.t1309 VSS.t1310 0.241078
R3782 VSS.t1307 VSS.t1308 0.241078
R3783 VSS.t1308 VSS.t1309 0.241078
R3784 VSS.t1302 VSS.t1460 0.241078
R3785 VSS.t1301 VSS.t1302 0.241078
R3786 VSS.n505 VSS.t1299 0.119605
R3787 VSS.t1297 VSS.t1298 0.241078
R3788 VSS.t1295 VSS.t1296 0.241078
R3789 VSS.t1296 VSS.t1297 0.241078
R3790 VSS.t1290 VSS.t1451 0.241078
R3791 VSS.t1399 VSS.t1400 0.241078
R3792 VSS.t1410 VSS.t1411 0.241078
R3793 VSS.t1422 VSS.t1423 0.241078
R3794 VSS.t1441 VSS.t1442 0.241078
R3795 VSS.n471 VSS.t1448 0.119605
R3796 VSS.t1445 VSS.t1446 0.241078
R3797 VSS.t1446 VSS.t1447 0.241078
R3798 VSS.t1442 VSS.t1443 0.241078
R3799 VSS.t1440 VSS.t1571 0.241078
R3800 VSS.t1438 VSS.t1568 0.241078
R3801 VSS.t1437 VSS.t1438 0.241078
R3802 VSS.t1433 VSS.t1563 0.241078
R3803 VSS.t1432 VSS.t1433 0.241078
R3804 VSS.t1429 VSS.t1430 0.241078
R3805 VSS.t1428 VSS.t1429 0.241078
R3806 VSS.t1425 VSS.t1426 0.241078
R3807 VSS.t1423 VSS.t1424 0.241078
R3808 VSS.n459 VSS.t1425 0.119605
R3809 VSS.t1418 VSS.t1551 0.241078
R3810 VSS.n453 VSS.t1418 0.119605
R3811 VSS.t1416 VSS.t1417 0.241078
R3812 VSS.t1414 VSS.t1415 0.241078
R3813 VSS.t1415 VSS.n450 0.119605
R3814 VSS.t1411 VSS.t1412 0.241078
R3815 VSS.t1409 VSS.t1544 0.241078
R3816 VSS.t1407 VSS.t1541 0.241078
R3817 VSS.t1406 VSS.t1407 0.241078
R3818 VSS.t1405 VSS.t1406 0.241078
R3819 VSS.t1402 VSS.t1403 0.241078
R3820 VSS.t1400 VSS.t1401 0.241078
R3821 VSS.n443 VSS.t1402 0.119605
R3822 VSS.t1393 VSS.t1394 0.241078
R3823 VSS.t1390 VSS.t1391 0.241078
R3824 VSS.n440 VSS.t1390 0.119605
R3825 VSS.n439 VSS.t1387 0.119605
R3826 VSS.t1377 VSS.t1378 0.241078
R3827 VSS.t1373 VSS.t1374 0.241078
R3828 VSS.t1372 VSS.t1373 0.241078
R3829 VSS.n856 VSS.t1371 0.241078
R3830 VSS.t1371 VSS.t1372 0.241078
R3831 VSS.t2827 VSS.t2828 0.241078
R3832 VSS.n261 VSS.t2820 0.119605
R3833 VSS.t2820 VSS.t2821 0.241078
R3834 VSS.n260 VSS.t2905 0.119605
R3835 VSS.n869 VSS.t1306 0.240486
R3836 VSS.n148 VSS.t2892 0.209511
R3837 VSS.t1721 VSS.t1719 0.233225
R3838 VSS.t1038 VSS.t1040 0.233225
R3839 VSS.t2111 VSS.t2113 0.233225
R3840 VSS.t2505 VSS.t2503 0.233225
R3841 VSS.n941 VSS.t83 0.232128
R3842 VSS.t317 VSS.t834 0.227075
R3843 VSS.t452 VSS.n847 0.135296
R3844 VSS.t447 VSS.n846 0.135296
R3845 VSS.n242 VSS.t513 0.135296
R3846 VSS.n243 VSS.t208 0.135296
R3847 VSS.n246 VSS.t523 0.135296
R3848 VSS.n247 VSS.t528 0.135296
R3849 VSS.n248 VSS.t533 0.135296
R3850 VSS.n249 VSS.t538 0.135296
R3851 VSS.n250 VSS.t543 0.135296
R3852 VSS.n251 VSS.t548 0.135296
R3853 VSS.n241 VSS.t508 0.135296
R3854 VSS.n238 VSS.t498 0.135296
R3855 VSS.n237 VSS.t493 0.135296
R3856 VSS.t78 VSS.t336 0.227075
R3857 VSS.t3028 VSS.t3030 0.226736
R3858 VSS.t3035 VSS.t3033 0.226736
R3859 VSS.t3038 VSS.t3040 0.226736
R3860 VSS.t3045 VSS.t3043 0.226736
R3861 VSS.t3048 VSS.t3050 0.226736
R3862 VSS.t3278 VSS.t3280 0.226736
R3863 VSS.t3285 VSS.t3283 0.226736
R3864 VSS.t3288 VSS.t3290 0.226736
R3865 VSS.t3295 VSS.t3293 0.226736
R3866 VSS.t3298 VSS.t3300 0.226736
R3867 VSS.t3305 VSS.t3303 0.226736
R3868 VSS.t3273 VSS.t3275 0.226736
R3869 VSS.t3268 VSS.t3270 0.226736
R3870 VSS.t3263 VSS.t3265 0.226736
R3871 VSS.t3258 VSS.t3260 0.226736
R3872 VSS.t3253 VSS.t3255 0.226736
R3873 VSS.t3248 VSS.t3250 0.226736
R3874 VSS.t3243 VSS.t3245 0.226736
R3875 VSS.t3238 VSS.t3240 0.226736
R3876 VSS.t3233 VSS.t3235 0.226736
R3877 VSS.t3228 VSS.t3230 0.226736
R3878 VSS.t3223 VSS.t3225 0.226736
R3879 VSS.t3218 VSS.t3220 0.226736
R3880 VSS.t3213 VSS.t3215 0.226736
R3881 VSS.t3208 VSS.t3210 0.226736
R3882 VSS.t3203 VSS.t3205 0.226736
R3883 VSS.t3198 VSS.t3200 0.226736
R3884 VSS.t3193 VSS.t3195 0.226736
R3885 VSS.t3188 VSS.t3190 0.226736
R3886 VSS.t3183 VSS.t3185 0.226736
R3887 VSS.t3178 VSS.t3180 0.226736
R3888 VSS.t3173 VSS.t3175 0.226736
R3889 VSS.t3163 VSS.t3165 0.226736
R3890 VSS.t3158 VSS.t3160 0.226736
R3891 VSS.t3153 VSS.t3155 0.226736
R3892 VSS.t3148 VSS.t3150 0.226736
R3893 VSS.t3143 VSS.t3145 0.226736
R3894 VSS.t3138 VSS.t3140 0.226736
R3895 VSS.t3133 VSS.t3135 0.226736
R3896 VSS.t3128 VSS.t3130 0.226736
R3897 VSS.t3123 VSS.t3125 0.226736
R3898 VSS.t3118 VSS.t3120 0.226736
R3899 VSS.t3113 VSS.t3115 0.226736
R3900 VSS.t3108 VSS.t3110 0.226736
R3901 VSS.t3103 VSS.t3105 0.226736
R3902 VSS.t3098 VSS.t3100 0.226736
R3903 VSS.t3093 VSS.t3095 0.226736
R3904 VSS.t3088 VSS.t3090 0.226736
R3905 VSS.t3083 VSS.t3085 0.226736
R3906 VSS.t3078 VSS.t3080 0.226736
R3907 VSS.t3073 VSS.t3075 0.226736
R3908 VSS.t3068 VSS.t3070 0.226736
R3909 VSS.t3063 VSS.t3065 0.226736
R3910 VSS.t3060 VSS.t3058 0.226736
R3911 VSS.t2365 VSS.t2363 0.226736
R3912 VSS.t2370 VSS.t2368 0.226736
R3913 VSS.t2375 VSS.t2373 0.226736
R3914 VSS.t2380 VSS.t2378 0.226736
R3915 VSS.t2385 VSS.t2383 0.226736
R3916 VSS.t2390 VSS.t2388 0.226736
R3917 VSS.t2395 VSS.t2393 0.226736
R3918 VSS.t2400 VSS.t2398 0.226736
R3919 VSS.t2405 VSS.t2403 0.226736
R3920 VSS.t2410 VSS.t2408 0.226736
R3921 VSS.t2415 VSS.t2413 0.226736
R3922 VSS.t2420 VSS.t2418 0.226736
R3923 VSS.t2425 VSS.t2423 0.226736
R3924 VSS.t2430 VSS.t2428 0.226736
R3925 VSS.t2435 VSS.t2433 0.226736
R3926 VSS.t2440 VSS.t2438 0.226736
R3927 VSS.t2445 VSS.t2443 0.226736
R3928 VSS.t2450 VSS.t2448 0.226736
R3929 VSS.t2455 VSS.t2453 0.226736
R3930 VSS.t2460 VSS.t2458 0.226736
R3931 VSS.t2465 VSS.t2463 0.226736
R3932 VSS.t2470 VSS.t2468 0.226736
R3933 VSS.t2475 VSS.t2473 0.226736
R3934 VSS.t2480 VSS.t2478 0.226736
R3935 VSS.t2485 VSS.t2483 0.226736
R3936 VSS.t2490 VSS.t2488 0.226736
R3937 VSS.t2495 VSS.t2493 0.226736
R3938 VSS.t2500 VSS.t2498 0.226736
R3939 VSS.t2508 VSS.t2510 0.226736
R3940 VSS.t2515 VSS.t2513 0.226736
R3941 VSS.t2518 VSS.t2520 0.226736
R3942 VSS.t2525 VSS.t2523 0.226736
R3943 VSS.t2528 VSS.t2530 0.226736
R3944 VSS.t2535 VSS.t2533 0.226736
R3945 VSS.t2538 VSS.t2540 0.226736
R3946 VSS.t2545 VSS.t2543 0.226736
R3947 VSS.t2548 VSS.t2550 0.226736
R3948 VSS.t2555 VSS.t2553 0.226736
R3949 VSS.t2558 VSS.t2560 0.226736
R3950 VSS.t2565 VSS.t2563 0.226736
R3951 VSS.t2568 VSS.t2570 0.226736
R3952 VSS.t2575 VSS.t2573 0.226736
R3953 VSS.t2578 VSS.t2580 0.226736
R3954 VSS.t2585 VSS.t2583 0.226736
R3955 VSS.t2588 VSS.t2590 0.226736
R3956 VSS.t2595 VSS.t2593 0.226736
R3957 VSS.t2598 VSS.t2600 0.226736
R3958 VSS.t2605 VSS.t2603 0.226736
R3959 VSS.t2608 VSS.t2610 0.226736
R3960 VSS.t2615 VSS.t2613 0.226736
R3961 VSS.t2618 VSS.t2620 0.226736
R3962 VSS.t2625 VSS.t2623 0.226736
R3963 VSS.t2628 VSS.t2630 0.226736
R3964 VSS.t2635 VSS.t2633 0.226736
R3965 VSS.t2638 VSS.t2640 0.226736
R3966 VSS.t1971 VSS.t1973 0.226736
R3967 VSS.t1978 VSS.t1976 0.226736
R3968 VSS.t1981 VSS.t1983 0.226736
R3969 VSS.t1988 VSS.t1986 0.226736
R3970 VSS.t1991 VSS.t1993 0.226736
R3971 VSS.t1998 VSS.t1996 0.226736
R3972 VSS.t2003 VSS.t2001 0.226736
R3973 VSS.t2006 VSS.t2008 0.226736
R3974 VSS.t2013 VSS.t2011 0.226736
R3975 VSS.t2016 VSS.t2018 0.226736
R3976 VSS.t2023 VSS.t2021 0.226736
R3977 VSS.t2026 VSS.t2028 0.226736
R3978 VSS.t2033 VSS.t2031 0.226736
R3979 VSS.t2036 VSS.t2038 0.226736
R3980 VSS.t2043 VSS.t2041 0.226736
R3981 VSS.t2046 VSS.t2048 0.226736
R3982 VSS.t2053 VSS.t2051 0.226736
R3983 VSS.t2056 VSS.t2058 0.226736
R3984 VSS.t2063 VSS.t2061 0.226736
R3985 VSS.t2066 VSS.t2068 0.226736
R3986 VSS.t2073 VSS.t2071 0.226736
R3987 VSS.t2076 VSS.t2078 0.226736
R3988 VSS.t2083 VSS.t2081 0.226736
R3989 VSS.t2086 VSS.t2088 0.226736
R3990 VSS.t2093 VSS.t2091 0.226736
R3991 VSS.t2096 VSS.t2098 0.226736
R3992 VSS.t2103 VSS.t2101 0.226736
R3993 VSS.t2106 VSS.t2108 0.226736
R3994 VSS.t2116 VSS.t2118 0.226736
R3995 VSS.t2123 VSS.t2121 0.226736
R3996 VSS.t2126 VSS.t2128 0.226736
R3997 VSS.t2133 VSS.t2131 0.226736
R3998 VSS.t2136 VSS.t2138 0.226736
R3999 VSS.t2143 VSS.t2141 0.226736
R4000 VSS.t2146 VSS.t2148 0.226736
R4001 VSS.t2153 VSS.t2151 0.226736
R4002 VSS.t2156 VSS.t2158 0.226736
R4003 VSS.t2163 VSS.t2161 0.226736
R4004 VSS.t2166 VSS.t2168 0.226736
R4005 VSS.t2173 VSS.t2171 0.226736
R4006 VSS.t2176 VSS.t2178 0.226736
R4007 VSS.t2183 VSS.t2181 0.226736
R4008 VSS.t2186 VSS.t2188 0.226736
R4009 VSS.t2193 VSS.t2191 0.226736
R4010 VSS.t2196 VSS.t2198 0.226736
R4011 VSS.t2203 VSS.t2201 0.226736
R4012 VSS.t2206 VSS.t2208 0.226736
R4013 VSS.t2213 VSS.t2211 0.226736
R4014 VSS.t2216 VSS.t2218 0.226736
R4015 VSS.t2223 VSS.t2221 0.226736
R4016 VSS.t2226 VSS.t2228 0.226736
R4017 VSS.t2233 VSS.t2231 0.226736
R4018 VSS.t2236 VSS.t2238 0.226736
R4019 VSS.t2243 VSS.t2241 0.226736
R4020 VSS.t2246 VSS.t2248 0.226736
R4021 VSS.t1579 VSS.t1581 0.226736
R4022 VSS.t1586 VSS.t1584 0.226736
R4023 VSS.t1589 VSS.t1591 0.226736
R4024 VSS.t1596 VSS.t1594 0.226736
R4025 VSS.t1599 VSS.t1601 0.226736
R4026 VSS.t1606 VSS.t1604 0.226736
R4027 VSS.t1609 VSS.t1611 0.226736
R4028 VSS.t1616 VSS.t1614 0.226736
R4029 VSS.t1619 VSS.t1621 0.226736
R4030 VSS.t1626 VSS.t1624 0.226736
R4031 VSS.t1629 VSS.t1631 0.226736
R4032 VSS.t1636 VSS.t1634 0.226736
R4033 VSS.t1639 VSS.t1641 0.226736
R4034 VSS.t1646 VSS.t1644 0.226736
R4035 VSS.t1649 VSS.t1651 0.226736
R4036 VSS.t1656 VSS.t1654 0.226736
R4037 VSS.t1659 VSS.t1661 0.226736
R4038 VSS.t1666 VSS.t1664 0.226736
R4039 VSS.t1669 VSS.t1671 0.226736
R4040 VSS.t1676 VSS.t1674 0.226736
R4041 VSS.t1679 VSS.t1681 0.226736
R4042 VSS.t1686 VSS.t1684 0.226736
R4043 VSS.t1689 VSS.t1691 0.226736
R4044 VSS.t1696 VSS.t1694 0.226736
R4045 VSS.t1699 VSS.t1701 0.226736
R4046 VSS.t1706 VSS.t1704 0.226736
R4047 VSS.t1709 VSS.t1711 0.226736
R4048 VSS.t1716 VSS.t1714 0.226736
R4049 VSS.t1726 VSS.t1724 0.226736
R4050 VSS.t1731 VSS.t1729 0.226736
R4051 VSS.t1736 VSS.t1734 0.226736
R4052 VSS.t1741 VSS.t1739 0.226736
R4053 VSS.t1746 VSS.t1744 0.226736
R4054 VSS.t1751 VSS.t1749 0.226736
R4055 VSS.t1756 VSS.t1754 0.226736
R4056 VSS.t1761 VSS.t1759 0.226736
R4057 VSS.t1766 VSS.t1764 0.226736
R4058 VSS.t1771 VSS.t1769 0.226736
R4059 VSS.t1776 VSS.t1774 0.226736
R4060 VSS.t1781 VSS.t1779 0.226736
R4061 VSS.t1786 VSS.t1784 0.226736
R4062 VSS.t1791 VSS.t1789 0.226736
R4063 VSS.t1796 VSS.t1794 0.226736
R4064 VSS.t1801 VSS.t1799 0.226736
R4065 VSS.t1806 VSS.t1804 0.226736
R4066 VSS.t1811 VSS.t1809 0.226736
R4067 VSS.t1816 VSS.t1814 0.226736
R4068 VSS.t1821 VSS.t1819 0.226736
R4069 VSS.t1826 VSS.t1824 0.226736
R4070 VSS.t1831 VSS.t1829 0.226736
R4071 VSS.t1836 VSS.t1834 0.226736
R4072 VSS.t1839 VSS.t1841 0.226736
R4073 VSS.t1846 VSS.t1844 0.226736
R4074 VSS.t1849 VSS.t1851 0.226736
R4075 VSS.t1856 VSS.t1854 0.226736
R4076 VSS.t900 VSS.t898 0.226736
R4077 VSS.t905 VSS.t903 0.226736
R4078 VSS.t910 VSS.t908 0.226736
R4079 VSS.t915 VSS.t913 0.226736
R4080 VSS.t920 VSS.t918 0.226736
R4081 VSS.t925 VSS.t923 0.226736
R4082 VSS.t930 VSS.t928 0.226736
R4083 VSS.t933 VSS.t935 0.226736
R4084 VSS.t940 VSS.t938 0.226736
R4085 VSS.t943 VSS.t945 0.226736
R4086 VSS.t950 VSS.t948 0.226736
R4087 VSS.t953 VSS.t955 0.226736
R4088 VSS.t960 VSS.t958 0.226736
R4089 VSS.t963 VSS.t965 0.226736
R4090 VSS.t970 VSS.t968 0.226736
R4091 VSS.t973 VSS.t975 0.226736
R4092 VSS.t980 VSS.t978 0.226736
R4093 VSS.t983 VSS.t985 0.226736
R4094 VSS.t990 VSS.t988 0.226736
R4095 VSS.t993 VSS.t995 0.226736
R4096 VSS.t1000 VSS.t998 0.226736
R4097 VSS.t1003 VSS.t1005 0.226736
R4098 VSS.t1010 VSS.t1008 0.226736
R4099 VSS.t1013 VSS.t1015 0.226736
R4100 VSS.t1020 VSS.t1018 0.226736
R4101 VSS.t1023 VSS.t1025 0.226736
R4102 VSS.t1030 VSS.t1028 0.226736
R4103 VSS.t1033 VSS.t1035 0.226736
R4104 VSS.t1043 VSS.t1045 0.226736
R4105 VSS.t1050 VSS.t1048 0.226736
R4106 VSS.t1053 VSS.t1055 0.226736
R4107 VSS.t1060 VSS.t1058 0.226736
R4108 VSS.t1063 VSS.t1065 0.226736
R4109 VSS.t1070 VSS.t1068 0.226736
R4110 VSS.t1073 VSS.t1075 0.226736
R4111 VSS.t1080 VSS.t1078 0.226736
R4112 VSS.t1083 VSS.t1085 0.226736
R4113 VSS.t1090 VSS.t1088 0.226736
R4114 VSS.t1093 VSS.t1095 0.226736
R4115 VSS.t1100 VSS.t1098 0.226736
R4116 VSS.t1103 VSS.t1105 0.226736
R4117 VSS.t1110 VSS.t1108 0.226736
R4118 VSS.t1113 VSS.t1115 0.226736
R4119 VSS.t1120 VSS.t1118 0.226736
R4120 VSS.t1123 VSS.t1125 0.226736
R4121 VSS.t1130 VSS.t1128 0.226736
R4122 VSS.t1133 VSS.t1135 0.226736
R4123 VSS.t1140 VSS.t1138 0.226736
R4124 VSS.t1143 VSS.t1145 0.226736
R4125 VSS.t1150 VSS.t1148 0.226736
R4126 VSS.t1153 VSS.t1155 0.226736
R4127 VSS.t1160 VSS.t1158 0.226736
R4128 VSS.t1163 VSS.t1165 0.226736
R4129 VSS.t1170 VSS.t1168 0.226736
R4130 VSS.t1173 VSS.t1175 0.226736
R4131 VSS.t861 VSS.t859 0.226736
R4132 VSS.t856 VSS.t854 0.226736
R4133 VSS.t582 VSS.t583 0.226736
R4134 VSS.t586 VSS.t585 0.226736
R4135 VSS.t589 VSS.t588 0.226736
R4136 VSS.t592 VSS.t591 0.226736
R4137 VSS.t595 VSS.t594 0.226736
R4138 VSS.t598 VSS.t597 0.226736
R4139 VSS.t601 VSS.t600 0.226736
R4140 VSS.t604 VSS.t603 0.226736
R4141 VSS.t607 VSS.t606 0.226736
R4142 VSS.t610 VSS.t609 0.226736
R4143 VSS.t616 VSS.t615 0.226736
R4144 VSS.t619 VSS.t618 0.226736
R4145 VSS.t622 VSS.t621 0.226736
R4146 VSS.t625 VSS.t624 0.226736
R4147 VSS.t572 VSS.t574 0.226736
R4148 VSS.t631 VSS.t180 0.226736
R4149 VSS.t36 VSS.t637 0.226736
R4150 VSS.t338 VSS.t831 0.226736
R4151 VSS.t303 VSS.t824 0.226736
R4152 VSS.t184 VSS.n123 0.219456
R4153 VSS.n829 VSS.t612 0.229319
R4154 VSS.t766 VSS.t764 0.224236
R4155 VSS.n681 VSS.t319 0.237966
R4156 VSS.n187 VSS.t3063 0.0863258
R4157 VSS.n188 VSS.t3068 0.0863258
R4158 VSS.n189 VSS.t3073 0.0863258
R4159 VSS.n190 VSS.t3078 0.0863258
R4160 VSS.n191 VSS.t3083 0.0863258
R4161 VSS.n192 VSS.t3088 0.0863258
R4162 VSS.n193 VSS.t3093 0.0863258
R4163 VSS.n194 VSS.t3098 0.0863258
R4164 VSS.n195 VSS.t3103 0.0863258
R4165 VSS.n196 VSS.t3108 0.0863258
R4166 VSS.n197 VSS.t3113 0.0863258
R4167 VSS.n198 VSS.t3118 0.0863258
R4168 VSS.n199 VSS.t3123 0.0863258
R4169 VSS.n200 VSS.t3128 0.0863258
R4170 VSS.n201 VSS.t3133 0.0863258
R4171 VSS.n202 VSS.t3138 0.0863258
R4172 VSS.n203 VSS.t3143 0.0863258
R4173 VSS.n204 VSS.t3148 0.0863258
R4174 VSS.n205 VSS.t3153 0.0863258
R4175 VSS.n206 VSS.t3158 0.0863258
R4176 VSS.n207 VSS.t3163 0.0863258
R4177 VSS.n209 VSS.t3173 0.0863258
R4178 VSS.n210 VSS.t3178 0.0863258
R4179 VSS.n211 VSS.t3183 0.0863258
R4180 VSS.n212 VSS.t3188 0.0863258
R4181 VSS.n213 VSS.t3193 0.0863258
R4182 VSS.n214 VSS.t3198 0.0863258
R4183 VSS.n215 VSS.t3203 0.0863258
R4184 VSS.n216 VSS.t3208 0.0863258
R4185 VSS.n217 VSS.t3213 0.0863258
R4186 VSS.n218 VSS.t3218 0.0863258
R4187 VSS.n219 VSS.t3223 0.0863258
R4188 VSS.n220 VSS.t3228 0.0863258
R4189 VSS.n221 VSS.t3233 0.0863258
R4190 VSS.n222 VSS.t3238 0.0863258
R4191 VSS.n223 VSS.t3243 0.0863258
R4192 VSS.n224 VSS.t3248 0.0863258
R4193 VSS.n225 VSS.t3253 0.0863258
R4194 VSS.n226 VSS.t3258 0.0863258
R4195 VSS.n227 VSS.t3263 0.0863258
R4196 VSS.n228 VSS.t3268 0.0863258
R4197 VSS.n229 VSS.t3273 0.0863258
R4198 VSS.n230 VSS.t3278 0.0863258
R4199 VSS.n291 VSS.t2508 0.0863258
R4200 VSS.n293 VSS.t2518 0.0863258
R4201 VSS.n295 VSS.t2528 0.0863258
R4202 VSS.n297 VSS.t2538 0.0863258
R4203 VSS.n299 VSS.t2548 0.0863258
R4204 VSS.n301 VSS.t2558 0.0863258
R4205 VSS.n303 VSS.t2568 0.0863258
R4206 VSS.n305 VSS.t2578 0.0863258
R4207 VSS.n307 VSS.t2588 0.0863258
R4208 VSS.n309 VSS.t2598 0.0863258
R4209 VSS.n311 VSS.t2608 0.0863258
R4210 VSS.n313 VSS.t2618 0.0863258
R4211 VSS.n315 VSS.t2628 0.0863258
R4212 VSS.n317 VSS.t2638 0.0863258
R4213 VSS.t2633 VSS.n316 0.0863258
R4214 VSS.t2623 VSS.n314 0.0863258
R4215 VSS.t2613 VSS.n312 0.0863258
R4216 VSS.t2603 VSS.n310 0.0863258
R4217 VSS.t2593 VSS.n308 0.0863258
R4218 VSS.t2583 VSS.n306 0.0863258
R4219 VSS.t2573 VSS.n304 0.0863258
R4220 VSS.t2563 VSS.n302 0.0863258
R4221 VSS.t2553 VSS.n300 0.0863258
R4222 VSS.t2543 VSS.n298 0.0863258
R4223 VSS.t2533 VSS.n296 0.0863258
R4224 VSS.t2523 VSS.n294 0.0863258
R4225 VSS.t2513 VSS.n292 0.0863258
R4226 VSS.t2498 VSS.n289 0.0863258
R4227 VSS.n262 VSS.t2362 0.130189
R4228 VSS.t2368 VSS.n263 0.0863258
R4229 VSS.t2373 VSS.n264 0.0863258
R4230 VSS.t2378 VSS.n265 0.0863258
R4231 VSS.t2383 VSS.n266 0.0863258
R4232 VSS.t2388 VSS.n267 0.0863258
R4233 VSS.n325 VSS.t2006 0.0863258
R4234 VSS.n327 VSS.t2016 0.0863258
R4235 VSS.n329 VSS.t2026 0.0863258
R4236 VSS.n331 VSS.t2036 0.0863258
R4237 VSS.n333 VSS.t2046 0.0863258
R4238 VSS.n335 VSS.t2056 0.0863258
R4239 VSS.n337 VSS.t2066 0.0863258
R4240 VSS.n339 VSS.t2076 0.0863258
R4241 VSS.n341 VSS.t2086 0.0863258
R4242 VSS.n343 VSS.t2096 0.0863258
R4243 VSS.n345 VSS.t2106 0.0863258
R4244 VSS.n347 VSS.t2116 0.0863258
R4245 VSS.n349 VSS.t2126 0.0863258
R4246 VSS.n351 VSS.t2136 0.0863258
R4247 VSS.n353 VSS.t2146 0.0863258
R4248 VSS.n355 VSS.t2156 0.0863258
R4249 VSS.n357 VSS.t2166 0.0863258
R4250 VSS.n359 VSS.t2176 0.0863258
R4251 VSS.n361 VSS.t2186 0.0863258
R4252 VSS.n363 VSS.t2196 0.0863258
R4253 VSS.n365 VSS.t2206 0.0863258
R4254 VSS.n367 VSS.t2216 0.0863258
R4255 VSS.n426 VSS.t1839 0.0863258
R4256 VSS.n428 VSS.t1849 0.0863258
R4257 VSS.t1854 VSS.n429 0.0863258
R4258 VSS.t1844 VSS.n427 0.0863258
R4259 VSS.t1834 VSS.n425 0.0863258
R4260 VSS.n616 VSS.t933 0.0863258
R4261 VSS.n618 VSS.t943 0.0863258
R4262 VSS.n620 VSS.t953 0.0863258
R4263 VSS.n622 VSS.t963 0.0863258
R4264 VSS.n624 VSS.t973 0.0863258
R4265 VSS.n626 VSS.t983 0.0863258
R4266 VSS.n628 VSS.t993 0.0863258
R4267 VSS.n630 VSS.t1003 0.0863258
R4268 VSS.n632 VSS.t1013 0.0863258
R4269 VSS.n634 VSS.t1023 0.0863258
R4270 VSS.n636 VSS.t1033 0.0863258
R4271 VSS.n638 VSS.t1043 0.0863258
R4272 VSS.n640 VSS.t1053 0.0863258
R4273 VSS.n642 VSS.t1063 0.0863258
R4274 VSS.n644 VSS.t1073 0.0863258
R4275 VSS.n646 VSS.t1083 0.0863258
R4276 VSS.n648 VSS.t1093 0.0863258
R4277 VSS.n650 VSS.t1103 0.0863258
R4278 VSS.n652 VSS.t1113 0.0863258
R4279 VSS.n654 VSS.t1123 0.0863258
R4280 VSS.n656 VSS.t1133 0.0863258
R4281 VSS.n658 VSS.t1143 0.0863258
R4282 VSS.t854 VSS.n700 0.0863258
R4283 VSS.n818 VSS.t582 0.0863258
R4284 VSS.n833 VSS.t624 0.0863258
R4285 VSS.n832 VSS.t621 0.0863258
R4286 VSS.n831 VSS.t618 0.0863258
R4287 VSS.n830 VSS.t615 0.0863258
R4288 VSS.n827 VSS.t609 0.0863258
R4289 VSS.n826 VSS.t606 0.0863258
R4290 VSS.n825 VSS.t603 0.0863258
R4291 VSS.n824 VSS.t600 0.0863258
R4292 VSS.n823 VSS.t597 0.0863258
R4293 VSS.n822 VSS.t594 0.0863258
R4294 VSS.n821 VSS.t591 0.0863258
R4295 VSS.n820 VSS.t588 0.0863258
R4296 VSS.t585 VSS.n819 0.0863258
R4297 VSS.t831 VSS.n675 0.0863258
R4298 VSS.n668 VSS.t430 0.130189
R4299 VSS.t571 VSS.n841 0.130189
R4300 VSS.n843 VSS.t213 0.130189
R4301 VSS.t637 VSS.n836 0.0863258
R4302 VSS.t859 VSS.n701 0.0863258
R4303 VSS.n660 VSS.t1153 0.0863258
R4304 VSS.n662 VSS.t1163 0.0863258
R4305 VSS.n664 VSS.t1173 0.0863258
R4306 VSS.t1168 VSS.n663 0.0863258
R4307 VSS.t1158 VSS.n661 0.0863258
R4308 VSS.t1148 VSS.n659 0.0863258
R4309 VSS.t1138 VSS.n657 0.0863258
R4310 VSS.t1128 VSS.n655 0.0863258
R4311 VSS.t1118 VSS.n653 0.0863258
R4312 VSS.t1108 VSS.n651 0.0863258
R4313 VSS.t1098 VSS.n649 0.0863258
R4314 VSS.t1088 VSS.n647 0.0863258
R4315 VSS.t1078 VSS.n645 0.0863258
R4316 VSS.t1068 VSS.n643 0.0863258
R4317 VSS.t1058 VSS.n641 0.0863258
R4318 VSS.t1048 VSS.n639 0.0863258
R4319 VSS.t1028 VSS.n635 0.0863258
R4320 VSS.t1018 VSS.n633 0.0863258
R4321 VSS.t1008 VSS.n631 0.0863258
R4322 VSS.t998 VSS.n629 0.0863258
R4323 VSS.t988 VSS.n627 0.0863258
R4324 VSS.t978 VSS.n625 0.0863258
R4325 VSS.t968 VSS.n623 0.0863258
R4326 VSS.t958 VSS.n621 0.0863258
R4327 VSS.t948 VSS.n619 0.0863258
R4328 VSS.t938 VSS.n617 0.0863258
R4329 VSS.t928 VSS.n615 0.0863258
R4330 VSS.n609 VSS.t897 0.130189
R4331 VSS.t903 VSS.n610 0.0863258
R4332 VSS.t908 VSS.n611 0.0863258
R4333 VSS.t913 VSS.n612 0.0863258
R4334 VSS.t918 VSS.n613 0.0863258
R4335 VSS.t923 VSS.n614 0.0863258
R4336 VSS.t1970 VSS.n318 0.130189
R4337 VSS.n320 VSS.t1981 0.0863258
R4338 VSS.n322 VSS.t1991 0.0863258
R4339 VSS.t1986 VSS.n321 0.0863258
R4340 VSS.t1976 VSS.n319 0.0863258
R4341 VSS.t1578 VSS.n374 0.130189
R4342 VSS.n376 VSS.t1589 0.0863258
R4343 VSS.n378 VSS.t1599 0.0863258
R4344 VSS.n380 VSS.t1609 0.0863258
R4345 VSS.n382 VSS.t1619 0.0863258
R4346 VSS.n384 VSS.t1629 0.0863258
R4347 VSS.n386 VSS.t1639 0.0863258
R4348 VSS.n388 VSS.t1649 0.0863258
R4349 VSS.n390 VSS.t1659 0.0863258
R4350 VSS.n392 VSS.t1669 0.0863258
R4351 VSS.n394 VSS.t1679 0.0863258
R4352 VSS.n396 VSS.t1689 0.0863258
R4353 VSS.n398 VSS.t1699 0.0863258
R4354 VSS.n400 VSS.t1709 0.0863258
R4355 VSS.t1714 VSS.n401 0.0863258
R4356 VSS.t1704 VSS.n399 0.0863258
R4357 VSS.t1694 VSS.n397 0.0863258
R4358 VSS.t1684 VSS.n395 0.0863258
R4359 VSS.t1674 VSS.n393 0.0863258
R4360 VSS.t1664 VSS.n391 0.0863258
R4361 VSS.t1654 VSS.n389 0.0863258
R4362 VSS.t1644 VSS.n387 0.0863258
R4363 VSS.t1634 VSS.n385 0.0863258
R4364 VSS.t1624 VSS.n383 0.0863258
R4365 VSS.t1614 VSS.n381 0.0863258
R4366 VSS.t1604 VSS.n379 0.0863258
R4367 VSS.t1594 VSS.n377 0.0863258
R4368 VSS.t1584 VSS.n375 0.0863258
R4369 VSS.t1724 VSS.n403 0.0863258
R4370 VSS.t1729 VSS.n404 0.0863258
R4371 VSS.t1734 VSS.n405 0.0863258
R4372 VSS.t1739 VSS.n406 0.0863258
R4373 VSS.t1744 VSS.n407 0.0863258
R4374 VSS.t1749 VSS.n408 0.0863258
R4375 VSS.t1754 VSS.n409 0.0863258
R4376 VSS.t1759 VSS.n410 0.0863258
R4377 VSS.t1764 VSS.n411 0.0863258
R4378 VSS.t1769 VSS.n412 0.0863258
R4379 VSS.t1774 VSS.n413 0.0863258
R4380 VSS.t1779 VSS.n414 0.0863258
R4381 VSS.t1784 VSS.n415 0.0863258
R4382 VSS.t1789 VSS.n416 0.0863258
R4383 VSS.t1794 VSS.n417 0.0863258
R4384 VSS.t1799 VSS.n418 0.0863258
R4385 VSS.t1804 VSS.n419 0.0863258
R4386 VSS.t1809 VSS.n420 0.0863258
R4387 VSS.t1814 VSS.n421 0.0863258
R4388 VSS.t1819 VSS.n422 0.0863258
R4389 VSS.t1824 VSS.n423 0.0863258
R4390 VSS.t1829 VSS.n424 0.0863258
R4391 VSS.n369 VSS.t2226 0.0863258
R4392 VSS.n371 VSS.t2236 0.0863258
R4393 VSS.n373 VSS.t2246 0.0863258
R4394 VSS.t2241 VSS.n372 0.0863258
R4395 VSS.t2231 VSS.n370 0.0863258
R4396 VSS.t2221 VSS.n368 0.0863258
R4397 VSS.t2211 VSS.n366 0.0863258
R4398 VSS.t2201 VSS.n364 0.0863258
R4399 VSS.t2191 VSS.n362 0.0863258
R4400 VSS.t2181 VSS.n360 0.0863258
R4401 VSS.t2171 VSS.n358 0.0863258
R4402 VSS.t2161 VSS.n356 0.0863258
R4403 VSS.t2151 VSS.n354 0.0863258
R4404 VSS.t2141 VSS.n352 0.0863258
R4405 VSS.t2131 VSS.n350 0.0863258
R4406 VSS.t2121 VSS.n348 0.0863258
R4407 VSS.t2101 VSS.n344 0.0863258
R4408 VSS.t2091 VSS.n342 0.0863258
R4409 VSS.t2081 VSS.n340 0.0863258
R4410 VSS.t2071 VSS.n338 0.0863258
R4411 VSS.t2061 VSS.n336 0.0863258
R4412 VSS.t2051 VSS.n334 0.0863258
R4413 VSS.t2041 VSS.n332 0.0863258
R4414 VSS.t2031 VSS.n330 0.0863258
R4415 VSS.t2021 VSS.n328 0.0863258
R4416 VSS.t2011 VSS.n326 0.0863258
R4417 VSS.t2001 VSS.n324 0.0863258
R4418 VSS.n323 VSS.t1996 0.0863258
R4419 VSS.t2393 VSS.n268 0.0863258
R4420 VSS.t2398 VSS.n269 0.0863258
R4421 VSS.t2403 VSS.n270 0.0863258
R4422 VSS.t2408 VSS.n271 0.0863258
R4423 VSS.t2413 VSS.n272 0.0863258
R4424 VSS.t2418 VSS.n273 0.0863258
R4425 VSS.t2423 VSS.n274 0.0863258
R4426 VSS.t2428 VSS.n275 0.0863258
R4427 VSS.t2433 VSS.n276 0.0863258
R4428 VSS.t2438 VSS.n277 0.0863258
R4429 VSS.t2443 VSS.n278 0.0863258
R4430 VSS.t2448 VSS.n279 0.0863258
R4431 VSS.t2453 VSS.n280 0.0863258
R4432 VSS.t2458 VSS.n281 0.0863258
R4433 VSS.t2463 VSS.n282 0.0863258
R4434 VSS.t2468 VSS.n283 0.0863258
R4435 VSS.t2473 VSS.n284 0.0863258
R4436 VSS.t2478 VSS.n285 0.0863258
R4437 VSS.t2483 VSS.n286 0.0863258
R4438 VSS.t2488 VSS.n287 0.0863258
R4439 VSS.t2493 VSS.n288 0.0863258
R4440 VSS.t3027 VSS.n180 0.130189
R4441 VSS.n182 VSS.t3038 0.0863258
R4442 VSS.n184 VSS.t3048 0.0863258
R4443 VSS.t3043 VSS.n183 0.0863258
R4444 VSS.t3033 VSS.n181 0.0863258
R4445 VSS.n232 VSS.t3288 0.0863258
R4446 VSS.n234 VSS.t3298 0.0863258
R4447 VSS.t3303 VSS.n235 0.0863258
R4448 VSS.t3293 VSS.n233 0.0863258
R4449 VSS.t3283 VSS.n231 0.0863258
R4450 VSS.t3058 VSS.n186 0.0863258
R4451 VSS.t450 VSS.t449 0.217986
R4452 VSS.t445 VSS.t444 0.217986
R4453 VSS.n679 VSS.t834 0.0861948
R4454 VSS.t511 VSS.t510 0.217986
R4455 VSS.t516 VSS.t515 0.217986
R4456 VSS.t88 VSS.t521 0.217986
R4457 VSS.t526 VSS.t525 0.217986
R4458 VSS.t531 VSS.t530 0.217986
R4459 VSS.t536 VSS.t535 0.217986
R4460 VSS.t541 VSS.t540 0.217986
R4461 VSS.t546 VSS.t545 0.217986
R4462 VSS.t506 VSS.t231 0.217986
R4463 VSS.t496 VSS.t495 0.217986
R4464 VSS.t491 VSS.t490 0.217986
R4465 VSS.n684 VSS.t336 0.0861948
R4466 VSS.n812 VSS.t290 0.060572
R4467 VSS.t2962 VSS.t2833 0.210825
R4468 VSS.t1289 VSS.t312 0.209938
R4469 VSS.t481 VSS.t486 0.205117
R4470 VSS.t81 VSS.t245 0.204291
R4471 VSS.t81 VSS.t553 0.195153
R4472 VSS.n502 VSS.t1462 0.120486
R4473 VSS.t580 VSS.t66 0.178261
R4474 VSS.t2507 VSS.t2505 0.168986
R4475 VSS.t2115 VSS.t2113 0.168986
R4476 VSS.t1723 VSS.t1721 0.168986
R4477 VSS.t1042 VSS.t1040 0.168986
R4478 VSS.t54 VSS.t702 0.168115
R4479 VSS.n178 VSS.t3168 0.083315
R4480 VSS.t2905 VSS.t2906 0.167039
R4481 VSS.t503 VSS.n239 0.0836055
R4482 VSS.t81 VSS.t471 0.166911
R4483 VSS.t81 VSS.t481 0.165378
R4484 VSS.t895 VSS.n767 0.0647427
R4485 VSS.n834 VSS.t627 0.0647427
R4486 VSS.t760 VSS.n750 0.0793054
R4487 VSS.t2767 VSS.t2768 0.150825
R4488 VSS.n871 VSS.t764 0.150825
R4489 VSS.t1435 VSS.t1436 0.150825
R4490 VSS.t648 VSS.t368 0.150789
R4491 VSS.t501 VSS.n906 0.150789
R4492 VSS.n871 VSS.t763 0.150789
R4493 VSS.t1565 VSS.t1435 0.150789
R4494 VSS.n856 VSS.t1370 0.150789
R4495 VSS.t2917 VSS.t2767 0.150789
R4496 VSS.t2892 VSS.t3015 0.150789
R4497 VSS.t3168 VSS.n849 0.150789
R4498 VSS.n840 VSS.t436 0.0735143
R4499 VSS.t3055 VSS.t3053 0.135506
R4500 VSS.t681 VSS.t702 0.13091
R4501 VSS.t613 VSS.n133 0.0362711
R4502 VSS.t174 VSS.n1098 0.10425
R4503 VSS.t681 VSS.t712 0.0997021
R4504 VSS.t500 VSS.n125 0.0333775
R4505 VSS.t2832 VSS.t2962 0.090789
R4506 VSS.t1370 VSS.n857 0.090789
R4507 VSS.t648 VSS.t436 0.090789
R4508 VSS.t455 VSS.n177 0.155751
R4509 VSS.t1305 VSS.t1462 0.0905
R4510 VSS.t550 VSS.t90 0.08675
R4511 VSS.t3030 VSS.t3032 0.0855
R4512 VSS.t3037 VSS.t3035 0.0855
R4513 VSS.t3040 VSS.t3042 0.0855
R4514 VSS.t3047 VSS.t3045 0.0855
R4515 VSS.t3050 VSS.t3052 0.0855
R4516 VSS.t523 VSS.t525 0.0855
R4517 VSS.t528 VSS.t530 0.0855
R4518 VSS.t533 VSS.t535 0.0855
R4519 VSS.t538 VSS.t540 0.0855
R4520 VSS.t543 VSS.t545 0.0855
R4521 VSS.t3280 VSS.t3282 0.0855
R4522 VSS.t3287 VSS.t3285 0.0855
R4523 VSS.t3290 VSS.t3292 0.0855
R4524 VSS.t3297 VSS.t3295 0.0855
R4525 VSS.t3300 VSS.t3302 0.0855
R4526 VSS.t3275 VSS.t3277 0.0855
R4527 VSS.t3270 VSS.t3272 0.0855
R4528 VSS.t3265 VSS.t3267 0.0855
R4529 VSS.t3260 VSS.t3262 0.0855
R4530 VSS.t3255 VSS.t3257 0.0855
R4531 VSS.t3250 VSS.t3252 0.0855
R4532 VSS.t3245 VSS.t3247 0.0855
R4533 VSS.t3240 VSS.t3242 0.0855
R4534 VSS.t3235 VSS.t3237 0.0855
R4535 VSS.t3230 VSS.t3232 0.0855
R4536 VSS.t3225 VSS.t3227 0.0855
R4537 VSS.t3220 VSS.t3222 0.0855
R4538 VSS.t3215 VSS.t3217 0.0855
R4539 VSS.t3210 VSS.t3212 0.0855
R4540 VSS.t3205 VSS.t3207 0.0855
R4541 VSS.t3200 VSS.t3202 0.0855
R4542 VSS.t3195 VSS.t3197 0.0855
R4543 VSS.t3190 VSS.t3192 0.0855
R4544 VSS.t3185 VSS.t3187 0.0855
R4545 VSS.t3180 VSS.t3182 0.0855
R4546 VSS.t3175 VSS.t3177 0.0855
R4547 VSS.t3172 VSS.t3170 0.0855
R4548 VSS.t3165 VSS.t3167 0.0855
R4549 VSS.t3160 VSS.t3162 0.0855
R4550 VSS.t3155 VSS.t3157 0.0855
R4551 VSS.t3150 VSS.t3152 0.0855
R4552 VSS.t3145 VSS.t3147 0.0855
R4553 VSS.t3140 VSS.t3142 0.0855
R4554 VSS.t3135 VSS.t3137 0.0855
R4555 VSS.t3130 VSS.t3132 0.0855
R4556 VSS.t3125 VSS.t3127 0.0855
R4557 VSS.t3120 VSS.t3122 0.0855
R4558 VSS.t3115 VSS.t3117 0.0855
R4559 VSS.t3110 VSS.t3112 0.0855
R4560 VSS.t3105 VSS.t3107 0.0855
R4561 VSS.t3100 VSS.t3102 0.0855
R4562 VSS.t3095 VSS.t3097 0.0855
R4563 VSS.t3090 VSS.t3092 0.0855
R4564 VSS.t3085 VSS.t3087 0.0855
R4565 VSS.t3080 VSS.t3082 0.0855
R4566 VSS.t3075 VSS.t3077 0.0855
R4567 VSS.t3070 VSS.t3072 0.0855
R4568 VSS.t3065 VSS.t3067 0.0855
R4569 VSS.t3062 VSS.t3060 0.0855
R4570 VSS.t3055 VSS.t3057 0.0855
R4571 VSS.t2367 VSS.t2365 0.0855
R4572 VSS.t2372 VSS.t2370 0.0855
R4573 VSS.t2377 VSS.t2375 0.0855
R4574 VSS.t2382 VSS.t2380 0.0855
R4575 VSS.t2387 VSS.t2385 0.0855
R4576 VSS.t2392 VSS.t2390 0.0855
R4577 VSS.t2397 VSS.t2395 0.0855
R4578 VSS.t2402 VSS.t2400 0.0855
R4579 VSS.t2407 VSS.t2405 0.0855
R4580 VSS.t2412 VSS.t2410 0.0855
R4581 VSS.t2417 VSS.t2415 0.0855
R4582 VSS.t2422 VSS.t2420 0.0855
R4583 VSS.t2427 VSS.t2425 0.0855
R4584 VSS.t2432 VSS.t2430 0.0855
R4585 VSS.t2437 VSS.t2435 0.0855
R4586 VSS.t2442 VSS.t2440 0.0855
R4587 VSS.t2447 VSS.t2445 0.0855
R4588 VSS.t2452 VSS.t2450 0.0855
R4589 VSS.t2457 VSS.t2455 0.0855
R4590 VSS.t2462 VSS.t2460 0.0855
R4591 VSS.t2467 VSS.t2465 0.0855
R4592 VSS.t2472 VSS.t2470 0.0855
R4593 VSS.t2477 VSS.t2475 0.0855
R4594 VSS.t2482 VSS.t2480 0.0855
R4595 VSS.t2487 VSS.t2485 0.0855
R4596 VSS.t2492 VSS.t2490 0.0855
R4597 VSS.t2497 VSS.t2495 0.0855
R4598 VSS.t2500 VSS.t2502 0.0855
R4599 VSS.t2510 VSS.t2512 0.0855
R4600 VSS.t2517 VSS.t2515 0.0855
R4601 VSS.t2520 VSS.t2522 0.0855
R4602 VSS.t2527 VSS.t2525 0.0855
R4603 VSS.t2530 VSS.t2532 0.0855
R4604 VSS.t2537 VSS.t2535 0.0855
R4605 VSS.t2540 VSS.t2542 0.0855
R4606 VSS.t2547 VSS.t2545 0.0855
R4607 VSS.t2550 VSS.t2552 0.0855
R4608 VSS.t2557 VSS.t2555 0.0855
R4609 VSS.t2560 VSS.t2562 0.0855
R4610 VSS.t2567 VSS.t2565 0.0855
R4611 VSS.t2570 VSS.t2572 0.0855
R4612 VSS.t2577 VSS.t2575 0.0855
R4613 VSS.t2580 VSS.t2582 0.0855
R4614 VSS.t2587 VSS.t2585 0.0855
R4615 VSS.t2590 VSS.t2592 0.0855
R4616 VSS.t2597 VSS.t2595 0.0855
R4617 VSS.t2600 VSS.t2602 0.0855
R4618 VSS.t2607 VSS.t2605 0.0855
R4619 VSS.t2610 VSS.t2612 0.0855
R4620 VSS.t2617 VSS.t2615 0.0855
R4621 VSS.t2620 VSS.t2622 0.0855
R4622 VSS.t2627 VSS.t2625 0.0855
R4623 VSS.t2630 VSS.t2632 0.0855
R4624 VSS.t2637 VSS.t2635 0.0855
R4625 VSS.t1973 VSS.t1975 0.0855
R4626 VSS.t1980 VSS.t1978 0.0855
R4627 VSS.t1983 VSS.t1985 0.0855
R4628 VSS.t1990 VSS.t1988 0.0855
R4629 VSS.t1993 VSS.t1995 0.0855
R4630 VSS.t1998 VSS.t2000 0.0855
R4631 VSS.t2005 VSS.t2003 0.0855
R4632 VSS.t2008 VSS.t2010 0.0855
R4633 VSS.t2015 VSS.t2013 0.0855
R4634 VSS.t2018 VSS.t2020 0.0855
R4635 VSS.t2025 VSS.t2023 0.0855
R4636 VSS.t2028 VSS.t2030 0.0855
R4637 VSS.t2035 VSS.t2033 0.0855
R4638 VSS.t2038 VSS.t2040 0.0855
R4639 VSS.t2045 VSS.t2043 0.0855
R4640 VSS.t2048 VSS.t2050 0.0855
R4641 VSS.t2055 VSS.t2053 0.0855
R4642 VSS.t2058 VSS.t2060 0.0855
R4643 VSS.t2065 VSS.t2063 0.0855
R4644 VSS.t2068 VSS.t2070 0.0855
R4645 VSS.t2075 VSS.t2073 0.0855
R4646 VSS.t2078 VSS.t2080 0.0855
R4647 VSS.t2085 VSS.t2083 0.0855
R4648 VSS.t2088 VSS.t2090 0.0855
R4649 VSS.t2095 VSS.t2093 0.0855
R4650 VSS.t2098 VSS.t2100 0.0855
R4651 VSS.t2105 VSS.t2103 0.0855
R4652 VSS.t2108 VSS.t2110 0.0855
R4653 VSS.t2118 VSS.t2120 0.0855
R4654 VSS.t2125 VSS.t2123 0.0855
R4655 VSS.t2128 VSS.t2130 0.0855
R4656 VSS.t2135 VSS.t2133 0.0855
R4657 VSS.t2138 VSS.t2140 0.0855
R4658 VSS.t2145 VSS.t2143 0.0855
R4659 VSS.t2148 VSS.t2150 0.0855
R4660 VSS.t2155 VSS.t2153 0.0855
R4661 VSS.t2158 VSS.t2160 0.0855
R4662 VSS.t2165 VSS.t2163 0.0855
R4663 VSS.t2168 VSS.t2170 0.0855
R4664 VSS.t2175 VSS.t2173 0.0855
R4665 VSS.t2178 VSS.t2180 0.0855
R4666 VSS.t2185 VSS.t2183 0.0855
R4667 VSS.t2188 VSS.t2190 0.0855
R4668 VSS.t2195 VSS.t2193 0.0855
R4669 VSS.t2198 VSS.t2200 0.0855
R4670 VSS.t2205 VSS.t2203 0.0855
R4671 VSS.t2208 VSS.t2210 0.0855
R4672 VSS.t2215 VSS.t2213 0.0855
R4673 VSS.t2218 VSS.t2220 0.0855
R4674 VSS.t2225 VSS.t2223 0.0855
R4675 VSS.t2228 VSS.t2230 0.0855
R4676 VSS.t2235 VSS.t2233 0.0855
R4677 VSS.t2238 VSS.t2240 0.0855
R4678 VSS.t2245 VSS.t2243 0.0855
R4679 VSS.t1581 VSS.t1583 0.0855
R4680 VSS.t1588 VSS.t1586 0.0855
R4681 VSS.t1591 VSS.t1593 0.0855
R4682 VSS.t1598 VSS.t1596 0.0855
R4683 VSS.t1601 VSS.t1603 0.0855
R4684 VSS.t1608 VSS.t1606 0.0855
R4685 VSS.t1611 VSS.t1613 0.0855
R4686 VSS.t1618 VSS.t1616 0.0855
R4687 VSS.t1621 VSS.t1623 0.0855
R4688 VSS.t1628 VSS.t1626 0.0855
R4689 VSS.t1631 VSS.t1633 0.0855
R4690 VSS.t1638 VSS.t1636 0.0855
R4691 VSS.t1641 VSS.t1643 0.0855
R4692 VSS.t1648 VSS.t1646 0.0855
R4693 VSS.t1651 VSS.t1653 0.0855
R4694 VSS.t1658 VSS.t1656 0.0855
R4695 VSS.t1661 VSS.t1663 0.0855
R4696 VSS.t1668 VSS.t1666 0.0855
R4697 VSS.t1671 VSS.t1673 0.0855
R4698 VSS.t1678 VSS.t1676 0.0855
R4699 VSS.t1681 VSS.t1683 0.0855
R4700 VSS.t1688 VSS.t1686 0.0855
R4701 VSS.t1691 VSS.t1693 0.0855
R4702 VSS.t1698 VSS.t1696 0.0855
R4703 VSS.t1701 VSS.t1703 0.0855
R4704 VSS.t1708 VSS.t1706 0.0855
R4705 VSS.t1711 VSS.t1713 0.0855
R4706 VSS.t1718 VSS.t1716 0.0855
R4707 VSS.t1728 VSS.t1726 0.0855
R4708 VSS.t1733 VSS.t1731 0.0855
R4709 VSS.t1738 VSS.t1736 0.0855
R4710 VSS.t1743 VSS.t1741 0.0855
R4711 VSS.t1748 VSS.t1746 0.0855
R4712 VSS.t1753 VSS.t1751 0.0855
R4713 VSS.t1758 VSS.t1756 0.0855
R4714 VSS.t1763 VSS.t1761 0.0855
R4715 VSS.t1768 VSS.t1766 0.0855
R4716 VSS.t1773 VSS.t1771 0.0855
R4717 VSS.t1778 VSS.t1776 0.0855
R4718 VSS.t1783 VSS.t1781 0.0855
R4719 VSS.t1788 VSS.t1786 0.0855
R4720 VSS.t1793 VSS.t1791 0.0855
R4721 VSS.t1798 VSS.t1796 0.0855
R4722 VSS.t1803 VSS.t1801 0.0855
R4723 VSS.t1808 VSS.t1806 0.0855
R4724 VSS.t1813 VSS.t1811 0.0855
R4725 VSS.t1818 VSS.t1816 0.0855
R4726 VSS.t1823 VSS.t1821 0.0855
R4727 VSS.t1828 VSS.t1826 0.0855
R4728 VSS.t1831 VSS.t1833 0.0855
R4729 VSS.t1838 VSS.t1836 0.0855
R4730 VSS.t1841 VSS.t1843 0.0855
R4731 VSS.t1848 VSS.t1846 0.0855
R4732 VSS.t1851 VSS.t1853 0.0855
R4733 VSS.t902 VSS.t900 0.0855
R4734 VSS.t907 VSS.t905 0.0855
R4735 VSS.t912 VSS.t910 0.0855
R4736 VSS.t917 VSS.t915 0.0855
R4737 VSS.t922 VSS.t920 0.0855
R4738 VSS.t925 VSS.t927 0.0855
R4739 VSS.t932 VSS.t930 0.0855
R4740 VSS.t935 VSS.t937 0.0855
R4741 VSS.t942 VSS.t940 0.0855
R4742 VSS.t945 VSS.t947 0.0855
R4743 VSS.t952 VSS.t950 0.0855
R4744 VSS.t955 VSS.t957 0.0855
R4745 VSS.t962 VSS.t960 0.0855
R4746 VSS.t965 VSS.t967 0.0855
R4747 VSS.t972 VSS.t970 0.0855
R4748 VSS.t975 VSS.t977 0.0855
R4749 VSS.t982 VSS.t980 0.0855
R4750 VSS.t985 VSS.t987 0.0855
R4751 VSS.t992 VSS.t990 0.0855
R4752 VSS.t995 VSS.t997 0.0855
R4753 VSS.t1002 VSS.t1000 0.0855
R4754 VSS.t1005 VSS.t1007 0.0855
R4755 VSS.t1012 VSS.t1010 0.0855
R4756 VSS.t1015 VSS.t1017 0.0855
R4757 VSS.t1022 VSS.t1020 0.0855
R4758 VSS.t1025 VSS.t1027 0.0855
R4759 VSS.t1032 VSS.t1030 0.0855
R4760 VSS.t1035 VSS.t1037 0.0855
R4761 VSS.t1045 VSS.t1047 0.0855
R4762 VSS.t1052 VSS.t1050 0.0855
R4763 VSS.t1055 VSS.t1057 0.0855
R4764 VSS.t1062 VSS.t1060 0.0855
R4765 VSS.t1065 VSS.t1067 0.0855
R4766 VSS.t1072 VSS.t1070 0.0855
R4767 VSS.t1075 VSS.t1077 0.0855
R4768 VSS.t1082 VSS.t1080 0.0855
R4769 VSS.t1085 VSS.t1087 0.0855
R4770 VSS.t1092 VSS.t1090 0.0855
R4771 VSS.t1095 VSS.t1097 0.0855
R4772 VSS.t1102 VSS.t1100 0.0855
R4773 VSS.t1105 VSS.t1107 0.0855
R4774 VSS.t1112 VSS.t1110 0.0855
R4775 VSS.t1115 VSS.t1117 0.0855
R4776 VSS.t1122 VSS.t1120 0.0855
R4777 VSS.t1125 VSS.t1127 0.0855
R4778 VSS.t1132 VSS.t1130 0.0855
R4779 VSS.t1135 VSS.t1137 0.0855
R4780 VSS.t1142 VSS.t1140 0.0855
R4781 VSS.t1145 VSS.t1147 0.0855
R4782 VSS.t1152 VSS.t1150 0.0855
R4783 VSS.t1155 VSS.t1157 0.0855
R4784 VSS.t1162 VSS.t1160 0.0855
R4785 VSS.t1165 VSS.t1167 0.0855
R4786 VSS.t1172 VSS.t1170 0.0855
R4787 VSS.t176 VSS.t861 0.0855
R4788 VSS.t856 VSS.t858 0.0855
R4789 VSS.t830 VSS.t307 0.0855
R4790 VSS.t405 VSS.t338 0.0855
R4791 VSS.t583 VSS.t584 0.0855
R4792 VSS.t586 VSS.t587 0.0855
R4793 VSS.t589 VSS.t590 0.0855
R4794 VSS.t592 VSS.t593 0.0855
R4795 VSS.t595 VSS.t596 0.0855
R4796 VSS.t598 VSS.t599 0.0855
R4797 VSS.t601 VSS.t602 0.0855
R4798 VSS.t604 VSS.t605 0.0855
R4799 VSS.t607 VSS.t608 0.0855
R4800 VSS.t610 VSS.t611 0.0855
R4801 VSS.t613 VSS.t614 0.0855
R4802 VSS.t616 VSS.t617 0.0855
R4803 VSS.t619 VSS.t620 0.0855
R4804 VSS.t622 VSS.t623 0.0855
R4805 VSS.t574 VSS.t7 0.0855
R4806 VSS.t640 VSS.t36 0.0855
R4807 VSS.t184 VSS.t188 0.0855
R4808 VSS.t508 VSS.t510 0.0855
R4809 VSS.t513 VSS.t515 0.0855
R4810 VSS.t498 VSS.t500 0.0855
R4811 VSS.t493 VSS.t495 0.0855
R4812 VSS.t449 VSS.t447 0.0855
R4813 VSS.t452 VSS.t454 0.0855
R4814 VSS.t548 VSS.t550 0.07425
R4815 VSS.t625 VSS.t626 0.07425
R4816 VSS.t226 VSS.t503 0.07425
R4817 VSS.t81 VSS.n4 0.219075
R4818 VSS.t81 VSS.n19 0.0643474
R4819 VSS.t81 VSS.n27 0.0643474
R4820 VSS.t81 VSS.n21 0.0643474
R4821 VSS.t81 VSS.n23 0.0643474
R4822 VSS.n1151 VSS.n848 0.0623545
R4823 VSS.n1147 VSS.n848 0.0623545
R4824 VSS.n1147 VSS.n1146 0.0623545
R4825 VSS.n1146 VSS.n853 0.0623545
R4826 VSS.n1141 VSS.n853 0.0623545
R4827 VSS.n1141 VSS.n1140 0.0623545
R4828 VSS.n1140 VSS.n870 0.0623545
R4829 VSS.n1005 VSS.n870 0.0623545
R4830 VSS.n1150 VSS.n850 0.0623545
R4831 VSS.n1145 VSS.n850 0.0623545
R4832 VSS.n1145 VSS.n1144 0.0623545
R4833 VSS.n1144 VSS.n854 0.0623545
R4834 VSS.n1139 VSS.n854 0.0623545
R4835 VSS.n1139 VSS.n1138 0.0623545
R4836 VSS.n1138 VSS.n828 0.0623545
R4837 VSS.n1149 VSS.n1148 0.0623545
R4838 VSS.n1148 VSS.n852 0.0623545
R4839 VSS.n1143 VSS.n852 0.0623545
R4840 VSS.n1143 VSS.n1142 0.0623545
R4841 VSS.n1142 VSS.n855 0.0623545
R4842 VSS.n1078 VSS.n855 0.0623545
R4843 VSS.n1078 VSS.n1077 0.0623545
R4844 VSS.t723 VSS.n896 0.0613562
R4845 VSS.n1098 VSS.t172 0.058
R4846 VSS.n208 VSS.n849 0.0957512
R4847 VSS.t2503 VSS.n290 0.0957512
R4848 VSS.n346 VSS.t2111 0.0957512
R4849 VSS.t1719 VSS.n402 0.0957512
R4850 VSS.n869 VSS.t1305 0.0305
R4851 VSS.n637 VSS.t1038 0.0957512
R4852 VSS.n133 VSS.n829 0.101538
R4853 VSS.n125 VSS.n906 0.0957512
R4854 VSS.t96 VSS.n814 0.0266763
R4855 VSS.t2629 VSS.n69 109.992
R4856 VSS.n69 VSS.t2624 109.992
R4857 VSS.t2619 VSS.n69 109.992
R4858 VSS.n69 VSS.t2604 109.992
R4859 VSS.t2569 VSS.n69 109.992
R4860 VSS.t2549 VSS.n69 109.992
R4861 VSS.n71 VSS.t2222 109.992
R4862 VSS.n71 VSS.t2202 109.992
R4863 VSS.t2197 VSS.n71 109.992
R4864 VSS.n71 VSS.t2192 109.992
R4865 VSS.t2177 VSS.n71 109.992
R4866 VSS.n71 VSS.t2152 109.992
R4867 VSS.t2147 VSS.n71 109.992
R4868 VSS.n75 VSS.t1845 109.992
R4869 VSS.t1840 VSS.n75 109.992
R4870 VSS.n75 VSS.t1835 109.992
R4871 VSS.n75 VSS.t1815 109.992
R4872 VSS.n75 VSS.t1790 109.992
R4873 VSS.n75 VSS.t1775 109.992
R4874 VSS.n75 VSS.t1770 109.992
R4875 VSS.n75 VSS.t1750 109.992
R4876 VSS.n75 VSS.t1745 109.992
R4877 VSS.n75 VSS.t1740 109.992
R4878 VSS.t1700 VSS.n75 109.992
R4879 VSS.n75 VSS.t1695 109.992
R4880 VSS.t1690 VSS.n75 109.992
R4881 VSS.t1670 VSS.n75 109.992
R4882 VSS.t1620 VSS.n75 109.992
R4883 VSS.n75 VSS.t1595 109.992
R4884 VSS.n73 VSS.t1169 109.992
R4885 VSS.n73 VSS.t1149 109.992
R4886 VSS.t1104 VSS.n73 109.992
R4887 VSS.n73 VSS.t1079 109.992
R4888 VSS.t1054 VSS.n73 109.992
R4889 VSS.n73 VSS.t1009 109.992
R4890 VSS.t1004 VSS.n73 109.992
R4891 VSS.t964 VSS.n73 109.992
R4892 VSS.n682 VSS.n694 0.0258175
R4893 VSS.n682 VSS.n693 0.0258175
R4894 VSS.n682 VSS.n687 0.0258175
R4895 VSS.n682 VSS.n688 0.0258175
R4896 VSS.n682 VSS.n692 0.0258175
R4897 VSS.n682 VSS.n691 0.0258175
R4898 VSS.n682 VSS.n689 0.0258175
R4899 VSS.n682 VSS.n690 0.0258175
R4900 VSS.n666 VSS.n670 0.0258175
R4901 VSS.t681 VSS.n808 0.0258175
R4902 VSS.t681 VSS.n783 0.0258175
R4903 VSS.t681 VSS.n806 0.0258175
R4904 VSS.t681 VSS.n785 0.0258175
R4905 VSS.t681 VSS.n804 0.0258175
R4906 VSS.t681 VSS.n787 0.0258175
R4907 VSS.t681 VSS.n802 0.0258175
R4908 VSS.t681 VSS.n789 0.0258175
R4909 VSS.t681 VSS.n800 0.0258175
R4910 VSS.t681 VSS.n791 0.0258175
R4911 VSS.t681 VSS.n798 0.0258175
R4912 VSS.t681 VSS.n793 0.0258175
R4913 VSS.t681 VSS.n768 0.0258175
R4914 VSS.t681 VSS.n769 0.0258175
R4915 VSS.t681 VSS.n781 0.0258175
R4916 VSS.t681 VSS.n771 0.0258175
R4917 VSS.t681 VSS.n779 0.0258175
R4918 VSS.t681 VSS.n773 0.0258175
R4919 VSS.t681 VSS.n777 0.0258175
R4920 VSS.t681 VSS.n775 0.0258175
R4921 VSS.t3209 VSS.n79 157.976
R4922 VSS.t3179 VSS.n79 157.976
R4923 VSS.t3129 VSS.n79 157.976
R4924 VSS.t3109 VSS.n79 157.976
R4925 VSS.t3084 VSS.n79 157.976
R4926 VSS.n79 VSS.t3059 157.976
R4927 VSS.n79 VSS.t3034 157.976
R4928 VSS VSS.n1151 0.00565455
R4929 VSS.n600 VSS.n601 0.00399966
R4930 VSS.n595 VSS.n596 0.00399966
R4931 VSS.n588 VSS.n861 0.00362425
R4932 VSS.n577 VSS.n863 0.00362425
R4933 VSS.n603 VSS.n467 0.00299994
R4934 VSS.n580 VSS.n447 0.00299994
R4935 VSS.n607 VSS.n606 0.00274942
R4936 VSS.n593 VSS.n860 0.00283308
R4937 VSS.n865 VSS.n430 0.002125
R4938 VSS.n571 VSS.n433 0.00181233
R4939 VSS.t681 VSS.n809 0.002
R4940 VSS.n667 VSS.n666 0.002
R4941 VSS.t681 VSS.n807 0.00194928
R4942 VSS.t681 VSS.n784 0.00194928
R4943 VSS.t681 VSS.n805 0.00194928
R4944 VSS.t681 VSS.n786 0.00194928
R4945 VSS.t681 VSS.n803 0.00194928
R4946 VSS.t681 VSS.n788 0.00194928
R4947 VSS.t681 VSS.n801 0.00194928
R4948 VSS.t681 VSS.n790 0.00194928
R4949 VSS.t681 VSS.n799 0.00194928
R4950 VSS.t681 VSS.n792 0.00194928
R4951 VSS.t681 VSS.n782 0.00194928
R4952 VSS.t681 VSS.n770 0.00194928
R4953 VSS.t681 VSS.n780 0.00194928
R4954 VSS.t681 VSS.n772 0.00194928
R4955 VSS.t681 VSS.n778 0.00194928
R4956 VSS.t681 VSS.n774 0.00194928
R4957 VSS.t681 VSS.n776 0.00194928
R4958 VSS.n434 VSS.n433 0.00318729
R4959 VSS.n431 VSS.n430 0.00187493
R4960 VSS.n470 VSS.n469 0.00175
R4961 VSS.n580 VSS.n579 0.00149995
R4962 VSS.n598 VSS.n597 0.00169993
R4963 VSS.n603 VSS.n602 0.00149995
R4964 VSS.n507 VSS.n506 0.00656105
R4965 VSS.n504 VSS.n503 0.00656105
R4966 VSS.n501 VSS.n500 0.00656105
R4967 VSS.n498 VSS.n497 0.00349966
R4968 VSS.n495 VSS.n494 0.00656105
R4969 VSS.n492 VSS.n491 0.00656105
R4970 VSS.n489 VSS.n488 0.00656105
R4971 VSS.n486 VSS.n485 0.00656105
R4972 VSS.n483 VSS.n482 0.00656105
R4973 VSS.n480 VSS.n479 0.00656105
R4974 VSS.n477 VSS.n476 0.00656105
R4975 VSS.n474 VSS.n110 0.00656105
R4976 VSS.n864 VSS.n436 0.00166667
R4977 VSS.n571 VSS.n437 0.00299994
R4978 VSS.n570 VSS.n434 0.00299992
R4979 VSS.n585 VSS.n449 0.00249997
R4980 VSS.n467 VSS.n466 0.002
R4981 VSS.n447 VSS.n446 0.002
R4982 VSS.n581 VSS.n582 0.00169993
R4983 VSS.n861 VSS.n454 0.00166667
R4984 VSS.n595 VSS.n594 0.00138884
R4985 VSS.n600 VSS.n599 0.00138884
R4986 VSS.n604 VSS.n605 0.00169993
R4987 VSS.t96 VSS.n667 0.0015
R4988 VSS.n809 VSS.t96 0.0015
R4989 VSS.n759 VSS.n763 0.0015
R4990 VSS.n755 VSS.n759 0.0015
R4991 VSS.n751 VSS.n755 0.0015
R4992 VSS.n747 VSS.n751 0.0015
R4993 VSS.n743 VSS.n747 0.0015
R4994 VSS.n739 VSS.n743 0.0015
R4995 VSS.n735 VSS.n739 0.0015
R4996 VSS.n731 VSS.n735 0.0015
R4997 VSS.n727 VSS.n731 0.0015
R4998 VSS.n723 VSS.n727 0.0015
R4999 VSS.n719 VSS.n723 0.0015
R5000 VSS.n715 VSS.n719 0.0015
R5001 VSS.n711 VSS.n715 0.0015
R5002 VSS.n707 VSS.n711 0.0015
R5003 VSS.n704 VSS.n707 0.0015
R5004 VSS.n702 VSS.n704 0.0015
R5005 VSS.n703 VSS.n702 0.0015
R5006 VSS.n703 VSS.t155 0.0015
R5007 VSS.n698 VSS.t155 0.0015
R5008 VSS.n685 VSS.n698 0.0015
R5009 VSS.n682 VSS.n685 0.0015
R5010 VSS.n680 VSS.n682 0.0015
R5011 VSS.n677 VSS.n680 0.0015
R5012 VSS.n676 VSS.n677 0.0015
R5013 VSS.n673 VSS.n676 0.0015
R5014 VSS.n672 VSS.n673 0.0015
R5015 VSS.n669 VSS.n672 0.0015
R5016 VSS.n666 VSS.n669 0.0015
R5017 VSS.n858 VSS.n606 0.0015
R5018 VSS.n466 VSS.n604 0.0015
R5019 VSS.n859 VSS.n598 0.0015
R5020 VSS.n860 VSS.n591 0.0015
R5021 VSS.n458 VSS.n457 0.0015
R5022 VSS.n586 VSS.n451 0.00199984
R5023 VSS.n452 VSS.n451 0.0015
R5024 VSS.n512 VSS.n507 0.00199997
R5025 VSS.n517 VSS.n504 0.00199997
R5026 VSS.n522 VSS.n501 0.00199997
R5027 VSS.n527 VSS.n498 0.00199997
R5028 VSS.n528 VSS.n495 0.00199997
R5029 VSS.n533 VSS.n492 0.00199997
R5030 VSS.n538 VSS.n489 0.00199997
R5031 VSS.n543 VSS.n486 0.00199997
R5032 VSS.n548 VSS.n483 0.00199997
R5033 VSS.n553 VSS.n480 0.00199997
R5034 VSS.n558 VSS.n477 0.00199997
R5035 VSS.n563 VSS.n474 0.00199997
R5036 VSS.n608 VSS.n470 0.00199997
R5037 VSS.n601 VSS.n464 0.00199997
R5038 VSS.n596 VSS.n462 0.00199997
R5039 VSS.n592 VSS.n460 0.00199997
R5040 VSS.n589 VSS.n458 0.00199997
R5041 VSS.n585 VSS.n452 0.00199997
R5042 VSS.n578 VSS.n444 0.00199997
R5043 VSS.n573 VSS.n442 0.00199997
R5044 VSS.n568 VSS.n431 0.00199997
R5045 VSS.n584 VSS.n583 0.00199984
R5046 VSS.n862 VSS.n583 0.0015
R5047 VSS.n446 VSS.n581 0.0015
R5048 VSS.n863 VSS.n575 0.0015
R5049 VSS.n442 VSS.n441 0.0015
R5050 VSS.n570 VSS.n569 0.00199984
R5051 VSS.n455 VSS.n454 0.00183332
R5052 VSS.n437 VSS.n436 0.00183332
R5053 VSS.n865 VSS.n569 0.0015
R5054 VSS.t392 VSS.t2906 8.5019
R5055 VSS.n262 VSS.n69 3.90579
R5056 VSS.t392 VSS.n130 2.95459
R5057 VSS.n185 VSS.n79 2.95001
R5058 VSS.t81 VSS.n11 1.04662
R5059 VSS.t28 VSS.t9 1.00507
R5060 VSS.t81 VSS.n56 1.00314
C0 sg13g2_dlygate4sd3_1_8.X a_9444_15552# 0.03494f
C1 a_27121_14845# a_26373_14495# 0.01058f
C2 a_17892_14909# a_18123_14495# 0.06628f
C3 sg13g2_dfrbpq_1_6.RESET_B a_22319_14845# 0.07576f
C4 sg13g2_buf_16_2.A sg13g2_buf_16_2.X 0.03835f
C5 sg13g2_dfrbpq_1_6.Q a_23960_15242# 0.01415f
C6 a_17584_13942# sg13g2_dfrbpq_1_2.RESET_B 0.06198f
C7 a_10337_14750# VDD 0.19397f
C8 sg13g2_dfrbpq_1_0.RESET_B VDD 1.09735f
C9 a_6086_14922# a_6372_14488# 0.21832f
C10 a_19169_15424# a_19450_15202# 0.15158f
C11 sg13g2_dlygate4sd3_1_0.A VDD 0.29218f
C12 sg13g2_or3_1_2.X sg13g2_o21ai_1_1.Y 0.29999f
C13 sg13g2_nor2_1_0.B sg13g2_dfrbpq_1_2.D 0.11402f
C14 sg13g2_a21oi_1_0.B1 sg13g2_buf_1_10.X 0.05486f
C15 sg13g2_xnor2_1_1.A sg13g2_dfrbpq_1_2.Q 0.02303f
C16 a_25862_13722# VDD 0.45381f
C17 a_7680_15549# VDD 0.16888f
C18 a_21034_14452# sg13g2_buf_16_2.X 0.01841f
C19 a_21562_15960# VDD 0.24998f
C20 sg13g2_dlygate4sd3_1_8.X a_8582_15238# 0.01811f
C21 a_26122_13945# a_26148_14040# 0.21121f
C22 a_26170_16237# a_26373_16033# 0.01313f
C23 a_21166_16263# sg13g2_a21oi_1_1.Y 0.0149f
C24 sg13g2_dfrbpq_1_2.Q sg13g2_buf_16_2.A 0.29333f
C25 a_25094_14484# a_24824_14525# 0.15158f
C26 sg13g2_dfrbpq_1_2.CLK a_9732_15247# 0.0108f
C27 a_26475_14495# a_25670_14922# 0.06896f
C28 a_6789_14495# a_6372_14488# 0.22698f
C29 sg13g2_nand4_1_0.Y sg13g2_and2_1_2.B 0.03046f
C30 a_26633_16334# VDD 0.09032f
C31 sg13g2_dfrbpq_1_5.D sg13g2_buf_16_2.X 0.05288f
C32 a_2916_15552# a_4081_15311# 0.22369f
C33 a_3209_16334# a_3333_16033# 0.06917f
C34 sg13g2_or3_1_2.B sg13g2_o21ai_1_2.A2 0.22379f
C35 a_6660_14909# a_6891_14495# 0.06628f
C36 sg13g2_dfrbpq_1_7.RESET_B sg13g2_or3_1_1.A 0.02537f
C37 a_17318_14922# a_17892_14909# 0.16388f
C38 sg13g2_xor2_1_0.B sg13g2_xnor2_1_2.B 0.0219f
C39 a_21579_14495# sg13g2_or3_1_2.X 0.05524f
C40 sg13g2_a21oi_1_0.B1 sg13g2_dfrbpq_1_3.Q 0.64376f
C41 a_26667_13844# sg13g2_buf_16_2.X 0.04208f
C42 sg13g2_dfrbpq_1_7.Q a_26373_14495# 0.0107f
C43 sg13g2_xor2_1_0.B sg13g2_dlygate4sd3_1_1.A 0.01984f
C44 sg13g2_dlygate4sd3_1_5.A a_18552_15552# 0.01075f
C45 a_5613_14832# VDD 0.26538f
C46 sg13g2_dfrbpq_1_6.RESET_B sg13g2_or3_1_2.A 0.0243f
C47 a_16055_16301# VDD 0.06876f
C48 sg13g2_a21oi_1_3.A2 sg13g2_a21oi_1_3.A1 0.1362f
C49 sg13g2_or3_1_1.B sg13g2_dfrbpq_1_2.D 0.01105f
C50 a_2248_16082# VDD 0.15493f
C51 a_9732_15247# a_9861_15213# 0.01562f
C52 sg13g2_dfrbpq_1_1.RESET_B a_6372_14488# 0.24833f
C53 sg13g2_dfrbpq_1_7.RESET_B a_25930_14452# 0.13229f
C54 a_6682_13690# sg13g2_xnor2_1_2.A 0.03717f
C55 sg13g2_dlygate4sd3_1_4.X sg13g2_xnor2_1_1.A 1.15556f
C56 a_21827_13690# VDD 0.25328f
C57 sg13g2_or3_1_1.B sg13g2_dfrbpq_1_3.D 0.0105f
C58 sg13g2_and2_1_0.X a_2516_14484# 0.03171f
C59 a_32492_15960# counter_value_o[6] 0.13349f
C60 a_20774_14922# sg13g2_or3_1_2.X 0.0173f
C61 a_38536_10034# VDD 0.13142f
C62 sg13g2_or3_1_1.X a_24923_15996# 0.07721f
C63 sg13g2_dfrbpq_1_2.Q a_23168_15366# 0.01296f
C64 sg13g2_dlygate4sd3_1_4.X sg13g2_buf_16_2.A 0.02678f
C65 sg13g2_or3_1_1.B a_14357_15238# 0.23255f
C66 sg13g2_xnor2_1_2.B a_6575_13342# 0.01245f
C67 sg13g2_a21oi_1_0.B1 a_25094_15238# 0.0148f
C68 sg13g2_dfrbpq_1_1.RESET_B a_7631_14845# 0.07576f
C69 a_2916_15552# sg13g2_dlygate4sd3_1_3.A 0.02251f
C70 sg13g2_or3_1_2.B a_23552_14570# 0.0176f
C71 sg13g2_buf_16_2.A sg13g2_nor2_1_0.B 0.03948f
C72 sg13g2_or3_1_2.B sg13g2_dfrbpq_1_2.CLK 0.02793f
C73 sg13g2_or3_1_2.B a_17825_15424# 0.0189f
C74 counter_value_o[2] VDD 0.09991f
C75 sg13g2_or3_1_1.B clock_i 0.08634f
C76 a_21477_14495# sg13g2_or3_1_2.A 0.05486f
C77 a_3204_15247# sg13g2_buf_1_0.X 0.0153f
C78 a_21946_16237# sg13g2_dfrbpq_1_6.RESET_B 0.04268f
C79 sg13g2_or3_1_1.A a_25774_15423# 0.01024f
C80 sg13g2_nand4_1_0.Y sg13g2_or3_1_1.B 0.01128f
C81 a_16055_16071# a_15880_16082# 0.01214f
C82 sg13g2_a21oi_1_0.B1 sg13g2_a21oi_1_3.Y 0.62334f
C83 sg13g2_dfrbpq_1_6.RESET_B a_22576_14726# 0.0605f
C84 sg13g2_a21oi_1_0.B1 sg13g2_or3_1_1.X 0.06644f
C85 sg13g2_dlygate4sd3_1_0.X sg13g2_and2_1_1.X 0.0464f
C86 sg13g2_or3_1_2.C sg13g2_or3_1_2.A 0.96406f
C87 sg13g2_dfrbpq_1_7.Q VDD 1.27189f
C88 a_25094_15238# a_25206_15302# 0.32411f
C89 sg13g2_xnor2_1_2.B a_6086_14922# 0.05961f
C90 sg13g2_buf_1_10.X a_10337_14750# 0.01922f
C91 sg13g2_dfrbpq_1_2.CLK a_12020_15202# 0.98555f
C92 a_25670_14922# sg13g2_dfrbpq_1_7.D 0.1564f
C93 a_16068_14040# sg13g2_a21oi_1_0.B1 0.0203f
C94 sg13g2_buf_1_10.X VDD 2.38024f
C95 sg13g2_dlygate4sd3_1_8.A sg13g2_dlygate4sd3_1_8.X 0.01211f
C96 sg13g2_a21oi_1_0.B1 sg13g2_dfrbpq_1_6.D 0.04061f
C97 a_26436_13735# a_26667_13844# 0.06628f
C98 a_27313_13799# a_26148_14040# 0.22369f
C99 a_9658_14725# sg13g2_tiehi_1.L_HI 0.05972f
C100 sg13g2_dfrbpq_1_3.D a_17318_14922# 0.17002f
C101 a_8685_14832# VDD 0.25215f
C102 sg13g2_dlygate4sd3_1_8.X sg13g2_dlygate4sd3_1_1.A 0.32804f
C103 sg13g2_dfrbpq_1_6.Q a_23368_14570# 0.02513f
C104 a_27500_15960# VDD 0.19742f
C105 sg13g2_or3_1_1.B sg13g2_xnor2_1_1.A 0.33936f
C106 a_22319_14845# sg13g2_buf_16_2.X 0.02039f
C107 sg13g2_dlygate4sd3_1_1.A a_6789_14495# 0.01353f
C108 sg13g2_or3_1_1.B sg13g2_buf_16_2.A 0.26884f
C109 sg13g2_or3_1_1.X a_25206_15302# 0.0267f
C110 sg13g2_buf_16_2.A a_18123_14495# 0.01303f
C111 sg13g2_dfrbpq_1_2.Q sg13g2_a21oi_1_0.A1 0.01894f
C112 a_23736_14464# sg13g2_o21ai_1_2.Y 0.01083f
C113 sg13g2_dfrbpq_1_2.CLK a_9861_15213# 0.16791f
C114 a_4474_14448# a_4193_14750# 0.15158f
C115 a_25956_14488# a_26373_14495# 0.22698f
C116 a_17327_13799# a_17233_13799# 0.15029f
C117 sg13g2_dfrbpq_1_5.RESET_B sg13g2_buf_16_2.X 0.0892f
C118 a_18106_15202# a_18454_15230# 0.02137f
C119 sg13g2_dfrbpq_1_3.Q VDD 1.04345f
C120 a_22319_14845# a_22225_14845# 0.15029f
C121 a_27121_14845# sg13g2_dfrbpq_1_7.Q 0.02056f
C122 sg13g2_buf_1_10.X a_5613_14832# 0.0879f
C123 a_18377_16334# sg13g2_dlygate4sd3_1_6.X 0.01804f
C124 a_2540_15960# counter_value_o[0] 0.13349f
C125 a_16356_13735# a_15782_13722# 0.16388f
C126 VDD a_27034_15202# 0.24502f
C127 VDD a_21466_15202# 0.25171f
C128 a_2490_14447# a_2516_14484# 0.19823f
C129 sg13g2_dfrbpq_1_7.RESET_B sg13g2_o21ai_1_2.B1 0.0255f
C130 a_10703_15311# sg13g2_tiehi_1.L_HI 0.07574f
C131 a_27215_14845# sg13g2_dfrbpq_1_7.RESET_B 0.07576f
C132 sg13g2_dfrbpq_1_1.RESET_B sg13g2_xnor2_1_2.B 0.12585f
C133 a_21034_14452# a_21060_14488# 0.21121f
C134 sg13g2_dfrbpq_1_2.CLK sg13g2_dfrbpq_1_2.D 0.01523f
C135 sg13g2_or3_1_2.B sg13g2_dfrbpq_1_3.D 0.02299f
C136 sg13g2_dfrbpq_1_5.RESET_B sg13g2_dfrbpq_1_6.Q 0.02798f
C137 a_22304_16082# counter_value_o[4] 0.01137f
C138 a_15782_13722# a_16587_13844# 0.06896f
C139 a_16068_14040# a_16485_13701# 0.22605f
C140 sg13g2_dfrbpq_1_1.RESET_B sg13g2_dlygate4sd3_1_1.A 0.02037f
C141 a_4842_15532# VDD 0.24296f
C142 sg13g2_dfrbpq_1_2.RESET_B sg13g2_nor2_1_0.B 0.0742f
C143 a_17900_15960# sg13g2_dfrbpq_1_3.RESET_B 0.01575f
C144 sg13g2_buf_16_2.A a_17318_14922# 0.03137f
C145 a_9444_15552# a_9963_15356# 0.18372f
C146 a_19530_14484# VDD 0.24513f
C147 VDD a_25094_15238# 0.19682f
C148 sg13g2_dfrbpq_1_5.D a_25670_14922# 0.04176f
C149 sg13g2_buf_16_2.X sg13g2_or3_1_2.A 0.92322f
C150 a_20705_15260# sg13g2_dlygate4sd3_1_11.X 0.0127f
C151 a_25786_15960# a_25505_16262# 0.15158f
C152 sg13g2_dfrbpq_1_2.CLK a_14357_15238# 0.01232f
C153 a_16068_14040# sg13g2_a21oi_1_0.A2 0.04264f
C154 sg13g2_dlygate4sd3_1_17.A sg13g2_or3_1_1.A 0.31702f
C155 a_9158_15234# a_9418_15457# 0.39302f
C156 sg13g2_dfrbpq_1_2.CLK clock_i 0.06381f
C157 a_25956_14488# VDD 0.07268f
C158 a_18478_13911# VDD 0.15211f
C159 sg13g2_dfrbpq_1_2.Q a_19054_15423# 0.03619f
C160 sg13g2_dfrbpq_1_2.Q sg13g2_or3_1_2.A 0.01215f
C161 VDD sg13g2_a21oi_1_3.Y 0.37642f
C162 a_19816_15366# a_20000_15366# 0.0262f
C163 sg13g2_dfrbpq_1_2.Q a_17710_15423# 0.02421f
C164 sg13g2_or3_1_1.X VDD 0.42033f
C165 sg13g2_dfrbpq_1_2.CLK sg13g2_nand4_1_0.Y 1.26852f
C166 a_12020_15202# clock_i 0.01451f
C167 a_16068_14040# VDD 0.07703f
C168 sg13g2_dlygate4sd3_1_17.A sg13g2_o21ai_1_2.Y 0.17641f
C169 sg13g2_buf_16_2.X sg13g2_a21oi_1_3.A1 0.02979f
C170 sg13g2_dfrbpq_1_6.D VDD 0.33374f
C171 sg13g2_dfrbpq_1_6.Q a_27898_15202# 0.01199f
C172 sg13g2_or3_1_2.B sg13g2_xnor2_1_1.A 0.90871f
C173 a_16556_15960# sg13g2_or3_1_1.B 0.16198f
C174 sg13g2_buf_1_10.X a_8685_14832# 0.10246f
C175 sg13g2_dfrbpq_1_2.RESET_B sg13g2_or3_1_1.B 0.04262f
C176 a_24263_14508# a_24169_14508# 0.02085f
C177 sg13g2_or3_1_2.B sg13g2_buf_16_2.A 0.09344f
C178 a_17900_15960# VDD 0.17597f
C179 a_5886_15486# sg13g2_dlygate4sd3_1_3.A 0.02682f
C180 a_8582_15238# sg13g2_and2_1_2.B 0.0171f
C181 a_22576_14726# sg13g2_buf_16_2.X 0.01541f
C182 a_2916_15552# sg13g2_buf_1_0.X 0.04257f
C183 sg13g2_buf_1_0.X sg13g2_xnor2_1_2.A 0.13228f
C184 sg13g2_dlygate4sd3_1_8.X a_9158_15234# 0.02597f
C185 sg13g2_dlygate4sd3_1_12.X sg13g2_dlygate4sd3_1_17.A 0.07004f
C186 sg13g2_dfrbpq_1_7.RESET_B a_26170_15202# 0.03481f
C187 a_27121_14845# a_25956_14488# 0.22369f
C188 sg13g2_dfrbpq_1_2.CLK sg13g2_buf_16_2.A 0.52851f
C189 a_7537_14845# a_6372_14488# 0.22369f
C190 a_27407_13799# a_27313_13799# 0.15029f
C191 a_17604_14488# a_18863_14845# 0.01303f
C192 sg13g2_dlygate4sd3_1_8.X a_9737_14822# 0.01437f
C193 a_25109_12972# sg13g2_a21oi_1_3.A1 0.02387f
C194 a_6286_13911# sg13g2_xnor2_1_2.B 0.05832f
C195 sg13g2_a21oi_1_0.B1 sg13g2_or3_1_2.X 0.01794f
C196 a_17327_13799# sg13g2_dfrbpq_1_2.RESET_B 0.07574f
C197 sg13g2_or3_1_1.B sg13g2_a21oi_1_0.A1 0.01449f
C198 sg13g2_and2_1_0.B VDD 0.13822f
C199 a_23638_14862# sg13g2_o21ai_1_2.Y 0.04934f
C200 a_10016_14570# VDD 0.07442f
C201 a_7532_15960# VDD 0.19909f
C202 sg13g2_buf_16_2.A a_12020_15202# 0.35756f
C203 a_6086_14922# a_6346_14452# 0.39302f
C204 a_6682_13690# sg13g2_dlygate4sd3_1_0.A 0.25819f
C205 a_6682_13690# VDD 0.26449f
C206 a_7631_14845# a_7537_14845# 0.15029f
C207 sg13g2_dfrbpq_1_7.Q a_27034_15202# 0.23558f
C208 a_26122_13945# VDD 0.09478f
C209 a_16042_13945# sg13g2_dfrbpq_1_2.RESET_B 0.16623f
C210 a_21166_16263# VDD 0.14796f
C211 a_26122_13945# a_25862_13722# 0.39302f
C212 sg13g2_dlygate4sd3_1_3.A sg13g2_dfrbpq_1_0.RESET_B 0.09578f
C213 clock_i sg13g2_dfrbpq_1_2.D 0.02877f
C214 sg13g2_dlygate4sd3_1_3.A VDD 1.29077f
C215 a_26244_14909# a_25670_14922# 0.16388f
C216 a_6789_14495# a_6346_14452# 0.02242f
C217 a_6080_13854# VDD 0.06917f
C218 a_17327_13799# sg13g2_a21oi_1_0.A1 0.03266f
C219 a_26249_16334# VDD 0.0679f
C220 a_25094_14484# sg13g2_buf_16_2.X 0.01487f
C221 a_21060_14488# a_22319_14845# 0.01303f
C222 a_10609_15311# a_10703_15311# 0.15029f
C223 a_6401_13912# sg13g2_dlygate4sd3_1_0.A 0.04891f
C224 a_25206_14508# VDD 0.14669f
C225 a_6401_13912# VDD 0.19923f
C226 a_14357_15238# clock_i 0.01611f
C227 a_26565_13701# sg13g2_buf_16_2.X 0.16278f
C228 sg13g2_a21oi_1_0.A1 a_17318_14922# 0.04479f
C229 sg13g2_dfrbpq_1_7.Q a_25956_14488# 0.03205f
C230 sg13g2_nand4_1_0.Y a_14357_15238# 0.20025f
C231 a_27882_14484# VDD 0.24179f
C232 sg13g2_dfrbpq_1_5.RESET_B a_25670_14922# 0.04149f
C233 sg13g2_dfrbpq_1_3.Q a_21466_15202# 0.01226f
C234 a_16055_16071# VDD 0.07703f
C235 sg13g2_dlygate4sd3_1_17.A a_24824_14525# 0.23876f
C236 sg13g2_dlygate4sd3_1_6.X sg13g2_dfrbpq_1_3.RESET_B 0.02516f
C237 counter_value_o[7] VDD 0.10064f
C238 sg13g2_dlygate4sd3_1_8.A a_9963_15356# 0.02895f
C239 a_2540_15960# VDD 0.17846f
C240 sg13g2_nand4_1_0.Y clock_i 0.01585f
C241 sg13g2_o21ai_1_3.Y sg13g2_dlygate4sd3_1_17.A 0.03767f
C242 a_9732_15247# a_9444_15552# 0.22255f
C243 sg13g2_dlygate4sd3_1_0.X VDD 0.42681f
C244 a_20376_14464# VDD 0.01847f
C245 sg13g2_buf_16_2.A sg13g2_dfrbpq_1_2.D 0.07692f
C246 sg13g2_dfrbpq_1_1.RESET_B a_6346_14452# 0.14145f
C247 sg13g2_dlygate4sd3_1_17.A sg13g2_o21ai_1_2.B1 0.02004f
C248 sg13g2_dfrbpq_1_6.RESET_B sg13g2_o21ai_1_1.Y 0.06014f
C249 sg13g2_or3_1_1.B sg13g2_or3_1_2.A 0.02564f
C250 sg13g2_a21oi_1_0.B1 sg13g2_or3_1_1.A 0.10021f
C251 sg13g2_nand3_1_0.Y VDD 0.64075f
C252 sg13g2_xnor2_1_1.A sg13g2_dfrbpq_1_3.D 0.01707f
C253 a_16556_15960# sg13g2_or3_1_2.B 0.13284f
C254 sg13g2_nand3_1_0.Y a_7680_15549# 0.18946f
C255 sg13g2_dfrbpq_1_3.Q a_19530_14484# 0.07201f
C256 a_1192_9948# VDD 0.16521f
C257 sg13g2_or3_1_2.B sg13g2_dfrbpq_1_2.RESET_B 0.1467f
C258 sg13g2_or3_1_1.A a_27502_15423# 0.10556f
C259 sg13g2_buf_16_2.A sg13g2_dfrbpq_1_3.D 0.01667f
C260 sg13g2_dfrbpq_1_1.RESET_B a_7888_14726# 0.0605f
C261 sg13g2_or3_1_2.B a_23368_14570# 0.01252f
C262 sg13g2_buf_16_2.A a_14357_15238# 0.03718f
C263 a_7680_15549# a_7829_15238# 0.17527f
C264 sg13g2_dfrbpq_1_2.CLK sg13g2_dfrbpq_1_2.RESET_B 0.04031f
C265 sg13g2_dlygate4sd3_1_12.X a_24923_15996# 0.05494f
C266 a_21060_14488# sg13g2_or3_1_2.A 0.02629f
C267 a_23368_14570# a_23552_14570# 0.0262f
C268 sg13g2_tiehi_1.L_HI VDD 0.9788f
C269 sg13g2_buf_16_2.A clock_i 0.04835f
C270 sg13g2_and2_1_0.X a_2630_15234# 0.17138f
C271 a_21281_16262# sg13g2_dfrbpq_1_6.RESET_B 0.02111f
C272 a_3435_15356# sg13g2_dfrbpq_1_2.CLK 0.01615f
C273 sg13g2_or3_1_1.A a_25206_15302# 0.01017f
C274 sg13g2_or3_1_2.B sg13g2_a21oi_1_0.A1 0.0535f
C275 sg13g2_and2_1_2.X a_9158_15234# 0.15383f
C276 a_16055_16071# a_16055_16301# 0.06917f
C277 sg13g2_or3_1_1.B sg13g2_a21oi_1_3.A1 0.01968f
C278 sg13g2_dlygate4sd3_1_1.A a_7537_14845# 0.01761f
C279 sg13g2_o21ai_1_2.B1 a_23638_14862# 0.02181f
C280 sg13g2_dfrbpq_1_6.RESET_B a_21579_14495# 0.21475f
C281 sg13g2_or3_1_2.X VDD 0.31077f
C282 sg13g2_nand4_1_0.Y sg13g2_buf_16_2.A 0.04439f
C283 sg13g2_dlygate4sd3_1_0.X a_5613_14832# 0.17799f
C284 sg13g2_xor2_1_0.B sg13g2_and2_1_1.X 0.01252f
C285 a_18863_14845# a_18769_14845# 0.15029f
C286 sg13g2_dlygate4sd3_1_6.X VDD 0.68479f
C287 sg13g2_buf_1_10.X sg13g2_and2_1_0.B 0.11219f
C288 a_32200_16082# VDD 0.1577f
C289 sg13g2_dfrbpq_1_3.RESET_B sg13g2_dlygate4sd3_1_5.A 0.08365f
C290 a_18021_14495# sg13g2_buf_16_2.X 0.15007f
C291 sg13g2_dlygate4sd3_1_4.X a_18454_15230# 0.01369f
C292 sg13g2_dfrbpq_1_2.CLK a_11370_15532# 0.01225f
C293 a_15782_13722# sg13g2_a21oi_1_0.B1 0.03545f
C294 sg13g2_dfrbpq_1_6.D sg13g2_dfrbpq_1_3.Q 0.01678f
C295 a_26436_13735# a_26565_13701# 0.01562f
C296 sg13g2_a21oi_1_0.B1 sg13g2_dlygate4sd3_1_12.X 0.03482f
C297 sg13g2_or3_1_2.C sg13g2_o21ai_1_1.Y 0.07176f
C298 a_26244_14909# a_26475_14495# 0.06628f
C299 sg13g2_a21oi_1_1.Y sg13g2_dlygate4sd3_1_11.X 0.0618f
C300 sg13g2_a21oi_1_0.B1 sg13g2_or3_1_1.C 0.02968f
C301 a_26757_16033# VDD 0.06812f
C302 a_2916_15552# sg13g2_xor2_1_0.B 0.01389f
C303 sg13g2_dfrbpq_1_5.D sg13g2_dfrbpq_1_7.D 0.02975f
C304 sg13g2_xor2_1_0.B sg13g2_xnor2_1_2.A 0.2895f
C305 sg13g2_dlygate4sd3_1_3.A sg13g2_buf_1_10.X 0.02533f
C306 sg13g2_buf_1_0.X enable_i 0.02769f
C307 VDD a_26638_15423# 0.14479f
C308 sg13g2_dfrbpq_1_2.Q a_18021_14495# 0.02182f
C309 sg13g2_dfrbpq_1_3.RESET_B a_18863_14845# 0.07576f
C310 sg13g2_xnor2_1_1.A sg13g2_buf_16_2.A 0.03403f
C311 counter_value_o[1] clock_i 0.04067f
C312 sg13g2_dfrbpq_1_6.RESET_B a_20774_14922# 0.07618f
C313 a_5504_14570# VDD 0.08231f
C314 sg13g2_or3_1_1.X a_25094_15238# 0.06671f
C315 sg13g2_dfrbpq_1_2.CLK a_9444_15552# 0.07991f
C316 a_21477_14495# a_21579_14495# 0.27006f
C317 sg13g2_xnor2_1_2.B a_6202_15238# 0.01833f
C318 a_4078_14751# a_4193_14750# 0.32411f
C319 a_25930_14452# a_26373_14495# 0.02242f
C320 sg13g2_dlygate4sd3_1_8.X a_8312_15238# 0.01655f
C321 sg13g2_xor2_1_0.B a_4078_14751# 0.09774f
C322 a_26633_16334# a_26757_16033# 0.06917f
C323 a_25956_14488# sg13g2_a21oi_1_3.Y 0.02684f
C324 a_22304_16082# VDD 0.07462f
C325 a_22319_14845# a_22986_14484# 0.06982f
C326 a_27882_14484# sg13g2_dfrbpq_1_7.Q 0.09063f
C327 sg13g2_dlygate4sd3_1_17.A sg13g2_a21oi_1_3.A2 0.04163f
C328 a_26475_14495# sg13g2_dfrbpq_1_5.RESET_B 0.02486f
C329 a_9963_15356# a_10960_15454# 0.01528f
C330 sg13g2_or3_1_1.X sg13g2_a21oi_1_3.Y 0.01181f
C331 a_25786_15960# sg13g2_dfrbpq_1_7.RESET_B 0.02937f
C332 sg13g2_dfrbpq_1_2.RESET_B sg13g2_dfrbpq_1_2.D 0.12609f
C333 a_17584_13942# a_16587_13844# 0.01528f
C334 a_21579_14495# sg13g2_or3_1_2.C 0.03172f
C335 sg13g2_or3_1_1.B a_16760_15238# 0.01488f
C336 sg13g2_dfrbpq_1_7.RESET_B sg13g2_buf_16_2.X 0.06075f
C337 sg13g2_dlygate4sd3_1_5.A VDD 0.28965f
C338 VDD a_26753_15424# 0.19793f
C339 VDD a_21185_15424# 0.19698f
C340 sg13g2_dfrbpq_1_2.CLK a_6372_14488# 0.08448f
C341 sg13g2_xnor2_1_2.A a_6575_13342# 0.01685f
C342 a_21827_13690# sg13g2_or3_1_2.X 0.10895f
C343 sg13g2_or3_1_2.B sg13g2_or3_1_2.A 0.3284f
C344 a_27472_14726# sg13g2_dfrbpq_1_7.RESET_B 0.0605f
C345 sg13g2_a21oi_1_1.Y a_20603_15532# 0.08543f
C346 a_20774_14922# a_21477_14495# 0.02432f
C347 sg13g2_or3_1_2.B a_17710_15423# 0.02518f
C348 sg13g2_a21oi_1_1.Y sg13g2_dfrbpq_1_6.RESET_B 0.11318f
C349 sg13g2_buf_1_10.X sg13g2_dlygate4sd3_1_0.X 0.04143f
C350 sg13g2_or3_1_1.A VDD 0.44648f
C351 a_15782_13722# a_16485_13701# 0.02454f
C352 sg13g2_or3_1_1.B a_15022_14484# 0.02919f
C353 a_19438_13726# VDD 1.62673f
C354 sg13g2_buf_1_0.X sg13g2_dfrbpq_1_0.RESET_B 0.03161f
C355 a_4432_15454# sg13g2_dfrbpq_1_0.RESET_B 0.06226f
C356 sg13g2_and2_1_1.X a_6086_14922# 0.16141f
C357 sg13g2_dfrbpq_1_5.Q VDD 2.06714f
C358 a_4432_15454# VDD 0.13137f
C359 sg13g2_buf_1_0.X VDD 3.3943f
C360 sg13g2_buf_1_10.X a_1192_9948# 0.13353f
C361 a_9158_15234# a_9963_15356# 0.06896f
C362 a_17710_15423# a_17825_15424# 0.32411f
C363 a_9444_15552# a_9861_15213# 0.22605f
C364 sg13g2_dfrbpq_1_7.RESET_B sg13g2_dfrbpq_1_6.Q 0.01922f
C365 a_18863_14845# VDD 0.1976f
C366 a_25390_16263# a_25505_16262# 0.32411f
C367 sg13g2_dlygate4sd3_1_4.X a_18021_14495# 0.03797f
C368 sg13g2_dfrbpq_1_2.RESET_B clock_i 0.01197f
C369 a_24841_13726# sg13g2_a21oi_1_3.A1 0.05013f
C370 sg13g2_a21oi_1_0.B1 sg13g2_o21ai_1_3.Y 0.33043f
C371 a_20774_14922# sg13g2_or3_1_2.C 0.01787f
C372 a_4842_15532# sg13g2_dlygate4sd3_1_3.A 0.11616f
C373 sg13g2_a21oi_1_0.B1 sg13g2_o21ai_1_2.B1 0.01843f
C374 sg13g2_xnor2_1_2.A a_6086_14922# 0.01665f
C375 sg13g2_dfrbpq_1_3.D sg13g2_a21oi_1_0.A1 0.27735f
C376 VDD sg13g2_o21ai_1_2.Y 0.3127f
C377 sg13g2_buf_16_2.X sg13g2_o21ai_1_1.Y 0.19101f
C378 sg13g2_buf_1_10.X sg13g2_tiehi_1.L_HI 0.03108f
C379 sg13g2_xnor2_1_2.A sg13g2_dlygate4sd3_1_8.X 0.01603f
C380 a_25930_14452# VDD 0.09582f
C381 a_17994_14020# VDD 0.24448f
C382 a_9158_15234# sg13g2_and2_1_2.B 0.01717f
C383 sg13g2_xnor2_1_2.A a_6789_14495# 0.02671f
C384 a_15782_13722# VDD 0.45225f
C385 sg13g2_dlygate4sd3_1_17.A a_24824_15238# 0.05853f
C386 sg13g2_dfrbpq_1_2.Q sg13g2_o21ai_1_1.Y 0.01062f
C387 sg13g2_dfrbpq_1_6.Q a_27617_15424# 0.04448f
C388 a_16556_15960# sg13g2_xnor2_1_1.A 0.0515f
C389 sg13g2_dlygate4sd3_1_12.X VDD 0.17031f
C390 sg13g2_dfrbpq_1_2.RESET_B sg13g2_xnor2_1_1.A 0.03753f
C391 a_21166_16263# sg13g2_dfrbpq_1_6.D 0.08802f
C392 sg13g2_or3_1_1.C VDD 0.83377f
C393 sg13g2_dfrbpq_1_1.RESET_B sg13g2_and2_1_1.X 0.03772f
C394 sg13g2_dfrbpq_1_2.RESET_B sg13g2_buf_16_2.A 0.17124f
C395 a_8582_15238# a_8694_15302# 0.32411f
C396 a_21579_14495# sg13g2_buf_16_2.X 0.02276f
C397 a_2916_15552# a_4175_15311# 0.01303f
C398 sg13g2_or3_1_1.X a_25206_14508# 0.02512f
C399 a_15722_15532# sg13g2_dfrbpq_1_2.D 0.01398f
C400 sg13g2_dfrbpq_1_7.RESET_B a_25889_15424# 0.07137f
C401 a_17233_13799# sg13g2_a21oi_1_0.A1 0.01852f
C402 a_18021_14495# a_18123_14495# 0.27006f
C403 a_25203_13320# sg13g2_a21oi_1_3.A1 0.01166f
C404 a_10618_14448# a_10337_14750# 0.15158f
C405 sg13g2_dfrbpq_1_1.RESET_B sg13g2_xnor2_1_2.A 0.03758f
C406 sg13g2_nand4_1_0.Y a_9444_15552# 0.01007f
C407 a_10618_14448# VDD 0.26808f
C408 a_22576_14726# a_22986_14484# 0.05221f
C409 a_3333_16033# VDD 0.069f
C410 a_19054_15423# a_19169_15424# 0.32411f
C411 sg13g2_or3_1_2.B a_16760_15238# 0.02231f
C412 a_7631_14845# a_8298_14484# 0.06982f
C413 sg13g2_buf_16_2.A sg13g2_a21oi_1_0.A1 0.0438f
C414 sg13g2_or3_1_2.X a_21466_15202# 0.01436f
C415 a_20774_14922# sg13g2_buf_16_2.X 0.0492f
C416 sg13g2_or3_1_2.B a_18454_15230# 0.06996f
C417 sg13g2_a21oi_1_0.B1 sg13g2_dlygate4sd3_1_11.X 0.12026f
C418 a_18176_16082# VDD 0.07203f
C419 sg13g2_dlygate4sd3_1_8.X a_7262_15242# 0.01764f
C420 sg13g2_dfrbpq_1_2.CLK sg13g2_xnor2_1_2.B 0.02517f
C421 sg13g2_dlygate4sd3_1_8.A sg13g2_dfrbpq_1_2.CLK 0.21826f
C422 sg13g2_dfrbpq_1_2.CLK a_16760_15238# 0.01208f
C423 sg13g2_dfrbpq_1_7.Q sg13g2_or3_1_1.A 0.07212f
C424 a_5896_13854# VDD 0.13424f
C425 a_6891_14495# a_6086_14922# 0.06896f
C426 sg13g2_dfrbpq_1_2.CLK sg13g2_dlygate4sd3_1_1.A 0.23936f
C427 sg13g2_dfrbpq_1_7.Q sg13g2_dfrbpq_1_5.Q 0.32979f
C428 sg13g2_dlygate4sd3_1_8.A a_12020_15202# 0.03257f
C429 sg13g2_buf_1_0.X sg13g2_buf_1_10.X 0.09818f
C430 sg13g2_dfrbpq_1_2.CLK a_15022_14484# 0.02126f
C431 a_20218_15238# sg13g2_or3_1_2.C 0.01856f
C432 a_6401_13912# a_6682_13690# 0.15158f
C433 a_24824_14525# VDD 0.24767f
C434 a_6789_14495# a_6891_14495# 0.27006f
C435 a_17318_14922# a_18021_14495# 0.02432f
C436 sg13g2_o21ai_1_3.Y VDD 0.47829f
C437 sg13g2_o21ai_1_2.B1 VDD 0.38273f
C438 a_26148_14040# sg13g2_buf_16_2.X 0.04569f
C439 a_27215_14845# VDD 0.17504f
C440 a_25774_15423# a_25889_15424# 0.32411f
C441 sg13g2_buf_1_0.X a_7160_15242# 0.01372f
C442 sg13g2_dlygate4sd3_1_8.A a_9861_15213# 0.01043f
C443 sg13g2_a21oi_1_0.B1 a_20603_15532# 0.0369f
C444 sg13g2_a21oi_1_0.B1 sg13g2_dfrbpq_1_6.RESET_B 0.07941f
C445 a_9732_15247# a_9158_15234# 0.16388f
C446 sg13g2_dlygate4sd3_1_17.A sg13g2_buf_16_2.X 0.02642f
C447 a_4193_14750# VDD 0.19937f
C448 a_26753_15424# a_27034_15202# 0.15158f
C449 sg13g2_xor2_1_0.B VDD 0.46418f
C450 sg13g2_a21oi_1_3.A1 sg13g2_dfrbpq_1_7.D 0.06727f
C451 sg13g2_dfrbpq_1_7.RESET_B a_25670_14922# 0.07529f
C452 sg13g2_dfrbpq_1_5.RESET_B sg13g2_dfrbpq_1_5.D 0.05658f
C453 a_21185_15424# a_21466_15202# 0.15158f
C454 sg13g2_dfrbpq_1_6.D sg13g2_or3_1_2.X 0.03748f
C455 a_2540_15960# sg13g2_dlygate4sd3_1_3.A 0.16437f
C456 a_16254_15934# sg13g2_or3_1_2.B 0.02856f
C457 a_38720_13058# VDD 0.0803f
C458 sg13g2_or3_1_1.A a_27034_15202# 0.04651f
C459 a_6080_13854# sg13g2_dlygate4sd3_1_0.X 0.01464f
C460 sg13g2_dfrbpq_1_1.RESET_B a_6891_14495# 0.2147f
C461 sg13g2_nand3_1_0.Y sg13g2_dlygate4sd3_1_3.A 0.01196f
C462 a_17219_16265# sg13g2_a21oi_1_0.A2 0.1092f
C463 sg13g2_or3_1_1.B sg13g2_o21ai_1_1.Y 0.01267f
C464 sg13g2_dlygate4sd3_1_6.X a_17900_15960# 0.01332f
C465 sg13g2_dfrbpq_1_5.RESET_B a_26667_13844# 0.22075f
C466 a_1856_14570# VDD 0.08194f
C467 sg13g2_dlygate4sd3_1_17.A sg13g2_dfrbpq_1_6.Q 0.01208f
C468 a_21034_14452# sg13g2_or3_1_2.A 0.01483f
C469 sg13g2_or3_1_2.B a_18021_14495# 0.01076f
C470 a_9418_15457# VDD 0.09803f
C471 a_27215_14845# a_27121_14845# 0.15029f
C472 a_4432_15454# a_4842_15532# 0.05221f
C473 a_4842_15532# sg13g2_buf_1_0.X 0.01195f
C474 a_21946_16237# a_22149_16033# 0.01313f
C475 sg13g2_or3_1_1.A a_25094_15238# 0.02127f
C476 a_3333_15213# sg13g2_dfrbpq_1_2.CLK 0.15276f
C477 sg13g2_dfrbpq_1_2.Q a_19232_13854# 0.02104f
C478 sg13g2_dfrbpq_1_2.RESET_B sg13g2_a21oi_1_0.A1 0.02004f
C479 sg13g2_dlygate4sd3_1_0.A a_6575_13342# 0.03578f
C480 sg13g2_dlygate4sd3_1_1.A a_8298_14484# 0.08812f
C481 a_21060_14488# sg13g2_o21ai_1_1.Y 0.02926f
C482 sg13g2_dfrbpq_1_2.D a_15022_14484# 0.07177f
C483 a_17219_16265# VDD 0.22747f
C484 a_18863_14845# a_19530_14484# 0.06982f
C485 a_32492_15960# VDD 0.19922f
C486 sg13g2_dfrbpq_1_3.RESET_B a_18106_15202# 0.06785f
C487 a_18021_14495# a_17892_14909# 0.01562f
C488 a_17604_14488# sg13g2_buf_16_2.X 0.04763f
C489 sg13g2_buf_1_10.X a_10618_14448# 0.01705f
C490 sg13g2_nor2_1_0.B a_16044_15424# 0.11846f
C491 sg13g2_dfrbpq_1_2.CLK a_10960_15454# 0.01154f
C492 counter_value_o[5] VDD 0.11349f
C493 sg13g2_a21oi_1_0.B1 sg13g2_or3_1_2.C 0.12242f
C494 a_9737_14822# a_9861_14521# 0.06917f
C495 sg13g2_dfrbpq_1_2.CLK a_4474_14448# 0.01336f
C496 sg13g2_dlygate4sd3_1_8.A clock_i 0.05566f
C497 a_26436_13735# a_26148_14040# 0.22255f
C498 sg13g2_dlygate4sd3_1_11.X VDD 0.17474f
C499 sg13g2_or3_1_1.A sg13g2_a21oi_1_3.Y 0.01825f
C500 sg13g2_dfrbpq_1_3.Q sg13g2_or3_1_1.C 0.07492f
C501 sg13g2_or3_1_1.X sg13g2_or3_1_1.A 0.5864f
C502 a_26554_16237# VDD 0.09432f
C503 VDD a_26170_15202# 0.24724f
C504 sg13g2_dlygate4sd3_1_8.A sg13g2_nand4_1_0.Y 0.02951f
C505 sg13g2_dfrbpq_1_2.Q a_17604_14488# 0.01326f
C506 sg13g2_dlygate4sd3_1_0.A a_6280_13058# 0.01641f
C507 a_6280_13058# VDD 0.15641f
C508 sg13g2_dfrbpq_1_3.RESET_B a_19120_14726# 0.0605f
C509 sg13g2_a21oi_1_3.A2 VDD 0.33856f
C510 a_6086_14922# VDD 0.44588f
C511 clock_i a_15022_14484# 0.36193f
C512 sg13g2_nand4_1_0.Y sg13g2_dlygate4sd3_1_1.A 0.05609f
C513 sg13g2_dlygate4sd3_1_8.X VDD 0.48669f
C514 a_4081_15311# sg13g2_buf_1_0.X 0.01018f
C515 sg13g2_dfrbpq_1_5.D sg13g2_a21oi_1_3.A1 0.0952f
C516 a_21477_14495# a_21348_14909# 0.01562f
C517 a_21060_14488# a_21579_14495# 0.18362f
C518 sg13g2_or3_1_1.B sg13g2_a21oi_1_0.Y 0.0255f
C519 a_25930_14452# a_25956_14488# 0.21121f
C520 sg13g2_dlygate4sd3_1_8.X a_7680_15549# 0.10539f
C521 a_26633_16334# a_26554_16237# 0.08074f
C522 a_25930_14452# sg13g2_a21oi_1_3.Y 0.04526f
C523 a_16955_12972# sg13g2_a21oi_1_0.A1 0.0581f
C524 a_6789_14495# VDD 0.24443f
C525 a_27215_14845# sg13g2_dfrbpq_1_7.Q 0.0476f
C526 a_5687_15315# a_5687_15549# 0.06917f
C527 a_5886_15486# sg13g2_dfrbpq_1_1.RESET_B 0.03904f
C528 a_26244_14909# sg13g2_dfrbpq_1_5.RESET_B 0.01677f
C529 a_9963_15356# a_10703_15311# 0.15395f
C530 a_22025_16334# a_22149_16033# 0.06917f
C531 a_17327_13799# a_16587_13844# 0.15395f
C532 a_18106_15202# VDD 0.27413f
C533 VDD a_20603_15532# 0.1404f
C534 sg13g2_dfrbpq_1_2.CLK a_6346_14452# 0.01501f
C535 sg13g2_dfrbpq_1_6.RESET_B VDD 1.10538f
C536 sg13g2_xnor2_1_1.A a_18454_15230# 0.05333f
C537 a_26475_14495# sg13g2_dfrbpq_1_7.RESET_B 0.21427f
C538 a_20774_14922# a_21060_14488# 0.21832f
C539 sg13g2_or3_1_2.B a_17142_15302# 0.01737f
C540 a_21562_15960# sg13g2_dfrbpq_1_6.RESET_B 0.03886f
C541 sg13g2_xor2_1_0.B sg13g2_buf_1_10.X 2.35712f
C542 a_15782_13722# a_16068_14040# 0.21832f
C543 sg13g2_o21ai_1_2.A2 a_23480_15242# 0.01564f
C544 a_18874_13690# VDD 0.336f
C545 sg13g2_dlygate4sd3_1_12.X sg13g2_or3_1_1.X 0.12937f
C546 a_4175_15311# sg13g2_dfrbpq_1_0.RESET_B 0.07619f
C547 a_4175_15311# VDD 0.1793f
C548 a_37192_16082# VDD 0.15602f
C549 sg13g2_or3_1_2.B sg13g2_o21ai_1_1.Y 0.01815f
C550 sg13g2_buf_16_2.A a_15022_14484# 0.93576f
C551 a_9158_15234# a_9861_15213# 0.02454f
C552 a_19120_14726# VDD 0.13612f
C553 a_22508_15960# counter_value_o[4] 0.13349f
C554 sg13g2_dlygate4sd3_1_4.X a_17604_14488# 0.01684f
C555 a_20278_14862# sg13g2_or3_1_2.C 0.07436f
C556 a_21824_15366# sg13g2_or3_1_2.A 0.01244f
C557 a_4432_15454# sg13g2_dlygate4sd3_1_3.A 0.05805f
C558 sg13g2_buf_1_0.X sg13g2_dlygate4sd3_1_3.A 0.47572f
C559 sg13g2_a21oi_1_0.B1 sg13g2_buf_16_2.X 0.03661f
C560 sg13g2_dfrbpq_1_1.RESET_B VDD 1.0757f
C561 sg13g2_buf_1_10.X a_1856_14570# 0.01077f
C562 a_17710_15423# sg13g2_a21oi_1_0.A1 0.08833f
C563 VDD a_24824_15238# 0.25559f
C564 a_21477_14495# VDD 0.25001f
C565 a_8218_13690# sg13g2_dlygate4sd3_1_1.A 0.24826f
C566 a_7937_13912# a_8218_13690# 0.15158f
C567 a_17584_13942# VDD 0.12991f
C568 sg13g2_xor2_1_0.B a_6660_14909# 0.02302f
C569 sg13g2_dlygate4sd3_1_1.A counter_value_o[1] 0.01004f
C570 a_32492_15960# sg13g2_dfrbpq_1_7.Q 0.16111f
C571 sg13g2_a21oi_1_0.B1 sg13g2_dfrbpq_1_2.Q 0.48521f
C572 sg13g2_a21oi_1_0.B1 sg13g2_dfrbpq_1_6.Q 0.05405f
C573 a_15680_13854# VDD 0.09228f
C574 VDD sg13g2_or3_1_2.C 0.52101f
C575 sg13g2_dfrbpq_1_2.Q a_22030_15423# 0.01328f
C576 sg13g2_dfrbpq_1_6.Q a_27502_15423# 0.05691f
C577 sg13g2_dfrbpq_1_5.Q counter_value_o[7] 0.01279f
C578 a_27500_15960# counter_value_o[5] 0.13339f
C579 a_26373_14495# sg13g2_buf_16_2.X 0.18647f
C580 sg13g2_buf_1_0.X sg13g2_nand3_1_0.Y 0.1661f
C581 a_26565_13701# a_26667_13844# 0.26919f
C582 a_26170_16237# sg13g2_dfrbpq_1_7.RESET_B 0.03978f
C583 sg13g2_or3_1_1.X sg13g2_o21ai_1_3.Y 0.02772f
C584 sg13g2_or3_1_1.B a_17604_14488# 0.01152f
C585 a_27215_14845# a_25956_14488# 0.01303f
C586 sg13g2_dlygate4sd3_1_8.X sg13g2_buf_1_10.X 0.01594f
C587 sg13g2_and2_1_0.X sg13g2_dfrbpq_1_0.RESET_B 0.0393f
C588 a_7631_14845# a_6372_14488# 0.01303f
C589 sg13g2_o21ai_1_2.B1 sg13g2_a21oi_1_3.Y 0.04338f
C590 sg13g2_or3_1_2.B a_20774_14922# 0.01258f
C591 a_16587_13844# sg13g2_dfrbpq_1_2.CLK 0.04115f
C592 sg13g2_and2_1_0.X VDD 0.27413f
C593 a_17604_14488# a_18123_14495# 0.18362f
C594 sg13g2_and2_1_2.X VDD 0.28425f
C595 sg13g2_or3_1_1.X sg13g2_o21ai_1_2.B1 0.01957f
C596 a_10222_14751# a_10337_14750# 0.32411f
C597 sg13g2_dfrbpq_1_2.CLK sg13g2_a21oi_1_0.Y 0.60224f
C598 sg13g2_buf_1_10.X a_6789_14495# 0.01337f
C599 a_10222_14751# VDD 0.14578f
C600 a_22576_14726# a_22319_14845# 0.20069f
C601 a_3008_16082# VDD 0.06492f
C602 sg13g2_dfrbpq_1_7.RESET_B sg13g2_dfrbpq_1_7.D 0.07044f
C603 sg13g2_or3_1_2.B a_16044_15424# 0.2091f
C604 a_7888_14726# a_8298_14484# 0.05221f
C605 sg13g2_or3_1_2.X a_21185_15424# 0.01085f
C606 sg13g2_dfrbpq_1_3.Q sg13g2_dlygate4sd3_1_11.X 0.01024f
C607 sg13g2_dlygate4sd3_1_6.X sg13g2_dlygate4sd3_1_5.A 0.24582f
C608 sg13g2_dfrbpq_1_2.Q sg13g2_dfrbpq_1_3.RESET_B 0.18375f
C609 a_17142_15302# sg13g2_dfrbpq_1_3.D 0.0915f
C610 sg13g2_a21oi_1_0.B1 sg13g2_dlygate4sd3_1_4.X 0.02267f
C611 a_18298_16237# a_18501_16033# 0.01313f
C612 sg13g2_dlygate4sd3_1_12.X a_25025_16344# 0.0127f
C613 a_6286_13911# sg13g2_dlygate4sd3_1_0.A 0.021f
C614 a_6660_14909# a_6086_14922# 0.16388f
C615 a_6286_13911# VDD 0.14438f
C616 sg13g2_dfrbpq_1_2.RESET_B a_15022_14484# 0.05771f
C617 sg13g2_a21oi_1_0.B1 sg13g2_nor2_1_0.B 0.04488f
C618 a_9658_14725# a_9861_14521# 0.01313f
C619 a_21827_13690# sg13g2_or3_1_2.C 0.1542f
C620 sg13g2_dlygate4sd3_1_8.A a_11370_15532# 0.08686f
C621 a_26638_15423# a_26753_15424# 0.32411f
C622 a_3209_16334# a_3130_16237# 0.08074f
C623 a_5896_13854# a_6080_13854# 0.0262f
C624 a_24169_14508# VDD 0.23388f
C625 a_6789_14495# a_6660_14909# 0.01562f
C626 a_17318_14922# a_17604_14488# 0.21832f
C627 sg13g2_or3_1_1.A a_26638_15423# 0.01019f
C628 a_25786_15960# VDD 0.2497f
C629 sg13g2_dfrbpq_1_2.CLK a_8312_15238# 0.01097f
C630 sg13g2_buf_16_2.X VDD 2.1036f
C631 sg13g2_dfrbpq_1_1.RESET_B sg13g2_buf_1_10.X 0.02446f
C632 sg13g2_o21ai_1_2.A2 a_23638_14862# 0.08448f
C633 a_22426_15202# VDD 0.27122f
C634 a_27472_14726# VDD 0.127f
C635 sg13g2_dfrbpq_1_6.RESET_B sg13g2_dfrbpq_1_3.Q 0.02974f
C636 a_3333_15213# a_2890_15457# 0.02242f
C637 sg13g2_dlygate4sd3_1_8.A a_9444_15552# 0.02595f
C638 a_38720_3986# VDD 0.0582f
C639 sg13g2_xor2_1_0.B sg13g2_and2_1_0.B 0.0645f
C640 sg13g2_xnor2_1_2.B a_6540_13238# 0.20886f
C641 a_3872_14570# VDD 0.09046f
C642 sg13g2_dfrbpq_1_2.Q VDD 1.33956f
C643 a_25774_15423# sg13g2_dfrbpq_1_7.D 0.08839f
C644 sg13g2_dfrbpq_1_6.RESET_B a_21466_15202# 0.01464f
C645 sg13g2_dfrbpq_1_6.Q VDD 0.75651f
C646 a_17318_14922# a_17578_14452# 0.39302f
C647 sg13g2_dlygate4sd3_1_4.X sg13g2_dfrbpq_1_3.RESET_B 0.17879f
C648 sg13g2_or3_1_1.B a_17030_15238# 0.01124f
C649 sg13g2_a21oi_1_0.B1 sg13g2_or3_1_1.B 0.09638f
C650 a_26170_15202# sg13g2_a21oi_1_3.Y 0.23489f
C651 a_16254_15934# sg13g2_dfrbpq_1_2.RESET_B 0.04276f
C652 a_25109_12972# VDD 0.17892f
C653 sg13g2_or3_1_1.A a_26753_15424# 0.01588f
C654 a_5896_13854# sg13g2_dlygate4sd3_1_0.X 0.01651f
C655 sg13g2_xor2_1_0.B sg13g2_dlygate4sd3_1_3.A 0.04261f
C656 sg13g2_dfrbpq_1_2.CLK sg13g2_and2_1_1.X 0.02068f
C657 sg13g2_dfrbpq_1_6.D sg13g2_dlygate4sd3_1_11.X 0.10897f
C658 a_9963_15356# VDD 0.20509f
C659 sg13g2_xnor2_1_2.B a_6372_14488# 0.03107f
C660 sg13g2_or3_1_2.B a_23638_14862# 0.05378f
C661 a_2490_14447# VDD 0.17088f
C662 sg13g2_dfrbpq_1_5.RESET_B a_26565_13701# 0.03093f
C663 sg13g2_dlygate4sd3_1_1.A a_6372_14488# 0.03089f
C664 sg13g2_or3_1_2.B a_17604_14488# 0.0296f
C665 a_27215_14845# a_27882_14484# 0.06982f
C666 a_2890_15457# a_2630_15234# 0.39302f
C667 sg13g2_dlygate4sd3_1_4.X sg13g2_a21oi_1_0.A2 0.07378f
C668 a_4175_15311# a_4842_15532# 0.06982f
C669 sg13g2_a21oi_1_0.B1 a_25670_14922# 0.01363f
C670 a_2916_15552# sg13g2_dfrbpq_1_2.CLK 0.06831f
C671 a_3333_15213# a_3435_15356# 0.26919f
C672 sg13g2_dfrbpq_1_2.CLK sg13g2_xnor2_1_2.A 0.07286f
C673 sg13g2_and2_1_0.X sg13g2_buf_1_10.X 0.04308f
C674 sg13g2_dlygate4sd3_1_1.A a_7631_14845# 0.04253f
C675 sg13g2_and2_1_2.X sg13g2_buf_1_10.X 0.02114f
C676 sg13g2_and2_1_2.B VDD 0.20849f
C677 a_19120_14726# a_19530_14484# 0.05221f
C678 sg13g2_and2_1_2.X a_8685_14832# 0.06173f
C679 a_17604_14488# a_17892_14909# 0.22255f
C680 sg13g2_dfrbpq_1_3.Q sg13g2_or3_1_2.C 0.15452f
C681 sg13g2_buf_1_10.X a_10222_14751# 0.01416f
C682 sg13g2_or3_1_1.A sg13g2_o21ai_1_2.Y 0.03611f
C683 sg13g2_dfrbpq_1_2.CLK a_10703_15311# 0.01584f
C684 a_16042_13945# sg13g2_a21oi_1_0.B1 0.0142f
C685 sg13g2_dfrbpq_1_2.CLK a_4078_14751# 0.01385f
C686 a_27664_13942# a_26667_13844# 0.01528f
C687 a_26436_13735# a_25862_13722# 0.16388f
C688 a_19450_15202# VDD 0.26028f
C689 sg13g2_dlygate4sd3_1_4.X VDD 0.54414f
C690 a_24824_15238# a_25094_15238# 0.15158f
C691 a_26373_16033# VDD 0.06591f
C692 a_10960_15454# a_11370_15532# 0.05221f
C693 sg13g2_dfrbpq_1_6.D sg13g2_dfrbpq_1_6.RESET_B 0.46378f
C694 sg13g2_or3_1_1.B sg13g2_dfrbpq_1_3.RESET_B 0.01529f
C695 VDD a_25889_15424# 0.19721f
C696 sg13g2_nor2_1_0.B VDD 0.26793f
C697 sg13g2_dfrbpq_1_3.RESET_B a_18123_14495# 0.22918f
C698 sg13g2_dlygate4sd3_1_8.X a_10016_14570# 0.01244f
C699 a_3435_15356# a_2630_15234# 0.06896f
C700 a_4175_15311# a_4081_15311# 0.15029f
C701 a_25094_14484# sg13g2_a21oi_1_3.A1 0.01721f
C702 sg13g2_xnor2_1_1.A sg13g2_a21oi_1_0.Y 0.01109f
C703 a_21060_14488# a_21348_14909# 0.22255f
C704 sg13g2_or3_1_1.C sg13g2_or3_1_1.A 0.15198f
C705 a_25670_14922# a_26373_14495# 0.02432f
C706 sg13g2_dfrbpq_1_7.Q sg13g2_buf_16_2.X 0.1299f
C707 sg13g2_buf_16_2.A sg13g2_a21oi_1_0.Y 0.04908f
C708 sg13g2_or3_1_1.X a_24824_15238# 0.01443f
C709 a_27472_14726# sg13g2_dfrbpq_1_7.Q 0.01866f
C710 sg13g2_or3_1_1.B sg13g2_a21oi_1_0.A2 0.02103f
C711 a_5687_15315# a_5600_15366# 0.01514f
C712 a_5886_15486# a_5687_15549# 0.08074f
C713 a_22025_16334# a_21946_16237# 0.08074f
C714 sg13g2_xnor2_1_1.A a_16044_15424# 0.08401f
C715 a_22508_15960# VDD 0.19766f
C716 sg13g2_o21ai_1_2.B1 a_26638_15423# 0.0886f
C717 sg13g2_buf_16_2.A a_16044_15424# 0.04329f
C718 sg13g2_or3_1_1.C sg13g2_o21ai_1_2.Y 0.11919f
C719 sg13g2_dfrbpq_1_7.Q sg13g2_dfrbpq_1_6.Q 0.03786f
C720 counter_value_o[3] VDD 0.07567f
C721 a_20774_14922# a_21034_14452# 0.39302f
C722 sg13g2_or3_1_2.B a_17030_15238# 0.02338f
C723 a_21166_16263# sg13g2_dfrbpq_1_6.RESET_B 0.02076f
C724 sg13g2_a21oi_1_0.B1 sg13g2_or3_1_2.B 0.22888f
C725 a_16042_13945# a_16485_13701# 0.02242f
C726 sg13g2_dfrbpq_1_3.RESET_B a_17318_14922# 0.112f
C727 a_18593_13912# VDD 0.23617f
C728 a_9418_15457# sg13g2_tiehi_1.L_HI 0.138f
C729 a_37484_15960# VDD 0.19691f
C730 sg13g2_or3_1_1.B VDD 1.64825f
C731 sg13g2_dfrbpq_1_2.CLK a_6891_14495# 0.02411f
C732 sg13g2_dfrbpq_1_6.D sg13g2_or3_1_2.C 0.01739f
C733 a_9158_15234# a_9444_15552# 0.21832f
C734 a_18123_14495# VDD 0.22246f
C735 a_27500_15960# sg13g2_dfrbpq_1_6.Q 0.16405f
C736 sg13g2_a21oi_1_0.B1 sg13g2_dfrbpq_1_2.CLK 1.22373f
C737 a_22149_16033# counter_value_o[4] 0.01278f
C738 sg13g2_dfrbpq_1_3.Q sg13g2_buf_16_2.X 0.01184f
C739 sg13g2_dfrbpq_1_3.Q a_22426_15202# 0.0308f
C740 a_4175_15311# sg13g2_dlygate4sd3_1_3.A 0.04306f
C741 a_5687_15549# VDD 0.08388f
C742 sg13g2_buf_1_10.X a_2490_14447# 0.01683f
C743 sg13g2_nand3_1_0.Y a_6680_15242# 0.01426f
C744 sg13g2_dfrbpq_1_7.RESET_B sg13g2_dfrbpq_1_5.RESET_B 0.07505f
C745 sg13g2_dlygate4sd3_1_8.X sg13g2_nand3_1_0.Y 0.31485f
C746 VDD a_24408_15552# 0.01765f
C747 a_21060_14488# VDD 0.07328f
C748 sg13g2_a21oi_1_0.A2 a_17318_14922# 0.01109f
C749 a_7937_13912# sg13g2_dlygate4sd3_1_1.A 0.02054f
C750 sg13g2_or3_1_1.A a_24824_14525# 0.05649f
C751 sg13g2_or3_1_2.B a_18769_14845# 0.01335f
C752 a_25670_14922# VDD 0.44677f
C753 a_22145_15424# a_22030_15423# 0.32411f
C754 a_21824_15366# sg13g2_o21ai_1_1.Y 0.01624f
C755 a_17327_13799# VDD 0.17791f
C756 sg13g2_dfrbpq_1_1.RESET_B sg13g2_dlygate4sd3_1_3.A 0.1263f
C757 sg13g2_o21ai_1_3.Y sg13g2_or3_1_1.A 0.19466f
C758 sg13g2_dfrbpq_1_2.Q sg13g2_dfrbpq_1_3.Q 2.57192f
C759 a_17219_16265# sg13g2_dlygate4sd3_1_6.X 0.1855f
C760 a_3435_15356# a_3204_15247# 0.06628f
C761 a_7240_16082# counter_value_o[1] 0.02118f
C762 sg13g2_dfrbpq_1_6.Q sg13g2_dfrbpq_1_3.Q 0.14356f
C763 sg13g2_dlygate4sd3_1_8.X a_7829_15238# 0.01415f
C764 sg13g2_o21ai_1_2.B1 sg13g2_or3_1_1.A 0.02645f
C765 sg13g2_xnor2_1_2.A sg13g2_nand4_1_0.Y 0.05046f
C766 sg13g2_buf_1_10.X sg13g2_and2_1_2.B 0.16567f
C767 sg13g2_dfrbpq_1_5.RESET_B a_27664_13942# 0.06198f
C768 sg13g2_dlygate4sd3_1_11.X sg13g2_or3_1_2.X 0.13838f
C769 a_16042_13945# VDD 0.09632f
C770 a_8685_14832# sg13g2_and2_1_2.B 0.14585f
C771 VDD a_20000_15366# 0.07189f
C772 sg13g2_buf_16_2.X a_19530_14484# 0.01377f
C773 sg13g2_dfrbpq_1_6.Q a_27034_15202# 0.01444f
C774 sg13g2_dlygate4sd3_1_8.X sg13g2_tiehi_1.L_HI 0.06927f
C775 sg13g2_or3_1_2.B sg13g2_dfrbpq_1_3.RESET_B 0.02356f
C776 a_37192_16082# counter_value_o[7] 0.02118f
C777 a_24824_14525# sg13g2_o21ai_1_2.Y 0.01214f
C778 a_17318_14922# VDD 0.45251f
C779 a_6346_14452# a_6372_14488# 0.21121f
C780 sg13g2_o21ai_1_3.Y sg13g2_o21ai_1_2.Y 0.06434f
C781 sg13g2_buf_1_0.X sg13g2_xor2_1_0.B 0.42323f
C782 a_16587_13844# sg13g2_dfrbpq_1_2.RESET_B 0.2153f
C783 a_25956_14488# sg13g2_buf_16_2.X 0.09231f
C784 sg13g2_o21ai_1_2.B1 sg13g2_o21ai_1_2.Y 0.50117f
C785 sg13g2_dfrbpq_1_3.RESET_B a_17825_15424# 0.01582f
C786 a_26148_14040# a_26667_13844# 0.18372f
C787 a_8312_15238# sg13g2_xnor2_1_0.Y 0.24455f
C788 clock_i counter_value_o[0] 0.04192f
C789 sg13g2_or3_1_2.B a_16218_15532# 0.01256f
C790 sg13g2_dfrbpq_1_2.Q a_19530_14484# 0.01127f
C791 sg13g2_and2_1_0.X sg13g2_and2_1_0.B 0.24209f
C792 a_26554_16237# a_26757_16033# 0.01313f
C793 sg13g2_o21ai_1_2.A2 VDD 0.49437f
C794 sg13g2_buf_16_2.X sg13g2_a21oi_1_3.Y 0.05642f
C795 sg13g2_dfrbpq_1_2.RESET_B sg13g2_a21oi_1_0.Y 0.01245f
C796 sg13g2_dfrbpq_1_2.CLK a_11752_15366# 0.0107f
C797 sg13g2_dfrbpq_1_3.RESET_B a_17892_14909# 0.03322f
C798 a_26475_14495# a_26373_14495# 0.27006f
C799 a_27664_13942# a_28074_14020# 0.05221f
C800 sg13g2_or3_1_1.X sg13g2_buf_16_2.X 0.02831f
C801 sg13g2_or3_1_2.B a_20278_14862# 0.07247f
C802 a_2528_15366# VDD 0.08307f
C803 a_16485_13701# sg13g2_dfrbpq_1_2.CLK 0.17413f
C804 sg13g2_buf_16_2.A a_17604_14488# 0.01468f
C805 sg13g2_or3_1_2.B sg13g2_a21oi_1_0.A2 0.04704f
C806 sg13g2_dfrbpq_1_1.RESET_B sg13g2_nand3_1_0.Y 0.01246f
C807 a_9861_14521# VDD 0.06515f
C808 a_21579_14495# a_22319_14845# 0.15395f
C809 sg13g2_a21oi_1_0.B1 sg13g2_dfrbpq_1_2.D 0.1418f
C810 sg13g2_dfrbpq_1_6.D sg13g2_buf_16_2.X 0.02051f
C811 a_2824_16082# VDD 0.12157f
C812 sg13g2_dlygate4sd3_1_12.X sg13g2_o21ai_1_3.Y 0.0391f
C813 sg13g2_or3_1_2.X a_20603_15532# 0.05694f
C814 a_7888_14726# a_7631_14845# 0.20069f
C815 sg13g2_and2_1_0.X sg13g2_dlygate4sd3_1_3.A 0.01317f
C816 sg13g2_dfrbpq_1_3.Q a_19450_15202# 0.23338f
C817 sg13g2_dfrbpq_1_6.RESET_B sg13g2_or3_1_2.X 0.04674f
C818 sg13g2_dfrbpq_1_2.RESET_B a_16044_15424# 0.02643f
C819 a_16587_13844# sg13g2_a21oi_1_0.A1 0.02992f
C820 sg13g2_o21ai_1_3.Y sg13g2_or3_1_1.C 0.04719f
C821 a_24841_13726# VDD 0.25729f
C822 sg13g2_dfrbpq_1_2.CLK sg13g2_a21oi_1_0.A2 0.12055f
C823 sg13g2_dfrbpq_1_6.Q sg13g2_a21oi_1_3.Y 0.01465f
C824 sg13g2_a21oi_1_0.Y sg13g2_a21oi_1_0.A1 0.0662f
C825 sg13g2_o21ai_1_2.B1 sg13g2_or3_1_1.C 0.41829f
C826 a_38720_15366# VDD 0.08021f
C827 sg13g2_nor2_1_0.B a_16079_15238# 0.02071f
C828 sg13g2_or3_1_1.X sg13g2_dfrbpq_1_6.Q 0.01399f
C829 sg13g2_a21oi_1_0.B1 sg13g2_dfrbpq_1_3.D 0.02771f
C830 a_18377_16334# a_18501_16033# 0.06917f
C831 a_25109_12972# sg13g2_a21oi_1_3.Y 0.08658f
C832 a_38720_14570# VDD 0.07927f
C833 sg13g2_o21ai_1_1.Y sg13g2_or3_1_2.A 0.12124f
C834 sg13g2_or3_1_2.B VDD 1.84716f
C835 sg13g2_dfrbpq_1_2.Q sg13g2_dfrbpq_1_6.D 0.01333f
C836 sg13g2_buf_16_2.A a_17578_14452# 0.01322f
C837 sg13g2_dlygate4sd3_1_8.A a_10960_15454# 0.01969f
C838 sg13g2_a21oi_1_0.B1 clock_i 0.07143f
C839 a_23552_14570# VDD 0.06356f
C840 sg13g2_a21oi_1_0.B1 sg13g2_dfrbpq_1_7.D 0.24792f
C841 a_27617_15424# a_27898_15202# 0.15158f
C842 a_16955_12972# sg13g2_a21oi_1_0.Y 0.08658f
C843 sg13g2_dfrbpq_1_2.CLK VDD 2.1153f
C844 a_17900_15960# sg13g2_dfrbpq_1_2.Q 0.16112f
C845 a_17825_15424# VDD 0.20013f
C846 sg13g2_or3_1_1.A a_26170_15202# 0.0121f
C847 a_25390_16263# VDD 0.14549f
C848 sg13g2_or3_1_1.A sg13g2_a21oi_1_3.A2 0.21322f
C849 a_21477_14495# sg13g2_or3_1_2.X 0.01328f
C850 sg13g2_a21oi_1_0.B1 sg13g2_nand4_1_0.Y 0.01895f
C851 a_22145_15424# VDD 0.19789f
C852 a_6286_13911# a_6401_13912# 0.32411f
C853 a_26475_14495# VDD 0.20548f
C854 a_12020_15202# VDD 1.62135f
C855 a_22508_15960# sg13g2_dfrbpq_1_3.Q 0.16116f
C856 a_2916_15552# a_2890_15457# 0.21121f
C857 sg13g2_buf_1_0.X sg13g2_dlygate4sd3_1_8.X 0.1643f
C858 a_38536_3986# VDD 0.13142f
C859 a_21579_14495# sg13g2_or3_1_2.A 0.03717f
C860 a_18106_15202# sg13g2_dlygate4sd3_1_5.A 0.218f
C861 sg13g2_or3_1_2.X sg13g2_or3_1_2.C 0.01939f
C862 a_2942_14484# VDD 0.0112f
C863 a_22986_14484# VDD 0.2399f
C864 a_18478_13911# sg13g2_dlygate4sd3_1_4.X 0.08936f
C865 sg13g2_dfrbpq_1_6.RESET_B a_21185_15424# 0.04653f
C866 a_27296_16082# VDD 0.09025f
C867 sg13g2_or3_1_1.B sg13g2_dfrbpq_1_3.Q 0.01515f
C868 sg13g2_a21oi_1_3.A2 sg13g2_o21ai_1_2.Y 0.04053f
C869 sg13g2_dfrbpq_1_3.RESET_B sg13g2_dfrbpq_1_3.D 0.03729f
C870 a_25206_14508# sg13g2_buf_16_2.X 0.01182f
C871 sg13g2_or3_1_1.A a_24310_15230# 0.02187f
C872 a_6286_13911# sg13g2_dlygate4sd3_1_0.X 0.08862f
C873 sg13g2_and2_1_0.B a_2490_14447# 0.13073f
C874 sg13g2_dfrbpq_1_2.CLK a_5613_14832# 0.01219f
C875 sg13g2_a21oi_1_0.B1 sg13g2_buf_16_2.A 0.25575f
C876 sg13g2_xnor2_1_2.B a_6346_14452# 0.01549f
C877 a_9861_15213# VDD 0.2425f
C878 sg13g2_and2_1_2.X sg13g2_tiehi_1.L_HI 0.05708f
C879 sg13g2_dfrbpq_1_5.RESET_B a_26148_14040# 0.2384f
C880 a_1965_14832# VDD 0.26526f
C881 sg13g2_or3_1_2.B a_21827_13690# 0.15791f
C882 a_27472_14726# a_27882_14484# 0.05221f
C883 a_4175_15311# a_4432_15454# 0.20069f
C884 a_4175_15311# sg13g2_buf_1_0.X 0.01373f
C885 sg13g2_a21oi_1_0.A2 sg13g2_dfrbpq_1_3.D 0.06203f
C886 a_2916_15552# a_3435_15356# 0.18372f
C887 reset_n_i VDD 0.14413f
C888 sg13g2_or3_1_1.C sg13g2_a21oi_1_3.A2 0.301f
C889 sg13g2_dlygate4sd3_1_1.A a_7888_14726# 0.01445f
C890 a_8694_15302# VDD 0.14464f
C891 a_19120_14726# a_18863_14845# 0.20069f
C892 sg13g2_a21oi_1_0.B1 sg13g2_dfrbpq_1_5.D 0.16949f
C893 sg13g2_dfrbpq_1_1.RESET_B sg13g2_buf_1_0.X 0.1459f
C894 sg13g2_dfrbpq_1_2.D VDD 0.41282f
C895 a_21579_14495# a_22576_14726# 0.01569f
C896 a_8312_15238# a_8582_15238# 0.15158f
C897 sg13g2_or3_1_1.A a_24824_15238# 0.04235f
C898 a_27407_13799# a_26667_13844# 0.15395f
C899 a_18478_13911# a_18593_13912# 0.32411f
C900 sg13g2_a21oi_1_0.A1 a_17604_14488# 0.06395f
C901 a_19169_15424# VDD 0.20878f
C902 a_8298_14484# VDD 0.24177f
C903 sg13g2_a21oi_1_0.B1 a_14816_14570# 0.0116f
C904 sg13g2_xor2_1_0.B a_4193_14750# 0.01614f
C905 sg13g2_dfrbpq_1_3.D VDD 0.1813f
C906 sg13g2_xnor2_1_1.A sg13g2_dfrbpq_1_3.RESET_B 0.01959f
C907 a_26170_16237# VDD 0.09145f
C908 a_10703_15311# a_11370_15532# 0.06982f
C909 a_14357_15238# VDD 0.43839f
C910 a_17233_13799# a_16485_13701# 0.01058f
C911 sg13g2_or3_1_1.C a_24310_15230# 0.10273f
C912 sg13g2_dfrbpq_1_3.Q sg13g2_o21ai_1_2.A2 0.13184f
C913 sg13g2_dfrbpq_1_3.RESET_B sg13g2_buf_16_2.A 0.03602f
C914 a_24824_15238# sg13g2_o21ai_1_2.Y 0.2216f
C915 a_3333_15213# a_2630_15234# 0.02454f
C916 clock_i VDD 1.71887f
C917 sg13g2_buf_16_2.X sg13g2_or3_1_2.X 0.05858f
C918 VDD sg13g2_dfrbpq_1_7.D 0.1787f
C919 a_25670_14922# a_25956_14488# 0.21832f
C920 a_17900_15960# counter_value_o[3] 0.13353f
C921 a_26249_16334# a_26373_16033# 0.06917f
C922 sg13g2_xnor2_1_2.A a_6540_13238# 0.12443f
C923 sg13g2_dfrbpq_1_2.CLK sg13g2_buf_1_10.X 1.89203f
C924 a_17584_13942# a_17994_14020# 0.05221f
C925 a_25670_14922# sg13g2_a21oi_1_3.Y 0.04943f
C926 sg13g2_a21oi_1_0.A1 a_17578_14452# 0.02533f
C927 sg13g2_xnor2_1_1.A sg13g2_a21oi_1_0.A2 0.06747f
C928 sg13g2_nand4_1_0.Y VDD 0.5472f
C929 a_26475_14495# sg13g2_dfrbpq_1_7.Q 0.03272f
C930 a_9444_15552# a_10703_15311# 0.01303f
C931 sg13g2_nand4_1_0.Y a_7680_15549# 0.0137f
C932 sg13g2_a21oi_1_0.A2 sg13g2_buf_16_2.A 0.10413f
C933 sg13g2_a21oi_1_3.A2 a_24824_14525# 0.04809f
C934 a_17327_13799# a_16068_14040# 0.01303f
C935 sg13g2_dfrbpq_1_6.D a_21060_14488# 0.01147f
C936 sg13g2_dfrbpq_1_2.Q sg13g2_or3_1_2.X 0.55313f
C937 a_22149_16033# VDD 0.06317f
C938 sg13g2_buf_1_0.X sg13g2_and2_1_0.X 0.07579f
C939 sg13g2_xnor2_1_2.A a_6372_14488# 0.01991f
C940 sg13g2_dlygate4sd3_1_6.X sg13g2_dfrbpq_1_2.Q 0.03446f
C941 a_9963_15356# sg13g2_tiehi_1.L_HI 0.21479f
C942 sg13g2_o21ai_1_2.B1 a_26170_15202# 0.04122f
C943 sg13g2_or3_1_2.B sg13g2_dfrbpq_1_3.Q 0.03642f
C944 sg13g2_a21oi_1_1.Y a_21946_16237# 0.0232f
C945 a_16042_13945# a_16068_14040# 0.21121f
C946 sg13g2_a21oi_1_0.B1 sg13g2_dfrbpq_1_2.RESET_B 0.08021f
C947 a_16760_15238# sg13g2_a21oi_1_0.Y 0.23186f
C948 sg13g2_xnor2_1_1.A VDD 0.75307f
C949 sg13g2_buf_16_2.A VDD 2.70548f
C950 a_21070_15423# VDD 0.14448f
C951 sg13g2_dfrbpq_1_3.Q a_22145_15424# 0.01468f
C952 sg13g2_a21oi_1_0.Y a_15022_14484# 0.0117f
C953 a_5600_15366# VDD 0.08546f
C954 sg13g2_buf_1_10.X a_1965_14832# 0.0959f
C955 sg13g2_o21ai_1_3.Y a_24310_15230# 0.04934f
C956 a_7822_13911# sg13g2_dlygate4sd3_1_1.A 0.01018f
C957 sg13g2_a21oi_1_0.B1 sg13g2_a21oi_1_0.A1 0.06132f
C958 a_21034_14452# VDD 0.09519f
C959 sg13g2_or3_1_2.B a_19530_14484# 0.01003f
C960 a_7822_13911# a_7937_13912# 0.32411f
C961 reset_n_i sg13g2_buf_1_10.X 0.01017f
C962 a_5687_15549# sg13g2_dlygate4sd3_1_3.A 0.01467f
C963 a_3333_15213# a_3204_15247# 0.01562f
C964 sg13g2_or3_1_1.A sg13g2_buf_16_2.X 0.02467f
C965 a_19438_13726# sg13g2_buf_16_2.X 0.93898f
C966 a_12524_15960# sg13g2_dlygate4sd3_1_8.A 0.16619f
C967 sg13g2_or3_1_1.X a_24841_13726# 0.11407f
C968 sg13g2_dfrbpq_1_5.RESET_B a_27407_13799# 0.07574f
C969 sg13g2_dfrbpq_1_5.D VDD 0.3746f
C970 a_8218_13690# VDD 0.27318f
C971 counter_value_o[2] clock_i 0.04067f
C972 sg13g2_dfrbpq_1_2.Q sg13g2_dlygate4sd3_1_5.A 0.31903f
C973 sg13g2_dfrbpq_1_5.D a_25862_13722# 0.16102f
C974 VDD a_19816_15366# 0.1293f
C975 sg13g2_buf_16_2.X a_18863_14845# 0.01524f
C976 sg13g2_dfrbpq_1_6.Q a_26753_15424# 0.01043f
C977 a_18501_16033# VDD 0.0704f
C978 sg13g2_dlygate4sd3_1_4.X sg13g2_dlygate4sd3_1_6.X 0.07714f
C979 sg13g2_dlygate4sd3_1_8.X a_9418_15457# 0.01733f
C980 counter_value_o[1] VDD 0.1011f
C981 a_37484_15960# counter_value_o[7] 0.13349f
C982 sg13g2_buf_1_10.X a_8298_14484# 0.0265f
C983 a_24169_14508# sg13g2_o21ai_1_2.Y 0.04637f
C984 a_14816_14570# VDD 0.07948f
C985 sg13g2_dfrbpq_1_6.Q sg13g2_or3_1_1.A 1.60085f
C986 sg13g2_o21ai_1_3.Y a_24824_15238# 0.02965f
C987 sg13g2_xnor2_1_0.Y VDD 0.29558f
C988 a_26667_13844# VDD 0.20564f
C989 sg13g2_buf_16_2.X sg13g2_o21ai_1_2.Y 0.46721f
C990 a_16485_13701# sg13g2_dfrbpq_1_2.RESET_B 0.0282f
C991 a_25930_14452# sg13g2_buf_16_2.X 0.014f
C992 a_7680_15549# sg13g2_xnor2_1_0.Y 0.11855f
C993 a_26148_14040# a_26565_13701# 0.22605f
C994 a_25862_13722# a_26667_13844# 0.06896f
C995 sg13g2_dfrbpq_1_2.Q a_18863_14845# 0.0389f
C996 a_23168_15366# VDD 0.09073f
C997 a_22025_16334# counter_value_o[4] 0.0142f
C998 sg13g2_or3_1_1.X a_25390_16263# 0.01101f
C999 a_26475_14495# a_25956_14488# 0.18362f
C1000 a_26244_14909# a_26373_14495# 0.01562f
C1001 a_6891_14495# a_6372_14488# 0.18362f
C1002 a_2890_15457# sg13g2_dfrbpq_1_0.RESET_B 0.16024f
C1003 clock_i sg13g2_buf_1_10.X 0.01638f
C1004 a_27407_13799# a_28074_14020# 0.06982f
C1005 a_16068_14040# sg13g2_dfrbpq_1_2.CLK 0.03943f
C1006 a_2890_15457# VDD 0.09938f
C1007 a_3204_15247# a_2630_15234# 0.16388f
C1008 sg13g2_dfrbpq_1_1.RESET_B sg13g2_xor2_1_0.B 0.03941f
C1009 sg13g2_xnor2_1_2.B sg13g2_and2_1_1.X 0.04407f
C1010 sg13g2_or3_1_2.B a_17900_15960# 0.01033f
C1011 a_9861_14521# a_10016_14570# 0.01514f
C1012 sg13g2_dfrbpq_1_3.RESET_B sg13g2_a21oi_1_0.A1 0.0443f
C1013 sg13g2_dfrbpq_1_2.RESET_B sg13g2_a21oi_1_0.A2 0.02033f
C1014 a_3130_16237# sg13g2_dfrbpq_1_0.RESET_B 0.04209f
C1015 sg13g2_buf_1_0.X a_2490_14447# 0.07216f
C1016 a_9536_14570# VDD 0.08891f
C1017 sg13g2_or3_1_1.C a_24169_14508# 0.03811f
C1018 sg13g2_dfrbpq_1_6.Q sg13g2_o21ai_1_2.Y 0.02566f
C1019 a_3130_16237# VDD 0.09315f
C1020 sg13g2_nand4_1_0.Y sg13g2_buf_1_10.X 0.51312f
C1021 a_6891_14495# a_7631_14845# 0.15395f
C1022 a_17994_14020# sg13g2_dfrbpq_1_2.Q 0.07084f
C1023 a_1192_3900# enable_i 0.1635f
C1024 sg13g2_or3_1_1.C sg13g2_buf_16_2.X 0.02129f
C1025 sg13g2_xnor2_1_2.A sg13g2_xnor2_1_2.B 0.26286f
C1026 sg13g2_dlygate4sd3_1_6.X counter_value_o[3] 0.01714f
C1027 sg13g2_dlygate4sd3_1_3.A a_2824_16082# 0.02159f
C1028 sg13g2_dfrbpq_1_7.RESET_B a_25774_15423# 0.02822f
C1029 sg13g2_dlygate4sd3_1_11.X a_20603_15532# 0.05486f
C1030 a_6789_14495# a_6086_14922# 0.02432f
C1031 sg13g2_dfrbpq_1_5.RESET_B a_26373_14495# 0.01256f
C1032 sg13g2_or3_1_1.B sg13g2_or3_1_2.X 0.01231f
C1033 a_22030_15423# sg13g2_or3_1_2.A 0.08842f
C1034 sg13g2_dlygate4sd3_1_4.X sg13g2_dlygate4sd3_1_5.A 0.08178f
C1035 sg13g2_xnor2_1_2.A sg13g2_dlygate4sd3_1_1.A 0.05164f
C1036 a_16556_15960# VDD 0.16505f
C1037 a_7937_13912# sg13g2_xnor2_1_2.A 0.01338f
C1038 sg13g2_a21oi_1_0.A2 sg13g2_a21oi_1_0.A1 0.37488f
C1039 sg13g2_dfrbpq_1_2.RESET_B VDD 1.2048f
C1040 sg13g2_dlygate4sd3_1_8.A a_10703_15311# 0.05992f
C1041 a_23368_14570# VDD 0.12812f
C1042 a_3435_15356# sg13g2_dfrbpq_1_0.RESET_B 0.21832f
C1043 sg13g2_dfrbpq_1_6.Q sg13g2_or3_1_1.C 0.07251f
C1044 a_3435_15356# VDD 0.23524f
C1045 sg13g2_or3_1_1.A a_25889_15424# 0.01269f
C1046 a_21060_14488# sg13g2_or3_1_2.X 0.01695f
C1047 sg13g2_a21oi_1_0.A2 a_16955_12972# 0.04932f
C1048 a_21824_15366# VDD 0.07792f
C1049 sg13g2_a21oi_1_0.B1 sg13g2_a21oi_1_3.A1 0.211f
C1050 sg13g2_dfrbpq_1_2.CLK sg13g2_dlygate4sd3_1_3.A 0.04644f
C1051 a_11370_15532# VDD 0.24136f
C1052 sg13g2_xor2_1_0.B sg13g2_and2_1_0.X 0.15539f
C1053 sg13g2_a21oi_1_0.A1 VDD 0.42347f
C1054 a_2540_15960# a_2824_16082# 0.01226f
C1055 a_2516_14484# VDD 0.11861f
C1056 a_1192_3900# VDD 0.16521f
C1057 a_22319_14845# VDD 0.1775f
C1058 sg13g2_xnor2_1_1.A a_16079_15238# 0.01072f
C1059 sg13g2_dfrbpq_1_1.RESET_B a_6086_14922# 0.07473f
C1060 a_18176_16082# sg13g2_dfrbpq_1_2.Q 0.0133f
C1061 a_24824_14525# sg13g2_buf_16_2.X 0.01228f
C1062 a_21827_13690# a_22125_14020# 0.02085f
C1063 a_16955_12972# VDD 0.1743f
C1064 sg13g2_o21ai_1_2.B1 a_24169_14508# 0.20427f
C1065 a_25786_15960# sg13g2_o21ai_1_3.Y 0.23716f
C1066 a_18377_16334# a_18298_16237# 0.08074f
C1067 sg13g2_and2_1_0.B a_1965_14832# 0.15967f
C1068 a_25206_15302# sg13g2_a21oi_1_3.A1 0.09698f
C1069 sg13g2_dfrbpq_1_1.RESET_B a_6789_14495# 0.02792f
C1070 a_9444_15552# VDD 0.07216f
C1071 sg13g2_dfrbpq_1_5.RESET_B VDD 1.17237f
C1072 sg13g2_dlygate4sd3_1_0.A a_6540_13238# 0.11291f
C1073 sg13g2_o21ai_1_2.B1 sg13g2_buf_16_2.X 0.15546f
C1074 a_6540_13238# VDD 0.1749f
C1075 sg13g2_dfrbpq_1_5.RESET_B a_25862_13722# 0.11114f
C1076 a_20278_14862# sg13g2_or3_1_2.A 0.02186f
C1077 sg13g2_or3_1_1.B sg13g2_or3_1_1.A 0.14101f
C1078 a_19438_13726# sg13g2_or3_1_1.B 0.02479f
C1079 a_27472_14726# a_27215_14845# 0.20069f
C1080 sg13g2_dfrbpq_1_2.CLK sg13g2_dlygate4sd3_1_0.X 0.03781f
C1081 a_37484_15960# sg13g2_dfrbpq_1_5.Q 0.16451f
C1082 a_2916_15552# a_3333_15213# 0.22605f
C1083 a_20774_14922# sg13g2_o21ai_1_1.Y 0.02664f
C1084 sg13g2_dlygate4sd3_1_1.A a_6891_14495# 0.03656f
C1085 a_6372_14488# VDD 0.07267f
C1086 sg13g2_dfrbpq_1_6.RESET_B a_21477_14495# 0.02811f
C1087 a_16760_15238# a_17030_15238# 0.15158f
C1088 a_8582_15238# VDD 0.19847f
C1089 sg13g2_dfrbpq_1_6.Q sg13g2_o21ai_1_2.B1 1.46814f
C1090 a_18123_14495# a_18863_14845# 0.15395f
C1091 sg13g2_dfrbpq_1_3.Q a_19816_15366# 0.03367f
C1092 a_17604_14488# a_18021_14495# 0.22698f
C1093 a_28074_14020# VDD 0.24417f
C1094 a_17517_16020# a_17219_16265# 0.02085f
C1095 a_9737_14822# a_9658_14725# 0.08074f
C1096 sg13g2_or3_1_1.B sg13g2_o21ai_1_2.Y 0.01707f
C1097 a_19054_15423# VDD 0.16782f
C1098 a_7631_14845# VDD 0.17592f
C1099 VDD sg13g2_or3_1_2.A 0.37342f
C1100 sg13g2_xor2_1_0.B a_3872_14570# 0.01249f
C1101 sg13g2_a21oi_1_0.B1 a_15022_14484# 0.06939f
C1102 sg13g2_or3_1_2.B sg13g2_or3_1_2.X 0.02851f
C1103 sg13g2_dfrbpq_1_2.CLK sg13g2_tiehi_1.L_HI 0.03984f
C1104 a_17710_15423# VDD 0.14816f
C1105 sg13g2_dfrbpq_1_6.RESET_B sg13g2_or3_1_2.C 0.02588f
C1106 a_25505_16262# VDD 0.19718f
C1107 a_10703_15311# a_10960_15454# 0.20069f
C1108 sg13g2_or3_1_2.B sg13g2_dlygate4sd3_1_6.X 0.1707f
C1109 sg13g2_dlygate4sd3_1_8.X sg13g2_and2_1_2.X 0.01687f
C1110 a_17233_13799# a_16068_14040# 0.22369f
C1111 a_16356_13735# a_16587_13844# 0.06628f
C1112 sg13g2_dlygate4sd3_1_8.X a_10222_14751# 0.08839f
C1113 VDD a_27898_15202# 0.26514f
C1114 a_17578_14452# a_18021_14495# 0.02242f
C1115 a_2916_15552# a_2630_15234# 0.21832f
C1116 a_20774_14922# a_21579_14495# 0.06896f
C1117 a_25670_14922# a_25930_14452# 0.39302f
C1118 sg13g2_xor2_1_0.B a_2490_14447# 0.1777f
C1119 a_26249_16334# a_26170_16237# 0.08074f
C1120 a_17327_13799# a_17994_14020# 0.06982f
C1121 sg13g2_or3_1_1.B sg13g2_or3_1_1.C 0.07619f
C1122 sg13g2_dfrbpq_1_6.D a_21070_15423# 0.03685f
C1123 a_16587_13844# sg13g2_a21oi_1_0.Y 0.04768f
C1124 sg13g2_dlygate4sd3_1_3.A clock_i 0.08657f
C1125 VDD sg13g2_a21oi_1_3.A1 0.27978f
C1126 sg13g2_a21oi_1_3.A2 a_24169_14508# 0.10865f
C1127 a_21477_14495# sg13g2_or3_1_2.C 0.01348f
C1128 sg13g2_dlygate4sd3_1_8.A a_11752_15366# 0.03267f
C1129 sg13g2_dfrbpq_1_5.D sg13g2_a21oi_1_3.Y 0.27264f
C1130 reset_n_i a_1192_9948# 0.16635f
C1131 a_21946_16237# VDD 0.09438f
C1132 a_9861_15213# sg13g2_tiehi_1.L_HI 0.02812f
C1133 sg13g2_dfrbpq_1_2.RESET_B a_16079_15238# 0.01657f
C1134 sg13g2_or3_1_1.C a_24408_15552# 0.01167f
C1135 sg13g2_a21oi_1_3.A2 sg13g2_buf_16_2.X 0.01097f
C1136 sg13g2_a21oi_1_1.Y a_21281_16262# 0.02113f
C1137 a_22576_14726# VDD 0.12615f
C1138 sg13g2_dfrbpq_1_6.Q counter_value_o[5] 0.01037f
C1139 a_16042_13945# a_15782_13722# 0.39302f
C1140 sg13g2_dfrbpq_1_2.Q sg13g2_dlygate4sd3_1_11.X 0.01953f
C1141 a_16044_15424# sg13g2_a21oi_1_0.Y 0.01013f
C1142 sg13g2_or3_1_1.A a_24841_13726# 0.18425f
C1143 sg13g2_or3_1_2.B sg13g2_dlygate4sd3_1_5.A 0.22722f
C1144 sg13g2_o21ai_1_2.A2 sg13g2_o21ai_1_2.Y 0.07474f
C1145 a_21827_13690# sg13g2_or3_1_2.A 0.17685f
C1146 sg13g2_dfrbpq_1_7.Q sg13g2_dfrbpq_1_5.RESET_B 0.02174f
C1147 sg13g2_a21oi_1_0.A2 a_16760_15238# 0.02068f
C1148 a_38536_13854# a_38720_13854# 0.0262f
C1149 a_19438_13726# sg13g2_or3_1_2.B 0.02802f
C1150 counter_value_o[6] VDD 0.10209f
C1151 sg13g2_a21oi_1_3.A2 a_25109_12972# 0.05394f
C1152 sg13g2_nand3_1_0.Y clock_i 0.02746f
C1153 sg13g2_dfrbpq_1_6.RESET_B sg13g2_buf_16_2.X 0.05354f
C1154 sg13g2_a21oi_1_0.A2 a_15022_14484# 0.01223f
C1155 sg13g2_or3_1_2.B a_18863_14845# 0.0112f
C1156 sg13g2_o21ai_1_2.B1 a_24062_15242# 0.01805f
C1157 sg13g2_or3_1_1.B a_24824_14525# 0.01011f
C1158 sg13g2_dlygate4sd3_1_0.A sg13g2_xnor2_1_2.B 0.3143f
C1159 sg13g2_xnor2_1_2.B VDD 0.59203f
C1160 a_2916_15552# a_3204_15247# 0.22255f
C1161 sg13g2_dlygate4sd3_1_8.A VDD 0.79302f
C1162 sg13g2_dfrbpq_1_2.CLK sg13g2_buf_1_0.X 0.0484f
C1163 sg13g2_buf_1_10.X a_6372_14488# 0.02336f
C1164 sg13g2_nand3_1_0.Y sg13g2_nand4_1_0.Y 0.02354f
C1165 sg13g2_dlygate4sd3_1_8.X a_9963_15356# 0.03544f
C1166 a_16760_15238# VDD 0.26489f
C1167 a_25094_14484# VDD 0.19616f
C1168 sg13g2_dlygate4sd3_1_1.A VDD 0.93268f
C1169 sg13g2_or3_1_2.B sg13g2_o21ai_1_2.Y 0.03997f
C1170 a_7937_13912# VDD 0.19965f
C1171 sg13g2_or3_1_1.B sg13g2_o21ai_1_2.B1 0.02119f
C1172 a_7680_15549# sg13g2_dlygate4sd3_1_1.A 0.05793f
C1173 sg13g2_dfrbpq_1_2.Q a_18106_15202# 0.0323f
C1174 sg13g2_dlygate4sd3_1_6.X a_19169_15424# 0.01113f
C1175 a_18021_14495# a_18769_14845# 0.01058f
C1176 sg13g2_buf_16_2.X a_19120_14726# 0.01083f
C1177 sg13g2_dfrbpq_1_2.Q sg13g2_dfrbpq_1_6.RESET_B 0.0154f
C1178 sg13g2_dlygate4sd3_1_4.X a_17219_16265# 0.0163f
C1179 a_7532_15960# counter_value_o[1] 0.13349f
C1180 a_22025_16334# VDD 0.06879f
C1181 sg13g2_buf_1_10.X a_7631_14845# 0.02314f
C1182 a_15022_14484# VDD 1.60271f
C1183 a_18298_16237# sg13g2_dfrbpq_1_3.RESET_B 0.03978f
C1184 a_18874_13690# sg13g2_dfrbpq_1_2.Q 0.23954f
C1185 sg13g2_o21ai_1_3.Y a_24408_15552# 0.01296f
C1186 sg13g2_or3_1_1.C a_24841_13726# 0.15147f
C1187 a_26565_13701# VDD 0.25684f
C1188 sg13g2_nand4_1_0.Y sg13g2_tiehi_1.L_HI 0.0284f
C1189 a_16068_14040# sg13g2_dfrbpq_1_2.RESET_B 0.23755f
C1190 a_21477_14495# sg13g2_buf_16_2.X 0.15602f
C1191 sg13g2_dlygate4sd3_1_8.X sg13g2_and2_1_2.B 0.01382f
C1192 a_25862_13722# a_26565_13701# 0.02454f
C1193 sg13g2_dfrbpq_1_2.Q a_19120_14726# 0.04689f
C1194 a_26373_16033# a_26554_16237# 0.02683f
C1195 sg13g2_a21oi_1_0.B1 sg13g2_dfrbpq_1_7.RESET_B 0.03092f
C1196 sg13g2_dfrbpq_1_5.D a_25206_14508# 0.08875f
C1197 sg13g2_dfrbpq_1_2.CLK a_10609_15311# 0.01369f
C1198 sg13g2_dfrbpq_1_3.RESET_B a_18021_14495# 0.03254f
C1199 a_26244_14909# a_25956_14488# 0.22255f
C1200 a_6660_14909# a_6372_14488# 0.22255f
C1201 sg13g2_or3_1_2.B sg13g2_or3_1_1.C 0.26229f
C1202 a_27407_13799# a_27664_13942# 0.20069f
C1203 a_25889_15424# a_26170_15202# 0.15158f
C1204 a_26244_14909# sg13g2_a21oi_1_3.Y 0.01171f
C1205 sg13g2_buf_16_2.X sg13g2_or3_1_2.C 0.11834f
C1206 a_3209_16334# sg13g2_dfrbpq_1_0.RESET_B 0.01018f
C1207 a_21477_14495# a_22225_14845# 0.01058f
C1208 sg13g2_dlygate4sd3_1_12.X a_25390_16263# 0.08969f
C1209 a_3209_16334# VDD 0.09043f
C1210 a_6891_14495# a_7888_14726# 0.01569f
C1211 a_6789_14495# a_7537_14845# 0.01058f
C1212 a_2890_15457# sg13g2_dlygate4sd3_1_3.A 0.01365f
C1213 a_16068_14040# sg13g2_a21oi_1_0.A1 0.02961f
C1214 a_17030_15238# a_17142_15302# 0.32411f
C1215 a_24841_13726# a_25037_14020# 0.01473f
C1216 a_17219_16265# counter_value_o[3] 0.04613f
C1217 sg13g2_dfrbpq_1_5.RESET_B a_25956_14488# 0.01475f
C1218 a_21466_15202# sg13g2_or3_1_2.A 0.01933f
C1219 sg13g2_dlygate4sd3_1_4.X a_18106_15202# 0.01815f
C1220 sg13g2_dfrbpq_1_2.Q sg13g2_or3_1_2.C 0.12403f
C1221 a_16254_15934# VDD 0.09519f
C1222 a_7822_13911# sg13g2_xnor2_1_2.A 0.09254f
C1223 sg13g2_dlygate4sd3_1_6.X sg13g2_xnor2_1_1.A 0.19121f
C1224 sg13g2_dfrbpq_1_5.RESET_B sg13g2_a21oi_1_3.Y 0.45818f
C1225 a_18298_16237# VDD 0.0957f
C1226 sg13g2_a21oi_1_0.B1 sg13g2_o21ai_1_1.Y 0.01333f
C1227 sg13g2_o21ai_1_2.B1 sg13g2_o21ai_1_2.A2 0.141f
C1228 sg13g2_or3_1_2.X a_21070_15423# 0.01158f
C1229 sg13g2_dlygate4sd3_1_8.A counter_value_o[2] 0.01365f
C1230 a_10609_15311# a_9861_15213# 0.01058f
C1231 a_3333_15213# sg13g2_dfrbpq_1_0.RESET_B 0.03072f
C1232 a_27502_15423# a_27617_15424# 0.32411f
C1233 a_16648_13058# sg13g2_a21oi_1_0.Y 0.01132f
C1234 sg13g2_dfrbpq_1_7.RESET_B a_26373_14495# 0.02734f
C1235 a_3333_15213# VDD 0.2987f
C1236 sg13g2_nand3_1_0.Y sg13g2_xnor2_1_0.Y 0.04653f
C1237 sg13g2_dfrbpq_1_7.Q counter_value_o[6] 0.01f
C1238 a_18021_14495# VDD 0.2588f
C1239 sg13g2_or3_1_1.B sg13g2_a21oi_1_3.A2 0.11499f
C1240 sg13g2_and2_1_0.B a_2516_14484# 0.05178f
C1241 sg13g2_a21oi_1_0.B1 a_25774_15423# 0.01369f
C1242 a_3435_15356# sg13g2_dlygate4sd3_1_3.A 0.02689f
C1243 a_10960_15454# VDD 0.1272f
C1244 a_22149_16033# a_22304_16082# 0.01514f
C1245 sg13g2_xnor2_1_0.Y a_7829_15238# 0.02071f
C1246 a_4474_14448# VDD 0.27751f
C1247 sg13g2_xnor2_1_2.B sg13g2_buf_1_10.X 0.01635f
C1248 sg13g2_dlygate4sd3_1_8.A sg13g2_buf_1_10.X 0.03118f
C1249 sg13g2_or3_1_2.B sg13g2_o21ai_1_2.B1 0.49052f
C1250 a_15782_13722# sg13g2_dfrbpq_1_2.D 0.1517f
C1251 sg13g2_buf_1_0.X sg13g2_nand4_1_0.Y 0.03081f
C1252 sg13g2_dlygate4sd3_1_1.A sg13g2_buf_1_10.X 0.1352f
C1253 a_16356_13735# sg13g2_a21oi_1_0.B1 0.02718f
C1254 a_16055_16301# a_16254_15934# 0.01313f
C1255 sg13g2_and2_1_0.X a_2490_14447# 0.05389f
C1256 a_21827_13690# a_22036_14020# 0.01473f
C1257 a_16055_16071# sg13g2_dfrbpq_1_2.RESET_B 0.0238f
C1258 a_21348_14909# sg13g2_o21ai_1_1.Y 0.0244f
C1259 sg13g2_dlygate4sd3_1_1.A a_8685_14832# 0.04541f
C1260 a_25390_16263# sg13g2_o21ai_1_3.Y 0.01578f
C1261 a_2630_15234# sg13g2_dfrbpq_1_0.RESET_B 0.10111f
C1262 a_2630_15234# VDD 0.45695f
C1263 sg13g2_xnor2_1_1.A sg13g2_dlygate4sd3_1_5.A 0.04995f
C1264 a_9158_15234# VDD 0.44786f
C1265 sg13g2_dfrbpq_1_6.D sg13g2_or3_1_2.A 0.012f
C1266 sg13g2_or3_1_1.B sg13g2_dfrbpq_1_6.RESET_B 0.01155f
C1267 a_16587_13844# sg13g2_a21oi_1_0.B1 0.01723f
C1268 a_38720_13854# VDD 0.05657f
C1269 sg13g2_dfrbpq_1_5.RESET_B a_26122_13945# 0.16732f
C1270 a_18593_13912# a_18874_13690# 0.15158f
C1271 sg13g2_a21oi_1_0.B1 sg13g2_a21oi_1_0.Y 0.90237f
C1272 a_9737_14822# VDD 0.07025f
C1273 sg13g2_dlygate4sd3_1_8.X a_9732_15247# 0.01632f
C1274 a_21070_15423# a_21185_15424# 0.32411f
C1275 a_26475_14495# a_27215_14845# 0.15395f
C1276 sg13g2_dfrbpq_1_2.CLK a_4193_14750# 0.01903f
C1277 sg13g2_dfrbpq_1_7.RESET_B VDD 1.02338f
C1278 sg13g2_dfrbpq_1_2.CLK sg13g2_xor2_1_0.B 0.10139f
C1279 sg13g2_and2_1_2.X sg13g2_and2_1_2.B 0.11092f
C1280 sg13g2_a21oi_1_0.A2 a_17142_15302# 0.05123f
C1281 a_19438_13726# sg13g2_buf_16_2.A 0.38032f
C1282 sg13g2_a21oi_1_3.A1 sg13g2_a21oi_1_3.Y 0.30532f
C1283 sg13g2_dfrbpq_1_2.Q sg13g2_buf_16_2.X 0.4486f
C1284 a_26249_16334# sg13g2_dfrbpq_1_5.RESET_B 0.01518f
C1285 a_20278_14862# sg13g2_o21ai_1_1.Y 0.05267f
C1286 sg13g2_dfrbpq_1_6.Q sg13g2_buf_16_2.X 0.08503f
C1287 sg13g2_dfrbpq_1_6.RESET_B a_21060_14488# 0.2413f
C1288 sg13g2_dfrbpq_1_2.Q a_22426_15202# 0.01336f
C1289 a_6346_14452# VDD 0.09666f
C1290 sg13g2_or3_1_1.X sg13g2_a21oi_1_3.A1 0.19264f
C1291 sg13g2_dfrbpq_1_6.Q a_22426_15202# 0.22623f
C1292 a_18123_14495# a_19120_14726# 0.01569f
C1293 a_15488_15366# VDD 0.09391f
C1294 a_21348_14909# a_21579_14495# 0.06628f
C1295 a_27664_13942# VDD 0.1286f
C1296 a_17428_16020# a_17219_16265# 0.01473f
C1297 sg13g2_dlygate4sd3_1_17.A a_24923_15996# 0.09826f
C1298 a_27407_13799# a_26148_14040# 0.01303f
C1299 a_18552_15552# VDD 0.01882f
C1300 a_7888_14726# VDD 0.12723f
C1301 a_17142_15302# VDD 0.14644f
C1302 sg13g2_dfrbpq_1_2.Q sg13g2_dfrbpq_1_6.Q 0.32803f
C1303 sg13g2_or3_1_2.B a_17219_16265# 0.15417f
C1304 a_16356_13735# a_16485_13701# 0.01562f
C1305 sg13g2_a21oi_1_0.B1 sg13g2_a21oi_1_1.Y 0.24439f
C1306 VDD a_27617_15424# 0.19613f
C1307 sg13g2_dlygate4sd3_1_8.X a_9861_14521# 0.01291f
C1308 VDD sg13g2_o21ai_1_1.Y 0.26566f
C1309 sg13g2_a21oi_1_3.A2 a_24841_13726# 0.05589f
C1310 a_17578_14452# a_17604_14488# 0.21121f
C1311 sg13g2_or3_1_1.B sg13g2_or3_1_2.C 0.04552f
C1312 a_21060_14488# a_21477_14495# 0.22698f
C1313 a_20774_14922# a_21348_14909# 0.16388f
C1314 a_16485_13701# a_16587_13844# 0.26919f
C1315 sg13g2_a21oi_1_0.B1 sg13g2_dlygate4sd3_1_17.A 0.22178f
C1316 a_17327_13799# a_17584_13942# 0.20069f
C1317 a_5886_15486# a_5687_15315# 0.01313f
C1318 VDD a_25774_15423# 0.14476f
C1319 sg13g2_o21ai_1_3.Y a_26170_16237# 0.02319f
C1320 sg13g2_dlygate4sd3_1_4.X sg13g2_buf_16_2.X 0.0241f
C1321 a_21060_14488# sg13g2_or3_1_2.C 0.01428f
C1322 a_16587_13844# sg13g2_a21oi_1_0.A2 0.02061f
C1323 sg13g2_dfrbpq_1_2.CLK a_6086_14922# 0.01599f
C1324 a_21281_16262# VDD 0.1966f
C1325 sg13g2_or3_1_1.X a_25094_14484# 0.07158f
C1326 a_9444_15552# sg13g2_tiehi_1.L_HI 0.25409f
C1327 a_9861_15213# a_9418_15457# 0.02242f
C1328 sg13g2_a21oi_1_0.A2 sg13g2_a21oi_1_0.Y 0.05648f
C1329 sg13g2_dfrbpq_1_2.CLK sg13g2_dlygate4sd3_1_8.X 0.44624f
C1330 a_21562_15960# a_21281_16262# 0.15158f
C1331 a_21579_14495# VDD 0.20436f
C1332 a_27296_16082# counter_value_o[5] 0.01377f
C1333 a_23736_14464# VDD 0.01765f
C1334 sg13g2_dfrbpq_1_2.Q a_19450_15202# 0.02852f
C1335 sg13g2_or3_1_2.B a_18106_15202# 0.01362f
C1336 sg13g2_dfrbpq_1_2.CLK a_6789_14495# 0.17873f
C1337 sg13g2_dlygate4sd3_1_4.X sg13g2_dfrbpq_1_2.Q 0.37806f
C1338 sg13g2_or3_1_2.B a_24310_15230# 0.07307f
C1339 sg13g2_xnor2_1_2.A a_6891_14495# 0.06395f
C1340 sg13g2_o21ai_1_2.B1 sg13g2_dfrbpq_1_7.D 0.02264f
C1341 sg13g2_or3_1_2.B sg13g2_dfrbpq_1_6.RESET_B 0.02705f
C1342 a_25206_14508# sg13g2_a21oi_1_3.A1 0.04785f
C1343 a_16587_13844# VDD 0.20672f
C1344 sg13g2_a21oi_1_0.B1 a_17604_14488# 0.01633f
C1345 a_5687_15315# VDD 0.07026f
C1346 a_17825_15424# a_18106_15202# 0.15158f
C1347 sg13g2_a21oi_1_0.Y VDD 0.22606f
C1348 sg13g2_dfrbpq_1_7.Q sg13g2_dfrbpq_1_7.RESET_B 0.01635f
C1349 a_20774_14922# VDD 0.44665f
C1350 sg13g2_dfrbpq_1_5.RESET_B a_26638_15423# 0.01353f
C1351 a_6682_13690# sg13g2_xnor2_1_2.B 0.0104f
C1352 a_12232_16082# VDD 0.15539f
C1353 a_3435_15356# a_4432_15454# 0.01528f
C1354 a_3435_15356# sg13g2_buf_1_0.X 0.01811f
C1355 sg13g2_dlygate4sd3_1_8.X a_9861_15213# 0.01428f
C1356 a_7532_15960# sg13g2_dlygate4sd3_1_1.A 0.16114f
C1357 a_16044_15424# VDD 0.16812f
C1358 a_7240_16082# VDD 0.15543f
C1359 sg13g2_or3_1_1.B sg13g2_buf_16_2.X 0.10814f
C1360 sg13g2_or3_1_2.X sg13g2_or3_1_2.A 0.19598f
C1361 a_7822_13911# VDD 0.14769f
C1362 sg13g2_dlygate4sd3_1_6.X a_19054_15423# 0.09539f
C1363 sg13g2_buf_16_2.X a_18123_14495# 0.01496f
C1364 a_17604_14488# a_18769_14845# 0.22369f
C1365 sg13g2_xnor2_1_2.B sg13g2_dlygate4sd3_1_3.A 0.1065f
C1366 sg13g2_a21oi_1_0.B1 a_16648_13058# 0.02468f
C1367 sg13g2_dfrbpq_1_2.CLK sg13g2_dfrbpq_1_1.RESET_B 0.03839f
C1368 sg13g2_buf_1_10.X a_7888_14726# 0.01431f
C1369 sg13g2_buf_1_0.X a_2516_14484# 0.01269f
C1370 a_14344_14570# VDD 0.149f
C1371 sg13g2_dlygate4sd3_1_3.A sg13g2_dlygate4sd3_1_1.A 0.15297f
C1372 a_1192_3900# sg13g2_buf_1_0.X 0.13726f
C1373 a_18593_13912# sg13g2_dfrbpq_1_2.Q 0.01147f
C1374 a_2528_15366# sg13g2_and2_1_0.X 0.01658f
C1375 a_26148_14040# VDD 0.07815f
C1376 a_8312_15238# VDD 0.26064f
C1377 sg13g2_or3_1_1.B sg13g2_dfrbpq_1_2.Q 0.03527f
C1378 a_6401_13912# sg13g2_xnor2_1_2.B 0.03894f
C1379 a_12524_15960# VDD 0.19759f
C1380 a_15782_13722# sg13g2_dfrbpq_1_2.RESET_B 0.09971f
C1381 sg13g2_dfrbpq_1_5.RESET_B a_26753_15424# 0.01106f
C1382 sg13g2_a21oi_1_1.Y VDD 0.42567f
C1383 sg13g2_or3_1_2.B sg13g2_or3_1_2.C 0.72288f
C1384 a_21060_14488# sg13g2_buf_16_2.X 0.08457f
C1385 sg13g2_dlygate4sd3_1_8.X a_8694_15302# 0.01396f
C1386 a_25670_14922# sg13g2_buf_16_2.X 0.01856f
C1387 sg13g2_or3_1_1.B sg13g2_dfrbpq_1_6.Q 0.01502f
C1388 a_25862_13722# a_26148_14040# 0.21832f
C1389 a_26122_13945# a_26565_13701# 0.02242f
C1390 sg13g2_dfrbpq_1_2.Q a_18123_14495# 0.05101f
C1391 a_21562_15960# sg13g2_a21oi_1_1.Y 0.23311f
C1392 sg13g2_a21oi_1_0.B1 a_24923_15996# 0.01159f
C1393 a_25094_14484# a_25206_14508# 0.32411f
C1394 sg13g2_dfrbpq_1_3.RESET_B a_17604_14488# 0.25194f
C1395 sg13g2_dfrbpq_1_5.RESET_B sg13g2_or3_1_1.A 0.02342f
C1396 sg13g2_dlygate4sd3_1_17.A VDD 0.26324f
C1397 a_3333_15213# a_4081_15311# 0.01058f
C1398 counter_value_o[4] VDD 0.08096f
C1399 a_18298_16237# a_17900_15960# 0.01124f
C1400 a_2824_16082# a_3008_16082# 0.0262f
C1401 a_3130_16237# a_3333_16033# 0.01313f
C1402 a_9658_14725# VDD 0.09878f
C1403 a_21060_14488# a_22225_14845# 0.22369f
C1404 sg13g2_xnor2_1_2.B sg13g2_dlygate4sd3_1_0.X 0.09015f
C1405 a_19232_13854# VDD 0.08101f
C1406 a_24841_13726# a_24935_14020# 0.02085f
C1407 sg13g2_o21ai_1_2.A2 a_24169_14508# 0.1504f
C1408 sg13g2_dlygate4sd3_1_8.X clock_i 0.0481f
C1409 sg13g2_dfrbpq_1_3.RESET_B a_17578_14452# 0.15945f
C1410 sg13g2_and2_1_1.X VDD 0.24423f
C1411 sg13g2_dfrbpq_1_5.RESET_B a_25930_14452# 0.01484f
C1412 sg13g2_nand3_1_0.Y sg13g2_dlygate4sd3_1_1.A 0.30877f
C1413 sg13g2_dfrbpq_1_2.Q a_20000_15366# 0.01141f
C1414 a_17219_16265# sg13g2_xnor2_1_1.A 0.151f
C1415 a_15880_16082# VDD 0.15276f
C1416 sg13g2_o21ai_1_2.A2 sg13g2_buf_16_2.X 0.05165f
C1417 a_18377_16334# VDD 0.09083f
C1418 sg13g2_dfrbpq_1_2.CLK sg13g2_and2_1_2.X 0.027f
C1419 sg13g2_dlygate4sd3_1_8.X sg13g2_nand4_1_0.Y 0.18772f
C1420 sg13g2_dfrbpq_1_5.Q a_28074_14020# 0.0702f
C1421 sg13g2_dfrbpq_1_2.Q a_17318_14922# 0.01185f
C1422 a_12232_16082# counter_value_o[2] 0.02118f
C1423 a_10609_15311# a_9444_15552# 0.22369f
C1424 a_9732_15247# a_9963_15356# 0.06628f
C1425 a_2916_15552# sg13g2_dfrbpq_1_0.RESET_B 0.22233f
C1426 sg13g2_dfrbpq_1_7.RESET_B a_25956_14488# 0.24038f
C1427 a_21466_15202# sg13g2_o21ai_1_1.Y 0.23998f
C1428 a_2916_15552# VDD 0.0944f
C1429 sg13g2_xnor2_1_2.A VDD 0.70278f
C1430 sg13g2_dlygate4sd3_1_0.A sg13g2_xnor2_1_2.A 0.07816f
C1431 sg13g2_dlygate4sd3_1_8.A sg13g2_tiehi_1.L_HI 0.01957f
C1432 sg13g2_or3_1_1.B sg13g2_dlygate4sd3_1_4.X 0.03156f
C1433 sg13g2_dfrbpq_1_7.RESET_B sg13g2_a21oi_1_3.Y 0.08143f
C1434 sg13g2_nand3_1_0.Y a_7923_15532# 0.01013f
C1435 a_32200_16082# counter_value_o[6] 0.02118f
C1436 a_17604_14488# VDD 0.09244f
C1437 a_38720_10034# VDD 0.0583f
C1438 sg13g2_dlygate4sd3_1_4.X a_18123_14495# 0.0537f
C1439 sg13g2_dlygate4sd3_1_11.X a_21070_15423# 0.08804f
C1440 sg13g2_dfrbpq_1_2.Q sg13g2_o21ai_1_2.A2 0.03379f
C1441 sg13g2_or3_1_1.B sg13g2_nor2_1_0.B 0.01935f
C1442 sg13g2_dfrbpq_1_6.Q sg13g2_o21ai_1_2.A2 0.21694f
C1443 sg13g2_a21oi_1_0.B1 a_25206_15302# 0.02107f
C1444 a_3333_15213# sg13g2_dlygate4sd3_1_3.A 0.01788f
C1445 sg13g2_dfrbpq_1_5.Q a_27898_15202# 0.23317f
C1446 a_10703_15311# VDD 0.17802f
C1447 sg13g2_or3_1_2.B a_24169_14508# 0.18093f
C1448 a_4078_14751# VDD 0.14757f
C1449 a_12524_15960# counter_value_o[2] 0.13349f
C1450 sg13g2_or3_1_2.B sg13g2_buf_16_2.X 0.54805f
C1451 a_5613_14832# sg13g2_and2_1_1.X 0.06558f
C1452 a_15680_13854# sg13g2_dfrbpq_1_2.D 0.01953f
C1453 sg13g2_dlygate4sd3_1_6.X a_18454_15230# 0.02287f
C1454 sg13g2_or3_1_1.A sg13g2_a21oi_1_3.A1 0.07719f
C1455 sg13g2_dlygate4sd3_1_3.A a_4474_14448# 0.23494f
C1456 a_16055_16071# a_16254_15934# 0.08074f
C1457 a_16055_16301# a_15880_16082# 0.01744f
C1458 a_17578_14452# VDD 0.09887f
C1459 sg13g2_and2_1_0.X a_1965_14832# 0.06463f
C1460 sg13g2_a21oi_1_0.B1 sg13g2_dfrbpq_1_3.RESET_B 0.03353f
C1461 a_16648_13058# VDD 0.14279f
C1462 counter_value_o[0] VDD 0.10122f
C1463 sg13g2_buf_1_10.X a_14344_14570# 0.02139f
C1464 sg13g2_or3_1_2.B sg13g2_dfrbpq_1_2.Q 0.17856f
C1465 a_38536_13854# VDD 0.13407f
C1466 sg13g2_or3_1_2.B sg13g2_dfrbpq_1_6.Q 0.03994f
C1467 a_22145_15424# a_22426_15202# 0.15158f
C1468 a_26475_14495# sg13g2_buf_16_2.X 0.04756f
C1469 a_27313_13799# a_26565_13701# 0.01058f
C1470 a_2630_15234# sg13g2_dlygate4sd3_1_3.A 0.03808f
C1471 sg13g2_dfrbpq_1_6.RESET_B a_21070_15423# 0.04947f
C1472 a_26475_14495# a_27472_14726# 0.01569f
C1473 sg13g2_dfrbpq_1_6.D sg13g2_o21ai_1_1.Y 0.08601f
C1474 a_24923_15996# VDD 0.14042f
C1475 sg13g2_dfrbpq_1_2.Q a_17825_15424# 0.06162f
C1476 sg13g2_a21oi_1_0.A2 a_17030_15238# 0.05498f
C1477 sg13g2_a21oi_1_0.B1 sg13g2_a21oi_1_0.A2 0.03598f
C1478 a_16044_15424# a_16079_15238# 0.17527f
C1479 a_22986_14484# sg13g2_buf_16_2.X 0.01556f
C1480 sg13g2_dfrbpq_1_2.Q a_22145_15424# 0.01321f
C1481 sg13g2_dfrbpq_1_6.RESET_B a_21034_14452# 0.13387f
C1482 a_38536_3986# a_38720_3986# 0.0262f
C1483 a_38536_10034# a_38720_10034# 0.0262f
C1484 sg13g2_dfrbpq_1_2.CLK a_9963_15356# 0.0255f
C1485 a_27407_13799# VDD 0.17779f
C1486 sg13g2_dlygate4sd3_1_8.X sg13g2_xnor2_1_0.Y 0.0558f
C1487 sg13g2_xor2_1_0.B a_2516_14484# 0.01121f
C1488 a_6891_14495# VDD 0.20425f
C1489 sg13g2_dfrbpq_1_5.RESET_B sg13g2_o21ai_1_2.B1 0.11618f
C1490 sg13g2_dlygate4sd3_1_5.A a_18454_15230# 0.05271f
C1491 a_17030_15238# VDD 0.20101f
C1492 sg13g2_dfrbpq_1_6.Q a_22986_14484# 0.07301f
C1493 sg13g2_buf_1_0.X sg13g2_xnor2_1_2.B 0.21353f
C1494 sg13g2_a21oi_1_0.B1 VDD 1.6309f
C1495 sg13g2_a21oi_1_1.Y sg13g2_dfrbpq_1_3.Q 0.02214f
C1496 sg13g2_or3_1_1.A a_25094_14484# 0.02191f
C1497 a_18298_16237# sg13g2_dlygate4sd3_1_6.X 0.01045f
C1498 sg13g2_buf_1_10.X sg13g2_and2_1_1.X 0.03778f
C1499 a_2248_16082# counter_value_o[0] 0.02118f
C1500 a_16356_13735# a_16068_14040# 0.22255f
C1501 sg13g2_buf_1_0.X sg13g2_dlygate4sd3_1_1.A 0.20248f
C1502 VDD a_27502_15423# 0.1454f
C1503 VDD a_22030_15423# 0.14394f
C1504 a_10960_15454# sg13g2_tiehi_1.L_HI 0.06198f
C1505 sg13g2_dfrbpq_1_2.CLK sg13g2_and2_1_2.B 0.03334f
C1506 sg13g2_or3_1_2.B sg13g2_dlygate4sd3_1_4.X 0.11113f
C1507 a_21034_14452# a_21477_14495# 0.02242f
C1508 sg13g2_nand4_1_0.Y sg13g2_and2_1_2.X 0.03117f
C1509 sg13g2_dfrbpq_1_3.Q counter_value_o[4] 0.0101f
C1510 a_16068_14040# a_16587_13844# 0.18372f
C1511 sg13g2_xnor2_1_2.A sg13g2_buf_1_10.X 0.0312f
C1512 sg13g2_or3_1_2.B sg13g2_nor2_1_0.B 0.04056f
C1513 a_16068_14040# sg13g2_a21oi_1_0.Y 0.01493f
C1514 a_17318_14922# a_18123_14495# 0.06896f
C1515 a_9861_15213# a_9963_15356# 0.26919f
C1516 VDD a_25206_15302# 0.14627f
C1517 sg13g2_o21ai_1_3.Y a_25505_16262# 0.02432f
C1518 a_21034_14452# sg13g2_or3_1_2.C 0.0121f
C1519 sg13g2_or3_1_1.B sg13g2_o21ai_1_2.A2 0.01019f
C1520 sg13g2_dlygate4sd3_1_8.A a_10609_15311# 0.0175f
C1521 a_16485_13701# sg13g2_a21oi_1_0.A2 0.03844f
C1522 sg13g2_dfrbpq_1_6.D a_20774_14922# 0.16155f
C1523 sg13g2_xor2_1_0.B a_6372_14488# 0.02399f
C1524 a_9158_15234# sg13g2_tiehi_1.L_HI 0.08194f
C1525 a_9444_15552# a_9418_15457# 0.21121f
C1526 a_21166_16263# a_21281_16262# 0.32411f
C1527 a_26373_14495# VDD 0.24654f
C1528 a_9737_14822# sg13g2_tiehi_1.L_HI 0.02156f
C1529 sg13g2_dfrbpq_1_2.Q a_19169_15424# 0.03402f
C1530 sg13g2_buf_16_2.X sg13g2_dfrbpq_1_7.D 0.01302f
C1531 sg13g2_dfrbpq_1_3.RESET_B VDD 1.09051f
C1532 a_6540_13238# a_6575_13342# 0.17527f
C1533 enable_i VDD 0.25308f
C1534 sg13g2_or3_1_1.B a_24841_13726# 0.15246f
C1535 a_11752_15366# VDD 0.14612f
C1536 sg13g2_or3_1_2.B counter_value_o[3] 0.02486f
C1537 a_16485_13701# VDD 0.25184f
C1538 a_20376_14464# sg13g2_o21ai_1_1.Y 0.01075f
C1539 a_5886_15486# VDD 0.09484f
C1540 sg13g2_o21ai_1_2.B1 sg13g2_a21oi_1_3.A1 0.02748f
C1541 sg13g2_or3_1_2.B sg13g2_or3_1_1.B 0.51265f
C1542 a_26554_16237# sg13g2_dfrbpq_1_5.RESET_B 0.03978f
C1543 sg13g2_a21oi_1_1.Y sg13g2_dfrbpq_1_6.D 0.02456f
C1544 a_24365_14508# a_24169_14508# 0.01473f
C1545 a_20278_14862# VDD 0.01106f
C1546 sg13g2_dfrbpq_1_5.RESET_B a_26170_15202# 0.02239f
C1547 sg13g2_or3_1_1.X sg13g2_dlygate4sd3_1_17.A 0.09132f
C1548 sg13g2_dlygate4sd3_1_8.A a_10618_14448# 0.23489f
C1549 sg13g2_a21oi_1_0.A2 VDD 0.45012f
C1550 a_8694_15302# sg13g2_and2_1_2.B 0.10685f
C1551 a_3435_15356# a_4175_15311# 0.15395f
C1552 a_3333_15213# sg13g2_buf_1_0.X 0.0155f
C1553 sg13g2_dfrbpq_1_2.CLK sg13g2_or3_1_1.B 0.05347f
C1554 counter_value_o[7] VSS 2.2765f
C1555 counter_value_o[6] VSS 2.0145f
C1556 counter_value_o[5] VSS 1.86644f
C1557 counter_value_o[4] VSS 1.55051f
C1558 counter_value_o[3] VSS 1.66873f
C1559 counter_value_o[2] VSS 1.71622f
C1560 counter_value_o[1] VSS 1.55762f
C1561 counter_value_o[0] VSS 1.87814f
C1562 a_38720_3986# VSS 0.07631f ; **FLOATING
C1563 a_38536_3986# VSS 0.0891f ; **FLOATING
C1564 a_38720_10034# VSS 0.07628f ; **FLOATING
C1565 a_38536_10034# VSS 0.0891f ; **FLOATING
C1566 a_38720_13058# VSS 0.08186f ; **FLOATING
C1567 a_25109_12972# VSS 0.45705f
C1568 a_25203_13320# VSS 0.14658f
C1569 a_16955_12972# VSS 0.11273f
C1570 a_17057_13320# VSS 0.47646f
C1571 a_16648_13058# VSS 0.09445f ; **FLOATING
C1572 a_6575_13342# VSS 0.17903f
C1573 a_6280_13058# VSS 0.08809f ; **FLOATING
C1574 a_38720_13854# VSS 0.07453f ; **FLOATING
C1575 a_38536_13854# VSS 0.09103f ; **FLOATING
C1576 a_27313_13799# VSS 0.05794f
C1577 a_26374_13735# VSS 0.7285f
C1578 a_26436_13735# VSS 0.5826f
C1579 a_27609_14037# VSS 0.13818f
C1580 a_25956_13722# VSS 0.0572f
C1581 a_26505_14113# VSS 0.3179f
C1582 a_25862_13722# VSS 0.27582f
C1583 a_25037_14020# VSS 0.05686f
C1584 a_24841_13726# VSS 0.0918f
C1585 a_22125_14020# VSS 0.27696f
C1586 a_22036_14020# VSS 0.22388f
C1587 a_19232_13854# VSS 0.04404f ; **FLOATING
C1588 a_17233_13799# VSS 0.05788f
C1589 a_16356_13735# VSS 0.13281f
C1590 a_17529_14037# VSS 0.07313f
C1591 a_15876_13722# VSS 0.07324f
C1592 a_16425_14113# VSS 0.46839f
C1593 a_15782_13722# VSS 0.92298f
C1594 a_15680_13854# VSS 0.0408f ; **FLOATING
C1595 a_16042_13945# VSS 0.31931f
C1596 a_6080_13854# VSS 0.03938f ; **FLOATING
C1597 a_5896_13854# VSS 0.09276f ; **FLOATING
C1598 a_6286_13911# VSS 0.0686f
C1599 a_38720_14570# VSS 0.08096f ; **FLOATING
C1600 a_27417_14607# VSS 0.12259f
C1601 a_26313_14531# VSS 0.26891f
C1602 a_27634_14922# VSS 0.1489f
C1603 a_27121_14845# VSS 0.12957f
C1604 a_27215_14845# VSS 0.05726f
C1605 a_26244_14909# VSS 0.56055f
C1606 a_26182_14909# VSS 0.79475f
C1607 a_24263_14508# VSS 0.26053f
C1608 a_23736_14464# VSS 0.03999f
C1609 a_25764_14922# VSS 0.15561f
C1610 a_25670_14922# VSS 0.548f
C1611 a_25094_14484# VSS 0.17496f
C1612 sg13g2_a21oi_1_3.A2 VSS 0.01941f
C1613 a_23552_14570# VSS 0.03584f ; **FLOATING
C1614 a_23368_14570# VSS 0.07808f ; **FLOATING
C1615 a_23638_14862# VSS 1.23862f
C1616 a_21417_14531# VSS 0.07311f
C1617 a_22225_14845# VSS 0.28218f
C1618 a_21348_14909# VSS 0.48806f
C1619 a_21286_14909# VSS 0.45083f
C1620 a_20868_14922# VSS 0.17922f
C1621 a_20774_14922# VSS 0.50128f
C1622 a_20278_14862# VSS 0.16652f
C1623 a_17961_14531# VSS 0.12923f
C1624 a_19282_14922# VSS 0.01933f
C1625 a_18769_14845# VSS 0.13095f
C1626 a_17892_14909# VSS 0.48505f
C1627 a_17830_14909# VSS 0.44833f
C1628 a_17412_14922# VSS 0.42493f
C1629 a_17318_14922# VSS 0.73688f
C1630 a_14816_14570# VSS 0.0433f ; **FLOATING
C1631 a_14344_14570# VSS 0.09551f ; **FLOATING
C1632 a_10016_14570# VSS 0.03932f ; **FLOATING
C1633 a_10618_14448# VSS 0.05722f
C1634 a_10222_14751# VSS 0.14637f
C1635 a_9536_14570# VSS 0.0441f ; **FLOATING
C1636 a_7833_14607# VSS 0.22733f
C1637 a_9658_14725# VSS 0.07811f
C1638 a_8779_14832# VSS 0.09327f
C1639 a_6729_14531# VSS 0.45013f
C1640 a_8050_14922# VSS 0.45796f
C1641 a_7537_14845# VSS 0.1302f
C1642 a_6660_14909# VSS 0.3807f
C1643 a_6598_14909# VSS 0.34383f
C1644 a_6180_14922# VSS 0.18046f
C1645 a_5707_14832# VSS 0.04504f
C1646 a_5504_14570# VSS 0.05371f ; **FLOATING
C1647 a_6086_14922# VSS 0.59032f
C1648 sg13g2_dlygate4sd3_1_0.X VSS 0.07345f
C1649 a_3872_14570# VSS 0.05491f ; **FLOATING
C1650 a_2516_14484# VSS 0.21471f
C1651 a_2646_14842# VSS 0.04488f
C1652 a_2059_14832# VSS 0.60576f
C1653 a_1856_14570# VSS 0.054f ; **FLOATING
C1654 sg13g2_buf_1_10.X VSS 0.14295f
C1655 a_38720_15366# VSS 0.08189f ; **FLOATING
C1656 a_27617_15424# VSS 0.15258f
C1657 a_24310_15230# VSS 0.12554f
C1658 a_24062_15242# VSS 0.07425f
C1659 a_23858_15242# VSS 0.01185f
C1660 a_23480_15242# VSS 0.08485f
C1661 a_23378_15242# VSS 0.04496f
C1662 a_25094_15238# VSS 0.13868f
C1663 sg13g2_o21ai_1_2.Y VSS 0.03999f
C1664 a_24408_15552# VSS 0.23646f
C1665 a_23168_15366# VSS 0.04381f ; **FLOATING
C1666 a_21824_15366# VSS 0.04441f ; **FLOATING
C1667 a_20705_15260# VSS 0.0115f
C1668 a_20218_15238# VSS 0.01306f
C1669 sg13g2_or3_1_2.A VSS 0.07239f
C1670 a_20603_15532# VSS 0.48429f
C1671 a_20000_15366# VSS 0.03774f ; **FLOATING
C1672 a_19816_15366# VSS 0.08179f ; **FLOATING
C1673 a_18454_15230# VSS 0.2308f
C1674 sg13g2_dlygate4sd3_1_11.X VSS 0.04885f
C1675 a_18552_15552# VSS 0.35869f
C1676 a_16079_15238# VSS 0.08111f
C1677 sg13g2_dlygate4sd3_1_5.A VSS 0.46222f
C1678 sg13g2_a21oi_1_0.A1 VSS 0.06939f
C1679 sg13g2_dfrbpq_1_3.D VSS 0.06915f
C1680 a_17710_15423# VSS 0.02046f
C1681 a_15722_15532# VSS 0.14548f
C1682 a_15488_15366# VSS 0.04427f ; **FLOATING
C1683 a_11752_15366# VSS 0.08373f ; **FLOATING
C1684 a_11122_15234# VSS 0.24551f
C1685 a_10609_15311# VSS 0.058f
C1686 a_9670_15247# VSS 0.02063f
C1687 a_9732_15247# VSS 0.05734f
C1688 a_10905_15549# VSS 0.2927f
C1689 a_9252_15234# VSS 0.49929f
C1690 a_7829_15238# VSS 0.08113f
C1691 a_9801_15625# VSS 0.56029f
C1692 a_9158_15234# VSS 0.38715f
C1693 a_9418_15457# VSS 0.01697f
C1694 a_8582_15238# VSS 0.14182f
C1695 a_7058_15242# VSS 0.464f
C1696 a_6578_15242# VSS 0.01219f
C1697 a_7923_15532# VSS 0.61533f
C1698 a_5600_15366# VSS 0.04045f ; **FLOATING
C1699 a_5886_15486# VSS 0.08166f
C1700 a_4081_15311# VSS 0.13282f
C1701 a_3142_15247# VSS 0.62548f
C1702 a_3204_15247# VSS 0.64588f
C1703 a_3273_15625# VSS 0.08304f
C1704 a_2630_15234# VSS 0.81349f
C1705 sg13g2_and2_1_0.X VSS 0.08738f
C1706 a_2528_15366# VSS 0.05013f ; **FLOATING
C1707 a_37192_16082# VSS 0.08963f ; **FLOATING
C1708 a_32200_16082# VSS 0.09113f ; **FLOATING
C1709 a_32492_15960# VSS 0.04579f
C1710 a_27296_16082# VSS 0.04651f ; **FLOATING
C1711 sg13g2_dfrbpq_1_5.RESET_B VSS 0.05806f
C1712 a_24923_15996# VSS 0.20557f
C1713 a_26170_16237# VSS 0.07968f
C1714 a_25025_16344# VSS 0.29069f
C1715 sg13g2_dlygate4sd3_1_17.A VSS 0.15295f
C1716 a_26633_16334# VSS 0.06155f
C1717 a_25786_15960# VSS 0.33617f
C1718 a_25390_16263# VSS 0.06167f
C1719 a_22304_16082# VSS 0.04037f ; **FLOATING
C1720 a_21946_16237# VSS 0.05549f
C1721 sg13g2_dfrbpq_1_6.D VSS 0.18308f
C1722 a_22025_16334# VSS 0.04892f
C1723 a_18176_16082# VSS 0.04354f ; **FLOATING
C1724 a_17517_16020# VSS 0.41166f
C1725 a_17428_16020# VSS 0.70093f
C1726 sg13g2_dfrbpq_1_2.RESET_B VSS 0.07032f
C1727 a_18298_16237# VSS 0.0891f
C1728 a_17219_16265# VSS 0.02447f
C1729 a_15880_16082# VSS 0.08473f ; **FLOATING
C1730 a_12232_16082# VSS 0.08821f ; **FLOATING
C1731 sg13g2_dlygate4sd3_1_1.A VSS 0.08881f
C1732 a_7240_16082# VSS 0.08925f ; **FLOATING
C1733 a_3008_16082# VSS 0.03902f ; **FLOATING
C1734 a_2824_16082# VSS 0.07954f ; **FLOATING
C1735 a_3130_16237# VSS 0.08869f
C1736 a_2248_16082# VSS 0.09051f ; **FLOATING
C1737 VSS.t553 VSS 0.10685f
C1738 VSS.t81 VSS 0.45225f
C1739 VSS.t9 VSS 3.58003f
C1740 VSS.t3063 VSS 0.71738f
C1741 VSS.t3068 VSS 0.18571f
C1742 VSS.t3088 VSS 0.25712f
C1743 VSS.t3108 VSS 0.15876f
C1744 VSS.t3138 VSS 0.64427f
C1745 VSS.t3143 VSS 0.07764f
C1746 VSS.t3163 VSS 0.01941f
C1747 VSS.t3024 VSS 0.01569f
C1748 VSS.t2765 VSS 0.05726f
C1749 VSS.t2773 VSS 0.46224f
C1750 VSS.t2781 VSS 0.15675f
C1751 VSS.t2779 VSS 0.0229f
C1752 VSS.t2782 VSS 0.03458f
C1753 VSS.t2784 VSS 0.15014f
C1754 VSS.t2787 VSS 0.06825f
C1755 VSS.t2785 VSS 0.11556f
C1756 VSS.t2799 VSS 0.56811f
C1757 VSS.t2802 VSS 0.01828f
C1758 VSS.t2808 VSS 0.08707f
C1759 VSS.t2822 VSS 0.10846f
C1760 VSS.t2821 VSS 0.10846f
C1761 VSS.t2827 VSS 0.0425f
C1762 VSS.t2830 VSS 0.18648f
C1763 VSS.t2829 VSS 0.61979f
C1764 VSS.t2837 VSS 0.05841f
C1765 VSS.t2838 VSS 0.05841f
C1766 VSS.t2840 VSS 0.06178f
C1767 VSS.t2848 VSS 0.45113f
C1768 VSS.t2851 VSS 1.23564f
C1769 VSS.t2864 VSS 0.07455f
C1770 VSS.t2868 VSS 0.04325f
C1771 VSS.t2869 VSS 0.04325f
C1772 VSS.t2871 VSS 0.03105f
C1773 VSS.t2870 VSS 0.31548f
C1774 VSS.t2872 VSS 0.03105f
C1775 VSS.t2875 VSS 0.11397f
C1776 VSS.t2878 VSS 0.03882f
C1777 VSS.t2880 VSS 0.27087f
C1778 VSS.t2885 VSS 0.03717f
C1779 VSS.t2887 VSS 0.22497f
C1780 VSS.t2886 VSS 0.03717f
C1781 VSS.t2888 VSS 0.22497f
C1782 VSS.t3013 VSS 0.0329f
C1783 VSS.t2891 VSS 0.0329f
C1784 VSS.t2503 VSS 0.57151f
C1785 VSS.t2493 VSS 0.20005f
C1786 VSS.t2478 VSS 0.03664f
C1787 VSS.t2473 VSS 0.34588f
C1788 VSS.t2448 VSS 0.05937f
C1789 VSS.t2438 VSS 0.15657f
C1790 VSS.t2432 VSS 0.12856f
C1791 VSS.t2433 VSS 0.12856f
C1792 VSS.t2423 VSS 0.03469f
C1793 VSS.t2418 VSS 0.02006f
C1794 VSS.t2410 VSS 0.04202f
C1795 VSS.t2408 VSS 0.04202f
C1796 VSS.t2403 VSS 0.07434f
C1797 VSS.t2000 VSS 0.1243f
C1798 VSS.t1996 VSS 0.0662f
C1799 VSS.t2001 VSS 0.49843f
C1800 VSS.t2003 VSS 0.37412f
C1801 VSS.t2011 VSS 0.20596f
C1802 VSS.t2016 VSS 0.02622f
C1803 VSS.t2020 VSS 0.01864f
C1804 VSS.t2021 VSS 0.01864f
C1805 VSS.t2026 VSS 0.10321f
C1806 VSS.t2025 VSS 0.03412f
C1807 VSS.t2031 VSS 0.03815f
C1808 VSS.t2033 VSS 0.03815f
C1809 VSS.t2046 VSS 0.05602f
C1810 VSS.t2056 VSS 0.02968f
C1811 VSS.t2055 VSS 0.02968f
C1812 VSS.t2066 VSS 0.05149f
C1813 VSS.t2065 VSS 0.05149f
C1814 VSS.t2086 VSS 0.07417f
C1815 VSS.t2085 VSS 0.07417f
C1816 VSS.t2091 VSS 0.0229f
C1817 VSS.t2096 VSS 0.03151f
C1818 VSS.t2121 VSS 0.21055f
C1819 VSS.t2123 VSS 0.21055f
C1820 VSS.t2130 VSS 0.08647f
C1821 VSS.t2131 VSS 0.1939f
C1822 VSS.t2136 VSS 0.17487f
C1823 VSS.t2146 VSS 0.08813f
C1824 VSS.t2145 VSS 0.01049f
C1825 VSS.t2150 VSS 0.06962f
C1826 VSS.t2151 VSS 0.29904f
C1827 VSS.t2161 VSS 0.36633f
C1828 VSS.t2166 VSS 0.07574f
C1829 VSS.t2181 VSS 0.06235f
C1830 VSS.t2186 VSS 0.05595f
C1831 VSS.t2206 VSS 0.0686f
C1832 VSS.t2205 VSS 0.0686f
C1833 VSS.t2211 VSS 0.07629f
C1834 VSS.t2216 VSS 0.29556f
C1835 VSS.t1829 VSS 0.21751f
C1836 VSS.t1824 VSS 0.07239f
C1837 VSS.t1819 VSS 0.05573f
C1838 VSS.t1814 VSS 0.16808f
C1839 VSS.t1809 VSS 0.49993f
C1840 VSS.t1799 VSS 0.02054f
C1841 VSS.t1789 VSS 0.09154f
C1842 VSS.t1784 VSS 0.03843f
C1843 VSS.t1779 VSS 0.11681f
C1844 VSS.t1769 VSS 0.1125f
C1845 VSS.t1759 VSS 0.53085f
C1846 VSS.t1744 VSS 0.03968f
C1847 VSS.t1731 VSS 0.02125f
C1848 VSS.t1734 VSS 0.31753f
C1849 VSS.t1728 VSS 0.05236f
C1850 VSS.t1729 VSS 0.143f
C1851 VSS.t1721 VSS 0.03574f
C1852 VSS.t1719 VSS 0.18408f
C1853 VSS.t1367 VSS 0.15738f
C1854 VSS.t1388 VSS 0.01494f
C1855 VSS.t1393 VSS 0.38666f
C1856 VSS.t1394 VSS 0.38666f
C1857 VSS.t1403 VSS 0.07775f
C1858 VSS.t1402 VSS 0.07775f
C1859 VSS.t1551 VSS 0.03234f
C1860 VSS.t1420 VSS 0.03234f
C1861 VSS.t1432 VSS 0.15394f
C1862 VSS.t1431 VSS 0.04451f
C1863 VSS.t1563 VSS 0.2927f
C1864 VSS.t1565 VSS 0.03454f
C1865 VSS.t1434 VSS 0.74592f
C1866 VSS.t1436 VSS 0.03454f
C1867 VSS.t1440 VSS 0.02903f
C1868 VSS.t1439 VSS 0.02903f
C1869 VSS.t1444 VSS 0.37293f
C1870 VSS.t1448 VSS 0.04451f
C1871 VSS.t1449 VSS 0.04451f
C1872 VSS.t1579 VSS 0.03084f
C1873 VSS.t1589 VSS 0.24351f
C1874 VSS.t1594 VSS 0.28887f
C1875 VSS.t1599 VSS 0.10331f
C1876 VSS.t1604 VSS 0.27223f
C1877 VSS.t1629 VSS 0.12602f
C1878 VSS.t1634 VSS 0.07852f
C1879 VSS.t1644 VSS 0.47497f
C1880 VSS.t1654 VSS 0.23811f
C1881 VSS.t1664 VSS 0.05236f
C1882 VSS.t1669 VSS 0.48326f
C1883 VSS.t1673 VSS 0.04178f
C1884 VSS.t1674 VSS 0.04178f
C1885 VSS.t1679 VSS 0.05726f
C1886 VSS.t1683 VSS 0.02787f
C1887 VSS.t1684 VSS 0.44883f
C1888 VSS.t1689 VSS 0.24701f
C1889 VSS.t1686 VSS 0.42096f
C1890 VSS.t1699 VSS 1.18744f
C1891 VSS.t1704 VSS 0.48942f
C1892 VSS.t1714 VSS 70.74253f
C1893 VSS.t1716 VSS 70.42789f
C1894 VSS.t1701 VSS 0.58028f
C1895 VSS.t1691 VSS 0.12992f
C1896 VSS.t1971 VSS 0.02099f
C1897 VSS.t1981 VSS 0.03274f
C1898 VSS.t1986 VSS 0.2004f
C1899 VSS.t1983 VSS 0.03274f
C1900 VSS.t1451 VSS 0.06236f
C1901 VSS.t1292 VSS 0.1367f
C1902 VSS.t1293 VSS 0.07434f
C1903 VSS.t1298 VSS 0.0259f
C1904 VSS.t1303 VSS 0.60594f
C1905 VSS.t1304 VSS 0.60594f
C1906 VSS.t1310 VSS 0.73267f
C1907 VSS.t1309 VSS 0.02046f
C1908 VSS.t1308 VSS 0.02046f
C1909 VSS.t1314 VSS 0.10943f
C1910 VSS.t1480 VSS 0.04197f
C1911 VSS.t1325 VSS 0.35578f
C1912 VSS.t1326 VSS 0.35578f
C1913 VSS.t1329 VSS 0.04232f
C1914 VSS.t1328 VSS 0.04232f
C1915 VSS.t1489 VSS 0.06648f
C1916 VSS.t1498 VSS 0.05809f
C1917 VSS.t1508 VSS 0.12655f
C1918 VSS.t1361 VSS 0.12655f
C1919 VSS.t1366 VSS 0.15738f
C1920 VSS.t1327 VSS 0.17375f
C1921 VSS.t920 VSS 0.07091f
C1922 VSS.t918 VSS 0.07091f
C1923 VSS.t913 VSS 0.56319p
C1924 VSS.t908 VSS 0.05625f
C1925 VSS.t903 VSS 0.08902f
C1926 VSS.t898 VSS 0.20609f
C1927 VSS.t933 VSS 0.22501f
C1928 VSS.t938 VSS 0.01311f
C1929 VSS.t943 VSS 0.04196f
C1930 VSS.t940 VSS 0.01311f
C1931 VSS.t947 VSS 0.18701f
C1932 VSS.t948 VSS 0.18701f
C1933 VSS.t953 VSS 0.0511f
C1934 VSS.t958 VSS 0.28159p
C1935 VSS.t967 VSS 0.14305f
C1936 VSS.t968 VSS 0.14305f
C1937 VSS.t973 VSS 0.03113f
C1938 VSS.t983 VSS 0.11874f
C1939 VSS.t988 VSS 0.06209f
C1940 VSS.t1003 VSS 1.27025f
C1941 VSS.t1008 VSS 71.11808f
C1942 VSS.t1013 VSS 0.27612f
C1943 VSS.t1010 VSS 71.11808f
C1944 VSS.t1012 VSS 0.06972f
C1945 VSS.t1017 VSS 0.05243f
C1946 VSS.t1018 VSS 0.97691f
C1947 VSS.t1043 VSS 0.05845f
C1948 VSS.t1042 VSS 0.05845f
C1949 VSS.t1048 VSS 0.26427f
C1950 VSS.t1053 VSS 0.30408f
C1951 VSS.t1058 VSS 1.18413f
C1952 VSS.t1063 VSS 0.03728f
C1953 VSS.t1060 VSS 1.18413f
C1954 VSS.t1073 VSS 0.21015f
C1955 VSS.t1078 VSS 0.14295f
C1956 VSS.t1080 VSS 0.14295f
C1957 VSS.t1093 VSS 0.16331f
C1958 VSS.t1092 VSS 0.13213f
C1959 VSS.t1103 VSS 0.1779f
C1960 VSS.t1123 VSS 0.16257f
C1961 VSS.t1128 VSS 0.04153f
C1962 VSS.t1130 VSS 0.04153f
C1963 VSS.t1143 VSS 0.03728f
C1964 VSS.t1147 VSS 0.04152f
C1965 VSS.t1148 VSS 0.10731f
C1966 VSS.t1158 VSS 0.223f
C1967 VSS.t1168 VSS 0.93612f
C1968 VSS.t1173 VSS 0.11736f
C1969 VSS.t764 VSS 0.16352f
C1970 VSS.t763 VSS 0.25983f
C1971 VSS.t766 VSS 0.02576f
C1972 VSS.t172 VSS 0.58716f
C1973 VSS.t164 VSS 0.1499f
C1974 VSS.t834 VSS 0.04782f
C1975 VSS.t45 VSS 1.01097f
C1976 VSS.t62 VSS 0.64455f
C1977 VSS.t18 VSS 0.10089f
C1978 VSS.t637 VSS 0.04594f
C1979 VSS.t60 VSS 0.30994f
C1980 VSS.t105 VSS 0.03504f
C1981 VSS.t39 VSS 0.52444f
C1982 VSS.t58 VSS 0.44256f
C1983 VSS.t48 VSS 0.20683f
C1984 VSS.t363 VSS 0.15775f
C1985 VSS.t347 VSS 0.14877f
C1986 VSS.t490 VSS 0.03728f
C1987 VSS.t491 VSS 0.03728f
C1988 VSS.t386 VSS 0.38288f
C1989 VSS.t208 VSS 0.11274f
C1990 VSS.t83 VSS 0.18823f
C1991 VSS.t521 VSS 0.63506f
C1992 VSS.t245 VSS 0.71204f
C1993 VSS.t546 VSS 0.28573f
C1994 VSS.t516 VSS 0.11274f
C1995 VSS.t450 VSS 0.14249f
C1996 VSS.t445 VSS 0.01295f
C1997 VSS.t7 VSS 0.66897f
C1998 VSS.t99 VSS 0.07005f
C1999 VSS.t224 VSS 0.13799f
C2000 VSS.t11 VSS 0.27441f
C2001 VSS.t693 VSS 0.11905f
C2002 VSS.t707 VSS 0.29133f
C2003 VSS.t303 VSS 0.06579f
C2004 VSS.t444 VSS 0.01295f
C2005 VSS.t21 VSS 0.27521f
C2006 VSS.t86 VSS 0.22424f
C2007 VSS.t23 VSS 0.07239f
C2008 VSS.t438 VSS 0.0329f
C2009 VSS.t266 VSS 0.03882f
C2010 VSS.t26 VSS 0.2706f
C2011 VSS.t55 VSS 0.14356f
C2012 VSS.t5 VSS 1.47714f
C2013 VSS.t28 VSS 0.34345f
C2014 VSS.t582 VSS 0.05855f
C2015 VSS.t246 VSS 0.05855f
C2016 VSS.t46 VSS 0.29185f
C2017 VSS.t600 VSS 0.03324f
C2018 VSS.t606 VSS 0.01766f
C2019 VSS.t618 VSS 0.04169f
C2020 VSS.t627 VSS 0.0518f
C2021 VSS.t619 VSS 0.04169f
C2022 VSS.t601 VSS 0.03324f
C2023 VSS.t265 VSS 0.8083f
C2024 VSS.t895 VSS 0.03516f
C2025 VSS.t1105 VSS 0.05372f
C2026 VSS.t1095 VSS 0.03118f
C2027 VSS.t1055 VSS 0.30408f
C2028 VSS.t1005 VSS 0.01603f
C2029 VSS.t955 VSS 0.04178f
C2030 VSS.t1834 VSS 0.09576f
C2031 VSS.t1854 VSS 0.05332f
C2032 VSS.t1856 VSS 0.05332f
C2033 VSS.t2168 VSS 0.01027f
C2034 VSS.t2098 VSS 0.03151f
C2035 VSS.t2048 VSS 0.05602f
C2036 VSS.t1998 VSS 0.0662f
C2037 VSS.t2387 VSS 0.05243f
C2038 VSS.t2388 VSS 0.05243f
C2039 VSS.t2498 VSS 0.31658f
C2040 VSS.t2553 VSS 0.15838f
C2041 VSS.t2558 VSS 0.232f
C2042 VSS.t2555 VSS 0.15838f
C2043 VSS.t2557 VSS 0.1818f
C2044 VSS.t2563 VSS 0.06862f
C2045 VSS.t2568 VSS 0.14197f
C2046 VSS.t2573 VSS 0.12469f
C2047 VSS.t2588 VSS 0.03431f
C2048 VSS.t2593 VSS 0.08957f
C2049 VSS.t2598 VSS 0.06301f
C2050 VSS.t2595 VSS 0.08957f
C2051 VSS.t2608 VSS 0.09158f
C2052 VSS.t2607 VSS 0.09158f
C2053 VSS.t2618 VSS 0.46806f
C2054 VSS.t2617 VSS 0.46806f
C2055 VSS.t2623 VSS 0.41409f
C2056 VSS.t2628 VSS 0.29715f
C2057 VSS.t2627 VSS 0.02944f
C2058 VSS.t2633 VSS 0.35869f
C2059 VSS.t2635 VSS 0.35869f
C2060 VSS.t2570 VSS 0.14197f
C2061 VSS.t2797 VSS 0.56811f
C2062 VSS.t3165 VSS 0.01941f
C2063 VSS.t3140 VSS 0.64427f
C2064 VSS.t3110 VSS 0.15876f
.ends

* PEX produced on Wed Aug 26 09:48:14 AM CEST 2026 using /foss/tools/sak/sak-pex.sh with m=3 and s=1 (extresist threshold=10000 mOhm, minres=1000 mOhm, mindelay=1 ps)
* NGSPICE file created from counter_top_pex.ext - technology: ihp-sg13g2

.subckt counter_top_pex VDD VSS clock_i reset_n_i enable_i counter_value_o[0]
+ counter_value_o[1] counter_value_o[2] counter_value_o[3] counter_value_o[4]
+ counter_value_o[5] counter_value_o[6] counter_value_o[7]
X0 VSS.t271 VDD VSS.t271 VSS.t457 sg13_lv_nmos ad=0.1428p pd=1.52u as=0 ps=0 w=0.42u l=1u
X1 sg13g2_o21ai_1_2.Y sg13g2_o21ai_1_2.B1 a_23638_14862# VSS.t30 sg13_lv_nmos ad=0.2516p pd=2.16u as=0.1406p ps=1.12u w=0.74u l=0.15u
X2 VDD VSS.t1691 VDD VDD sg13_lv_pmos ad=0.19p pd=1.38u as=3.18405n ps=0.01242 w=1u l=1u
X3 VSS.t700 VDD VSS.t302 VSS.t704 sg13_lv_nmos ad=79.8f pd=0.8u as=0 ps=0 w=0.42u l=1u
X4 VDD VSS.t214 VDD VDD sg13_lv_pmos ad=0.34p pd=2.68u as=0 ps=0 w=1u l=1u
X5 a_18874_13690# sg13g2_dfrbpq_1_2.Q VDD VDD sg13_lv_pmos ad=0.1428p pd=1.52u as=0.1523p ps=1.38u w=0.42u l=0.13u
X6 VSS.t1293 VDD VSS.t1294 VSS.t377 sg13_lv_nmos ad=79.8f pd=0.8u as=0 ps=0 w=0.42u l=1u
X7 VSS.t2358 VDD VSS.t2357 VSS.t2356 sg13_lv_nmos ad=0.1428p pd=1.52u as=0 ps=0 w=0.42u l=1u
X8 VSS.t1971 VDD VSS.t1973 VSS.t1972 sg13_lv_nmos ad=79.8f pd=0.8u as=0 ps=0 w=0.42u l=1u
X9 VDD VSS.t1421 VDD VDD sg13_lv_pmos ad=0.34p pd=2.68u as=0 ps=0 w=1u l=1u
X10 VSS.t760 VDD VSS.t758 VSS.t759 sg13_lv_nmos ad=0.1428p pd=1.52u as=0 ps=0 w=0.42u l=1u
X11 VDD VSS.t1293 VDD VDD sg13_lv_pmos ad=0.19p pd=1.38u as=0 ps=0 w=1u l=1u
X12 VSS.t2433 VDD VSS.t2432 VSS.t2431 sg13_lv_nmos ad=0.1428p pd=1.52u as=0 ps=0 w=0.42u l=1u
X13 VSS.t1719 VDD VSS.t1718 VSS.t1717 sg13_lv_nmos ad=0.1428p pd=1.52u as=0 ps=0 w=0.42u l=1u
X14 VSS.t3245 VDD VSS.t3244 VSS.t3243 sg13_lv_nmos ad=0.1428p pd=1.52u as=0 ps=0 w=0.42u l=1u
X15 VDD VSS.t2392 VDD VDD sg13_lv_pmos ad=0.34p pd=2.68u as=0 ps=0 w=1u l=1u
X16 a_1965_14832# sg13g2_buf_1_10.X VDD VDD sg13_lv_pmos ad=0.1596p pd=1.22u as=0.2856p ps=2.36u w=0.84u l=0.13u
X17 VSS.t1010 VDD VSS.t1009 VSS.t1008 sg13_lv_nmos ad=0.1428p pd=1.52u as=0 ps=0 w=0.42u l=1u
X18 VSS.t2801 VDD VSS.t2802 VSS.t412 sg13_lv_nmos ad=79.8f pd=0.8u as=0 ps=0 w=0.42u l=1u
X19 a_25094_15238# a_24824_15238# VSS.t78 VSS.t28 sg13_lv_nmos ad=0.1428p pd=1.52u as=79.8f ps=0.8u w=0.42u l=0.5u
X20 VSS.t1055 VDD VSS.t1054 VSS.t1053 sg13_lv_nmos ad=0.1428p pd=1.52u as=0 ps=0 w=0.42u l=1u
X21 VSS.t930 VDD VSS.t932 VSS.t931 sg13_lv_nmos ad=79.8f pd=0.8u as=0 ps=0 w=0.42u l=1u
X22 VSS.t1365 VDD VSS.t1367 VSS.t377 sg13_lv_nmos ad=79.8f pd=0.8u as=0 ps=0 w=0.42u l=1u
X23 VSS.t2868 VDD VSS.t2869 VSS.t412 sg13_lv_nmos ad=79.8f pd=0.8u as=0 ps=0 w=0.42u l=1u
X24 VSS.t2001 VDD VSS.t2000 VSS.t1999 sg13_lv_nmos ad=0.1428p pd=1.52u as=0 ps=0 w=0.42u l=1u
X25 VDD VSS.t1841 VDD VDD sg13_lv_pmos ad=0.19p pd=1.38u as=0 ps=0 w=1u l=1u
X26 VDD VSS.t3132 VDD VDD sg13_lv_pmos ad=0.19p pd=1.38u as=0 ps=0 w=1u l=1u
X27 VDD VSS.t1998 VDD VDD sg13_lv_pmos ad=0.19p pd=1.38u as=0 ps=0 w=1u l=1u
X28 VDD sg13g2_dfrbpq_1_2.RESET_B a_15782_13722# VDD sg13_lv_pmos ad=0.36237p pd=2.605u as=79.8f ps=0.8u w=0.42u l=0.13u
X29 VSS.t1714 VDD VSS.t1713 VSS.t1712 sg13_lv_nmos ad=0.1428p pd=1.52u as=0 ps=0 w=0.42u l=1u
X30 VSS.t14 sg13g2_or3_1_1.A a_24841_13726# VSS.t218 sg13_lv_nmos ad=0.13395p pd=1.12u as=0.198p ps=1.27u w=0.55u l=0.13u
X31 VSS.t2844 VDD VSS.t2844 VSS.t412 sg13_lv_nmos ad=0.1428p pd=1.52u as=0 ps=0 w=0.42u l=1u
X32 VSS.t2241 VDD VSS.t2240 VSS.t2239 sg13_lv_nmos ad=0.1428p pd=1.52u as=0 ps=0 w=0.42u l=1u
X33 VDD VSS.t1365 VDD VDD sg13_lv_pmos ad=0.34p pd=2.68u as=0 ps=0 w=1u l=1u
X34 VDD VSS.t2869 VDD VDD sg13_lv_pmos ad=0.34p pd=2.68u as=0 ps=0 w=1u l=1u
X35 VDD sg13g2_a21oi_1_3.A2 a_25109_12972# VDD sg13_lv_pmos ad=0.2128p pd=1.5u as=0.3808p ps=2.92u w=1.12u l=0.13u
X36 VSS.t1115 VDD VSS.t1117 VSS.t1116 sg13_lv_nmos ad=79.8f pd=0.8u as=0 ps=0 w=0.42u l=1u
X37 VDD VSS.t2530 VDD VDD sg13_lv_pmos ad=0.19p pd=1.38u as=0 ps=0 w=1u l=1u
X38 VDD VSS.t2188 VDD VDD sg13_lv_pmos ad=0.19p pd=1.38u as=0 ps=0 w=1u l=1u
X39 VDD VSS.t2365 VDD VDD sg13_lv_pmos ad=0.19p pd=1.38u as=0 ps=0 w=1u l=1u
X40 a_18021_14495# sg13g2_buf_16_2.X VDD VDD sg13_lv_pmos ad=0.4088p pd=2.97u as=2.3367p ps=15.135u w=1.12u l=0.13u
X41 VDD VSS.t982 VDD VDD sg13_lv_pmos ad=0.19p pd=1.38u as=0 ps=0 w=1u l=1u
X42 VSS.t1385 VDD VSS.t1386 VSS.t377 sg13_lv_nmos ad=79.8f pd=0.8u as=0 ps=0 w=0.42u l=1u
X43 VSS.t2786 VDD VSS.t2786 VSS.t412 sg13_lv_nmos ad=0.1428p pd=1.52u as=0 ps=0 w=0.42u l=1u
X44 VSS.t2548 VDD VSS.t2550 VSS.t2549 sg13_lv_nmos ad=79.8f pd=0.8u as=0 ps=0 w=0.42u l=1u
X45 VDD VSS.t1636 VDD VDD sg13_lv_pmos ad=0.19p pd=1.38u as=0 ps=0 w=1u l=1u
X46 VDD VSS.t1653 VDD VDD sg13_lv_pmos ad=0.34p pd=2.68u as=0 ps=0 w=1u l=1u
X47 VSS.t2755 VDD VSS.t2756 VSS.t412 sg13_lv_nmos ad=79.8f pd=0.8u as=0 ps=0 w=0.42u l=1u
X48 VDD VSS.t475 VDD VDD sg13_lv_pmos ad=0.19p pd=1.38u as=0 ps=0 w=1u l=1u
X49 a_10703_15311# a_9861_15213# a_9444_15552# VDD sg13_lv_pmos ad=0.2048p pd=1.63u as=0.34p ps=2.68u w=1u l=0.13u
X50 VSS.t2453 VDD VSS.t2452 VSS.t2451 sg13_lv_nmos ad=0.1428p pd=1.52u as=0 ps=0 w=0.42u l=1u
X51 VDD VSS.t142 VDD VDD sg13_lv_pmos ad=0.34p pd=2.68u as=0 ps=0 w=1u l=1u
X52 a_15022_14484# clock_i VSS.t16 VSS.t364 sg13_lv_nmos ad=0.1406p pd=1.12u as=0.1406p ps=1.12u w=0.74u l=0.13u
X53 VDD VSS.t2215 VDD VDD sg13_lv_pmos ad=0.34p pd=2.68u as=0 ps=0 w=1u l=1u
X54 a_16068_14040# a_16042_13945# VSS.t356 VSS.t355 sg13_lv_nmos ad=0.2516p pd=2.16u as=0.1626p ps=1.415u w=0.74u l=0.13u
X55 VSS.t1085 VDD VSS.t1087 VSS.t1086 sg13_lv_nmos ad=79.8f pd=0.8u as=0 ps=0 w=0.42u l=1u
X56 VDD VSS.t1074 VDD VDD sg13_lv_pmos ad=0.34p pd=2.68u as=0 ps=0 w=1u l=1u
X57 VDD VSS.t1357 VDD VDD sg13_lv_pmos ad=0.34p pd=2.68u as=0 ps=0 w=1u l=1u
X58 VDD VSS.t1990 VDD VDD sg13_lv_pmos ad=0.34p pd=2.68u as=0 ps=0 w=1u l=1u
X59 VDD VSS.t2833 VDD VDD sg13_lv_pmos ad=0.34p pd=2.68u as=0 ps=0 w=1u l=1u
X60 a_10960_15454# a_10703_15311# a_11122_15234# VSS.t429 sg13_lv_nmos ad=0.1428p pd=1.52u as=37.8f ps=0.6u w=0.42u l=0.13u
X61 VDD VSS.t2756 VDD VDD sg13_lv_pmos ad=0.34p pd=2.68u as=0 ps=0 w=1u l=1u
X62 VDD VSS.t3152 VDD VDD sg13_lv_pmos ad=0.19p pd=1.38u as=0 ps=0 w=1u l=1u
X63 VDD VSS.t2018 VDD VDD sg13_lv_pmos ad=0.19p pd=1.38u as=0 ps=0 w=1u l=1u
X64 VSS.t1834 VDD VSS.t1836 VSS.t1835 sg13_lv_nmos ad=79.8f pd=0.8u as=0 ps=0 w=0.42u l=1u
X65 VDD VSS.t613 VDD VDD sg13_lv_pmos ad=0.19p pd=1.38u as=0 ps=0 w=1u l=1u
X66 VSS.t2226 VDD VSS.t2225 VSS.t2224 sg13_lv_nmos ad=0.1428p pd=1.52u as=0 ps=0 w=0.42u l=1u
X67 VDD VSS.t2180 VDD VDD sg13_lv_pmos ad=0.34p pd=2.68u as=0 ps=0 w=1u l=1u
X68 VDD VSS.t1283 VDD VDD sg13_lv_pmos ad=0.34p pd=2.68u as=0 ps=0 w=1u l=1u
X69 VDD sg13g2_or3_1_1.A sg13g2_o21ai_1_3.Y VDD sg13_lv_pmos ad=0.3808p pd=2.92u as=0.2128p ps=1.5u w=1.12u l=0.15u
X70 VDD VSS.t1137 VDD VDD sg13_lv_pmos ad=0.19p pd=1.38u as=0 ps=0 w=1u l=1u
X71 VSS.t1534 VDD VSS.t1399 VSS.t377 sg13_lv_nmos ad=79.8f pd=0.8u as=0 ps=0 w=0.42u l=1u
X72 VSS.t24 sg13g2_dfrbpq_1_3.RESET_B a_17412_14922# VSS.t86 sg13_lv_nmos ad=0.1626p pd=1.415u as=60.89999f ps=0.71u w=0.42u l=0.13u
X73 VSS.t1704 VDD VSS.t1706 VSS.t1705 sg13_lv_nmos ad=79.8f pd=0.8u as=0 ps=0 w=0.42u l=1u
X74 VDD VSS.t2482 VDD VDD sg13_lv_pmos ad=0.34p pd=2.68u as=0 ps=0 w=1u l=1u
X75 VSS.t1005 VDD VSS.t1007 VSS.t1006 sg13_lv_nmos ad=79.8f pd=0.8u as=0 ps=0 w=0.42u l=1u
X76 VSS.t1574 VDD VSS.t1576 VSS.t1575 sg13_lv_nmos ad=79.8f pd=0.8u as=0 ps=0 w=0.42u l=1u
X77 a_17900_15960# sg13g2_dfrbpq_1_2.Q VDD VDD sg13_lv_pmos ad=0.2856p pd=2.36u as=0.2114p ps=1.54u w=0.84u l=0.13u
X78 VSS.t158 a_32492_15960# counter_value_o[6] VSS.t216 sg13_lv_nmos ad=0.14875p pd=1.16u as=0.2886p ps=2.26u w=0.74u l=0.13u
X79 VSS.t2767 VDD VSS.t2768 VSS.t412 sg13_lv_nmos ad=79.8f pd=0.8u as=0 ps=0 w=0.42u l=1u
X80 a_21070_15423# a_21185_15424# VSS.t6 VSS.t5 sg13_lv_nmos ad=0.1428p pd=1.52u as=0.1426p ps=1.16u w=0.42u l=0.5u
X81 VDD VSS.t565 VDD VDD sg13_lv_pmos ad=0.34p pd=2.68u as=0 ps=0 w=1u l=1u
X82 VDD VSS.t853 VDD VDD sg13_lv_pmos ad=0.19p pd=1.38u as=0 ps=0 w=1u l=1u
X83 sg13g2_and2_1_2.B a_8694_15302# VDD VDD sg13_lv_pmos ad=0.4256p pd=3u as=0.2254p ps=1.53u w=1.12u l=0.13u
X84 VDD VSS.t1284 VDD VDD sg13_lv_pmos ad=0.19p pd=1.38u as=0 ps=0 w=1u l=1u
X85 VDD VSS.t2058 VDD VDD sg13_lv_pmos ad=0.19p pd=1.38u as=0 ps=0 w=1u l=1u
X86 VSS.t1055 VDD VSS.t1054 VSS.t1053 sg13_lv_nmos ad=0.1428p pd=1.52u as=0 ps=0 w=0.42u l=1u
X87 VDD VSS.t2377 VDD VDD sg13_lv_pmos ad=0.34p pd=2.68u as=0 ps=0 w=1u l=1u
X88 a_7923_15532# sg13g2_dlygate4sd3_1_8.X VDD VDD sg13_lv_pmos ad=0.1428p pd=1.375u as=0.2891p ps=1.695u w=1.12u l=0.13u
X89 VDD VSS.t1975 VDD VDD sg13_lv_pmos ad=0.34p pd=2.68u as=0 ps=0 w=1u l=1u
X90 VSS.t2889 VDD VSS.t3012 VSS.t412 sg13_lv_nmos ad=0.1428p pd=1.52u as=0 ps=0 w=0.42u l=1u
X91 VDD VSS.t2768 VDD VDD sg13_lv_pmos ad=0.34p pd=2.68u as=0 ps=0 w=1u l=1u
X92 VDD VSS.t2863 VDD VDD sg13_lv_pmos ad=0.19p pd=1.38u as=0 ps=0 w=1u l=1u
X93 VDD VSS.t593 VDD VDD sg13_lv_pmos ad=0.34p pd=2.68u as=0 ps=0 w=1u l=1u
X94 VDD sg13g2_o21ai_1_2.B1 a_24365_14508# VDD sg13_lv_pmos ad=0.3822p pd=1.84u as=0.1575p ps=1.315u w=1u l=0.13u
X95 VSS.t14 sg13g2_a21oi_1_0.B1 sg13g2_a21oi_1_3.Y VSS.t13 sg13_lv_nmos ad=0.2516p pd=2.16u as=0.1406p ps=1.12u w=0.74u l=0.13u
X96 VDD VSS.t3294 VDD VDD sg13_lv_pmos ad=0.34p pd=2.68u as=0 ps=0 w=1u l=1u
X97 a_27502_15423# a_27617_15424# VDD VDD sg13_lv_pmos ad=0.34p pd=2.68u as=0.2254p ps=1.53u w=1u l=0.5u
X98 VDD VSS.t686 VDD VDD sg13_lv_pmos ad=0.19p pd=1.38u as=0 ps=0 w=1u l=1u
X99 VDD VSS.t583 VDD VDD sg13_lv_pmos ad=0.19p pd=1.38u as=0 ps=0 w=1u l=1u
X100 VDD VSS.t760 VDD VDD sg13_lv_pmos ad=0.34p pd=2.68u as=0 ps=0 w=1u l=1u
X101 VSS.t2836 VDD VSS.t2836 VSS.t412 sg13_lv_nmos ad=0.1428p pd=1.52u as=0 ps=0 w=0.42u l=1u
X102 a_32492_15960# sg13g2_dfrbpq_1_7.Q VSS.t158 VSS.t157 sg13_lv_nmos ad=0.187p pd=1.78u as=0.14875p ps=1.16u w=0.55u l=0.13u
X103 VDD a_27034_15202# a_26753_15424# VDD sg13_lv_pmos ad=0.1523p pd=1.38u as=0.34p ps=2.68u w=1u l=0.5u
X104 VSS.t1115 VDD VSS.t1117 VSS.t1116 sg13_lv_nmos ad=79.8f pd=0.8u as=0 ps=0 w=0.42u l=1u
X105 VDD VSS.t1104 VDD VDD sg13_lv_pmos ad=0.34p pd=2.68u as=0 ps=0 w=1u l=1u
X106 VDD VSS.t1375 VDD VDD sg13_lv_pmos ad=0.34p pd=2.68u as=0 ps=0 w=1u l=1u
X107 VDD VSS.t912 VDD VDD sg13_lv_pmos ad=0.19p pd=1.38u as=0 ps=0 w=1u l=1u
X108 VSS.t1794 VDD VSS.t1793 VSS.t1792 sg13_lv_nmos ad=0.1428p pd=1.52u as=0 ps=0 w=0.42u l=1u
X109 VSS.t137 sg13g2_or3_1_2.B a_23638_14862# VSS.t30 sg13_lv_nmos ad=0.1406p pd=1.12u as=0.2516p ps=2.16u w=0.74u l=0.15u
X110 VSS.t407 VDD VSS.t407 VSS.t856 sg13_lv_nmos ad=0.1428p pd=1.52u as=0 ps=0 w=0.42u l=1u
X111 VSS.t2791 VDD VSS.t2792 VSS.t412 sg13_lv_nmos ad=79.8f pd=0.8u as=0 ps=0 w=0.42u l=1u
X112 VDD VSS.t2515 VDD VDD sg13_lv_pmos ad=0.19p pd=1.38u as=0 ps=0 w=1u l=1u
X113 VSS.t147 VDD VSS.t147 VSS.t435 sg13_lv_nmos ad=79.8f pd=0.8u as=0 ps=0 w=0.42u l=1u
X114 VDD a_14357_15238# sg13g2_or3_1_1.B VDD sg13_lv_pmos ad=0.3808p pd=2.92u as=0.2128p ps=1.5u w=1.12u l=0.13u
X115 VDD VSS.t1696 VDD VDD sg13_lv_pmos ad=0.19p pd=1.38u as=0 ps=0 w=1u l=1u
X116 VDD VSS.t2030 VDD VDD sg13_lv_pmos ad=0.34p pd=2.68u as=0 ps=0 w=1u l=1u
X117 VSS.t975 VDD VSS.t974 VSS.t973 sg13_lv_nmos ad=0.1428p pd=1.52u as=0 ps=0 w=0.42u l=1u
X118 VDD a_10960_15454# a_10905_15549# VDD sg13_lv_pmos ad=2.8961p pd=18.25u as=93.45f ps=0.865u w=0.42u l=0.13u
X119 VSS.t2778 VDD VSS.t2777 VSS.t412 sg13_lv_nmos ad=0.1428p pd=1.52u as=0 ps=0 w=0.42u l=1u
X120 VSS.t131 VDD VSS.t131 VSS.t473 sg13_lv_nmos ad=79.8f pd=0.8u as=0 ps=0 w=0.42u l=1u
X121 VSS.t63 VDD VSS.t63 VSS.t641 sg13_lv_nmos ad=79.8f pd=0.8u as=0 ps=0 w=0.42u l=1u
X122 VDD VSS.t1027 VDD VDD sg13_lv_pmos ad=0.19p pd=1.38u as=0 ps=0 w=1u l=1u
X123 VDD VSS.t2826 VDD VDD sg13_lv_pmos ad=0.19p pd=1.38u as=0 ps=0 w=1u l=1u
X124 VSS.t2096 VDD VSS.t2095 VSS.t2094 sg13_lv_nmos ad=0.1428p pd=1.52u as=0 ps=0 w=0.42u l=1u
X125 VDD VSS.t1316 VDD VDD sg13_lv_pmos ad=0.34p pd=2.68u as=0 ps=0 w=1u l=1u
X126 VSS.t2438 VDD VSS.t2437 VSS.t2436 sg13_lv_nmos ad=0.1428p pd=1.52u as=0 ps=0 w=0.42u l=1u
X127 VSS.t202 a_18106_15202# a_17825_15424# VSS.t269 sg13_lv_nmos ad=79.8f pd=0.8u as=0.1428p ps=1.52u w=0.42u l=0.5u
X128 VSS.t760 VDD VSS.t763 VSS.t881 sg13_lv_nmos ad=79.8f pd=0.8u as=0 ps=0 w=0.42u l=1u
X129 VDD VSS.t2397 VDD VDD sg13_lv_pmos ad=0.34p pd=2.68u as=0 ps=0 w=1u l=1u
X130 a_2540_15960# sg13g2_dlygate4sd3_1_3.A VSS.t147 VSS.t256 sg13_lv_nmos ad=0.187p pd=1.78u as=0.14875p ps=1.16u w=0.55u l=0.13u
X131 VSS.t2803 VDD VSS.t2804 VSS.t412 sg13_lv_nmos ad=79.8f pd=0.8u as=0 ps=0 w=0.42u l=1u
X132 VDD VSS.t2570 VDD VDD sg13_lv_pmos ad=0.19p pd=1.38u as=0 ps=0 w=1u l=1u
X133 VSS.t2628 VDD VSS.t2630 VSS.t2629 sg13_lv_nmos ad=79.8f pd=0.8u as=0 ps=0 w=0.42u l=1u
X134 VDD VSS.t902 VDD VDD sg13_lv_pmos ad=0.19p pd=1.38u as=0 ps=0 w=1u l=1u
X135 VSS.t2006 VDD VSS.t2005 VSS.t2004 sg13_lv_nmos ad=0.1428p pd=1.52u as=0 ps=0 w=0.42u l=1u
X136 VDD VSS.t737 VDD VDD sg13_lv_pmos ad=0.19p pd=1.38u as=0 ps=0 w=1u l=1u
X137 VSS.t1337 VDD VSS.t1338 VSS.t377 sg13_lv_nmos ad=79.8f pd=0.8u as=0 ps=0 w=0.42u l=1u
X138 VDD VSS.t3137 VDD VDD sg13_lv_pmos ad=0.19p pd=1.38u as=0 ps=0 w=1u l=1u
X139 VDD VSS.t2003 VDD VDD sg13_lv_pmos ad=0.19p pd=1.38u as=0 ps=0 w=1u l=1u
X140 VSS.t2176 VDD VSS.t2178 VSS.t2177 sg13_lv_nmos ad=79.8f pd=0.8u as=0 ps=0 w=0.42u l=1u
X141 VSS.t579 VDD VSS.t580 VSS.t33 sg13_lv_nmos ad=79.8f pd=0.8u as=0 ps=0 w=0.42u l=1u
X142 VDD VSS.t1067 VDD VDD sg13_lv_pmos ad=0.19p pd=1.38u as=0 ps=0 w=1u l=1u
X143 VDD VSS.t1851 VDD VDD sg13_lv_pmos ad=0.19p pd=1.38u as=0 ps=0 w=1u l=1u
X144 VDD VSS.t1368 VDD VDD sg13_lv_pmos ad=0.34p pd=2.68u as=0 ps=0 w=1u l=1u
X145 VDD VSS.t2872 VDD VDD sg13_lv_pmos ad=0.34p pd=2.68u as=0 ps=0 w=1u l=1u
X146 VDD VSS.t2535 VDD VDD sg13_lv_pmos ad=0.19p pd=1.38u as=0 ps=0 w=1u l=1u
X147 VDD a_27500_15960# counter_value_o[5] VDD sg13_lv_pmos ad=0.2114p pd=1.54u as=0.42p ps=2.99u w=1.12u l=0.13u
X148 VSS.t935 VDD VSS.t937 VSS.t936 sg13_lv_nmos ad=79.8f pd=0.8u as=0 ps=0 w=0.42u l=1u
X149 VDD sg13g2_nand4_1_0.Y a_14357_15238# VDD sg13_lv_pmos ad=0.203p pd=1.5u as=0.1596p ps=1.22u w=0.84u l=0.13u
X150 VDD VSS.t601 VDD VDD sg13_lv_pmos ad=0.19p pd=1.38u as=0 ps=0 w=1u l=1u
X151 VSS.t1005 VDD VSS.t1007 VSS.t1006 sg13_lv_nmos ad=79.8f pd=0.8u as=0 ps=0 w=0.42u l=1u
X152 VDD VSS.t994 VDD VDD sg13_lv_pmos ad=0.34p pd=2.68u as=0 ps=0 w=1u l=1u
X153 VSS.t3045 VDD VSS.t3044 VSS.t3043 sg13_lv_nmos ad=0.1428p pd=1.52u as=0 ps=0 w=0.42u l=1u
X154 a_26436_13735# a_26667_13844# a_26122_13945# VSS.t409 sg13_lv_nmos ad=0.2373p pd=1.97u as=79.8f ps=0.8u w=0.42u l=0.13u
X155 a_26374_13735# sg13g2_dfrbpq_1_5.RESET_B VSS.t74 VSS.t73 sg13_lv_nmos ad=37.8f pd=0.6u as=0.1701p ps=1.65u w=0.42u l=0.13u
X156 VSS.t1689 VDD VSS.t1691 VSS.t1690 sg13_lv_nmos ad=79.8f pd=0.8u as=0 ps=0 w=0.42u l=1u
X157 VSS.t356 sg13g2_dfrbpq_1_2.RESET_B a_15876_13722# VSS.t3303 sg13_lv_nmos ad=0.1626p pd=1.415u as=60.89999f ps=0.71u w=0.42u l=0.13u
X158 VDD VSS.t746 VDD VDD sg13_lv_pmos ad=0.19p pd=1.38u as=0 ps=0 w=1u l=1u
X159 VSS.t1346 VDD VSS.t1347 VSS.t377 sg13_lv_nmos ad=79.8f pd=0.8u as=0 ps=0 w=0.42u l=1u
X160 VSS.t2758 VDD VSS.t2759 VSS.t412 sg13_lv_nmos ad=79.8f pd=0.8u as=0 ps=0 w=0.42u l=1u
X161 VSS.t465 VDD VSS.t465 VSS.t470 sg13_lv_nmos ad=79.8f pd=0.8u as=0 ps=0 w=0.42u l=1u
X162 VSS.t33 a_27472_14726# a_27121_14845# VSS.t33 sg13_lv_nmos ad=79.8f pd=0.8u as=0.1428p ps=1.52u w=0.42u l=0.13u
X163 VSS.t740 VDD VSS.t740 VSS.t868 sg13_lv_nmos ad=0.1428p pd=1.52u as=0 ps=0 w=0.42u l=1u
X164 VDD VSS.t2562 VDD VDD sg13_lv_pmos ad=0.34p pd=2.68u as=0 ps=0 w=1u l=1u
X165 VDD VSS.t2220 VDD VDD sg13_lv_pmos ad=0.34p pd=2.68u as=0 ps=0 w=1u l=1u
X166 a_8582_15238# a_8312_15238# VSS.t164 VSS.t163 sg13_lv_nmos ad=0.1428p pd=1.52u as=79.8f ps=0.8u w=0.42u l=0.5u
X167 VSS.t700 VDD VSS.t302 VSS.t704 sg13_lv_nmos ad=79.8f pd=0.8u as=0 ps=0 w=0.42u l=1u
X168 VSS.t2613 VDD VSS.t2615 VSS.t2614 sg13_lv_nmos ad=79.8f pd=0.8u as=0 ps=0 w=0.42u l=1u
X169 VSS.t1311 VDD VSS.t1310 VSS.t377 sg13_lv_nmos ad=0.1428p pd=1.52u as=0 ps=0 w=0.42u l=1u
X170 VSS.t1351 VDD VSS.t1352 VSS.t377 sg13_lv_nmos ad=79.8f pd=0.8u as=0 ps=0 w=0.42u l=1u
X171 VDD VSS.t2759 VDD VDD sg13_lv_pmos ad=0.34p pd=2.68u as=0 ps=0 w=1u l=1u
X172 VDD VSS.t1444 VDD VDD sg13_lv_pmos ad=0.19p pd=1.38u as=0 ps=0 w=1u l=1u
X173 VDD VSS.t3122 VDD VDD sg13_lv_pmos ad=0.19p pd=1.38u as=0 ps=0 w=1u l=1u
X174 VDD VSS.t686 VDD VDD sg13_lv_pmos ad=0.19p pd=1.38u as=0 ps=0 w=1u l=1u
X175 a_27472_14726# a_27215_14845# a_27634_14922# VSS.t33 sg13_lv_nmos ad=0.1428p pd=1.52u as=37.8f ps=0.6u w=0.42u l=0.13u
X176 VSS.t1839 VDD VSS.t1841 VSS.t1840 sg13_lv_nmos ad=79.8f pd=0.8u as=0 ps=0 w=0.42u l=1u
X177 VSS.t905 VDD VSS.t904 VSS.t903 sg13_lv_nmos ad=0.1428p pd=1.52u as=0 ps=0 w=0.42u l=1u
X178 VSS.t2811 VDD VSS.t2810 VSS.t412 sg13_lv_nmos ad=0.1428p pd=1.52u as=0 ps=0 w=0.42u l=1u
X179 VSS.t975 VDD VSS.t974 VSS.t973 sg13_lv_nmos ad=0.1428p pd=1.52u as=0 ps=0 w=0.42u l=1u
X180 VDD VSS.t1681 VDD VDD sg13_lv_pmos ad=0.19p pd=1.38u as=0 ps=0 w=1u l=1u
X181 VSS.t2879 VDD VSS.t2878 VSS.t412 sg13_lv_nmos ad=0.1428p pd=1.52u as=0 ps=0 w=0.42u l=1u
X182 VDD VSS.t2015 VDD VDD sg13_lv_pmos ad=0.34p pd=2.68u as=0 ps=0 w=1u l=1u
X183 VSS.t2146 VDD VSS.t2148 VSS.t2147 sg13_lv_nmos ad=79.8f pd=0.8u as=0 ps=0 w=0.42u l=1u
X184 a_26122_13945# a_26565_13701# a_26505_14113# VDD sg13_lv_pmos ad=79.8f pd=0.8u as=63f ps=0.72u w=0.42u l=0.13u
X185 VDD VSS.t1072 VDD VDD sg13_lv_pmos ad=0.19p pd=1.38u as=0 ps=0 w=1u l=1u
X186 VSS.t1328 VDD VSS.t1327 VSS.t377 sg13_lv_nmos ad=0.1428p pd=1.52u as=0 ps=0 w=0.42u l=1u
X187 a_21827_13690# sg13g2_or3_1_2.C a_22125_14020# VDD sg13_lv_pmos ad=0.34p pd=2.68u as=0.19p ps=1.38u w=1u l=0.13u
X188 VDD sg13g2_buf_16_2.A a_12020_15202# VDD sg13_lv_pmos ad=0.2128p pd=1.5u as=0.2128p ps=1.5u w=1.12u l=0.13u
X189 VDD VSS.t2547 VDD VDD sg13_lv_pmos ad=0.34p pd=2.68u as=0 ps=0 w=1u l=1u
X190 VSS.t1485 VDD VSS.t1332 VSS.t377 sg13_lv_nmos ad=0.1428p pd=1.52u as=0 ps=0 w=0.42u l=1u
X191 VSS.t1634 VDD VSS.t1636 VSS.t1635 sg13_lv_nmos ad=79.8f pd=0.8u as=0 ps=0 w=0.42u l=1u
X192 VDD VSS.t2382 VDD VDD sg13_lv_pmos ad=0.34p pd=2.68u as=0 ps=0 w=1u l=1u
X193 VDD VSS.t1980 VDD VDD sg13_lv_pmos ad=0.34p pd=2.68u as=0 ps=0 w=1u l=1u
X194 VDD VSS.t2827 VDD VDD sg13_lv_pmos ad=0.34p pd=2.68u as=0 ps=0 w=1u l=1u
X195 VDD VSS.t16 VDD VDD sg13_lv_pmos ad=0.34p pd=2.68u as=0 ps=0 w=1u l=1u
X196 VSS.t1364 VDD VSS.t1365 VSS.t377 sg13_lv_nmos ad=79.8f pd=0.8u as=0 ps=0 w=0.42u l=1u
X197 VDD VSS.t2866 VDD VDD sg13_lv_pmos ad=0.19p pd=1.38u as=0 ps=0 w=1u l=1u
X198 VDD VSS.t2153 VDD VDD sg13_lv_pmos ad=0.19p pd=1.38u as=0 ps=0 w=1u l=1u
X199 VDD sg13g2_dfrbpq_1_0.RESET_B a_2890_15457# VDD sg13_lv_pmos ad=0.1563p pd=1.22u as=0.147p ps=1.54u w=0.42u l=0.13u
X200 VDD VSS.t1361 VDD VDD sg13_lv_pmos ad=0.19p pd=1.38u as=0 ps=0 w=1u l=1u
X201 VSS.t2568 VDD VSS.t2567 VSS.t2566 sg13_lv_nmos ad=0.1428p pd=1.52u as=0 ps=0 w=0.42u l=1u
X202 VSS.t1991 VDD VSS.t1990 VSS.t1989 sg13_lv_nmos ad=0.1428p pd=1.52u as=0 ps=0 w=0.42u l=1u
X203 VSS.t19 sg13g2_tiehi_1.L_HI a_9252_15234# VSS.t4 sg13_lv_nmos ad=0.1626p pd=1.415u as=60.89999f ps=0.71u w=0.42u l=0.13u
X204 a_16068_14040# a_16042_13945# VDD VDD sg13_lv_pmos ad=0.34p pd=2.68u as=0.36237p ps=2.605u w=1u l=0.13u
X205 VSS.t763 VDD VSS.t760 VSS.t762 sg13_lv_nmos ad=0.1428p pd=1.52u as=0 ps=0 w=0.42u l=1u
X206 VDD VSS.t3299 VDD VDD sg13_lv_pmos ad=0.34p pd=2.68u as=0 ps=0 w=1u l=1u
X207 a_18478_13911# a_18593_13912# VSS.t373 VSS.t404 sg13_lv_nmos ad=0.1428p pd=1.52u as=0.1426p ps=1.16u w=0.42u l=0.5u
X208 VSS.t1060 VDD VSS.t1059 VSS.t1058 sg13_lv_nmos ad=0.1428p pd=1.52u as=0 ps=0 w=0.42u l=1u
X209 VDD VSS.t2572 VDD VDD sg13_lv_pmos ad=0.34p pd=2.68u as=0 ps=0 w=1u l=1u
X210 VSS.t935 VDD VSS.t937 VSS.t936 sg13_lv_nmos ad=79.8f pd=0.8u as=0 ps=0 w=0.42u l=1u
X211 VSS.t1369 VDD VSS.t1370 VSS.t377 sg13_lv_nmos ad=79.8f pd=0.8u as=0 ps=0 w=0.42u l=1u
X212 VDD VSS.t1836 VDD VDD sg13_lv_pmos ad=0.19p pd=1.38u as=0 ps=0 w=1u l=1u
X213 VSS.t2633 VDD VSS.t2635 VSS.t2634 sg13_lv_nmos ad=79.8f pd=0.8u as=0 ps=0 w=0.42u l=1u
X214 VSS.t2794 VDD VSS.t2795 VSS.t412 sg13_lv_nmos ad=79.8f pd=0.8u as=0 ps=0 w=0.42u l=1u
X215 VDD VSS.t2520 VDD VDD sg13_lv_pmos ad=0.19p pd=1.38u as=0 ps=0 w=1u l=1u
X216 VSS.t2181 VDD VSS.t2180 VSS.t2179 sg13_lv_nmos ad=0.1428p pd=1.52u as=0 ps=0 w=0.42u l=1u
X217 VDD VSS.t1039 VDD VDD sg13_lv_pmos ad=0.34p pd=2.68u as=0 ps=0 w=1u l=1u
X218 VDD VSS.t1701 VDD VDD sg13_lv_pmos ad=0.19p pd=1.38u as=0 ps=0 w=1u l=1u
X219 VSS.t3030 VDD VSS.t3029 VSS.t3028 sg13_lv_nmos ad=0.1428p pd=1.52u as=0 ps=0 w=0.42u l=1u
X220 VSS.t2780 VDD VSS.t2780 VSS.t412 sg13_lv_nmos ad=0.1428p pd=1.52u as=0 ps=0 w=0.42u l=1u
X221 VSS.t2066 VDD VSS.t2065 VSS.t2064 sg13_lv_nmos ad=0.1428p pd=1.52u as=0 ps=0 w=0.42u l=1u
X222 VDD a_12020_15202# sg13g2_dfrbpq_1_2.CLK VDD sg13_lv_pmos ad=0.2128p pd=1.5u as=0.2128p ps=1.5u w=1.12u l=0.13u
X223 VDD VSS.t592 VDD VDD sg13_lv_pmos ad=0.19p pd=1.38u as=0 ps=0 w=1u l=1u
X224 VDD VSS.t2795 VDD VDD sg13_lv_pmos ad=0.34p pd=2.68u as=0 ps=0 w=1u l=1u
X225 VSS.t515 VDD VSS.t517 VSS.t516 sg13_lv_nmos ad=79.8f pd=0.8u as=0 ps=0 w=0.42u l=1u
X226 a_25930_14452# a_26373_14495# a_26313_14531# VDD sg13_lv_pmos ad=79.8f pd=0.8u as=63f ps=0.72u w=0.42u l=0.13u
X227 VDD VSS.t987 VDD VDD sg13_lv_pmos ad=0.19p pd=1.38u as=0 ps=0 w=1u l=1u
X228 VSS.t1075 VDD VSS.t1074 VSS.t1073 sg13_lv_nmos ad=0.1428p pd=1.52u as=0 ps=0 w=0.42u l=1u
X229 VDD VSS.t2367 VDD VDD sg13_lv_pmos ad=0.34p pd=2.68u as=0 ps=0 w=1u l=1u
X230 VSS.t2598 VDD VSS.t2600 VSS.t2599 sg13_lv_nmos ad=79.8f pd=0.8u as=0 ps=0 w=0.42u l=1u
X231 a_21348_14909# a_21060_14488# a_21286_14909# VSS.t122 sg13_lv_nmos ad=0.1428p pd=1.52u as=37.8f ps=0.6u w=0.42u l=0.13u
X232 VSS.t588 VDD VSS.t587 VSS.t33 sg13_lv_nmos ad=0.1428p pd=1.52u as=0 ps=0 w=0.42u l=1u
X233 VSS.t1518 VDD VSS.t1379 VSS.t377 sg13_lv_nmos ad=79.8f pd=0.8u as=0 ps=0 w=0.42u l=1u
X234 VSS.t1594 VDD VSS.t1593 VSS.t1592 sg13_lv_nmos ad=0.1428p pd=1.52u as=0 ps=0 w=0.42u l=1u
X235 VSS.t2503 VDD VSS.t2502 VSS.t2501 sg13_lv_nmos ad=0.1428p pd=1.52u as=0 ps=0 w=0.42u l=1u
X236 VDD VSS.t3107 VDD VDD sg13_lv_pmos ad=0.19p pd=1.38u as=0 ps=0 w=1u l=1u
X237 VDD VSS.t3284 VDD VDD sg13_lv_pmos ad=0.34p pd=2.68u as=0 ps=0 w=1u l=1u
X238 VSS.t1976 VDD VSS.t1975 VSS.t1974 sg13_lv_nmos ad=0.1428p pd=1.52u as=0 ps=0 w=0.42u l=1u
X239 sg13g2_dfrbpq_1_2.CLK a_12020_15202# VSS.t50 VSS.t57 sg13_lv_nmos ad=0.1406p pd=1.12u as=0.1406p ps=1.12u w=0.74u l=0.13u
X240 VSS.t905 VDD VSS.t904 VSS.t903 sg13_lv_nmos ad=0.1428p pd=1.52u as=0 ps=0 w=0.42u l=1u
X241 VDD VSS.t1360 VDD VDD sg13_lv_pmos ad=0.34p pd=2.68u as=0 ps=0 w=1u l=1u
X242 VSS.t35 a_6682_13690# a_6401_13912# VSS.t34 sg13_lv_nmos ad=79.8f pd=0.8u as=0.1428p ps=1.52u w=0.42u l=0.5u
X243 VSS.t100 VDD VSS.t100 VSS.t691 sg13_lv_nmos ad=0.1428p pd=1.52u as=0 ps=0 w=0.42u l=1u
X244 VSS.t1135 VDD VSS.t1137 VSS.t1136 sg13_lv_nmos ad=79.8f pd=0.8u as=0 ps=0 w=0.42u l=1u
X245 VDD VSS.t1315 VDD VDD sg13_lv_pmos ad=0.19p pd=1.38u as=0 ps=0 w=1u l=1u
X246 VSS.t2803 VDD VSS.t2803 VSS.t412 sg13_lv_nmos ad=0.1428p pd=1.52u as=0 ps=0 w=0.42u l=1u
X247 VDD enable_i a_1192_3900# VDD sg13_lv_pmos ad=0.2114p pd=1.54u as=0.2856p ps=2.36u w=0.84u l=0.13u
X248 VSS.t95 a_4432_15454# a_4081_15311# VSS.t94 sg13_lv_nmos ad=79.8f pd=0.8u as=0.1428p ps=1.52u w=0.42u l=0.13u
X249 VDD VSS.t1002 VDD VDD sg13_lv_pmos ad=0.19p pd=1.38u as=0 ps=0 w=1u l=1u
X250 VDD VSS.t2750 VDD VDD sg13_lv_pmos ad=0.19p pd=1.38u as=0 ps=0 w=1u l=1u
X251 VDD VSS.t1843 VDD VDD sg13_lv_pmos ad=0.34p pd=2.68u as=0 ps=0 w=1u l=1u
X252 VSS.t2131 VDD VSS.t2133 VSS.t2132 sg13_lv_nmos ad=79.8f pd=0.8u as=0 ps=0 w=0.42u l=1u
X253 VDD sg13g2_and2_1_2.B a_8685_14832# VDD sg13_lv_pmos ad=0.1918p pd=1.5u as=0.1596p ps=1.22u w=0.84u l=0.13u
X254 VDD a_19438_13726# sg13g2_buf_16_2.X VDD sg13_lv_pmos ad=0.2128p pd=1.5u as=0.2128p ps=1.5u w=1.12u l=0.13u
X255 VDD VSS.t715 VDD VDD sg13_lv_pmos ad=0.34p pd=2.68u as=0 ps=0 w=1u l=1u
X256 VSS.t1694 VDD VSS.t1696 VSS.t1695 sg13_lv_nmos ad=79.8f pd=0.8u as=0 ps=0 w=0.42u l=1u
X257 VSS.t3220 VDD VSS.t3222 VSS.t3221 sg13_lv_nmos ad=79.8f pd=0.8u as=0 ps=0 w=0.42u l=1u
X258 VDD VSS.t1286 VDD VDD sg13_lv_pmos ad=0.34p pd=2.68u as=0 ps=0 w=1u l=1u
X259 VSS.t2086 VDD VSS.t2085 VSS.t2084 sg13_lv_nmos ad=0.1428p pd=1.52u as=0 ps=0 w=0.42u l=1u
X260 VDD VSS.t939 VDD VDD sg13_lv_pmos ad=0.34p pd=2.68u as=0 ps=0 w=1u l=1u
X261 VSS.t2761 VDD VSS.t2762 VSS.t412 sg13_lv_nmos ad=79.8f pd=0.8u as=0 ps=0 w=0.42u l=1u
X262 VSS.t1428 VDD VSS.t1427 VSS.t377 sg13_lv_nmos ad=0.1428p pd=1.52u as=0 ps=0 w=0.42u l=1u
X263 VDD VSS.t2532 VDD VDD sg13_lv_pmos ad=0.34p pd=2.68u as=0 ps=0 w=1u l=1u
X264 VDD VSS.t2190 VDD VDD sg13_lv_pmos ad=0.34p pd=2.68u as=0 ps=0 w=1u l=1u
X265 VDD VSS.t1965 VDD VDD sg13_lv_pmos ad=0.34p pd=2.68u as=0 ps=0 w=1u l=1u
X266 VDD VSS.t2762 VDD VDD sg13_lv_pmos ad=0.34p pd=2.68u as=0 ps=0 w=1u l=1u
X267 VSS.t1060 VDD VSS.t1059 VSS.t1058 sg13_lv_nmos ad=0.1428p pd=1.52u as=0 ps=0 w=0.42u l=1u
X268 VDD VSS.t302 VDD VDD sg13_lv_pmos ad=0.34p pd=2.68u as=0 ps=0 w=1u l=1u
X269 VSS.t1105 VDD VSS.t1104 VSS.t1103 sg13_lv_nmos ad=0.1428p pd=1.52u as=0 ps=0 w=0.42u l=1u
X270 VDD VSS.t1295 VDD VDD sg13_lv_pmos ad=0.34p pd=2.68u as=0 ps=0 w=1u l=1u
X271 VDD VSS.t1405 VDD VDD sg13_lv_pmos ad=0.19p pd=1.38u as=0 ps=0 w=1u l=1u
X272 a_27500_15960# sg13g2_dfrbpq_1_6.Q VSS.t124 VSS.t155 sg13_lv_nmos ad=0.187p pd=1.78u as=0.14875p ps=1.16u w=0.55u l=0.13u
X273 VDD VSS.t969 VDD VDD sg13_lv_pmos ad=0.34p pd=2.68u as=0 ps=0 w=1u l=1u
X274 VDD VSS.t1157 VDD VDD sg13_lv_pmos ad=0.19p pd=1.38u as=0 ps=0 w=1u l=1u
X275 VSS.t2813 VDD VSS.t2813 VSS.t412 sg13_lv_nmos ad=0.1428p pd=1.52u as=0 ps=0 w=0.42u l=1u
X276 VDD sg13g2_xnor2_1_2.A sg13g2_nand4_1_0.Y VDD sg13_lv_pmos ad=0.2128p pd=1.5u as=0.2128p ps=1.5u w=1.12u l=0.13u
X277 VSS.t393 a_19438_13726# sg13g2_buf_16_2.X VSS.t392 sg13_lv_nmos ad=0.1406p pd=1.12u as=0.1406p ps=1.12u w=0.74u l=0.13u
X278 VDD a_27407_13799# a_27664_13942# VDD sg13_lv_pmos ad=2.42015p pd=15.68u as=79.8f ps=0.8u w=0.42u l=0.13u
X279 a_19450_15202# sg13g2_dfrbpq_1_3.Q VSS.t97 VSS.t9 sg13_lv_nmos ad=0.1428p pd=1.52u as=79.8f ps=0.8u w=0.42u l=0.13u
X280 VSS.t2618 VDD VSS.t2620 VSS.t2619 sg13_lv_nmos ad=79.8f pd=0.8u as=0 ps=0 w=0.42u l=1u
X281 VDD VSS.t766 VDD VDD sg13_lv_pmos ad=0.19p pd=1.38u as=0 ps=0 w=1u l=1u
X282 VDD VSS.t1686 VDD VDD sg13_lv_pmos ad=0.19p pd=1.38u as=0 ps=0 w=1u l=1u
X283 VDD VSS.t3154 VDD VDD sg13_lv_pmos ad=0.34p pd=2.68u as=0 ps=0 w=1u l=1u
X284 VSS.t2882 VDD VSS.t2881 VSS.t412 sg13_lv_nmos ad=0.1428p pd=1.52u as=0 ps=0 w=0.42u l=1u
X285 VDD VSS.t2020 VDD VDD sg13_lv_pmos ad=0.34p pd=2.68u as=0 ps=0 w=1u l=1u
X286 VSS.t2116 VDD VSS.t2118 VSS.t2117 sg13_lv_nmos ad=79.8f pd=0.8u as=0 ps=0 w=0.42u l=1u
X287 a_26436_13735# a_26148_14040# a_26374_13735# VSS.t405 sg13_lv_nmos ad=0.1428p pd=1.52u as=37.8f ps=0.6u w=0.42u l=0.13u
X288 VSS.t1025 VDD VSS.t1027 VSS.t1026 sg13_lv_nmos ad=79.8f pd=0.8u as=0 ps=0 w=0.42u l=1u
X289 VDD VSS.t1691 VDD VDD sg13_lv_pmos ad=0.19p pd=1.38u as=0 ps=0 w=1u l=1u
X290 VSS.t2752 VDD VSS.t2753 VSS.t412 sg13_lv_nmos ad=79.8f pd=0.8u as=0 ps=0 w=0.42u l=1u
X291 VSS.t1075 VDD VSS.t1074 VSS.t1073 sg13_lv_nmos ad=0.1428p pd=1.52u as=0 ps=0 w=0.42u l=1u
X292 VSS.t1441 VDD VSS.t1441 VSS.t377 sg13_lv_nmos ad=0.1428p pd=1.52u as=0 ps=0 w=0.42u l=1u
X293 VSS.t2488 VDD VSS.t2490 VSS.t2489 sg13_lv_nmos ad=79.8f pd=0.8u as=0 ps=0 w=0.42u l=1u
X294 VDD VSS.t1032 VDD VDD sg13_lv_pmos ad=0.19p pd=1.38u as=0 ps=0 w=1u l=1u
X295 VDD VSS.t2033 VDD VDD sg13_lv_pmos ad=0.19p pd=1.38u as=0 ps=0 w=1u l=1u
X296 VSS.t2036 VDD VSS.t2035 VSS.t2034 sg13_lv_nmos ad=0.1428p pd=1.52u as=0 ps=0 w=0.42u l=1u
X297 VSS.t900 VDD VSS.t902 VSS.t901 sg13_lv_nmos ad=79.8f pd=0.8u as=0 ps=0 w=0.42u l=1u
X298 VDD VSS.t2158 VDD VDD sg13_lv_pmos ad=0.19p pd=1.38u as=0 ps=0 w=1u l=1u
X299 VDD VSS.t605 VDD VDD sg13_lv_pmos ad=0.34p pd=2.68u as=0 ps=0 w=1u l=1u
X300 VDD VSS.t959 VDD VDD sg13_lv_pmos ad=0.34p pd=2.68u as=0 ps=0 w=1u l=1u
X301 VSS.t1579 VDD VSS.t1578 VSS.t1577 sg13_lv_nmos ad=0.1428p pd=1.52u as=0 ps=0 w=0.42u l=1u
X302 a_17412_14922# sg13g2_dfrbpq_1_3.D a_17318_14922# VSS.t85 sg13_lv_nmos ad=60.89999f pd=0.71u as=0.1428p ps=1.52u w=0.42u l=0.13u
X303 VDD VSS.t3269 VDD VDD sg13_lv_pmos ad=0.34p pd=2.68u as=0 ps=0 w=1u l=1u
X304 VSS.t2770 VDD VSS.t2768 VSS.t412 sg13_lv_nmos ad=0.1428p pd=1.52u as=0 ps=0 w=0.42u l=1u
X305 VDD a_25774_15423# sg13g2_dfrbpq_1_7.D VDD sg13_lv_pmos ad=0.2254p pd=1.53u as=0.4256p ps=3u w=1.12u l=0.13u
X306 VSS.t1135 VDD VSS.t1137 VSS.t1136 sg13_lv_nmos ad=79.8f pd=0.8u as=0 ps=0 w=0.42u l=1u
X307 VDD VSS.t1387 VDD VDD sg13_lv_pmos ad=0.34p pd=2.68u as=0 ps=0 w=1u l=1u
X308 VSS.t2830 VDD VSS.t2831 VSS.t412 sg13_lv_nmos ad=79.8f pd=0.8u as=0 ps=0 w=0.42u l=1u
X309 VDD VSS.t1841 VDD VDD sg13_lv_pmos ad=0.19p pd=1.38u as=0 ps=0 w=1u l=1u
X310 VDD a_18021_14495# a_18123_14495# VDD sg13_lv_pmos ad=2.42015p pd=15.68u as=0.3864p ps=2.93u w=1.12u l=0.13u
X311 VSS.t384 a_19438_13726# sg13g2_buf_16_2.X VSS.t388 sg13_lv_nmos ad=0.1406p pd=1.12u as=0.1406p ps=1.12u w=0.74u l=0.13u
X312 VSS.t995 VDD VSS.t994 VSS.t993 sg13_lv_nmos ad=0.1428p pd=1.52u as=0 ps=0 w=0.42u l=1u
X313 VDD a_22319_14845# a_22986_14484# VDD sg13_lv_pmos ad=0.2128p pd=1.5u as=0.3864p ps=2.93u w=1.12u l=0.13u
X314 VSS.t1330 VDD VSS.t1331 VSS.t377 sg13_lv_nmos ad=79.8f pd=0.8u as=0 ps=0 w=0.42u l=1u
X315 VDD VSS.t1671 VDD VDD sg13_lv_pmos ad=0.19p pd=1.38u as=0 ps=0 w=1u l=1u
X316 VSS.t566 VDD VSS.t565 VSS.t564 sg13_lv_nmos ad=0.1428p pd=1.52u as=0 ps=0 w=0.42u l=1u
X317 VDD VSS.t465 VDD VDD sg13_lv_pmos ad=0.34p pd=2.68u as=0 ps=0 w=1u l=1u
X318 VDD VSS.t1423 VDD VDD sg13_lv_pmos ad=0.19p pd=1.38u as=0 ps=0 w=1u l=1u
X319 VSS.t2784 VDD VSS.t2783 VSS.t412 sg13_lv_nmos ad=0.1428p pd=1.52u as=0 ps=0 w=0.42u l=1u
X320 VDD VSS.t2585 VDD VDD sg13_lv_pmos ad=0.19p pd=1.38u as=0 ps=0 w=1u l=1u
X321 VSS.t2071 VDD VSS.t2070 VSS.t2069 sg13_lv_nmos ad=0.1428p pd=1.52u as=0 ps=0 w=0.42u l=1u
X322 VSS.t3160 VDD VSS.t3159 VSS.t3158 sg13_lv_nmos ad=0.1428p pd=1.52u as=0 ps=0 w=0.42u l=1u
X323 VSS.t454 VDD VSS.t454 VSS.t456 sg13_lv_nmos ad=0.1428p pd=1.52u as=0 ps=0 w=0.42u l=1u
X324 VDD VSS.t2372 VDD VDD sg13_lv_pmos ad=0.34p pd=2.68u as=0 ps=0 w=1u l=1u
X325 VSS.t2603 VDD VSS.t2605 VSS.t2604 sg13_lv_nmos ad=79.8f pd=0.8u as=0 ps=0 w=0.42u l=1u
X326 VSS.t582 VDD VSS.t583 VSS.t33 sg13_lv_nmos ad=79.8f pd=0.8u as=0 ps=0 w=0.42u l=1u
X327 VDD VSS.t302 VDD VDD sg13_lv_pmos ad=0.34p pd=2.68u as=0 ps=0 w=1u l=1u
X328 VDD VSS.t922 VDD VDD sg13_lv_pmos ad=0.19p pd=1.38u as=0 ps=0 w=1u l=1u
X329 VDD VSS.t1636 VDD VDD sg13_lv_pmos ad=0.19p pd=1.38u as=0 ps=0 w=1u l=1u
X330 VDD VSS.t2545 VDD VDD sg13_lv_pmos ad=0.19p pd=1.38u as=0 ps=0 w=1u l=1u
X331 VDD VSS.t142 VDD VDD sg13_lv_pmos ad=0.34p pd=2.68u as=0 ps=0 w=1u l=1u
X332 VSS.t1105 VDD VSS.t1104 VSS.t1103 sg13_lv_nmos ad=0.1428p pd=1.52u as=0 ps=0 w=0.42u l=1u
X333 VSS.t1769 VDD VSS.t1771 VSS.t1770 sg13_lv_nmos ad=79.8f pd=0.8u as=0 ps=0 w=0.42u l=1u
X334 VSS.t1981 VDD VSS.t1980 VSS.t1979 sg13_lv_nmos ad=0.1428p pd=1.52u as=0 ps=0 w=0.42u l=1u
X335 VDD VSS.t302 VDD VDD sg13_lv_pmos ad=0.34p pd=2.68u as=0 ps=0 w=1u l=1u
X336 VSS.t2151 VDD VSS.t2153 VSS.t2152 sg13_lv_nmos ad=79.8f pd=0.8u as=0 ps=0 w=0.42u l=1u
X337 VDD VSS.t1432 VDD VDD sg13_lv_pmos ad=0.19p pd=1.38u as=0 ps=0 w=1u l=1u
X338 VSS.t1314 VDD VSS.t1315 VSS.t377 sg13_lv_nmos ad=79.8f pd=0.8u as=0 ps=0 w=0.42u l=1u
X339 VDD VSS.t2080 VDD VDD sg13_lv_pmos ad=0.34p pd=2.68u as=0 ps=0 w=1u l=1u
X340 VSS.t3 a_26633_16334# a_26554_16237# VSS.t79 sg13_lv_nmos ad=5.24677p pd=34.365u as=0.27427p ps=2.28u w=0.795u l=0.13u
X341 sg13g2_nor2_1_0.B a_16044_15424# VDD VDD sg13_lv_pmos ad=0.2408p pd=1.55u as=0.3808p ps=2.92u w=1.12u l=0.13u
X342 VSS.t2806 VDD VSS.t2805 VSS.t412 sg13_lv_nmos ad=0.1428p pd=1.52u as=0 ps=0 w=0.42u l=1u
X343 a_2516_14484# a_2490_14447# sg13g2_and2_1_0.B VDD sg13_lv_pmos ad=0.2128p pd=1.5u as=0.3808p ps=2.92u w=1.12u l=0.13u
X344 VSS.t1025 VDD VSS.t1027 VSS.t1026 sg13_lv_nmos ad=79.8f pd=0.8u as=0 ps=0 w=0.42u l=1u
X345 VDD VSS.t613 VDD VDD sg13_lv_pmos ad=0.19p pd=1.38u as=0 ps=0 w=1u l=1u
X346 VDD VSS.t1014 VDD VDD sg13_lv_pmos ad=0.34p pd=2.68u as=0 ps=0 w=1u l=1u
X347 VSS.t384 a_19438_13726# sg13g2_buf_16_2.X VSS.t383 sg13_lv_nmos ad=0.1406p pd=1.12u as=0.1406p ps=1.12u w=0.74u l=0.13u
X348 VDD VSS.t1848 VDD VDD sg13_lv_pmos ad=0.34p pd=2.68u as=0 ps=0 w=1u l=1u
X349 VSS.t740 VDD VSS.t737 VSS.t739 sg13_lv_nmos ad=0.1428p pd=1.52u as=0 ps=0 w=0.42u l=1u
X350 VDD VSS.t1139 VDD VDD sg13_lv_pmos ad=0.34p pd=2.68u as=0 ps=0 w=1u l=1u
X351 VSS.t1699 VDD VSS.t1701 VSS.t1700 sg13_lv_nmos ad=79.8f pd=0.8u as=0 ps=0 w=0.42u l=1u
X352 VSS.t3225 VDD VSS.t3227 VSS.t3226 sg13_lv_nmos ad=79.8f pd=0.8u as=0 ps=0 w=0.42u l=1u
X353 VDD a_3130_16237# sg13g2_dfrbpq_1_0.RESET_B VDD sg13_lv_pmos ad=2.8961p pd=18.25u as=0.3927p ps=2.99u w=1.155u l=0.13u
X354 VDD a_18478_13911# sg13g2_dlygate4sd3_1_4.X VDD sg13_lv_pmos ad=0.2254p pd=1.53u as=0.4256p ps=3u w=1.12u l=0.13u
X355 VSS.t755 VDD VSS.t752 VSS.t876 sg13_lv_nmos ad=0.1428p pd=1.52u as=0 ps=0 w=0.42u l=1u
X356 VSS.t2473 VDD VSS.t2475 VSS.t2474 sg13_lv_nmos ad=79.8f pd=0.8u as=0 ps=0 w=0.42u l=1u
X357 VSS.t900 VDD VSS.t902 VSS.t901 sg13_lv_nmos ad=79.8f pd=0.8u as=0 ps=0 w=0.42u l=1u
X358 VDD VSS.t889 VDD VDD sg13_lv_pmos ad=0.34p pd=2.68u as=0 ps=0 w=1u l=1u
X359 VDD VSS.t2537 VDD VDD sg13_lv_pmos ad=0.34p pd=2.68u as=0 ps=0 w=1u l=1u
X360 VDD VSS.t2195 VDD VDD sg13_lv_pmos ad=0.34p pd=2.68u as=0 ps=0 w=1u l=1u
X361 VDD VSS.t1077 VDD VDD sg13_lv_pmos ad=0.19p pd=1.38u as=0 ps=0 w=1u l=1u
X362 VSS.t695 VDD VSS.t695 VSS.t697 sg13_lv_nmos ad=79.8f pd=0.8u as=0 ps=0 w=0.42u l=1u
X363 VDD VSS.t547 VDD VDD sg13_lv_pmos ad=0.34p pd=2.68u as=0 ps=0 w=1u l=1u
X364 VDD sg13g2_dlygate4sd3_1_0.X a_5613_14832# VDD sg13_lv_pmos ad=0.1918p pd=1.5u as=0.1596p ps=1.22u w=0.84u l=0.13u
X365 VDD VSS.t100 VDD VDD sg13_lv_pmos ad=0.19p pd=1.38u as=0 ps=0 w=1u l=1u
X366 VDD VSS.t1355 VDD VDD sg13_lv_pmos ad=0.19p pd=1.38u as=0 ps=0 w=1u l=1u
X367 VDD VSS.t2860 VDD VDD sg13_lv_pmos ad=0.19p pd=1.38u as=0 ps=0 w=1u l=1u
X368 VSS.t2558 VDD VSS.t2557 VSS.t2556 sg13_lv_nmos ad=0.1428p pd=1.52u as=0 ps=0 w=0.42u l=1u
X369 VSS.t2171 VDD VSS.t2173 VSS.t2172 sg13_lv_nmos ad=79.8f pd=0.8u as=0 ps=0 w=0.42u l=1u
X370 VSS.t24 a_17030_15238# a_17142_15302# VSS.t312 sg13_lv_nmos ad=0.1426p pd=1.16u as=0.1428p ps=1.52u w=0.42u l=0.5u
X371 VDD VSS.t2238 VDD VDD sg13_lv_pmos ad=0.19p pd=1.38u as=0 ps=0 w=1u l=1u
X372 VSS.t600 VDD VSS.t601 VSS.t33 sg13_lv_nmos ad=79.8f pd=0.8u as=0 ps=0 w=0.42u l=1u
X373 sg13g2_buf_16_2.A a_15022_14484# VDD VDD sg13_lv_pmos ad=0.2128p pd=1.5u as=0.2128p ps=1.5u w=1.12u l=0.13u
X374 VDD VSS.t593 VDD VDD sg13_lv_pmos ad=0.34p pd=2.68u as=0 ps=0 w=1u l=1u
X375 VSS.t995 VDD VSS.t994 VSS.t993 sg13_lv_nmos ad=0.1428p pd=1.52u as=0 ps=0 w=0.42u l=1u
X376 VSS.t1288 VDD VSS.t1290 VSS.t377 sg13_lv_nmos ad=79.8f pd=0.8u as=0 ps=0 w=0.42u l=1u
X377 VDD VSS.t537 VDD VDD sg13_lv_pmos ad=0.19p pd=1.38u as=0 ps=0 w=1u l=1u
X378 VSS.t1040 VDD VSS.t1039 VSS.t1038 sg13_lv_nmos ad=0.1428p pd=1.52u as=0 ps=0 w=0.42u l=1u
X379 VSS.t2798 VDD VSS.t2798 VSS.t412 sg13_lv_nmos ad=0.1428p pd=1.52u as=0 ps=0 w=0.42u l=1u
X380 VSS.t2623 VDD VSS.t2625 VSS.t2624 sg13_lv_nmos ad=79.8f pd=0.8u as=0 ps=0 w=0.42u l=1u
X381 a_27407_13799# a_26565_13701# a_26148_14040# VDD sg13_lv_pmos ad=0.2048p pd=1.63u as=0.34p ps=2.68u w=1u l=0.13u
X382 VDD VSS.t1656 VDD VDD sg13_lv_pmos ad=0.19p pd=1.38u as=0 ps=0 w=1u l=1u
X383 VDD VSS.t1833 VDD VDD sg13_lv_pmos ad=0.34p pd=2.68u as=0 ps=0 w=1u l=1u
X384 VDD VSS.t3124 VDD VDD sg13_lv_pmos ad=0.34p pd=2.68u as=0 ps=0 w=1u l=1u
X385 VDD VSS.t2025 VDD VDD sg13_lv_pmos ad=0.34p pd=2.68u as=0 ps=0 w=1u l=1u
X386 VSS.t2121 VDD VSS.t2123 VSS.t2122 sg13_lv_nmos ad=79.8f pd=0.8u as=0 ps=0 w=0.42u l=1u
X387 VDD VSS.t446 VDD VDD sg13_lv_pmos ad=0.19p pd=1.38u as=0 ps=0 w=1u l=1u
X388 VSS.t31 a_22319_14845# a_22986_14484# VSS.t30 sg13_lv_nmos ad=0.1406p pd=1.12u as=0.2516p ps=2.16u w=0.74u l=0.13u
X389 VSS.t2774 VDD VSS.t2774 VSS.t412 sg13_lv_nmos ad=0.1428p pd=1.52u as=0 ps=0 w=0.42u l=1u
X390 VSS.t100 VDD VSS.t100 VSS.t691 sg13_lv_nmos ad=0.1428p pd=1.52u as=0 ps=0 w=0.42u l=1u
X391 VDD VSS.t1696 VDD VDD sg13_lv_pmos ad=0.19p pd=1.38u as=0 ps=0 w=1u l=1u
X392 VDD VSS.t2824 VDD VDD sg13_lv_pmos ad=0.19p pd=1.38u as=0 ps=0 w=1u l=1u
X393 VDD VSS.t1044 VDD VDD sg13_lv_pmos ad=0.34p pd=2.68u as=0 ps=0 w=1u l=1u
X394 VDD VSS.t1339 VDD VDD sg13_lv_pmos ad=0.34p pd=2.68u as=0 ps=0 w=1u l=1u
X395 a_17892_14909# a_17604_14488# a_17830_14909# VSS.t196 sg13_lv_nmos ad=0.1428p pd=1.52u as=37.8f ps=0.6u w=0.42u l=0.13u
X396 VDD VSS.t715 VDD VDD sg13_lv_pmos ad=0.34p pd=2.68u as=0 ps=0 w=1u l=1u
X397 VDD VSS.t302 VDD VDD sg13_lv_pmos ad=0.34p pd=2.68u as=0 ps=0 w=1u l=1u
X398 VSS.t1376 VDD VSS.t1377 VSS.t377 sg13_lv_nmos ad=79.8f pd=0.8u as=0 ps=0 w=0.42u l=1u
X399 VDD VSS.t2357 VDD VDD sg13_lv_pmos ad=0.34p pd=2.68u as=0 ps=0 w=1u l=1u
X400 VSS.t2418 VDD VSS.t2420 VSS.t2419 sg13_lv_nmos ad=79.8f pd=0.8u as=0 ps=0 w=0.42u l=1u
X401 VSS.t2773 VDD VSS.t2772 VSS.t412 sg13_lv_nmos ad=0.1428p pd=1.52u as=0 ps=0 w=0.42u l=1u
X402 VSS.t1966 VDD VSS.t1965 VSS.t1964 sg13_lv_nmos ad=0.1428p pd=1.52u as=0 ps=0 w=0.42u l=1u
X403 a_16425_14113# a_16068_14040# VDD VDD sg13_lv_pmos ad=63f pd=0.72u as=0.1563p ps=1.22u w=0.42u l=0.13u
X404 VSS.t2866 VDD VSS.t2866 VSS.t412 sg13_lv_nmos ad=79.8f pd=0.8u as=0 ps=0 w=0.42u l=1u
X405 VSS.t1381 VDD VSS.t1382 VSS.t377 sg13_lv_nmos ad=79.8f pd=0.8u as=0 ps=0 w=0.42u l=1u
X406 VDD a_17584_13942# a_17529_14037# VDD sg13_lv_pmos ad=2.42015p pd=15.68u as=93.45f ps=0.865u w=0.42u l=0.13u
X407 VSS.t1709 VDD VSS.t1708 VSS.t1707 sg13_lv_nmos ad=0.1428p pd=1.52u as=0 ps=0 w=0.42u l=1u
X408 VSS.t2458 VDD VSS.t2460 VSS.t2459 sg13_lv_nmos ad=79.8f pd=0.8u as=0 ps=0 w=0.42u l=1u
X409 VDD VSS.t2400 VDD VDD sg13_lv_pmos ad=0.19p pd=1.38u as=0 ps=0 w=1u l=1u
X410 VDD VSS.t1059 VDD VDD sg13_lv_pmos ad=0.34p pd=2.68u as=0 ps=0 w=1u l=1u
X411 VDD VSS.t3192 VDD VDD sg13_lv_pmos ad=0.19p pd=1.38u as=0 ps=0 w=1u l=1u
X412 VDD VSS.t1362 VDD VDD sg13_lv_pmos ad=0.34p pd=2.68u as=0 ps=0 w=1u l=1u
X413 VDD VSS.t2866 VDD VDD sg13_lv_pmos ad=0.34p pd=2.68u as=0 ps=0 w=1u l=1u
X414 VDD VSS.t1318 VDD VDD sg13_lv_pmos ad=0.19p pd=1.38u as=0 ps=0 w=1u l=1u
X415 VSS.t1684 VDD VSS.t1686 VSS.t1685 sg13_lv_nmos ad=79.8f pd=0.8u as=0 ps=0 w=0.42u l=1u
X416 VSS.t2076 VDD VSS.t2075 VSS.t2074 sg13_lv_nmos ad=0.1428p pd=1.52u as=0 ps=0 w=0.42u l=1u
X417 a_9252_15234# sg13g2_and2_1_2.X a_9158_15234# VSS.t165 sg13_lv_nmos ad=60.89999f pd=0.71u as=0.1428p ps=1.52u w=0.42u l=0.13u
X418 VSS.t621 VDD VSS.t620 VSS.t33 sg13_lv_nmos ad=0.1428p pd=1.52u as=0 ps=0 w=0.42u l=1u
X419 VSS.t393 VDD VSS.t393 VSS.t831 sg13_lv_nmos ad=79.8f pd=0.8u as=0 ps=0 w=0.42u l=1u
X420 VDD VSS.t1122 VDD VDD sg13_lv_pmos ad=0.19p pd=1.38u as=0 ps=0 w=1u l=1u
X421 VSS.t1390 VDD VSS.t1391 VSS.t377 sg13_lv_nmos ad=79.8f pd=0.8u as=0 ps=0 w=0.42u l=1u
X422 VDD VSS.t1703 VDD VDD sg13_lv_pmos ad=0.34p pd=2.68u as=0 ps=0 w=1u l=1u
X423 VSS.t2608 VDD VSS.t2610 VSS.t2609 sg13_lv_nmos ad=79.8f pd=0.8u as=0 ps=0 w=0.42u l=1u
X424 VDD VSS.t2550 VDD VDD sg13_lv_pmos ad=0.19p pd=1.38u as=0 ps=0 w=1u l=1u
X425 VDD VSS.t743 VDD VDD sg13_lv_pmos ad=0.19p pd=1.38u as=0 ps=0 w=1u l=1u
X426 VSS.t1774 VDD VSS.t1776 VSS.t1775 sg13_lv_nmos ad=79.8f pd=0.8u as=0 ps=0 w=0.42u l=1u
X427 VSS.t2156 VDD VSS.t2158 VSS.t2157 sg13_lv_nmos ad=79.8f pd=0.8u as=0 ps=0 w=0.42u l=1u
X428 VDD VSS.t465 VDD VDD sg13_lv_pmos ad=0.19p pd=1.38u as=0 ps=0 w=1u l=1u
X429 VSS.t1155 VDD VSS.t1157 VSS.t1156 sg13_lv_nmos ad=79.8f pd=0.8u as=0 ps=0 w=0.42u l=1u
X430 VDD VSS.t2050 VDD VDD sg13_lv_pmos ad=0.34p pd=2.68u as=0 ps=0 w=1u l=1u
X431 VSS.t1040 VDD VSS.t1039 VSS.t1038 sg13_lv_nmos ad=0.1428p pd=1.52u as=0 ps=0 w=0.42u l=1u
X432 VDD VSS.t2223 VDD VDD sg13_lv_pmos ad=0.19p pd=1.38u as=0 ps=0 w=1u l=1u
X433 VSS.t145 a_4078_14751# sg13g2_xor2_1_0.B VSS.t144 sg13_lv_nmos ad=0.1426p pd=1.16u as=0.2516p ps=2.16u w=0.74u l=0.13u
X434 VDD VSS.t1022 VDD VDD sg13_lv_pmos ad=0.19p pd=1.38u as=0 ps=0 w=1u l=1u
X435 VDD VSS.t3177 VDD VDD sg13_lv_pmos ad=0.19p pd=1.38u as=0 ps=0 w=1u l=1u
X436 VDD VSS.t2385 VDD VDD sg13_lv_pmos ad=0.19p pd=1.38u as=0 ps=0 w=1u l=1u
X437 VSS.t2790 VDD VSS.t2789 VSS.t412 sg13_lv_nmos ad=0.1428p pd=1.52u as=0 ps=0 w=0.42u l=1u
X438 VDD VSS.t2175 VDD VDD sg13_lv_pmos ad=0.34p pd=2.68u as=0 ps=0 w=1u l=1u
X439 VDD VSS.t584 VDD VDD sg13_lv_pmos ad=0.34p pd=2.68u as=0 ps=0 w=1u l=1u
X440 VDD VSS.t1298 VDD VDD sg13_lv_pmos ad=0.34p pd=2.68u as=0 ps=0 w=1u l=1u
X441 VDD VSS.t1818 VDD VDD sg13_lv_pmos ad=0.34p pd=2.68u as=0 ps=0 w=1u l=1u
X442 VDD VSS.t2010 VDD VDD sg13_lv_pmos ad=0.34p pd=2.68u as=0 ps=0 w=1u l=1u
X443 VSS.t2106 VDD VSS.t2108 VSS.t2107 sg13_lv_nmos ad=79.8f pd=0.8u as=0 ps=0 w=0.42u l=1u
X444 VSS.t615 VDD VSS.t614 VSS.t33 sg13_lv_nmos ad=0.1428p pd=1.52u as=0 ps=0 w=0.42u l=1u
X445 VDD VSS.t302 VDD VDD sg13_lv_pmos ad=0.19p pd=1.38u as=0 ps=0 w=1u l=1u
X446 VSS.t1669 VDD VSS.t1671 VSS.t1670 sg13_lv_nmos ad=79.8f pd=0.8u as=0 ps=0 w=0.42u l=1u
X447 VSS.t3195 VDD VSS.t3197 VSS.t3196 sg13_lv_nmos ad=79.8f pd=0.8u as=0 ps=0 w=0.42u l=1u
X448 VSS.t2403 VDD VSS.t2405 VSS.t2404 sg13_lv_nmos ad=79.8f pd=0.8u as=0 ps=0 w=0.42u l=1u
X449 VDD sg13g2_xnor2_1_2.A a_6714_12972# VDD sg13_lv_pmos ad=0.2891p pd=1.695u as=0.1428p ps=1.375u w=1.12u l=0.13u
X450 VDD VSS.t1366 VDD VDD sg13_lv_pmos ad=0.34p pd=2.68u as=0 ps=0 w=1u l=1u
X451 VSS.t1358 VDD VSS.t1359 VSS.t377 sg13_lv_nmos ad=79.8f pd=0.8u as=0 ps=0 w=0.42u l=1u
X452 VDD VSS.t1681 VDD VDD sg13_lv_pmos ad=0.19p pd=1.38u as=0 ps=0 w=1u l=1u
X453 a_10905_15549# a_9963_15356# a_10703_15311# VDD sg13_lv_pmos ad=93.45f pd=0.865u as=0.2048p ps=1.63u w=0.42u l=0.13u
X454 VDD VSS.t897 VDD VDD sg13_lv_pmos ad=0.19p pd=1.38u as=0 ps=0 w=1u l=1u
X455 VSS.t2478 VDD VSS.t2480 VSS.t2479 sg13_lv_nmos ad=79.8f pd=0.8u as=0 ps=0 w=0.42u l=1u
X456 VSS.t50 a_12020_15202# sg13g2_dfrbpq_1_2.CLK VSS.t56 sg13_lv_nmos ad=0.1406p pd=1.12u as=0.1406p ps=1.12u w=0.74u l=0.13u
X457 VDD VSS.t2542 VDD VDD sg13_lv_pmos ad=0.34p pd=2.68u as=0 ps=0 w=1u l=1u
X458 a_22426_15202# sg13g2_dfrbpq_1_6.Q VSS.t29 VSS.t28 sg13_lv_nmos ad=0.1428p pd=1.52u as=79.8f ps=0.8u w=0.42u l=0.13u
X459 VDD VSS.t2751 VDD VDD sg13_lv_pmos ad=0.34p pd=2.68u as=0 ps=0 w=1u l=1u
X460 a_19120_14726# sg13g2_dfrbpq_1_3.RESET_B VDD VDD sg13_lv_pmos ad=79.8f pd=0.8u as=2.42015p ps=15.68u w=0.42u l=0.13u
X461 VDD sg13g2_o21ai_1_2.B1 sg13g2_or3_1_1.C VDD sg13_lv_pmos ad=0.3808p pd=2.92u as=0.2128p ps=1.5u w=1.12u l=0.13u
X462 a_23480_15242# sg13g2_dfrbpq_1_3.Q a_23378_15242# VSS.t28 sg13_lv_nmos ad=0.1406p pd=1.12u as=0.1406p ps=1.12u w=0.74u l=0.13u
X463 VDD VSS.t1307 VDD VDD sg13_lv_pmos ad=0.34p pd=2.68u as=0 ps=0 w=1u l=1u
X464 VSS.t2764 VDD VSS.t2762 VSS.t412 sg13_lv_nmos ad=0.1428p pd=1.52u as=0 ps=0 w=0.42u l=1u
X465 VSS.t475 VDD VSS.t131 VSS.t474 sg13_lv_nmos ad=0.1428p pd=1.52u as=0 ps=0 w=0.42u l=1u
X466 VSS.t1542 VDD VSS.t1408 VSS.t377 sg13_lv_nmos ad=79.8f pd=0.8u as=0 ps=0 w=0.42u l=1u
X467 VDD a_21562_15960# a_21281_16262# VDD sg13_lv_pmos ad=0.1523p pd=1.38u as=0.34p ps=2.68u w=1u l=0.5u
X468 VDD sg13g2_o21ai_1_2.Y a_24824_15238# VDD sg13_lv_pmos ad=0.1523p pd=1.38u as=0.1428p ps=1.52u w=0.42u l=0.13u
X469 VDD a_18863_14845# a_19530_14484# VDD sg13_lv_pmos ad=0.2128p pd=1.5u as=0.3864p ps=2.93u w=1.12u l=0.13u
X470 a_20603_15532# sg13g2_a21oi_1_0.B1 sg13g2_a21oi_1_1.Y VDD sg13_lv_pmos ad=0.2128p pd=1.5u as=0.3808p ps=2.92u w=1.12u l=0.13u
X471 VDD VSS.t967 VDD VDD sg13_lv_pmos ad=0.19p pd=1.38u as=0 ps=0 w=1u l=1u
X472 VDD VSS.t1394 VDD VDD sg13_lv_pmos ad=0.19p pd=1.38u as=0 ps=0 w=1u l=1u
X473 VDD VSS.t2896 VDD VDD sg13_lv_pmos ad=0.19p pd=1.38u as=0 ps=0 w=1u l=1u
X474 VSS.t2623 VDD VSS.t2622 VSS.t2621 sg13_lv_nmos ad=0.1428p pd=1.52u as=0 ps=0 w=0.42u l=1u
X475 VSS.t2443 VDD VSS.t2445 VSS.t2444 sg13_lv_nmos ad=79.8f pd=0.8u as=0 ps=0 w=0.42u l=1u
X476 VDD VSS.t2208 VDD VDD sg13_lv_pmos ad=0.19p pd=1.38u as=0 ps=0 w=1u l=1u
X477 VSS.t2801 VDD VSS.t2800 VSS.t412 sg13_lv_nmos ad=0.1428p pd=1.52u as=0 ps=0 w=0.42u l=1u
X478 VDD VSS.t3129 VDD VDD sg13_lv_pmos ad=0.34p pd=2.68u as=0 ps=0 w=1u l=1u
X479 VSS.t2868 VDD VSS.t2868 VSS.t412 sg13_lv_nmos ad=0.1428p pd=1.52u as=0 ps=0 w=0.42u l=1u
X480 VDD VSS.t1995 VDD VDD sg13_lv_pmos ad=0.34p pd=2.68u as=0 ps=0 w=1u l=1u
X481 VSS.t1849 VDD VSS.t1848 VSS.t1847 sg13_lv_nmos ad=0.1428p pd=1.52u as=0 ps=0 w=0.42u l=1u
X482 VSS.t582 VDD VSS.t581 VSS.t33 sg13_lv_nmos ad=0.1428p pd=1.52u as=0 ps=0 w=0.42u l=1u
X483 VDD VSS.t1052 VDD VDD sg13_lv_pmos ad=0.19p pd=1.38u as=0 ps=0 w=1u l=1u
X484 VDD VSS.t1701 VDD VDD sg13_lv_pmos ad=0.19p pd=1.38u as=0 ps=0 w=1u l=1u
X485 VDD VSS.t2575 VDD VDD sg13_lv_pmos ad=0.19p pd=1.38u as=0 ps=0 w=1u l=1u
X486 VSS.t3150 VDD VSS.t3149 VSS.t3148 sg13_lv_nmos ad=0.1428p pd=1.52u as=0 ps=0 w=0.42u l=1u
X487 VSS.t495 VDD VSS.t497 VSS.t496 sg13_lv_nmos ad=79.8f pd=0.8u as=0 ps=0 w=0.42u l=1u
X488 VDD VSS.t460 VDD VDD sg13_lv_pmos ad=0.34p pd=2.68u as=0 ps=0 w=1u l=1u
X489 VSS.t311 a_22508_15960# counter_value_o[4] VSS.t328 sg13_lv_nmos ad=0.14875p pd=1.16u as=0.2886p ps=2.26u w=0.74u l=0.13u
X490 sg13g2_buf_16_2.A a_15022_14484# VSS.t24 VSS.t238 sg13_lv_nmos ad=0.1406p pd=1.12u as=0.1406p ps=1.12u w=0.74u l=0.13u
X491 VDD VSS.t2858 VDD VDD sg13_lv_pmos ad=0.19p pd=1.38u as=0 ps=0 w=1u l=1u
X492 VSS.t2593 VDD VSS.t2595 VSS.t2594 sg13_lv_nmos ad=79.8f pd=0.8u as=0 ps=0 w=0.42u l=1u
X493 VDD VSS.t592 VDD VDD sg13_lv_pmos ad=0.19p pd=1.38u as=0 ps=0 w=1u l=1u
X494 VDD VSS.t1398 VDD VDD sg13_lv_pmos ad=0.34p pd=2.68u as=0 ps=0 w=1u l=1u
X495 VDD VSS.t178 VDD VDD sg13_lv_pmos ad=0.19p pd=1.38u as=0 ps=0 w=1u l=1u
X496 VSS.t1155 VDD VSS.t1157 VSS.t1156 sg13_lv_nmos ad=79.8f pd=0.8u as=0 ps=0 w=0.42u l=1u
X497 VSS.t2755 VDD VSS.t2754 VSS.t412 sg13_lv_nmos ad=0.1428p pd=1.52u as=0 ps=0 w=0.42u l=1u
X498 VDD VSS.t2630 VDD VDD sg13_lv_pmos ad=0.19p pd=1.38u as=0 ps=0 w=1u l=1u
X499 VSS.t1349 VDD VSS.t1348 VSS.t377 sg13_lv_nmos ad=0.1428p pd=1.52u as=0 ps=0 w=0.42u l=1u
X500 sg13g2_dfrbpq_1_2.CLK a_12020_15202# VDD VDD sg13_lv_pmos ad=0.2128p pd=1.5u as=0.2128p ps=1.5u w=1.12u l=0.13u
X501 VSS.t695 VDD VSS.t695 VSS.t697 sg13_lv_nmos ad=79.8f pd=0.8u as=0 ps=0 w=0.42u l=1u
X502 VSS.t2463 VDD VSS.t2465 VSS.t2464 sg13_lv_nmos ad=79.8f pd=0.8u as=0 ps=0 w=0.42u l=1u
X503 VDD VSS.t2035 VDD VDD sg13_lv_pmos ad=0.34p pd=2.68u as=0 ps=0 w=1u l=1u
X504 VSS.t1015 VDD VSS.t1014 VSS.t1013 sg13_lv_nmos ad=0.1428p pd=1.52u as=0 ps=0 w=0.42u l=1u
X505 VDD VSS.t2370 VDD VDD sg13_lv_pmos ad=0.19p pd=1.38u as=0 ps=0 w=1u l=1u
X506 VSS.t2236 VDD VSS.t2238 VSS.t2237 sg13_lv_nmos ad=79.8f pd=0.8u as=0 ps=0 w=0.42u l=1u
X507 VDD sg13g2_dlygate4sd3_1_17.A a_24824_14525# VDD sg13_lv_pmos ad=0.1523p pd=1.38u as=0.1428p ps=1.52u w=0.42u l=0.13u
X508 VSS.t1342 VDD VSS.t1343 VSS.t377 sg13_lv_nmos ad=79.8f pd=0.8u as=0 ps=0 w=0.42u l=1u
X509 VDD VSS.t1435 VDD VDD sg13_lv_pmos ad=0.19p pd=1.38u as=0 ps=0 w=1u l=1u
X510 VDD VSS.t2160 VDD VDD sg13_lv_pmos ad=0.34p pd=2.68u as=0 ps=0 w=1u l=1u
X511 VDD VSS.t302 VDD VDD sg13_lv_pmos ad=0.19p pd=1.38u as=0 ps=0 w=1u l=1u
X512 VSS.t1834 VDD VSS.t1833 VSS.t1832 sg13_lv_nmos ad=0.1428p pd=1.52u as=0 ps=0 w=0.42u l=1u
X513 VDD a_19450_15202# a_19169_15424# VDD sg13_lv_pmos ad=0.1523p pd=1.38u as=0.34p ps=2.68u w=1u l=0.5u
X514 a_26373_14495# sg13g2_buf_16_2.X VSS.t33 VSS.t299 sg13_lv_nmos ad=0.2516p pd=2.16u as=5.01922p ps=33.275u w=0.74u l=0.13u
X515 VDD VSS.t454 VDD VDD sg13_lv_pmos ad=0.34p pd=2.68u as=0 ps=0 w=1u l=1u
X516 a_26170_15202# sg13g2_a21oi_1_3.Y VSS.t255 VSS.t264 sg13_lv_nmos ad=0.1428p pd=1.52u as=79.8f ps=0.8u w=0.42u l=0.13u
X517 VSS.t27 a_21827_13690# sg13g2_or3_1_2.X VSS.t370 sg13_lv_nmos ad=0.13395p pd=1.12u as=0.2516p ps=2.16u w=0.74u l=0.13u
X518 VSS.t890 VDD VSS.t889 VSS.t888 sg13_lv_nmos ad=0.1428p pd=1.52u as=0 ps=0 w=0.42u l=1u
X519 VDD VSS.t1843 VDD VDD sg13_lv_pmos ad=0.34p pd=2.68u as=0 ps=0 w=1u l=1u
X520 VSS.t1075 VDD VSS.t1077 VSS.t1076 sg13_lv_nmos ad=79.8f pd=0.8u as=0 ps=0 w=0.42u l=1u
X521 VSS.t181 sg13g2_or3_1_2.B a_24310_15230# VSS.t28 sg13_lv_nmos ad=0.1406p pd=1.12u as=0.2516p ps=2.16u w=0.74u l=0.15u
X522 VDD VSS.t2527 VDD VDD sg13_lv_pmos ad=0.34p pd=2.68u as=0 ps=0 w=1u l=1u
X523 VDD VSS.t1673 VDD VDD sg13_lv_pmos ad=0.34p pd=2.68u as=0 ps=0 w=1u l=1u
X524 sg13g2_buf_16_2.A a_15022_14484# VSS.t24 VSS.t234 sg13_lv_nmos ad=0.1406p pd=1.12u as=0.1406p ps=1.12u w=0.74u l=0.13u
X525 a_16042_13945# a_16485_13701# a_15782_13722# VSS.t358 sg13_lv_nmos ad=79.8f pd=0.8u as=0.1296p ps=1.52u w=0.42u l=0.13u
X526 VSS.t2578 VDD VSS.t2580 VSS.t2579 sg13_lv_nmos ad=79.8f pd=0.8u as=0 ps=0 w=0.42u l=1u
X527 VSS.t600 VDD VSS.t599 VSS.t33 sg13_lv_nmos ad=0.1428p pd=1.52u as=0 ps=0 w=0.42u l=1u
X528 VDD VSS.t302 VDD VDD sg13_lv_pmos ad=0.34p pd=2.68u as=0 ps=0 w=1u l=1u
X529 VSS.t1744 VDD VSS.t1746 VSS.t1745 sg13_lv_nmos ad=79.8f pd=0.8u as=0 ps=0 w=0.42u l=1u
X530 VDD VSS.t2055 VDD VDD sg13_lv_pmos ad=0.34p pd=2.68u as=0 ps=0 w=1u l=1u
X531 VDD VSS.t551 VDD VDD sg13_lv_pmos ad=0.19p pd=1.38u as=0 ps=0 w=1u l=1u
X532 VSS.t1324 VDD VSS.t1323 VSS.t377 sg13_lv_nmos ad=0.1428p pd=1.52u as=0 ps=0 w=0.42u l=1u
X533 VDD VSS.t1282 VDD VDD sg13_lv_pmos ad=0.34p pd=2.68u as=0 ps=0 w=1u l=1u
X534 a_19120_14726# a_18863_14845# a_19282_14922# VSS.t25 sg13_lv_nmos ad=0.1428p pd=1.52u as=37.8f ps=0.6u w=0.42u l=0.13u
X535 VSS.t97 a_18863_14845# a_19530_14484# VSS.t25 sg13_lv_nmos ad=0.1406p pd=1.12u as=0.2516p ps=2.16u w=0.74u l=0.13u
X536 VDD VSS.t1385 VDD VDD sg13_lv_pmos ad=0.19p pd=1.38u as=0 ps=0 w=1u l=1u
X537 VDD VSS.t2887 VDD VDD sg13_lv_pmos ad=0.19p pd=1.38u as=0 ps=0 w=1u l=1u
X538 VDD VSS.t1416 VDD VDD sg13_lv_pmos ad=0.34p pd=2.68u as=0 ps=0 w=1u l=1u
X539 VSS.t2792 VDD VSS.t2792 VSS.t412 sg13_lv_nmos ad=0.1428p pd=1.52u as=0 ps=0 w=0.42u l=1u
X540 VSS.t2608 VDD VSS.t2607 VSS.t2606 sg13_lv_nmos ad=0.1428p pd=1.52u as=0 ps=0 w=0.42u l=1u
X541 VSS.t2221 VDD VSS.t2223 VSS.t2222 sg13_lv_nmos ad=79.8f pd=0.8u as=0 ps=0 w=0.42u l=1u
X542 VDD VSS.t106 VDD VDD sg13_lv_pmos ad=0.34p pd=2.68u as=0 ps=0 w=1u l=1u
X543 VDD VSS.t1159 VDD VDD sg13_lv_pmos ad=0.34p pd=2.68u as=0 ps=0 w=1u l=1u
X544 VSS.t752 VDD VSS.t749 VSS.t751 sg13_lv_nmos ad=0.1428p pd=1.52u as=0 ps=0 w=0.42u l=1u
X545 VSS.t1367 VDD VSS.t1366 VSS.t377 sg13_lv_nmos ad=0.1428p pd=1.52u as=0 ps=0 w=0.42u l=1u
X546 VSS.t2111 VDD VSS.t2113 VSS.t2112 sg13_lv_nmos ad=79.8f pd=0.8u as=0 ps=0 w=0.42u l=1u
X547 VSS.t3200 VDD VSS.t3202 VSS.t3201 sg13_lv_nmos ad=79.8f pd=0.8u as=0 ps=0 w=0.42u l=1u
X548 VSS.t2408 VDD VSS.t2410 VSS.t2409 sg13_lv_nmos ad=79.8f pd=0.8u as=0 ps=0 w=0.42u l=1u
X549 VSS.t551 VDD VSS.t551 VSS.t553 sg13_lv_nmos ad=0.1428p pd=1.52u as=0 ps=0 w=0.42u l=1u
X550 VSS.t609 VDD VSS.t608 VSS.t33 sg13_lv_nmos ad=0.1428p pd=1.52u as=0 ps=0 w=0.42u l=1u
X551 VSS.t1045 VDD VSS.t1044 VSS.t1043 sg13_lv_nmos ad=0.1428p pd=1.52u as=0 ps=0 w=0.42u l=1u
X552 VDD VSS.t1686 VDD VDD sg13_lv_pmos ad=0.19p pd=1.38u as=0 ps=0 w=1u l=1u
X553 VSS.t576 VDD VSS.t142 VSS.t33 sg13_lv_nmos ad=0.1428p pd=1.52u as=0 ps=0 w=0.42u l=1u
X554 VDD VSS.t1097 VDD VDD sg13_lv_pmos ad=0.19p pd=1.38u as=0 ps=0 w=1u l=1u
X555 VDD VSS.t1741 VDD VDD sg13_lv_pmos ad=0.19p pd=1.38u as=0 ps=0 w=1u l=1u
X556 VSS.t2483 VDD VSS.t2485 VSS.t2484 sg13_lv_nmos ad=79.8f pd=0.8u as=0 ps=0 w=0.42u l=1u
X557 VDD VSS.t449 VDD VDD sg13_lv_pmos ad=0.19p pd=1.38u as=0 ps=0 w=1u l=1u
X558 VDD VSS.t2512 VDD VDD sg13_lv_pmos ad=0.34p pd=2.68u as=0 ps=0 w=1u l=1u
X559 a_27034_15202# sg13g2_dfrbpq_1_7.Q VDD VDD sg13_lv_pmos ad=0.1428p pd=1.52u as=0.1523p ps=1.38u w=0.42u l=0.13u
X560 VSS.t2791 VDD VSS.t2790 VSS.t412 sg13_lv_nmos ad=0.1428p pd=1.52u as=0 ps=0 w=0.42u l=1u
X561 VDD VSS.t728 VDD VDD sg13_lv_pmos ad=0.19p pd=1.38u as=0 ps=0 w=1u l=1u
X562 VDD VSS.t2023 VDD VDD sg13_lv_pmos ad=0.19p pd=1.38u as=0 ps=0 w=1u l=1u
X563 VDD VSS.t2850 VDD VDD sg13_lv_pmos ad=0.19p pd=1.38u as=0 ps=0 w=1u l=1u
X564 VSS.t1704 VDD VSS.t1703 VSS.t1702 sg13_lv_nmos ad=0.1428p pd=1.52u as=0 ps=0 w=0.42u l=1u
X565 VSS.t3230 VDD VSS.t3229 VSS.t3228 sg13_lv_nmos ad=0.1428p pd=1.52u as=0 ps=0 w=0.42u l=1u
X566 sg13g2_buf_16_2.A a_15022_14484# VSS.t24 VSS.t230 sg13_lv_nmos ad=0.1406p pd=1.12u as=0.1406p ps=1.12u w=0.74u l=0.13u
X567 VDD VSS.t2430 VDD VDD sg13_lv_pmos ad=0.19p pd=1.38u as=0 ps=0 w=1u l=1u
X568 VDD VSS.t2825 VDD VDD sg13_lv_pmos ad=0.34p pd=2.68u as=0 ps=0 w=1u l=1u
X569 VSS.t1015 VDD VSS.t1014 VSS.t1013 sg13_lv_nmos ad=0.1428p pd=1.52u as=0 ps=0 w=0.42u l=1u
X570 a_25390_16263# a_25505_16262# VDD VDD sg13_lv_pmos ad=0.34p pd=2.68u as=0.2254p ps=1.53u w=1u l=0.5u
X571 VSS.t612 VDD VSS.t613 VSS.t33 sg13_lv_nmos ad=79.8f pd=0.8u as=0 ps=0 w=0.42u l=1u
X572 VDD VSS.t605 VDD VDD sg13_lv_pmos ad=0.34p pd=2.68u as=0 ps=0 w=1u l=1u
X573 VDD VSS.t972 VDD VDD sg13_lv_pmos ad=0.19p pd=1.38u as=0 ps=0 w=1u l=1u
X574 VDD VSS.t2615 VDD VDD sg13_lv_pmos ad=0.19p pd=1.38u as=0 ps=0 w=1u l=1u
X575 VDD VSS.t1396 VDD VDD sg13_lv_pmos ad=0.19p pd=1.38u as=0 ps=0 w=1u l=1u
X576 VSS.t1699 VDD VSS.t1698 VSS.t1697 sg13_lv_nmos ad=0.1428p pd=1.52u as=0 ps=0 w=0.42u l=1u
X577 VDD VSS.t2898 VDD VDD sg13_lv_pmos ad=0.19p pd=1.38u as=0 ps=0 w=1u l=1u
X578 VSS.t2628 VDD VSS.t2627 VSS.t2626 sg13_lv_nmos ad=0.1428p pd=1.52u as=0 ps=0 w=0.42u l=1u
X579 VSS.t2448 VDD VSS.t2450 VSS.t2449 sg13_lv_nmos ad=79.8f pd=0.8u as=0 ps=0 w=0.42u l=1u
X580 VDD VSS.t2213 VDD VDD sg13_lv_pmos ad=0.19p pd=1.38u as=0 ps=0 w=1u l=1u
X581 VDD VSS.t2567 VDD VDD sg13_lv_pmos ad=0.34p pd=2.68u as=0 ps=0 w=1u l=1u
X582 VDD VSS.t3134 VDD VDD sg13_lv_pmos ad=0.34p pd=2.68u as=0 ps=0 w=1u l=1u
X583 VDD VSS.t2173 VDD VDD sg13_lv_pmos ad=0.19p pd=1.38u as=0 ps=0 w=1u l=1u
X584 VSS.t2176 VDD VSS.t2175 VSS.t2174 sg13_lv_nmos ad=0.1428p pd=1.52u as=0 ps=0 w=0.42u l=1u
X585 VSS.t890 VDD VSS.t889 VSS.t888 sg13_lv_nmos ad=0.1428p pd=1.52u as=0 ps=0 w=0.42u l=1u
X586 VSS.t1075 VDD VSS.t1077 VSS.t1076 sg13_lv_nmos ad=79.8f pd=0.8u as=0 ps=0 w=0.42u l=1u
X587 VDD VSS.t1351 VDD VDD sg13_lv_pmos ad=0.34p pd=2.68u as=0 ps=0 w=1u l=1u
X588 VDD VSS.t1671 VDD VDD sg13_lv_pmos ad=0.19p pd=1.38u as=0 ps=0 w=1u l=1u
X589 VDD VSS.t1726 VDD VDD sg13_lv_pmos ad=0.19p pd=1.38u as=0 ps=0 w=1u l=1u
X590 VDD a_8218_13690# a_7937_13912# VDD sg13_lv_pmos ad=0.1523p pd=1.38u as=0.34p ps=2.68u w=1u l=0.5u
X591 sg13g2_dfrbpq_1_2.Q a_17994_14020# VDD VDD sg13_lv_pmos ad=0.3808p pd=2.92u as=0.2128p ps=1.5u w=1.12u l=0.13u
X592 VDD VSS.t2788 VDD VDD sg13_lv_pmos ad=0.19p pd=1.38u as=0 ps=0 w=1u l=1u
X593 VDD VSS.t2861 VDD VDD sg13_lv_pmos ad=0.19p pd=1.38u as=0 ps=0 w=1u l=1u
X594 VSS.t2126 VDD VSS.t2125 VSS.t2124 sg13_lv_nmos ad=0.1428p pd=1.52u as=0 ps=0 w=0.42u l=1u
X595 VDD VSS.t106 VDD VDD sg13_lv_pmos ad=0.34p pd=2.68u as=0 ps=0 w=1u l=1u
X596 VDD VSS.t398 VDD VDD sg13_lv_pmos ad=0.34p pd=2.68u as=0 ps=0 w=1u l=1u
X597 VDD VSS.t1004 VDD VDD sg13_lv_pmos ad=0.34p pd=2.68u as=0 ps=0 w=1u l=1u
X598 VSS.t3215 VDD VSS.t3214 VSS.t3213 sg13_lv_nmos ad=0.1428p pd=1.52u as=0 ps=0 w=0.42u l=1u
X599 VSS.t2423 VDD VSS.t2422 VSS.t2421 sg13_lv_nmos ad=0.1428p pd=1.52u as=0 ps=0 w=0.42u l=1u
X600 VDD VSS.t480 VDD VDD sg13_lv_pmos ad=0.19p pd=1.38u as=0 ps=0 w=1u l=1u
X601 a_23960_15242# sg13g2_dfrbpq_1_3.Q a_23858_15242# VSS.t28 sg13_lv_nmos ad=0.1406p pd=1.12u as=0.1406p ps=1.12u w=0.74u l=0.13u
X602 VSS.t594 VDD VSS.t593 VSS.t33 sg13_lv_nmos ad=0.1428p pd=1.52u as=0 ps=0 w=0.42u l=1u
X603 VDD sg13g2_dlygate4sd3_1_4.X sg13g2_xnor2_1_1.A VDD sg13_lv_pmos ad=0.3808p pd=2.92u as=0.3808p ps=2.92u w=1.12u l=0.13u
X604 a_7680_15549# sg13g2_dlygate4sd3_1_8.X VDD VDD sg13_lv_pmos ad=0.1596p pd=1.22u as=0.4536p ps=2.76u w=0.84u l=0.13u
X605 VDD sg13g2_xnor2_1_0.Y a_8312_15238# VDD sg13_lv_pmos ad=0.1523p pd=1.38u as=0.1428p ps=1.52u w=0.42u l=0.13u
X606 VSS.t2758 VDD VSS.t2756 VSS.t412 sg13_lv_nmos ad=0.1428p pd=1.52u as=0 ps=0 w=0.42u l=1u
X607 a_24923_15996# sg13g2_or3_1_1.X VDD VDD sg13_lv_pmos ad=0.3808p pd=2.92u as=0.2128p ps=1.5u w=1.12u l=0.13u
X608 VSS.t2852 VDD VSS.t2853 VSS.t412 sg13_lv_nmos ad=79.8f pd=0.8u as=0 ps=0 w=0.42u l=1u
X609 VDD VSS.t2600 VDD VDD sg13_lv_pmos ad=0.19p pd=1.38u as=0 ps=0 w=1u l=1u
X610 VDD VSS.t746 VDD VDD sg13_lv_pmos ad=0.19p pd=1.38u as=0 ps=0 w=1u l=1u
X611 VDD VSS.t2040 VDD VDD sg13_lv_pmos ad=0.34p pd=2.68u as=0 ps=0 w=1u l=1u
X612 VDD VSS.t3167 VDD VDD sg13_lv_pmos ad=0.19p pd=1.38u as=0 ps=0 w=1u l=1u
X613 VDD VSS.t2375 VDD VDD sg13_lv_pmos ad=0.19p pd=1.38u as=0 ps=0 w=1u l=1u
X614 VDD VSS.t63 VDD VDD sg13_lv_pmos ad=0.19p pd=1.38u as=0 ps=0 w=1u l=1u
X615 a_20868_14922# sg13g2_dfrbpq_1_6.D a_20774_14922# VSS.t25 sg13_lv_nmos ad=60.89999f pd=0.71u as=0.1428p ps=1.52u w=0.42u l=0.13u
X616 VSS.t2206 VDD VSS.t2208 VSS.t2207 sg13_lv_nmos ad=79.8f pd=0.8u as=0 ps=0 w=0.42u l=1u
X617 VSS.t178 sg13g2_buf_16_2.A a_19438_13726# VSS.t180 sg13_lv_nmos ad=0.1406p pd=1.12u as=0.1406p ps=1.12u w=0.74u l=0.13u
X618 VDD VSS.t2165 VDD VDD sg13_lv_pmos ad=0.34p pd=2.68u as=0 ps=0 w=1u l=1u
X619 VSS.t1045 VDD VSS.t1044 VSS.t1043 sg13_lv_nmos ad=0.1428p pd=1.52u as=0 ps=0 w=0.42u l=1u
X620 VSS.t1424 VDD VSS.t1423 VSS.t377 sg13_lv_nmos ad=0.1428p pd=1.52u as=0 ps=0 w=0.42u l=1u
X621 VSS.t530 VDD VSS.t532 VSS.t531 sg13_lv_nmos ad=79.8f pd=0.8u as=0 ps=0 w=0.42u l=1u
X622 VDD VSS.t695 VDD VDD sg13_lv_pmos ad=0.34p pd=2.68u as=0 ps=0 w=1u l=1u
X623 VSS.t3185 VDD VSS.t3187 VSS.t3186 sg13_lv_nmos ad=79.8f pd=0.8u as=0 ps=0 w=0.42u l=1u
X624 VSS.t2393 VDD VSS.t2395 VSS.t2394 sg13_lv_nmos ad=79.8f pd=0.8u as=0 ps=0 w=0.42u l=1u
X625 a_21562_15960# sg13g2_a21oi_1_1.Y VSS.t1 VSS.t0 sg13_lv_nmos ad=0.1428p pd=1.52u as=79.8f ps=0.8u w=0.42u l=0.13u
X626 VDD sg13g2_dlygate4sd3_1_1.A sg13g2_nand3_1_0.Y VDD sg13_lv_pmos ad=0.2128p pd=1.5u as=0.2128p ps=1.5u w=1.12u l=0.13u
X627 VDD a_21477_14495# a_21579_14495# VDD sg13_lv_pmos ad=2.42015p pd=15.68u as=0.3864p ps=2.93u w=1.12u l=0.13u
X628 VDD VSS.t1848 VDD VDD sg13_lv_pmos ad=0.34p pd=2.68u as=0 ps=0 w=1u l=1u
X629 VDD a_15022_14484# sg13g2_buf_16_2.A VDD sg13_lv_pmos ad=0.2128p pd=1.5u as=0.2128p ps=1.5u w=1.12u l=0.13u
X630 a_16218_15532# sg13g2_or3_1_2.B sg13g2_nor2_1_0.B VDD sg13_lv_pmos ad=0.1428p pd=1.375u as=0.2408p ps=1.55u w=1.12u l=0.13u
X631 VSS.t1754 VDD VSS.t1756 VSS.t1755 sg13_lv_nmos ad=79.8f pd=0.8u as=0 ps=0 w=0.42u l=1u
X632 VSS.t2468 VDD VSS.t2470 VSS.t2469 sg13_lv_nmos ad=79.8f pd=0.8u as=0 ps=0 w=0.42u l=1u
X633 a_17830_14909# sg13g2_dfrbpq_1_3.RESET_B VSS.t24 VSS.t87 sg13_lv_nmos ad=37.8f pd=0.6u as=0.1701p ps=1.65u w=0.42u l=0.13u
X634 VDD VSS.t758 VDD VDD sg13_lv_pmos ad=0.19p pd=1.38u as=0 ps=0 w=1u l=1u
X635 VDD VSS.t1678 VDD VDD sg13_lv_pmos ad=0.34p pd=2.68u as=0 ps=0 w=1u l=1u
X636 VDD VSS.t2592 VDD VDD sg13_lv_pmos ad=0.34p pd=2.68u as=0 ps=0 w=1u l=1u
X637 VSS.t1749 VDD VSS.t1751 VSS.t1750 sg13_lv_nmos ad=79.8f pd=0.8u as=0 ps=0 w=0.42u l=1u
X638 VDD VSS.t2816 VDD VDD sg13_lv_pmos ad=0.34p pd=2.68u as=0 ps=0 w=1u l=1u
X639 VSS.t965 VDD VSS.t967 VSS.t966 sg13_lv_nmos ad=79.8f pd=0.8u as=0 ps=0 w=0.42u l=1u
X640 VSS.t2863 VDD VSS.t2864 VSS.t412 sg13_lv_nmos ad=79.8f pd=0.8u as=0 ps=0 w=0.42u l=1u
X641 a_26565_13701# sg13g2_buf_16_2.X VSS.t302 VSS.t301 sg13_lv_nmos ad=0.2516p pd=2.16u as=15.10457p ps=99.59499u w=0.74u l=0.13u
X642 VDD VSS.t1285 VDD VDD sg13_lv_pmos ad=0.34p pd=2.68u as=0 ps=0 w=1u l=1u
X643 VDD VSS.t1388 VDD VDD sg13_lv_pmos ad=0.19p pd=1.38u as=0 ps=0 w=1u l=1u
X644 VDD VSS.t2890 VDD VDD sg13_lv_pmos ad=0.19p pd=1.38u as=0 ps=0 w=1u l=1u
X645 VDD VSS.t2198 VDD VDD sg13_lv_pmos ad=0.19p pd=1.38u as=0 ps=0 w=1u l=1u
X646 VDD VSS.t2552 VDD VDD sg13_lv_pmos ad=0.34p pd=2.68u as=0 ps=0 w=1u l=1u
X647 VSS.t2613 VDD VSS.t2612 VSS.t2611 sg13_lv_nmos ad=0.1428p pd=1.52u as=0 ps=0 w=0.42u l=1u
X648 VDD VSS.t2864 VDD VDD sg13_lv_pmos ad=0.34p pd=2.68u as=0 ps=0 w=1u l=1u
X649 VDD VSS.t302 VDD VDD sg13_lv_pmos ad=0.19p pd=1.38u as=0 ps=0 w=1u l=1u
X650 VDD VSS.t3119 VDD VDD sg13_lv_pmos ad=0.34p pd=2.68u as=0 ps=0 w=1u l=1u
X651 VSS.t174 sg13g2_buf_16_2.A a_19438_13726# VSS.t175 sg13_lv_nmos ad=0.1406p pd=1.12u as=0.1406p ps=1.12u w=0.74u l=0.13u
X652 VSS.t1779 VDD VSS.t1778 VSS.t1777 sg13_lv_nmos ad=0.1428p pd=1.52u as=0 ps=0 w=0.42u l=1u
X653 sg13g2_o21ai_1_3.Y sg13g2_or3_1_1.C a_24408_15552# VDD sg13_lv_pmos ad=0.2128p pd=1.5u as=0.2128p ps=1.5u w=1.12u l=0.15u
X654 a_27664_13942# a_27407_13799# a_27826_13722# VSS.t431 sg13_lv_nmos ad=0.1428p pd=1.52u as=37.8f ps=0.6u w=0.42u l=0.13u
X655 VDD VSS.t2068 VDD VDD sg13_lv_pmos ad=0.19p pd=1.38u as=0 ps=0 w=1u l=1u
X656 VDD VSS.t494 VDD VDD sg13_lv_pmos ad=0.34p pd=2.68u as=0 ps=0 w=1u l=1u
X657 VDD VSS.t1656 VDD VDD sg13_lv_pmos ad=0.19p pd=1.38u as=0 ps=0 w=1u l=1u
X658 VDD VSS.t1833 VDD VDD sg13_lv_pmos ad=0.34p pd=2.68u as=0 ps=0 w=1u l=1u
X659 a_17584_13942# sg13g2_dfrbpq_1_2.RESET_B VDD VDD sg13_lv_pmos ad=79.8f pd=0.8u as=2.42015p ps=15.68u w=0.42u l=0.13u
X660 VDD a_15022_14484# sg13g2_buf_16_2.A VDD sg13_lv_pmos ad=0.2128p pd=1.5u as=0.2128p ps=1.5u w=1.12u l=0.13u
X661 VDD VSS.t734 VDD VDD sg13_lv_pmos ad=0.34p pd=2.68u as=0 ps=0 w=1u l=1u
X662 VSS.t2453 VDD VSS.t2455 VSS.t2454 sg13_lv_nmos ad=79.8f pd=0.8u as=0 ps=0 w=0.42u l=1u
X663 VDD a_25786_15960# a_25505_16262# VDD sg13_lv_pmos ad=0.1523p pd=1.38u as=0.34p ps=2.68u w=1u l=0.5u
X664 VSS.t24 sg13g2_or3_1_2.B a_16079_15238# VSS.t206 sg13_lv_nmos ad=0.1898p pd=1.36u as=0.1406p ps=1.12u w=0.74u l=0.13u
X665 VSS.t1296 VDD VSS.t1297 VSS.t377 sg13_lv_nmos ad=79.8f pd=0.8u as=0 ps=0 w=0.42u l=1u
X666 VDD VSS.t2779 VDD VDD sg13_lv_pmos ad=0.19p pd=1.38u as=0 ps=0 w=1u l=1u
X667 VSS.t2408 VDD VSS.t2407 VSS.t2406 sg13_lv_nmos ad=0.1428p pd=1.52u as=0 ps=0 w=0.42u l=1u
X668 VSS.t1674 VDD VSS.t1673 VSS.t1672 sg13_lv_nmos ad=0.1428p pd=1.52u as=0 ps=0 w=0.42u l=1u
X669 VSS.t3200 VDD VSS.t3199 VSS.t3198 sg13_lv_nmos ad=0.1428p pd=1.52u as=0 ps=0 w=0.42u l=1u
X670 VDD VSS.t2435 VDD VDD sg13_lv_pmos ad=0.19p pd=1.38u as=0 ps=0 w=1u l=1u
X671 a_21466_15202# sg13g2_o21ai_1_1.Y VSS.t6 VSS.t71 sg13_lv_nmos ad=0.1428p pd=1.52u as=79.8f ps=0.8u w=0.42u l=0.13u
X672 VSS.t2749 VDD VSS.t413 VSS.t412 sg13_lv_nmos ad=0.1428p pd=1.52u as=0 ps=0 w=0.42u l=1u
X673 VDD VSS.t2882 VDD VDD sg13_lv_pmos ad=0.19p pd=1.38u as=0 ps=0 w=1u l=1u
X674 VDD VSS.t2218 VDD VDD sg13_lv_pmos ad=0.19p pd=1.38u as=0 ps=0 w=1u l=1u
X675 VDD VSS.t302 VDD VDD sg13_lv_pmos ad=0.34p pd=2.68u as=0 ps=0 w=1u l=1u
X676 a_3209_16334# a_3333_16033# VDD VDD sg13_lv_pmos ad=0.2442p pd=2.06u as=2.8961p ps=18.25u w=0.66u l=0.13u
X677 VDD VSS.t924 VDD VDD sg13_lv_pmos ad=0.34p pd=2.68u as=0 ps=0 w=1u l=1u
X678 VSS.t1352 VDD VSS.t1351 VSS.t377 sg13_lv_nmos ad=0.1428p pd=1.52u as=0 ps=0 w=0.42u l=1u
X679 VSS.t302 VDD VSS.t302 VSS.t712 sg13_lv_nmos ad=79.8f pd=0.8u as=0 ps=0 w=0.42u l=1u
X680 VDD VSS.t695 VDD VDD sg13_lv_pmos ad=0.34p pd=2.68u as=0 ps=0 w=1u l=1u
X681 VSS.t1764 VDD VSS.t1763 VSS.t1762 sg13_lv_nmos ad=0.1428p pd=1.52u as=0 ps=0 w=0.42u l=1u
X682 VSS.t1305 VDD VSS.t1306 VSS.t377 sg13_lv_nmos ad=79.8f pd=0.8u as=0 ps=0 w=0.42u l=1u
X683 VDD a_25094_14484# a_25206_14508# VDD sg13_lv_pmos ad=0.2254p pd=1.53u as=0.34p ps=2.68u w=1u l=0.5u
X684 VSS.t1739 VDD VSS.t1741 VSS.t1740 sg13_lv_nmos ad=79.8f pd=0.8u as=0 ps=0 w=0.42u l=1u
X685 VDD VSS.t2415 VDD VDD sg13_lv_pmos ad=0.19p pd=1.38u as=0 ps=0 w=1u l=1u
X686 VSS.t2633 VDD VSS.t2632 VSS.t2631 sg13_lv_nmos ad=0.1428p pd=1.52u as=0 ps=0 w=0.42u l=1u
X687 VSS.t1466 VDD VSS.t1311 VSS.t377 sg13_lv_nmos ad=79.8f pd=0.8u as=0 ps=0 w=0.42u l=1u
X688 VDD VSS.t2013 VDD VDD sg13_lv_pmos ad=0.19p pd=1.38u as=0 ps=0 w=1u l=1u
X689 VSS.t2131 VDD VSS.t2130 VSS.t2129 sg13_lv_nmos ad=0.1428p pd=1.52u as=0 ps=0 w=0.42u l=1u
X690 a_19054_15423# a_19169_15424# VDD VDD sg13_lv_pmos ad=0.34p pd=2.68u as=0.2254p ps=1.53u w=1u l=0.5u
X691 VSS.t1694 VDD VSS.t1693 VSS.t1692 sg13_lv_nmos ad=0.1428p pd=1.52u as=0 ps=0 w=0.42u l=1u
X692 VSS.t3220 VDD VSS.t3219 VSS.t3218 sg13_lv_nmos ad=0.1428p pd=1.52u as=0 ps=0 w=0.42u l=1u
X693 VDD VSS.t2845 VDD VDD sg13_lv_pmos ad=0.19p pd=1.38u as=0 ps=0 w=1u l=1u
X694 a_18377_16334# a_18501_16033# VDD VDD sg13_lv_pmos ad=0.2442p pd=2.06u as=2.8961p ps=18.25u w=0.66u l=0.13u
X695 VDD VSS.t574 VDD VDD sg13_lv_pmos ad=0.34p pd=2.68u as=0 ps=0 w=1u l=1u
X696 VSS.t965 VDD VSS.t967 VSS.t966 sg13_lv_nmos ad=79.8f pd=0.8u as=0 ps=0 w=0.42u l=1u
X697 VDD VSS.t1703 VDD VDD sg13_lv_pmos ad=0.34p pd=2.68u as=0 ps=0 w=1u l=1u
X698 VDD VSS.t2577 VDD VDD sg13_lv_pmos ad=0.34p pd=2.68u as=0 ps=0 w=1u l=1u
X699 VSS.t1734 VDD VSS.t1736 VSS.t1735 sg13_lv_nmos ad=79.8f pd=0.8u as=0 ps=0 w=0.42u l=1u
X700 VDD VSS.t578 VDD VDD sg13_lv_pmos ad=0.34p pd=2.68u as=0 ps=0 w=1u l=1u
X701 VSS.t2855 VDD VSS.t2856 VSS.t412 sg13_lv_nmos ad=79.8f pd=0.8u as=0 ps=0 w=0.42u l=1u
X702 VDD VSS.t2605 VDD VDD sg13_lv_pmos ad=0.19p pd=1.38u as=0 ps=0 w=1u l=1u
X703 VDD VSS.t2045 VDD VDD sg13_lv_pmos ad=0.34p pd=2.68u as=0 ps=0 w=1u l=1u
X704 VDD VSS.t3172 VDD VDD sg13_lv_pmos ad=0.19p pd=1.38u as=0 ps=0 w=1u l=1u
X705 VSS.t2438 VDD VSS.t2440 VSS.t2439 sg13_lv_nmos ad=79.8f pd=0.8u as=0 ps=0 w=0.42u l=1u
X706 VDD VSS.t2380 VDD VDD sg13_lv_pmos ad=0.19p pd=1.38u as=0 ps=0 w=1u l=1u
X707 a_9801_15625# a_9444_15552# VDD VDD sg13_lv_pmos ad=63f pd=0.72u as=0.1563p ps=1.22u w=0.42u l=0.13u
X708 VDD VSS.t302 VDD VDD sg13_lv_pmos ad=0.19p pd=1.38u as=0 ps=0 w=1u l=1u
X709 VDD VSS.t1079 VDD VDD sg13_lv_pmos ad=0.34p pd=2.68u as=0 ps=0 w=1u l=1u
X710 VSS.t2211 VDD VSS.t2213 VSS.t2212 sg13_lv_nmos ad=79.8f pd=0.8u as=0 ps=0 w=0.42u l=1u
X711 VSS.t695 VDD VSS.t695 VSS.t698 sg13_lv_nmos ad=0.1428p pd=1.52u as=0 ps=0 w=0.42u l=1u
X712 VDD VSS.t1323 VDD VDD sg13_lv_pmos ad=0.19p pd=1.38u as=0 ps=0 w=1u l=1u
X713 VDD VSS.t1350 VDD VDD sg13_lv_pmos ad=0.34p pd=2.68u as=0 ps=0 w=1u l=1u
X714 VDD VSS.t2856 VDD VDD sg13_lv_pmos ad=0.34p pd=2.68u as=0 ps=0 w=1u l=1u
X715 VSS.t1396 VDD VSS.t1397 VSS.t377 sg13_lv_nmos ad=79.8f pd=0.8u as=0 ps=0 w=0.42u l=1u
X716 VDD a_25094_15238# a_25206_15302# VDD sg13_lv_pmos ad=0.2254p pd=1.53u as=0.34p ps=2.68u w=1u l=0.5u
X717 VDD VSS.t1818 VDD VDD sg13_lv_pmos ad=0.34p pd=2.68u as=0 ps=0 w=1u l=1u
X718 VDD VSS.t2230 VDD VDD sg13_lv_pmos ad=0.34p pd=2.68u as=0 ps=0 w=1u l=1u
X719 VDD VSS.t2053 VDD VDD sg13_lv_pmos ad=0.19p pd=1.38u as=0 ps=0 w=1u l=1u
X720 VDD VSS.t584 VDD VDD sg13_lv_pmos ad=0.34p pd=2.68u as=0 ps=0 w=1u l=1u
X721 VSS.t1724 VDD VSS.t1726 VSS.t1725 sg13_lv_nmos ad=79.8f pd=0.8u as=0 ps=0 w=0.42u l=1u
X722 VSS.t3250 VDD VSS.t3252 VSS.t3251 sg13_lv_nmos ad=79.8f pd=0.8u as=0 ps=0 w=0.42u l=1u
X723 VSS.t2618 VDD VSS.t2617 VSS.t2616 sg13_lv_nmos ad=0.1428p pd=1.52u as=0 ps=0 w=0.42u l=1u
X724 VSS.t612 VDD VSS.t611 VSS.t33 sg13_lv_nmos ad=0.1428p pd=1.52u as=0 ps=0 w=0.42u l=1u
X725 VDD VSS.t369 VDD VDD sg13_lv_pmos ad=0.34p pd=2.68u as=0 ps=0 w=1u l=1u
X726 VDD VSS.t1683 VDD VDD sg13_lv_pmos ad=0.34p pd=2.68u as=0 ps=0 w=1u l=1u
X727 VDD a_21946_16237# sg13g2_dfrbpq_1_6.RESET_B VDD sg13_lv_pmos ad=2.8961p pd=18.25u as=0.3927p ps=2.99u w=1.155u l=0.13u
X728 VDD a_12020_15202# sg13g2_dfrbpq_1_2.CLK VDD sg13_lv_pmos ad=0.2128p pd=1.5u as=0.2128p ps=1.5u w=1.12u l=0.13u
X729 VSS.t2900 VDD VSS.t2901 VSS.t412 sg13_lv_nmos ad=79.8f pd=0.8u as=0 ps=0 w=0.42u l=1u
X730 VDD VSS.t1094 VDD VDD sg13_lv_pmos ad=0.34p pd=2.68u as=0 ps=0 w=1u l=1u
X731 VDD VSS.t2597 VDD VDD sg13_lv_pmos ad=0.34p pd=2.68u as=0 ps=0 w=1u l=1u
X732 a_17428_16020# sg13g2_dlygate4sd3_1_6.X VDD VDD sg13_lv_pmos ad=0.1575p pd=1.315u as=0.3822p ps=1.84u w=1u l=0.13u
X733 VDD VSS.t2819 VDD VDD sg13_lv_pmos ad=0.34p pd=2.68u as=0 ps=0 w=1u l=1u
X734 sg13g2_dfrbpq_1_2.CLK a_12020_15202# VSS.t50 VSS.t53 sg13_lv_nmos ad=0.1406p pd=1.12u as=0.1406p ps=1.12u w=0.74u l=0.13u
X735 VSS.t686 VDD VSS.t302 VSS.t688 sg13_lv_nmos ad=79.8f pd=0.8u as=0 ps=0 w=0.42u l=1u
X736 VDD VSS.t302 VDD VDD sg13_lv_pmos ad=0.34p pd=2.68u as=0 ps=0 w=1u l=1u
X737 VDD VSS.t1391 VDD VDD sg13_lv_pmos ad=0.19p pd=1.38u as=0 ps=0 w=1u l=1u
X738 VDD VSS.t2874 VDD VDD sg13_lv_pmos ad=0.19p pd=1.38u as=0 ps=0 w=1u l=1u
X739 VDD VSS.t2203 VDD VDD sg13_lv_pmos ad=0.19p pd=1.38u as=0 ps=0 w=1u l=1u
X740 VSS.t766 VDD VSS.t763 VSS.t765 sg13_lv_nmos ad=0.1428p pd=1.52u as=0 ps=0 w=0.42u l=1u
X741 VDD VSS.t2557 VDD VDD sg13_lv_pmos ad=0.34p pd=2.68u as=0 ps=0 w=1u l=1u
X742 VSS.t2583 VDD VSS.t2582 VSS.t2581 sg13_lv_nmos ad=0.1428p pd=1.52u as=0 ps=0 w=0.42u l=1u
X743 VSS.t302 a_6286_13911# sg13g2_dlygate4sd3_1_0.X VSS.t354 sg13_lv_nmos ad=0.1426p pd=1.16u as=0.2516p ps=2.16u w=0.74u l=0.13u
X744 VSS.t1379 VDD VSS.t1378 VSS.t377 sg13_lv_nmos ad=0.1428p pd=1.52u as=0 ps=0 w=0.42u l=1u
X745 VSS.t449 VDD VSS.t449 VSS.t452 sg13_lv_nmos ad=79.8f pd=0.8u as=0 ps=0 w=0.42u l=1u
X746 VSS.t485 VDD VSS.t487 VSS.t486 sg13_lv_nmos ad=79.8f pd=0.8u as=0 ps=0 w=0.42u l=1u
X747 VSS.t3080 VDD VSS.t3082 VSS.t3081 sg13_lv_nmos ad=79.8f pd=0.8u as=0 ps=0 w=0.42u l=1u
X748 VSS.t1749 VDD VSS.t1748 VSS.t1747 sg13_lv_nmos ad=0.1428p pd=1.52u as=0 ps=0 w=0.42u l=1u
X749 VSS.t2166 VDD VSS.t2165 VSS.t2164 sg13_lv_nmos ad=0.1428p pd=1.52u as=0 ps=0 w=0.42u l=1u
X750 VSS.t1372 VDD VSS.t1373 VSS.t377 sg13_lv_nmos ad=79.8f pd=0.8u as=0 ps=0 w=0.42u l=1u
X751 VDD VSS.t131 VDD VDD sg13_lv_pmos ad=0.34p pd=2.68u as=0 ps=0 w=1u l=1u
X752 a_26638_15423# a_26753_15424# VDD VDD sg13_lv_pmos ad=0.34p pd=2.68u as=0.2254p ps=1.53u w=1u l=0.5u
X753 VDD a_19438_13726# sg13g2_buf_16_2.X VDD sg13_lv_pmos ad=0.2128p pd=1.5u as=0.2128p ps=1.5u w=1.12u l=0.13u
X754 VDD VSS.t731 VDD VDD sg13_lv_pmos ad=0.19p pd=1.38u as=0 ps=0 w=1u l=1u
X755 VDD VSS.t917 VDD VDD sg13_lv_pmos ad=0.19p pd=1.38u as=0 ps=0 w=1u l=1u
X756 VDD VSS.t1716 VDD VDD sg13_lv_pmos ad=0.19p pd=1.38u as=0 ps=0 w=1u l=1u
X757 VDD VSS.t3184 VDD VDD sg13_lv_pmos ad=0.34p pd=2.68u as=0 ps=0 w=1u l=1u
X758 VDD VSS.t2392 VDD VDD sg13_lv_pmos ad=0.34p pd=2.68u as=0 ps=0 w=1u l=1u
X759 VSS.t725 VDD VSS.t725 VSS.t858 sg13_lv_nmos ad=0.1428p pd=1.52u as=0 ps=0 w=0.42u l=1u
X760 VDD a_26170_15202# a_25889_15424# VDD sg13_lv_pmos ad=0.1523p pd=1.38u as=0.34p ps=2.68u w=1u l=0.5u
X761 VDD VSS.t1356 VDD VDD sg13_lv_pmos ad=0.19p pd=1.38u as=0 ps=0 w=1u l=1u
X762 VSS.t1414 VDD VSS.t1415 VSS.t377 sg13_lv_nmos ad=79.8f pd=0.8u as=0 ps=0 w=0.42u l=1u
X763 VDD VSS.t1998 VDD VDD sg13_lv_pmos ad=0.19p pd=1.38u as=0 ps=0 w=1u l=1u
X764 VDD VSS.t2782 VDD VDD sg13_lv_pmos ad=0.19p pd=1.38u as=0 ps=0 w=1u l=1u
X765 VDD VSS.t2837 VDD VDD sg13_lv_pmos ad=0.19p pd=1.38u as=0 ps=0 w=1u l=1u
X766 VSS.t2413 VDD VSS.t2412 VSS.t2411 sg13_lv_nmos ad=0.1428p pd=1.52u as=0 ps=0 w=0.42u l=1u
X767 VSS.t2116 VDD VSS.t2115 VSS.t2114 sg13_lv_nmos ad=0.1428p pd=1.52u as=0 ps=0 w=0.42u l=1u
X768 VSS.t566 VDD VSS.t568 VSS.t567 sg13_lv_nmos ad=79.8f pd=0.8u as=0 ps=0 w=0.42u l=1u
X769 a_6789_14495# sg13g2_dfrbpq_1_2.CLK VSS.t33 VSS.t331 sg13_lv_nmos ad=0.2516p pd=2.16u as=5.01922p ps=33.275u w=0.74u l=0.13u
X770 VSS.t1679 VDD VSS.t1678 VSS.t1677 sg13_lv_nmos ad=0.1428p pd=1.52u as=0 ps=0 w=0.42u l=1u
X771 VSS.t3205 VDD VSS.t3204 VSS.t3203 sg13_lv_nmos ad=0.1428p pd=1.52u as=0 ps=0 w=0.42u l=1u
X772 VDD VSS.t1319 VDD VDD sg13_lv_pmos ad=0.34p pd=2.68u as=0 ps=0 w=1u l=1u
X773 VDD VSS.t27 VDD VDD sg13_lv_pmos ad=0.34p pd=2.68u as=0 ps=0 w=1u l=1u
X774 VDD VSS.t2590 VDD VDD sg13_lv_pmos ad=0.19p pd=1.38u as=0 ps=0 w=1u l=1u
X775 VSS.t2488 VDD VSS.t2487 VSS.t2486 sg13_lv_nmos ad=0.1428p pd=1.52u as=0 ps=0 w=0.42u l=1u
X776 VDD VSS.t1124 VDD VDD sg13_lv_pmos ad=0.34p pd=2.68u as=0 ps=0 w=1u l=1u
X777 VDD VSS.t1282 VDD VDD sg13_lv_pmos ad=0.19p pd=1.38u as=0 ps=0 w=1u l=1u
X778 VDD VSS.t1382 VDD VDD sg13_lv_pmos ad=0.19p pd=1.38u as=0 ps=0 w=1u l=1u
X779 VDD VSS.t2884 VDD VDD sg13_lv_pmos ad=0.19p pd=1.38u as=0 ps=0 w=1u l=1u
X780 VDD VSS.t2188 VDD VDD sg13_lv_pmos ad=0.19p pd=1.38u as=0 ps=0 w=1u l=1u
X781 VSS.t78 sg13g2_dlygate4sd3_1_17.A a_24824_14525# VSS.t30 sg13_lv_nmos ad=79.8f pd=0.8u as=0.1428p ps=1.52u w=0.42u l=0.13u
X782 VDD VSS.t932 VDD VDD sg13_lv_pmos ad=0.19p pd=1.38u as=0 ps=0 w=1u l=1u
X783 VSS.t2603 VDD VSS.t2602 VSS.t2601 sg13_lv_nmos ad=0.1428p pd=1.52u as=0 ps=0 w=0.42u l=1u
X784 VSS.t2423 VDD VSS.t2425 VSS.t2424 sg13_lv_nmos ad=79.8f pd=0.8u as=0 ps=0 w=0.42u l=1u
X785 VDD VSS.t2365 VDD VDD sg13_lv_pmos ad=0.19p pd=1.38u as=0 ps=0 w=1u l=1u
X786 sg13g2_dfrbpq_1_2.CLK a_12020_15202# VSS.t46 VSS.t48 sg13_lv_nmos ad=0.1406p pd=1.12u as=0.1406p ps=1.12u w=0.74u l=0.13u
X787 a_22576_14726# sg13g2_dfrbpq_1_6.RESET_B VDD VDD sg13_lv_pmos ad=79.8f pd=0.8u as=2.42015p ps=15.68u w=0.42u l=0.13u
X788 a_27609_14037# a_26667_13844# a_27407_13799# VDD sg13_lv_pmos ad=93.45f pd=0.865u as=0.2048p ps=1.63u w=0.42u l=0.13u
X789 VSS.t2898 VDD VSS.t2899 VSS.t412 sg13_lv_nmos ad=79.8f pd=0.8u as=0 ps=0 w=0.42u l=1u
X790 VSS.t33 a_26373_14495# a_26475_14495# VSS.t69 sg13_lv_nmos ad=5.4375p pd=36.05u as=0.2516p ps=2.16u w=0.74u l=0.13u
X791 VSS.t1769 VDD VSS.t1768 VSS.t1767 sg13_lv_nmos ad=0.1428p pd=1.52u as=0 ps=0 w=0.42u l=1u
X792 VDD VSS.t2460 VDD VDD sg13_lv_pmos ad=0.19p pd=1.38u as=0 ps=0 w=1u l=1u
X793 VDD VSS.t14 VDD VDD sg13_lv_pmos ad=0.34p pd=2.68u as=0 ps=0 w=1u l=1u
X794 VDD a_37484_15960# counter_value_o[7] VDD sg13_lv_pmos ad=0.2114p pd=1.54u as=0.42p ps=2.99u w=1.12u l=0.13u
X795 VDD sg13g2_dfrbpq_1_1.RESET_B a_6086_14922# VDD sg13_lv_pmos ad=0.36237p pd=2.605u as=79.8f ps=0.8u w=0.42u l=0.13u
X796 VSS.t1160 VDD VSS.t1159 VSS.t1158 sg13_lv_nmos ad=0.1428p pd=1.52u as=0 ps=0 w=0.42u l=1u
X797 VDD VSS.t1397 VDD VDD sg13_lv_pmos ad=0.34p pd=2.68u as=0 ps=0 w=1u l=1u
X798 VDD VSS.t2899 VDD VDD sg13_lv_pmos ad=0.34p pd=2.68u as=0 ps=0 w=1u l=1u
X799 VDD VSS.t2215 VDD VDD sg13_lv_pmos ad=0.34p pd=2.68u as=0 ps=0 w=1u l=1u
X800 a_20774_14922# a_21579_14495# a_21034_14452# VDD sg13_lv_pmos ad=0.1428p pd=1.52u as=79.8f ps=0.8u w=0.42u l=0.13u
X801 VDD a_19438_13726# sg13g2_buf_16_2.X VDD sg13_lv_pmos ad=0.2128p pd=1.5u as=0.2128p ps=1.5u w=1.12u l=0.13u
X802 VSS.t1427 VDD VSS.t1428 VSS.t377 sg13_lv_nmos ad=79.8f pd=0.8u as=0 ps=0 w=0.42u l=1u
X803 VDD VSS.t2243 VDD VDD sg13_lv_pmos ad=0.19p pd=1.38u as=0 ps=0 w=1u l=1u
X804 VSS.t2066 VDD VSS.t2068 VSS.t2067 sg13_lv_nmos ad=79.8f pd=0.8u as=0 ps=0 w=0.42u l=1u
X805 VDD VSS.t700 VDD VDD sg13_lv_pmos ad=0.19p pd=1.38u as=0 ps=0 w=1u l=1u
X806 VDD VSS.t720 VDD VDD sg13_lv_pmos ad=0.34p pd=2.68u as=0 ps=0 w=1u l=1u
X807 VDD VSS.t1668 VDD VDD sg13_lv_pmos ad=0.34p pd=2.68u as=0 ps=0 w=1u l=1u
X808 VDD VSS.t2018 VDD VDD sg13_lv_pmos ad=0.19p pd=1.38u as=0 ps=0 w=1u l=1u
X809 VSS.t606 VDD VSS.t605 VSS.t33 sg13_lv_nmos ad=0.1428p pd=1.52u as=0 ps=0 w=0.42u l=1u
X810 VSS.t2892 VDD VSS.t2893 VSS.t412 sg13_lv_nmos ad=79.8f pd=0.8u as=0 ps=0 w=0.42u l=1u
X811 VDD VSS.t2848 VDD VDD sg13_lv_pmos ad=0.19p pd=1.38u as=0 ps=0 w=1u l=1u
X812 sg13g2_dlygate4sd3_1_17.A sg13g2_a21oi_1_0.B1 VSS.t12 VSS.t11 sg13_lv_nmos ad=0.1406p pd=1.12u as=0.2516p ps=2.16u w=0.74u l=0.13u
X813 VDD VSS.t749 VDD VDD sg13_lv_pmos ad=0.19p pd=1.38u as=0 ps=0 w=1u l=1u
X814 VSS.t1349 VDD VSS.t1350 VSS.t377 sg13_lv_nmos ad=79.8f pd=0.8u as=0 ps=0 w=0.42u l=1u
X815 VDD VSS.t1673 VDD VDD sg13_lv_pmos ad=0.34p pd=2.68u as=0 ps=0 w=1u l=1u
X816 a_18106_15202# sg13g2_dlygate4sd3_1_5.A VSS.t202 VSS.t284 sg13_lv_nmos ad=0.1428p pd=1.52u as=79.8f ps=0.8u w=0.42u l=0.13u
X817 VDD VSS.t760 VDD VDD sg13_lv_pmos ad=0.19p pd=1.38u as=0 ps=0 w=1u l=1u
X818 VSS.t40 sg13g2_buf_1_0.X a_2490_14447# VSS.t39 sg13_lv_nmos ad=0.374p pd=2.46u as=0.17462p ps=1.185u w=0.55u l=0.13u
X819 VDD VSS.t2610 VDD VDD sg13_lv_pmos ad=0.19p pd=1.38u as=0 ps=0 w=1u l=1u
X820 VDD VSS.t1087 VDD VDD sg13_lv_pmos ad=0.19p pd=1.38u as=0 ps=0 w=1u l=1u
X821 VDD VSS.t2862 VDD VDD sg13_lv_pmos ad=0.34p pd=2.68u as=0 ps=0 w=1u l=1u
X822 VSS.t1799 VDD VSS.t1801 VSS.t1800 sg13_lv_nmos ad=79.8f pd=0.8u as=0 ps=0 w=0.42u l=1u
X823 VSS.t2216 VDD VSS.t2218 VSS.t2217 sg13_lv_nmos ad=79.8f pd=0.8u as=0 ps=0 w=0.42u l=1u
X824 VSS.t970 VDD VSS.t972 VSS.t971 sg13_lv_nmos ad=79.8f pd=0.8u as=0 ps=0 w=0.42u l=1u
X825 VSS.t2890 VDD VSS.t2891 VSS.t412 sg13_lv_nmos ad=79.8f pd=0.8u as=0 ps=0 w=0.42u l=1u
X826 VSS.t3065 VDD VSS.t3067 VSS.t3066 sg13_lv_nmos ad=79.8f pd=0.8u as=0 ps=0 w=0.42u l=1u
X827 a_2916_15552# a_3435_15356# a_4175_15311# VSS.t334 sg13_lv_nmos ad=0.3473p pd=2.71u as=0.12665p ps=1.145u w=0.74u l=0.13u
X828 VSS.t2101 VDD VSS.t2103 VSS.t2102 sg13_lv_nmos ad=79.8f pd=0.8u as=0 ps=0 w=0.42u l=1u
X829 VDD a_22030_15423# sg13g2_or3_1_2.A VDD sg13_lv_pmos ad=0.2254p pd=1.53u as=0.4256p ps=3u w=1.12u l=0.13u
X830 VDD VSS.t2797 VDD VDD sg13_lv_pmos ad=0.19p pd=1.38u as=0 ps=0 w=1u l=1u
X831 VSS.t2473 VDD VSS.t2472 VSS.t2471 sg13_lv_nmos ad=0.1428p pd=1.52u as=0 ps=0 w=0.42u l=1u
X832 VDD VSS.t2058 VDD VDD sg13_lv_pmos ad=0.19p pd=1.38u as=0 ps=0 w=1u l=1u
X833 VDD VSS.t769 VDD VDD sg13_lv_pmos ad=0.19p pd=1.38u as=0 ps=0 w=1u l=1u
X834 VDD VSS.t3169 VDD VDD sg13_lv_pmos ad=0.34p pd=2.68u as=0 ps=0 w=1u l=1u
X835 VDD VSS.t2377 VDD VDD sg13_lv_pmos ad=0.34p pd=2.68u as=0 ps=0 w=1u l=1u
X836 VSS.t1729 VDD VSS.t1731 VSS.t1730 sg13_lv_nmos ad=79.8f pd=0.8u as=0 ps=0 w=0.42u l=1u
X837 VSS.t3255 VDD VSS.t3257 VSS.t3256 sg13_lv_nmos ad=79.8f pd=0.8u as=0 ps=0 w=0.42u l=1u
X838 VDD a_19438_13726# sg13g2_buf_16_2.X VDD sg13_lv_pmos ad=0.2128p pd=1.5u as=0.2128p ps=1.5u w=1.12u l=0.13u
X839 VDD VSS.t2405 VDD VDD sg13_lv_pmos ad=0.19p pd=1.38u as=0 ps=0 w=1u l=1u
X840 a_7532_15960# sg13g2_dlygate4sd3_1_1.A VDD VDD sg13_lv_pmos ad=0.2856p pd=2.36u as=0.2114p ps=1.54u w=0.84u l=0.13u
X841 a_4175_15311# a_3333_15213# a_2916_15552# VDD sg13_lv_pmos ad=0.2048p pd=1.63u as=0.34p ps=2.68u w=1u l=0.13u
X842 VSS.t302 VDD VSS.t302 VSS.t712 sg13_lv_nmos ad=79.8f pd=0.8u as=0 ps=0 w=0.42u l=1u
X843 VSS.t1331 VDD VSS.t1330 VSS.t377 sg13_lv_nmos ad=0.1428p pd=1.52u as=0 ps=0 w=0.42u l=1u
X844 VDD VSS.t1741 VDD VDD sg13_lv_pmos ad=0.19p pd=1.38u as=0 ps=0 w=1u l=1u
X845 a_26182_14909# sg13g2_dfrbpq_1_7.RESET_B VSS.t255 VSS.t421 sg13_lv_nmos ad=37.8f pd=0.6u as=0.1701p ps=1.65u w=0.42u l=0.13u
X846 VSS.t1629 VDD VSS.t1631 VSS.t1630 sg13_lv_nmos ad=79.8f pd=0.8u as=0 ps=0 w=0.42u l=1u
X847 VSS.t2538 VDD VSS.t2540 VSS.t2539 sg13_lv_nmos ad=79.8f pd=0.8u as=0 ps=0 w=0.42u l=1u
X848 VSS.t2011 VDD VSS.t2013 VSS.t2012 sg13_lv_nmos ad=79.8f pd=0.8u as=0 ps=0 w=0.42u l=1u
X849 VDD VSS.t1054 VDD VDD sg13_lv_pmos ad=0.34p pd=2.68u as=0 ps=0 w=1u l=1u
X850 VSS.t158 VDD VSS.t544 VSS.t543 sg13_lv_nmos ad=0.1428p pd=1.52u as=0 ps=0 w=0.42u l=1u
X851 VDD VSS.t1373 VDD VDD sg13_lv_pmos ad=0.19p pd=1.38u as=0 ps=0 w=1u l=1u
X852 VDD VSS.t2030 VDD VDD sg13_lv_pmos ad=0.34p pd=2.68u as=0 ps=0 w=1u l=1u
X853 VDD VSS.t2876 VDD VDD sg13_lv_pmos ad=0.19p pd=1.38u as=0 ps=0 w=1u l=1u
X854 VSS.t925 VDD VSS.t924 VSS.t923 sg13_lv_nmos ad=0.1428p pd=1.52u as=0 ps=0 w=0.42u l=1u
X855 VSS.t2821 VDD VSS.t2823 VSS.t412 sg13_lv_nmos ad=79.8f pd=0.8u as=0 ps=0 w=0.42u l=1u
X856 VDD VSS.t2854 VDD VDD sg13_lv_pmos ad=0.34p pd=2.68u as=0 ps=0 w=1u l=1u
X857 VSS.t2588 VDD VSS.t2587 VSS.t2586 sg13_lv_nmos ad=0.1428p pd=1.52u as=0 ps=0 w=0.42u l=1u
X858 a_17318_14922# a_18123_14495# a_17578_14452# VDD sg13_lv_pmos ad=0.1428p pd=1.52u as=79.8f ps=0.8u w=0.42u l=0.13u
X859 VSS.t609 VDD VSS.t610 VSS.t33 sg13_lv_nmos ad=79.8f pd=0.8u as=0 ps=0 w=0.42u l=1u
X860 VSS.t3052 VDD VSS.t3050 VSS.t3051 sg13_lv_nmos ad=79.8f pd=0.8u as=0 ps=0 w=0.42u l=1u
X861 VSS.t1160 VDD VSS.t1159 VSS.t1158 sg13_lv_nmos ad=0.1428p pd=1.52u as=0 ps=0 w=0.42u l=1u
X862 VSS.t1754 VDD VSS.t1753 VSS.t1752 sg13_lv_nmos ad=0.1428p pd=1.52u as=0 ps=0 w=0.42u l=1u
X863 VDD VSS.t1117 VDD VDD sg13_lv_pmos ad=0.19p pd=1.38u as=0 ps=0 w=1u l=1u
X864 VSS.t2866 VDD VSS.t2865 VSS.t412 sg13_lv_nmos ad=0.1428p pd=1.52u as=0 ps=0 w=0.42u l=1u
X865 VDD VSS.t2622 VDD VDD sg13_lv_pmos ad=0.34p pd=2.68u as=0 ps=0 w=1u l=1u
X866 VDD VSS.t2445 VDD VDD sg13_lv_pmos ad=0.19p pd=1.38u as=0 ps=0 w=1u l=1u
X867 VDD VSS.t700 VDD VDD sg13_lv_pmos ad=0.19p pd=1.38u as=0 ps=0 w=1u l=1u
X868 VDD VSS.t1721 VDD VDD sg13_lv_pmos ad=0.19p pd=1.38u as=0 ps=0 w=1u l=1u
X869 VDD VSS.t3189 VDD VDD sg13_lv_pmos ad=0.34p pd=2.68u as=0 ps=0 w=1u l=1u
X870 VDD VSS.t2397 VDD VDD sg13_lv_pmos ad=0.34p pd=2.68u as=0 ps=0 w=1u l=1u
X871 VSS.t695 VDD VSS.t695 VSS.t698 sg13_lv_nmos ad=0.1428p pd=1.52u as=0 ps=0 w=0.42u l=1u
X872 VDD VSS.t2570 VDD VDD sg13_lv_pmos ad=0.19p pd=1.38u as=0 ps=0 w=1u l=1u
X873 VSS.t2231 VDD VSS.t2230 VSS.t2229 sg13_lv_nmos ad=0.1428p pd=1.52u as=0 ps=0 w=0.42u l=1u
X874 VSS.t2051 VDD VSS.t2053 VSS.t2052 sg13_lv_nmos ad=79.8f pd=0.8u as=0 ps=0 w=0.42u l=1u
X875 VSS.t1308 VDD VSS.t1309 VSS.t377 sg13_lv_nmos ad=79.8f pd=0.8u as=0 ps=0 w=0.42u l=1u
X876 VDD VSS.t2228 VDD VDD sg13_lv_pmos ad=0.19p pd=1.38u as=0 ps=0 w=1u l=1u
X877 VSS.t1494 VDD VSS.t1344 VSS.t377 sg13_lv_nmos ad=0.1428p pd=1.52u as=0 ps=0 w=0.42u l=1u
X878 VDD VSS.t1726 VDD VDD sg13_lv_pmos ad=0.19p pd=1.38u as=0 ps=0 w=1u l=1u
X879 a_4175_15311# a_3333_15213# a_4081_15311# VSS.t337 sg13_lv_nmos ad=0.12665p pd=1.145u as=0.1428p ps=1.52u w=0.42u l=0.13u
X880 VDD VSS.t1436 VDD VDD sg13_lv_pmos ad=0.34p pd=2.68u as=0 ps=0 w=1u l=1u
X881 VDD VSS.t2003 VDD VDD sg13_lv_pmos ad=0.19p pd=1.38u as=0 ps=0 w=1u l=1u
X882 VDD VSS.t2785 VDD VDD sg13_lv_pmos ad=0.19p pd=1.38u as=0 ps=0 w=1u l=1u
X883 VDD VSS.t2840 VDD VDD sg13_lv_pmos ad=0.19p pd=1.38u as=0 ps=0 w=1u l=1u
X884 VSS.t2418 VDD VSS.t2417 VSS.t2416 sg13_lv_nmos ad=0.1428p pd=1.52u as=0 ps=0 w=0.42u l=1u
X885 VSS.t1684 VDD VSS.t1683 VSS.t1682 sg13_lv_nmos ad=0.1428p pd=1.52u as=0 ps=0 w=0.42u l=1u
X886 VSS.t3210 VDD VSS.t3209 VSS.t3208 sg13_lv_nmos ad=0.1428p pd=1.52u as=0 ps=0 w=0.42u l=1u
X887 VSS.t150 a_16556_15960# sg13g2_or3_1_2.B VSS.t149 sg13_lv_nmos ad=0.14875p pd=1.16u as=0.2886p ps=2.26u w=0.74u l=0.13u
X888 VSS.t734 VDD VSS.t734 VSS.t735 sg13_lv_nmos ad=79.8f pd=0.8u as=0 ps=0 w=0.42u l=1u
X889 VDD VSS.t2595 VDD VDD sg13_lv_pmos ad=0.19p pd=1.38u as=0 ps=0 w=1u l=1u
X890 VSS.t2458 VDD VSS.t2457 VSS.t2456 sg13_lv_nmos ad=0.1428p pd=1.52u as=0 ps=0 w=0.42u l=1u
X891 VSS.t82 a_7888_14726# a_7537_14845# VSS.t222 sg13_lv_nmos ad=79.8f pd=0.8u as=0.1428p ps=1.52u w=0.42u l=0.13u
X892 VSS.t1080 VDD VSS.t1079 VSS.t1078 sg13_lv_nmos ad=0.1428p pd=1.52u as=0 ps=0 w=0.42u l=1u
X893 VSS.t970 VDD VSS.t972 VSS.t971 sg13_lv_nmos ad=79.8f pd=0.8u as=0 ps=0 w=0.42u l=1u
X894 VDD VSS.t944 VDD VDD sg13_lv_pmos ad=0.34p pd=2.68u as=0 ps=0 w=1u l=1u
X895 VSS.t2813 VDD VSS.t2814 VSS.t412 sg13_lv_nmos ad=79.8f pd=0.8u as=0 ps=0 w=0.42u l=1u
X896 VSS.t591 VDD VSS.t590 VSS.t33 sg13_lv_nmos ad=0.1428p pd=1.52u as=0 ps=0 w=0.42u l=1u
X897 VSS.t2201 VDD VSS.t2203 VSS.t2202 sg13_lv_nmos ad=79.8f pd=0.8u as=0 ps=0 w=0.42u l=1u
X898 VSS.t2882 VDD VSS.t2882 VSS.t412 sg13_lv_nmos ad=79.8f pd=0.8u as=0 ps=0 w=0.42u l=1u
X899 VDD VSS.t547 VDD VDD sg13_lv_pmos ad=0.19p pd=1.38u as=0 ps=0 w=1u l=1u
X900 a_27826_13722# sg13g2_dfrbpq_1_5.RESET_B VSS.t76 VSS.t75 sg13_lv_nmos ad=37.8f pd=0.6u as=79.8f ps=0.8u w=0.42u l=0.13u
X901 VSS.t686 VDD VSS.t302 VSS.t688 sg13_lv_nmos ad=79.8f pd=0.8u as=0 ps=0 w=0.42u l=1u
X902 VDD VSS.t1400 VDD VDD sg13_lv_pmos ad=0.34p pd=2.68u as=0 ps=0 w=1u l=1u
X903 VDD VSS.t2882 VDD VDD sg13_lv_pmos ad=0.34p pd=2.68u as=0 ps=0 w=1u l=1u
X904 VDD VSS.t2220 VDD VDD sg13_lv_pmos ad=0.34p pd=2.68u as=0 ps=0 w=1u l=1u
X905 VDD VSS.t507 VDD VDD sg13_lv_pmos ad=0.19p pd=1.38u as=0 ps=0 w=1u l=1u
X906 VSS.t1290 VDD VSS.t1289 VSS.t377 sg13_lv_nmos ad=0.1428p pd=1.52u as=0 ps=0 w=0.42u l=1u
X907 VSS.t2071 VDD VSS.t2073 VSS.t2072 sg13_lv_nmos ad=79.8f pd=0.8u as=0 ps=0 w=0.42u l=1u
X908 VDD VSS.t1007 VDD VDD sg13_lv_pmos ad=0.19p pd=1.38u as=0 ps=0 w=1u l=1u
X909 VSS.t1095 VDD VSS.t1094 VSS.t1093 sg13_lv_nmos ad=0.1428p pd=1.52u as=0 ps=0 w=0.42u l=1u
X910 VSS.t1714 VDD VSS.t1716 VSS.t1715 sg13_lv_nmos ad=79.8f pd=0.8u as=0 ps=0 w=0.42u l=1u
X911 VSS.t3240 VDD VSS.t3242 VSS.t3241 sg13_lv_nmos ad=79.8f pd=0.8u as=0 ps=0 w=0.42u l=1u
X912 VDD VSS.t2390 VDD VDD sg13_lv_pmos ad=0.19p pd=1.38u as=0 ps=0 w=1u l=1u
X913 sg13g2_a21oi_1_3.A1 a_25206_15302# VSS.t143 VSS.t28 sg13_lv_nmos ad=0.2516p pd=2.16u as=0.1426p ps=1.16u w=0.74u l=0.13u
X914 VDD VSS.t2776 VDD VDD sg13_lv_pmos ad=0.19p pd=1.38u as=0 ps=0 w=1u l=1u
X915 VSS.t2106 VDD VSS.t2105 VSS.t2104 sg13_lv_nmos ad=0.1428p pd=1.52u as=0 ps=0 w=0.42u l=1u
X916 VSS.t3195 VDD VSS.t3194 VSS.t3193 sg13_lv_nmos ad=0.1428p pd=1.52u as=0 ps=0 w=0.42u l=1u
X917 VSS.t2403 VDD VSS.t2402 VSS.t2401 sg13_lv_nmos ad=0.1428p pd=1.52u as=0 ps=0 w=0.42u l=1u
X918 VSS.t1614 VDD VSS.t1616 VSS.t1615 sg13_lv_nmos ad=79.8f pd=0.8u as=0 ps=0 w=0.42u l=1u
X919 VDD VSS.t1678 VDD VDD sg13_lv_pmos ad=0.34p pd=2.68u as=0 ps=0 w=1u l=1u
X920 VSS.t2523 VDD VSS.t2525 VSS.t2524 sg13_lv_nmos ad=79.8f pd=0.8u as=0 ps=0 w=0.42u l=1u
X921 a_6729_14531# a_6372_14488# VDD VDD sg13_lv_pmos ad=63f pd=0.72u as=0.1563p ps=1.22u w=0.42u l=0.13u
X922 VDD VSS.t1733 VDD VDD sg13_lv_pmos ad=0.34p pd=2.68u as=0 ps=0 w=1u l=1u
X923 VSS.t33 a_27034_15202# a_26753_15424# VSS.t293 sg13_lv_nmos ad=79.8f pd=0.8u as=0.1428p ps=1.52u w=0.42u l=0.5u
X924 VSS.t925 VDD VSS.t924 VSS.t923 sg13_lv_nmos ad=0.1428p pd=1.52u as=0 ps=0 w=0.42u l=1u
X925 VDD VSS.t2580 VDD VDD sg13_lv_pmos ad=0.19p pd=1.38u as=0 ps=0 w=1u l=1u
X926 VSS.t2478 VDD VSS.t2477 VSS.t2476 sg13_lv_nmos ad=0.1428p pd=1.52u as=0 ps=0 w=0.42u l=1u
X927 VDD VSS.t1099 VDD VDD sg13_lv_pmos ad=0.34p pd=2.68u as=0 ps=0 w=1u l=1u
X928 VSS.t302 VDD VSS.t302 VSS.t707 sg13_lv_nmos ad=0.1428p pd=1.52u as=0 ps=0 w=0.42u l=1u
X929 VDD VSS.t1037 VDD VDD sg13_lv_pmos ad=0.19p pd=1.38u as=0 ps=0 w=1u l=1u
X930 VDD VSS.t1335 VDD VDD sg13_lv_pmos ad=0.19p pd=1.38u as=0 ps=0 w=1u l=1u
X931 VSS.t1804 VDD VSS.t1806 VSS.t1805 sg13_lv_nmos ad=79.8f pd=0.8u as=0 ps=0 w=0.42u l=1u
X932 VDD VSS.t2015 VDD VDD sg13_lv_pmos ad=0.34p pd=2.68u as=0 ps=0 w=1u l=1u
X933 VDD VSS.t2846 VDD VDD sg13_lv_pmos ad=0.34p pd=2.68u as=0 ps=0 w=1u l=1u
X934 VSS.t2186 VDD VSS.t2188 VSS.t2187 sg13_lv_nmos ad=79.8f pd=0.8u as=0 ps=0 w=0.42u l=1u
X935 VSS.t3035 VDD VSS.t3037 VSS.t3036 sg13_lv_nmos ad=79.8f pd=0.8u as=0 ps=0 w=0.42u l=1u
X936 a_37484_15960# sg13g2_dfrbpq_1_5.Q VSS.t214 VSS.t213 sg13_lv_nmos ad=0.187p pd=1.78u as=0.14875p ps=1.16u w=0.55u l=0.13u
X937 VDD VSS.t1419 VDD VDD sg13_lv_pmos ad=0.19p pd=1.38u as=0 ps=0 w=1u l=1u
X938 VDD VSS.t2607 VDD VDD sg13_lv_pmos ad=0.34p pd=2.68u as=0 ps=0 w=1u l=1u
X939 VDD a_26170_16237# sg13g2_dfrbpq_1_7.RESET_B VDD sg13_lv_pmos ad=2.8961p pd=18.25u as=0.3927p ps=2.99u w=1.155u l=0.13u
X940 VSS.t1382 VDD VSS.t1381 VSS.t377 sg13_lv_nmos ad=0.1428p pd=1.52u as=0 ps=0 w=0.42u l=1u
X941 VSS.t1304 VDD VSS.t1303 VSS.t377 sg13_lv_nmos ad=0.1428p pd=1.52u as=0 ps=0 w=0.42u l=1u
X942 VDD VSS.t2799 VDD VDD sg13_lv_pmos ad=0.19p pd=1.38u as=0 ps=0 w=1u l=1u
X943 VDD sg13g2_tiehi_1.L_HI a_9158_15234# VDD sg13_lv_pmos ad=0.36237p pd=2.605u as=79.8f ps=0.8u w=0.42u l=0.13u
X944 sg13g2_and2_1_0.X a_1965_14832# VSS.t186 VSS.t342 sg13_lv_nmos ad=0.2516p pd=2.16u as=0.1331p ps=1.12u w=0.74u l=0.13u
X945 VDD VSS.t974 VDD VDD sg13_lv_pmos ad=0.34p pd=2.68u as=0 ps=0 w=1u l=1u
X946 VDD VSS.t3174 VDD VDD sg13_lv_pmos ad=0.34p pd=2.68u as=0 ps=0 w=1u l=1u
X947 VSS.t2443 VDD VSS.t2442 VSS.t2441 sg13_lv_nmos ad=0.1428p pd=1.52u as=0 ps=0 w=0.42u l=1u
X948 VDD VSS.t2382 VDD VDD sg13_lv_pmos ad=0.34p pd=2.68u as=0 ps=0 w=1u l=1u
X949 VSS.t2216 VDD VSS.t2215 VSS.t2214 sg13_lv_nmos ad=0.1428p pd=1.52u as=0 ps=0 w=0.42u l=1u
X950 a_27898_15202# sg13g2_dfrbpq_1_5.Q VSS.t142 VSS.t33 sg13_lv_nmos ad=0.1428p pd=1.52u as=79.8f ps=0.8u w=0.42u l=0.13u
X951 VDD VSS.t2410 VDD VDD sg13_lv_pmos ad=0.19p pd=1.38u as=0 ps=0 w=1u l=1u
X952 a_17030_15238# a_16760_15238# VDD VDD sg13_lv_pmos ad=0.34p pd=2.68u as=0.1523p ps=1.38u w=1u l=0.5u
X953 a_26633_16334# a_26757_16033# VDD VDD sg13_lv_pmos ad=0.2442p pd=2.06u as=2.8961p ps=18.25u w=0.66u l=0.13u
X954 VSS.t1599 VDD VSS.t1601 VSS.t1600 sg13_lv_nmos ad=79.8f pd=0.8u as=0 ps=0 w=0.42u l=1u
X955 VSS.t2508 VDD VSS.t2510 VSS.t2509 sg13_lv_nmos ad=79.8f pd=0.8u as=0 ps=0 w=0.42u l=1u
X956 VSS.t2016 VDD VSS.t2018 VSS.t2017 sg13_lv_nmos ad=79.8f pd=0.8u as=0 ps=0 w=0.42u l=1u
X957 a_18863_14845# a_18021_14495# a_18769_14845# VSS.t25 sg13_lv_nmos ad=0.12665p pd=1.145u as=0.1428p ps=1.52u w=0.42u l=0.13u
X958 VSS.t1080 VDD VSS.t1079 VSS.t1078 sg13_lv_nmos ad=0.1428p pd=1.52u as=0 ps=0 w=0.42u l=1u
X959 VDD VSS.t2572 VDD VDD sg13_lv_pmos ad=0.34p pd=2.68u as=0 ps=0 w=1u l=1u
X960 VDD VSS.t2083 VDD VDD sg13_lv_pmos ad=0.19p pd=1.38u as=0 ps=0 w=1u l=1u
X961 a_3204_15247# a_2916_15552# a_3142_15247# VSS.t217 sg13_lv_nmos ad=0.1428p pd=1.52u as=37.8f ps=0.6u w=0.42u l=0.13u
X962 VDD VSS.t715 VDD VDD sg13_lv_pmos ad=0.34p pd=2.68u as=0 ps=0 w=1u l=1u
X963 VSS.t1125 VDD VSS.t1124 VSS.t1123 sg13_lv_nmos ad=0.1428p pd=1.52u as=0 ps=0 w=0.42u l=1u
X964 VSS.t1391 VDD VSS.t1390 VSS.t377 sg13_lv_nmos ad=0.1428p pd=1.52u as=0 ps=0 w=0.42u l=1u
X965 a_10960_15454# sg13g2_tiehi_1.L_HI VDD VDD sg13_lv_pmos ad=79.8f pd=0.8u as=2.8961p ps=18.25u w=0.42u l=0.13u
X966 VSS.t1966 VDD VSS.t1968 VSS.t1967 sg13_lv_nmos ad=79.8f pd=0.8u as=0 ps=0 w=0.42u l=1u
X967 VSS.t3055 VDD VSS.t3057 VSS.t3056 sg13_lv_nmos ad=79.8f pd=0.8u as=0 ps=0 w=0.42u l=1u
X968 sg13g2_nand4_1_0.Y sg13g2_dlygate4sd3_1_8.X a_7262_15242# VSS.t265 sg13_lv_nmos ad=0.2516p pd=2.16u as=0.1406p ps=1.12u w=0.74u l=0.13u
X969 VSS.t1759 VDD VSS.t1758 VSS.t1757 sg13_lv_nmos ad=0.1428p pd=1.52u as=0 ps=0 w=0.42u l=1u
X970 VDD VSS.t937 VDD VDD sg13_lv_pmos ad=0.19p pd=1.38u as=0 ps=0 w=1u l=1u
X971 VDD VSS.t2450 VDD VDD sg13_lv_pmos ad=0.19p pd=1.38u as=0 ps=0 w=1u l=1u
X972 VDD VSS.t737 VDD VDD sg13_lv_pmos ad=0.19p pd=1.38u as=0 ps=0 w=1u l=1u
X973 VSS.t1095 VDD VSS.t1094 VSS.t1093 sg13_lv_nmos ad=0.1428p pd=1.52u as=0 ps=0 w=0.42u l=1u
X974 VSS.t1425 VDD VSS.t1426 VSS.t377 sg13_lv_nmos ad=79.8f pd=0.8u as=0 ps=0 w=0.42u l=1u
X975 VDD VSS.t1392 VDD VDD sg13_lv_pmos ad=0.34p pd=2.68u as=0 ps=0 w=1u l=1u
X976 VDD VSS.t2367 VDD VDD sg13_lv_pmos ad=0.34p pd=2.68u as=0 ps=0 w=1u l=1u
X977 VDD VSS.t84 VDD VDD sg13_lv_pmos ad=0.19p pd=1.38u as=0 ps=0 w=1u l=1u
X978 VSS.t2236 VDD VSS.t2235 VSS.t2234 sg13_lv_nmos ad=0.1428p pd=1.52u as=0 ps=0 w=0.42u l=1u
X979 VSS.t2056 VDD VSS.t2058 VSS.t2057 sg13_lv_nmos ad=79.8f pd=0.8u as=0 ps=0 w=0.42u l=1u
X980 VDD VSS.t2233 VDD VDD sg13_lv_pmos ad=0.19p pd=1.38u as=0 ps=0 w=1u l=1u
X981 VDD VSS.t2767 VDD VDD sg13_lv_pmos ad=0.19p pd=1.38u as=0 ps=0 w=1u l=1u
X982 VDD VSS.t617 VDD VDD sg13_lv_pmos ad=0.34p pd=2.68u as=0 ps=0 w=1u l=1u
X983 VSS.t3180 VDD VSS.t3179 VSS.t3178 sg13_lv_nmos ad=0.1428p pd=1.52u as=0 ps=0 w=0.42u l=1u
X984 VSS.t2388 VDD VSS.t2387 VSS.t2386 sg13_lv_nmos ad=0.1428p pd=1.52u as=0 ps=0 w=0.42u l=1u
X985 VDD VSS.t1294 VDD VDD sg13_lv_pmos ad=0.19p pd=1.38u as=0 ps=0 w=1u l=1u
X986 VSS.t444 VDD VSS.t443 VSS.t442 sg13_lv_nmos ad=0.1428p pd=1.52u as=0 ps=0 w=0.42u l=1u
X987 VDD VSS.t1144 VDD VDD sg13_lv_pmos ad=0.34p pd=2.68u as=0 ps=0 w=1u l=1u
X988 VDD VSS.t1718 VDD VDD sg13_lv_pmos ad=0.34p pd=2.68u as=0 ps=0 w=1u l=1u
X989 VSS.t3095 VDD VSS.t3097 VSS.t3096 sg13_lv_nmos ad=79.8f pd=0.8u as=0 ps=0 w=0.42u l=1u
X990 VDD VSS.t2874 VDD VDD sg13_lv_pmos ad=0.19p pd=1.38u as=0 ps=0 w=1u l=1u
X991 VSS.t2463 VDD VSS.t2462 VSS.t2461 sg13_lv_nmos ad=0.1428p pd=1.52u as=0 ps=0 w=0.42u l=1u
X992 VSS.t2186 VDD VSS.t2185 VSS.t2184 sg13_lv_nmos ad=0.1428p pd=1.52u as=0 ps=0 w=0.42u l=1u
X993 VDD VSS.t2422 VDD VDD sg13_lv_pmos ad=0.34p pd=2.68u as=0 ps=0 w=1u l=1u
X994 VSS.t2816 VDD VSS.t2817 VSS.t412 sg13_lv_nmos ad=79.8f pd=0.8u as=0 ps=0 w=0.42u l=1u
X995 VDD VSS.t578 VDD VDD sg13_lv_pmos ad=0.34p pd=2.68u as=0 ps=0 w=1u l=1u
X996 VDD VSS.t758 VDD VDD sg13_lv_pmos ad=0.34p pd=2.68u as=0 ps=0 w=1u l=1u
X997 VSS.t1789 VDD VSS.t1791 VSS.t1790 sg13_lv_nmos ad=79.8f pd=0.8u as=0 ps=0 w=0.42u l=1u
X998 VDD VSS.t3162 VDD VDD sg13_lv_pmos ad=0.19p pd=1.38u as=0 ps=0 w=1u l=1u
X999 VSS.t2884 VDD VSS.t2885 VSS.t412 sg13_lv_nmos ad=79.8f pd=0.8u as=0 ps=0 w=0.42u l=1u
X1000 VDD VSS.t2028 VDD VDD sg13_lv_pmos ad=0.19p pd=1.38u as=0 ps=0 w=1u l=1u
X1001 VSS.t2031 VDD VSS.t2030 VSS.t2029 sg13_lv_nmos ad=0.1428p pd=1.52u as=0 ps=0 w=0.42u l=1u
X1002 VSS.t33 a_3333_15213# a_3435_15356# VSS.t336 sg13_lv_nmos ad=5.4375p pd=36.05u as=0.2516p ps=2.16u w=0.74u l=0.13u
X1003 VDD VSS.t407 VDD VDD sg13_lv_pmos ad=0.34p pd=2.68u as=0 ps=0 w=1u l=1u
X1004 VDD VSS.t904 VDD VDD sg13_lv_pmos ad=0.34p pd=2.68u as=0 ps=0 w=1u l=1u
X1005 VSS.t1744 VDD VSS.t1743 VSS.t1742 sg13_lv_nmos ad=0.1428p pd=1.52u as=0 ps=0 w=0.42u l=1u
X1006 VSS.t1408 VDD VSS.t1407 VSS.t377 sg13_lv_nmos ad=0.1428p pd=1.52u as=0 ps=0 w=0.42u l=1u
X1007 VSS.t1568 VDD VSS.t1440 VSS.t377 sg13_lv_nmos ad=79.8f pd=0.8u as=0 ps=0 w=0.42u l=1u
X1008 VDD VSS.t1383 VDD VDD sg13_lv_pmos ad=0.34p pd=2.68u as=0 ps=0 w=1u l=1u
X1009 VDD VSS.t2885 VDD VDD sg13_lv_pmos ad=0.34p pd=2.68u as=0 ps=0 w=1u l=1u
X1010 VDD VSS.t2190 VDD VDD sg13_lv_pmos ad=0.34p pd=2.68u as=0 ps=0 w=1u l=1u
X1011 VSS.t50 VDD VSS.t50 VSS.t638 sg13_lv_nmos ad=0.1428p pd=1.52u as=0 ps=0 w=0.42u l=1u
X1012 VSS.t1719 VDD VSS.t1721 VSS.t1720 sg13_lv_nmos ad=79.8f pd=0.8u as=0 ps=0 w=0.42u l=1u
X1013 VDD VSS.t2395 VDD VDD sg13_lv_pmos ad=0.19p pd=1.38u as=0 ps=0 w=1u l=1u
X1014 VDD VSS.t957 VDD VDD sg13_lv_pmos ad=0.19p pd=1.38u as=0 ps=0 w=1u l=1u
X1015 VSS.t1361 VDD VSS.t1362 VSS.t377 sg13_lv_nmos ad=79.8f pd=0.8u as=0 ps=0 w=0.42u l=1u
X1016 a_2890_15457# a_3333_15213# a_3273_15625# VDD sg13_lv_pmos ad=79.8f pd=0.8u as=63f ps=0.72u w=0.42u l=0.13u
X1017 VDD VSS.t763 VDD VDD sg13_lv_pmos ad=0.19p pd=1.38u as=0 ps=0 w=1u l=1u
X1018 VSS.t1125 VDD VSS.t1124 VSS.t1123 sg13_lv_nmos ad=0.1428p pd=1.52u as=0 ps=0 w=0.42u l=1u
X1019 VDD VSS.t1386 VDD VDD sg13_lv_pmos ad=0.19p pd=1.38u as=0 ps=0 w=1u l=1u
X1020 VSS.t1584 VDD VSS.t1586 VSS.t1585 sg13_lv_nmos ad=79.8f pd=0.8u as=0 ps=0 w=0.42u l=1u
X1021 VDD VSS.t1683 VDD VDD sg13_lv_pmos ad=0.34p pd=2.68u as=0 ps=0 w=1u l=1u
X1022 VSS.t2001 VDD VSS.t2003 VSS.t2002 sg13_lv_nmos ad=79.8f pd=0.8u as=0 ps=0 w=0.42u l=1u
X1023 VDD VSS.t1738 VDD VDD sg13_lv_pmos ad=0.34p pd=2.68u as=0 ps=0 w=1u l=1u
X1024 VSS.t1287 VDD VSS.t1288 VSS.t377 sg13_lv_nmos ad=79.8f pd=0.8u as=0 ps=0 w=0.42u l=1u
X1025 VDD VSS.t2020 VDD VDD sg13_lv_pmos ad=0.34p pd=2.68u as=0 ps=0 w=1u l=1u
X1026 VDD VSS.t2849 VDD VDD sg13_lv_pmos ad=0.34p pd=2.68u as=0 ps=0 w=1u l=1u
X1027 sg13g2_dfrbpq_1_2.CLK a_12020_15202# VDD VDD sg13_lv_pmos ad=0.2128p pd=1.5u as=0.2128p ps=1.5u w=1.12u l=0.13u
X1028 VDD VSS.t460 VDD VDD sg13_lv_pmos ad=0.19p pd=1.38u as=0 ps=0 w=1u l=1u
X1029 VSS.t475 VDD VSS.t475 VSS.t477 sg13_lv_nmos ad=0.1428p pd=1.52u as=0 ps=0 w=0.42u l=1u
X1030 VSS.t3040 VDD VSS.t3042 VSS.t3041 sg13_lv_nmos ad=79.8f pd=0.8u as=0 ps=0 w=0.42u l=1u
X1031 VSS.t1554 VDD VSS.t1420 VSS.t377 sg13_lv_nmos ad=0.1428p pd=1.52u as=0 ps=0 w=0.42u l=1u
X1032 VSS.t2860 VDD VSS.t2860 VSS.t412 sg13_lv_nmos ad=0.1428p pd=1.52u as=0 ps=0 w=0.42u l=1u
X1033 VDD VSS.t2612 VDD VDD sg13_lv_pmos ad=0.34p pd=2.68u as=0 ps=0 w=1u l=1u
X1034 VSS.t766 VDD VSS.t766 VSS.t884 sg13_lv_nmos ad=0.1428p pd=1.52u as=0 ps=0 w=0.42u l=1u
X1035 VDD VSS.t2033 VDD VDD sg13_lv_pmos ad=0.19p pd=1.38u as=0 ps=0 w=1u l=1u
X1036 VDD VSS.t2802 VDD VDD sg13_lv_pmos ad=0.19p pd=1.38u as=0 ps=0 w=1u l=1u
X1037 VSS.t2448 VDD VSS.t2447 VSS.t2446 sg13_lv_nmos ad=0.1428p pd=1.52u as=0 ps=0 w=0.42u l=1u
X1038 VSS.t816 VDD VSS.t369 VSS.t817 sg13_lv_nmos ad=79.8f pd=0.8u as=0 ps=0 w=0.42u l=1u
X1039 VSS.t2221 VDD VSS.t2220 VSS.t2219 sg13_lv_nmos ad=0.1428p pd=1.52u as=0 ps=0 w=0.42u l=1u
X1040 VDD VSS.t740 VDD VDD sg13_lv_pmos ad=0.34p pd=2.68u as=0 ps=0 w=1u l=1u
X1041 VDD VSS.t909 VDD VDD sg13_lv_pmos ad=0.34p pd=2.68u as=0 ps=0 w=1u l=1u
X1042 VSS.t1343 VDD VSS.t1342 VSS.t377 sg13_lv_nmos ad=0.1428p pd=1.52u as=0 ps=0 w=0.42u l=1u
X1043 a_3333_16033# a_3333_16033# VSS.t3 VSS.t129 sg13_lv_nmos ad=0.111p pd=1.34u as=5.24677p ps=34.365u w=0.3u l=0.13u
X1044 VSS.t465 VDD VSS.t465 VSS.t467 sg13_lv_nmos ad=0.1428p pd=1.52u as=0 ps=0 w=0.42u l=1u
X1045 VSS.t33 a_6789_14495# a_6891_14495# VSS.t112 sg13_lv_nmos ad=5.4375p pd=36.05u as=0.2516p ps=2.16u w=0.74u l=0.13u
X1046 VSS.t22 a_10222_14751# sg13g2_dlygate4sd3_1_8.X VSS.t224 sg13_lv_nmos ad=0.1426p pd=1.16u as=0.2516p ps=2.16u w=0.74u l=0.13u
X1047 VSS.t302 VDD VSS.t302 VSS.t706 sg13_lv_nmos ad=79.8f pd=0.8u as=0 ps=0 w=0.42u l=1u
X1048 VDD VSS.t1716 VDD VDD sg13_lv_pmos ad=0.19p pd=1.38u as=0 ps=0 w=1u l=1u
X1049 VDD a_21070_15423# sg13g2_dlygate4sd3_1_11.X VDD sg13_lv_pmos ad=0.2254p pd=1.53u as=0.4256p ps=3u w=1.12u l=0.13u
X1050 VSS.t715 VDD VSS.t715 VSS.t717 sg13_lv_nmos ad=0.1428p pd=1.52u as=0 ps=0 w=0.42u l=1u
X1051 VDD VSS.t1074 VDD VDD sg13_lv_pmos ad=0.34p pd=2.68u as=0 ps=0 w=1u l=1u
X1052 VSS.t1604 VDD VSS.t1606 VSS.t1605 sg13_lv_nmos ad=79.8f pd=0.8u as=0 ps=0 w=0.42u l=1u
X1053 VSS.t2513 VDD VSS.t2515 VSS.t2514 sg13_lv_nmos ad=79.8f pd=0.8u as=0 ps=0 w=0.42u l=1u
X1054 VDD VSS.t2088 VDD VDD sg13_lv_pmos ad=0.19p pd=1.38u as=0 ps=0 w=1u l=1u
X1055 VDD VSS.t544 VDD VDD sg13_lv_pmos ad=0.34p pd=2.68u as=0 ps=0 w=1u l=1u
X1056 VSS.t945 VDD VSS.t944 VSS.t943 sg13_lv_nmos ad=0.1428p pd=1.52u as=0 ps=0 w=0.42u l=1u
X1057 VDD VSS.t1302 VDD VDD sg13_lv_pmos ad=0.19p pd=1.38u as=0 ps=0 w=1u l=1u
X1058 VSS.t1300 VDD VSS.t1302 VSS.t377 sg13_lv_nmos ad=79.8f pd=0.8u as=0 ps=0 w=0.42u l=1u
X1059 VSS.t1734 VDD VSS.t1733 VSS.t1732 sg13_lv_nmos ad=0.1428p pd=1.52u as=0 ps=0 w=0.42u l=1u
X1060 VSS.t3260 VDD VSS.t3259 VSS.t3258 sg13_lv_nmos ad=0.1428p pd=1.52u as=0 ps=0 w=0.42u l=1u
X1061 VDD VSS.t2407 VDD VDD sg13_lv_pmos ad=0.34p pd=2.68u as=0 ps=0 w=1u l=1u
X1062 VSS.t2808 VDD VSS.t2809 VSS.t412 sg13_lv_nmos ad=79.8f pd=0.8u as=0 ps=0 w=0.42u l=1u
X1063 a_9418_15457# a_9861_15213# a_9158_15234# VSS.t4 sg13_lv_nmos ad=79.8f pd=0.8u as=0.1296p ps=1.52u w=0.42u l=0.13u
X1064 sg13g2_dfrbpq_1_2.CLK a_12020_15202# VDD VDD sg13_lv_pmos ad=0.2128p pd=1.5u as=0.2128p ps=1.5u w=1.12u l=0.13u
X1065 VDD VSS.t1137 VDD VDD sg13_lv_pmos ad=0.19p pd=1.38u as=0 ps=0 w=1u l=1u
X1066 VSS.t2016 VDD VSS.t2015 VSS.t2014 sg13_lv_nmos ad=0.1428p pd=1.52u as=0 ps=0 w=0.42u l=1u
X1067 a_18501_16033# a_18501_16033# VSS.t3 VSS.t326 sg13_lv_nmos ad=0.111p pd=1.34u as=5.24677p ps=34.365u w=0.3u l=0.13u
X1068 VSS.t737 VDD VSS.t737 VSS.t738 sg13_lv_nmos ad=79.8f pd=0.8u as=0 ps=0 w=0.42u l=1u
X1069 VDD VSS.t517 VDD VDD sg13_lv_pmos ad=0.19p pd=1.38u as=0 ps=0 w=1u l=1u
X1070 VSS.t1729 VDD VSS.t1728 VSS.t1727 sg13_lv_nmos ad=0.1428p pd=1.52u as=0 ps=0 w=0.42u l=1u
X1071 VSS.t302 VDD VSS.t302 VSS.t707 sg13_lv_nmos ad=0.1428p pd=1.52u as=0 ps=0 w=0.42u l=1u
X1072 VDD VSS.t2372 VDD VDD sg13_lv_pmos ad=0.34p pd=2.68u as=0 ps=0 w=1u l=1u
X1073 VDD a_3333_15213# a_3435_15356# VDD sg13_lv_pmos ad=2.8961p pd=18.25u as=0.3864p ps=2.93u w=1.12u l=0.13u
X1074 VDD VSS.t1064 VDD VDD sg13_lv_pmos ad=0.34p pd=2.68u as=0 ps=0 w=1u l=1u
X1075 VSS.t1503 VDD VSS.t1356 VSS.t377 sg13_lv_nmos ad=0.1428p pd=1.52u as=0 ps=0 w=0.42u l=1u
X1076 VSS.t1644 VDD VSS.t1646 VSS.t1645 sg13_lv_nmos ad=79.8f pd=0.8u as=0 ps=0 w=0.42u l=1u
X1077 VDD VSS.t3164 VDD VDD sg13_lv_pmos ad=0.34p pd=2.68u as=0 ps=0 w=1u l=1u
X1078 VDD sg13g2_dfrbpq_1_2.RESET_B a_16042_13945# VDD sg13_lv_pmos ad=0.1563p pd=1.22u as=0.147p ps=1.54u w=0.42u l=0.13u
X1079 VSS.t2807 VDD VSS.t2808 VSS.t412 sg13_lv_nmos ad=79.8f pd=0.8u as=0 ps=0 w=0.42u l=1u
X1080 VDD VSS.t2774 VDD VDD sg13_lv_pmos ad=0.19p pd=1.38u as=0 ps=0 w=1u l=1u
X1081 VDD VSS.t2545 VDD VDD sg13_lv_pmos ad=0.19p pd=1.38u as=0 ps=0 w=1u l=1u
X1082 VDD VSS.t12 VDD VDD sg13_lv_pmos ad=0.19p pd=1.38u as=0 ps=0 w=1u l=1u
X1083 sg13g2_buf_16_2.X a_19438_13726# VSS.t398 VSS.t399 sg13_lv_nmos ad=0.1406p pd=1.12u as=0.1406p ps=1.12u w=0.74u l=0.13u
X1084 VDD VSS.t2080 VDD VDD sg13_lv_pmos ad=0.34p pd=2.68u as=0 ps=0 w=1u l=1u
X1085 VSS.t401 VDD VSS.t27 VSS.t833 sg13_lv_nmos ad=79.8f pd=0.8u as=0 ps=0 w=0.42u l=1u
X1086 VSS.t1100 VDD VSS.t1099 VSS.t1098 sg13_lv_nmos ad=0.1428p pd=1.52u as=0 ps=0 w=0.42u l=1u
X1087 VDD VSS.t1668 VDD VDD sg13_lv_pmos ad=0.34p pd=2.68u as=0 ps=0 w=1u l=1u
X1088 sg13g2_buf_16_2.A a_15022_14484# VSS.t16 VSS.t226 sg13_lv_nmos ad=0.1406p pd=1.12u as=0.1406p ps=1.12u w=0.74u l=0.13u
X1089 VSS.t1283 VDD VSS.t1282 VSS.t377 sg13_lv_nmos ad=0.1428p pd=1.52u as=0 ps=0 w=0.42u l=1u
X1090 VSS.t1393 VDD VSS.t1394 VSS.t377 sg13_lv_nmos ad=79.8f pd=0.8u as=0 ps=0 w=0.42u l=1u
X1091 VDD VSS.t1723 VDD VDD sg13_lv_pmos ad=0.34p pd=2.68u as=0 ps=0 w=1u l=1u
X1092 VSS.t3100 VDD VSS.t3102 VSS.t3101 sg13_lv_nmos ad=79.8f pd=0.8u as=0 ps=0 w=0.42u l=1u
X1093 VSS.t2468 VDD VSS.t2467 VSS.t2466 sg13_lv_nmos ad=0.1428p pd=1.52u as=0 ps=0 w=0.42u l=1u
X1094 VSS.t603 VDD VSS.t602 VSS.t33 sg13_lv_nmos ad=0.1428p pd=1.52u as=0 ps=0 w=0.42u l=1u
X1095 VSS.t1035 VDD VSS.t1037 VSS.t1036 sg13_lv_nmos ad=79.8f pd=0.8u as=0 ps=0 w=0.42u l=1u
X1096 VSS.t2819 VDD VSS.t2820 VSS.t412 sg13_lv_nmos ad=79.8f pd=0.8u as=0 ps=0 w=0.42u l=1u
X1097 VDD VSS.t1104 VDD VDD sg13_lv_pmos ad=0.34p pd=2.68u as=0 ps=0 w=1u l=1u
X1098 VDD VSS.t2786 VDD VDD sg13_lv_pmos ad=0.34p pd=2.68u as=0 ps=0 w=1u l=1u
X1099 VSS.t2887 VDD VSS.t2888 VSS.t412 sg13_lv_nmos ad=79.8f pd=0.8u as=0 ps=0 w=0.42u l=1u
X1100 VSS.t100 VDD VSS.t100 VSS.t789 sg13_lv_nmos ad=79.8f pd=0.8u as=0 ps=0 w=0.42u l=1u
X1101 VDD VSS.t1338 VDD VDD sg13_lv_pmos ad=0.19p pd=1.38u as=0 ps=0 w=1u l=1u
X1102 VSS.t302 VDD VSS.t302 VSS.t681 sg13_lv_nmos ad=79.8f pd=0.8u as=0 ps=0 w=0.42u l=1u
X1103 VDD VSS.t1027 VDD VDD sg13_lv_pmos ad=0.19p pd=1.38u as=0 ps=0 w=1u l=1u
X1104 VDD VSS.t1386 VDD VDD sg13_lv_pmos ad=0.34p pd=2.68u as=0 ps=0 w=1u l=1u
X1105 VDD VSS.t2794 VDD VDD sg13_lv_pmos ad=0.19p pd=1.38u as=0 ps=0 w=1u l=1u
X1106 VDD VSS.t3012 VDD VDD sg13_lv_pmos ad=0.34p pd=2.68u as=0 ps=0 w=1u l=1u
X1107 VDD VSS.t2195 VDD VDD sg13_lv_pmos ad=0.34p pd=2.68u as=0 ps=0 w=1u l=1u
X1108 VDD a_12524_15960# counter_value_o[2] VDD sg13_lv_pmos ad=0.2114p pd=1.54u as=0.42p ps=2.99u w=1.12u l=0.13u
X1109 VSS.t715 VDD VSS.t720 VSS.t839 sg13_lv_nmos ad=79.8f pd=0.8u as=0 ps=0 w=0.42u l=1u
X1110 VSS.t2433 VDD VSS.t2432 VSS.t2431 sg13_lv_nmos ad=0.1428p pd=1.52u as=0 ps=0 w=0.42u l=1u
X1111 VSS.t2046 VDD VSS.t2048 VSS.t2047 sg13_lv_nmos ad=79.8f pd=0.8u as=0 ps=0 w=0.42u l=1u
X1112 VDD sg13g2_buf_16_2.A a_19438_13726# VDD sg13_lv_pmos ad=0.2128p pd=1.5u as=0.2128p ps=1.5u w=1.12u l=0.13u
X1113 VSS.t1370 VDD VSS.t1369 VSS.t377 sg13_lv_nmos ad=0.1428p pd=1.52u as=0 ps=0 w=0.42u l=1u
X1114 VSS.t1986 VDD VSS.t1985 VSS.t1984 sg13_lv_nmos ad=0.1428p pd=1.52u as=0 ps=0 w=0.42u l=1u
X1115 VSS.t439 VDD VSS.t441 VSS.t440 sg13_lv_nmos ad=79.8f pd=0.8u as=0 ps=0 w=0.42u l=1u
X1116 sg13g2_o21ai_1_2.A2 sg13g2_dfrbpq_1_2.Q VDD VDD sg13_lv_pmos ad=0.2128p pd=1.5u as=0.3808p ps=2.92u w=1.12u l=0.13u
X1117 VSS.t95 a_4474_14448# a_4193_14750# VSS.t343 sg13_lv_nmos ad=79.8f pd=0.8u as=0.1428p ps=1.52u w=0.42u l=0.5u
X1118 VDD VSS.t2765 VDD VDD sg13_lv_pmos ad=0.19p pd=1.38u as=0 ps=0 w=1u l=1u
X1119 a_24263_14508# sg13g2_o21ai_1_2.A2 a_24169_14508# VDD sg13_lv_pmos ad=0.19p pd=1.38u as=0.34p ps=2.68u w=1u l=0.13u
X1120 a_21060_14488# a_21034_14452# VDD VDD sg13_lv_pmos ad=0.34p pd=2.68u as=0.36237p ps=2.605u w=1u l=0.13u
X1121 a_17057_13320# sg13g2_a21oi_1_0.A1 sg13g2_a21oi_1_0.Y VSS.t64 sg13_lv_nmos ad=0.1406p pd=1.12u as=0.1406p ps=1.12u w=0.74u l=0.13u
X1122 VSS.t1589 VDD VSS.t1591 VSS.t1590 sg13_lv_nmos ad=79.8f pd=0.8u as=0 ps=0 w=0.42u l=1u
X1123 VSS.t2498 VDD VSS.t2500 VSS.t2499 sg13_lv_nmos ad=79.8f pd=0.8u as=0 ps=0 w=0.42u l=1u
X1124 VSS.t24 a_17710_15423# sg13g2_a21oi_1_0.A1 VSS.t420 sg13_lv_nmos ad=0.1426p pd=1.16u as=0.2516p ps=2.16u w=0.74u l=0.13u
X1125 sg13g2_buf_16_2.X a_19438_13726# VSS.t393 VSS.t394 sg13_lv_nmos ad=0.1406p pd=1.12u as=0.1406p ps=1.12u w=0.74u l=0.13u
X1126 VDD VSS.t902 VDD VDD sg13_lv_pmos ad=0.19p pd=1.38u as=0 ps=0 w=1u l=1u
X1127 VSS.t945 VDD VSS.t944 VSS.t943 sg13_lv_nmos ad=0.1428p pd=1.52u as=0 ps=0 w=0.42u l=1u
X1128 VSS.t1375 VDD VSS.t1374 VSS.t377 sg13_lv_nmos ad=0.1428p pd=1.52u as=0 ps=0 w=0.42u l=1u
X1129 VSS.t2776 VDD VSS.t2777 VSS.t412 sg13_lv_nmos ad=79.8f pd=0.8u as=0 ps=0 w=0.42u l=1u
X1130 VDD VSS.t1347 VDD VDD sg13_lv_pmos ad=0.19p pd=1.38u as=0 ps=0 w=1u l=1u
X1131 VDD VSS.t3027 VDD VDD sg13_lv_pmos ad=0.19p pd=1.38u as=0 ps=0 w=1u l=1u
X1132 VDD VSS.t2073 VDD VDD sg13_lv_pmos ad=0.19p pd=1.38u as=0 ps=0 w=1u l=1u
X1133 VDD VSS.t2025 VDD VDD sg13_lv_pmos ad=0.34p pd=2.68u as=0 ps=0 w=1u l=1u
X1134 VSS.t3019 VDD VSS.t2897 VSS.t412 sg13_lv_nmos ad=0.1428p pd=1.52u as=0 ps=0 w=0.42u l=1u
X1135 VDD VSS.t2777 VDD VDD sg13_lv_pmos ad=0.34p pd=2.68u as=0 ps=0 w=1u l=1u
X1136 VDD VSS.t2852 VDD VDD sg13_lv_pmos ad=0.34p pd=2.68u as=0 ps=0 w=1u l=1u
X1137 VSS.t50 VDD VSS.t50 VSS.t637 sg13_lv_nmos ad=79.8f pd=0.8u as=0 ps=0 w=0.42u l=1u
X1138 VDD VSS.t1310 VDD VDD sg13_lv_pmos ad=0.34p pd=2.68u as=0 ps=0 w=1u l=1u
X1139 sg13g2_buf_1_10.X a_1192_9948# VSS.t378 VSS.t377 sg13_lv_nmos ad=0.2886p pd=2.26u as=0.14875p ps=1.16u w=0.74u l=0.13u
X1140 VSS.t3045 VDD VSS.t3047 VSS.t3046 sg13_lv_nmos ad=79.8f pd=0.8u as=0 ps=0 w=0.42u l=1u
X1141 VSS.t1316 VDD VSS.t1315 VSS.t377 sg13_lv_nmos ad=0.1428p pd=1.52u as=0 ps=0 w=0.42u l=1u
X1142 sg13g2_dfrbpq_1_5.Q a_28074_14020# VSS.t407 VSS.t406 sg13_lv_nmos ad=0.2516p pd=2.16u as=0.1406p ps=1.12u w=0.74u l=0.13u
X1143 VDD VSS.t994 VDD VDD sg13_lv_pmos ad=0.34p pd=2.68u as=0 ps=0 w=1u l=1u
X1144 VDD VSS.t2804 VDD VDD sg13_lv_pmos ad=0.19p pd=1.38u as=0 ps=0 w=1u l=1u
X1145 VDD VSS.t2582 VDD VDD sg13_lv_pmos ad=0.34p pd=2.68u as=0 ps=0 w=1u l=1u
X1146 VDD VSS.t1109 VDD VDD sg13_lv_pmos ad=0.34p pd=2.68u as=0 ps=0 w=1u l=1u
X1147 VSS.t2959 VDD VSS.t2826 VSS.t412 sg13_lv_nmos ad=0.1428p pd=1.52u as=0 ps=0 w=0.42u l=1u
X1148 VSS.t2453 VDD VSS.t2452 VSS.t2451 sg13_lv_nmos ad=0.1428p pd=1.52u as=0 ps=0 w=0.42u l=1u
X1149 VSS.t1809 VDD VSS.t1808 VSS.t1807 sg13_lv_nmos ad=0.1428p pd=1.52u as=0 ps=0 w=0.42u l=1u
X1150 VDD VSS.t2357 VDD VDD sg13_lv_pmos ad=0.34p pd=2.68u as=0 ps=0 w=1u l=1u
X1151 VDD VSS.t1711 VDD VDD sg13_lv_pmos ad=0.19p pd=1.38u as=0 ps=0 w=1u l=1u
X1152 VSS.t2896 VDD VSS.t2895 VSS.t412 sg13_lv_nmos ad=0.1428p pd=1.52u as=0 ps=0 w=0.42u l=1u
X1153 VSS.t2799 VDD VSS.t2800 VSS.t412 sg13_lv_nmos ad=79.8f pd=0.8u as=0 ps=0 w=0.42u l=1u
X1154 VSS.t2191 VDD VSS.t2190 VSS.t2189 sg13_lv_nmos ad=0.1428p pd=1.52u as=0 ps=0 w=0.42u l=1u
X1155 VDD a_7680_15549# sg13g2_xnor2_1_0.Y VDD sg13_lv_pmos ad=0.3808p pd=2.92u as=0.2408p ps=1.55u w=1.12u l=0.13u
X1156 VSS.t16 VDD VSS.t16 VSS.t572 sg13_lv_nmos ad=0.1428p pd=1.52u as=0 ps=0 w=0.42u l=1u
X1157 VDD sg13g2_buf_16_2.A a_19438_13726# VDD sg13_lv_pmos ad=0.2128p pd=1.5u as=0.2128p ps=1.5u w=1.12u l=0.13u
X1158 VDD VSS.t1721 VDD VDD sg13_lv_pmos ad=0.19p pd=1.38u as=0 ps=0 w=1u l=1u
X1159 VSS.t3 a_3209_16334# a_3130_16237# VSS.t305 sg13_lv_nmos ad=5.24677p pd=34.365u as=0.27427p ps=2.28u w=0.795u l=0.13u
X1160 VSS.t1100 VDD VSS.t1099 VSS.t1098 sg13_lv_nmos ad=0.1428p pd=1.52u as=0 ps=0 w=0.42u l=1u
X1161 VSS.t1145 VDD VSS.t1144 VSS.t1143 sg13_lv_nmos ad=0.1428p pd=1.52u as=0 ps=0 w=0.42u l=1u
X1162 VSS.t1035 VDD VSS.t1037 VSS.t1036 sg13_lv_nmos ad=79.8f pd=0.8u as=0 ps=0 w=0.42u l=1u
X1163 VDD VSS.t1327 VDD VDD sg13_lv_pmos ad=0.34p pd=2.68u as=0 ps=0 w=1u l=1u
X1164 VSS.t1551 VDD VSS.t1419 VSS.t377 sg13_lv_nmos ad=79.8f pd=0.8u as=0 ps=0 w=0.42u l=1u
X1165 VDD VSS.t2093 VDD VDD sg13_lv_pmos ad=0.19p pd=1.38u as=0 ps=0 w=1u l=1u
X1166 VDD VSS.t1305 VDD VDD sg13_lv_pmos ad=0.19p pd=1.38u as=0 ps=0 w=1u l=1u
X1167 VDD VSS.t2869 VDD VDD sg13_lv_pmos ad=0.19p pd=1.38u as=0 ps=0 w=1u l=1u
X1168 a_27215_14845# a_26373_14495# a_27121_14845# VSS.t33 sg13_lv_nmos ad=0.12665p pd=1.145u as=0.1428p ps=1.52u w=0.42u l=0.13u
X1169 VSS.t1739 VDD VSS.t1738 VSS.t1737 sg13_lv_nmos ad=0.1428p pd=1.52u as=0 ps=0 w=0.42u l=1u
X1170 VSS.t3265 VDD VSS.t3264 VSS.t3263 sg13_lv_nmos ad=0.1428p pd=1.52u as=0 ps=0 w=0.42u l=1u
X1171 VDD VSS.t2412 VDD VDD sg13_lv_pmos ad=0.34p pd=2.68u as=0 ps=0 w=1u l=1u
X1172 VSS.t2811 VDD VSS.t2812 VSS.t412 sg13_lv_nmos ad=79.8f pd=0.8u as=0 ps=0 w=0.42u l=1u
X1173 VDD VSS.t740 VDD VDD sg13_lv_pmos ad=0.19p pd=1.38u as=0 ps=0 w=1u l=1u
X1174 VDD VSS.t1149 VDD VDD sg13_lv_pmos ad=0.34p pd=2.68u as=0 ps=0 w=1u l=1u
X1175 VSS.t2879 VDD VSS.t2880 VSS.t412 sg13_lv_nmos ad=79.8f pd=0.8u as=0 ps=0 w=0.42u l=1u
X1176 VSS.t2021 VDD VSS.t2020 VSS.t2019 sg13_lv_nmos ad=0.1428p pd=1.52u as=0 ps=0 w=0.42u l=1u
X1177 VSS.t3030 VDD VSS.t3032 VSS.t3031 sg13_lv_nmos ad=79.8f pd=0.8u as=0 ps=0 w=0.42u l=1u
X1178 VDD VSS.t1365 VDD VDD sg13_lv_pmos ad=0.19p pd=1.38u as=0 ps=0 w=1u l=1u
X1179 VSS.t1437 VDD VSS.t1437 VSS.t377 sg13_lv_nmos ad=79.8f pd=0.8u as=0 ps=0 w=0.42u l=1u
X1180 VDD VSS.t2425 VDD VDD sg13_lv_pmos ad=0.19p pd=1.38u as=0 ps=0 w=1u l=1u
X1181 VSS.t715 VDD VSS.t715 VSS.t716 sg13_lv_nmos ad=79.8f pd=0.8u as=0 ps=0 w=0.42u l=1u
X1182 VDD VSS.t1072 VDD VDD sg13_lv_pmos ad=0.19p pd=1.38u as=0 ps=0 w=1u l=1u
X1183 VDD VSS.t1377 VDD VDD sg13_lv_pmos ad=0.34p pd=2.68u as=0 ps=0 w=1u l=1u
X1184 VSS.t1649 VDD VSS.t1651 VSS.t1650 sg13_lv_nmos ad=79.8f pd=0.8u as=0 ps=0 w=0.42u l=1u
X1185 VDD VSS.t2880 VDD VDD sg13_lv_pmos ad=0.34p pd=2.68u as=0 ps=0 w=1u l=1u
X1186 VSS.t2211 VDD VSS.t2210 VSS.t2209 sg13_lv_nmos ad=0.1428p pd=1.52u as=0 ps=0 w=0.42u l=1u
X1187 VSS.t2031 VDD VSS.t2033 VSS.t2032 sg13_lv_nmos ad=79.8f pd=0.8u as=0 ps=0 w=0.42u l=1u
X1188 VSS.t955 VDD VSS.t957 VSS.t956 sg13_lv_nmos ad=79.8f pd=0.8u as=0 ps=0 w=0.42u l=1u
X1189 VSS.t2809 VDD VSS.t2810 VSS.t412 sg13_lv_nmos ad=79.8f pd=0.8u as=0 ps=0 w=0.42u l=1u
X1190 VDD VSS.t2550 VDD VDD sg13_lv_pmos ad=0.19p pd=1.38u as=0 ps=0 w=1u l=1u
X1191 VSS.t1441 VDD VSS.t1443 VSS.t377 sg13_lv_nmos ad=79.8f pd=0.8u as=0 ps=0 w=0.42u l=1u
X1192 VSS.t3060 VDD VSS.t3059 VSS.t3058 sg13_lv_nmos ad=0.1428p pd=1.52u as=0 ps=0 w=0.42u l=1u
X1193 VDD VSS.t2756 VDD VDD sg13_lv_pmos ad=0.19p pd=1.38u as=0 ps=0 w=1u l=1u
X1194 VSS.t1971 VDD VSS.t1970 VSS.t1969 sg13_lv_nmos ad=0.1428p pd=1.52u as=0 ps=0 w=0.42u l=1u
X1195 a_21417_14531# a_21060_14488# VDD VDD sg13_lv_pmos ad=63f pd=0.72u as=0.1563p ps=1.22u w=0.42u l=0.13u
X1196 VDD VSS.t1432 VDD VDD sg13_lv_pmos ad=0.34p pd=2.68u as=0 ps=0 w=1u l=1u
X1197 VDD a_15022_14484# sg13g2_buf_16_2.A VDD sg13_lv_pmos ad=0.2128p pd=1.5u as=0.2128p ps=1.5u w=1.12u l=0.13u
X1198 VDD a_15022_14484# sg13g2_buf_16_2.A VDD sg13_lv_pmos ad=0.3976p pd=2.95u as=0.2128p ps=1.5u w=1.12u l=0.13u
X1199 VDD VSS.t1164 VDD VDD sg13_lv_pmos ad=0.34p pd=2.68u as=0 ps=0 w=1u l=1u
X1200 VDD VSS.t2810 VDD VDD sg13_lv_pmos ad=0.34p pd=2.68u as=0 ps=0 w=1u l=1u
X1201 VDD VSS.t2050 VDD VDD sg13_lv_pmos ad=0.34p pd=2.68u as=0 ps=0 w=1u l=1u
X1202 a_3204_15247# a_3435_15356# a_2890_15457# VSS.t333 sg13_lv_nmos ad=0.2373p pd=1.97u as=79.8f ps=0.8u w=0.42u l=0.13u
X1203 a_3142_15247# sg13g2_dfrbpq_1_0.RESET_B VSS.t40 VSS.t318 sg13_lv_nmos ad=37.8f pd=0.6u as=0.1701p ps=1.65u w=0.42u l=0.13u
X1204 VDD VSS.t2235 VDD VDD sg13_lv_pmos ad=0.34p pd=2.68u as=0 ps=0 w=1u l=1u
X1205 sg13g2_or3_1_1.B a_14357_15238# VSS.t246 VSS.t245 sg13_lv_nmos ad=0.1406p pd=1.12u as=0.3293p ps=1.63u w=0.74u l=0.13u
X1206 VSS.t302 VDD VSS.t302 VSS.t706 sg13_lv_nmos ad=79.8f pd=0.8u as=0 ps=0 w=0.42u l=1u
X1207 sg13g2_dfrbpq_1_3.D a_17142_15302# VSS.t24 VSS.t23 sg13_lv_nmos ad=0.2516p pd=2.16u as=0.1426p ps=1.16u w=0.74u l=0.13u
X1208 VSS.t100 a_8218_13690# a_7937_13912# VSS.t371 sg13_lv_nmos ad=79.8f pd=0.8u as=0.1428p ps=1.52u w=0.42u l=0.5u
X1209 a_22036_14020# sg13g2_or3_1_2.A VDD VDD sg13_lv_pmos ad=0.1575p pd=1.315u as=0.3822p ps=1.84u w=1u l=0.13u
X1210 VDD VSS.t1733 VDD VDD sg13_lv_pmos ad=0.34p pd=2.68u as=0 ps=0 w=1u l=1u
X1211 VDD VSS.t2010 VDD VDD sg13_lv_pmos ad=0.34p pd=2.68u as=0 ps=0 w=1u l=1u
X1212 VDD VSS.t2844 VDD VDD sg13_lv_pmos ad=0.34p pd=2.68u as=0 ps=0 w=1u l=1u
X1213 VSS.t2871 VDD VSS.t2872 VSS.t412 sg13_lv_nmos ad=79.8f pd=0.8u as=0 ps=0 w=0.42u l=1u
X1214 VDD VSS.t1039 VDD VDD sg13_lv_pmos ad=0.34p pd=2.68u as=0 ps=0 w=1u l=1u
X1215 VDD VSS.t460 VDD VDD sg13_lv_pmos ad=0.19p pd=1.38u as=0 ps=0 w=1u l=1u
X1216 VSS.t2819 VDD VSS.t2818 VSS.t412 sg13_lv_nmos ad=0.1428p pd=1.52u as=0 ps=0 w=0.42u l=1u
X1217 VSS.t2438 VDD VSS.t2437 VSS.t2436 sg13_lv_nmos ad=0.1428p pd=1.52u as=0 ps=0 w=0.42u l=1u
X1218 VDD sg13g2_dfrbpq_1_1.RESET_B a_6346_14452# VDD sg13_lv_pmos ad=0.1563p pd=1.22u as=0.147p ps=1.54u w=0.42u l=0.13u
X1219 VDD VSS.t100 VDD VDD sg13_lv_pmos ad=0.34p pd=2.68u as=0 ps=0 w=1u l=1u
X1220 VSS.t2887 VDD VSS.t2886 VSS.t412 sg13_lv_nmos ad=0.1428p pd=1.52u as=0 ps=0 w=0.42u l=1u
X1221 VSS.t2161 VDD VSS.t2163 VSS.t2162 sg13_lv_nmos ad=79.8f pd=0.8u as=0 ps=0 w=0.42u l=1u
X1222 VSS.t1145 VDD VSS.t1144 VSS.t1143 sg13_lv_nmos ad=0.1428p pd=1.52u as=0 ps=0 w=0.42u l=1u
X1223 VDD VSS.t2472 VDD VDD sg13_lv_pmos ad=0.34p pd=2.68u as=0 ps=0 w=1u l=1u
X1224 VDD clock_i a_15022_14484# VDD sg13_lv_pmos ad=0.2128p pd=1.5u as=0.2128p ps=1.5u w=1.12u l=0.13u
X1225 VSS.t1594 VDD VSS.t1596 VSS.t1595 sg13_lv_nmos ad=79.8f pd=0.8u as=0 ps=0 w=0.42u l=1u
X1226 VSS.t2503 VDD VSS.t2505 VSS.t2504 sg13_lv_nmos ad=79.8f pd=0.8u as=0 ps=0 w=0.42u l=1u
X1227 VSS.t2779 VDD VSS.t2780 VSS.t412 sg13_lv_nmos ad=79.8f pd=0.8u as=0 ps=0 w=0.42u l=1u
X1228 a_17517_16020# sg13g2_xnor2_1_1.A a_17428_16020# VDD sg13_lv_pmos ad=0.19p pd=1.38u as=0.1575p ps=1.315u w=1u l=0.13u
X1229 VSS.t579 VDD VSS.t578 VSS.t33 sg13_lv_nmos ad=0.1428p pd=1.52u as=0 ps=0 w=0.42u l=1u
X1230 a_6575_13342# a_6540_13238# sg13g2_dlygate4sd3_1_0.A VSS.t411 sg13_lv_nmos ad=0.1406p pd=1.12u as=0.2516p ps=2.16u w=0.74u l=0.13u
X1231 VDD VSS.t1713 VDD VDD sg13_lv_pmos ad=0.34p pd=2.68u as=0 ps=0 w=1u l=1u
X1232 VSS.t2081 VDD VSS.t2080 VSS.t2079 sg13_lv_nmos ad=0.1428p pd=1.52u as=0 ps=0 w=0.42u l=1u
X1233 VDD VSS.t1296 VDD VDD sg13_lv_pmos ad=0.19p pd=1.38u as=0 ps=0 w=1u l=1u
X1234 VDD VSS.t2078 VDD VDD sg13_lv_pmos ad=0.19p pd=1.38u as=0 ps=0 w=1u l=1u
X1235 sg13g2_o21ai_1_1.Y sg13g2_or3_1_2.C a_20376_14464# VDD sg13_lv_pmos ad=0.2128p pd=1.5u as=0.2128p ps=1.5u w=1.12u l=0.15u
X1236 VSS.t1335 VDD VSS.t1335 VSS.t377 sg13_lv_nmos ad=0.1428p pd=1.52u as=0 ps=0 w=0.42u l=1u
X1237 VSS.t1724 VDD VSS.t1723 VSS.t1722 sg13_lv_nmos ad=0.1428p pd=1.52u as=0 ps=0 w=0.42u l=1u
X1238 VDD VSS.t1427 VDD VDD sg13_lv_pmos ad=0.34p pd=2.68u as=0 ps=0 w=1u l=1u
X1239 VDD VSS.t1995 VDD VDD sg13_lv_pmos ad=0.34p pd=2.68u as=0 ps=0 w=1u l=1u
X1240 VDD VSS.t2780 VDD VDD sg13_lv_pmos ad=0.34p pd=2.68u as=0 ps=0 w=1u l=1u
X1241 VDD VSS.t2836 VDD VDD sg13_lv_pmos ad=0.34p pd=2.68u as=0 ps=0 w=1u l=1u
X1242 a_12020_15202# sg13g2_buf_16_2.A VSS.t63 VSS.t169 sg13_lv_nmos ad=0.1406p pd=1.12u as=0.1406p ps=1.12u w=0.74u l=0.13u
X1243 a_12524_15960# sg13g2_dlygate4sd3_1_8.A VSS.t131 VSS.t130 sg13_lv_nmos ad=0.187p pd=1.78u as=0.14875p ps=1.16u w=0.55u l=0.13u
X1244 VDD VSS.t1408 VDD VDD sg13_lv_pmos ad=0.19p pd=1.38u as=0 ps=0 w=1u l=1u
X1245 VDD VSS.t2792 VDD VDD sg13_lv_pmos ad=0.19p pd=1.38u as=0 ps=0 w=1u l=1u
X1246 VSS.t1065 VDD VSS.t1064 VSS.t1063 sg13_lv_nmos ad=0.1428p pd=1.52u as=0 ps=0 w=0.42u l=1u
X1247 VDD VSS.t2587 VDD VDD sg13_lv_pmos ad=0.34p pd=2.68u as=0 ps=0 w=1u l=1u
X1248 sg13g2_or3_1_1.C sg13g2_dfrbpq_1_2.Q VDD VDD sg13_lv_pmos ad=0.2128p pd=1.5u as=0.3808p ps=2.92u w=1.12u l=0.13u
X1249 VSS.t955 VDD VSS.t957 VSS.t956 sg13_lv_nmos ad=79.8f pd=0.8u as=0 ps=0 w=0.42u l=1u
X1250 VSS.t1355 VDD VSS.t1354 VSS.t377 sg13_lv_nmos ad=0.1428p pd=1.52u as=0 ps=0 w=0.42u l=1u
X1251 a_24408_15552# sg13g2_or3_1_2.B VDD VDD sg13_lv_pmos ad=0.2128p pd=1.5u as=0.3808p ps=2.92u w=1.12u l=0.15u
X1252 VDD VSS.t752 VDD VDD sg13_lv_pmos ad=0.34p pd=2.68u as=0 ps=0 w=1u l=1u
X1253 VSS.t1814 VDD VSS.t1813 VSS.t1812 sg13_lv_nmos ad=0.1428p pd=1.52u as=0 ps=0 w=0.42u l=1u
X1254 VSS.t33 a_27502_15423# sg13g2_or3_1_1.A VSS.t33 sg13_lv_nmos ad=0.1426p pd=1.16u as=0.2516p ps=2.16u w=0.74u l=0.13u
X1255 VSS.t2898 VDD VSS.t2898 VSS.t412 sg13_lv_nmos ad=0.1428p pd=1.52u as=0 ps=0 w=0.42u l=1u
X1256 VSS.t2802 VDD VSS.t2803 VSS.t412 sg13_lv_nmos ad=79.8f pd=0.8u as=0 ps=0 w=0.42u l=1u
X1257 VSS.t2196 VDD VSS.t2195 VSS.t2194 sg13_lv_nmos ad=0.1428p pd=1.52u as=0 ps=0 w=0.42u l=1u
X1258 VSS.t1579 VDD VSS.t1581 VSS.t1580 sg13_lv_nmos ad=79.8f pd=0.8u as=0 ps=0 w=0.42u l=1u
X1259 VDD VSS.t2630 VDD VDD sg13_lv_pmos ad=0.19p pd=1.38u as=0 ps=0 w=1u l=1u
X1260 VSS.t214 VDD VSS.t562 VSS.t561 sg13_lv_nmos ad=79.8f pd=0.8u as=0 ps=0 w=0.42u l=1u
X1261 a_7058_15242# sg13g2_xor2_1_0.B VSS.t82 VSS.t160 sg13_lv_nmos ad=0.1406p pd=1.12u as=0.2516p ps=2.16u w=0.74u l=0.13u
X1262 VSS.t302 VDD VSS.t302 VSS.t681 sg13_lv_nmos ad=79.8f pd=0.8u as=0 ps=0 w=0.42u l=1u
X1263 VDD VSS.t2035 VDD VDD sg13_lv_pmos ad=0.34p pd=2.68u as=0 ps=0 w=1u l=1u
X1264 VDD VSS.t2803 VDD VDD sg13_lv_pmos ad=0.34p pd=2.68u as=0 ps=0 w=1u l=1u
X1265 VDD VSS.t547 VDD VDD sg13_lv_pmos ad=0.34p pd=2.68u as=0 ps=0 w=1u l=1u
X1266 VSS.t1281 VDD VSS.t378 VSS.t377 sg13_lv_nmos ad=0.1428p pd=1.52u as=0 ps=0 w=0.42u l=1u
X1267 VSS.t1391 VDD VSS.t1392 VSS.t377 sg13_lv_nmos ad=79.8f pd=0.8u as=0 ps=0 w=0.42u l=1u
X1268 VSS.t1313 VDD VSS.t1314 VSS.t377 sg13_lv_nmos ad=79.8f pd=0.8u as=0 ps=0 w=0.42u l=1u
X1269 VDD VSS.t617 VDD VDD sg13_lv_pmos ad=0.34p pd=2.68u as=0 ps=0 w=1u l=1u
X1270 a_7822_13911# a_7937_13912# VDD VDD sg13_lv_pmos ad=0.34p pd=2.68u as=0.2254p ps=1.53u w=1u l=0.5u
X1271 a_25862_13722# sg13g2_dfrbpq_1_5.D VDD VDD sg13_lv_pmos ad=79.8f pd=0.8u as=0.1428p ps=1.52u w=0.42u l=0.13u
X1272 VDD VSS.t1287 VDD VDD sg13_lv_pmos ad=0.19p pd=1.38u as=0 ps=0 w=1u l=1u
X1273 VDD VSS.t2063 VDD VDD sg13_lv_pmos ad=0.19p pd=1.38u as=0 ps=0 w=1u l=1u
X1274 VDD VSS.t2417 VDD VDD sg13_lv_pmos ad=0.34p pd=2.68u as=0 ps=0 w=1u l=1u
X1275 a_26249_16334# a_26373_16033# VDD VDD sg13_lv_pmos ad=0.2442p pd=2.06u as=2.8961p ps=18.25u w=0.66u l=0.13u
X1276 a_6286_13911# a_6401_13912# VDD VDD sg13_lv_pmos ad=0.34p pd=2.68u as=0.2254p ps=1.53u w=1u l=0.5u
X1277 VSS.t749 VDD VSS.t749 VSS.t750 sg13_lv_nmos ad=79.8f pd=0.8u as=0 ps=0 w=0.42u l=1u
X1278 VDD VSS.t1157 VDD VDD sg13_lv_pmos ad=0.19p pd=1.38u as=0 ps=0 w=1u l=1u
X1279 VDD VSS.t1718 VDD VDD sg13_lv_pmos ad=0.34p pd=2.68u as=0 ps=0 w=1u l=1u
X1280 VSS.t1609 VDD VSS.t1608 VSS.t1607 sg13_lv_nmos ad=0.1428p pd=1.52u as=0 ps=0 w=0.42u l=1u
X1281 VDD VSS.t3157 VDD VDD sg13_lv_pmos ad=0.19p pd=1.38u as=0 ps=0 w=1u l=1u
X1282 VSS.t2518 VDD VSS.t2517 VSS.t2516 sg13_lv_nmos ad=0.1428p pd=1.52u as=0 ps=0 w=0.42u l=1u
X1283 VSS.t2026 VDD VSS.t2025 VSS.t2024 sg13_lv_nmos ad=0.1428p pd=1.52u as=0 ps=0 w=0.42u l=1u
X1284 VSS.t551 VDD VSS.t551 VSS.t552 sg13_lv_nmos ad=79.8f pd=0.8u as=0 ps=0 w=0.42u l=1u
X1285 sg13g2_dfrbpq_1_2.CLK a_12020_15202# VSS.t50 VSS.t61 sg13_lv_nmos ad=0.1406p pd=1.12u as=0.1406p ps=1.12u w=0.74u l=0.13u
X1286 VSS.t606 VDD VSS.t607 VSS.t33 sg13_lv_nmos ad=79.8f pd=0.8u as=0 ps=0 w=0.42u l=1u
X1287 VSS.t2788 VDD VSS.t2786 VSS.t412 sg13_lv_nmos ad=0.1428p pd=1.52u as=0 ps=0 w=0.42u l=1u
X1288 VSS.t356 VDD VSS.t356 VSS.t813 sg13_lv_nmos ad=0.1428p pd=1.52u as=0 ps=0 w=0.42u l=1u
X1289 VSS.t2846 VDD VSS.t2847 VSS.t412 sg13_lv_nmos ad=79.8f pd=0.8u as=0 ps=0 w=0.42u l=1u
X1290 VDD VSS.t1084 VDD VDD sg13_lv_pmos ad=0.34p pd=2.68u as=0 ps=0 w=1u l=1u
X1291 VDD VSS.t1576 VDD VDD sg13_lv_pmos ad=0.19p pd=1.38u as=0 ps=0 w=1u l=1u
X1292 VDD VSS.t438 VDD VDD sg13_lv_pmos ad=0.34p pd=2.68u as=0 ps=0 w=1u l=1u
X1293 VSS.t271 VDD VSS.t271 VSS.t458 sg13_lv_nmos ad=79.8f pd=0.8u as=0 ps=0 w=0.42u l=1u
X1294 VSS.t700 VDD VSS.t700 VSS.t701 sg13_lv_nmos ad=0.1428p pd=1.52u as=0 ps=0 w=0.42u l=1u
X1295 a_9737_14822# a_9861_14521# VDD VDD sg13_lv_pmos ad=0.2442p pd=2.06u as=2.42015p ps=15.68u w=0.66u l=0.13u
X1296 VDD VSS.t100 VDD VDD sg13_lv_pmos ad=0.34p pd=2.68u as=0 ps=0 w=1u l=1u
X1297 a_17604_14488# a_17578_14452# VDD VDD sg13_lv_pmos ad=0.34p pd=2.68u as=0.36237p ps=2.605u w=1u l=0.13u
X1298 VDD a_27472_14726# a_27417_14607# VDD sg13_lv_pmos ad=2.42015p pd=15.68u as=93.45f ps=0.865u w=0.42u l=0.13u
X1299 VSS.t3065 VDD VSS.t3064 VSS.t3063 sg13_lv_nmos ad=0.1428p pd=1.52u as=0 ps=0 w=0.42u l=1u
X1300 VDD VSS.t2759 VDD VDD sg13_lv_pmos ad=0.19p pd=1.38u as=0 ps=0 w=1u l=1u
X1301 VSS.t720 VDD VSS.t183 VSS.t841 sg13_lv_nmos ad=79.8f pd=0.8u as=0 ps=0 w=0.42u l=1u
X1302 VDD VSS.t1415 VDD VDD sg13_lv_pmos ad=0.34p pd=2.68u as=0 ps=0 w=1u l=1u
X1303 VSS.t1709 VDD VSS.t1711 VSS.t1710 sg13_lv_nmos ad=79.8f pd=0.8u as=0 ps=0 w=0.42u l=1u
X1304 VSS.t3235 VDD VSS.t3237 VSS.t3236 sg13_lv_nmos ad=79.8f pd=0.8u as=0 ps=0 w=0.42u l=1u
X1305 VSS.t1373 VDD VSS.t1372 VSS.t377 sg13_lv_nmos ad=0.1428p pd=1.52u as=0 ps=0 w=0.42u l=1u
X1306 VSS.t1295 VDD VSS.t1294 VSS.t377 sg13_lv_nmos ad=0.1428p pd=1.52u as=0 ps=0 w=0.42u l=1u
X1307 VSS.t1539 VDD VSS.t1405 VSS.t377 sg13_lv_nmos ad=79.8f pd=0.8u as=0 ps=0 w=0.42u l=1u
X1308 VSS.t2101 VDD VSS.t2100 VSS.t2099 sg13_lv_nmos ad=0.1428p pd=1.52u as=0 ps=0 w=0.42u l=1u
X1309 VDD VSS.t2055 VDD VDD sg13_lv_pmos ad=0.34p pd=2.68u as=0 ps=0 w=1u l=1u
X1310 VDD VSS.t959 VDD VDD sg13_lv_pmos ad=0.34p pd=2.68u as=0 ps=0 w=1u l=1u
X1311 VSS.t2770 VDD VSS.t2771 VSS.t412 sg13_lv_nmos ad=79.8f pd=0.8u as=0 ps=0 w=0.42u l=1u
X1312 VDD VSS.t2240 VDD VDD sg13_lv_pmos ad=0.34p pd=2.68u as=0 ps=0 w=1u l=1u
X1313 VSS.t2633 VDD VSS.t2635 VSS.t2634 sg13_lv_nmos ad=79.8f pd=0.8u as=0 ps=0 w=0.42u l=1u
X1314 VDD VSS.t484 VDD VDD sg13_lv_pmos ad=0.34p pd=2.68u as=0 ps=0 w=1u l=1u
X1315 VDD VSS.t1738 VDD VDD sg13_lv_pmos ad=0.34p pd=2.68u as=0 ps=0 w=1u l=1u
X1316 VDD VSS.t2771 VDD VDD sg13_lv_pmos ad=0.34p pd=2.68u as=0 ps=0 w=1u l=1u
X1317 VDD a_18874_13690# a_18593_13912# VDD sg13_lv_pmos ad=0.1523p pd=1.38u as=0.34p ps=2.68u w=1u l=0.5u
X1318 VSS.t76 VDD VSS.t407 VSS.t855 sg13_lv_nmos ad=79.8f pd=0.8u as=0 ps=0 w=0.42u l=1u
X1319 VSS.t2011 VDD VSS.t2010 VSS.t2009 sg13_lv_nmos ad=0.1428p pd=1.52u as=0 ps=0 w=0.42u l=1u
X1320 VSS.t1065 VDD VSS.t1064 VSS.t1063 sg13_lv_nmos ad=0.1428p pd=1.52u as=0 ps=0 w=0.42u l=1u
X1321 a_26757_16033# a_26757_16033# VSS.t3 VSS.t2 sg13_lv_nmos ad=0.111p pd=1.34u as=5.24677p ps=34.365u w=0.3u l=0.13u
X1322 VDD VSS.t2878 VDD VDD sg13_lv_pmos ad=0.34p pd=2.68u as=0 ps=0 w=1u l=1u
X1323 a_17219_16265# sg13g2_or3_1_2.B VSS.t150 VSS.t205 sg13_lv_nmos ad=0.187p pd=1.78u as=0.1045p ps=0.93u w=0.55u l=0.13u
X1324 VSS.t490 VDD VSS.t492 VSS.t491 sg13_lv_nmos ad=79.8f pd=0.8u as=0 ps=0 w=0.42u l=1u
X1325 VSS.t2821 VDD VSS.t2821 VSS.t412 sg13_lv_nmos ad=0.1428p pd=1.52u as=0 ps=0 w=0.42u l=1u
X1326 VSS.t35 VDD VSS.t35 VSS.t689 sg13_lv_nmos ad=0.1428p pd=1.52u as=0 ps=0 w=0.42u l=1u
X1327 VDD VSS.t393 VDD VDD sg13_lv_pmos ad=0.19p pd=1.38u as=0 ps=0 w=1u l=1u
X1328 VSS.t2890 VDD VSS.t2889 VSS.t412 sg13_lv_nmos ad=0.1428p pd=1.52u as=0 ps=0 w=0.42u l=1u
X1329 VDD VSS.t131 VDD VDD sg13_lv_pmos ad=0.34p pd=2.68u as=0 ps=0 w=1u l=1u
X1330 VSS.t384 VDD VSS.t178 VSS.t828 sg13_lv_nmos ad=0.1428p pd=1.52u as=0 ps=0 w=0.42u l=1u
X1331 VDD VSS.t1322 VDD VDD sg13_lv_pmos ad=0.19p pd=1.38u as=0 ps=0 w=1u l=1u
X1332 VDD VSS.t2831 VDD VDD sg13_lv_pmos ad=0.19p pd=1.38u as=0 ps=0 w=1u l=1u
X1333 VSS.t2166 VDD VSS.t2168 VSS.t2167 sg13_lv_nmos ad=79.8f pd=0.8u as=0 ps=0 w=0.42u l=1u
X1334 VDD VSS.t922 VDD VDD sg13_lv_pmos ad=0.19p pd=1.38u as=0 ps=0 w=1u l=1u
X1335 VDD VSS.t1114 VDD VDD sg13_lv_pmos ad=0.34p pd=2.68u as=0 ps=0 w=1u l=1u
X1336 VSS.t1387 VDD VSS.t1386 VSS.t377 sg13_lv_nmos ad=0.1428p pd=1.52u as=0 ps=0 w=0.42u l=1u
X1337 VSS.t2503 VDD VSS.t2502 VSS.t2501 sg13_lv_nmos ad=0.1428p pd=1.52u as=0 ps=0 w=0.42u l=1u
X1338 VDD VSS.t2442 VDD VDD sg13_lv_pmos ad=0.34p pd=2.68u as=0 ps=0 w=1u l=1u
X1339 VDD VSS.t2615 VDD VDD sg13_lv_pmos ad=0.19p pd=1.38u as=0 ps=0 w=1u l=1u
X1340 VDD VSS.t1359 VDD VDD sg13_lv_pmos ad=0.19p pd=1.38u as=0 ps=0 w=1u l=1u
X1341 VDD VSS.t737 VDD VDD sg13_lv_pmos ad=0.34p pd=2.68u as=0 ps=0 w=1u l=1u
X1342 VSS.t2051 VDD VSS.t2050 VSS.t2049 sg13_lv_nmos ad=0.1428p pd=1.52u as=0 ps=0 w=0.42u l=1u
X1343 VDD VSS.t2567 VDD VDD sg13_lv_pmos ad=0.34p pd=2.68u as=0 ps=0 w=1u l=1u
X1344 VDD VSS.t2225 VDD VDD sg13_lv_pmos ad=0.34p pd=2.68u as=0 ps=0 w=1u l=1u
X1345 VDD VSS.t2048 VDD VDD sg13_lv_pmos ad=0.19p pd=1.38u as=0 ps=0 w=1u l=1u
X1346 VDD VSS.t634 VDD VDD sg13_lv_pmos ad=0.34p pd=2.68u as=0 ps=0 w=1u l=1u
X1347 VDD VSS.t2402 VDD VDD sg13_lv_pmos ad=0.34p pd=2.68u as=0 ps=0 w=1u l=1u
X1348 VSS.t1150 VDD VSS.t1149 VSS.t1148 sg13_lv_nmos ad=0.1428p pd=1.52u as=0 ps=0 w=0.42u l=1u
X1349 VDD VSS.t2783 VDD VDD sg13_lv_pmos ad=0.34p pd=2.68u as=0 ps=0 w=1u l=1u
X1350 VSS.t1554 VDD VSS.t1422 VSS.t377 sg13_lv_nmos ad=79.8f pd=0.8u as=0 ps=0 w=0.42u l=1u
X1351 VDD VSS.t2173 VDD VDD sg13_lv_pmos ad=0.19p pd=1.38u as=0 ps=0 w=1u l=1u
X1352 VDD VSS.t695 VDD VDD sg13_lv_pmos ad=0.19p pd=1.38u as=0 ps=0 w=1u l=1u
X1353 VDD VSS.t1014 VDD VDD sg13_lv_pmos ad=0.34p pd=2.68u as=0 ps=0 w=1u l=1u
X1354 VSS.t106 a_4175_15311# a_4842_15532# VSS.t105 sg13_lv_nmos ad=0.1406p pd=1.12u as=0.2516p ps=2.16u w=0.74u l=0.13u
X1355 sg13g2_xnor2_1_0.Y sg13g2_nand3_1_0.Y a_7923_15532# VDD sg13_lv_pmos ad=0.2408p pd=1.55u as=0.1428p ps=1.375u w=1.12u l=0.13u
X1356 VSS.t97 a_19450_15202# a_19169_15424# VSS.t9 sg13_lv_nmos ad=79.8f pd=0.8u as=0.1428p ps=1.52u w=0.42u l=0.5u
X1357 VDD VSS.t992 VDD VDD sg13_lv_pmos ad=0.19p pd=1.38u as=0 ps=0 w=1u l=1u
X1358 VDD VSS.t1285 VDD VDD sg13_lv_pmos ad=0.19p pd=1.38u as=0 ps=0 w=1u l=1u
X1359 VSS.t2779 VDD VSS.t2778 VSS.t412 sg13_lv_nmos ad=0.1428p pd=1.52u as=0 ps=0 w=0.42u l=1u
X1360 VSS.t2838 VDD VSS.t2839 VSS.t412 sg13_lv_nmos ad=79.8f pd=0.8u as=0 ps=0 w=0.42u l=1u
X1361 VDD VSS.t2795 VDD VDD sg13_lv_pmos ad=0.19p pd=1.38u as=0 ps=0 w=1u l=1u
X1362 VDD a_8582_15238# a_8694_15302# VDD sg13_lv_pmos ad=0.2254p pd=1.53u as=0.34p ps=2.68u w=1u l=0.5u
X1363 VSS.t127 a_15022_14484# sg13g2_buf_16_2.A VSS.t227 sg13_lv_nmos ad=0.1406p pd=1.12u as=0.1406p ps=1.12u w=0.74u l=0.13u
X1364 VDD VSS.t3029 VDD VDD sg13_lv_pmos ad=0.34p pd=2.68u as=0 ps=0 w=1u l=1u
X1365 sg13g2_a21oi_1_0.Y sg13g2_a21oi_1_0.B1 VSS.t18 VSS.t17 sg13_lv_nmos ad=0.1406p pd=1.12u as=0.2516p ps=2.16u w=0.74u l=0.13u
X1366 VDD sg13g2_and2_1_0.B a_1965_14832# VDD sg13_lv_pmos ad=0.1918p pd=1.5u as=0.1596p ps=1.22u w=0.84u l=0.13u
X1367 VSS.t737 VDD VSS.t740 VSS.t867 sg13_lv_nmos ad=79.8f pd=0.8u as=0 ps=0 w=0.42u l=1u
X1368 a_17318_14922# sg13g2_dfrbpq_1_3.D VDD VDD sg13_lv_pmos ad=79.8f pd=0.8u as=0.1428p ps=1.52u w=0.42u l=0.13u
X1369 VDD VSS.t889 VDD VDD sg13_lv_pmos ad=0.34p pd=2.68u as=0 ps=0 w=1u l=1u
X1370 VDD VSS.t1077 VDD VDD sg13_lv_pmos ad=0.19p pd=1.38u as=0 ps=0 w=1u l=1u
X1371 VSS.t1165 VDD VSS.t1164 VSS.t1163 sg13_lv_nmos ad=0.1428p pd=1.52u as=0 ps=0 w=0.42u l=1u
X1372 VSS.t3050 VDD VSS.t3049 VSS.t3048 sg13_lv_nmos ad=0.1428p pd=1.52u as=0 ps=0 w=0.42u l=1u
X1373 VSS.t1430 VDD VSS.t1431 VSS.t377 sg13_lv_nmos ad=79.8f pd=0.8u as=0 ps=0 w=0.42u l=1u
X1374 VSS.t143 a_25094_14484# a_25206_14508# VSS.t30 sg13_lv_nmos ad=0.1426p pd=1.16u as=0.1428p ps=1.52u w=0.42u l=0.5u
X1375 sg13g2_or3_1_1.X a_24841_13726# VSS.t14 VSS.t403 sg13_lv_nmos ad=0.2516p pd=2.16u as=0.13395p ps=1.12u w=0.74u l=0.13u
X1376 VDD VSS.t2040 VDD VDD sg13_lv_pmos ad=0.34p pd=2.68u as=0 ps=0 w=1u l=1u
X1377 VDD VSS.t2805 VDD VDD sg13_lv_pmos ad=0.34p pd=2.68u as=0 ps=0 w=1u l=1u
X1378 VDD VSS.t2600 VDD VDD sg13_lv_pmos ad=0.19p pd=1.38u as=0 ps=0 w=1u l=1u
X1379 VSS.t631 VDD VSS.t22 VSS.t630 sg13_lv_nmos ad=0.1428p pd=1.52u as=0 ps=0 w=0.42u l=1u
X1380 VDD VSS.t1290 VDD VDD sg13_lv_pmos ad=0.19p pd=1.38u as=0 ps=0 w=1u l=1u
X1381 VSS.t1714 VDD VSS.t1713 VSS.t1712 sg13_lv_nmos ad=0.1428p pd=1.52u as=0 ps=0 w=0.42u l=1u
X1382 VSS.t3240 VDD VSS.t3239 VSS.t3238 sg13_lv_nmos ad=0.1428p pd=1.52u as=0 ps=0 w=0.42u l=1u
X1383 VDD VSS.t2387 VDD VDD sg13_lv_pmos ad=0.34p pd=2.68u as=0 ps=0 w=1u l=1u
X1384 a_25109_12972# sg13g2_a21oi_1_3.A1 VDD VDD sg13_lv_pmos ad=0.2128p pd=1.5u as=0.2128p ps=1.5u w=1.12u l=0.13u
X1385 VSS.t2618 VDD VSS.t2620 VSS.t2619 sg13_lv_nmos ad=79.8f pd=0.8u as=0 ps=0 w=0.42u l=1u
X1386 VDD VSS.t302 VDD VDD sg13_lv_pmos ad=0.34p pd=2.68u as=0 ps=0 w=1u l=1u
X1387 VDD VSS.t1723 VDD VDD sg13_lv_pmos ad=0.34p pd=2.68u as=0 ps=0 w=1u l=1u
X1388 VDD VSS.t1377 VDD VDD sg13_lv_pmos ad=0.19p pd=1.38u as=0 ps=0 w=1u l=1u
X1389 VSS.t1614 VDD VSS.t1613 VSS.t1612 sg13_lv_nmos ad=0.1428p pd=1.52u as=0 ps=0 w=0.42u l=1u
X1390 VSS.t2523 VDD VSS.t2522 VSS.t2521 sg13_lv_nmos ad=0.1428p pd=1.52u as=0 ps=0 w=0.42u l=1u
X1391 VSS.t1996 VDD VSS.t1995 VSS.t1994 sg13_lv_nmos ad=0.1428p pd=1.52u as=0 ps=0 w=0.42u l=1u
X1392 VSS.t1784 VDD VSS.t1786 VSS.t1785 sg13_lv_nmos ad=79.8f pd=0.8u as=0 ps=0 w=0.42u l=1u
X1393 VSS.t1325 VDD VSS.t1326 VSS.t377 sg13_lv_nmos ad=79.8f pd=0.8u as=0 ps=0 w=0.42u l=1u
X1394 VDD VSS.t2870 VDD VDD sg13_lv_pmos ad=0.34p pd=2.68u as=0 ps=0 w=1u l=1u
X1395 VDD VSS.t2095 VDD VDD sg13_lv_pmos ad=0.34p pd=2.68u as=0 ps=0 w=1u l=1u
X1396 VSS.t16 clock_i a_15022_14484# VSS.t365 sg13_lv_nmos ad=0.1406p pd=1.12u as=0.1406p ps=1.12u w=0.74u l=0.13u
X1397 VDD VSS.t3222 VDD VDD sg13_lv_pmos ad=0.19p pd=1.38u as=0 ps=0 w=1u l=1u
X1398 VSS.t2488 VDD VSS.t2490 VSS.t2489 sg13_lv_nmos ad=79.8f pd=0.8u as=0 ps=0 w=0.42u l=1u
X1399 a_16485_13701# sg13g2_dfrbpq_1_2.CLK VDD VDD sg13_lv_pmos ad=0.4088p pd=2.97u as=2.3367p ps=15.135u w=1.12u l=0.13u
X1400 VDD VSS.t1044 VDD VDD sg13_lv_pmos ad=0.34p pd=2.68u as=0 ps=0 w=1u l=1u
X1401 VSS.t2797 VDD VSS.t2798 VSS.t412 sg13_lv_nmos ad=79.8f pd=0.8u as=0 ps=0 w=0.42u l=1u
X1402 VDD VSS.t2762 VDD VDD sg13_lv_pmos ad=0.19p pd=1.38u as=0 ps=0 w=1u l=1u
X1403 VDD a_4474_14448# a_4193_14750# VDD sg13_lv_pmos ad=0.1523p pd=1.38u as=0.34p ps=2.68u w=1u l=0.5u
X1404 VSS.t1413 VDD VSS.t1412 VSS.t377 sg13_lv_nmos ad=0.1428p pd=1.52u as=0 ps=0 w=0.42u l=1u
X1405 VSS.t3035 VDD VSS.t3034 VSS.t3033 sg13_lv_nmos ad=0.1428p pd=1.52u as=0 ps=0 w=0.42u l=1u
X1406 VDD VSS.t1418 VDD VDD sg13_lv_pmos ad=0.34p pd=2.68u as=0 ps=0 w=1u l=1u
X1407 VDD VSS.t2427 VDD VDD sg13_lv_pmos ad=0.34p pd=2.68u as=0 ps=0 w=1u l=1u
X1408 VDD VSS.t2798 VDD VDD sg13_lv_pmos ad=0.34p pd=2.68u as=0 ps=0 w=1u l=1u
X1409 VDD sg13g2_buf_1_0.X a_2942_14484# VDD sg13_lv_pmos ad=0.36p pd=2.72u as=0.1225p ps=1.245u w=1u l=0.13u
X1410 a_6540_13238# sg13g2_xnor2_1_2.B VDD VDD sg13_lv_pmos ad=0.1596p pd=1.22u as=0.2891p ps=1.695u w=0.84u l=0.13u
X1411 VDD VSS.t731 VDD VDD sg13_lv_pmos ad=0.34p pd=2.68u as=0 ps=0 w=1u l=1u
X1412 VSS.t1150 VDD VSS.t1149 VSS.t1148 sg13_lv_nmos ad=0.1428p pd=1.52u as=0 ps=0 w=0.42u l=1u
X1413 VDD VSS.t2552 VDD VDD sg13_lv_pmos ad=0.34p pd=2.68u as=0 ps=0 w=1u l=1u
X1414 VDD VSS.t2210 VDD VDD sg13_lv_pmos ad=0.34p pd=2.68u as=0 ps=0 w=1u l=1u
X1415 VDD VSS.t2774 VDD VDD sg13_lv_pmos ad=0.34p pd=2.68u as=0 ps=0 w=1u l=1u
X1416 VDD VSS.t695 VDD VDD sg13_lv_pmos ad=0.19p pd=1.38u as=0 ps=0 w=1u l=1u
X1417 VDD VSS.t1059 VDD VDD sg13_lv_pmos ad=0.34p pd=2.68u as=0 ps=0 w=1u l=1u
X1418 a_21034_14452# a_21477_14495# a_20774_14922# VSS.t65 sg13_lv_nmos ad=79.8f pd=0.8u as=0.1296p ps=1.52u w=0.42u l=0.13u
X1419 VDD VSS.t1456 VDD VDD sg13_lv_pmos ad=0.34p pd=2.68u as=0 ps=0 w=1u l=1u
X1420 VDD VSS.t2881 VDD VDD sg13_lv_pmos ad=0.34p pd=2.68u as=0 ps=0 w=1u l=1u
X1421 VSS.t2824 VDD VSS.t2824 VSS.t412 sg13_lv_nmos ad=0.1428p pd=1.52u as=0 ps=0 w=0.42u l=1u
X1422 VSS.t1574 VDD VSS.t1576 VSS.t1575 sg13_lv_nmos ad=79.8f pd=0.8u as=0 ps=0 w=0.42u l=1u
X1423 sg13g2_a21oi_1_3.A2 a_24169_14508# VSS.t181 VSS.t30 sg13_lv_nmos ad=0.2516p pd=2.16u as=0.13395p ps=1.12u w=0.74u l=0.13u
X1424 VDD VSS.t1122 VDD VDD sg13_lv_pmos ad=0.19p pd=1.38u as=0 ps=0 w=1u l=1u
X1425 VSS.t1165 VDD VSS.t1164 VSS.t1163 sg13_lv_nmos ad=0.1428p pd=1.52u as=0 ps=0 w=0.42u l=1u
X1426 VDD reset_n_i a_1192_9948# VDD sg13_lv_pmos ad=0.2114p pd=1.54u as=0.2856p ps=2.36u w=0.84u l=0.13u
X1427 VSS.t1070 VDD VSS.t1072 VSS.t1071 sg13_lv_nmos ad=79.8f pd=0.8u as=0 ps=0 w=0.42u l=1u
X1428 VDD VSS.t1706 VDD VDD sg13_lv_pmos ad=0.19p pd=1.38u as=0 ps=0 w=1u l=1u
X1429 VSS.t2874 VDD VSS.t2873 VSS.t412 sg13_lv_nmos ad=0.1428p pd=1.52u as=0 ps=0 w=0.42u l=1u
X1430 VSS.t2136 VDD VSS.t2138 VSS.t2137 sg13_lv_nmos ad=79.8f pd=0.8u as=0 ps=0 w=0.42u l=1u
X1431 VSS.t585 VDD VSS.t586 VSS.t33 sg13_lv_nmos ad=79.8f pd=0.8u as=0 ps=0 w=0.42u l=1u
X1432 VDD VSS.t1711 VDD VDD sg13_lv_pmos ad=0.19p pd=1.38u as=0 ps=0 w=1u l=1u
X1433 VDD VSS.t2447 VDD VDD sg13_lv_pmos ad=0.34p pd=2.68u as=0 ps=0 w=1u l=1u
X1434 VDD VSS.t519 VDD VDD sg13_lv_pmos ad=0.34p pd=2.68u as=0 ps=0 w=1u l=1u
X1435 VSS.t700 VDD VSS.t700 VSS.t701 sg13_lv_nmos ad=0.1428p pd=1.52u as=0 ps=0 w=0.42u l=1u
X1436 VSS.t2056 VDD VSS.t2055 VSS.t2054 sg13_lv_nmos ad=0.1428p pd=1.52u as=0 ps=0 w=0.42u l=1u
X1437 a_25774_15423# a_25889_15424# VDD VDD sg13_lv_pmos ad=0.34p pd=2.68u as=0.2254p ps=1.53u w=1u l=0.5u
X1438 VDD VSS.t302 VDD VDD sg13_lv_pmos ad=0.34p pd=2.68u as=0 ps=0 w=1u l=1u
X1439 VDD VSS.t1439 VDD VDD sg13_lv_pmos ad=0.34p pd=2.68u as=0 ps=0 w=1u l=1u
X1440 VDD VSS.t2768 VDD VDD sg13_lv_pmos ad=0.34p pd=2.68u as=0 ps=0 w=1u l=1u
X1441 VSS.t1599 VDD VSS.t1598 VSS.t1597 sg13_lv_nmos ad=0.1428p pd=1.52u as=0 ps=0 w=0.42u l=1u
X1442 VSS.t2508 VDD VSS.t2507 VSS.t2506 sg13_lv_nmos ad=0.1428p pd=1.52u as=0 ps=0 w=0.42u l=1u
X1443 VSS.t525 VDD VSS.t527 VSS.t526 sg13_lv_nmos ad=79.8f pd=0.8u as=0 ps=0 w=0.42u l=1u
X1444 VSS.t1794 VDD VSS.t1793 VSS.t1792 sg13_lv_nmos ad=0.1428p pd=1.52u as=0 ps=0 w=0.42u l=1u
X1445 VSS.t2782 VDD VSS.t2780 VSS.t412 sg13_lv_nmos ad=0.1428p pd=1.52u as=0 ps=0 w=0.42u l=1u
X1446 VDD VSS.t106 VDD VDD sg13_lv_pmos ad=0.19p pd=1.38u as=0 ps=0 w=1u l=1u
X1447 VSS.t2841 VDD VSS.t2842 VSS.t412 sg13_lv_nmos ad=79.8f pd=0.8u as=0 ps=0 w=0.42u l=1u
X1448 a_22319_14845# a_21477_14495# a_21060_14488# VDD sg13_lv_pmos ad=0.2048p pd=1.63u as=0.34p ps=2.68u w=1u l=0.13u
X1449 VSS.t3095 VDD VSS.t3094 VSS.t3093 sg13_lv_nmos ad=0.1428p pd=1.52u as=0 ps=0 w=0.42u l=1u
X1450 VDD VSS.t3207 VDD VDD sg13_lv_pmos ad=0.19p pd=1.38u as=0 ps=0 w=1u l=1u
X1451 VSS.t2473 VDD VSS.t2475 VSS.t2474 sg13_lv_nmos ad=79.8f pd=0.8u as=0 ps=0 w=0.42u l=1u
X1452 VDD VSS.t2415 VDD VDD sg13_lv_pmos ad=0.19p pd=1.38u as=0 ps=0 w=1u l=1u
X1453 VSS.t246 a_14357_15238# sg13g2_or3_1_1.B VSS.t247 sg13_lv_nmos ad=0.1406p pd=1.12u as=0.1406p ps=1.12u w=0.74u l=0.13u
X1454 a_24062_15242# sg13g2_dfrbpq_1_6.Q a_23960_15242# VSS.t28 sg13_lv_nmos ad=0.1406p pd=1.12u as=0.1406p ps=1.12u w=0.74u l=0.13u
X1455 VSS.t1789 VDD VSS.t1788 VSS.t1787 sg13_lv_nmos ad=0.1428p pd=1.52u as=0 ps=0 w=0.42u l=1u
X1456 VSS.t2788 VDD VSS.t2789 VSS.t412 sg13_lv_nmos ad=79.8f pd=0.8u as=0 ps=0 w=0.42u l=1u
X1457 a_8779_14832# sg13g2_buf_1_10.X a_8685_14832# VSS.t291 sg13_lv_nmos ad=0.1216p pd=1.02u as=0.2176p ps=1.96u w=0.64u l=0.13u
X1458 VDD VSS.t1092 VDD VDD sg13_lv_pmos ad=0.19p pd=1.38u as=0 ps=0 w=1u l=1u
X1459 VDD VSS.t3159 VDD VDD sg13_lv_pmos ad=0.34p pd=2.68u as=0 ps=0 w=1u l=1u
X1460 VSS.t2884 VDD VSS.t2884 VSS.t412 sg13_lv_nmos ad=0.1428p pd=1.52u as=0 ps=0 w=0.42u l=1u
X1461 VDD VSS.t2753 VDD VDD sg13_lv_pmos ad=0.19p pd=1.38u as=0 ps=0 w=1u l=1u
X1462 VDD VSS.t1329 VDD VDD sg13_lv_pmos ad=0.19p pd=1.38u as=0 ps=0 w=1u l=1u
X1463 VDD VSS.t1409 VDD VDD sg13_lv_pmos ad=0.34p pd=2.68u as=0 ps=0 w=1u l=1u
X1464 VDD VSS.t2605 VDD VDD sg13_lv_pmos ad=0.19p pd=1.38u as=0 ps=0 w=1u l=1u
X1465 VSS.t2091 VDD VSS.t2090 VSS.t2089 sg13_lv_nmos ad=0.1428p pd=1.52u as=0 ps=0 w=0.42u l=1u
X1466 VDD VSS.t2045 VDD VDD sg13_lv_pmos ad=0.34p pd=2.68u as=0 ps=0 w=1u l=1u
X1467 VDD VSS.t2789 VDD VDD sg13_lv_pmos ad=0.34p pd=2.68u as=0 ps=0 w=1u l=1u
X1468 VSS.t6 sg13g2_dfrbpq_1_6.RESET_B a_20868_14922# VSS.t91 sg13_lv_nmos ad=0.1626p pd=1.415u as=60.89999f ps=0.71u w=0.42u l=0.13u
X1469 VSS.t302 VDD VSS.t302 VSS.t682 sg13_lv_nmos ad=0.1428p pd=1.52u as=0 ps=0 w=0.42u l=1u
X1470 a_17578_14452# a_18021_14495# a_17318_14922# VSS.t120 sg13_lv_nmos ad=79.8f pd=0.8u as=0.1296p ps=1.52u w=0.42u l=0.13u
X1471 VSS.t2623 VDD VSS.t2625 VSS.t2624 sg13_lv_nmos ad=79.8f pd=0.8u as=0 ps=0 w=0.42u l=1u
X1472 sg13g2_or3_1_1.B a_14357_15238# VDD VDD sg13_lv_pmos ad=0.2128p pd=1.5u as=0.203p ps=1.5u w=1.12u l=0.13u
X1473 a_25956_14488# a_25930_14452# VSS.t255 VSS.t254 sg13_lv_nmos ad=0.2516p pd=2.16u as=0.1626p ps=1.415u w=0.74u l=0.13u
X1474 VSS.t618 VDD VSS.t619 VSS.t33 sg13_lv_nmos ad=79.8f pd=0.8u as=0 ps=0 w=0.42u l=1u
X1475 VDD VSS.t967 VDD VDD sg13_lv_pmos ad=0.19p pd=1.38u as=0 ps=0 w=1u l=1u
X1476 VDD VSS.t2565 VDD VDD sg13_lv_pmos ad=0.19p pd=1.38u as=0 ps=0 w=1u l=1u
X1477 VSS.t1584 VDD VSS.t1583 VSS.t1582 sg13_lv_nmos ad=0.1428p pd=1.52u as=0 ps=0 w=0.42u l=1u
X1478 VSS.t513 VDD VSS.t513 VSS.t512 sg13_lv_nmos ad=0.1428p pd=1.52u as=0 ps=0 w=0.42u l=1u
X1479 VSS.t1365 VDD VSS.t1365 VSS.t377 sg13_lv_nmos ad=0.1428p pd=1.52u as=0 ps=0 w=0.42u l=1u
X1480 a_6372_14488# a_6891_14495# a_7631_14845# VSS.t314 sg13_lv_nmos ad=0.3473p pd=2.71u as=0.12665p ps=1.145u w=0.74u l=0.13u
X1481 VSS.t2833 VDD VSS.t2834 VSS.t412 sg13_lv_nmos ad=79.8f pd=0.8u as=0 ps=0 w=0.42u l=1u
X1482 VDD VSS.t449 VDD VDD sg13_lv_pmos ad=0.34p pd=2.68u as=0 ps=0 w=1u l=1u
X1483 VDD VSS.t489 VDD VDD sg13_lv_pmos ad=0.34p pd=2.68u as=0 ps=0 w=1u l=1u
X1484 a_27634_14922# sg13g2_dfrbpq_1_7.RESET_B VSS.t33 VSS.t33 sg13_lv_nmos ad=37.8f pd=0.6u as=79.8f ps=0.8u w=0.42u l=0.13u
X1485 VSS.t35 sg13g2_xnor2_1_2.B a_6575_13342# VSS.t417 sg13_lv_nmos ad=0.1898p pd=1.36u as=0.1406p ps=1.12u w=0.74u l=0.13u
X1486 VDD VSS.t2065 VDD VDD sg13_lv_pmos ad=0.34p pd=2.68u as=0 ps=0 w=1u l=1u
X1487 VDD VSS.t145 VDD VDD sg13_lv_pmos ad=0.19p pd=1.38u as=0 ps=0 w=1u l=1u
X1488 a_20278_14862# sg13g2_or3_1_2.C VSS.t10 VSS.t25 sg13_lv_nmos ad=0.1406p pd=1.12u as=0.1406p ps=1.12u w=0.74u l=0.15u
X1489 a_18478_13911# a_18593_13912# VDD VDD sg13_lv_pmos ad=0.34p pd=2.68u as=0.2254p ps=1.53u w=1u l=0.5u
X1490 VSS.t407 VDD VSS.t725 VSS.t857 sg13_lv_nmos ad=79.8f pd=0.8u as=0 ps=0 w=0.42u l=1u
X1491 VDD VSS.t1288 VDD VDD sg13_lv_pmos ad=0.34p pd=2.68u as=0 ps=0 w=1u l=1u
X1492 VDD VSS.t3227 VDD VDD sg13_lv_pmos ad=0.19p pd=1.38u as=0 ps=0 w=1u l=1u
X1493 VSS.t1070 VDD VSS.t1072 VSS.t1071 sg13_lv_nmos ad=79.8f pd=0.8u as=0 ps=0 w=0.42u l=1u
X1494 VDD VSS.t1348 VDD VDD sg13_lv_pmos ad=0.34p pd=2.68u as=0 ps=0 w=1u l=1u
X1495 VSS.t1115 VDD VSS.t1114 VSS.t1113 sg13_lv_nmos ad=0.1428p pd=1.52u as=0 ps=0 w=0.42u l=1u
X1496 VSS.t1307 VDD VSS.t1306 VSS.t377 sg13_lv_nmos ad=0.1428p pd=1.52u as=0 ps=0 w=0.42u l=1u
X1497 VSS.t3040 VDD VSS.t3039 VSS.t3038 sg13_lv_nmos ad=0.1428p pd=1.52u as=0 ps=0 w=0.42u l=1u
X1498 VSS.t618 VDD VSS.t617 VSS.t33 sg13_lv_nmos ad=0.1428p pd=1.52u as=0 ps=0 w=0.42u l=1u
X1499 a_7888_14726# a_7631_14845# a_8050_14922# VSS.t193 sg13_lv_nmos ad=0.1428p pd=1.52u as=37.8f ps=0.6u w=0.42u l=0.13u
X1500 VSS.t3210 VDD VSS.t3212 VSS.t3211 sg13_lv_nmos ad=79.8f pd=0.8u as=0 ps=0 w=0.42u l=1u
X1501 VSS.t2418 VDD VSS.t2420 VSS.t2419 sg13_lv_nmos ad=79.8f pd=0.8u as=0 ps=0 w=0.42u l=1u
X1502 VDD VSS.t604 VDD VDD sg13_lv_pmos ad=0.19p pd=1.38u as=0 ps=0 w=1u l=1u
X1503 VDD VSS.t2432 VDD VDD sg13_lv_pmos ad=0.34p pd=2.68u as=0 ps=0 w=1u l=1u
X1504 VDD VSS.t1578 VDD VDD sg13_lv_pmos ad=0.34p pd=2.68u as=0 ps=0 w=1u l=1u
X1505 VDD a_10703_15311# a_11370_15532# VDD sg13_lv_pmos ad=0.2128p pd=1.5u as=0.3864p ps=2.93u w=1.12u l=0.13u
X1506 VSS.t2493 VDD VSS.t2495 VSS.t2494 sg13_lv_nmos ad=79.8f pd=0.8u as=0 ps=0 w=0.42u l=1u
X1507 VSS.t2814 VDD VSS.t2814 VSS.t412 sg13_lv_nmos ad=0.1428p pd=1.52u as=0 ps=0 w=0.42u l=1u
X1508 VDD VSS.t2557 VDD VDD sg13_lv_pmos ad=0.34p pd=2.68u as=0 ps=0 w=1u l=1u
X1509 VSS.t2041 VDD VSS.t2040 VSS.t2039 sg13_lv_nmos ad=0.1428p pd=1.52u as=0 ps=0 w=0.42u l=1u
X1510 VDD VSS.t2760 VDD VDD sg13_lv_pmos ad=0.34p pd=2.68u as=0 ps=0 w=1u l=1u
X1511 VSS.t24 sg13g2_a21oi_1_0.Y a_16760_15238# VSS.t338 sg13_lv_nmos ad=79.8f pd=0.8u as=0.1428p ps=1.52u w=0.42u l=0.13u
X1512 VDD VSS.t1713 VDD VDD sg13_lv_pmos ad=0.34p pd=2.68u as=0 ps=0 w=1u l=1u
X1513 VSS.t505 VDD VSS.t504 VSS.t503 sg13_lv_nmos ad=0.1428p pd=1.52u as=0 ps=0 w=0.42u l=1u
X1514 a_25862_13722# a_26667_13844# a_26122_13945# VDD sg13_lv_pmos ad=0.1428p pd=1.52u as=79.8f ps=0.8u w=0.42u l=0.13u
X1515 VSS.t990 VDD VSS.t992 VSS.t991 sg13_lv_nmos ad=79.8f pd=0.8u as=0 ps=0 w=0.42u l=1u
X1516 VDD VSS.t2133 VDD VDD sg13_lv_pmos ad=0.19p pd=1.38u as=0 ps=0 w=1u l=1u
X1517 a_12020_15202# sg13g2_buf_16_2.A VDD VDD sg13_lv_pmos ad=0.2128p pd=1.5u as=0.2128p ps=1.5u w=1.12u l=0.13u
X1518 VDD VSS.t50 VDD VDD sg13_lv_pmos ad=0.34p pd=2.68u as=0 ps=0 w=1u l=1u
X1519 a_15022_14484# clock_i VDD VDD sg13_lv_pmos ad=0.2128p pd=1.5u as=0.2128p ps=1.5u w=1.12u l=0.13u
X1520 VSS.t19 VDD VSS.t19 VSS.t4 sg13_lv_nmos ad=0.1428p pd=1.52u as=0 ps=0 w=0.42u l=1u
X1521 VDD VSS.t1300 VDD VDD sg13_lv_pmos ad=0.34p pd=2.68u as=0 ps=0 w=1u l=1u
X1522 VDD VSS.t1402 VDD VDD sg13_lv_pmos ad=0.19p pd=1.38u as=0 ps=0 w=1u l=1u
X1523 VDD a_27664_13942# a_27609_14037# VDD sg13_lv_pmos ad=2.42015p pd=15.68u as=93.45f ps=0.865u w=0.42u l=0.13u
X1524 VSS.t2808 VDD VSS.t2808 VSS.t412 sg13_lv_nmos ad=0.1428p pd=1.52u as=0 ps=0 w=0.42u l=1u
X1525 VDD VSS.t1134 VDD VDD sg13_lv_pmos ad=0.34p pd=2.68u as=0 ps=0 w=1u l=1u
X1526 VDD VSS.t3144 VDD VDD sg13_lv_pmos ad=0.34p pd=2.68u as=0 ps=0 w=1u l=1u
X1527 VSS.t2876 VDD VSS.t2876 VSS.t412 sg13_lv_nmos ad=0.1428p pd=1.52u as=0 ps=0 w=0.42u l=1u
X1528 VSS.t2141 VDD VSS.t2143 VSS.t2142 sg13_lv_nmos ad=79.8f pd=0.8u as=0 ps=0 w=0.42u l=1u
X1529 sg13g2_and2_1_2.B a_8694_15302# VSS.t19 VSS.t268 sg13_lv_nmos ad=0.2516p pd=2.16u as=0.1426p ps=1.16u w=0.74u l=0.13u
X1530 VSS.t63 a_12020_15202# sg13g2_dfrbpq_1_2.CLK VSS.t62 sg13_lv_nmos ad=0.1406p pd=1.12u as=0.1406p ps=1.12u w=0.74u l=0.13u
X1531 VSS.t369 a_17327_13799# a_17994_14020# VSS.t376 sg13_lv_nmos ad=0.1406p pd=1.12u as=0.2516p ps=2.16u w=0.74u l=0.13u
X1532 VSS.t3230 VDD VSS.t3232 VSS.t3231 sg13_lv_nmos ad=79.8f pd=0.8u as=0 ps=0 w=0.42u l=1u
X1533 VDD VSS.t749 VDD VDD sg13_lv_pmos ad=0.34p pd=2.68u as=0 ps=0 w=1u l=1u
X1534 VSS.t1440 VDD VSS.t1439 VSS.t377 sg13_lv_nmos ad=0.1428p pd=1.52u as=0 ps=0 w=0.42u l=1u
X1535 VDD VSS.t2590 VDD VDD sg13_lv_pmos ad=0.19p pd=1.38u as=0 ps=0 w=1u l=1u
X1536 VDD VSS.t1771 VDD VDD sg13_lv_pmos ad=0.19p pd=1.38u as=0 ps=0 w=1u l=1u
X1537 VSS.t2061 VDD VSS.t2060 VSS.t2059 sg13_lv_nmos ad=0.1428p pd=1.52u as=0 ps=0 w=0.42u l=1u
X1538 VSS.t846 VDD VSS.t74 VSS.t845 sg13_lv_nmos ad=0.1428p pd=1.52u as=0 ps=0 w=0.42u l=1u
X1539 VSS.t1644 VDD VSS.t1643 VSS.t1642 sg13_lv_nmos ad=0.1428p pd=1.52u as=0 ps=0 w=0.42u l=1u
X1540 VSS.t3 a_22025_16334# a_21946_16237# VSS.t327 sg13_lv_nmos ad=5.24677p pd=34.365u as=0.27427p ps=2.28u w=0.795u l=0.13u
X1541 VSS.t1433 VDD VSS.t1434 VSS.t377 sg13_lv_nmos ad=79.8f pd=0.8u as=0 ps=0 w=0.42u l=1u
X1542 VDD VSS.t2772 VDD VDD sg13_lv_pmos ad=0.34p pd=2.68u as=0 ps=0 w=1u l=1u
X1543 VSS.t540 VDD VSS.t539 VSS.t538 sg13_lv_nmos ad=0.1428p pd=1.52u as=0 ps=0 w=0.42u l=1u
X1544 VSS.t960 VDD VSS.t959 VSS.t958 sg13_lv_nmos ad=0.1428p pd=1.52u as=0 ps=0 w=0.42u l=1u
X1545 VDD VSS.t2866 VDD VDD sg13_lv_pmos ad=0.19p pd=1.38u as=0 ps=0 w=1u l=1u
X1546 VSS.t2171 VDD VSS.t2170 VSS.t2169 sg13_lv_nmos ad=0.1428p pd=1.52u as=0 ps=0 w=0.42u l=1u
X1547 VDD VSS.t1012 VDD VDD sg13_lv_pmos ad=0.19p pd=1.38u as=0 ps=0 w=1u l=1u
X1548 VDD VSS.t2460 VDD VDD sg13_lv_pmos ad=0.19p pd=1.38u as=0 ps=0 w=1u l=1u
X1549 VDD VSS.t2118 VDD VDD sg13_lv_pmos ad=0.19p pd=1.38u as=0 ps=0 w=1u l=1u
X1550 VDD a_27215_14845# a_27882_14484# VDD sg13_lv_pmos ad=0.2128p pd=1.5u as=0.3864p ps=2.93u w=1.12u l=0.13u
X1551 VSS.t2785 VDD VSS.t2784 VSS.t412 sg13_lv_nmos ad=0.1428p pd=1.52u as=0 ps=0 w=0.42u l=1u
X1552 sg13g2_dfrbpq_1_2.CLK a_12020_15202# VDD VDD sg13_lv_pmos ad=0.2128p pd=1.5u as=0.2128p ps=1.5u w=1.12u l=0.13u
X1553 VSS.t749 VDD VSS.t752 VSS.t875 sg13_lv_nmos ad=79.8f pd=0.8u as=0 ps=0 w=0.42u l=1u
X1554 VDD VSS.t2243 VDD VDD sg13_lv_pmos ad=0.19p pd=1.38u as=0 ps=0 w=1u l=1u
X1555 VSS.t147 a_2540_15960# counter_value_o[0] VSS.t146 sg13_lv_nmos ad=0.14875p pd=1.16u as=0.2886p ps=2.26u w=0.74u l=0.13u
X1556 a_25670_14922# a_26475_14495# a_25930_14452# VDD sg13_lv_pmos ad=0.1428p pd=1.52u as=79.8f ps=0.8u w=0.42u l=0.13u
X1557 VSS.t1115 VDD VSS.t1114 VSS.t1113 sg13_lv_nmos ad=0.1428p pd=1.52u as=0 ps=0 w=0.42u l=1u
X1558 VSS.t2478 VDD VSS.t2480 VSS.t2479 sg13_lv_nmos ad=79.8f pd=0.8u as=0 ps=0 w=0.42u l=1u
X1559 VDD VSS.t183 VDD VDD sg13_lv_pmos ad=0.34p pd=2.68u as=0 ps=0 w=1u l=1u
X1560 VDD VSS.t1097 VDD VDD sg13_lv_pmos ad=0.19p pd=1.38u as=0 ps=0 w=1u l=1u
X1561 VDD VSS.t1576 VDD VDD sg13_lv_pmos ad=0.19p pd=1.38u as=0 ps=0 w=1u l=1u
X1562 VSS.t413 enable_i a_1192_3900# VSS.t412 sg13_lv_nmos ad=0.14875p pd=1.16u as=0.187p ps=1.78u w=0.55u l=0.13u
X1563 VSS.t1328 VDD VSS.t1329 VSS.t377 sg13_lv_nmos ad=79.8f pd=0.8u as=0 ps=0 w=0.42u l=1u
X1564 VSS.t147 VDD VSS.t147 VSS.t434 sg13_lv_nmos ad=0.1428p pd=1.52u as=0 ps=0 w=0.42u l=1u
X1565 VSS.t106 VDD VSS.t106 VSS.t571 sg13_lv_nmos ad=0.1428p pd=1.52u as=0 ps=0 w=0.42u l=1u
X1566 VSS.t3025 VDD VSS.t3024 VSS.t3023 sg13_lv_nmos ad=0.1428p pd=1.52u as=0 ps=0 w=0.42u l=1u
X1567 VDD VSS.t547 VDD VDD sg13_lv_pmos ad=0.19p pd=1.38u as=0 ps=0 w=1u l=1u
X1568 VSS.t50 a_12020_15202# sg13g2_dfrbpq_1_2.CLK VSS.t58 sg13_lv_nmos ad=0.1406p pd=1.12u as=0.1406p ps=1.12u w=0.74u l=0.13u
X1569 sg13g2_dfrbpq_1_5.D a_25206_14508# VDD VDD sg13_lv_pmos ad=0.4256p pd=3u as=0.2254p ps=1.53u w=1.12u l=0.13u
X1570 VDD sg13g2_or3_1_1.A a_25037_14020# VDD sg13_lv_pmos ad=0.3822p pd=1.84u as=0.1575p ps=1.315u w=1u l=0.13u
X1571 VDD VSS.t1412 VDD VDD sg13_lv_pmos ad=0.34p pd=2.68u as=0 ps=0 w=1u l=1u
X1572 VDD VSS.t2610 VDD VDD sg13_lv_pmos ad=0.19p pd=1.38u as=0 ps=0 w=1u l=1u
X1573 VSS.t181 sg13g2_o21ai_1_2.B1 a_24169_14508# VSS.t30 sg13_lv_nmos ad=0.13395p pd=1.12u as=0.198p ps=1.27u w=0.55u l=0.13u
X1574 VDD VSS.t2792 VDD VDD sg13_lv_pmos ad=0.34p pd=2.68u as=0 ps=0 w=1u l=1u
X1575 VSS.t1594 VDD VSS.t1593 VSS.t1592 sg13_lv_nmos ad=0.1428p pd=1.52u as=0 ps=0 w=0.42u l=1u
X1576 VSS.t920 VDD VSS.t922 VSS.t921 sg13_lv_nmos ad=79.8f pd=0.8u as=0 ps=0 w=0.42u l=1u
X1577 VSS.t990 VDD VSS.t992 VSS.t991 sg13_lv_nmos ad=79.8f pd=0.8u as=0 ps=0 w=0.42u l=1u
X1578 VDD VSS.t979 VDD VDD sg13_lv_pmos ad=0.34p pd=2.68u as=0 ps=0 w=1u l=1u
X1579 VSS.t2156 VDD VSS.t2155 VSS.t2154 sg13_lv_nmos ad=0.1428p pd=1.52u as=0 ps=0 w=0.42u l=1u
X1580 a_4594_15234# sg13g2_dfrbpq_1_0.RESET_B VSS.t95 VSS.t317 sg13_lv_nmos ad=37.8f pd=0.6u as=79.8f ps=0.8u w=0.42u l=0.13u
X1581 a_5707_14832# sg13g2_buf_1_10.X a_5613_14832# VSS.t290 sg13_lv_nmos ad=0.1216p pd=1.02u as=0.2176p ps=1.96u w=0.64u l=0.13u
X1582 sg13g2_and2_1_2.X a_8685_14832# VDD VDD sg13_lv_pmos ad=0.3808p pd=2.92u as=0.1918p ps=1.5u w=1.12u l=0.13u
X1583 sg13g2_buf_16_2.X a_19438_13726# VDD VDD sg13_lv_pmos ad=0.2128p pd=1.5u as=0.2128p ps=1.5u w=1.12u l=0.13u
X1584 VSS.t1589 VDD VSS.t1588 VSS.t1587 sg13_lv_nmos ad=0.1428p pd=1.52u as=0 ps=0 w=0.42u l=1u
X1585 a_6598_14909# sg13g2_dfrbpq_1_1.RESET_B VSS.t106 VSS.t279 sg13_lv_nmos ad=37.8f pd=0.6u as=0.1701p ps=1.65u w=0.42u l=0.13u
X1586 VSS.t2776 VDD VSS.t2774 VSS.t412 sg13_lv_nmos ad=0.1428p pd=1.52u as=0 ps=0 w=0.42u l=1u
X1587 VSS.t2498 VDD VSS.t2497 VSS.t2496 sg13_lv_nmos ad=0.1428p pd=1.52u as=0 ps=0 w=0.42u l=1u
X1588 VSS.t731 VDD VSS.t731 VSS.t862 sg13_lv_nmos ad=0.1428p pd=1.52u as=0 ps=0 w=0.42u l=1u
X1589 VSS.t1759 VDD VSS.t1761 VSS.t1760 sg13_lv_nmos ad=79.8f pd=0.8u as=0 ps=0 w=0.42u l=1u
X1590 VDD VSS.t214 VDD VDD sg13_lv_pmos ad=0.19p pd=1.38u as=0 ps=0 w=1u l=1u
X1591 VDD VSS.t2070 VDD VDD sg13_lv_pmos ad=0.34p pd=2.68u as=0 ps=0 w=1u l=1u
X1592 VDD VSS.t1291 VDD VDD sg13_lv_pmos ad=0.34p pd=2.68u as=0 ps=0 w=1u l=1u
X1593 a_9444_15552# a_9418_15457# VDD VDD sg13_lv_pmos ad=0.34p pd=2.68u as=0.36237p ps=2.605u w=1u l=0.13u
X1594 VSS.t255 a_26170_15202# a_25889_15424# VSS.t340 sg13_lv_nmos ad=79.8f pd=0.8u as=0.1428p ps=1.52u w=0.42u l=0.5u
X1595 VDD VSS.t1042 VDD VDD sg13_lv_pmos ad=0.19p pd=1.38u as=0 ps=0 w=1u l=1u
X1596 VSS.t1302 VDD VSS.t1301 VSS.t377 sg13_lv_nmos ad=0.1428p pd=1.52u as=0 ps=0 w=0.42u l=1u
X1597 VDD VSS.t3197 VDD VDD sg13_lv_pmos ad=0.19p pd=1.38u as=0 ps=0 w=1u l=1u
X1598 VDD VSS.t2405 VDD VDD sg13_lv_pmos ad=0.19p pd=1.38u as=0 ps=0 w=1u l=1u
X1599 VSS.t2126 VDD VSS.t2128 VSS.t2127 sg13_lv_nmos ad=79.8f pd=0.8u as=0 ps=0 w=0.42u l=1u
X1600 VSS.t2980 VDD VSS.t2850 VSS.t412 sg13_lv_nmos ad=0.1428p pd=1.52u as=0 ps=0 w=0.42u l=1u
X1601 VSS.t3215 VDD VSS.t3217 VSS.t3216 sg13_lv_nmos ad=79.8f pd=0.8u as=0 ps=0 w=0.42u l=1u
X1602 VDD VSS.t2437 VDD VDD sg13_lv_pmos ad=0.34p pd=2.68u as=0 ps=0 w=1u l=1u
X1603 VDD VSS.t1756 VDD VDD sg13_lv_pmos ad=0.19p pd=1.38u as=0 ps=0 w=1u l=1u
X1604 VSS.t960 VDD VSS.t959 VSS.t958 sg13_lv_nmos ad=0.1428p pd=1.52u as=0 ps=0 w=0.42u l=1u
X1605 VDD VSS.t942 VDD VDD sg13_lv_pmos ad=0.19p pd=1.38u as=0 ps=0 w=1u l=1u
X1606 VSS.t2046 VDD VSS.t2045 VSS.t2044 sg13_lv_nmos ad=0.1428p pd=1.52u as=0 ps=0 w=0.42u l=1u
X1607 sg13g2_nand4_1_0.Y sg13g2_buf_1_0.X VDD VDD sg13_lv_pmos ad=0.2128p pd=1.5u as=0.2128p ps=1.5u w=1.12u l=0.13u
X1608 a_6578_15242# sg13g2_dlygate4sd3_1_3.A VSS.t106 VSS.t258 sg13_lv_nmos ad=0.1406p pd=1.12u as=0.2886p ps=2.26u w=0.74u l=0.13u
X1609 VSS.t588 VDD VSS.t589 VSS.t33 sg13_lv_nmos ad=79.8f pd=0.8u as=0 ps=0 w=0.42u l=1u
X1610 VDD VSS.t1708 VDD VDD sg13_lv_pmos ad=0.34p pd=2.68u as=0 ps=0 w=1u l=1u
X1611 VSS.t2799 VDD VSS.t2799 VSS.t412 sg13_lv_nmos ad=0.1428p pd=1.52u as=0 ps=0 w=0.42u l=1u
X1612 VDD VSS.t2762 VDD VDD sg13_lv_pmos ad=0.34p pd=2.68u as=0 ps=0 w=1u l=1u
X1613 VDD VSS.t524 VDD VDD sg13_lv_pmos ad=0.34p pd=2.68u as=0 ps=0 w=1u l=1u
X1614 VDD VSS.t1057 VDD VDD sg13_lv_pmos ad=0.19p pd=1.38u as=0 ps=0 w=1u l=1u
X1615 VSS.t1351 VDD VSS.t1350 VSS.t377 sg13_lv_nmos ad=0.1428p pd=1.52u as=0 ps=0 w=0.42u l=1u
X1616 a_18863_14845# a_18021_14495# a_17604_14488# VDD sg13_lv_pmos ad=0.2048p pd=1.63u as=0.34p ps=2.68u w=1u l=0.13u
X1617 sg13g2_buf_16_2.X a_19438_13726# VDD VDD sg13_lv_pmos ad=0.2128p pd=1.5u as=0.2128p ps=1.5u w=1.12u l=0.13u
X1618 VSS.t1779 VDD VSS.t1781 VSS.t1780 sg13_lv_nmos ad=79.8f pd=0.8u as=0 ps=0 w=0.42u l=1u
X1619 VDD VSS.t2622 VDD VDD sg13_lv_pmos ad=0.34p pd=2.68u as=0 ps=0 w=1u l=1u
X1620 VDD VSS.t2445 VDD VDD sg13_lv_pmos ad=0.19p pd=1.38u as=0 ps=0 w=1u l=1u
X1621 VSS.t302 VDD VSS.t302 VSS.t682 sg13_lv_nmos ad=0.1428p pd=1.52u as=0 ps=0 w=0.42u l=1u
X1622 VDD VSS.t2868 VDD VDD sg13_lv_pmos ad=0.34p pd=2.68u as=0 ps=0 w=1u l=1u
X1623 VSS.t142 a_27215_14845# a_27882_14484# VSS.t33 sg13_lv_nmos ad=0.1406p pd=1.12u as=0.2516p ps=2.16u w=0.74u l=0.13u
X1624 VSS.t1394 VDD VSS.t1393 VSS.t377 sg13_lv_nmos ad=0.1428p pd=1.52u as=0 ps=0 w=0.42u l=1u
X1625 VDD VSS.t1405 VDD VDD sg13_lv_pmos ad=0.19p pd=1.38u as=0 ps=0 w=1u l=1u
X1626 VDD VSS.t2228 VDD VDD sg13_lv_pmos ad=0.19p pd=1.38u as=0 ps=0 w=1u l=1u
X1627 VSS.t35 VDD VSS.t100 VSS.t690 sg13_lv_nmos ad=79.8f pd=0.8u as=0 ps=0 w=0.42u l=1u
X1628 VSS.t740 VDD VSS.t740 VSS.t741 sg13_lv_nmos ad=79.8f pd=0.8u as=0 ps=0 w=0.42u l=1u
X1629 sg13g2_a21oi_1_3.Y sg13g2_a21oi_1_0.B1 a_25109_12972# VDD sg13_lv_pmos ad=0.3808p pd=2.92u as=0.2128p ps=1.5u w=1.12u l=0.13u
X1630 VSS.t1090 VDD VSS.t1092 VSS.t1091 sg13_lv_nmos ad=79.8f pd=0.8u as=0 ps=0 w=0.42u l=1u
X1631 a_26373_16033# a_26373_16033# VSS.t3 VSS.t278 sg13_lv_nmos ad=0.111p pd=1.34u as=5.24677p ps=34.365u w=0.3u l=0.13u
X1632 a_4377_15549# a_3435_15356# a_4175_15311# VDD sg13_lv_pmos ad=93.45f pd=0.865u as=0.2048p ps=1.63u w=0.42u l=0.13u
X1633 VSS.t597 VDD VSS.t598 VSS.t33 sg13_lv_nmos ad=79.8f pd=0.8u as=0 ps=0 w=0.42u l=1u
X1634 VDD VSS.t3149 VDD VDD sg13_lv_pmos ad=0.34p pd=2.68u as=0 ps=0 w=1u l=1u
X1635 VSS.t2358 VDD VSS.t2360 VSS.t2359 sg13_lv_nmos ad=79.8f pd=0.8u as=0 ps=0 w=0.42u l=1u
X1636 VSS.t920 VDD VSS.t922 VSS.t921 sg13_lv_nmos ad=79.8f pd=0.8u as=0 ps=0 w=0.42u l=1u
X1637 VDD VSS.t2595 VDD VDD sg13_lv_pmos ad=0.19p pd=1.38u as=0 ps=0 w=1u l=1u
X1638 VDD VSS.t1776 VDD VDD sg13_lv_pmos ad=0.19p pd=1.38u as=0 ps=0 w=1u l=1u
X1639 VSS.t460 VDD VSS.t271 VSS.t459 sg13_lv_nmos ad=0.1428p pd=1.52u as=0 ps=0 w=0.42u l=1u
X1640 VDD VSS.t46 VDD VDD sg13_lv_pmos ad=0.19p pd=1.38u as=0 ps=0 w=1u l=1u
X1641 VSS.t1579 VDD VSS.t1578 VSS.t1577 sg13_lv_nmos ad=0.1428p pd=1.52u as=0 ps=0 w=0.42u l=1u
X1642 VSS.t1402 VDD VSS.t1401 VSS.t377 sg13_lv_nmos ad=0.1428p pd=1.52u as=0 ps=0 w=0.42u l=1u
X1643 VDD VSS.t2754 VDD VDD sg13_lv_pmos ad=0.34p pd=2.68u as=0 ps=0 w=1u l=1u
X1644 a_17900_15960# sg13g2_dfrbpq_1_2.Q VSS.t134 VSS.t133 sg13_lv_nmos ad=0.187p pd=1.78u as=0.14875p ps=1.16u w=0.55u l=0.13u
X1645 a_7680_15549# sg13g2_nand3_1_0.Y a_7643_15280# VSS.t80 sg13_lv_nmos ad=0.2176p pd=1.96u as=78.39999f ps=0.885u w=0.64u l=0.13u
X1646 sg13g2_dfrbpq_1_6.Q a_22986_14484# VDD VDD sg13_lv_pmos ad=0.3808p pd=2.92u as=0.2128p ps=1.5u w=1.12u l=0.13u
X1647 sg13g2_buf_16_2.X a_19438_13726# VSS.t384 VSS.t389 sg13_lv_nmos ad=0.1406p pd=1.12u as=0.1406p ps=1.12u w=0.74u l=0.13u
X1648 VSS.t2141 VDD VSS.t2140 VSS.t2139 sg13_lv_nmos ad=0.1428p pd=1.52u as=0 ps=0 w=0.42u l=1u
X1649 VDD VSS.t1326 VDD VDD sg13_lv_pmos ad=0.34p pd=2.68u as=0 ps=0 w=1u l=1u
X1650 VDD VSS.t1297 VDD VDD sg13_lv_pmos ad=0.19p pd=1.38u as=0 ps=0 w=1u l=1u
X1651 VSS.t1574 VDD VSS.t1573 VSS.t1572 sg13_lv_nmos ad=0.1428p pd=1.52u as=0 ps=0 w=0.42u l=1u
X1652 VSS.t1542 VDD VSS.t1405 VSS.t377 sg13_lv_nmos ad=0.1428p pd=1.52u as=0 ps=0 w=0.42u l=1u
X1653 VSS.t2767 VDD VSS.t2766 VSS.t412 sg13_lv_nmos ad=0.1428p pd=1.52u as=0 ps=0 w=0.42u l=1u
X1654 VSS.t449 VDD VSS.t448 VSS.t447 sg13_lv_nmos ad=0.1428p pd=1.52u as=0 ps=0 w=0.42u l=1u
X1655 VSS.t2959 VDD VSS.t2960 VSS.t412 sg13_lv_nmos ad=79.8f pd=0.8u as=0 ps=0 w=0.42u l=1u
X1656 VSS.t2578 VDD VSS.t2577 VSS.t2576 sg13_lv_nmos ad=0.1428p pd=1.52u as=0 ps=0 w=0.42u l=1u
X1657 VSS.t2483 VDD VSS.t2485 VSS.t2484 sg13_lv_nmos ad=79.8f pd=0.8u as=0 ps=0 w=0.42u l=1u
X1658 VDD VSS.t3182 VDD VDD sg13_lv_pmos ad=0.19p pd=1.38u as=0 ps=0 w=1u l=1u
X1659 VDD VSS.t2390 VDD VDD sg13_lv_pmos ad=0.19p pd=1.38u as=0 ps=0 w=1u l=1u
X1660 a_9444_15552# a_9418_15457# VSS.t19 VSS.t4 sg13_lv_nmos ad=0.2516p pd=2.16u as=0.1626p ps=1.415u w=0.74u l=0.13u
X1661 VSS.t14 VDD VSS.t14 VSS.t844 sg13_lv_nmos ad=79.8f pd=0.8u as=0 ps=0 w=0.42u l=1u
X1662 VSS.t574 VDD VSS.t31 VSS.t28 sg13_lv_nmos ad=0.1428p pd=1.52u as=0 ps=0 w=0.42u l=1u
X1663 VDD VSS.t725 VDD VDD sg13_lv_pmos ad=0.34p pd=2.68u as=0 ps=0 w=1u l=1u
X1664 VSS.t2973 VDD VSS.t2842 VSS.t412 sg13_lv_nmos ad=0.1428p pd=1.52u as=0 ps=0 w=0.42u l=1u
X1665 sg13g2_a21oi_1_0.B1 sg13g2_buf_1_10.X VSS.t246 VSS.t292 sg13_lv_nmos ad=0.2516p pd=2.16u as=0.2516p ps=2.16u w=0.74u l=0.13u
X1666 VDD VSS.t302 VDD VDD sg13_lv_pmos ad=0.19p pd=1.38u as=0 ps=0 w=1u l=1u
X1667 VDD VSS.t2580 VDD VDD sg13_lv_pmos ad=0.19p pd=1.38u as=0 ps=0 w=1u l=1u
X1668 VSS.t1120 VDD VSS.t1122 VSS.t1121 sg13_lv_nmos ad=79.8f pd=0.8u as=0 ps=0 w=0.42u l=1u
X1669 VDD VSS.t1306 VDD VDD sg13_lv_pmos ad=0.19p pd=1.38u as=0 ps=0 w=1u l=1u
X1670 a_20774_14922# sg13g2_dfrbpq_1_6.D VDD VDD sg13_lv_pmos ad=79.8f pd=0.8u as=0.1428p ps=1.52u w=0.42u l=0.13u
X1671 VDD sg13g2_xor2_1_0.B a_2516_14484# VDD sg13_lv_pmos ad=0.2128p pd=1.5u as=0.2128p ps=1.5u w=1.12u l=0.13u
X1672 VSS.t1769 VDD VSS.t1771 VSS.t1770 sg13_lv_nmos ad=79.8f pd=0.8u as=0 ps=0 w=0.42u l=1u
X1673 VSS.t3295 VDD VSS.t3297 VSS.t3296 sg13_lv_nmos ad=79.8f pd=0.8u as=0 ps=0 w=0.42u l=1u
X1674 a_17327_13799# a_16485_13701# a_17233_13799# VSS.t360 sg13_lv_nmos ad=0.12665p pd=1.145u as=0.1428p ps=1.52u w=0.42u l=0.13u
X1675 VDD VSS.t1693 VDD VDD sg13_lv_pmos ad=0.34p pd=2.68u as=0 ps=0 w=1u l=1u
X1676 VSS.t2161 VDD VSS.t2160 VSS.t2159 sg13_lv_nmos ad=0.1428p pd=1.52u as=0 ps=0 w=0.42u l=1u
X1677 sg13g2_buf_16_2.X a_19438_13726# VSS.t384 VSS.t385 sg13_lv_nmos ad=0.1406p pd=1.12u as=0.1406p ps=1.12u w=0.74u l=0.13u
X1678 VDD VSS.t513 VDD VDD sg13_lv_pmos ad=0.34p pd=2.68u as=0 ps=0 w=1u l=1u
X1679 VDD VSS.t924 VDD VDD sg13_lv_pmos ad=0.34p pd=2.68u as=0 ps=0 w=1u l=1u
X1680 VDD VSS.t2607 VDD VDD sg13_lv_pmos ad=0.34p pd=2.68u as=0 ps=0 w=1u l=1u
X1681 VSS.t1764 VDD VSS.t1766 VSS.t1765 sg13_lv_nmos ad=79.8f pd=0.8u as=0 ps=0 w=0.42u l=1u
X1682 VSS.t1419 VDD VSS.t1419 VSS.t377 sg13_lv_nmos ad=0.1428p pd=1.52u as=0 ps=0 w=0.42u l=1u
X1683 VDD VSS.t2635 VDD VDD sg13_lv_pmos ad=0.19p pd=1.38u as=0 ps=0 w=1u l=1u
X1684 VDD VSS.t2075 VDD VDD sg13_lv_pmos ad=0.34p pd=2.68u as=0 ps=0 w=1u l=1u
X1685 VSS.t1 a_21562_15960# a_21281_16262# VSS.t308 sg13_lv_nmos ad=79.8f pd=0.8u as=0.1428p ps=1.52u w=0.42u l=0.5u
X1686 a_2490_14447# sg13g2_xor2_1_0.B VSS.t40 VSS.t162 sg13_lv_nmos ad=0.17462p pd=1.185u as=0.15245p ps=1.17u w=0.55u l=0.13u
X1687 VSS.t1090 VDD VSS.t1092 VSS.t1091 sg13_lv_nmos ad=79.8f pd=0.8u as=0 ps=0 w=0.42u l=1u
X1688 VDD VSS.t1294 VDD VDD sg13_lv_pmos ad=0.34p pd=2.68u as=0 ps=0 w=1u l=1u
X1689 VSS.t510 VDD VSS.t509 VSS.t508 sg13_lv_nmos ad=0.1428p pd=1.52u as=0 ps=0 w=0.42u l=1u
X1690 VDD VSS.t3202 VDD VDD sg13_lv_pmos ad=0.19p pd=1.38u as=0 ps=0 w=1u l=1u
X1691 VDD VSS.t2410 VDD VDD sg13_lv_pmos ad=0.19p pd=1.38u as=0 ps=0 w=1u l=1u
X1692 VSS.t2241 VDD VSS.t2243 VSS.t2242 sg13_lv_nmos ad=79.8f pd=0.8u as=0 ps=0 w=0.42u l=1u
X1693 VSS.t480 VDD VSS.t475 VSS.t479 sg13_lv_nmos ad=0.1428p pd=1.52u as=0 ps=0 w=0.42u l=1u
X1694 VDD VSS.t616 VDD VDD sg13_lv_pmos ad=0.19p pd=1.38u as=0 ps=0 w=1u l=1u
X1695 sg13g2_and2_1_1.X a_5613_14832# VDD VDD sg13_lv_pmos ad=0.3808p pd=2.92u as=0.1918p ps=1.5u w=1.12u l=0.13u
X1696 VDD VSS.t977 VDD VDD sg13_lv_pmos ad=0.19p pd=1.38u as=0 ps=0 w=1u l=1u
X1697 VDD VSS.t1397 VDD VDD sg13_lv_pmos ad=0.19p pd=1.38u as=0 ps=0 w=1u l=1u
X1698 VSS.t2966 VDD VSS.t2835 VSS.t412 sg13_lv_nmos ad=0.1428p pd=1.52u as=0 ps=0 w=0.42u l=1u
X1699 VDD VSS.t2083 VDD VDD sg13_lv_pmos ad=0.19p pd=1.38u as=0 ps=0 w=1u l=1u
X1700 VSS.t124 a_27500_15960# counter_value_o[5] VSS.t123 sg13_lv_nmos ad=0.14875p pd=1.16u as=0.2886p ps=2.26u w=0.74u l=0.13u
X1701 VDD VSS.t1142 VDD VDD sg13_lv_pmos ad=0.19p pd=1.38u as=0 ps=0 w=1u l=1u
X1702 VDD VSS.t1706 VDD VDD sg13_lv_pmos ad=0.19p pd=1.38u as=0 ps=0 w=1u l=1u
X1703 VDD VSS.t3229 VDD VDD sg13_lv_pmos ad=0.34p pd=2.68u as=0 ps=0 w=1u l=1u
X1704 VSS.t2191 VDD VSS.t2193 VSS.t2192 sg13_lv_nmos ad=79.8f pd=0.8u as=0 ps=0 w=0.42u l=1u
X1705 VSS.t3280 VDD VSS.t3282 VSS.t3281 sg13_lv_nmos ad=79.8f pd=0.8u as=0 ps=0 w=0.42u l=1u
X1706 a_4432_15454# a_4175_15311# a_4594_15234# VSS.t104 sg13_lv_nmos ad=0.1428p pd=1.52u as=37.8f ps=0.6u w=0.42u l=0.13u
X1707 VSS.t2802 VDD VSS.t2801 VSS.t412 sg13_lv_nmos ad=0.1428p pd=1.52u as=0 ps=0 w=0.42u l=1u
X1708 VSS.t1010 VDD VSS.t1012 VSS.t1011 sg13_lv_nmos ad=79.8f pd=0.8u as=0 ps=0 w=0.42u l=1u
X1709 a_6202_15238# sg13g2_dlygate4sd3_1_3.A VSS.t106 VSS.t259 sg13_lv_nmos ad=0.1406p pd=1.12u as=0.2516p ps=2.16u w=0.74u l=0.13u
X1710 sg13g2_dfrbpq_1_6.Q a_22986_14484# VSS.t31 VSS.t30 sg13_lv_nmos ad=0.2516p pd=2.16u as=0.1406p ps=1.12u w=0.74u l=0.13u
X1711 VDD VSS.t1079 VDD VDD sg13_lv_pmos ad=0.34p pd=2.68u as=0 ps=0 w=1u l=1u
X1712 a_7829_15238# sg13g2_nand3_1_0.Y VSS.t82 VSS.t81 sg13_lv_nmos ad=0.1406p pd=1.12u as=0.1898p ps=1.36u w=0.74u l=0.13u
X1713 VSS.t22 a_10618_14448# a_10337_14750# VSS.t296 sg13_lv_nmos ad=79.8f pd=0.8u as=0.1428p ps=1.52u w=0.42u l=0.5u
X1714 VDD VSS.t2450 VDD VDD sg13_lv_pmos ad=0.19p pd=1.38u as=0 ps=0 w=1u l=1u
X1715 VDD VSS.t2108 VDD VDD sg13_lv_pmos ad=0.19p pd=1.38u as=0 ps=0 w=1u l=1u
X1716 VSS.t2111 VDD VSS.t2110 VSS.t2109 sg13_lv_nmos ad=0.1428p pd=1.52u as=0 ps=0 w=0.42u l=1u
X1717 VDD sg13g2_or3_1_2.A sg13g2_o21ai_1_1.Y VDD sg13_lv_pmos ad=0.3808p pd=2.92u as=0.2128p ps=1.5u w=1.12u l=0.15u
X1718 VSS.t1433 VDD VSS.t1432 VSS.t377 sg13_lv_nmos ad=0.1428p pd=1.52u as=0 ps=0 w=0.42u l=1u
X1719 a_2630_15234# sg13g2_and2_1_0.X VDD VDD sg13_lv_pmos ad=79.8f pd=0.8u as=0.1428p ps=1.52u w=0.42u l=0.13u
X1720 VDD VSS.t2233 VDD VDD sg13_lv_pmos ad=0.19p pd=1.38u as=0 ps=0 w=1u l=1u
X1721 VSS.t2468 VDD VSS.t2470 VSS.t2469 sg13_lv_nmos ad=79.8f pd=0.8u as=0 ps=0 w=0.42u l=1u
X1722 a_6372_14488# a_6346_14452# VSS.t106 VSS.t191 sg13_lv_nmos ad=0.2516p pd=2.16u as=0.1626p ps=1.415u w=0.74u l=0.13u
X1723 VSS.t2021 VDD VSS.t2023 VSS.t2022 sg13_lv_nmos ad=79.8f pd=0.8u as=0 ps=0 w=0.42u l=1u
X1724 VDD VSS.t596 VDD VDD sg13_lv_pmos ad=0.34p pd=2.68u as=0 ps=0 w=1u l=1u
X1725 VSS.t2870 VDD VSS.t2871 VSS.t412 sg13_lv_nmos ad=79.8f pd=0.8u as=0 ps=0 w=0.42u l=1u
X1726 VDD a_14357_15238# sg13g2_or3_1_1.B VDD sg13_lv_pmos ad=0.2128p pd=1.5u as=0.2128p ps=1.5u w=1.12u l=0.13u
X1727 VDD VSS.t763 VDD VDD sg13_lv_pmos ad=0.34p pd=2.68u as=0 ps=0 w=1u l=1u
X1728 VDD VSS.t522 VDD VDD sg13_lv_pmos ad=0.19p pd=1.38u as=0 ps=0 w=1u l=1u
X1729 VSS.t1120 VDD VSS.t1122 VSS.t1121 sg13_lv_nmos ad=79.8f pd=0.8u as=0 ps=0 w=0.42u l=1u
X1730 VDD VSS.t1378 VDD VDD sg13_lv_pmos ad=0.34p pd=2.68u as=0 ps=0 w=1u l=1u
X1731 VSS.t3 a_26249_16334# a_26170_16237# VSS.t211 sg13_lv_nmos ad=5.24677p pd=34.365u as=0.27427p ps=2.28u w=0.795u l=0.13u
X1732 a_8050_14922# sg13g2_dfrbpq_1_1.RESET_B VSS.t82 VSS.t280 sg13_lv_nmos ad=37.8f pd=0.6u as=79.8f ps=0.8u w=0.42u l=0.13u
X1733 VDD VSS.t302 VDD VDD sg13_lv_pmos ad=0.19p pd=1.38u as=0 ps=0 w=1u l=1u
X1734 VDD VSS.t1094 VDD VDD sg13_lv_pmos ad=0.34p pd=2.68u as=0 ps=0 w=1u l=1u
X1735 VDD VSS.t1746 VDD VDD sg13_lv_pmos ad=0.19p pd=1.38u as=0 ps=0 w=1u l=1u
X1736 VDD VSS.t3214 VDD VDD sg13_lv_pmos ad=0.34p pd=2.68u as=0 ps=0 w=1u l=1u
X1737 VDD VSS.t2422 VDD VDD sg13_lv_pmos ad=0.34p pd=2.68u as=0 ps=0 w=1u l=1u
X1738 VSS.t980 VDD VSS.t979 VSS.t978 sg13_lv_nmos ad=0.1428p pd=1.52u as=0 ps=0 w=0.42u l=1u
X1739 VSS.t1476 VDD VSS.t1322 VSS.t377 sg13_lv_nmos ad=79.8f pd=0.8u as=0 ps=0 w=0.42u l=1u
X1740 VDD VSS.t2756 VDD VDD sg13_lv_pmos ad=0.34p pd=2.68u as=0 ps=0 w=1u l=1u
X1741 VDD VSS.t2028 VDD VDD sg13_lv_pmos ad=0.19p pd=1.38u as=0 ps=0 w=1u l=1u
X1742 VDD VSS.t2853 VDD VDD sg13_lv_pmos ad=0.19p pd=1.38u as=0 ps=0 w=1u l=1u
X1743 VSS.t2146 VDD VSS.t2145 VSS.t2144 sg13_lv_nmos ad=0.1428p pd=1.52u as=0 ps=0 w=0.42u l=1u
X1744 VDD VSS.t1415 VDD VDD sg13_lv_pmos ad=0.19p pd=1.38u as=0 ps=0 w=1u l=1u
X1745 VSS.t1709 VDD VSS.t1708 VSS.t1707 sg13_lv_nmos ad=0.1428p pd=1.52u as=0 ps=0 w=0.42u l=1u
X1746 VSS.t3235 VDD VSS.t3234 VSS.t3233 sg13_lv_nmos ad=0.1428p pd=1.52u as=0 ps=0 w=0.42u l=1u
X1747 VSS.t763 VDD VSS.t766 VSS.t883 sg13_lv_nmos ad=79.8f pd=0.8u as=0 ps=0 w=0.42u l=1u
X1748 sg13g2_dlygate4sd3_1_8.A a_11370_15532# VDD VDD sg13_lv_pmos ad=0.3808p pd=2.92u as=0.2128p ps=1.5u w=1.12u l=0.13u
X1749 sg13g2_a21oi_1_1.Y sg13g2_a21oi_1_0.B1 VSS.t10 VSS.t9 sg13_lv_nmos ad=0.1406p pd=1.12u as=0.2516p ps=2.16u w=0.74u l=0.13u
X1750 VDD VSS.t2620 VDD VDD sg13_lv_pmos ad=0.19p pd=1.38u as=0 ps=0 w=1u l=1u
X1751 VDD VSS.t2060 VDD VDD sg13_lv_pmos ad=0.34p pd=2.68u as=0 ps=0 w=1u l=1u
X1752 VSS.t1040 VDD VSS.t1042 VSS.t1041 sg13_lv_nmos ad=79.8f pd=0.8u as=0 ps=0 w=0.42u l=1u
X1753 VSS.t2453 VDD VSS.t2455 VSS.t2454 sg13_lv_nmos ad=79.8f pd=0.8u as=0 ps=0 w=0.42u l=1u
X1754 VDD VSS.t907 VDD VDD sg13_lv_pmos ad=0.19p pd=1.38u as=0 ps=0 w=1u l=1u
X1755 VSS.t1844 VDD VSS.t1846 VSS.t1845 sg13_lv_nmos ad=79.8f pd=0.8u as=0 ps=0 w=0.42u l=1u
X1756 VDD VSS.t3187 VDD VDD sg13_lv_pmos ad=0.19p pd=1.38u as=0 ps=0 w=1u l=1u
X1757 VDD VSS.t2395 VDD VDD sg13_lv_pmos ad=0.19p pd=1.38u as=0 ps=0 w=1u l=1u
X1758 VSS.t465 VDD VSS.t465 VSS.t466 sg13_lv_nmos ad=79.8f pd=0.8u as=0 ps=0 w=0.42u l=1u
X1759 a_17030_15238# a_16760_15238# VSS.t24 VSS.t419 sg13_lv_nmos ad=0.1428p pd=1.52u as=79.8f ps=0.8u w=0.42u l=0.5u
X1760 VSS.t2226 VDD VSS.t2228 VSS.t2227 sg13_lv_nmos ad=79.8f pd=0.8u as=0 ps=0 w=0.42u l=1u
X1761 VDD VSS.t214 VDD VDD sg13_lv_pmos ad=0.19p pd=1.38u as=0 ps=0 w=1u l=1u
X1762 VSS.t940 VDD VSS.t942 VSS.t941 sg13_lv_nmos ad=79.8f pd=0.8u as=0 ps=0 w=0.42u l=1u
X1763 VSS.t2096 VDD VSS.t2098 VSS.t2097 sg13_lv_nmos ad=79.8f pd=0.8u as=0 ps=0 w=0.42u l=1u
X1764 VSS.t1010 VDD VSS.t1012 VSS.t1011 sg13_lv_nmos ad=79.8f pd=0.8u as=0 ps=0 w=0.42u l=1u
X1765 VDD VSS.t604 VDD VDD sg13_lv_pmos ad=0.19p pd=1.38u as=0 ps=0 w=1u l=1u
X1766 VDD VSS.t999 VDD VDD sg13_lv_pmos ad=0.34p pd=2.68u as=0 ps=0 w=1u l=1u
X1767 VSS.t1774 VDD VSS.t1776 VSS.t1775 sg13_lv_nmos ad=79.8f pd=0.8u as=0 ps=0 w=0.42u l=1u
X1768 VSS.t3265 VDD VSS.t3267 VSS.t3266 sg13_lv_nmos ad=79.8f pd=0.8u as=0 ps=0 w=0.42u l=1u
X1769 VSS.t1055 VDD VSS.t1057 VSS.t1056 sg13_lv_nmos ad=79.8f pd=0.8u as=0 ps=0 w=0.42u l=1u
X1770 VDD VSS.t1698 VDD VDD sg13_lv_pmos ad=0.34p pd=2.68u as=0 ps=0 w=1u l=1u
X1771 VDD VSS.t1578 VDD VDD sg13_lv_pmos ad=0.34p pd=2.68u as=0 ps=0 w=1u l=1u
X1772 VSS.t2794 VDD VSS.t2792 VSS.t412 sg13_lv_nmos ad=0.1428p pd=1.52u as=0 ps=0 w=0.42u l=1u
X1773 a_15022_14484# clock_i VSS.t16 VSS.t362 sg13_lv_nmos ad=0.1406p pd=1.12u as=0.2516p ps=2.16u w=0.74u l=0.13u
X1774 VDD VSS.t1124 VDD VDD sg13_lv_pmos ad=0.34p pd=2.68u as=0 ps=0 w=1u l=1u
X1775 VSS.t2378 VDD VSS.t2377 VSS.t2376 sg13_lv_nmos ad=0.1428p pd=1.52u as=0 ps=0 w=0.42u l=1u
X1776 VSS.t743 VDD VSS.t743 VSS.t870 sg13_lv_nmos ad=0.1428p pd=1.52u as=0 ps=0 w=0.42u l=1u
X1777 VDD a_22426_15202# a_22145_15424# VDD sg13_lv_pmos ad=0.1523p pd=1.38u as=0.34p ps=2.68u w=1u l=0.5u
X1778 VDD VSS.t2612 VDD VDD sg13_lv_pmos ad=0.34p pd=2.68u as=0 ps=0 w=1u l=1u
X1779 a_22508_15960# sg13g2_dfrbpq_1_3.Q VDD VDD sg13_lv_pmos ad=0.2856p pd=2.36u as=0.2114p ps=1.54u w=0.84u l=0.13u
X1780 VDD VSS.t1350 VDD VDD sg13_lv_pmos ad=0.19p pd=1.38u as=0 ps=0 w=1u l=1u
X1781 VSS.t1314 VDD VSS.t1313 VSS.t377 sg13_lv_nmos ad=0.1428p pd=1.52u as=0 ps=0 w=0.42u l=1u
X1782 VDD VSS.t14 VDD VDD sg13_lv_pmos ad=0.34p pd=2.68u as=0 ps=0 w=1u l=1u
X1783 VDD VSS.t1062 VDD VDD sg13_lv_pmos ad=0.19p pd=1.38u as=0 ps=0 w=1u l=1u
X1784 VSS.t1354 VDD VSS.t1355 VSS.t377 sg13_lv_nmos ad=79.8f pd=0.8u as=0 ps=0 w=0.42u l=1u
X1785 VDD VSS.t1399 VDD VDD sg13_lv_pmos ad=0.19p pd=1.38u as=0 ps=0 w=1u l=1u
X1786 VDD VSS.t2901 VDD VDD sg13_lv_pmos ad=0.19p pd=1.38u as=0 ps=0 w=1u l=1u
X1787 VSS.t2633 VDD VSS.t2632 VSS.t2631 sg13_lv_nmos ad=0.1428p pd=1.52u as=0 ps=0 w=0.42u l=1u
X1788 VSS.t1829 VDD VSS.t1831 VSS.t1830 sg13_lv_nmos ad=79.8f pd=0.8u as=0 ps=0 w=0.42u l=1u
X1789 VSS.t2006 VDD VSS.t2008 VSS.t2007 sg13_lv_nmos ad=79.8f pd=0.8u as=0 ps=0 w=0.42u l=1u
X1790 VDD VSS.t311 VDD VDD sg13_lv_pmos ad=0.34p pd=2.68u as=0 ps=0 w=1u l=1u
X1791 VSS.t1473 VDD VSS.t1318 VSS.t377 sg13_lv_nmos ad=0.1428p pd=1.52u as=0 ps=0 w=0.42u l=1u
X1792 VSS.t530 VDD VSS.t529 VSS.t528 sg13_lv_nmos ad=0.1428p pd=1.52u as=0 ps=0 w=0.42u l=1u
X1793 a_20218_15238# sg13g2_dfrbpq_1_2.Q VSS.t136 VSS.t9 sg13_lv_nmos ad=0.1406p pd=1.12u as=0.2516p ps=2.16u w=0.74u l=0.13u
X1794 sg13g2_o21ai_1_2.A2 sg13g2_dfrbpq_1_6.Q a_23480_15242# VSS.t28 sg13_lv_nmos ad=0.2516p pd=2.16u as=0.1406p ps=1.12u w=0.74u l=0.13u
X1795 VDD a_18863_14845# a_19120_14726# VDD sg13_lv_pmos ad=2.42015p pd=15.68u as=79.8f ps=0.8u w=0.42u l=0.13u
X1796 VSS.t1095 VDD VSS.t1097 VSS.t1096 sg13_lv_nmos ad=79.8f pd=0.8u as=0 ps=0 w=0.42u l=1u
X1797 VSS.t2838 VDD VSS.t2837 VSS.t412 sg13_lv_nmos ad=0.1428p pd=1.52u as=0 ps=0 w=0.42u l=1u
X1798 VDD VSS.t2088 VDD VDD sg13_lv_pmos ad=0.19p pd=1.38u as=0 ps=0 w=1u l=1u
X1799 VDD a_12020_15202# sg13g2_dfrbpq_1_2.CLK VDD sg13_lv_pmos ad=0.2128p pd=1.5u as=0.2128p ps=1.5u w=1.12u l=0.13u
X1800 VDD VSS.t577 VDD VDD sg13_lv_pmos ad=0.19p pd=1.38u as=0 ps=0 w=1u l=1u
X1801 VSS.t591 VDD VSS.t592 VSS.t33 sg13_lv_nmos ad=79.8f pd=0.8u as=0 ps=0 w=0.42u l=1u
X1802 VSS.t980 VDD VSS.t979 VSS.t978 sg13_lv_nmos ad=0.1428p pd=1.52u as=0 ps=0 w=0.42u l=1u
X1803 VDD VSS.t1731 VDD VDD sg13_lv_pmos ad=0.19p pd=1.38u as=0 ps=0 w=1u l=1u
X1804 VDD VSS.t3199 VDD VDD sg13_lv_pmos ad=0.34p pd=2.68u as=0 ps=0 w=1u l=1u
X1805 VDD VSS.t2407 VDD VDD sg13_lv_pmos ad=0.34p pd=2.68u as=0 ps=0 w=1u l=1u
X1806 VSS.t2196 VDD VSS.t2198 VSS.t2197 sg13_lv_nmos ad=79.8f pd=0.8u as=0 ps=0 w=0.42u l=1u
X1807 VDD sg13g2_dlygate4sd3_1_11.X a_20603_15532# VDD sg13_lv_pmos ad=0.2128p pd=1.5u as=0.2128p ps=1.5u w=1.12u l=0.13u
X1808 VSS.t2804 VDD VSS.t2804 VSS.t412 sg13_lv_nmos ad=0.1428p pd=1.52u as=0 ps=0 w=0.42u l=1u
X1809 VDD VSS.t413 VDD VDD sg13_lv_pmos ad=0.34p pd=2.68u as=0 ps=0 w=1u l=1u
X1810 VDD VSS.t1771 VDD VDD sg13_lv_pmos ad=0.19p pd=1.38u as=0 ps=0 w=1u l=1u
X1811 a_20376_14464# sg13g2_or3_1_2.B VDD VDD sg13_lv_pmos ad=0.2128p pd=1.5u as=0.3808p ps=2.92u w=1.12u l=0.15u
X1812 VDD VSS.t2113 VDD VDD sg13_lv_pmos ad=0.19p pd=1.38u as=0 ps=0 w=1u l=1u
X1813 sg13g2_dfrbpq_1_5.D a_25206_14508# VSS.t143 VSS.t30 sg13_lv_nmos ad=0.2516p pd=2.16u as=0.1426p ps=1.16u w=0.74u l=0.13u
X1814 VSS.t1040 VDD VSS.t1042 VSS.t1041 sg13_lv_nmos ad=79.8f pd=0.8u as=0 ps=0 w=0.42u l=1u
X1815 VDD VSS.t1029 VDD VDD sg13_lv_pmos ad=0.34p pd=2.68u as=0 ps=0 w=1u l=1u
X1816 VDD VSS.t1330 VDD VDD sg13_lv_pmos ad=0.34p pd=2.68u as=0 ps=0 w=1u l=1u
X1817 VSS.t1405 VDD VSS.t1404 VSS.t377 sg13_lv_nmos ad=0.1428p pd=1.52u as=0 ps=0 w=0.42u l=1u
X1818 VSS.t302 VDD VSS.t302 VSS.t676 sg13_lv_nmos ad=0.1428p pd=1.52u as=0 ps=0 w=0.42u l=1u
X1819 VSS.t1367 VDD VSS.t1368 VSS.t377 sg13_lv_nmos ad=79.8f pd=0.8u as=0 ps=0 w=0.42u l=1u
X1820 VDD VSS.t2893 VDD VDD sg13_lv_pmos ad=0.19p pd=1.38u as=0 ps=0 w=1u l=1u
X1821 VSS.t24 a_15022_14484# sg13g2_buf_16_2.A VSS.t239 sg13_lv_nmos ad=0.1406p pd=1.12u as=0.1406p ps=1.12u w=0.74u l=0.13u
X1822 VSS.t2618 VDD VSS.t2617 VSS.t2616 sg13_lv_nmos ad=0.1428p pd=1.52u as=0 ps=0 w=0.42u l=1u
X1823 VDD VSS.t534 VDD VDD sg13_lv_pmos ad=0.34p pd=2.68u as=0 ps=0 w=1u l=1u
X1824 VSS.t1991 VDD VSS.t1993 VSS.t1992 sg13_lv_nmos ad=79.8f pd=0.8u as=0 ps=0 w=0.42u l=1u
X1825 VDD a_27407_13799# a_28074_14020# VDD sg13_lv_pmos ad=0.2128p pd=1.5u as=0.3864p ps=2.93u w=1.12u l=0.13u
X1826 VSS.t1784 VDD VSS.t1783 VSS.t1782 sg13_lv_nmos ad=0.1428p pd=1.52u as=0 ps=0 w=0.42u l=1u
X1827 VSS.t940 VDD VSS.t942 VSS.t941 sg13_lv_nmos ad=79.8f pd=0.8u as=0 ps=0 w=0.42u l=1u
X1828 VDD VSS.t2475 VDD VDD sg13_lv_pmos ad=0.19p pd=1.38u as=0 ps=0 w=1u l=1u
X1829 VDD a_12020_15202# sg13g2_dfrbpq_1_2.CLK VDD sg13_lv_pmos ad=0.2128p pd=1.5u as=0.2128p ps=1.5u w=1.12u l=0.13u
X1830 VSS.t846 VDD VSS.t848 VSS.t847 sg13_lv_nmos ad=79.8f pd=0.8u as=0 ps=0 w=0.42u l=1u
X1831 VSS.t1055 VDD VSS.t1057 VSS.t1056 sg13_lv_nmos ad=79.8f pd=0.8u as=0 ps=0 w=0.42u l=1u
X1832 VDD VSS.t1405 VDD VDD sg13_lv_pmos ad=0.34p pd=2.68u as=0 ps=0 w=1u l=1u
X1833 VDD VSS.t1751 VDD VDD sg13_lv_pmos ad=0.19p pd=1.38u as=0 ps=0 w=1u l=1u
X1834 VSS.t2081 VDD VSS.t2083 VSS.t2082 sg13_lv_nmos ad=79.8f pd=0.8u as=0 ps=0 w=0.42u l=1u
X1835 VDD VSS.t2856 VDD VDD sg13_lv_pmos ad=0.19p pd=1.38u as=0 ps=0 w=1u l=1u
X1836 VSS.t2151 VDD VSS.t2150 VSS.t2149 sg13_lv_nmos ad=0.1428p pd=1.52u as=0 ps=0 w=0.42u l=1u
X1837 VDD VSS.t1309 VDD VDD sg13_lv_pmos ad=0.19p pd=1.38u as=0 ps=0 w=1u l=1u
X1838 VSS.t2363 VDD VSS.t2362 VSS.t2361 sg13_lv_nmos ad=0.1428p pd=1.52u as=0 ps=0 w=0.42u l=1u
X1839 VDD VSS.t595 VDD VDD sg13_lv_pmos ad=0.19p pd=1.38u as=0 ps=0 w=1u l=1u
X1840 VSS.t2759 VDD VSS.t2761 VSS.t412 sg13_lv_nmos ad=79.8f pd=0.8u as=0 ps=0 w=0.42u l=1u
X1841 a_21827_13690# sg13g2_or3_1_2.A VSS.t27 VSS.t67 sg13_lv_nmos ad=0.198p pd=1.27u as=0.13395p ps=1.12u w=0.55u l=0.13u
X1842 VDD VSS.t1778 VDD VDD sg13_lv_pmos ad=0.34p pd=2.68u as=0 ps=0 w=1u l=1u
X1843 VSS.t88 a_19054_15423# sg13g2_dlygate4sd3_1_6.X VSS.t9 sg13_lv_nmos ad=0.1426p pd=1.16u as=0.2516p ps=2.16u w=0.74u l=0.13u
X1844 VDD VSS.t1107 VDD VDD sg13_lv_pmos ad=0.19p pd=1.38u as=0 ps=0 w=1u l=1u
X1845 VDD VSS.t2625 VDD VDD sg13_lv_pmos ad=0.19p pd=1.38u as=0 ps=0 w=1u l=1u
X1846 VSS.t24 a_15022_14484# sg13g2_buf_16_2.A VSS.t235 sg13_lv_nmos ad=0.1406p pd=1.12u as=0.1406p ps=1.12u w=0.74u l=0.13u
X1847 a_16356_13735# a_16587_13844# a_16042_13945# VSS.t352 sg13_lv_nmos ad=0.2373p pd=1.97u as=79.8f ps=0.8u w=0.42u l=0.13u
X1848 a_16294_13735# sg13g2_dfrbpq_1_2.RESET_B VSS.t356 VSS.t3304 sg13_lv_nmos ad=37.8f pd=0.6u as=0.1701p ps=1.65u w=0.42u l=0.13u
X1849 a_25956_13722# sg13g2_dfrbpq_1_5.D a_25862_13722# VSS.t200 sg13_lv_nmos ad=60.89999f pd=0.71u as=0.1428p ps=1.52u w=0.42u l=0.13u
X1850 VDD VSS.t734 VDD VDD sg13_lv_pmos ad=0.19p pd=1.38u as=0 ps=0 w=1u l=1u
X1851 VSS.t1814 VDD VSS.t1816 VSS.t1815 sg13_lv_nmos ad=79.8f pd=0.8u as=0 ps=0 w=0.42u l=1u
X1852 VSS.t2231 VDD VSS.t2233 VSS.t2232 sg13_lv_nmos ad=79.8f pd=0.8u as=0 ps=0 w=0.42u l=1u
X1853 VSS.t975 VDD VSS.t977 VSS.t976 sg13_lv_nmos ad=79.8f pd=0.8u as=0 ps=0 w=0.42u l=1u
X1854 VDD VSS.t2125 VDD VDD sg13_lv_pmos ad=0.34p pd=2.68u as=0 ps=0 w=1u l=1u
X1855 VSS.t1095 VDD VSS.t1097 VSS.t1096 sg13_lv_nmos ad=79.8f pd=0.8u as=0 ps=0 w=0.42u l=1u
X1856 VSS.t100 VDD VSS.t100 VSS.t693 sg13_lv_nmos ad=0.1428p pd=1.52u as=0 ps=0 w=0.42u l=1u
X1857 VSS.t1140 VDD VSS.t1142 VSS.t1141 sg13_lv_nmos ad=79.8f pd=0.8u as=0 ps=0 w=0.42u l=1u
X1858 VDD VSS.t3252 VDD VDD sg13_lv_pmos ad=0.19p pd=1.38u as=0 ps=0 w=1u l=1u
X1859 VSS.t2830 VDD VSS.t2829 VSS.t412 sg13_lv_nmos ad=0.1428p pd=1.52u as=0 ps=0 w=0.42u l=1u
X1860 VDD VSS.t2073 VDD VDD sg13_lv_pmos ad=0.19p pd=1.38u as=0 ps=0 w=1u l=1u
X1861 VSS.t625 VDD VSS.t40 VSS.t624 sg13_lv_nmos ad=0.1428p pd=1.52u as=0 ps=0 w=0.42u l=1u
X1862 VDD VSS.t2823 VDD VDD sg13_lv_pmos ad=0.19p pd=1.38u as=0 ps=0 w=1u l=1u
X1863 VSS.t2488 VDD VSS.t2487 VSS.t2486 sg13_lv_nmos ad=0.1428p pd=1.52u as=0 ps=0 w=0.42u l=1u
X1864 VSS.t2181 VDD VSS.t2183 VSS.t2182 sg13_lv_nmos ad=79.8f pd=0.8u as=0 ps=0 w=0.42u l=1u
X1865 VSS.t1744 VDD VSS.t1746 VSS.t1745 sg13_lv_nmos ad=79.8f pd=0.8u as=0 ps=0 w=0.42u l=1u
X1866 VSS.t3270 VDD VSS.t3272 VSS.t3271 sg13_lv_nmos ad=79.8f pd=0.8u as=0 ps=0 w=0.42u l=1u
X1867 VDD VSS.t2420 VDD VDD sg13_lv_pmos ad=0.19p pd=1.38u as=0 ps=0 w=1u l=1u
X1868 VDD VSS.t1289 VDD VDD sg13_lv_pmos ad=0.34p pd=2.68u as=0 ps=0 w=1u l=1u
X1869 VSS.t2797 VDD VSS.t2796 VSS.t412 sg13_lv_nmos ad=0.1428p pd=1.52u as=0 ps=0 w=0.42u l=1u
X1870 VSS.t2136 VDD VSS.t2135 VSS.t2134 sg13_lv_nmos ad=0.1428p pd=1.52u as=0 ps=0 w=0.42u l=1u
X1871 VDD VSS.t1756 VDD VDD sg13_lv_pmos ad=0.19p pd=1.38u as=0 ps=0 w=1u l=1u
X1872 VSS.t90 a_25786_15960# a_25505_16262# VSS.t103 sg13_lv_nmos ad=79.8f pd=0.8u as=0.1428p ps=1.52u w=0.42u l=0.5u
X1873 VDD VSS.t944 VDD VDD sg13_lv_pmos ad=0.34p pd=2.68u as=0 ps=0 w=1u l=1u
X1874 VSS.t2553 VDD VSS.t2555 VSS.t2554 sg13_lv_nmos ad=79.8f pd=0.8u as=0 ps=0 w=0.42u l=1u
X1875 VSS.t2026 VDD VSS.t2028 VSS.t2027 sg13_lv_nmos ad=79.8f pd=0.8u as=0 ps=0 w=0.42u l=1u
X1876 VSS.t1431 VDD VSS.t1430 VSS.t377 sg13_lv_nmos ad=0.1428p pd=1.52u as=0 ps=0 w=0.42u l=1u
X1877 VDD VSS.t1708 VDD VDD sg13_lv_pmos ad=0.34p pd=2.68u as=0 ps=0 w=1u l=1u
X1878 VDD VSS.t2582 VDD VDD sg13_lv_pmos ad=0.34p pd=2.68u as=0 ps=0 w=1u l=1u
X1879 VDD VSS.t1763 VDD VDD sg13_lv_pmos ad=0.34p pd=2.68u as=0 ps=0 w=1u l=1u
X1880 a_8218_13690# sg13g2_dlygate4sd3_1_1.A VSS.t100 VSS.t273 sg13_lv_nmos ad=0.1428p pd=1.52u as=79.8f ps=0.8u w=0.42u l=0.13u
X1881 a_16042_13945# a_16485_13701# a_16425_14113# VDD sg13_lv_pmos ad=79.8f pd=0.8u as=63f ps=0.72u w=0.42u l=0.13u
X1882 VSS.t1565 VDD VSS.t1435 VSS.t377 sg13_lv_nmos ad=0.1428p pd=1.52u as=0 ps=0 w=0.42u l=1u
X1883 VDD VSS.t302 VDD VDD sg13_lv_pmos ad=0.34p pd=2.68u as=0 ps=0 w=1u l=1u
X1884 VDD VSS.t997 VDD VDD sg13_lv_pmos ad=0.19p pd=1.38u as=0 ps=0 w=1u l=1u
X1885 VSS.t1976 VDD VSS.t1978 VSS.t1977 sg13_lv_nmos ad=79.8f pd=0.8u as=0 ps=0 w=0.42u l=1u
X1886 VSS.t24 a_15022_14484# sg13g2_buf_16_2.A VSS.t231 sg13_lv_nmos ad=0.1406p pd=1.12u as=0.1406p ps=1.12u w=0.74u l=0.13u
X1887 VDD VSS.t1437 VDD VDD sg13_lv_pmos ad=0.19p pd=1.38u as=0 ps=0 w=1u l=1u
X1888 VSS.t139 a_18874_13690# a_18593_13912# VSS.t402 sg13_lv_nmos ad=79.8f pd=0.8u as=0.1428p ps=1.52u w=0.42u l=0.5u
X1889 VSS.t740 VDD VSS.t743 VSS.t869 sg13_lv_nmos ad=79.8f pd=0.8u as=0 ps=0 w=0.42u l=1u
X1890 VSS.t2841 VDD VSS.t2840 VSS.t412 sg13_lv_nmos ad=0.1428p pd=1.52u as=0 ps=0 w=0.42u l=1u
X1891 VDD VSS.t2093 VDD VDD sg13_lv_pmos ad=0.19p pd=1.38u as=0 ps=0 w=1u l=1u
X1892 VDD VSS.t214 VDD VDD sg13_lv_pmos ad=0.34p pd=2.68u as=0 ps=0 w=1u l=1u
X1893 VDD VSS.t2814 VDD VDD sg13_lv_pmos ad=0.19p pd=1.38u as=0 ps=0 w=1u l=1u
X1894 VDD VSS.t1736 VDD VDD sg13_lv_pmos ad=0.19p pd=1.38u as=0 ps=0 w=1u l=1u
X1895 VDD VSS.t3204 VDD VDD sg13_lv_pmos ad=0.34p pd=2.68u as=0 ps=0 w=1u l=1u
X1896 VDD VSS.t2412 VDD VDD sg13_lv_pmos ad=0.34p pd=2.68u as=0 ps=0 w=1u l=1u
X1897 a_16500_15280# sg13g2_or3_1_2.B a_16044_15424# VSS.t207 sg13_lv_nmos ad=78.39999f pd=0.885u as=0.2176p ps=1.96u w=0.64u l=0.13u
X1898 VSS.t1319 VDD VSS.t1320 VSS.t377 sg13_lv_nmos ad=79.8f pd=0.8u as=0 ps=0 w=0.42u l=1u
X1899 VDD VSS.t186 VDD VDD sg13_lv_pmos ad=0.34p pd=2.68u as=0 ps=0 w=1u l=1u
X1900 VDD VSS.t1099 VDD VDD sg13_lv_pmos ad=0.34p pd=2.68u as=0 ps=0 w=1u l=1u
X1901 VDD VSS.t1776 VDD VDD sg13_lv_pmos ad=0.19p pd=1.38u as=0 ps=0 w=1u l=1u
X1902 VSS.t33 a_26638_15423# sg13g2_o21ai_1_2.B1 VSS.t184 sg13_lv_nmos ad=0.1426p pd=1.16u as=0.2516p ps=2.16u w=0.74u l=0.13u
X1903 VSS.t1699 VDD VSS.t1698 VSS.t1697 sg13_lv_nmos ad=0.1428p pd=1.52u as=0 ps=0 w=0.42u l=1u
X1904 VSS.t3225 VDD VSS.t3224 VSS.t3223 sg13_lv_nmos ad=0.1428p pd=1.52u as=0 ps=0 w=0.42u l=1u
X1905 VDD VSS.t1037 VDD VDD sg13_lv_pmos ad=0.19p pd=1.38u as=0 ps=0 w=1u l=1u
X1906 VDD VSS.t2425 VDD VDD sg13_lv_pmos ad=0.19p pd=1.38u as=0 ps=0 w=1u l=1u
X1907 VSS.t2751 VDD VSS.t2752 VSS.t412 sg13_lv_nmos ad=79.8f pd=0.8u as=0 ps=0 w=0.42u l=1u
X1908 VDD VSS.t2899 VDD VDD sg13_lv_pmos ad=0.19p pd=1.38u as=0 ps=0 w=1u l=1u
X1909 VDD VSS.t271 VDD VDD sg13_lv_pmos ad=0.34p pd=2.68u as=0 ps=0 w=1u l=1u
X1910 VSS.t905 VDD VSS.t907 VSS.t906 sg13_lv_nmos ad=79.8f pd=0.8u as=0 ps=0 w=0.42u l=1u
X1911 VSS.t975 VDD VSS.t977 VSS.t976 sg13_lv_nmos ad=79.8f pd=0.8u as=0 ps=0 w=0.42u l=1u
X1912 VDD VSS.t964 VDD VDD sg13_lv_pmos ad=0.34p pd=2.68u as=0 ps=0 w=1u l=1u
X1913 VDD VSS.t19 VDD VDD sg13_lv_pmos ad=0.34p pd=2.68u as=0 ps=0 w=1u l=1u
X1914 VDD VSS.t766 VDD VDD sg13_lv_pmos ad=0.34p pd=2.68u as=0 ps=0 w=1u l=1u
X1915 VSS.t384 a_19438_13726# sg13g2_buf_16_2.X VSS.t386 sg13_lv_nmos ad=0.1406p pd=1.12u as=0.1406p ps=1.12u w=0.74u l=0.13u
X1916 VDD VSS.t1390 VDD VDD sg13_lv_pmos ad=0.34p pd=2.68u as=0 ps=0 w=1u l=1u
X1917 VSS.t1996 VDD VSS.t1998 VSS.t1997 sg13_lv_nmos ad=79.8f pd=0.8u as=0 ps=0 w=0.42u l=1u
X1918 VDD VSS.t369 VDD VDD sg13_lv_pmos ad=0.19p pd=1.38u as=0 ps=0 w=1u l=1u
X1919 VSS.t1140 VDD VSS.t1142 VSS.t1141 sg13_lv_nmos ad=79.8f pd=0.8u as=0 ps=0 w=0.42u l=1u
X1920 VDD VSS.t2110 VDD VDD sg13_lv_pmos ad=0.34p pd=2.68u as=0 ps=0 w=1u l=1u
X1921 VSS.t725 VDD VSS.t407 VSS.t724 sg13_lv_nmos ad=0.1428p pd=1.52u as=0 ps=0 w=0.42u l=1u
X1922 VSS.t2538 VDD VSS.t2540 VSS.t2539 sg13_lv_nmos ad=79.8f pd=0.8u as=0 ps=0 w=0.42u l=1u
X1923 VDD sg13g2_nand3_1_0.Y a_7680_15549# VDD sg13_lv_pmos ad=0.2891p pd=1.695u as=0.1596p ps=1.22u w=0.84u l=0.13u
X1924 VDD VSS.t2480 VDD VDD sg13_lv_pmos ad=0.19p pd=1.38u as=0 ps=0 w=1u l=1u
X1925 VSS.t576 VDD VSS.t577 VSS.t33 sg13_lv_nmos ad=79.8f pd=0.8u as=0 ps=0 w=0.42u l=1u
X1926 sg13g2_dfrbpq_1_2.D sg13g2_a21oi_1_0.B1 VSS.t16 VSS.t15 sg13_lv_nmos ad=0.1406p pd=1.12u as=0.2516p ps=2.16u w=0.74u l=0.13u
X1927 VSS.t1000 VDD VSS.t999 VSS.t998 sg13_lv_nmos ad=0.1428p pd=1.52u as=0 ps=0 w=0.42u l=1u
X1928 VSS.t2086 VDD VSS.t2088 VSS.t2087 sg13_lv_nmos ad=79.8f pd=0.8u as=0 ps=0 w=0.42u l=1u
X1929 VDD VSS.t2235 VDD VDD sg13_lv_pmos ad=0.34p pd=2.68u as=0 ps=0 w=1u l=1u
X1930 VSS.t1485 VDD VSS.t1334 VSS.t377 sg13_lv_nmos ad=79.8f pd=0.8u as=0 ps=0 w=0.42u l=1u
X1931 VDD VSS.t1426 VDD VDD sg13_lv_pmos ad=0.19p pd=1.38u as=0 ps=0 w=1u l=1u
X1932 VSS.t763 VDD VSS.t763 VSS.t764 sg13_lv_nmos ad=79.8f pd=0.8u as=0 ps=0 w=0.42u l=1u
X1933 VSS.t2121 VDD VSS.t2120 VSS.t2119 sg13_lv_nmos ad=0.1428p pd=1.52u as=0 ps=0 w=0.42u l=1u
X1934 VSS.t1457 VDD VSS.t1456 VSS.t377 sg13_lv_nmos ad=0.1428p pd=1.52u as=0 ps=0 w=0.42u l=1u
X1935 sg13g2_nand3_1_0.Y sg13g2_buf_1_0.X VDD VDD sg13_lv_pmos ad=0.3808p pd=2.92u as=0.2128p ps=1.5u w=1.12u l=0.13u
X1936 VDD VSS.t1693 VDD VDD sg13_lv_pmos ad=0.34p pd=2.68u as=0 ps=0 w=1u l=1u
X1937 VSS.t823 VDD VSS.t822 VSS.t821 sg13_lv_nmos ad=0.1428p pd=1.52u as=0 ps=0 w=0.42u l=1u
X1938 VSS.t1060 VDD VSS.t1062 VSS.t1061 sg13_lv_nmos ad=79.8f pd=0.8u as=0 ps=0 w=0.42u l=1u
X1939 VDD VSS.t1748 VDD VDD sg13_lv_pmos ad=0.34p pd=2.68u as=0 ps=0 w=1u l=1u
X1940 VSS.t2036 VDD VSS.t2038 VSS.t2037 sg13_lv_nmos ad=79.8f pd=0.8u as=0 ps=0 w=0.42u l=1u
X1941 sg13g2_buf_16_2.A a_15022_14484# VDD VDD sg13_lv_pmos ad=0.2128p pd=1.5u as=0.2128p ps=1.5u w=1.12u l=0.13u
X1942 VDD VSS.t927 VDD VDD sg13_lv_pmos ad=0.19p pd=1.38u as=0 ps=0 w=1u l=1u
X1943 VDD VSS.t3067 VDD VDD sg13_lv_pmos ad=0.19p pd=1.38u as=0 ps=0 w=1u l=1u
X1944 VSS.t3125 VDD VSS.t3127 VSS.t3126 sg13_lv_nmos ad=79.8f pd=0.8u as=0 ps=0 w=0.42u l=1u
X1945 VSS.t2493 VDD VSS.t2492 VSS.t2491 sg13_lv_nmos ad=0.1428p pd=1.52u as=0 ps=0 w=0.42u l=1u
X1946 a_22030_15423# a_22145_15424# VDD VDD sg13_lv_pmos ad=0.34p pd=2.68u as=0.2254p ps=1.53u w=1u l=0.5u
X1947 VDD VSS.t302 VDD VDD sg13_lv_pmos ad=0.34p pd=2.68u as=0 ps=0 w=1u l=1u
X1948 VSS.t1819 VDD VSS.t1821 VSS.t1820 sg13_lv_nmos ad=79.8f pd=0.8u as=0 ps=0 w=0.42u l=1u
X1949 VSS.t2901 VDD VSS.t2902 VSS.t412 sg13_lv_nmos ad=79.8f pd=0.8u as=0 ps=0 w=0.42u l=1u
X1950 VDD VSS.t2472 VDD VDD sg13_lv_pmos ad=0.34p pd=2.68u as=0 ps=0 w=1u l=1u
X1951 VDD VSS.t2130 VDD VDD sg13_lv_pmos ad=0.34p pd=2.68u as=0 ps=0 w=1u l=1u
X1952 sg13g2_o21ai_1_1.Y sg13g2_or3_1_2.A a_20278_14862# VSS.t25 sg13_lv_nmos ad=0.2516p pd=2.16u as=0.1406p ps=1.12u w=0.74u l=0.15u
X1953 VSS.t302 VDD VSS.t302 VSS.t676 sg13_lv_nmos ad=0.1428p pd=1.52u as=0 ps=0 w=0.42u l=1u
X1954 VDD VSS.t1428 VDD VDD sg13_lv_pmos ad=0.19p pd=1.38u as=0 ps=0 w=1u l=1u
X1955 VSS.t1385 VDD VSS.t1384 VSS.t377 sg13_lv_nmos ad=0.1428p pd=1.52u as=0 ps=0 w=0.42u l=1u
X1956 VSS.t2833 VDD VSS.t2832 VSS.t412 sg13_lv_nmos ad=0.1428p pd=1.52u as=0 ps=0 w=0.42u l=1u
X1957 VDD VSS.t2078 VDD VDD sg13_lv_pmos ad=0.19p pd=1.38u as=0 ps=0 w=1u l=1u
X1958 VSS.t480 VDD VSS.t480 VSS.t482 sg13_lv_nmos ad=0.1428p pd=1.52u as=0 ps=0 w=0.42u l=1u
X1959 VDD VSS.t616 VDD VDD sg13_lv_pmos ad=0.19p pd=1.38u as=0 ps=0 w=1u l=1u
X1960 VDD VSS.t2807 VDD VDD sg13_lv_pmos ad=0.19p pd=1.38u as=0 ps=0 w=1u l=1u
X1961 VDD VSS.t1407 VDD VDD sg13_lv_pmos ad=0.34p pd=2.68u as=0 ps=0 w=1u l=1u
X1962 VSS.t2458 VDD VSS.t2457 VSS.t2456 sg13_lv_nmos ad=0.1428p pd=1.52u as=0 ps=0 w=0.42u l=1u
X1963 VDD VSS.t27 VDD VDD sg13_lv_pmos ad=0.19p pd=1.38u as=0 ps=0 w=1u l=1u
X1964 VDD VSS.t1144 VDD VDD sg13_lv_pmos ad=0.34p pd=2.68u as=0 ps=0 w=1u l=1u
X1965 VSS.t1749 VDD VSS.t1751 VSS.t1750 sg13_lv_nmos ad=79.8f pd=0.8u as=0 ps=0 w=0.42u l=1u
X1966 VSS.t3275 VDD VSS.t3277 VSS.t3276 sg13_lv_nmos ad=79.8f pd=0.8u as=0 ps=0 w=0.42u l=1u
X1967 VSS.t743 VDD VSS.t740 VSS.t742 sg13_lv_nmos ad=0.1428p pd=1.52u as=0 ps=0 w=0.42u l=1u
X1968 VDD VSS.t580 VDD VDD sg13_lv_pmos ad=0.19p pd=1.38u as=0 ps=0 w=1u l=1u
X1969 VSS.t158 VDD VSS.t158 VSS.t545 sg13_lv_nmos ad=0.1428p pd=1.52u as=0 ps=0 w=0.42u l=1u
X1970 a_19438_13726# sg13g2_buf_16_2.A VSS.t174 VSS.t176 sg13_lv_nmos ad=0.1406p pd=1.12u as=0.1406p ps=1.12u w=0.74u l=0.13u
X1971 VSS.t2558 VDD VSS.t2560 VSS.t2559 sg13_lv_nmos ad=79.8f pd=0.8u as=0 ps=0 w=0.42u l=1u
X1972 VSS.t1030 VDD VSS.t1029 VSS.t1028 sg13_lv_nmos ad=0.1428p pd=1.52u as=0 ps=0 w=0.42u l=1u
X1973 VDD VSS.t1362 VDD VDD sg13_lv_pmos ad=0.19p pd=1.38u as=0 ps=0 w=1u l=1u
X1974 VDD VSS.t2587 VDD VDD sg13_lv_pmos ad=0.34p pd=2.68u as=0 ps=0 w=1u l=1u
X1975 sg13g2_xnor2_1_2.B sg13g2_dlygate4sd3_1_3.A VDD VDD sg13_lv_pmos ad=0.2128p pd=1.5u as=0.3808p ps=2.92u w=1.12u l=0.13u
X1976 VDD a_10618_14448# a_10337_14750# VDD sg13_lv_pmos ad=0.1523p pd=1.38u as=0.34p ps=2.68u w=1u l=0.5u
X1977 VSS.t905 VDD VSS.t907 VSS.t906 sg13_lv_nmos ad=79.8f pd=0.8u as=0 ps=0 w=0.42u l=1u
X1978 VDD VSS.t1082 VDD VDD sg13_lv_pmos ad=0.19p pd=1.38u as=0 ps=0 w=1u l=1u
X1979 VSS.t2831 VDD VSS.t2830 VSS.t412 sg13_lv_nmos ad=0.1428p pd=1.52u as=0 ps=0 w=0.42u l=1u
X1980 VDD a_17900_15960# counter_value_o[3] VDD sg13_lv_pmos ad=0.2114p pd=1.54u as=0.42p ps=2.99u w=1.12u l=0.13u
X1981 VDD a_17327_13799# a_17584_13942# VDD sg13_lv_pmos ad=2.42015p pd=15.68u as=79.8f ps=0.8u w=0.42u l=0.13u
X1982 VDD VSS.t2891 VDD VDD sg13_lv_pmos ad=0.19p pd=1.38u as=0 ps=0 w=1u l=1u
X1983 VSS.t1779 VDD VSS.t1778 VSS.t1777 sg13_lv_nmos ad=0.1428p pd=1.52u as=0 ps=0 w=0.42u l=1u
X1984 VDD VSS.t3052 VDD VDD sg13_lv_pmos ad=0.19p pd=1.38u as=0 ps=0 w=1u l=1u
X1985 sg13g2_buf_16_2.A a_15022_14484# VDD VDD sg13_lv_pmos ad=0.2128p pd=1.5u as=0.2128p ps=1.5u w=1.12u l=0.13u
X1986 VSS.t100 VDD VSS.t35 VSS.t786 sg13_lv_nmos ad=0.1428p pd=1.52u as=0 ps=0 w=0.42u l=1u
X1987 VDD VSS.t100 VDD VDD sg13_lv_pmos ad=0.19p pd=1.38u as=0 ps=0 w=1u l=1u
X1988 VDD VSS.t2865 VDD VDD sg13_lv_pmos ad=0.34p pd=2.68u as=0 ps=0 w=1u l=1u
X1989 VDD a_21466_15202# a_21185_15424# VDD sg13_lv_pmos ad=0.1523p pd=1.38u as=0.34p ps=2.68u w=1u l=0.5u
X1990 a_16356_13735# a_16068_14040# a_16294_13735# VSS.t361 sg13_lv_nmos ad=0.1428p pd=1.52u as=37.8f ps=0.6u w=0.42u l=0.13u
X1991 VDD VSS.t720 VDD VDD sg13_lv_pmos ad=0.19p pd=1.38u as=0 ps=0 w=1u l=1u
X1992 VSS.t1981 VDD VSS.t1983 VSS.t1982 sg13_lv_nmos ad=79.8f pd=0.8u as=0 ps=0 w=0.42u l=1u
X1993 VSS.t302 VDD VSS.t302 VSS.t678 sg13_lv_nmos ad=0.1428p pd=1.52u as=0 ps=0 w=0.42u l=1u
X1994 VSS.t715 VDD VSS.t715 VSS.t836 sg13_lv_nmos ad=0.1428p pd=1.52u as=0 ps=0 w=0.42u l=1u
X1995 VDD VSS.t1288 VDD VDD sg13_lv_pmos ad=0.19p pd=1.38u as=0 ps=0 w=1u l=1u
X1996 VSS.t3070 VDD VSS.t3072 VSS.t3071 sg13_lv_nmos ad=79.8f pd=0.8u as=0 ps=0 w=0.42u l=1u
X1997 VSS.t1000 VDD VSS.t999 VSS.t998 sg13_lv_nmos ad=0.1428p pd=1.52u as=0 ps=0 w=0.42u l=1u
X1998 VSS.t1534 VDD VSS.t1397 VSS.t377 sg13_lv_nmos ad=0.1428p pd=1.52u as=0 ps=0 w=0.42u l=1u
X1999 VDD VSS.t1440 VDD VDD sg13_lv_pmos ad=0.19p pd=1.38u as=0 ps=0 w=1u l=1u
X2000 VSS.t1774 VDD VSS.t1773 VSS.t1772 sg13_lv_nmos ad=0.1428p pd=1.52u as=0 ps=0 w=0.42u l=1u
X2001 VSS.t2523 VDD VSS.t2525 VSS.t2524 sg13_lv_nmos ad=79.8f pd=0.8u as=0 ps=0 w=0.42u l=1u
X2002 VSS.t603 VDD VSS.t604 VSS.t33 sg13_lv_nmos ad=79.8f pd=0.8u as=0 ps=0 w=0.42u l=1u
X2003 VDD VSS.t596 VDD VDD sg13_lv_pmos ad=0.34p pd=2.68u as=0 ps=0 w=1u l=1u
X2004 VDD VSS.t957 VDD VDD sg13_lv_pmos ad=0.19p pd=1.38u as=0 ps=0 w=1u l=1u
X2005 VDD VSS.t2465 VDD VDD sg13_lv_pmos ad=0.19p pd=1.38u as=0 ps=0 w=1u l=1u
X2006 VDD VSS.t2817 VDD VDD sg13_lv_pmos ad=0.19p pd=1.38u as=0 ps=0 w=1u l=1u
X2007 VSS.t2478 VDD VSS.t2477 VSS.t2476 sg13_lv_nmos ad=0.1428p pd=1.52u as=0 ps=0 w=0.42u l=1u
X2008 VDD VSS.t2063 VDD VDD sg13_lv_pmos ad=0.19p pd=1.38u as=0 ps=0 w=1u l=1u
X2009 VDD VSS.t3209 VDD VDD sg13_lv_pmos ad=0.34p pd=2.68u as=0 ps=0 w=1u l=1u
X2010 VDD VSS.t2417 VDD VDD sg13_lv_pmos ad=0.34p pd=2.68u as=0 ps=0 w=1u l=1u
X2011 VDD VSS.t850 VDD VDD sg13_lv_pmos ad=0.34p pd=2.68u as=0 ps=0 w=1u l=1u
X2012 VDD VSS.t1746 VDD VDD sg13_lv_pmos ad=0.19p pd=1.38u as=0 ps=0 w=1u l=1u
X2013 VDD a_7888_14726# a_7833_14607# VDD sg13_lv_pmos ad=2.42015p pd=15.68u as=93.45f ps=0.865u w=0.42u l=0.13u
X2014 VSS.t100 VDD VSS.t100 VSS.t693 sg13_lv_nmos ad=0.1428p pd=1.52u as=0 ps=0 w=0.42u l=1u
X2015 VSS.t1060 VDD VSS.t1062 VSS.t1061 sg13_lv_nmos ad=79.8f pd=0.8u as=0 ps=0 w=0.42u l=1u
X2016 VDD VSS.t1342 VDD VDD sg13_lv_pmos ad=0.34p pd=2.68u as=0 ps=0 w=1u l=1u
X2017 VDD VSS.t1801 VDD VDD sg13_lv_pmos ad=0.19p pd=1.38u as=0 ps=0 w=1u l=1u
X2018 VSS.t562 VDD VSS.t562 VSS.t3 sg13_lv_nmos ad=0.1428p pd=1.52u as=0 ps=0 w=0.42u l=1u
X2019 VDD VSS.t302 VDD VDD sg13_lv_pmos ad=0.19p pd=1.38u as=0 ps=0 w=1u l=1u
X2020 VSS.t302 VDD VSS.t302 VSS.t684 sg13_lv_nmos ad=0.1428p pd=1.52u as=0 ps=0 w=0.42u l=1u
X2021 VSS.t1105 VDD VSS.t1107 VSS.t1106 sg13_lv_nmos ad=79.8f pd=0.8u as=0 ps=0 w=0.42u l=1u
X2022 VDD VSS.t1319 VDD VDD sg13_lv_pmos ad=0.19p pd=1.38u as=0 ps=0 w=1u l=1u
X2023 VSS.t2201 VDD VSS.t2200 VSS.t2199 sg13_lv_nmos ad=0.1428p pd=1.52u as=0 ps=0 w=0.42u l=1u
X2024 VSS.t1764 VDD VSS.t1763 VSS.t1762 sg13_lv_nmos ad=0.1428p pd=1.52u as=0 ps=0 w=0.42u l=1u
X2025 VSS.t3290 VDD VSS.t3289 VSS.t3288 sg13_lv_nmos ad=0.1428p pd=1.52u as=0 ps=0 w=0.42u l=1u
X2026 VSS.t3110 VDD VSS.t3112 VSS.t3111 sg13_lv_nmos ad=79.8f pd=0.8u as=0 ps=0 w=0.42u l=1u
X2027 VDD VSS.t2882 VDD VDD sg13_lv_pmos ad=0.19p pd=1.38u as=0 ps=0 w=1u l=1u
X2028 VDD VSS.t147 VDD VDD sg13_lv_pmos ad=0.19p pd=1.38u as=0 ps=0 w=1u l=1u
X2029 a_6346_14452# a_6789_14495# a_6729_14531# VDD sg13_lv_pmos ad=79.8f pd=0.8u as=63f ps=0.72u w=0.42u l=0.13u
X2030 sg13g2_buf_16_2.A a_15022_14484# VDD VDD sg13_lv_pmos ad=0.2128p pd=1.5u as=0.2128p ps=1.5u w=1.12u l=0.13u
X2031 VSS.t2824 VDD VSS.t2825 VSS.t412 sg13_lv_nmos ad=79.8f pd=0.8u as=0 ps=0 w=0.42u l=1u
X2032 VDD VSS.t131 VDD VDD sg13_lv_pmos ad=0.19p pd=1.38u as=0 ps=0 w=1u l=1u
X2033 VSS.t585 VDD VSS.t584 VSS.t33 sg13_lv_nmos ad=0.1428p pd=1.52u as=0 ps=0 w=0.42u l=1u
X2034 VDD VSS.t909 VDD VDD sg13_lv_pmos ad=0.34p pd=2.68u as=0 ps=0 w=1u l=1u
X2035 VDD VSS.t1112 VDD VDD sg13_lv_pmos ad=0.19p pd=1.38u as=0 ps=0 w=1u l=1u
X2036 VSS.t2893 VDD VSS.t2894 VSS.t412 sg13_lv_nmos ad=79.8f pd=0.8u as=0 ps=0 w=0.42u l=1u
X2037 VDD VSS.t2115 VDD VDD sg13_lv_pmos ad=0.34p pd=2.68u as=0 ps=0 w=1u l=1u
X2038 VSS.t2508 VDD VSS.t2510 VSS.t2509 sg13_lv_nmos ad=79.8f pd=0.8u as=0 ps=0 w=0.42u l=1u
X2039 VSS.t725 VDD VSS.t728 VSS.t859 sg13_lv_nmos ad=79.8f pd=0.8u as=0 ps=0 w=0.42u l=1u
X2040 VDD VSS.t3242 VDD VDD sg13_lv_pmos ad=0.19p pd=1.38u as=0 ps=0 w=1u l=1u
X2041 VDD VSS.t2485 VDD VDD sg13_lv_pmos ad=0.19p pd=1.38u as=0 ps=0 w=1u l=1u
X2042 VDD VSS.t2894 VDD VDD sg13_lv_pmos ad=0.34p pd=2.68u as=0 ps=0 w=1u l=1u
X2043 VSS.t2091 VDD VSS.t2093 VSS.t2092 sg13_lv_nmos ad=79.8f pd=0.8u as=0 ps=0 w=0.42u l=1u
X2044 VDD VSS.t2240 VDD VDD sg13_lv_pmos ad=0.34p pd=2.68u as=0 ps=0 w=1u l=1u
X2045 VSS.t1674 VDD VSS.t1676 VSS.t1675 sg13_lv_nmos ad=79.8f pd=0.8u as=0 ps=0 w=0.42u l=1u
X2046 VSS.t2823 VDD VSS.t2824 VSS.t412 sg13_lv_nmos ad=79.8f pd=0.8u as=0 ps=0 w=0.42u l=1u
X2047 VSS.t63 VDD VSS.t63 VSS.t640 sg13_lv_nmos ad=0.1428p pd=1.52u as=0 ps=0 w=0.42u l=1u
X2048 VSS.t1734 VDD VSS.t1736 VSS.t1735 sg13_lv_nmos ad=79.8f pd=0.8u as=0 ps=0 w=0.42u l=1u
X2049 VSS.t3260 VDD VSS.t3262 VSS.t3261 sg13_lv_nmos ad=79.8f pd=0.8u as=0 ps=0 w=0.42u l=1u
X2050 VDD VSS.t607 VDD VDD sg13_lv_pmos ad=0.19p pd=1.38u as=0 ps=0 w=1u l=1u
X2051 VSS.t1030 VDD VSS.t1029 VSS.t1028 sg13_lv_nmos ad=0.1428p pd=1.52u as=0 ps=0 w=0.42u l=1u
X2052 VSS.t1416 VDD VSS.t1415 VSS.t377 sg13_lv_nmos ad=0.1428p pd=1.52u as=0 ps=0 w=0.42u l=1u
X2053 a_26244_14909# a_25956_14488# a_26182_14909# VSS.t7 sg13_lv_nmos ad=0.1428p pd=1.52u as=37.8f ps=0.6u w=0.42u l=0.13u
X2054 VDD VSS.t1389 VDD VDD sg13_lv_pmos ad=0.19p pd=1.38u as=0 ps=0 w=1u l=1u
X2055 VDD VSS.t1127 VDD VDD sg13_lv_pmos ad=0.19p pd=1.38u as=0 ps=0 w=1u l=1u
X2056 VDD VSS.t1698 VDD VDD sg13_lv_pmos ad=0.34p pd=2.68u as=0 ps=0 w=1u l=1u
X2057 VSS.t214 VDD VSS.t214 VSS.t559 sg13_lv_nmos ad=0.1428p pd=1.52u as=0 ps=0 w=0.42u l=1u
X2058 VDD VSS.t1753 VDD VDD sg13_lv_pmos ad=0.34p pd=2.68u as=0 ps=0 w=1u l=1u
X2059 VSS.t2041 VDD VSS.t2043 VSS.t2042 sg13_lv_nmos ad=79.8f pd=0.8u as=0 ps=0 w=0.42u l=1u
X2060 a_19450_15202# sg13g2_dfrbpq_1_3.Q VDD VDD sg13_lv_pmos ad=0.1428p pd=1.52u as=0.1523p ps=1.38u w=0.42u l=0.13u
X2061 VSS.t3130 VDD VSS.t3132 VSS.t3131 sg13_lv_nmos ad=79.8f pd=0.8u as=0 ps=0 w=0.42u l=1u
X2062 a_20603_15532# sg13g2_or3_1_2.X VDD VDD sg13_lv_pmos ad=0.3808p pd=2.92u as=0.2128p ps=1.5u w=1.12u l=0.13u
X2063 VDD VSS.t3037 VDD VDD sg13_lv_pmos ad=0.19p pd=1.38u as=0 ps=0 w=1u l=1u
X2064 VDD VSS.t1064 VDD VDD sg13_lv_pmos ad=0.34p pd=2.68u as=0 ps=0 w=1u l=1u
X2065 VSS.t1434 VDD VSS.t1433 VSS.t377 sg13_lv_nmos ad=0.1428p pd=1.52u as=0 ps=0 w=0.42u l=1u
X2066 VSS.t1824 VDD VSS.t1826 VSS.t1825 sg13_lv_nmos ad=79.8f pd=0.8u as=0 ps=0 w=0.42u l=1u
X2067 VDD VSS.t2857 VDD VDD sg13_lv_pmos ad=0.34p pd=2.68u as=0 ps=0 w=1u l=1u
X2068 VDD VSS.t50 VDD VDD sg13_lv_pmos ad=0.34p pd=2.68u as=0 ps=0 w=1u l=1u
X2069 VSS.t10 sg13g2_or3_1_2.B a_20278_14862# VSS.t25 sg13_lv_nmos ad=0.1406p pd=1.12u as=0.2516p ps=2.16u w=0.74u l=0.15u
X2070 VDD VSS.t2442 VDD VDD sg13_lv_pmos ad=0.34p pd=2.68u as=0 ps=0 w=1u l=1u
X2071 VDD VSS.t465 VDD VDD sg13_lv_pmos ad=0.19p pd=1.38u as=0 ps=0 w=1u l=1u
X2072 VDD VSS.t1431 VDD VDD sg13_lv_pmos ad=0.19p pd=1.38u as=0 ps=0 w=1u l=1u
X2073 VDD VSS.t2627 VDD VDD sg13_lv_pmos ad=0.34p pd=2.68u as=0 ps=0 w=1u l=1u
X2074 sg13g2_or3_1_2.C sg13g2_dfrbpq_1_2.Q VDD VDD sg13_lv_pmos ad=0.2128p pd=1.5u as=0.3808p ps=2.92u w=1.12u l=0.13u
X2075 VDD VSS.t1403 VDD VDD sg13_lv_pmos ad=0.34p pd=2.68u as=0 ps=0 w=1u l=1u
X2076 VDD VSS.t2809 VDD VDD sg13_lv_pmos ad=0.19p pd=1.38u as=0 ps=0 w=1u l=1u
X2077 VDD VSS.t2225 VDD VDD sg13_lv_pmos ad=0.34p pd=2.68u as=0 ps=0 w=1u l=1u
X2078 VDD VSS.t2048 VDD VDD sg13_lv_pmos ad=0.19p pd=1.38u as=0 ps=0 w=1u l=1u
X2079 VSS.t50 a_12020_15202# sg13g2_dfrbpq_1_2.CLK VSS.t54 sg13_lv_nmos ad=0.1406p pd=1.12u as=0.1406p ps=1.12u w=0.74u l=0.13u
X2080 VDD VSS.t3194 VDD VDD sg13_lv_pmos ad=0.34p pd=2.68u as=0 ps=0 w=1u l=1u
X2081 VSS.t2463 VDD VSS.t2462 VSS.t2461 sg13_lv_nmos ad=0.1428p pd=1.52u as=0 ps=0 w=0.42u l=1u
X2082 VDD VSS.t2402 VDD VDD sg13_lv_pmos ad=0.34p pd=2.68u as=0 ps=0 w=1u l=1u
X2083 VDD VSS.t587 VDD VDD sg13_lv_pmos ad=0.34p pd=2.68u as=0 ps=0 w=1u l=1u
X2084 a_16044_15424# sg13g2_or3_1_2.B VDD VDD sg13_lv_pmos ad=0.1596p pd=1.22u as=0.2891p ps=1.695u w=0.84u l=0.13u
X2085 VDD VSS.t577 VDD VDD sg13_lv_pmos ad=0.19p pd=1.38u as=0 ps=0 w=1u l=1u
X2086 VDD VSS.t302 VDD VDD sg13_lv_pmos ad=0.19p pd=1.38u as=0 ps=0 w=1u l=1u
X2087 VSS.t3245 VDD VSS.t3247 VSS.t3246 sg13_lv_nmos ad=79.8f pd=0.8u as=0 ps=0 w=0.42u l=1u
X2088 VSS.t1105 VDD VSS.t1107 VSS.t1106 sg13_lv_nmos ad=79.8f pd=0.8u as=0 ps=0 w=0.42u l=1u
X2089 VDD VSS.t1369 VDD VDD sg13_lv_pmos ad=0.34p pd=2.68u as=0 ps=0 w=1u l=1u
X2090 VDD VSS.t1731 VDD VDD sg13_lv_pmos ad=0.19p pd=1.38u as=0 ps=0 w=1u l=1u
X2091 VDD VSS.t302 VDD VDD sg13_lv_pmos ad=0.19p pd=1.38u as=0 ps=0 w=1u l=1u
X2092 VSS.t1443 VDD VSS.t1442 VSS.t377 sg13_lv_nmos ad=0.1428p pd=1.52u as=0 ps=0 w=0.42u l=1u
X2093 VSS.t720 VDD VSS.t720 VSS.t719 sg13_lv_nmos ad=0.1428p pd=1.52u as=0 ps=0 w=0.42u l=1u
X2094 VSS.t1619 VDD VSS.t1621 VSS.t1620 sg13_lv_nmos ad=79.8f pd=0.8u as=0 ps=0 w=0.42u l=1u
X2095 VSS.t2528 VDD VSS.t2530 VSS.t2529 sg13_lv_nmos ad=79.8f pd=0.8u as=0 ps=0 w=0.42u l=1u
X2096 VSS.t965 VDD VSS.t964 VSS.t963 sg13_lv_nmos ad=0.1428p pd=1.52u as=0 ps=0 w=0.42u l=1u
X2097 VDD VSS.t2103 VDD VDD sg13_lv_pmos ad=0.19p pd=1.38u as=0 ps=0 w=1u l=1u
X2098 VDD VSS.t1311 VDD VDD sg13_lv_pmos ad=0.19p pd=1.38u as=0 ps=0 w=1u l=1u
X2099 VSS.t1749 VDD VSS.t1748 VSS.t1747 sg13_lv_nmos ad=0.1428p pd=1.52u as=0 ps=0 w=0.42u l=1u
X2100 VSS.t3275 VDD VSS.t3274 VSS.t3273 sg13_lv_nmos ad=0.1428p pd=1.52u as=0 ps=0 w=0.42u l=1u
X2101 a_17327_13799# a_16485_13701# a_16068_14040# VDD sg13_lv_pmos ad=0.2048p pd=1.63u as=0.34p ps=2.68u w=1u l=0.13u
X2102 VSS.t1986 VDD VSS.t1988 VSS.t1987 sg13_lv_nmos ad=79.8f pd=0.8u as=0 ps=0 w=0.42u l=1u
X2103 VSS.t3075 VDD VSS.t3077 VSS.t3076 sg13_lv_nmos ad=79.8f pd=0.8u as=0 ps=0 w=0.42u l=1u
X2104 VDD sg13g2_dfrbpq_1_5.RESET_B a_25862_13722# VDD sg13_lv_pmos ad=0.36237p pd=2.605u as=79.8f ps=0.8u w=0.42u l=0.13u
X2105 VDD VSS.t1422 VDD VDD sg13_lv_pmos ad=0.19p pd=1.38u as=0 ps=0 w=1u l=1u
X2106 VDD VSS.t2470 VDD VDD sg13_lv_pmos ad=0.19p pd=1.38u as=0 ps=0 w=1u l=1u
X2107 VDD VSS.t1616 VDD VDD sg13_lv_pmos ad=0.19p pd=1.38u as=0 ps=0 w=1u l=1u
X2108 VDD VSS.t3179 VDD VDD sg13_lv_pmos ad=0.34p pd=2.68u as=0 ps=0 w=1u l=1u
X2109 VDD VSS.t2387 VDD VDD sg13_lv_pmos ad=0.34p pd=2.68u as=0 ps=0 w=1u l=1u
X2110 a_25094_14484# a_24824_14525# VSS.t78 VSS.t30 sg13_lv_nmos ad=0.1428p pd=1.52u as=79.8f ps=0.8u w=0.42u l=0.5u
X2111 VSS.t728 VDD VSS.t725 VSS.t727 sg13_lv_nmos ad=0.1428p pd=1.52u as=0 ps=0 w=0.42u l=1u
X2112 VSS.t1659 VDD VSS.t1661 VSS.t1660 sg13_lv_nmos ad=79.8f pd=0.8u as=0 ps=0 w=0.42u l=1u
X2113 VSS.t1839 VDD VSS.t1838 VSS.t1837 sg13_lv_nmos ad=0.1428p pd=1.52u as=0 ps=0 w=0.42u l=1u
X2114 VSS.t2076 VDD VSS.t2078 VSS.t2077 sg13_lv_nmos ad=79.8f pd=0.8u as=0 ps=0 w=0.42u l=1u
X2115 VSS.t50 a_12020_15202# sg13g2_dfrbpq_1_2.CLK VSS.t49 sg13_lv_nmos ad=0.1406p pd=1.12u as=0.1406p ps=1.12u w=0.74u l=0.13u
X2116 VDD a_22319_14845# a_22576_14726# VDD sg13_lv_pmos ad=2.42015p pd=15.68u as=79.8f ps=0.8u w=0.42u l=0.13u
X2117 VSS.t2814 VDD VSS.t2815 VSS.t412 sg13_lv_nmos ad=79.8f pd=0.8u as=0 ps=0 w=0.42u l=1u
X2118 VDD VSS.t2783 VDD VDD sg13_lv_pmos ad=0.19p pd=1.38u as=0 ps=0 w=1u l=1u
X2119 VDD VSS.t1751 VDD VDD sg13_lv_pmos ad=0.19p pd=1.38u as=0 ps=0 w=1u l=1u
X2120 VDD VSS.t3097 VDD VDD sg13_lv_pmos ad=0.19p pd=1.38u as=0 ps=0 w=1u l=1u
X2121 VSS.t925 VDD VSS.t927 VSS.t926 sg13_lv_nmos ad=79.8f pd=0.8u as=0 ps=0 w=0.42u l=1u
X2122 VDD VSS.t2095 VDD VDD sg13_lv_pmos ad=0.34p pd=2.68u as=0 ps=0 w=1u l=1u
X2123 VSS.t2206 VDD VSS.t2205 VSS.t2204 sg13_lv_nmos ad=0.1428p pd=1.52u as=0 ps=0 w=0.42u l=1u
X2124 VDD VSS.t595 VDD VDD sg13_lv_pmos ad=0.19p pd=1.38u as=0 ps=0 w=1u l=1u
X2125 VDD VSS.t984 VDD VDD sg13_lv_pmos ad=0.34p pd=2.68u as=0 ps=0 w=1u l=1u
X2126 VSS.t1769 VDD VSS.t1768 VSS.t1767 sg13_lv_nmos ad=0.1428p pd=1.52u as=0 ps=0 w=0.42u l=1u
X2127 VSS.t3295 VDD VSS.t3294 VSS.t3293 sg13_lv_nmos ad=0.1428p pd=1.52u as=0 ps=0 w=0.42u l=1u
X2128 VSS.t3115 VDD VSS.t3117 VSS.t3116 sg13_lv_nmos ad=79.8f pd=0.8u as=0 ps=0 w=0.42u l=1u
X2129 VDD VSS.t2885 VDD VDD sg13_lv_pmos ad=0.19p pd=1.38u as=0 ps=0 w=1u l=1u
X2130 VSS.t2483 VDD VSS.t2482 VSS.t2481 sg13_lv_nmos ad=0.1428p pd=1.52u as=0 ps=0 w=0.42u l=1u
X2131 sg13g2_buf_16_2.X a_19438_13726# VDD VDD sg13_lv_pmos ad=0.2128p pd=1.5u as=0.2128p ps=1.5u w=1.12u l=0.13u
X2132 VDD a_16485_13701# a_16587_13844# VDD sg13_lv_pmos ad=2.42015p pd=15.68u as=0.3864p ps=2.93u w=1.12u l=0.13u
X2133 VDD VSS.t1109 VDD VDD sg13_lv_pmos ad=0.34p pd=2.68u as=0 ps=0 w=1u l=1u
X2134 VDD VSS.t1778 VDD VDD sg13_lv_pmos ad=0.34p pd=2.68u as=0 ps=0 w=1u l=1u
X2135 a_10618_14448# sg13g2_dlygate4sd3_1_8.A VDD VDD sg13_lv_pmos ad=0.1428p pd=1.52u as=0.1523p ps=1.38u w=0.42u l=0.13u
X2136 VSS.t826 VDD VSS.t174 VSS.t825 sg13_lv_nmos ad=0.1428p pd=1.52u as=0 ps=0 w=0.42u l=1u
X2137 VSS.t734 VDD VSS.t734 VSS.t864 sg13_lv_nmos ad=0.1428p pd=1.52u as=0 ps=0 w=0.42u l=1u
X2138 VSS.t1809 VDD VSS.t1811 VSS.t1810 sg13_lv_nmos ad=79.8f pd=0.8u as=0 ps=0 w=0.42u l=1u
X2139 VSS.t1971 VDD VSS.t1973 VSS.t1972 sg13_lv_nmos ad=79.8f pd=0.8u as=0 ps=0 w=0.42u l=1u
X2140 a_25025_16344# sg13g2_dlygate4sd3_1_12.X sg13g2_dlygate4sd3_1_17.A VSS.t102 sg13_lv_nmos ad=0.1406p pd=1.12u as=0.1406p ps=1.12u w=0.74u l=0.13u
X2141 VSS.t2896 VDD VSS.t2897 VSS.t412 sg13_lv_nmos ad=79.8f pd=0.8u as=0 ps=0 w=0.42u l=1u
X2142 VSS.t302 VDD VSS.t302 VSS.t711 sg13_lv_nmos ad=0.1428p pd=1.52u as=0 ps=0 w=0.42u l=1u
X2143 VSS.t2513 VDD VSS.t2515 VSS.t2514 sg13_lv_nmos ad=79.8f pd=0.8u as=0 ps=0 w=0.42u l=1u
X2144 VDD VSS.t2427 VDD VDD sg13_lv_pmos ad=0.34p pd=2.68u as=0 ps=0 w=1u l=1u
X2145 VDD VSS.t2455 VDD VDD sg13_lv_pmos ad=0.19p pd=1.38u as=0 ps=0 w=1u l=1u
X2146 VDD VSS.t1047 VDD VDD sg13_lv_pmos ad=0.19p pd=1.38u as=0 ps=0 w=1u l=1u
X2147 VSS.t1494 VDD VSS.t1346 VSS.t377 sg13_lv_nmos ad=79.8f pd=0.8u as=0 ps=0 w=0.42u l=1u
X2148 VDD VSS.t1601 VDD VDD sg13_lv_pmos ad=0.19p pd=1.38u as=0 ps=0 w=1u l=1u
X2149 a_22025_16334# a_22149_16033# VDD VDD sg13_lv_pmos ad=0.2442p pd=2.06u as=2.8961p ps=18.25u w=0.66u l=0.13u
X2150 VDD VSS.t1395 VDD VDD sg13_lv_pmos ad=0.34p pd=2.68u as=0 ps=0 w=1u l=1u
X2151 VDD VSS.t2897 VDD VDD sg13_lv_pmos ad=0.34p pd=2.68u as=0 ps=0 w=1u l=1u
X2152 VDD VSS.t2210 VDD VDD sg13_lv_pmos ad=0.34p pd=2.68u as=0 ps=0 w=1u l=1u
X2153 VDD VSS.t302 VDD VDD sg13_lv_pmos ad=0.19p pd=1.38u as=0 ps=0 w=1u l=1u
X2154 VDD VSS.t1437 VDD VDD sg13_lv_pmos ad=0.19p pd=1.38u as=0 ps=0 w=1u l=1u
X2155 VSS.t1679 VDD VSS.t1681 VSS.t1680 sg13_lv_nmos ad=79.8f pd=0.8u as=0 ps=0 w=0.42u l=1u
X2156 VSS.t2061 VDD VSS.t2063 VSS.t2062 sg13_lv_nmos ad=79.8f pd=0.8u as=0 ps=0 w=0.42u l=1u
X2157 a_17710_15423# a_17825_15424# VSS.t24 VSS.t250 sg13_lv_nmos ad=0.1428p pd=1.52u as=0.1426p ps=1.16u w=0.42u l=0.5u
X2158 VDD VSS.t715 VDD VDD sg13_lv_pmos ad=0.19p pd=1.38u as=0 ps=0 w=1u l=1u
X2159 VSS.t302 VDD VSS.t302 VSS.t678 sg13_lv_nmos ad=0.1428p pd=1.52u as=0 ps=0 w=0.42u l=1u
X2160 VSS.t2001 VDD VSS.t2000 VSS.t1999 sg13_lv_nmos ad=0.1428p pd=1.52u as=0 ps=0 w=0.42u l=1u
X2161 VSS.t1388 VDD VSS.t1389 VSS.t377 sg13_lv_nmos ad=79.8f pd=0.8u as=0 ps=0 w=0.42u l=1u
X2162 VSS.t3090 VDD VSS.t3089 VSS.t3088 sg13_lv_nmos ad=0.1428p pd=1.52u as=0 ps=0 w=0.42u l=1u
X2163 sg13g2_buf_16_2.A a_15022_14484# VSS.t24 VSS.t232 sg13_lv_nmos ad=0.1406p pd=1.12u as=0.1406p ps=1.12u w=0.74u l=0.13u
X2164 VSS.t1466 VDD VSS.t1309 VSS.t377 sg13_lv_nmos ad=0.1428p pd=1.52u as=0 ps=0 w=0.42u l=1u
X2165 VSS.t515 VDD VSS.t124 VSS.t514 sg13_lv_nmos ad=0.1428p pd=1.52u as=0 ps=0 w=0.42u l=1u
X2166 VSS.t1080 VDD VSS.t1082 VSS.t1081 sg13_lv_nmos ad=79.8f pd=0.8u as=0 ps=0 w=0.42u l=1u
X2167 VSS.t965 VDD VSS.t964 VSS.t963 sg13_lv_nmos ad=0.1428p pd=1.52u as=0 ps=0 w=0.42u l=1u
X2168 VSS.t1799 VDD VSS.t1801 VSS.t1800 sg13_lv_nmos ad=79.8f pd=0.8u as=0 ps=0 w=0.42u l=1u
X2169 a_25930_14452# a_26373_14495# a_25670_14922# VSS.t68 sg13_lv_nmos ad=79.8f pd=0.8u as=0.1296p ps=1.52u w=0.42u l=0.13u
X2170 VDD VSS.t1149 VDD VDD sg13_lv_pmos ad=0.34p pd=2.68u as=0 ps=0 w=1u l=1u
X2171 VDD VSS.t1758 VDD VDD sg13_lv_pmos ad=0.34p pd=2.68u as=0 ps=0 w=1u l=1u
X2172 VSS.t2785 VDD VSS.t2786 VSS.t412 sg13_lv_nmos ad=79.8f pd=0.8u as=0 ps=0 w=0.42u l=1u
X2173 VDD VSS.t356 VDD VDD sg13_lv_pmos ad=0.34p pd=2.68u as=0 ps=0 w=1u l=1u
X2174 VDD VSS.t3042 VDD VDD sg13_lv_pmos ad=0.19p pd=1.38u as=0 ps=0 w=1u l=1u
X2175 sg13g2_buf_16_2.X a_19438_13726# VDD VDD sg13_lv_pmos ad=0.2128p pd=1.5u as=0.2128p ps=1.5u w=1.12u l=0.13u
X2176 VDD VSS.t1763 VDD VDD sg13_lv_pmos ad=0.34p pd=2.68u as=0 ps=0 w=1u l=1u
X2177 VDD a_27502_15423# sg13g2_or3_1_1.A VDD sg13_lv_pmos ad=0.2254p pd=1.53u as=0.4256p ps=3u w=1.12u l=0.13u
X2178 VSS.t1794 VDD VSS.t1796 VSS.t1795 sg13_lv_nmos ad=79.8f pd=0.8u as=0 ps=0 w=0.42u l=1u
X2179 VDD VSS.t2860 VDD VDD sg13_lv_pmos ad=0.34p pd=2.68u as=0 ps=0 w=1u l=1u
X2180 VSS.t100 VDD VSS.t695 VSS.t694 sg13_lv_nmos ad=79.8f pd=0.8u as=0 ps=0 w=0.42u l=1u
X2181 VSS.t302 VDD VSS.t302 VSS.t684 sg13_lv_nmos ad=0.1428p pd=1.52u as=0 ps=0 w=0.42u l=1u
X2182 VDD VSS.t2447 VDD VDD sg13_lv_pmos ad=0.34p pd=2.68u as=0 ps=0 w=1u l=1u
X2183 a_16556_15960# sg13g2_or3_1_1.B VDD VDD sg13_lv_pmos ad=0.2856p pd=2.36u as=0.2114p ps=1.54u w=0.84u l=0.13u
X2184 VSS.t181 sg13g2_o21ai_1_2.A2 a_24169_14508# VSS.t30 sg13_lv_nmos ad=0.1045p pd=0.93u as=0.187p ps=1.78u w=0.55u l=0.13u
X2185 VDD VSS.t1321 VDD VDD sg13_lv_pmos ad=0.34p pd=2.68u as=0 ps=0 w=1u l=1u
X2186 VSS.t3060 VDD VSS.t3062 VSS.t3061 sg13_lv_nmos ad=79.8f pd=0.8u as=0 ps=0 w=0.42u l=1u
X2187 VDD VSS.t2105 VDD VDD sg13_lv_pmos ad=0.34p pd=2.68u as=0 ps=0 w=1u l=1u
X2188 VDD VSS.t1414 VDD VDD sg13_lv_pmos ad=0.19p pd=1.38u as=0 ps=0 w=1u l=1u
X2189 VDD VSS.t480 VDD VDD sg13_lv_pmos ad=0.34p pd=2.68u as=0 ps=0 w=1u l=1u
X2190 VDD VSS.t2632 VDD VDD sg13_lv_pmos ad=0.34p pd=2.68u as=0 ps=0 w=1u l=1u
X2191 a_3333_15213# sg13g2_dfrbpq_1_2.CLK VSS.t33 VSS.t330 sg13_lv_nmos ad=0.2516p pd=2.16u as=5.01922p ps=33.275u w=0.74u l=0.13u
X2192 a_21070_15423# a_21185_15424# VDD VDD sg13_lv_pmos ad=0.34p pd=2.68u as=0.2254p ps=1.53u w=1u l=0.5u
X2193 VDD VSS.t183 VDD VDD sg13_lv_pmos ad=0.19p pd=1.38u as=0 ps=0 w=1u l=1u
X2194 VDD VSS.t2812 VDD VDD sg13_lv_pmos ad=0.19p pd=1.38u as=0 ps=0 w=1u l=1u
X2195 sg13g2_dfrbpq_1_3.Q a_19530_14484# VDD VDD sg13_lv_pmos ad=0.3808p pd=2.92u as=0.2128p ps=1.5u w=1.12u l=0.13u
X2196 VSS.t756 VDD VSS.t755 VSS.t754 sg13_lv_nmos ad=0.1428p pd=1.52u as=0 ps=0 w=0.42u l=1u
X2197 VDD VSS.t1164 VDD VDD sg13_lv_pmos ad=0.34p pd=2.68u as=0 ps=0 w=1u l=1u
X2198 VSS.t1629 VDD VSS.t1631 VSS.t1630 sg13_lv_nmos ad=79.8f pd=0.8u as=0 ps=0 w=0.42u l=1u
X2199 VSS.t2468 VDD VSS.t2467 VSS.t2466 sg13_lv_nmos ad=0.1428p pd=1.52u as=0 ps=0 w=0.42u l=1u
X2200 a_26373_14495# sg13g2_buf_16_2.X VDD VDD sg13_lv_pmos ad=0.4088p pd=2.97u as=2.3367p ps=15.135u w=1.12u l=0.13u
X2201 VSS.t1824 VDD VSS.t1823 VSS.t1822 sg13_lv_nmos ad=0.1428p pd=1.52u as=0 ps=0 w=0.42u l=1u
X2202 VSS.t2241 VDD VSS.t2240 VSS.t2239 sg13_lv_nmos ad=0.1428p pd=1.52u as=0 ps=0 w=0.42u l=1u
X2203 VSS.t214 VDD VSS.t551 VSS.t555 sg13_lv_nmos ad=0.1428p pd=1.52u as=0 ps=0 w=0.42u l=1u
X2204 sg13g2_dlygate4sd3_1_3.A a_4842_15532# VSS.t106 VSS.t119 sg13_lv_nmos ad=0.2516p pd=2.16u as=0.1406p ps=1.12u w=0.74u l=0.13u
X2205 VDD VSS.t1736 VDD VDD sg13_lv_pmos ad=0.19p pd=1.38u as=0 ps=0 w=1u l=1u
X2206 VSS.t925 VDD VSS.t927 VSS.t926 sg13_lv_nmos ad=79.8f pd=0.8u as=0 ps=0 w=0.42u l=1u
X2207 VSS.t1362 VDD VSS.t1364 VSS.t377 sg13_lv_nmos ad=79.8f pd=0.8u as=0 ps=0 w=0.42u l=1u
X2208 VDD VSS.t1791 VDD VDD sg13_lv_pmos ad=0.19p pd=1.38u as=0 ps=0 w=1u l=1u
X2209 VDD VSS.t3259 VDD VDD sg13_lv_pmos ad=0.34p pd=2.68u as=0 ps=0 w=1u l=1u
X2210 VSS.t1624 VDD VSS.t1626 VSS.t1625 sg13_lv_nmos ad=79.8f pd=0.8u as=0 ps=0 w=0.42u l=1u
X2211 VSS.t2533 VDD VSS.t2535 VSS.t2534 sg13_lv_nmos ad=79.8f pd=0.8u as=0 ps=0 w=0.42u l=1u
X2212 VSS.t851 VDD VSS.t850 VSS.t849 sg13_lv_nmos ad=0.1428p pd=1.52u as=0 ps=0 w=0.42u l=1u
X2213 VDD VSS.t407 VDD VDD sg13_lv_pmos ad=0.19p pd=1.38u as=0 ps=0 w=1u l=1u
X2214 VSS.t100 a_7822_13911# sg13g2_xnor2_1_2.A VSS.t99 sg13_lv_nmos ad=0.1426p pd=1.16u as=0.2516p ps=2.16u w=0.74u l=0.13u
X2215 VDD VSS.t1314 VDD VDD sg13_lv_pmos ad=0.19p pd=1.38u as=0 ps=0 w=1u l=1u
X2216 VSS.t1754 VDD VSS.t1753 VSS.t1752 sg13_lv_nmos ad=0.1428p pd=1.52u as=0 ps=0 w=0.42u l=1u
X2217 VSS.t3280 VDD VSS.t3279 VSS.t3278 sg13_lv_nmos ad=0.1428p pd=1.52u as=0 ps=0 w=0.42u l=1u
X2218 VDD VSS.t2877 VDD VDD sg13_lv_pmos ad=0.19p pd=1.38u as=0 ps=0 w=1u l=1u
X2219 sg13g2_buf_1_0.X a_1192_3900# VDD VDD sg13_lv_pmos ad=0.42p pd=2.99u as=0.2114p ps=1.54u w=1.12u l=0.13u
X2220 VSS.t686 VDD VSS.t686 VSS.t687 sg13_lv_nmos ad=0.1428p pd=1.52u as=0 ps=0 w=0.42u l=1u
X2221 VSS.t1110 VDD VSS.t1112 VSS.t1111 sg13_lv_nmos ad=79.8f pd=0.8u as=0 ps=0 w=0.42u l=1u
X2222 VDD VSS.t1300 VDD VDD sg13_lv_pmos ad=0.19p pd=1.38u as=0 ps=0 w=1u l=1u
X2223 VSS.t449 VDD VSS.t449 VSS.t451 sg13_lv_nmos ad=0.1428p pd=1.52u as=0 ps=0 w=0.42u l=1u
X2224 VSS.t615 VDD VSS.t616 VSS.t33 sg13_lv_nmos ad=79.8f pd=0.8u as=0 ps=0 w=0.42u l=1u
X2225 VSS.t2563 VDD VSS.t2562 VSS.t2561 sg13_lv_nmos ad=0.1428p pd=1.52u as=0 ps=0 w=0.42u l=1u
X2226 VDD VSS.t1425 VDD VDD sg13_lv_pmos ad=0.19p pd=1.38u as=0 ps=0 w=1u l=1u
X2227 VSS.t2756 VDD VSS.t2756 VSS.t412 sg13_lv_nmos ad=0.1428p pd=1.52u as=0 ps=0 w=0.42u l=1u
X2228 VDD VSS.t2808 VDD VDD sg13_lv_pmos ad=0.19p pd=1.38u as=0 ps=0 w=1u l=1u
X2229 a_9418_15457# a_9861_15213# a_9801_15625# VDD sg13_lv_pmos ad=79.8f pd=0.8u as=63f ps=0.72u w=0.42u l=0.13u
X2230 VDD VSS.t178 VDD VDD sg13_lv_pmos ad=0.34p pd=2.68u as=0 ps=0 w=1u l=1u
X2231 VDD VSS.t2617 VDD VDD sg13_lv_pmos ad=0.34p pd=2.68u as=0 ps=0 w=1u l=1u
X2232 VDD VSS.t2440 VDD VDD sg13_lv_pmos ad=0.19p pd=1.38u as=0 ps=0 w=1u l=1u
X2233 VSS.t2498 VDD VSS.t2500 VSS.t2499 sg13_lv_nmos ad=79.8f pd=0.8u as=0 ps=0 w=0.42u l=1u
X2234 VDD VSS.t1586 VDD VDD sg13_lv_pmos ad=0.19p pd=1.38u as=0 ps=0 w=1u l=1u
X2235 a_15722_15532# sg13g2_a21oi_1_0.B1 VDD VDD sg13_lv_pmos ad=0.1176p pd=1.33u as=0.4032p ps=2.96u w=1.12u l=0.13u
X2236 VSS.t255 sg13g2_dfrbpq_1_7.RESET_B a_25764_14922# VSS.t423 sg13_lv_nmos ad=0.1626p pd=1.415u as=60.89999f ps=0.71u w=0.42u l=0.13u
X2237 VSS.t1664 VDD VSS.t1666 VSS.t1665 sg13_lv_nmos ad=79.8f pd=0.8u as=0 ps=0 w=0.42u l=1u
X2238 VSS.t1844 VDD VSS.t1843 VSS.t1842 sg13_lv_nmos ad=0.1428p pd=1.52u as=0 ps=0 w=0.42u l=1u
X2239 VDD VSS.t2565 VDD VDD sg13_lv_pmos ad=0.19p pd=1.38u as=0 ps=0 w=1u l=1u
X2240 VSS.t2226 VDD VSS.t2225 VSS.t2224 sg13_lv_nmos ad=0.1428p pd=1.52u as=0 ps=0 w=0.42u l=1u
X2241 VDD VSS.t1354 VDD VDD sg13_lv_pmos ad=0.34p pd=2.68u as=0 ps=0 w=1u l=1u
X2242 VSS.t1414 VDD VSS.t1413 VSS.t377 sg13_lv_nmos ad=0.1428p pd=1.52u as=0 ps=0 w=0.42u l=1u
X2243 VSS.t2817 VDD VSS.t2818 VSS.t412 sg13_lv_nmos ad=79.8f pd=0.8u as=0 ps=0 w=0.42u l=1u
X2244 VSS.t500 VDD VSS.t502 VSS.t501 sg13_lv_nmos ad=79.8f pd=0.8u as=0 ps=0 w=0.42u l=1u
X2245 VSS.t1080 VDD VSS.t1082 VSS.t1081 sg13_lv_nmos ad=79.8f pd=0.8u as=0 ps=0 w=0.42u l=1u
X2246 VSS.t3075 VDD VSS.t3074 VSS.t3073 sg13_lv_nmos ad=0.1428p pd=1.52u as=0 ps=0 w=0.42u l=1u
X2247 VDD VSS.t562 VDD VDD sg13_lv_pmos ad=0.34p pd=2.68u as=0 ps=0 w=1u l=1u
X2248 VSS.t1125 VDD VSS.t1127 VSS.t1126 sg13_lv_nmos ad=79.8f pd=0.8u as=0 ps=0 w=0.42u l=1u
X2249 VDD VSS.t1441 VDD VDD sg13_lv_pmos ad=0.34p pd=2.68u as=0 ps=0 w=1u l=1u
X2250 VDD VSS.t3102 VDD VDD sg13_lv_pmos ad=0.19p pd=1.38u as=0 ps=0 w=1u l=1u
X2251 VDD VSS.t1968 VDD VDD sg13_lv_pmos ad=0.19p pd=1.38u as=0 ps=0 w=1u l=1u
X2252 VSS.t475 VDD VSS.t475 VSS.t476 sg13_lv_nmos ad=79.8f pd=0.8u as=0 ps=0 w=0.42u l=1u
X2253 VSS.t566 VDD VSS.t565 VSS.t564 sg13_lv_nmos ad=0.1428p pd=1.52u as=0 ps=0 w=0.42u l=1u
X2254 VSS.t14 sg13g2_dfrbpq_1_5.RESET_B a_25956_13722# VSS.t72 sg13_lv_nmos ad=0.1626p pd=1.415u as=60.89999f ps=0.71u w=0.42u l=0.13u
X2255 VDD VSS.t2818 VDD VDD sg13_lv_pmos ad=0.34p pd=2.68u as=0 ps=0 w=1u l=1u
X2256 VDD VSS.t2065 VDD VDD sg13_lv_pmos ad=0.34p pd=2.68u as=0 ps=0 w=1u l=1u
X2257 VDD VSS.t1743 VDD VDD sg13_lv_pmos ad=0.34p pd=2.68u as=0 ps=0 w=1u l=1u
X2258 VDD VSS.t2888 VDD VDD sg13_lv_pmos ad=0.19p pd=1.38u as=0 ps=0 w=1u l=1u
X2259 VDD VSS.t378 VDD VDD sg13_lv_pmos ad=0.34p pd=2.68u as=0 ps=0 w=1u l=1u
X2260 VDD VSS.t1392 VDD VDD sg13_lv_pmos ad=0.19p pd=1.38u as=0 ps=0 w=1u l=1u
X2261 VSS.t621 VDD VSS.t620 VSS.t33 sg13_lv_nmos ad=0.1428p pd=1.52u as=0 ps=0 w=0.42u l=1u
X2262 VDD VSS.t1748 VDD VDD sg13_lv_pmos ad=0.34p pd=2.68u as=0 ps=0 w=1u l=1u
X2263 VSS.t597 VDD VSS.t596 VSS.t33 sg13_lv_nmos ad=0.1428p pd=1.52u as=0 ps=0 w=0.42u l=1u
X2264 VSS.t725 VDD VSS.t725 VSS.t726 sg13_lv_nmos ad=79.8f pd=0.8u as=0 ps=0 w=0.42u l=1u
X2265 VSS.t1340 VDD VSS.t1341 VSS.t377 sg13_lv_nmos ad=79.8f pd=0.8u as=0 ps=0 w=0.42u l=1u
X2266 VSS.t1639 VDD VSS.t1638 VSS.t1637 sg13_lv_nmos ad=0.1428p pd=1.52u as=0 ps=0 w=0.42u l=1u
X2267 VSS.t2548 VDD VSS.t2547 VSS.t2546 sg13_lv_nmos ad=0.1428p pd=1.52u as=0 ps=0 w=0.42u l=1u
X2268 VDD VSS.t2432 VDD VDD sg13_lv_pmos ad=0.34p pd=2.68u as=0 ps=0 w=1u l=1u
X2269 VSS.t582 VDD VSS.t583 VSS.t33 sg13_lv_nmos ad=79.8f pd=0.8u as=0 ps=0 w=0.42u l=1u
X2270 VDD VSS.t749 VDD VDD sg13_lv_pmos ad=0.19p pd=1.38u as=0 ps=0 w=1u l=1u
X2271 VDD sg13g2_xnor2_1_2.A a_6540_13238# VDD sg13_lv_pmos ad=0.4536p pd=2.76u as=0.1596p ps=1.22u w=0.84u l=0.13u
X2272 a_22426_15202# sg13g2_dfrbpq_1_6.Q VDD VDD sg13_lv_pmos ad=0.1428p pd=1.52u as=0.1523p ps=1.38u w=0.42u l=0.13u
X2273 VDD VSS.t63 VDD VDD sg13_lv_pmos ad=0.19p pd=1.38u as=0 ps=0 w=1u l=1u
X2274 VSS.t1427 VDD VSS.t1426 VSS.t377 sg13_lv_nmos ad=0.1428p pd=1.52u as=0 ps=0 w=0.42u l=1u
X2275 VSS.t1614 VDD VSS.t1616 VSS.t1615 sg13_lv_nmos ad=79.8f pd=0.8u as=0 ps=0 w=0.42u l=1u
X2276 sg13g2_dfrbpq_1_3.Q a_19530_14484# VSS.t97 VSS.t25 sg13_lv_nmos ad=0.2516p pd=2.16u as=0.1406p ps=1.12u w=0.74u l=0.13u
X2277 VDD VSS.t700 VDD VDD sg13_lv_pmos ad=0.34p pd=2.68u as=0 ps=0 w=1u l=1u
X2278 VDD VSS.t2777 VDD VDD sg13_lv_pmos ad=0.19p pd=1.38u as=0 ps=0 w=1u l=1u
X2279 VSS.t2006 VDD VSS.t2005 VSS.t2004 sg13_lv_nmos ad=0.1428p pd=1.52u as=0 ps=0 w=0.42u l=1u
X2280 VSS.t2176 VDD VSS.t2178 VSS.t2177 sg13_lv_nmos ad=79.8f pd=0.8u as=0 ps=0 w=0.42u l=1u
X2281 a_3333_15213# sg13g2_dfrbpq_1_2.CLK VDD VDD sg13_lv_pmos ad=0.4088p pd=2.97u as=2.77542p ps=17.49u w=1.12u l=0.13u
X2282 VDD VSS.t1328 VDD VDD sg13_lv_pmos ad=0.19p pd=1.38u as=0 ps=0 w=1u l=1u
X2283 VDD VSS.t2133 VDD VDD sg13_lv_pmos ad=0.19p pd=1.38u as=0 ps=0 w=1u l=1u
X2284 VDD VSS.t214 VDD VDD sg13_lv_pmos ad=0.34p pd=2.68u as=0 ps=0 w=1u l=1u
X2285 VDD VSS.t3244 VDD VDD sg13_lv_pmos ad=0.34p pd=2.68u as=0 ps=0 w=1u l=1u
X2286 VDD VSS.t2487 VDD VDD sg13_lv_pmos ad=0.34p pd=2.68u as=0 ps=0 w=1u l=1u
X2287 VSS.t27 sg13g2_or3_1_2.B a_21827_13690# VSS.t210 sg13_lv_nmos ad=0.1045p pd=0.93u as=0.198p ps=1.27u w=0.55u l=0.13u
X2288 VSS.t1804 VDD VSS.t1806 VSS.t1805 sg13_lv_nmos ad=79.8f pd=0.8u as=0 ps=0 w=0.42u l=1u
X2289 VSS.t1609 VDD VSS.t1611 VSS.t1610 sg13_lv_nmos ad=79.8f pd=0.8u as=0 ps=0 w=0.42u l=1u
X2290 VSS.t2518 VDD VSS.t2520 VSS.t2519 sg13_lv_nmos ad=79.8f pd=0.8u as=0 ps=0 w=0.42u l=1u
X2291 VDD VSS.t580 VDD VDD sg13_lv_pmos ad=0.19p pd=1.38u as=0 ps=0 w=1u l=1u
X2292 VDD VSS.t1372 VDD VDD sg13_lv_pmos ad=0.34p pd=2.68u as=0 ps=0 w=1u l=1u
X2293 VDD VSS.t1728 VDD VDD sg13_lv_pmos ad=0.34p pd=2.68u as=0 ps=0 w=1u l=1u
X2294 VSS.t3105 VDD VSS.t3107 VSS.t3106 sg13_lv_nmos ad=79.8f pd=0.8u as=0 ps=0 w=0.42u l=1u
X2295 VSS.t2096 VDD VSS.t2095 VSS.t2094 sg13_lv_nmos ad=0.1428p pd=1.52u as=0 ps=0 w=0.42u l=1u
X2296 VSS.t1110 VDD VSS.t1112 VSS.t1111 sg13_lv_nmos ad=79.8f pd=0.8u as=0 ps=0 w=0.42u l=1u
X2297 VDD VSS.t3047 VDD VDD sg13_lv_pmos ad=0.19p pd=1.38u as=0 ps=0 w=1u l=1u
X2298 VDD a_7532_15960# counter_value_o[1] VDD sg13_lv_pmos ad=0.2114p pd=1.54u as=0.42p ps=2.99u w=1.12u l=0.13u
X2299 VDD VSS.t1084 VDD VDD sg13_lv_pmos ad=0.34p pd=2.68u as=0 ps=0 w=1u l=1u
X2300 VSS.t1322 VDD VSS.t1321 VSS.t377 sg13_lv_nmos ad=0.1428p pd=1.52u as=0 ps=0 w=0.42u l=1u
X2301 VDD VSS.t1646 VDD VDD sg13_lv_pmos ad=0.19p pd=1.38u as=0 ps=0 w=1u l=1u
X2302 a_27502_15423# a_27617_15424# VSS.t33 VSS.t33 sg13_lv_nmos ad=0.1428p pd=1.52u as=0.1426p ps=1.16u w=0.42u l=0.5u
X2303 VDD VSS.t1417 VDD VDD sg13_lv_pmos ad=0.19p pd=1.38u as=0 ps=0 w=1u l=1u
X2304 VSS.t22 a_10960_15454# a_10609_15311# VSS.t428 sg13_lv_nmos ad=79.8f pd=0.8u as=0.1428p ps=1.52u w=0.42u l=0.13u
X2305 VDD VSS.t2895 VDD VDD sg13_lv_pmos ad=0.34p pd=2.68u as=0 ps=0 w=1u l=1u
X2306 VDD VSS.t2800 VDD VDD sg13_lv_pmos ad=0.19p pd=1.38u as=0 ps=0 w=1u l=1u
X2307 VDD VSS.t2602 VDD VDD sg13_lv_pmos ad=0.34p pd=2.68u as=0 ps=0 w=1u l=1u
X2308 VSS.t910 VDD VSS.t909 VSS.t908 sg13_lv_nmos ad=0.1428p pd=1.52u as=0 ps=0 w=0.42u l=1u
X2309 VSS.t1599 VDD VSS.t1601 VSS.t1600 sg13_lv_nmos ad=79.8f pd=0.8u as=0 ps=0 w=0.42u l=1u
X2310 VDD a_10703_15311# a_10960_15454# VDD sg13_lv_pmos ad=2.8961p pd=18.25u as=79.8f ps=0.8u w=0.42u l=0.13u
X2311 a_6086_14922# a_6891_14495# a_6346_14452# VDD sg13_lv_pmos ad=0.1428p pd=1.52u as=79.8f ps=0.8u w=0.42u l=0.13u
X2312 VSS.t88 a_19120_14726# a_18769_14845# VSS.t25 sg13_lv_nmos ad=79.8f pd=0.8u as=0.1428p ps=1.52u w=0.42u l=0.13u
X2313 VDD VSS.t1381 VDD VDD sg13_lv_pmos ad=0.34p pd=2.68u as=0 ps=0 w=1u l=1u
X2314 VSS.t1829 VDD VSS.t1828 VSS.t1827 sg13_lv_nmos ad=0.1428p pd=1.52u as=0 ps=0 w=0.42u l=1u
X2315 VSS.t600 VDD VSS.t601 VSS.t33 sg13_lv_nmos ad=79.8f pd=0.8u as=0 ps=0 w=0.42u l=1u
X2316 VDD VSS.t812 VDD VDD sg13_lv_pmos ad=0.19p pd=1.38u as=0 ps=0 w=1u l=1u
X2317 VSS.t1125 VDD VSS.t1127 VSS.t1126 sg13_lv_nmos ad=79.8f pd=0.8u as=0 ps=0 w=0.42u l=1u
X2318 VDD VSS.t302 VDD VDD sg13_lv_pmos ad=0.34p pd=2.68u as=0 ps=0 w=1u l=1u
X2319 VSS.t302 VDD VSS.t302 VSS.t711 sg13_lv_nmos ad=0.1428p pd=1.52u as=0 ps=0 w=0.42u l=1u
X2320 VDD VSS.t2118 VDD VDD sg13_lv_pmos ad=0.19p pd=1.38u as=0 ps=0 w=1u l=1u
X2321 VDD VSS.t3264 VDD VDD sg13_lv_pmos ad=0.34p pd=2.68u as=0 ps=0 w=1u l=1u
X2322 VDD VSS.t35 VDD VDD sg13_lv_pmos ad=0.34p pd=2.68u as=0 ps=0 w=1u l=1u
X2323 VSS.t183 VDD VSS.t183 VSS.t722 sg13_lv_nmos ad=0.1428p pd=1.52u as=0 ps=0 w=0.42u l=1u
X2324 VDD VSS.t1801 VDD VDD sg13_lv_pmos ad=0.19p pd=1.38u as=0 ps=0 w=1u l=1u
X2325 VDD VSS.t1418 VDD VDD sg13_lv_pmos ad=0.19p pd=1.38u as=0 ps=0 w=1u l=1u
X2326 VSS.t1299 VDD VSS.t1300 VSS.t377 sg13_lv_nmos ad=79.8f pd=0.8u as=0 ps=0 w=0.42u l=1u
X2327 VDD VSS.t1317 VDD VDD sg13_lv_pmos ad=0.19p pd=1.38u as=0 ps=0 w=1u l=1u
X2328 VSS.t1759 VDD VSS.t1758 VSS.t1757 sg13_lv_nmos ad=0.1428p pd=1.52u as=0 ps=0 w=0.42u l=1u
X2329 VDD VSS.t2880 VDD VDD sg13_lv_pmos ad=0.19p pd=1.38u as=0 ps=0 w=1u l=1u
X2330 VSS.t3250 VDD VSS.t3249 VSS.t3248 sg13_lv_nmos ad=0.1428p pd=1.52u as=0 ps=0 w=0.42u l=1u
X2331 a_26170_15202# sg13g2_a21oi_1_3.Y VDD VDD sg13_lv_pmos ad=0.1428p pd=1.52u as=0.1523p ps=1.38u w=0.42u l=0.13u
X2332 VSS.t40 sg13g2_dfrbpq_1_0.RESET_B a_2724_15234# VSS.t316 sg13_lv_nmos ad=0.1626p pd=1.415u as=60.89999f ps=0.71u w=0.42u l=0.13u
X2333 VSS.t1624 VDD VSS.t1623 VSS.t1622 sg13_lv_nmos ad=0.1428p pd=1.52u as=0 ps=0 w=0.42u l=1u
X2334 VSS.t2533 VDD VSS.t2532 VSS.t2531 sg13_lv_nmos ad=0.1428p pd=1.52u as=0 ps=0 w=0.42u l=1u
X2335 VDD VSS.t1114 VDD VDD sg13_lv_pmos ad=0.34p pd=2.68u as=0 ps=0 w=1u l=1u
X2336 VSS.t2854 VDD VSS.t2855 VSS.t412 sg13_lv_nmos ad=79.8f pd=0.8u as=0 ps=0 w=0.42u l=1u
X2337 VSS.t2503 VDD VSS.t2505 VSS.t2504 sg13_lv_nmos ad=79.8f pd=0.8u as=0 ps=0 w=0.42u l=1u
X2338 VDD VSS.t1591 VDD VDD sg13_lv_pmos ad=0.19p pd=1.38u as=0 ps=0 w=1u l=1u
X2339 VDD VSS.t3059 VDD VDD sg13_lv_pmos ad=0.34p pd=2.68u as=0 ps=0 w=1u l=1u
X2340 VSS.t106 VDD VSS.t106 VSS.t627 sg13_lv_nmos ad=0.1428p pd=1.52u as=0 ps=0 w=0.42u l=1u
X2341 VDD VSS.t929 VDD VDD sg13_lv_pmos ad=0.34p pd=2.68u as=0 ps=0 w=1u l=1u
X2342 VDD VSS.t700 VDD VDD sg13_lv_pmos ad=0.34p pd=2.68u as=0 ps=0 w=1u l=1u
X2343 VSS.t100 VDD VSS.t695 VSS.t694 sg13_lv_nmos ad=79.8f pd=0.8u as=0 ps=0 w=0.42u l=1u
X2344 VSS.t2820 VDD VSS.t2821 VSS.t412 sg13_lv_nmos ad=79.8f pd=0.8u as=0 ps=0 w=0.42u l=1u
X2345 VDD VSS.t2768 VDD VDD sg13_lv_pmos ad=0.19p pd=1.38u as=0 ps=0 w=1u l=1u
X2346 VSS.t1991 VDD VSS.t1990 VSS.t1989 sg13_lv_nmos ad=0.1428p pd=1.52u as=0 ps=0 w=0.42u l=1u
X2347 VSS.t147 VDD VSS.t147 VSS.t436 sg13_lv_nmos ad=0.1428p pd=1.52u as=0 ps=0 w=0.42u l=1u
X2348 VSS.t3080 VDD VSS.t3079 VSS.t3078 sg13_lv_nmos ad=0.1428p pd=1.52u as=0 ps=0 w=0.42u l=1u
X2349 VDD VSS.t1423 VDD VDD sg13_lv_pmos ad=0.34p pd=2.68u as=0 ps=0 w=1u l=1u
X2350 VSS.t2146 VDD VSS.t2148 VSS.t2147 sg13_lv_nmos ad=79.8f pd=0.8u as=0 ps=0 w=0.42u l=1u
X2351 VDD VSS.t607 VDD VDD sg13_lv_pmos ad=0.19p pd=1.38u as=0 ps=0 w=1u l=1u
X2352 VDD VSS.t2821 VDD VDD sg13_lv_pmos ad=0.34p pd=2.68u as=0 ps=0 w=1u l=1u
X2353 VDD VSS.t2070 VDD VDD sg13_lv_pmos ad=0.34p pd=2.68u as=0 ps=0 w=1u l=1u
X2354 VSS.t1789 VDD VSS.t1791 VSS.t1790 sg13_lv_nmos ad=79.8f pd=0.8u as=0 ps=0 w=0.42u l=1u
X2355 VDD VSS.t992 VDD VDD sg13_lv_pmos ad=0.19p pd=1.38u as=0 ps=0 w=1u l=1u
X2356 VDD VSS.t1308 VDD VDD sg13_lv_pmos ad=0.19p pd=1.38u as=0 ps=0 w=1u l=1u
X2357 VDD VSS.t2872 VDD VDD sg13_lv_pmos ad=0.19p pd=1.38u as=0 ps=0 w=1u l=1u
X2358 VSS.t2181 VDD VSS.t2180 VSS.t2179 sg13_lv_nmos ad=0.1428p pd=1.52u as=0 ps=0 w=0.42u l=1u
X2359 a_24923_15996# sg13g2_a21oi_1_0.B1 sg13g2_dlygate4sd3_1_17.A VDD sg13_lv_pmos ad=0.2128p pd=1.5u as=0.3808p ps=2.92u w=1.12u l=0.13u
X2360 a_12020_15202# sg13g2_buf_16_2.A VSS.t63 VSS.t171 sg13_lv_nmos ad=0.1406p pd=1.12u as=0.1406p ps=1.12u w=0.74u l=0.13u
X2361 VSS.t734 VDD VSS.t731 VSS.t733 sg13_lv_nmos ad=0.1428p pd=1.52u as=0 ps=0 w=0.42u l=1u
X2362 VSS.t1744 VDD VSS.t1743 VSS.t1742 sg13_lv_nmos ad=0.1428p pd=1.52u as=0 ps=0 w=0.42u l=1u
X2363 VDD VSS.t3032 VDD VDD sg13_lv_pmos ad=0.19p pd=1.38u as=0 ps=0 w=1u l=1u
X2364 VSS.t3270 VDD VSS.t3269 VSS.t3268 sg13_lv_nmos ad=0.1428p pd=1.52u as=0 ps=0 w=0.42u l=1u
X2365 VSS.t3090 VDD VSS.t3092 VSS.t3091 sg13_lv_nmos ad=79.8f pd=0.8u as=0 ps=0 w=0.42u l=1u
X2366 VDD VSS.t1753 VDD VDD sg13_lv_pmos ad=0.34p pd=2.68u as=0 ps=0 w=1u l=1u
X2367 VDD VSS.t1808 VDD VDD sg13_lv_pmos ad=0.34p pd=2.68u as=0 ps=0 w=1u l=1u
X2368 a_2630_15234# a_3435_15356# a_2890_15457# VDD sg13_lv_pmos ad=0.1428p pd=1.52u as=79.8f ps=0.8u w=0.42u l=0.13u
X2369 VDD VSS.t581 VDD VDD sg13_lv_pmos ad=0.34p pd=2.68u as=0 ps=0 w=1u l=1u
X2370 VSS.t2553 VDD VSS.t2552 VSS.t2551 sg13_lv_nmos ad=0.1428p pd=1.52u as=0 ps=0 w=0.42u l=1u
X2371 VDD VSS.t2437 VDD VDD sg13_lv_pmos ad=0.34p pd=2.68u as=0 ps=0 w=1u l=1u
X2372 VSS.t910 VDD VSS.t909 VSS.t908 sg13_lv_nmos ad=0.1428p pd=1.52u as=0 ps=0 w=0.42u l=1u
X2373 VDD VSS.t2886 VDD VDD sg13_lv_pmos ad=0.34p pd=2.68u as=0 ps=0 w=1u l=1u
X2374 a_25956_14488# a_25930_14452# VDD VDD sg13_lv_pmos ad=0.34p pd=2.68u as=0.36237p ps=2.605u w=1u l=0.13u
X2375 VDD a_4432_15454# a_4377_15549# VDD sg13_lv_pmos ad=2.8961p pd=18.25u as=93.45f ps=0.865u w=0.42u l=0.13u
X2376 VSS.t686 VDD VSS.t686 VSS.t687 sg13_lv_nmos ad=0.1428p pd=1.52u as=0 ps=0 w=0.42u l=1u
X2377 VDD VSS.t1326 VDD VDD sg13_lv_pmos ad=0.19p pd=1.38u as=0 ps=0 w=1u l=1u
X2378 VSS.t1399 VDD VSS.t1400 VSS.t377 sg13_lv_nmos ad=79.8f pd=0.8u as=0 ps=0 w=0.42u l=1u
X2379 VSS.t1584 VDD VSS.t1586 VSS.t1585 sg13_lv_nmos ad=79.8f pd=0.8u as=0 ps=0 w=0.42u l=1u
X2380 VSS.t1654 VDD VSS.t1656 VSS.t1655 sg13_lv_nmos ad=79.8f pd=0.8u as=0 ps=0 w=0.42u l=1u
X2381 VDD VSS.t2780 VDD VDD sg13_lv_pmos ad=0.19p pd=1.38u as=0 ps=0 w=1u l=1u
X2382 VDD a_12020_15202# sg13g2_dfrbpq_1_2.CLK VDD sg13_lv_pmos ad=0.2128p pd=1.5u as=0.2128p ps=1.5u w=1.12u l=0.13u
X2383 VSS.t1976 VDD VSS.t1975 VSS.t1974 sg13_lv_nmos ad=0.1428p pd=1.52u as=0 ps=0 w=0.42u l=1u
X2384 VSS.t214 a_37484_15960# counter_value_o[7] VSS.t215 sg13_lv_nmos ad=0.14875p pd=1.16u as=0.2886p ps=2.26u w=0.74u l=0.13u
X2385 VDD VSS.t1331 VDD VDD sg13_lv_pmos ad=0.19p pd=1.38u as=0 ps=0 w=1u l=1u
X2386 VDD VSS.t2839 VDD VDD sg13_lv_pmos ad=0.19p pd=1.38u as=0 ps=0 w=1u l=1u
X2387 VSS.t594 VDD VSS.t595 VSS.t33 sg13_lv_nmos ad=79.8f pd=0.8u as=0 ps=0 w=0.42u l=1u
X2388 VDD VSS.t587 VDD VDD sg13_lv_pmos ad=0.34p pd=2.68u as=0 ps=0 w=1u l=1u
X2389 VDD VSS.t2457 VDD VDD sg13_lv_pmos ad=0.34p pd=2.68u as=0 ps=0 w=1u l=1u
X2390 VSS.t2518 VDD VSS.t2517 VSS.t2516 sg13_lv_nmos ad=0.1428p pd=1.52u as=0 ps=0 w=0.42u l=1u
X2391 VSS.t369 a_17584_13942# a_17233_13799# VSS.t374 sg13_lv_nmos ad=79.8f pd=0.8u as=0.1428p ps=1.52u w=0.42u l=0.13u
X2392 VSS.t465 VDD VSS.t465 VSS.t471 sg13_lv_nmos ad=0.1428p pd=1.52u as=0 ps=0 w=0.42u l=1u
X2393 VSS.t214 VDD VSS.t214 VSS.t557 sg13_lv_nmos ad=0.1428p pd=1.52u as=0 ps=0 w=0.42u l=1u
X2394 a_7833_14607# a_6891_14495# a_7631_14845# VDD sg13_lv_pmos ad=93.45f pd=0.865u as=0.2048p ps=1.63u w=0.42u l=0.13u
X2395 VSS.t615 VDD VSS.t614 VSS.t33 sg13_lv_nmos ad=0.1428p pd=1.52u as=0 ps=0 w=0.42u l=1u
X2396 a_16485_13701# sg13g2_dfrbpq_1_2.CLK VSS.t302 VSS.t332 sg13_lv_nmos ad=0.2516p pd=2.16u as=15.10457p ps=99.59499u w=0.74u l=0.13u
X2397 VDD VSS.t2098 VDD VDD sg13_lv_pmos ad=0.19p pd=1.38u as=0 ps=0 w=1u l=1u
X2398 VSS.t2066 VDD VSS.t2065 VSS.t2064 sg13_lv_nmos ad=0.1428p pd=1.52u as=0 ps=0 w=0.42u l=1u
X2399 VSS.t2583 VDD VSS.t2585 VSS.t2584 sg13_lv_nmos ad=79.8f pd=0.8u as=0 ps=0 w=0.42u l=1u
X2400 VDD VSS.t1651 VDD VDD sg13_lv_pmos ad=0.19p pd=1.38u as=0 ps=0 w=1u l=1u
X2401 a_17584_13942# a_17327_13799# a_17746_13722# VSS.t375 sg13_lv_nmos ad=0.1428p pd=1.52u as=37.8f ps=0.6u w=0.42u l=0.13u
X2402 VSS.t2751 VDD VSS.t2750 VSS.t412 sg13_lv_nmos ad=0.1428p pd=1.52u as=0 ps=0 w=0.42u l=1u
X2403 VSS.t1110 VDD VSS.t1109 VSS.t1108 sg13_lv_nmos ad=0.1428p pd=1.52u as=0 ps=0 w=0.42u l=1u
X2404 VSS.t3140 VDD VSS.t3139 VSS.t3138 sg13_lv_nmos ad=0.1428p pd=1.52u as=0 ps=0 w=0.42u l=1u
X2405 VDD VSS.t2803 VDD VDD sg13_lv_pmos ad=0.19p pd=1.38u as=0 ps=0 w=1u l=1u
X2406 VDD VSS.t1162 VDD VDD sg13_lv_pmos ad=0.19p pd=1.38u as=0 ps=0 w=1u l=1u
X2407 VDD VSS.t3044 VDD VDD sg13_lv_pmos ad=0.34p pd=2.68u as=0 ps=0 w=1u l=1u
X2408 VSS.t454 VDD VSS.t454 VSS.t455 sg13_lv_nmos ad=79.8f pd=0.8u as=0 ps=0 w=0.42u l=1u
X2409 VSS.t1604 VDD VSS.t1606 VSS.t1605 sg13_lv_nmos ad=79.8f pd=0.8u as=0 ps=0 w=0.42u l=1u
X2410 VSS.t1799 VDD VSS.t1798 VSS.t1797 sg13_lv_nmos ad=0.1428p pd=1.52u as=0 ps=0 w=0.42u l=1u
X2411 a_25094_14484# a_24824_14525# VDD VDD sg13_lv_pmos ad=0.34p pd=2.68u as=0.1523p ps=1.38u w=1u l=0.5u
X2412 sg13g2_dfrbpq_1_7.Q a_27882_14484# VDD VDD sg13_lv_pmos ad=0.3808p pd=2.92u as=0.2128p ps=1.5u w=1.12u l=0.13u
X2413 VDD VSS.t1616 VDD VDD sg13_lv_pmos ad=0.19p pd=1.38u as=0 ps=0 w=1u l=1u
X2414 VSS.t2812 VDD VSS.t2813 VSS.t412 sg13_lv_nmos ad=79.8f pd=0.8u as=0 ps=0 w=0.42u l=1u
X2415 VDD VSS.t2525 VDD VDD sg13_lv_pmos ad=0.19p pd=1.38u as=0 ps=0 w=1u l=1u
X2416 a_9732_15247# a_9963_15356# a_9418_15457# VSS.t4 sg13_lv_nmos ad=0.2373p pd=1.97u as=79.8f ps=0.8u w=0.42u l=0.13u
X2417 a_9670_15247# sg13g2_tiehi_1.L_HI VSS.t19 VSS.t4 sg13_lv_nmos ad=37.8f pd=0.6u as=0.1701p ps=1.65u w=0.42u l=0.13u
X2418 VDD a_12020_15202# sg13g2_dfrbpq_1_2.CLK VDD sg13_lv_pmos ad=0.2128p pd=1.5u as=0.2128p ps=1.5u w=1.12u l=0.13u
X2419 VSS.t2413 VDD VSS.t2415 VSS.t2414 sg13_lv_nmos ad=79.8f pd=0.8u as=0 ps=0 w=0.42u l=1u
X2420 VSS.t2131 VDD VSS.t2133 VSS.t2132 sg13_lv_nmos ad=79.8f pd=0.8u as=0 ps=0 w=0.42u l=1u
X2421 VSS.t728 VDD VSS.t728 VSS.t860 sg13_lv_nmos ad=0.1428p pd=1.52u as=0 ps=0 w=0.42u l=1u
X2422 VSS.t1417 VDD VSS.t1418 VSS.t377 sg13_lv_nmos ad=79.8f pd=0.8u as=0 ps=0 w=0.42u l=1u
X2423 VDD VSS.t2813 VDD VDD sg13_lv_pmos ad=0.34p pd=2.68u as=0 ps=0 w=1u l=1u
X2424 a_7532_15960# sg13g2_dlygate4sd3_1_1.A VSS.t271 VSS.t270 sg13_lv_nmos ad=0.187p pd=1.78u as=0.14875p ps=1.16u w=0.55u l=0.13u
X2425 VSS.t2086 VDD VSS.t2085 VSS.t2084 sg13_lv_nmos ad=0.1428p pd=1.52u as=0 ps=0 w=0.42u l=1u
X2426 VDD VSS.t1299 VDD VDD sg13_lv_pmos ad=0.19p pd=1.38u as=0 ps=0 w=1u l=1u
X2427 VDD VSS.t2786 VDD VDD sg13_lv_pmos ad=0.34p pd=2.68u as=0 ps=0 w=1u l=1u
X2428 VSS.t1729 VDD VSS.t1728 VSS.t1727 sg13_lv_nmos ad=0.1428p pd=1.52u as=0 ps=0 w=0.42u l=1u
X2429 VSS.t3255 VDD VSS.t3254 VSS.t3253 sg13_lv_nmos ad=0.1428p pd=1.52u as=0 ps=0 w=0.42u l=1u
X2430 VSS.t475 VDD VSS.t475 VSS.t478 sg13_lv_nmos ad=79.8f pd=0.8u as=0 ps=0 w=0.42u l=1u
X2431 sg13g2_dfrbpq_1_2.CLK a_12020_15202# VSS.t46 VSS.t45 sg13_lv_nmos ad=0.1406p pd=1.12u as=0.2516p ps=2.16u w=0.74u l=0.13u
X2432 a_10618_14448# sg13g2_dlygate4sd3_1_8.A VSS.t22 VSS.t132 sg13_lv_nmos ad=0.1428p pd=1.52u as=79.8f ps=0.8u w=0.42u l=0.13u
X2433 VDD VSS.t608 VDD VDD sg13_lv_pmos ad=0.34p pd=2.68u as=0 ps=0 w=1u l=1u
X2434 VDD VSS.t1793 VDD VDD sg13_lv_pmos ad=0.34p pd=2.68u as=0 ps=0 w=1u l=1u
X2435 VSS.t1644 VDD VSS.t1646 VSS.t1645 sg13_lv_nmos ad=79.8f pd=0.8u as=0 ps=0 w=0.42u l=1u
X2436 VSS.t1629 VDD VSS.t1628 VSS.t1627 sg13_lv_nmos ad=0.1428p pd=1.52u as=0 ps=0 w=0.42u l=1u
X2437 VSS.t2538 VDD VSS.t2537 VSS.t2536 sg13_lv_nmos ad=0.1428p pd=1.52u as=0 ps=0 w=0.42u l=1u
X2438 VSS.t401 a_19438_13726# sg13g2_buf_16_2.X VSS.t400 sg13_lv_nmos ad=0.2516p pd=2.16u as=0.1406p ps=1.12u w=0.74u l=0.13u
X2439 VDD VSS.t497 VDD VDD sg13_lv_pmos ad=0.19p pd=1.38u as=0 ps=0 w=1u l=1u
X2440 VDD VSS.t1129 VDD VDD sg13_lv_pmos ad=0.34p pd=2.68u as=0 ps=0 w=1u l=1u
X2441 VSS.t2857 VDD VSS.t2858 VSS.t412 sg13_lv_nmos ad=79.8f pd=0.8u as=0 ps=0 w=0.42u l=1u
X2442 VSS.t2036 VDD VSS.t2035 VSS.t2034 sg13_lv_nmos ad=0.1428p pd=1.52u as=0 ps=0 w=0.42u l=1u
X2443 VDD VSS.t1596 VDD VDD sg13_lv_pmos ad=0.19p pd=1.38u as=0 ps=0 w=1u l=1u
X2444 VDD VSS.t3064 VDD VDD sg13_lv_pmos ad=0.34p pd=2.68u as=0 ps=0 w=1u l=1u
X2445 VSS.t373 a_18478_13911# sg13g2_dlygate4sd3_1_4.X VSS.t372 sg13_lv_nmos ad=0.1426p pd=1.16u as=0.2516p ps=2.16u w=0.74u l=0.13u
X2446 VDD VSS.t3237 VDD VDD sg13_lv_pmos ad=0.19p pd=1.38u as=0 ps=0 w=1u l=1u
X2447 VDD a_19438_13726# sg13g2_buf_16_2.X VDD sg13_lv_pmos ad=0.2128p pd=1.5u as=0.2128p ps=1.5u w=1.12u l=0.13u
X2448 VSS.t1639 VDD VSS.t1641 VSS.t1640 sg13_lv_nmos ad=79.8f pd=0.8u as=0 ps=0 w=0.42u l=1u
X2449 VSS.t1819 VDD VSS.t1818 VSS.t1817 sg13_lv_nmos ad=0.1428p pd=1.52u as=0 ps=0 w=0.42u l=1u
X2450 VDD VSS.t1601 VDD VDD sg13_lv_pmos ad=0.19p pd=1.38u as=0 ps=0 w=1u l=1u
X2451 VSS.t2804 VDD VSS.t2805 VSS.t412 sg13_lv_nmos ad=79.8f pd=0.8u as=0 ps=0 w=0.42u l=1u
X2452 VDD VSS.t2771 VDD VDD sg13_lv_pmos ad=0.19p pd=1.38u as=0 ps=0 w=1u l=1u
X2453 VDD VSS.t2510 VDD VDD sg13_lv_pmos ad=0.19p pd=1.38u as=0 ps=0 w=1u l=1u
X2454 VSS.t186 VDD VSS.t186 VSS.t569 sg13_lv_nmos ad=0.1428p pd=1.52u as=0 ps=0 w=0.42u l=1u
X2455 VSS.t3085 VDD VSS.t3084 VSS.t3083 sg13_lv_nmos ad=0.1428p pd=1.52u as=0 ps=0 w=0.42u l=1u
X2456 VDD VSS.t74 VDD VDD sg13_lv_pmos ad=0.34p pd=2.68u as=0 ps=0 w=1u l=1u
X2457 VDD VSS.t1426 VDD VDD sg13_lv_pmos ad=0.34p pd=2.68u as=0 ps=0 w=1u l=1u
X2458 VDD VSS.t2635 VDD VDD sg13_lv_pmos ad=0.19p pd=1.38u as=0 ps=0 w=1u l=1u
X2459 VSS.t2116 VDD VSS.t2118 VSS.t2117 sg13_lv_nmos ad=79.8f pd=0.8u as=0 ps=0 w=0.42u l=1u
X2460 VDD a_9658_14725# sg13g2_tiehi_1.L_HI VDD sg13_lv_pmos ad=2.42015p pd=15.68u as=0.3927p ps=2.99u w=1.155u l=0.13u
X2461 VDD VSS.t2824 VDD VDD sg13_lv_pmos ad=0.34p pd=2.68u as=0 ps=0 w=1u l=1u
X2462 VDD VSS.t2075 VDD VDD sg13_lv_pmos ad=0.34p pd=2.68u as=0 ps=0 w=1u l=1u
X2463 a_6789_14495# sg13g2_dfrbpq_1_2.CLK VDD VDD sg13_lv_pmos ad=0.4088p pd=2.97u as=2.3367p ps=15.135u w=1.12u l=0.13u
X2464 VDD VSS.t1403 VDD VDD sg13_lv_pmos ad=0.19p pd=1.38u as=0 ps=0 w=1u l=1u
X2465 VDD sg13g2_dfrbpq_1_3.Q sg13g2_o21ai_1_2.A2 VDD sg13_lv_pmos ad=0.2128p pd=1.5u as=0.2128p ps=1.5u w=1.12u l=0.13u
X2466 VSS.t1352 VDD VSS.t1353 VSS.t377 sg13_lv_nmos ad=79.8f pd=0.8u as=0 ps=0 w=0.42u l=1u
X2467 VDD VSS.t1758 VDD VDD sg13_lv_pmos ad=0.34p pd=2.68u as=0 ps=0 w=1u l=1u
X2468 a_25764_14922# sg13g2_dfrbpq_1_7.D a_25670_14922# VSS.t30 sg13_lv_nmos ad=60.89999f pd=0.71u as=0.1428p ps=1.52u w=0.42u l=0.13u
X2469 a_24365_14508# sg13g2_or3_1_2.B a_24263_14508# VDD sg13_lv_pmos ad=0.1575p pd=1.315u as=0.19p ps=1.38u w=1u l=0.13u
X2470 VDD VSS.t752 VDD VDD sg13_lv_pmos ad=0.19p pd=1.38u as=0 ps=0 w=1u l=1u
X2471 VDD VSS.t1813 VDD VDD sg13_lv_pmos ad=0.34p pd=2.68u as=0 ps=0 w=1u l=1u
X2472 VDD VSS.t1970 VDD VDD sg13_lv_pmos ad=0.34p pd=2.68u as=0 ps=0 w=1u l=1u
X2473 VSS.t746 VDD VSS.t746 VSS.t872 sg13_lv_nmos ad=0.1428p pd=1.52u as=0 ps=0 w=0.42u l=1u
X2474 VSS.t1110 VDD VSS.t1109 VSS.t1108 sg13_lv_nmos ad=0.1428p pd=1.52u as=0 ps=0 w=0.42u l=1u
X2475 VDD VSS.t1092 VDD VDD sg13_lv_pmos ad=0.19p pd=1.38u as=0 ps=0 w=1u l=1u
X2476 VSS.t243 sg13g2_a21oi_1_0.A2 a_17057_13320# VSS.t242 sg13_lv_nmos ad=0.2516p pd=2.16u as=0.1406p ps=1.12u w=0.74u l=0.13u
X2477 VSS.t393 a_19438_13726# sg13g2_buf_16_2.X VSS.t395 sg13_lv_nmos ad=0.1406p pd=1.12u as=0.1406p ps=1.12u w=0.74u l=0.13u
X2478 sg13g2_or3_1_1.X a_24841_13726# VDD VDD sg13_lv_pmos ad=0.3808p pd=2.92u as=0.3822p ps=1.84u w=1.12u l=0.13u
X2479 VDD VSS.t2889 VDD VDD sg13_lv_pmos ad=0.34p pd=2.68u as=0 ps=0 w=1u l=1u
X2480 VDD a_26373_14495# a_26475_14495# VDD sg13_lv_pmos ad=2.42015p pd=15.68u as=0.3864p ps=2.93u w=1.12u l=0.13u
X2481 VSS.t1568 VDD VSS.t1437 VSS.t377 sg13_lv_nmos ad=0.1428p pd=1.52u as=0 ps=0 w=0.42u l=1u
X2482 VDD VSS.t302 VDD VDD sg13_lv_pmos ad=0.34p pd=2.68u as=0 ps=0 w=1u l=1u
X2483 VSS.t1589 VDD VSS.t1591 VSS.t1590 sg13_lv_nmos ad=79.8f pd=0.8u as=0 ps=0 w=0.42u l=1u
X2484 VDD VSS.t1019 VDD VDD sg13_lv_pmos ad=0.34p pd=2.68u as=0 ps=0 w=1u l=1u
X2485 VSS.t3070 VDD VSS.t3069 VSS.t3068 sg13_lv_nmos ad=0.1428p pd=1.52u as=0 ps=0 w=0.42u l=1u
X2486 VSS.t2901 VDD VSS.t2900 VSS.t412 sg13_lv_nmos ad=0.1428p pd=1.52u as=0 ps=0 w=0.42u l=1u
X2487 VSS.t1981 VDD VSS.t1980 VSS.t1979 sg13_lv_nmos ad=0.1428p pd=1.52u as=0 ps=0 w=0.42u l=1u
X2488 a_21466_15202# sg13g2_o21ai_1_1.Y VDD VDD sg13_lv_pmos ad=0.1428p pd=1.52u as=0.1523p ps=1.38u w=0.42u l=0.13u
X2489 VDD VSS.t1334 VDD VDD sg13_lv_pmos ad=0.19p pd=1.38u as=0 ps=0 w=1u l=1u
X2490 VDD VSS.t2842 VDD VDD sg13_lv_pmos ad=0.19p pd=1.38u as=0 ps=0 w=1u l=1u
X2491 VSS.t2398 VDD VSS.t2400 VSS.t2399 sg13_lv_nmos ad=79.8f pd=0.8u as=0 ps=0 w=0.42u l=1u
X2492 VSS.t2151 VDD VSS.t2153 VSS.t2152 sg13_lv_nmos ad=79.8f pd=0.8u as=0 ps=0 w=0.42u l=1u
X2493 VDD VSS.t2108 VDD VDD sg13_lv_pmos ad=0.19p pd=1.38u as=0 ps=0 w=1u l=1u
X2494 sg13g2_dfrbpq_1_7.Q a_27882_14484# VSS.t142 VSS.t33 sg13_lv_nmos ad=0.2516p pd=2.16u as=0.1406p ps=1.12u w=0.74u l=0.13u
X2495 VDD VSS.t2462 VDD VDD sg13_lv_pmos ad=0.34p pd=2.68u as=0 ps=0 w=1u l=1u
X2496 VSS.t2523 VDD VSS.t2522 VSS.t2521 sg13_lv_nmos ad=0.1428p pd=1.52u as=0 ps=0 w=0.42u l=1u
X2497 VDD sg13g2_tiehi_1.L_HI a_9418_15457# VDD sg13_lv_pmos ad=0.1563p pd=1.22u as=0.147p ps=1.54u w=0.42u l=0.13u
X2498 VDD a_17030_15238# a_17142_15302# VDD sg13_lv_pmos ad=0.2254p pd=1.53u as=0.34p ps=2.68u w=1u l=0.5u
X2499 VSS.t758 VDD VSS.t758 VSS.t878 sg13_lv_nmos ad=0.1428p pd=1.52u as=0 ps=0 w=0.42u l=1u
X2500 VDD VSS.t1608 VDD VDD sg13_lv_pmos ad=0.34p pd=2.68u as=0 ps=0 w=1u l=1u
X2501 VSS.t302 VDD VSS.t812 VSS.t811 sg13_lv_nmos ad=79.8f pd=0.8u as=0 ps=0 w=0.42u l=1u
X2502 VSS.t1689 VDD VSS.t1688 VSS.t1687 sg13_lv_nmos ad=0.1428p pd=1.52u as=0 ps=0 w=0.42u l=1u
X2503 VDD VSS.t1791 VDD VDD sg13_lv_pmos ad=0.19p pd=1.38u as=0 ps=0 w=1u l=1u
X2504 VSS.t2071 VDD VSS.t2070 VSS.t2069 sg13_lv_nmos ad=0.1428p pd=1.52u as=0 ps=0 w=0.42u l=1u
X2505 VDD VSS.t894 VDD VDD sg13_lv_pmos ad=0.34p pd=2.68u as=0 ps=0 w=1u l=1u
X2506 VSS.t1334 VDD VSS.t1333 VSS.t377 sg13_lv_nmos ad=0.1428p pd=1.52u as=0 ps=0 w=0.42u l=1u
X2507 VSS.t576 VDD VSS.t142 VSS.t33 sg13_lv_nmos ad=0.1428p pd=1.52u as=0 ps=0 w=0.42u l=1u
X2508 VSS.t695 VDD VSS.t700 VSS.t699 sg13_lv_nmos ad=79.8f pd=0.8u as=0 ps=0 w=0.42u l=1u
X2509 VDD VSS.t2778 VDD VDD sg13_lv_pmos ad=0.34p pd=2.68u as=0 ps=0 w=1u l=1u
X2510 VSS.t2588 VDD VSS.t2590 VSS.t2589 sg13_lv_nmos ad=79.8f pd=0.8u as=0 ps=0 w=0.42u l=1u
X2511 VDD VSS.t551 VDD VDD sg13_lv_pmos ad=0.34p pd=2.68u as=0 ps=0 w=1u l=1u
X2512 a_19438_13726# sg13g2_buf_16_2.A VDD VDD sg13_lv_pmos ad=0.2128p pd=1.5u as=0.2128p ps=1.5u w=1.12u l=0.13u
X2513 VDD VSS.t2163 VDD VDD sg13_lv_pmos ad=0.19p pd=1.38u as=0 ps=0 w=1u l=1u
X2514 a_25786_15960# sg13g2_o21ai_1_3.Y VDD VDD sg13_lv_pmos ad=0.1428p pd=1.52u as=0.1523p ps=1.38u w=0.42u l=0.13u
X2515 VSS.t1809 VDD VSS.t1808 VSS.t1807 sg13_lv_nmos ad=0.1428p pd=1.52u as=0 ps=0 w=0.42u l=1u
X2516 VSS.t2753 VDD VSS.t2753 VSS.t412 sg13_lv_nmos ad=0.1428p pd=1.52u as=0 ps=0 w=0.42u l=1u
X2517 VSS.t930 VDD VSS.t929 VSS.t928 sg13_lv_nmos ad=0.1428p pd=1.52u as=0 ps=0 w=0.42u l=1u
X2518 VSS.t2849 VDD VSS.t2850 VSS.t412 sg13_lv_nmos ad=79.8f pd=0.8u as=0 ps=0 w=0.42u l=1u
X2519 VSS.t1370 VDD VSS.t1370 VSS.t377 sg13_lv_nmos ad=79.8f pd=0.8u as=0 ps=0 w=0.42u l=1u
X2520 VSS.t1292 VDD VSS.t1293 VSS.t377 sg13_lv_nmos ad=79.8f pd=0.8u as=0 ps=0 w=0.42u l=1u
X2521 VDD VSS.t1581 VDD VDD sg13_lv_pmos ad=0.19p pd=1.38u as=0 ps=0 w=1u l=1u
X2522 VDD VSS.t3049 VDD VDD sg13_lv_pmos ad=0.34p pd=2.68u as=0 ps=0 w=1u l=1u
X2523 VSS.t3110 VDD VSS.t3109 VSS.t3108 sg13_lv_nmos ad=0.1428p pd=1.52u as=0 ps=0 w=0.42u l=1u
X2524 VSS.t612 VDD VSS.t613 VSS.t33 sg13_lv_nmos ad=79.8f pd=0.8u as=0 ps=0 w=0.42u l=1u
X2525 VSS.t1804 VDD VSS.t1803 VSS.t1802 sg13_lv_nmos ad=0.1428p pd=1.52u as=0 ps=0 w=0.42u l=1u
X2526 a_21477_14495# sg13g2_buf_16_2.X VSS.t33 VSS.t298 sg13_lv_nmos ad=0.2516p pd=2.16u as=5.01922p ps=33.275u w=0.74u l=0.13u
X2527 VDD VSS.t1586 VDD VDD sg13_lv_pmos ad=0.19p pd=1.38u as=0 ps=0 w=1u l=1u
X2528 VSS.t2893 VDD VSS.t2892 VSS.t412 sg13_lv_nmos ad=0.1428p pd=1.52u as=0 ps=0 w=0.42u l=1u
X2529 VSS.t579 VDD VSS.t580 VSS.t33 sg13_lv_nmos ad=79.8f pd=0.8u as=0 ps=0 w=0.42u l=1u
X2530 VSS.t2171 VDD VSS.t2173 VSS.t2172 sg13_lv_nmos ad=79.8f pd=0.8u as=0 ps=0 w=0.42u l=1u
X2531 VSS.t2383 VDD VSS.t2385 VSS.t2384 sg13_lv_nmos ad=79.8f pd=0.8u as=0 ps=0 w=0.42u l=1u
X2532 VDD VSS.t3239 VDD VDD sg13_lv_pmos ad=0.34p pd=2.68u as=0 ps=0 w=1u l=1u
X2533 VDD VSS.t2620 VDD VDD sg13_lv_pmos ad=0.19p pd=1.38u as=0 ps=0 w=1u l=1u
X2534 VDD VSS.t2060 VDD VDD sg13_lv_pmos ad=0.34p pd=2.68u as=0 ps=0 w=1u l=1u
X2535 VDD VSS.t1049 VDD VDD sg13_lv_pmos ad=0.34p pd=2.68u as=0 ps=0 w=1u l=1u
X2536 VSS.t1311 VDD VSS.t1312 VSS.t377 sg13_lv_nmos ad=79.8f pd=0.8u as=0 ps=0 w=0.42u l=1u
X2537 VSS.t1347 VDD VSS.t1347 VSS.t377 sg13_lv_nmos ad=0.1428p pd=1.52u as=0 ps=0 w=0.42u l=1u
X2538 a_22149_16033# a_22149_16033# VSS.t3 VSS.t8 sg13_lv_nmos ad=0.111p pd=1.34u as=5.24677p ps=34.365u w=0.3u l=0.13u
X2539 VSS.t1379 VDD VSS.t1379 VSS.t377 sg13_lv_nmos ad=79.8f pd=0.8u as=0 ps=0 w=0.42u l=1u
X2540 VDD VSS.t1743 VDD VDD sg13_lv_pmos ad=0.34p pd=2.68u as=0 ps=0 w=1u l=1u
X2541 VSS.t1649 VDD VSS.t1651 VSS.t1650 sg13_lv_nmos ad=79.8f pd=0.8u as=0 ps=0 w=0.42u l=1u
X2542 VSS.t1634 VDD VSS.t1633 VSS.t1632 sg13_lv_nmos ad=0.1428p pd=1.52u as=0 ps=0 w=0.42u l=1u
X2543 VSS.t2543 VDD VSS.t2542 VSS.t2541 sg13_lv_nmos ad=0.1428p pd=1.52u as=0 ps=0 w=0.42u l=1u
X2544 VDD VSS.t1134 VDD VDD sg13_lv_pmos ad=0.34p pd=2.68u as=0 ps=0 w=1u l=1u
X2545 VSS.t1085 VDD VSS.t1084 VSS.t1083 sg13_lv_nmos ad=0.1428p pd=1.52u as=0 ps=0 w=0.42u l=1u
X2546 VDD VSS.t949 VDD VDD sg13_lv_pmos ad=0.34p pd=2.68u as=0 ps=0 w=1u l=1u
X2547 VSS.t1384 VDD VSS.t1385 VSS.t377 sg13_lv_nmos ad=79.8f pd=0.8u as=0 ps=0 w=0.42u l=1u
X2548 VSS.t2987 VDD VSS.t2860 VSS.t412 sg13_lv_nmos ad=79.8f pd=0.8u as=0 ps=0 w=0.42u l=1u
X2549 VSS.t24 sg13g2_xnor2_1_1.A a_16500_15280# VSS.t276 sg13_lv_nmos ad=0.2272p pd=1.99u as=78.39999f ps=0.885u w=0.64u l=0.13u
X2550 VSS.t594 VDD VSS.t593 VSS.t33 sg13_lv_nmos ad=0.1428p pd=1.52u as=0 ps=0 w=0.42u l=1u
X2551 VDD VSS.t302 VDD VDD sg13_lv_pmos ad=0.34p pd=2.68u as=0 ps=0 w=1u l=1u
X2552 VDD VSS.t1318 VDD VDD sg13_lv_pmos ad=0.34p pd=2.68u as=0 ps=0 w=1u l=1u
X2553 VDD VSS.t3034 VDD VDD sg13_lv_pmos ad=0.34p pd=2.68u as=0 ps=0 w=1u l=1u
X2554 VDD VSS.t147 VDD VDD sg13_lv_pmos ad=0.34p pd=2.68u as=0 ps=0 w=1u l=1u
X2555 VSS.t1966 VDD VSS.t1965 VSS.t1964 sg13_lv_nmos ad=0.1428p pd=1.52u as=0 ps=0 w=0.42u l=1u
X2556 VSS.t695 VDD VSS.t695 VSS.t696 sg13_lv_nmos ad=0.1428p pd=1.52u as=0 ps=0 w=0.42u l=1u
X2557 VSS.t14 VDD VSS.t14 VSS.t723 sg13_lv_nmos ad=0.1428p pd=1.52u as=0 ps=0 w=0.42u l=1u
X2558 VSS.t1145 VDD VSS.t1147 VSS.t1146 sg13_lv_nmos ad=79.8f pd=0.8u as=0 ps=0 w=0.42u l=1u
X2559 VDD VSS.t1325 VDD VDD sg13_lv_pmos ad=0.19p pd=1.38u as=0 ps=0 w=1u l=1u
X2560 VDD VSS.t1560 VDD VDD sg13_lv_pmos ad=0.34p pd=2.68u as=0 ps=0 w=1u l=1u
X2561 VDD VSS.t2834 VDD VDD sg13_lv_pmos ad=0.19p pd=1.38u as=0 ps=0 w=1u l=1u
X2562 VSS.t3055 VDD VSS.t3054 VSS.t3053 sg13_lv_nmos ad=0.1428p pd=1.52u as=0 ps=0 w=0.42u l=1u
X2563 VSS.t2508 VDD VSS.t2507 VSS.t2506 sg13_lv_nmos ad=0.1428p pd=1.52u as=0 ps=0 w=0.42u l=1u
X2564 VSS.t2121 VDD VSS.t2123 VSS.t2122 sg13_lv_nmos ad=79.8f pd=0.8u as=0 ps=0 w=0.42u l=1u
X2565 a_2724_15234# sg13g2_and2_1_0.X a_2630_15234# VSS.t77 sg13_lv_nmos ad=60.89999f pd=0.71u as=0.1428p ps=1.52u w=0.42u l=0.13u
X2566 VSS.t302 VDD VSS.t302 VSS.t675 sg13_lv_nmos ad=79.8f pd=0.8u as=0 ps=0 w=0.42u l=1u
X2567 VDD VSS.t715 VDD VDD sg13_lv_pmos ad=0.19p pd=1.38u as=0 ps=0 w=1u l=1u
X2568 VDD VSS.t1012 VDD VDD sg13_lv_pmos ad=0.19p pd=1.38u as=0 ps=0 w=1u l=1u
X2569 VSS.t1402 VDD VSS.t1403 VSS.t377 sg13_lv_nmos ad=79.8f pd=0.8u as=0 ps=0 w=0.42u l=1u
X2570 VDD VSS.t1593 VDD VDD sg13_lv_pmos ad=0.34p pd=2.68u as=0 ps=0 w=1u l=1u
X2571 VDD VSS.t2808 VDD VDD sg13_lv_pmos ad=0.34p pd=2.68u as=0 ps=0 w=1u l=1u
X2572 VSS.t2823 VDD VSS.t2821 VSS.t412 sg13_lv_nmos ad=0.1428p pd=1.52u as=0 ps=0 w=0.42u l=1u
X2573 VDD VSS.t532 VDD VDD sg13_lv_pmos ad=0.19p pd=1.38u as=0 ps=0 w=1u l=1u
X2574 VSS.t2573 VDD VSS.t2575 VSS.t2574 sg13_lv_nmos ad=79.8f pd=0.8u as=0 ps=0 w=0.42u l=1u
X2575 VDD VSS.t1728 VDD VDD sg13_lv_pmos ad=0.34p pd=2.68u as=0 ps=0 w=1u l=1u
X2576 VSS.t1619 VDD VSS.t1618 VSS.t1617 sg13_lv_nmos ad=0.1428p pd=1.52u as=0 ps=0 w=0.42u l=1u
X2577 VSS.t2528 VDD VSS.t2527 VSS.t2526 sg13_lv_nmos ad=0.1428p pd=1.52u as=0 ps=0 w=0.42u l=1u
X2578 sg13g2_buf_16_2.A a_15022_14484# VDD VDD sg13_lv_pmos ad=0.2128p pd=1.5u as=0.2128p ps=1.5u w=1.12u l=0.13u
X2579 VSS.t930 VDD VSS.t929 VSS.t928 sg13_lv_nmos ad=0.1428p pd=1.52u as=0 ps=0 w=0.42u l=1u
X2580 VDD VSS.t2148 VDD VDD sg13_lv_pmos ad=0.19p pd=1.38u as=0 ps=0 w=1u l=1u
X2581 VSS.t33 a_9861_15213# a_9963_15356# VSS.t43 sg13_lv_nmos ad=5.4375p pd=36.05u as=0.2516p ps=2.16u w=0.74u l=0.13u
X2582 VSS.t302 VDD VSS.t302 VSS.t709 sg13_lv_nmos ad=0.1428p pd=1.52u as=0 ps=0 w=0.42u l=1u
X2583 VDD VSS.t14 VDD VDD sg13_lv_pmos ad=0.19p pd=1.38u as=0 ps=0 w=1u l=1u
X2584 VSS.t1160 VDD VSS.t1162 VSS.t1161 sg13_lv_nmos ad=79.8f pd=0.8u as=0 ps=0 w=0.42u l=1u
X2585 VDD VSS.t1646 VDD VDD sg13_lv_pmos ad=0.19p pd=1.38u as=0 ps=0 w=1u l=1u
X2586 a_17219_16265# sg13g2_or3_1_2.B a_17517_16020# VDD sg13_lv_pmos ad=0.34p pd=2.68u as=0.19p ps=1.38u w=1u l=0.13u
X2587 VDD VSS.t1309 VDD VDD sg13_lv_pmos ad=0.34p pd=2.68u as=0 ps=0 w=1u l=1u
X2588 VDD VSS.t2873 VDD VDD sg13_lv_pmos ad=0.34p pd=2.68u as=0 ps=0 w=1u l=1u
X2589 VDD VSS.t2100 VDD VDD sg13_lv_pmos ad=0.34p pd=2.68u as=0 ps=0 w=1u l=1u
X2590 a_2059_14832# sg13g2_buf_1_10.X a_1965_14832# VSS.t289 sg13_lv_nmos ad=0.1216p pd=1.02u as=0.2176p ps=1.96u w=0.64u l=0.13u
X2591 VSS.t1594 VDD VSS.t1596 VSS.t1595 sg13_lv_nmos ad=79.8f pd=0.8u as=0 ps=0 w=0.42u l=1u
X2592 VSS.t2816 VDD VSS.t2815 VSS.t412 sg13_lv_nmos ad=0.1428p pd=1.52u as=0 ps=0 w=0.42u l=1u
X2593 VDD VSS.t1301 VDD VDD sg13_lv_pmos ad=0.34p pd=2.68u as=0 ps=0 w=1u l=1u
X2594 VSS.t378 reset_n_i a_1192_9948# VSS.t377 sg13_lv_nmos ad=0.14875p pd=1.16u as=0.187p ps=1.78u w=0.55u l=0.13u
X2595 VSS.t63 sg13g2_buf_16_2.A a_12020_15202# VSS.t170 sg13_lv_nmos ad=0.1406p pd=1.12u as=0.1406p ps=1.12u w=0.74u l=0.13u
X2596 VDD VSS.t1167 VDD VDD sg13_lv_pmos ad=0.19p pd=1.38u as=0 ps=0 w=1u l=1u
X2597 VDD VSS.t1337 VDD VDD sg13_lv_pmos ad=0.19p pd=1.38u as=0 ps=0 w=1u l=1u
X2598 VSS.t2156 VDD VSS.t2158 VSS.t2157 sg13_lv_nmos ad=79.8f pd=0.8u as=0 ps=0 w=0.42u l=1u
X2599 VDD VSS.t2113 VDD VDD sg13_lv_pmos ad=0.19p pd=1.38u as=0 ps=0 w=1u l=1u
X2600 VDD VSS.t979 VDD VDD sg13_lv_pmos ad=0.34p pd=2.68u as=0 ps=0 w=1u l=1u
X2601 VSS.t2994 VDD VSS.t2866 VSS.t412 sg13_lv_nmos ad=0.1428p pd=1.52u as=0 ps=0 w=0.42u l=1u
X2602 VDD VSS.t2467 VDD VDD sg13_lv_pmos ad=0.34p pd=2.68u as=0 ps=0 w=1u l=1u
X2603 VSS.t2368 VDD VSS.t2370 VSS.t2369 sg13_lv_nmos ad=79.8f pd=0.8u as=0 ps=0 w=0.42u l=1u
X2604 VDD VSS.t465 VDD VDD sg13_lv_pmos ad=0.34p pd=2.68u as=0 ps=0 w=1u l=1u
X2605 VDD VSS.t1613 VDD VDD sg13_lv_pmos ad=0.34p pd=2.68u as=0 ps=0 w=1u l=1u
X2606 VDD VSS.t487 VDD VDD sg13_lv_pmos ad=0.19p pd=1.38u as=0 ps=0 w=1u l=1u
X2607 VDD VSS.t1786 VDD VDD sg13_lv_pmos ad=0.19p pd=1.38u as=0 ps=0 w=1u l=1u
X2608 VSS.t1659 VDD VSS.t1658 VSS.t1657 sg13_lv_nmos ad=0.1428p pd=1.52u as=0 ps=0 w=0.42u l=1u
X2609 VSS.t2076 VDD VSS.t2075 VSS.t2074 sg13_lv_nmos ad=0.1428p pd=1.52u as=0 ps=0 w=0.42u l=1u
X2610 VDD sg13g2_dfrbpq_1_3.Q sg13g2_or3_1_1.C VDD sg13_lv_pmos ad=0.2128p pd=1.5u as=0.2128p ps=1.5u w=1.12u l=0.13u
X2611 VDD VSS.t2780 VDD VDD sg13_lv_pmos ad=0.34p pd=2.68u as=0 ps=0 w=1u l=1u
X2612 VDD VSS.t1042 VDD VDD sg13_lv_pmos ad=0.19p pd=1.38u as=0 ps=0 w=1u l=1u
X2613 VSS.t1085 VDD VSS.t1084 VSS.t1083 sg13_lv_nmos ad=0.1428p pd=1.52u as=0 ps=0 w=0.42u l=1u
X2614 VDD VSS.t2475 VDD VDD sg13_lv_pmos ad=0.19p pd=1.38u as=0 ps=0 w=1u l=1u
X2615 VDD VSS.t2168 VDD VDD sg13_lv_pmos ad=0.19p pd=1.38u as=0 ps=0 w=1u l=1u
X2616 VSS.t1130 VDD VSS.t1129 VSS.t1128 sg13_lv_nmos ad=0.1428p pd=1.52u as=0 ps=0 w=0.42u l=1u
X2617 a_7160_15242# sg13g2_xnor2_1_2.A a_7058_15242# VSS.t107 sg13_lv_nmos ad=0.1406p pd=1.12u as=0.1406p ps=1.12u w=0.74u l=0.13u
X2618 VSS.t255 a_25774_15423# sg13g2_dfrbpq_1_7.D VSS.t28 sg13_lv_nmos ad=0.1426p pd=1.16u as=0.2516p ps=2.16u w=0.74u l=0.13u
X2619 VSS.t1409 VDD VSS.t1411 VSS.t377 sg13_lv_nmos ad=79.8f pd=0.8u as=0 ps=0 w=0.42u l=1u
X2620 VSS.t1814 VDD VSS.t1813 VSS.t1812 sg13_lv_nmos ad=0.1428p pd=1.52u as=0 ps=0 w=0.42u l=1u
X2621 VSS.t2980 VDD VSS.t2852 VSS.t412 sg13_lv_nmos ad=79.8f pd=0.8u as=0 ps=0 w=0.42u l=1u
X2622 VDD VSS.t2789 VDD VDD sg13_lv_pmos ad=0.19p pd=1.38u as=0 ps=0 w=1u l=1u
X2623 VDD VSS.t611 VDD VDD sg13_lv_pmos ad=0.34p pd=2.68u as=0 ps=0 w=1u l=1u
X2624 VSS.t3115 VDD VSS.t3114 VSS.t3113 sg13_lv_nmos ad=0.1428p pd=1.52u as=0 ps=0 w=0.42u l=1u
X2625 VSS.t2493 VDD VSS.t2495 VSS.t2494 sg13_lv_nmos ad=79.8f pd=0.8u as=0 ps=0 w=0.42u l=1u
X2626 VSS.t588 VDD VSS.t587 VSS.t33 sg13_lv_nmos ad=0.1428p pd=1.52u as=0 ps=0 w=0.42u l=1u
X2627 VDD VSS.t1393 VDD VDD sg13_lv_pmos ad=0.34p pd=2.68u as=0 ps=0 w=1u l=1u
X2628 VSS.t1579 VDD VSS.t1581 VSS.t1580 sg13_lv_nmos ad=79.8f pd=0.8u as=0 ps=0 w=0.42u l=1u
X2629 a_21166_16263# a_21281_16262# VSS.t117 VSS.t116 sg13_lv_nmos ad=0.1428p pd=1.52u as=0.1426p ps=1.16u w=0.42u l=0.5u
X2630 a_18106_15202# sg13g2_dlygate4sd3_1_5.A VDD VDD sg13_lv_pmos ad=0.1428p pd=1.52u as=0.1523p ps=1.38u w=0.42u l=0.13u
X2631 VSS.t1145 VDD VSS.t1147 VSS.t1146 sg13_lv_nmos ad=79.8f pd=0.8u as=0 ps=0 w=0.42u l=1u
X2632 VSS.t1331 VDD VSS.t1332 VSS.t377 sg13_lv_nmos ad=79.8f pd=0.8u as=0 ps=0 w=0.42u l=1u
X2633 VDD VSS.t1591 VDD VDD sg13_lv_pmos ad=0.19p pd=1.38u as=0 ps=0 w=1u l=1u
X2634 VDD VSS.t2500 VDD VDD sg13_lv_pmos ad=0.19p pd=1.38u as=0 ps=0 w=1u l=1u
X2635 VSS.t29 a_22426_15202# a_22145_15424# VSS.t28 sg13_lv_nmos ad=79.8f pd=0.8u as=0.1428p ps=1.52u w=0.42u l=0.5u
X2636 VDD VSS.t100 VDD VDD sg13_lv_pmos ad=0.19p pd=1.38u as=0 ps=0 w=1u l=1u
X2637 VDD VSS.t740 VDD VDD sg13_lv_pmos ad=0.19p pd=1.38u as=0 ps=0 w=1u l=1u
X2638 VDD VSS.t942 VDD VDD sg13_lv_pmos ad=0.19p pd=1.38u as=0 ps=0 w=1u l=1u
X2639 VSS.t1428 VDD VSS.t1429 VSS.t377 sg13_lv_nmos ad=79.8f pd=0.8u as=0 ps=0 w=0.42u l=1u
X2640 VSS.t2388 VDD VSS.t2390 VSS.t2389 sg13_lv_nmos ad=79.8f pd=0.8u as=0 ps=0 w=0.42u l=1u
X2641 VDD VSS.t1057 VDD VDD sg13_lv_pmos ad=0.19p pd=1.38u as=0 ps=0 w=1u l=1u
X2642 VDD VSS.t1420 VDD VDD sg13_lv_pmos ad=0.34p pd=2.68u as=0 ps=0 w=1u l=1u
X2643 VSS.t2106 VDD VSS.t2108 VSS.t2107 sg13_lv_nmos ad=79.8f pd=0.8u as=0 ps=0 w=0.42u l=1u
X2644 VSS.t29 a_22576_14726# a_22225_14845# VSS.t30 sg13_lv_nmos ad=79.8f pd=0.8u as=0.1428p ps=1.52u w=0.42u l=0.13u
X2645 VSS.t2850 VDD VSS.t2850 VSS.t412 sg13_lv_nmos ad=79.8f pd=0.8u as=0 ps=0 w=0.42u l=1u
X2646 VDD VSS.t2625 VDD VDD sg13_lv_pmos ad=0.19p pd=1.38u as=0 ps=0 w=1u l=1u
X2647 VSS.t1609 VDD VSS.t1608 VSS.t1607 sg13_lv_nmos ad=0.1428p pd=1.52u as=0 ps=0 w=0.42u l=1u
X2648 VDD VSS.t2800 VDD VDD sg13_lv_pmos ad=0.34p pd=2.68u as=0 ps=0 w=1u l=1u
X2649 a_12020_15202# sg13g2_buf_16_2.A VDD VDD sg13_lv_pmos ad=0.2128p pd=1.5u as=0.2128p ps=1.5u w=1.12u l=0.13u
X2650 VDD VSS.t1344 VDD VDD sg13_lv_pmos ad=0.34p pd=2.68u as=0 ps=0 w=1u l=1u
X2651 VDD VSS.t2850 VDD VDD sg13_lv_pmos ad=0.34p pd=2.68u as=0 ps=0 w=1u l=1u
X2652 VDD VSS.t2125 VDD VDD sg13_lv_pmos ad=0.34p pd=2.68u as=0 ps=0 w=1u l=1u
X2653 a_27472_14726# sg13g2_dfrbpq_1_7.RESET_B VDD VDD sg13_lv_pmos ad=79.8f pd=0.8u as=2.42015p ps=15.68u w=0.42u l=0.13u
X2654 a_8218_13690# sg13g2_dlygate4sd3_1_1.A VDD VDD sg13_lv_pmos ad=0.1428p pd=1.52u as=0.1523p ps=1.38u w=0.42u l=0.13u
X2655 a_26148_14040# a_26122_13945# VSS.t14 VSS.t433 sg13_lv_nmos ad=0.2516p pd=2.16u as=0.1626p ps=1.415u w=0.74u l=0.13u
X2656 VSS.t1160 VDD VSS.t1162 VSS.t1161 sg13_lv_nmos ad=79.8f pd=0.8u as=0 ps=0 w=0.42u l=1u
X2657 VDD VSS.t1401 VDD VDD sg13_lv_pmos ad=0.34p pd=2.68u as=0 ps=0 w=1u l=1u
X2658 VSS.t1604 VDD VSS.t1603 VSS.t1602 sg13_lv_nmos ad=0.1428p pd=1.52u as=0 ps=0 w=0.42u l=1u
X2659 VSS.t2513 VDD VSS.t2512 VSS.t2511 sg13_lv_nmos ad=0.1428p pd=1.52u as=0 ps=0 w=0.42u l=1u
X2660 a_17746_13722# sg13g2_dfrbpq_1_2.RESET_B VSS.t369 VSS.t3305 sg13_lv_nmos ad=37.8f pd=0.6u as=79.8f ps=0.8u w=0.42u l=0.13u
X2661 VDD VSS.t1808 VDD VDD sg13_lv_pmos ad=0.34p pd=2.68u as=0 ps=0 w=1u l=1u
X2662 VSS.t2973 VDD VSS.t2844 VSS.t412 sg13_lv_nmos ad=79.8f pd=0.8u as=0 ps=0 w=0.42u l=1u
X2663 VDD VSS.t581 VDD VDD sg13_lv_pmos ad=0.34p pd=2.68u as=0 ps=0 w=1u l=1u
X2664 VDD VSS.t3039 VDD VDD sg13_lv_pmos ad=0.34p pd=2.68u as=0 ps=0 w=1u l=1u
X2665 VDD VSS.t2085 VDD VDD sg13_lv_pmos ad=0.34p pd=2.68u as=0 ps=0 w=1u l=1u
X2666 a_2916_15552# a_2890_15457# VDD VDD sg13_lv_pmos ad=0.34p pd=2.68u as=0.36237p ps=2.605u w=1u l=0.13u
X2667 VSS.t16 clock_i a_15022_14484# VSS.t363 sg13_lv_nmos ad=0.1406p pd=1.12u as=0.1406p ps=1.12u w=0.74u l=0.13u
X2668 VSS.t695 VDD VSS.t700 VSS.t699 sg13_lv_nmos ad=79.8f pd=0.8u as=0 ps=0 w=0.42u l=1u
X2669 VSS.t1020 VDD VSS.t1019 VSS.t1018 sg13_lv_nmos ad=0.1428p pd=1.52u as=0 ps=0 w=0.42u l=1u
X2670 VSS.t2428 VDD VSS.t2430 VSS.t2429 sg13_lv_nmos ad=79.8f pd=0.8u as=0 ps=0 w=0.42u l=1u
X2671 VDD VSS.t2420 VDD VDD sg13_lv_pmos ad=0.19p pd=1.38u as=0 ps=0 w=1u l=1u
X2672 VDD VSS.t3212 VDD VDD sg13_lv_pmos ad=0.19p pd=1.38u as=0 ps=0 w=1u l=1u
X2673 VDD a_9861_15213# a_9963_15356# VDD sg13_lv_pmos ad=2.8961p pd=18.25u as=0.3864p ps=2.93u w=1.12u l=0.13u
X2674 VDD VSS.t568 VDD VDD sg13_lv_pmos ad=0.19p pd=1.38u as=0 ps=0 w=1u l=1u
X2675 a_22521_14607# a_21579_14495# a_22319_14845# VDD sg13_lv_pmos ad=93.45f pd=0.865u as=0.2048p ps=1.63u w=0.42u l=0.13u
X2676 a_4078_14751# a_4193_14750# VDD VDD sg13_lv_pmos ad=0.34p pd=2.68u as=0.2254p ps=1.53u w=1u l=0.5u
X2677 VSS.t2987 VDD VSS.t2858 VSS.t412 sg13_lv_nmos ad=0.1428p pd=1.52u as=0 ps=0 w=0.42u l=1u
X2678 VDD VSS.t2814 VDD VDD sg13_lv_pmos ad=0.34p pd=2.68u as=0 ps=0 w=1u l=1u
X2679 VDD VSS.t2452 VDD VDD sg13_lv_pmos ad=0.34p pd=2.68u as=0 ps=0 w=1u l=1u
X2680 VDD VSS.t1024 VDD VDD sg13_lv_pmos ad=0.34p pd=2.68u as=0 ps=0 w=1u l=1u
X2681 VDD VSS.t1598 VDD VDD sg13_lv_pmos ad=0.34p pd=2.68u as=0 ps=0 w=1u l=1u
X2682 VSS.t895 VDD VSS.t894 VSS.t893 sg13_lv_nmos ad=0.1428p pd=1.52u as=0 ps=0 w=0.42u l=1u
X2683 VSS.t2236 VDD VSS.t2238 VSS.t2237 sg13_lv_nmos ad=79.8f pd=0.8u as=0 ps=0 w=0.42u l=1u
X2684 VDD VSS.t947 VDD VDD sg13_lv_pmos ad=0.19p pd=1.38u as=0 ps=0 w=1u l=1u
X2685 VDD VSS.t766 VDD VDD sg13_lv_pmos ad=0.19p pd=1.38u as=0 ps=0 w=1u l=1u
X2686 VSS.t2807 VDD VSS.t2806 VSS.t412 sg13_lv_nmos ad=0.1428p pd=1.52u as=0 ps=0 w=0.42u l=1u
X2687 VDD sg13g2_a21oi_1_0.A1 a_16955_12972# VDD sg13_lv_pmos ad=0.2128p pd=1.5u as=0.2128p ps=1.5u w=1.12u l=0.13u
X2688 VSS.t760 VDD VSS.t760 VSS.t880 sg13_lv_nmos ad=0.1428p pd=1.52u as=0 ps=0 w=0.42u l=1u
X2689 VDD VSS.t529 VDD VDD sg13_lv_pmos ad=0.34p pd=2.68u as=0 ps=0 w=1u l=1u
X2690 VSS.t1130 VDD VSS.t1129 VSS.t1128 sg13_lv_nmos ad=0.1428p pd=1.52u as=0 ps=0 w=0.42u l=1u
X2691 VDD VSS.t1788 VDD VDD sg13_lv_pmos ad=0.34p pd=2.68u as=0 ps=0 w=1u l=1u
X2692 VDD VSS.t620 VDD VDD sg13_lv_pmos ad=0.34p pd=2.68u as=0 ps=0 w=1u l=1u
X2693 VDD VSS.t899 VDD VDD sg13_lv_pmos ad=0.34p pd=2.68u as=0 ps=0 w=1u l=1u
X2694 VDD VSS.t1651 VDD VDD sg13_lv_pmos ad=0.19p pd=1.38u as=0 ps=0 w=1u l=1u
X2695 VSS.t1290 VDD VSS.t1291 VSS.t377 sg13_lv_nmos ad=79.8f pd=0.8u as=0 ps=0 w=0.42u l=1u
X2696 VDD VSS.t1312 VDD VDD sg13_lv_pmos ad=0.34p pd=2.68u as=0 ps=0 w=1u l=1u
X2697 VDD VSS.t2876 VDD VDD sg13_lv_pmos ad=0.34p pd=2.68u as=0 ps=0 w=1u l=1u
X2698 a_18021_14495# sg13g2_buf_16_2.X VSS.t33 VSS.t300 sg13_lv_nmos ad=0.2516p pd=2.16u as=5.01922p ps=33.275u w=0.74u l=0.13u
X2699 VSS.t1327 VDD VSS.t1326 VSS.t377 sg13_lv_nmos ad=0.1428p pd=1.52u as=0 ps=0 w=0.42u l=1u
X2700 VSS.t3100 VDD VSS.t3099 VSS.t3098 sg13_lv_nmos ad=0.1428p pd=1.52u as=0 ps=0 w=0.42u l=1u
X2701 VDD VSS.t1419 VDD VDD sg13_lv_pmos ad=0.34p pd=2.68u as=0 ps=0 w=1u l=1u
X2702 VSS.t935 VDD VSS.t934 VSS.t933 sg13_lv_nmos ad=0.1428p pd=1.52u as=0 ps=0 w=0.42u l=1u
X2703 VSS.t131 a_12524_15960# counter_value_o[2] VSS.t148 sg13_lv_nmos ad=0.14875p pd=1.16u as=0.2886p ps=2.26u w=0.74u l=0.13u
X2704 VSS.t1295 VDD VSS.t1296 VSS.t377 sg13_lv_nmos ad=79.8f pd=0.8u as=0 ps=0 w=0.42u l=1u
X2705 VDD VSS.t2960 VDD VDD sg13_lv_pmos ad=0.19p pd=1.38u as=0 ps=0 w=1u l=1u
X2706 VSS.t2373 VDD VSS.t2375 VSS.t2374 sg13_lv_nmos ad=79.8f pd=0.8u as=0 ps=0 w=0.42u l=1u
X2707 VSS.t2498 VDD VSS.t2497 VSS.t2496 sg13_lv_nmos ad=0.1428p pd=1.52u as=0 ps=0 w=0.42u l=1u
X2708 VSS.t819 VDD VSS.t373 VSS.t820 sg13_lv_nmos ad=79.8f pd=0.8u as=0 ps=0 w=0.42u l=1u
X2709 VSS.t1050 VDD VSS.t1049 VSS.t1048 sg13_lv_nmos ad=0.1428p pd=1.52u as=0 ps=0 w=0.42u l=1u
X2710 sg13g2_buf_16_2.A a_15022_14484# VSS.t127 VSS.t228 sg13_lv_nmos ad=0.1406p pd=1.12u as=0.1406p ps=1.12u w=0.74u l=0.13u
X2711 sg13g2_buf_16_2.A a_15022_14484# VSS.t24 VSS.t240 sg13_lv_nmos ad=0.1406p pd=1.12u as=0.1406p ps=1.12u w=0.74u l=0.13u
X2712 VDD VSS.t914 VDD VDD sg13_lv_pmos ad=0.34p pd=2.68u as=0 ps=0 w=1u l=1u
X2713 VDD VSS.t1102 VDD VDD sg13_lv_pmos ad=0.19p pd=1.38u as=0 ps=0 w=1u l=1u
X2714 VSS.t1346 VDD VSS.t1345 VSS.t377 sg13_lv_nmos ad=0.1428p pd=1.52u as=0 ps=0 w=0.42u l=1u
X2715 VDD VSS.t1583 VDD VDD sg13_lv_pmos ad=0.34p pd=2.68u as=0 ps=0 w=1u l=1u
X2716 VSS.t2842 VDD VSS.t2842 VSS.t412 sg13_lv_nmos ad=79.8f pd=0.8u as=0 ps=0 w=0.42u l=1u
X2717 VSS.t465 VDD VSS.t465 VSS.t469 sg13_lv_nmos ad=0.1428p pd=1.52u as=0 ps=0 w=0.42u l=1u
X2718 VSS.t302 VDD VSS.t302 VSS.t708 sg13_lv_nmos ad=79.8f pd=0.8u as=0 ps=0 w=0.42u l=1u
X2719 VDD VSS.t743 VDD VDD sg13_lv_pmos ad=0.34p pd=2.68u as=0 ps=0 w=1u l=1u
X2720 VSS.t1664 VDD VSS.t1663 VSS.t1662 sg13_lv_nmos ad=0.1428p pd=1.52u as=0 ps=0 w=0.42u l=1u
X2721 VSS.t2221 VDD VSS.t2223 VSS.t2222 sg13_lv_nmos ad=79.8f pd=0.8u as=0 ps=0 w=0.42u l=1u
X2722 VDD VSS.t449 VDD VDD sg13_lv_pmos ad=0.19p pd=1.38u as=0 ps=0 w=1u l=1u
X2723 sg13g2_and2_1_0.X a_1965_14832# VDD VDD sg13_lv_pmos ad=0.3808p pd=2.92u as=0.1918p ps=1.5u w=1.12u l=0.13u
X2724 VDD VSS.t183 VDD VDD sg13_lv_pmos ad=0.34p pd=2.68u as=0 ps=0 w=1u l=1u
X2725 VSS.t2817 VDD VSS.t2816 VSS.t412 sg13_lv_nmos ad=0.1428p pd=1.52u as=0 ps=0 w=0.42u l=1u
X2726 a_16079_15238# sg13g2_xnor2_1_1.A VSS.t24 VSS.t277 sg13_lv_nmos ad=0.2516p pd=2.16u as=0.1898p ps=1.36u w=0.74u l=0.13u
X2727 VDD VSS.t2784 VDD VDD sg13_lv_pmos ad=0.34p pd=2.68u as=0 ps=0 w=1u l=1u
X2728 VDD sg13g2_dfrbpq_1_3.RESET_B a_17318_14922# VDD sg13_lv_pmos ad=0.36237p pd=2.605u as=79.8f ps=0.8u w=0.42u l=0.13u
X2729 VSS.t695 VDD VSS.t695 VSS.t696 sg13_lv_nmos ad=0.1428p pd=1.52u as=0 ps=0 w=0.42u l=1u
X2730 VDD VSS.t1335 VDD VDD sg13_lv_pmos ad=0.34p pd=2.68u as=0 ps=0 w=1u l=1u
X2731 VDD VSS.t2842 VDD VDD sg13_lv_pmos ad=0.34p pd=2.68u as=0 ps=0 w=1u l=1u
X2732 VDD VSS.t2110 VDD VDD sg13_lv_pmos ad=0.34p pd=2.68u as=0 ps=0 w=1u l=1u
X2733 VDD VSS.t2480 VDD VDD sg13_lv_pmos ad=0.19p pd=1.38u as=0 ps=0 w=1u l=1u
X2734 sg13g2_dfrbpq_1_2.CLK a_12020_15202# VDD VDD sg13_lv_pmos ad=0.2128p pd=1.5u as=0.3976p ps=2.95u w=1.12u l=0.13u
X2735 VSS.t302 VDD VSS.t302 VSS.t675 sg13_lv_nmos ad=79.8f pd=0.8u as=0 ps=0 w=0.42u l=1u
X2736 VSS.t950 VDD VSS.t949 VSS.t948 sg13_lv_nmos ad=0.1428p pd=1.52u as=0 ps=0 w=0.42u l=1u
X2737 VDD VSS.t2138 VDD VDD sg13_lv_pmos ad=0.19p pd=1.38u as=0 ps=0 w=1u l=1u
X2738 VSS.t1382 VDD VSS.t1383 VSS.t377 sg13_lv_nmos ad=79.8f pd=0.8u as=0 ps=0 w=0.42u l=1u
X2739 VSS.t1304 VDD VSS.t1305 VSS.t377 sg13_lv_nmos ad=79.8f pd=0.8u as=0 ps=0 w=0.42u l=1u
X2740 VDD VSS.t608 VDD VDD sg13_lv_pmos ad=0.34p pd=2.68u as=0 ps=0 w=1u l=1u
X2741 VDD VSS.t977 VDD VDD sg13_lv_pmos ad=0.19p pd=1.38u as=0 ps=0 w=1u l=1u
X2742 VSS.t1020 VDD VSS.t1019 VSS.t1018 sg13_lv_nmos ad=0.1428p pd=1.52u as=0 ps=0 w=0.42u l=1u
X2743 VSS.t2966 VDD VSS.t2836 VSS.t412 sg13_lv_nmos ad=79.8f pd=0.8u as=0 ps=0 w=0.42u l=1u
X2744 VDD VSS.t1793 VDD VDD sg13_lv_pmos ad=0.34p pd=2.68u as=0 ps=0 w=1u l=1u
X2745 VSS.t3120 VDD VSS.t3119 VSS.t3118 sg13_lv_nmos ad=0.1428p pd=1.52u as=0 ps=0 w=0.42u l=1u
X2746 VDD VSS.t3024 VDD VDD sg13_lv_pmos ad=0.34p pd=2.68u as=0 ps=0 w=1u l=1u
X2747 VSS.t2593 VDD VSS.t2592 VSS.t2591 sg13_lv_nmos ad=0.1428p pd=1.52u as=0 ps=0 w=0.42u l=1u
X2748 a_6180_14922# sg13g2_and2_1_1.X a_6086_14922# VSS.t190 sg13_lv_nmos ad=60.89999f pd=0.71u as=0.1428p ps=1.52u w=0.42u l=0.13u
X2749 VDD VSS.t1142 VDD VDD sg13_lv_pmos ad=0.19p pd=1.38u as=0 ps=0 w=1u l=1u
X2750 VDD VSS.t1596 VDD VDD sg13_lv_pmos ad=0.19p pd=1.38u as=0 ps=0 w=1u l=1u
X2751 VSS.t2886 VDD VSS.t2887 VSS.t412 sg13_lv_nmos ad=79.8f pd=0.8u as=0 ps=0 w=0.42u l=1u
X2752 VDD VSS.t2505 VDD VDD sg13_lv_pmos ad=0.19p pd=1.38u as=0 ps=0 w=1u l=1u
X2753 VSS.t302 VDD VSS.t302 VSS.t709 sg13_lv_nmos ad=0.1428p pd=1.52u as=0 ps=0 w=0.42u l=1u
X2754 VSS.t895 VDD VSS.t894 VSS.t893 sg13_lv_nmos ad=0.1428p pd=1.52u as=0 ps=0 w=0.42u l=1u
X2755 VDD VSS.t1069 VDD VDD sg13_lv_pmos ad=0.34p pd=2.68u as=0 ps=0 w=1u l=1u
X2756 VSS.t1360 VDD VSS.t1359 VSS.t377 sg13_lv_nmos ad=0.1428p pd=1.52u as=0 ps=0 w=0.42u l=1u
X2757 VSS.t2111 VDD VSS.t2113 VSS.t2112 sg13_lv_nmos ad=79.8f pd=0.8u as=0 ps=0 w=0.42u l=1u
X2758 VDD a_6789_14495# a_6891_14495# VDD sg13_lv_pmos ad=2.42015p pd=15.68u as=0.3864p ps=2.93u w=1.12u l=0.13u
X2759 VSS.t2834 VDD VSS.t2835 VSS.t412 sg13_lv_nmos ad=79.8f pd=0.8u as=0 ps=0 w=0.42u l=1u
X2760 VSS.t1614 VDD VSS.t1613 VSS.t1612 sg13_lv_nmos ad=0.1428p pd=1.52u as=0 ps=0 w=0.42u l=1u
X2761 VSS.t117 VDD VSS.t117 VSS.t498 sg13_lv_nmos ad=0.1428p pd=1.52u as=0 ps=0 w=0.42u l=1u
X2762 VDD a_21166_16263# sg13g2_dfrbpq_1_6.D VDD sg13_lv_pmos ad=0.2254p pd=1.53u as=0.4256p ps=3u w=1.12u l=0.13u
X2763 a_15022_14484# clock_i VSS.t16 VSS.t366 sg13_lv_nmos ad=0.1406p pd=1.12u as=0.1406p ps=1.12u w=0.74u l=0.13u
X2764 VDD VSS.t610 VDD VDD sg13_lv_pmos ad=0.19p pd=1.38u as=0 ps=0 w=1u l=1u
X2765 VSS.t1784 VDD VSS.t1786 VSS.t1785 sg13_lv_nmos ad=79.8f pd=0.8u as=0 ps=0 w=0.42u l=1u
X2766 VSS.t2176 VDD VSS.t2175 VSS.t2174 sg13_lv_nmos ad=0.1428p pd=1.52u as=0 ps=0 w=0.42u l=1u
X2767 VDD VSS.t2130 VDD VDD sg13_lv_pmos ad=0.34p pd=2.68u as=0 ps=0 w=1u l=1u
X2768 VSS.t302 VDD VSS.t302 VSS.t677 sg13_lv_nmos ad=79.8f pd=0.8u as=0 ps=0 w=0.42u l=1u
X2769 VSS.t715 VDD VSS.t715 VSS.t835 sg13_lv_nmos ad=79.8f pd=0.8u as=0 ps=0 w=0.42u l=1u
X2770 VDD VSS.t2835 VDD VDD sg13_lv_pmos ad=0.34p pd=2.68u as=0 ps=0 w=1u l=1u
X2771 sg13g2_dlygate4sd3_1_5.A sg13g2_dlygate4sd3_1_6.X a_18454_15230# VSS.t9 sg13_lv_nmos ad=0.2516p pd=2.16u as=0.1406p ps=1.12u w=0.74u l=0.15u
X2772 VDD VSS.t1132 VDD VDD sg13_lv_pmos ad=0.19p pd=1.38u as=0 ps=0 w=1u l=1u
X2773 VSS.t1364 VDD VSS.t1362 VSS.t377 sg13_lv_nmos ad=0.1428p pd=1.52u as=0 ps=0 w=0.42u l=1u
X2774 VSS.t1448 VDD VSS.t1285 VSS.t377 sg13_lv_nmos ad=0.1428p pd=1.52u as=0 ps=0 w=0.42u l=1u
X2775 VSS.t1531 VDD VSS.t1396 VSS.t377 sg13_lv_nmos ad=79.8f pd=0.8u as=0 ps=0 w=0.42u l=1u
X2776 VSS.t606 VDD VSS.t605 VSS.t33 sg13_lv_nmos ad=0.1428p pd=1.52u as=0 ps=0 w=0.42u l=1u
X2777 VSS.t2358 VDD VSS.t2360 VSS.t2359 sg13_lv_nmos ad=79.8f pd=0.8u as=0 ps=0 w=0.42u l=1u
X2778 VDD VSS.t1813 VDD VDD sg13_lv_pmos ad=0.34p pd=2.68u as=0 ps=0 w=1u l=1u
X2779 a_27898_15202# sg13g2_dfrbpq_1_5.Q VDD VDD sg13_lv_pmos ad=0.1428p pd=1.52u as=0.1523p ps=1.38u w=0.42u l=0.13u
X2780 VDD VSS.t1303 VDD VDD sg13_lv_pmos ad=0.34p pd=2.68u as=0 ps=0 w=1u l=1u
X2781 VDD VSS.t2090 VDD VDD sg13_lv_pmos ad=0.34p pd=2.68u as=0 ps=0 w=1u l=1u
X2782 VSS.t2433 VDD VSS.t2435 VSS.t2434 sg13_lv_nmos ad=79.8f pd=0.8u as=0 ps=0 w=0.42u l=1u
X2783 VSS.t935 VDD VSS.t934 VSS.t933 sg13_lv_nmos ad=0.1428p pd=1.52u as=0 ps=0 w=0.42u l=1u
X2784 VDD VSS.t3217 VDD VDD sg13_lv_pmos ad=0.19p pd=1.38u as=0 ps=0 w=1u l=1u
X2785 VDD VSS.t848 VDD VDD sg13_lv_pmos ad=0.19p pd=1.38u as=0 ps=0 w=1u l=1u
X2786 VSS.t1050 VDD VSS.t1049 VSS.t1048 sg13_lv_nmos ad=0.1428p pd=1.52u as=0 ps=0 w=0.42u l=1u
X2787 VSS.t1165 VDD VSS.t1167 VSS.t1166 sg13_lv_nmos ad=79.8f pd=0.8u as=0 ps=0 w=0.42u l=1u
X2788 VSS.t535 VDD VSS.t537 VSS.t536 sg13_lv_nmos ad=79.8f pd=0.8u as=0 ps=0 w=0.42u l=1u
X2789 VSS.t302 VDD VSS.t302 VSS.t683 sg13_lv_nmos ad=79.8f pd=0.8u as=0 ps=0 w=0.42u l=1u
X2790 VSS.t2862 VDD VSS.t2861 VSS.t412 sg13_lv_nmos ad=0.1428p pd=1.52u as=0 ps=0 w=0.42u l=1u
X2791 VDD VSS.t2799 VDD VDD sg13_lv_pmos ad=0.34p pd=2.68u as=0 ps=0 w=1u l=1u
X2792 a_21348_14909# a_21579_14495# a_21034_14452# VSS.t303 sg13_lv_nmos ad=0.2373p pd=1.97u as=79.8f ps=0.8u w=0.42u l=0.13u
X2793 VDD VSS.t1147 VDD VDD sg13_lv_pmos ad=0.19p pd=1.38u as=0 ps=0 w=1u l=1u
X2794 VSS.t444 VDD VSS.t446 VSS.t445 sg13_lv_nmos ad=79.8f pd=0.8u as=0 ps=0 w=0.42u l=1u
X2795 VDD a_27898_15202# a_27617_15424# VDD sg13_lv_pmos ad=0.1523p pd=1.38u as=0.34p ps=2.68u w=1u l=0.5u
X2796 VDD VSS.t590 VDD VDD sg13_lv_pmos ad=0.34p pd=2.68u as=0 ps=0 w=1u l=1u
X2797 VDD VSS.t1367 VDD VDD sg13_lv_pmos ad=0.19p pd=1.38u as=0 ps=0 w=1u l=1u
X2798 VDD VSS.t2871 VDD VDD sg13_lv_pmos ad=0.19p pd=1.38u as=0 ps=0 w=1u l=1u
X2799 VSS.t2206 VDD VSS.t2208 VSS.t2207 sg13_lv_nmos ad=79.8f pd=0.8u as=0 ps=0 w=0.42u l=1u
X2800 VSS.t1649 VDD VSS.t1648 VSS.t1647 sg13_lv_nmos ad=0.1428p pd=1.52u as=0 ps=0 w=0.42u l=1u
X2801 VDD VSS.t1608 VDD VDD sg13_lv_pmos ad=0.34p pd=2.68u as=0 ps=0 w=1u l=1u
X2802 VSS.t2809 VDD VSS.t2809 VSS.t412 sg13_lv_nmos ad=0.1428p pd=1.52u as=0 ps=0 w=0.42u l=1u
X2803 VDD VSS.t2517 VDD VDD sg13_lv_pmos ad=0.34p pd=2.68u as=0 ps=0 w=1u l=1u
X2804 VSS.t2578 VDD VSS.t2577 VSS.t2576 sg13_lv_nmos ad=0.1428p pd=1.52u as=0 ps=0 w=0.42u l=1u
X2805 VDD VSS.t2774 VDD VDD sg13_lv_pmos ad=0.34p pd=2.68u as=0 ps=0 w=1u l=1u
X2806 VDD VSS.t907 VDD VDD sg13_lv_pmos ad=0.19p pd=1.38u as=0 ps=0 w=1u l=1u
X2807 VSS.t950 VDD VSS.t949 VSS.t948 sg13_lv_nmos ad=0.1428p pd=1.52u as=0 ps=0 w=0.42u l=1u
X2808 VSS.t1518 VDD VSS.t1377 VSS.t377 sg13_lv_nmos ad=0.1428p pd=1.52u as=0 ps=0 w=0.42u l=1u
X2809 a_22125_14020# sg13g2_or3_1_2.B a_22036_14020# VDD sg13_lv_pmos ad=0.19p pd=1.38u as=0.1575p ps=1.315u w=1u l=0.13u
X2810 VDD VSS.t725 VDD VDD sg13_lv_pmos ad=0.19p pd=1.38u as=0 ps=0 w=1u l=1u
X2811 VSS.t2126 VDD VSS.t2125 VSS.t2124 sg13_lv_nmos ad=0.1428p pd=1.52u as=0 ps=0 w=0.42u l=1u
X2812 VSS.t76 VDD VSS.t76 VSS.t854 sg13_lv_nmos ad=0.1428p pd=1.52u as=0 ps=0 w=0.42u l=1u
X2813 VSS.t1408 VDD VSS.t1409 VSS.t377 sg13_lv_nmos ad=79.8f pd=0.8u as=0 ps=0 w=0.42u l=1u
X2814 VDD VSS.t2465 VDD VDD sg13_lv_pmos ad=0.19p pd=1.38u as=0 ps=0 w=1u l=1u
X2815 VDD VSS.t2123 VDD VDD sg13_lv_pmos ad=0.19p pd=1.38u as=0 ps=0 w=1u l=1u
X2816 a_26148_14040# a_26122_13945# VDD VDD sg13_lv_pmos ad=0.34p pd=2.68u as=0.36237p ps=2.605u w=1u l=0.13u
X2817 VDD VSS.t1315 VDD VDD sg13_lv_pmos ad=0.34p pd=2.68u as=0 ps=0 w=1u l=1u
X2818 VSS.t3105 VDD VSS.t3104 VSS.t3103 sg13_lv_nmos ad=0.1428p pd=1.52u as=0 ps=0 w=0.42u l=1u
X2819 VSS.t50 VDD VSS.t63 VSS.t639 sg13_lv_nmos ad=79.8f pd=0.8u as=0 ps=0 w=0.42u l=1u
X2820 VSS.t1135 VDD VSS.t1134 VSS.t1133 sg13_lv_nmos ad=0.1428p pd=1.52u as=0 ps=0 w=0.42u l=1u
X2821 VDD VSS.t599 VDD VDD sg13_lv_pmos ad=0.34p pd=2.68u as=0 ps=0 w=1u l=1u
X2822 VDD VSS.t1313 VDD VDD sg13_lv_pmos ad=0.34p pd=2.68u as=0 ps=0 w=1u l=1u
X2823 VSS.t1413 VDD VSS.t1414 VSS.t377 sg13_lv_nmos ad=79.8f pd=0.8u as=0 ps=0 w=0.42u l=1u
X2824 VDD VSS.t999 VDD VDD sg13_lv_pmos ad=0.34p pd=2.68u as=0 ps=0 w=1u l=1u
X2825 VDD VSS.t1581 VDD VDD sg13_lv_pmos ad=0.19p pd=1.38u as=0 ps=0 w=1u l=1u
X2826 VSS.t2878 VDD VSS.t2879 VSS.t412 sg13_lv_nmos ad=79.8f pd=0.8u as=0 ps=0 w=0.42u l=1u
X2827 VSS.t758 VDD VSS.t760 VSS.t879 sg13_lv_nmos ad=79.8f pd=0.8u as=0 ps=0 w=0.42u l=1u
X2828 VSS.t2854 VDD VSS.t2853 VSS.t412 sg13_lv_nmos ad=0.1428p pd=1.52u as=0 ps=0 w=0.42u l=1u
X2829 VSS.t2378 VDD VSS.t2380 VSS.t2379 sg13_lv_nmos ad=79.8f pd=0.8u as=0 ps=0 w=0.42u l=1u
X2830 VDD VSS.t1588 VDD VDD sg13_lv_pmos ad=0.34p pd=2.68u as=0 ps=0 w=1u l=1u
X2831 VDD VSS.t1761 VDD VDD sg13_lv_pmos ad=0.19p pd=1.38u as=0 ps=0 w=1u l=1u
X2832 VSS.t1669 VDD VSS.t1668 VSS.t1667 sg13_lv_nmos ad=0.1428p pd=1.52u as=0 ps=0 w=0.42u l=1u
X2833 sg13g2_or3_1_1.B a_14357_15238# VSS.t246 VSS.t248 sg13_lv_nmos ad=0.1406p pd=1.12u as=0.1406p ps=1.12u w=0.74u l=0.13u
X2834 sg13g2_or3_1_1.C sg13g2_o21ai_1_2.B1 a_24062_15242# VSS.t28 sg13_lv_nmos ad=0.2516p pd=2.16u as=0.1406p ps=1.12u w=0.74u l=0.13u
X2835 VSS.t1599 VDD VSS.t1598 VSS.t1597 sg13_lv_nmos ad=0.1428p pd=1.52u as=0 ps=0 w=0.42u l=1u
X2836 VDD VSS.t1062 VDD VDD sg13_lv_pmos ad=0.19p pd=1.38u as=0 ps=0 w=1u l=1u
X2837 VDD VSS.t2766 VDD VDD sg13_lv_pmos ad=0.34p pd=2.68u as=0 ps=0 w=1u l=1u
X2838 VDD VSS.t1338 VDD VDD sg13_lv_pmos ad=0.34p pd=2.68u as=0 ps=0 w=1u l=1u
X2839 VDD VSS.t2115 VDD VDD sg13_lv_pmos ad=0.34p pd=2.68u as=0 ps=0 w=1u l=1u
X2840 VSS.t19 sg13g2_and2_1_2.B a_8779_14832# VSS.t166 sg13_lv_nmos ad=0.1331p pd=1.12u as=0.1216p ps=1.02u w=0.64u l=0.13u
X2841 a_27407_13799# a_26565_13701# a_27313_13799# VSS.t381 sg13_lv_nmos ad=0.12665p pd=1.145u as=0.1428p ps=1.52u w=0.42u l=0.13u
X2842 VDD VSS.t2485 VDD VDD sg13_lv_pmos ad=0.19p pd=1.38u as=0 ps=0 w=1u l=1u
X2843 a_6660_14909# a_6372_14488# a_6598_14909# VSS.t221 sg13_lv_nmos ad=0.1428p pd=1.52u as=37.8f ps=0.6u w=0.42u l=0.13u
X2844 VDD VSS.t2143 VDD VDD sg13_lv_pmos ad=0.19p pd=1.38u as=0 ps=0 w=1u l=1u
X2845 a_25203_13320# sg13g2_a21oi_1_3.A2 VSS.t14 VSS.t346 sg13_lv_nmos ad=0.1406p pd=1.12u as=0.2516p ps=2.16u w=0.74u l=0.13u
X2846 VSS.t1789 VDD VSS.t1788 VSS.t1787 sg13_lv_nmos ad=0.1428p pd=1.52u as=0 ps=0 w=0.42u l=1u
X2847 VDD VSS.t989 VDD VDD sg13_lv_pmos ad=0.34p pd=2.68u as=0 ps=0 w=1u l=1u
X2848 VSS.t1165 VDD VSS.t1167 VSS.t1166 sg13_lv_nmos ad=79.8f pd=0.8u as=0 ps=0 w=0.42u l=1u
X2849 VDD VSS.t1404 VDD VDD sg13_lv_pmos ad=0.34p pd=2.68u as=0 ps=0 w=1u l=1u
X2850 VSS.t2598 VDD VSS.t2597 VSS.t2596 sg13_lv_nmos ad=0.1428p pd=1.52u as=0 ps=0 w=0.42u l=1u
X2851 a_17892_14909# a_18123_14495# a_17578_14452# VSS.t197 sg13_lv_nmos ad=0.2373p pd=1.97u as=79.8f ps=0.8u w=0.42u l=0.13u
X2852 a_17961_14531# a_17604_14488# VDD VDD sg13_lv_pmos ad=63f pd=0.72u as=0.1563p ps=1.22u w=0.42u l=0.13u
X2853 VDD VSS.t302 VDD VDD sg13_lv_pmos ad=0.34p pd=2.68u as=0 ps=0 w=1u l=1u
X2854 VDD VSS.t743 VDD VDD sg13_lv_pmos ad=0.19p pd=1.38u as=0 ps=0 w=1u l=1u
X2855 VDD a_32492_15960# counter_value_o[6] VDD sg13_lv_pmos ad=0.2114p pd=1.54u as=0.42p ps=2.99u w=1.12u l=0.13u
X2856 VSS.t737 VDD VSS.t737 VSS.t866 sg13_lv_nmos ad=0.1428p pd=1.52u as=0 ps=0 w=0.42u l=1u
X2857 VDD VSS.t1368 VDD VDD sg13_lv_pmos ad=0.19p pd=1.38u as=0 ps=0 w=1u l=1u
X2858 VDD VSS.t2170 VDD VDD sg13_lv_pmos ad=0.34p pd=2.68u as=0 ps=0 w=1u l=1u
X2859 VDD a_15022_14484# sg13g2_buf_16_2.A VDD sg13_lv_pmos ad=0.2128p pd=1.5u as=0.2128p ps=1.5u w=1.12u l=0.13u
X2860 VSS.t715 VDD VSS.t715 VSS.t718 sg13_lv_nmos ad=79.8f pd=0.8u as=0 ps=0 w=0.42u l=1u
X2861 VSS.t1025 VDD VSS.t1024 VSS.t1023 sg13_lv_nmos ad=0.1428p pd=1.52u as=0 ps=0 w=0.42u l=1u
X2862 VDD VSS.t3297 VDD VDD sg13_lv_pmos ad=0.19p pd=1.38u as=0 ps=0 w=1u l=1u
X2863 VSS.t2363 VDD VSS.t2365 VSS.t2364 sg13_lv_nmos ad=79.8f pd=0.8u as=0 ps=0 w=0.42u l=1u
X2864 VSS.t1347 VDD VSS.t1349 VSS.t377 sg13_lv_nmos ad=79.8f pd=0.8u as=0 ps=0 w=0.42u l=1u
X2865 VDD VSS.t2790 VDD VDD sg13_lv_pmos ad=0.34p pd=2.68u as=0 ps=0 w=1u l=1u
X2866 VSS.t2836 VDD VSS.t2837 VSS.t412 sg13_lv_nmos ad=79.8f pd=0.8u as=0 ps=0 w=0.42u l=1u
X2867 VDD VSS.t1029 VDD VDD sg13_lv_pmos ad=0.34p pd=2.68u as=0 ps=0 w=1u l=1u
X2868 VSS.t1584 VDD VSS.t1583 VSS.t1582 sg13_lv_nmos ad=0.1428p pd=1.52u as=0 ps=0 w=0.42u l=1u
X2869 VSS.t246 sg13g2_nand4_1_0.Y a_14357_15238# VSS.t282 sg13_lv_nmos ad=0.3293p pd=1.63u as=0.2516p ps=2.16u w=0.74u l=0.13u
X2870 VSS.t6 a_21466_15202# a_21185_15424# VSS.t425 sg13_lv_nmos ad=79.8f pd=0.8u as=0.1428p ps=1.52u w=0.42u l=0.5u
X2871 VDD VSS.t1593 VDD VDD sg13_lv_pmos ad=0.34p pd=2.68u as=0 ps=0 w=1u l=1u
X2872 VDD VSS.t2502 VDD VDD sg13_lv_pmos ad=0.34p pd=2.68u as=0 ps=0 w=1u l=1u
X2873 VSS.t202 sg13g2_xnor2_1_1.A a_18454_15230# VSS.t274 sg13_lv_nmos ad=0.1406p pd=1.12u as=0.2516p ps=2.16u w=0.74u l=0.15u
X2874 VSS.t900 VDD VSS.t899 VSS.t898 sg13_lv_nmos ad=0.1428p pd=1.52u as=0 ps=0 w=0.42u l=1u
X2875 VDD VSS.t1329 VDD VDD sg13_lv_pmos ad=0.34p pd=2.68u as=0 ps=0 w=1u l=1u
X2876 VDD VSS.t2837 VDD VDD sg13_lv_pmos ad=0.34p pd=2.68u as=0 ps=0 w=1u l=1u
X2877 VSS.t2393 VDD VSS.t2392 VSS.t2391 sg13_lv_nmos ad=0.1428p pd=1.52u as=0 ps=0 w=0.42u l=1u
X2878 a_32492_15960# sg13g2_dfrbpq_1_7.Q VDD VDD sg13_lv_pmos ad=0.2856p pd=2.36u as=0.2114p ps=1.54u w=0.84u l=0.13u
X2879 VDD VSS.t952 VDD VDD sg13_lv_pmos ad=0.19p pd=1.38u as=0 ps=0 w=1u l=1u
X2880 VSS.t2778 VDD VSS.t2779 VSS.t412 sg13_lv_nmos ad=79.8f pd=0.8u as=0 ps=0 w=0.42u l=1u
X2881 VDD VSS.t2627 VDD VDD sg13_lv_pmos ad=0.34p pd=2.68u as=0 ps=0 w=1u l=1u
X2882 VSS.t302 VDD VSS.t302 VSS.t708 sg13_lv_nmos ad=79.8f pd=0.8u as=0 ps=0 w=0.42u l=1u
X2883 VSS.t1135 VDD VSS.t1134 VSS.t1133 sg13_lv_nmos ad=0.1428p pd=1.52u as=0 ps=0 w=0.42u l=1u
X2884 VSS.t1325 VDD VSS.t1324 VSS.t377 sg13_lv_nmos ad=0.1428p pd=1.52u as=0 ps=0 w=0.42u l=1u
X2885 VSS.t1503 VDD VSS.t1358 VSS.t377 sg13_lv_nmos ad=79.8f pd=0.8u as=0 ps=0 w=0.42u l=1u
X2886 VDD VSS.t1306 VDD VDD sg13_lv_pmos ad=0.34p pd=2.68u as=0 ps=0 w=1u l=1u
X2887 VDD VSS.t2155 VDD VDD sg13_lv_pmos ad=0.34p pd=2.68u as=0 ps=0 w=1u l=1u
X2888 VSS.t1330 VDD VSS.t1329 VSS.t377 sg13_lv_nmos ad=0.1428p pd=1.52u as=0 ps=0 w=0.42u l=1u
X2889 VDD sg13g2_buf_16_2.A a_12020_15202# VDD sg13_lv_pmos ad=0.2128p pd=1.5u as=0.2128p ps=1.5u w=1.12u l=0.13u
X2890 VSS.t915 VDD VSS.t914 VSS.t913 sg13_lv_nmos ad=0.1428p pd=1.52u as=0 ps=0 w=0.42u l=1u
X2891 VSS.t1100 VDD VSS.t1102 VSS.t1101 sg13_lv_nmos ad=79.8f pd=0.8u as=0 ps=0 w=0.42u l=1u
X2892 VSS.t2846 VDD VSS.t2845 VSS.t412 sg13_lv_nmos ad=0.1428p pd=1.52u as=0 ps=0 w=0.42u l=1u
X2893 VDD VSS.t2801 VDD VDD sg13_lv_pmos ad=0.34p pd=2.68u as=0 ps=0 w=1u l=1u
X2894 a_2540_15960# sg13g2_dlygate4sd3_1_3.A VDD VDD sg13_lv_pmos ad=0.2856p pd=2.36u as=0.2114p ps=1.54u w=0.84u l=0.13u
X2895 VDD clock_i a_15022_14484# VDD sg13_lv_pmos ad=0.2128p pd=1.5u as=0.2128p ps=1.5u w=1.12u l=0.13u
X2896 VSS.t1283 VDD VSS.t1284 VSS.t377 sg13_lv_nmos ad=79.8f pd=0.8u as=0 ps=0 w=0.42u l=1u
X2897 VDD VSS.t2103 VDD VDD sg13_lv_pmos ad=0.19p pd=1.38u as=0 ps=0 w=1u l=1u
X2898 VDD VSS.t100 VDD VDD sg13_lv_pmos ad=0.34p pd=2.68u as=0 ps=0 w=1u l=1u
X2899 VDD VSS.t1573 VDD VDD sg13_lv_pmos ad=0.34p pd=2.68u as=0 ps=0 w=1u l=1u
X2900 VSS.t2211 VDD VSS.t2213 VSS.t2212 sg13_lv_nmos ad=79.8f pd=0.8u as=0 ps=0 w=0.42u l=1u
X2901 VDD VSS.t822 VDD VDD sg13_lv_pmos ad=0.34p pd=2.68u as=0 ps=0 w=1u l=1u
X2902 VDD VSS.t1107 VDD VDD sg13_lv_pmos ad=0.19p pd=1.38u as=0 ps=0 w=1u l=1u
X2903 VSS.t1654 VDD VSS.t1653 VSS.t1652 sg13_lv_nmos ad=0.1428p pd=1.52u as=0 ps=0 w=0.42u l=1u
X2904 VDD VSS.t1613 VDD VDD sg13_lv_pmos ad=0.34p pd=2.68u as=0 ps=0 w=1u l=1u
X2905 VSS.t3300 VDD VSS.t3302 VSS.t3301 sg13_lv_nmos ad=79.8f pd=0.8u as=0 ps=0 w=0.42u l=1u
X2906 VSS.t2812 VDD VSS.t2811 VSS.t412 sg13_lv_nmos ad=0.1428p pd=1.52u as=0 ps=0 w=0.42u l=1u
X2907 VDD VSS.t2522 VDD VDD sg13_lv_pmos ad=0.34p pd=2.68u as=0 ps=0 w=1u l=1u
X2908 VDD VSS.t1786 VDD VDD sg13_lv_pmos ad=0.19p pd=1.38u as=0 ps=0 w=1u l=1u
X2909 VDD VSS.t919 VDD VDD sg13_lv_pmos ad=0.34p pd=2.68u as=0 ps=0 w=1u l=1u
X2910 VSS.t465 VDD VSS.t460 VSS.t464 sg13_lv_nmos ad=0.1428p pd=1.52u as=0 ps=0 w=0.42u l=1u
X2911 a_12020_15202# sg13g2_buf_16_2.A VSS.t63 VSS.t167 sg13_lv_nmos ad=0.1406p pd=1.12u as=0.1406p ps=1.12u w=0.74u l=0.13u
X2912 VSS.t582 VDD VSS.t581 VSS.t33 sg13_lv_nmos ad=0.1428p pd=1.52u as=0 ps=0 w=0.42u l=1u
X2913 sg13g2_and2_1_0.B a_2490_14447# VSS.t189 VSS.t188 sg13_lv_nmos ad=0.1628p pd=1.18u as=0.3108p ps=2.32u w=0.74u l=0.13u
X2914 sg13g2_dfrbpq_1_2.Q a_17994_14020# VSS.t369 VSS.t368 sg13_lv_nmos ad=0.2516p pd=2.16u as=0.1406p ps=1.12u w=0.74u l=0.13u
X2915 VSS.t2131 VDD VSS.t2130 VSS.t2129 sg13_lv_nmos ad=0.1428p pd=1.52u as=0 ps=0 w=0.42u l=1u
X2916 VSS.t302 VDD VSS.t302 VSS.t710 sg13_lv_nmos ad=79.8f pd=0.8u as=0 ps=0 w=0.42u l=1u
X2917 VDD VSS.t2470 VDD VDD sg13_lv_pmos ad=0.19p pd=1.38u as=0 ps=0 w=1u l=1u
X2918 VDD VSS.t2128 VDD VDD sg13_lv_pmos ad=0.19p pd=1.38u as=0 ps=0 w=1u l=1u
X2919 VDD VSS.t1034 VDD VDD sg13_lv_pmos ad=0.34p pd=2.68u as=0 ps=0 w=1u l=1u
X2920 VSS.t1302 VDD VSS.t1303 VSS.t377 sg13_lv_nmos ad=79.8f pd=0.8u as=0 ps=0 w=0.42u l=1u
X2921 VSS.t1339 VDD VSS.t1338 VSS.t377 sg13_lv_nmos ad=0.1428p pd=1.52u as=0 ps=0 w=0.42u l=1u
X2922 VDD VSS.t302 VDD VDD sg13_lv_pmos ad=0.34p pd=2.68u as=0 ps=0 w=1u l=1u
X2923 VDD VSS.t1430 VDD VDD sg13_lv_pmos ad=0.34p pd=2.68u as=0 ps=0 w=1u l=1u
X2924 a_9444_15552# a_9963_15356# a_10703_15311# VSS.t70 sg13_lv_nmos ad=0.3473p pd=2.71u as=0.12665p ps=1.145u w=0.74u l=0.13u
X2925 a_7888_14726# sg13g2_dfrbpq_1_1.RESET_B VDD VDD sg13_lv_pmos ad=79.8f pd=0.8u as=2.42015p ps=15.68u w=0.42u l=0.13u
X2926 VSS.t769 VDD VSS.t766 VSS.t768 sg13_lv_nmos ad=0.1428p pd=1.52u as=0 ps=0 w=0.42u l=1u
X2927 VSS.t302 VDD VSS.t302 VSS.t677 sg13_lv_nmos ad=79.8f pd=0.8u as=0 ps=0 w=0.42u l=1u
X2928 VDD a_27215_14845# a_27472_14726# VDD sg13_lv_pmos ad=2.42015p pd=15.68u as=79.8f ps=0.8u w=0.42u l=0.13u
X2929 VDD VSS.t611 VDD VDD sg13_lv_pmos ad=0.34p pd=2.68u as=0 ps=0 w=1u l=1u
X2930 VSS.t1025 VDD VSS.t1024 VSS.t1023 sg13_lv_nmos ad=0.1428p pd=1.52u as=0 ps=0 w=0.42u l=1u
X2931 VSS.t1307 VDD VSS.t1308 VSS.t377 sg13_lv_nmos ad=79.8f pd=0.8u as=0 ps=0 w=0.42u l=1u
X2932 VDD VSS.t2761 VDD VDD sg13_lv_pmos ad=0.19p pd=1.38u as=0 ps=0 w=1u l=1u
X2933 VDD a_7631_14845# a_8298_14484# VDD sg13_lv_pmos ad=0.2128p pd=1.5u as=0.3864p ps=2.93u w=1.12u l=0.13u
X2934 VSS.t1070 VDD VSS.t1069 VSS.t1068 sg13_lv_nmos ad=0.1428p pd=1.52u as=0 ps=0 w=0.42u l=1u
X2935 VSS.t1644 VDD VSS.t1643 VSS.t1642 sg13_lv_nmos ad=0.1428p pd=1.52u as=0 ps=0 w=0.42u l=1u
X2936 VSS.t3170 VDD VSS.t3169 VSS.t3168 sg13_lv_nmos ad=0.1428p pd=1.52u as=0 ps=0 w=0.42u l=1u
X2937 VSS.t2378 VDD VSS.t2377 VSS.t2376 sg13_lv_nmos ad=0.1428p pd=1.52u as=0 ps=0 w=0.42u l=1u
X2938 a_16955_12972# sg13g2_a21oi_1_0.B1 sg13g2_a21oi_1_0.Y VDD sg13_lv_pmos ad=0.2128p pd=1.5u as=0.3808p ps=2.92u w=1.12u l=0.13u
X2939 VDD VSS.t934 VDD VDD sg13_lv_pmos ad=0.34p pd=2.68u as=0 ps=0 w=1u l=1u
X2940 VSS.t1375 VDD VSS.t1376 VSS.t377 sg13_lv_nmos ad=79.8f pd=0.8u as=0 ps=0 w=0.42u l=1u
X2941 VDD VSS.t3282 VDD VDD sg13_lv_pmos ad=0.19p pd=1.38u as=0 ps=0 w=1u l=1u
X2942 VSS.t2828 VDD VSS.t2829 VSS.t412 sg13_lv_nmos ad=79.8f pd=0.8u as=0 ps=0 w=0.42u l=1u
X2943 VDD VSS.t1766 VDD VDD sg13_lv_pmos ad=0.19p pd=1.38u as=0 ps=0 w=1u l=1u
X2944 VDD VSS.t3234 VDD VDD sg13_lv_pmos ad=0.34p pd=2.68u as=0 ps=0 w=1u l=1u
X2945 VSS.t900 VDD VSS.t899 VSS.t898 sg13_lv_nmos ad=0.1428p pd=1.52u as=0 ps=0 w=0.42u l=1u
X2946 VSS.t505 VDD VSS.t507 VSS.t506 sg13_lv_nmos ad=79.8f pd=0.8u as=0 ps=0 w=0.42u l=1u
X2947 a_19054_15423# a_19169_15424# VSS.t88 VSS.t9 sg13_lv_nmos ad=0.1428p pd=1.52u as=0.1426p ps=1.16u w=0.42u l=0.5u
X2948 VSS.t302 VDD VSS.t302 VSS.t683 sg13_lv_nmos ad=79.8f pd=0.8u as=0 ps=0 w=0.42u l=1u
X2949 VSS.t1130 VDD VSS.t1132 VSS.t1131 sg13_lv_nmos ad=79.8f pd=0.8u as=0 ps=0 w=0.42u l=1u
X2950 VDD VSS.t2864 VDD VDD sg13_lv_pmos ad=0.19p pd=1.38u as=0 ps=0 w=1u l=1u
X2951 VSS.t2166 VDD VSS.t2165 VSS.t2164 sg13_lv_nmos ad=0.1428p pd=1.52u as=0 ps=0 w=0.42u l=1u
X2952 VDD VSS.t1320 VDD VDD sg13_lv_pmos ad=0.19p pd=1.38u as=0 ps=0 w=1u l=1u
X2953 VDD VSS.t1320 VDD VDD sg13_lv_pmos ad=0.34p pd=2.68u as=0 ps=0 w=1u l=1u
X2954 VDD VSS.t2829 VDD VDD sg13_lv_pmos ad=0.34p pd=2.68u as=0 ps=0 w=1u l=1u
X2955 sg13g2_dfrbpq_1_2.CLK a_12020_15202# VSS.t50 VSS.t59 sg13_lv_nmos ad=0.1406p pd=1.12u as=0.1406p ps=1.12u w=0.74u l=0.13u
X2956 VDD VSS.t997 VDD VDD sg13_lv_pmos ad=0.19p pd=1.38u as=0 ps=0 w=1u l=1u
X2957 VSS.t1394 VDD VSS.t1395 VSS.t377 sg13_lv_nmos ad=79.8f pd=0.8u as=0 ps=0 w=0.42u l=1u
X2958 VSS.t1316 VDD VSS.t1317 VSS.t377 sg13_lv_nmos ad=79.8f pd=0.8u as=0 ps=0 w=0.42u l=1u
X2959 VDD VSS.t2455 VDD VDD sg13_lv_pmos ad=0.19p pd=1.38u as=0 ps=0 w=1u l=1u
X2960 VSS.t2768 VDD VSS.t2770 VSS.t412 sg13_lv_nmos ad=79.8f pd=0.8u as=0 ps=0 w=0.42u l=1u
X2961 VDD VSS.t715 VDD VDD sg13_lv_pmos ad=0.34p pd=2.68u as=0 ps=0 w=1u l=1u
X2962 VSS.t551 VDD VSS.t551 VSS.t554 sg13_lv_nmos ad=79.8f pd=0.8u as=0 ps=0 w=0.42u l=1u
X2963 sg13g2_dfrbpq_1_1.RESET_B a_5886_15486# VDD VDD sg13_lv_pmos ad=0.3927p pd=2.99u as=2.8961p ps=18.25u w=1.155u l=0.13u
X2964 VSS.t600 VDD VSS.t599 VSS.t33 sg13_lv_nmos ad=0.1428p pd=1.52u as=0 ps=0 w=0.42u l=1u
X2965 VSS.t106 sg13g2_dlygate4sd3_1_0.X a_5707_14832# VSS.t344 sg13_lv_nmos ad=0.1331p pd=1.12u as=0.1216p ps=1.02u w=0.64u l=0.13u
X2966 VSS.t2873 VDD VSS.t2874 VSS.t412 sg13_lv_nmos ad=79.8f pd=0.8u as=0 ps=0 w=0.42u l=1u
X2967 VDD a_19438_13726# sg13g2_buf_16_2.X VDD sg13_lv_pmos ad=0.3976p pd=2.95u as=0.2128p ps=1.5u w=1.12u l=0.13u
X2968 VSS.t915 VDD VSS.t914 VSS.t913 sg13_lv_nmos ad=0.1428p pd=1.52u as=0 ps=0 w=0.42u l=1u
X2969 VSS.t1100 VDD VSS.t1102 VSS.t1101 sg13_lv_nmos ad=79.8f pd=0.8u as=0 ps=0 w=0.42u l=1u
X2970 VDD VSS.t1089 VDD VDD sg13_lv_pmos ad=0.34p pd=2.68u as=0 ps=0 w=1u l=1u
X2971 VDD VSS.t2140 VDD VDD sg13_lv_pmos ad=0.34p pd=2.68u as=0 ps=0 w=1u l=1u
X2972 VDD a_25390_16263# sg13g2_dlygate4sd3_1_12.X VDD sg13_lv_pmos ad=0.2254p pd=1.53u as=0.4256p ps=3u w=1.12u l=0.13u
X2973 VSS.t700 VDD VSS.t700 VSS.t703 sg13_lv_nmos ad=0.1428p pd=1.52u as=0 ps=0 w=0.42u l=1u
X2974 VDD VSS.t443 VDD VDD sg13_lv_pmos ad=0.34p pd=2.68u as=0 ps=0 w=1u l=1u
X2975 VSS.t143 a_25094_15238# a_25206_15302# VSS.t28 sg13_lv_nmos ad=0.1426p pd=1.16u as=0.1428p ps=1.52u w=0.42u l=0.5u
X2976 VDD VSS.t3267 VDD VDD sg13_lv_pmos ad=0.19p pd=1.38u as=0 ps=0 w=1u l=1u
X2977 VDD VSS.t2792 VDD VDD sg13_lv_pmos ad=0.34p pd=2.68u as=0 ps=0 w=1u l=1u
X2978 VDD VSS.t568 VDD VDD sg13_lv_pmos ad=0.19p pd=1.38u as=0 ps=0 w=1u l=1u
X2979 a_9861_14521# a_9861_14521# VSS.t33 VSS.t195 sg13_lv_nmos ad=0.111p pd=1.34u as=5.4375p ps=36.05u w=0.3u l=0.13u
X2980 VDD VSS.t407 VDD VDD sg13_lv_pmos ad=0.34p pd=2.68u as=0 ps=0 w=1u l=1u
X2981 VDD VSS.t100 VDD VDD sg13_lv_pmos ad=0.34p pd=2.68u as=0 ps=0 w=1u l=1u
X2982 VDD VSS.t117 VDD VDD sg13_lv_pmos ad=0.34p pd=2.68u as=0 ps=0 w=1u l=1u
X2983 a_10703_15311# a_9861_15213# a_10609_15311# VSS.t44 sg13_lv_nmos ad=0.12665p pd=1.145u as=0.1428p ps=1.52u w=0.42u l=0.13u
X2984 VSS.t540 VDD VSS.t542 VSS.t541 sg13_lv_nmos ad=79.8f pd=0.8u as=0 ps=0 w=0.42u l=1u
X2985 VSS.t1589 VDD VSS.t1588 VSS.t1587 sg13_lv_nmos ad=0.1428p pd=1.52u as=0 ps=0 w=0.42u l=1u
X2986 VSS.t1759 VDD VSS.t1761 VSS.t1760 sg13_lv_nmos ad=79.8f pd=0.8u as=0 ps=0 w=0.42u l=1u
X2987 VDD VSS.t1598 VDD VDD sg13_lv_pmos ad=0.34p pd=2.68u as=0 ps=0 w=1u l=1u
X2988 VSS.t3285 VDD VSS.t3287 VSS.t3286 sg13_lv_nmos ad=79.8f pd=0.8u as=0 ps=0 w=0.42u l=1u
X2989 VDD VSS.t1152 VDD VDD sg13_lv_pmos ad=0.19p pd=1.38u as=0 ps=0 w=1u l=1u
X2990 VDD VSS.t1292 VDD VDD sg13_lv_pmos ad=0.34p pd=2.68u as=0 ps=0 w=1u l=1u
X2991 VDD VSS.t2507 VDD VDD sg13_lv_pmos ad=0.34p pd=2.68u as=0 ps=0 w=1u l=1u
X2992 VSS.t449 VDD VSS.t449 VSS.t450 sg13_lv_nmos ad=79.8f pd=0.8u as=0 ps=0 w=0.42u l=1u
X2993 VSS.t609 VDD VSS.t608 VSS.t33 sg13_lv_nmos ad=0.1428p pd=1.52u as=0 ps=0 w=0.42u l=1u
X2994 VDD VSS.t964 VDD VDD sg13_lv_pmos ad=0.34p pd=2.68u as=0 ps=0 w=1u l=1u
X2995 VSS.t2398 VDD VSS.t2397 VSS.t2396 sg13_lv_nmos ad=0.1428p pd=1.52u as=0 ps=0 w=0.42u l=1u
X2996 VDD VSS.t2105 VDD VDD sg13_lv_pmos ad=0.34p pd=2.68u as=0 ps=0 w=1u l=1u
X2997 VSS.t2568 VDD VSS.t2570 VSS.t2569 sg13_lv_nmos ad=79.8f pd=0.8u as=0 ps=0 w=0.42u l=1u
X2998 VDD VSS.t763 VDD VDD sg13_lv_pmos ad=0.19p pd=1.38u as=0 ps=0 w=1u l=1u
X2999 VDD VSS.t2632 VDD VDD sg13_lv_pmos ad=0.34p pd=2.68u as=0 ps=0 w=1u l=1u
X3000 VSS.t2116 VDD VSS.t2115 VSS.t2114 sg13_lv_nmos ad=0.1428p pd=1.52u as=0 ps=0 w=0.42u l=1u
X3001 VSS.t33 a_18021_14495# a_18123_14495# VSS.t121 sg13_lv_nmos ad=5.4375p pd=36.05u as=0.2516p ps=2.16u w=0.74u l=0.13u
X3002 VSS.t2066 VDD VSS.t2068 VSS.t2067 sg13_lv_nmos ad=79.8f pd=0.8u as=0 ps=0 w=0.42u l=1u
X3003 VDD sg13g2_dfrbpq_1_6.RESET_B a_21034_14452# VDD sg13_lv_pmos ad=0.1563p pd=1.22u as=0.147p ps=1.54u w=0.42u l=0.13u
X3004 VDD VSS.t1788 VDD VDD sg13_lv_pmos ad=0.34p pd=2.68u as=0 ps=0 w=1u l=1u
X3005 VSS.t3155 VDD VSS.t3157 VSS.t3156 sg13_lv_nmos ad=79.8f pd=0.8u as=0 ps=0 w=0.42u l=1u
X3006 VDD VSS.t728 VDD VDD sg13_lv_pmos ad=0.19p pd=1.38u as=0 ps=0 w=1u l=1u
X3007 VDD sg13g2_dlygate4sd3_1_8.X sg13g2_nand4_1_0.Y VDD sg13_lv_pmos ad=0.3808p pd=2.92u as=0.2128p ps=1.5u w=1.12u l=0.13u
X3008 a_6680_15242# sg13g2_dlygate4sd3_1_1.A a_6578_15242# VSS.t272 sg13_lv_nmos ad=0.1406p pd=1.12u as=0.1406p ps=1.12u w=0.74u l=0.13u
X3009 VSS.t1411 VDD VSS.t1412 VSS.t377 sg13_lv_nmos ad=79.8f pd=0.8u as=0 ps=0 w=0.42u l=1u
X3010 VSS.t1849 VDD VSS.t1851 VSS.t1850 sg13_lv_nmos ad=79.8f pd=0.8u as=0 ps=0 w=0.42u l=1u
X3011 VSS.t1070 VDD VSS.t1069 VSS.t1068 sg13_lv_nmos ad=0.1428p pd=1.52u as=0 ps=0 w=0.42u l=1u
X3012 VDD VSS.t2752 VDD VDD sg13_lv_pmos ad=0.19p pd=1.38u as=0 ps=0 w=1u l=1u
X3013 VSS.t2363 VDD VSS.t2362 VSS.t2361 sg13_lv_nmos ad=0.1428p pd=1.52u as=0 ps=0 w=0.42u l=1u
X3014 VSS.t164 a_7631_14845# a_8298_14484# VSS.t194 sg13_lv_nmos ad=0.1406p pd=1.12u as=0.2516p ps=2.16u w=0.74u l=0.13u
X3015 VDD a_19438_13726# sg13g2_buf_16_2.X VDD sg13_lv_pmos ad=0.2128p pd=1.5u as=0.2128p ps=1.5u w=1.12u l=0.13u
X3016 VSS.t2849 VDD VSS.t2848 VSS.t412 sg13_lv_nmos ad=0.1428p pd=1.52u as=0 ps=0 w=0.42u l=1u
X3017 VDD VSS.t602 VDD VDD sg13_lv_pmos ad=0.34p pd=2.68u as=0 ps=0 w=1u l=1u
X3018 a_26638_15423# a_26753_15424# VSS.t33 VSS.t219 sg13_lv_nmos ad=0.1428p pd=1.52u as=0.1426p ps=1.16u w=0.42u l=0.5u
X3019 a_16068_14040# a_16587_13844# a_17327_13799# VSS.t353 sg13_lv_nmos ad=0.3473p pd=2.71u as=0.12665p ps=1.145u w=0.74u l=0.13u
X3020 VDD VSS.t1384 VDD VDD sg13_lv_pmos ad=0.34p pd=2.68u as=0 ps=0 w=1u l=1u
X3021 VDD VSS.t3219 VDD VDD sg13_lv_pmos ad=0.34p pd=2.68u as=0 ps=0 w=1u l=1u
X3022 VSS.t2216 VDD VSS.t2218 VSS.t2217 sg13_lv_nmos ad=79.8f pd=0.8u as=0 ps=0 w=0.42u l=1u
X3023 VDD VSS.t475 VDD VDD sg13_lv_pmos ad=0.34p pd=2.68u as=0 ps=0 w=1u l=1u
X3024 VSS.t1130 VDD VSS.t1132 VSS.t1131 sg13_lv_nmos ad=79.8f pd=0.8u as=0 ps=0 w=0.42u l=1u
X3025 VDD VSS.t1119 VDD VDD sg13_lv_pmos ad=0.34p pd=2.68u as=0 ps=0 w=1u l=1u
X3026 VSS.t1779 VDD VSS.t1781 VSS.t1780 sg13_lv_nmos ad=79.8f pd=0.8u as=0 ps=0 w=0.42u l=1u
X3027 VDD VSS.t927 VDD VDD sg13_lv_pmos ad=0.19p pd=1.38u as=0 ps=0 w=1u l=1u
X3028 VDD VSS.t1583 VDD VDD sg13_lv_pmos ad=0.34p pd=2.68u as=0 ps=0 w=1u l=1u
X3029 VDD VSS.t1846 VDD VDD sg13_lv_pmos ad=0.19p pd=1.38u as=0 ps=0 w=1u l=1u
X3030 VDD sg13g2_xnor2_1_1.A a_16218_15532# VDD sg13_lv_pmos ad=0.2891p pd=1.695u as=0.1428p ps=1.375u w=1.12u l=0.13u
X3031 VDD VSS.t740 VDD VDD sg13_lv_pmos ad=0.34p pd=2.68u as=0 ps=0 w=1u l=1u
X3032 VSS.t1419 VDD VSS.t1420 VSS.t377 sg13_lv_nmos ad=79.8f pd=0.8u as=0 ps=0 w=0.42u l=1u
X3033 VSS.t990 VDD VSS.t989 VSS.t988 sg13_lv_nmos ad=0.1428p pd=1.52u as=0 ps=0 w=0.42u l=1u
X3034 VSS.t1719 VDD VSS.t1718 VSS.t1717 sg13_lv_nmos ad=0.1428p pd=1.52u as=0 ps=0 w=0.42u l=1u
X3035 VDD VSS.t2617 VDD VDD sg13_lv_pmos ad=0.34p pd=2.68u as=0 ps=0 w=1u l=1u
X3036 VDD VSS.t2440 VDD VDD sg13_lv_pmos ad=0.19p pd=1.38u as=0 ps=0 w=1u l=1u
X3037 VSS.t1327 VDD VSS.t1328 VSS.t377 sg13_lv_nmos ad=79.8f pd=0.8u as=0 ps=0 w=0.42u l=1u
X3038 VDD a_6286_13911# sg13g2_dlygate4sd3_1_0.X VDD sg13_lv_pmos ad=0.2254p pd=1.53u as=0.4256p ps=3u w=1.12u l=0.13u
X3039 a_26505_14113# a_26148_14040# VDD VDD sg13_lv_pmos ad=63f pd=0.72u as=0.1563p ps=1.22u w=0.42u l=0.13u
X3040 VDD VSS.t465 VDD VDD sg13_lv_pmos ad=0.34p pd=2.68u as=0 ps=0 w=1u l=1u
X3041 VDD VSS.t100 VDD VDD sg13_lv_pmos ad=0.19p pd=1.38u as=0 ps=0 w=1u l=1u
X3042 VSS.t1424 VDD VSS.t1425 VSS.t377 sg13_lv_nmos ad=79.8f pd=0.8u as=0 ps=0 w=0.42u l=1u
X3043 VDD VSS.t2193 VDD VDD sg13_lv_pmos ad=0.19p pd=1.38u as=0 ps=0 w=1u l=1u
X3044 VSS.t384 a_19438_13726# sg13g2_buf_16_2.X VSS.t390 sg13_lv_nmos ad=0.1406p pd=1.12u as=0.1406p ps=1.12u w=0.74u l=0.13u
X3045 VDD a_16055_16301# a_16055_16071# VDD sg13_lv_pmos ad=2.8961p pd=18.25u as=0.2442p ps=2.06u w=0.66u l=0.13u
X3046 VSS.t78 sg13g2_o21ai_1_2.Y a_24824_15238# VSS.t28 sg13_lv_nmos ad=79.8f pd=0.8u as=0.1428p ps=1.52u w=0.42u l=0.13u
X3047 VDD VSS.t1968 VDD VDD sg13_lv_pmos ad=0.19p pd=1.38u as=0 ps=0 w=1u l=1u
X3048 VSS.t2011 VDD VSS.t2013 VSS.t2012 sg13_lv_nmos ad=79.8f pd=0.8u as=0 ps=0 w=0.42u l=1u
X3049 VDD VSS.t2495 VDD VDD sg13_lv_pmos ad=0.19p pd=1.38u as=0 ps=0 w=1u l=1u
X3050 VSS.t2553 VDD VSS.t2555 VSS.t2554 sg13_lv_nmos ad=79.8f pd=0.8u as=0 ps=0 w=0.42u l=1u
X3051 VDD VSS.t302 VDD VDD sg13_lv_pmos ad=0.34p pd=2.68u as=0 ps=0 w=1u l=1u
X3052 a_15782_13722# sg13g2_dfrbpq_1_2.D VDD VDD sg13_lv_pmos ad=79.8f pd=0.8u as=0.1428p ps=1.52u w=0.42u l=0.13u
X3053 VSS.t2831 VDD VSS.t2832 VSS.t412 sg13_lv_nmos ad=79.8f pd=0.8u as=0 ps=0 w=0.42u l=1u
X3054 VSS.t2101 VDD VSS.t2103 VSS.t2102 sg13_lv_nmos ad=79.8f pd=0.8u as=0 ps=0 w=0.42u l=1u
X3055 a_4474_14448# sg13g2_dlygate4sd3_1_3.A VDD VDD sg13_lv_pmos ad=0.1428p pd=1.52u as=0.1523p ps=1.38u w=0.42u l=0.13u
X3056 VSS.t720 VDD VSS.t720 VSS.t721 sg13_lv_nmos ad=79.8f pd=0.8u as=0 ps=0 w=0.42u l=1u
X3057 VDD VSS.t1082 VDD VDD sg13_lv_pmos ad=0.19p pd=1.38u as=0 ps=0 w=1u l=1u
X3058 VSS.t1574 VDD VSS.t1573 VSS.t1572 sg13_lv_nmos ad=0.1428p pd=1.52u as=0 ps=0 w=0.42u l=1u
X3059 a_27500_15960# sg13g2_dfrbpq_1_6.Q VDD VDD sg13_lv_pmos ad=0.2856p pd=2.36u as=0.2114p ps=1.54u w=0.84u l=0.13u
X3060 VSS.t950 VDD VSS.t952 VSS.t951 sg13_lv_nmos ad=79.8f pd=0.8u as=0 ps=0 w=0.42u l=1u
X3061 VDD VSS.t1323 VDD VDD sg13_lv_pmos ad=0.34p pd=2.68u as=0 ps=0 w=1u l=1u
X3062 VDD VSS.t2832 VDD VDD sg13_lv_pmos ad=0.34p pd=2.68u as=0 ps=0 w=1u l=1u
X3063 VSS.t2383 VDD VSS.t2382 VSS.t2381 sg13_lv_nmos ad=0.1428p pd=1.52u as=0 ps=0 w=0.42u l=1u
X3064 VDD VSS.t610 VDD VDD sg13_lv_pmos ad=0.19p pd=1.38u as=0 ps=0 w=1u l=1u
X3065 VDD VSS.t1009 VDD VDD sg13_lv_pmos ad=0.34p pd=2.68u as=0 ps=0 w=1u l=1u
X3066 VSS.t2772 VDD VSS.t2773 VSS.t412 sg13_lv_nmos ad=79.8f pd=0.8u as=0 ps=0 w=0.42u l=1u
X3067 VSS.t2231 VDD VSS.t2230 VSS.t2229 sg13_lv_nmos ad=0.1428p pd=1.52u as=0 ps=0 w=0.42u l=1u
X3068 VSS.t2051 VDD VSS.t2053 VSS.t2052 sg13_lv_nmos ad=79.8f pd=0.8u as=0 ps=0 w=0.42u l=1u
X3069 VDD sg13g2_dfrbpq_1_6.RESET_B a_20774_14922# VDD sg13_lv_pmos ad=0.36237p pd=2.605u as=79.8f ps=0.8u w=0.42u l=0.13u
X3070 VDD VSS.t302 VDD VDD sg13_lv_pmos ad=0.34p pd=2.68u as=0 ps=0 w=1u l=1u
X3071 VDD VSS.t758 VDD VDD sg13_lv_pmos ad=0.19p pd=1.38u as=0 ps=0 w=1u l=1u
X3072 VDD VSS.t3082 VDD VDD sg13_lv_pmos ad=0.19p pd=1.38u as=0 ps=0 w=1u l=1u
X3073 VSS.t3140 VDD VSS.t3142 VSS.t3141 sg13_lv_nmos ad=79.8f pd=0.8u as=0 ps=0 w=0.42u l=1u
X3074 a_2516_14484# sg13g2_buf_1_0.X VDD VDD sg13_lv_pmos ad=0.3808p pd=2.92u as=0.2128p ps=1.5u w=1.12u l=0.13u
X3075 VSS.t749 VDD VSS.t749 VSS.t874 sg13_lv_nmos ad=0.1428p pd=1.52u as=0 ps=0 w=0.42u l=1u
X3076 VSS.t2573 VDD VSS.t2572 VSS.t2571 sg13_lv_nmos ad=0.1428p pd=1.52u as=0 ps=0 w=0.42u l=1u
X3077 VSS.t302 VDD VSS.t302 VSS.t710 sg13_lv_nmos ad=79.8f pd=0.8u as=0 ps=0 w=0.42u l=1u
X3078 VSS.t1834 VDD VSS.t1836 VSS.t1835 sg13_lv_nmos ad=79.8f pd=0.8u as=0 ps=0 w=0.42u l=1u
X3079 VDD VSS.t2487 VDD VDD sg13_lv_pmos ad=0.34p pd=2.68u as=0 ps=0 w=1u l=1u
X3080 VDD VSS.t2145 VDD VDD sg13_lv_pmos ad=0.34p pd=2.68u as=0 ps=0 w=1u l=1u
X3081 a_26313_14531# a_25956_14488# VDD VDD sg13_lv_pmos ad=63f pd=0.72u as=0.1563p ps=1.22u w=0.42u l=0.13u
X3082 VSS.t1360 VDD VSS.t1361 VSS.t377 sg13_lv_nmos ad=79.8f pd=0.8u as=0 ps=0 w=0.42u l=1u
X3083 VDD VSS.t3272 VDD VDD sg13_lv_pmos ad=0.19p pd=1.38u as=0 ps=0 w=1u l=1u
X3084 VDD VSS.t2796 VDD VDD sg13_lv_pmos ad=0.34p pd=2.68u as=0 ps=0 w=1u l=1u
X3085 VDD VSS.t1410 VDD VDD sg13_lv_pmos ad=0.34p pd=2.68u as=0 ps=0 w=1u l=1u
X3086 VSS.t1293 VDD VSS.t1292 VSS.t377 sg13_lv_nmos ad=0.1428p pd=1.52u as=0 ps=0 w=0.42u l=1u
X3087 VSS.t1704 VDD VSS.t1706 VSS.t1705 sg13_lv_nmos ad=79.8f pd=0.8u as=0 ps=0 w=0.42u l=1u
X3088 VSS.t33 a_9737_14822# a_9658_14725# VSS.t223 sg13_lv_nmos ad=5.4375p pd=36.05u as=0.27427p ps=2.28u w=0.795u l=0.13u
X3089 VSS.t2201 VDD VSS.t2203 VSS.t2202 sg13_lv_nmos ad=79.8f pd=0.8u as=0 ps=0 w=0.42u l=1u
X3090 VSS.t495 VDD VSS.t494 VSS.t493 sg13_lv_nmos ad=0.1428p pd=1.52u as=0 ps=0 w=0.42u l=1u
X3091 VSS.t920 VDD VSS.t919 VSS.t918 sg13_lv_nmos ad=0.1428p pd=1.52u as=0 ps=0 w=0.42u l=1u
X3092 VSS.t1764 VDD VSS.t1766 VSS.t1765 sg13_lv_nmos ad=79.8f pd=0.8u as=0 ps=0 w=0.42u l=1u
X3093 VSS.t2892 VDD VSS.t2891 VSS.t412 sg13_lv_nmos ad=0.1428p pd=1.52u as=0 ps=0 w=0.42u l=1u
X3094 VSS.t3290 VDD VSS.t3292 VSS.t3291 sg13_lv_nmos ad=79.8f pd=0.8u as=0 ps=0 w=0.42u l=1u
X3095 VSS.t1448 VDD VSS.t1287 VSS.t377 sg13_lv_nmos ad=79.8f pd=0.8u as=0 ps=0 w=0.42u l=1u
X3096 VDD VSS.t590 VDD VDD sg13_lv_pmos ad=0.34p pd=2.68u as=0 ps=0 w=1u l=1u
X3097 VSS.t990 VDD VSS.t989 VSS.t988 sg13_lv_nmos ad=0.1428p pd=1.52u as=0 ps=0 w=0.42u l=1u
X3098 VSS.t2368 VDD VSS.t2367 VSS.t2366 sg13_lv_nmos ad=0.1428p pd=1.52u as=0 ps=0 w=0.42u l=1u
X3099 VSS.t356 VDD VSS.t18 VSS.t814 sg13_lv_nmos ad=79.8f pd=0.8u as=0 ps=0 w=0.42u l=1u
X3100 VDD VSS.t1831 VDD VDD sg13_lv_pmos ad=0.19p pd=1.38u as=0 ps=0 w=1u l=1u
X3101 VSS.t2762 VDD VSS.t2764 VSS.t412 sg13_lv_nmos ad=79.8f pd=0.8u as=0 ps=0 w=0.42u l=1u
X3102 VDD VSS.t2602 VDD VDD sg13_lv_pmos ad=0.34p pd=2.68u as=0 ps=0 w=1u l=1u
X3103 VDD VSS.t174 VDD VDD sg13_lv_pmos ad=0.34p pd=2.68u as=0 ps=0 w=1u l=1u
X3104 VDD VSS.t734 VDD VDD sg13_lv_pmos ad=0.34p pd=2.68u as=0 ps=0 w=1u l=1u
X3105 VDD VSS.t1112 VDD VDD sg13_lv_pmos ad=0.19p pd=1.38u as=0 ps=0 w=1u l=1u
X3106 VDD VSS.t1783 VDD VDD sg13_lv_pmos ad=0.34p pd=2.68u as=0 ps=0 w=1u l=1u
X3107 VSS.t2839 VDD VSS.t2838 VSS.t412 sg13_lv_nmos ad=0.1428p pd=1.52u as=0 ps=0 w=0.42u l=1u
X3108 VSS.t2071 VDD VSS.t2073 VSS.t2072 sg13_lv_nmos ad=79.8f pd=0.8u as=0 ps=0 w=0.42u l=1u
X3109 VDD VSS.t441 VDD VDD sg13_lv_pmos ad=0.19p pd=1.38u as=0 ps=0 w=1u l=1u
X3110 VDD VSS.t100 VDD VDD sg13_lv_pmos ad=0.19p pd=1.38u as=0 ps=0 w=1u l=1u
X3111 VSS.t100 VDD VSS.t100 VSS.t788 sg13_lv_nmos ad=0.1428p pd=1.52u as=0 ps=0 w=0.42u l=1u
X3112 VSS.t1342 VDD VSS.t1341 VSS.t377 sg13_lv_nmos ad=0.1428p pd=1.52u as=0 ps=0 w=0.42u l=1u
X3113 sg13g2_xnor2_1_2.B sg13g2_buf_1_0.X a_6202_15238# VSS.t36 sg13_lv_nmos ad=0.2516p pd=2.16u as=0.1406p ps=1.12u w=0.74u l=0.13u
X3114 sg13g2_xnor2_1_0.Y a_7680_15549# a_7829_15238# VSS.t42 sg13_lv_nmos ad=0.2516p pd=2.16u as=0.1406p ps=1.12u w=0.74u l=0.13u
X3115 VDD VSS.t1433 VDD VDD sg13_lv_pmos ad=0.34p pd=2.68u as=0 ps=0 w=1u l=1u
X3116 VSS.t3085 VDD VSS.t3087 VSS.t3086 sg13_lv_nmos ad=79.8f pd=0.8u as=0 ps=0 w=0.42u l=1u
X3117 VDD VSS.t599 VDD VDD sg13_lv_pmos ad=0.34p pd=2.68u as=0 ps=0 w=1u l=1u
X3118 VDD VSS.t302 VDD VDD sg13_lv_pmos ad=0.34p pd=2.68u as=0 ps=0 w=1u l=1u
X3119 sg13g2_a21oi_1_0.B1 sg13g2_buf_1_10.X VDD VDD sg13_lv_pmos ad=0.3808p pd=2.92u as=0.3808p ps=2.92u w=1.12u l=0.13u
X3120 VDD VSS.t2825 VDD VDD sg13_lv_pmos ad=0.19p pd=1.38u as=0 ps=0 w=1u l=1u
X3121 VSS.t2493 VDD VSS.t2492 VSS.t2491 sg13_lv_nmos ad=0.1428p pd=1.52u as=0 ps=0 w=0.42u l=1u
X3122 VSS.t731 VDD VSS.t731 VSS.t732 sg13_lv_nmos ad=79.8f pd=0.8u as=0 ps=0 w=0.42u l=1u
X3123 VDD VSS.t1127 VDD VDD sg13_lv_pmos ad=0.19p pd=1.38u as=0 ps=0 w=1u l=1u
X3124 VDD VSS.t3224 VDD VDD sg13_lv_pmos ad=0.34p pd=2.68u as=0 ps=0 w=1u l=1u
X3125 VSS.t2186 VDD VSS.t2188 VSS.t2187 sg13_lv_nmos ad=79.8f pd=0.8u as=0 ps=0 w=0.42u l=1u
X3126 VSS.t950 VDD VSS.t952 VSS.t951 sg13_lv_nmos ad=79.8f pd=0.8u as=0 ps=0 w=0.42u l=1u
X3127 VDD VSS.t302 VDD VDD sg13_lv_pmos ad=0.34p pd=2.68u as=0 ps=0 w=1u l=1u
X3128 VDD VSS.t1588 VDD VDD sg13_lv_pmos ad=0.34p pd=2.68u as=0 ps=0 w=1u l=1u
X3129 VDD VSS.t2497 VDD VDD sg13_lv_pmos ad=0.34p pd=2.68u as=0 ps=0 w=1u l=1u
X3130 sg13g2_or3_1_1.B a_14357_15238# VDD VDD sg13_lv_pmos ad=0.2128p pd=1.5u as=0.2128p ps=1.5u w=1.12u l=0.13u
X3131 VSS.t700 VDD VSS.t700 VSS.t703 sg13_lv_nmos ad=0.1428p pd=1.52u as=0 ps=0 w=0.42u l=1u
X3132 VDD VSS.t1761 VDD VDD sg13_lv_pmos ad=0.19p pd=1.38u as=0 ps=0 w=1u l=1u
X3133 a_27034_15202# sg13g2_dfrbpq_1_7.Q VSS.t33 VSS.t33 sg13_lv_nmos ad=0.1428p pd=1.52u as=79.8f ps=0.8u w=0.42u l=0.13u
X3134 VDD VSS.t1816 VDD VDD sg13_lv_pmos ad=0.19p pd=1.38u as=0 ps=0 w=1u l=1u
X3135 VDD VSS.t2008 VDD VDD sg13_lv_pmos ad=0.19p pd=1.38u as=0 ps=0 w=1u l=1u
X3136 VSS.t2106 VDD VSS.t2105 VSS.t2104 sg13_lv_nmos ad=0.1428p pd=1.52u as=0 ps=0 w=0.42u l=1u
X3137 VDD VSS.t1442 VDD VDD sg13_lv_pmos ad=0.34p pd=2.68u as=0 ps=0 w=1u l=1u
X3138 VSS.t100 VDD VSS.t100 VSS.t692 sg13_lv_nmos ad=79.8f pd=0.8u as=0 ps=0 w=0.42u l=1u
X3139 VDD VSS.t720 VDD VDD sg13_lv_pmos ad=0.34p pd=2.68u as=0 ps=0 w=1u l=1u
X3140 VDD VSS.t302 VDD VDD sg13_lv_pmos ad=0.34p pd=2.68u as=0 ps=0 w=1u l=1u
X3141 VSS.t2216 VDD VSS.t2215 VSS.t2214 sg13_lv_nmos ad=0.1428p pd=1.52u as=0 ps=0 w=0.42u l=1u
X3142 VSS.t384 VDD VSS.t384 VSS.t829 sg13_lv_nmos ad=79.8f pd=0.8u as=0 ps=0 w=0.42u l=1u
X3143 VSS.t1090 VDD VSS.t1089 VSS.t1088 sg13_lv_nmos ad=0.1428p pd=1.52u as=0 ps=0 w=0.42u l=1u
X3144 VSS.t1387 VDD VSS.t1388 VSS.t377 sg13_lv_nmos ad=79.8f pd=0.8u as=0 ps=0 w=0.42u l=1u
X3145 VSS.t2016 VDD VSS.t2018 VSS.t2017 sg13_lv_nmos ad=79.8f pd=0.8u as=0 ps=0 w=0.42u l=1u
X3146 VSS.t2994 VDD VSS.t2868 VSS.t412 sg13_lv_nmos ad=79.8f pd=0.8u as=0 ps=0 w=0.42u l=1u
X3147 VSS.t2558 VDD VSS.t2560 VSS.t2559 sg13_lv_nmos ad=79.8f pd=0.8u as=0 ps=0 w=0.42u l=1u
X3148 VDD VSS.t3257 VDD VDD sg13_lv_pmos ad=0.19p pd=1.38u as=0 ps=0 w=1u l=1u
X3149 a_20705_15260# sg13g2_dlygate4sd3_1_11.X sg13g2_a21oi_1_1.Y VSS.t9 sg13_lv_nmos ad=0.1406p pd=1.12u as=0.1406p ps=1.12u w=0.74u l=0.13u
X3150 VSS.t920 VDD VSS.t919 VSS.t918 sg13_lv_nmos ad=0.1428p pd=1.52u as=0 ps=0 w=0.42u l=1u
X3151 VSS.t1689 VDD VSS.t1691 VSS.t1690 sg13_lv_nmos ad=79.8f pd=0.8u as=0 ps=0 w=0.42u l=1u
X3152 VSS.t2428 VDD VSS.t2427 VSS.t2426 sg13_lv_nmos ad=0.1428p pd=1.52u as=0 ps=0 w=0.42u l=1u
X3153 VSS.t1150 VDD VSS.t1152 VSS.t1151 sg13_lv_nmos ad=79.8f pd=0.8u as=0 ps=0 w=0.42u l=1u
X3154 VDD VSS.t725 VDD VDD sg13_lv_pmos ad=0.34p pd=2.68u as=0 ps=0 w=1u l=1u
X3155 a_14357_15238# sg13g2_nand4_1_0.Y VDD VDD sg13_lv_pmos ad=0.1596p pd=1.22u as=0.2856p ps=2.36u w=0.84u l=0.13u
X3156 VDD VSS.t3127 VDD VDD sg13_lv_pmos ad=0.19p pd=1.38u as=0 ps=0 w=1u l=1u
X3157 VDD VSS.t1993 VDD VDD sg13_lv_pmos ad=0.19p pd=1.38u as=0 ps=0 w=1u l=1u
X3158 VDD sg13g2_dfrbpq_1_3.RESET_B a_17578_14452# VDD sg13_lv_pmos ad=0.1563p pd=1.22u as=0.147p ps=1.54u w=0.42u l=0.13u
X3159 a_26122_13945# a_26565_13701# a_25862_13722# VSS.t379 sg13_lv_nmos ad=79.8f pd=0.8u as=0.1296p ps=1.52u w=0.42u l=0.13u
X3160 VSS.t1844 VDD VSS.t1846 VSS.t1845 sg13_lv_nmos ad=79.8f pd=0.8u as=0 ps=0 w=0.42u l=1u
X3161 VSS.t2753 VDD VSS.t2755 VSS.t412 sg13_lv_nmos ad=79.8f pd=0.8u as=0 ps=0 w=0.42u l=1u
X3162 VDD VSS.t1768 VDD VDD sg13_lv_pmos ad=0.34p pd=2.68u as=0 ps=0 w=1u l=1u
X3163 VDD VSS.t2902 VDD VDD sg13_lv_pmos ad=0.19p pd=1.38u as=0 ps=0 w=1u l=1u
X3164 VSS.t2236 VDD VSS.t2235 VSS.t2234 sg13_lv_nmos ad=0.1428p pd=1.52u as=0 ps=0 w=0.42u l=1u
X3165 VSS.t2056 VDD VSS.t2058 VSS.t2057 sg13_lv_nmos ad=79.8f pd=0.8u as=0 ps=0 w=0.42u l=1u
X3166 VSS.t612 VDD VSS.t611 VSS.t33 sg13_lv_nmos ad=0.1428p pd=1.52u as=0 ps=0 w=0.42u l=1u
X3167 VSS.t3145 VDD VSS.t3147 VSS.t3146 sg13_lv_nmos ad=79.8f pd=0.8u as=0 ps=0 w=0.42u l=1u
X3168 VSS.t164 sg13g2_xnor2_1_0.Y a_8312_15238# VSS.t244 sg13_lv_nmos ad=79.8f pd=0.8u as=0.1428p ps=1.52u w=0.42u l=0.13u
X3169 sg13g2_a21oi_1_3.A2 a_24169_14508# VDD VDD sg13_lv_pmos ad=0.3808p pd=2.92u as=0.3822p ps=1.84u w=1.12u l=0.13u
X3170 VSS.t1369 VDD VSS.t1368 VSS.t377 sg13_lv_nmos ad=0.1428p pd=1.52u as=0 ps=0 w=0.42u l=1u
X3171 VDD VSS.t2360 VDD VDD sg13_lv_pmos ad=0.19p pd=1.38u as=0 ps=0 w=1u l=1u
X3172 VSS.t1839 VDD VSS.t1841 VSS.t1840 sg13_lv_nmos ad=79.8f pd=0.8u as=0 ps=0 w=0.42u l=1u
X3173 VDD VSS.t2457 VDD VDD sg13_lv_pmos ad=0.34p pd=2.68u as=0 ps=0 w=1u l=1u
X3174 VDD VSS.t2150 VDD VDD sg13_lv_pmos ad=0.34p pd=2.68u as=0 ps=0 w=1u l=1u
X3175 VSS.t1966 VDD VSS.t1968 VSS.t1967 sg13_lv_nmos ad=79.8f pd=0.8u as=0 ps=0 w=0.42u l=1u
X3176 VSS.t1411 VDD VSS.t1410 VSS.t377 sg13_lv_nmos ad=0.1428p pd=1.52u as=0 ps=0 w=0.42u l=1u
X3177 VDD VSS.t3277 VDD VDD sg13_lv_pmos ad=0.19p pd=1.38u as=0 ps=0 w=1u l=1u
X3178 VDD a_17710_15423# sg13g2_a21oi_1_0.A1 VDD sg13_lv_pmos ad=0.2254p pd=1.53u as=0.4256p ps=3u w=1.12u l=0.13u
X3179 VSS.t287 a_22030_15423# sg13g2_or3_1_2.A VSS.t426 sg13_lv_nmos ad=0.1426p pd=1.16u as=0.2516p ps=2.16u w=0.74u l=0.13u
X3180 VDD VSS.t2098 VDD VDD sg13_lv_pmos ad=0.19p pd=1.38u as=0 ps=0 w=1u l=1u
X3181 VDD VSS.t302 VDD VDD sg13_lv_pmos ad=0.34p pd=2.68u as=0 ps=0 w=1u l=1u
X3182 VSS.t302 a_16485_13701# a_16587_13844# VSS.t359 sg13_lv_nmos ad=15.10457p pd=99.59499u as=0.2516p ps=2.16u w=0.74u l=0.13u
X3183 VSS.t302 VDD VSS.t302 VSS.t785 sg13_lv_nmos ad=0.1428p pd=1.52u as=0 ps=0 w=0.42u l=1u
X3184 VSS.t1120 VDD VSS.t1119 VSS.t1118 sg13_lv_nmos ad=0.1428p pd=1.52u as=0 ps=0 w=0.42u l=1u
X3185 VSS.t131 VDD VSS.t131 VSS.t472 sg13_lv_nmos ad=0.1428p pd=1.52u as=0 ps=0 w=0.42u l=1u
X3186 VDD VSS.t984 VDD VDD sg13_lv_pmos ad=0.34p pd=2.68u as=0 ps=0 w=1u l=1u
X3187 VSS.t2031 VDD VSS.t2030 VSS.t2029 sg13_lv_nmos ad=0.1428p pd=1.52u as=0 ps=0 w=0.42u l=1u
X3188 VDD VSS.t962 VDD VDD sg13_lv_pmos ad=0.19p pd=1.38u as=0 ps=0 w=1u l=1u
X3189 VDD VSS.t1573 VDD VDD sg13_lv_pmos ad=0.34p pd=2.68u as=0 ps=0 w=1u l=1u
X3190 VSS.t3001 VDD VSS.t2874 VSS.t412 sg13_lv_nmos ad=0.1428p pd=1.52u as=0 ps=0 w=0.42u l=1u
X3191 a_11122_15234# sg13g2_tiehi_1.L_HI VSS.t22 VSS.t21 sg13_lv_nmos ad=37.8f pd=0.6u as=79.8f ps=0.8u w=0.42u l=0.13u
X3192 VSS.t2373 VDD VSS.t2372 VSS.t2371 sg13_lv_nmos ad=0.1428p pd=1.52u as=0 ps=0 w=0.42u l=1u
X3193 VSS.t1634 VDD VSS.t1636 VSS.t1635 sg13_lv_nmos ad=79.8f pd=0.8u as=0 ps=0 w=0.42u l=1u
X3194 sg13g2_or3_1_2.C sg13g2_dfrbpq_1_3.Q a_20218_15238# VSS.t9 sg13_lv_nmos ad=0.2516p pd=2.16u as=0.1406p ps=1.12u w=0.74u l=0.13u
X3195 VSS.t1829 VDD VSS.t1831 VSS.t1830 sg13_lv_nmos ad=79.8f pd=0.8u as=0 ps=0 w=0.42u l=1u
X3196 VSS.t2543 VDD VSS.t2545 VSS.t2544 sg13_lv_nmos ad=79.8f pd=0.8u as=0 ps=0 w=0.42u l=1u
X3197 a_12020_15202# sg13g2_buf_16_2.A VDD VDD sg13_lv_pmos ad=0.2128p pd=1.5u as=0.2128p ps=1.5u w=1.12u l=0.13u
X3198 VSS.t2842 VDD VSS.t2841 VSS.t412 sg13_lv_nmos ad=0.1428p pd=1.52u as=0 ps=0 w=0.42u l=1u
X3199 VDD VSS.t3072 VDD VDD sg13_lv_pmos ad=0.19p pd=1.38u as=0 ps=0 w=1u l=1u
X3200 VSS.t579 VDD VSS.t578 VSS.t33 sg13_lv_nmos ad=0.1428p pd=1.52u as=0 ps=0 w=0.42u l=1u
X3201 VDD VSS.t1047 VDD VDD sg13_lv_pmos ad=0.19p pd=1.38u as=0 ps=0 w=1u l=1u
X3202 VSS.t1090 VDD VSS.t1089 VSS.t1088 sg13_lv_nmos ad=0.1428p pd=1.52u as=0 ps=0 w=0.42u l=1u
X3203 VSS.t995 VDD VSS.t997 VSS.t996 sg13_lv_nmos ad=79.8f pd=0.8u as=0 ps=0 w=0.42u l=1u
X3204 VDD VSS.t2525 VDD VDD sg13_lv_pmos ad=0.19p pd=1.38u as=0 ps=0 w=1u l=1u
X3205 VDD VSS.t2183 VDD VDD sg13_lv_pmos ad=0.19p pd=1.38u as=0 ps=0 w=1u l=1u
X3206 VSS.t2186 VDD VSS.t2185 VSS.t2184 sg13_lv_nmos ad=0.1428p pd=1.52u as=0 ps=0 w=0.42u l=1u
X3207 VSS.t566 VDD VSS.t568 VSS.t567 sg13_lv_nmos ad=79.8f pd=0.8u as=0 ps=0 w=0.42u l=1u
X3208 VSS.t2001 VDD VSS.t2003 VSS.t2002 sg13_lv_nmos ad=79.8f pd=0.8u as=0 ps=0 w=0.42u l=1u
X3209 VDD VSS.t614 VDD VDD sg13_lv_pmos ad=0.34p pd=2.68u as=0 ps=0 w=1u l=1u
X3210 VDD VSS.t695 VDD VDD sg13_lv_pmos ad=0.19p pd=1.38u as=0 ps=0 w=1u l=1u
X3211 VDD a_4175_15311# a_4842_15532# VDD sg13_lv_pmos ad=0.2128p pd=1.5u as=0.3864p ps=2.93u w=1.12u l=0.13u
X3212 VDD VSS.t1631 VDD VDD sg13_lv_pmos ad=0.19p pd=1.38u as=0 ps=0 w=1u l=1u
X3213 VDD a_10222_14751# sg13g2_dlygate4sd3_1_8.X VDD sg13_lv_pmos ad=0.2254p pd=1.53u as=0.4256p ps=3u w=1.12u l=0.13u
X3214 VSS.t1150 VDD VSS.t1152 VSS.t1151 sg13_lv_nmos ad=79.8f pd=0.8u as=0 ps=0 w=0.42u l=1u
X3215 VDD VSS.t1396 VDD VDD sg13_lv_pmos ad=0.34p pd=2.68u as=0 ps=0 w=1u l=1u
X3216 VSS.t2790 VDD VSS.t2791 VSS.t412 sg13_lv_nmos ad=79.8f pd=0.8u as=0 ps=0 w=0.42u l=1u
X3217 VDD VSS.t755 VDD VDD sg13_lv_pmos ad=0.34p pd=2.68u as=0 ps=0 w=1u l=1u
X3218 VDD VSS.t1766 VDD VDD sg13_lv_pmos ad=0.19p pd=1.38u as=0 ps=0 w=1u l=1u
X3219 sg13g2_dfrbpq_1_5.Q a_28074_14020# VDD VDD sg13_lv_pmos ad=0.3808p pd=2.92u as=0.2128p ps=1.5u w=1.12u l=0.13u
X3220 VDD VSS.t1821 VDD VDD sg13_lv_pmos ad=0.19p pd=1.38u as=0 ps=0 w=1u l=1u
X3221 VDD VSS.t3112 VDD VDD sg13_lv_pmos ad=0.19p pd=1.38u as=0 ps=0 w=1u l=1u
X3222 VDD VSS.t3289 VDD VDD sg13_lv_pmos ad=0.34p pd=2.68u as=0 ps=0 w=1u l=1u
X3223 VSS.t2563 VDD VSS.t2565 VSS.t2564 sg13_lv_nmos ad=79.8f pd=0.8u as=0 ps=0 w=0.42u l=1u
X3224 VDD VSS.t1978 VDD VDD sg13_lv_pmos ad=0.19p pd=1.38u as=0 ps=0 w=1u l=1u
X3225 sg13g2_dfrbpq_1_2.CLK a_12020_15202# VDD VDD sg13_lv_pmos ad=0.2128p pd=1.5u as=0.2128p ps=1.5u w=1.12u l=0.13u
X3226 VDD VSS.t2894 VDD VDD sg13_lv_pmos ad=0.19p pd=1.38u as=0 ps=0 w=1u l=1u
X3227 VSS.t2221 VDD VSS.t2220 VSS.t2219 sg13_lv_nmos ad=0.1428p pd=1.52u as=0 ps=0 w=0.42u l=1u
X3228 VSS.t1784 VDD VSS.t1783 VSS.t1782 sg13_lv_nmos ad=0.1428p pd=1.52u as=0 ps=0 w=0.42u l=1u
X3229 VDD VSS.t1017 VDD VDD sg13_lv_pmos ad=0.19p pd=1.38u as=0 ps=0 w=1u l=1u
X3230 VDD VSS.t2510 VDD VDD sg13_lv_pmos ad=0.19p pd=1.38u as=0 ps=0 w=1u l=1u
X3231 VDD VSS.t562 VDD VDD sg13_lv_pmos ad=0.19p pd=1.38u as=0 ps=0 w=1u l=1u
X3232 VDD VSS.t686 VDD VDD sg13_lv_pmos ad=0.34p pd=2.68u as=0 ps=0 w=1u l=1u
X3233 VDD VSS.t2135 VDD VDD sg13_lv_pmos ad=0.34p pd=2.68u as=0 ps=0 w=1u l=1u
X3234 VSS.t755 VDD VSS.t758 VSS.t877 sg13_lv_nmos ad=79.8f pd=0.8u as=0 ps=0 w=0.42u l=1u
X3235 VDD VSS.t954 VDD VDD sg13_lv_pmos ad=0.34p pd=2.68u as=0 ps=0 w=1u l=1u
X3236 VSS.t2528 VDD VSS.t2530 VSS.t2529 sg13_lv_nmos ad=79.8f pd=0.8u as=0 ps=0 w=0.42u l=1u
X3237 VDD VSS.t302 VDD VDD sg13_lv_pmos ad=0.34p pd=2.68u as=0 ps=0 w=1u l=1u
X3238 VSS.t1120 VDD VSS.t1119 VSS.t1118 sg13_lv_nmos ad=0.1428p pd=1.52u as=0 ps=0 w=0.42u l=1u
X3239 VDD VSS.t3262 VDD VDD sg13_lv_pmos ad=0.19p pd=1.38u as=0 ps=0 w=1u l=1u
X3240 VDD VSS.t189 VDD VDD sg13_lv_pmos ad=0.19p pd=1.38u as=0 ps=0 w=1u l=1u
X3241 VDD VSS.t892 VDD VDD sg13_lv_pmos ad=0.19p pd=1.38u as=0 ps=0 w=1u l=1u
X3242 VSS.t1694 VDD VSS.t1696 VSS.t1695 sg13_lv_nmos ad=79.8f pd=0.8u as=0 ps=0 w=0.42u l=1u
X3243 VDD VSS.t551 VDD VDD sg13_lv_pmos ad=0.19p pd=1.38u as=0 ps=0 w=1u l=1u
X3244 VDD VSS.t1970 VDD VDD sg13_lv_pmos ad=0.34p pd=2.68u as=0 ps=0 w=1u l=1u
X3245 VSS.t2016 VDD VSS.t2015 VSS.t2014 sg13_lv_nmos ad=0.1428p pd=1.52u as=0 ps=0 w=0.42u l=1u
X3246 sg13g2_buf_16_2.A a_15022_14484# VSS.t24 VSS.t236 sg13_lv_nmos ad=0.1406p pd=1.12u as=0.1406p ps=1.12u w=0.74u l=0.13u
X3247 sg13g2_dlygate4sd3_1_0.A a_6540_13238# VDD VDD sg13_lv_pmos ad=0.2408p pd=1.55u as=0.3808p ps=2.92u w=1.12u l=0.13u
X3248 VSS.t1476 VDD VSS.t1320 VSS.t377 sg13_lv_nmos ad=0.1428p pd=1.52u as=0 ps=0 w=0.42u l=1u
X3249 VDD VSS.t271 VDD VDD sg13_lv_pmos ad=0.19p pd=1.38u as=0 ps=0 w=1u l=1u
X3250 a_8685_14832# sg13g2_buf_1_10.X VDD VDD sg13_lv_pmos ad=0.1596p pd=1.22u as=0.2856p ps=2.36u w=0.84u l=0.13u
X3251 a_21060_14488# a_21579_14495# a_22319_14845# VSS.t30 sg13_lv_nmos ad=0.3473p pd=2.71u as=0.12665p ps=1.145u w=0.74u l=0.13u
X3252 VDD VSS.t1413 VDD VDD sg13_lv_pmos ad=0.34p pd=2.68u as=0 ps=0 w=1u l=1u
X3253 VSS.t2358 VDD VSS.t2357 VSS.t2356 sg13_lv_nmos ad=0.1428p pd=1.52u as=0 ps=0 w=0.42u l=1u
X3254 VSS.t749 VDD VSS.t746 VSS.t748 sg13_lv_nmos ad=0.1428p pd=1.52u as=0 ps=0 w=0.42u l=1u
X3255 VSS.t1814 VDD VSS.t1816 VSS.t1815 sg13_lv_nmos ad=79.8f pd=0.8u as=0 ps=0 w=0.42u l=1u
X3256 VSS.t2756 VDD VSS.t2758 VSS.t412 sg13_lv_nmos ad=79.8f pd=0.8u as=0 ps=0 w=0.42u l=1u
X3257 VDD a_18298_16237# sg13g2_dfrbpq_1_3.RESET_B VDD sg13_lv_pmos ad=2.8961p pd=18.25u as=0.3927p ps=2.99u w=1.155u l=0.13u
X3258 VSS.t995 VDD VSS.t997 VSS.t996 sg13_lv_nmos ad=79.8f pd=0.8u as=0 ps=0 w=0.42u l=1u
X3259 VDD VSS.t1773 VDD VDD sg13_lv_pmos ad=0.34p pd=2.68u as=0 ps=0 w=1u l=1u
X3260 VSS.t2834 VDD VSS.t2833 VSS.t412 sg13_lv_nmos ad=0.1428p pd=1.52u as=0 ps=0 w=0.42u l=1u
X3261 VSS.t3150 VDD VSS.t3152 VSS.t3151 sg13_lv_nmos ad=79.8f pd=0.8u as=0 ps=0 w=0.42u l=1u
X3262 VDD VSS.t3057 VDD VDD sg13_lv_pmos ad=0.19p pd=1.38u as=0 ps=0 w=1u l=1u
X3263 a_21166_16263# a_21281_16262# VDD VDD sg13_lv_pmos ad=0.34p pd=2.68u as=0.2254p ps=1.53u w=1u l=0.5u
X3264 VDD a_5687_15315# a_5687_15549# VDD sg13_lv_pmos ad=2.8961p pd=18.25u as=0.2442p ps=2.06u w=0.66u l=0.13u
X3265 VDD VSS.t2462 VDD VDD sg13_lv_pmos ad=0.34p pd=2.68u as=0 ps=0 w=1u l=1u
X3266 VDD VSS.t695 VDD VDD sg13_lv_pmos ad=0.19p pd=1.38u as=0 ps=0 w=1u l=1u
X3267 VDD VSS.t2120 VDD VDD sg13_lv_pmos ad=0.34p pd=2.68u as=0 ps=0 w=1u l=1u
X3268 VDD a_22508_15960# counter_value_o[4] VDD sg13_lv_pmos ad=0.2114p pd=1.54u as=0.42p ps=2.99u w=1.12u l=0.13u
X3269 VDD VSS.t725 VDD VDD sg13_lv_pmos ad=0.19p pd=1.38u as=0 ps=0 w=1u l=1u
X3270 VSS.t100 VDD VSS.t100 VSS.t692 sg13_lv_nmos ad=79.8f pd=0.8u as=0 ps=0 w=0.42u l=1u
X3271 VDD VSS.t1341 VDD VDD sg13_lv_pmos ad=0.19p pd=1.38u as=0 ps=0 w=1u l=1u
X3272 VDD VSS.t1443 VDD VDD sg13_lv_pmos ad=0.19p pd=1.38u as=0 ps=0 w=1u l=1u
X3273 VDD VSS.t3247 VDD VDD sg13_lv_pmos ad=0.19p pd=1.38u as=0 ps=0 w=1u l=1u
X3274 VSS.t1305 VDD VSS.t1304 VSS.t377 sg13_lv_nmos ad=0.1428p pd=1.52u as=0 ps=0 w=0.42u l=1u
X3275 VDD VSS.t2820 VDD VDD sg13_lv_pmos ad=0.19p pd=1.38u as=0 ps=0 w=1u l=1u
X3276 VSS.t2483 VDD VSS.t2482 VSS.t2481 sg13_lv_nmos ad=0.1428p pd=1.52u as=0 ps=0 w=0.42u l=1u
X3277 VDD VSS.t2038 VDD VDD sg13_lv_pmos ad=0.19p pd=1.38u as=0 ps=0 w=1u l=1u
X3278 a_27664_13942# sg13g2_dfrbpq_1_5.RESET_B VDD VDD sg13_lv_pmos ad=79.8f pd=0.8u as=2.42015p ps=15.68u w=0.42u l=0.13u
X3279 a_16254_15934# a_16055_16071# VSS.t3 VSS.t321 sg13_lv_nmos ad=0.27427p pd=2.28u as=5.24677p ps=34.365u w=0.795u l=0.13u
X3280 sg13g2_nand4_1_0.Y sg13g2_xor2_1_0.B VDD VDD sg13_lv_pmos ad=0.2128p pd=1.5u as=0.3808p ps=2.92u w=1.12u l=0.13u
X3281 VSS.t609 VDD VSS.t610 VSS.t33 sg13_lv_nmos ad=79.8f pd=0.8u as=0 ps=0 w=0.42u l=1u
X3282 VDD VSS.t602 VDD VDD sg13_lv_pmos ad=0.34p pd=2.68u as=0 ps=0 w=1u l=1u
X3283 a_15782_13722# a_16587_13844# a_16042_13945# VDD sg13_lv_pmos ad=0.1428p pd=1.52u as=79.8f ps=0.8u w=0.42u l=0.13u
X3284 sg13g2_buf_16_2.X a_19438_13726# VSS.t384 VSS.t391 sg13_lv_nmos ad=0.1406p pd=1.12u as=0.1406p ps=1.12u w=0.74u l=0.13u
X3285 VSS.t1457 VDD VSS.t1299 VSS.t377 sg13_lv_nmos ad=79.8f pd=0.8u as=0 ps=0 w=0.42u l=1u
X3286 VSS.t2878 VDD VSS.t2877 VSS.t412 sg13_lv_nmos ad=0.1428p pd=1.52u as=0 ps=0 w=0.42u l=1u
X3287 VDD VSS.t2163 VDD VDD sg13_lv_pmos ad=0.19p pd=1.38u as=0 ps=0 w=1u l=1u
X3288 sg13g2_dfrbpq_1_2.D sg13g2_nor2_1_0.B a_15722_15532# VDD sg13_lv_pmos ad=0.3808p pd=2.92u as=0.1176p ps=1.33u w=1.12u l=0.13u
X3289 VDD VSS.t1806 VDD VDD sg13_lv_pmos ad=0.19p pd=1.38u as=0 ps=0 w=1u l=1u
X3290 VDD VSS.t3274 VDD VDD sg13_lv_pmos ad=0.34p pd=2.68u as=0 ps=0 w=1u l=1u
X3291 VDD VSS.t454 VDD VDD sg13_lv_pmos ad=0.19p pd=1.38u as=0 ps=0 w=1u l=1u
X3292 VDD VSS.t492 VDD VDD sg13_lv_pmos ad=0.19p pd=1.38u as=0 ps=0 w=1u l=1u
X3293 VSS.t2548 VDD VSS.t2550 VSS.t2549 sg13_lv_nmos ad=79.8f pd=0.8u as=0 ps=0 w=0.42u l=1u
X3294 VSS.t2046 VDD VSS.t2048 VSS.t2047 sg13_lv_nmos ad=79.8f pd=0.8u as=0 ps=0 w=0.42u l=1u
X3295 a_10222_14751# a_10337_14750# VDD VDD sg13_lv_pmos ad=0.34p pd=2.68u as=0.2254p ps=1.53u w=1u l=0.5u
X3296 VDD VSS.t1846 VDD VDD sg13_lv_pmos ad=0.19p pd=1.38u as=0 ps=0 w=1u l=1u
X3297 VDD VSS.t3077 VDD VDD sg13_lv_pmos ad=0.19p pd=1.38u as=0 ps=0 w=1u l=1u
X3298 a_15022_14484# clock_i VDD VDD sg13_lv_pmos ad=0.2128p pd=1.5u as=0.3808p ps=2.92u w=1.12u l=0.13u
X3299 VDD VSS.t1676 VDD VDD sg13_lv_pmos ad=0.19p pd=1.38u as=0 ps=0 w=1u l=1u
X3300 VSS.t33 a_21477_14495# a_21579_14495# VSS.t66 sg13_lv_nmos ad=5.4375p pd=36.05u as=0.2516p ps=2.16u w=0.74u l=0.13u
X3301 VDD a_26565_13701# a_26667_13844# VDD sg13_lv_pmos ad=2.42015p pd=15.68u as=0.3864p ps=2.93u w=1.12u l=0.13u
X3302 VDD VSS.t686 VDD VDD sg13_lv_pmos ad=0.34p pd=2.68u as=0 ps=0 w=1u l=1u
X3303 VSS.t1396 VDD VSS.t1396 VSS.t377 sg13_lv_nmos ad=0.1428p pd=1.52u as=0 ps=0 w=0.42u l=1u
X3304 VSS.t2914 VDD VSS.t2913 VSS.t412 sg13_lv_nmos ad=0.1428p pd=1.52u as=0 ps=0 w=0.42u l=1u
X3305 VDD VSS.t384 VDD VDD sg13_lv_pmos ad=0.34p pd=2.68u as=0 ps=0 w=1u l=1u
X3306 VDD VSS.t1434 VDD VDD sg13_lv_pmos ad=0.19p pd=1.38u as=0 ps=0 w=1u l=1u
X3307 VDD VSS.t2815 VDD VDD sg13_lv_pmos ad=0.19p pd=1.38u as=0 ps=0 w=1u l=1u
X3308 VDD VSS.t2490 VDD VDD sg13_lv_pmos ad=0.19p pd=1.38u as=0 ps=0 w=1u l=1u
X3309 VSS.t158 VDD VSS.t547 VSS.t546 sg13_lv_nmos ad=79.8f pd=0.8u as=0 ps=0 w=0.42u l=1u
X3310 VSS.t591 VDD VSS.t590 VSS.t33 sg13_lv_nmos ad=0.1428p pd=1.52u as=0 ps=0 w=0.42u l=1u
X3311 a_4474_14448# sg13g2_dlygate4sd3_1_3.A VSS.t95 VSS.t257 sg13_lv_nmos ad=0.1428p pd=1.52u as=79.8f ps=0.8u w=0.42u l=0.13u
X3312 VSS.t2792 VDD VSS.t2794 VSS.t412 sg13_lv_nmos ad=79.8f pd=0.8u as=0 ps=0 w=0.42u l=1u
X3313 VSS.t2825 VDD VSS.t2826 VSS.t412 sg13_lv_nmos ad=79.8f pd=0.8u as=0 ps=0 w=0.42u l=1u
X3314 sg13g2_buf_16_2.X a_19438_13726# VSS.t384 VSS.t387 sg13_lv_nmos ad=0.1406p pd=1.12u as=0.1406p ps=1.12u w=0.74u l=0.13u
X3315 VSS.t1986 VDD VSS.t1985 VSS.t1984 sg13_lv_nmos ad=0.1428p pd=1.52u as=0 ps=0 w=0.42u l=1u
X3316 VSS.t1431 VDD VSS.t1432 VSS.t377 sg13_lv_nmos ad=79.8f pd=0.8u as=0 ps=0 w=0.42u l=1u
X3317 VDD VSS.t1826 VDD VDD sg13_lv_pmos ad=0.19p pd=1.38u as=0 ps=0 w=1u l=1u
X3318 VDD VSS.t3117 VDD VDD sg13_lv_pmos ad=0.19p pd=1.38u as=0 ps=0 w=1u l=1u
X3319 VDD VSS.t1983 VDD VDD sg13_lv_pmos ad=0.19p pd=1.38u as=0 ps=0 w=1u l=1u
X3320 VSS.t460 VDD VSS.t460 VSS.t462 sg13_lv_nmos ad=0.1428p pd=1.52u as=0 ps=0 w=0.42u l=1u
X3321 VDD VSS.t50 VDD VDD sg13_lv_pmos ad=0.19p pd=1.38u as=0 ps=0 w=1u l=1u
X3322 VDD VSS.t35 VDD VDD sg13_lv_pmos ad=0.34p pd=2.68u as=0 ps=0 w=1u l=1u
X3323 VDD VSS.t2826 VDD VDD sg13_lv_pmos ad=0.34p pd=2.68u as=0 ps=0 w=1u l=1u
X3324 VSS.t127 sg13g2_nor2_1_0.B sg13g2_dfrbpq_1_2.D VSS.t126 sg13_lv_nmos ad=0.2516p pd=2.16u as=0.1406p ps=1.12u w=0.74u l=0.13u
X3325 VDD VSS.t2897 VDD VDD sg13_lv_pmos ad=0.19p pd=1.38u as=0 ps=0 w=1u l=1u
X3326 a_27215_14845# a_26373_14495# a_25956_14488# VDD sg13_lv_pmos ad=0.2048p pd=1.63u as=0.34p ps=2.68u w=1u l=0.13u
X3327 VSS.t3135 VDD VSS.t3137 VSS.t3136 sg13_lv_nmos ad=79.8f pd=0.8u as=0 ps=0 w=0.42u l=1u
X3328 VSS.t2191 VDD VSS.t2190 VSS.t2189 sg13_lv_nmos ad=0.1428p pd=1.52u as=0 ps=0 w=0.42u l=1u
X3329 VSS.t715 VDD VSS.t715 VSS.t837 sg13_lv_nmos ad=79.8f pd=0.8u as=0 ps=0 w=0.42u l=1u
X3330 VDD VSS.t586 VDD VDD sg13_lv_pmos ad=0.19p pd=1.38u as=0 ps=0 w=1u l=1u
X3331 VDD VSS.t1154 VDD VDD sg13_lv_pmos ad=0.34p pd=2.68u as=0 ps=0 w=1u l=1u
X3332 VDD VSS.t752 VDD VDD sg13_lv_pmos ad=0.19p pd=1.38u as=0 ps=0 w=1u l=1u
X3333 VSS.t2533 VDD VSS.t2535 VSS.t2534 sg13_lv_nmos ad=79.8f pd=0.8u as=0 ps=0 w=0.42u l=1u
X3334 VSS.t1440 VDD VSS.t1441 VSS.t377 sg13_lv_nmos ad=79.8f pd=0.8u as=0 ps=0 w=0.42u l=1u
X3335 VDD sg13g2_a21oi_1_0.Y a_16760_15238# VDD sg13_lv_pmos ad=0.1523p pd=1.38u as=0.1428p ps=1.52u w=0.42u l=0.13u
X3336 VDD a_15022_14484# sg13g2_buf_16_2.A VDD sg13_lv_pmos ad=0.2128p pd=1.5u as=0.2128p ps=1.5u w=1.12u l=0.13u
X3337 VDD VSS.t1621 VDD VDD sg13_lv_pmos ad=0.19p pd=1.38u as=0 ps=0 w=1u l=1u
X3338 VDD VSS.t3089 VDD VDD sg13_lv_pmos ad=0.34p pd=2.68u as=0 ps=0 w=1u l=1u
X3339 VSS.t1699 VDD VSS.t1701 VSS.t1700 sg13_lv_nmos ad=79.8f pd=0.8u as=0 ps=0 w=0.42u l=1u
X3340 VDD VSS.t2200 VDD VDD sg13_lv_pmos ad=0.34p pd=2.68u as=0 ps=0 w=1u l=1u
X3341 VDD VSS.t728 VDD VDD sg13_lv_pmos ad=0.34p pd=2.68u as=0 ps=0 w=1u l=1u
X3342 a_4078_14751# a_4193_14750# VSS.t145 VSS.t345 sg13_lv_nmos ad=0.1428p pd=1.52u as=0.1426p ps=1.16u w=0.42u l=0.5u
X3343 VSS.t960 VDD VSS.t962 VSS.t961 sg13_lv_nmos ad=79.8f pd=0.8u as=0 ps=0 w=0.42u l=1u
X3344 VDD VSS.t2786 VDD VDD sg13_lv_pmos ad=0.19p pd=1.38u as=0 ps=0 w=1u l=1u
X3345 VSS.t2021 VDD VSS.t2020 VSS.t2019 sg13_lv_nmos ad=0.1428p pd=1.52u as=0 ps=0 w=0.42u l=1u
X3346 VDD VSS.t1358 VDD VDD sg13_lv_pmos ad=0.19p pd=1.38u as=0 ps=0 w=1u l=1u
X3347 VSS.t2870 VDD VSS.t2869 VSS.t412 sg13_lv_nmos ad=0.1428p pd=1.52u as=0 ps=0 w=0.42u l=1u
X3348 VDD VSS.t2148 VDD VDD sg13_lv_pmos ad=0.19p pd=1.38u as=0 ps=0 w=1u l=1u
X3349 a_21286_14909# sg13g2_dfrbpq_1_6.RESET_B VSS.t6 VSS.t93 sg13_lv_nmos ad=37.8f pd=0.6u as=0.1701p ps=1.65u w=0.42u l=0.13u
X3350 sg13g2_buf_16_2.X a_19438_13726# VSS.t178 VSS.t382 sg13_lv_nmos ad=0.1406p pd=1.12u as=0.1406p ps=1.12u w=0.74u l=0.13u
X3351 VSS.t2563 VDD VSS.t2562 VSS.t2561 sg13_lv_nmos ad=0.1428p pd=1.52u as=0 ps=0 w=0.42u l=1u
X3352 VSS.t1819 VDD VSS.t1821 VSS.t1820 sg13_lv_nmos ad=79.8f pd=0.8u as=0 ps=0 w=0.42u l=1u
X3353 VDD VSS.t2100 VDD VDD sg13_lv_pmos ad=0.34p pd=2.68u as=0 ps=0 w=1u l=1u
X3354 VSS.t2211 VDD VSS.t2210 VSS.t2209 sg13_lv_nmos ad=0.1428p pd=1.52u as=0 ps=0 w=0.42u l=1u
X3355 VSS.t2031 VDD VSS.t2033 VSS.t2032 sg13_lv_nmos ad=79.8f pd=0.8u as=0 ps=0 w=0.42u l=1u
X3356 a_18454_15230# sg13g2_or3_1_2.B VSS.t202 VSS.t201 sg13_lv_nmos ad=0.1406p pd=1.12u as=0.1406p ps=1.12u w=0.74u l=0.15u
X3357 VDD VSS.t1831 VDD VDD sg13_lv_pmos ad=0.19p pd=1.38u as=0 ps=0 w=1u l=1u
X3358 VSS.t3120 VDD VSS.t3122 VSS.t3121 sg13_lv_nmos ad=79.8f pd=0.8u as=0 ps=0 w=0.42u l=1u
X3359 VDD VSS.t3062 VDD VDD sg13_lv_pmos ad=0.19p pd=1.38u as=0 ps=0 w=1u l=1u
X3360 VSS.t2628 VDD VSS.t2630 VSS.t2629 sg13_lv_nmos ad=79.8f pd=0.8u as=0 ps=0 w=0.42u l=1u
X3361 VDD VSS.t1783 VDD VDD sg13_lv_pmos ad=0.34p pd=2.68u as=0 ps=0 w=1u l=1u
X3362 a_2942_14484# sg13g2_xor2_1_0.B a_2490_14447# VDD sg13_lv_pmos ad=0.1225p pd=1.245u as=0.34p ps=2.68u w=1u l=0.13u
X3363 VDD VSS.t731 VDD VDD sg13_lv_pmos ad=0.34p pd=2.68u as=0 ps=0 w=1u l=1u
X3364 VDD VSS.t929 VDD VDD sg13_lv_pmos ad=0.34p pd=2.68u as=0 ps=0 w=1u l=1u
X3365 VDD VSS.t1661 VDD VDD sg13_lv_pmos ad=0.19p pd=1.38u as=0 ps=0 w=1u l=1u
X3366 VDD VSS.t1838 VDD VDD sg13_lv_pmos ad=0.34p pd=2.68u as=0 ps=0 w=1u l=1u
X3367 a_5613_14832# sg13g2_buf_1_10.X VDD VDD sg13_lv_pmos ad=0.1596p pd=1.22u as=0.2856p ps=2.36u w=0.84u l=0.13u
X3368 VSS.t178 sg13g2_buf_16_2.A a_19438_13726# VSS.t177 sg13_lv_nmos ad=0.1406p pd=1.12u as=0.1406p ps=1.12u w=0.74u l=0.13u
X3369 VSS.t1422 VDD VSS.t1421 VSS.t377 sg13_lv_nmos ad=0.1428p pd=1.52u as=0 ps=0 w=0.42u l=1u
X3370 VDD VSS.t2467 VDD VDD sg13_lv_pmos ad=0.34p pd=2.68u as=0 ps=0 w=1u l=1u
X3371 VDD a_17219_16265# sg13g2_a21oi_1_0.A2 VDD sg13_lv_pmos ad=0.3822p pd=1.84u as=0.3808p ps=2.92u w=1.12u l=0.13u
X3372 VDD sg13g2_buf_1_0.X sg13g2_xnor2_1_2.B VDD sg13_lv_pmos ad=0.3808p pd=2.92u as=0.2128p ps=1.5u w=1.12u l=0.13u
X3373 VDD VSS.t769 VDD VDD sg13_lv_pmos ad=0.34p pd=2.68u as=0 ps=0 w=1u l=1u
X3374 VSS.t186 VDD VSS.t189 VSS.t570 sg13_lv_nmos ad=79.8f pd=0.8u as=0 ps=0 w=0.42u l=1u
X3375 a_5886_15486# a_5687_15549# VSS.t33 VSS.t294 sg13_lv_nmos ad=0.27427p pd=2.28u as=5.4375p ps=36.05u w=0.795u l=0.13u
X3376 VSS.t1416 VDD VSS.t1417 VSS.t377 sg13_lv_nmos ad=79.8f pd=0.8u as=0 ps=0 w=0.42u l=1u
X3377 VDD VSS.t2043 VDD VDD sg13_lv_pmos ad=0.19p pd=1.38u as=0 ps=0 w=1u l=1u
X3378 VDD VSS.t619 VDD VDD sg13_lv_pmos ad=0.19p pd=1.38u as=0 ps=0 w=1u l=1u
X3379 VDD a_15022_14484# sg13g2_buf_16_2.A VDD sg13_lv_pmos ad=0.2128p pd=1.5u as=0.2128p ps=1.5u w=1.12u l=0.13u
X3380 VDD VSS.t982 VDD VDD sg13_lv_pmos ad=0.19p pd=1.38u as=0 ps=0 w=1u l=1u
X3381 VDD VSS.t2362 VDD VDD sg13_lv_pmos ad=0.34p pd=2.68u as=0 ps=0 w=1u l=1u
X3382 VSS.t2881 VDD VSS.t2880 VSS.t412 sg13_lv_nmos ad=0.1428p pd=1.52u as=0 ps=0 w=0.42u l=1u
X3383 VDD VSS.t2168 VDD VDD sg13_lv_pmos ad=0.19p pd=1.38u as=0 ps=0 w=1u l=1u
X3384 VSS.t3 a_16055_16301# a_16055_16301# VSS.t320 sg13_lv_nmos ad=5.24677p pd=34.365u as=0.111p ps=1.34u w=0.3u l=0.13u
X3385 VSS.t6 a_21070_15423# sg13g2_dlygate4sd3_1_11.X VSS.t285 sg13_lv_nmos ad=0.1426p pd=1.16u as=0.2516p ps=2.16u w=0.74u l=0.13u
X3386 VDD VSS.t1400 VDD VDD sg13_lv_pmos ad=0.19p pd=1.38u as=0 ps=0 w=1u l=1u
X3387 VDD VSS.t1349 VDD VDD sg13_lv_pmos ad=0.19p pd=1.38u as=0 ps=0 w=1u l=1u
X3388 VDD VSS.t2855 VDD VDD sg13_lv_pmos ad=0.19p pd=1.38u as=0 ps=0 w=1u l=1u
X3389 VSS.t2548 VDD VSS.t2547 VSS.t2546 sg13_lv_nmos ad=0.1428p pd=1.52u as=0 ps=0 w=0.42u l=1u
X3390 VSS.t1971 VDD VSS.t1970 VSS.t1969 sg13_lv_nmos ad=0.1428p pd=1.52u as=0 ps=0 w=0.42u l=1u
X3391 VDD a_7822_13911# sg13g2_xnor2_1_2.A VDD sg13_lv_pmos ad=0.2254p pd=1.53u as=0.4256p ps=3u w=1.12u l=0.13u
X3392 VDD VSS.t1811 VDD VDD sg13_lv_pmos ad=0.19p pd=1.38u as=0 ps=0 w=1u l=1u
X3393 VDD VSS.t3279 VDD VDD sg13_lv_pmos ad=0.34p pd=2.68u as=0 ps=0 w=1u l=1u
X3394 VSS.t823 VDD VSS.t139 VSS.t824 sg13_lv_nmos ad=79.8f pd=0.8u as=0 ps=0 w=0.42u l=1u
X3395 VSS.t731 VDD VSS.t734 VSS.t863 sg13_lv_nmos ad=79.8f pd=0.8u as=0 ps=0 w=0.42u l=1u
X3396 VSS.t2828 VDD VSS.t2827 VSS.t412 sg13_lv_nmos ad=0.1428p pd=1.52u as=0 ps=0 w=0.42u l=1u
X3397 VSS.t6 sg13g2_or3_1_2.X a_20705_15260# VSS.t9 sg13_lv_nmos ad=0.2516p pd=2.16u as=0.1406p ps=1.12u w=0.74u l=0.13u
X3398 VSS.t1015 VDD VSS.t1017 VSS.t1016 sg13_lv_nmos ad=79.8f pd=0.8u as=0 ps=0 w=0.42u l=1u
X3399 VDD VSS.t1816 VDD VDD sg13_lv_pmos ad=0.19p pd=1.38u as=0 ps=0 w=1u l=1u
X3400 VSS.t1774 VDD VSS.t1773 VSS.t1772 sg13_lv_nmos ad=0.1428p pd=1.52u as=0 ps=0 w=0.42u l=1u
X3401 VSS.t3300 VDD VSS.t3299 VSS.t3298 sg13_lv_nmos ad=0.1428p pd=1.52u as=0 ps=0 w=0.42u l=1u
X3402 VSS.t2613 VDD VSS.t2615 VSS.t2614 sg13_lv_nmos ad=79.8f pd=0.8u as=0 ps=0 w=0.42u l=1u
X3403 VDD VSS.t2500 VDD VDD sg13_lv_pmos ad=0.19p pd=1.38u as=0 ps=0 w=1u l=1u
X3404 a_22508_15960# sg13g2_dfrbpq_1_3.Q VSS.t311 VSS.t310 sg13_lv_nmos ad=0.187p pd=1.78u as=0.14875p ps=1.16u w=0.55u l=0.13u
X3405 a_7631_14845# a_6789_14495# a_7537_14845# VSS.t113 sg13_lv_nmos ad=0.12665p pd=1.145u as=0.1428p ps=1.52u w=0.42u l=0.13u
X3406 VSS.t955 VDD VSS.t954 VSS.t953 sg13_lv_nmos ad=0.1428p pd=1.52u as=0 ps=0 w=0.42u l=1u
X3407 VSS.t2768 VDD VSS.t2768 VSS.t412 sg13_lv_nmos ad=0.1428p pd=1.52u as=0 ps=0 w=0.42u l=1u
X3408 VDD VSS.t2818 VDD VDD sg13_lv_pmos ad=0.19p pd=1.38u as=0 ps=0 w=1u l=1u
X3409 VSS.t2518 VDD VSS.t2520 VSS.t2519 sg13_lv_nmos ad=79.8f pd=0.8u as=0 ps=0 w=0.42u l=1u
X3410 VSS.t2081 VDD VSS.t2080 VSS.t2079 sg13_lv_nmos ad=0.1428p pd=1.52u as=0 ps=0 w=0.42u l=1u
X3411 VSS.t890 VDD VSS.t892 VSS.t891 sg13_lv_nmos ad=79.8f pd=0.8u as=0 ps=0 w=0.42u l=1u
X3412 VSS.t2862 VDD VSS.t2863 VSS.t412 sg13_lv_nmos ad=79.8f pd=0.8u as=0 ps=0 w=0.42u l=1u
X3413 VSS.t960 VDD VSS.t962 VSS.t961 sg13_lv_nmos ad=79.8f pd=0.8u as=0 ps=0 w=0.42u l=1u
X3414 VSS.t1358 VDD VSS.t1357 VSS.t377 sg13_lv_nmos ad=0.1428p pd=1.52u as=0 ps=0 w=0.42u l=1u
X3415 VDD VSS.t1606 VDD VDD sg13_lv_pmos ad=0.19p pd=1.38u as=0 ps=0 w=1u l=1u
X3416 VDD VSS.t3074 VDD VDD sg13_lv_pmos ad=0.34p pd=2.68u as=0 ps=0 w=1u l=1u
X3417 a_21562_15960# sg13g2_a21oi_1_1.Y VDD VDD sg13_lv_pmos ad=0.1428p pd=1.52u as=0.1523p ps=1.38u w=0.42u l=0.13u
X3418 VDD VSS.t758 VDD VDD sg13_lv_pmos ad=0.34p pd=2.68u as=0 ps=0 w=1u l=1u
X3419 VDD VSS.t2185 VDD VDD sg13_lv_pmos ad=0.34p pd=2.68u as=0 ps=0 w=1u l=1u
X3420 VDD a_15022_14484# sg13g2_buf_16_2.A VDD sg13_lv_pmos ad=0.2128p pd=1.5u as=0.2128p ps=1.5u w=1.12u l=0.13u
X3421 a_17604_14488# a_18123_14495# a_18863_14845# VSS.t25 sg13_lv_nmos ad=0.3473p pd=2.71u as=0.12665p ps=1.145u w=0.74u l=0.13u
X3422 VSS.t1684 VDD VSS.t1686 VSS.t1685 sg13_lv_nmos ad=79.8f pd=0.8u as=0 ps=0 w=0.42u l=1u
X3423 VSS.t90 sg13g2_or3_1_1.X a_25025_16344# VSS.t89 sg13_lv_nmos ad=0.2516p pd=2.16u as=0.1406p ps=1.12u w=0.74u l=0.13u
X3424 VDD VSS.t527 VDD VDD sg13_lv_pmos ad=0.19p pd=1.38u as=0 ps=0 w=1u l=1u
X3425 VDD VSS.t2555 VDD VDD sg13_lv_pmos ad=0.19p pd=1.38u as=0 ps=0 w=1u l=1u
X3426 VSS.t1362 VDD VSS.t1362 VSS.t377 sg13_lv_nmos ad=0.1428p pd=1.52u as=0 ps=0 w=0.42u l=1u
X3427 VDD VSS.t1796 VDD VDD sg13_lv_pmos ad=0.19p pd=1.38u as=0 ps=0 w=1u l=1u
X3428 VDD VSS.t1988 VDD VDD sg13_lv_pmos ad=0.19p pd=1.38u as=0 ps=0 w=1u l=1u
X3429 VSS.t2161 VDD VSS.t2163 VSS.t2162 sg13_lv_nmos ad=79.8f pd=0.8u as=0 ps=0 w=0.42u l=1u
X3430 VSS.t985 VDD VSS.t984 VSS.t983 sg13_lv_nmos ad=0.1428p pd=1.52u as=0 ps=0 w=0.42u l=1u
X3431 VSS.t1284 VDD VSS.t1283 VSS.t377 sg13_lv_nmos ad=0.1428p pd=1.52u as=0 ps=0 w=0.42u l=1u
X3432 VDD VSS.t2085 VDD VDD sg13_lv_pmos ad=0.34p pd=2.68u as=0 ps=0 w=1u l=1u
X3433 a_17219_16265# sg13g2_dlygate4sd3_1_6.X VSS.t150 VSS.t322 sg13_lv_nmos ad=0.198p pd=1.27u as=0.13395p ps=1.12u w=0.55u l=0.13u
X3434 VSS.t1324 VDD VSS.t1325 VSS.t377 sg13_lv_nmos ad=79.8f pd=0.8u as=0 ps=0 w=0.42u l=1u
X3435 VSS.t3285 VDD VSS.t3284 VSS.t3283 sg13_lv_nmos ad=0.1428p pd=1.52u as=0 ps=0 w=0.42u l=1u
X3436 VSS.t2196 VDD VSS.t2195 VSS.t2194 sg13_lv_nmos ad=0.1428p pd=1.52u as=0 ps=0 w=0.42u l=1u
X3437 VSS.t752 VDD VSS.t752 VSS.t753 sg13_lv_nmos ad=79.8f pd=0.8u as=0 ps=0 w=0.42u l=1u
X3438 VDD VSS.t1162 VDD VDD sg13_lv_pmos ad=0.19p pd=1.38u as=0 ps=0 w=1u l=1u
X3439 sg13g2_buf_1_10.X a_1192_9948# VDD VDD sg13_lv_pmos ad=0.42p pd=2.99u as=0.2114p ps=1.54u w=1.12u l=0.13u
X3440 VDD VSS.t1768 VDD VDD sg13_lv_pmos ad=0.34p pd=2.68u as=0 ps=0 w=1u l=1u
X3441 VSS.t766 VDD VSS.t769 VSS.t885 sg13_lv_nmos ad=79.8f pd=0.8u as=0 ps=0 w=0.42u l=1u
X3442 VSS.t1288 VDD VSS.t1288 VSS.t377 sg13_lv_nmos ad=0.1428p pd=1.52u as=0 ps=0 w=0.42u l=1u
X3443 VDD VSS.t1823 VDD VDD sg13_lv_pmos ad=0.34p pd=2.68u as=0 ps=0 w=1u l=1u
X3444 VSS.t1674 VDD VSS.t1676 VSS.t1675 sg13_lv_nmos ad=79.8f pd=0.8u as=0 ps=0 w=0.42u l=1u
X3445 VSS.t2568 VDD VSS.t2567 VSS.t2566 sg13_lv_nmos ad=0.1428p pd=1.52u as=0 ps=0 w=0.42u l=1u
X3446 VDD VSS.t2452 VDD VDD sg13_lv_pmos ad=0.34p pd=2.68u as=0 ps=0 w=1u l=1u
X3447 a_27417_14607# a_26475_14495# a_27215_14845# VDD sg13_lv_pmos ad=93.45f pd=0.865u as=0.2048p ps=1.63u w=0.42u l=0.13u
X3448 VDD VSS.t243 VDD VDD sg13_lv_pmos ad=0.34p pd=2.68u as=0 ps=0 w=1u l=1u
X3449 VSS.t1045 VDD VSS.t1047 VSS.t1046 sg13_lv_nmos ad=79.8f pd=0.8u as=0 ps=0 w=0.42u l=1u
X3450 VDD VSS.t912 VDD VDD sg13_lv_pmos ad=0.19p pd=1.38u as=0 ps=0 w=1u l=1u
X3451 VSS.t2749 VDD VSS.t2750 VSS.t412 sg13_lv_nmos ad=79.8f pd=0.8u as=0 ps=0 w=0.42u l=1u
X3452 VSS.t460 VDD VSS.t460 VSS.t461 sg13_lv_nmos ad=79.8f pd=0.8u as=0 ps=0 w=0.42u l=1u
X3453 VDD VSS.t1626 VDD VDD sg13_lv_pmos ad=0.19p pd=1.38u as=0 ps=0 w=1u l=1u
X3454 VDD VSS.t2205 VDD VDD sg13_lv_pmos ad=0.34p pd=2.68u as=0 ps=0 w=1u l=1u
X3455 VSS.t1669 VDD VSS.t1671 VSS.t1670 sg13_lv_nmos ad=79.8f pd=0.8u as=0 ps=0 w=0.42u l=1u
X3456 VSS.t2026 VDD VSS.t2025 VSS.t2024 sg13_lv_nmos ad=0.1428p pd=1.52u as=0 ps=0 w=0.42u l=1u
X3457 VDD VSS.t1424 VDD VDD sg13_lv_pmos ad=0.34p pd=2.68u as=0 ps=0 w=1u l=1u
X3458 VSS.t1308 VDD VSS.t1307 VSS.t377 sg13_lv_nmos ad=0.1428p pd=1.52u as=0 ps=0 w=0.42u l=1u
X3459 VSS.t2873 VDD VSS.t2872 VSS.t412 sg13_lv_nmos ad=0.1428p pd=1.52u as=0 ps=0 w=0.42u l=1u
X3460 VDD VSS.t2750 VDD VDD sg13_lv_pmos ad=0.34p pd=2.68u as=0 ps=0 w=1u l=1u
X3461 VSS.t302 VDD VSS.t686 VSS.t685 sg13_lv_nmos ad=79.8f pd=0.8u as=0 ps=0 w=0.42u l=1u
X3462 VDD VSS.t1340 VDD VDD sg13_lv_pmos ad=0.19p pd=1.38u as=0 ps=0 w=1u l=1u
X3463 VDD VSS.t2847 VDD VDD sg13_lv_pmos ad=0.19p pd=1.38u as=0 ps=0 w=1u l=1u
X3464 VSS.t1376 VDD VSS.t1375 VSS.t377 sg13_lv_nmos ad=0.1428p pd=1.52u as=0 ps=0 w=0.42u l=1u
X3465 VSS.t2533 VDD VSS.t2532 VSS.t2531 sg13_lv_nmos ad=0.1428p pd=1.52u as=0 ps=0 w=0.42u l=1u
X3466 VSS.t1015 VDD VSS.t1017 VSS.t1016 sg13_lv_nmos ad=79.8f pd=0.8u as=0 ps=0 w=0.42u l=1u
X3467 VSS.t1824 VDD VSS.t1826 VSS.t1825 sg13_lv_nmos ad=79.8f pd=0.8u as=0 ps=0 w=0.42u l=1u
X3468 VDD sg13g2_dfrbpq_1_3.Q sg13g2_or3_1_2.C VDD sg13_lv_pmos ad=0.3808p pd=2.92u as=0.2128p ps=1.5u w=1.12u l=0.13u
X3469 VSS.t618 VDD VSS.t617 VSS.t33 sg13_lv_nmos ad=0.1428p pd=1.52u as=0 ps=0 w=0.42u l=1u
X3470 sg13g2_dfrbpq_1_2.CLK a_12020_15202# VSS.t50 VSS.t55 sg13_lv_nmos ad=0.1406p pd=1.12u as=0.1406p ps=1.12u w=0.74u l=0.13u
X3471 VDD VSS.t1129 VDD VDD sg13_lv_pmos ad=0.34p pd=2.68u as=0 ps=0 w=1u l=1u
X3472 VDD sg13g2_xnor2_1_1.A a_16044_15424# VDD sg13_lv_pmos ad=0.4536p pd=2.76u as=0.1596p ps=1.22u w=0.84u l=0.13u
X3473 VSS.t955 VDD VSS.t954 VSS.t953 sg13_lv_nmos ad=0.1428p pd=1.52u as=0 ps=0 w=0.42u l=1u
X3474 VSS.t2598 VDD VSS.t2600 VSS.t2599 sg13_lv_nmos ad=79.8f pd=0.8u as=0 ps=0 w=0.42u l=1u
X3475 VDD VSS.t1666 VDD VDD sg13_lv_pmos ad=0.19p pd=1.38u as=0 ps=0 w=1u l=1u
X3476 VSS.t2871 VDD VSS.t2870 VSS.t412 sg13_lv_nmos ad=0.1428p pd=1.52u as=0 ps=0 w=0.42u l=1u
X3477 VDD VSS.t2000 VDD VDD sg13_lv_pmos ad=0.34p pd=2.68u as=0 ps=0 w=1u l=1u
X3478 VDD VSS.t1353 VDD VDD sg13_lv_pmos ad=0.19p pd=1.38u as=0 ps=0 w=1u l=1u
X3479 VDD a_19120_14726# a_19065_14607# VDD sg13_lv_pmos ad=2.42015p pd=15.68u as=93.45f ps=0.865u w=0.42u l=0.13u
X3480 a_24841_13726# sg13g2_or3_1_1.B VSS.t183 VSS.t307 sg13_lv_nmos ad=0.198p pd=1.27u as=0.1045p ps=0.93u w=0.55u l=0.13u
X3481 VSS.t890 VDD VSS.t892 VSS.t891 sg13_lv_nmos ad=79.8f pd=0.8u as=0 ps=0 w=0.42u l=1u
X3482 VDD VSS.t1067 VDD VDD sg13_lv_pmos ad=0.19p pd=1.38u as=0 ps=0 w=1u l=1u
X3483 VSS.t1317 VDD VSS.t1316 VSS.t377 sg13_lv_nmos ad=0.1428p pd=1.52u as=0 ps=0 w=0.42u l=1u
X3484 sg13g2_or3_1_1.C sg13g2_dfrbpq_1_6.Q VDD VDD sg13_lv_pmos ad=0.2128p pd=1.5u as=0.2128p ps=1.5u w=1.12u l=0.13u
X3485 a_23378_15242# sg13g2_dfrbpq_1_2.Q VSS.t31 VSS.t28 sg13_lv_nmos ad=0.1406p pd=1.12u as=0.2886p ps=2.26u w=0.74u l=0.13u
X3486 VSS.t2759 VDD VSS.t2759 VSS.t412 sg13_lv_nmos ad=0.1428p pd=1.52u as=0 ps=0 w=0.42u l=1u
X3487 VDD VSS.t2810 VDD VDD sg13_lv_pmos ad=0.19p pd=1.38u as=0 ps=0 w=1u l=1u
X3488 VSS.t3155 VDD VSS.t3154 VSS.t3153 sg13_lv_nmos ad=0.1428p pd=1.52u as=0 ps=0 w=0.42u l=1u
X3489 VDD sg13g2_dfrbpq_1_0.RESET_B a_2630_15234# VDD sg13_lv_pmos ad=0.36237p pd=2.605u as=79.8f ps=0.8u w=0.42u l=0.13u
X3490 VDD VSS.t504 VDD VDD sg13_lv_pmos ad=0.34p pd=2.68u as=0 ps=0 w=1u l=1u
X3491 VDD VSS.t614 VDD VDD sg13_lv_pmos ad=0.34p pd=2.68u as=0 ps=0 w=1u l=1u
X3492 VSS.t1619 VDD VSS.t1621 VSS.t1620 sg13_lv_nmos ad=79.8f pd=0.8u as=0 ps=0 w=0.42u l=1u
X3493 VSS.t1849 VDD VSS.t1848 VSS.t1847 sg13_lv_nmos ad=0.1428p pd=1.52u as=0 ps=0 w=0.42u l=1u
X3494 VSS.t2011 VDD VSS.t2010 VSS.t2009 sg13_lv_nmos ad=0.1428p pd=1.52u as=0 ps=0 w=0.42u l=1u
X3495 VSS.t393 VDD VSS.t384 VSS.t830 sg13_lv_nmos ad=0.1428p pd=1.52u as=0 ps=0 w=0.42u l=1u
X3496 VDD VSS.t1631 VDD VDD sg13_lv_pmos ad=0.19p pd=1.38u as=0 ps=0 w=1u l=1u
X3497 VDD VSS.t2540 VDD VDD sg13_lv_pmos ad=0.19p pd=1.38u as=0 ps=0 w=1u l=1u
X3498 VSS.t985 VDD VSS.t984 VSS.t983 sg13_lv_nmos ad=0.1428p pd=1.52u as=0 ps=0 w=0.42u l=1u
X3499 VSS.t1390 VDD VSS.t1389 VSS.t377 sg13_lv_nmos ad=0.1428p pd=1.52u as=0 ps=0 w=0.42u l=1u
X3500 VDD VSS.t1352 VDD VDD sg13_lv_pmos ad=0.19p pd=1.38u as=0 ps=0 w=1u l=1u
X3501 VDD VSS.t2858 VDD VDD sg13_lv_pmos ad=0.19p pd=1.38u as=0 ps=0 w=1u l=1u
X3502 VSS.t2553 VDD VSS.t2552 VSS.t2551 sg13_lv_nmos ad=0.1428p pd=1.52u as=0 ps=0 w=0.42u l=1u
X3503 VDD VSS.t2138 VDD VDD sg13_lv_pmos ad=0.19p pd=1.38u as=0 ps=0 w=1u l=1u
X3504 VDD sg13g2_dlygate4sd3_1_6.X sg13g2_dlygate4sd3_1_5.A VDD sg13_lv_pmos ad=0.3808p pd=2.92u as=0.2128p ps=1.5u w=1.12u l=0.15u
X3505 VDD VSS.t3249 VDD VDD sg13_lv_pmos ad=0.34p pd=2.68u as=0 ps=0 w=1u l=1u
X3506 VDD VSS.t2492 VDD VDD sg13_lv_pmos ad=0.34p pd=2.68u as=0 ps=0 w=1u l=1u
X3507 VDD VSS.t1973 VDD VDD sg13_lv_pmos ad=0.19p pd=1.38u as=0 ps=0 w=1u l=1u
X3508 VDD VSS.t1638 VDD VDD sg13_lv_pmos ad=0.34p pd=2.68u as=0 ps=0 w=1u l=1u
X3509 VSS.t510 VDD VSS.t12 VSS.t511 sg13_lv_nmos ad=79.8f pd=0.8u as=0 ps=0 w=0.42u l=1u
X3510 a_21060_14488# a_21034_14452# VSS.t6 VSS.t98 sg13_lv_nmos ad=0.2516p pd=2.16u as=0.1626p ps=1.415u w=0.74u l=0.13u
X3511 VDD VSS.t1821 VDD VDD sg13_lv_pmos ad=0.19p pd=1.38u as=0 ps=0 w=1u l=1u
X3512 VSS.t2101 VDD VSS.t2100 VSS.t2099 sg13_lv_nmos ad=0.1428p pd=1.52u as=0 ps=0 w=0.42u l=1u
X3513 sg13g2_dfrbpq_1_2.CLK a_12020_15202# VSS.t50 VSS.t51 sg13_lv_nmos ad=0.1406p pd=1.12u as=0.1406p ps=1.12u w=0.74u l=0.13u
X3514 VSS.t1155 VDD VSS.t1154 VSS.t1153 sg13_lv_nmos ad=0.1428p pd=1.52u as=0 ps=0 w=0.42u l=1u
X3515 VDD VSS.t2505 VDD VDD sg13_lv_pmos ad=0.19p pd=1.38u as=0 ps=0 w=1u l=1u
X3516 VSS.t24 a_15022_14484# sg13g2_buf_16_2.A VSS.t237 sg13_lv_nmos ad=0.1406p pd=1.12u as=0.1406p ps=1.12u w=0.74u l=0.13u
X3517 VDD VSS.t1333 VDD VDD sg13_lv_pmos ad=0.34p pd=2.68u as=0 ps=0 w=1u l=1u
X3518 VDD VSS.t700 VDD VDD sg13_lv_pmos ad=0.19p pd=1.38u as=0 ps=0 w=1u l=1u
X3519 VSS.t1045 VDD VSS.t1047 VSS.t1046 sg13_lv_nmos ad=79.8f pd=0.8u as=0 ps=0 w=0.42u l=1u
X3520 VDD VSS.t1019 VDD VDD sg13_lv_pmos ad=0.34p pd=2.68u as=0 ps=0 w=1u l=1u
X3521 VSS.t1659 VDD VSS.t1661 VSS.t1660 sg13_lv_nmos ad=79.8f pd=0.8u as=0 ps=0 w=0.42u l=1u
X3522 VSS.t1839 VDD VSS.t1838 VSS.t1837 sg13_lv_nmos ad=0.1428p pd=1.52u as=0 ps=0 w=0.42u l=1u
X3523 VSS.t2772 VDD VSS.t2771 VSS.t412 sg13_lv_nmos ad=0.1428p pd=1.52u as=0 ps=0 w=0.42u l=1u
X3524 a_6682_13690# sg13g2_dlygate4sd3_1_0.A VSS.t35 VSS.t115 sg13_lv_nmos ad=0.1428p pd=1.52u as=79.8f ps=0.8u w=0.42u l=0.13u
X3525 VDD VSS.t2821 VDD VDD sg13_lv_pmos ad=0.19p pd=1.38u as=0 ps=0 w=1u l=1u
X3526 VSS.t603 VDD VSS.t602 VSS.t33 sg13_lv_nmos ad=0.1428p pd=1.52u as=0 ps=0 w=0.42u l=1u
X3527 VSS.t2865 VDD VSS.t2866 VSS.t412 sg13_lv_nmos ad=79.8f pd=0.8u as=0 ps=0 w=0.42u l=1u
X3528 VSS.t2051 VDD VSS.t2050 VSS.t2049 sg13_lv_nmos ad=0.1428p pd=1.52u as=0 ps=0 w=0.42u l=1u
X3529 VDD VSS.t539 VDD VDD sg13_lv_pmos ad=0.34p pd=2.68u as=0 ps=0 w=1u l=1u
X3530 VDD VSS.t589 VDD VDD sg13_lv_pmos ad=0.19p pd=1.38u as=0 ps=0 w=1u l=1u
X3531 VDD VSS.t1611 VDD VDD sg13_lv_pmos ad=0.19p pd=1.38u as=0 ps=0 w=1u l=1u
X3532 VDD VSS.t3079 VDD VDD sg13_lv_pmos ad=0.34p pd=2.68u as=0 ps=0 w=1u l=1u
X3533 VDD a_19438_13726# sg13g2_buf_16_2.X VDD sg13_lv_pmos ad=0.2128p pd=1.5u as=0.2128p ps=1.5u w=1.12u l=0.13u
X3534 VDD VSS.t1370 VDD VDD sg13_lv_pmos ad=0.19p pd=1.38u as=0 ps=0 w=1u l=1u
X3535 VSS.t1834 VDD VSS.t1833 VSS.t1832 sg13_lv_nmos ad=0.1428p pd=1.52u as=0 ps=0 w=0.42u l=1u
X3536 VSS.t2583 VDD VSS.t2585 VSS.t2584 sg13_lv_nmos ad=79.8f pd=0.8u as=0 ps=0 w=0.42u l=1u
X3537 VDD VSS.t894 VDD VDD sg13_lv_pmos ad=0.34p pd=2.68u as=0 ps=0 w=1u l=1u
X3538 VSS.t1443 VDD VSS.t1444 VSS.t377 sg13_lv_nmos ad=79.8f pd=0.8u as=0 ps=0 w=0.42u l=1u
X3539 VDD VSS.t2560 VDD VDD sg13_lv_pmos ad=0.19p pd=1.38u as=0 ps=0 w=1u l=1u
X3540 VSS.t851 VDD VSS.t853 VSS.t852 sg13_lv_nmos ad=79.8f pd=0.8u as=0 ps=0 w=0.42u l=1u
X3541 VDD VSS.t1435 VDD VDD sg13_lv_pmos ad=0.34p pd=2.68u as=0 ps=0 w=1u l=1u
X3542 VDD VSS.t3092 VDD VDD sg13_lv_pmos ad=0.19p pd=1.38u as=0 ps=0 w=1u l=1u
X3543 VSS.t2166 VDD VSS.t2168 VSS.t2167 sg13_lv_nmos ad=79.8f pd=0.8u as=0 ps=0 w=0.42u l=1u
X3544 VSS.t76 a_27664_13942# a_27313_13799# VSS.t408 sg13_lv_nmos ad=79.8f pd=0.8u as=0.1428p ps=1.52u w=0.42u l=0.13u
X3545 VSS.t1809 VDD VSS.t1811 VSS.t1810 sg13_lv_nmos ad=79.8f pd=0.8u as=0 ps=0 w=0.42u l=1u
X3546 VDD VSS.t2090 VDD VDD sg13_lv_pmos ad=0.34p pd=2.68u as=0 ps=0 w=1u l=1u
X3547 VSS.t46 VDD VSS.t634 VSS.t633 sg13_lv_nmos ad=0.1428p pd=1.52u as=0 ps=0 w=0.42u l=1u
X3548 VDD VSS.t147 VDD VDD sg13_lv_pmos ad=0.34p pd=2.68u as=0 ps=0 w=1u l=1u
X3549 VDD VSS.t598 VDD VDD sg13_lv_pmos ad=0.19p pd=1.38u as=0 ps=0 w=1u l=1u
X3550 VDD VSS.t1312 VDD VDD sg13_lv_pmos ad=0.19p pd=1.38u as=0 ps=0 w=1u l=1u
X3551 VSS.t2796 VDD VSS.t2795 VSS.t412 sg13_lv_nmos ad=0.1428p pd=1.52u as=0 ps=0 w=0.42u l=1u
X3552 VDD VSS.t1773 VDD VDD sg13_lv_pmos ad=0.34p pd=2.68u as=0 ps=0 w=1u l=1u
X3553 a_25094_15238# a_24824_15238# VDD VDD sg13_lv_pmos ad=0.34p pd=2.68u as=0.1523p ps=1.38u w=1u l=0.5u
X3554 VSS.t24 a_15022_14484# sg13g2_buf_16_2.A VSS.t233 sg13_lv_nmos ad=0.1406p pd=1.12u as=0.1406p ps=1.12u w=0.74u l=0.13u
X3555 a_6714_12972# sg13g2_xnor2_1_2.B sg13g2_dlygate4sd3_1_0.A VDD sg13_lv_pmos ad=0.1428p pd=1.375u as=0.2408p ps=1.55u w=1.12u l=0.13u
X3556 VDD VSS.t1379 VDD VDD sg13_lv_pmos ad=0.19p pd=1.38u as=0 ps=0 w=1u l=1u
X3557 VDD VSS.t1828 VDD VDD sg13_lv_pmos ad=0.34p pd=2.68u as=0 ps=0 w=1u l=1u
X3558 VDD VSS.t1985 VDD VDD sg13_lv_pmos ad=0.34p pd=2.68u as=0 ps=0 w=1u l=1u
X3559 VSS.t1679 VDD VSS.t1681 VSS.t1680 sg13_lv_nmos ad=79.8f pd=0.8u as=0 ps=0 w=0.42u l=1u
X3560 VSS.t3205 VDD VSS.t3207 VSS.t3206 sg13_lv_nmos ad=79.8f pd=0.8u as=0 ps=0 w=0.42u l=1u
X3561 VSS.t2413 VDD VSS.t2415 VSS.t2414 sg13_lv_nmos ad=79.8f pd=0.8u as=0 ps=0 w=0.42u l=1u
X3562 a_6575_13342# sg13g2_xnor2_1_2.A VSS.t35 VSS.t109 sg13_lv_nmos ad=0.2516p pd=2.16u as=0.1898p ps=1.36u w=0.74u l=0.13u
X3563 a_26244_14909# a_26475_14495# a_25930_14452# VSS.t32 sg13_lv_nmos ad=0.2373p pd=1.97u as=79.8f ps=0.8u w=0.42u l=0.13u
X3564 VDD VSS.t2898 VDD VDD sg13_lv_pmos ad=0.34p pd=2.68u as=0 ps=0 w=1u l=1u
X3565 VSS.t980 VDD VSS.t982 VSS.t981 sg13_lv_nmos ad=79.8f pd=0.8u as=0 ps=0 w=0.42u l=1u
X3566 VDD VSS.t2517 VDD VDD sg13_lv_pmos ad=0.34p pd=2.68u as=0 ps=0 w=1u l=1u
X3567 a_25670_14922# sg13g2_dfrbpq_1_7.D VDD VDD sg13_lv_pmos ad=79.8f pd=0.8u as=0.1428p ps=1.52u w=0.42u l=0.13u
X3568 VDD VSS.t1049 VDD VDD sg13_lv_pmos ad=0.34p pd=2.68u as=0 ps=0 w=1u l=1u
X3569 VSS.t1425 VDD VSS.t1424 VSS.t377 sg13_lv_nmos ad=0.1428p pd=1.52u as=0 ps=0 w=0.42u l=1u
X3570 VDD VSS.t22 VDD VDD sg13_lv_pmos ad=0.34p pd=2.68u as=0 ps=0 w=1u l=1u
X3571 VSS.t1996 VDD VSS.t1995 VSS.t1994 sg13_lv_nmos ad=0.1428p pd=1.52u as=0 ps=0 w=0.42u l=1u
X3572 VDD VSS.t2753 VDD VDD sg13_lv_pmos ad=0.34p pd=2.68u as=0 ps=0 w=1u l=1u
X3573 a_24169_14508# sg13g2_or3_1_2.B VSS.t181 VSS.t30 sg13_lv_nmos ad=0.198p pd=1.27u as=0.1045p ps=0.93u w=0.55u l=0.13u
X3574 VDD VSS.t1343 VDD VDD sg13_lv_pmos ad=0.19p pd=1.38u as=0 ps=0 w=1u l=1u
X3575 VDD VSS.t2850 VDD VDD sg13_lv_pmos ad=0.19p pd=1.38u as=0 ps=0 w=1u l=1u
X3576 VDD VSS.t2123 VDD VDD sg13_lv_pmos ad=0.19p pd=1.38u as=0 ps=0 w=1u l=1u
X3577 VSS.t183 VDD VSS.t183 VSS.t842 sg13_lv_nmos ad=0.1428p pd=1.52u as=0 ps=0 w=0.42u l=1u
X3578 VDD VSS.t2477 VDD VDD sg13_lv_pmos ad=0.34p pd=2.68u as=0 ps=0 w=1u l=1u
X3579 VSS.t2538 VDD VSS.t2537 VSS.t2536 sg13_lv_nmos ad=0.1428p pd=1.52u as=0 ps=0 w=0.42u l=1u
X3580 VDD VSS.t695 VDD VDD sg13_lv_pmos ad=0.34p pd=2.68u as=0 ps=0 w=1u l=1u
X3581 VDD VSS.t987 VDD VDD sg13_lv_pmos ad=0.19p pd=1.38u as=0 ps=0 w=1u l=1u
X3582 VDD VSS.t1623 VDD VDD sg13_lv_pmos ad=0.34p pd=2.68u as=0 ps=0 w=1u l=1u
X3583 VSS.t1794 VDD VSS.t1796 VSS.t1795 sg13_lv_nmos ad=79.8f pd=0.8u as=0 ps=0 w=0.42u l=1u
X3584 VSS.t1155 VDD VSS.t1154 VSS.t1153 sg13_lv_nmos ad=0.1428p pd=1.52u as=0 ps=0 w=0.42u l=1u
X3585 VSS.t1704 VDD VSS.t1703 VSS.t1702 sg13_lv_nmos ad=0.1428p pd=1.52u as=0 ps=0 w=0.42u l=1u
X3586 VDD VSS.t1806 VDD VDD sg13_lv_pmos ad=0.19p pd=1.38u as=0 ps=0 w=1u l=1u
X3587 VDD VSS.t302 VDD VDD sg13_lv_pmos ad=0.19p pd=1.38u as=0 ps=0 w=1u l=1u
X3588 VDD VSS.t743 VDD VDD sg13_lv_pmos ad=0.34p pd=2.68u as=0 ps=0 w=1u l=1u
X3589 a_6996_13320# sg13g2_xnor2_1_2.B a_6540_13238# VSS.t418 sg13_lv_nmos ad=78.39999f pd=0.885u as=0.2176p ps=1.96u w=0.64u l=0.13u
X3590 VDD VSS.t949 VDD VDD sg13_lv_pmos ad=0.34p pd=2.68u as=0 ps=0 w=1u l=1u
X3591 sg13g2_buf_1_0.X a_1192_3900# VSS.t413 VSS.t412 sg13_lv_nmos ad=0.2886p pd=2.26u as=0.14875p ps=1.16u w=0.74u l=0.13u
X3592 VSS.t734 VDD VSS.t737 VSS.t865 sg13_lv_nmos ad=79.8f pd=0.8u as=0 ps=0 w=0.42u l=1u
X3593 VSS.t2603 VDD VSS.t2605 VSS.t2604 sg13_lv_nmos ad=79.8f pd=0.8u as=0 ps=0 w=0.42u l=1u
X3594 VDD VSS.t700 VDD VDD sg13_lv_pmos ad=0.19p pd=1.38u as=0 ps=0 w=1u l=1u
X3595 VDD VSS.t3139 VDD VDD sg13_lv_pmos ad=0.34p pd=2.68u as=0 ps=0 w=1u l=1u
X3596 VDD VSS.t2005 VDD VDD sg13_lv_pmos ad=0.34p pd=2.68u as=0 ps=0 w=1u l=1u
X3597 VDD VSS.t2178 VDD VDD sg13_lv_pmos ad=0.19p pd=1.38u as=0 ps=0 w=1u l=1u
X3598 VSS.t1824 VDD VSS.t1823 VSS.t1822 sg13_lv_nmos ad=0.1428p pd=1.52u as=0 ps=0 w=0.42u l=1u
X3599 VDD VSS.t1676 VDD VDD sg13_lv_pmos ad=0.19p pd=1.38u as=0 ps=0 w=1u l=1u
X3600 VSS.t2762 VDD VSS.t2762 VSS.t412 sg13_lv_nmos ad=0.1428p pd=1.52u as=0 ps=0 w=0.42u l=1u
X3601 VDD VSS.t2813 VDD VDD sg13_lv_pmos ad=0.19p pd=1.38u as=0 ps=0 w=1u l=1u
X3602 VSS.t19 a_8582_15238# a_8694_15302# VSS.t125 sg13_lv_nmos ad=0.1426p pd=1.16u as=0.1428p ps=1.52u w=0.42u l=0.5u
X3603 VDD VSS.t1002 VDD VDD sg13_lv_pmos ad=0.19p pd=1.38u as=0 ps=0 w=1u l=1u
X3604 VSS.t3125 VDD VSS.t3124 VSS.t3123 sg13_lv_nmos ad=0.1428p pd=1.52u as=0 ps=0 w=0.42u l=1u
X3605 VSS.t1624 VDD VSS.t1626 VSS.t1625 sg13_lv_nmos ad=79.8f pd=0.8u as=0 ps=0 w=0.42u l=1u
X3606 VSS.t895 VDD VSS.t897 VSS.t896 sg13_lv_nmos ad=79.8f pd=0.8u as=0 ps=0 w=0.42u l=1u
X3607 a_18552_15552# sg13g2_xnor2_1_1.A VDD VDD sg13_lv_pmos ad=0.2128p pd=1.5u as=0.3808p ps=2.92u w=1.12u l=0.15u
X3608 VSS.t743 VDD VSS.t746 VSS.t871 sg13_lv_nmos ad=79.8f pd=0.8u as=0 ps=0 w=0.42u l=1u
X3609 VDD VSS.t2143 VDD VDD sg13_lv_pmos ad=0.19p pd=1.38u as=0 ps=0 w=1u l=1u
X3610 VDD VSS.t760 VDD VDD sg13_lv_pmos ad=0.34p pd=2.68u as=0 ps=0 w=1u l=1u
X3611 VDD VSS.t939 VDD VDD sg13_lv_pmos ad=0.34p pd=2.68u as=0 ps=0 w=1u l=1u
X3612 VSS.t1361 VDD VSS.t1360 VSS.t377 sg13_lv_nmos ad=0.1428p pd=1.52u as=0 ps=0 w=0.42u l=1u
X3613 VDD VSS.t3254 VDD VDD sg13_lv_pmos ad=0.34p pd=2.68u as=0 ps=0 w=1u l=1u
X3614 VSS.t2761 VDD VSS.t2760 VSS.t412 sg13_lv_nmos ad=0.1428p pd=1.52u as=0 ps=0 w=0.42u l=1u
X3615 a_9158_15234# a_9963_15356# a_9418_15457# VDD sg13_lv_pmos ad=0.1428p pd=1.52u as=79.8f ps=0.8u w=0.42u l=0.13u
X3616 VSS.t106 sg13g2_dfrbpq_1_1.RESET_B a_6180_14922# VSS.t281 sg13_lv_nmos ad=0.1626p pd=1.415u as=60.89999f ps=0.71u w=0.42u l=0.13u
X3617 sg13g2_o21ai_1_2.Y sg13g2_o21ai_1_2.A2 a_23736_14464# VDD sg13_lv_pmos ad=0.2128p pd=1.5u as=0.2128p ps=1.5u w=1.12u l=0.15u
X3618 VDD VSS.t1826 VDD VDD sg13_lv_pmos ad=0.19p pd=1.38u as=0 ps=0 w=1u l=1u
X3619 VDD VSS.t2170 VDD VDD sg13_lv_pmos ad=0.34p pd=2.68u as=0 ps=0 w=1u l=1u
X3620 VDD a_17327_13799# a_17994_14020# VDD sg13_lv_pmos ad=0.2128p pd=1.5u as=0.3864p ps=2.93u w=1.12u l=0.13u
X3621 VSS.t302 VDD VSS.t686 VSS.t685 sg13_lv_nmos ad=79.8f pd=0.8u as=0 ps=0 w=0.42u l=1u
X3622 VSS.t1287 VDD VSS.t1286 VSS.t377 sg13_lv_nmos ad=0.1428p pd=1.52u as=0 ps=0 w=0.42u l=1u
X3623 VSS.t134 a_17900_15960# counter_value_o[3] VSS.t151 sg13_lv_nmos ad=0.14875p pd=1.16u as=0.2886p ps=2.26u w=0.74u l=0.13u
X3624 VSS.t1473 VDD VSS.t1319 VSS.t377 sg13_lv_nmos ad=79.8f pd=0.8u as=0 ps=0 w=0.42u l=1u
X3625 a_23858_15242# sg13g2_dfrbpq_1_2.Q VSS.t137 VSS.t28 sg13_lv_nmos ad=0.1406p pd=1.12u as=0.2516p ps=2.16u w=0.74u l=0.13u
X3626 VSS.t910 VDD VSS.t912 VSS.t911 sg13_lv_nmos ad=79.8f pd=0.8u as=0 ps=0 w=0.42u l=1u
X3627 VSS.t1664 VDD VSS.t1666 VSS.t1665 sg13_lv_nmos ad=79.8f pd=0.8u as=0 ps=0 w=0.42u l=1u
X3628 VSS.t1844 VDD VSS.t1843 VSS.t1842 sg13_lv_nmos ad=0.1428p pd=1.52u as=0 ps=0 w=0.42u l=1u
X3629 VSS.t3190 VDD VSS.t3192 VSS.t3191 sg13_lv_nmos ad=79.8f pd=0.8u as=0 ps=0 w=0.42u l=1u
X3630 VSS.t2558 VDD VSS.t2557 VSS.t2556 sg13_lv_nmos ad=0.1428p pd=1.52u as=0 ps=0 w=0.42u l=1u
X3631 VSS.t2398 VDD VSS.t2400 VSS.t2399 sg13_lv_nmos ad=79.8f pd=0.8u as=0 ps=0 w=0.42u l=1u
X3632 VDD VSS.t271 VDD VDD sg13_lv_pmos ad=0.34p pd=2.68u as=0 ps=0 w=1u l=1u
X3633 a_7643_15280# sg13g2_dlygate4sd3_1_8.X VSS.t82 VSS.t266 sg13_lv_nmos ad=78.39999f pd=0.885u as=0.2272p ps=1.99u w=0.64u l=0.13u
X3634 VSS.t142 a_27898_15202# a_27617_15424# VSS.t33 sg13_lv_nmos ad=79.8f pd=0.8u as=0.1428p ps=1.52u w=0.42u l=0.5u
X3635 VDD VSS.t586 VDD VDD sg13_lv_pmos ad=0.19p pd=1.38u as=0 ps=0 w=1u l=1u
X3636 VDD VSS.t1167 VDD VDD sg13_lv_pmos ad=0.19p pd=1.38u as=0 ps=0 w=1u l=1u
X3637 VSS.t980 VDD VSS.t982 VSS.t981 sg13_lv_nmos ad=79.8f pd=0.8u as=0 ps=0 w=0.42u l=1u
X3638 VDD VSS.t969 VDD VDD sg13_lv_pmos ad=0.34p pd=2.68u as=0 ps=0 w=1u l=1u
X3639 VSS.t3145 VDD VSS.t3144 VSS.t3143 sg13_lv_nmos ad=0.1428p pd=1.52u as=0 ps=0 w=0.42u l=1u
X3640 VDD VSS.t2805 VDD VDD sg13_lv_pmos ad=0.19p pd=1.38u as=0 ps=0 w=1u l=1u
X3641 VSS.t2056 VDD VSS.t2055 VSS.t2054 sg13_lv_nmos ad=0.1428p pd=1.52u as=0 ps=0 w=0.42u l=1u
X3642 VDD VSS.t3084 VDD VDD sg13_lv_pmos ad=0.34p pd=2.68u as=0 ps=0 w=1u l=1u
X3643 VDD VSS.t2502 VDD VDD sg13_lv_pmos ad=0.34p pd=2.68u as=0 ps=0 w=1u l=1u
X3644 VSS.t214 VDD VSS.t214 VSS.t556 sg13_lv_nmos ad=79.8f pd=0.8u as=0 ps=0 w=0.42u l=1u
X3645 a_18874_13690# sg13g2_dfrbpq_1_2.Q VSS.t139 VSS.t138 sg13_lv_nmos ad=0.1428p pd=1.52u as=79.8f ps=0.8u w=0.42u l=0.13u
X3646 VSS.t816 VDD VSS.t243 VSS.t815 sg13_lv_nmos ad=0.1428p pd=1.52u as=0 ps=0 w=0.42u l=1u
X3647 VDD VSS.t373 VDD VDD sg13_lv_pmos ad=0.19p pd=1.38u as=0 ps=0 w=1u l=1u
X3648 VSS.t2588 VDD VSS.t2590 VSS.t2589 sg13_lv_nmos ad=79.8f pd=0.8u as=0 ps=0 w=0.42u l=1u
X3649 VDD VSS.t1621 VDD VDD sg13_lv_pmos ad=0.19p pd=1.38u as=0 ps=0 w=1u l=1u
X3650 VDD VSS.t2530 VDD VDD sg13_lv_pmos ad=0.19p pd=1.38u as=0 ps=0 w=1u l=1u
X3651 VSS.t460 VDD VSS.t460 VSS.t463 sg13_lv_nmos ad=79.8f pd=0.8u as=0 ps=0 w=0.42u l=1u
X3652 a_19438_13726# sg13g2_buf_16_2.A VSS.t178 VSS.t179 sg13_lv_nmos ad=0.1406p pd=1.12u as=0.1406p ps=1.12u w=0.74u l=0.13u
X3653 a_25956_14488# a_26475_14495# a_27215_14845# VSS.t33 sg13_lv_nmos ad=0.3473p pd=2.71u as=0.12665p ps=1.145u w=0.74u l=0.13u
X3654 VSS.t302 VDD VSS.t302 VSS.t705 sg13_lv_nmos ad=0.1428p pd=1.52u as=0 ps=0 w=0.42u l=1u
X3655 VDD VSS.t1332 VDD VDD sg13_lv_pmos ad=0.19p pd=1.38u as=0 ps=0 w=1u l=1u
X3656 VDD VSS.t1437 VDD VDD sg13_lv_pmos ad=0.34p pd=2.68u as=0 ps=0 w=1u l=1u
X3657 sg13g2_nand3_1_0.Y sg13g2_dlygate4sd3_1_3.A VDD VDD sg13_lv_pmos ad=0.2128p pd=1.5u as=0.3808p ps=2.92u w=1.12u l=0.13u
X3658 VDD VSS.t695 VDD VDD sg13_lv_pmos ad=0.34p pd=2.68u as=0 ps=0 w=1u l=1u
X3659 VDD VSS.t1032 VDD VDD sg13_lv_pmos ad=0.19p pd=1.38u as=0 ps=0 w=1u l=1u
X3660 VSS.t1296 VDD VSS.t1295 VSS.t377 sg13_lv_nmos ad=0.1428p pd=1.52u as=0 ps=0 w=0.42u l=1u
X3661 VSS.t1405 VDD VSS.t1405 VSS.t377 sg13_lv_nmos ad=79.8f pd=0.8u as=0 ps=0 w=0.42u l=1u
X3662 VSS.t1335 VDD VSS.t1337 VSS.t377 sg13_lv_nmos ad=79.8f pd=0.8u as=0 ps=0 w=0.42u l=1u
X3663 VSS.t1754 VDD VSS.t1756 VSS.t1755 sg13_lv_nmos ad=79.8f pd=0.8u as=0 ps=0 w=0.42u l=1u
X3664 VSS.t2136 VDD VSS.t2138 VSS.t2137 sg13_lv_nmos ad=79.8f pd=0.8u as=0 ps=0 w=0.42u l=1u
X3665 VDD VSS.t2815 VDD VDD sg13_lv_pmos ad=0.34p pd=2.68u as=0 ps=0 w=1u l=1u
X3666 VDD VSS.t302 VDD VDD sg13_lv_pmos ad=0.19p pd=1.38u as=0 ps=0 w=1u l=1u
X3667 VDD VSS.t1429 VDD VDD sg13_lv_pmos ad=0.19p pd=1.38u as=0 ps=0 w=1u l=1u
X3668 VSS.t1639 VDD VSS.t1638 VSS.t1637 sg13_lv_nmos ad=0.1428p pd=1.52u as=0 ps=0 w=0.42u l=1u
X3669 a_15876_13722# sg13g2_dfrbpq_1_2.D a_15782_13722# VSS.t283 sg13_lv_nmos ad=60.89999f pd=0.71u as=0.1428p ps=1.52u w=0.42u l=0.13u
X3670 VSS.t766 VDD VSS.t766 VSS.t767 sg13_lv_nmos ad=79.8f pd=0.8u as=0 ps=0 w=0.42u l=1u
X3671 VDD a_18106_15202# a_17825_15424# VDD sg13_lv_pmos ad=0.1523p pd=1.38u as=0.34p ps=2.68u w=1u l=0.5u
X3672 VSS.t1300 VDD VSS.t1300 VSS.t377 sg13_lv_nmos ad=0.1428p pd=1.52u as=0 ps=0 w=0.42u l=1u
X3673 VDD VSS.t2155 VDD VDD sg13_lv_pmos ad=0.34p pd=2.68u as=0 ps=0 w=1u l=1u
X3674 VSS.t1065 VDD VSS.t1067 VSS.t1066 sg13_lv_nmos ad=79.8f pd=0.8u as=0 ps=0 w=0.42u l=1u
X3675 VDD VSS.t1990 VDD VDD sg13_lv_pmos ad=0.34p pd=2.68u as=0 ps=0 w=1u l=1u
X3676 VDD VSS.t1798 VDD VDD sg13_lv_pmos ad=0.34p pd=2.68u as=0 ps=0 w=1u l=1u
X3677 VSS.t3175 VDD VSS.t3177 VSS.t3176 sg13_lv_nmos ad=79.8f pd=0.8u as=0 ps=0 w=0.42u l=1u
X3678 VSS.t2383 VDD VSS.t2385 VSS.t2384 sg13_lv_nmos ad=79.8f pd=0.8u as=0 ps=0 w=0.42u l=1u
X3679 VSS.t106 VDD VSS.t106 VSS.t628 sg13_lv_nmos ad=79.8f pd=0.8u as=0 ps=0 w=0.42u l=1u
X3680 VDD VSS.t1661 VDD VDD sg13_lv_pmos ad=0.19p pd=1.38u as=0 ps=0 w=1u l=1u
X3681 VDD VSS.t1838 VDD VDD sg13_lv_pmos ad=0.34p pd=2.68u as=0 ps=0 w=1u l=1u
X3682 VDD VSS.t2900 VDD VDD sg13_lv_pmos ad=0.34p pd=2.68u as=0 ps=0 w=1u l=1u
X3683 VSS.t2458 VDD VSS.t2460 VSS.t2459 sg13_lv_nmos ad=79.8f pd=0.8u as=0 ps=0 w=0.42u l=1u
X3684 VDD VSS.t2522 VDD VDD sg13_lv_pmos ad=0.34p pd=2.68u as=0 ps=0 w=1u l=1u
X3685 VSS.t895 VDD VSS.t897 VSS.t896 sg13_lv_nmos ad=79.8f pd=0.8u as=0 ps=0 w=0.42u l=1u
X3686 VSS.t1609 VDD VSS.t1611 VSS.t1610 sg13_lv_nmos ad=79.8f pd=0.8u as=0 ps=0 w=0.42u l=1u
X3687 VDD VSS.t2180 VDD VDD sg13_lv_pmos ad=0.34p pd=2.68u as=0 ps=0 w=1u l=1u
X3688 VDD a_16556_15960# sg13g2_or3_1_2.B VDD sg13_lv_pmos ad=0.2114p pd=1.54u as=0.42p ps=2.99u w=1.12u l=0.13u
X3689 a_9732_15247# a_9444_15552# a_9670_15247# VSS.t4 sg13_lv_nmos ad=0.1428p pd=1.52u as=37.8f ps=0.6u w=0.42u l=0.13u
X3690 VSS.t1388 VDD VSS.t1387 VSS.t377 sg13_lv_nmos ad=0.1428p pd=1.52u as=0 ps=0 w=0.42u l=1u
X3691 VDD VSS.t1346 VDD VDD sg13_lv_pmos ad=0.19p pd=1.38u as=0 ps=0 w=1u l=1u
X3692 VDD VSS.t2852 VDD VDD sg13_lv_pmos ad=0.19p pd=1.38u as=0 ps=0 w=1u l=1u
X3693 VDD VSS.t2128 VDD VDD sg13_lv_pmos ad=0.19p pd=1.38u as=0 ps=0 w=1u l=1u
X3694 a_17604_14488# a_17578_14452# VSS.t24 VSS.t297 sg13_lv_nmos ad=0.2516p pd=2.16u as=0.1626p ps=1.415u w=0.74u l=0.13u
X3695 VDD VSS.t619 VDD VDD sg13_lv_pmos ad=0.19p pd=1.38u as=0 ps=0 w=1u l=1u
X3696 a_19438_13726# sg13g2_buf_16_2.A VSS.t174 VSS.t173 sg13_lv_nmos ad=0.1406p pd=1.12u as=0.2516p ps=2.16u w=0.74u l=0.13u
X3697 VDD VSS.t2482 VDD VDD sg13_lv_pmos ad=0.34p pd=2.68u as=0 ps=0 w=1u l=1u
X3698 VSS.t2543 VDD VSS.t2542 VSS.t2541 sg13_lv_nmos ad=0.1428p pd=1.52u as=0 ps=0 w=0.42u l=1u
X3699 VDD VSS.t509 VDD VDD sg13_lv_pmos ad=0.34p pd=2.68u as=0 ps=0 w=1u l=1u
X3700 VDD VSS.t1628 VDD VDD sg13_lv_pmos ad=0.34p pd=2.68u as=0 ps=0 w=1u l=1u
X3701 VSS.t2752 VDD VSS.t2751 VSS.t412 sg13_lv_nmos ad=0.1428p pd=1.52u as=0 ps=0 w=0.42u l=1u
X3702 VSS.t746 VDD VSS.t743 VSS.t745 sg13_lv_nmos ad=0.1428p pd=1.52u as=0 ps=0 w=0.42u l=1u
X3703 VDD VSS.t475 VDD VDD sg13_lv_pmos ad=0.34p pd=2.68u as=0 ps=0 w=1u l=1u
X3704 a_22319_14845# a_21477_14495# a_22225_14845# VSS.t30 sg13_lv_nmos ad=0.12665p pd=1.145u as=0.1428p ps=1.52u w=0.42u l=0.13u
X3705 VSS.t1674 VDD VSS.t1673 VSS.t1672 sg13_lv_nmos ad=0.1428p pd=1.52u as=0 ps=0 w=0.42u l=1u
X3706 VDD VSS.t1811 VDD VDD sg13_lv_pmos ad=0.19p pd=1.38u as=0 ps=0 w=1u l=1u
X3707 VSS.t2091 VDD VSS.t2090 VSS.t2089 sg13_lv_nmos ad=0.1428p pd=1.52u as=0 ps=0 w=0.42u l=1u
X3708 VSS.t547 VDD VSS.t547 VSS.t548 sg13_lv_nmos ad=0.1428p pd=1.52u as=0 ps=0 w=0.42u l=1u
X3709 a_25774_15423# a_25889_15424# VSS.t255 VSS.t341 sg13_lv_nmos ad=0.1428p pd=1.52u as=0.1426p ps=1.16u w=0.42u l=0.5u
X3710 sg13g2_buf_16_2.A a_15022_14484# VDD VDD sg13_lv_pmos ad=0.2128p pd=1.5u as=0.2128p ps=1.5u w=1.12u l=0.13u
X3711 a_19282_14922# sg13g2_dfrbpq_1_3.RESET_B VSS.t88 VSS.t25 sg13_lv_nmos ad=37.8f pd=0.6u as=79.8f ps=0.8u w=0.42u l=0.13u
X3712 VSS.t1393 VDD VSS.t1392 VSS.t377 sg13_lv_nmos ad=0.1428p pd=1.52u as=0 ps=0 w=0.42u l=1u
X3713 VSS.t2608 VDD VSS.t2610 VSS.t2609 sg13_lv_nmos ad=79.8f pd=0.8u as=0 ps=0 w=0.42u l=1u
X3714 a_8582_15238# a_8312_15238# VDD VDD sg13_lv_pmos ad=0.34p pd=2.68u as=0.1523p ps=1.38u w=1u l=0.5u
X3715 VDD a_21827_13690# sg13g2_or3_1_2.X VDD sg13_lv_pmos ad=0.3822p pd=1.84u as=0.3808p ps=2.92u w=1.12u l=0.13u
X3716 VSS.t910 VDD VSS.t912 VSS.t911 sg13_lv_nmos ad=79.8f pd=0.8u as=0 ps=0 w=0.42u l=1u
X3717 VSS.t1422 VDD VSS.t1423 VSS.t377 sg13_lv_nmos ad=79.8f pd=0.8u as=0 ps=0 w=0.42u l=1u
X3718 VDD VSS.t1641 VDD VDD sg13_lv_pmos ad=0.19p pd=1.38u as=0 ps=0 w=1u l=1u
X3719 VDD VSS.t3109 VDD VDD sg13_lv_pmos ad=0.34p pd=2.68u as=0 ps=0 w=1u l=1u
X3720 VDD VSS.t1975 VDD VDD sg13_lv_pmos ad=0.34p pd=2.68u as=0 ps=0 w=1u l=1u
X3721 a_16079_15238# a_16044_15424# sg13g2_nor2_1_0.B VSS.t424 sg13_lv_nmos ad=0.1406p pd=1.12u as=0.2516p ps=2.16u w=0.74u l=0.13u
X3722 VDD a_4078_14751# sg13g2_xor2_1_0.B VDD sg13_lv_pmos ad=0.2254p pd=1.53u as=0.4256p ps=3u w=1.12u l=0.13u
X3723 VSS.t1829 VDD VSS.t1828 VSS.t1827 sg13_lv_nmos ad=0.1428p pd=1.52u as=0 ps=0 w=0.42u l=1u
X3724 VSS.t625 VDD VSS.t145 VSS.t626 sg13_lv_nmos ad=79.8f pd=0.8u as=0 ps=0 w=0.42u l=1u
X3725 VDD VSS.t2892 VDD VDD sg13_lv_pmos ad=0.34p pd=2.68u as=0 ps=0 w=1u l=1u
X3726 VDD VSS.t2798 VDD VDD sg13_lv_pmos ad=0.19p pd=1.38u as=0 ps=0 w=1u l=1u
X3727 VSS.t2041 VDD VSS.t2040 VSS.t2039 sg13_lv_nmos ad=0.1428p pd=1.52u as=0 ps=0 w=0.42u l=1u
X3728 VDD VSS.t3069 VDD VDD sg13_lv_pmos ad=0.34p pd=2.68u as=0 ps=0 w=1u l=1u
X3729 VSS.t3130 VDD VSS.t3129 VSS.t3128 sg13_lv_nmos ad=0.1428p pd=1.52u as=0 ps=0 w=0.42u l=1u
X3730 VSS.t302 VDD VSS.t302 VSS.t680 sg13_lv_nmos ad=0.1428p pd=1.52u as=0 ps=0 w=0.42u l=1u
X3731 VSS.t715 VDD VSS.t715 VSS.t838 sg13_lv_nmos ad=0.1428p pd=1.52u as=0 ps=0 w=0.42u l=1u
X3732 VDD VSS.t1024 VDD VDD sg13_lv_pmos ad=0.34p pd=2.68u as=0 ps=0 w=1u l=1u
X3733 sg13g2_o21ai_1_3.Y sg13g2_or3_1_1.A a_24310_15230# VSS.t28 sg13_lv_nmos ad=0.2516p pd=2.16u as=0.1406p ps=1.12u w=0.74u l=0.15u
X3734 VDD VSS.t1139 VDD VDD sg13_lv_pmos ad=0.34p pd=2.68u as=0 ps=0 w=1u l=1u
X3735 VDD VSS.t1291 VDD VDD sg13_lv_pmos ad=0.19p pd=1.38u as=0 ps=0 w=1u l=1u
X3736 VSS.t439 VDD VSS.t438 VSS.t437 sg13_lv_nmos ad=0.1428p pd=1.52u as=0 ps=0 w=0.42u l=1u
X3737 VSS.t606 VDD VSS.t607 VSS.t33 sg13_lv_nmos ad=79.8f pd=0.8u as=0 ps=0 w=0.42u l=1u
X3738 VDD VSS.t947 VDD VDD sg13_lv_pmos ad=0.19p pd=1.38u as=0 ps=0 w=1u l=1u
X3739 VSS.t1401 VDD VSS.t1400 VSS.t377 sg13_lv_nmos ad=0.1428p pd=1.52u as=0 ps=0 w=0.42u l=1u
X3740 VDD VSS.t1606 VDD VDD sg13_lv_pmos ad=0.19p pd=1.38u as=0 ps=0 w=1u l=1u
X3741 VDD VSS.t2515 VDD VDD sg13_lv_pmos ad=0.19p pd=1.38u as=0 ps=0 w=1u l=1u
X3742 VSS.t2573 VDD VSS.t2575 VSS.t2574 sg13_lv_nmos ad=79.8f pd=0.8u as=0 ps=0 w=0.42u l=1u
X3743 VDD sg13g2_dfrbpq_1_5.RESET_B a_26122_13945# VDD sg13_lv_pmos ad=0.1563p pd=1.22u as=0.147p ps=1.54u w=0.42u l=0.13u
X3744 VSS.t35 sg13g2_xnor2_1_2.A a_6996_13320# VSS.t108 sg13_lv_nmos ad=0.2272p pd=1.99u as=78.39999f ps=0.885u w=0.64u l=0.13u
X3745 VDD VSS.t2844 VDD VDD sg13_lv_pmos ad=0.19p pd=1.38u as=0 ps=0 w=1u l=1u
X3746 VSS.t2403 VDD VSS.t2405 VSS.t2404 sg13_lv_nmos ad=79.8f pd=0.8u as=0 ps=0 w=0.42u l=1u
X3747 VSS.t2528 VDD VSS.t2527 VSS.t2526 sg13_lv_nmos ad=0.1428p pd=1.52u as=0 ps=0 w=0.42u l=1u
X3748 VSS.t1739 VDD VSS.t1741 VSS.t1740 sg13_lv_nmos ad=79.8f pd=0.8u as=0 ps=0 w=0.42u l=1u
X3749 VSS.t2858 VDD VSS.t2858 VSS.t412 sg13_lv_nmos ad=79.8f pd=0.8u as=0 ps=0 w=0.42u l=1u
X3750 VSS.t183 sg13g2_or3_1_1.C a_24841_13726# VSS.t182 sg13_lv_nmos ad=0.1045p pd=0.93u as=0.187p ps=1.78u w=0.55u l=0.13u
X3751 VDD VSS.t76 VDD VDD sg13_lv_pmos ad=0.34p pd=2.68u as=0 ps=0 w=1u l=1u
X3752 VDD VSS.t899 VDD VDD sg13_lv_pmos ad=0.34p pd=2.68u as=0 ps=0 w=1u l=1u
X3753 VSS.t1624 VDD VSS.t1623 VSS.t1622 sg13_lv_nmos ad=0.1428p pd=1.52u as=0 ps=0 w=0.42u l=1u
X3754 VSS.t1694 VDD VSS.t1693 VSS.t1692 sg13_lv_nmos ad=0.1428p pd=1.52u as=0 ps=0 w=0.42u l=1u
X3755 VDD VSS.t1796 VDD VDD sg13_lv_pmos ad=0.19p pd=1.38u as=0 ps=0 w=1u l=1u
X3756 a_37484_15960# sg13g2_dfrbpq_1_5.Q VDD VDD sg13_lv_pmos ad=0.2856p pd=2.36u as=0.2114p ps=1.54u w=0.84u l=0.13u
X3757 VDD VSS.t1345 VDD VDD sg13_lv_pmos ad=0.34p pd=2.68u as=0 ps=0 w=1u l=1u
X3758 VSS.t1065 VDD VSS.t1067 VSS.t1066 sg13_lv_nmos ad=79.8f pd=0.8u as=0 ps=0 w=0.42u l=1u
X3759 VSS.t1565 VDD VSS.t1437 VSS.t377 sg13_lv_nmos ad=79.8f pd=0.8u as=0 ps=0 w=0.42u l=1u
X3760 VDD VSS.t302 VDD VDD sg13_lv_pmos ad=0.19p pd=1.38u as=0 ps=0 w=1u l=1u
X3761 VDD VSS.t1353 VDD VDD sg13_lv_pmos ad=0.34p pd=2.68u as=0 ps=0 w=1u l=1u
X3762 VDD VSS.t2858 VDD VDD sg13_lv_pmos ad=0.34p pd=2.68u as=0 ps=0 w=1u l=1u
X3763 VDD VSS.t2140 VDD VDD sg13_lv_pmos ad=0.34p pd=2.68u as=0 ps=0 w=1u l=1u
X3764 VSS.t485 VDD VSS.t484 VSS.t483 sg13_lv_nmos ad=0.1428p pd=1.52u as=0 ps=0 w=0.42u l=1u
X3765 VSS.t50 VDD VSS.t50 VSS.t636 sg13_lv_nmos ad=0.1428p pd=1.52u as=0 ps=0 w=0.42u l=1u
X3766 VSS.t2368 VDD VSS.t2370 VSS.t2369 sg13_lv_nmos ad=79.8f pd=0.8u as=0 ps=0 w=0.42u l=1u
X3767 VDD VSS.t760 VDD VDD sg13_lv_pmos ad=0.19p pd=1.38u as=0 ps=0 w=1u l=1u
X3768 VDD VSS.t1823 VDD VDD sg13_lv_pmos ad=0.34p pd=2.68u as=0 ps=0 w=1u l=1u
X3769 VSS.t2061 VDD VSS.t2060 VSS.t2059 sg13_lv_nmos ad=0.1428p pd=1.52u as=0 ps=0 w=0.42u l=1u
X3770 VDD VSS.t3054 VDD VDD sg13_lv_pmos ad=0.34p pd=2.68u as=0 ps=0 w=1u l=1u
X3771 VDD sg13g2_dlygate4sd3_1_12.X a_24923_15996# VDD sg13_lv_pmos ad=0.2128p pd=1.5u as=0.2128p ps=1.5u w=1.12u l=0.13u
X3772 VSS.t63 sg13g2_buf_16_2.A a_12020_15202# VSS.t172 sg13_lv_nmos ad=0.2516p pd=2.16u as=0.1406p ps=1.12u w=0.74u l=0.13u
X3773 VDD VSS.t1383 VDD VDD sg13_lv_pmos ad=0.19p pd=1.38u as=0 ps=0 w=1u l=1u
X3774 VSS.t2623 VDD VSS.t2622 VSS.t2621 sg13_lv_nmos ad=0.1428p pd=1.52u as=0 ps=0 w=0.42u l=1u
X3775 VSS.t2443 VDD VSS.t2445 VSS.t2444 sg13_lv_nmos ad=79.8f pd=0.8u as=0 ps=0 w=0.42u l=1u
X3776 VDD VSS.t2507 VDD VDD sg13_lv_pmos ad=0.34p pd=2.68u as=0 ps=0 w=1u l=1u
X3777 VDD VSS.t914 VDD VDD sg13_lv_pmos ad=0.34p pd=2.68u as=0 ps=0 w=1u l=1u
X3778 VDD VSS.t1102 VDD VDD sg13_lv_pmos ad=0.19p pd=1.38u as=0 ps=0 w=1u l=1u
X3779 VDD VSS.t1688 VDD VDD sg13_lv_pmos ad=0.34p pd=2.68u as=0 ps=0 w=1u l=1u
X3780 VDD VSS.t1626 VDD VDD sg13_lv_pmos ad=0.19p pd=1.38u as=0 ps=0 w=1u l=1u
X3781 VDD VSS.t2535 VDD VDD sg13_lv_pmos ad=0.19p pd=1.38u as=0 ps=0 w=1u l=1u
X3782 VSS.t985 VDD VSS.t987 VSS.t986 sg13_lv_nmos ad=79.8f pd=0.8u as=0 ps=0 w=0.42u l=1u
X3783 VDD VSS.t2821 VDD VDD sg13_lv_pmos ad=0.34p pd=2.68u as=0 ps=0 w=1u l=1u
X3784 VSS.t1724 VDD VSS.t1726 VSS.t1725 sg13_lv_nmos ad=79.8f pd=0.8u as=0 ps=0 w=0.42u l=1u
X3785 VSS.t2141 VDD VSS.t2143 VSS.t2142 sg13_lv_nmos ad=79.8f pd=0.8u as=0 ps=0 w=0.42u l=1u
X3786 a_6372_14488# a_6346_14452# VDD VDD sg13_lv_pmos ad=0.34p pd=2.68u as=0.36237p ps=2.605u w=1u l=0.13u
X3787 VDD VSS.t465 VDD VDD sg13_lv_pmos ad=0.19p pd=1.38u as=0 ps=0 w=1u l=1u
X3788 VSS.t1551 VDD VSS.t1418 VSS.t377 sg13_lv_nmos ad=0.1428p pd=1.52u as=0 ps=0 w=0.42u l=1u
X3789 a_4432_15454# sg13g2_dfrbpq_1_0.RESET_B VDD VDD sg13_lv_pmos ad=79.8f pd=0.8u as=2.8961p ps=18.25u w=0.42u l=0.13u
X3790 VDD sg13g2_dfrbpq_1_7.RESET_B a_25930_14452# VDD sg13_lv_pmos ad=0.1563p pd=1.22u as=0.147p ps=1.54u w=0.42u l=0.13u
X3791 VDD VSS.t2562 VDD VDD sg13_lv_pmos ad=0.34p pd=2.68u as=0 ps=0 w=1u l=1u
X3792 sg13g2_dfrbpq_1_2.CLK a_12020_15202# VDD VDD sg13_lv_pmos ad=0.2128p pd=1.5u as=0.2128p ps=1.5u w=1.12u l=0.13u
X3793 VSS.t2593 VDD VSS.t2595 VSS.t2594 sg13_lv_nmos ad=79.8f pd=0.8u as=0 ps=0 w=0.42u l=1u
X3794 VDD VSS.t3094 VDD VDD sg13_lv_pmos ad=0.34p pd=2.68u as=0 ps=0 w=1u l=1u
X3795 VSS.t1340 VDD VSS.t1339 VSS.t377 sg13_lv_nmos ad=0.1428p pd=1.52u as=0 ps=0 w=0.42u l=1u
X3796 VDD VSS.t1803 VDD VDD sg13_lv_pmos ad=0.34p pd=2.68u as=0 ps=0 w=1u l=1u
X3797 VSS.t1654 VDD VSS.t1656 VSS.t1655 sg13_lv_nmos ad=79.8f pd=0.8u as=0 ps=0 w=0.42u l=1u
X3798 VSS.t3180 VDD VSS.t3182 VSS.t3181 sg13_lv_nmos ad=79.8f pd=0.8u as=0 ps=0 w=0.42u l=1u
X3799 VSS.t2388 VDD VSS.t2390 VSS.t2389 sg13_lv_nmos ad=79.8f pd=0.8u as=0 ps=0 w=0.42u l=1u
X3800 VSS.t2171 VDD VSS.t2170 VSS.t2169 sg13_lv_nmos ad=0.1428p pd=1.52u as=0 ps=0 w=0.42u l=1u
X3801 a_22576_14726# a_22319_14845# a_22738_14922# VSS.t30 sg13_lv_nmos ad=0.1428p pd=1.52u as=37.8f ps=0.6u w=0.42u l=0.13u
X3802 VDD VSS.t737 VDD VDD sg13_lv_pmos ad=0.34p pd=2.68u as=0 ps=0 w=1u l=1u
X3803 VSS.t1000 VDD VSS.t1002 VSS.t1001 sg13_lv_nmos ad=79.8f pd=0.8u as=0 ps=0 w=0.42u l=1u
X3804 VDD VSS.t1362 VDD VDD sg13_lv_pmos ad=0.34p pd=2.68u as=0 ps=0 w=1u l=1u
X3805 VDD VSS.t1666 VDD VDD sg13_lv_pmos ad=0.19p pd=1.38u as=0 ps=0 w=1u l=1u
X3806 VDD VSS.t2884 VDD VDD sg13_lv_pmos ad=0.34p pd=2.68u as=0 ps=0 w=1u l=1u
X3807 VSS.t715 VDD VSS.t715 VSS.t714 sg13_lv_nmos ad=0.1428p pd=1.52u as=0 ps=0 w=0.42u l=1u
X3808 VDD VSS.t1069 VDD VDD sg13_lv_pmos ad=0.34p pd=2.68u as=0 ps=0 w=1u l=1u
X3809 VSS.t2463 VDD VSS.t2465 VSS.t2464 sg13_lv_nmos ad=79.8f pd=0.8u as=0 ps=0 w=0.42u l=1u
X3810 VSS.t50 a_12020_15202# sg13g2_dfrbpq_1_2.CLK VSS.t52 sg13_lv_nmos ad=0.1406p pd=1.12u as=0.1406p ps=1.12u w=0.74u l=0.13u
X3811 VSS.t940 VDD VSS.t939 VSS.t938 sg13_lv_nmos ad=0.1428p pd=1.52u as=0 ps=0 w=0.42u l=1u
X3812 VDD VSS.t2836 VDD VDD sg13_lv_pmos ad=0.19p pd=1.38u as=0 ps=0 w=1u l=1u
X3813 VSS.t2513 VDD VSS.t2512 VSS.t2511 sg13_lv_nmos ad=0.1428p pd=1.52u as=0 ps=0 w=0.42u l=1u
X3814 VDD VSS.t1633 VDD VDD sg13_lv_pmos ad=0.34p pd=2.68u as=0 ps=0 w=1u l=1u
X3815 VDD VSS.t302 VDD VDD sg13_lv_pmos ad=0.19p pd=1.38u as=0 ps=0 w=1u l=1u
X3816 VDD VSS.t746 VDD VDD sg13_lv_pmos ad=0.34p pd=2.68u as=0 ps=0 w=1u l=1u
X3817 VDD VSS.t1132 VDD VDD sg13_lv_pmos ad=0.19p pd=1.38u as=0 ps=0 w=1u l=1u
X3818 sg13g2_buf_16_2.X a_19438_13726# VDD VDD sg13_lv_pmos ad=0.2128p pd=1.5u as=0.2128p ps=1.5u w=1.12u l=0.13u
X3819 VSS.t1679 VDD VSS.t1678 VSS.t1677 sg13_lv_nmos ad=0.1428p pd=1.52u as=0 ps=0 w=0.42u l=1u
X3820 VSS.t2428 VDD VSS.t2430 VSS.t2429 sg13_lv_nmos ad=79.8f pd=0.8u as=0 ps=0 w=0.42u l=1u
X3821 VDD VSS.t2193 VDD VDD sg13_lv_pmos ad=0.19p pd=1.38u as=0 ps=0 w=1u l=1u
X3822 VSS.t591 VDD VSS.t592 VSS.t33 sg13_lv_nmos ad=79.8f pd=0.8u as=0 ps=0 w=0.42u l=1u
X3823 VDD VSS.t302 VDD VDD sg13_lv_pmos ad=0.19p pd=1.38u as=0 ps=0 w=1u l=1u
X3824 VDD VSS.t1638 VDD VDD sg13_lv_pmos ad=0.34p pd=2.68u as=0 ps=0 w=1u l=1u
X3825 VSS.t2825 VDD VSS.t2825 VSS.t412 sg13_lv_nmos ad=0.1428p pd=1.52u as=0 ps=0 w=0.42u l=1u
X3826 VDD VSS.t2547 VDD VDD sg13_lv_pmos ad=0.34p pd=2.68u as=0 ps=0 w=1u l=1u
X3827 VSS.t150 sg13g2_dlygate4sd3_1_4.X sg13g2_xnor2_1_1.A VSS.t324 sg13_lv_nmos ad=0.2516p pd=2.16u as=0.2516p ps=2.16u w=0.74u l=0.13u
X3828 VSS.t302 VDD VSS.t302 VSS.t705 sg13_lv_nmos ad=0.1428p pd=1.52u as=0 ps=0 w=0.42u l=1u
X3829 VSS.t2578 VDD VSS.t2580 VSS.t2579 sg13_lv_nmos ad=79.8f pd=0.8u as=0 ps=0 w=0.42u l=1u
X3830 VSS.t1317 VDD VSS.t1318 VSS.t377 sg13_lv_nmos ad=79.8f pd=0.8u as=0 ps=0 w=0.42u l=1u
X3831 VDD VSS.t3114 VDD VDD sg13_lv_pmos ad=0.34p pd=2.68u as=0 ps=0 w=1u l=1u
X3832 VDD VSS.t1980 VDD VDD sg13_lv_pmos ad=0.34p pd=2.68u as=0 ps=0 w=1u l=1u
X3833 sg13g2_dfrbpq_1_2.CLK a_12020_15202# VDD VDD sg13_lv_pmos ad=0.2128p pd=1.5u as=0.2128p ps=1.5u w=1.12u l=0.13u
X3834 VSS.t1354 VDD VSS.t1353 VSS.t377 sg13_lv_nmos ad=0.1428p pd=1.52u as=0 ps=0 w=0.42u l=1u
X3835 VDD VSS.t2495 VDD VDD sg13_lv_pmos ad=0.19p pd=1.38u as=0 ps=0 w=1u l=1u
X3836 VSS.t2156 VDD VSS.t2155 VSS.t2154 sg13_lv_nmos ad=0.1428p pd=1.52u as=0 ps=0 w=0.42u l=1u
X3837 VSS.t970 VDD VSS.t969 VSS.t968 sg13_lv_nmos ad=0.1428p pd=1.52u as=0 ps=0 w=0.42u l=1u
X3838 VDD VSS.t2153 VDD VDD sg13_lv_pmos ad=0.19p pd=1.38u as=0 ps=0 w=1u l=1u
X3839 VDD VSS.t1022 VDD VDD sg13_lv_pmos ad=0.19p pd=1.38u as=0 ps=0 w=1u l=1u
X3840 VSS.t1799 VDD VSS.t1798 VSS.t1797 sg13_lv_nmos ad=0.1428p pd=1.52u as=0 ps=0 w=0.42u l=1u
X3841 VSS.t2046 VDD VSS.t2045 VSS.t2044 sg13_lv_nmos ad=0.1428p pd=1.52u as=0 ps=0 w=0.42u l=1u
X3842 a_16556_15960# sg13g2_or3_1_1.B VSS.t150 VSS.t306 sg13_lv_nmos ad=0.187p pd=1.78u as=0.14875p ps=1.16u w=0.55u l=0.13u
X3843 a_9861_15213# sg13g2_dfrbpq_1_2.CLK VSS.t33 VSS.t43 sg13_lv_nmos ad=0.2516p pd=2.16u as=5.01922p ps=33.275u w=0.74u l=0.13u
X3844 VDD VSS.t1409 VDD VDD sg13_lv_pmos ad=0.19p pd=1.38u as=0 ps=0 w=1u l=1u
X3845 VSS.t3135 VDD VSS.t3134 VSS.t3133 sg13_lv_nmos ad=0.1428p pd=1.52u as=0 ps=0 w=0.42u l=1u
X3846 VSS.t743 VDD VSS.t743 VSS.t744 sg13_lv_nmos ad=79.8f pd=0.8u as=0 ps=0 w=0.42u l=1u
X3847 VDD VSS.t1147 VDD VDD sg13_lv_pmos ad=0.19p pd=1.38u as=0 ps=0 w=1u l=1u
X3848 VSS.t2608 VDD VSS.t2607 VSS.t2606 sg13_lv_nmos ad=0.1428p pd=1.52u as=0 ps=0 w=0.42u l=1u
X3849 VSS.t46 a_12020_15202# sg13g2_dfrbpq_1_2.CLK VSS.t47 sg13_lv_nmos ad=0.1406p pd=1.12u as=0.1406p ps=1.12u w=0.74u l=0.13u
X3850 VDD a_22576_14726# a_22521_14607# VDD sg13_lv_pmos ad=2.42015p pd=15.68u as=93.45f ps=0.865u w=0.42u l=0.13u
X3851 VDD VSS.t589 VDD VDD sg13_lv_pmos ad=0.19p pd=1.38u as=0 ps=0 w=1u l=1u
X3852 VSS.t985 VDD VSS.t987 VSS.t986 sg13_lv_nmos ad=79.8f pd=0.8u as=0 ps=0 w=0.42u l=1u
X3853 VDD VSS.t1611 VDD VDD sg13_lv_pmos ad=0.19p pd=1.38u as=0 ps=0 w=1u l=1u
X3854 VSS.t2895 VDD VSS.t2896 VSS.t412 sg13_lv_nmos ad=79.8f pd=0.8u as=0 ps=0 w=0.42u l=1u
X3855 VDD VSS.t2520 VDD VDD sg13_lv_pmos ad=0.19p pd=1.38u as=0 ps=0 w=1u l=1u
X3856 VSS.t1030 VDD VSS.t1032 VSS.t1031 sg13_lv_nmos ad=79.8f pd=0.8u as=0 ps=0 w=0.42u l=1u
X3857 VSS.t2408 VDD VSS.t2410 VSS.t2409 sg13_lv_nmos ad=79.8f pd=0.8u as=0 ps=0 w=0.42u l=1u
X3858 VDD VSS.t897 VDD VDD sg13_lv_pmos ad=0.19p pd=1.38u as=0 ps=0 w=1u l=1u
X3859 VSS.t150 a_17219_16265# sg13g2_a21oi_1_0.A2 VSS.t323 sg13_lv_nmos ad=0.13395p pd=1.12u as=0.2516p ps=2.16u w=0.74u l=0.13u
X3860 VSS.t97 VDD VSS.t642 VSS.t25 sg13_lv_nmos ad=0.1428p pd=1.52u as=0 ps=0 w=0.42u l=1u
X3861 VSS.t2126 VDD VSS.t2128 VSS.t2127 sg13_lv_nmos ad=79.8f pd=0.8u as=0 ps=0 w=0.42u l=1u
X3862 sg13g2_a21oi_1_3.A1 a_25206_15302# VDD VDD sg13_lv_pmos ad=0.4256p pd=3u as=0.2254p ps=1.53u w=1.12u l=0.13u
X3863 VDD VSS.t620 VDD VDD sg13_lv_pmos ad=0.34p pd=2.68u as=0 ps=0 w=1u l=1u
X3864 VSS.t2860 VDD VSS.t2861 VSS.t412 sg13_lv_nmos ad=79.8f pd=0.8u as=0 ps=0 w=0.42u l=1u
X3865 a_6086_14922# sg13g2_and2_1_1.X VDD VDD sg13_lv_pmos ad=79.8f pd=0.8u as=0.1428p ps=1.52u w=0.42u l=0.13u
X3866 a_21034_14452# a_21477_14495# a_21417_14531# VDD sg13_lv_pmos ad=79.8f pd=0.8u as=63f ps=0.72u w=0.42u l=0.13u
X3867 VSS.t1629 VDD VSS.t1628 VSS.t1627 sg13_lv_nmos ad=0.1428p pd=1.52u as=0 ps=0 w=0.42u l=1u
X3868 VDD sg13g2_dfrbpq_1_7.RESET_B a_25670_14922# VDD sg13_lv_pmos ad=0.36237p pd=2.605u as=79.8f ps=0.8u w=0.42u l=0.13u
X3869 sg13g2_buf_16_2.X a_19438_13726# VDD VDD sg13_lv_pmos ad=0.2128p pd=1.5u as=0.2128p ps=1.5u w=1.12u l=0.13u
X3870 VSS.t100 VDD VSS.t100 VSS.t787 sg13_lv_nmos ad=79.8f pd=0.8u as=0 ps=0 w=0.42u l=1u
X3871 VSS.t1299 VDD VSS.t1298 VSS.t377 sg13_lv_nmos ad=0.1428p pd=1.52u as=0 ps=0 w=0.42u l=1u
X3872 VSS.t302 VDD VSS.t302 VSS.t679 sg13_lv_nmos ad=79.8f pd=0.8u as=0 ps=0 w=0.42u l=1u
X3873 VDD VSS.t1356 VDD VDD sg13_lv_pmos ad=0.34p pd=2.68u as=0 ps=0 w=1u l=1u
X3874 VDD VSS.t2861 VDD VDD sg13_lv_pmos ad=0.34p pd=2.68u as=0 ps=0 w=1u l=1u
X3875 VDD VSS.t2145 VDD VDD sg13_lv_pmos ad=0.34p pd=2.68u as=0 ps=0 w=1u l=1u
X3876 VDD VSS.t598 VDD VDD sg13_lv_pmos ad=0.19p pd=1.38u as=0 ps=0 w=1u l=1u
X3877 VSS.t1000 VDD VSS.t1002 VSS.t1001 sg13_lv_nmos ad=79.8f pd=0.8u as=0 ps=0 w=0.42u l=1u
X3878 VSS.t2373 VDD VSS.t2375 VSS.t2374 sg13_lv_nmos ad=79.8f pd=0.8u as=0 ps=0 w=0.42u l=1u
X3879 VSS.t769 VDD VSS.t769 VSS.t770 sg13_lv_nmos ad=79.8f pd=0.8u as=0 ps=0 w=0.42u l=1u
X3880 VSS.t1639 VDD VSS.t1641 VSS.t1640 sg13_lv_nmos ad=79.8f pd=0.8u as=0 ps=0 w=0.42u l=1u
X3881 VSS.t1819 VDD VSS.t1818 VSS.t1817 sg13_lv_nmos ad=0.1428p pd=1.52u as=0 ps=0 w=0.42u l=1u
X3882 VSS.t3165 VDD VSS.t3167 VSS.t3166 sg13_lv_nmos ad=79.8f pd=0.8u as=0 ps=0 w=0.42u l=1u
X3883 VDD VSS.t542 VDD VDD sg13_lv_pmos ad=0.19p pd=1.38u as=0 ps=0 w=1u l=1u
X3884 VDD VSS.t1828 VDD VDD sg13_lv_pmos ad=0.34p pd=2.68u as=0 ps=0 w=1u l=1u
X3885 a_19065_14607# a_18123_14495# a_18863_14845# VDD sg13_lv_pmos ad=93.45f pd=0.865u as=0.2048p ps=1.63u w=0.42u l=0.13u
X3886 VSS.t940 VDD VSS.t939 VSS.t938 sg13_lv_nmos ad=0.1428p pd=1.52u as=0 ps=0 w=0.42u l=1u
X3887 VSS.t1372 VDD VSS.t1370 VSS.t377 sg13_lv_nmos ad=0.1428p pd=1.52u as=0 ps=0 w=0.42u l=1u
X3888 VDD VSS.t3232 VDD VDD sg13_lv_pmos ad=0.19p pd=1.38u as=0 ps=0 w=1u l=1u
X3889 VSS.t2628 VDD VSS.t2627 VSS.t2626 sg13_lv_nmos ad=0.1428p pd=1.52u as=0 ps=0 w=0.42u l=1u
X3890 VSS.t2448 VDD VSS.t2450 VSS.t2449 sg13_lv_nmos ad=79.8f pd=0.8u as=0 ps=0 w=0.42u l=1u
X3891 a_2916_15552# a_2890_15457# VSS.t40 VSS.t156 sg13_lv_nmos ad=0.2516p pd=2.16u as=0.1626p ps=1.415u w=0.74u l=0.13u
X3892 sg13g2_o21ai_1_2.A2 sg13g2_dfrbpq_1_6.Q VDD VDD sg13_lv_pmos ad=0.3808p pd=2.92u as=0.2128p ps=1.5u w=1.12u l=0.13u
X3893 VDD VSS.t1658 VDD VDD sg13_lv_pmos ad=0.34p pd=2.68u as=0 ps=0 w=1u l=1u
X3894 VDD VSS.t1052 VDD VDD sg13_lv_pmos ad=0.19p pd=1.38u as=0 ps=0 w=1u l=1u
X3895 VDD VSS.t1344 VDD VDD sg13_lv_pmos ad=0.19p pd=1.38u as=0 ps=0 w=1u l=1u
X3896 VSS.t1729 VDD VSS.t1731 VSS.t1730 sg13_lv_nmos ad=79.8f pd=0.8u as=0 ps=0 w=0.42u l=1u
X3897 VDD VSS.t2806 VDD VDD sg13_lv_pmos ad=0.34p pd=2.68u as=0 ps=0 w=1u l=1u
X3898 VSS.t46 VDD VSS.t46 VSS.t635 sg13_lv_nmos ad=79.8f pd=0.8u as=0 ps=0 w=0.42u l=1u
X3899 VDD VSS.t715 VDD VDD sg13_lv_pmos ad=0.19p pd=1.38u as=0 ps=0 w=1u l=1u
X3900 sg13g2_buf_16_2.X a_19438_13726# VSS.t393 VSS.t396 sg13_lv_nmos ad=0.1406p pd=1.12u as=0.1406p ps=1.12u w=0.74u l=0.13u
X3901 VDD VSS.t302 VDD VDD sg13_lv_pmos ad=0.19p pd=1.38u as=0 ps=0 w=1u l=1u
X3902 VDD VSS.t1618 VDD VDD sg13_lv_pmos ad=0.34p pd=2.68u as=0 ps=0 w=1u l=1u
X3903 VSS.t302 VDD VSS.t302 VSS.t680 sg13_lv_nmos ad=0.1428p pd=1.52u as=0 ps=0 w=0.42u l=1u
X3904 VSS.t1313 VDD VSS.t1312 VSS.t377 sg13_lv_nmos ad=0.1428p pd=1.52u as=0 ps=0 w=0.42u l=1u
X3905 VDD VSS.t1376 VDD VDD sg13_lv_pmos ad=0.19p pd=1.38u as=0 ps=0 w=1u l=1u
X3906 VDD VSS.t2879 VDD VDD sg13_lv_pmos ad=0.19p pd=1.38u as=0 ps=0 w=1u l=1u
X3907 VSS.t520 VDD VSS.t519 VSS.t518 sg13_lv_nmos ad=0.1428p pd=1.52u as=0 ps=0 w=0.42u l=1u
X3908 VDD VSS.t989 VDD VDD sg13_lv_pmos ad=0.34p pd=2.68u as=0 ps=0 w=1u l=1u
X3909 VDD VSS.t1623 VDD VDD sg13_lv_pmos ad=0.34p pd=2.68u as=0 ps=0 w=1u l=1u
X3910 VDD VSS.t2532 VDD VDD sg13_lv_pmos ad=0.34p pd=2.68u as=0 ps=0 w=1u l=1u
X3911 VSS.t2593 VDD VSS.t2592 VSS.t2591 sg13_lv_nmos ad=0.1428p pd=1.52u as=0 ps=0 w=0.42u l=1u
X3912 a_2646_14842# sg13g2_xor2_1_0.B sg13g2_and2_1_0.B VSS.t161 sg13_lv_nmos ad=88.8f pd=0.98u as=0.1628p ps=1.18u w=0.74u l=0.13u
X3913 sg13g2_buf_16_2.X a_19438_13726# VDD VDD sg13_lv_pmos ad=0.2128p pd=1.5u as=0.2128p ps=1.5u w=1.12u l=0.13u
X3914 VSS.t970 VDD VSS.t969 VSS.t968 sg13_lv_nmos ad=0.1428p pd=1.52u as=0 ps=0 w=0.42u l=1u
X3915 VSS.t1381 VDD VSS.t1379 VSS.t377 sg13_lv_nmos ad=0.1428p pd=1.52u as=0 ps=0 w=0.42u l=1u
X3916 VSS.t585 VDD VSS.t586 VSS.t33 sg13_lv_nmos ad=79.8f pd=0.8u as=0 ps=0 w=0.42u l=1u
X3917 VDD VSS.t3099 VDD VDD sg13_lv_pmos ad=0.34p pd=2.68u as=0 ps=0 w=1u l=1u
X3918 VSS.t2423 VDD VSS.t2422 VSS.t2421 sg13_lv_nmos ad=0.1428p pd=1.52u as=0 ps=0 w=0.42u l=1u
X3919 VDD VSS.t1965 VDD VDD sg13_lv_pmos ad=0.34p pd=2.68u as=0 ps=0 w=1u l=1u
X3920 VSS.t2141 VDD VSS.t2140 VSS.t2139 sg13_lv_nmos ad=0.1428p pd=1.52u as=0 ps=0 w=0.42u l=1u
X3921 VSS.t551 VDD VSS.t547 VSS.t550 sg13_lv_nmos ad=0.1428p pd=1.52u as=0 ps=0 w=0.42u l=1u
X3922 a_23638_14862# sg13g2_o21ai_1_2.A2 VSS.t137 VSS.t30 sg13_lv_nmos ad=0.1406p pd=1.12u as=0.1406p ps=1.12u w=0.74u l=0.15u
X3923 VSS.t302 VDD VSS.t302 VSS.t713 sg13_lv_nmos ad=0.1428p pd=1.52u as=0 ps=0 w=0.42u l=1u
X3924 a_3273_15625# a_2916_15552# VDD VDD sg13_lv_pmos ad=63f pd=0.72u as=0.1563p ps=1.22u w=0.42u l=0.13u
X3925 VSS.t1140 VDD VSS.t1139 VSS.t1138 sg13_lv_nmos ad=0.1428p pd=1.52u as=0 ps=0 w=0.42u l=1u
X3926 VDD VSS.t1324 VDD VDD sg13_lv_pmos ad=0.34p pd=2.68u as=0 ps=0 w=1u l=1u
X3927 VDD VSS.t2497 VDD VDD sg13_lv_pmos ad=0.34p pd=2.68u as=0 ps=0 w=1u l=1u
X3928 VDD sg13g2_buf_16_2.A a_19438_13726# VDD sg13_lv_pmos ad=0.2128p pd=1.5u as=0.2128p ps=1.5u w=1.12u l=0.13u
X3929 VSS.t1030 VDD VSS.t1032 VSS.t1031 sg13_lv_nmos ad=79.8f pd=0.8u as=0 ps=0 w=0.42u l=1u
X3930 VSS.t1399 VDD VSS.t1398 VSS.t377 sg13_lv_nmos ad=0.1428p pd=1.52u as=0 ps=0 w=0.42u l=1u
X3931 VDD VSS.t2008 VDD VDD sg13_lv_pmos ad=0.19p pd=1.38u as=0 ps=0 w=1u l=1u
X3932 a_17578_14452# a_18021_14495# a_17961_14531# VDD sg13_lv_pmos ad=79.8f pd=0.8u as=63f ps=0.72u w=0.42u l=0.13u
X3933 VSS.t1689 VDD VSS.t1688 VSS.t1687 sg13_lv_nmos ad=0.1428p pd=1.52u as=0 ps=0 w=0.42u l=1u
X3934 VDD VSS.t2842 VDD VDD sg13_lv_pmos ad=0.19p pd=1.38u as=0 ps=0 w=1u l=1u
X3935 a_9861_15213# sg13g2_dfrbpq_1_2.CLK VDD VDD sg13_lv_pmos ad=0.4088p pd=2.97u as=2.77542p ps=17.49u w=1.12u l=0.13u
X3936 VSS.t2393 VDD VSS.t2395 VSS.t2394 sg13_lv_nmos ad=79.8f pd=0.8u as=0 ps=0 w=0.42u l=1u
X3937 VSS.t720 VDD VSS.t720 VSS.t840 sg13_lv_nmos ad=0.1428p pd=1.52u as=0 ps=0 w=0.42u l=1u
X3938 VDD VSS.t1603 VDD VDD sg13_lv_pmos ad=0.34p pd=2.68u as=0 ps=0 w=1u l=1u
X3939 VDD VSS.t952 VDD VDD sg13_lv_pmos ad=0.19p pd=1.38u as=0 ps=0 w=1u l=1u
X3940 VSS.t1539 VDD VSS.t1403 VSS.t377 sg13_lv_nmos ad=0.1428p pd=1.52u as=0 ps=0 w=0.42u l=1u
X3941 VSS.t1684 VDD VSS.t1683 VSS.t1682 sg13_lv_nmos ad=0.1428p pd=1.52u as=0 ps=0 w=0.42u l=1u
X3942 VSS.t2433 VDD VSS.t2435 VSS.t2434 sg13_lv_nmos ad=79.8f pd=0.8u as=0 ps=0 w=0.42u l=1u
X3943 VSS.t2241 VDD VSS.t2243 VSS.t2242 sg13_lv_nmos ad=79.8f pd=0.8u as=0 ps=0 w=0.42u l=1u
X3944 VDD a_26554_16237# sg13g2_dfrbpq_1_5.RESET_B VDD sg13_lv_pmos ad=2.8961p pd=18.25u as=0.3927p ps=2.99u w=1.155u l=0.13u
X3945 VSS.t1434 VDD VSS.t1435 VSS.t377 sg13_lv_nmos ad=79.8f pd=0.8u as=0 ps=0 w=0.42u l=1u
X3946 VDD VSS.t1347 VDD VDD sg13_lv_pmos ad=0.34p pd=2.68u as=0 ps=0 w=1u l=1u
X3947 VDD VSS.t2853 VDD VDD sg13_lv_pmos ad=0.34p pd=2.68u as=0 ps=0 w=1u l=1u
X3948 VSS.t2161 VDD VSS.t2160 VSS.t2159 sg13_lv_nmos ad=0.1428p pd=1.52u as=0 ps=0 w=0.42u l=1u
X3949 VSS.t271 a_7532_15960# counter_value_o[1] VSS.t319 sg13_lv_nmos ad=0.14875p pd=1.16u as=0.2886p ps=2.26u w=0.74u l=0.13u
X3950 VDD VSS.t2158 VDD VDD sg13_lv_pmos ad=0.19p pd=1.38u as=0 ps=0 w=1u l=1u
X3951 VSS.t1804 VDD VSS.t1803 VSS.t1802 sg13_lv_nmos ad=0.1428p pd=1.52u as=0 ps=0 w=0.42u l=1u
X3952 VDD VSS.t302 VDD VDD sg13_lv_pmos ad=0.19p pd=1.38u as=0 ps=0 w=1u l=1u
X3953 VDD VSS.t1303 VDD VDD sg13_lv_pmos ad=0.19p pd=1.38u as=0 ps=0 w=1u l=1u
X3954 VSS.t454 VDD VSS.t449 VSS.t453 sg13_lv_nmos ad=0.1428p pd=1.52u as=0 ps=0 w=0.42u l=1u
X3955 VSS.t618 VDD VSS.t619 VSS.t33 sg13_lv_nmos ad=79.8f pd=0.8u as=0 ps=0 w=0.42u l=1u
X3956 VDD VSS.t1159 VDD VDD sg13_lv_pmos ad=0.34p pd=2.68u as=0 ps=0 w=1u l=1u
X3957 VSS.t2613 VDD VSS.t2612 VSS.t2611 sg13_lv_nmos ad=0.1428p pd=1.52u as=0 ps=0 w=0.42u l=1u
X3958 VSS.t490 VDD VSS.t489 VSS.t488 sg13_lv_nmos ad=0.1428p pd=1.52u as=0 ps=0 w=0.42u l=1u
X3959 VDD VSS.t1643 VDD VDD sg13_lv_pmos ad=0.34p pd=2.68u as=0 ps=0 w=1u l=1u
X3960 VDD VSS.t1993 VDD VDD sg13_lv_pmos ad=0.19p pd=1.38u as=0 ps=0 w=1u l=1u
X3961 VSS.t3019 VDD VSS.t2898 VSS.t412 sg13_lv_nmos ad=79.8f pd=0.8u as=0 ps=0 w=0.42u l=1u
X3962 VDD VSS.t2835 VDD VDD sg13_lv_pmos ad=0.19p pd=1.38u as=0 ps=0 w=1u l=1u
X3963 VSS.t2111 VDD VSS.t2110 VSS.t2109 sg13_lv_nmos ad=0.1428p pd=1.52u as=0 ps=0 w=0.42u l=1u
X3964 VDD VSS.t766 VDD VDD sg13_lv_pmos ad=0.34p pd=2.68u as=0 ps=0 w=1u l=1u
X3965 VDD VSS.t919 VDD VDD sg13_lv_pmos ad=0.34p pd=2.68u as=0 ps=0 w=1u l=1u
X3966 VSS.t1714 VDD VSS.t1716 VSS.t1715 sg13_lv_nmos ad=79.8f pd=0.8u as=0 ps=0 w=0.42u l=1u
X3967 VSS.t2844 VDD VSS.t2845 VSS.t412 sg13_lv_nmos ad=79.8f pd=0.8u as=0 ps=0 w=0.42u l=1u
X3968 VDD VSS.t2585 VDD VDD sg13_lv_pmos ad=0.19p pd=1.38u as=0 ps=0 w=1u l=1u
X3969 VDD a_19054_15423# sg13g2_dlygate4sd3_1_6.X VDD sg13_lv_pmos ad=0.2254p pd=1.53u as=0.4256p ps=3u w=1.12u l=0.13u
X3970 VSS.t576 VDD VSS.t577 VSS.t33 sg13_lv_nmos ad=79.8f pd=0.8u as=0 ps=0 w=0.42u l=1u
X3971 VDD VSS.t1034 VDD VDD sg13_lv_pmos ad=0.34p pd=2.68u as=0 ps=0 w=1u l=1u
X3972 VSS.t1417 VDD VSS.t1416 VSS.t377 sg13_lv_nmos ad=0.1428p pd=1.52u as=0 ps=0 w=0.42u l=1u
X3973 VSS.t1634 VDD VSS.t1633 VSS.t1632 sg13_lv_nmos ad=0.1428p pd=1.52u as=0 ps=0 w=0.42u l=1u
X3974 VDD VSS.t2360 VDD VDD sg13_lv_pmos ad=0.19p pd=1.38u as=0 ps=0 w=1u l=1u
X3975 VSS.t2191 VDD VSS.t2193 VSS.t2192 sg13_lv_nmos ad=79.8f pd=0.8u as=0 ps=0 w=0.42u l=1u
X3976 VDD VSS.t1359 VDD VDD sg13_lv_pmos ad=0.34p pd=2.68u as=0 ps=0 w=1u l=1u
X3977 VDD VSS.t2845 VDD VDD sg13_lv_pmos ad=0.34p pd=2.68u as=0 ps=0 w=1u l=1u
X3978 VDD VSS.t2150 VDD VDD sg13_lv_pmos ad=0.34p pd=2.68u as=0 ps=0 w=1u l=1u
X3979 VSS.t2408 VDD VSS.t2407 VSS.t2406 sg13_lv_nmos ad=0.1428p pd=1.52u as=0 ps=0 w=0.42u l=1u
X3980 VSS.t33 a_5687_15315# a_5687_15315# VSS.t96 sg13_lv_nmos ad=5.4375p pd=36.05u as=0.111p ps=1.34u w=0.3u l=0.13u
X3981 VDD VSS.t972 VDD VDD sg13_lv_pmos ad=0.19p pd=1.38u as=0 ps=0 w=1u l=1u
X3982 VSS.t2786 VDD VSS.t2788 VSS.t412 sg13_lv_nmos ad=79.8f pd=0.8u as=0 ps=0 w=0.42u l=1u
X3983 VSS.t2378 VDD VSS.t2380 VSS.t2379 sg13_lv_nmos ad=79.8f pd=0.8u as=0 ps=0 w=0.42u l=1u
X3984 VSS.t3170 VDD VSS.t3172 VSS.t3171 sg13_lv_nmos ad=79.8f pd=0.8u as=0 ps=0 w=0.42u l=1u
X3985 VSS.t1140 VDD VSS.t1139 VSS.t1138 sg13_lv_nmos ad=0.1428p pd=1.52u as=0 ps=0 w=0.42u l=1u
X3986 VDD VSS.t1395 VDD VDD sg13_lv_pmos ad=0.19p pd=1.38u as=0 ps=0 w=1u l=1u
X3987 VDD VSS.t934 VDD VDD sg13_lv_pmos ad=0.34p pd=2.68u as=0 ps=0 w=1u l=1u
X3988 VDD VSS.t1798 VDD VDD sg13_lv_pmos ad=0.34p pd=2.68u as=0 ps=0 w=1u l=1u
X3989 VSS.t728 VDD VSS.t728 VSS.t729 sg13_lv_nmos ad=79.8f pd=0.8u as=0 ps=0 w=0.42u l=1u
X3990 VSS.t1343 VDD VSS.t1344 VSS.t377 sg13_lv_nmos ad=79.8f pd=0.8u as=0 ps=0 w=0.42u l=1u
X3991 VSS.t465 VDD VSS.t465 VSS.t468 sg13_lv_nmos ad=79.8f pd=0.8u as=0 ps=0 w=0.42u l=1u
X3992 VDD VSS.t1663 VDD VDD sg13_lv_pmos ad=0.34p pd=2.68u as=0 ps=0 w=1u l=1u
X3993 VSS.t2021 VDD VSS.t2023 VSS.t2022 sg13_lv_nmos ad=79.8f pd=0.8u as=0 ps=0 w=0.42u l=1u
X3994 VDD VSS.t2809 VDD VDD sg13_lv_pmos ad=0.34p pd=2.68u as=0 ps=0 w=1u l=1u
X3995 VSS.t1430 VDD VSS.t1560 VSS.t377 sg13_lv_nmos ad=0.1428p pd=1.52u as=0 ps=0 w=0.42u l=1u
X3996 a_9158_15234# sg13g2_and2_1_2.X VDD VDD sg13_lv_pmos ad=79.8f pd=0.8u as=0.1428p ps=1.52u w=0.42u l=0.13u
X3997 VSS.t186 sg13g2_and2_1_0.B a_2059_14832# VSS.t185 sg13_lv_nmos ad=0.1331p pd=1.12u as=0.1216p ps=1.02u w=0.64u l=0.13u
X3998 VDD VSS.t700 VDD VDD sg13_lv_pmos ad=0.34p pd=2.68u as=0 ps=0 w=1u l=1u
X3999 VSS.t945 VDD VSS.t947 VSS.t946 sg13_lv_nmos ad=79.8f pd=0.8u as=0 ps=0 w=0.42u l=1u
X4000 VSS.t1619 VDD VSS.t1618 VSS.t1617 sg13_lv_nmos ad=0.1428p pd=1.52u as=0 ps=0 w=0.42u l=1u
X4001 VDD VSS.t1004 VDD VDD sg13_lv_pmos ad=0.34p pd=2.68u as=0 ps=0 w=1u l=1u
X4002 VDD VSS.t1379 VDD VDD sg13_lv_pmos ad=0.19p pd=1.38u as=0 ps=0 w=1u l=1u
X4003 VSS.t2226 VDD VSS.t2228 VSS.t2227 sg13_lv_nmos ad=79.8f pd=0.8u as=0 ps=0 w=0.42u l=1u
X4004 VDD VSS.t2183 VDD VDD sg13_lv_pmos ad=0.19p pd=1.38u as=0 ps=0 w=1u l=1u
X4005 VDD VSS.t1628 VDD VDD sg13_lv_pmos ad=0.34p pd=2.68u as=0 ps=0 w=1u l=1u
X4006 VSS.t2820 VDD VSS.t2819 VSS.t412 sg13_lv_nmos ad=0.1428p pd=1.52u as=0 ps=0 w=0.42u l=1u
X4007 VDD VSS.t2537 VDD VDD sg13_lv_pmos ad=0.34p pd=2.68u as=0 ps=0 w=1u l=1u
X4008 VSS.t2598 VDD VSS.t2597 VSS.t2596 sg13_lv_nmos ad=0.1428p pd=1.52u as=0 ps=0 w=0.42u l=1u
X4009 VSS.t826 VDD VSS.t178 VSS.t827 sg13_lv_nmos ad=79.8f pd=0.8u as=0 ps=0 w=0.42u l=1u
X4010 VDD VSS.t749 VDD VDD sg13_lv_pmos ad=0.34p pd=2.68u as=0 ps=0 w=1u l=1u
X4011 VDD VSS.t3104 VDD VDD sg13_lv_pmos ad=0.34p pd=2.68u as=0 ps=0 w=1u l=1u
X4012 a_10222_14751# a_10337_14750# VSS.t22 VSS.t224 sg13_lv_nmos ad=0.1428p pd=1.52u as=0.1426p ps=1.16u w=0.42u l=0.5u
X4013 VSS.t2146 VDD VSS.t2145 VSS.t2144 sg13_lv_nmos ad=0.1428p pd=1.52u as=0 ps=0 w=0.42u l=1u
X4014 VSS.t2363 VDD VSS.t2365 VSS.t2364 sg13_lv_nmos ad=79.8f pd=0.8u as=0 ps=0 w=0.42u l=1u
X4015 VSS.t2096 VDD VSS.t2098 VSS.t2097 sg13_lv_nmos ad=79.8f pd=0.8u as=0 ps=0 w=0.42u l=1u
X4016 VDD VSS.t302 VDD VDD sg13_lv_pmos ad=0.19p pd=1.38u as=0 ps=0 w=1u l=1u
X4017 VDD VSS.t1089 VDD VDD sg13_lv_pmos ad=0.34p pd=2.68u as=0 ps=0 w=1u l=1u
X4018 VDD VSS.t1641 VDD VDD sg13_lv_pmos ad=0.19p pd=1.38u as=0 ps=0 w=1u l=1u
X4019 VSS.t2438 VDD VSS.t2440 VSS.t2439 sg13_lv_nmos ad=79.8f pd=0.8u as=0 ps=0 w=0.42u l=1u
X4020 VDD VSS.t2238 VDD VDD sg13_lv_pmos ad=0.19p pd=1.38u as=0 ps=0 w=1u l=1u
X4021 VDD VSS.t158 VDD VDD sg13_lv_pmos ad=0.34p pd=2.68u as=0 ps=0 w=1u l=1u
X4022 VSS.t302 VDD VSS.t302 VSS.t679 sg13_lv_nmos ad=79.8f pd=0.8u as=0 ps=0 w=0.42u l=1u
X4023 a_25037_14020# sg13g2_or3_1_1.B a_24935_14020# VDD sg13_lv_pmos ad=0.1575p pd=1.315u as=0.19p ps=1.38u w=1u l=0.13u
X4024 VDD VSS.t1978 VDD VDD sg13_lv_pmos ad=0.19p pd=1.38u as=0 ps=0 w=1u l=1u
X4025 VSS.t2889 VDD VSS.t2890 VSS.t412 sg13_lv_nmos ad=79.8f pd=0.8u as=0 ps=0 w=0.42u l=1u
X4026 VDD VSS.t2770 VDD VDD sg13_lv_pmos ad=0.19p pd=1.38u as=0 ps=0 w=1u l=1u
X4027 VDD a_26638_15423# sg13g2_o21ai_1_2.B1 VDD sg13_lv_pmos ad=0.2254p pd=1.53u as=0.4256p ps=3u w=1.12u l=0.13u
X4028 VDD VSS.t1412 VDD VDD sg13_lv_pmos ad=0.19p pd=1.38u as=0 ps=0 w=1u l=1u
X4029 VSS.t1659 VDD VSS.t1658 VSS.t1657 sg13_lv_nmos ad=0.1428p pd=1.52u as=0 ps=0 w=0.42u l=1u
X4030 VSS.t3185 VDD VSS.t3184 VSS.t3183 sg13_lv_nmos ad=0.1428p pd=1.52u as=0 ps=0 w=0.42u l=1u
X4031 VSS.t2393 VDD VSS.t2392 VSS.t2391 sg13_lv_nmos ad=0.1428p pd=1.52u as=0 ps=0 w=0.42u l=1u
X4032 a_7262_15242# sg13g2_buf_1_0.X a_7160_15242# VSS.t38 sg13_lv_nmos ad=0.1406p pd=1.12u as=0.1406p ps=1.12u w=0.74u l=0.13u
X4033 VDD a_6682_13690# a_6401_13912# VDD sg13_lv_pmos ad=0.1523p pd=1.38u as=0.34p ps=2.68u w=1u l=0.5u
X4034 VSS.t746 VDD VSS.t746 VSS.t747 sg13_lv_nmos ad=79.8f pd=0.8u as=0 ps=0 w=0.42u l=1u
X4035 VDD VSS.t1152 VDD VDD sg13_lv_pmos ad=0.19p pd=1.38u as=0 ps=0 w=1u l=1u
X4036 VSS.t2865 VDD VSS.t2864 VSS.t412 sg13_lv_nmos ad=0.1428p pd=1.52u as=0 ps=0 w=0.42u l=1u
X4037 VSS.t603 VDD VSS.t604 VSS.t33 sg13_lv_nmos ad=79.8f pd=0.8u as=0 ps=0 w=0.42u l=1u
X4038 VSS.t547 VDD VSS.t547 VSS.t549 sg13_lv_nmos ad=79.8f pd=0.8u as=0 ps=0 w=0.42u l=1u
X4039 VDD VSS.t18 VDD VDD sg13_lv_pmos ad=0.19p pd=1.38u as=0 ps=0 w=1u l=1u
X4040 VDD VSS.t1781 VDD VDD sg13_lv_pmos ad=0.19p pd=1.38u as=0 ps=0 w=1u l=1u
X4041 VSS.t302 VDD VSS.t302 VSS.t810 sg13_lv_nmos ad=0.1428p pd=1.52u as=0 ps=0 w=0.42u l=1u
X4042 VDD VSS.t2135 VDD VDD sg13_lv_pmos ad=0.34p pd=2.68u as=0 ps=0 w=1u l=1u
X4043 VDD VSS.t100 VDD VDD sg13_lv_pmos ad=0.34p pd=2.68u as=0 ps=0 w=1u l=1u
X4044 VDD VSS.t1420 VDD VDD sg13_lv_pmos ad=0.19p pd=1.38u as=0 ps=0 w=1u l=1u
X4045 a_22738_14922# sg13g2_dfrbpq_1_6.RESET_B VSS.t29 VSS.t30 sg13_lv_nmos ad=37.8f pd=0.6u as=79.8f ps=0.8u w=0.42u l=0.13u
X4046 VDD a_4175_15311# a_4432_15454# VDD sg13_lv_pmos ad=2.8961p pd=18.25u as=79.8f ps=0.8u w=0.42u l=0.13u
X4047 VSS.t756 VDD VSS.t758 VSS.t757 sg13_lv_nmos ad=79.8f pd=0.8u as=0 ps=0 w=0.42u l=1u
X4048 VSS.t1292 VDD VSS.t1291 VSS.t377 sg13_lv_nmos ad=0.1428p pd=1.52u as=0 ps=0 w=0.42u l=1u
X4049 VSS.t1401 VDD VSS.t1402 VSS.t377 sg13_lv_nmos ad=79.8f pd=0.8u as=0 ps=0 w=0.42u l=1u
X4050 VSS.t2583 VDD VSS.t2582 VSS.t2581 sg13_lv_nmos ad=0.1428p pd=1.52u as=0 ps=0 w=0.42u l=1u
X4051 VSS.t1050 VDD VSS.t1052 VSS.t1051 sg13_lv_nmos ad=79.8f pd=0.8u as=0 ps=0 w=0.42u l=1u
X4052 VDD VSS.t2400 VDD VDD sg13_lv_pmos ad=0.19p pd=1.38u as=0 ps=0 w=1u l=1u
X4053 VDD sg13g2_buf_16_2.A a_12020_15202# VDD sg13_lv_pmos ad=0.3808p pd=2.92u as=0.2128p ps=1.5u w=1.12u l=0.13u
X4054 a_26565_13701# sg13g2_buf_16_2.X VDD VDD sg13_lv_pmos ad=0.4088p pd=2.97u as=2.3367p ps=15.135u w=1.12u l=0.13u
X4055 VDD VSS.t1648 VDD VDD sg13_lv_pmos ad=0.34p pd=2.68u as=0 ps=0 w=1u l=1u
X4056 VSS.t2881 VDD VSS.t2882 VSS.t412 sg13_lv_nmos ad=79.8f pd=0.8u as=0 ps=0 w=0.42u l=1u
X4057 VDD VSS.t1119 VDD VDD sg13_lv_pmos ad=0.34p pd=2.68u as=0 ps=0 w=1u l=1u
X4058 VDD VSS.t448 VDD VDD sg13_lv_pmos ad=0.34p pd=2.68u as=0 ps=0 w=1u l=1u
X4059 VSS.t945 VDD VSS.t947 VSS.t946 sg13_lv_nmos ad=79.8f pd=0.8u as=0 ps=0 w=0.42u l=1u
X4060 VDD VSS.t1688 VDD VDD sg13_lv_pmos ad=0.34p pd=2.68u as=0 ps=0 w=1u l=1u
X4061 VSS.t2006 VDD VSS.t2008 VSS.t2007 sg13_lv_nmos ad=79.8f pd=0.8u as=0 ps=0 w=0.42u l=1u
X4062 VSS.t585 VDD VSS.t584 VSS.t33 sg13_lv_nmos ad=0.1428p pd=1.52u as=0 ps=0 w=0.42u l=1u
X4063 VDD VSS.t700 VDD VDD sg13_lv_pmos ad=0.34p pd=2.68u as=0 ps=0 w=1u l=1u
X4064 VSS.t1719 VDD VSS.t1721 VSS.t1720 sg13_lv_nmos ad=79.8f pd=0.8u as=0 ps=0 w=0.42u l=1u
X4065 VSS.t2847 VDD VSS.t2848 VSS.t412 sg13_lv_nmos ad=79.8f pd=0.8u as=0 ps=0 w=0.42u l=1u
X4066 VDD VSS.t1370 VDD VDD sg13_lv_pmos ad=0.19p pd=1.38u as=0 ps=0 w=1u l=1u
X4067 VSS.t1604 VDD VSS.t1603 VSS.t1602 sg13_lv_nmos ad=0.1428p pd=1.52u as=0 ps=0 w=0.42u l=1u
X4068 a_12524_15960# sg13g2_dlygate4sd3_1_8.A VDD VDD sg13_lv_pmos ad=0.2856p pd=2.36u as=0.2114p ps=1.54u w=0.84u l=0.13u
X4069 a_17529_14037# a_16587_13844# a_17327_13799# VDD sg13_lv_pmos ad=93.45f pd=0.865u as=0.2048p ps=1.63u w=0.42u l=0.13u
X4070 VSS.t2196 VDD VSS.t2198 VSS.t2197 sg13_lv_nmos ad=79.8f pd=0.8u as=0 ps=0 w=0.42u l=1u
X4071 VDD VSS.t720 VDD VDD sg13_lv_pmos ad=0.19p pd=1.38u as=0 ps=0 w=1u l=1u
X4072 VDD VSS.t1341 VDD VDD sg13_lv_pmos ad=0.34p pd=2.68u as=0 ps=0 w=1u l=1u
X4073 VDD VSS.t2848 VDD VDD sg13_lv_pmos ad=0.34p pd=2.68u as=0 ps=0 w=1u l=1u
X4074 VDD VSS.t2120 VDD VDD sg13_lv_pmos ad=0.34p pd=2.68u as=0 ps=0 w=1u l=1u
X4075 VSS.t2413 VDD VSS.t2412 VSS.t2411 sg13_lv_nmos ad=0.1428p pd=1.52u as=0 ps=0 w=0.42u l=1u
X4076 VDD VSS.t384 VDD VDD sg13_lv_pmos ad=0.19p pd=1.38u as=0 ps=0 w=1u l=1u
X4077 VSS.t525 VDD VSS.t524 VSS.t523 sg13_lv_nmos ad=0.1428p pd=1.52u as=0 ps=0 w=0.42u l=1u
X4078 VSS.t737 VDD VSS.t734 VSS.t736 sg13_lv_nmos ad=0.1428p pd=1.52u as=0 ps=0 w=0.42u l=1u
X4079 VSS.t2863 VDD VSS.t2862 VSS.t412 sg13_lv_nmos ad=0.1428p pd=1.52u as=0 ps=0 w=0.42u l=1u
X4080 VSS.t84 a_10703_15311# a_11370_15532# VSS.t430 sg13_lv_nmos ad=0.1406p pd=1.12u as=0.2516p ps=2.16u w=0.74u l=0.13u
X4081 a_21827_13690# sg13g2_or3_1_2.C VSS.t27 VSS.t26 sg13_lv_nmos ad=0.187p pd=1.78u as=0.1045p ps=0.93u w=0.55u l=0.13u
X4082 VDD VSS.t2038 VDD VDD sg13_lv_pmos ad=0.19p pd=1.38u as=0 ps=0 w=1u l=1u
X4083 VSS.t2081 VDD VSS.t2083 VSS.t2082 sg13_lv_nmos ad=79.8f pd=0.8u as=0 ps=0 w=0.42u l=1u
X4084 VSS.t588 VDD VSS.t589 VSS.t33 sg13_lv_nmos ad=79.8f pd=0.8u as=0 ps=0 w=0.42u l=1u
X4085 a_6346_14452# a_6789_14495# a_6086_14922# VSS.t111 sg13_lv_nmos ad=79.8f pd=0.8u as=0.1296p ps=1.52u w=0.42u l=0.13u
X4086 VSS.t1384 VDD VSS.t1383 VSS.t377 sg13_lv_nmos ad=0.1428p pd=1.52u as=0 ps=0 w=0.42u l=1u
X4087 VDD VSS.t1803 VDD VDD sg13_lv_pmos ad=0.34p pd=2.68u as=0 ps=0 w=1u l=1u
X4088 VSS.t2603 VDD VSS.t2602 VSS.t2601 sg13_lv_nmos ad=0.1428p pd=1.52u as=0 ps=0 w=0.42u l=1u
X4089 VSS.t2423 VDD VSS.t2425 VSS.t2424 sg13_lv_nmos ad=79.8f pd=0.8u as=0 ps=0 w=0.42u l=1u
X4090 a_16955_12972# sg13g2_a21oi_1_0.A2 VDD VDD sg13_lv_pmos ad=0.3808p pd=2.92u as=0.2128p ps=1.5u w=1.12u l=0.13u
X4091 VDD VSS.t2385 VDD VDD sg13_lv_pmos ad=0.19p pd=1.38u as=0 ps=0 w=1u l=1u
X4092 VDD VSS.t2223 VDD VDD sg13_lv_pmos ad=0.19p pd=1.38u as=0 ps=0 w=1u l=1u
X4093 VDD a_12020_15202# sg13g2_dfrbpq_1_2.CLK VDD sg13_lv_pmos ad=0.2128p pd=1.5u as=0.2128p ps=1.5u w=1.12u l=0.13u
X4094 VDD VSS.t2175 VDD VDD sg13_lv_pmos ad=0.34p pd=2.68u as=0 ps=0 w=1u l=1u
X4095 VDD VSS.t3302 VDD VDD sg13_lv_pmos ad=0.19p pd=1.38u as=0 ps=0 w=1u l=1u
X4096 VSS.t1991 VDD VSS.t1993 VSS.t1992 sg13_lv_nmos ad=79.8f pd=0.8u as=0 ps=0 w=0.42u l=1u
X4097 VSS.t2857 VDD VSS.t2856 VSS.t412 sg13_lv_nmos ad=0.1428p pd=1.52u as=0 ps=0 w=0.42u l=1u
X4098 VDD VSS.t2811 VDD VDD sg13_lv_pmos ad=0.34p pd=2.68u as=0 ps=0 w=1u l=1u
X4099 VSS.t302 VDD VSS.t302 VSS.t674 sg13_lv_nmos ad=0.1428p pd=1.52u as=0 ps=0 w=0.42u l=1u
X4100 VSS.t401 VDD VSS.t398 VSS.t832 sg13_lv_nmos ad=0.1428p pd=1.52u as=0 ps=0 w=0.42u l=1u
X4101 VDD VSS.t1009 VDD VDD sg13_lv_pmos ad=0.34p pd=2.68u as=0 ps=0 w=1u l=1u
X4102 VSS.t2231 VDD VSS.t2233 VSS.t2232 sg13_lv_nmos ad=79.8f pd=0.8u as=0 ps=0 w=0.42u l=1u
X4103 VSS.t597 VDD VSS.t598 VSS.t33 sg13_lv_nmos ad=79.8f pd=0.8u as=0 ps=0 w=0.42u l=1u
X4104 VDD VSS.t1633 VDD VDD sg13_lv_pmos ad=0.34p pd=2.68u as=0 ps=0 w=1u l=1u
X4105 VDD VSS.t2542 VDD VDD sg13_lv_pmos ad=0.34p pd=2.68u as=0 ps=0 w=1u l=1u
X4106 sg13g2_dlygate4sd3_1_3.A a_4842_15532# VDD VDD sg13_lv_pmos ad=0.3808p pd=2.92u as=0.2128p ps=1.5u w=1.12u l=0.13u
X4107 VSS.t1734 VDD VSS.t1733 VSS.t1732 sg13_lv_nmos ad=0.1428p pd=1.52u as=0 ps=0 w=0.42u l=1u
X4108 VDD VSS.t2490 VDD VDD sg13_lv_pmos ad=0.19p pd=1.38u as=0 ps=0 w=1u l=1u
X4109 VSS.t2151 VDD VSS.t2150 VSS.t2149 sg13_lv_nmos ad=0.1428p pd=1.52u as=0 ps=0 w=0.42u l=1u
X4110 VSS.t3 a_18377_16334# a_18298_16237# VSS.t140 sg13_lv_nmos ad=5.24677p pd=34.365u as=0.27427p ps=2.28u w=0.795u l=0.13u
X4111 VSS.t2855 VDD VSS.t2854 VSS.t412 sg13_lv_nmos ad=0.1428p pd=1.52u as=0 ps=0 w=0.42u l=1u
X4112 VSS.t24 a_15022_14484# sg13g2_buf_16_2.A VSS.t229 sg13_lv_nmos ad=0.1406p pd=1.12u as=0.1406p ps=1.12u w=0.74u l=0.13u
X4113 VSS.t1020 VDD VSS.t1022 VSS.t1021 sg13_lv_nmos ad=79.8f pd=0.8u as=0 ps=0 w=0.42u l=1u
X4114 VSS.t24 a_15022_14484# sg13g2_buf_16_2.A VSS.t241 sg13_lv_nmos ad=0.2516p pd=2.16u as=0.1406p ps=1.12u w=0.74u l=0.13u
X4115 VDD VSS.t1336 VDD VDD sg13_lv_pmos ad=0.34p pd=2.68u as=0 ps=0 w=1u l=1u
X4116 VDD VSS.t40 VDD VDD sg13_lv_pmos ad=0.34p pd=2.68u as=0 ps=0 w=1u l=1u
X4117 VSS.t1050 VDD VSS.t1052 VSS.t1051 sg13_lv_nmos ad=79.8f pd=0.8u as=0 ps=0 w=0.42u l=1u
X4118 a_7631_14845# a_6789_14495# a_6372_14488# VDD sg13_lv_pmos ad=0.2048p pd=1.63u as=0.34p ps=2.68u w=1u l=0.13u
X4119 VDD VSS.t2208 VDD VDD sg13_lv_pmos ad=0.19p pd=1.38u as=0 ps=0 w=1u l=1u
X4120 VSS.t2026 VDD VSS.t2028 VSS.t2027 sg13_lv_nmos ad=79.8f pd=0.8u as=0 ps=0 w=0.42u l=1u
X4121 VDD VSS.t1983 VDD VDD sg13_lv_pmos ad=0.19p pd=1.38u as=0 ps=0 w=1u l=1u
X4122 VDD VSS.t2773 VDD VDD sg13_lv_pmos ad=0.19p pd=1.38u as=0 ps=0 w=1u l=1u
X4123 VDD VSS.t2829 VDD VDD sg13_lv_pmos ad=0.19p pd=1.38u as=0 ps=0 w=1u l=1u
X4124 VDD a_12020_15202# sg13g2_dfrbpq_1_2.CLK VDD sg13_lv_pmos ad=0.2128p pd=1.5u as=0.2128p ps=1.5u w=1.12u l=0.13u
X4125 VSS.t1664 VDD VSS.t1663 VSS.t1662 sg13_lv_nmos ad=0.1428p pd=1.52u as=0 ps=0 w=0.42u l=1u
X4126 VSS.t3190 VDD VSS.t3189 VSS.t3188 sg13_lv_nmos ad=0.1428p pd=1.52u as=0 ps=0 w=0.42u l=1u
X4127 VSS.t2398 VDD VSS.t2397 VSS.t2396 sg13_lv_nmos ad=0.1428p pd=1.52u as=0 ps=0 w=0.42u l=1u
X4128 VSS.t2568 VDD VSS.t2570 VSS.t2569 sg13_lv_nmos ad=79.8f pd=0.8u as=0 ps=0 w=0.42u l=1u
X4129 VDD VSS.t1374 VDD VDD sg13_lv_pmos ad=0.19p pd=1.38u as=0 ps=0 w=1u l=1u
X4130 VSS.t2839 VDD VSS.t2840 VSS.t412 sg13_lv_nmos ad=79.8f pd=0.8u as=0 ps=0 w=0.42u l=1u
X4131 VDD VSS.t2575 VDD VDD sg13_lv_pmos ad=0.19p pd=1.38u as=0 ps=0 w=1u l=1u
X4132 VSS.t2473 VDD VSS.t2472 VSS.t2471 sg13_lv_nmos ad=0.1428p pd=1.52u as=0 ps=0 w=0.42u l=1u
X4133 sg13g2_dlygate4sd3_1_5.A sg13g2_or3_1_2.B a_18552_15552# VDD sg13_lv_pmos ad=0.2128p pd=1.5u as=0.2128p ps=1.5u w=1.12u l=0.15u
X4134 VSS.t117 a_21166_16263# sg13g2_dfrbpq_1_6.D VSS.t325 sg13_lv_nmos ad=0.1426p pd=1.16u as=0.2516p ps=2.16u w=0.74u l=0.13u
X4135 VSS.t1322 VDD VSS.t1323 VSS.t377 sg13_lv_nmos ad=79.8f pd=0.8u as=0 ps=0 w=0.42u l=1u
X4136 a_25786_15960# sg13g2_o21ai_1_3.Y VSS.t90 VSS.t153 sg13_lv_nmos ad=0.1428p pd=1.52u as=79.8f ps=0.8u w=0.42u l=0.13u
X4137 VDD VSS.t731 VDD VDD sg13_lv_pmos ad=0.19p pd=1.38u as=0 ps=0 w=1u l=1u
X4138 VSS.t2181 VDD VSS.t2183 VSS.t2182 sg13_lv_nmos ad=79.8f pd=0.8u as=0 ps=0 w=0.42u l=1u
X4139 VDD sg13g2_o21ai_1_2.B1 sg13g2_o21ai_1_2.Y VDD sg13_lv_pmos ad=0.3808p pd=2.92u as=0.2128p ps=1.5u w=1.12u l=0.15u
X4140 VDD VSS.t1332 VDD VDD sg13_lv_pmos ad=0.34p pd=2.68u as=0 ps=0 w=1u l=1u
X4141 VDD VSS.t2840 VDD VDD sg13_lv_pmos ad=0.34p pd=2.68u as=0 ps=0 w=1u l=1u
X4142 VSS.t2136 VDD VSS.t2135 VSS.t2134 sg13_lv_nmos ad=0.1428p pd=1.52u as=0 ps=0 w=0.42u l=1u
X4143 sg13g2_dfrbpq_1_3.D a_17142_15302# VDD VDD sg13_lv_pmos ad=0.4256p pd=3u as=0.2254p ps=1.53u w=1.12u l=0.13u
X4144 VSS.t398 a_19438_13726# sg13g2_buf_16_2.X VSS.t397 sg13_lv_nmos ad=0.1406p pd=1.12u as=0.1406p ps=1.12u w=0.74u l=0.13u
X4145 VSS.t2780 VDD VSS.t2782 VSS.t412 sg13_lv_nmos ad=79.8f pd=0.8u as=0 ps=0 w=0.42u l=1u
X4146 VSS.t480 VDD VSS.t480 VSS.t481 sg13_lv_nmos ad=79.8f pd=0.8u as=0 ps=0 w=0.42u l=1u
X4147 VSS.t1409 VDD VSS.t1409 VSS.t377 sg13_lv_nmos ad=0.1428p pd=1.52u as=0 ps=0 w=0.42u l=1u
X4148 VDD VSS.t1389 VDD VDD sg13_lv_pmos ad=0.34p pd=2.68u as=0 ps=0 w=1u l=1u
X4149 VDD VSS.t2891 VDD VDD sg13_lv_pmos ad=0.34p pd=2.68u as=0 ps=0 w=1u l=1u
X4150 VDD VSS.t2200 VDD VDD sg13_lv_pmos ad=0.34p pd=2.68u as=0 ps=0 w=1u l=1u
X4151 VSS.t16 clock_i a_15022_14484# VSS.t367 sg13_lv_nmos ad=0.1406p pd=1.12u as=0.1406p ps=1.12u w=0.74u l=0.13u
X4152 VSS.t2588 VDD VSS.t2587 VSS.t2586 sg13_lv_nmos ad=0.1428p pd=1.52u as=0 ps=0 w=0.42u l=1u
X4153 VDD VSS.t2370 VDD VDD sg13_lv_pmos ad=0.19p pd=1.38u as=0 ps=0 w=1u l=1u
X4154 VDD VSS.t1653 VDD VDD sg13_lv_pmos ad=0.34p pd=2.68u as=0 ps=0 w=1u l=1u
X4155 VSS.t3008 VDD VSS.t2884 VSS.t412 sg13_lv_nmos ad=79.8f pd=0.8u as=0 ps=0 w=0.42u l=1u
X4156 VDD VSS.t2160 VDD VDD sg13_lv_pmos ad=0.34p pd=2.68u as=0 ps=0 w=1u l=1u
X4157 VDD VSS.t917 VDD VDD sg13_lv_pmos ad=0.19p pd=1.38u as=0 ps=0 w=1u l=1u
X4158 VDD VSS.t3287 VDD VDD sg13_lv_pmos ad=0.19p pd=1.38u as=0 ps=0 w=1u l=1u
X4159 VSS.t1976 VDD VSS.t1978 VSS.t1977 sg13_lv_nmos ad=79.8f pd=0.8u as=0 ps=0 w=0.42u l=1u
X4160 VDD VSS.t1658 VDD VDD sg13_lv_pmos ad=0.34p pd=2.68u as=0 ps=0 w=1u l=1u
X4161 VDD VSS.t2804 VDD VDD sg13_lv_pmos ad=0.34p pd=2.68u as=0 ps=0 w=1u l=1u
X4162 VSS.t1005 VDD VSS.t1004 VSS.t1003 sg13_lv_nmos ad=0.1428p pd=1.52u as=0 ps=0 w=0.42u l=1u
X4163 a_26148_14040# a_26667_13844# a_27407_13799# VSS.t410 sg13_lv_nmos ad=0.3473p pd=2.71u as=0.12665p ps=1.145u w=0.74u l=0.13u
X4164 a_19438_13726# sg13g2_buf_16_2.A VDD VDD sg13_lv_pmos ad=0.2128p pd=1.5u as=0.2128p ps=1.5u w=1.12u l=0.13u
X4165 VDD VSS.t1618 VDD VDD sg13_lv_pmos ad=0.34p pd=2.68u as=0 ps=0 w=1u l=1u
X4166 VSS.t2900 VDD VSS.t2899 VSS.t412 sg13_lv_nmos ad=0.1428p pd=1.52u as=0 ps=0 w=0.42u l=1u
X4167 VDD VSS.t2527 VDD VDD sg13_lv_pmos ad=0.34p pd=2.68u as=0 ps=0 w=1u l=1u
X4168 VSS.t2418 VDD VSS.t2417 VSS.t2416 sg13_lv_nmos ad=0.1428p pd=1.52u as=0 ps=0 w=0.42u l=1u
X4169 VSS.t1020 VDD VSS.t1022 VSS.t1021 sg13_lv_nmos ad=79.8f pd=0.8u as=0 ps=0 w=0.42u l=1u
X4170 VDD VSS.t302 VDD VDD sg13_lv_pmos ad=0.19p pd=1.38u as=0 ps=0 w=1u l=1u
X4171 VSS.t2847 VDD VSS.t2846 VSS.t412 sg13_lv_nmos ad=0.1428p pd=1.52u as=0 ps=0 w=0.42u l=1u
X4172 VDD VSS.t932 VDD VDD sg13_lv_pmos ad=0.19p pd=1.38u as=0 ps=0 w=1u l=1u
X4173 VDD VSS.t2043 VDD VDD sg13_lv_pmos ad=0.19p pd=1.38u as=0 ps=0 w=1u l=1u
X4174 VSS.t2086 VDD VSS.t2088 VSS.t2087 sg13_lv_nmos ad=79.8f pd=0.8u as=0 ps=0 w=0.42u l=1u
X4175 VSS.t1355 VDD VSS.t1356 VSS.t377 sg13_lv_nmos ad=79.8f pd=0.8u as=0 ps=0 w=0.42u l=1u
X4176 VDD VSS.t2362 VDD VDD sg13_lv_pmos ad=0.34p pd=2.68u as=0 ps=0 w=1u l=1u
X4177 VDD VSS.t124 VDD VDD sg13_lv_pmos ad=0.34p pd=2.68u as=0 ps=0 w=1u l=1u
X4178 VDD VSS.t565 VDD VDD sg13_lv_pmos ad=0.34p pd=2.68u as=0 ps=0 w=1u l=1u
X4179 VSS.t1319 VDD VSS.t1319 VSS.t377 sg13_lv_nmos ad=0.1428p pd=1.52u as=0 ps=0 w=0.42u l=1u
X4180 VDD VSS.t2764 VDD VDD sg13_lv_pmos ad=0.19p pd=1.38u as=0 ps=0 w=1u l=1u
X4181 VSS.t1649 VDD VSS.t1648 VSS.t1647 sg13_lv_nmos ad=0.1428p pd=1.52u as=0 ps=0 w=0.42u l=1u
X4182 VSS.t3175 VDD VSS.t3174 VSS.t3173 sg13_lv_nmos ad=0.1428p pd=1.52u as=0 ps=0 w=0.42u l=1u
X4183 VSS.t2383 VDD VSS.t2382 VSS.t2381 sg13_lv_nmos ad=0.1428p pd=1.52u as=0 ps=0 w=0.42u l=1u
X4184 VSS.t1996 VDD VSS.t1998 VSS.t1997 sg13_lv_nmos ad=79.8f pd=0.8u as=0 ps=0 w=0.42u l=1u
X4185 VDD clock_i a_15022_14484# VDD sg13_lv_pmos ad=0.2128p pd=1.5u as=0.2128p ps=1.5u w=1.12u l=0.13u
X4186 VSS.t1281 VDD VSS.t1282 VSS.t377 sg13_lv_nmos ad=79.8f pd=0.8u as=0 ps=0 w=0.42u l=1u
X4187 VSS.t407 a_27407_13799# a_28074_14020# VSS.t432 sg13_lv_nmos ad=0.1406p pd=1.12u as=0.2516p ps=2.16u w=0.74u l=0.13u
X4188 VSS.t520 VDD VSS.t522 VSS.t521 sg13_lv_nmos ad=79.8f pd=0.8u as=0 ps=0 w=0.42u l=1u
X4189 VSS.t82 sg13g2_dlygate4sd3_1_8.X a_7829_15238# VSS.t267 sg13_lv_nmos ad=0.1898p pd=1.36u as=0.2516p ps=2.16u w=0.74u l=0.13u
X4190 VDD VSS.t1364 VDD VDD sg13_lv_pmos ad=0.19p pd=1.38u as=0 ps=0 w=1u l=1u
X4191 VDD VSS.t2868 VDD VDD sg13_lv_pmos ad=0.19p pd=1.38u as=0 ps=0 w=1u l=1u
X4192 VDD VSS.t763 VDD VDD sg13_lv_pmos ad=0.34p pd=2.68u as=0 ps=0 w=1u l=1u
X4193 VDD VSS.t1603 VDD VDD sg13_lv_pmos ad=0.34p pd=2.68u as=0 ps=0 w=1u l=1u
X4194 VSS.t2796 VDD VSS.t2797 VSS.t412 sg13_lv_nmos ad=79.8f pd=0.8u as=0 ps=0 w=0.42u l=1u
X4195 VSS.t2573 VDD VSS.t2572 VSS.t2571 sg13_lv_nmos ad=0.1428p pd=1.52u as=0 ps=0 w=0.42u l=1u
X4196 VDD VSS.t2512 VDD VDD sg13_lv_pmos ad=0.34p pd=2.68u as=0 ps=0 w=1u l=1u
X4197 VDD VSS.t583 VDD VDD sg13_lv_pmos ad=0.19p pd=1.38u as=0 ps=0 w=1u l=1u
X4198 a_19438_13726# sg13g2_buf_16_2.A VDD VDD sg13_lv_pmos ad=0.2128p pd=1.5u as=0.3808p ps=2.92u w=1.12u l=0.13u
X4199 VSS.t2403 VDD VSS.t2402 VSS.t2401 sg13_lv_nmos ad=0.1428p pd=1.52u as=0 ps=0 w=0.42u l=1u
X4200 VDD VSS.t2023 VDD VDD sg13_lv_pmos ad=0.19p pd=1.38u as=0 ps=0 w=1u l=1u
X4201 VSS.t1035 VDD VSS.t1034 VSS.t1033 sg13_lv_nmos ad=0.1428p pd=1.52u as=0 ps=0 w=0.42u l=1u
X4202 VSS.t1739 VDD VSS.t1738 VSS.t1737 sg13_lv_nmos ad=0.1428p pd=1.52u as=0 ps=0 w=0.42u l=1u
X4203 VDD VSS.t1087 VDD VDD sg13_lv_pmos ad=0.19p pd=1.38u as=0 ps=0 w=1u l=1u
X4204 VSS.t1337 VDD VSS.t1336 VSS.t377 sg13_lv_nmos ad=0.1428p pd=1.52u as=0 ps=0 w=0.42u l=1u
X4205 VSS.t2858 VDD VSS.t2857 VSS.t412 sg13_lv_nmos ad=0.1428p pd=1.52u as=0 ps=0 w=0.42u l=1u
X4206 VDD VSS.t2430 VDD VDD sg13_lv_pmos ad=0.19p pd=1.38u as=0 ps=0 w=1u l=1u
X4207 VSS.t2121 VDD VSS.t2120 VSS.t2119 sg13_lv_nmos ad=0.1428p pd=1.52u as=0 ps=0 w=0.42u l=1u
X4208 VSS.t700 VDD VSS.t700 VSS.t702 sg13_lv_nmos ad=79.8f pd=0.8u as=0 ps=0 w=0.42u l=1u
X4209 VDD VSS.t551 VDD VDD sg13_lv_pmos ad=0.34p pd=2.68u as=0 ps=0 w=1u l=1u
X4210 VDD VSS.t1379 VDD VDD sg13_lv_pmos ad=0.34p pd=2.68u as=0 ps=0 w=1u l=1u
X4211 VDD VSS.t2185 VDD VDD sg13_lv_pmos ad=0.34p pd=2.68u as=0 ps=0 w=1u l=1u
X4212 VSS.t16 a_14357_15238# sg13g2_or3_1_1.B VSS.t249 sg13_lv_nmos ad=0.2516p pd=2.16u as=0.1406p ps=1.12u w=0.74u l=0.13u
X4213 VDD VSS.t2555 VDD VDD sg13_lv_pmos ad=0.19p pd=1.38u as=0 ps=0 w=1u l=1u
X4214 VSS.t2036 VDD VSS.t2038 VSS.t2037 sg13_lv_nmos ad=79.8f pd=0.8u as=0 ps=0 w=0.42u l=1u
X4215 VDD VSS.t2213 VDD VDD sg13_lv_pmos ad=0.19p pd=1.38u as=0 ps=0 w=1u l=1u
X4216 VDD VSS.t460 VDD VDD sg13_lv_pmos ad=0.34p pd=2.68u as=0 ps=0 w=1u l=1u
X4217 sg13g2_and2_1_2.X a_8685_14832# VSS.t19 VSS.t295 sg13_lv_nmos ad=0.2516p pd=2.16u as=0.1331p ps=1.12u w=0.74u l=0.13u
X4218 VDD VSS.t1988 VDD VDD sg13_lv_pmos ad=0.19p pd=1.38u as=0 ps=0 w=1u l=1u
X4219 VSS.t3001 VDD VSS.t2876 VSS.t412 sg13_lv_nmos ad=79.8f pd=0.8u as=0 ps=0 w=0.42u l=1u
X4220 VDD VSS.t2755 VDD VDD sg13_lv_pmos ad=0.19p pd=1.38u as=0 ps=0 w=1u l=1u
X4221 VDD VSS.t2832 VDD VDD sg13_lv_pmos ad=0.19p pd=1.38u as=0 ps=0 w=1u l=1u
X4222 VSS.t760 VDD VSS.t760 VSS.t761 sg13_lv_nmos ad=79.8f pd=0.8u as=0 ps=0 w=0.42u l=1u
X4223 VSS.t1373 VDD VSS.t1374 VSS.t377 sg13_lv_nmos ad=79.8f pd=0.8u as=0 ps=0 w=0.42u l=1u
X4224 VSS.t1669 VDD VSS.t1668 VSS.t1667 sg13_lv_nmos ad=0.1428p pd=1.52u as=0 ps=0 w=0.42u l=1u
X4225 VSS.t2368 VDD VSS.t2367 VSS.t2366 sg13_lv_nmos ad=0.1428p pd=1.52u as=0 ps=0 w=0.42u l=1u
X4226 sg13g2_a21oi_1_3.Y sg13g2_a21oi_1_3.A1 a_25203_13320# VSS.t313 sg13_lv_nmos ad=0.1406p pd=1.12u as=0.1406p ps=1.12u w=0.74u l=0.13u
X4227 VDD VSS.t962 VDD VDD sg13_lv_pmos ad=0.19p pd=1.38u as=0 ps=0 w=1u l=1u
X4228 VSS.t1005 VDD VSS.t1004 VSS.t1003 sg13_lv_nmos ad=0.1428p pd=1.52u as=0 ps=0 w=0.42u l=1u
X4229 VSS.t214 VDD VSS.t214 VSS.t558 sg13_lv_nmos ad=79.8f pd=0.8u as=0 ps=0 w=0.42u l=1u
X4230 VSS.t615 VDD VSS.t616 VSS.t33 sg13_lv_nmos ad=79.8f pd=0.8u as=0 ps=0 w=0.42u l=1u
X4231 VDD VSS.t139 VDD VDD sg13_lv_pmos ad=0.19p pd=1.38u as=0 ps=0 w=1u l=1u
X4232 VDD VSS.t1643 VDD VDD sg13_lv_pmos ad=0.34p pd=2.68u as=0 ps=0 w=1u l=1u
X4233 VSS.t819 VDD VSS.t369 VSS.t818 sg13_lv_nmos ad=0.1428p pd=1.52u as=0 ps=0 w=0.42u l=1u
X4234 VSS.t2443 VDD VSS.t2442 VSS.t2441 sg13_lv_nmos ad=0.1428p pd=1.52u as=0 ps=0 w=0.42u l=1u
X4235 VDD VSS.t449 VDD VDD sg13_lv_pmos ad=0.34p pd=2.68u as=0 ps=0 w=1u l=1u
X4236 VSS.t2806 VDD VSS.t2807 VSS.t412 sg13_lv_nmos ad=79.8f pd=0.8u as=0 ps=0 w=0.42u l=1u
X4237 a_23736_14464# sg13g2_or3_1_2.B VDD VDD sg13_lv_pmos ad=0.2128p pd=1.5u as=0.3808p ps=2.92u w=1.12u l=0.15u
X4238 VDD VSS.t728 VDD VDD sg13_lv_pmos ad=0.34p pd=2.68u as=0 ps=0 w=1u l=1u
X4239 VDD VSS.t1851 VDD VDD sg13_lv_pmos ad=0.19p pd=1.38u as=0 ps=0 w=1u l=1u
X4240 VDD VSS.t3142 VDD VDD sg13_lv_pmos ad=0.19p pd=1.38u as=0 ps=0 w=1u l=1u
X4241 VSS.t2874 VDD VSS.t2874 VSS.t412 sg13_lv_nmos ad=79.8f pd=0.8u as=0 ps=0 w=0.42u l=1u
X4242 sg13g2_buf_16_2.A a_15022_14484# VDD VDD sg13_lv_pmos ad=0.2128p pd=1.5u as=0.2128p ps=1.5u w=1.12u l=0.13u
X4243 VDD VSS.t1054 VDD VDD sg13_lv_pmos ad=0.34p pd=2.68u as=0 ps=0 w=1u l=1u
X4244 sg13g2_buf_16_2.A a_15022_14484# VDD VDD sg13_lv_pmos ad=0.2128p pd=1.5u as=0.2128p ps=1.5u w=1.12u l=0.13u
X4245 VDD VSS.t302 VDD VDD sg13_lv_pmos ad=0.19p pd=1.38u as=0 ps=0 w=1u l=1u
X4246 a_24935_14020# sg13g2_or3_1_1.C a_24841_13726# VDD sg13_lv_pmos ad=0.19p pd=1.38u as=0.34p ps=2.68u w=1u l=0.13u
X4247 VSS.t302 VDD VSS.t302 VSS.t674 sg13_lv_nmos ad=0.1428p pd=1.52u as=0 ps=0 w=0.42u l=1u
X4248 VSS.t2784 VDD VSS.t2785 VSS.t412 sg13_lv_nmos ad=79.8f pd=0.8u as=0 ps=0 w=0.42u l=1u
X4249 VDD VSS.t2205 VDD VDD sg13_lv_pmos ad=0.34p pd=2.68u as=0 ps=0 w=1u l=1u
X4250 VDD VSS.t601 VDD VDD sg13_lv_pmos ad=0.19p pd=1.38u as=0 ps=0 w=1u l=1u
X4251 VDD VSS.t1370 VDD VDD sg13_lv_pmos ad=0.34p pd=2.68u as=0 ps=0 w=1u l=1u
X4252 VDD VSS.t2874 VDD VDD sg13_lv_pmos ad=0.34p pd=2.68u as=0 ps=0 w=1u l=1u
X4253 VSS.t3160 VDD VSS.t3162 VSS.t3161 sg13_lv_nmos ad=79.8f pd=0.8u as=0 ps=0 w=0.42u l=1u
X4254 sg13g2_dfrbpq_1_2.RESET_B a_16254_15934# VDD VDD sg13_lv_pmos ad=0.3927p pd=2.99u as=2.8961p ps=18.25u w=1.155u l=0.13u
X4255 VDD VSS.t502 VDD VDD sg13_lv_pmos ad=0.19p pd=1.38u as=0 ps=0 w=1u l=1u
X4256 a_2890_15457# a_3333_15213# a_2630_15234# VSS.t335 sg13_lv_nmos ad=79.8f pd=0.8u as=0.1296p ps=1.52u w=0.42u l=0.13u
X4257 a_22030_15423# a_22145_15424# VSS.t287 VSS.t286 sg13_lv_nmos ad=0.1428p pd=1.52u as=0.1426p ps=1.16u w=0.42u l=0.5u
X4258 VSS.t769 VDD VSS.t887 VSS.t886 sg13_lv_nmos ad=0.1428p pd=1.52u as=0 ps=0 w=0.42u l=1u
X4259 VDD VSS.t2375 VDD VDD sg13_lv_pmos ad=0.19p pd=1.38u as=0 ps=0 w=1u l=1u
X4260 VDD VSS.t475 VDD VDD sg13_lv_pmos ad=0.19p pd=1.38u as=0 ps=0 w=1u l=1u
X4261 VDD VSS.t1117 VDD VDD sg13_lv_pmos ad=0.19p pd=1.38u as=0 ps=0 w=1u l=1u
X4262 VSS.t597 VDD VSS.t596 VSS.t33 sg13_lv_nmos ad=0.1428p pd=1.52u as=0 ps=0 w=0.42u l=1u
X4263 VDD VSS.t2165 VDD VDD sg13_lv_pmos ad=0.34p pd=2.68u as=0 ps=0 w=1u l=1u
X4264 VSS.t728 VDD VSS.t731 VSS.t861 sg13_lv_nmos ad=79.8f pd=0.8u as=0 ps=0 w=0.42u l=1u
X4265 VDD VSS.t3292 VDD VDD sg13_lv_pmos ad=0.19p pd=1.38u as=0 ps=0 w=1u l=1u
X4266 VSS.t1981 VDD VSS.t1983 VSS.t1982 sg13_lv_nmos ad=79.8f pd=0.8u as=0 ps=0 w=0.42u l=1u
X4267 a_21477_14495# sg13g2_buf_16_2.X VDD VDD sg13_lv_pmos ad=0.4088p pd=2.97u as=2.3367p ps=15.135u w=1.12u l=0.13u
X4268 VDD VSS.t1663 VDD VDD sg13_lv_pmos ad=0.34p pd=2.68u as=0 ps=0 w=1u l=1u
X4269 VSS.t2782 VDD VSS.t2783 VSS.t412 sg13_lv_nmos ad=79.8f pd=0.8u as=0 ps=0 w=0.42u l=1u
X4270 VSS.t500 VDD VSS.t311 VSS.t499 sg13_lv_nmos ad=0.1428p pd=1.52u as=0 ps=0 w=0.42u l=1u
X4271 VDD VSS.t97 VDD VDD sg13_lv_pmos ad=0.34p pd=2.68u as=0 ps=0 w=1u l=1u
X4272 VDD VSS.t2000 VDD VDD sg13_lv_pmos ad=0.34p pd=2.68u as=0 ps=0 w=1u l=1u
X4273 VSS.t3008 VDD VSS.t2882 VSS.t412 sg13_lv_nmos ad=0.1428p pd=1.52u as=0 ps=0 w=0.42u l=1u
X4274 VDD VSS.t2838 VDD VDD sg13_lv_pmos ad=0.34p pd=2.68u as=0 ps=0 w=1u l=1u
X4275 VSS.t1035 VDD VSS.t1034 VSS.t1033 sg13_lv_nmos ad=0.1428p pd=1.52u as=0 ps=0 w=0.42u l=1u
X4276 VDD VSS.t715 VDD VDD sg13_lv_pmos ad=0.19p pd=1.38u as=0 ps=0 w=1u l=1u
X4277 VDD VSS.t1017 VDD VDD sg13_lv_pmos ad=0.19p pd=1.38u as=0 ps=0 w=1u l=1u
X4278 VSS.t2388 VDD VSS.t2387 VSS.t2386 sg13_lv_nmos ad=0.1428p pd=1.52u as=0 ps=0 w=0.42u l=1u
X4279 VSS.t715 VDD VSS.t27 VSS.t834 sg13_lv_nmos ad=0.1428p pd=1.52u as=0 ps=0 w=0.42u l=1u
X4280 VDD VSS.t1411 VDD VDD sg13_lv_pmos ad=0.19p pd=1.38u as=0 ps=0 w=1u l=1u
X4281 VSS.t1724 VDD VSS.t1723 VSS.t1722 sg13_lv_nmos ad=0.1428p pd=1.52u as=0 ps=0 w=0.42u l=1u
X4282 a_15022_14484# clock_i VDD VDD sg13_lv_pmos ad=0.2128p pd=1.5u as=0.2128p ps=1.5u w=1.12u l=0.13u
X4283 VSS.t1531 VDD VSS.t1395 VSS.t377 sg13_lv_nmos ad=0.1428p pd=1.52u as=0 ps=0 w=0.42u l=1u
X4284 VSS.t2774 VDD VSS.t2776 VSS.t412 sg13_lv_nmos ad=79.8f pd=0.8u as=0 ps=0 w=0.42u l=1u
X4285 VSS.t2850 VDD VSS.t2849 VSS.t412 sg13_lv_nmos ad=0.1428p pd=1.52u as=0 ps=0 w=0.42u l=1u
X4286 VDD VSS.t2592 VDD VDD sg13_lv_pmos ad=0.34p pd=2.68u as=0 ps=0 w=1u l=1u
X4287 VDD VSS.t2791 VDD VDD sg13_lv_pmos ad=0.19p pd=1.38u as=0 ps=0 w=1u l=1u
X4288 VSS.t2091 VDD VSS.t2093 VSS.t2092 sg13_lv_nmos ad=79.8f pd=0.8u as=0 ps=0 w=0.42u l=1u
X4289 VDD VSS.t954 VDD VDD sg13_lv_pmos ad=0.34p pd=2.68u as=0 ps=0 w=1u l=1u
X4290 VDD VSS.t3087 VDD VDD sg13_lv_pmos ad=0.19p pd=1.38u as=0 ps=0 w=1u l=1u
X4291 VSS.t2428 VDD VSS.t2427 VSS.t2426 sg13_lv_nmos ad=0.1428p pd=1.52u as=0 ps=0 w=0.42u l=1u
X4292 a_6682_13690# sg13g2_dlygate4sd3_1_0.A VDD VDD sg13_lv_pmos ad=0.1428p pd=1.52u as=0.1523p ps=1.38u w=0.42u l=0.13u
X4293 VDD VSS.t746 VDD VDD sg13_lv_pmos ad=0.34p pd=2.68u as=0 ps=0 w=1u l=1u
X4294 VSS.t2201 VDD VSS.t2200 VSS.t2199 sg13_lv_nmos ad=0.1428p pd=1.52u as=0 ps=0 w=0.42u l=1u
X4295 VSS.t1437 VDD VSS.t1436 VSS.t377 sg13_lv_nmos ad=0.1428p pd=1.52u as=0 ps=0 w=0.42u l=1u
X4296 VDD VSS.t2540 VDD VDD sg13_lv_pmos ad=0.19p pd=1.38u as=0 ps=0 w=1u l=1u
X4297 VDD VSS.t2198 VDD VDD sg13_lv_pmos ad=0.19p pd=1.38u as=0 ps=0 w=1u l=1u
X4298 VDD VSS.t63 VDD VDD sg13_lv_pmos ad=0.34p pd=2.68u as=0 ps=0 w=1u l=1u
X4299 VDD VSS.t892 VDD VDD sg13_lv_pmos ad=0.19p pd=1.38u as=0 ps=0 w=1u l=1u
X4300 VSS.t63 sg13g2_buf_16_2.A a_12020_15202# VSS.t168 sg13_lv_nmos ad=0.1406p pd=1.12u as=0.1406p ps=1.12u w=0.74u l=0.13u
X4301 VSS.t14 VDD VSS.t14 VSS.t843 sg13_lv_nmos ad=0.1428p pd=1.52u as=0 ps=0 w=0.42u l=1u
X4302 VDD VSS.t1973 VDD VDD sg13_lv_pmos ad=0.19p pd=1.38u as=0 ps=0 w=1u l=1u
X4303 VDD VSS.t2492 VDD VDD sg13_lv_pmos ad=0.34p pd=2.68u as=0 ps=0 w=1u l=1u
X4304 VSS.t1654 VDD VSS.t1653 VSS.t1652 sg13_lv_nmos ad=0.1428p pd=1.52u as=0 ps=0 w=0.42u l=1u
X4305 VSS.t535 VDD VSS.t534 VSS.t533 sg13_lv_nmos ad=0.1428p pd=1.52u as=0 ps=0 w=0.42u l=1u
X4306 VDD VSS.t302 VDD VDD sg13_lv_pmos ad=0.19p pd=1.38u as=0 ps=0 w=1u l=1u
X4307 VDD VSS.t1007 VDD VDD sg13_lv_pmos ad=0.19p pd=1.38u as=0 ps=0 w=1u l=1u
X4308 VSS.t631 VDD VSS.t84 VSS.t632 sg13_lv_nmos ad=79.8f pd=0.8u as=0 ps=0 w=0.42u l=1u
X4309 VDD VSS.t2068 VDD VDD sg13_lv_pmos ad=0.19p pd=1.38u as=0 ps=0 w=1u l=1u
X4310 VDD VSS.t1304 VDD VDD sg13_lv_pmos ad=0.34p pd=2.68u as=0 ps=0 w=1u l=1u
X4311 VDD a_7631_14845# a_7888_14726# VDD sg13_lv_pmos ad=2.42015p pd=15.68u as=79.8f ps=0.8u w=0.42u l=0.13u
X4312 VSS.t2895 VDD VSS.t2894 VSS.t412 sg13_lv_nmos ad=0.1428p pd=1.52u as=0 ps=0 w=0.42u l=1u
X4313 VSS.t2798 VDD VSS.t2799 VSS.t412 sg13_lv_nmos ad=79.8f pd=0.8u as=0 ps=0 w=0.42u l=1u
X4314 VSS.t746 VDD VSS.t749 VSS.t873 sg13_lv_nmos ad=79.8f pd=0.8u as=0 ps=0 w=0.42u l=1u
X4315 sg13g2_dlygate4sd3_1_1.A a_8298_14484# VDD VDD sg13_lv_pmos ad=0.3808p pd=2.92u as=0.2128p ps=1.5u w=1.12u l=0.13u
X4316 VDD VSS.t1781 VDD VDD sg13_lv_pmos ad=0.19p pd=1.38u as=0 ps=0 w=1u l=1u
X4317 VDD VSS.t1836 VDD VDD sg13_lv_pmos ad=0.19p pd=1.38u as=0 ps=0 w=1u l=1u
X4318 VDD VSS.t2435 VDD VDD sg13_lv_pmos ad=0.19p pd=1.38u as=0 ps=0 w=1u l=1u
X4319 VDD VSS.t2560 VDD VDD sg13_lv_pmos ad=0.19p pd=1.38u as=0 ps=0 w=1u l=1u
X4320 VSS.t2041 VDD VSS.t2043 VSS.t2042 sg13_lv_nmos ad=79.8f pd=0.8u as=0 ps=0 w=0.42u l=1u
X4321 VDD VSS.t2218 VDD VDD sg13_lv_pmos ad=0.19p pd=1.38u as=0 ps=0 w=1u l=1u
X4322 VSS.t915 VDD VSS.t917 VSS.t916 sg13_lv_nmos ad=79.8f pd=0.8u as=0 ps=0 w=0.42u l=1u
X4323 VDD VSS.t2758 VDD VDD sg13_lv_pmos ad=0.19p pd=1.38u as=0 ps=0 w=1u l=1u
X4324 VSS.t90 a_25390_16263# sg13g2_dlygate4sd3_1_12.X VSS.t118 sg13_lv_nmos ad=0.1426p pd=1.16u as=0.2516p ps=2.16u w=0.74u l=0.13u
X4325 VSS.t3165 VDD VSS.t3164 VSS.t3163 sg13_lv_nmos ad=0.1428p pd=1.52u as=0 ps=0 w=0.42u l=1u
X4326 VSS.t2373 VDD VSS.t2372 VSS.t2371 sg13_lv_nmos ad=0.1428p pd=1.52u as=0 ps=0 w=0.42u l=1u
X4327 VSS.t50 a_12020_15202# sg13g2_dfrbpq_1_2.CLK VSS.t60 sg13_lv_nmos ad=0.1406p pd=1.12u as=0.1406p ps=1.12u w=0.74u l=0.13u
X4328 a_24310_15230# sg13g2_or3_1_1.C VSS.t181 VSS.t28 sg13_lv_nmos ad=0.1406p pd=1.12u as=0.1406p ps=1.12u w=0.74u l=0.15u
X4329 VDD VSS.t974 VDD VDD sg13_lv_pmos ad=0.34p pd=2.68u as=0 ps=0 w=1u l=1u
X4330 VSS.t2543 VDD VSS.t2545 VSS.t2544 sg13_lv_nmos ad=79.8f pd=0.8u as=0 ps=0 w=0.42u l=1u
X4331 sg13g2_dlygate4sd3_1_8.A a_11370_15532# VSS.t84 VSS.t83 sg13_lv_nmos ad=0.2516p pd=2.16u as=0.1406p ps=1.12u w=0.74u l=0.13u
X4332 VDD VSS.t1648 VDD VDD sg13_lv_pmos ad=0.34p pd=2.68u as=0 ps=0 w=1u l=1u
X4333 VSS.t2773 VDD VSS.t2774 VSS.t412 sg13_lv_nmos ad=79.8f pd=0.8u as=0 ps=0 w=0.42u l=1u
X4334 VSS.t40 sg13g2_buf_1_0.X a_2646_14842# VSS.t41 sg13_lv_nmos ad=0.15245p pd=1.17u as=88.8f ps=0.98u w=0.74u l=0.13u
X4335 a_6660_14909# a_6891_14495# a_6346_14452# VSS.t111 sg13_lv_nmos ad=0.2373p pd=1.97u as=79.8f ps=0.8u w=0.42u l=0.13u
X4336 VSS.t1334 VDD VSS.t1335 VSS.t377 sg13_lv_nmos ad=79.8f pd=0.8u as=0 ps=0 w=0.42u l=1u
X4337 VSS.t2448 VDD VSS.t2447 VSS.t2446 sg13_lv_nmos ad=0.1428p pd=1.52u as=0 ps=0 w=0.42u l=1u
X4338 VSS.t302 a_26565_13701# a_26667_13844# VSS.t380 sg13_lv_nmos ad=15.10457p pd=99.59499u as=0.2516p ps=2.16u w=0.74u l=0.13u
X4339 VDD VSS.t734 VDD VDD sg13_lv_pmos ad=0.19p pd=1.38u as=0 ps=0 w=1u l=1u
X4340 VSS.t1709 VDD VSS.t1711 VSS.t1710 sg13_lv_nmos ad=79.8f pd=0.8u as=0 ps=0 w=0.42u l=1u
X4341 VSS.t731 VDD VSS.t728 VSS.t730 sg13_lv_nmos ad=0.1428p pd=1.52u as=0 ps=0 w=0.42u l=1u
X4342 sg13g2_and2_1_1.X a_5613_14832# VSS.t106 VSS.t294 sg13_lv_nmos ad=0.2516p pd=2.16u as=0.1331p ps=1.12u w=0.74u l=0.13u
X4343 VDD VSS.t1985 VDD VDD sg13_lv_pmos ad=0.34p pd=2.68u as=0 ps=0 w=1u l=1u
X4344 VDD VSS.t2830 VDD VDD sg13_lv_pmos ad=0.34p pd=2.68u as=0 ps=0 w=1u l=1u
X4345 VSS.t1010 VDD VSS.t1009 VSS.t1008 sg13_lv_nmos ad=0.1428p pd=1.52u as=0 ps=0 w=0.42u l=1u
X4346 VDD VSS.t3147 VDD VDD sg13_lv_pmos ad=0.19p pd=1.38u as=0 ps=0 w=1u l=1u
X4347 VSS.t2876 VDD VSS.t2877 VSS.t412 sg13_lv_nmos ad=79.8f pd=0.8u as=0 ps=0 w=0.42u l=1u
X4348 VSS.t1339 VDD VSS.t1340 VSS.t377 sg13_lv_nmos ad=79.8f pd=0.8u as=0 ps=0 w=0.42u l=1u
X4349 VDD VSS.t2013 VDD VDD sg13_lv_pmos ad=0.19p pd=1.38u as=0 ps=0 w=1u l=1u
X4350 VSS.t930 VDD VSS.t932 VSS.t931 sg13_lv_nmos ad=79.8f pd=0.8u as=0 ps=0 w=0.42u l=1u
X4351 VSS.t2914 VDD VSS.t2767 VSS.t412 sg13_lv_nmos ad=79.8f pd=0.8u as=0 ps=0 w=0.42u l=1u
X4352 a_25390_16263# a_25505_16262# VSS.t90 VSS.t152 sg13_lv_nmos ad=0.1428p pd=1.52u as=0.1426p ps=1.16u w=0.42u l=0.5u
X4353 VDD VSS.t2577 VDD VDD sg13_lv_pmos ad=0.34p pd=2.68u as=0 ps=0 w=1u l=1u
X4354 VSS.t2076 VDD VSS.t2078 VSS.t2077 sg13_lv_nmos ad=79.8f pd=0.8u as=0 ps=0 w=0.42u l=1u
X4355 VDD VSS.t1374 VDD VDD sg13_lv_pmos ad=0.34p pd=2.68u as=0 ps=0 w=1u l=1u
X4356 VDD VSS.t2877 VDD VDD sg13_lv_pmos ad=0.34p pd=2.68u as=0 ps=0 w=1u l=1u
X4357 a_17710_15423# a_17825_15424# VDD VDD sg13_lv_pmos ad=0.34p pd=2.68u as=0.2254p ps=1.53u w=1u l=0.5u
X4358 VDD VSS.t2380 VDD VDD sg13_lv_pmos ad=0.19p pd=1.38u as=0 ps=0 w=1u l=1u
X4359 VDD VSS.t937 VDD VDD sg13_lv_pmos ad=0.19p pd=1.38u as=0 ps=0 w=1u l=1u
X4360 VDD VSS.t2477 VDD VDD sg13_lv_pmos ad=0.34p pd=2.68u as=0 ps=0 w=1u l=1u
X4361 VSS.t700 VDD VSS.t700 VSS.t702 sg13_lv_nmos ad=79.8f pd=0.8u as=0 ps=0 w=0.42u l=1u
X4362 VDD VSS.t302 VDD VDD sg13_lv_pmos ad=0.19p pd=1.38u as=0 ps=0 w=1u l=1u
X4363 VSS.t2563 VDD VSS.t2565 VSS.t2564 sg13_lv_nmos ad=79.8f pd=0.8u as=0 ps=0 w=0.42u l=1u
X4364 VSS.t1986 VDD VSS.t1988 VSS.t1987 sg13_lv_nmos ad=79.8f pd=0.8u as=0 ps=0 w=0.42u l=1u
X4365 a_7822_13911# a_7937_13912# VSS.t100 VSS.t357 sg13_lv_nmos ad=0.1428p pd=1.52u as=0.1426p ps=1.16u w=0.42u l=0.5u
X4366 VSS.t2764 VDD VSS.t2765 VSS.t412 sg13_lv_nmos ad=79.8f pd=0.8u as=0 ps=0 w=0.42u l=1u
X4367 VDD VSS.t1441 VDD VDD sg13_lv_pmos ad=0.19p pd=1.38u as=0 ps=0 w=1u l=1u
X4368 VDD VSS.t2230 VDD VDD sg13_lv_pmos ad=0.34p pd=2.68u as=0 ps=0 w=1u l=1u
X4369 VDD VSS.t2053 VDD VDD sg13_lv_pmos ad=0.19p pd=1.38u as=0 ps=0 w=1u l=1u
X4370 VSS.t150 sg13g2_xnor2_1_1.A a_17219_16265# VSS.t275 sg13_lv_nmos ad=0.1045p pd=0.93u as=0.198p ps=1.27u w=0.55u l=0.13u
X4371 sg13g2_nand3_1_0.Y sg13g2_buf_1_0.X a_6680_15242# VSS.t37 sg13_lv_nmos ad=0.2516p pd=2.16u as=0.1406p ps=1.12u w=0.74u l=0.13u
X4372 a_6286_13911# a_6401_13912# VSS.t302 VSS.t315 sg13_lv_nmos ad=0.1428p pd=1.52u as=0.1426p ps=1.16u w=0.42u l=0.5u
X4373 VSS.t214 VDD VSS.t214 VSS.t560 sg13_lv_nmos ad=0.1428p pd=1.52u as=0 ps=0 w=0.42u l=1u
X4374 VDD VSS.t2005 VDD VDD sg13_lv_pmos ad=0.34p pd=2.68u as=0 ps=0 w=1u l=1u
X4375 VSS.t2886 VDD VSS.t2885 VSS.t412 sg13_lv_nmos ad=0.1428p pd=1.52u as=0 ps=0 w=0.42u l=1u
X4376 VDD VSS.t2913 VDD VDD sg13_lv_pmos ad=0.34p pd=2.68u as=0 ps=0 w=1u l=1u
X4377 VDD VSS.t2841 VDD VDD sg13_lv_pmos ad=0.34p pd=2.68u as=0 ps=0 w=1u l=1u
X4378 VSS.t1284 VDD VSS.t1285 VSS.t377 sg13_lv_nmos ad=79.8f pd=0.8u as=0 ps=0 w=0.42u l=1u
X4379 VDD VSS.t2178 VDD VDD sg13_lv_pmos ad=0.19p pd=1.38u as=0 ps=0 w=1u l=1u
X4380 VDD a_2540_15960# counter_value_o[0] VDD sg13_lv_pmos ad=0.2114p pd=1.54u as=0.42p ps=2.99u w=1.12u l=0.13u
X4381 sg13g2_buf_16_2.X a_19438_13726# VDD VDD sg13_lv_pmos ad=0.2128p pd=1.5u as=0.2128p ps=1.5u w=1.12u l=0.13u
X4382 VSS.t1085 VDD VSS.t1087 VSS.t1086 sg13_lv_nmos ad=79.8f pd=0.8u as=0 ps=0 w=0.42u l=1u
X4383 VSS.t3025 VDD VSS.t3027 VSS.t3026 sg13_lv_nmos ad=79.8f pd=0.8u as=0 ps=0 w=0.42u l=1u
X4384 sg13g2_dlygate4sd3_1_1.A a_8298_14484# VSS.t164 VSS.t192 sg13_lv_nmos ad=0.2516p pd=2.16u as=0.1406p ps=1.12u w=0.74u l=0.13u
X4385 VSS.t594 VDD VSS.t595 VSS.t33 sg13_lv_nmos ad=79.8f pd=0.8u as=0 ps=0 w=0.42u l=1u
X4386 VDD VSS.t769 VDD VDD sg13_lv_pmos ad=0.19p pd=1.38u as=0 ps=0 w=1u l=1u
X4387 VDD VSS.t1154 VDD VDD sg13_lv_pmos ad=0.34p pd=2.68u as=0 ps=0 w=1u l=1u
X4388 VSS.t1849 VDD VSS.t1851 VSS.t1850 sg13_lv_nmos ad=79.8f pd=0.8u as=0 ps=0 w=0.42u l=1u
X4389 VSS.t2852 VDD VSS.t2852 VSS.t412 sg13_lv_nmos ad=0.1428p pd=1.52u as=0 ps=0 w=0.42u l=1u
X4390 VDD VSS.t2597 VDD VDD sg13_lv_pmos ad=0.34p pd=2.68u as=0 ps=0 w=1u l=1u
X4391 VSS.t763 VDD VSS.t763 VSS.t882 sg13_lv_nmos ad=0.1428p pd=1.52u as=0 ps=0 w=0.42u l=1u
X4392 VSS.t2061 VDD VSS.t2063 VSS.t2062 sg13_lv_nmos ad=79.8f pd=0.8u as=0 ps=0 w=0.42u l=1u
X4393 VSS.t2206 VDD VSS.t2205 VSS.t2204 sg13_lv_nmos ad=0.1428p pd=1.52u as=0 ps=0 w=0.42u l=1u
X4394 VSS.t915 VDD VSS.t917 VSS.t916 sg13_lv_nmos ad=79.8f pd=0.8u as=0 ps=0 w=0.42u l=1u
X4395 VDD VSS.t904 VDD VDD sg13_lv_pmos ad=0.34p pd=2.68u as=0 ps=0 w=1u l=1u
X4396 VDD VSS.t2203 VDD VDD sg13_lv_pmos ad=0.19p pd=1.38u as=0 ps=0 w=1u l=1u
R0 VSS.t111 VSS.n852 2.277e+06
R1 VSS.t195 VSS.n862 1.34743e+06
R2 VSS.t412 VSS.n710 4108.7
R3 VSS.n716 VSS.n710 4108.7
R4 VSS.n717 VSS.n716 4108.7
R5 VSS.t377 VSS.n717 4108.7
R6 VSS.t377 VSS.n718 4108.7
R7 VSS.n848 VSS.n718 4108.7
R8 VSS.n849 VSS.n848 4108.7
R9 VSS.n850 VSS.n849 3692.29
R10 VSS.t3028 VSS.n139 156.482
R11 VSS.t3056 VSS.n139 157.976
R12 VSS.n139 VSS.t3061 157.976
R13 VSS.n139 VSS.t3066 157.976
R14 VSS.n139 VSS.t3076 157.976
R15 VSS.n139 VSS.t3086 157.976
R16 VSS.n139 VSS.t3131 157.976
R17 VSS.n139 VSS.t3136 157.976
R18 VSS.n139 VSS.t3146 157.976
R19 VSS.n139 VSS.t3156 157.976
R20 VSS.n139 VSS.t3161 157.976
R21 VSS.t3166 VSS.n139 157.976
R22 VSS.n139 VSS.t3181 157.976
R23 VSS.n139 VSS.t3206 157.976
R24 VSS.n139 VSS.t3216 157.976
R25 VSS.n139 VSS.t3226 157.976
R26 VSS.n139 VSS.t3256 157.976
R27 VSS.n139 VSS.t3276 157.976
R28 VSS.n139 VSS.t3286 157.976
R29 VSS.t224 VSS.t223 612.602
R30 VSS.t412 VSS.n139 4425.74
R31 VSS.t1715 VSS.n57 109.992
R32 VSS.n55 VSS.t2371 109.001
R33 VSS.t2399 VSS.n55 109.992
R34 VSS.n55 VSS.t2416 108.999
R35 VSS.n55 VSS.t2426 108.999
R36 VSS.n55 VSS.t2441 108.999
R37 VSS.t2449 VSS.n55 109.992
R38 VSS.n55 VSS.t2471 108.999
R39 VSS.t2484 VSS.n55 109.993
R40 VSS.n55 VSS.t2491 108.999
R41 VSS.n55 VSS.t2504 109.993
R42 VSS.t2539 VSS.n55 109.993
R43 VSS.n55 VSS.t2544 109.992
R44 VSS.t2569 VSS.n55 109.992
R45 VSS.n55 VSS.t2584 109.993
R46 VSS.t2619 VSS.n55 109.992
R47 VSS.n56 VSS.t1967 109.986
R48 VSS.n56 VSS.t1984 109.001
R49 VSS.t2004 VSS.n56 108.999
R50 VSS.n56 VSS.t2009 109.001
R51 VSS.t2024 VSS.n56 108.999
R52 VSS.n56 VSS.t2049 109.001
R53 VSS.t2054 VSS.n56 108.999
R54 VSS.n56 VSS.t2079 109.001
R55 VSS.t2104 VSS.n56 108.999
R56 VSS.n56 VSS.t2122 109.992
R57 VSS.n56 VSS.t2152 109.992
R58 VSS.n56 VSS.t2172 109.992
R59 VSS.t2187 VSS.n56 109.993
R60 VSS.n56 VSS.t2192 109.992
R61 VSS.t2197 VSS.n56 109.992
R62 VSS.n56 VSS.t2212 109.992
R63 VSS.t1597 VSS.n57 108.999
R64 VSS.n57 VSS.t1602 109.001
R65 VSS.t1607 VSS.n57 108.999
R66 VSS.n57 VSS.t1622 109.001
R67 VSS.t1647 VSS.n57 108.999
R68 VSS.t1667 VSS.n57 108.999
R69 VSS.n57 VSS.t1672 109.001
R70 VSS.n57 VSS.t1682 109.001
R71 VSS.t1687 VSS.n57 108.999
R72 VSS.n57 VSS.t1692 108.999
R73 VSS.t1697 VSS.n57 109.001
R74 VSS.n57 VSS.t1702 109.001
R75 VSS.t1707 VSS.n57 108.999
R76 VSS.t1725 VSS.n57 109.992
R77 VSS.t1730 VSS.n57 109.993
R78 VSS.t1735 VSS.n57 109.992
R79 VSS.t1760 VSS.n57 109.992
R80 VSS.t1785 VSS.n57 109.993
R81 VSS.t1790 VSS.n57 109.992
R82 VSS.t1805 VSS.n57 109.993
R83 VSS.t1810 VSS.n57 109.992
R84 VSS.t1820 VSS.n57 109.992
R85 VSS.t1830 VSS.n57 109.993
R86 VSS.n57 VSS.t1835 109.992
R87 VSS.t1840 VSS.n57 109.992
R88 VSS.t891 VSS.n54 109.986
R89 VSS.n54 VSS.t903 109.001
R90 VSS.t931 VSS.n54 109.992
R91 VSS.n54 VSS.t946 109.993
R92 VSS.t951 VSS.n54 109.992
R93 VSS.n54 VSS.t983 108.999
R94 VSS.t991 VSS.n54 109.992
R95 VSS.n54 VSS.t996 109.993
R96 VSS.t1018 VSS.n54 108.999
R97 VSS.n54 VSS.t1046 109.992
R98 VSS.t1061 VSS.n54 109.992
R99 VSS.n54 VSS.t1076 109.992
R100 VSS.t1081 VSS.n54 109.993
R101 VSS.t1091 VSS.n54 109.992
R102 VSS.t1111 VSS.n54 109.992
R103 VSS.n54 VSS.t1116 109.993
R104 VSS.t1141 VSS.n54 109.992
R105 VSS.t1151 VSS.n54 109.992
R106 VSS.n54 VSS.t1156 109.992
R107 VSS.t824 VSS.t302 243.47
R108 VSS.n114 VSS.t37 424.017
R109 VSS.t292 VSS.n119 422.846
R110 VSS.n257 VSS.t886 8.00267
R111 VSS.n77 VSS.t13 418.56
R112 VSS.t302 VSS.t847 237.142
R113 VSS.n55 VSS.n710 427.5
R114 VSS.n716 VSS.n56 427.5
R115 VSS.n717 VSS.n57 427.5
R116 VSS.n54 VSS.n718 427.5
R117 VSS.n278 VSS.t729 242.846
R118 VSS.n254 VSS.t732 242.846
R119 VSS.n277 VSS.t735 242.846
R120 VSS.n174 VSS.t738 242.846
R121 VSS.n276 VSS.t741 242.846
R122 VSS.n255 VSS.t744 242.846
R123 VSS.n275 VSS.t747 242.846
R124 VSS.n212 VSS.t750 242.846
R125 VSS.n274 VSS.t753 242.846
R126 VSS.t757 VSS.n256 242.846
R127 VSS.t761 VSS.n273 242.846
R128 VSS.t764 VSS.n170 242.846
R129 VSS.t767 VSS.n272 242.846
R130 VSS.t370 VSS.n280 15.7034
R131 VSS.n849 VSS.t33 427.5
R132 VSS.t38 VSS.n783 408.31
R133 VSS.t108 VSS.n846 402.858
R134 VSS.t245 VSS.n766 402.858
R135 VSS.t217 VSS.n226 119.835
R136 VSS.n160 VSS.t410 26.1545
R137 VSS.n843 VSS.t353 398.572
R138 VSS.t176 VSS.n839 398.572
R139 VSS.n913 VSS.t396 398.572
R140 VSS.n918 VSS.t397 398.572
R141 VSS.t70 VSS.n777 398.572
R142 VSS.t48 VSS.n865 398.572
R143 VSS.n867 VSS.t49 398.572
R144 VSS.t170 VSS.n767 398.572
R145 VSS.t364 VSS.n879 398.572
R146 VSS.n881 VSS.t365 398.572
R147 VSS.n112 VSS.t257 398.228
R148 VSS.t273 VSS.n159 26.8308
R149 VSS.t132 VSS.n106 397.132
R150 VSS.n739 VSS.t313 394.286
R151 VSS.n856 VSS.t107 391.118
R152 VSS.t294 VSS.n171 36.5344
R153 VSS.n130 VSS.t71 386.526
R154 VSS.n919 VSS.t67 385.714
R155 VSS.n816 VSS.t342 385.714
R156 VSS.n108 VSS.t267 385.334
R157 VSS.t282 VSS.n118 384.274
R158 VSS.t115 VSS.n822 381.43
R159 VSS.t338 VSS.n756 381.43
R160 VSS.t161 VSS.n817 381.43
R161 VSS.n109 VSS.t258 381.036
R162 VSS.t160 VSS.n114 381.036
R163 VSS.n892 VSS.t284 378.714
R164 VSS.t302 VSS.t359 377.351
R165 VSS.t417 VSS.n824 377.144
R166 VSS.n877 VSS.t247 377.144
R167 VSS.t380 VSS.n138 43.6455
R168 VSS.n130 VSS.t66 376.724
R169 VSS.t179 VSS.n746 372.858
R170 VSS.t168 VSS.n768 372.858
R171 VSS.n765 VSS.t363 372.858
R172 VSS.t366 VSS.n763 372.858
R173 VSS.n887 VSS.t237 372.858
R174 VSS.t240 VSS.n755 372.858
R175 VSS.t242 VSS.n835 369.32
R176 VSS.t182 VSS.n740 368.572
R177 VSS.n920 VSS.t346 368.572
R178 VSS.n827 VSS.t109 368.572
R179 VSS.t113 VSS.n115 368.142
R180 VSS.n116 VSS.t42 368.142
R181 VSS.n152 VSS.t173 52.5375
R182 VSS.n78 VSS.t400 362.846
R183 VSS.n167 VSS.t45 363.127
R184 VSS.t172 VSS.n118 362.846
R185 VSS.n892 VSS.t121 361.033
R186 VSS.n821 VSS.t336 361.033
R187 VSS.t112 VSS.n784 361.033
R188 VSS.t185 VSS.n815 360
R189 VSS.t381 VSS.n736 351.43
R190 VSS.n732 VSS.t406 351.43
R191 VSS.t360 VSS.n835 351.43
R192 VSS.n825 VSS.t411 351.43
R193 VSS.n166 VSS.t83 60.3116
R194 VSS.n878 VSS.t248 351.43
R195 VSS.t291 VSS.n117 350.95
R196 VSS.n859 VSS.t222 348.139
R197 VSS.t374 VSS.n837 347.144
R198 VSS.n747 VSS.t180 347.144
R199 VSS.t394 VSS.n912 347.144
R200 VSS.t428 VSS.n776 347.144
R201 VSS.n868 VSS.t52 347.144
R202 VSS.n873 VSS.t167 347.144
R203 VSS.t367 VSS.n762 347.144
R204 VSS.n889 VSS.t241 347.144
R205 VSS.t3033 VSS.n139 156.482
R206 VSS.n139 VSS.t3038 156.482
R207 VSS.t3088 VSS.n139 156.482
R208 VSS.t3098 VSS.n139 156.482
R209 VSS.t3108 VSS.n139 156.482
R210 VSS.t3113 VSS.n139 156.482
R211 VSS.t3168 VSS.n139 156.482
R212 VSS.t3183 VSS.n139 156.482
R213 VSS.t3188 VSS.n139 156.482
R214 VSS.t3198 VSS.n139 156.482
R215 VSS.t3208 VSS.n139 156.482
R216 VSS.t3228 VSS.n139 156.482
R217 VSS.t3238 VSS.n139 156.482
R218 VSS.t3248 VSS.n139 156.482
R219 VSS.t3263 VSS.n139 156.482
R220 VSS.t3268 VSS.n139 156.482
R221 VSS.n139 VSS.t3278 156.482
R222 VSS.t3293 VSS.n139 156.482
R223 VSS.n139 VSS.t3298 156.482
R224 VSS.n919 VSS.t210 342.858
R225 VSS.n920 VSS.t307 342.858
R226 VSS.t105 VSS.n112 342.354
R227 VSS.n116 VSS.t194 342.354
R228 VSS.n156 VSS.t376 65.92
R229 VSS.t268 VSS.n779 339.543
R230 VSS.t372 VSS.n841 338.572
R231 VSS.t99 VSS.n829 338.572
R232 VSS.t236 VSS.t276 338.572
R233 VSS.t184 VSS.n900 337.046
R234 VSS.t290 VSS.n853 335.245
R235 VSS.n137 VSS.t433 66.199
R236 VSS.t355 VSS.n833 329.168
R237 VSS.n903 VSS.t98 329.168
R238 VSS.n898 VSS.t285 329.168
R239 VSS.t297 VSS.n753 329.168
R240 VSS.n891 VSS.t420 329.168
R241 VSS.n819 VSS.t156 329.168
R242 VSS.t36 VSS.t191 326.649
R243 VSS.n923 VSS.t432 325.714
R244 VSS.t33 VSS.t190 321.486
R245 VSS.n173 VSS.t165 77.4642
R246 VSS.t382 VSS.n745 321.43
R247 VSS.t392 VSS.n911 321.43
R248 VSS.t53 VSS.n773 321.43
R249 VSS.t62 VSS.n769 321.43
R250 VSS.n882 VSS.t226 321.43
R251 VSS.n75 VSS.t200 319.99
R252 VSS.t188 VSS.n105 319.99
R253 VSS.n858 VSS.t80 313.755
R254 VSS.n862 VSS.t192 313.755
R255 VSS.n847 VSS.t418 312.858
R256 VSS.t852 VSS.n735 305.159
R257 VSS.n750 VSS.t9 305.159
R258 VSS.n852 VSS.n789 305.159
R259 VSS.n158 VSS.t283 312.969
R260 VSS.t85 VSS.n754 304.286
R261 VSS.t227 VSS.n761 295.714
R262 VSS.t234 VSS.n758 295.714
R263 VSS.t219 VSS.n900 292.264
R264 VSS.t286 VSS.n894 292.264
R265 VSS.n790 VSS.t345 292.264
R266 VSS.n841 VSS.t404 291.43
R267 VSS.t315 VSS.n161 304.37
R268 VSS.t357 VSS.n829 291.43
R269 VSS.t312 VSS.n754 291.43
R270 VSS.n115 VSS.t331 290.779
R271 VSS.t3026 VSS.n139 157.972
R272 VSS.t3036 VSS.n139 157.976
R273 VSS.t3046 VSS.n139 157.976
R274 VSS.t3081 VSS.n139 157.976
R275 VSS.t3091 VSS.n139 157.976
R276 VSS.t3121 VSS.n139 157.976
R277 VSS.t3176 VSS.n139 157.976
R278 VSS.t3186 VSS.n139 157.976
R279 VSS.t3191 VSS.n139 157.976
R280 VSS.t3211 VSS.n139 157.976
R281 VSS.t3241 VSS.n139 157.976
R282 VSS.t3266 VSS.n139 157.976
R283 VSS.t3281 VSS.n139 157.976
R284 VSS.t3301 VSS.n139 157.976
R285 VSS.n818 VSS.t41 287.144
R286 VSS.n902 VSS.t341 283.334
R287 VSS.n898 VSS.t5 283.334
R288 VSS.t337 VSS.t144 279.37
R289 VSS.n735 VSS.t301 275.072
R290 VSS.n836 VSS.t332 275.072
R291 VSS.t298 VSS.n894 275.072
R292 VSS.n789 VSS.t330 275.072
R293 VSS.t3296 VSS.n139 157.976
R294 VSS.t3288 VSS.n139 156.482
R295 VSS.n139 VSS.t3283 156.482
R296 VSS.n139 VSS.t3273 156.482
R297 VSS.t3271 VSS.n139 157.976
R298 VSS.n139 VSS.t3258 156.482
R299 VSS.n139 VSS.t3253 156.482
R300 VSS.t3251 VSS.n139 157.976
R301 VSS.n139 VSS.t3243 156.482
R302 VSS.n139 VSS.t3233 156.482
R303 VSS.t3231 VSS.n139 157.976
R304 VSS.n139 VSS.t3223 156.482
R305 VSS.n139 VSS.t3218 156.482
R306 VSS.n139 VSS.t3213 156.482
R307 VSS.n139 VSS.t3203 156.482
R308 VSS.t3201 VSS.n139 157.976
R309 VSS.n139 VSS.t3193 156.482
R310 VSS.n139 VSS.t3178 156.482
R311 VSS.n139 VSS.t3173 156.482
R312 VSS.t3171 VSS.n139 157.976
R313 VSS.t3163 VSS.n139 156.482
R314 VSS.n139 VSS.t3158 156.482
R315 VSS.n139 VSS.t3153 156.482
R316 VSS.n139 VSS.t3148 156.482
R317 VSS.n139 VSS.t3143 156.482
R318 VSS.n139 VSS.t3138 156.482
R319 VSS.n139 VSS.t3133 156.482
R320 VSS.n139 VSS.t3128 156.482
R321 VSS.n139 VSS.t3123 156.482
R322 VSS.n139 VSS.t3118 156.482
R323 VSS.t3116 VSS.n139 157.976
R324 VSS.t3111 VSS.n139 157.976
R325 VSS.n139 VSS.t3103 156.482
R326 VSS.t3101 VSS.n139 157.976
R327 VSS.n139 VSS.t3093 156.482
R328 VSS.n139 VSS.t3083 156.482
R329 VSS.n139 VSS.t3078 156.482
R330 VSS.n139 VSS.t3073 156.482
R331 VSS.n139 VSS.t3068 156.482
R332 VSS.n139 VSS.t3063 156.482
R333 VSS.n139 VSS.t3058 156.482
R334 VSS.n139 VSS.t3053 156.482
R335 VSS.t3048 VSS.n139 156.482
R336 VSS.n139 VSS.t3043 156.482
R337 VSS.n139 VSS.t3041 157.976
R338 VSS.n139 VSS.t3031 157.976
R339 VSS.n139 VSS.t3023 156.288
R340 VSS.n117 VSS.t163 273.587
R341 VSS.n85 VSS.t371 272.846
R342 VSS.t385 VSS.n744 270
R343 VSS.t390 VSS.n909 270
R344 VSS.t55 VSS.n772 270
R345 VSS.t60 VSS.n770 270
R346 VSS.n883 VSS.t228 270
R347 VSS.t317 VSS.t104 266.476
R348 VSS.n854 VSS.t96 266.476
R349 VSS.t221 VSS.t279 266.476
R350 VSS.t280 VSS.t193 266.476
R351 VSS.t431 VSS.t75 265.714
R352 VSS.t249 VSS.t362 261.43
R353 VSS.t379 VSS.n737 258.334
R354 VSS.t3304 VSS.t361 258.334
R355 VSS.t358 VSS.n141 264.873
R356 VSS.n901 VSS.t68 258.334
R357 VSS.t122 VSS.t93 258.334
R358 VSS.t120 VSS.n752 258.334
R359 VSS.t217 VSS.t318 258.334
R360 VSS.n145 VSS.t299 288.68
R361 VSS.n821 VSS.t626 257.88
R362 VSS.t402 VSS.n838 257.144
R363 VSS.n826 VSS.t34 257.144
R364 VSS.n863 VSS.t296 257.144
R365 VSS.n888 VSS.t419 257.144
R366 VSS.t281 VSS.n786 253.583
R367 VSS.t302 VSS.t676 108.999
R368 VSS.t682 VSS.t302 109.001
R369 VSS.t302 VSS.t684 108.999
R370 VSS.t696 VSS.t302 108.999
R371 VSS.t701 VSS.t302 108.999
R372 VSS.t705 VSS.t302 108.999
R373 VSS.t709 VSS.t302 108.999
R374 VSS.t691 VSS.t302 108.993
R375 VSS.n91 VSS.t724 251.417
R376 VSS.n96 VSS.t727 251.417
R377 VSS.n99 VSS.t730 251.417
R378 VSS.n95 VSS.t733 251.417
R379 VSS.n92 VSS.t736 251.417
R380 VSS.n71 VSS.t739 251.417
R381 VSS.n74 VSS.t742 251.417
R382 VSS.n70 VSS.t745 251.417
R383 VSS.n67 VSS.t748 251.417
R384 VSS.n62 VSS.t751 251.417
R385 VSS.n59 VSS.t754 251.417
R386 VSS.n63 VSS.t759 251.417
R387 VSS.n66 VSS.t762 251.417
R388 VSS.n100 VSS.t765 251.417
R389 VSS.n103 VSS.t768 251.417
R390 VSS.n848 VSS.t302 427.5
R391 VSS.t786 VSS.n88 251.417
R392 VSS.n845 VSS.t3303 250.952
R393 VSS.n890 VSS.t86 250.952
R394 VSS.t316 VSS.n813 250.952
R395 VSS.t302 VSS.n141 9.79521
R396 VSS.t32 VSS.n127 249.002
R397 VSS.n107 VSS.t333 249.002
R398 VSS.t87 VSS.t250 245.833
R399 VSS.t274 VSS.n751 244.987
R400 VSS.n916 VSS.t386 244.286
R401 VSS.t389 VSS.n908 244.286
R402 VSS.n870 VSS.t56 244.286
R403 VSS.n871 VSS.t59 244.286
R404 VSS.t229 VSS.n760 244.286
R405 VSS.t232 VSS.n759 244.286
R406 VSS.t111 VSS.n110 243.5
R407 VSS.t675 VSS.t302 109.986
R408 VSS.t679 VSS.t302 109.992
R409 VSS.t688 VSS.t302 109.992
R410 VSS.t302 VSS.t699 109.992
R411 VSS.t302 VSS.t708 109.992
R412 VSS.t302 VSS.t712 109.992
R413 VSS.n90 VSS.t857 242.846
R414 VSS.n97 VSS.t859 242.846
R415 VSS.n98 VSS.t861 242.846
R416 VSS.n94 VSS.t863 242.846
R417 VSS.n93 VSS.t865 242.846
R418 VSS.n72 VSS.t867 242.846
R419 VSS.n73 VSS.t869 242.846
R420 VSS.n69 VSS.t871 242.846
R421 VSS.n68 VSS.t873 242.846
R422 VSS.n61 VSS.t875 242.846
R423 VSS.n60 VSS.t877 242.846
R424 VSS.n64 VSS.t879 242.846
R425 VSS.n65 VSS.t881 242.846
R426 VSS.n101 VSS.t883 242.846
R427 VSS.n102 VSS.t885 242.846
R428 VSS.t690 VSS.n87 242.846
R429 VSS.t787 VSS.n86 242.846
R430 VSS.n105 VSS.t570 242.846
R431 VSS.t125 VSS.t166 240.689
R432 VSS.n138 VSS.t849 238.357
R433 VSS.n792 VSS.t627 236.391
R434 VSS.n55 VSS.t2356 108.722
R435 VSS.n55 VSS.t2401 108.999
R436 VSS.n55 VSS.t2451 108.999
R437 VSS.n55 VSS.t2456 108.999
R438 VSS.n55 VSS.t2476 109.001
R439 VSS.t2511 VSS.n55 108.999
R440 VSS.n55 VSS.t2516 109.001
R441 VSS.t2521 VSS.n55 108.999
R442 VSS.t2531 VSS.n55 108.999
R443 VSS.n55 VSS.t2546 108.999
R444 VSS.t2561 VSS.n55 108.999
R445 VSS.t2571 VSS.n55 108.999
R446 VSS.n55 VSS.t2586 109.001
R447 VSS.t2591 VSS.n55 108.999
R448 VSS.t2601 VSS.n55 108.999
R449 VSS.t2611 VSS.n55 108.999
R450 VSS.t2631 VSS.n55 108.999
R451 VSS.n56 VSS.t2074 108.999
R452 VSS.n56 VSS.t2114 108.999
R453 VSS.n56 VSS.t2124 108.999
R454 VSS.t2139 VSS.n56 109.001
R455 VSS.n56 VSS.t2144 108.999
R456 VSS.t2159 VSS.n56 108.999
R457 VSS.n56 VSS.t2164 108.999
R458 VSS.n56 VSS.t2174 109.001
R459 VSS.t2179 VSS.n56 108.999
R460 VSS.t2199 VSS.n56 108.999
R461 VSS.n56 VSS.t2214 108.999
R462 VSS.t2219 VSS.n56 108.999
R463 VSS.t2229 VSS.n56 109.001
R464 VSS.t2239 VSS.n56 108.999
R465 VSS.n57 VSS.t1717 108.999
R466 VSS.n57 VSS.t1737 108.999
R467 VSS.n57 VSS.t1742 108.999
R468 VSS.n57 VSS.t1762 108.999
R469 VSS.n57 VSS.t1777 108.999
R470 VSS.n57 VSS.t1792 108.999
R471 VSS.n54 VSS.t888 108.722
R472 VSS.t923 VSS.n54 108.999
R473 VSS.t963 VSS.n54 108.999
R474 VSS.n54 VSS.t998 108.999
R475 VSS.t1023 VSS.n54 108.999
R476 VSS.n54 VSS.t1038 108.999
R477 VSS.t1063 VSS.n54 108.999
R478 VSS.n54 VSS.t1068 108.999
R479 VSS.t1083 VSS.n54 108.999
R480 VSS.t1093 VSS.n54 108.999
R481 VSS.n54 VSS.t1098 109.001
R482 VSS.t1103 VSS.n54 108.999
R483 VSS.t1133 VSS.n54 108.999
R484 VSS.n54 VSS.t1158 108.999
R485 VSS.t1163 VSS.n54 108.999
R486 VSS.n279 VSS.t856 251.417
R487 VSS.n213 VSS.t858 251.417
R488 VSS.n278 VSS.t860 251.417
R489 VSS.n254 VSS.t862 251.417
R490 VSS.n277 VSS.t864 251.417
R491 VSS.n174 VSS.t866 251.417
R492 VSS.n276 VSS.t868 251.417
R493 VSS.n255 VSS.t870 251.417
R494 VSS.n275 VSS.t872 251.417
R495 VSS.n212 VSS.t874 251.417
R496 VSS.n274 VSS.t876 251.417
R497 VSS.n256 VSS.t878 251.417
R498 VSS.n273 VSS.t880 251.417
R499 VSS.n170 VSS.t882 251.417
R500 VSS.n272 VSS.t884 251.417
R501 VSS.n842 VSS.t815 235.714
R502 VSS.n156 VSS.t818 238.992
R503 VSS.n214 VSS.t821 251.417
R504 VSS.n152 VSS.t825 238.173
R505 VSS.t830 VSS.n910 235.714
R506 VSS.t834 VSS.n742 235.714
R507 VSS.t714 VSS.n150 105.684
R508 VSS.t719 VSS.n151 105.684
R509 VSS.n921 VSS.t843 235.714
R510 VSS.n846 VSS.t689 235.714
R511 VSS.n831 VSS.t788 235.714
R512 VSS.n874 VSS.t640 235.714
R513 VSS.t33 VSS.t569 252.065
R514 VSS.t303 VSS.n895 233.333
R515 VSS.n104 VSS.t39 232.335
R516 VSS.n834 VSS.t813 229.167
R517 VSS.n55 VSS.t2364 109.992
R518 VSS.n55 VSS.t2369 109.993
R519 VSS.n55 VSS.t2379 109.992
R520 VSS.n55 VSS.t2414 109.992
R521 VSS.n55 VSS.t2424 109.992
R522 VSS.n55 VSS.t2469 109.992
R523 VSS.n56 VSS.t1972 109.992
R524 VSS.n56 VSS.t1982 109.992
R525 VSS.n56 VSS.t2002 109.992
R526 VSS.n56 VSS.t2022 109.992
R527 VSS.n56 VSS.t2032 109.992
R528 VSS.n56 VSS.t2042 109.992
R529 VSS.n56 VSS.t2047 109.993
R530 VSS.n56 VSS.t2092 109.992
R531 VSS.n56 VSS.t2097 109.993
R532 VSS.n56 VSS.t2102 109.992
R533 VSS.n56 VSS.t2237 109.992
R534 VSS.n57 VSS.t1580 109.992
R535 VSS.n57 VSS.t1595 109.992
R536 VSS.n57 VSS.t1615 109.992
R537 VSS.n57 VSS.t1620 109.993
R538 VSS.n57 VSS.t1665 109.992
R539 VSS.n54 VSS.t896 109.993
R540 VSS.n54 VSS.t901 109.992
R541 VSS.n54 VSS.t911 109.993
R542 VSS.n54 VSS.t941 109.992
R543 VSS.n54 VSS.t971 109.993
R544 VSS.n54 VSS.t976 109.992
R545 VSS.n54 VSS.t981 109.992
R546 VSS.n54 VSS.t1011 109.993
R547 VSS.n923 VSS.t855 227.143
R548 VSS.n213 VSS.t726 242.846
R549 VSS.n257 VSS.t770 243.169
R550 VSS.n840 VSS.t827 227.143
R551 VSS.t370 VSS.t833 227.143
R552 VSS.n146 VSS.t837 106.677
R553 VSS.n869 VSS.t637 227.143
R554 VSS.n875 VSS.t641 227.143
R555 VSS.t277 VSS.t233 227.143
R556 VSS.t33 VSS.t567 109.986
R557 VSS.t207 VSS.t235 222.857
R558 VSS.t785 VSS.t302 111.022
R559 VSS.n157 VSS.t302 96.0268
R560 VSS.t722 VSS.n143 107.194
R561 VSS.t354 VSS.n161 67.9
R562 VSS.t842 VSS.n142 102.703
R563 VSS.t571 VSS.n110 222.011
R564 VSS.t723 VSS.n77 221.417
R565 VSS.n844 VSS.t814 220.833
R566 VSS.t387 VSS.n915 218.571
R567 VSS.n915 VSS.t388 218.571
R568 VSS.t57 VSS.n771 218.571
R569 VSS.t58 VSS.n771 218.571
R570 VSS.n884 VSS.t231 218.571
R571 VSS.t340 VSS.t421 212.5
R572 VSS.n163 VSS.t571 214.988
R573 VSS.t841 VSS.n143 106.159
R574 VSS.n921 VSS.t723 205.714
R575 VSS.n880 VSS.t572 205.714
R576 VSS.t572 VSS.n764 205.714
R577 VSS.t628 VSS.n163 102.749
R578 VSS.t2359 VSS.n55 109.986
R579 VSS.t2384 VSS.n55 109.993
R580 VSS.t2394 VSS.n55 109.993
R581 VSS.t2409 VSS.n55 109.993
R582 VSS.t2419 VSS.n55 109.993
R583 VSS.t2434 VSS.n55 109.993
R584 VSS.t2454 VSS.n55 109.993
R585 VSS.n55 VSS.t2494 109.993
R586 VSS.t2514 VSS.n55 109.993
R587 VSS.t2534 VSS.n55 109.993
R588 VSS.t2549 VSS.n55 109.993
R589 VSS.t2554 VSS.n55 109.993
R590 VSS.t2574 VSS.n55 109.993
R591 VSS.t2599 VSS.n55 109.993
R592 VSS.t2604 VSS.n55 109.993
R593 VSS.t2629 VSS.n55 109.993
R594 VSS.t2634 VSS.n55 109.993
R595 VSS.t1977 VSS.n56 109.993
R596 VSS.t1992 VSS.n56 109.993
R597 VSS.t1997 VSS.n56 109.993
R598 VSS.t2017 VSS.n56 109.993
R599 VSS.t2037 VSS.n56 109.993
R600 VSS.t2072 VSS.n56 109.993
R601 VSS.t2087 VSS.n56 109.993
R602 VSS.t2107 VSS.n56 109.993
R603 VSS.t2117 VSS.n56 109.993
R604 VSS.t2137 VSS.n56 109.993
R605 VSS.t2147 VSS.n56 109.993
R606 VSS.t2157 VSS.n56 109.993
R607 VSS.t2182 VSS.n56 109.993
R608 VSS.t2202 VSS.n56 109.993
R609 VSS.t2207 VSS.n56 109.993
R610 VSS.t2242 VSS.n56 109.993
R611 VSS.t1575 VSS.n57 109.986
R612 VSS.t1585 VSS.n57 109.993
R613 VSS.t1590 VSS.n57 109.993
R614 VSS.t1630 VSS.n57 109.993
R615 VSS.t1640 VSS.n57 109.993
R616 VSS.t1660 VSS.n57 109.993
R617 VSS.t1680 VSS.n57 109.993
R618 VSS.t1710 VSS.n57 109.993
R619 VSS.t1755 VSS.n57 109.993
R620 VSS.t1780 VSS.n57 109.993
R621 VSS.t1795 VSS.n57 109.993
R622 VSS.t1815 VSS.n57 109.993
R623 VSS.t1845 VSS.n57 109.993
R624 VSS.t1850 VSS.n57 109.993
R625 VSS.t921 VSS.n54 109.993
R626 VSS.t936 VSS.n54 109.993
R627 VSS.t956 VSS.n54 109.993
R628 VSS.t986 VSS.n54 109.993
R629 VSS.t1001 VSS.n54 109.993
R630 VSS.t1026 VSS.n54 109.993
R631 VSS.t1031 VSS.n54 109.993
R632 VSS.t1041 VSS.n54 109.993
R633 VSS.t1056 VSS.n54 109.993
R634 VSS.t1066 VSS.n54 109.993
R635 VSS.t1096 VSS.n54 109.993
R636 VSS.t1121 VSS.n54 109.993
R637 VSS.t1131 VSS.n54 109.993
R638 VSS.t1146 VSS.n54 109.993
R639 VSS.t1166 VSS.n54 109.993
R640 VSS.t820 VSS.n155 102.457
R641 VSS.n150 VSS.t835 106.677
R642 VSS.n148 VSS.t716 23.2336
R643 VSS.n146 VSS.t302 3.31704
R644 VSS.n147 VSS.t302 86.7547
R645 VSS.n151 VSS.t839 106.677
R646 VSS.t302 VSS.n144 86.7547
R647 VSS.t681 VSS.t302 109.993
R648 VSS.t302 VSS.t692 109.986
R649 VSS.t302 VSS.t697 109.993
R650 VSS.t302 VSS.t702 109.993
R651 VSS.t811 VSS.n158 102.457
R652 VSS.t632 VSS.t33 200.613
R653 VSS.t855 VSS.n89 199.989
R654 VSS.n90 VSS.t726 199.989
R655 VSS.n97 VSS.t729 199.989
R656 VSS.n98 VSS.t732 199.989
R657 VSS.n94 VSS.t735 199.989
R658 VSS.n93 VSS.t738 199.989
R659 VSS.n72 VSS.t741 199.989
R660 VSS.n73 VSS.t744 199.989
R661 VSS.n69 VSS.t747 199.989
R662 VSS.n68 VSS.t750 199.989
R663 VSS.n61 VSS.t753 199.989
R664 VSS.t757 VSS.n60 199.989
R665 VSS.t761 VSS.n64 199.989
R666 VSS.t764 VSS.n65 199.989
R667 VSS.t767 VSS.n101 199.989
R668 VSS.t770 VSS.n102 199.989
R669 VSS.t833 VSS.n78 199.989
R670 VSS.n87 VSS.t787 199.989
R671 VSS.t399 VSS.t832 197.143
R672 VSS.t51 VSS.t636 197.143
R673 VSS.t343 VSS.t94 193.411
R674 VSS.t388 VSS.n908 192.857
R675 VSS.n870 VSS.t57 192.857
R676 VSS.t230 VSS.n760 192.857
R677 VSS.t2626 VSS.n55 108.999
R678 VSS.n55 VSS.t2621 109.001
R679 VSS.t2616 VSS.n55 109.001
R680 VSS.t2614 VSS.n55 109.993
R681 VSS.t2606 VSS.n55 109.001
R682 VSS.t2596 VSS.n55 108.999
R683 VSS.t2594 VSS.n55 109.993
R684 VSS.n55 VSS.t2589 109.992
R685 VSS.n55 VSS.t2581 108.999
R686 VSS.t2576 VSS.n55 109.001
R687 VSS.t2566 VSS.n55 109.001
R688 VSS.t2564 VSS.n55 109.993
R689 VSS.t2556 VSS.n55 109.001
R690 VSS.n55 VSS.t2551 108.999
R691 VSS.n55 VSS.t2541 109.001
R692 VSS.t2536 VSS.n55 108.999
R693 VSS.t2526 VSS.n55 109.001
R694 VSS.t2524 VSS.n55 109.993
R695 VSS.n55 VSS.t2519 109.992
R696 VSS.t2506 VSS.n55 109.001
R697 VSS.n55 VSS.t2501 108.999
R698 VSS.t2486 VSS.n55 109.001
R699 VSS.t2481 VSS.n55 108.999
R700 VSS.n55 VSS.t2479 109.992
R701 VSS.n55 VSS.t2474 109.993
R702 VSS.t2466 VSS.n55 109.001
R703 VSS.t2461 VSS.n55 109.001
R704 VSS.n55 VSS.t2459 109.993
R705 VSS.t2446 VSS.n55 109.001
R706 VSS.n55 VSS.t2444 109.993
R707 VSS.t2436 VSS.n55 109.001
R708 VSS.t2431 VSS.n55 108.999
R709 VSS.n55 VSS.t2429 109.993
R710 VSS.t2421 VSS.n55 109.001
R711 VSS.t2411 VSS.n55 109.001
R712 VSS.t2406 VSS.n55 108.999
R713 VSS.n55 VSS.t2404 109.993
R714 VSS.t2396 VSS.n55 109.001
R715 VSS.t2391 VSS.n55 108.999
R716 VSS.t2386 VSS.n55 109.001
R717 VSS.t2381 VSS.n55 108.999
R718 VSS.t2376 VSS.n55 109.001
R719 VSS.n55 VSS.t2374 109.992
R720 VSS.t2366 VSS.n55 108.999
R721 VSS.t2361 VSS.n55 109.001
R722 VSS.n55 VSS.t2496 109.001
R723 VSS.t2234 VSS.n56 109.001
R724 VSS.t2232 VSS.n56 109.992
R725 VSS.t2224 VSS.n56 109.001
R726 VSS.t2222 VSS.n56 109.993
R727 VSS.n56 VSS.t2217 109.993
R728 VSS.n56 VSS.t2209 109.001
R729 VSS.t2204 VSS.n56 108.999
R730 VSS.t2194 VSS.n56 109.001
R731 VSS.n56 VSS.t2189 109.001
R732 VSS.t2184 VSS.n56 108.999
R733 VSS.n56 VSS.t2177 109.992
R734 VSS.n56 VSS.t2169 109.001
R735 VSS.n56 VSS.t2167 109.993
R736 VSS.t2162 VSS.n56 109.993
R737 VSS.t2154 VSS.n56 108.999
R738 VSS.n56 VSS.t2149 109.001
R739 VSS.t2142 VSS.n56 109.992
R740 VSS.t2134 VSS.n56 108.999
R741 VSS.n56 VSS.t2129 109.001
R742 VSS.n56 VSS.t2127 109.993
R743 VSS.n56 VSS.t2119 109.001
R744 VSS.n56 VSS.t2109 109.001
R745 VSS.n56 VSS.t2099 109.001
R746 VSS.t2094 VSS.n56 108.999
R747 VSS.n56 VSS.t2089 109.001
R748 VSS.t2084 VSS.n56 108.999
R749 VSS.t2082 VSS.n56 109.992
R750 VSS.n56 VSS.t2077 109.993
R751 VSS.n56 VSS.t2069 108.999
R752 VSS.t2064 VSS.n56 109.001
R753 VSS.n56 VSS.t2059 109.001
R754 VSS.n56 VSS.t2057 109.993
R755 VSS.t2052 VSS.n56 109.992
R756 VSS.t2044 VSS.n56 108.999
R757 VSS.n56 VSS.t2039 109.001
R758 VSS.t2034 VSS.n56 108.999
R759 VSS.n56 VSS.t2029 109.001
R760 VSS.n56 VSS.t2027 109.993
R761 VSS.n56 VSS.t2019 109.001
R762 VSS.t2014 VSS.n56 108.999
R763 VSS.t2012 VSS.n56 109.992
R764 VSS.n56 VSS.t2007 109.993
R765 VSS.n56 VSS.t1999 109.001
R766 VSS.n56 VSS.t1994 108.999
R767 VSS.t1989 VSS.n56 108.999
R768 VSS.t1987 VSS.n56 109.992
R769 VSS.t1979 VSS.n56 109.001
R770 VSS.n56 VSS.t1974 108.999
R771 VSS.t1969 VSS.n56 109.001
R772 VSS.n56 VSS.t1964 108.722
R773 VSS.t1847 VSS.n57 108.999
R774 VSS.n57 VSS.t1842 108.999
R775 VSS.t1837 VSS.n57 109.001
R776 VSS.n57 VSS.t1832 109.001
R777 VSS.n57 VSS.t1827 108.999
R778 VSS.t1822 VSS.n57 109.001
R779 VSS.t1817 VSS.n57 109.001
R780 VSS.t1812 VSS.n57 108.999
R781 VSS.t1807 VSS.n57 109.001
R782 VSS.t1802 VSS.n57 108.999
R783 VSS.t1797 VSS.n57 109.001
R784 VSS.t1787 VSS.n57 109.001
R785 VSS.t1782 VSS.n57 108.999
R786 VSS.t1772 VSS.n57 109.001
R787 VSS.t1767 VSS.n57 109.001
R788 VSS.n57 VSS.t1765 109.993
R789 VSS.t1757 VSS.n57 109.001
R790 VSS.t1752 VSS.n57 108.999
R791 VSS.t1747 VSS.n57 109.001
R792 VSS.n57 VSS.t1745 109.993
R793 VSS.n57 VSS.t1740 109.993
R794 VSS.t1732 VSS.n57 109.001
R795 VSS.t1727 VSS.n57 108.999
R796 VSS.t1722 VSS.n57 109.001
R797 VSS.n57 VSS.t1720 109.993
R798 VSS.t1705 VSS.n57 109.992
R799 VSS.n57 VSS.t1700 109.992
R800 VSS.t1695 VSS.n57 109.993
R801 VSS.n57 VSS.t1690 109.993
R802 VSS.t1685 VSS.n57 109.992
R803 VSS.t1677 VSS.n57 108.999
R804 VSS.t1675 VSS.n57 109.992
R805 VSS.n57 VSS.t1670 109.993
R806 VSS.n57 VSS.t1662 109.001
R807 VSS.t1657 VSS.n57 108.999
R808 VSS.n57 VSS.t1652 109.001
R809 VSS.n57 VSS.t1650 109.993
R810 VSS.n57 VSS.t1642 109.001
R811 VSS.t1637 VSS.n57 108.999
R812 VSS.n57 VSS.t1632 109.001
R813 VSS.t1627 VSS.n57 108.999
R814 VSS.t1625 VSS.n57 109.992
R815 VSS.t1617 VSS.n57 108.999
R816 VSS.n57 VSS.t1612 109.001
R817 VSS.n57 VSS.t1610 109.993
R818 VSS.t1605 VSS.n57 109.992
R819 VSS.n57 VSS.t1600 109.993
R820 VSS.n57 VSS.t1592 109.001
R821 VSS.t1587 VSS.n57 108.999
R822 VSS.n57 VSS.t1582 108.999
R823 VSS.t1577 VSS.n57 109.001
R824 VSS.n57 VSS.t1572 108.722
R825 VSS.t1712 VSS.n57 109.001
R826 VSS.n54 VSS.t1161 109.993
R827 VSS.n54 VSS.t1153 109.001
R828 VSS.t1148 VSS.n54 109.001
R829 VSS.n54 VSS.t1143 108.999
R830 VSS.t1138 VSS.n54 109.001
R831 VSS.t1136 VSS.n54 109.993
R832 VSS.t1128 VSS.n54 108.999
R833 VSS.n54 VSS.t1123 109.001
R834 VSS.t1118 VSS.n54 108.999
R835 VSS.n54 VSS.t1113 108.999
R836 VSS.t1108 VSS.n54 109.001
R837 VSS.t1106 VSS.n54 109.993
R838 VSS.n54 VSS.t1101 109.992
R839 VSS.t1088 VSS.n54 109.001
R840 VSS.t1086 VSS.n54 109.993
R841 VSS.t1078 VSS.n54 108.999
R842 VSS.n54 VSS.t1073 109.001
R843 VSS.n54 VSS.t1071 109.993
R844 VSS.t1058 VSS.n54 109.001
R845 VSS.n54 VSS.t1053 108.999
R846 VSS.t1048 VSS.n54 109.001
R847 VSS.n54 VSS.t1043 109.001
R848 VSS.n54 VSS.t1033 109.001
R849 VSS.n54 VSS.t1021 109.993
R850 VSS.n54 VSS.t1013 109.001
R851 VSS.t1008 VSS.n54 108.999
R852 VSS.n54 VSS.t1003 109.001
R853 VSS.n54 VSS.t993 108.999
R854 VSS.t988 VSS.n54 109.001
R855 VSS.t978 VSS.n54 109.001
R856 VSS.n54 VSS.t973 109.001
R857 VSS.t968 VSS.n54 108.999
R858 VSS.t966 VSS.n54 109.993
R859 VSS.t958 VSS.n54 109.001
R860 VSS.n54 VSS.t953 108.999
R861 VSS.t948 VSS.n54 109.001
R862 VSS.n54 VSS.t943 108.999
R863 VSS.t938 VSS.n54 109.001
R864 VSS.n54 VSS.t933 108.999
R865 VSS.t928 VSS.n54 109.001
R866 VSS.t926 VSS.n54 109.993
R867 VSS.n54 VSS.t918 108.999
R868 VSS.t913 VSS.n54 109.001
R869 VSS.t908 VSS.n54 108.999
R870 VSS.n54 VSS.t906 109.992
R871 VSS.t898 VSS.n54 109.001
R872 VSS.t893 VSS.n54 108.999
R873 VSS.n54 VSS.t1028 108.999
R874 VSS.t840 VSS.n144 22.2411
R875 VSS.t302 VSS.n151 3.31705
R876 VSS.n147 VSS.t838 22.2411
R877 VSS.t717 VSS.n146 105.683
R878 VSS.n148 VSS.t302 86.7547
R879 VSS.t302 VSS.n150 3.31705
R880 VSS.n157 VSS.t810 12.9737
R881 VSS.t711 VSS.t302 109.001
R882 VSS.t710 VSS.t302 109.993
R883 VSS.t707 VSS.t302 109.001
R884 VSS.t706 VSS.t302 109.993
R885 VSS.t703 VSS.t302 109.001
R886 VSS.t698 VSS.t302 109.001
R887 VSS.t693 VSS.t302 109.001
R888 VSS.t302 VSS.t687 109.001
R889 VSS.t302 VSS.t685 109.993
R890 VSS.t683 VSS.t302 109.992
R891 VSS.t680 VSS.t302 108.999
R892 VSS.t302 VSS.t678 109.001
R893 VSS.t302 VSS.t677 109.993
R894 VSS.t302 VSS.t674 108.722
R895 VSS.t33 VSS.t564 108.722
R896 VSS.t73 VSS.t845 191.667
R897 VSS.t856 VSS.n91 191.417
R898 VSS.t858 VSS.n96 191.417
R899 VSS.t860 VSS.n99 191.417
R900 VSS.t862 VSS.n95 191.417
R901 VSS.t864 VSS.n92 191.417
R902 VSS.t866 VSS.n71 191.417
R903 VSS.t868 VSS.n74 191.417
R904 VSS.t870 VSS.n70 191.417
R905 VSS.t872 VSS.n67 191.417
R906 VSS.t874 VSS.n62 191.417
R907 VSS.t876 VSS.n59 191.417
R908 VSS.n63 VSS.t878 191.417
R909 VSS.n66 VSS.t880 191.417
R910 VSS.n100 VSS.t882 191.417
R911 VSS.n103 VSS.t884 191.417
R912 VSS.n84 VSS.t815 191.417
R913 VSS.t843 VSS.n75 191.417
R914 VSS.n88 VSS.t689 191.417
R915 VSS.t788 VSS.n85 191.417
R916 VSS.t633 VSS.n167 108.635
R917 VSS.t831 VSS.t395 188.571
R918 VSS.t635 VSS.t47 188.571
R919 VSS.t813 VSS.n83 186.502
R920 VSS.n853 VSS.t111 184.815
R921 VSS.n173 VSS.t4 188.911
R922 VSS.t857 VSS.n731 184.286
R923 VSS.t859 VSS.n730 184.286
R924 VSS.t861 VSS.n729 184.286
R925 VSS.t863 VSS.n728 184.286
R926 VSS.t865 VSS.n727 184.286
R927 VSS.t867 VSS.n726 184.286
R928 VSS.t869 VSS.n725 184.286
R929 VSS.t871 VSS.n724 184.286
R930 VSS.t873 VSS.n723 184.286
R931 VSS.t875 VSS.n722 184.286
R932 VSS.t877 VSS.n721 184.286
R933 VSS.t879 VSS.n924 184.286
R934 VSS.t881 VSS.n925 184.286
R935 VSS.t883 VSS.n926 184.286
R936 VSS.t885 VSS.n927 184.286
R937 VSS.n916 VSS.t829 184.286
R938 VSS.n914 VSS.t831 184.286
R939 VSS.t844 VSS.n738 184.286
R940 VSS.n830 VSS.t690 184.286
R941 VSS.t789 VSS.n828 184.286
R942 VSS.n775 VSS.t635 184.286
R943 VSS.n872 VSS.t639 184.286
R944 VSS.t570 VSS.n814 184.286
R945 VSS.t39 VSS.n812 183.333
R946 VSS.t814 VSS.n832 179.167
R947 VSS.t849 VSS.n734 176.219
R948 VSS.t854 VSS.n733 175.714
R949 VSS.t724 VSS.n731 175.714
R950 VSS.t727 VSS.n730 175.714
R951 VSS.t730 VSS.n729 175.714
R952 VSS.t733 VSS.n728 175.714
R953 VSS.t736 VSS.n727 175.714
R954 VSS.t739 VSS.n726 175.714
R955 VSS.t742 VSS.n725 175.714
R956 VSS.t745 VSS.n724 175.714
R957 VSS.t748 VSS.n723 175.714
R958 VSS.t751 VSS.n722 175.714
R959 VSS.t754 VSS.n721 175.714
R960 VSS.t759 VSS.n924 175.714
R961 VSS.t762 VSS.n925 175.714
R962 VSS.t765 VSS.n926 175.714
R963 VSS.t768 VSS.n927 175.714
R964 VSS.n838 VSS.t821 175.714
R965 VSS.n907 VSS.t828 175.714
R966 VSS.t832 VSS.n743 175.714
R967 VSS.n830 VSS.t786 175.714
R968 VSS.t636 VSS.n774 175.714
R969 VSS.n871 VSS.t638 175.714
R970 VSS.t223 VSS.t195 171.53
R971 VSS.t408 VSS.t854 171.429
R972 VSS.t375 VSS.t817 171.429
R973 VSS.t827 VSS.t177 171.429
R974 VSS.n820 VSS.t624 170.833
R975 VSS.n80 VSS.t402 169.989
R976 VSS.n893 VSS.t274 167.623
R977 VSS.t386 VSS.n744 167.143
R978 VSS.n909 VSS.t389 167.143
R979 VSS.t56 VSS.n772 167.143
R980 VSS.t59 VSS.n770 167.143
R981 VSS.n883 VSS.t229 167.143
R982 VSS.n885 VSS.t232 167.143
R983 VSS.n737 VSS.t409 166.667
R984 VSS.n141 VSS.t352 96.0227
R985 VSS.n901 VSS.t32 166.667
R986 VSS.n899 VSS.t303 166.667
R987 VSS.t197 VSS.n752 166.667
R988 VSS.t333 VSS.n820 166.667
R989 VSS.n124 VSS.t269 165.669
R990 VSS.t626 VSS.n107 165.669
R991 VSS.t640 VSS.t169 162.857
R992 VSS.n855 VSS.t281 159.026
R993 VSS.t424 VSS.t230 158.571
R994 VSS.t231 VSS.t206 158.571
R995 VSS.n79 VSS.t379 157.335
R996 VSS.t65 VSS.n129 157.335
R997 VSS.n121 VSS.t120 157.335
R998 VSS.n791 VSS.t343 154.728
R999 VSS.t163 VSS.n780 154.728
R1000 VSS.t824 VSS.t138 154.286
R1001 VSS.t34 VSS.n823 154.286
R1002 VSS.t371 VSS.n828 154.286
R1003 VSS.n137 VSS.t72 167.082
R1004 VSS.n833 VSS.t3303 154.167
R1005 VSS.t423 VSS.n902 154.167
R1006 VSS.t91 VSS.n903 154.167
R1007 VSS.t86 VSS.n753 154.167
R1008 VSS.t299 VSS.n125 153.243
R1009 VSS.t330 VSS.n111 153.243
R1010 VSS.t300 VSS.t201 150.43
R1011 VSS.n899 VSS.t425 150
R1012 VSS.t21 VSS.t630 145.714
R1013 VSS.t641 VSS.t171 145.714
R1014 VSS.n844 VSS.t358 141.667
R1015 VSS.n226 VSS.t335 157.335
R1016 VSS.n907 VSS.t385 141.429
R1017 VSS.n910 VSS.t390 141.429
R1018 VSS.t430 VSS.t632 141.429
R1019 VSS.n869 VSS.t55 141.429
R1020 VSS.n872 VSS.t60 141.429
R1021 VSS.t233 VSS.n758 141.429
R1022 VSS.t419 VSS.t239 141.429
R1023 VSS.t301 VSS.n734 137.536
R1024 VSS.n893 VSS.t300 137.536
R1025 VSS.t825 VSS.t175 137.143
R1026 VSS.t26 VSS.t834 132.857
R1027 VSS.t201 VSS.n750 124.642
R1028 VSS.t332 VSS.t64 120.344
R1029 VSS.n860 VSS.t125 120.344
R1030 VSS.n214 VSS.t404 135.703
R1031 VSS.t828 VSS.t383 120.001
R1032 VSS.n825 VSS.t315 120.001
R1033 VSS.n831 VSS.t357 120.001
R1034 VSS.t630 VSS.t429 120.001
R1035 VSS.n889 VSS.t312 120.001
R1036 VSS.t405 VSS.n79 119.835
R1037 VSS.n126 VSS.t7 119.835
R1038 VSS.n129 VSS.t122 119.835
R1039 VSS.t196 VSS.n121 119.835
R1040 VSS.t5 VSS.n896 116.668
R1041 VSS.t627 VSS.t119 116.046
R1042 VSS.t818 VSS.t368 115.715
R1043 VSS.t383 VSS.n745 115.715
R1044 VSS.n911 VSS.t391 115.715
R1045 VSS.t54 VSS.n773 115.715
R1046 VSS.t61 VSS.n769 115.715
R1047 VSS.n886 VSS.t234 115.715
R1048 VSS.t68 VSS.t264 112.501
R1049 VSS.t639 VSS.t61 111.43
R1050 VSS.t425 VSS.t65 108.334
R1051 VSS.n852 VSS.n788 107.451
R1052 VSS.t345 VSS.t334 107.451
R1053 VSS.t331 VSS.t265 107.451
R1054 VSS.n736 VSS.t852 107.144
R1055 VSS.t200 VSS.n738 107.144
R1056 VSS.t283 VSS.n845 107.144
R1057 VSS.n863 VSS.t224 107.144
R1058 VSS.n817 VSS.t188 107.144
R1059 VSS.t77 VSS.n813 107.144
R1060 VSS.t361 VSS.n832 104.168
R1061 VSS.t162 VSS.t316 100.001
R1062 VSS.t418 VSS.n822 98.5719
R1063 VSS.n886 VSS.t207 98.5719
R1064 VSS.t289 VSS.t569 98.5719
R1065 VSS.t96 VSS.t344 94.5564
R1066 VSS.t190 VSS.t259 94.5564
R1067 VSS.t817 VSS.t3305 94.2862
R1068 VSS.t296 VSS.t44 94.2862
R1069 VSS.n791 VSS.t317 90.2584
R1070 VSS.t75 VSS.n733 90.0005
R1071 VSS.t3305 VSS.n837 90.0005
R1072 VSS.n747 VSS.t382 90.0005
R1073 VSS.n912 VSS.t392 90.0005
R1074 VSS.n776 VSS.t21 90.0005
R1075 VSS.n868 VSS.t53 90.0005
R1076 VSS.n873 VSS.t62 90.0005
R1077 VSS.t226 VSS.n762 90.0005
R1078 VSS.t235 VSS.n757 90.0005
R1079 VSS.n133 VSS.t3 0.219019
R1080 VSS.t323 VSS.n794 89.2763
R1081 VSS.n31 VSS.t486 26.1547
R1082 VSS.n58 VSS.t491 26.2517
R1083 VSS.n53 VSS.t3 0.121819
R1084 VSS.t503 VSS.n178 58.6613
R1085 VSS.n252 VSS.t506 57.0465
R1086 VSS.t11 VSS.n215 89.7897
R1087 VSS.n140 VSS.t516 26.1547
R1088 VSS.n135 VSS.t521 26.2517
R1089 VSS.n136 VSS.t526 26.2524
R1090 VSS.t3 VSS.n0 0.121827
R1091 VSS.n2 VSS.t536 26.2517
R1092 VSS.t3 VSS.n1 0.121859
R1093 VSS.n128 VSS.t426 88.7727
R1094 VSS.t191 VSS.n109 88.7727
R1095 VSS.n86 VSS.t99 88.5605
R1096 VSS.n794 VSS.t324 88.4694
R1097 VSS.t624 VSS.t335 87.5005
R1098 VSS.t33 VSS.t254 87.1423
R1099 VSS.n127 VSS.t184 86.5025
R1100 VSS.n123 VSS.t297 86.5025
R1101 VSS.t420 VSS.n123 86.5025
R1102 VSS.n792 VSS.t105 85.9604
R1103 VSS.t272 VSS.t221 85.9604
R1104 VSS.t80 VSS.t314 85.9604
R1105 VSS.t0 VSS.n34 85.7543
R1106 VSS.n39 VSS.t153 85.7543
R1107 VSS.t432 VSS.n732 85.7148
R1108 VSS.n166 VSS.t430 99.148
R1109 VSS.n878 VSS.t249 85.7148
R1110 VSS.t269 VSS.t197 83.3338
R1111 VSS.t89 VSS.n42 83.3336
R1112 VSS.t126 VSS.n761 81.4291
R1113 VSS.t94 VSS.t33 80.7982
R1114 VSS.n84 VSS.t374 79.9891
R1115 VSS.n106 VSS.t428 79.9891
R1116 VSS.n854 VSS.t290 77.3644
R1117 VSS.n860 VSS.t291 77.3644
R1118 VSS.n815 VSS.t289 77.1434
R1119 VSS.t119 VSS.t33 76.5012
R1120 VSS.t368 VSS.t302 76.3274
R1121 VSS.n806 VSS.t102 74.234
R1122 VSS.t3 VSS.n179 2.33095
R1123 VSS.t133 VSS.n16 73.1842
R1124 VSS.t144 VSS.n788 73.0664
R1125 VSS.n155 VSS.t372 81.5403
R1126 VSS.n890 VSS.t23 72.8576
R1127 VSS.t270 VSS.n27 72.8441
R1128 VSS.t130 VSS.n21 72.8441
R1129 VSS.t306 VSS.n17 72.8441
R1130 VSS.n43 VSS.t157 72.8441
R1131 VSS.n49 VSS.t213 72.8441
R1132 VSS.t321 VSS.n172 76.9073
R1133 VSS.n810 VSS.t322 72.6202
R1134 VSS.n797 VSS.t140 72.6202
R1135 VSS.n808 VSS.t327 72.6202
R1136 VSS.t211 VSS.n803 72.6202
R1137 VSS.t79 VSS.n804 72.6202
R1138 VSS.t429 VSS.t33 72.0417
R1139 VSS.n89 VSS.t431 71.4177
R1140 VSS.n834 VSS.t355 70.8338
R1141 VSS.n897 VSS.t98 70.8338
R1142 VSS.t285 VSS.n897 70.8338
R1143 VSS.t156 VSS.n812 70.8338
R1144 VSS.t310 VSS.n310 72.8451
R1145 VSS.n253 VSS.t155 72.8451
R1146 VSS.t319 VSS.n185 13.9422
R1147 VSS.t149 VSS.n811 70.1995
R1148 VSS.t151 VSS.n798 70.1995
R1149 VSS.n807 VSS.t328 70.1995
R1150 VSS.n175 VSS.t216 13.9422
R1151 VSS.t205 VSS.n796 69.3927
R1152 VSS.t69 VSS.t219 68.7684
R1153 VSS.t210 VSS.n742 68.5719
R1154 VSS.t307 VSS.n740 68.5719
R1155 VSS.t637 VSS.t54 68.5719
R1156 VSS.n125 VSS.t69 67.2827
R1157 VSS.t66 VSS.n128 67.2827
R1158 VSS.t336 VSS.n111 67.2827
R1159 VSS.t72 VSS.t844 66.6672
R1160 VSS.t845 VSS.t405 66.6672
R1161 VSS.t30 VSS.t423 66.6672
R1162 VSS.t25 VSS.t91 66.6672
R1163 VSS.n810 VSS.t275 64.5513
R1164 VSS.t426 VSS.t298 64.4704
R1165 VSS.t222 VSS.n782 64.4704
R1166 VSS.t3 VSS.n172 10.0581
R1167 VSS.t8 VSS.n35 64.3085
R1168 VSS.t302 VSS.t408 80.6121
R1169 VSS.t180 VSS.n746 64.2862
R1170 VSS.n914 VSS.t394 64.2862
R1171 VSS.t400 VSS.n743 64.2862
R1172 VSS.t45 VSS.n775 64.2862
R1173 VSS.t52 VSS.n774 64.2862
R1174 VSS.t167 VSS.n768 64.2862
R1175 VSS.n875 VSS.t172 64.2862
R1176 VSS.t362 VSS.n765 64.2862
R1177 VSS.n763 VSS.t367 64.2862
R1178 VSS.n887 VSS.t236 64.2862
R1179 VSS.t241 VSS.n755 64.2862
R1180 VSS.n40 VSS.t278 63.9684
R1181 VSS.n799 VSS.t325 63.7444
R1182 VSS.n805 VSS.t118 63.7444
R1183 VSS.n36 VSS.t308 62.3556
R1184 VSS.t103 VSS.n41 62.3556
R1185 VSS.n225 VSS.t129 63.9693
R1186 VSS.t326 VSS.n205 63.9693
R1187 VSS.n168 VSS.t2 64.171
R1188 VSS.n790 VSS.t337 60.1724
R1189 VSS.t42 VSS.n781 60.1724
R1190 VSS.n780 VSS.t192 60.1724
R1191 VSS.n160 VSS.t381 75.2357
R1192 VSS.n279 VSS.t406 75.7034
R1193 VSS.n843 VSS.t360 60.0005
R1194 VSS.t391 VSS.t830 60.0005
R1195 VSS.t411 VSS.n824 60.0005
R1196 VSS.t44 VSS.n777 60.0005
R1197 VSS.t248 VSS.n877 60.0005
R1198 VSS.t15 VSS.t227 60.0005
R1199 VSS.t228 VSS.t126 60.0005
R1200 VSS.n884 VSS.t424 60.0005
R1201 VSS.t302 VSS.t26 59.1846
R1202 VSS.n4 VSS.t451 58.6622
R1203 VSS.t453 VSS.n29 58.6622
R1204 VSS.t459 VSS.n26 58.6622
R1205 VSS.n7 VSS.t462 58.6622
R1206 VSS.t464 VSS.n24 58.6622
R1207 VSS.n9 VSS.t467 58.6622
R1208 VSS.t469 VSS.n22 58.6622
R1209 VSS.t474 VSS.n20 58.6622
R1210 VSS.n12 VSS.t477 58.6622
R1211 VSS.t479 VSS.n18 58.6622
R1212 VSS.n44 VSS.t548 58.6622
R1213 VSS.t550 VSS.n51 58.6622
R1214 VSS.n46 VSS.t553 58.6622
R1215 VSS.n47 VSS.t557 58.6622
R1216 VSS.t3 VSS.n153 0.225189
R1217 VSS.n119 VSS.t282 58.5605
R1218 VSS.t457 VSS.n27 58.3211
R1219 VSS.t472 VSS.n21 58.3211
R1220 VSS.n43 VSS.t545 58.3211
R1221 VSS.n49 VSS.t560 58.3211
R1222 VSS.t3 VSS.n165 0.219073
R1223 VSS.n154 VSS.t3 0.219019
R1224 VSS.n4 VSS.t450 57.0465
R1225 VSS.t452 VSS.n29 57.0465
R1226 VSS.t458 VSS.n26 57.0465
R1227 VSS.n7 VSS.t461 57.0465
R1228 VSS.t463 VSS.n24 57.0465
R1229 VSS.n9 VSS.t466 57.0465
R1230 VSS.t468 VSS.n22 57.0465
R1231 VSS.t3 VSS.n162 0.219075
R1232 VSS.t473 VSS.n20 57.0465
R1233 VSS.n12 VSS.t476 57.0465
R1234 VSS.t478 VSS.n18 57.0465
R1235 VSS.t3 VSS.n164 0.219075
R1236 VSS.n44 VSS.t546 57.0465
R1237 VSS.t549 VSS.n51 57.0465
R1238 VSS.n46 VSS.t552 57.0465
R1239 VSS.n47 VSS.t556 57.0465
R1240 VSS.t434 VSS.n850 56.194
R1241 VSS.t104 VSS.n787 55.8744
R1242 VSS.t81 VSS.t280 55.8744
R1243 VSS.t193 VSS.n781 55.8744
R1244 VSS.t194 VSS.t244 55.8744
R1245 VSS.t302 VSS.t375 72.0407
R1246 VSS.n882 VSS.t15 55.7148
R1247 VSS.t116 VSS.n799 54.8687
R1248 VSS.n805 VSS.t152 54.8687
R1249 VSS.n819 VSS.t162 54.1672
R1250 VSS.t421 VSS.t33 53.8079
R1251 VSS.n83 VSS.t3304 53.1692
R1252 VSS.t318 VSS.n104 53.1692
R1253 VSS.t471 VSS.t3 26.5067
R1254 VSS.t482 VSS.t3 26.5047
R1255 VSS.n168 VSS.t3 0.203703
R1256 VSS.t436 VSS.t3 26.5067
R1257 VSS.t3 VSS.t456 26.5067
R1258 VSS.t559 VSS.t3 26.5067
R1259 VSS.t325 VSS.n33 28.033
R1260 VSS.t121 VSS.n751 51.5764
R1261 VSS.t344 VSS.n171 66.3233
R1262 VSS.n857 VSS.t112 51.5764
R1263 VSS.t266 VSS.t113 51.5764
R1264 VSS.t166 VSS.n779 51.5764
R1265 VSS.n148 VSS.t836 22.2411
R1266 VSS.n147 VSS.t718 23.2336
R1267 VSS.t721 VSS.n144 23.2336
R1268 VSS.n816 VSS.t185 51.4291
R1269 VSS.t434 VSS.n3 47.2101
R1270 VSS.n133 VSS.t440 26.1547
R1271 VSS.n132 VSS.t445 26.2522
R1272 VSS.n5 VSS.t452 48.6385
R1273 VSS.n28 VSS.t453 47.2101
R1274 VSS.n6 VSS.t458 48.6385
R1275 VSS.t461 VSS.n25 48.6385
R1276 VSS.n8 VSS.t463 48.6385
R1277 VSS.t466 VSS.n23 48.6385
R1278 VSS.n10 VSS.t468 48.6385
R1279 VSS.t470 VSS.n162 26.1613
R1280 VSS.n11 VSS.t473 48.6385
R1281 VSS.t476 VSS.n19 48.6385
R1282 VSS.n13 VSS.t478 48.6385
R1283 VSS.t481 VSS.n164 26.1613
R1284 VSS.n31 VSS.t483 47.2102
R1285 VSS.t501 VSS.n32 48.6385
R1286 VSS.t506 VSS.n37 48.6385
R1287 VSS.t511 VSS.n38 48.6385
R1288 VSS.n140 VSS.t514 47.2102
R1289 VSS.n136 VSS.t523 26.1049
R1290 VSS.t531 VSS.n0 26.2524
R1291 VSS.n2 VSS.t533 26.1056
R1292 VSS.t541 VSS.n1 26.2593
R1293 VSS.t546 VSS.n52 48.6385
R1294 VSS.n45 VSS.t549 48.6385
R1295 VSS.t552 VSS.n50 48.6385
R1296 VSS.n154 VSS.t554 26.1547
R1297 VSS.t556 VSS.n153 48.8187
R1298 VSS.t557 VSS.n48 47.2101
R1299 VSS.t561 VSS.n165 26.1611
R1300 VSS.n145 VSS.t293 37.8459
R1301 VSS.t258 VSS.n785 47.2784
R1302 VSS.n856 VSS.t160 47.2784
R1303 VSS.t295 VSS.t268 47.2784
R1304 VSS.n53 VSS.t496 26.2514
R1305 VSS.n30 VSS.t450 48.8178
R1306 VSS.t451 VSS.n5 47.0238
R1307 VSS.n6 VSS.t457 47.0238
R1308 VSS.n25 VSS.t459 47.0238
R1309 VSS.t462 VSS.n8 47.0238
R1310 VSS.n23 VSS.t464 47.0238
R1311 VSS.t467 VSS.n10 47.0238
R1312 VSS.n11 VSS.t472 47.0238
R1313 VSS.n19 VSS.t474 47.0238
R1314 VSS.t477 VSS.n13 47.0238
R1315 VSS.t488 VSS.n58 26.1056
R1316 VSS.t499 VSS.n32 47.0238
R1317 VSS.t503 VSS.n37 47.0238
R1318 VSS.t508 VSS.n38 47.0238
R1319 VSS.t518 VSS.n135 26.1056
R1320 VSS.t545 VSS.n52 47.0238
R1321 VSS.t548 VSS.n45 47.0238
R1322 VSS.n50 VSS.t550 47.0238
R1323 VSS.t555 VSS.n153 26.0019
R1324 VSS.t254 VSS.t341 45.8338
R1325 VSS.t7 VSS.t340 45.8338
R1326 VSS.t138 VSS.n80 45.7034
R1327 VSS.t264 VSS.n126 44.8359
R1328 VSS.t284 VSS.n124 44.8359
R1329 VSS.n225 VSS.t437 58.3202
R1330 VSS.t3 VSS.n132 0.121826
R1331 VSS.n30 VSS.t447 26.0022
R1332 VSS.n205 VSS.t483 58.3202
R1333 VSS.t3 VSS.n58 0.121819
R1334 VSS.n53 VSS.t493 26.1059
R1335 VSS.n310 VSS.t499 58.3202
R1336 VSS.n252 VSS.t508 58.6613
R1337 VSS.t514 VSS.n253 58.3202
R1338 VSS.t3 VSS.n135 0.121819
R1339 VSS.t3 VSS.n136 0.121827
R1340 VSS.n0 VSS.t528 26.1049
R1341 VSS.n1 VSS.t538 26.1049
R1342 VSS.t359 VSS.t17 42.9804
R1343 VSS.n836 VSS.t242 42.9804
R1344 VSS.t267 VSS.n782 42.9804
R1345 VSS.n142 VSS.t182 50.7212
R1346 VSS.t109 VSS.n823 42.8576
R1347 VSS.n885 VSS.t277 42.8576
R1348 VSS.n178 VSS.t501 57.0465
R1349 VSS.n215 VSS.t511 56.7064
R1350 VSS.t33 VSS.n171 1.60658
R1351 VSS.t33 VSS.t295 42.1172
R1352 VSS.t308 VSS.n809 40.8632
R1353 VSS.n802 VSS.t103 40.8632
R1354 VSS.n33 VSS.t498 26.4908
R1355 VSS.n168 VSS.t512 26.3338
R1356 VSS.t3 VSS.t543 26.5063
R1357 VSS.t279 VSS.n785 38.6824
R1358 VSS.n862 VSS.n861 38.6824
R1359 VSS.t175 VSS.n839 38.5719
R1360 VSS.n840 VSS.t179 38.5719
R1361 VSS.t395 VSS.n913 38.5719
R1362 VSS.n918 VSS.t399 38.5719
R1363 VSS.n865 VSS.t47 38.5719
R1364 VSS.n867 VSS.t51 38.5719
R1365 VSS.n874 VSS.t168 38.5719
R1366 VSS.t171 VSS.n767 38.5719
R1367 VSS.n879 VSS.t363 38.5719
R1368 VSS.n881 VSS.t366 38.5719
R1369 VSS.t237 VSS.n756 38.5719
R1370 VSS.n888 VSS.t240 38.5719
R1371 VSS.t302 VSS.t73 53.8079
R1372 VSS.t93 VSS.n896 37.5005
R1373 VSS.n891 VSS.t87 37.5005
R1374 VSS.n113 VSS.t272 37.1968
R1375 VSS.n36 VSS.t116 36.5343
R1376 VSS.t152 VSS.n41 36.5343
R1377 VSS.n859 VSS.t81 34.3845
R1378 VSS.n826 VSS.t417 34.2862
R1379 VSS.t247 VSS.n766 34.2862
R1380 VSS.t206 VSS.n759 34.2862
R1381 VSS.t23 VSS.t85 34.2862
R1382 VSS.t64 VSS.n82 32.8988
R1383 VSS.t257 VSS.n787 30.0865
R1384 VSS.t265 VSS.n783 30.0865
R1385 VSS.n861 VSS.t244 30.0865
R1386 VSS.n827 VSS.t115 30.0005
R1387 VSS.t789 VSS.n159 228.291
R1388 VSS.n157 VSS.t713 15.0018
R1389 VSS.n864 VSS.t132 30.0005
R1390 VSS.n818 VSS.t161 30.0005
R1391 VSS.t334 VSS.t33 29.2233
R1392 VSS.t71 VSS.n895 29.1672
R1393 VSS.t314 VSS.n108 28.6008
R1394 VSS.n81 VSS.t176 28.5605
R1395 VSS.t177 VSS.n81 28.5605
R1396 VSS.n917 VSS.t396 28.5605
R1397 VSS.t397 VSS.n917 28.5605
R1398 VSS.n866 VSS.t48 28.5605
R1399 VSS.t49 VSS.n866 28.5605
R1400 VSS.t169 VSS.n120 28.5605
R1401 VSS.n120 VSS.t170 28.5605
R1402 VSS.n122 VSS.t238 28.5605
R1403 VSS.t239 VSS.n122 28.5605
R1404 VSS.t118 VSS.n42 27.6595
R1405 VSS.t129 VSS.n180 38.7811
R1406 VSS.t320 VSS.n172 16.2308
R1407 VSS.n797 VSS.t326 27.4346
R1408 VSS.n808 VSS.t8 27.4346
R1409 VSS.t278 VSS.n803 27.4346
R1410 VSS.t2 VSS.n804 27.4346
R1411 VSS.t67 VSS.n280 41.4177
R1412 VSS.t218 VSS.n739 25.7148
R1413 VSS.t342 VSS.n814 25.7148
R1414 VSS.t17 VSS.n82 24.3028
R1415 VSS.t13 VSS.n76 24.2748
R1416 VSS.n15 VSS.t205 22.3504
R1417 VSS.t146 VSS.n179 14.8819
R1418 VSS.t3 VSS.n185 3.37712
R1419 VSS.n188 VSS.t148 13.9422
R1420 VSS.n175 VSS.t3 3.37712
R1421 VSS.t215 VSS.n176 13.9422
R1422 VSS.t123 VSS.n169 13.9374
R1423 VSS.n14 VSS.t149 21.5455
R1424 VSS.n15 VSS.t151 21.5455
R1425 VSS.t328 VSS.n35 21.5455
R1426 VSS.t107 VSS.n784 21.4905
R1427 VSS.t37 VSS.n113 20.0048
R1428 VSS.n180 VSS.t305 12.8073
R1429 VSS.t140 VSS.n16 19.1248
R1430 VSS.n14 VSS.t321 19.1229
R1431 VSS.t327 VSS.n34 18.7838
R1432 VSS.n39 VSS.t211 18.7838
R1433 VSS.n40 VSS.t79 18.7838
R1434 VSS.t256 VSS.n179 20.3752
R1435 VSS.n185 VSS.t270 29.5272
R1436 VSS.n188 VSS.t130 29.5272
R1437 VSS.n811 VSS.t306 18.5589
R1438 VSS.n798 VSS.t133 18.5589
R1439 VSS.n807 VSS.t310 18.5589
R1440 VSS.t155 VSS.n169 29.5281
R1441 VSS.t157 VSS.n175 29.5272
R1442 VSS.t213 VSS.n176 29.5272
R1443 VSS.n809 VSS.t0 17.4635
R1444 VSS.t153 VSS.n802 17.4635
R1445 VSS.t346 VSS.t218 17.1434
R1446 VSS.t313 VSS.t403 17.1434
R1447 VSS.t638 VSS.t58 17.1434
R1448 VSS.t238 VSS.t338 17.1434
R1449 VSS.t41 VSS.t77 17.1434
R1450 VSS.n341 VSS.n139 5.6463
R1451 VSS.t3 VSS.n180 2.99891
R1452 VSS.n225 VSS.t3 0.405951
R1453 VSS.t3 VSS.n188 3.37712
R1454 VSS.t3 VSS.n811 17.0005
R1455 VSS.t3 VSS.n810 17.0005
R1456 VSS.t3 VSS.n796 17.0005
R1457 VSS.t3 VSS.n798 17.0005
R1458 VSS.t3 VSS.n797 17.0005
R1459 VSS.t3 VSS.n205 0.405951
R1460 VSS.t3 VSS.n799 17.0005
R1461 VSS.t3 VSS.n808 17.0005
R1462 VSS.t3 VSS.n807 17.0005
R1463 VSS.t3 VSS.n310 0.405951
R1464 VSS.t3 VSS.n806 17.0005
R1465 VSS.t3 VSS.n805 17.0005
R1466 VSS.t3 VSS.n803 17.0005
R1467 VSS.t3 VSS.n804 17.0005
R1468 VSS.t3 VSS.n169 3.37595
R1469 VSS.t3 VSS.n176 3.37712
R1470 VSS.n216 VSS.t3 5.6463
R1471 VSS.t412 VSS.t2828 17.0005
R1472 VSS.t2913 VSS.t412 17.0005
R1473 VSS.n423 VSS.n55 5.6463
R1474 VSS.n56 VSS.n479 5.6463
R1475 VSS.n535 VSS.n57 5.6463
R1476 VSS.t377 VSS.n715 17.0005
R1477 VSS.n259 VSS.t377 4.17712
R1478 VSS.n54 VSS.n623 5.6463
R1479 VSS.t302 VSS.n916 17.0005
R1480 VSS.t302 VSS.n744 17.0005
R1481 VSS.t302 VSS.n907 17.0005
R1482 VSS.t302 VSS.n908 17.0005
R1483 VSS.t302 VSS.n915 17.0005
R1484 VSS.t302 VSS.n914 17.0005
R1485 VSS.t302 VSS.n912 17.0005
R1486 VSS.t302 VSS.n911 17.0005
R1487 VSS.t302 VSS.n910 17.0005
R1488 VSS.t302 VSS.n909 17.0005
R1489 VSS.t302 VSS.n913 17.0005
R1490 VSS.t302 VSS.n138 14.3867
R1491 VSS.t302 VSS.n737 17.0005
R1492 VSS.n922 VSS.t302 17.0005
R1493 VSS.t302 VSS.n738 17.0005
R1494 VSS.t302 VSS.n921 17.0005
R1495 VSS.t302 VSS.n739 17.0005
R1496 VSS.t302 VSS.n920 17.0005
R1497 VSS.t302 VSS.n740 17.0005
R1498 VSS.t302 VSS.n142 8.48812
R1499 VSS.t302 VSS.n143 3.83506
R1500 VSS.t302 VSS.n742 17.0005
R1501 VSS.t302 VSS.n919 17.0005
R1502 VSS.t302 VSS.n280 0.649813
R1503 VSS.t302 VSS.n743 17.0005
R1504 VSS.t302 VSS.n918 17.0005
R1505 VSS.t302 VSS.n745 17.0005
R1506 VSS.t302 VSS.n747 17.0005
R1507 VSS.t302 VSS.n746 17.0005
R1508 VSS.t302 VSS.n840 17.0005
R1509 VSS.t302 VSS.n839 17.0005
R1510 VSS.t302 VSS.n152 13.894
R1511 VSS.t302 VSS.n838 17.0005
R1512 VSS.n214 VSS.t302 0.649813
R1513 VSS.n841 VSS.t302 17.0005
R1514 VSS.t302 VSS.n155 7.66905
R1515 VSS.t302 VSS.n156 13.0749
R1516 VSS.t302 VSS.n837 17.0005
R1517 VSS.n842 VSS.t302 17.0005
R1518 VSS.t302 VSS.n843 17.0005
R1519 VSS.t302 VSS.n835 17.0005
R1520 VSS.t302 VSS.n836 17.0005
R1521 VSS.t302 VSS.n734 17.0005
R1522 VSS.t302 VSS.n927 17.0005
R1523 VSS.t302 VSS.n272 0.649813
R1524 VSS.t302 VSS.n926 17.0005
R1525 VSS.t302 VSS.n170 0.649813
R1526 VSS.t302 VSS.n925 17.0005
R1527 VSS.t302 VSS.n273 0.649813
R1528 VSS.t302 VSS.n924 17.0005
R1529 VSS.t302 VSS.n256 0.649813
R1530 VSS.t302 VSS.n721 17.0005
R1531 VSS.n274 VSS.t302 0.649813
R1532 VSS.t302 VSS.n722 17.0005
R1533 VSS.n212 VSS.t302 0.649813
R1534 VSS.t302 VSS.n723 17.0005
R1535 VSS.n275 VSS.t302 0.649813
R1536 VSS.t302 VSS.n724 17.0005
R1537 VSS.n255 VSS.t302 0.649813
R1538 VSS.t302 VSS.n725 17.0005
R1539 VSS.n276 VSS.t302 0.649813
R1540 VSS.t302 VSS.n726 17.0005
R1541 VSS.n174 VSS.t302 0.649813
R1542 VSS.t302 VSS.n727 17.0005
R1543 VSS.n277 VSS.t302 0.649813
R1544 VSS.t302 VSS.n728 17.0005
R1545 VSS.n254 VSS.t302 0.649813
R1546 VSS.t302 VSS.n729 17.0005
R1547 VSS.n278 VSS.t302 0.649813
R1548 VSS.t302 VSS.n730 17.0005
R1549 VSS.t302 VSS.n213 0.649813
R1550 VSS.t302 VSS.n731 17.0005
R1551 VSS.t302 VSS.n279 0.649813
R1552 VSS.t302 VSS.n732 17.0005
R1553 VSS.t302 VSS.n923 17.0005
R1554 VSS.t302 VSS.n733 17.0005
R1555 VSS.t302 VSS.n736 17.0005
R1556 VSS.t302 VSS.n735 17.0005
R1557 VSS.t302 VSS.n844 17.0005
R1558 VSS.t302 VSS.n832 17.0005
R1559 VSS.t302 VSS.n834 17.0005
R1560 VSS.t302 VSS.n833 17.0005
R1561 VSS.n845 VSS.t302 17.0005
R1562 VSS.t302 VSS.n158 7.66905
R1563 VSS.t302 VSS.n159 15.2046
R1564 VSS.t302 VSS.n828 17.0005
R1565 VSS.t302 VSS.n831 17.0005
R1566 VSS.t302 VSS.n829 17.0005
R1567 VSS.t302 VSS.n830 17.0005
R1568 VSS.n846 VSS.t302 17.0005
R1569 VSS.t302 VSS.n847 17.0005
R1570 VSS.t302 VSS.n822 17.0005
R1571 VSS.t302 VSS.n827 17.0005
R1572 VSS.t302 VSS.n823 17.0005
R1573 VSS.t302 VSS.n826 17.0005
R1574 VSS.t302 VSS.n824 17.0005
R1575 VSS.t302 VSS.n825 17.0005
R1576 VSS.t302 VSS.n161 3.41028
R1577 VSS.t33 VSS.n894 17.0005
R1578 VSS.t33 VSS.n895 17.0005
R1579 VSS.t33 VSS.n899 17.0005
R1580 VSS.t33 VSS.n896 17.0005
R1581 VSS.t33 VSS.n898 17.0005
R1582 VSS.t33 VSS.n897 17.0005
R1583 VSS.n903 VSS.t33 17.0005
R1584 VSS.t33 VSS.n677 5.61485
R1585 VSS.t642 VSS.t33 17.0005
R1586 VSS.n699 VSS.t33 5.64879
R1587 VSS.t33 VSS.n900 17.0005
R1588 VSS.t33 VSS.n901 17.0005
R1589 VSS.n902 VSS.t33 17.0005
R1590 VSS.t33 VSS.n209 5.64438
R1591 VSS.t33 VSS.n145 2.49582
R1592 VSS.t33 VSS.n750 17.0005
R1593 VSS.t33 VSS.n893 17.0005
R1594 VSS.t33 VSS.n751 17.0005
R1595 VSS.t33 VSS.n892 17.0005
R1596 VSS.t33 VSS.n752 17.0005
R1597 VSS.t33 VSS.n891 17.0005
R1598 VSS.t33 VSS.n753 17.0005
R1599 VSS.t33 VSS.n890 17.0005
R1600 VSS.t33 VSS.n754 17.0005
R1601 VSS.t33 VSS.n889 17.0005
R1602 VSS.t33 VSS.n755 17.0005
R1603 VSS.t33 VSS.n888 17.0005
R1604 VSS.t33 VSS.n756 17.0005
R1605 VSS.t33 VSS.n887 17.0005
R1606 VSS.t33 VSS.n757 17.0005
R1607 VSS.t33 VSS.n886 17.0005
R1608 VSS.t33 VSS.n758 17.0005
R1609 VSS.t33 VSS.n885 17.0005
R1610 VSS.t33 VSS.n759 17.0005
R1611 VSS.t33 VSS.n884 17.0005
R1612 VSS.t33 VSS.n760 17.0005
R1613 VSS.t33 VSS.n883 17.0005
R1614 VSS.t33 VSS.n761 17.0005
R1615 VSS.t33 VSS.n882 17.0005
R1616 VSS.t33 VSS.n762 17.0005
R1617 VSS.t33 VSS.n763 17.0005
R1618 VSS.t33 VSS.n881 17.0005
R1619 VSS.t33 VSS.n764 17.0005
R1620 VSS.t33 VSS.n880 17.0005
R1621 VSS.n879 VSS.t33 17.0005
R1622 VSS.t33 VSS.n765 17.0005
R1623 VSS.t33 VSS.n878 17.0005
R1624 VSS.t33 VSS.n877 17.0005
R1625 VSS.t33 VSS.n766 17.0005
R1626 VSS.t33 VSS.n876 17.0005
R1627 VSS.t33 VSS.n875 17.0005
R1628 VSS.t33 VSS.n767 17.0005
R1629 VSS.t33 VSS.n874 17.0005
R1630 VSS.t33 VSS.n768 17.0005
R1631 VSS.t33 VSS.n873 17.0005
R1632 VSS.t33 VSS.n769 17.0005
R1633 VSS.t33 VSS.n872 17.0005
R1634 VSS.t33 VSS.n770 17.0005
R1635 VSS.t33 VSS.n871 17.0005
R1636 VSS.t33 VSS.n771 17.0005
R1637 VSS.t33 VSS.n870 17.0005
R1638 VSS.t33 VSS.n772 17.0005
R1639 VSS.t33 VSS.n869 17.0005
R1640 VSS.t33 VSS.n773 17.0005
R1641 VSS.t33 VSS.n868 17.0005
R1642 VSS.t33 VSS.n774 17.0005
R1643 VSS.t33 VSS.n867 17.0005
R1644 VSS.n865 VSS.t33 17.0005
R1645 VSS.t33 VSS.n775 17.0005
R1646 VSS.t33 VSS.n776 17.0005
R1647 VSS.t33 VSS.n864 17.0005
R1648 VSS.t33 VSS.n777 17.0005
R1649 VSS.t33 VSS.n863 17.0005
R1650 VSS.t33 VSS.n173 12.2567
R1651 VSS.t33 VSS.n779 17.0005
R1652 VSS.t33 VSS.n860 17.0005
R1653 VSS.t33 VSS.n780 17.0005
R1654 VSS.n861 VSS.t33 17.0005
R1655 VSS.t33 VSS.n781 17.0005
R1656 VSS.t33 VSS.n859 17.0005
R1657 VSS.t33 VSS.n782 17.0005
R1658 VSS.t33 VSS.n858 17.0005
R1659 VSS.t33 VSS.n783 17.0005
R1660 VSS.t33 VSS.n857 17.0005
R1661 VSS.t33 VSS.n784 17.0005
R1662 VSS.t33 VSS.n856 17.0005
R1663 VSS.t33 VSS.n785 17.0005
R1664 VSS.t33 VSS.n855 17.0005
R1665 VSS.t33 VSS.n786 17.0005
R1666 VSS.t33 VSS.n854 17.0005
R1667 VSS.t33 VSS.n853 17.0005
R1668 VSS.t33 VSS.n163 7.66894
R1669 VSS.t33 VSS.n792 17.0005
R1670 VSS.t33 VSS.n787 17.0005
R1671 VSS.t33 VSS.n791 17.0005
R1672 VSS.t33 VSS.n790 17.0005
R1673 VSS.t33 VSS.n788 17.0005
R1674 VSS.t33 VSS.n789 17.0005
R1675 VSS.t33 VSS.n821 17.0005
R1676 VSS.t33 VSS.n820 17.0005
R1677 VSS.t33 VSS.n226 0.666899
R1678 VSS.t33 VSS.n812 17.0005
R1679 VSS.t33 VSS.n819 17.0005
R1680 VSS.t33 VSS.n813 17.0005
R1681 VSS.t33 VSS.n818 17.0005
R1682 VSS.t33 VSS.n817 17.0005
R1683 VSS.t33 VSS.n814 17.0005
R1684 VSS.t33 VSS.n816 17.0005
R1685 VSS.t33 VSS.n815 17.0005
R1686 VSS.t322 VSS.n795 16.6566
R1687 VSS.t403 VSS.n76 15.7034
R1688 VSS.t102 VSS.n801 15.0429
R1689 VSS.t324 VSS.n17 14.7493
R1690 VSS.n801 VSS.t11 13.4291
R1691 VSS.t275 VSS.n796 12.9107
R1692 VSS.t28 VSS.t286 12.8945
R1693 VSS.t259 VSS.n786 12.8945
R1694 VSS.n855 VSS.t36 12.8945
R1695 VSS.t353 VSS.n842 12.8576
R1696 VSS.n864 VSS.t70 12.8576
R1697 VSS.n880 VSS.t364 12.8576
R1698 VSS.t365 VSS.n764 12.8576
R1699 VSS.t409 VSS.t847 12.5005
R1700 VSS.t250 VSS.t196 12.5005
R1701 VSS.n795 VSS.t323 11.8153
R1702 VSS.n858 VSS.t266 8.59649
R1703 VSS.t829 VSS.t387 8.57193
R1704 VSS.n847 VSS.t108 8.57193
R1705 VSS.n876 VSS.t245 8.57193
R1706 VSS.t276 VSS.n757 8.57193
R1707 VSS.t377 VSS.n186 3.31995
R1708 VSS.t412 VSS.t413 8.50365
R1709 VSS.n139 VSS.t3302 8.50199
R1710 VSS.t2635 VSS.n55 8.50198
R1711 VSS.t2243 VSS.n56 8.50198
R1712 VSS.n57 VSS.t1851 8.50198
R1713 VSS.t1167 VSS.n54 8.50198
R1714 VSS.n368 VSS.t3299 0.130189
R1715 VSS.t3297 VSS.n139 8.501
R1716 VSS.n367 VSS.t3294 0.130189
R1717 VSS.t3292 VSS.n139 8.501
R1718 VSS.n366 VSS.t3289 0.130189
R1719 VSS.t3287 VSS.n139 8.501
R1720 VSS.n365 VSS.t3284 0.130189
R1721 VSS.t3282 VSS.n139 8.501
R1722 VSS.n364 VSS.t3279 0.130189
R1723 VSS.t3277 VSS.n139 8.501
R1724 VSS.t3274 VSS.n363 0.130189
R1725 VSS.t3272 VSS.n139 8.501
R1726 VSS.t3269 VSS.n362 0.130189
R1727 VSS.t3267 VSS.n139 8.501
R1728 VSS.t3264 VSS.n361 0.130189
R1729 VSS.t3262 VSS.n139 8.501
R1730 VSS.t3259 VSS.n360 0.130189
R1731 VSS.t3257 VSS.n139 8.501
R1732 VSS.t3254 VSS.n359 0.130189
R1733 VSS.t3252 VSS.n139 8.501
R1734 VSS.t3249 VSS.n358 0.130189
R1735 VSS.t3247 VSS.n139 8.501
R1736 VSS.t3244 VSS.n357 0.130189
R1737 VSS.t3242 VSS.n139 8.501
R1738 VSS.t3239 VSS.n356 0.130189
R1739 VSS.t3237 VSS.n139 8.501
R1740 VSS.t3234 VSS.n355 0.130189
R1741 VSS.t3232 VSS.n139 8.501
R1742 VSS.t3229 VSS.n354 0.130189
R1743 VSS.t3227 VSS.n139 8.501
R1744 VSS.t3224 VSS.n353 0.130189
R1745 VSS.t3222 VSS.n139 8.501
R1746 VSS.t3219 VSS.n352 0.130189
R1747 VSS.t3217 VSS.n139 8.501
R1748 VSS.t3214 VSS.n351 0.130189
R1749 VSS.t3212 VSS.n139 8.501
R1750 VSS.t3209 VSS.n350 0.130189
R1751 VSS.t3207 VSS.n139 8.501
R1752 VSS.t3204 VSS.n349 0.130189
R1753 VSS.t3202 VSS.n139 8.501
R1754 VSS.t3199 VSS.n348 0.130189
R1755 VSS.t3197 VSS.n139 8.501
R1756 VSS.t3194 VSS.n347 0.130189
R1757 VSS.t3192 VSS.n139 8.501
R1758 VSS.t3189 VSS.n346 0.130189
R1759 VSS.t3187 VSS.n139 8.501
R1760 VSS.t3184 VSS.n345 0.130189
R1761 VSS.t3182 VSS.n139 8.501
R1762 VSS.t3179 VSS.n344 0.130189
R1763 VSS.t3177 VSS.n139 8.501
R1764 VSS.t3174 VSS.n343 0.130189
R1765 VSS.t3172 VSS.n139 8.501
R1766 VSS.n342 VSS.t3169 0.130189
R1767 VSS.t3167 VSS.n312 0.0836055
R1768 VSS.t3164 VSS.n341 0.0333775
R1769 VSS.t3162 VSS.n139 8.501
R1770 VSS.t3159 VSS.n340 0.130189
R1771 VSS.t3157 VSS.n139 8.501
R1772 VSS.t3154 VSS.n339 0.130189
R1773 VSS.t3152 VSS.n139 8.501
R1774 VSS.t3149 VSS.n338 0.130189
R1775 VSS.t3147 VSS.n139 8.501
R1776 VSS.t3144 VSS.n337 0.130189
R1777 VSS.t3142 VSS.n139 8.501
R1778 VSS.t3139 VSS.n336 0.130189
R1779 VSS.t3137 VSS.n139 8.501
R1780 VSS.t3134 VSS.n335 0.130189
R1781 VSS.t3132 VSS.n139 8.501
R1782 VSS.t3129 VSS.n334 0.130189
R1783 VSS.t3127 VSS.n139 8.501
R1784 VSS.t3124 VSS.n333 0.130189
R1785 VSS.t3122 VSS.n139 8.501
R1786 VSS.t3119 VSS.n332 0.130189
R1787 VSS.t3117 VSS.n139 8.501
R1788 VSS.t3114 VSS.n331 0.130189
R1789 VSS.t3112 VSS.n139 8.501
R1790 VSS.t3109 VSS.n330 0.130189
R1791 VSS.t3107 VSS.n139 8.501
R1792 VSS.t3104 VSS.n329 0.130189
R1793 VSS.t3102 VSS.n139 8.501
R1794 VSS.t3099 VSS.n328 0.130189
R1795 VSS.t3097 VSS.n139 8.501
R1796 VSS.t3094 VSS.n327 0.130189
R1797 VSS.t3092 VSS.n139 8.501
R1798 VSS.t3089 VSS.n326 0.130189
R1799 VSS.t3087 VSS.n139 8.501
R1800 VSS.t3084 VSS.n325 0.130189
R1801 VSS.t3082 VSS.n139 8.501
R1802 VSS.t3079 VSS.n324 0.130189
R1803 VSS.t3077 VSS.n139 8.501
R1804 VSS.t3074 VSS.n323 0.130189
R1805 VSS.t3072 VSS.n139 8.501
R1806 VSS.t3069 VSS.n322 0.130189
R1807 VSS.t3067 VSS.n139 8.501
R1808 VSS.t3064 VSS.n321 0.130189
R1809 VSS.t3062 VSS.n139 8.501
R1810 VSS.n320 VSS.t3059 0.130189
R1811 VSS.t3057 VSS.n139 8.501
R1812 VSS.n319 VSS.t3054 0.130189
R1813 VSS.t3049 VSS.n318 0.215686
R1814 VSS.t3047 VSS.n139 8.501
R1815 VSS.n317 VSS.t3044 0.130189
R1816 VSS.t3042 VSS.n139 8.501
R1817 VSS.n316 VSS.t3039 0.130189
R1818 VSS.t3037 VSS.n139 8.501
R1819 VSS.n315 VSS.t3034 0.130189
R1820 VSS.t3032 VSS.n139 8.501
R1821 VSS.n314 VSS.t3029 0.130189
R1822 VSS.t3027 VSS.n139 8.501
R1823 VSS.n139 VSS.n313 3.33079
R1824 VSS.t438 VSS.n704 0.893724
R1825 VSS.n705 VSS.t3 3.32876
R1826 VSS.t443 VSS.t3 8.501
R1827 VSS.t3 VSS.n706 3.32876
R1828 VSS.t3 VSS.n311 5.6463
R1829 VSS.t484 VSS.n369 0.743924
R1830 VSS.n370 VSS.t3 3.32876
R1831 VSS.t489 VSS.t3 8.501
R1832 VSS.n371 VSS.t3 3.32876
R1833 VSS.t494 VSS.n216 0.0333775
R1834 VSS.n372 VSS.t3 4.20253
R1835 VSS.t3 VSS.t117 8.501
R1836 VSS.t311 VSS.n373 0.86307
R1837 VSS.n374 VSS.t3 3.32876
R1838 VSS.t504 VSS.t3 8.501
R1839 VSS.n375 VSS.t3 3.32876
R1840 VSS.t509 VSS.t3 8.501
R1841 VSS.n376 VSS.t3 3.32876
R1842 VSS.n377 VSS.t3 0.642426
R1843 VSS.t3 VSS.n378 1.73631
R1844 VSS.n379 VSS.t3 3.32876
R1845 VSS.t3 VSS.t519 8.501
R1846 VSS.n380 VSS.t3 3.32876
R1847 VSS.t524 VSS.t3 8.501
R1848 VSS.n381 VSS.t3 3.32876
R1849 VSS.t529 VSS.t3 8.501
R1850 VSS.n382 VSS.t3 3.32876
R1851 VSS.t534 VSS.t3 8.501
R1852 VSS.n383 VSS.t3 3.32876
R1853 VSS.t539 VSS.t3 8.501
R1854 VSS.n384 VSS.t3 3.32876
R1855 VSS.t544 VSS.t3 8.501
R1856 VSS.n450 VSS.t2632 0.130189
R1857 VSS.t2630 VSS.n55 8.501
R1858 VSS.n449 VSS.t2627 0.130189
R1859 VSS.t2625 VSS.n55 8.501
R1860 VSS.n448 VSS.t2622 0.130189
R1861 VSS.t2620 VSS.n55 8.501
R1862 VSS.n447 VSS.t2617 0.130189
R1863 VSS.t2615 VSS.n55 8.501
R1864 VSS.n446 VSS.t2612 0.130189
R1865 VSS.t2610 VSS.n55 8.501
R1866 VSS.n445 VSS.t2607 0.130189
R1867 VSS.t2605 VSS.n55 8.501
R1868 VSS.n444 VSS.t2602 0.130189
R1869 VSS.t2600 VSS.n55 8.501
R1870 VSS.n443 VSS.t2597 0.130189
R1871 VSS.t2595 VSS.n55 8.501
R1872 VSS.n442 VSS.t2592 0.130189
R1873 VSS.t2590 VSS.n55 8.501
R1874 VSS.n441 VSS.t2587 0.130189
R1875 VSS.t2585 VSS.n55 8.501
R1876 VSS.n440 VSS.t2582 0.130189
R1877 VSS.t2580 VSS.n55 8.501
R1878 VSS.n439 VSS.t2577 0.130189
R1879 VSS.t2575 VSS.n55 8.501
R1880 VSS.n438 VSS.t2572 0.130189
R1881 VSS.t2570 VSS.n55 8.501
R1882 VSS.n437 VSS.t2567 0.130189
R1883 VSS.t2565 VSS.n55 8.501
R1884 VSS.n436 VSS.t2562 0.130189
R1885 VSS.t2560 VSS.n55 8.501
R1886 VSS.n435 VSS.t2557 0.130189
R1887 VSS.t2555 VSS.n55 8.501
R1888 VSS.n434 VSS.t2552 0.130189
R1889 VSS.t2550 VSS.n55 8.501
R1890 VSS.n433 VSS.t2547 0.130189
R1891 VSS.t2545 VSS.n55 8.501
R1892 VSS.n432 VSS.t2542 0.130189
R1893 VSS.t2540 VSS.n55 8.501
R1894 VSS.n431 VSS.t2537 0.130189
R1895 VSS.t2535 VSS.n55 8.501
R1896 VSS.n430 VSS.t2532 0.130189
R1897 VSS.t2530 VSS.n55 8.501
R1898 VSS.n429 VSS.t2527 0.130189
R1899 VSS.t2525 VSS.n55 8.501
R1900 VSS.n428 VSS.t2522 0.130189
R1901 VSS.t2520 VSS.n55 8.501
R1902 VSS.n427 VSS.t2517 0.130189
R1903 VSS.t2515 VSS.n55 8.501
R1904 VSS.n426 VSS.t2512 0.130189
R1905 VSS.t2510 VSS.n55 8.501
R1906 VSS.n425 VSS.t2507 0.130189
R1907 VSS.t2505 VSS.n55 8.501
R1908 VSS.n424 VSS.t2502 0.130189
R1909 VSS.n423 VSS.t2497 0.0333775
R1910 VSS.n55 VSS.t2495 8.501
R1911 VSS.t2492 VSS.n422 0.130189
R1912 VSS.t2490 VSS.n55 8.501
R1913 VSS.t2487 VSS.n421 0.130189
R1914 VSS.t2485 VSS.n55 8.501
R1915 VSS.t2482 VSS.n420 0.130189
R1916 VSS.t2480 VSS.n55 8.501
R1917 VSS.t2477 VSS.n419 0.130189
R1918 VSS.t2475 VSS.n55 8.501
R1919 VSS.t2472 VSS.n418 0.130189
R1920 VSS.t2470 VSS.n55 8.501
R1921 VSS.t2467 VSS.n417 0.130189
R1922 VSS.t2465 VSS.n55 8.501
R1923 VSS.t2462 VSS.n416 0.130189
R1924 VSS.t2460 VSS.n55 8.501
R1925 VSS.t2457 VSS.n415 0.130189
R1926 VSS.t2455 VSS.n55 8.501
R1927 VSS.t2452 VSS.n414 0.130189
R1928 VSS.t2450 VSS.n55 8.501
R1929 VSS.t2447 VSS.n413 0.130189
R1930 VSS.t2445 VSS.n55 8.501
R1931 VSS.t2442 VSS.n412 0.130189
R1932 VSS.t2440 VSS.n55 8.501
R1933 VSS.t2437 VSS.n411 0.130189
R1934 VSS.t2435 VSS.n55 8.501
R1935 VSS.t2432 VSS.n410 0.130189
R1936 VSS.t2430 VSS.n55 8.501
R1937 VSS.t2427 VSS.n409 0.130189
R1938 VSS.t2425 VSS.n55 8.501
R1939 VSS.t2422 VSS.n408 0.130189
R1940 VSS.t2420 VSS.n55 8.501
R1941 VSS.t2417 VSS.n407 0.130189
R1942 VSS.t2415 VSS.n55 8.501
R1943 VSS.t2412 VSS.n406 0.130189
R1944 VSS.t2410 VSS.n55 8.501
R1945 VSS.t2407 VSS.n405 0.130189
R1946 VSS.t2405 VSS.n55 8.501
R1947 VSS.t2402 VSS.n404 0.130189
R1948 VSS.t2400 VSS.n55 8.501
R1949 VSS.t2397 VSS.n403 0.130189
R1950 VSS.t2395 VSS.n55 8.501
R1951 VSS.t2392 VSS.n402 0.130189
R1952 VSS.t2390 VSS.n55 8.501
R1953 VSS.t2387 VSS.n401 0.130189
R1954 VSS.t2385 VSS.n55 8.501
R1955 VSS.t2382 VSS.n400 0.130189
R1956 VSS.t2380 VSS.n55 8.501
R1957 VSS.t2377 VSS.n399 0.130189
R1958 VSS.t2375 VSS.n55 8.501
R1959 VSS.t2372 VSS.n398 0.130189
R1960 VSS.t2370 VSS.n55 8.501
R1961 VSS.t2367 VSS.n397 0.130189
R1962 VSS.t2365 VSS.n55 8.501
R1963 VSS.t2362 VSS.n396 0.130189
R1964 VSS.t2360 VSS.n55 8.501
R1965 VSS.n395 VSS.n55 3.33079
R1966 VSS.n506 VSS.t2240 0.130189
R1967 VSS.t2238 VSS.n56 8.501
R1968 VSS.n505 VSS.t2235 0.130189
R1969 VSS.t2233 VSS.n56 8.501
R1970 VSS.n504 VSS.t2230 0.130189
R1971 VSS.t2228 VSS.n56 8.501
R1972 VSS.n503 VSS.t2225 0.130189
R1973 VSS.t2223 VSS.n56 8.501
R1974 VSS.n502 VSS.t2220 0.130189
R1975 VSS.t2218 VSS.n56 8.501
R1976 VSS.n501 VSS.t2215 0.130189
R1977 VSS.t2213 VSS.n56 8.501
R1978 VSS.n500 VSS.t2210 0.130189
R1979 VSS.t2208 VSS.n56 8.501
R1980 VSS.n499 VSS.t2205 0.130189
R1981 VSS.t2203 VSS.n56 8.501
R1982 VSS.n498 VSS.t2200 0.130189
R1983 VSS.t2198 VSS.n56 8.501
R1984 VSS.n497 VSS.t2195 0.130189
R1985 VSS.t2193 VSS.n56 8.501
R1986 VSS.n496 VSS.t2190 0.130189
R1987 VSS.t2188 VSS.n56 8.501
R1988 VSS.n495 VSS.t2185 0.130189
R1989 VSS.t2183 VSS.n56 8.501
R1990 VSS.n494 VSS.t2180 0.130189
R1991 VSS.t2178 VSS.n56 8.501
R1992 VSS.n493 VSS.t2175 0.130189
R1993 VSS.t2173 VSS.n56 8.501
R1994 VSS.n492 VSS.t2170 0.130189
R1995 VSS.t2168 VSS.n56 8.501
R1996 VSS.n491 VSS.t2165 0.130189
R1997 VSS.t2163 VSS.n56 8.501
R1998 VSS.n490 VSS.t2160 0.130189
R1999 VSS.t2158 VSS.n56 8.501
R2000 VSS.n489 VSS.t2155 0.130189
R2001 VSS.t2153 VSS.n56 8.501
R2002 VSS.n488 VSS.t2150 0.130189
R2003 VSS.t2148 VSS.n56 8.501
R2004 VSS.n487 VSS.t2145 0.130189
R2005 VSS.t2143 VSS.n56 8.501
R2006 VSS.n486 VSS.t2140 0.130189
R2007 VSS.t2138 VSS.n56 8.501
R2008 VSS.n485 VSS.t2135 0.130189
R2009 VSS.t2133 VSS.n56 8.501
R2010 VSS.n484 VSS.t2130 0.130189
R2011 VSS.t2128 VSS.n56 8.501
R2012 VSS.n483 VSS.t2125 0.130189
R2013 VSS.t2123 VSS.n56 8.501
R2014 VSS.n482 VSS.t2120 0.130189
R2015 VSS.t2118 VSS.n56 8.501
R2016 VSS.n481 VSS.t2115 0.130189
R2017 VSS.t2113 VSS.n56 8.501
R2018 VSS.n480 VSS.t2110 0.130189
R2019 VSS.n479 VSS.t2105 0.0333775
R2020 VSS.t2103 VSS.n56 8.501
R2021 VSS.n478 VSS.t2100 0.130189
R2022 VSS.t2098 VSS.n56 8.501
R2023 VSS.n477 VSS.t2095 0.130189
R2024 VSS.t2093 VSS.n56 8.501
R2025 VSS.n476 VSS.t2090 0.130189
R2026 VSS.t2088 VSS.n56 8.501
R2027 VSS.n475 VSS.t2085 0.130189
R2028 VSS.t2083 VSS.n56 8.501
R2029 VSS.n474 VSS.t2080 0.130189
R2030 VSS.t2078 VSS.n56 8.501
R2031 VSS.n473 VSS.t2075 0.130189
R2032 VSS.t2073 VSS.n56 8.501
R2033 VSS.n472 VSS.t2070 0.130189
R2034 VSS.t2068 VSS.n56 8.501
R2035 VSS.n471 VSS.t2065 0.130189
R2036 VSS.t2063 VSS.n56 8.501
R2037 VSS.n470 VSS.t2060 0.130189
R2038 VSS.t2058 VSS.n56 8.501
R2039 VSS.n469 VSS.t2055 0.130189
R2040 VSS.t2053 VSS.n56 8.501
R2041 VSS.n468 VSS.t2050 0.130189
R2042 VSS.t2048 VSS.n56 8.501
R2043 VSS.n467 VSS.t2045 0.130189
R2044 VSS.t2043 VSS.n56 8.501
R2045 VSS.n466 VSS.t2040 0.130189
R2046 VSS.t2038 VSS.n56 8.501
R2047 VSS.n465 VSS.t2035 0.130189
R2048 VSS.t2033 VSS.n56 8.501
R2049 VSS.n464 VSS.t2030 0.130189
R2050 VSS.t2028 VSS.n56 8.501
R2051 VSS.n463 VSS.t2025 0.130189
R2052 VSS.t2023 VSS.n56 8.501
R2053 VSS.n462 VSS.t2020 0.130189
R2054 VSS.t2018 VSS.n56 8.501
R2055 VSS.n461 VSS.t2015 0.130189
R2056 VSS.t2013 VSS.n56 8.501
R2057 VSS.n460 VSS.t2010 0.130189
R2058 VSS.t2008 VSS.n56 8.501
R2059 VSS.n459 VSS.t2005 0.130189
R2060 VSS.t2003 VSS.n56 8.501
R2061 VSS.n458 VSS.t2000 0.130189
R2062 VSS.t1998 VSS.n56 8.501
R2063 VSS.n457 VSS.t1995 0.130189
R2064 VSS.t1993 VSS.n56 8.501
R2065 VSS.t1990 VSS.n456 0.130189
R2066 VSS.t1988 VSS.n56 8.501
R2067 VSS.n455 VSS.t1985 0.130189
R2068 VSS.t1983 VSS.n56 8.501
R2069 VSS.n454 VSS.t1980 0.130189
R2070 VSS.t1978 VSS.n56 8.501
R2071 VSS.n453 VSS.t1975 0.130189
R2072 VSS.t1973 VSS.n56 8.501
R2073 VSS.n452 VSS.t1970 0.130189
R2074 VSS.t1968 VSS.n56 8.501
R2075 VSS.n56 VSS.n451 3.33079
R2076 VSS.n562 VSS.t1848 0.130189
R2077 VSS.t1846 VSS.n57 8.501
R2078 VSS.n561 VSS.t1843 0.130189
R2079 VSS.t1841 VSS.n57 8.501
R2080 VSS.n560 VSS.t1838 0.130189
R2081 VSS.t1836 VSS.n57 8.501
R2082 VSS.n559 VSS.t1833 0.130189
R2083 VSS.t1831 VSS.n57 8.501
R2084 VSS.n558 VSS.t1828 0.130189
R2085 VSS.t1826 VSS.n57 8.501
R2086 VSS.t1823 VSS.n557 0.130189
R2087 VSS.t1821 VSS.n57 8.501
R2088 VSS.t1818 VSS.n556 0.130189
R2089 VSS.t1816 VSS.n57 8.501
R2090 VSS.t1813 VSS.n555 0.130189
R2091 VSS.t1811 VSS.n57 8.501
R2092 VSS.t1808 VSS.n554 0.130189
R2093 VSS.t1806 VSS.n57 8.501
R2094 VSS.t1803 VSS.n553 0.130189
R2095 VSS.t1801 VSS.n57 8.501
R2096 VSS.t1798 VSS.n552 0.130189
R2097 VSS.t1796 VSS.n57 8.501
R2098 VSS.t1793 VSS.n551 0.130189
R2099 VSS.t1791 VSS.n57 8.501
R2100 VSS.t1788 VSS.n550 0.130189
R2101 VSS.t1786 VSS.n57 8.501
R2102 VSS.t1783 VSS.n549 0.130189
R2103 VSS.t1781 VSS.n57 8.501
R2104 VSS.t1778 VSS.n548 0.130189
R2105 VSS.t1776 VSS.n57 8.501
R2106 VSS.t1773 VSS.n547 0.130189
R2107 VSS.t1771 VSS.n57 8.501
R2108 VSS.t1768 VSS.n546 0.130189
R2109 VSS.t1766 VSS.n57 8.501
R2110 VSS.t1763 VSS.n545 0.130189
R2111 VSS.t1761 VSS.n57 8.501
R2112 VSS.t1758 VSS.n544 0.130189
R2113 VSS.t1756 VSS.n57 8.501
R2114 VSS.t1753 VSS.n543 0.130189
R2115 VSS.t1751 VSS.n57 8.501
R2116 VSS.t1748 VSS.n542 0.130189
R2117 VSS.t1746 VSS.n57 8.501
R2118 VSS.t1743 VSS.n541 0.130189
R2119 VSS.t1741 VSS.n57 8.501
R2120 VSS.t1738 VSS.n540 0.130189
R2121 VSS.t1736 VSS.n57 8.501
R2122 VSS.t1733 VSS.n539 0.130189
R2123 VSS.t1731 VSS.n57 8.501
R2124 VSS.t1728 VSS.n538 0.130189
R2125 VSS.t1726 VSS.n57 8.501
R2126 VSS.t1723 VSS.n537 0.130189
R2127 VSS.t1721 VSS.n57 8.501
R2128 VSS.t1718 VSS.n536 0.130189
R2129 VSS.n535 VSS.t1713 0.0333775
R2130 VSS.t1711 VSS.n57 8.501
R2131 VSS.n534 VSS.t1708 0.130189
R2132 VSS.t1706 VSS.n57 8.501
R2133 VSS.n533 VSS.t1703 0.130189
R2134 VSS.t1701 VSS.n57 8.501
R2135 VSS.n532 VSS.t1698 0.130189
R2136 VSS.t1696 VSS.n57 8.501
R2137 VSS.n531 VSS.t1693 0.130189
R2138 VSS.t1691 VSS.n57 8.501
R2139 VSS.n530 VSS.t1688 0.130189
R2140 VSS.t1686 VSS.n57 8.501
R2141 VSS.n529 VSS.t1683 0.130189
R2142 VSS.t1681 VSS.n57 8.501
R2143 VSS.n528 VSS.t1678 0.130189
R2144 VSS.t1676 VSS.n57 8.501
R2145 VSS.n527 VSS.t1673 0.130189
R2146 VSS.t1671 VSS.n57 8.501
R2147 VSS.n526 VSS.t1668 0.130189
R2148 VSS.t1666 VSS.n57 8.501
R2149 VSS.n525 VSS.t1663 0.130189
R2150 VSS.t1661 VSS.n57 8.501
R2151 VSS.n524 VSS.t1658 0.130189
R2152 VSS.t1656 VSS.n57 8.501
R2153 VSS.n523 VSS.t1653 0.130189
R2154 VSS.t1651 VSS.n57 8.501
R2155 VSS.n522 VSS.t1648 0.130189
R2156 VSS.t1646 VSS.n57 8.501
R2157 VSS.n521 VSS.t1643 0.130189
R2158 VSS.t1641 VSS.n57 8.501
R2159 VSS.n520 VSS.t1638 0.130189
R2160 VSS.t1636 VSS.n57 8.501
R2161 VSS.n519 VSS.t1633 0.130189
R2162 VSS.t1631 VSS.n57 8.501
R2163 VSS.n518 VSS.t1628 0.130189
R2164 VSS.t1626 VSS.n57 8.501
R2165 VSS.n517 VSS.t1623 0.130189
R2166 VSS.t1621 VSS.n57 8.501
R2167 VSS.n516 VSS.t1618 0.130189
R2168 VSS.t1616 VSS.n57 8.501
R2169 VSS.n515 VSS.t1613 0.130189
R2170 VSS.t1611 VSS.n57 8.501
R2171 VSS.n514 VSS.t1608 0.130189
R2172 VSS.t1606 VSS.n57 8.501
R2173 VSS.n513 VSS.t1603 0.130189
R2174 VSS.t1601 VSS.n57 8.501
R2175 VSS.n512 VSS.t1598 0.130189
R2176 VSS.t1596 VSS.n57 8.501
R2177 VSS.n511 VSS.t1593 0.130189
R2178 VSS.t1591 VSS.n57 8.501
R2179 VSS.n510 VSS.t1588 0.130189
R2180 VSS.t1586 VSS.n57 8.501
R2181 VSS.n509 VSS.t1583 0.130189
R2182 VSS.t1581 VSS.n57 8.501
R2183 VSS.n508 VSS.t1578 0.130189
R2184 VSS.t1576 VSS.n57 8.501
R2185 VSS.n57 VSS.n507 3.33079
R2186 VSS.n251 VSS.t377 4.20276
R2187 VSS.n650 VSS.t1164 0.130189
R2188 VSS.t1162 VSS.n54 8.501
R2189 VSS.n649 VSS.t1159 0.130189
R2190 VSS.t1157 VSS.n54 8.501
R2191 VSS.n648 VSS.t1154 0.130189
R2192 VSS.t1152 VSS.n54 8.501
R2193 VSS.n647 VSS.t1149 0.130189
R2194 VSS.t1147 VSS.n54 8.501
R2195 VSS.n646 VSS.t1144 0.130189
R2196 VSS.t1142 VSS.n54 8.501
R2197 VSS.n645 VSS.t1139 0.130189
R2198 VSS.t1137 VSS.n54 8.501
R2199 VSS.n644 VSS.t1134 0.130189
R2200 VSS.t1132 VSS.n54 8.501
R2201 VSS.n643 VSS.t1129 0.130189
R2202 VSS.t1127 VSS.n54 8.501
R2203 VSS.n642 VSS.t1124 0.130189
R2204 VSS.t1122 VSS.n54 8.501
R2205 VSS.n641 VSS.t1119 0.130189
R2206 VSS.t1117 VSS.n54 8.501
R2207 VSS.n640 VSS.t1114 0.130189
R2208 VSS.t1112 VSS.n54 8.501
R2209 VSS.n639 VSS.t1109 0.130189
R2210 VSS.t1107 VSS.n54 8.501
R2211 VSS.n638 VSS.t1104 0.130189
R2212 VSS.t1102 VSS.n54 8.501
R2213 VSS.n637 VSS.t1099 0.130189
R2214 VSS.t1097 VSS.n54 8.501
R2215 VSS.n636 VSS.t1094 0.130189
R2216 VSS.t1092 VSS.n54 8.501
R2217 VSS.n635 VSS.t1089 0.130189
R2218 VSS.t1087 VSS.n54 8.501
R2219 VSS.n634 VSS.t1084 0.130189
R2220 VSS.t1082 VSS.n54 8.501
R2221 VSS.n633 VSS.t1079 0.130189
R2222 VSS.t1077 VSS.n54 8.501
R2223 VSS.n632 VSS.t1074 0.130189
R2224 VSS.t1072 VSS.n54 8.501
R2225 VSS.n631 VSS.t1069 0.130189
R2226 VSS.t1067 VSS.n54 8.501
R2227 VSS.n630 VSS.t1064 0.130189
R2228 VSS.t1062 VSS.n54 8.501
R2229 VSS.n629 VSS.t1059 0.130189
R2230 VSS.t1057 VSS.n54 8.501
R2231 VSS.n628 VSS.t1054 0.130189
R2232 VSS.t1052 VSS.n54 8.501
R2233 VSS.n627 VSS.t1049 0.130189
R2234 VSS.t1047 VSS.n54 8.501
R2235 VSS.n626 VSS.t1044 0.130189
R2236 VSS.t1042 VSS.n54 8.501
R2237 VSS.n625 VSS.t1039 0.130189
R2238 VSS.t1037 VSS.n54 8.501
R2239 VSS.n624 VSS.t1034 0.130189
R2240 VSS.n623 VSS.t1029 0.0333775
R2241 VSS.t1027 VSS.n54 8.501
R2242 VSS.n622 VSS.t1024 0.130189
R2243 VSS.t1022 VSS.n54 8.501
R2244 VSS.n621 VSS.t1019 0.130189
R2245 VSS.t1017 VSS.n54 8.501
R2246 VSS.n620 VSS.t1014 0.130189
R2247 VSS.t1012 VSS.n54 8.501
R2248 VSS.n619 VSS.t1009 0.130189
R2249 VSS.t1007 VSS.n54 8.501
R2250 VSS.n618 VSS.t1004 0.130189
R2251 VSS.t1002 VSS.n54 8.501
R2252 VSS.n617 VSS.t999 0.130189
R2253 VSS.t997 VSS.n54 8.501
R2254 VSS.n616 VSS.t994 0.130189
R2255 VSS.t992 VSS.n54 8.501
R2256 VSS.n615 VSS.t989 0.130189
R2257 VSS.t987 VSS.n54 8.501
R2258 VSS.n614 VSS.t984 0.130189
R2259 VSS.t982 VSS.n54 8.501
R2260 VSS.n613 VSS.t979 0.130189
R2261 VSS.t977 VSS.n54 8.501
R2262 VSS.n612 VSS.t974 0.130189
R2263 VSS.t972 VSS.n54 8.501
R2264 VSS.n611 VSS.t969 0.130189
R2265 VSS.t967 VSS.n54 8.501
R2266 VSS.n610 VSS.t964 0.130189
R2267 VSS.t962 VSS.n54 8.501
R2268 VSS.n609 VSS.t959 0.130189
R2269 VSS.t957 VSS.n54 8.501
R2270 VSS.n608 VSS.t954 0.130189
R2271 VSS.t952 VSS.n54 8.501
R2272 VSS.n607 VSS.t949 0.130189
R2273 VSS.t947 VSS.n54 8.501
R2274 VSS.n606 VSS.t944 0.130189
R2275 VSS.t942 VSS.n54 8.501
R2276 VSS.n605 VSS.t939 0.130189
R2277 VSS.t937 VSS.n54 8.501
R2278 VSS.n604 VSS.t934 0.130189
R2279 VSS.t932 VSS.n54 8.501
R2280 VSS.n603 VSS.t929 0.130189
R2281 VSS.t927 VSS.n54 8.501
R2282 VSS.n602 VSS.t924 0.130189
R2283 VSS.t922 VSS.n54 8.501
R2284 VSS.n601 VSS.t919 0.130189
R2285 VSS.t917 VSS.n54 8.501
R2286 VSS.t914 VSS.n600 0.130189
R2287 VSS.t912 VSS.n54 8.501
R2288 VSS.t909 VSS.n599 0.130189
R2289 VSS.t907 VSS.n54 8.501
R2290 VSS.t904 VSS.n598 0.130189
R2291 VSS.t902 VSS.n54 8.501
R2292 VSS.t899 VSS.n597 0.130189
R2293 VSS.t897 VSS.n54 8.501
R2294 VSS.t894 VSS.n596 0.130189
R2295 VSS.t892 VSS.n54 8.501
R2296 VSS.n595 VSS.n54 3.33079
R2297 VSS.t850 VSS.n658 0.130189
R2298 VSS.t302 VSS.t848 8.501
R2299 VSS.t74 VSS.n657 0.130189
R2300 VSS.t27 VSS.t302 8.501
R2301 VSS.t398 VSS.n656 0.129991
R2302 VSS.t178 VSS.n655 0.13218
R2303 VSS.n654 VSS.t174 0.129991
R2304 VSS.t139 VSS.t302 8.501
R2305 VSS.t822 VSS.n653 0.130189
R2306 VSS.t373 VSS.t302 8.501
R2307 VSS.t369 VSS.n652 0.238005
R2308 VSS.n651 VSS.t302 3.33079
R2309 VSS.t769 VSS.n675 0.096752
R2310 VSS.t766 VSS.n674 0.235729
R2311 VSS.t763 VSS.n673 0.235729
R2312 VSS.t760 VSS.n672 0.235729
R2313 VSS.t758 VSS.n671 0.235729
R2314 VSS.t752 VSS.n670 0.0793054
R2315 VSS.t749 VSS.n669 0.235729
R2316 VSS.t746 VSS.n668 0.235729
R2317 VSS.t743 VSS.n667 0.235729
R2318 VSS.t740 VSS.n666 0.235729
R2319 VSS.t737 VSS.n665 0.235729
R2320 VSS.t734 VSS.n664 0.235729
R2321 VSS.t731 VSS.n663 0.235729
R2322 VSS.t728 VSS.n662 0.235729
R2323 VSS.t725 VSS.n661 0.235729
R2324 VSS.t407 VSS.n660 0.235729
R2325 VSS.t76 VSS.n659 0.235736
R2326 VSS.t853 VSS.t302 8.501
R2327 VSS.t18 VSS.n676 0.343184
R2328 VSS.t35 VSS.t302 0.952798
R2329 VSS.t620 VSS.n693 0.096752
R2330 VSS.t33 VSS.t619 8.501
R2331 VSS.t617 VSS.n692 0.130189
R2332 VSS.t33 VSS.t616 8.501
R2333 VSS.t614 VSS.n691 0.130189
R2334 VSS.t33 VSS.t613 8.501
R2335 VSS.t611 VSS.n690 0.130189
R2336 VSS.t33 VSS.t610 8.501
R2337 VSS.t608 VSS.n689 0.130189
R2338 VSS.n209 VSS.t607 0.0362711
R2339 VSS.t605 VSS.t606 0.0793054
R2340 VSS.t33 VSS.t604 8.501
R2341 VSS.t602 VSS.n686 0.130189
R2342 VSS.t33 VSS.t601 8.501
R2343 VSS.t599 VSS.n685 0.130189
R2344 VSS.t33 VSS.t598 8.501
R2345 VSS.t596 VSS.n684 0.130189
R2346 VSS.t33 VSS.t595 8.501
R2347 VSS.t593 VSS.n683 0.130189
R2348 VSS.t33 VSS.t592 8.501
R2349 VSS.t590 VSS.n682 0.130189
R2350 VSS.t33 VSS.t589 8.501
R2351 VSS.t587 VSS.n681 0.130189
R2352 VSS.t33 VSS.t586 8.501
R2353 VSS.t584 VSS.n680 0.130189
R2354 VSS.t33 VSS.t583 8.501
R2355 VSS.t581 VSS.n679 0.130189
R2356 VSS.t33 VSS.t580 8.501
R2357 VSS.n678 VSS.t578 0.130189
R2358 VSS.t577 VSS.t33 8.501
R2359 VSS.n699 VSS.t97 0.0296542
R2360 VSS.t16 VSS.n698 0.857433
R2361 VSS.n697 VSS.t33 1.52998
R2362 VSS.n696 VSS.t33 0.610396
R2363 VSS.n270 VSS.t46 0.219456
R2364 VSS.t84 VSS.t33 8.501
R2365 VSS.t22 VSS.n695 0.130189
R2366 VSS.n694 VSS.t33 0.574066
R2367 VSS.t145 VSS.n703 0.623747
R2368 VSS.n702 VSS.t33 3.33079
R2369 VSS.n701 VSS.t186 0.570079
R2370 VSS.t568 VSS.t33 8.501
R2371 VSS.t33 VSS.n700 3.33079
R2372 VSS.n257 VSS.t302 0.325424
R2373 VSS.n139 VSS.n312 4.20253
R2374 VSS.n372 VSS.t495 0.083315
R2375 VSS.t412 VSS.n385 3.30688
R2376 VSS.t412 VSS.t2831 8.47111
R2377 VSS.t412 VSS.n203 3.30688
R2378 VSS.n298 VSS.t2834 0.119605
R2379 VSS.t2966 VSS.n386 0.17801
R2380 VSS.t412 VSS.n298 4.177
R2381 VSS.n297 VSS.t2837 0.17801
R2382 VSS.t412 VSS.n387 3.30696
R2383 VSS.n296 VSS.t412 3.30688
R2384 VSS.n295 VSS.t2845 0.17801
R2385 VSS.t412 VSS.n388 3.30696
R2386 VSS.n294 VSS.t412 3.30688
R2387 VSS.n293 VSS.t2853 0.17801
R2388 VSS.t412 VSS.n389 3.30696
R2389 VSS.n292 VSS.t412 3.30688
R2390 VSS.n291 VSS.t2861 0.17801
R2391 VSS.t412 VSS.n390 3.30696
R2392 VSS.n290 VSS.t412 3.30688
R2393 VSS.n289 VSS.t2869 0.17801
R2394 VSS.t412 VSS.n391 3.30696
R2395 VSS.n288 VSS.t412 3.30688
R2396 VSS.n287 VSS.t2877 0.17801
R2397 VSS.t412 VSS.n392 3.30696
R2398 VSS.n286 VSS.t412 3.30688
R2399 VSS.n285 VSS.t2885 0.17801
R2400 VSS.n181 VSS.t2887 0.119605
R2401 VSS.t412 VSS.n301 3.30688
R2402 VSS.n181 VSS.t412 4.177
R2403 VSS.n284 VSS.t2891 0.17801
R2404 VSS.t412 VSS.n204 4.177
R2405 VSS.n204 VSS.t2895 0.119605
R2406 VSS.n299 VSS.t2896 0.119605
R2407 VSS.t3019 VSS.n393 0.17801
R2408 VSS.t412 VSS.n299 4.177
R2409 VSS.t412 VSS.n267 3.30688
R2410 VSS.n183 VSS.t2901 0.149144
R2411 VSS.t2827 VSS.t412 8.47111
R2412 VSS.n300 VSS.t412 4.177
R2413 VSS.n300 VSS.t2826 0.119605
R2414 VSS.n206 VSS.t2818 0.177814
R2415 VSS.t2817 VSS.n302 0.17801
R2416 VSS.t2812 VSS.n265 0.17801
R2417 VSS.t2808 VSS.n303 0.177814
R2418 VSS.t2803 VSS.n304 0.177814
R2419 VSS.t2798 VSS.n264 0.177814
R2420 VSS.n305 VSS.t2794 0.177814
R2421 VSS.n263 VSS.t2788 0.177814
R2422 VSS.n306 VSS.t2783 0.17801
R2423 VSS.n307 VSS.t2777 0.17801
R2424 VSS.n262 VSS.t2771 0.17801
R2425 VSS.t2766 VSS.n308 0.119605
R2426 VSS.t412 VSS.n308 4.177
R2427 VSS.t2760 VSS.n309 0.17801
R2428 VSS.t2754 VSS.n261 0.17801
R2429 VSS.t412 VSS.n394 4.177
R2430 VSS.n394 VSS.t2749 0.119605
R2431 VSS.t1365 VSS.n217 0.177814
R2432 VSS.n563 VSS.t377 4.177
R2433 VSS.t1367 VSS.n563 0.119605
R2434 VSS.t377 VSS.t1368 8.47111
R2435 VSS.t377 VSS.n177 3.30696
R2436 VSS.t377 VSS.n260 3.30688
R2437 VSS.t377 VSS.n228 4.177
R2438 VSS.t1518 VSS.n564 0.119605
R2439 VSS.n228 VSS.t1377 0.119605
R2440 VSS.n564 VSS.t377 4.177
R2441 VSS.t377 VSS.n211 3.30696
R2442 VSS.n565 VSS.t1383 0.17801
R2443 VSS.n566 VSS.t1386 0.119605
R2444 VSS.t377 VSS.n566 4.177
R2445 VSS.t377 VSS.n191 3.30688
R2446 VSS.n229 VSS.t1390 0.119605
R2447 VSS.t377 VSS.n229 4.177
R2448 VSS.n567 VSS.t1392 0.17801
R2449 VSS.n182 VSS.t1394 0.119605
R2450 VSS.t1531 VSS.n568 0.17801
R2451 VSS.t377 VSS.n182 4.177
R2452 VSS.n569 VSS.t377 4.177
R2453 VSS.t377 VSS.t1397 8.47111
R2454 VSS.t1398 VSS.n569 0.119605
R2455 VSS.t1399 VSS.t377 8.47111
R2456 VSS.t377 VSS.n570 4.177
R2457 VSS.n570 VSS.t1401 0.119605
R2458 VSS.n571 VSS.t1402 0.119605
R2459 VSS.t1539 VSS.t377 8.47111
R2460 VSS.t377 VSS.n571 4.177
R2461 VSS.n572 VSS.t377 3.30688
R2462 VSS.t1542 VSS.t377 8.47111
R2463 VSS.t1407 VSS.n573 0.119605
R2464 VSS.n573 VSS.t377 4.177
R2465 VSS.t1410 VSS.n220 0.119605
R2466 VSS.n220 VSS.t377 4.177
R2467 VSS.n574 VSS.t1412 0.119605
R2468 VSS.t377 VSS.n574 4.177
R2469 VSS.t377 VSS.t1414 8.47111
R2470 VSS.t377 VSS.n283 3.30688
R2471 VSS.n230 VSS.t1417 0.119605
R2472 VSS.t1551 VSS.n575 0.17801
R2473 VSS.t377 VSS.n230 4.177
R2474 VSS.n576 VSS.t377 4.177
R2475 VSS.t377 VSS.t1420 8.47111
R2476 VSS.t1421 VSS.n576 0.119605
R2477 VSS.n282 VSS.t377 4.177
R2478 VSS.n282 VSS.t1423 0.119605
R2479 VSS.t1425 VSS.n281 0.17801
R2480 VSS.n577 VSS.t1426 0.119605
R2481 VSS.t377 VSS.n577 4.177
R2482 VSS.n266 VSS.t377 3.30688
R2483 VSS.t377 VSS.n219 4.177
R2484 VSS.n219 VSS.t1433 0.119605
R2485 VSS.n578 VSS.t1434 0.119605
R2486 VSS.t1565 VSS.t377 8.47111
R2487 VSS.t377 VSS.n578 4.177
R2488 VSS.n579 VSS.t377 3.30688
R2489 VSS.t1568 VSS.t377 8.47111
R2490 VSS.t1439 VSS.n580 0.119605
R2491 VSS.n580 VSS.t377 4.177
R2492 VSS.n581 VSS.t377 3.30688
R2493 VSS.t1443 VSS.n251 0.0833107
R2494 VSS.n210 VSS.t377 3.30688
R2495 VSS.n258 VSS.t377 3.30688
R2496 VSS.t377 VSS.n582 4.177
R2497 VSS.t1358 VSS.n582 0.119605
R2498 VSS.n231 VSS.t377 4.177
R2499 VSS.t1503 VSS.n231 0.119605
R2500 VSS.t377 VSS.n192 4.177
R2501 VSS.n192 VSS.t1355 0.119605
R2502 VSS.t377 VSS.n583 4.177
R2503 VSS.n583 VSS.t1352 0.119605
R2504 VSS.t377 VSS.n232 4.177
R2505 VSS.n232 VSS.t1350 0.119605
R2506 VSS.n193 VSS.t377 4.177
R2507 VSS.t1348 VSS.n193 0.119605
R2508 VSS.n584 VSS.t377 4.177
R2509 VSS.t1345 VSS.n584 0.119605
R2510 VSS.n233 VSS.t377 4.177
R2511 VSS.n233 VSS.t1344 0.119605
R2512 VSS.t377 VSS.n194 4.177
R2513 VSS.n194 VSS.t1342 0.119605
R2514 VSS.t377 VSS.n585 4.177
R2515 VSS.n585 VSS.t1339 0.119605
R2516 VSS.t377 VSS.n234 4.177
R2517 VSS.t1337 VSS.n234 0.119605
R2518 VSS.n195 VSS.t377 4.177
R2519 VSS.t1335 VSS.n195 0.119605
R2520 VSS.n586 VSS.t377 4.177
R2521 VSS.t1485 VSS.n586 0.119605
R2522 VSS.t377 VSS.n235 4.177
R2523 VSS.n235 VSS.t1331 0.119605
R2524 VSS.t377 VSS.n196 4.177
R2525 VSS.n196 VSS.t1329 0.119605
R2526 VSS.t377 VSS.n587 4.177
R2527 VSS.n587 VSS.t1326 0.119605
R2528 VSS.t377 VSS.n588 4.177
R2529 VSS.n588 VSS.t1323 0.119605
R2530 VSS.n236 VSS.t377 4.177
R2531 VSS.t1321 VSS.n236 0.119605
R2532 VSS.n197 VSS.t377 4.177
R2533 VSS.n197 VSS.t1320 0.119605
R2534 VSS.n589 VSS.t377 4.177
R2535 VSS.n589 VSS.t1318 0.119605
R2536 VSS.t377 VSS.n237 4.177
R2537 VSS.n237 VSS.t1316 0.119605
R2538 VSS.t377 VSS.n198 4.177
R2539 VSS.t1314 VSS.n198 0.119605
R2540 VSS.t377 VSS.n590 4.177
R2541 VSS.t1311 VSS.n590 0.119605
R2542 VSS.n238 VSS.t377 4.177
R2543 VSS.t1466 VSS.n238 0.119605
R2544 VSS.t377 VSS.n199 4.177
R2545 VSS.n199 VSS.t1308 0.119605
R2546 VSS.t377 VSS.n591 4.177
R2547 VSS.n591 VSS.t1305 0.119605
R2548 VSS.t377 VSS.n239 4.177
R2549 VSS.n239 VSS.t1303 0.119605
R2550 VSS.n200 VSS.t377 4.177
R2551 VSS.t1301 VSS.n200 0.119605
R2552 VSS.n592 VSS.t377 4.177
R2553 VSS.t1298 VSS.n592 0.119605
R2554 VSS.t1457 VSS.t377 8.47111
R2555 VSS.t377 VSS.n218 4.177
R2556 VSS.n218 VSS.t1296 0.119605
R2557 VSS.t377 VSS.n190 3.30688
R2558 VSS.t377 VSS.n593 4.177
R2559 VSS.n593 VSS.t1292 0.119605
R2560 VSS.t377 VSS.n240 4.177
R2561 VSS.t1290 VSS.n240 0.119605
R2562 VSS.n201 VSS.t377 4.177
R2563 VSS.t1288 VSS.n201 0.119605
R2564 VSS.n594 VSS.t377 4.177
R2565 VSS.t1448 VSS.n594 0.119605
R2566 VSS.t377 VSS.n241 4.177
R2567 VSS.n241 VSS.t1284 0.119605
R2568 VSS.t377 VSS.n202 4.177
R2569 VSS.n202 VSS.t1282 0.119605
R2570 VSS.n670 VSS.t302 4.20468
R2571 VSS.t287 VSS.n268 0.177814
R2572 VSS.t6 VSS.n269 0.798381
R2573 VSS.t10 VSS.n677 0.0605362
R2574 VSS.n271 VSS.t33 3.30688
R2575 VSS.n207 VSS.t33 4.177
R2576 VSS.t33 VSS.t606 4.20468
R2577 VSS.n851 VSS.t449 8.36235
R2578 VSS.t551 VSS.n687 8.36235
R2579 VSS.t3277 VSS.n940 8.36235
R2580 VSS.n939 VSS.n708 8.36235
R2581 VSS.n905 VSS.n748 8.36235
R2582 VSS.t106 VSS.n851 8.3005
R2583 VSS.t686 VSS.n719 8.3005
R2584 VSS.n930 VSS.t917 8.3005
R2585 VSS.t1297 VSS.n931 8.3005
R2586 VSS.t1601 VSS.n712 8.3005
R2587 VSS.n936 VSS.t1993 8.3005
R2588 VSS.t2385 VSS.n937 8.3005
R2589 VSS.t2765 VSS.n707 8.3005
R2590 VSS.n941 VSS.t3052 8.3005
R2591 VSS.n688 VSS.n687 8.3005
R2592 VSS.n928 VSS.n720 8.3005
R2593 VSS.t1142 VSS.n929 8.3005
R2594 VSS.t1429 VSS.n713 8.3005
R2595 VSS.n934 VSS.t1826 8.3005
R2596 VSS.t2218 VSS.n935 8.3005
R2597 VSS.t2610 VSS.n709 8.3005
R2598 VSS.n940 VSS.t2888 8.3005
R2599 VSS.t2960 VSS.n939 8.3005
R2600 VSS.n938 VSS.t2498 8.3005
R2601 VSS.t2106 VSS.n711 8.3005
R2602 VSS.t1714 VSS.n933 8.3005
R2603 VSS.n932 VSS.t1364 8.3005
R2604 VSS.t1030 VSS.n714 8.3005
R2605 VSS.t384 VSS.n906 8.3005
R2606 VSS.n905 VSS.n904 8.3005
R2607 VSS.n806 VSS.t89 8.06935
R2608 VSS.t224 VSS.t43 7.1604
R2609 VSS.t302 VSS.n675 3.35999
R2610 VSS.t574 VSS.t33 5.64857
R2611 VSS.n139 VSS.n368 3.33079
R2612 VSS.n367 VSS.n139 3.33079
R2613 VSS.n139 VSS.n366 3.33079
R2614 VSS.n365 VSS.n139 3.33079
R2615 VSS.n139 VSS.n364 3.33079
R2616 VSS.n363 VSS.n139 3.33079
R2617 VSS.n362 VSS.n139 3.33079
R2618 VSS.n361 VSS.n139 3.33079
R2619 VSS.n360 VSS.n139 3.33079
R2620 VSS.n359 VSS.n139 3.33079
R2621 VSS.n358 VSS.n139 3.33079
R2622 VSS.n357 VSS.n139 3.33079
R2623 VSS.n356 VSS.n139 3.33079
R2624 VSS.n355 VSS.n139 3.33079
R2625 VSS.n354 VSS.n139 3.33079
R2626 VSS.n353 VSS.n139 3.33079
R2627 VSS.n352 VSS.n139 3.33079
R2628 VSS.n351 VSS.n139 3.33079
R2629 VSS.n350 VSS.n139 3.33079
R2630 VSS.n349 VSS.n139 3.33079
R2631 VSS.n348 VSS.n139 3.33079
R2632 VSS.n347 VSS.n139 3.33079
R2633 VSS.n346 VSS.n139 3.33079
R2634 VSS.n345 VSS.n139 3.33079
R2635 VSS.n344 VSS.n139 3.33079
R2636 VSS.n343 VSS.n139 3.33079
R2637 VSS.n342 VSS.n139 3.33079
R2638 VSS.n340 VSS.n139 3.33079
R2639 VSS.n339 VSS.n139 3.33079
R2640 VSS.n338 VSS.n139 3.33079
R2641 VSS.n337 VSS.n139 3.33079
R2642 VSS.n336 VSS.n139 3.33079
R2643 VSS.n335 VSS.n139 3.33079
R2644 VSS.n334 VSS.n139 3.33079
R2645 VSS.n333 VSS.n139 3.33079
R2646 VSS.n332 VSS.n139 3.33079
R2647 VSS.n331 VSS.n139 3.33079
R2648 VSS.n330 VSS.n139 3.33079
R2649 VSS.n329 VSS.n139 3.33079
R2650 VSS.n328 VSS.n139 3.33079
R2651 VSS.n327 VSS.n139 3.33079
R2652 VSS.n326 VSS.n139 3.33079
R2653 VSS.n325 VSS.n139 3.33079
R2654 VSS.n324 VSS.n139 3.33079
R2655 VSS.n323 VSS.n139 3.33079
R2656 VSS.n322 VSS.n139 3.33079
R2657 VSS.n321 VSS.n139 3.33079
R2658 VSS.n320 VSS.n139 3.33079
R2659 VSS.n139 VSS.n319 3.33079
R2660 VSS.n317 VSS.n139 3.33079
R2661 VSS.n139 VSS.n316 3.33079
R2662 VSS.n315 VSS.n139 3.33079
R2663 VSS.n139 VSS.n314 3.33079
R2664 VSS.t3025 VSS.n313 0.0863258
R2665 VSS.t439 VSS.n705 0.0896992
R2666 VSS.t444 VSS.n706 0.0896992
R2667 VSS.t485 VSS.n370 0.0896992
R2668 VSS.t490 VSS.n371 0.0896992
R2669 VSS.t500 VSS.n374 0.0896992
R2670 VSS.n375 VSS.t505 0.0896992
R2671 VSS.n376 VSS.t510 0.0896992
R2672 VSS.t515 VSS.n379 0.0896992
R2673 VSS.n380 VSS.t520 0.0896992
R2674 VSS.n381 VSS.t525 0.0896992
R2675 VSS.n382 VSS.t530 0.0896992
R2676 VSS.n383 VSS.t535 0.0896992
R2677 VSS.n384 VSS.t540 0.0896992
R2678 VSS.n385 VSS.t2830 0.118323
R2679 VSS.n203 VSS.t2832 0.118323
R2680 VSS.t412 VSS.n386 3.30688
R2681 VSS.t412 VSS.n297 3.30688
R2682 VSS.t2839 VSS.t412 5.61485
R2683 VSS.t2841 VSS.n387 0.118193
R2684 VSS.t412 VSS.t2842 5.61485
R2685 VSS.n296 VSS.t2844 0.118323
R2686 VSS.t412 VSS.n295 3.30688
R2687 VSS.t2847 VSS.t412 5.61485
R2688 VSS.t2849 VSS.n388 0.118193
R2689 VSS.t412 VSS.t2850 5.61485
R2690 VSS.n294 VSS.t2852 0.118323
R2691 VSS.t412 VSS.n293 3.30688
R2692 VSS.t2855 VSS.t412 5.61485
R2693 VSS.t2857 VSS.n389 0.118193
R2694 VSS.t412 VSS.t2858 5.61485
R2695 VSS.n292 VSS.t2860 0.118323
R2696 VSS.t412 VSS.n291 3.30688
R2697 VSS.t2863 VSS.t412 5.61485
R2698 VSS.t2865 VSS.n390 0.118193
R2699 VSS.t412 VSS.t2866 5.61485
R2700 VSS.n290 VSS.t2868 0.118323
R2701 VSS.t412 VSS.n289 3.30688
R2702 VSS.t2871 VSS.t412 5.61485
R2703 VSS.t2873 VSS.n391 0.118193
R2704 VSS.t412 VSS.t2874 5.61485
R2705 VSS.n288 VSS.t2876 0.118323
R2706 VSS.t412 VSS.n287 3.30688
R2707 VSS.t2879 VSS.t412 5.61485
R2708 VSS.t2881 VSS.n392 0.118193
R2709 VSS.t412 VSS.t2882 5.61485
R2710 VSS.n286 VSS.t2884 0.118323
R2711 VSS.t412 VSS.n285 3.30688
R2712 VSS.n301 VSS.t2890 0.118323
R2713 VSS.t412 VSS.n284 3.30688
R2714 VSS.t2893 VSS.t412 5.61485
R2715 VSS.t412 VSS.n393 3.30688
R2716 VSS.n267 VSS.t2900 0.118323
R2717 VSS.t2825 VSS.n184 0.175714
R2718 VSS.t412 VSS.n184 2.72082
R2719 VSS.t412 VSS.n227 2.72098
R2720 VSS.t2821 VSS.n227 0.175395
R2721 VSS.t2820 VSS.t412 5.61485
R2722 VSS.t412 VSS.n206 3.30696
R2723 VSS.t412 VSS.n302 3.30688
R2724 VSS.n249 VSS.t2815 0.175395
R2725 VSS.n249 VSS.t412 2.72098
R2726 VSS.t412 VSS.t2813 5.61485
R2727 VSS.t412 VSS.n265 3.30688
R2728 VSS.n221 VSS.t2810 0.175395
R2729 VSS.n221 VSS.t412 2.72098
R2730 VSS.n303 VSS.t412 3.30696
R2731 VSS.n248 VSS.t2806 0.175554
R2732 VSS.t412 VSS.n248 2.7209
R2733 VSS.t2804 VSS.t412 5.61485
R2734 VSS.n304 VSS.t412 3.30696
R2735 VSS.n247 VSS.t2801 0.175554
R2736 VSS.t412 VSS.n247 2.7209
R2737 VSS.t2799 VSS.t412 5.61485
R2738 VSS.n264 VSS.t412 3.30696
R2739 VSS.n222 VSS.t2796 0.175554
R2740 VSS.t412 VSS.n222 2.7209
R2741 VSS.n305 VSS.t412 3.30696
R2742 VSS.t2791 VSS.n246 0.175714
R2743 VSS.t412 VSS.t2789 5.61485
R2744 VSS.n263 VSS.t412 3.30696
R2745 VSS.t2785 VSS.n223 0.175714
R2746 VSS.t412 VSS.n223 2.72082
R2747 VSS.t412 VSS.n306 3.30688
R2748 VSS.t2780 VSS.n245 0.175554
R2749 VSS.n245 VSS.t412 2.7209
R2750 VSS.t412 VSS.t2778 5.61485
R2751 VSS.t412 VSS.n307 3.30688
R2752 VSS.t2774 VSS.n244 0.175554
R2753 VSS.n244 VSS.t412 2.7209
R2754 VSS.t412 VSS.t2772 5.61485
R2755 VSS.t412 VSS.n262 3.30688
R2756 VSS.t2768 VSS.n224 0.175554
R2757 VSS.n224 VSS.t412 2.7209
R2758 VSS.n243 VSS.t2764 0.175395
R2759 VSS.n243 VSS.t412 2.72098
R2760 VSS.t2761 VSS.t412 5.61485
R2761 VSS.t412 VSS.n309 3.30688
R2762 VSS.n242 VSS.t2758 0.175395
R2763 VSS.n242 VSS.t412 2.72098
R2764 VSS.t2755 VSS.t412 5.61485
R2765 VSS.t412 VSS.n261 3.30688
R2766 VSS.n187 VSS.t2752 0.175395
R2767 VSS.n187 VSS.t412 2.72098
R2768 VSS.n450 VSS.n55 3.33079
R2769 VSS.n448 VSS.n55 3.33079
R2770 VSS.n55 VSS.n447 3.33079
R2771 VSS.n446 VSS.n55 3.33079
R2772 VSS.n55 VSS.n445 3.33079
R2773 VSS.n444 VSS.n55 3.33079
R2774 VSS.n55 VSS.n443 3.33079
R2775 VSS.n442 VSS.n55 3.33079
R2776 VSS.n55 VSS.n441 3.33079
R2777 VSS.n440 VSS.n55 3.33079
R2778 VSS.n55 VSS.n439 3.33079
R2779 VSS.n438 VSS.n55 3.33079
R2780 VSS.n55 VSS.n437 3.33079
R2781 VSS.n436 VSS.n55 3.33079
R2782 VSS.n55 VSS.n435 3.33079
R2783 VSS.n434 VSS.n55 3.33079
R2784 VSS.n55 VSS.n433 3.33079
R2785 VSS.n432 VSS.n55 3.33079
R2786 VSS.n55 VSS.n431 3.33079
R2787 VSS.n430 VSS.n55 3.33079
R2788 VSS.n55 VSS.n429 3.33079
R2789 VSS.n428 VSS.n55 3.33079
R2790 VSS.n55 VSS.n427 3.33079
R2791 VSS.n426 VSS.n55 3.33079
R2792 VSS.n55 VSS.n425 3.33079
R2793 VSS.n424 VSS.n55 3.33079
R2794 VSS.n422 VSS.n55 3.33079
R2795 VSS.n421 VSS.n55 3.33079
R2796 VSS.n420 VSS.n55 3.33079
R2797 VSS.n419 VSS.n55 3.33079
R2798 VSS.n418 VSS.n55 3.33079
R2799 VSS.n417 VSS.n55 3.33079
R2800 VSS.n416 VSS.n55 3.33079
R2801 VSS.n415 VSS.n55 3.33079
R2802 VSS.n414 VSS.n55 3.33079
R2803 VSS.n413 VSS.n55 3.33079
R2804 VSS.n412 VSS.n55 3.33079
R2805 VSS.n411 VSS.n55 3.33079
R2806 VSS.n410 VSS.n55 3.33079
R2807 VSS.n409 VSS.n55 3.33079
R2808 VSS.n408 VSS.n55 3.33079
R2809 VSS.n407 VSS.n55 3.33079
R2810 VSS.n406 VSS.n55 3.33079
R2811 VSS.n405 VSS.n55 3.33079
R2812 VSS.n404 VSS.n55 3.33079
R2813 VSS.n403 VSS.n55 3.33079
R2814 VSS.n402 VSS.n55 3.33079
R2815 VSS.n401 VSS.n55 3.33079
R2816 VSS.n400 VSS.n55 3.33079
R2817 VSS.n399 VSS.n55 3.33079
R2818 VSS.n398 VSS.n55 3.33079
R2819 VSS.n397 VSS.n55 3.33079
R2820 VSS.n396 VSS.n55 3.33079
R2821 VSS.t2358 VSS.n395 0.0863258
R2822 VSS.n506 VSS.n56 3.33079
R2823 VSS.n504 VSS.n56 3.33079
R2824 VSS.n56 VSS.n503 3.33079
R2825 VSS.n502 VSS.n56 3.33079
R2826 VSS.n56 VSS.n501 3.33079
R2827 VSS.n500 VSS.n56 3.33079
R2828 VSS.n56 VSS.n499 3.33079
R2829 VSS.n498 VSS.n56 3.33079
R2830 VSS.n56 VSS.n497 3.33079
R2831 VSS.n496 VSS.n56 3.33079
R2832 VSS.n56 VSS.n495 3.33079
R2833 VSS.n494 VSS.n56 3.33079
R2834 VSS.n56 VSS.n493 3.33079
R2835 VSS.n492 VSS.n56 3.33079
R2836 VSS.n56 VSS.n491 3.33079
R2837 VSS.n490 VSS.n56 3.33079
R2838 VSS.n56 VSS.n489 3.33079
R2839 VSS.n488 VSS.n56 3.33079
R2840 VSS.n56 VSS.n487 3.33079
R2841 VSS.n486 VSS.n56 3.33079
R2842 VSS.n56 VSS.n485 3.33079
R2843 VSS.n484 VSS.n56 3.33079
R2844 VSS.n56 VSS.n483 3.33079
R2845 VSS.n482 VSS.n56 3.33079
R2846 VSS.n56 VSS.n481 3.33079
R2847 VSS.n480 VSS.n56 3.33079
R2848 VSS.n478 VSS.n56 3.33079
R2849 VSS.n56 VSS.n477 3.33079
R2850 VSS.n476 VSS.n56 3.33079
R2851 VSS.n56 VSS.n475 3.33079
R2852 VSS.n474 VSS.n56 3.33079
R2853 VSS.n56 VSS.n473 3.33079
R2854 VSS.n472 VSS.n56 3.33079
R2855 VSS.n56 VSS.n471 3.33079
R2856 VSS.n470 VSS.n56 3.33079
R2857 VSS.n56 VSS.n469 3.33079
R2858 VSS.n468 VSS.n56 3.33079
R2859 VSS.n56 VSS.n467 3.33079
R2860 VSS.n466 VSS.n56 3.33079
R2861 VSS.n56 VSS.n465 3.33079
R2862 VSS.n464 VSS.n56 3.33079
R2863 VSS.n56 VSS.n463 3.33079
R2864 VSS.n462 VSS.n56 3.33079
R2865 VSS.n56 VSS.n461 3.33079
R2866 VSS.n460 VSS.n56 3.33079
R2867 VSS.n56 VSS.n459 3.33079
R2868 VSS.n458 VSS.n56 3.33079
R2869 VSS.n56 VSS.n457 3.33079
R2870 VSS.n456 VSS.n56 3.33079
R2871 VSS.n455 VSS.n56 3.33079
R2872 VSS.n56 VSS.n454 3.33079
R2873 VSS.n453 VSS.n56 3.33079
R2874 VSS.n56 VSS.n452 3.33079
R2875 VSS.t1966 VSS.n451 0.0863258
R2876 VSS.n57 VSS.n562 3.33079
R2877 VSS.n57 VSS.n560 3.33079
R2878 VSS.n559 VSS.n57 3.33079
R2879 VSS.n57 VSS.n558 3.33079
R2880 VSS.n557 VSS.n57 3.33079
R2881 VSS.n556 VSS.n57 3.33079
R2882 VSS.n555 VSS.n57 3.33079
R2883 VSS.n554 VSS.n57 3.33079
R2884 VSS.n553 VSS.n57 3.33079
R2885 VSS.n552 VSS.n57 3.33079
R2886 VSS.n551 VSS.n57 3.33079
R2887 VSS.n550 VSS.n57 3.33079
R2888 VSS.n549 VSS.n57 3.33079
R2889 VSS.n548 VSS.n57 3.33079
R2890 VSS.n547 VSS.n57 3.33079
R2891 VSS.n546 VSS.n57 3.33079
R2892 VSS.n545 VSS.n57 3.33079
R2893 VSS.n544 VSS.n57 3.33079
R2894 VSS.n543 VSS.n57 3.33079
R2895 VSS.n542 VSS.n57 3.33079
R2896 VSS.n541 VSS.n57 3.33079
R2897 VSS.n540 VSS.n57 3.33079
R2898 VSS.n539 VSS.n57 3.33079
R2899 VSS.n538 VSS.n57 3.33079
R2900 VSS.n537 VSS.n57 3.33079
R2901 VSS.n536 VSS.n57 3.33079
R2902 VSS.n57 VSS.n534 3.33079
R2903 VSS.n533 VSS.n57 3.33079
R2904 VSS.n57 VSS.n532 3.33079
R2905 VSS.n531 VSS.n57 3.33079
R2906 VSS.n57 VSS.n530 3.33079
R2907 VSS.n529 VSS.n57 3.33079
R2908 VSS.n57 VSS.n528 3.33079
R2909 VSS.n527 VSS.n57 3.33079
R2910 VSS.n57 VSS.n526 3.33079
R2911 VSS.n525 VSS.n57 3.33079
R2912 VSS.n57 VSS.n524 3.33079
R2913 VSS.n523 VSS.n57 3.33079
R2914 VSS.n57 VSS.n522 3.33079
R2915 VSS.n521 VSS.n57 3.33079
R2916 VSS.n57 VSS.n520 3.33079
R2917 VSS.n519 VSS.n57 3.33079
R2918 VSS.n57 VSS.n518 3.33079
R2919 VSS.n517 VSS.n57 3.33079
R2920 VSS.n57 VSS.n516 3.33079
R2921 VSS.n515 VSS.n57 3.33079
R2922 VSS.n57 VSS.n514 3.33079
R2923 VSS.n513 VSS.n57 3.33079
R2924 VSS.n57 VSS.n512 3.33079
R2925 VSS.n511 VSS.n57 3.33079
R2926 VSS.n57 VSS.n510 3.33079
R2927 VSS.n509 VSS.n57 3.33079
R2928 VSS.n57 VSS.n508 3.33079
R2929 VSS.t1574 VSS.n507 0.0863258
R2930 VSS.t377 VSS.n217 3.30696
R2931 VSS.n208 VSS.t1370 0.175714
R2932 VSS.n177 VSS.t1372 0.118193
R2933 VSS.n260 VSS.t1374 0.118323
R2934 VSS.t377 VSS.t1379 5.61485
R2935 VSS.n211 VSS.t1381 0.118193
R2936 VSS.t377 VSS.n565 3.30688
R2937 VSS.t1385 VSS.t377 5.61485
R2938 VSS.t1388 VSS.n191 0.118323
R2939 VSS.t377 VSS.n567 3.30688
R2940 VSS.t377 VSS.n568 3.30688
R2941 VSS.n572 VSS.t1405 0.118323
R2942 VSS.t1409 VSS.t377 5.61485
R2943 VSS.n283 VSS.t1415 0.118323
R2944 VSS.t377 VSS.n575 3.30688
R2945 VSS.n281 VSS.t377 3.30688
R2946 VSS.t1428 VSS.n259 0.0600369
R2947 VSS.t1430 VSS.n266 0.118323
R2948 VSS.n579 VSS.t1437 0.118323
R2949 VSS.t1441 VSS.n581 0.118323
R2950 VSS.t1362 VSS.n210 0.118323
R2951 VSS.n258 VSS.t1360 0.118323
R2952 VSS.t1354 VSS.t377 5.61485
R2953 VSS.t377 VSS.t1347 5.61485
R2954 VSS.t377 VSS.t1341 5.61485
R2955 VSS.t1334 VSS.t377 5.61485
R2956 VSS.t377 VSS.t1328 5.61485
R2957 VSS.t377 VSS.t1325 5.61485
R2958 VSS.t1319 VSS.t377 5.61485
R2959 VSS.t377 VSS.t1313 5.61485
R2960 VSS.t1307 VSS.t377 5.61485
R2961 VSS.t377 VSS.t1300 5.61485
R2962 VSS.n190 VSS.t1294 0.118323
R2963 VSS.t1287 VSS.t377 5.61485
R2964 VSS.n186 VSS.t1281 0.106127
R2965 VSS.n650 VSS.n54 3.33079
R2966 VSS.n648 VSS.n54 3.33079
R2967 VSS.n54 VSS.n647 3.33079
R2968 VSS.n646 VSS.n54 3.33079
R2969 VSS.n54 VSS.n645 3.33079
R2970 VSS.n644 VSS.n54 3.33079
R2971 VSS.n54 VSS.n643 3.33079
R2972 VSS.n642 VSS.n54 3.33079
R2973 VSS.n54 VSS.n641 3.33079
R2974 VSS.n640 VSS.n54 3.33079
R2975 VSS.n54 VSS.n639 3.33079
R2976 VSS.n638 VSS.n54 3.33079
R2977 VSS.n54 VSS.n637 3.33079
R2978 VSS.n636 VSS.n54 3.33079
R2979 VSS.n54 VSS.n635 3.33079
R2980 VSS.n634 VSS.n54 3.33079
R2981 VSS.n54 VSS.n633 3.33079
R2982 VSS.n632 VSS.n54 3.33079
R2983 VSS.n54 VSS.n631 3.33079
R2984 VSS.n630 VSS.n54 3.33079
R2985 VSS.n54 VSS.n629 3.33079
R2986 VSS.n628 VSS.n54 3.33079
R2987 VSS.n54 VSS.n627 3.33079
R2988 VSS.n626 VSS.n54 3.33079
R2989 VSS.n54 VSS.n625 3.33079
R2990 VSS.n624 VSS.n54 3.33079
R2991 VSS.n622 VSS.n54 3.33079
R2992 VSS.n54 VSS.n621 3.33079
R2993 VSS.n620 VSS.n54 3.33079
R2994 VSS.n54 VSS.n619 3.33079
R2995 VSS.n618 VSS.n54 3.33079
R2996 VSS.n54 VSS.n617 3.33079
R2997 VSS.n616 VSS.n54 3.33079
R2998 VSS.n54 VSS.n615 3.33079
R2999 VSS.n614 VSS.n54 3.33079
R3000 VSS.n54 VSS.n613 3.33079
R3001 VSS.n612 VSS.n54 3.33079
R3002 VSS.n54 VSS.n611 3.33079
R3003 VSS.n610 VSS.n54 3.33079
R3004 VSS.n54 VSS.n609 3.33079
R3005 VSS.n608 VSS.n54 3.33079
R3006 VSS.n54 VSS.n607 3.33079
R3007 VSS.n606 VSS.n54 3.33079
R3008 VSS.n54 VSS.n605 3.33079
R3009 VSS.n604 VSS.n54 3.33079
R3010 VSS.n54 VSS.n603 3.33079
R3011 VSS.n602 VSS.n54 3.33079
R3012 VSS.n54 VSS.n601 3.33079
R3013 VSS.n600 VSS.n54 3.33079
R3014 VSS.n599 VSS.n54 3.33079
R3015 VSS.n598 VSS.n54 3.33079
R3016 VSS.n597 VSS.n54 3.33079
R3017 VSS.n596 VSS.n54 3.33079
R3018 VSS.t890 VSS.n595 0.0863258
R3019 VSS.t302 VSS.n655 3.33
R3020 VSS.t302 VSS.n657 3.33079
R3021 VSS.t302 VSS.n656 3.33087
R3022 VSS.n654 VSS.t302 3.33087
R3023 VSS.t302 VSS.n653 3.33079
R3024 VSS.n651 VSS.t816 0.0863258
R3025 VSS.t302 VSS.t756 5.61485
R3026 VSS.t302 VSS.n658 3.33079
R3027 VSS.t33 VSS.n268 3.30696
R3028 VSS.t31 VSS.n271 0.118323
R3029 VSS.t78 VSS.n189 0.339658
R3030 VSS.n189 VSS.t33 1.72295
R3031 VSS.n250 VSS.t33 1.97612
R3032 VSS.t33 VSS.n692 3.33079
R3033 VSS.t33 VSS.n691 3.33079
R3034 VSS.t33 VSS.n690 3.33079
R3035 VSS.t33 VSS.n689 3.33079
R3036 VSS.t33 VSS.n686 3.33079
R3037 VSS.t33 VSS.n685 3.33079
R3038 VSS.t33 VSS.n684 3.33079
R3039 VSS.t33 VSS.n683 3.33079
R3040 VSS.t33 VSS.n682 3.33079
R3041 VSS.t33 VSS.n681 3.33079
R3042 VSS.t33 VSS.n680 3.33079
R3043 VSS.t33 VSS.n679 3.33079
R3044 VSS.t33 VSS.n678 3.33079
R3045 VSS.n149 VSS.t33 0.854305
R3046 VSS.t33 VSS.n270 2.33234
R3047 VSS.n695 VSS.t33 3.33079
R3048 VSS.n702 VSS.t625 0.0863258
R3049 VSS.t566 VSS.n700 0.0863258
R3050 VSS.n857 VSS.t38 4.29849
R3051 VSS.n876 VSS.t292 4.28621
R3052 VSS.n693 VSS.t33 3.36082
R3053 VSS.t33 VSS.t43 4.2505
R3054 VSS.n55 VSS.t2500 4.20259
R3055 VSS.n56 VSS.t2108 4.20259
R3056 VSS.t1716 VSS.n57 4.20259
R3057 VSS.n54 VSS.t1032 4.20259
R3058 VSS.t224 VSS.n778 3.50108
R3059 VSS.t4 VSS.n778 3.50108
R3060 VSS.n134 VSS.t356 0.15935
R3061 VSS.t302 VSS.n652 2.31523
R3062 VSS.t302 VSS.n674 2.31585
R3063 VSS.t302 VSS.n673 2.31585
R3064 VSS.t302 VSS.n672 2.31585
R3065 VSS.t302 VSS.n671 2.31585
R3066 VSS.t302 VSS.n669 2.31585
R3067 VSS.t302 VSS.n668 2.31585
R3068 VSS.t302 VSS.n667 2.31585
R3069 VSS.t302 VSS.n666 2.31585
R3070 VSS.t302 VSS.n665 2.31585
R3071 VSS.t302 VSS.n664 2.31585
R3072 VSS.t302 VSS.n663 2.31585
R3073 VSS.t302 VSS.n662 2.31585
R3074 VSS.t302 VSS.n661 2.31585
R3075 VSS.t302 VSS.n660 2.31585
R3076 VSS.t302 VSS.n659 2.31573
R3077 VSS.t3 VSS.n850 2.59384
R3078 VSS.t3 VSS.n794 2.59384
R3079 VSS.t3 VSS.n795 2.59384
R3080 VSS.t3 VSS.n809 2.59384
R3081 VSS.n178 VSS.t3 0.0643469
R3082 VSS.t3 VSS.n215 0.405951
R3083 VSS.t3 VSS.n801 2.59384
R3084 VSS.t3 VSS.n802 2.59384
R3085 VSS.t3 VSS.n253 0.405951
R3086 VSS.t513 VSS.n378 0.531244
R3087 VSS.n800 VSS.t3 2.29778
R3088 VSS.t302 VSS.n676 1.73657
R3089 VSS.n697 VSS.t246 0.0922815
R3090 VSS.t33 VSS.n778 1.88939
R3091 VSS.t25 VSS.t9 1.37665
R3092 VSS.t302 VSS.t393 1.35824
R3093 VSS.t25 VSS.t33 0.739618
R3094 VSS.t33 VSS.t255 1.06748
R3095 VSS.t33 VSS.n701 0.991912
R3096 VSS.t142 VSS.n149 0.0342296
R3097 VSS.n131 VSS.t82 0.350654
R3098 VSS.n134 VSS.t302 0.739058
R3099 VSS.t695 VSS.t302 0.341734
R3100 VSS.t158 VSS.t547 1.1135
R3101 VSS.t454 VSS.t271 1.1131
R3102 VSS.t131 VSS.t475 1.111
R3103 VSS.t460 VSS.t465 1.10982
R3104 VSS.t202 VSS.t88 1.10263
R3105 VSS.t106 VSS.t33 1.10098
R3106 VSS.t33 VSS.n749 1.08179
R3107 VSS.t33 VSS.n703 0.889835
R3108 VSS.t35 VSS.t100 1.07052
R3109 VSS.n741 VSS.t720 1.05022
R3110 VSS.t147 VSS.n704 0.042434
R3111 VSS.t27 VSS.t715 1.02913
R3112 VSS.t117 VSS.t1 1.02354
R3113 VSS.t183 VSS.t14 1.02116
R3114 VSS.t480 VSS.t150 1.02018
R3115 VSS.t1 VSS.n373 0.0536702
R3116 VSS.t720 VSS.t183 1.01648
R3117 VSS.n698 VSS.t127 0.0566061
R3118 VSS.t127 VSS.t24 1.00916
R3119 VSS.t214 VSS.t551 1.00185
R3120 VSS.t287 VSS.n269 1.04169
R3121 VSS.t63 VSS.n696 0.995711
R3122 VSS.t465 VSS.t131 0.928205
R3123 VSS.t50 VSS.n696 0.771979
R3124 VSS.t547 VSS.t551 0.919999
R3125 VSS.t302 VSS.t700 0.356274
R3126 VSS.t150 VSS.t134 0.903814
R3127 VSS.t19 VSS.n694 0.752903
R3128 VSS.t33 VSS.t202 0.882295
R3129 VSS.t134 VSS.n369 0.059721
R3130 VSS.t19 VSS.t164 0.876684
R3131 VSS.n131 VSS.t164 0.244215
R3132 VSS.t30 VSS.t28 0.829229
R3133 VSS.t562 VSS.t214 0.815879
R3134 VSS.t449 VSS.n793 0.806717
R3135 VSS.t33 VSS.n269 0.663402
R3136 VSS.t33 VSS.n131 0.329317
R3137 VSS.n377 VSS.t513 0.666026
R3138 VSS.t24 VSS.t202 0.781136
R3139 VSS.n377 VSS.t90 1.07725
R3140 VSS.n703 VSS.t95 0.0801996
R3141 VSS.n749 VSS.t97 0.7487
R3142 VSS.t95 VSS.t106 0.74696
R3143 VSS.t189 VSS.n701 0.0822487
R3144 VSS.t22 VSS.n694 1.00067
R3145 VSS.t3 VSS.n369 0.569247
R3146 VSS.t302 VSS.n79 0.666899
R3147 VSS.t302 VSS.n137 3.41984
R3148 VSS.t302 VSS.n83 0.666899
R3149 VSS.t33 VSS.n129 0.666899
R3150 VSS.t33 VSS.n127 0.666899
R3151 VSS.t33 VSS.n126 0.666899
R3152 VSS.t33 VSS.n124 0.666899
R3153 VSS.t33 VSS.n121 0.666899
R3154 VSS.t33 VSS.n123 0.666899
R3155 VSS.t33 VSS.n107 0.666899
R3156 VSS.t33 VSS.n104 0.666899
R3157 VSS.t33 VSS.n130 0.655024
R3158 VSS.t302 VSS.n75 0.649813
R3159 VSS.t302 VSS.n77 0.649813
R3160 VSS.t302 VSS.n76 0.649813
R3161 VSS.t302 VSS.n78 0.649813
R3162 VSS.n917 VSS.t302 0.649813
R3163 VSS.t302 VSS.n81 0.649813
R3164 VSS.t302 VSS.n80 0.649813
R3165 VSS.t302 VSS.n84 0.649813
R3166 VSS.t302 VSS.n102 0.649813
R3167 VSS.t302 VSS.n103 0.649813
R3168 VSS.t302 VSS.n101 0.649813
R3169 VSS.t302 VSS.n100 0.649813
R3170 VSS.t302 VSS.n65 0.649813
R3171 VSS.t302 VSS.n66 0.649813
R3172 VSS.t302 VSS.n64 0.649813
R3173 VSS.t302 VSS.n63 0.649813
R3174 VSS.t302 VSS.n60 0.649813
R3175 VSS.t302 VSS.n59 0.649813
R3176 VSS.t302 VSS.n61 0.649813
R3177 VSS.t302 VSS.n62 0.649813
R3178 VSS.t302 VSS.n68 0.649813
R3179 VSS.t302 VSS.n67 0.649813
R3180 VSS.t302 VSS.n69 0.649813
R3181 VSS.t302 VSS.n70 0.649813
R3182 VSS.t302 VSS.n73 0.649813
R3183 VSS.t302 VSS.n74 0.649813
R3184 VSS.t302 VSS.n72 0.649813
R3185 VSS.t302 VSS.n71 0.649813
R3186 VSS.t302 VSS.n93 0.649813
R3187 VSS.t302 VSS.n92 0.649813
R3188 VSS.t302 VSS.n94 0.649813
R3189 VSS.t302 VSS.n95 0.649813
R3190 VSS.t302 VSS.n98 0.649813
R3191 VSS.t302 VSS.n99 0.649813
R3192 VSS.t302 VSS.n97 0.649813
R3193 VSS.t302 VSS.n96 0.649813
R3194 VSS.t302 VSS.n90 0.649813
R3195 VSS.t302 VSS.n91 0.649813
R3196 VSS.t302 VSS.n89 0.649813
R3197 VSS.n160 VSS.t302 1.11651
R3198 VSS.t302 VSS.n85 0.649813
R3199 VSS.t302 VSS.n86 0.649813
R3200 VSS.t302 VSS.n87 0.649813
R3201 VSS.t302 VSS.n88 0.649813
R3202 VSS.t33 VSS.n122 0.649813
R3203 VSS.t33 VSS.n119 0.649813
R3204 VSS.t33 VSS.n118 0.649813
R3205 VSS.t33 VSS.n120 0.649813
R3206 VSS.n866 VSS.t33 0.649813
R3207 VSS.n166 VSS.t33 2.91846
R3208 VSS.t33 VSS.n106 0.649813
R3209 VSS.t33 VSS.n105 0.649813
R3210 VSS.n793 VSS.t454 0.648185
R3211 VSS.t302 VSS.n82 0.648101
R3212 VSS.t33 VSS.n128 0.648101
R3213 VSS.t33 VSS.n125 0.648101
R3214 VSS.t33 VSS.n117 0.648101
R3215 VSS.t33 VSS.n116 0.648101
R3216 VSS.t33 VSS.n108 0.648101
R3217 VSS.t33 VSS.n115 0.648101
R3218 VSS.t33 VSS.n114 0.648101
R3219 VSS.t33 VSS.n113 0.648101
R3220 VSS.t33 VSS.n109 0.648101
R3221 VSS.t33 VSS.n110 0.648101
R3222 VSS.t33 VSS.n112 0.648101
R3223 VSS.t33 VSS.n111 0.648101
R3224 VSS.t393 VSS.t384 0.640136
R3225 VSS.t271 VSS.t460 0.611475
R3226 VSS.t189 VSS.t40 0.600657
R3227 VSS.t33 VSS.n698 0.467051
R3228 VSS.t393 VSS.t398 0.533029
R3229 VSS.t3 VSS.n373 0.440816
R3230 VSS.t3 VSS.t271 0.508724
R3231 VSS.t63 VSS.n697 0.393758
R3232 VSS.t302 VSS.t183 0.504946
R3233 VSS.t246 VSS.t16 0.499392
R3234 VSS.t302 VSS.n741 0.462435
R3235 VSS.t124 VSS.n378 0.345153
R3236 VSS.t243 VSS.n676 0.54843
R3237 VSS.t12 VSS.n800 0.452661
R3238 VSS.n749 VSS.t88 0.419152
R3239 VSS.t3 VSS.n793 0.40979
R3240 VSS.t3 VSS.n3 0.219075
R3241 VSS.t437 VSS.n133 47.2102
R3242 VSS.t442 VSS.n132 26.1049
R3243 VSS.t3 VSS.n30 0.225187
R3244 VSS.t3 VSS.n5 0.405951
R3245 VSS.t3 VSS.n28 0.219075
R3246 VSS.t3 VSS.n27 0.405951
R3247 VSS.t3 VSS.n6 0.405951
R3248 VSS.t3 VSS.n25 0.405951
R3249 VSS.t3 VSS.n8 0.405951
R3250 VSS.t3 VSS.n23 0.405951
R3251 VSS.t3 VSS.n10 0.405951
R3252 VSS.n162 VSS.t469 47.2101
R3253 VSS.t3 VSS.n21 0.405951
R3254 VSS.t3 VSS.n11 0.405951
R3255 VSS.t3 VSS.n19 0.405951
R3256 VSS.t3 VSS.n13 0.405951
R3257 VSS.n164 VSS.t479 47.2101
R3258 VSS.t3 VSS.n17 0.405951
R3259 VSS.t3 VSS.n31 0.219019
R3260 VSS.t3 VSS.n36 0.405951
R3261 VSS.t3 VSS.n34 0.405951
R3262 VSS.t3 VSS.n32 0.405951
R3263 VSS.t3 VSS.n37 0.405951
R3264 VSS.t3 VSS.n38 0.405951
R3265 VSS.t3 VSS.n42 0.405951
R3266 VSS.t3 VSS.n41 0.405951
R3267 VSS.t3 VSS.n39 0.405951
R3268 VSS.t3 VSS.n40 0.405951
R3269 VSS.n140 VSS.t3 0.219019
R3270 VSS.t3 VSS.n2 0.121819
R3271 VSS.t3 VSS.n43 0.405951
R3272 VSS.t3 VSS.n52 0.405951
R3273 VSS.t3 VSS.n45 0.405951
R3274 VSS.t3 VSS.n50 0.405951
R3275 VSS.n154 VSS.t553 47.2102
R3276 VSS.t3 VSS.n48 0.219075
R3277 VSS.t3 VSS.n49 0.405951
R3278 VSS.n165 VSS.t560 47.2101
R3279 VSS.n704 VSS.t3 0.338438
R3280 VSS.t2824 VSS.n184 0.175714
R3281 VSS.t2813 VSS.t2814 0.36115
R3282 VSS.t2772 VSS.t2773 0.36115
R3283 VSS.t2778 VSS.t2779 0.36115
R3284 VSS.t2784 VSS.n223 0.175714
R3285 VSS.t2790 VSS.n246 0.175714
R3286 VSS.t2796 VSS.t2797 0.36115
R3287 VSS.t2801 VSS.t2802 0.36115
R3288 VSS.t2806 VSS.t2807 0.36115
R3289 VSS.t2819 VSS.t2820 0.36115
R3290 VSS.t2881 VSS.t2882 0.36115
R3291 VSS.t2873 VSS.t2874 0.36115
R3292 VSS.t2865 VSS.t2866 0.36115
R3293 VSS.t2857 VSS.t2858 0.36115
R3294 VSS.t2849 VSS.t2850 0.36115
R3295 VSS.t2841 VSS.t2842 0.36115
R3296 VSS.t1369 VSS.n208 0.175714
R3297 VSS.n189 VSS.t181 0.340149
R3298 VSS.t2755 VSS.t2756 0.360811
R3299 VSS.t2761 VSS.t2762 0.360811
R3300 VSS.t2767 VSS.n224 0.175554
R3301 VSS.t2773 VSS.n244 0.175554
R3302 VSS.t2779 VSS.n245 0.175554
R3303 VSS.t2785 VSS.t2786 0.360811
R3304 VSS.t2791 VSS.t2792 0.360811
R3305 VSS.t2820 VSS.t2821 0.360811
R3306 VSS.t181 VSS.n250 0.646802
R3307 VSS.t1379 VSS.t1381 0.360811
R3308 VSS.t1370 VSS.t1372 0.360811
R3309 VSS.t2824 VSS.t2823 0.360811
R3310 VSS.t2815 VSS.t2816 0.360811
R3311 VSS.t2810 VSS.t2811 0.360811
R3312 VSS.t2805 VSS.n248 0.175554
R3313 VSS.t2800 VSS.n247 0.175554
R3314 VSS.t2795 VSS.n222 0.175554
R3315 VSS.t2789 VSS.t2790 0.360811
R3316 VSS.t2759 VSS.t2758 0.360811
R3317 VSS.t2753 VSS.t2752 0.360811
R3318 VSS.t2879 VSS.t2878 0.360471
R3319 VSS.t2871 VSS.t2870 0.360471
R3320 VSS.t2863 VSS.t2862 0.360471
R3321 VSS.t2855 VSS.t2854 0.360471
R3322 VSS.t2847 VSS.t2846 0.360471
R3323 VSS.t2839 VSS.t2838 0.360471
R3324 VSS.t1385 VSS.t1384 0.360471
R3325 VSS.n227 VSS.t2823 0.175395
R3326 VSS.t2814 VSS.n249 0.175395
R3327 VSS.t2809 VSS.n221 0.175395
R3328 VSS.t2804 VSS.t2805 0.360471
R3329 VSS.t2799 VSS.t2800 0.360471
R3330 VSS.t2780 VSS.t2782 0.360471
R3331 VSS.t2774 VSS.t2776 0.360471
R3332 VSS.t2768 VSS.t2770 0.360471
R3333 VSS.t2762 VSS.n243 0.175395
R3334 VSS.t2756 VSS.n242 0.175395
R3335 VSS.t2751 VSS.n187 0.175395
R3336 VSS.t2893 VSS.t2892 0.360471
R3337 VSS.t373 VSS.t819 0.344973
R3338 VSS.t766 VSS.n673 0.433869
R3339 VSS.t763 VSS.n672 0.433869
R3340 VSS.t760 VSS.n671 0.433869
R3341 VSS.n660 VSS.t725 0.433869
R3342 VSS.n661 VSS.t728 0.433869
R3343 VSS.n662 VSS.t731 0.433869
R3344 VSS.n663 VSS.t734 0.433869
R3345 VSS.n664 VSS.t737 0.433869
R3346 VSS.n665 VSS.t740 0.433869
R3347 VSS.n666 VSS.t743 0.433869
R3348 VSS.n667 VSS.t746 0.433869
R3349 VSS.n668 VSS.t749 0.433869
R3350 VSS.n669 VSS.t752 0.433869
R3351 VSS.n659 VSS.t407 0.433862
R3352 VSS.t819 VSS.n652 0.0931939
R3353 VSS.t769 VSS.n674 0.422619
R3354 VSS.t356 VSS.t18 0.312745
R3355 VSS.n318 VSS.t3050 0.0850573
R3356 VSS.t2798 VSS.t2799 0.301114
R3357 VSS.t2803 VSS.t2804 0.301114
R3358 VSS.t2808 VSS.t2809 0.301114
R3359 VSS.t3008 VSS.n286 0.17801
R3360 VSS.t3001 VSS.n288 0.17801
R3361 VSS.t2994 VSS.n290 0.17801
R3362 VSS.t2987 VSS.n292 0.17801
R3363 VSS.t2980 VSS.n294 0.17801
R3364 VSS.t2973 VSS.n296 0.17801
R3365 VSS.n386 VSS.t2836 0.118323
R3366 VSS.t1473 VSS.t1319 0.301114
R3367 VSS.t1347 VSS.t1348 0.301114
R3368 VSS.t1300 VSS.t1301 0.301114
R3369 VSS.n581 VSS.t1442 0.17801
R3370 VSS.n575 VSS.t1419 0.118323
R3371 VSS.t1409 VSS.t1410 0.301114
R3372 VSS.n568 VSS.t1396 0.118323
R3373 VSS.t2759 VSS.n309 0.118323
R3374 VSS.t2753 VSS.n261 0.118323
R3375 VSS.n393 VSS.t2898 0.118323
R3376 VSS.n301 VSS.t2889 0.17801
R3377 VSS.t2754 VSS.t2755 0.301114
R3378 VSS.t2760 VSS.t2761 0.301114
R3379 VSS.t2766 VSS.t2767 0.301114
R3380 VSS.n285 VSS.t2886 0.118323
R3381 VSS.t2811 VSS.n265 0.118323
R3382 VSS.t2816 VSS.n302 0.118323
R3383 VSS.t2879 VSS.t2880 0.301114
R3384 VSS.n287 VSS.t2878 0.118323
R3385 VSS.t2871 VSS.t2872 0.301114
R3386 VSS.n289 VSS.t2870 0.118323
R3387 VSS.t2863 VSS.t2864 0.301114
R3388 VSS.n291 VSS.t2862 0.118323
R3389 VSS.t2855 VSS.t2856 0.301114
R3390 VSS.n293 VSS.t2854 0.118323
R3391 VSS.t2847 VSS.t2848 0.301114
R3392 VSS.n295 VSS.t2846 0.118323
R3393 VSS.t2839 VSS.t2840 0.301114
R3394 VSS.n297 VSS.t2838 0.118323
R3395 VSS.n203 VSS.t2833 0.17801
R3396 VSS.t2829 VSS.n385 0.17801
R3397 VSS.t1286 VSS.t1287 0.301114
R3398 VSS.t137 VSS.n271 0.478624
R3399 VSS.n207 VSS.t78 0.420219
R3400 VSS.t1333 VSS.t1334 0.301114
R3401 VSS.t1313 VSS.t1314 0.301114
R3402 VSS.n258 VSS.t1361 0.17801
R3403 VSS.t1353 VSS.t1354 0.301114
R3404 VSS.t1341 VSS.t1342 0.301114
R3405 VSS.t1329 VSS.t1328 0.301114
R3406 VSS.t1326 VSS.t1325 0.301114
R3407 VSS.t1306 VSS.t1307 0.301114
R3408 VSS.n190 VSS.t1295 0.17801
R3409 VSS.t1436 VSS.n579 0.17801
R3410 VSS.t1424 VSS.n281 0.118323
R3411 VSS.n266 VSS.t1431 0.17801
R3412 VSS.n283 VSS.t1416 0.17801
R3413 VSS.t1404 VSS.n572 0.17801
R3414 VSS.n567 VSS.t1393 0.118323
R3415 VSS.n191 VSS.t1389 0.17801
R3416 VSS.t1385 VSS.t1386 0.301114
R3417 VSS.n565 VSS.t1384 0.118323
R3418 VSS.t1378 VSS.t1379 0.301114
R3419 VSS.n260 VSS.t1375 0.17801
R3420 VSS.n306 VSS.t2782 0.118323
R3421 VSS.n307 VSS.t2776 0.118323
R3422 VSS.n262 VSS.t2770 0.118323
R3423 VSS.t2750 VSS.t2751 0.301114
R3424 VSS.t2899 VSS.n267 0.17801
R3425 VSS.t2893 VSS.t2894 0.301114
R3426 VSS.n284 VSS.t2892 0.118323
R3427 VSS.t2797 VSS.n264 0.118193
R3428 VSS.t2802 VSS.n304 0.118193
R3429 VSS.t2807 VSS.n303 0.118193
R3430 VSS.t2886 VSS.t2887 0.300775
R3431 VSS.t2884 VSS.t2885 0.300775
R3432 VSS.t2882 VSS.t3008 0.300775
R3433 VSS.n392 VSS.t2880 0.177814
R3434 VSS.t2876 VSS.t2877 0.300775
R3435 VSS.t2874 VSS.t3001 0.300775
R3436 VSS.n391 VSS.t2872 0.177814
R3437 VSS.t2868 VSS.t2869 0.300775
R3438 VSS.t2866 VSS.t2994 0.300775
R3439 VSS.n390 VSS.t2864 0.177814
R3440 VSS.t2860 VSS.t2861 0.300775
R3441 VSS.t2858 VSS.t2987 0.300775
R3442 VSS.n389 VSS.t2856 0.177814
R3443 VSS.t2852 VSS.t2853 0.300775
R3444 VSS.t2850 VSS.t2980 0.300775
R3445 VSS.n388 VSS.t2848 0.177814
R3446 VSS.t2844 VSS.t2845 0.300775
R3447 VSS.t2842 VSS.t2973 0.300775
R3448 VSS.n387 VSS.t2840 0.177814
R3449 VSS.t2836 VSS.t2837 0.300775
R3450 VSS.t2831 VSS.t2832 0.300775
R3451 VSS.t2830 VSS.t2831 0.300775
R3452 VSS.t1287 VSS.t1288 0.300775
R3453 VSS.n250 VSS.t137 0.286827
R3454 VSS.t2786 VSS.n263 0.118193
R3455 VSS.t2792 VSS.n305 0.118193
R3456 VSS.t2825 VSS.t2826 0.300775
R3457 VSS.n268 VSS.t29 0.118193
R3458 VSS.t1334 VSS.t1335 0.300775
R3459 VSS.t1359 VSS.t1360 0.300775
R3460 VSS.t1307 VSS.t1308 0.300775
R3461 VSS.t1319 VSS.t1320 0.300775
R3462 VSS.t1354 VSS.t1355 0.300775
R3463 VSS.t1346 VSS.t1347 0.300775
R3464 VSS.t1340 VSS.t1341 0.300775
R3465 VSS.t1327 VSS.t1328 0.300775
R3466 VSS.t1324 VSS.t1325 0.300775
R3467 VSS.t1312 VSS.t1313 0.300775
R3468 VSS.t1299 VSS.t1300 0.300775
R3469 VSS.t1293 VSS.t1294 0.300775
R3470 VSS.t1281 VSS.t1282 0.300775
R3471 VSS.t1364 VSS.n217 0.328518
R3472 VSS.t1441 VSS.t1440 0.300775
R3473 VSS.t1437 VSS.t1568 0.300775
R3474 VSS.t1428 VSS.t1427 0.300775
R3475 VSS.t1424 VSS.t1423 0.300775
R3476 VSS.t1419 VSS.t1420 0.300775
R3477 VSS.t1414 VSS.t1415 0.300775
R3478 VSS.t1409 VSS.t1408 0.300775
R3479 VSS.t1405 VSS.t1542 0.300775
R3480 VSS.t1396 VSS.t1397 0.300775
R3481 VSS.t1393 VSS.t1394 0.300775
R3482 VSS.t1388 VSS.t1387 0.300775
R3483 VSS.n211 VSS.t1382 0.177814
R3484 VSS.t1373 VSS.t1374 0.300775
R3485 VSS.n177 VSS.t1373 0.177814
R3486 VSS.t1369 VSS.t1368 0.300775
R3487 VSS.t1361 VSS.t1362 0.300775
R3488 VSS.n206 VSS.t2819 0.118193
R3489 VSS.t2812 VSS.t2813 0.300775
R3490 VSS.t2794 VSS.t2795 0.300775
R3491 VSS.t2788 VSS.t2789 0.300775
R3492 VSS.t2783 VSS.t2784 0.300775
R3493 VSS.t2777 VSS.t2778 0.300775
R3494 VSS.t2771 VSS.t2772 0.300775
R3495 VSS.t2900 VSS.t2901 0.300775
R3496 VSS.t2898 VSS.t2899 0.300775
R3497 VSS.t2890 VSS.t2891 0.300775
R3498 VSS.t31 VSS.t574 0.298292
R3499 VSS.n186 VSS.t378 0.160301
R3500 VSS.n183 VSS.t2902 0.0997889
R3501 VSS.t574 VSS.t29 0.242478
R3502 VSS.t2914 VSS.n308 0.119605
R3503 VSS.t2959 VSS.t2827 0.241078
R3504 VSS.n594 VSS.t1286 0.119605
R3505 VSS.n201 VSS.t1289 0.119605
R3506 VSS.t1457 VSS.t1298 0.241078
R3507 VSS.n238 VSS.t1310 0.119605
R3508 VSS.t1476 VSS.t1321 0.241078
R3509 VSS.n586 VSS.t1333 0.119605
R3510 VSS.n195 VSS.t1336 0.119605
R3511 VSS.t1494 VSS.t1345 0.241078
R3512 VSS.n231 VSS.t1357 0.119605
R3513 VSS.t1365 VSS.t1366 0.241078
R3514 VSS.n564 VSS.t1378 0.119605
R3515 VSS.t1534 VSS.n569 0.119605
R3516 VSS.t1539 VSS.t1404 0.241078
R3517 VSS.t1542 VSS.t1407 0.241078
R3518 VSS.t1554 VSS.n576 0.119605
R3519 VSS.t1565 VSS.t1436 0.241078
R3520 VSS.t1568 VSS.t1439 0.241078
R3521 VSS.t255 VSS.t143 0.241078
R3522 VSS.t2835 VSS.t2966 0.241078
R3523 VSS.n298 VSS.t2835 0.119605
R3524 VSS.t2833 VSS.t2834 0.241078
R3525 VSS.t1289 VSS.t1290 0.241078
R3526 VSS.n394 VSS.t2750 0.119605
R3527 VSS.n181 VSS.t3012 0.119605
R3528 VSS.t143 VSS.n207 0.119605
R3529 VSS.t6 VSS.t10 0.241078
R3530 VSS.n592 VSS.t1299 0.119605
R3531 VSS.n200 VSS.t1302 0.119605
R3532 VSS.t1310 VSS.t1311 0.241078
R3533 VSS.n236 VSS.t1322 0.119605
R3534 VSS.t1336 VSS.t1337 0.241078
R3535 VSS.n584 VSS.t1346 0.119605
R3536 VSS.n193 VSS.t1349 0.119605
R3537 VSS.t1357 VSS.t1358 0.241078
R3538 VSS.n582 VSS.t1359 0.119605
R3539 VSS.t1356 VSS.t1503 0.241078
R3540 VSS.n192 VSS.t1356 0.119605
R3541 VSS.n583 VSS.t1353 0.119605
R3542 VSS.t1351 VSS.t1352 0.241078
R3543 VSS.t1349 VSS.t1350 0.241078
R3544 VSS.n232 VSS.t1351 0.119605
R3545 VSS.n233 VSS.t1494 0.119605
R3546 VSS.t1343 VSS.t1344 0.241078
R3547 VSS.n194 VSS.t1343 0.119605
R3548 VSS.n585 VSS.t1340 0.119605
R3549 VSS.n234 VSS.t1338 0.119605
R3550 VSS.t1338 VSS.t1339 0.241078
R3551 VSS.t1332 VSS.t1485 0.241078
R3552 VSS.n235 VSS.t1332 0.119605
R3553 VSS.t1330 VSS.t1331 0.241078
R3554 VSS.n196 VSS.t1330 0.119605
R3555 VSS.n587 VSS.t1327 0.119605
R3556 VSS.t1322 VSS.t1323 0.241078
R3557 VSS.n588 VSS.t1324 0.119605
R3558 VSS.n197 VSS.t1476 0.119605
R3559 VSS.n589 VSS.t1473 0.119605
R3560 VSS.t1317 VSS.t1318 0.241078
R3561 VSS.n237 VSS.t1317 0.119605
R3562 VSS.n198 VSS.t1315 0.119605
R3563 VSS.t1315 VSS.t1316 0.241078
R3564 VSS.n590 VSS.t1312 0.119605
R3565 VSS.t1309 VSS.t1466 0.241078
R3566 VSS.n199 VSS.t1309 0.119605
R3567 VSS.n591 VSS.t1306 0.119605
R3568 VSS.t1304 VSS.t1305 0.241078
R3569 VSS.t1302 VSS.t1303 0.241078
R3570 VSS.n239 VSS.t1304 0.119605
R3571 VSS.n218 VSS.t1456 0.119605
R3572 VSS.t1295 VSS.t1296 0.241078
R3573 VSS.n593 VSS.t1293 0.119605
R3574 VSS.n240 VSS.t1291 0.119605
R3575 VSS.t1291 VSS.t1292 0.241078
R3576 VSS.t1285 VSS.t1448 0.241078
R3577 VSS.n241 VSS.t1285 0.119605
R3578 VSS.t1283 VSS.t1284 0.241078
R3579 VSS.n202 VSS.t1283 0.119605
R3580 VSS.t1366 VSS.n563 0.119605
R3581 VSS.t1398 VSS.t1399 0.241078
R3582 VSS.n573 VSS.t1408 0.119605
R3583 VSS.n220 VSS.t1411 0.119605
R3584 VSS.t1421 VSS.t1422 0.241078
R3585 VSS.n580 VSS.t1440 0.119605
R3586 VSS.t1442 VSS.t1443 0.241078
R3587 VSS.t1435 VSS.t1565 0.241078
R3588 VSS.n578 VSS.t1435 0.119605
R3589 VSS.t1433 VSS.t1434 0.241078
R3590 VSS.t1431 VSS.t1432 0.241078
R3591 VSS.t1432 VSS.n219 0.119605
R3592 VSS.t1425 VSS.t1426 0.241078
R3593 VSS.n577 VSS.t1427 0.119605
R3594 VSS.t1422 VSS.n282 0.119605
R3595 VSS.t1420 VSS.t1554 0.241078
R3596 VSS.t1418 VSS.t1551 0.241078
R3597 VSS.n230 VSS.t1418 0.119605
R3598 VSS.t1416 VSS.t1417 0.241078
R3599 VSS.t1413 VSS.t1414 0.241078
R3600 VSS.t1411 VSS.t1412 0.241078
R3601 VSS.n574 VSS.t1413 0.119605
R3602 VSS.t1403 VSS.t1539 0.241078
R3603 VSS.n571 VSS.t1403 0.119605
R3604 VSS.t1401 VSS.t1402 0.241078
R3605 VSS.t1399 VSS.t1400 0.241078
R3606 VSS.t1400 VSS.n570 0.119605
R3607 VSS.t1397 VSS.t1534 0.241078
R3608 VSS.t1395 VSS.t1531 0.241078
R3609 VSS.n182 VSS.t1395 0.119605
R3610 VSS.t1391 VSS.t1392 0.241078
R3611 VSS.n229 VSS.t1391 0.119605
R3612 VSS.t1389 VSS.t1390 0.241078
R3613 VSS.n566 VSS.t1387 0.119605
R3614 VSS.t1382 VSS.t1383 0.241078
R3615 VSS.t1377 VSS.t1518 0.241078
R3616 VSS.t1376 VSS.n228 0.119605
R3617 VSS.t1375 VSS.t1376 0.241078
R3618 VSS.t1367 VSS.t1368 0.241078
R3619 VSS.n300 VSS.t2959 0.119605
R3620 VSS.t2817 VSS.t2818 0.241078
R3621 VSS.t2897 VSS.t3019 0.241078
R3622 VSS.n299 VSS.t2897 0.119605
R3623 VSS.t2895 VSS.t2896 0.241078
R3624 VSS.t2894 VSS.n204 0.119605
R3625 VSS.n259 VSS.t1560 0.179761
R3626 VSS.t2913 VSS.t2764 0.240825
R3627 VSS.t1430 VSS.n715 0.240486
R3628 VSS.t1716 VSS.t1714 0.233225
R3629 VSS.t1030 VSS.t1032 0.233225
R3630 VSS.t2106 VSS.t2108 0.233225
R3631 VSS.t2500 VSS.t2498 0.233225
R3632 VSS.n800 VSS.t90 0.232128
R3633 VSS.t178 VSS.t826 0.227075
R3634 VSS.t446 VSS.n706 0.135296
R3635 VSS.t441 VSS.n705 0.135296
R3636 VSS.n375 VSS.t507 0.135296
R3637 VSS.n376 VSS.t12 0.135296
R3638 VSS.n379 VSS.t517 0.135296
R3639 VSS.n380 VSS.t522 0.135296
R3640 VSS.n381 VSS.t527 0.135296
R3641 VSS.n382 VSS.t532 0.135296
R3642 VSS.n383 VSS.t537 0.135296
R3643 VSS.n384 VSS.t542 0.135296
R3644 VSS.n374 VSS.t502 0.135296
R3645 VSS.n371 VSS.t492 0.135296
R3646 VSS.n370 VSS.t487 0.135296
R3647 VSS.t27 VSS.t401 0.227075
R3648 VSS.t3025 VSS.t3027 0.226736
R3649 VSS.t3032 VSS.t3030 0.226736
R3650 VSS.t3035 VSS.t3037 0.226736
R3651 VSS.t3042 VSS.t3040 0.226736
R3652 VSS.t3045 VSS.t3047 0.226736
R3653 VSS.t3275 VSS.t3277 0.226736
R3654 VSS.t3282 VSS.t3280 0.226736
R3655 VSS.t3285 VSS.t3287 0.226736
R3656 VSS.t3292 VSS.t3290 0.226736
R3657 VSS.t3295 VSS.t3297 0.226736
R3658 VSS.t3302 VSS.t3300 0.226736
R3659 VSS.t3270 VSS.t3272 0.226736
R3660 VSS.t3265 VSS.t3267 0.226736
R3661 VSS.t3260 VSS.t3262 0.226736
R3662 VSS.t3255 VSS.t3257 0.226736
R3663 VSS.t3250 VSS.t3252 0.226736
R3664 VSS.t3245 VSS.t3247 0.226736
R3665 VSS.t3240 VSS.t3242 0.226736
R3666 VSS.t3235 VSS.t3237 0.226736
R3667 VSS.t3230 VSS.t3232 0.226736
R3668 VSS.t3225 VSS.t3227 0.226736
R3669 VSS.t3220 VSS.t3222 0.226736
R3670 VSS.t3215 VSS.t3217 0.226736
R3671 VSS.t3210 VSS.t3212 0.226736
R3672 VSS.t3205 VSS.t3207 0.226736
R3673 VSS.t3200 VSS.t3202 0.226736
R3674 VSS.t3195 VSS.t3197 0.226736
R3675 VSS.t3190 VSS.t3192 0.226736
R3676 VSS.t3185 VSS.t3187 0.226736
R3677 VSS.t3180 VSS.t3182 0.226736
R3678 VSS.t3175 VSS.t3177 0.226736
R3679 VSS.t3170 VSS.t3172 0.226736
R3680 VSS.t3160 VSS.t3162 0.226736
R3681 VSS.t3155 VSS.t3157 0.226736
R3682 VSS.t3150 VSS.t3152 0.226736
R3683 VSS.t3145 VSS.t3147 0.226736
R3684 VSS.t3140 VSS.t3142 0.226736
R3685 VSS.t3135 VSS.t3137 0.226736
R3686 VSS.t3130 VSS.t3132 0.226736
R3687 VSS.t3125 VSS.t3127 0.226736
R3688 VSS.t3120 VSS.t3122 0.226736
R3689 VSS.t3115 VSS.t3117 0.226736
R3690 VSS.t3110 VSS.t3112 0.226736
R3691 VSS.t3105 VSS.t3107 0.226736
R3692 VSS.t3100 VSS.t3102 0.226736
R3693 VSS.t3095 VSS.t3097 0.226736
R3694 VSS.t3090 VSS.t3092 0.226736
R3695 VSS.t3085 VSS.t3087 0.226736
R3696 VSS.t3080 VSS.t3082 0.226736
R3697 VSS.t3075 VSS.t3077 0.226736
R3698 VSS.t3070 VSS.t3072 0.226736
R3699 VSS.t3065 VSS.t3067 0.226736
R3700 VSS.t3060 VSS.t3062 0.226736
R3701 VSS.t3057 VSS.t3055 0.226736
R3702 VSS.t2360 VSS.t2358 0.226736
R3703 VSS.t2365 VSS.t2363 0.226736
R3704 VSS.t2370 VSS.t2368 0.226736
R3705 VSS.t2375 VSS.t2373 0.226736
R3706 VSS.t2380 VSS.t2378 0.226736
R3707 VSS.t2385 VSS.t2383 0.226736
R3708 VSS.t2390 VSS.t2388 0.226736
R3709 VSS.t2395 VSS.t2393 0.226736
R3710 VSS.t2400 VSS.t2398 0.226736
R3711 VSS.t2405 VSS.t2403 0.226736
R3712 VSS.t2410 VSS.t2408 0.226736
R3713 VSS.t2415 VSS.t2413 0.226736
R3714 VSS.t2420 VSS.t2418 0.226736
R3715 VSS.t2425 VSS.t2423 0.226736
R3716 VSS.t2430 VSS.t2428 0.226736
R3717 VSS.t2435 VSS.t2433 0.226736
R3718 VSS.t2440 VSS.t2438 0.226736
R3719 VSS.t2445 VSS.t2443 0.226736
R3720 VSS.t2450 VSS.t2448 0.226736
R3721 VSS.t2455 VSS.t2453 0.226736
R3722 VSS.t2460 VSS.t2458 0.226736
R3723 VSS.t2465 VSS.t2463 0.226736
R3724 VSS.t2470 VSS.t2468 0.226736
R3725 VSS.t2475 VSS.t2473 0.226736
R3726 VSS.t2480 VSS.t2478 0.226736
R3727 VSS.t2485 VSS.t2483 0.226736
R3728 VSS.t2490 VSS.t2488 0.226736
R3729 VSS.t2495 VSS.t2493 0.226736
R3730 VSS.t2503 VSS.t2505 0.226736
R3731 VSS.t2510 VSS.t2508 0.226736
R3732 VSS.t2513 VSS.t2515 0.226736
R3733 VSS.t2520 VSS.t2518 0.226736
R3734 VSS.t2523 VSS.t2525 0.226736
R3735 VSS.t2530 VSS.t2528 0.226736
R3736 VSS.t2533 VSS.t2535 0.226736
R3737 VSS.t2540 VSS.t2538 0.226736
R3738 VSS.t2543 VSS.t2545 0.226736
R3739 VSS.t2550 VSS.t2548 0.226736
R3740 VSS.t2553 VSS.t2555 0.226736
R3741 VSS.t2560 VSS.t2558 0.226736
R3742 VSS.t2563 VSS.t2565 0.226736
R3743 VSS.t2570 VSS.t2568 0.226736
R3744 VSS.t2573 VSS.t2575 0.226736
R3745 VSS.t2580 VSS.t2578 0.226736
R3746 VSS.t2583 VSS.t2585 0.226736
R3747 VSS.t2590 VSS.t2588 0.226736
R3748 VSS.t2593 VSS.t2595 0.226736
R3749 VSS.t2600 VSS.t2598 0.226736
R3750 VSS.t2603 VSS.t2605 0.226736
R3751 VSS.t2610 VSS.t2608 0.226736
R3752 VSS.t2613 VSS.t2615 0.226736
R3753 VSS.t2620 VSS.t2618 0.226736
R3754 VSS.t2623 VSS.t2625 0.226736
R3755 VSS.t2630 VSS.t2628 0.226736
R3756 VSS.t2633 VSS.t2635 0.226736
R3757 VSS.t1966 VSS.t1968 0.226736
R3758 VSS.t1973 VSS.t1971 0.226736
R3759 VSS.t1976 VSS.t1978 0.226736
R3760 VSS.t1983 VSS.t1981 0.226736
R3761 VSS.t1986 VSS.t1988 0.226736
R3762 VSS.t1993 VSS.t1991 0.226736
R3763 VSS.t1998 VSS.t1996 0.226736
R3764 VSS.t2001 VSS.t2003 0.226736
R3765 VSS.t2008 VSS.t2006 0.226736
R3766 VSS.t2011 VSS.t2013 0.226736
R3767 VSS.t2018 VSS.t2016 0.226736
R3768 VSS.t2021 VSS.t2023 0.226736
R3769 VSS.t2028 VSS.t2026 0.226736
R3770 VSS.t2031 VSS.t2033 0.226736
R3771 VSS.t2038 VSS.t2036 0.226736
R3772 VSS.t2041 VSS.t2043 0.226736
R3773 VSS.t2048 VSS.t2046 0.226736
R3774 VSS.t2051 VSS.t2053 0.226736
R3775 VSS.t2058 VSS.t2056 0.226736
R3776 VSS.t2061 VSS.t2063 0.226736
R3777 VSS.t2068 VSS.t2066 0.226736
R3778 VSS.t2071 VSS.t2073 0.226736
R3779 VSS.t2078 VSS.t2076 0.226736
R3780 VSS.t2081 VSS.t2083 0.226736
R3781 VSS.t2088 VSS.t2086 0.226736
R3782 VSS.t2091 VSS.t2093 0.226736
R3783 VSS.t2098 VSS.t2096 0.226736
R3784 VSS.t2101 VSS.t2103 0.226736
R3785 VSS.t2111 VSS.t2113 0.226736
R3786 VSS.t2118 VSS.t2116 0.226736
R3787 VSS.t2121 VSS.t2123 0.226736
R3788 VSS.t2128 VSS.t2126 0.226736
R3789 VSS.t2131 VSS.t2133 0.226736
R3790 VSS.t2138 VSS.t2136 0.226736
R3791 VSS.t2141 VSS.t2143 0.226736
R3792 VSS.t2148 VSS.t2146 0.226736
R3793 VSS.t2151 VSS.t2153 0.226736
R3794 VSS.t2158 VSS.t2156 0.226736
R3795 VSS.t2161 VSS.t2163 0.226736
R3796 VSS.t2168 VSS.t2166 0.226736
R3797 VSS.t2171 VSS.t2173 0.226736
R3798 VSS.t2178 VSS.t2176 0.226736
R3799 VSS.t2181 VSS.t2183 0.226736
R3800 VSS.t2188 VSS.t2186 0.226736
R3801 VSS.t2191 VSS.t2193 0.226736
R3802 VSS.t2198 VSS.t2196 0.226736
R3803 VSS.t2201 VSS.t2203 0.226736
R3804 VSS.t2208 VSS.t2206 0.226736
R3805 VSS.t2211 VSS.t2213 0.226736
R3806 VSS.t2218 VSS.t2216 0.226736
R3807 VSS.t2221 VSS.t2223 0.226736
R3808 VSS.t2228 VSS.t2226 0.226736
R3809 VSS.t2231 VSS.t2233 0.226736
R3810 VSS.t2238 VSS.t2236 0.226736
R3811 VSS.t2241 VSS.t2243 0.226736
R3812 VSS.t1574 VSS.t1576 0.226736
R3813 VSS.t1581 VSS.t1579 0.226736
R3814 VSS.t1584 VSS.t1586 0.226736
R3815 VSS.t1591 VSS.t1589 0.226736
R3816 VSS.t1594 VSS.t1596 0.226736
R3817 VSS.t1601 VSS.t1599 0.226736
R3818 VSS.t1604 VSS.t1606 0.226736
R3819 VSS.t1611 VSS.t1609 0.226736
R3820 VSS.t1614 VSS.t1616 0.226736
R3821 VSS.t1621 VSS.t1619 0.226736
R3822 VSS.t1624 VSS.t1626 0.226736
R3823 VSS.t1631 VSS.t1629 0.226736
R3824 VSS.t1634 VSS.t1636 0.226736
R3825 VSS.t1641 VSS.t1639 0.226736
R3826 VSS.t1644 VSS.t1646 0.226736
R3827 VSS.t1651 VSS.t1649 0.226736
R3828 VSS.t1654 VSS.t1656 0.226736
R3829 VSS.t1661 VSS.t1659 0.226736
R3830 VSS.t1664 VSS.t1666 0.226736
R3831 VSS.t1671 VSS.t1669 0.226736
R3832 VSS.t1674 VSS.t1676 0.226736
R3833 VSS.t1681 VSS.t1679 0.226736
R3834 VSS.t1684 VSS.t1686 0.226736
R3835 VSS.t1691 VSS.t1689 0.226736
R3836 VSS.t1694 VSS.t1696 0.226736
R3837 VSS.t1701 VSS.t1699 0.226736
R3838 VSS.t1704 VSS.t1706 0.226736
R3839 VSS.t1711 VSS.t1709 0.226736
R3840 VSS.t1721 VSS.t1719 0.226736
R3841 VSS.t1726 VSS.t1724 0.226736
R3842 VSS.t1731 VSS.t1729 0.226736
R3843 VSS.t1736 VSS.t1734 0.226736
R3844 VSS.t1741 VSS.t1739 0.226736
R3845 VSS.t1746 VSS.t1744 0.226736
R3846 VSS.t1751 VSS.t1749 0.226736
R3847 VSS.t1756 VSS.t1754 0.226736
R3848 VSS.t1761 VSS.t1759 0.226736
R3849 VSS.t1766 VSS.t1764 0.226736
R3850 VSS.t1771 VSS.t1769 0.226736
R3851 VSS.t1776 VSS.t1774 0.226736
R3852 VSS.t1781 VSS.t1779 0.226736
R3853 VSS.t1786 VSS.t1784 0.226736
R3854 VSS.t1791 VSS.t1789 0.226736
R3855 VSS.t1796 VSS.t1794 0.226736
R3856 VSS.t1801 VSS.t1799 0.226736
R3857 VSS.t1806 VSS.t1804 0.226736
R3858 VSS.t1811 VSS.t1809 0.226736
R3859 VSS.t1816 VSS.t1814 0.226736
R3860 VSS.t1821 VSS.t1819 0.226736
R3861 VSS.t1826 VSS.t1824 0.226736
R3862 VSS.t1831 VSS.t1829 0.226736
R3863 VSS.t1834 VSS.t1836 0.226736
R3864 VSS.t1841 VSS.t1839 0.226736
R3865 VSS.t1844 VSS.t1846 0.226736
R3866 VSS.t1851 VSS.t1849 0.226736
R3867 VSS.t892 VSS.t890 0.226736
R3868 VSS.t897 VSS.t895 0.226736
R3869 VSS.t902 VSS.t900 0.226736
R3870 VSS.t907 VSS.t905 0.226736
R3871 VSS.t912 VSS.t910 0.226736
R3872 VSS.t917 VSS.t915 0.226736
R3873 VSS.t922 VSS.t920 0.226736
R3874 VSS.t925 VSS.t927 0.226736
R3875 VSS.t932 VSS.t930 0.226736
R3876 VSS.t935 VSS.t937 0.226736
R3877 VSS.t942 VSS.t940 0.226736
R3878 VSS.t945 VSS.t947 0.226736
R3879 VSS.t952 VSS.t950 0.226736
R3880 VSS.t955 VSS.t957 0.226736
R3881 VSS.t962 VSS.t960 0.226736
R3882 VSS.t965 VSS.t967 0.226736
R3883 VSS.t972 VSS.t970 0.226736
R3884 VSS.t975 VSS.t977 0.226736
R3885 VSS.t982 VSS.t980 0.226736
R3886 VSS.t985 VSS.t987 0.226736
R3887 VSS.t992 VSS.t990 0.226736
R3888 VSS.t995 VSS.t997 0.226736
R3889 VSS.t1002 VSS.t1000 0.226736
R3890 VSS.t1005 VSS.t1007 0.226736
R3891 VSS.t1012 VSS.t1010 0.226736
R3892 VSS.t1015 VSS.t1017 0.226736
R3893 VSS.t1022 VSS.t1020 0.226736
R3894 VSS.t1025 VSS.t1027 0.226736
R3895 VSS.t1035 VSS.t1037 0.226736
R3896 VSS.t1042 VSS.t1040 0.226736
R3897 VSS.t1045 VSS.t1047 0.226736
R3898 VSS.t1052 VSS.t1050 0.226736
R3899 VSS.t1055 VSS.t1057 0.226736
R3900 VSS.t1062 VSS.t1060 0.226736
R3901 VSS.t1065 VSS.t1067 0.226736
R3902 VSS.t1072 VSS.t1070 0.226736
R3903 VSS.t1075 VSS.t1077 0.226736
R3904 VSS.t1082 VSS.t1080 0.226736
R3905 VSS.t1085 VSS.t1087 0.226736
R3906 VSS.t1092 VSS.t1090 0.226736
R3907 VSS.t1095 VSS.t1097 0.226736
R3908 VSS.t1102 VSS.t1100 0.226736
R3909 VSS.t1105 VSS.t1107 0.226736
R3910 VSS.t1112 VSS.t1110 0.226736
R3911 VSS.t1115 VSS.t1117 0.226736
R3912 VSS.t1122 VSS.t1120 0.226736
R3913 VSS.t1125 VSS.t1127 0.226736
R3914 VSS.t1132 VSS.t1130 0.226736
R3915 VSS.t1135 VSS.t1137 0.226736
R3916 VSS.t1142 VSS.t1140 0.226736
R3917 VSS.t1145 VSS.t1147 0.226736
R3918 VSS.t1152 VSS.t1150 0.226736
R3919 VSS.t1155 VSS.t1157 0.226736
R3920 VSS.t1162 VSS.t1160 0.226736
R3921 VSS.t1165 VSS.t1167 0.226736
R3922 VSS.t853 VSS.t851 0.226736
R3923 VSS.t848 VSS.t846 0.226736
R3924 VSS.t576 VSS.t577 0.226736
R3925 VSS.t580 VSS.t579 0.226736
R3926 VSS.t583 VSS.t582 0.226736
R3927 VSS.t586 VSS.t585 0.226736
R3928 VSS.t589 VSS.t588 0.226736
R3929 VSS.t592 VSS.t591 0.226736
R3930 VSS.t595 VSS.t594 0.226736
R3931 VSS.t598 VSS.t597 0.226736
R3932 VSS.t601 VSS.t600 0.226736
R3933 VSS.t604 VSS.t603 0.226736
R3934 VSS.t610 VSS.t609 0.226736
R3935 VSS.t613 VSS.t612 0.226736
R3936 VSS.t616 VSS.t615 0.226736
R3937 VSS.t619 VSS.t618 0.226736
R3938 VSS.t566 VSS.t568 0.226736
R3939 VSS.t625 VSS.t145 0.226736
R3940 VSS.t84 VSS.t631 0.226736
R3941 VSS.t139 VSS.t823 0.226736
R3942 VSS.t369 VSS.t816 0.226736
R3943 VSS.n270 VSS.t634 0.216275
R3944 VSS.n688 VSS.t606 0.229319
R3945 VSS.t758 VSS.t756 0.224236
R3946 VSS.n655 VSS.t384 0.237966
R3947 VSS.n320 VSS.t3060 0.0863258
R3948 VSS.n321 VSS.t3065 0.0863258
R3949 VSS.n322 VSS.t3070 0.0863258
R3950 VSS.n323 VSS.t3075 0.0863258
R3951 VSS.n324 VSS.t3080 0.0863258
R3952 VSS.n325 VSS.t3085 0.0863258
R3953 VSS.n326 VSS.t3090 0.0863258
R3954 VSS.n327 VSS.t3095 0.0863258
R3955 VSS.n328 VSS.t3100 0.0863258
R3956 VSS.n329 VSS.t3105 0.0863258
R3957 VSS.n330 VSS.t3110 0.0863258
R3958 VSS.n331 VSS.t3115 0.0863258
R3959 VSS.n332 VSS.t3120 0.0863258
R3960 VSS.n333 VSS.t3125 0.0863258
R3961 VSS.n334 VSS.t3130 0.0863258
R3962 VSS.n335 VSS.t3135 0.0863258
R3963 VSS.n336 VSS.t3140 0.0863258
R3964 VSS.n337 VSS.t3145 0.0863258
R3965 VSS.n338 VSS.t3150 0.0863258
R3966 VSS.n339 VSS.t3155 0.0863258
R3967 VSS.n340 VSS.t3160 0.0863258
R3968 VSS.n342 VSS.t3170 0.0863258
R3969 VSS.n343 VSS.t3175 0.0863258
R3970 VSS.n344 VSS.t3180 0.0863258
R3971 VSS.n345 VSS.t3185 0.0863258
R3972 VSS.n346 VSS.t3190 0.0863258
R3973 VSS.n347 VSS.t3195 0.0863258
R3974 VSS.n348 VSS.t3200 0.0863258
R3975 VSS.n349 VSS.t3205 0.0863258
R3976 VSS.n350 VSS.t3210 0.0863258
R3977 VSS.n351 VSS.t3215 0.0863258
R3978 VSS.n352 VSS.t3220 0.0863258
R3979 VSS.n353 VSS.t3225 0.0863258
R3980 VSS.n354 VSS.t3230 0.0863258
R3981 VSS.n355 VSS.t3235 0.0863258
R3982 VSS.n356 VSS.t3240 0.0863258
R3983 VSS.n357 VSS.t3245 0.0863258
R3984 VSS.n358 VSS.t3250 0.0863258
R3985 VSS.n359 VSS.t3255 0.0863258
R3986 VSS.n360 VSS.t3260 0.0863258
R3987 VSS.n361 VSS.t3265 0.0863258
R3988 VSS.n362 VSS.t3270 0.0863258
R3989 VSS.n363 VSS.t3275 0.0863258
R3990 VSS.n424 VSS.t2503 0.0863258
R3991 VSS.n426 VSS.t2513 0.0863258
R3992 VSS.n428 VSS.t2523 0.0863258
R3993 VSS.n430 VSS.t2533 0.0863258
R3994 VSS.n432 VSS.t2543 0.0863258
R3995 VSS.n434 VSS.t2553 0.0863258
R3996 VSS.n436 VSS.t2563 0.0863258
R3997 VSS.n438 VSS.t2573 0.0863258
R3998 VSS.n440 VSS.t2583 0.0863258
R3999 VSS.n442 VSS.t2593 0.0863258
R4000 VSS.n444 VSS.t2603 0.0863258
R4001 VSS.n446 VSS.t2613 0.0863258
R4002 VSS.n448 VSS.t2623 0.0863258
R4003 VSS.n450 VSS.t2633 0.0863258
R4004 VSS.t2628 VSS.n449 0.0863258
R4005 VSS.t2618 VSS.n447 0.0863258
R4006 VSS.t2608 VSS.n445 0.0863258
R4007 VSS.t2598 VSS.n443 0.0863258
R4008 VSS.t2588 VSS.n441 0.0863258
R4009 VSS.t2578 VSS.n439 0.0863258
R4010 VSS.t2568 VSS.n437 0.0863258
R4011 VSS.t2558 VSS.n435 0.0863258
R4012 VSS.t2548 VSS.n433 0.0863258
R4013 VSS.t2538 VSS.n431 0.0863258
R4014 VSS.t2528 VSS.n429 0.0863258
R4015 VSS.t2518 VSS.n427 0.0863258
R4016 VSS.t2508 VSS.n425 0.0863258
R4017 VSS.t2493 VSS.n422 0.0863258
R4018 VSS.n395 VSS.t2357 0.130189
R4019 VSS.t2363 VSS.n396 0.0863258
R4020 VSS.t2368 VSS.n397 0.0863258
R4021 VSS.t2373 VSS.n398 0.0863258
R4022 VSS.t2378 VSS.n399 0.0863258
R4023 VSS.t2383 VSS.n400 0.0863258
R4024 VSS.n458 VSS.t2001 0.0863258
R4025 VSS.n460 VSS.t2011 0.0863258
R4026 VSS.n462 VSS.t2021 0.0863258
R4027 VSS.n464 VSS.t2031 0.0863258
R4028 VSS.n466 VSS.t2041 0.0863258
R4029 VSS.n468 VSS.t2051 0.0863258
R4030 VSS.n470 VSS.t2061 0.0863258
R4031 VSS.n472 VSS.t2071 0.0863258
R4032 VSS.n474 VSS.t2081 0.0863258
R4033 VSS.n476 VSS.t2091 0.0863258
R4034 VSS.n478 VSS.t2101 0.0863258
R4035 VSS.n480 VSS.t2111 0.0863258
R4036 VSS.n482 VSS.t2121 0.0863258
R4037 VSS.n484 VSS.t2131 0.0863258
R4038 VSS.n486 VSS.t2141 0.0863258
R4039 VSS.n488 VSS.t2151 0.0863258
R4040 VSS.n490 VSS.t2161 0.0863258
R4041 VSS.n492 VSS.t2171 0.0863258
R4042 VSS.n494 VSS.t2181 0.0863258
R4043 VSS.n496 VSS.t2191 0.0863258
R4044 VSS.n498 VSS.t2201 0.0863258
R4045 VSS.n500 VSS.t2211 0.0863258
R4046 VSS.n559 VSS.t1834 0.0863258
R4047 VSS.n561 VSS.t1844 0.0863258
R4048 VSS.t1849 VSS.n562 0.0863258
R4049 VSS.t1839 VSS.n560 0.0863258
R4050 VSS.t1829 VSS.n558 0.0863258
R4051 VSS.n602 VSS.t925 0.0863258
R4052 VSS.n604 VSS.t935 0.0863258
R4053 VSS.n606 VSS.t945 0.0863258
R4054 VSS.n608 VSS.t955 0.0863258
R4055 VSS.n610 VSS.t965 0.0863258
R4056 VSS.n612 VSS.t975 0.0863258
R4057 VSS.n614 VSS.t985 0.0863258
R4058 VSS.n616 VSS.t995 0.0863258
R4059 VSS.n618 VSS.t1005 0.0863258
R4060 VSS.n620 VSS.t1015 0.0863258
R4061 VSS.n622 VSS.t1025 0.0863258
R4062 VSS.n624 VSS.t1035 0.0863258
R4063 VSS.n626 VSS.t1045 0.0863258
R4064 VSS.n628 VSS.t1055 0.0863258
R4065 VSS.n630 VSS.t1065 0.0863258
R4066 VSS.n632 VSS.t1075 0.0863258
R4067 VSS.n634 VSS.t1085 0.0863258
R4068 VSS.n636 VSS.t1095 0.0863258
R4069 VSS.n638 VSS.t1105 0.0863258
R4070 VSS.n640 VSS.t1115 0.0863258
R4071 VSS.n642 VSS.t1125 0.0863258
R4072 VSS.n644 VSS.t1135 0.0863258
R4073 VSS.t846 VSS.n657 0.0863258
R4074 VSS.n149 VSS.t576 0.17967
R4075 VSS.n692 VSS.t618 0.0863258
R4076 VSS.n691 VSS.t615 0.0863258
R4077 VSS.n690 VSS.t612 0.0863258
R4078 VSS.n689 VSS.t609 0.0863258
R4079 VSS.n686 VSS.t603 0.0863258
R4080 VSS.n685 VSS.t600 0.0863258
R4081 VSS.n684 VSS.t597 0.0863258
R4082 VSS.n683 VSS.t594 0.0863258
R4083 VSS.n682 VSS.t591 0.0863258
R4084 VSS.n681 VSS.t588 0.0863258
R4085 VSS.n680 VSS.t585 0.0863258
R4086 VSS.n679 VSS.t582 0.0863258
R4087 VSS.t579 VSS.n678 0.0863258
R4088 VSS.t823 VSS.n653 0.0863258
R4089 VSS.n651 VSS.t243 0.130189
R4090 VSS.t565 VSS.n700 0.130189
R4091 VSS.n702 VSS.t40 0.130189
R4092 VSS.t631 VSS.n695 0.0863258
R4093 VSS.t851 VSS.n658 0.0863258
R4094 VSS.n646 VSS.t1145 0.0863258
R4095 VSS.n648 VSS.t1155 0.0863258
R4096 VSS.n650 VSS.t1165 0.0863258
R4097 VSS.t1160 VSS.n649 0.0863258
R4098 VSS.t1150 VSS.n647 0.0863258
R4099 VSS.t1140 VSS.n645 0.0863258
R4100 VSS.t1130 VSS.n643 0.0863258
R4101 VSS.t1120 VSS.n641 0.0863258
R4102 VSS.t1110 VSS.n639 0.0863258
R4103 VSS.t1100 VSS.n637 0.0863258
R4104 VSS.t1090 VSS.n635 0.0863258
R4105 VSS.t1080 VSS.n633 0.0863258
R4106 VSS.t1070 VSS.n631 0.0863258
R4107 VSS.t1060 VSS.n629 0.0863258
R4108 VSS.t1050 VSS.n627 0.0863258
R4109 VSS.t1040 VSS.n625 0.0863258
R4110 VSS.t1020 VSS.n621 0.0863258
R4111 VSS.t1010 VSS.n619 0.0863258
R4112 VSS.t1000 VSS.n617 0.0863258
R4113 VSS.t990 VSS.n615 0.0863258
R4114 VSS.t980 VSS.n613 0.0863258
R4115 VSS.t970 VSS.n611 0.0863258
R4116 VSS.t960 VSS.n609 0.0863258
R4117 VSS.t950 VSS.n607 0.0863258
R4118 VSS.t940 VSS.n605 0.0863258
R4119 VSS.t930 VSS.n603 0.0863258
R4120 VSS.t920 VSS.n601 0.0863258
R4121 VSS.n595 VSS.t889 0.130189
R4122 VSS.t895 VSS.n596 0.0863258
R4123 VSS.t900 VSS.n597 0.0863258
R4124 VSS.t905 VSS.n598 0.0863258
R4125 VSS.t910 VSS.n599 0.0863258
R4126 VSS.t915 VSS.n600 0.0863258
R4127 VSS.t1965 VSS.n451 0.130189
R4128 VSS.n453 VSS.t1976 0.0863258
R4129 VSS.n455 VSS.t1986 0.0863258
R4130 VSS.t1981 VSS.n454 0.0863258
R4131 VSS.t1971 VSS.n452 0.0863258
R4132 VSS.t1573 VSS.n507 0.130189
R4133 VSS.n509 VSS.t1584 0.0863258
R4134 VSS.n511 VSS.t1594 0.0863258
R4135 VSS.n513 VSS.t1604 0.0863258
R4136 VSS.n515 VSS.t1614 0.0863258
R4137 VSS.n517 VSS.t1624 0.0863258
R4138 VSS.n519 VSS.t1634 0.0863258
R4139 VSS.n521 VSS.t1644 0.0863258
R4140 VSS.n523 VSS.t1654 0.0863258
R4141 VSS.n525 VSS.t1664 0.0863258
R4142 VSS.n527 VSS.t1674 0.0863258
R4143 VSS.n529 VSS.t1684 0.0863258
R4144 VSS.n531 VSS.t1694 0.0863258
R4145 VSS.n533 VSS.t1704 0.0863258
R4146 VSS.t1709 VSS.n534 0.0863258
R4147 VSS.t1699 VSS.n532 0.0863258
R4148 VSS.t1689 VSS.n530 0.0863258
R4149 VSS.t1679 VSS.n528 0.0863258
R4150 VSS.t1669 VSS.n526 0.0863258
R4151 VSS.t1659 VSS.n524 0.0863258
R4152 VSS.t1649 VSS.n522 0.0863258
R4153 VSS.t1639 VSS.n520 0.0863258
R4154 VSS.t1629 VSS.n518 0.0863258
R4155 VSS.t1619 VSS.n516 0.0863258
R4156 VSS.t1609 VSS.n514 0.0863258
R4157 VSS.t1599 VSS.n512 0.0863258
R4158 VSS.t1589 VSS.n510 0.0863258
R4159 VSS.t1579 VSS.n508 0.0863258
R4160 VSS.t1719 VSS.n536 0.0863258
R4161 VSS.t1724 VSS.n537 0.0863258
R4162 VSS.t1729 VSS.n538 0.0863258
R4163 VSS.t1734 VSS.n539 0.0863258
R4164 VSS.t1739 VSS.n540 0.0863258
R4165 VSS.t1744 VSS.n541 0.0863258
R4166 VSS.t1749 VSS.n542 0.0863258
R4167 VSS.t1754 VSS.n543 0.0863258
R4168 VSS.t1759 VSS.n544 0.0863258
R4169 VSS.t1764 VSS.n545 0.0863258
R4170 VSS.t1769 VSS.n546 0.0863258
R4171 VSS.t1774 VSS.n547 0.0863258
R4172 VSS.t1779 VSS.n548 0.0863258
R4173 VSS.t1784 VSS.n549 0.0863258
R4174 VSS.t1789 VSS.n550 0.0863258
R4175 VSS.t1794 VSS.n551 0.0863258
R4176 VSS.t1799 VSS.n552 0.0863258
R4177 VSS.t1804 VSS.n553 0.0863258
R4178 VSS.t1809 VSS.n554 0.0863258
R4179 VSS.t1814 VSS.n555 0.0863258
R4180 VSS.t1819 VSS.n556 0.0863258
R4181 VSS.t1824 VSS.n557 0.0863258
R4182 VSS.n502 VSS.t2221 0.0863258
R4183 VSS.n504 VSS.t2231 0.0863258
R4184 VSS.n506 VSS.t2241 0.0863258
R4185 VSS.t2236 VSS.n505 0.0863258
R4186 VSS.t2226 VSS.n503 0.0863258
R4187 VSS.t2216 VSS.n501 0.0863258
R4188 VSS.t2206 VSS.n499 0.0863258
R4189 VSS.t2196 VSS.n497 0.0863258
R4190 VSS.t2186 VSS.n495 0.0863258
R4191 VSS.t2176 VSS.n493 0.0863258
R4192 VSS.t2166 VSS.n491 0.0863258
R4193 VSS.t2156 VSS.n489 0.0863258
R4194 VSS.t2146 VSS.n487 0.0863258
R4195 VSS.t2136 VSS.n485 0.0863258
R4196 VSS.t2126 VSS.n483 0.0863258
R4197 VSS.t2116 VSS.n481 0.0863258
R4198 VSS.t2096 VSS.n477 0.0863258
R4199 VSS.t2086 VSS.n475 0.0863258
R4200 VSS.t2076 VSS.n473 0.0863258
R4201 VSS.t2066 VSS.n471 0.0863258
R4202 VSS.t2056 VSS.n469 0.0863258
R4203 VSS.t2046 VSS.n467 0.0863258
R4204 VSS.t2036 VSS.n465 0.0863258
R4205 VSS.t2026 VSS.n463 0.0863258
R4206 VSS.t2016 VSS.n461 0.0863258
R4207 VSS.t2006 VSS.n459 0.0863258
R4208 VSS.t1996 VSS.n457 0.0863258
R4209 VSS.n456 VSS.t1991 0.0863258
R4210 VSS.t2388 VSS.n401 0.0863258
R4211 VSS.t2393 VSS.n402 0.0863258
R4212 VSS.t2398 VSS.n403 0.0863258
R4213 VSS.t2403 VSS.n404 0.0863258
R4214 VSS.t2408 VSS.n405 0.0863258
R4215 VSS.t2413 VSS.n406 0.0863258
R4216 VSS.t2418 VSS.n407 0.0863258
R4217 VSS.t2423 VSS.n408 0.0863258
R4218 VSS.t2428 VSS.n409 0.0863258
R4219 VSS.t2433 VSS.n410 0.0863258
R4220 VSS.t2438 VSS.n411 0.0863258
R4221 VSS.t2443 VSS.n412 0.0863258
R4222 VSS.t2448 VSS.n413 0.0863258
R4223 VSS.t2453 VSS.n414 0.0863258
R4224 VSS.t2458 VSS.n415 0.0863258
R4225 VSS.t2463 VSS.n416 0.0863258
R4226 VSS.t2468 VSS.n417 0.0863258
R4227 VSS.t2473 VSS.n418 0.0863258
R4228 VSS.t2478 VSS.n419 0.0863258
R4229 VSS.t2483 VSS.n420 0.0863258
R4230 VSS.t2488 VSS.n421 0.0863258
R4231 VSS.t3024 VSS.n313 0.130189
R4232 VSS.n315 VSS.t3035 0.0863258
R4233 VSS.n317 VSS.t3045 0.0863258
R4234 VSS.t3040 VSS.n316 0.0863258
R4235 VSS.t3030 VSS.n314 0.0863258
R4236 VSS.n365 VSS.t3285 0.0863258
R4237 VSS.n367 VSS.t3295 0.0863258
R4238 VSS.t3300 VSS.n368 0.0863258
R4239 VSS.t3290 VSS.n366 0.0863258
R4240 VSS.t3280 VSS.n364 0.0863258
R4241 VSS.t3055 VSS.n319 0.0863258
R4242 VSS.t444 VSS.t443 0.217986
R4243 VSS.t439 VSS.t438 0.217986
R4244 VSS.n654 VSS.t826 0.0861948
R4245 VSS.t505 VSS.t504 0.217986
R4246 VSS.t510 VSS.t509 0.217986
R4247 VSS.t124 VSS.t515 0.217986
R4248 VSS.t520 VSS.t519 0.217986
R4249 VSS.t525 VSS.t524 0.217986
R4250 VSS.t530 VSS.t529 0.217986
R4251 VSS.t535 VSS.t534 0.217986
R4252 VSS.t540 VSS.t539 0.217986
R4253 VSS.t500 VSS.t311 0.217986
R4254 VSS.t490 VSS.t489 0.217986
R4255 VSS.t485 VSS.t484 0.217986
R4256 VSS.n656 VSS.t401 0.0861948
R4257 VSS.t812 VSS.n134 0.0489051
R4258 VSS.t2749 VSS.t413 0.209938
R4259 VSS.t475 VSS.t480 0.205117
R4260 VSS.t3 VSS.t214 0.204291
R4261 VSS.t3 VSS.t547 0.195153
R4262 VSS.t2828 VSS.t2829 0.180789
R4263 VSS.n677 VSS.n904 0.210486
R4264 VSS.t2502 VSS.t2500 0.168986
R4265 VSS.t2110 VSS.t2108 0.168986
R4266 VSS.t1718 VSS.t1716 0.168986
R4267 VSS.t1034 VSS.t1032 0.168986
R4268 VSS.t100 VSS.t695 0.168115
R4269 VSS.n312 VSS.t3165 0.083315
R4270 VSS.n251 VSS.t1444 0.08361
R4271 VSS.t497 VSS.n372 0.0836055
R4272 VSS.t3 VSS.t465 0.166911
R4273 VSS.t3 VSS.t475 0.165378
R4274 VSS.t887 VSS.n675 0.0647427
R4275 VSS.n693 VSS.t621 0.0647427
R4276 VSS.n670 VSS.t755 0.07903
R4277 VSS.n720 VSS.t756 0.150825
R4278 VSS.t495 VSS.n748 0.150789
R4279 VSS.n720 VSS.t755 0.150789
R4280 VSS.t1456 VSS.t1297 0.150789
R4281 VSS.t2888 VSS.t3012 0.150789
R4282 VSS.t3165 VSS.n708 0.150789
R4283 VSS.t3052 VSS.t3050 0.135506
R4284 VSS.t642 VSS.t136 0.1205
R4285 VSS.n209 VSS.n688 0.101538
R4286 VSS.t74 VSS.n922 0.10425
R4287 VSS.n311 VSS.t448 0.0333775
R4288 VSS.t2827 VSS.t2960 0.090789
R4289 VSS.t2888 VSS.t2889 0.090789
R4290 VSS.t2914 VSS.t2765 0.090789
R4291 VSS.t1364 VSS.n210 0.268299
R4292 VSS.t1297 VSS.t1457 0.090789
R4293 VSS.t449 VSS.n311 0.155751
R4294 VSS.t2828 VSS.t2960 0.0905
R4295 VSS.t1429 VSS.t1560 0.0905
R4296 VSS.t2765 VSS.t2913 0.0905
R4297 VSS.t544 VSS.t158 0.08675
R4298 VSS.n699 VSS.t136 0.0583051
R4299 VSS.t3027 VSS.t3029 0.0855
R4300 VSS.t3034 VSS.t3032 0.0855
R4301 VSS.t3037 VSS.t3039 0.0855
R4302 VSS.t3044 VSS.t3042 0.0855
R4303 VSS.t3047 VSS.t3049 0.0855
R4304 VSS.t517 VSS.t519 0.0855
R4305 VSS.t522 VSS.t524 0.0855
R4306 VSS.t527 VSS.t529 0.0855
R4307 VSS.t532 VSS.t534 0.0855
R4308 VSS.t537 VSS.t539 0.0855
R4309 VSS.t3277 VSS.t3279 0.0855
R4310 VSS.t3284 VSS.t3282 0.0855
R4311 VSS.t3287 VSS.t3289 0.0855
R4312 VSS.t3294 VSS.t3292 0.0855
R4313 VSS.t3297 VSS.t3299 0.0855
R4314 VSS.t3272 VSS.t3274 0.0855
R4315 VSS.t3267 VSS.t3269 0.0855
R4316 VSS.t3262 VSS.t3264 0.0855
R4317 VSS.t3257 VSS.t3259 0.0855
R4318 VSS.t3252 VSS.t3254 0.0855
R4319 VSS.t3247 VSS.t3249 0.0855
R4320 VSS.t3242 VSS.t3244 0.0855
R4321 VSS.t3237 VSS.t3239 0.0855
R4322 VSS.t3232 VSS.t3234 0.0855
R4323 VSS.t3227 VSS.t3229 0.0855
R4324 VSS.t3222 VSS.t3224 0.0855
R4325 VSS.t3217 VSS.t3219 0.0855
R4326 VSS.t3212 VSS.t3214 0.0855
R4327 VSS.t3207 VSS.t3209 0.0855
R4328 VSS.t3202 VSS.t3204 0.0855
R4329 VSS.t3197 VSS.t3199 0.0855
R4330 VSS.t3192 VSS.t3194 0.0855
R4331 VSS.t3187 VSS.t3189 0.0855
R4332 VSS.t3182 VSS.t3184 0.0855
R4333 VSS.t3177 VSS.t3179 0.0855
R4334 VSS.t3172 VSS.t3174 0.0855
R4335 VSS.t3169 VSS.t3167 0.0855
R4336 VSS.t3162 VSS.t3164 0.0855
R4337 VSS.t3157 VSS.t3159 0.0855
R4338 VSS.t3152 VSS.t3154 0.0855
R4339 VSS.t3147 VSS.t3149 0.0855
R4340 VSS.t3142 VSS.t3144 0.0855
R4341 VSS.t3137 VSS.t3139 0.0855
R4342 VSS.t3132 VSS.t3134 0.0855
R4343 VSS.t3127 VSS.t3129 0.0855
R4344 VSS.t3122 VSS.t3124 0.0855
R4345 VSS.t3117 VSS.t3119 0.0855
R4346 VSS.t3112 VSS.t3114 0.0855
R4347 VSS.t3107 VSS.t3109 0.0855
R4348 VSS.t3102 VSS.t3104 0.0855
R4349 VSS.t3097 VSS.t3099 0.0855
R4350 VSS.t3092 VSS.t3094 0.0855
R4351 VSS.t3087 VSS.t3089 0.0855
R4352 VSS.t3082 VSS.t3084 0.0855
R4353 VSS.t3077 VSS.t3079 0.0855
R4354 VSS.t3072 VSS.t3074 0.0855
R4355 VSS.t3067 VSS.t3069 0.0855
R4356 VSS.t3062 VSS.t3064 0.0855
R4357 VSS.t3059 VSS.t3057 0.0855
R4358 VSS.t3052 VSS.t3054 0.0855
R4359 VSS.t2362 VSS.t2360 0.0855
R4360 VSS.t2367 VSS.t2365 0.0855
R4361 VSS.t2372 VSS.t2370 0.0855
R4362 VSS.t2377 VSS.t2375 0.0855
R4363 VSS.t2382 VSS.t2380 0.0855
R4364 VSS.t2387 VSS.t2385 0.0855
R4365 VSS.t2392 VSS.t2390 0.0855
R4366 VSS.t2397 VSS.t2395 0.0855
R4367 VSS.t2402 VSS.t2400 0.0855
R4368 VSS.t2407 VSS.t2405 0.0855
R4369 VSS.t2412 VSS.t2410 0.0855
R4370 VSS.t2417 VSS.t2415 0.0855
R4371 VSS.t2422 VSS.t2420 0.0855
R4372 VSS.t2427 VSS.t2425 0.0855
R4373 VSS.t2432 VSS.t2430 0.0855
R4374 VSS.t2437 VSS.t2435 0.0855
R4375 VSS.t2442 VSS.t2440 0.0855
R4376 VSS.t2447 VSS.t2445 0.0855
R4377 VSS.t2452 VSS.t2450 0.0855
R4378 VSS.t2457 VSS.t2455 0.0855
R4379 VSS.t2462 VSS.t2460 0.0855
R4380 VSS.t2467 VSS.t2465 0.0855
R4381 VSS.t2472 VSS.t2470 0.0855
R4382 VSS.t2477 VSS.t2475 0.0855
R4383 VSS.t2482 VSS.t2480 0.0855
R4384 VSS.t2487 VSS.t2485 0.0855
R4385 VSS.t2492 VSS.t2490 0.0855
R4386 VSS.t2495 VSS.t2497 0.0855
R4387 VSS.t2505 VSS.t2507 0.0855
R4388 VSS.t2512 VSS.t2510 0.0855
R4389 VSS.t2515 VSS.t2517 0.0855
R4390 VSS.t2522 VSS.t2520 0.0855
R4391 VSS.t2525 VSS.t2527 0.0855
R4392 VSS.t2532 VSS.t2530 0.0855
R4393 VSS.t2535 VSS.t2537 0.0855
R4394 VSS.t2542 VSS.t2540 0.0855
R4395 VSS.t2545 VSS.t2547 0.0855
R4396 VSS.t2552 VSS.t2550 0.0855
R4397 VSS.t2555 VSS.t2557 0.0855
R4398 VSS.t2562 VSS.t2560 0.0855
R4399 VSS.t2565 VSS.t2567 0.0855
R4400 VSS.t2572 VSS.t2570 0.0855
R4401 VSS.t2575 VSS.t2577 0.0855
R4402 VSS.t2582 VSS.t2580 0.0855
R4403 VSS.t2585 VSS.t2587 0.0855
R4404 VSS.t2592 VSS.t2590 0.0855
R4405 VSS.t2595 VSS.t2597 0.0855
R4406 VSS.t2602 VSS.t2600 0.0855
R4407 VSS.t2605 VSS.t2607 0.0855
R4408 VSS.t2612 VSS.t2610 0.0855
R4409 VSS.t2615 VSS.t2617 0.0855
R4410 VSS.t2622 VSS.t2620 0.0855
R4411 VSS.t2625 VSS.t2627 0.0855
R4412 VSS.t2632 VSS.t2630 0.0855
R4413 VSS.t1968 VSS.t1970 0.0855
R4414 VSS.t1975 VSS.t1973 0.0855
R4415 VSS.t1978 VSS.t1980 0.0855
R4416 VSS.t1985 VSS.t1983 0.0855
R4417 VSS.t1988 VSS.t1990 0.0855
R4418 VSS.t1993 VSS.t1995 0.0855
R4419 VSS.t2000 VSS.t1998 0.0855
R4420 VSS.t2003 VSS.t2005 0.0855
R4421 VSS.t2010 VSS.t2008 0.0855
R4422 VSS.t2013 VSS.t2015 0.0855
R4423 VSS.t2020 VSS.t2018 0.0855
R4424 VSS.t2023 VSS.t2025 0.0855
R4425 VSS.t2030 VSS.t2028 0.0855
R4426 VSS.t2033 VSS.t2035 0.0855
R4427 VSS.t2040 VSS.t2038 0.0855
R4428 VSS.t2043 VSS.t2045 0.0855
R4429 VSS.t2050 VSS.t2048 0.0855
R4430 VSS.t2053 VSS.t2055 0.0855
R4431 VSS.t2060 VSS.t2058 0.0855
R4432 VSS.t2063 VSS.t2065 0.0855
R4433 VSS.t2070 VSS.t2068 0.0855
R4434 VSS.t2073 VSS.t2075 0.0855
R4435 VSS.t2080 VSS.t2078 0.0855
R4436 VSS.t2083 VSS.t2085 0.0855
R4437 VSS.t2090 VSS.t2088 0.0855
R4438 VSS.t2093 VSS.t2095 0.0855
R4439 VSS.t2100 VSS.t2098 0.0855
R4440 VSS.t2103 VSS.t2105 0.0855
R4441 VSS.t2113 VSS.t2115 0.0855
R4442 VSS.t2120 VSS.t2118 0.0855
R4443 VSS.t2123 VSS.t2125 0.0855
R4444 VSS.t2130 VSS.t2128 0.0855
R4445 VSS.t2133 VSS.t2135 0.0855
R4446 VSS.t2140 VSS.t2138 0.0855
R4447 VSS.t2143 VSS.t2145 0.0855
R4448 VSS.t2150 VSS.t2148 0.0855
R4449 VSS.t2153 VSS.t2155 0.0855
R4450 VSS.t2160 VSS.t2158 0.0855
R4451 VSS.t2163 VSS.t2165 0.0855
R4452 VSS.t2170 VSS.t2168 0.0855
R4453 VSS.t2173 VSS.t2175 0.0855
R4454 VSS.t2180 VSS.t2178 0.0855
R4455 VSS.t2183 VSS.t2185 0.0855
R4456 VSS.t2190 VSS.t2188 0.0855
R4457 VSS.t2193 VSS.t2195 0.0855
R4458 VSS.t2200 VSS.t2198 0.0855
R4459 VSS.t2203 VSS.t2205 0.0855
R4460 VSS.t2210 VSS.t2208 0.0855
R4461 VSS.t2213 VSS.t2215 0.0855
R4462 VSS.t2220 VSS.t2218 0.0855
R4463 VSS.t2223 VSS.t2225 0.0855
R4464 VSS.t2230 VSS.t2228 0.0855
R4465 VSS.t2233 VSS.t2235 0.0855
R4466 VSS.t2240 VSS.t2238 0.0855
R4467 VSS.t1576 VSS.t1578 0.0855
R4468 VSS.t1583 VSS.t1581 0.0855
R4469 VSS.t1586 VSS.t1588 0.0855
R4470 VSS.t1593 VSS.t1591 0.0855
R4471 VSS.t1596 VSS.t1598 0.0855
R4472 VSS.t1603 VSS.t1601 0.0855
R4473 VSS.t1606 VSS.t1608 0.0855
R4474 VSS.t1613 VSS.t1611 0.0855
R4475 VSS.t1616 VSS.t1618 0.0855
R4476 VSS.t1623 VSS.t1621 0.0855
R4477 VSS.t1626 VSS.t1628 0.0855
R4478 VSS.t1633 VSS.t1631 0.0855
R4479 VSS.t1636 VSS.t1638 0.0855
R4480 VSS.t1643 VSS.t1641 0.0855
R4481 VSS.t1646 VSS.t1648 0.0855
R4482 VSS.t1653 VSS.t1651 0.0855
R4483 VSS.t1656 VSS.t1658 0.0855
R4484 VSS.t1663 VSS.t1661 0.0855
R4485 VSS.t1666 VSS.t1668 0.0855
R4486 VSS.t1673 VSS.t1671 0.0855
R4487 VSS.t1676 VSS.t1678 0.0855
R4488 VSS.t1683 VSS.t1681 0.0855
R4489 VSS.t1686 VSS.t1688 0.0855
R4490 VSS.t1693 VSS.t1691 0.0855
R4491 VSS.t1696 VSS.t1698 0.0855
R4492 VSS.t1703 VSS.t1701 0.0855
R4493 VSS.t1706 VSS.t1708 0.0855
R4494 VSS.t1713 VSS.t1711 0.0855
R4495 VSS.t1723 VSS.t1721 0.0855
R4496 VSS.t1728 VSS.t1726 0.0855
R4497 VSS.t1733 VSS.t1731 0.0855
R4498 VSS.t1738 VSS.t1736 0.0855
R4499 VSS.t1743 VSS.t1741 0.0855
R4500 VSS.t1748 VSS.t1746 0.0855
R4501 VSS.t1753 VSS.t1751 0.0855
R4502 VSS.t1758 VSS.t1756 0.0855
R4503 VSS.t1763 VSS.t1761 0.0855
R4504 VSS.t1768 VSS.t1766 0.0855
R4505 VSS.t1773 VSS.t1771 0.0855
R4506 VSS.t1778 VSS.t1776 0.0855
R4507 VSS.t1783 VSS.t1781 0.0855
R4508 VSS.t1788 VSS.t1786 0.0855
R4509 VSS.t1793 VSS.t1791 0.0855
R4510 VSS.t1798 VSS.t1796 0.0855
R4511 VSS.t1803 VSS.t1801 0.0855
R4512 VSS.t1808 VSS.t1806 0.0855
R4513 VSS.t1813 VSS.t1811 0.0855
R4514 VSS.t1818 VSS.t1816 0.0855
R4515 VSS.t1823 VSS.t1821 0.0855
R4516 VSS.t1826 VSS.t1828 0.0855
R4517 VSS.t1833 VSS.t1831 0.0855
R4518 VSS.t1836 VSS.t1838 0.0855
R4519 VSS.t1843 VSS.t1841 0.0855
R4520 VSS.t1846 VSS.t1848 0.0855
R4521 VSS.t894 VSS.t892 0.0855
R4522 VSS.t899 VSS.t897 0.0855
R4523 VSS.t904 VSS.t902 0.0855
R4524 VSS.t909 VSS.t907 0.0855
R4525 VSS.t914 VSS.t912 0.0855
R4526 VSS.t917 VSS.t919 0.0855
R4527 VSS.t924 VSS.t922 0.0855
R4528 VSS.t927 VSS.t929 0.0855
R4529 VSS.t934 VSS.t932 0.0855
R4530 VSS.t937 VSS.t939 0.0855
R4531 VSS.t944 VSS.t942 0.0855
R4532 VSS.t947 VSS.t949 0.0855
R4533 VSS.t954 VSS.t952 0.0855
R4534 VSS.t957 VSS.t959 0.0855
R4535 VSS.t964 VSS.t962 0.0855
R4536 VSS.t967 VSS.t969 0.0855
R4537 VSS.t974 VSS.t972 0.0855
R4538 VSS.t977 VSS.t979 0.0855
R4539 VSS.t984 VSS.t982 0.0855
R4540 VSS.t987 VSS.t989 0.0855
R4541 VSS.t994 VSS.t992 0.0855
R4542 VSS.t997 VSS.t999 0.0855
R4543 VSS.t1004 VSS.t1002 0.0855
R4544 VSS.t1007 VSS.t1009 0.0855
R4545 VSS.t1014 VSS.t1012 0.0855
R4546 VSS.t1017 VSS.t1019 0.0855
R4547 VSS.t1024 VSS.t1022 0.0855
R4548 VSS.t1027 VSS.t1029 0.0855
R4549 VSS.t1037 VSS.t1039 0.0855
R4550 VSS.t1044 VSS.t1042 0.0855
R4551 VSS.t1047 VSS.t1049 0.0855
R4552 VSS.t1054 VSS.t1052 0.0855
R4553 VSS.t1057 VSS.t1059 0.0855
R4554 VSS.t1064 VSS.t1062 0.0855
R4555 VSS.t1067 VSS.t1069 0.0855
R4556 VSS.t1074 VSS.t1072 0.0855
R4557 VSS.t1077 VSS.t1079 0.0855
R4558 VSS.t1084 VSS.t1082 0.0855
R4559 VSS.t1087 VSS.t1089 0.0855
R4560 VSS.t1094 VSS.t1092 0.0855
R4561 VSS.t1097 VSS.t1099 0.0855
R4562 VSS.t1104 VSS.t1102 0.0855
R4563 VSS.t1107 VSS.t1109 0.0855
R4564 VSS.t1114 VSS.t1112 0.0855
R4565 VSS.t1117 VSS.t1119 0.0855
R4566 VSS.t1124 VSS.t1122 0.0855
R4567 VSS.t1127 VSS.t1129 0.0855
R4568 VSS.t1134 VSS.t1132 0.0855
R4569 VSS.t1137 VSS.t1139 0.0855
R4570 VSS.t1144 VSS.t1142 0.0855
R4571 VSS.t1147 VSS.t1149 0.0855
R4572 VSS.t1154 VSS.t1152 0.0855
R4573 VSS.t1157 VSS.t1159 0.0855
R4574 VSS.t1164 VSS.t1162 0.0855
R4575 VSS.t76 VSS.t853 0.0855
R4576 VSS.t848 VSS.t850 0.0855
R4577 VSS.t822 VSS.t373 0.0855
R4578 VSS.t174 VSS.t139 0.0855
R4579 VSS.t577 VSS.t578 0.0855
R4580 VSS.t580 VSS.t581 0.0855
R4581 VSS.t583 VSS.t584 0.0855
R4582 VSS.t586 VSS.t587 0.0855
R4583 VSS.t589 VSS.t590 0.0855
R4584 VSS.t592 VSS.t593 0.0855
R4585 VSS.t595 VSS.t596 0.0855
R4586 VSS.t598 VSS.t599 0.0855
R4587 VSS.t601 VSS.t602 0.0855
R4588 VSS.t604 VSS.t605 0.0855
R4589 VSS.t607 VSS.t608 0.0855
R4590 VSS.t610 VSS.t611 0.0855
R4591 VSS.t613 VSS.t614 0.0855
R4592 VSS.t616 VSS.t617 0.0855
R4593 VSS.t568 VSS.t186 0.0855
R4594 VSS.t634 VSS.t84 0.0855
R4595 VSS.t46 VSS.t50 0.0855
R4596 VSS.t502 VSS.t504 0.0855
R4597 VSS.t507 VSS.t509 0.0855
R4598 VSS.t492 VSS.t494 0.0855
R4599 VSS.t487 VSS.t489 0.0855
R4600 VSS.t443 VSS.t441 0.0855
R4601 VSS.t446 VSS.t448 0.0855
R4602 VSS.t542 VSS.t544 0.07425
R4603 VSS.t619 VSS.t620 0.07425
R4604 VSS.t117 VSS.t497 0.07425
R4605 VSS.n3 VSS.t435 26.1613
R4606 VSS.t3 VSS.n4 0.0643474
R4607 VSS.t3 VSS.n29 0.0643474
R4608 VSS.n28 VSS.t455 26.1613
R4609 VSS.t3 VSS.n26 0.0643474
R4610 VSS.t3 VSS.n7 0.0643474
R4611 VSS.t3 VSS.n24 0.0643474
R4612 VSS.t3 VSS.n9 0.0643474
R4613 VSS.t3 VSS.n22 0.0643474
R4614 VSS.t3 VSS.n20 0.0643474
R4615 VSS.t3 VSS.n12 0.0643474
R4616 VSS.t3 VSS.n18 0.0643474
R4617 VSS.t3 VSS.n14 0.0643474
R4618 VSS.t3 VSS.n15 0.0643474
R4619 VSS.t3 VSS.n16 0.0643474
R4620 VSS.t3 VSS.n33 0.0329045
R4621 VSS.t3 VSS.n35 0.0643474
R4622 VSS.t3 VSS.n44 0.0643474
R4623 VSS.t3 VSS.n51 0.0643474
R4624 VSS.t3 VSS.n46 0.0643474
R4625 VSS.t3 VSS.n47 0.0643474
R4626 VSS.n48 VSS.t558 26.1613
R4627 VSS.n941 VSS.n707 0.0623545
R4628 VSS.n937 VSS.n707 0.0623545
R4629 VSS.n937 VSS.n936 0.0623545
R4630 VSS.n936 VSS.n712 0.0623545
R4631 VSS.n931 VSS.n712 0.0623545
R4632 VSS.n931 VSS.n930 0.0623545
R4633 VSS.n930 VSS.n719 0.0623545
R4634 VSS.n851 VSS.n719 0.0623545
R4635 VSS.n940 VSS.n709 0.0623545
R4636 VSS.n935 VSS.n709 0.0623545
R4637 VSS.n935 VSS.n934 0.0623545
R4638 VSS.n934 VSS.n713 0.0623545
R4639 VSS.n929 VSS.n713 0.0623545
R4640 VSS.n929 VSS.n928 0.0623545
R4641 VSS.n928 VSS.n687 0.0623545
R4642 VSS.n939 VSS.n938 0.0623545
R4643 VSS.n938 VSS.n711 0.0623545
R4644 VSS.n933 VSS.n711 0.0623545
R4645 VSS.n933 VSS.n932 0.0623545
R4646 VSS.n932 VSS.n714 0.0623545
R4647 VSS.n906 VSS.n714 0.0623545
R4648 VSS.n906 VSS.n905 0.0623545
R4649 VSS.t715 VSS.n741 0.0613562
R4650 VSS.n922 VSS.t14 0.058
R4651 VSS.n341 VSS.n708 0.0957512
R4652 VSS.t2498 VSS.n423 0.0957512
R4653 VSS.n479 VSS.t2106 0.0957512
R4654 VSS.t1714 VSS.n535 0.0957512
R4655 VSS.n715 VSS.t1429 0.0305
R4656 VSS.n623 VSS.t1030 0.0957512
R4657 VSS.n904 VSS.t642 0.0305
R4658 VSS.n216 VSS.n748 0.0957512
R4659 VSS.n55 VSS.t2499 109.992
R4660 VSS.t2624 VSS.n55 109.992
R4661 VSS.n55 VSS.t2609 109.992
R4662 VSS.n55 VSS.t2579 109.992
R4663 VSS.n55 VSS.t2559 109.992
R4664 VSS.n55 VSS.t2529 109.992
R4665 VSS.n55 VSS.t2509 109.992
R4666 VSS.n55 VSS.t2489 109.992
R4667 VSS.n55 VSS.t2464 109.992
R4668 VSS.n55 VSS.t2439 109.992
R4669 VSS.n55 VSS.t2389 109.992
R4670 VSS.n56 VSS.t2227 109.992
R4671 VSS.t2132 VSS.n56 109.992
R4672 VSS.t2112 VSS.n56 109.992
R4673 VSS.n56 VSS.t2067 109.992
R4674 VSS.t2062 VSS.n56 109.992
R4675 VSS.n57 VSS.t1825 109.992
R4676 VSS.n57 VSS.t1800 109.992
R4677 VSS.n57 VSS.t1775 109.992
R4678 VSS.n57 VSS.t1770 109.992
R4679 VSS.n57 VSS.t1750 109.992
R4680 VSS.t1655 VSS.n57 109.992
R4681 VSS.t1645 VSS.n57 109.992
R4682 VSS.t1635 VSS.n57 109.992
R4683 VSS.t1126 VSS.n54 109.992
R4684 VSS.n54 VSS.t1051 109.992
R4685 VSS.t1036 VSS.n54 109.992
R4686 VSS.t1016 VSS.n54 109.992
R4687 VSS.t1006 VSS.n54 109.992
R4688 VSS.n54 VSS.t961 109.992
R4689 VSS.n54 VSS.t916 109.992
R4690 VSS.t302 VSS.t704 109.992
R4691 VSS.t302 VSS.t694 109.992
R4692 VSS.n139 VSS.t3291 157.976
R4693 VSS.t3261 VSS.n139 157.976
R4694 VSS.t3246 VSS.n139 157.976
R4695 VSS.t3236 VSS.n139 157.976
R4696 VSS.t3221 VSS.n139 157.976
R4697 VSS.t3196 VSS.n139 157.976
R4698 VSS.t3151 VSS.n139 157.976
R4699 VSS.t3141 VSS.n139 157.976
R4700 VSS.t3126 VSS.n139 157.976
R4701 VSS.t3106 VSS.n139 157.976
R4702 VSS.t3096 VSS.n139 157.976
R4703 VSS.t3071 VSS.n139 157.976
R4704 VSS.n139 VSS.t3051 157.976
R4705 VSS.n54 VSS.n649 4.29335
R4706 VSS.n55 VSS.n449 4.29334
R4707 VSS.n561 VSS.n57 4.29332
R4708 VSS.n56 VSS.n505 4.29332
R4709 VSS VSS.n941 0.00565455
R4710 VSS.t412 VSS.n183 3.33051
R4711 VSS.n318 VSS.n139 2.95002
R4712 VSS.t412 VSS.n246 2.92851
R4713 VSS.n208 VSS.t377 2.88634
R4714 VSS.t30 VSS.t33 1.28692
R4715 VSS.t686 VSS.t302 1.16358
R4716 VSS.t33 VSS.n167 1.12745
R4717 VSS.t3 VSS.n252 1.05914
C0 a_27215_14845# a_25956_14488# 0.01303f
C1 a_15782_13722# sg13g2_dfrbpq_1_2.D 0.1517f
C2 a_17318_14922# a_17578_14452# 0.39302f
C3 a_26122_13945# a_26565_13701# 0.02242f
C4 a_25862_13722# a_26148_14040# 0.21832f
C5 sg13g2_o21ai_1_1.Y sg13g2_or3_1_2.A 0.12124f
C6 sg13g2_dfrbpq_1_3.RESET_B sg13g2_or3_1_2.B 0.02356f
C7 a_16485_13701# a_16587_13844# 0.26919f
C8 sg13g2_nand4_1_0.Y VDD 0.5472f
C9 sg13g2_dlygate4sd3_1_11.X sg13g2_or3_1_2.X 0.13838f
C10 sg13g2_and2_1_0.X a_2516_14484# 0.03171f
C11 a_6280_13058# VDD 0.15641f
C12 a_18874_13690# VDD 0.336f
C13 sg13g2_or3_1_2.B a_18021_14495# 0.01076f
C14 sg13g2_dfrbpq_1_6.RESET_B a_21034_14452# 0.13387f
C15 sg13g2_or3_1_2.X a_20603_15532# 0.05694f
C16 sg13g2_o21ai_1_2.A2 sg13g2_buf_16_2.X 0.05165f
C17 a_7937_13912# VDD 0.19965f
C18 sg13g2_buf_1_0.X sg13g2_nand4_1_0.Y 0.03081f
C19 sg13g2_buf_16_2.X a_21034_14452# 0.01841f
C20 sg13g2_dfrbpq_1_2.RESET_B a_16068_14040# 0.23755f
C21 sg13g2_dfrbpq_1_3.RESET_B sg13g2_or3_1_1.B 0.01529f
C22 sg13g2_o21ai_1_2.B1 a_24062_15242# 0.01805f
C23 a_24841_13726# a_24935_14020# 0.02085f
C24 sg13g2_buf_16_2.X a_19530_14484# 0.01377f
C25 sg13g2_dlygate4sd3_1_0.X VDD 0.42681f
C26 sg13g2_a21oi_1_0.Y a_15022_14484# 0.0117f
C27 a_27898_15202# sg13g2_dfrbpq_1_6.Q 0.01199f
C28 a_23736_14464# VDD 0.01765f
C29 a_25956_14488# sg13g2_buf_16_2.X 0.09231f
C30 sg13g2_dlygate4sd3_1_6.X sg13g2_xnor2_1_1.A 0.19121f
C31 sg13g2_or3_1_1.A sg13g2_o21ai_1_3.Y 0.19466f
C32 sg13g2_dfrbpq_1_7.D VDD 0.1787f
C33 sg13g2_dlygate4sd3_1_8.A a_11752_15366# 0.03267f
C34 sg13g2_o21ai_1_2.Y a_24169_14508# 0.04637f
C35 sg13g2_dlygate4sd3_1_12.X VDD 0.17031f
C36 sg13g2_or3_1_2.X a_21579_14495# 0.05524f
C37 a_26554_16237# a_26373_16033# 0.02683f
C38 a_18377_16334# a_18298_16237# 0.08074f
C39 a_22145_15424# VDD 0.19789f
C40 sg13g2_a21oi_1_0.B1 sg13g2_buf_16_2.A 0.25575f
C41 a_22025_16334# VDD 0.06879f
C42 sg13g2_dfrbpq_1_0.RESET_B a_4432_15454# 0.06226f
C43 a_27215_14845# a_27121_14845# 0.15029f
C44 sg13g2_dfrbpq_1_6.D a_21070_15423# 0.03685f
C45 sg13g2_dlygate4sd3_1_4.X sg13g2_or3_1_2.B 0.11113f
C46 sg13g2_dfrbpq_1_2.CLK a_6086_14922# 0.01599f
C47 sg13g2_or3_1_2.A a_21477_14495# 0.05486f
C48 sg13g2_dfrbpq_1_2.CLK a_11370_15532# 0.01225f
C49 a_27500_15960# VDD 0.19742f
C50 sg13g2_o21ai_1_2.Y sg13g2_or3_1_2.B 0.03997f
C51 sg13g2_dlygate4sd3_1_1.A a_8218_13690# 0.24826f
C52 a_17584_13942# VDD 0.12991f
C53 sg13g2_or3_1_2.B sg13g2_o21ai_1_1.Y 0.01815f
C54 a_38720_14570# VDD 0.07927f
C55 a_22426_15202# sg13g2_dfrbpq_1_3.Q 0.0308f
C56 a_6086_14922# sg13g2_xnor2_1_2.B 0.05961f
C57 sg13g2_or3_1_2.B sg13g2_nor2_1_0.B 0.04056f
C58 sg13g2_a21oi_1_3.A1 sg13g2_a21oi_1_3.Y 0.30532f
C59 a_18176_16082# VDD 0.07203f
C60 sg13g2_or3_1_2.X VDD 0.31077f
C61 a_25094_15238# sg13g2_or3_1_1.A 0.02127f
C62 sg13g2_or3_1_2.X a_20774_14922# 0.0173f
C63 sg13g2_or3_1_2.X sg13g2_or3_1_2.C 0.01939f
C64 a_27407_13799# a_28074_14020# 0.06982f
C65 clock_i counter_value_o[2] 0.04067f
C66 sg13g2_buf_1_10.X sg13g2_and2_1_0.B 0.11219f
C67 sg13g2_dfrbpq_1_2.RESET_B sg13g2_xnor2_1_1.A 0.03753f
C68 sg13g2_or3_1_1.B sg13g2_dlygate4sd3_1_4.X 0.03156f
C69 sg13g2_dfrbpq_1_2.RESET_B a_16254_15934# 0.04276f
C70 a_6372_14488# sg13g2_xor2_1_0.B 0.02399f
C71 a_38536_10034# a_38720_10034# 0.0262f
C72 sg13g2_o21ai_1_2.Y sg13g2_or3_1_1.B 0.01707f
C73 sg13g2_tiehi_1.L_HI sg13g2_nand4_1_0.Y 0.0284f
C74 sg13g2_and2_1_2.B sg13g2_dlygate4sd3_1_8.X 0.01382f
C75 a_3435_15356# a_4175_15311# 0.15395f
C76 a_17327_13799# sg13g2_a21oi_1_0.A1 0.03266f
C77 sg13g2_or3_1_1.B sg13g2_o21ai_1_1.Y 0.01267f
C78 a_6540_13238# sg13g2_dlygate4sd3_1_0.A 0.11291f
C79 a_15680_13854# VDD 0.09228f
C80 a_10609_15311# a_10703_15311# 0.15029f
C81 sg13g2_dfrbpq_1_2.RESET_B sg13g2_buf_16_2.A 0.17124f
C82 sg13g2_or3_1_1.C sg13g2_o21ai_1_3.Y 0.04719f
C83 sg13g2_or3_1_1.B sg13g2_nor2_1_0.B 0.01935f
C84 sg13g2_dfrbpq_1_2.Q sg13g2_dfrbpq_1_3.RESET_B 0.18375f
C85 sg13g2_dlygate4sd3_1_8.A counter_value_o[2] 0.01365f
C86 sg13g2_xor2_1_0.B sg13g2_dlygate4sd3_1_3.A 0.04261f
C87 a_21185_15424# VDD 0.19698f
C88 a_26554_16237# sg13g2_dfrbpq_1_5.RESET_B 0.03978f
C89 sg13g2_o21ai_1_3.Y a_26170_16237# 0.02319f
C90 a_6789_14495# a_6891_14495# 0.27006f
C91 a_32492_15960# sg13g2_dfrbpq_1_7.Q 0.16111f
C92 sg13g2_a21oi_1_3.A1 a_25109_12972# 0.02387f
C93 a_22576_14726# a_22319_14845# 0.20069f
C94 sg13g2_dfrbpq_1_2.Q a_18021_14495# 0.02182f
C95 a_16556_15960# sg13g2_or3_1_2.B 0.13284f
C96 sg13g2_dfrbpq_1_3.Q a_21466_15202# 0.01226f
C97 a_20376_14464# VDD 0.01847f
C98 sg13g2_dfrbpq_1_2.CLK sg13g2_and2_1_2.X 0.027f
C99 a_6575_13342# sg13g2_dlygate4sd3_1_0.A 0.03578f
C100 sg13g2_dfrbpq_1_5.RESET_B a_26244_14909# 0.01677f
C101 a_6891_14495# sg13g2_xnor2_1_2.A 0.06395f
C102 a_12232_16082# counter_value_o[2] 0.02118f
C103 sg13g2_or3_1_1.X sg13g2_dfrbpq_1_6.Q 0.01399f
C104 sg13g2_or3_1_2.B sg13g2_dlygate4sd3_1_5.A 0.22722f
C105 a_7888_14726# a_7631_14845# 0.20069f
C106 sg13g2_dfrbpq_1_7.RESET_B a_26475_14495# 0.21427f
C107 sg13g2_or3_1_2.B a_16218_15532# 0.01256f
C108 sg13g2_buf_1_10.X sg13g2_and2_1_0.X 0.04308f
C109 sg13g2_or3_1_1.B a_16556_15960# 0.16198f
C110 a_22025_16334# a_22149_16033# 0.06917f
C111 a_16055_16071# a_16055_16301# 0.06917f
C112 a_9158_15234# sg13g2_dlygate4sd3_1_8.X 0.02597f
C113 a_16587_13844# sg13g2_a21oi_1_0.Y 0.04768f
C114 a_6280_13058# sg13g2_dlygate4sd3_1_0.A 0.01641f
C115 a_26436_13735# a_26148_14040# 0.22255f
C116 sg13g2_dfrbpq_1_2.Q sg13g2_dlygate4sd3_1_4.X 0.37806f
C117 a_16055_16301# VDD 0.06876f
C118 a_22426_15202# sg13g2_dfrbpq_1_6.Q 0.22623f
C119 a_23168_15366# VDD 0.09073f
C120 a_25109_12972# sg13g2_a21oi_1_3.A2 0.05394f
C121 sg13g2_dfrbpq_1_3.RESET_B a_18021_14495# 0.03254f
C122 a_1965_14832# VDD 0.26526f
C123 sg13g2_dfrbpq_1_7.D sg13g2_buf_16_2.X 0.01302f
C124 sg13g2_dfrbpq_1_2.Q sg13g2_o21ai_1_1.Y 0.01062f
C125 a_6086_14922# VDD 0.44588f
C126 sg13g2_dfrbpq_1_1.RESET_B a_6891_14495# 0.2147f
C127 a_25390_16263# sg13g2_o21ai_1_3.Y 0.01578f
C128 a_11370_15532# VDD 0.24136f
C129 a_18863_14845# VDD 0.1976f
C130 sg13g2_or3_1_1.A sg13g2_or3_1_1.B 0.14101f
C131 sg13g2_o21ai_1_2.A2 sg13g2_dfrbpq_1_3.Q 0.13184f
C132 a_10960_15454# a_11370_15532# 0.05221f
C133 a_25930_14452# VDD 0.09582f
C134 a_21827_13690# sg13g2_or3_1_2.A 0.17685f
C135 a_19120_14726# a_18863_14845# 0.20069f
C136 sg13g2_a21oi_1_0.B1 sg13g2_or3_1_1.X 0.06644f
C137 sg13g2_dlygate4sd3_1_1.A a_6891_14495# 0.03656f
C138 sg13g2_a21oi_1_3.Y VDD 0.37642f
C139 clock_i sg13g2_dlygate4sd3_1_8.X 0.0481f
C140 sg13g2_or3_1_1.C a_24169_14508# 0.03811f
C141 sg13g2_dfrbpq_1_3.Q a_19530_14484# 0.07201f
C142 a_25206_15302# sg13g2_or3_1_1.X 0.0267f
C143 sg13g2_a21oi_1_0.A1 VDD 0.42347f
C144 sg13g2_dfrbpq_1_2.CLK a_4193_14750# 0.01903f
C145 a_25670_14922# a_25956_14488# 0.21832f
C146 a_3130_16237# sg13g2_dfrbpq_1_0.RESET_B 0.04209f
C147 a_4432_15454# sg13g2_dlygate4sd3_1_3.A 0.05805f
C148 a_27502_15423# VDD 0.1454f
C149 sg13g2_dfrbpq_1_6.RESET_B sg13g2_or3_1_2.X 0.04674f
C150 a_25774_15423# sg13g2_dfrbpq_1_7.D 0.08839f
C151 a_16044_15424# VDD 0.16812f
C152 sg13g2_or3_1_2.X sg13g2_buf_16_2.X 0.05858f
C153 sg13g2_dfrbpq_1_3.RESET_B sg13g2_dlygate4sd3_1_4.X 0.17879f
C154 a_37484_15960# sg13g2_dfrbpq_1_5.Q 0.16451f
C155 sg13g2_or3_1_1.C sg13g2_or3_1_2.B 0.26229f
C156 sg13g2_dlygate4sd3_1_8.A sg13g2_dlygate4sd3_1_8.X 0.01211f
C157 sg13g2_a21oi_1_0.A2 sg13g2_a21oi_1_0.A1 0.37488f
C158 sg13g2_dlygate4sd3_1_17.A sg13g2_a21oi_1_3.A2 0.04163f
C159 sg13g2_a21oi_1_0.B1 a_24923_15996# 0.01159f
C160 sg13g2_dfrbpq_1_2.CLK a_9963_15356# 0.0255f
C161 sg13g2_or3_1_1.A a_25094_14484# 0.02191f
C162 sg13g2_dfrbpq_1_5.RESET_B a_25862_13722# 0.11114f
C163 a_6540_13238# sg13g2_xnor2_1_2.A 0.12443f
C164 sg13g2_dfrbpq_1_6.D sg13g2_or3_1_2.A 0.012f
C165 a_16356_13735# a_16068_14040# 0.22255f
C166 a_17710_15423# a_17825_15424# 0.32411f
C167 a_25109_12972# VDD 0.17892f
C168 sg13g2_dlygate4sd3_1_4.X a_18021_14495# 0.03797f
C169 sg13g2_buf_16_2.A a_15022_14484# 0.93576f
C170 a_24824_15238# sg13g2_o21ai_1_3.Y 0.02965f
C171 a_38720_13854# VDD 0.05657f
C172 a_3209_16334# sg13g2_dfrbpq_1_0.RESET_B 0.01018f
C173 sg13g2_dfrbpq_1_2.CLK sg13g2_xnor2_1_2.B 0.02517f
C174 sg13g2_dfrbpq_1_6.RESET_B a_21185_15424# 0.04653f
C175 a_2630_15234# VDD 0.45695f
C176 a_9737_14822# sg13g2_dlygate4sd3_1_8.X 0.01437f
C177 sg13g2_dfrbpq_1_3.D sg13g2_a21oi_1_0.A1 0.27735f
C178 sg13g2_and2_1_2.X VDD 0.28425f
C179 sg13g2_or3_1_1.C sg13g2_or3_1_1.B 0.07619f
C180 sg13g2_dfrbpq_1_2.Q sg13g2_dlygate4sd3_1_5.A 0.31903f
C181 sg13g2_or3_1_1.B sg13g2_a21oi_1_0.Y 0.0255f
C182 sg13g2_a21oi_1_0.A1 a_17318_14922# 0.04479f
C183 a_27882_14484# VDD 0.24179f
C184 a_4081_15311# sg13g2_buf_1_0.X 0.01018f
C185 a_6575_13342# sg13g2_xnor2_1_2.A 0.01685f
C186 sg13g2_dfrbpq_1_7.Q a_25956_14488# 0.03205f
C187 counter_value_o[3] VDD 0.07567f
C188 a_10222_14751# VDD 0.14578f
C189 a_21827_13690# sg13g2_or3_1_2.B 0.15791f
C190 sg13g2_a21oi_1_0.B1 a_15782_13722# 0.03545f
C191 sg13g2_buf_1_10.X a_10337_14750# 0.01922f
C192 sg13g2_dfrbpq_1_2.CLK a_9732_15247# 0.0108f
C193 a_2516_14484# sg13g2_xor2_1_0.B 0.01121f
C194 a_9963_15356# a_9732_15247# 0.06628f
C195 a_9444_15552# a_10609_15311# 0.22369f
C196 sg13g2_dlygate4sd3_1_8.X sg13g2_nand3_1_0.Y 0.31485f
C197 a_27664_13942# VDD 0.1286f
C198 sg13g2_a21oi_1_3.A1 a_24841_13726# 0.05013f
C199 a_26475_14495# a_26373_14495# 0.27006f
C200 a_5886_15486# sg13g2_dfrbpq_1_1.RESET_B 0.03904f
C201 a_5687_15315# a_5687_15549# 0.06917f
C202 a_24824_15238# a_25094_15238# 0.15158f
C203 sg13g2_dfrbpq_1_0.RESET_B a_2890_15457# 0.16024f
C204 a_22508_15960# VDD 0.19766f
C205 sg13g2_o21ai_1_2.B1 a_24169_14508# 0.20427f
C206 sg13g2_buf_1_10.X sg13g2_dlygate4sd3_1_8.X 0.01594f
C207 a_15680_13854# sg13g2_dfrbpq_1_2.D 0.01953f
C208 sg13g2_a21oi_1_3.A1 sg13g2_a21oi_1_3.A2 0.1362f
C209 sg13g2_a21oi_1_1.Y sg13g2_dlygate4sd3_1_11.X 0.0618f
C210 sg13g2_and2_1_2.B a_8685_14832# 0.14585f
C211 sg13g2_o21ai_1_2.A2 sg13g2_dfrbpq_1_6.Q 0.21694f
C212 a_26122_13945# a_26148_14040# 0.21121f
C213 sg13g2_xnor2_1_2.A sg13g2_nand4_1_0.Y 0.05046f
C214 a_7829_15238# sg13g2_dlygate4sd3_1_8.X 0.01415f
C215 a_22030_15423# sg13g2_or3_1_2.A 0.08842f
C216 counter_value_o[7] VDD 0.10064f
C217 a_16068_14040# a_16587_13844# 0.18372f
C218 sg13g2_dlygate4sd3_1_17.A VDD 0.26324f
C219 a_2916_15552# sg13g2_xor2_1_0.B 0.01389f
C220 sg13g2_a21oi_1_1.Y a_20603_15532# 0.08543f
C221 sg13g2_xnor2_1_2.A a_7937_13912# 0.01338f
C222 sg13g2_o21ai_1_2.B1 sg13g2_or3_1_2.B 0.49052f
C223 a_18593_13912# VDD 0.23617f
C224 sg13g2_or3_1_2.B a_17604_14488# 0.0296f
C225 a_38536_13854# a_38720_13854# 0.0262f
C226 sg13g2_dfrbpq_1_3.RESET_B sg13g2_dlygate4sd3_1_5.A 0.08365f
C227 sg13g2_dfrbpq_1_6.Q counter_value_o[5] 0.01037f
C228 a_7822_13911# VDD 0.14769f
C229 sg13g2_buf_1_10.X sg13g2_and2_1_1.X 0.03778f
C230 sg13g2_and2_1_0.B sg13g2_and2_1_0.X 0.24209f
C231 sg13g2_dfrbpq_1_2.RESET_B a_15782_13722# 0.09971f
C232 a_8582_15238# VDD 0.19847f
C233 a_2890_15457# a_3333_15213# 0.02242f
C234 sg13g2_buf_16_2.X a_18863_14845# 0.01524f
C235 a_1192_3900# enable_i 0.1635f
C236 a_38720_3986# VDD 0.0582f
C237 sg13g2_dlygate4sd3_1_11.X a_20603_15532# 0.05486f
C238 a_4193_14750# VDD 0.19937f
C239 a_27617_15424# sg13g2_dfrbpq_1_6.Q 0.04448f
C240 clock_i a_14357_15238# 0.01611f
C241 a_24841_13726# sg13g2_a21oi_1_3.A2 0.05589f
C242 a_25930_14452# sg13g2_buf_16_2.X 0.014f
C243 a_17219_16265# sg13g2_xnor2_1_1.A 0.151f
C244 sg13g2_or3_1_1.A sg13g2_dfrbpq_1_5.RESET_B 0.02342f
C245 a_2824_16082# sg13g2_dlygate4sd3_1_3.A 0.02159f
C246 a_16648_13058# sg13g2_a21oi_1_0.Y 0.01132f
C247 sg13g2_dfrbpq_1_7.Q a_27121_14845# 0.02056f
C248 a_17233_13799# sg13g2_a21oi_1_0.A1 0.01852f
C249 sg13g2_o21ai_1_2.B1 sg13g2_or3_1_1.B 0.02119f
C250 sg13g2_or3_1_1.B a_17604_14488# 0.01152f
C251 sg13g2_a21oi_1_3.Y sg13g2_buf_16_2.X 0.05642f
C252 a_26170_16237# a_26373_16033# 0.01313f
C253 sg13g2_dlygate4sd3_1_1.A sg13g2_nand4_1_0.Y 0.05609f
C254 sg13g2_tiehi_1.L_HI sg13g2_and2_1_2.X 0.05708f
C255 a_6680_15242# sg13g2_nand3_1_0.Y 0.01426f
C256 sg13g2_dfrbpq_1_2.RESET_B a_16079_15238# 0.01657f
C257 a_21824_15366# VDD 0.07792f
C258 sg13g2_dfrbpq_1_2.CLK VDD 2.1153f
C259 sg13g2_dfrbpq_1_7.D a_25670_14922# 0.1564f
C260 a_9963_15356# VDD 0.20509f
C261 sg13g2_dfrbpq_1_0.RESET_B a_4175_15311# 0.07619f
C262 sg13g2_a21oi_1_3.A1 VDD 0.27978f
C263 a_27215_14845# a_27882_14484# 0.06982f
C264 sg13g2_or3_1_2.A a_21060_14488# 0.02629f
C265 sg13g2_dfrbpq_1_2.CLK a_10960_15454# 0.01154f
C266 a_26757_16033# VDD 0.06812f
C267 a_9963_15356# a_10960_15454# 0.01528f
C268 sg13g2_xnor2_1_2.B VDD 0.59203f
C269 sg13g2_dlygate4sd3_1_1.A a_7937_13912# 0.02054f
C270 a_17327_13799# VDD 0.17791f
C271 sg13g2_a21oi_1_1.Y VDD 0.42567f
C272 a_22145_15424# sg13g2_dfrbpq_1_3.Q 0.01468f
C273 a_27898_15202# sg13g2_dfrbpq_1_5.Q 0.23317f
C274 sg13g2_buf_1_0.X sg13g2_dfrbpq_1_2.CLK 0.0484f
C275 sg13g2_dfrbpq_1_2.CLK sg13g2_a21oi_1_0.A2 0.12055f
C276 sg13g2_xnor2_1_0.Y VDD 0.29558f
C277 sg13g2_dlygate4sd3_1_4.X sg13g2_dlygate4sd3_1_5.A 0.08178f
C278 a_27407_13799# a_27664_13942# 0.20069f
C279 sg13g2_buf_1_0.X sg13g2_xnor2_1_2.B 0.21353f
C280 sg13g2_or3_1_2.B a_23638_14862# 0.05378f
C281 a_8694_15302# sg13g2_dlygate4sd3_1_8.X 0.01396f
C282 sg13g2_o21ai_1_2.Y sg13g2_or3_1_1.A 0.03611f
C283 sg13g2_dlygate4sd3_1_11.X VDD 0.17474f
C284 a_24841_13726# VDD 0.25729f
C285 clock_i sg13g2_buf_16_2.A 0.04835f
C286 a_16042_13945# VDD 0.09632f
C287 sg13g2_or3_1_1.B a_14357_15238# 0.23255f
C288 a_1192_9948# reset_n_i 0.16635f
C289 a_18552_15552# sg13g2_dlygate4sd3_1_5.A 0.01075f
C290 sg13g2_a21oi_1_3.A2 VDD 0.33856f
C291 a_20603_15532# VDD 0.1404f
C292 sg13g2_o21ai_1_3.Y a_25505_16262# 0.02432f
C293 a_6789_14495# a_6660_14909# 0.01562f
C294 a_6372_14488# a_6891_14495# 0.18362f
C295 sg13g2_a21oi_1_3.A1 a_25203_13320# 0.01166f
C296 sg13g2_buf_1_10.X sg13g2_xor2_1_0.B 2.35712f
C297 sg13g2_xnor2_1_1.A sg13g2_or3_1_2.B 0.90871f
C298 sg13g2_dfrbpq_1_2.Q sg13g2_dfrbpq_1_6.D 0.01333f
C299 sg13g2_dfrbpq_1_2.Q a_17604_14488# 0.01326f
C300 a_16254_15934# sg13g2_or3_1_2.B 0.02856f
C301 a_2630_15234# a_3435_15356# 0.06896f
C302 a_22319_14845# a_21060_14488# 0.01303f
C303 sg13g2_dlygate4sd3_1_17.A sg13g2_buf_16_2.X 0.02642f
C304 sg13g2_or3_1_2.B sg13g2_buf_16_2.A 0.09344f
C305 a_21579_14495# VDD 0.20436f
C306 a_2890_15457# sg13g2_dlygate4sd3_1_3.A 0.01365f
C307 sg13g2_or3_1_2.C a_21579_14495# 0.03172f
C308 a_20774_14922# a_21579_14495# 0.06896f
C309 sg13g2_or3_1_2.B a_18769_14845# 0.01335f
C310 a_9536_14570# VDD 0.08891f
C311 sg13g2_or3_1_2.B a_18106_15202# 0.01362f
C312 a_6891_14495# a_7631_14845# 0.15395f
C313 sg13g2_dfrbpq_1_2.CLK sg13g2_tiehi_1.L_HI 0.03984f
C314 a_26753_15424# VDD 0.19793f
C315 sg13g2_tiehi_1.L_HI a_9963_15356# 0.21479f
C316 sg13g2_buf_1_10.X a_7888_14726# 0.01431f
C317 clock_i counter_value_o[0] 0.04192f
C318 a_6086_14922# a_6789_14495# 0.02432f
C319 sg13g2_or3_1_1.B sg13g2_xnor2_1_1.A 0.33936f
C320 a_22025_16334# a_21946_16237# 0.08074f
C321 sg13g2_or3_1_1.X sg13g2_o21ai_1_3.Y 0.02772f
C322 sg13g2_o21ai_1_2.Y sg13g2_or3_1_1.C 0.11919f
C323 sg13g2_a21oi_1_0.B1 sg13g2_nand4_1_0.Y 0.01895f
C324 a_16055_16071# VDD 0.07703f
C325 a_26436_13735# a_25862_13722# 0.16388f
C326 a_27664_13942# a_26667_13844# 0.01528f
C327 sg13g2_or3_1_1.B sg13g2_buf_16_2.A 0.26884f
C328 a_6086_14922# sg13g2_xnor2_1_2.A 0.01665f
C329 a_26638_15423# a_26753_15424# 0.32411f
C330 a_9444_15552# sg13g2_nand4_1_0.Y 0.01007f
C331 a_20774_14922# VDD 0.44665f
C332 sg13g2_or3_1_2.C VDD 0.52101f
C333 sg13g2_or3_1_2.C a_20774_14922# 0.01787f
C334 sg13g2_dfrbpq_1_3.RESET_B a_17604_14488# 0.25194f
C335 a_27500_15960# sg13g2_dfrbpq_1_6.Q 0.16405f
C336 sg13g2_dfrbpq_1_2.Q a_22030_15423# 0.01328f
C337 a_26757_16033# a_26633_16334# 0.06917f
C338 sg13g2_buf_1_10.X a_8685_14832# 0.10246f
C339 a_38536_3986# a_38720_3986# 0.0262f
C340 sg13g2_buf_1_10.X a_1856_14570# 0.01077f
C341 a_10960_15454# VDD 0.1272f
C342 a_19120_14726# VDD 0.13612f
C343 sg13g2_o21ai_1_2.B1 sg13g2_dfrbpq_1_5.RESET_B 0.11618f
C344 a_21166_16263# a_21281_16262# 0.32411f
C345 a_10703_15311# a_11370_15532# 0.06982f
C346 a_18123_14495# a_18863_14845# 0.15395f
C347 sg13g2_buf_1_0.X VDD 3.3943f
C348 sg13g2_dfrbpq_1_7.RESET_B sg13g2_dfrbpq_1_5.RESET_B 0.07505f
C349 a_17604_14488# a_18021_14495# 0.22698f
C350 sg13g2_a21oi_1_0.A2 VDD 0.45012f
C351 sg13g2_a21oi_1_3.A1 sg13g2_buf_16_2.X 0.02979f
C352 sg13g2_dfrbpq_1_7.RESET_B a_25786_15960# 0.02937f
C353 a_26638_15423# VDD 0.14479f
C354 a_17233_13799# a_17327_13799# 0.15029f
C355 sg13g2_a21oi_1_1.Y sg13g2_dfrbpq_1_6.RESET_B 0.11318f
C356 a_25094_15238# sg13g2_or3_1_1.X 0.06671f
C357 sg13g2_dfrbpq_1_7.D sg13g2_a21oi_1_0.B1 0.24792f
C358 a_25670_14922# a_25930_14452# 0.39302f
C359 sg13g2_a21oi_1_0.B1 sg13g2_dlygate4sd3_1_12.X 0.03482f
C360 a_4175_15311# sg13g2_dlygate4sd3_1_3.A 0.04306f
C361 sg13g2_a21oi_1_3.Y a_25670_14922# 0.04943f
C362 sg13g2_dfrbpq_1_1.RESET_B a_6086_14922# 0.07473f
C363 sg13g2_nand4_1_0.Y a_7680_15549# 0.0137f
C364 sg13g2_dfrbpq_1_3.D VDD 0.1813f
C365 a_26170_15202# sg13g2_a21oi_1_3.Y 0.23489f
C366 sg13g2_xnor2_1_2.B sg13g2_dlygate4sd3_1_0.A 0.3143f
C367 a_5896_13854# a_6080_13854# 0.0262f
C368 a_6286_13911# a_6401_13912# 0.32411f
C369 counter_value_o[0] a_2248_16082# 0.02118f
C370 sg13g2_dfrbpq_1_2.CLK a_9861_15213# 0.16791f
C371 a_9861_15213# a_9963_15356# 0.26919f
C372 a_3435_15356# sg13g2_dfrbpq_1_2.CLK 0.01615f
C373 a_18478_13911# sg13g2_dlygate4sd3_1_4.X 0.08936f
C374 a_17318_14922# VDD 0.45251f
C375 a_24365_14508# a_24169_14508# 0.01473f
C376 sg13g2_dfrbpq_1_2.Q sg13g2_xnor2_1_1.A 0.02303f
C377 sg13g2_dfrbpq_1_5.RESET_B a_26122_13945# 0.16732f
C378 a_16356_13735# a_15782_13722# 0.16388f
C379 sg13g2_dfrbpq_1_2.CLK sg13g2_dfrbpq_1_2.D 0.01523f
C380 a_5886_15486# sg13g2_dlygate4sd3_1_3.A 0.02682f
C381 sg13g2_dlygate4sd3_1_4.X a_17604_14488# 0.01684f
C382 a_24408_15552# sg13g2_o21ai_1_3.Y 0.01296f
C383 a_1192_9948# sg13g2_buf_1_10.X 0.13353f
C384 sg13g2_a21oi_1_0.A2 sg13g2_dfrbpq_1_3.D 0.06203f
C385 a_38536_13854# VDD 0.13407f
C386 sg13g2_o21ai_1_2.Y sg13g2_o21ai_1_2.B1 0.50117f
C387 sg13g2_a21oi_1_0.B1 sg13g2_or3_1_2.X 0.01794f
C388 sg13g2_dfrbpq_1_6.D sg13g2_o21ai_1_1.Y 0.08601f
C389 sg13g2_a21oi_1_3.A2 sg13g2_buf_16_2.X 0.01097f
C390 a_17710_15423# sg13g2_a21oi_1_0.A1 0.08833f
C391 sg13g2_a21oi_1_0.A2 a_17318_14922# 0.01109f
C392 sg13g2_dfrbpq_1_2.Q sg13g2_buf_16_2.A 0.29333f
C393 sg13g2_or3_1_1.C sg13g2_or3_1_1.A 0.15198f
C394 sg13g2_dfrbpq_1_2.Q a_18106_15202# 0.0323f
C395 a_21562_15960# sg13g2_a21oi_1_1.Y 0.23311f
C396 a_27215_14845# VDD 0.17504f
C397 a_9861_14521# VDD 0.06515f
C398 a_19438_13726# sg13g2_or3_1_2.B 0.02802f
C399 a_16955_12972# sg13g2_a21oi_1_0.A1 0.0581f
C400 sg13g2_tiehi_1.L_HI VDD 0.9788f
C401 a_20705_15260# sg13g2_dlygate4sd3_1_11.X 0.0127f
C402 a_18298_16237# a_18501_16033# 0.01313f
C403 a_9861_15213# a_9732_15247# 0.01562f
C404 sg13g2_dfrbpq_1_6.RESET_B a_21579_14495# 0.21475f
C405 sg13g2_tiehi_1.L_HI a_10960_15454# 0.06198f
C406 a_27407_13799# VDD 0.17779f
C407 sg13g2_dfrbpq_1_3.D a_17318_14922# 0.17002f
C408 a_26244_14909# a_26373_14495# 0.01562f
C409 a_26475_14495# a_25956_14488# 0.18362f
C410 a_5687_15315# a_5600_15366# 0.01514f
C411 a_5886_15486# a_5687_15549# 0.08074f
C412 a_22149_16033# VDD 0.06317f
C413 sg13g2_buf_16_2.X a_21579_14495# 0.02276f
C414 a_17900_15960# counter_value_o[3] 0.13353f
C415 sg13g2_dfrbpq_1_2.RESET_B a_17584_13942# 0.06198f
C416 sg13g2_a21oi_1_3.A1 a_25206_14508# 0.04785f
C417 sg13g2_and2_1_0.B sg13g2_xor2_1_0.B 0.0645f
C418 sg13g2_dfrbpq_1_3.RESET_B sg13g2_xnor2_1_1.A 0.01959f
C419 a_26122_13945# a_25862_13722# 0.39302f
C420 a_21466_15202# sg13g2_or3_1_2.A 0.01933f
C421 a_15782_13722# a_16587_13844# 0.06896f
C422 a_16068_14040# a_16485_13701# 0.22605f
C423 a_26633_16334# VDD 0.09032f
C424 a_19438_13726# sg13g2_or3_1_1.B 0.02479f
C425 a_24824_15238# sg13g2_o21ai_1_2.Y 0.2216f
C426 a_22508_15960# sg13g2_dfrbpq_1_3.Q 0.16116f
C427 sg13g2_xnor2_1_2.A a_7822_13911# 0.09254f
C428 sg13g2_dfrbpq_1_3.RESET_B sg13g2_buf_16_2.A 0.03602f
C429 sg13g2_dfrbpq_1_6.RESET_B VDD 1.10538f
C430 sg13g2_dfrbpq_1_6.RESET_B sg13g2_or3_1_2.C 0.02588f
C431 sg13g2_dfrbpq_1_6.RESET_B a_20774_14922# 0.07618f
C432 sg13g2_dfrbpq_1_3.RESET_B a_18106_15202# 0.06785f
C433 a_27296_16082# counter_value_o[5] 0.01377f
C434 sg13g2_buf_1_10.X a_5613_14832# 0.0879f
C435 sg13g2_dfrbpq_1_6.Q sg13g2_a21oi_1_3.Y 0.01465f
C436 sg13g2_buf_16_2.X VDD 2.1036f
C437 a_3204_15247# a_2630_15234# 0.16388f
C438 sg13g2_buf_16_2.X a_20774_14922# 0.0492f
C439 sg13g2_buf_16_2.X sg13g2_or3_1_2.C 0.11834f
C440 sg13g2_dfrbpq_1_2.CLK a_6789_14495# 0.17873f
C441 sg13g2_dfrbpq_1_5.RESET_B a_26373_14495# 0.01256f
C442 sg13g2_o21ai_1_2.Y a_23638_14862# 0.04934f
C443 sg13g2_buf_16_2.X a_19120_14726# 0.01083f
C444 a_2890_15457# a_2916_15552# 0.21121f
C445 a_18021_14495# a_18769_14845# 0.01058f
C446 a_38536_3986# VDD 0.13142f
C447 a_3872_14570# VDD 0.09046f
C448 a_27502_15423# sg13g2_dfrbpq_1_6.Q 0.05691f
C449 counter_value_o[1] VDD 0.1011f
C450 a_2490_14447# a_2516_14484# 0.19823f
C451 sg13g2_dlygate4sd3_1_0.A VDD 0.29218f
C452 sg13g2_dlygate4sd3_1_8.A a_10609_15311# 0.0175f
C453 sg13g2_dfrbpq_1_7.Q a_27882_14484# 0.09063f
C454 sg13g2_o21ai_1_2.B1 sg13g2_or3_1_1.A 0.02645f
C455 sg13g2_dfrbpq_1_2.CLK sg13g2_xnor2_1_2.A 0.07286f
C456 sg13g2_dlygate4sd3_1_4.X sg13g2_xnor2_1_1.A 1.15556f
C457 sg13g2_or3_1_1.A sg13g2_dfrbpq_1_7.RESET_B 0.02537f
C458 a_3435_15356# VDD 0.23524f
C459 a_9861_15213# VDD 0.2425f
C460 a_27472_14726# a_27882_14484# 0.05221f
C461 a_25774_15423# VDD 0.14476f
C462 sg13g2_xnor2_1_2.A sg13g2_xnor2_1_2.B 0.26286f
C463 sg13g2_and2_1_0.X sg13g2_xor2_1_0.B 0.15539f
C464 sg13g2_or3_1_1.X a_25094_14484# 0.07158f
C465 sg13g2_or3_1_2.A a_21034_14452# 0.01483f
C466 sg13g2_dfrbpq_1_2.D VDD 0.41282f
C467 a_9963_15356# a_10703_15311# 0.15395f
C468 sg13g2_dfrbpq_1_2.CLK a_10703_15311# 0.01584f
C469 a_26667_13844# VDD 0.20564f
C470 sg13g2_dlygate4sd3_1_1.A a_7822_13911# 0.01018f
C471 sg13g2_a21oi_1_0.B1 sg13g2_a21oi_1_3.Y 0.62334f
C472 a_21562_15960# VDD 0.24998f
C473 sg13g2_dfrbpq_1_7.D sg13g2_dfrbpq_1_5.D 0.02975f
C474 sg13g2_dlygate4sd3_1_4.X sg13g2_buf_16_2.A 0.02678f
C475 sg13g2_buf_1_0.X a_3435_15356# 0.01811f
C476 sg13g2_a21oi_1_0.B1 sg13g2_a21oi_1_0.A1 0.06132f
C477 sg13g2_o21ai_1_1.Y a_21060_14488# 0.02926f
C478 sg13g2_dlygate4sd3_1_4.X a_18106_15202# 0.01815f
C479 sg13g2_or3_1_2.X a_21070_15423# 0.01158f
C480 sg13g2_dfrbpq_1_0.RESET_B a_2630_15234# 0.10111f
C481 sg13g2_a21oi_1_1.Y sg13g2_dfrbpq_1_3.Q 0.02214f
C482 a_2528_15366# sg13g2_and2_1_0.X 0.01658f
C483 sg13g2_dfrbpq_1_1.RESET_B sg13g2_dfrbpq_1_2.CLK 0.03839f
C484 sg13g2_buf_16_2.A sg13g2_nor2_1_0.B 0.03948f
C485 a_24824_15238# sg13g2_or3_1_1.A 0.04235f
C486 a_19450_15202# VDD 0.26028f
C487 a_2916_15552# a_4175_15311# 0.01303f
C488 clock_i a_12020_15202# 0.01451f
C489 sg13g2_dfrbpq_1_1.RESET_B sg13g2_xnor2_1_2.B 0.12585f
C490 sg13g2_dlygate4sd3_1_1.A sg13g2_dfrbpq_1_2.CLK 0.23936f
C491 sg13g2_o21ai_1_2.A2 a_24169_14508# 0.1504f
C492 a_21348_14909# a_21579_14495# 0.06628f
C493 a_25206_14508# VDD 0.14669f
C494 sg13g2_o21ai_1_2.B1 sg13g2_or3_1_1.C 0.41829f
C495 sg13g2_and2_1_2.B sg13g2_nand4_1_0.Y 0.03046f
C496 a_21070_15423# a_21185_15424# 0.32411f
C497 sg13g2_dfrbpq_1_6.Q sg13g2_dlygate4sd3_1_17.A 0.01208f
C498 sg13g2_dfrbpq_1_3.Q sg13g2_dlygate4sd3_1_11.X 0.01024f
C499 a_25786_15960# a_25505_16262# 0.15158f
C500 a_6372_14488# a_6660_14909# 0.22255f
C501 sg13g2_xnor2_1_1.A a_16556_15960# 0.0515f
C502 sg13g2_dfrbpq_1_2.Q a_22426_15202# 0.01336f
C503 a_4081_15311# a_3333_15213# 0.01058f
C504 sg13g2_dlygate4sd3_1_8.A a_12020_15202# 0.03257f
C505 sg13g2_dfrbpq_1_2.RESET_B sg13g2_a21oi_1_0.A1 0.02004f
C506 a_2630_15234# a_3333_15213# 0.02454f
C507 sg13g2_dfrbpq_1_7.RESET_B a_26170_16237# 0.03978f
C508 sg13g2_o21ai_1_2.A2 sg13g2_or3_1_2.B 0.22379f
C509 sg13g2_dfrbpq_1_5.Q a_28074_14020# 0.0702f
C510 sg13g2_dfrbpq_1_2.RESET_B a_16044_15424# 0.02643f
C511 sg13g2_dlygate4sd3_1_6.X counter_value_o[3] 0.01714f
C512 sg13g2_dfrbpq_1_2.Q a_17994_14020# 0.07084f
C513 a_12524_15960# VDD 0.19759f
C514 sg13g2_or3_1_2.B a_19530_14484# 0.01003f
C515 a_21060_14488# a_21477_14495# 0.22698f
C516 a_20774_14922# a_21348_14909# 0.16388f
C517 sg13g2_xnor2_1_1.A sg13g2_dlygate4sd3_1_5.A 0.04995f
C518 a_6789_14495# VDD 0.24443f
C519 sg13g2_or3_1_2.B a_17825_15424# 0.0189f
C520 a_6789_14495# a_7537_14845# 0.01058f
C521 sg13g2_tiehi_1.L_HI a_9861_15213# 0.02812f
C522 a_6086_14922# a_6372_14488# 0.21832f
C523 sg13g2_dfrbpq_1_6.RESET_B sg13g2_buf_16_2.X 0.05354f
C524 sg13g2_o21ai_1_2.A2 sg13g2_or3_1_1.B 0.01019f
C525 sg13g2_a21oi_1_0.B1 sg13g2_dlygate4sd3_1_17.A 0.22178f
C526 a_16068_14040# sg13g2_a21oi_1_0.Y 0.01493f
C527 sg13g2_xnor2_1_2.A VDD 0.70278f
C528 a_27407_13799# a_26667_13844# 0.15395f
C529 a_18106_15202# sg13g2_dlygate4sd3_1_5.A 0.218f
C530 a_20000_15366# VDD 0.07189f
C531 a_20278_14862# VDD 0.01106f
C532 sg13g2_a21oi_1_1.Y a_21946_16237# 0.0232f
C533 a_8298_14484# VDD 0.24177f
C534 sg13g2_or3_1_2.C a_20278_14862# 0.07436f
C535 sg13g2_dlygate4sd3_1_12.X sg13g2_o21ai_1_3.Y 0.0391f
C536 sg13g2_buf_1_10.X a_2490_14447# 0.01683f
C537 a_10703_15311# VDD 0.17802f
C538 a_18123_14495# VDD 0.22246f
C539 sg13g2_buf_1_0.X sg13g2_xnor2_1_2.A 0.13228f
C540 a_10703_15311# a_10960_15454# 0.20069f
C541 a_25670_14922# VDD 0.44677f
C542 a_18123_14495# a_19120_14726# 0.01569f
C543 sg13g2_dfrbpq_1_3.Q VDD 1.04345f
C544 sg13g2_dfrbpq_1_3.Q sg13g2_or3_1_2.C 0.15452f
C545 a_17900_15960# VDD 0.17597f
C546 a_26170_15202# VDD 0.24724f
C547 sg13g2_o21ai_1_2.B1 sg13g2_dfrbpq_1_7.RESET_B 0.0255f
C548 a_21562_15960# sg13g2_dfrbpq_1_6.RESET_B 0.03886f
C549 a_26667_13844# sg13g2_buf_16_2.X 0.04208f
C550 sg13g2_dlygate4sd3_1_8.A a_10618_14448# 0.23489f
C551 a_3130_16237# a_3333_16033# 0.01313f
C552 sg13g2_dfrbpq_1_1.RESET_B VDD 1.0757f
C553 clock_i sg13g2_nand4_1_0.Y 0.01585f
C554 sg13g2_and2_1_1.X sg13g2_xor2_1_0.B 0.01252f
C555 sg13g2_a21oi_1_0.B1 sg13g2_dfrbpq_1_2.CLK 1.22373f
C556 sg13g2_a21oi_1_3.A1 sg13g2_a21oi_1_0.B1 0.211f
C557 a_17710_15423# VDD 0.14816f
C558 sg13g2_xnor2_1_2.B a_6682_13690# 0.0104f
C559 a_8312_15238# a_8582_15238# 0.15158f
C560 sg13g2_dlygate4sd3_1_1.A VDD 0.93268f
C561 counter_value_o[0] a_2540_15960# 0.13349f
C562 sg13g2_xnor2_1_1.A sg13g2_a21oi_1_0.Y 0.01109f
C563 sg13g2_dlygate4sd3_1_1.A a_7537_14845# 0.01761f
C564 a_4432_15454# a_4842_15532# 0.05221f
C565 sg13g2_dlygate4sd3_1_17.A a_24824_14525# 0.23876f
C566 sg13g2_dfrbpq_1_1.RESET_B sg13g2_buf_1_0.X 0.1459f
C567 a_3333_15213# sg13g2_dfrbpq_1_2.CLK 0.15276f
C568 sg13g2_dfrbpq_1_2.CLK a_9444_15552# 0.07991f
C569 a_9444_15552# a_9963_15356# 0.18372f
C570 a_25206_15302# sg13g2_a21oi_1_3.A1 0.09698f
C571 a_14816_14570# VDD 0.07948f
C572 sg13g2_a21oi_1_3.Y sg13g2_dfrbpq_1_5.D 0.27264f
C573 a_25889_15424# VDD 0.19721f
C574 a_24263_14508# a_24169_14508# 0.02085f
C575 sg13g2_a21oi_1_1.Y sg13g2_a21oi_1_0.B1 0.24439f
C576 a_16955_12972# VDD 0.1743f
C577 a_22025_16334# counter_value_o[4] 0.0142f
C578 a_2630_15234# sg13g2_dlygate4sd3_1_3.A 0.03808f
C579 a_17318_14922# a_18123_14495# 0.06896f
C580 sg13g2_dlygate4sd3_1_8.A sg13g2_nand4_1_0.Y 0.02951f
C581 sg13g2_dfrbpq_1_2.Q sg13g2_o21ai_1_2.A2 0.03379f
C582 sg13g2_dlygate4sd3_1_1.A sg13g2_buf_1_0.X 0.20248f
C583 a_3209_16334# a_3333_16033# 0.06917f
C584 sg13g2_buf_16_2.A sg13g2_a21oi_1_0.Y 0.04908f
C585 sg13g2_dfrbpq_1_7.Q VDD 1.27189f
C586 a_25206_14508# sg13g2_buf_16_2.X 0.01182f
C587 sg13g2_dfrbpq_1_2.CLK a_8312_15238# 0.01097f
C588 sg13g2_dfrbpq_1_2.Q a_19530_14484# 0.01127f
C589 sg13g2_dfrbpq_1_2.Q a_17825_15424# 0.06162f
C590 a_16587_13844# a_17584_13942# 0.01528f
C591 a_16955_12972# sg13g2_a21oi_1_0.A2 0.04932f
C592 sg13g2_or3_1_2.X sg13g2_or3_1_2.A 0.19598f
C593 sg13g2_a21oi_1_0.B1 sg13g2_dlygate4sd3_1_11.X 0.12026f
C594 a_3204_15247# sg13g2_buf_1_0.X 0.0153f
C595 a_27472_14726# VDD 0.127f
C596 sg13g2_dfrbpq_1_6.Q a_26753_15424# 0.01043f
C597 sg13g2_a21oi_1_0.B1 a_16042_13945# 0.0142f
C598 sg13g2_buf_1_10.X a_10618_14448# 0.01705f
C599 a_9418_15457# VDD 0.09803f
C600 a_18377_16334# a_18501_16033# 0.06917f
C601 sg13g2_dfrbpq_1_2.CLK a_16760_15238# 0.01208f
C602 a_4078_14751# sg13g2_xor2_1_0.B 0.09774f
C603 a_9444_15552# a_9732_15247# 0.22255f
C604 sg13g2_dfrbpq_1_2.RESET_B sg13g2_dfrbpq_1_2.CLK 0.04031f
C605 sg13g2_o21ai_1_2.B1 a_23638_14862# 0.02181f
C606 a_8312_15238# sg13g2_xnor2_1_0.Y 0.24455f
C607 sg13g2_a21oi_1_0.B1 a_20603_15532# 0.0369f
C608 sg13g2_tiehi_1.L_HI a_10703_15311# 0.07574f
C609 a_26244_14909# a_25956_14488# 0.22255f
C610 a_21946_16237# VDD 0.09438f
C611 sg13g2_dfrbpq_1_2.RESET_B a_17327_13799# 0.07574f
C612 sg13g2_or3_1_1.B sg13g2_nand4_1_0.Y 0.01128f
C613 sg13g2_nand3_1_0.Y sg13g2_nand4_1_0.Y 0.02354f
C614 sg13g2_dfrbpq_1_6.Q VDD 0.75651f
C615 a_15782_13722# a_16485_13701# 0.02454f
C616 a_26249_16334# VDD 0.0679f
C617 sg13g2_xnor2_1_0.Y a_7680_15549# 0.11855f
C618 sg13g2_buf_1_10.X sg13g2_nand4_1_0.Y 0.51312f
C619 a_21466_15202# sg13g2_o21ai_1_1.Y 0.23998f
C620 sg13g2_dfrbpq_1_0.RESET_B VDD 1.09735f
C621 sg13g2_dfrbpq_1_3.RESET_B a_17825_15424# 0.01582f
C622 sg13g2_or3_1_1.A sg13g2_or3_1_1.X 0.5864f
C623 sg13g2_dfrbpq_1_6.D a_21060_14488# 0.01147f
C624 sg13g2_dfrbpq_1_2.RESET_B a_16042_13945# 0.16623f
C625 sg13g2_dfrbpq_1_2.CLK a_6372_14488# 0.08448f
C626 sg13g2_xnor2_1_2.A sg13g2_dlygate4sd3_1_0.A 0.07816f
C627 sg13g2_dfrbpq_1_5.RESET_B a_25956_14488# 0.01475f
C628 sg13g2_buf_16_2.A a_17604_14488# 0.01468f
C629 a_32492_15960# counter_value_o[6] 0.13349f
C630 a_17604_14488# a_18769_14845# 0.22369f
C631 sg13g2_buf_16_2.X a_18123_14495# 0.01496f
C632 sg13g2_dfrbpq_1_0.RESET_B sg13g2_buf_1_0.X 0.03161f
C633 a_1192_3900# VDD 0.16521f
C634 sg13g2_dfrbpq_1_6.RESET_B sg13g2_dfrbpq_1_3.Q 0.02974f
C635 a_2942_14484# VDD 0.0112f
C636 a_6682_13690# VDD 0.26449f
C637 sg13g2_buf_1_10.X sg13g2_dlygate4sd3_1_0.X 0.04143f
C638 a_25670_14922# sg13g2_buf_16_2.X 0.01856f
C639 a_2824_16082# a_2540_15960# 0.01226f
C640 a_16079_15238# sg13g2_nor2_1_0.B 0.02071f
C641 a_6372_14488# sg13g2_xnor2_1_2.B 0.03107f
C642 sg13g2_or3_1_2.B sg13g2_or3_1_2.X 0.02851f
C643 sg13g2_dfrbpq_1_3.Q sg13g2_buf_16_2.X 0.01184f
C644 sg13g2_dfrbpq_1_7.Q a_27215_14845# 0.0476f
C645 sg13g2_dlygate4sd3_1_8.X a_10016_14570# 0.01244f
C646 sg13g2_dfrbpq_1_7.RESET_B a_26373_14495# 0.02734f
C647 a_24824_14525# sg13g2_a21oi_1_3.A2 0.04809f
C648 sg13g2_a21oi_1_0.B1 VDD 1.6309f
C649 sg13g2_a21oi_1_0.B1 sg13g2_or3_1_2.C 0.12242f
C650 sg13g2_dfrbpq_1_2.CLK sg13g2_dlygate4sd3_1_3.A 0.04644f
C651 sg13g2_dlygate4sd3_1_6.X VDD 0.68479f
C652 a_1192_3900# sg13g2_buf_1_0.X 0.13726f
C653 sg13g2_and2_1_0.B a_2490_14447# 0.13073f
C654 a_9444_15552# VDD 0.07216f
C655 a_3333_15213# VDD 0.2987f
C656 a_25206_15302# VDD 0.14627f
C657 a_27472_14726# a_27215_14845# 0.20069f
C658 sg13g2_dfrbpq_1_3.RESET_B a_17578_14452# 0.15945f
C659 sg13g2_xnor2_1_2.B sg13g2_dlygate4sd3_1_3.A 0.1065f
C660 sg13g2_a21oi_1_0.B1 sg13g2_a21oi_1_0.A2 0.03598f
C661 a_26565_13701# VDD 0.25684f
C662 sg13g2_and2_1_2.B sg13g2_and2_1_2.X 0.11092f
C663 a_9418_15457# sg13g2_tiehi_1.L_HI 0.138f
C664 sg13g2_o21ai_1_2.A2 sg13g2_o21ai_1_2.Y 0.07474f
C665 sg13g2_or3_1_1.B sg13g2_or3_1_2.X 0.01231f
C666 sg13g2_buf_1_0.X a_3333_15213# 0.0155f
C667 a_17578_14452# a_18021_14495# 0.02242f
C668 a_17318_14922# a_17892_14909# 0.16388f
C669 a_8312_15238# VDD 0.26064f
C670 sg13g2_dfrbpq_1_2.Q a_18874_13690# 0.23954f
C671 sg13g2_dlygate4sd3_1_1.A counter_value_o[1] 0.01004f
C672 sg13g2_a21oi_1_3.A1 sg13g2_dfrbpq_1_5.D 0.0952f
C673 sg13g2_dfrbpq_1_2.RESET_B a_16055_16071# 0.0238f
C674 sg13g2_buf_16_2.A a_14357_15238# 0.03718f
C675 sg13g2_a21oi_1_0.B1 sg13g2_dfrbpq_1_3.D 0.02771f
C676 a_21946_16237# a_22149_16033# 0.01313f
C677 sg13g2_dfrbpq_1_7.Q sg13g2_buf_16_2.X 0.1299f
C678 a_16760_15238# VDD 0.26489f
C679 sg13g2_dfrbpq_1_2.RESET_B VDD 1.2048f
C680 a_19169_15424# VDD 0.20878f
C681 a_16587_13844# sg13g2_a21oi_1_0.A1 0.02992f
C682 a_23552_14570# VDD 0.06356f
C683 sg13g2_dlygate4sd3_1_11.X a_21070_15423# 0.08804f
C684 a_7680_15549# VDD 0.16888f
C685 a_27034_15202# a_26753_15424# 0.15158f
C686 a_24824_14525# VDD 0.24767f
C687 sg13g2_dfrbpq_1_2.CLK a_15022_14484# 0.02126f
C688 a_25774_15423# a_25889_15424# 0.32411f
C689 sg13g2_dfrbpq_1_3.Q a_19450_15202# 0.23338f
C690 a_25390_16263# a_25505_16262# 0.32411f
C691 sg13g2_dfrbpq_1_2.RESET_B sg13g2_a21oi_1_0.A2 0.02033f
C692 sg13g2_a21oi_1_0.A2 a_16760_15238# 0.02068f
C693 a_5613_14832# sg13g2_and2_1_1.X 0.06558f
C694 a_2490_14447# sg13g2_and2_1_0.X 0.05389f
C695 a_21946_16237# sg13g2_dfrbpq_1_6.RESET_B 0.04268f
C696 sg13g2_dfrbpq_1_2.Q a_22145_15424# 0.01321f
C697 a_4081_15311# a_2916_15552# 0.22369f
C698 a_3204_15247# a_3435_15356# 0.06628f
C699 sg13g2_dlygate4sd3_1_8.A a_11370_15532# 0.08686f
C700 a_2630_15234# a_2916_15552# 0.21832f
C701 a_27034_15202# VDD 0.24502f
C702 sg13g2_o21ai_1_3.Y sg13g2_dlygate4sd3_1_17.A 0.03767f
C703 sg13g2_and2_1_2.X a_9158_15234# 0.15383f
C704 a_22986_14484# VDD 0.2399f
C705 sg13g2_dfrbpq_1_6.Q sg13g2_buf_16_2.X 0.08503f
C706 sg13g2_and2_1_2.B a_8582_15238# 0.0171f
C707 a_17219_16265# counter_value_o[3] 0.04613f
C708 a_6789_14495# sg13g2_xnor2_1_2.A 0.02671f
C709 sg13g2_xnor2_1_1.A sg13g2_buf_16_2.A 0.03403f
C710 sg13g2_or3_1_2.B a_18863_14845# 0.0112f
C711 a_21034_14452# a_21477_14495# 0.02242f
C712 a_9658_14725# VDD 0.09878f
C713 a_6372_14488# VDD 0.07267f
C714 a_6372_14488# a_7537_14845# 0.22369f
C715 sg13g2_dfrbpq_1_2.Q a_18176_16082# 0.0133f
C716 sg13g2_tiehi_1.L_HI a_9444_15552# 0.25409f
C717 a_9418_15457# a_9861_15213# 0.02242f
C718 sg13g2_dfrbpq_1_2.Q sg13g2_or3_1_2.X 0.55313f
C719 sg13g2_dfrbpq_1_5.Q counter_value_o[7] 0.01279f
C720 a_6086_14922# a_6346_14452# 0.39302f
C721 sg13g2_or3_1_1.X a_25390_16263# 0.01101f
C722 a_24408_15552# sg13g2_or3_1_1.C 0.01167f
C723 sg13g2_or3_1_2.B sg13g2_a21oi_1_0.A1 0.0535f
C724 sg13g2_dfrbpq_1_2.CLK sg13g2_and2_1_2.B 0.03334f
C725 sg13g2_dlygate4sd3_1_3.A VDD 1.29077f
C726 sg13g2_o21ai_1_2.B1 sg13g2_or3_1_1.X 0.01957f
C727 sg13g2_or3_1_2.B a_16044_15424# 0.2091f
C728 a_22508_15960# counter_value_o[4] 0.13349f
C729 a_19816_15366# VDD 0.1293f
C730 sg13g2_a21oi_1_1.Y a_21281_16262# 0.02113f
C731 a_2824_16082# a_3008_16082# 0.0262f
C732 a_7631_14845# VDD 0.17592f
C733 a_21070_15423# VDD 0.14448f
C734 sg13g2_dfrbpq_1_6.RESET_B sg13g2_a21oi_1_0.B1 0.07941f
C735 a_7631_14845# a_7537_14845# 0.15029f
C736 sg13g2_dfrbpq_1_1.RESET_B a_6789_14495# 0.02792f
C737 sg13g2_buf_1_10.X a_1965_14832# 0.0959f
C738 sg13g2_a21oi_1_0.B1 sg13g2_buf_16_2.X 0.03661f
C739 sg13g2_buf_1_0.X sg13g2_dlygate4sd3_1_3.A 0.47572f
C740 sg13g2_dfrbpq_1_0.RESET_B a_3435_15356# 0.21832f
C741 sg13g2_dlygate4sd3_1_0.X a_6080_13854# 0.01464f
C742 a_6682_13690# sg13g2_dlygate4sd3_1_0.A 0.25819f
C743 a_22304_16082# VDD 0.07462f
C744 sg13g2_or3_1_1.B sg13g2_a21oi_1_0.A1 0.01449f
C745 sg13g2_dlygate4sd3_1_1.A a_6789_14495# 0.01353f
C746 sg13g2_dfrbpq_1_1.RESET_B sg13g2_xnor2_1_2.A 0.03758f
C747 a_26565_13701# sg13g2_buf_16_2.X 0.16278f
C748 sg13g2_dfrbpq_1_5.D VDD 0.3746f
C749 a_5687_15549# VDD 0.08388f
C750 sg13g2_dlygate4sd3_1_1.A sg13g2_xnor2_1_2.A 0.05164f
C751 a_21166_16263# sg13g2_dfrbpq_1_6.D 0.08802f
C752 a_24824_15238# sg13g2_or3_1_1.X 0.01443f
C753 a_25774_15423# sg13g2_a21oi_1_0.B1 0.01369f
C754 a_17142_15302# VDD 0.14644f
C755 sg13g2_or3_1_2.B counter_value_o[3] 0.02486f
C756 sg13g2_xnor2_1_2.B a_6401_13912# 0.03894f
C757 a_7240_16082# VDD 0.15543f
C758 sg13g2_dlygate4sd3_1_1.A a_8298_14484# 0.08812f
C759 sg13g2_o21ai_1_2.Y a_23736_14464# 0.01083f
C760 sg13g2_a21oi_1_0.B1 sg13g2_dfrbpq_1_2.D 0.1418f
C761 a_4175_15311# a_4842_15532# 0.06982f
C762 a_9158_15234# a_9963_15356# 0.06896f
C763 a_9444_15552# a_9861_15213# 0.22605f
C764 a_2916_15552# sg13g2_dfrbpq_1_2.CLK 0.06831f
C765 a_3333_15213# a_3435_15356# 0.26919f
C766 a_15022_14484# VDD 1.60271f
C767 a_21824_15366# sg13g2_or3_1_2.A 0.01244f
C768 a_9658_14725# a_9861_14521# 0.01313f
C769 sg13g2_tiehi_1.L_HI a_9658_14725# 0.05972f
C770 sg13g2_dfrbpq_1_2.Q a_23168_15366# 0.01296f
C771 sg13g2_a21oi_1_0.A2 a_17142_15302# 0.05123f
C772 a_15722_15532# sg13g2_dfrbpq_1_2.D 0.01398f
C773 sg13g2_dfrbpq_1_2.CLK a_16587_13844# 0.04115f
C774 a_17517_16020# a_17219_16265# 0.02085f
C775 a_32200_16082# VDD 0.1577f
C776 a_24824_14525# sg13g2_buf_16_2.X 0.01228f
C777 sg13g2_a21oi_1_0.A2 a_15022_14484# 0.01223f
C778 sg13g2_dfrbpq_1_2.Q a_18863_14845# 0.0389f
C779 a_26565_13701# a_26667_13844# 0.26919f
C780 a_25889_15424# a_26170_15202# 0.15158f
C781 sg13g2_buf_1_10.X sg13g2_and2_1_2.X 0.02114f
C782 a_16587_13844# a_17327_13799# 0.15395f
C783 sg13g2_dlygate4sd3_1_1.A sg13g2_dfrbpq_1_1.RESET_B 0.02037f
C784 a_26475_14495# VDD 0.20548f
C785 sg13g2_dfrbpq_1_2.CLK clock_i 0.06381f
C786 a_17142_15302# sg13g2_dfrbpq_1_3.D 0.0915f
C787 sg13g2_buf_1_10.X a_10222_14751# 0.01416f
C788 a_9158_15234# a_9732_15247# 0.16388f
C789 a_22986_14484# sg13g2_buf_16_2.X 0.01556f
C790 a_19232_13854# VDD 0.08101f
C791 sg13g2_dfrbpq_1_2.Q sg13g2_a21oi_1_0.A1 0.01894f
C792 sg13g2_or3_1_2.X sg13g2_o21ai_1_1.Y 0.29999f
C793 sg13g2_dfrbpq_1_2.RESET_B sg13g2_dfrbpq_1_2.D 0.12609f
C794 a_19438_13726# sg13g2_buf_16_2.A 0.38032f
C795 a_21281_16262# VDD 0.1966f
C796 sg13g2_and2_1_2.B VDD 0.20849f
C797 sg13g2_a21oi_1_3.Y a_26244_14909# 0.01171f
C798 a_27296_16082# VDD 0.09025f
C799 a_15782_13722# a_16068_14040# 0.21832f
C800 sg13g2_dlygate4sd3_1_8.A a_9963_15356# 0.02895f
C801 sg13g2_dfrbpq_1_2.CLK sg13g2_dlygate4sd3_1_8.A 0.21826f
C802 a_22149_16033# a_22304_16082# 0.01514f
C803 a_7532_15960# VDD 0.19909f
C804 sg13g2_dfrbpq_1_3.RESET_B a_18863_14845# 0.07576f
C805 sg13g2_dfrbpq_1_2.CLK sg13g2_or3_1_2.B 0.02793f
C806 sg13g2_o21ai_1_3.Y VDD 0.47829f
C807 sg13g2_dfrbpq_1_3.Q sg13g2_dfrbpq_1_6.Q 0.14356f
C808 sg13g2_o21ai_1_2.A2 sg13g2_o21ai_1_2.B1 0.141f
C809 sg13g2_dfrbpq_1_6.RESET_B a_21070_15423# 0.04947f
C810 a_19169_15424# a_19450_15202# 0.15158f
C811 sg13g2_dfrbpq_1_2.CLK a_6346_14452# 0.01501f
C812 a_10618_14448# a_10337_14750# 0.15158f
C813 sg13g2_xnor2_1_2.A a_6682_13690# 0.03717f
C814 sg13g2_or3_1_2.A a_21579_14495# 0.03717f
C815 sg13g2_dfrbpq_1_5.RESET_B a_25930_14452# 0.01484f
C816 a_17892_14909# a_18123_14495# 0.06628f
C817 a_38720_10034# VDD 0.0583f
C818 a_2516_14484# VDD 0.11861f
C819 sg13g2_dfrbpq_1_3.RESET_B sg13g2_a21oi_1_0.A1 0.0443f
C820 a_20376_14464# sg13g2_o21ai_1_1.Y 0.01075f
C821 sg13g2_dfrbpq_1_5.Q VDD 2.06714f
C822 sg13g2_dfrbpq_1_5.RESET_B sg13g2_a21oi_1_3.Y 0.45818f
C823 a_6401_13912# VDD 0.19923f
C824 a_6346_14452# sg13g2_xnor2_1_2.B 0.01549f
C825 sg13g2_dfrbpq_1_7.Q a_27472_14726# 0.01866f
C826 sg13g2_dfrbpq_1_2.CLK sg13g2_or3_1_1.B 0.05347f
C827 sg13g2_a21oi_1_3.A1 sg13g2_or3_1_1.B 0.01968f
C828 reset_n_i VDD 0.14413f
C829 sg13g2_dfrbpq_1_7.RESET_B a_25956_14488# 0.24038f
C830 a_24169_14508# sg13g2_a21oi_1_3.A2 0.10865f
C831 sg13g2_buf_1_0.X a_7160_15242# 0.01372f
C832 sg13g2_or3_1_2.X a_21477_14495# 0.01328f
C833 a_3435_15356# sg13g2_dlygate4sd3_1_3.A 0.02689f
C834 a_27407_13799# a_27313_13799# 0.15029f
C835 a_17219_16265# VDD 0.22747f
C836 sg13g2_and2_1_0.B a_1965_14832# 0.15967f
C837 sg13g2_dlygate4sd3_1_6.X a_18454_15230# 0.02287f
C838 sg13g2_buf_1_0.X a_2516_14484# 0.01269f
C839 sg13g2_dfrbpq_1_5.D sg13g2_buf_16_2.X 0.05288f
C840 a_2916_15552# VDD 0.0944f
C841 a_9158_15234# VDD 0.44786f
C842 a_26475_14495# a_27215_14845# 0.15395f
C843 a_25094_15238# VDD 0.19682f
C844 sg13g2_buf_1_10.X sg13g2_dfrbpq_1_2.CLK 1.89203f
C845 sg13g2_or3_1_2.A VDD 0.37342f
C846 sg13g2_or3_1_2.C sg13g2_or3_1_2.A 0.96406f
C847 sg13g2_a21oi_1_0.B1 a_25670_14922# 0.01363f
C848 a_15488_15366# VDD 0.09391f
C849 a_9444_15552# a_10703_15311# 0.01303f
C850 sg13g2_dfrbpq_1_3.Q sg13g2_a21oi_1_0.B1 0.64376f
C851 counter_value_o[4] VDD 0.08096f
C852 a_26148_14040# VDD 0.07815f
C853 sg13g2_xnor2_1_0.Y sg13g2_nand3_1_0.Y 0.04653f
C854 a_17219_16265# sg13g2_a21oi_1_0.A2 0.1092f
C855 sg13g2_dlygate4sd3_1_6.X a_17900_15960# 0.01332f
C856 sg13g2_dfrbpq_1_6.Q sg13g2_dfrbpq_1_7.Q 0.03786f
C857 a_16587_13844# VDD 0.20672f
C858 sg13g2_buf_1_10.X sg13g2_xnor2_1_2.B 0.01635f
C859 sg13g2_buf_1_0.X a_2916_15552# 0.04257f
C860 sg13g2_dlygate4sd3_1_8.X sg13g2_nand4_1_0.Y 0.18772f
C861 a_17578_14452# a_17604_14488# 0.21121f
C862 sg13g2_dfrbpq_1_2.Q a_18593_13912# 0.01147f
C863 a_6891_14495# a_7888_14726# 0.01569f
C864 a_7240_16082# counter_value_o[1] 0.02118f
C865 sg13g2_xnor2_1_1.A a_16079_15238# 0.01072f
C866 a_7829_15238# sg13g2_xnor2_1_0.Y 0.02071f
C867 sg13g2_a21oi_1_3.A1 a_25094_14484# 0.01721f
C868 a_2490_14447# sg13g2_xor2_1_0.B 0.1777f
C869 a_16587_13844# sg13g2_a21oi_1_0.A2 0.02061f
C870 sg13g2_or3_1_1.B a_24841_13726# 0.15246f
C871 clock_i VDD 1.71887f
C872 sg13g2_o21ai_1_2.A2 a_23638_14862# 0.08448f
C873 a_18298_16237# VDD 0.0957f
C874 a_19054_15423# VDD 0.16782f
C875 sg13g2_or3_1_1.B sg13g2_a21oi_1_3.A2 0.11499f
C876 a_23368_14570# VDD 0.12812f
C877 a_22319_14845# a_21579_14495# 0.15395f
C878 sg13g2_a21oi_1_0.B1 a_14816_14570# 0.0116f
C879 a_26475_14495# sg13g2_buf_16_2.X 0.04756f
C880 a_24169_14508# VDD 0.23388f
C881 sg13g2_dfrbpq_1_5.RESET_B a_27664_13942# 0.06198f
C882 a_6372_14488# a_6789_14495# 0.22698f
C883 sg13g2_dfrbpq_1_2.D a_15022_14484# 0.07177f
C884 a_1965_14832# sg13g2_and2_1_0.X 0.06463f
C885 sg13g2_dlygate4sd3_1_8.A VDD 0.79302f
C886 a_21281_16262# sg13g2_dfrbpq_1_6.RESET_B 0.02111f
C887 sg13g2_nor2_1_0.B a_16044_15424# 0.11846f
C888 a_3204_15247# a_3333_15213# 0.01562f
C889 sg13g2_dlygate4sd3_1_8.A a_10960_15454# 0.01969f
C890 a_26554_16237# a_26757_16033# 0.01313f
C891 a_22319_14845# VDD 0.1775f
C892 sg13g2_or3_1_2.B VDD 1.84716f
C893 sg13g2_dlygate4sd3_1_0.X sg13g2_and2_1_1.X 0.0464f
C894 sg13g2_or3_1_2.B sg13g2_or3_1_2.C 0.72288f
C895 sg13g2_or3_1_2.B a_20774_14922# 0.01258f
C896 a_8694_15302# a_8582_15238# 0.32411f
C897 a_6372_14488# sg13g2_xnor2_1_2.A 0.01991f
C898 a_25206_14508# sg13g2_dfrbpq_1_5.D 0.08875f
C899 a_9737_14822# VDD 0.07025f
C900 a_21034_14452# a_21060_14488# 0.21121f
C901 sg13g2_o21ai_1_2.A2 a_23480_15242# 0.01564f
C902 a_6346_14452# VDD 0.09666f
C903 sg13g2_dlygate4sd3_1_1.A a_7680_15549# 0.05793f
C904 sg13g2_tiehi_1.L_HI a_9158_15234# 0.08194f
C905 a_9418_15457# a_9444_15552# 0.21121f
C906 a_37192_16082# counter_value_o[7] 0.02118f
C907 a_12232_16082# VDD 0.15539f
C908 sg13g2_a21oi_1_0.A2 sg13g2_or3_1_2.B 0.04704f
C909 a_12020_15202# sg13g2_buf_16_2.A 0.35756f
C910 sg13g2_a21oi_1_0.B1 sg13g2_dfrbpq_1_6.Q 0.05405f
C911 sg13g2_or3_1_1.B VDD 1.64825f
C912 sg13g2_or3_1_1.B sg13g2_or3_1_2.C 0.04552f
C913 sg13g2_dfrbpq_1_2.Q sg13g2_dlygate4sd3_1_11.X 0.01953f
C914 sg13g2_nand3_1_0.Y VDD 0.64075f
C915 a_7532_15960# counter_value_o[1] 0.13349f
C916 a_2248_16082# VDD 0.15493f
C917 a_27407_13799# a_26148_14040# 0.01303f
C918 a_17825_15424# a_18106_15202# 0.15158f
C919 a_25956_14488# a_26373_14495# 0.22698f
C920 a_22149_16033# counter_value_o[4] 0.01278f
C921 a_21562_15960# a_21281_16262# 0.15158f
C922 a_19816_15366# a_20000_15366# 0.0262f
C923 sg13g2_or3_1_1.X a_24923_15996# 0.07721f
C924 sg13g2_dfrbpq_1_7.D sg13g2_o21ai_1_2.B1 0.02264f
C925 a_21827_13690# sg13g2_or3_1_2.X 0.10895f
C926 sg13g2_buf_1_10.X VDD 2.38024f
C927 sg13g2_dlygate4sd3_1_12.X a_25390_16263# 0.08969f
C928 a_7631_14845# a_8298_14484# 0.06982f
C929 sg13g2_or3_1_2.B sg13g2_dfrbpq_1_3.D 0.02299f
C930 sg13g2_dfrbpq_1_1.RESET_B a_6372_14488# 0.24833f
C931 sg13g2_or3_1_1.B sg13g2_a21oi_1_0.A2 0.02103f
C932 sg13g2_buf_1_0.X sg13g2_nand3_1_0.Y 0.1661f
C933 a_4474_14448# a_4193_14750# 0.15158f
C934 sg13g2_dfrbpq_1_0.RESET_B a_3333_15213# 0.03072f
C935 sg13g2_dlygate4sd3_1_0.X a_5896_13854# 0.01651f
C936 sg13g2_dfrbpq_1_7.D sg13g2_dfrbpq_1_7.RESET_B 0.07044f
C937 sg13g2_and2_1_0.X a_2630_15234# 0.17138f
C938 sg13g2_o21ai_1_2.Y sg13g2_dlygate4sd3_1_17.A 0.17641f
C939 sg13g2_or3_1_1.A sg13g2_a21oi_1_3.Y 0.01825f
C940 a_6401_13912# sg13g2_dlygate4sd3_1_0.A 0.04891f
C941 sg13g2_dfrbpq_1_6.RESET_B sg13g2_or3_1_2.A 0.0243f
C942 sg13g2_dfrbpq_1_3.Q a_19816_15366# 0.03367f
C943 sg13g2_dlygate4sd3_1_1.A a_6372_14488# 0.03089f
C944 sg13g2_buf_1_10.X sg13g2_buf_1_0.X 0.09818f
C945 sg13g2_buf_16_2.X sg13g2_or3_1_2.A 0.92322f
C946 sg13g2_dfrbpq_1_1.RESET_B sg13g2_dlygate4sd3_1_3.A 0.1263f
C947 a_27034_15202# sg13g2_dfrbpq_1_7.Q 0.23558f
C948 sg13g2_or3_1_1.A a_27502_15423# 0.10556f
C949 a_14357_15238# sg13g2_nand4_1_0.Y 0.20025f
C950 sg13g2_buf_16_2.A a_17578_14452# 0.01322f
C951 sg13g2_dfrbpq_1_2.CLK a_4474_14448# 0.01336f
C952 a_26148_14040# sg13g2_buf_16_2.X 0.04569f
C953 a_25094_14484# VDD 0.19616f
C954 sg13g2_or3_1_1.B sg13g2_dfrbpq_1_3.D 0.0105f
C955 a_5600_15366# VDD 0.08546f
C956 sg13g2_dlygate4sd3_1_8.A sg13g2_tiehi_1.L_HI 0.01957f
C957 sg13g2_dfrbpq_1_1.RESET_B a_7631_14845# 0.07576f
C958 a_27617_15424# a_27898_15202# 0.15158f
C959 sg13g2_dlygate4sd3_1_1.A sg13g2_dlygate4sd3_1_3.A 0.15297f
C960 sg13g2_dfrbpq_1_6.D sg13g2_or3_1_2.X 0.03748f
C961 a_25206_15302# sg13g2_a21oi_1_0.B1 0.02107f
C962 a_17030_15238# VDD 0.20101f
C963 sg13g2_dfrbpq_1_5.D a_25670_14922# 0.04176f
C964 sg13g2_dlygate4sd3_1_1.A a_7631_14845# 0.04253f
C965 a_4175_15311# a_4432_15454# 0.20069f
C966 a_2916_15552# a_3435_15356# 0.18372f
C967 a_9158_15234# a_9861_15213# 0.02454f
C968 a_14344_14570# VDD 0.149f
C969 a_9737_14822# a_9861_14521# 0.06917f
C970 sg13g2_dfrbpq_1_2.CLK a_11752_15366# 0.0107f
C971 sg13g2_tiehi_1.L_HI a_9737_14822# 0.02156f
C972 a_16648_13058# VDD 0.14279f
C973 sg13g2_a21oi_1_0.A2 a_17030_15238# 0.05498f
C974 a_26373_16033# VDD 0.06591f
C975 a_26554_16237# VDD 0.09432f
C976 sg13g2_dfrbpq_1_2.CLK a_16485_13701# 0.17413f
C977 sg13g2_dfrbpq_1_2.Q VDD 1.33956f
C978 sg13g2_dfrbpq_1_2.Q sg13g2_or3_1_2.C 0.12403f
C979 a_27121_14845# a_26373_14495# 0.01058f
C980 a_27034_15202# sg13g2_dfrbpq_1_6.Q 0.01444f
C981 clock_i counter_value_o[1] 0.04067f
C982 a_17428_16020# a_17219_16265# 0.01473f
C983 sg13g2_dfrbpq_1_6.Q a_22986_14484# 0.07301f
C984 a_21824_15366# sg13g2_o21ai_1_1.Y 0.01624f
C985 a_22145_15424# a_22030_15423# 0.32411f
C986 sg13g2_dfrbpq_1_2.Q a_19120_14726# 0.04689f
C987 a_26148_14040# a_26667_13844# 0.18372f
C988 sg13g2_dfrbpq_1_2.RESET_B sg13g2_a21oi_1_0.B1 0.08021f
C989 sg13g2_dlygate4sd3_1_6.X a_19169_15424# 0.01113f
C990 sg13g2_dfrbpq_1_6.RESET_B a_22319_14845# 0.07576f
C991 sg13g2_dfrbpq_1_6.RESET_B sg13g2_or3_1_2.B 0.02705f
C992 sg13g2_a21oi_1_0.Y sg13g2_a21oi_1_0.A1 0.0662f
C993 sg13g2_buf_16_2.A sg13g2_nand4_1_0.Y 0.04439f
C994 sg13g2_buf_1_10.X sg13g2_tiehi_1.L_HI 0.03108f
C995 a_22319_14845# sg13g2_buf_16_2.X 0.02039f
C996 sg13g2_or3_1_2.B sg13g2_buf_16_2.X 0.54805f
C997 clock_i sg13g2_dfrbpq_1_2.D 0.02877f
C998 a_3209_16334# a_3130_16237# 0.08074f
C999 a_16044_15424# sg13g2_a21oi_1_0.Y 0.01013f
C1000 a_26475_14495# a_25670_14922# 0.06896f
C1001 a_5886_15486# a_5687_15315# 0.01313f
C1002 sg13g2_dfrbpq_1_5.RESET_B a_26753_15424# 0.01106f
C1003 sg13g2_and2_1_1.X a_6086_14922# 0.16141f
C1004 a_24310_15230# sg13g2_o21ai_1_3.Y 0.04934f
C1005 sg13g2_or3_1_1.A sg13g2_dlygate4sd3_1_17.A 0.31702f
C1006 a_8694_15302# VDD 0.14464f
C1007 a_16042_13945# a_16485_13701# 0.02242f
C1008 sg13g2_dlygate4sd3_1_8.A a_9861_15213# 0.01043f
C1009 sg13g2_dfrbpq_1_6.RESET_B sg13g2_or3_1_1.B 0.01155f
C1010 sg13g2_dfrbpq_1_3.RESET_B VDD 1.09051f
C1011 sg13g2_dfrbpq_1_0.RESET_B sg13g2_dlygate4sd3_1_3.A 0.09578f
C1012 sg13g2_dfrbpq_1_2.Q a_17318_14922# 0.01185f
C1013 sg13g2_o21ai_1_2.Y sg13g2_a21oi_1_3.A2 0.04053f
C1014 sg13g2_or3_1_1.B sg13g2_buf_16_2.X 0.10814f
C1015 a_3333_16033# VDD 0.069f
C1016 sg13g2_dfrbpq_1_3.RESET_B a_19120_14726# 0.0605f
C1017 sg13g2_dfrbpq_1_5.RESET_B VDD 1.17237f
C1018 a_25786_15960# VDD 0.2497f
C1019 a_18021_14495# VDD 0.2588f
C1020 a_10222_14751# a_10337_14750# 0.32411f
C1021 a_17604_14488# a_18863_14845# 0.01303f
C1022 sg13g2_and2_1_2.X sg13g2_dlygate4sd3_1_8.X 0.01687f
C1023 a_4474_14448# VDD 0.27751f
C1024 a_37192_16082# VDD 0.15602f
C1025 sg13g2_dfrbpq_1_5.RESET_B a_26638_15423# 0.01353f
C1026 a_6080_13854# VDD 0.06917f
C1027 sg13g2_dfrbpq_1_7.Q a_26475_14495# 0.03272f
C1028 sg13g2_o21ai_1_2.B1 sg13g2_a21oi_1_3.Y 0.04338f
C1029 sg13g2_dlygate4sd3_1_8.X a_10222_14751# 0.08839f
C1030 sg13g2_dfrbpq_1_7.RESET_B a_25930_14452# 0.13229f
C1031 sg13g2_a21oi_1_3.A1 sg13g2_or3_1_1.A 0.07719f
C1032 sg13g2_or3_1_2.X a_21060_14488# 0.01695f
C1033 sg13g2_and2_1_0.B VDD 0.13822f
C1034 a_3333_15213# sg13g2_dlygate4sd3_1_3.A 0.01788f
C1035 sg13g2_dfrbpq_1_3.RESET_B sg13g2_dfrbpq_1_3.D 0.03729f
C1036 sg13g2_or3_1_1.B sg13g2_dfrbpq_1_2.D 0.01105f
C1037 sg13g2_a21oi_1_0.A1 a_17604_14488# 0.06395f
C1038 sg13g2_dfrbpq_1_7.RESET_B sg13g2_a21oi_1_3.Y 0.08143f
C1039 a_25094_14484# sg13g2_buf_16_2.X 0.01487f
C1040 a_6660_14909# sg13g2_xor2_1_0.B 0.02302f
C1041 a_26475_14495# a_27472_14726# 0.01569f
C1042 sg13g2_dfrbpq_1_3.RESET_B a_17318_14922# 0.112f
C1043 sg13g2_or3_1_2.A a_20278_14862# 0.02186f
C1044 a_7532_15960# sg13g2_dlygate4sd3_1_1.A 0.16114f
C1045 a_11752_15366# VDD 0.14612f
C1046 sg13g2_dlygate4sd3_1_4.X VDD 0.54414f
C1047 a_26554_16237# a_26633_16334# 0.08074f
C1048 a_25862_13722# VDD 0.45381f
C1049 a_7923_15532# sg13g2_nand3_1_0.Y 0.01013f
C1050 a_16485_13701# VDD 0.25184f
C1051 sg13g2_o21ai_1_2.Y VDD 0.3127f
C1052 sg13g2_o21ai_1_1.Y VDD 0.26566f
C1053 a_17318_14922# a_18021_14495# 0.02432f
C1054 sg13g2_or3_1_2.C sg13g2_o21ai_1_1.Y 0.07176f
C1055 sg13g2_o21ai_1_1.Y a_20774_14922# 0.02664f
C1056 sg13g2_a21oi_1_0.B1 sg13g2_dfrbpq_1_5.D 0.16949f
C1057 sg13g2_dfrbpq_1_2.Q sg13g2_dfrbpq_1_6.RESET_B 0.0154f
C1058 sg13g2_nor2_1_0.B VDD 0.26793f
C1059 sg13g2_dfrbpq_1_3.Q counter_value_o[4] 0.0101f
C1060 sg13g2_dlygate4sd3_1_4.X sg13g2_a21oi_1_0.A2 0.07378f
C1061 a_12524_15960# sg13g2_dlygate4sd3_1_8.A 0.16619f
C1062 a_16485_13701# sg13g2_a21oi_1_0.A2 0.03844f
C1063 sg13g2_dfrbpq_1_2.Q sg13g2_buf_16_2.X 0.4486f
C1064 a_22319_14845# a_22225_14845# 0.15029f
C1065 sg13g2_or3_1_1.A a_24841_13726# 0.18425f
C1066 a_18377_16334# VDD 0.09083f
C1067 a_18552_15552# VDD 0.01882f
C1068 a_16068_14040# sg13g2_a21oi_1_0.A1 0.02961f
C1069 a_8582_15238# sg13g2_dlygate4sd3_1_8.X 0.01811f
C1070 a_22576_14726# a_21579_14495# 0.01569f
C1071 sg13g2_or3_1_1.A sg13g2_a21oi_1_3.A2 0.21322f
C1072 sg13g2_a21oi_1_0.B1 a_15022_14484# 0.06939f
C1073 a_24310_15230# sg13g2_or3_1_2.B 0.07307f
C1074 sg13g2_dfrbpq_1_7.Q sg13g2_dfrbpq_1_5.Q 0.32979f
C1075 a_21477_14495# a_21579_14495# 0.27006f
C1076 sg13g2_dfrbpq_1_5.RESET_B a_27407_13799# 0.07574f
C1077 sg13g2_and2_1_0.X VDD 0.27413f
C1078 a_18298_16237# a_17900_15960# 0.01124f
C1079 a_6346_14452# a_6789_14495# 0.02242f
C1080 sg13g2_dfrbpq_1_2.CLK sg13g2_a21oi_1_0.Y 0.60224f
C1081 a_7937_13912# a_8218_13690# 0.15158f
C1082 a_3204_15247# a_2916_15552# 0.22255f
C1083 sg13g2_dlygate4sd3_1_8.A a_10703_15311# 0.05992f
C1084 a_16055_16301# a_16254_15934# 0.01313f
C1085 sg13g2_dfrbpq_1_2.CLK sg13g2_dlygate4sd3_1_8.X 0.44624f
C1086 a_9963_15356# sg13g2_dlygate4sd3_1_8.X 0.03544f
C1087 counter_value_o[2] VDD 0.09991f
C1088 a_22576_14726# VDD 0.12615f
C1089 sg13g2_dlygate4sd3_1_0.X a_5613_14832# 0.17799f
C1090 a_27313_13799# a_26565_13701# 0.01058f
C1091 a_16556_15960# VDD 0.16505f
C1092 sg13g2_buf_1_0.X sg13g2_and2_1_0.X 0.07579f
C1093 sg13g2_or3_1_2.B a_20278_14862# 0.07247f
C1094 sg13g2_or3_1_2.B a_18454_15230# 0.06996f
C1095 sg13g2_o21ai_1_2.B1 sg13g2_dlygate4sd3_1_17.A 0.02004f
C1096 sg13g2_or3_1_1.A a_26753_15424# 0.01588f
C1097 a_25206_14508# a_25094_14484# 0.32411f
C1098 a_21477_14495# VDD 0.25001f
C1099 a_20774_14922# a_21477_14495# 0.02432f
C1100 sg13g2_or3_1_2.C a_21477_14495# 0.01348f
C1101 a_18478_13911# a_18593_13912# 0.32411f
C1102 a_9418_15457# a_9158_15234# 0.39302f
C1103 a_6372_14488# a_7631_14845# 0.01303f
C1104 sg13g2_buf_1_10.X a_6789_14495# 0.01337f
C1105 sg13g2_xnor2_1_0.Y sg13g2_dlygate4sd3_1_8.X 0.0558f
C1106 a_37484_15960# counter_value_o[7] 0.13349f
C1107 sg13g2_dfrbpq_1_3.Q sg13g2_or3_1_2.B 0.03642f
C1108 sg13g2_dfrbpq_1_2.RESET_B a_15022_14484# 0.05771f
C1109 sg13g2_dfrbpq_1_5.RESET_B sg13g2_buf_16_2.X 0.0892f
C1110 a_17900_15960# sg13g2_or3_1_2.B 0.01033f
C1111 sg13g2_dlygate4sd3_1_5.A VDD 0.28965f
C1112 sg13g2_dfrbpq_1_2.CLK sg13g2_and2_1_1.X 0.02068f
C1113 sg13g2_or3_1_1.C a_24841_13726# 0.15147f
C1114 a_18863_14845# a_18769_14845# 0.15029f
C1115 counter_value_o[6] VDD 0.10209f
C1116 sg13g2_dlygate4sd3_1_12.X sg13g2_or3_1_1.X 0.12937f
C1117 a_18021_14495# sg13g2_buf_16_2.X 0.15007f
C1118 sg13g2_dfrbpq_1_2.Q a_19450_15202# 0.02852f
C1119 sg13g2_or3_1_1.A VDD 0.44648f
C1120 sg13g2_or3_1_1.C sg13g2_a21oi_1_3.A2 0.301f
C1121 a_2540_15960# VDD 0.17846f
C1122 a_9732_15247# sg13g2_dlygate4sd3_1_8.X 0.01632f
C1123 sg13g2_and2_1_1.X sg13g2_xnor2_1_2.B 0.04407f
C1124 sg13g2_xnor2_1_1.A a_16044_15424# 0.08401f
C1125 sg13g2_buf_1_10.X sg13g2_xnor2_1_2.A 0.0312f
C1126 a_25930_14452# a_26373_14495# 0.02242f
C1127 a_16356_13735# sg13g2_a21oi_1_0.B1 0.02718f
C1128 sg13g2_buf_16_2.A sg13g2_a21oi_1_0.A1 0.0438f
C1129 a_38720_15366# VDD 0.08021f
C1130 sg13g2_a21oi_1_0.B1 sg13g2_o21ai_1_3.Y 0.33043f
C1131 sg13g2_or3_1_2.B a_17710_15423# 0.02518f
C1132 sg13g2_buf_1_10.X a_8298_14484# 0.0265f
C1133 sg13g2_dfrbpq_1_1.RESET_B a_6346_14452# 0.14145f
C1134 sg13g2_dfrbpq_1_3.Q sg13g2_or3_1_1.B 0.01515f
C1135 a_4842_15532# VDD 0.24296f
C1136 a_4078_14751# a_4193_14750# 0.32411f
C1137 sg13g2_dfrbpq_1_0.RESET_B a_2916_15552# 0.22233f
C1138 sg13g2_dlygate4sd3_1_0.X a_6286_13911# 0.08862f
C1139 sg13g2_buf_16_2.A a_16044_15424# 0.04329f
C1140 a_24824_15238# sg13g2_dlygate4sd3_1_17.A 0.05853f
C1141 sg13g2_or3_1_1.A a_26638_15423# 0.01019f
C1142 a_6401_13912# a_6682_13690# 0.15158f
C1143 a_22145_15424# a_22426_15202# 0.15158f
C1144 sg13g2_dlygate4sd3_1_12.X a_24923_15996# 0.05494f
C1145 sg13g2_a21oi_1_3.A1 sg13g2_o21ai_1_2.B1 0.02748f
C1146 sg13g2_dfrbpq_1_5.RESET_B a_26667_13844# 0.22075f
C1147 sg13g2_dfrbpq_1_1.RESET_B sg13g2_nand3_1_0.Y 0.01246f
C1148 a_17233_13799# a_16485_13701# 0.01058f
C1149 a_5687_15549# sg13g2_dlygate4sd3_1_3.A 0.01467f
C1150 sg13g2_buf_1_0.X a_4842_15532# 0.01195f
C1151 a_38536_10034# VDD 0.13142f
C1152 sg13g2_dlygate4sd3_1_4.X sg13g2_buf_16_2.X 0.0241f
C1153 sg13g2_dfrbpq_1_2.CLK a_4078_14751# 0.01385f
C1154 sg13g2_dfrbpq_1_6.RESET_B sg13g2_o21ai_1_1.Y 0.06014f
C1155 sg13g2_a21oi_1_1.Y sg13g2_dfrbpq_1_6.D 0.02456f
C1156 sg13g2_o21ai_1_2.Y sg13g2_buf_16_2.X 0.46721f
C1157 sg13g2_buf_1_10.X sg13g2_dfrbpq_1_1.RESET_B 0.02446f
C1158 sg13g2_dfrbpq_1_6.Q a_23368_14570# 0.02513f
C1159 sg13g2_dlygate4sd3_1_1.A sg13g2_nand3_1_0.Y 0.30877f
C1160 sg13g2_buf_16_2.X sg13g2_o21ai_1_1.Y 0.19101f
C1161 a_17219_16265# sg13g2_dlygate4sd3_1_6.X 0.1855f
C1162 sg13g2_and2_1_2.X a_8685_14832# 0.06173f
C1163 a_25094_15238# sg13g2_a21oi_1_0.B1 0.0148f
C1164 a_17584_13942# a_17994_14020# 0.05221f
C1165 sg13g2_dlygate4sd3_1_1.A sg13g2_buf_1_10.X 0.1352f
C1166 a_2916_15552# a_3333_15213# 0.22605f
C1167 a_9158_15234# a_9444_15552# 0.21832f
C1168 a_25094_15238# a_25206_15302# 0.32411f
C1169 a_10337_14750# VDD 0.19397f
C1170 sg13g2_or3_1_1.C VDD 0.83377f
C1171 a_20218_15238# sg13g2_or3_1_2.C 0.01856f
C1172 sg13g2_a21oi_1_0.B1 a_16587_13844# 0.01723f
C1173 a_4193_14750# sg13g2_xor2_1_0.B 0.01614f
C1174 sg13g2_dfrbpq_1_6.D sg13g2_dlygate4sd3_1_11.X 0.10897f
C1175 sg13g2_a21oi_1_0.Y VDD 0.22606f
C1176 a_26170_16237# VDD 0.09145f
C1177 sg13g2_dfrbpq_1_2.CLK a_16068_14040# 0.03943f
C1178 a_27121_14845# a_25956_14488# 0.22369f
C1179 sg13g2_dfrbpq_1_2.Q a_20000_15366# 0.01141f
C1180 sg13g2_dlygate4sd3_1_8.X VDD 0.48669f
C1181 sg13g2_dfrbpq_1_6.Q sg13g2_or3_1_2.B 0.03994f
C1182 sg13g2_dfrbpq_1_2.Q a_18123_14495# 0.05101f
C1183 a_26148_14040# a_26565_13701# 0.22605f
C1184 a_25862_13722# a_26667_13844# 0.06896f
C1185 a_16068_14040# a_17327_13799# 0.01303f
C1186 sg13g2_dfrbpq_1_2.CLK a_14357_15238# 0.01232f
C1187 sg13g2_a21oi_1_0.B1 clock_i 0.07143f
C1188 sg13g2_a21oi_1_0.A2 sg13g2_a21oi_1_0.Y 0.05648f
C1189 sg13g2_dfrbpq_1_2.CLK sg13g2_xor2_1_0.B 0.10139f
C1190 sg13g2_dfrbpq_1_2.Q sg13g2_dfrbpq_1_3.Q 2.57192f
C1191 sg13g2_dfrbpq_1_6.Q a_23960_15242# 0.01415f
C1192 sg13g2_dfrbpq_1_2.D sg13g2_nor2_1_0.B 0.11402f
C1193 sg13g2_dfrbpq_1_2.Q a_17900_15960# 0.16112f
C1194 a_18298_16237# sg13g2_dlygate4sd3_1_6.X 0.01045f
C1195 sg13g2_dlygate4sd3_1_6.X a_19054_15423# 0.09539f
C1196 sg13g2_buf_1_0.X sg13g2_dlygate4sd3_1_8.X 0.1643f
C1197 sg13g2_dfrbpq_1_6.RESET_B a_22576_14726# 0.0605f
C1198 sg13g2_xor2_1_0.B sg13g2_xnor2_1_2.B 0.0219f
C1199 a_21827_13690# VDD 0.25328f
C1200 a_22576_14726# sg13g2_buf_16_2.X 0.01541f
C1201 a_21827_13690# sg13g2_or3_1_2.C 0.1542f
C1202 sg13g2_dfrbpq_1_6.RESET_B a_21477_14495# 0.02811f
C1203 sg13g2_or3_1_2.X a_21466_15202# 0.01436f
C1204 sg13g2_and2_1_1.X VDD 0.24423f
C1205 a_26244_14909# a_25670_14922# 0.16388f
C1206 sg13g2_dfrbpq_1_6.Q sg13g2_or3_1_1.B 0.01502f
C1207 sg13g2_buf_16_2.X a_21477_14495# 0.15602f
C1208 sg13g2_dfrbpq_1_2.RESET_B a_16587_13844# 0.2153f
C1209 sg13g2_dfrbpq_1_2.Q a_17710_15423# 0.02421f
C1210 a_16042_13945# a_16068_14040# 0.21121f
C1211 sg13g2_dlygate4sd3_1_8.A a_9444_15552# 0.02595f
C1212 sg13g2_a21oi_1_0.B1 sg13g2_or3_1_2.B 0.22888f
C1213 sg13g2_dlygate4sd3_1_6.X sg13g2_or3_1_2.B 0.1707f
C1214 a_6575_13342# a_6540_13238# 0.17527f
C1215 a_21185_15424# a_21466_15202# 0.15158f
C1216 a_3008_16082# VDD 0.06492f
C1217 sg13g2_or3_1_1.A sg13g2_buf_16_2.X 0.02467f
C1218 sg13g2_dfrbpq_1_3.RESET_B a_18123_14495# 0.22918f
C1219 a_18478_13911# VDD 0.15211f
C1220 sg13g2_dfrbpq_1_2.RESET_B clock_i 0.01197f
C1221 a_25390_16263# VDD 0.14549f
C1222 sg13g2_or3_1_1.X sg13g2_a21oi_1_3.Y 0.01181f
C1223 a_19054_15423# a_19169_15424# 0.32411f
C1224 sg13g2_o21ai_1_2.B1 VDD 0.38273f
C1225 sg13g2_dfrbpq_1_6.D VDD 0.33374f
C1226 a_17604_14488# VDD 0.09244f
C1227 sg13g2_dfrbpq_1_6.D a_20774_14922# 0.16155f
C1228 sg13g2_dfrbpq_1_6.D sg13g2_or3_1_2.C 0.01739f
C1229 a_23368_14570# a_23552_14570# 0.0262f
C1230 sg13g2_dfrbpq_1_3.RESET_B a_17900_15960# 0.01575f
C1231 sg13g2_dfrbpq_1_5.RESET_B a_25670_14922# 0.04149f
C1232 sg13g2_dfrbpq_1_2.CLK sg13g2_buf_16_2.A 0.52851f
C1233 sg13g2_dfrbpq_1_7.RESET_B VDD 1.02338f
C1234 a_18021_14495# a_18123_14495# 0.27006f
C1235 a_4078_14751# VDD 0.14757f
C1236 sg13g2_a21oi_1_0.B1 sg13g2_or3_1_1.B 0.09638f
C1237 a_37484_15960# VDD 0.19691f
C1238 sg13g2_dfrbpq_1_5.RESET_B a_26170_15202# 0.02239f
C1239 a_5896_13854# VDD 0.13424f
C1240 sg13g2_dlygate4sd3_1_8.X a_9861_14521# 0.01291f
C1241 sg13g2_o21ai_1_2.B1 a_26638_15423# 0.0886f
C1242 sg13g2_o21ai_1_1.Y a_21348_14909# 0.0244f
C1243 a_25774_15423# sg13g2_or3_1_1.A 0.01024f
C1244 sg13g2_tiehi_1.L_HI sg13g2_dlygate4sd3_1_8.X 0.06927f
C1245 a_2916_15552# sg13g2_dlygate4sd3_1_3.A 0.02251f
C1246 sg13g2_a21oi_1_0.B1 sg13g2_buf_1_10.X 0.05486f
C1247 a_27500_15960# counter_value_o[5] 0.13339f
C1248 sg13g2_or3_1_2.B a_16760_15238# 0.02231f
C1249 sg13g2_dfrbpq_1_2.RESET_B sg13g2_or3_1_2.B 0.1467f
C1250 sg13g2_or3_1_2.B a_23552_14570# 0.0176f
C1251 a_26249_16334# a_26373_16033# 0.06917f
C1252 sg13g2_dfrbpq_1_2.Q sg13g2_dfrbpq_1_6.Q 0.32803f
C1253 sg13g2_dlygate4sd3_1_4.X a_18454_15230# 0.01369f
C1254 a_26122_13945# VDD 0.09478f
C1255 a_16068_14040# VDD 0.07703f
C1256 a_24824_15238# VDD 0.25559f
C1257 sg13g2_dlygate4sd3_1_4.X a_18123_14495# 0.0537f
C1258 a_22030_15423# VDD 0.14394f
C1259 a_17318_14922# a_17604_14488# 0.21832f
C1260 sg13g2_o21ai_1_1.Y a_20278_14862# 0.05267f
C1261 sg13g2_or3_1_1.C sg13g2_buf_16_2.X 0.02129f
C1262 a_14357_15238# VDD 0.43839f
C1263 a_6660_14909# a_6891_14495# 0.06628f
C1264 sg13g2_dfrbpq_1_2.RESET_B sg13g2_or3_1_1.B 0.04262f
C1265 sg13g2_xor2_1_0.B VDD 0.46418f
C1266 sg13g2_or3_1_1.B a_16760_15238# 0.01488f
C1267 a_22304_16082# counter_value_o[4] 0.01137f
C1268 sg13g2_dfrbpq_1_5.RESET_B sg13g2_dfrbpq_1_7.Q 0.02174f
C1269 clock_i sg13g2_dlygate4sd3_1_3.A 0.08657f
C1270 a_16068_14040# sg13g2_a21oi_1_0.A2 0.04264f
C1271 sg13g2_nand3_1_0.Y a_7680_15549# 0.18946f
C1272 a_22319_14845# a_22986_14484# 0.06982f
C1273 sg13g2_or3_1_1.B a_24824_14525# 0.01011f
C1274 a_12524_15960# counter_value_o[2] 0.13349f
C1275 a_22225_14845# a_21477_14495# 0.01058f
C1276 sg13g2_buf_1_0.X sg13g2_xor2_1_0.B 0.42323f
C1277 a_7829_15238# a_7680_15549# 0.17527f
C1278 a_16648_13058# sg13g2_a21oi_1_0.B1 0.02468f
C1279 a_21060_14488# a_21579_14495# 0.18362f
C1280 a_21477_14495# a_21348_14909# 0.01562f
C1281 a_9737_14822# a_9658_14725# 0.08074f
C1282 a_7888_14726# VDD 0.12723f
C1283 sg13g2_or3_1_1.X sg13g2_dlygate4sd3_1_17.A 0.09132f
C1284 sg13g2_dlygate4sd3_1_12.X a_25025_16344# 0.0127f
C1285 sg13g2_dfrbpq_1_2.Q sg13g2_a21oi_1_0.B1 0.48521f
C1286 a_2528_15366# VDD 0.08307f
C1287 sg13g2_dfrbpq_1_7.RESET_B a_27215_14845# 0.07576f
C1288 sg13g2_dfrbpq_1_2.Q sg13g2_dlygate4sd3_1_6.X 0.03446f
C1289 a_6346_14452# a_6372_14488# 0.21121f
C1290 a_6086_14922# a_6891_14495# 0.06896f
C1291 a_16055_16301# a_15880_16082# 0.01744f
C1292 a_16055_16071# a_16254_15934# 0.08074f
C1293 a_9861_15213# sg13g2_dlygate4sd3_1_8.X 0.01428f
C1294 sg13g2_dfrbpq_1_5.RESET_B sg13g2_dfrbpq_1_6.Q 0.02798f
C1295 sg13g2_xnor2_1_1.A VDD 0.75307f
C1296 sg13g2_dfrbpq_1_5.RESET_B a_26249_16334# 0.01518f
C1297 a_27313_13799# a_26148_14040# 0.22369f
C1298 a_26436_13735# a_26667_13844# 0.06628f
C1299 a_16254_15934# VDD 0.09519f
C1300 a_16079_15238# a_16044_15424# 0.17527f
C1301 sg13g2_or3_1_1.A a_24310_15230# 0.02187f
C1302 a_24824_14525# a_25094_14484# 0.15158f
C1303 a_21060_14488# VDD 0.07328f
C1304 a_16760_15238# a_17030_15238# 0.15158f
C1305 a_8685_14832# VDD 0.25215f
C1306 a_20774_14922# a_21060_14488# 0.21832f
C1307 sg13g2_or3_1_2.C a_21060_14488# 0.01428f
C1308 sg13g2_dfrbpq_1_3.RESET_B a_17892_14909# 0.03322f
C1309 a_1856_14570# VDD 0.08194f
C1310 a_24923_15996# sg13g2_dlygate4sd3_1_17.A 0.09826f
C1311 sg13g2_buf_16_2.A VDD 2.70548f
C1312 clock_i a_15022_14484# 0.36193f
C1313 sg13g2_xnor2_1_1.A sg13g2_a21oi_1_0.A2 0.06747f
C1314 sg13g2_buf_1_10.X a_6372_14488# 0.02336f
C1315 sg13g2_dfrbpq_1_6.D sg13g2_dfrbpq_1_6.RESET_B 0.46378f
C1316 a_18106_15202# VDD 0.27413f
C1317 sg13g2_dfrbpq_1_2.CLK a_5613_14832# 0.01219f
C1318 a_18454_15230# sg13g2_dlygate4sd3_1_5.A 0.05271f
C1319 a_26373_14495# VDD 0.24654f
C1320 sg13g2_nand3_1_0.Y sg13g2_dlygate4sd3_1_3.A 0.01196f
C1321 a_18863_14845# a_19530_14484# 0.06982f
C1322 sg13g2_o21ai_1_2.B1 sg13g2_buf_16_2.X 0.15546f
C1323 sg13g2_dfrbpq_1_6.D sg13g2_buf_16_2.X 0.02051f
C1324 a_17604_14488# sg13g2_buf_16_2.X 0.04763f
C1325 a_18021_14495# a_17892_14909# 0.01562f
C1326 sg13g2_and2_1_2.B a_9158_15234# 0.01717f
C1327 sg13g2_dfrbpq_1_2.Q a_19169_15424# 0.03402f
C1328 sg13g2_dfrbpq_1_3.RESET_B sg13g2_a21oi_1_0.B1 0.03353f
C1329 sg13g2_a21oi_1_0.A2 sg13g2_buf_16_2.A 0.10413f
C1330 sg13g2_dfrbpq_1_7.RESET_B sg13g2_buf_16_2.X 0.06075f
C1331 sg13g2_a21oi_1_3.A1 sg13g2_or3_1_1.X 0.19264f
C1332 sg13g2_buf_1_10.X sg13g2_dlygate4sd3_1_3.A 0.02533f
C1333 sg13g2_dfrbpq_1_3.RESET_B sg13g2_dlygate4sd3_1_6.X 0.02516f
C1334 a_25930_14452# a_25956_14488# 0.21121f
C1335 sg13g2_xnor2_1_1.A sg13g2_dfrbpq_1_3.D 0.01707f
C1336 a_27898_15202# VDD 0.26514f
C1337 sg13g2_or3_1_2.B a_17142_15302# 0.01737f
C1338 sg13g2_buf_1_10.X a_7631_14845# 0.02314f
C1339 sg13g2_a21oi_1_3.Y a_25956_14488# 0.02684f
C1340 a_4432_15454# VDD 0.13137f
C1341 sg13g2_o21ai_1_2.Y sg13g2_dfrbpq_1_6.Q 0.02566f
C1342 a_2890_15457# a_2630_15234# 0.39302f
C1343 sg13g2_or3_1_1.A a_26170_15202# 0.0121f
C1344 sg13g2_buf_16_2.A sg13g2_dfrbpq_1_3.D 0.01667f
C1345 counter_value_o[0] VDD 0.10122f
C1346 a_21827_13690# a_22125_14020# 0.02085f
C1347 sg13g2_dfrbpq_1_5.RESET_B a_26565_13701# 0.03093f
C1348 a_16356_13735# a_16587_13844# 0.06628f
C1349 a_17233_13799# a_16068_14040# 0.22369f
C1350 a_25774_15423# sg13g2_dfrbpq_1_7.RESET_B 0.02822f
C1351 a_1192_9948# VDD 0.16521f
C1352 sg13g2_buf_16_2.A a_17318_14922# 0.03137f
C1353 sg13g2_or3_1_1.C a_24310_15230# 0.10273f
C1354 a_5687_15315# VDD 0.07026f
C1355 sg13g2_or3_1_1.X a_24841_13726# 0.11407f
C1356 a_27502_15423# a_27617_15424# 0.32411f
C1357 sg13g2_or3_1_1.B a_15022_14484# 0.02919f
C1358 sg13g2_or3_1_1.A a_25889_15424# 0.01269f
C1359 sg13g2_xnor2_1_2.B a_6286_13911# 0.05832f
C1360 a_17327_13799# a_17994_14020# 0.06982f
C1361 sg13g2_a21oi_1_0.A1 a_17578_14452# 0.02533f
C1362 sg13g2_a21oi_1_0.B1 sg13g2_dlygate4sd3_1_4.X 0.02267f
C1363 a_10016_14570# VDD 0.07442f
C1364 sg13g2_dfrbpq_1_7.Q counter_value_o[6] 0.01f
C1365 sg13g2_dlygate4sd3_1_4.X sg13g2_dlygate4sd3_1_6.X 0.07714f
C1366 a_21166_16263# sg13g2_a21oi_1_1.Y 0.0149f
C1367 sg13g2_dfrbpq_1_2.CLK a_10609_15311# 0.01369f
C1368 a_3872_14570# sg13g2_xor2_1_0.B 0.01249f
C1369 sg13g2_xnor2_1_2.A sg13g2_dlygate4sd3_1_8.X 0.01603f
C1370 sg13g2_or3_1_1.A sg13g2_dfrbpq_1_7.Q 0.07212f
C1371 sg13g2_a21oi_1_0.B1 sg13g2_o21ai_1_1.Y 0.01333f
C1372 a_25505_16262# VDD 0.19718f
C1373 sg13g2_dfrbpq_1_0.RESET_B sg13g2_and2_1_0.X 0.0393f
C1374 sg13g2_a21oi_1_0.B1 sg13g2_nor2_1_0.B 0.04488f
C1375 sg13g2_or3_1_1.C sg13g2_dfrbpq_1_3.Q 0.07492f
C1376 a_4081_15311# a_4175_15311# 0.15029f
C1377 a_25862_13722# a_26565_13701# 0.02454f
C1378 a_18377_16334# sg13g2_dlygate4sd3_1_6.X 0.01804f
C1379 a_17030_15238# a_17142_15302# 0.32411f
C1380 a_19438_13726# VDD 1.62673f
C1381 sg13g2_dfrbpq_1_6.RESET_B a_21060_14488# 0.2413f
C1382 sg13g2_or3_1_2.X a_21185_15424# 0.01085f
C1383 a_5613_14832# VDD 0.26538f
C1384 a_8218_13690# VDD 0.27318f
C1385 sg13g2_or3_1_1.A sg13g2_dfrbpq_1_6.Q 1.60085f
C1386 sg13g2_buf_16_2.X a_21060_14488# 0.08457f
C1387 sg13g2_dfrbpq_1_2.RESET_B a_16485_13701# 0.0282f
C1388 sg13g2_dfrbpq_1_2.CLK a_6891_14495# 0.02411f
C1389 a_24841_13726# a_25037_14020# 0.01473f
C1390 sg13g2_buf_1_10.X sg13g2_and2_1_2.B 0.16567f
C1391 sg13g2_buf_16_2.A sg13g2_buf_16_2.X 0.03835f
C1392 sg13g2_or3_1_1.X VDD 0.42033f
C1393 a_16042_13945# a_15782_13722# 0.39302f
C1394 sg13g2_dlygate4sd3_1_1.A sg13g2_dlygate4sd3_1_8.X 0.32804f
C1395 a_26373_14495# sg13g2_buf_16_2.X 0.18647f
C1396 sg13g2_dfrbpq_1_2.RESET_B sg13g2_nor2_1_0.B 0.0742f
C1397 sg13g2_o21ai_1_2.Y a_24824_14525# 0.01214f
C1398 a_16955_12972# sg13g2_a21oi_1_0.Y 0.08658f
C1399 a_17219_16265# sg13g2_or3_1_2.B 0.15417f
C1400 a_32492_15960# VDD 0.19922f
C1401 a_2824_16082# VDD 0.12157f
C1402 sg13g2_dfrbpq_1_1.RESET_B sg13g2_and2_1_1.X 0.03772f
C1403 sg13g2_or3_1_2.B sg13g2_or3_1_2.A 0.3284f
C1404 a_22426_15202# VDD 0.27122f
C1405 a_18501_16033# VDD 0.0704f
C1406 a_4474_14448# sg13g2_dlygate4sd3_1_3.A 0.23494f
C1407 a_9861_14521# a_10016_14570# 0.01514f
C1408 sg13g2_dlygate4sd3_1_6.X sg13g2_dlygate4sd3_1_5.A 0.24582f
C1409 a_24923_15996# VDD 0.14042f
C1410 sg13g2_dfrbpq_1_2.CLK a_12020_15202# 0.98555f
C1411 a_17604_14488# a_18123_14495# 0.18362f
C1412 a_17994_14020# VDD 0.24448f
C1413 sg13g2_dfrbpq_1_2.D sg13g2_buf_16_2.A 0.07692f
C1414 a_6286_13911# VDD 0.14438f
C1415 clock_i sg13g2_dlygate4sd3_1_8.A 0.05566f
C1416 sg13g2_or3_1_1.A sg13g2_a21oi_1_0.B1 0.10021f
C1417 sg13g2_dfrbpq_1_6.D sg13g2_dfrbpq_1_3.Q 0.01678f
C1418 sg13g2_o21ai_1_2.B1 a_26170_15202# 0.04122f
C1419 sg13g2_dfrbpq_1_7.RESET_B a_25670_14922# 0.07529f
C1420 sg13g2_and2_1_2.X sg13g2_nand4_1_0.Y 0.03117f
C1421 sg13g2_dfrbpq_1_5.RESET_B sg13g2_dfrbpq_1_5.D 0.05658f
C1422 a_3130_16237# VDD 0.09315f
C1423 a_9418_15457# sg13g2_dlygate4sd3_1_8.X 0.01733f
C1424 a_21166_16263# VDD 0.14796f
C1425 sg13g2_dfrbpq_1_2.Q a_19232_13854# 0.02104f
C1426 a_25206_15302# sg13g2_or3_1_1.A 0.01017f
C1427 sg13g2_buf_1_10.X reset_n_i 0.01017f
C1428 a_27664_13942# a_28074_14020# 0.05221f
C1429 sg13g2_or3_1_1.B sg13g2_or3_1_2.A 0.02564f
C1430 sg13g2_or3_1_1.C sg13g2_dfrbpq_1_6.Q 0.07251f
C1431 sg13g2_dfrbpq_1_7.RESET_B a_26170_15202# 0.03481f
C1432 a_26244_14909# a_26475_14495# 0.06628f
C1433 sg13g2_or3_1_2.B a_23368_14570# 0.01252f
C1434 a_3435_15356# a_4432_15454# 0.01528f
C1435 a_26249_16334# a_26170_16237# 0.08074f
C1436 sg13g2_or3_1_2.B a_24169_14508# 0.18093f
C1437 a_15782_13722# VDD 0.45225f
C1438 a_24408_15552# VDD 0.01765f
C1439 sg13g2_xor2_1_0.B sg13g2_xnor2_1_2.A 0.2895f
C1440 a_21466_15202# VDD 0.25171f
C1441 a_3209_16334# VDD 0.09043f
C1442 clock_i sg13g2_or3_1_1.B 0.08634f
C1443 clock_i sg13g2_nand3_1_0.Y 0.02746f
C1444 sg13g2_dfrbpq_1_7.RESET_B a_25889_15424# 0.07137f
C1445 a_22576_14726# a_22986_14484# 0.05221f
C1446 sg13g2_buf_1_10.X clock_i 0.01638f
C1447 a_7262_15242# sg13g2_dlygate4sd3_1_8.X 0.01764f
C1448 a_25862_13722# sg13g2_dfrbpq_1_5.D 0.16102f
C1449 a_22225_14845# a_21060_14488# 0.22369f
C1450 sg13g2_dfrbpq_1_5.RESET_B a_26475_14495# 0.02486f
C1451 a_8694_15302# sg13g2_and2_1_2.B 0.10685f
C1452 sg13g2_or3_1_1.A a_24824_14525# 0.05649f
C1453 a_6540_13238# sg13g2_xnor2_1_2.B 0.20886f
C1454 sg13g2_or3_1_1.C sg13g2_a21oi_1_0.B1 0.02968f
C1455 sg13g2_dfrbpq_1_7.RESET_B sg13g2_dfrbpq_1_7.Q 0.01635f
C1456 sg13g2_a21oi_1_0.B1 sg13g2_a21oi_1_0.Y 0.90237f
C1457 sg13g2_and2_1_0.X sg13g2_dlygate4sd3_1_3.A 0.01317f
C1458 a_18593_13912# a_18874_13690# 0.15158f
C1459 a_21060_14488# a_21348_14909# 0.22255f
C1460 a_6891_14495# VDD 0.20425f
C1461 a_7888_14726# a_8298_14484# 0.05221f
C1462 a_2890_15457# VDD 0.09938f
C1463 sg13g2_dfrbpq_1_7.RESET_B a_27472_14726# 0.0605f
C1464 a_6086_14922# a_6660_14909# 0.16388f
C1465 a_19438_13726# sg13g2_buf_16_2.X 0.93898f
C1466 sg13g2_dfrbpq_1_1.RESET_B sg13g2_xor2_1_0.B 0.03941f
C1467 sg13g2_or3_1_1.A a_27034_15202# 0.04651f
C1468 sg13g2_buf_1_10.X sg13g2_dlygate4sd3_1_8.A 0.03118f
C1469 sg13g2_or3_1_1.B sg13g2_or3_1_2.B 0.51265f
C1470 a_7822_13911# a_7937_13912# 0.32411f
C1471 a_16055_16071# a_15880_16082# 0.01214f
C1472 a_9444_15552# sg13g2_dlygate4sd3_1_8.X 0.03494f
C1473 sg13g2_dlygate4sd3_1_12.X sg13g2_dlygate4sd3_1_17.A 0.07004f
C1474 sg13g2_dfrbpq_1_2.Q sg13g2_or3_1_2.A 0.01215f
C1475 a_6575_13342# sg13g2_xnor2_1_2.B 0.01245f
C1476 sg13g2_xnor2_1_1.A a_18454_15230# 0.05333f
C1477 sg13g2_dlygate4sd3_1_1.A sg13g2_xor2_1_0.B 0.01984f
C1478 a_15880_16082# VDD 0.15276f
C1479 a_26436_13735# a_26565_13701# 0.01562f
C1480 sg13g2_o21ai_1_2.B1 sg13g2_dfrbpq_1_6.Q 1.46814f
C1481 sg13g2_or3_1_1.X sg13g2_buf_16_2.X 0.02831f
C1482 sg13g2_o21ai_1_2.A2 VDD 0.49437f
C1483 enable_i VDD 0.25308f
C1484 sg13g2_dfrbpq_1_2.CLK sg13g2_nand4_1_0.Y 1.26852f
C1485 a_21034_14452# VDD 0.09519f
C1486 sg13g2_or3_1_2.C a_21034_14452# 0.0121f
C1487 a_20774_14922# a_21034_14452# 0.39302f
C1488 sg13g2_dfrbpq_1_7.RESET_B sg13g2_dfrbpq_1_6.Q 0.01922f
C1489 a_2490_14447# VDD 0.17088f
C1490 a_5504_14570# VDD 0.08231f
C1491 sg13g2_dfrbpq_1_1.RESET_B a_7888_14726# 0.0605f
C1492 a_25786_15960# sg13g2_o21ai_1_3.Y 0.23716f
C1493 a_12020_15202# VDD 1.62135f
C1494 a_8312_15238# sg13g2_dlygate4sd3_1_8.X 0.01655f
C1495 a_19530_14484# VDD 0.24513f
C1496 a_17825_15424# VDD 0.20013f
C1497 a_18454_15230# a_18106_15202# 0.02137f
C1498 a_25956_14488# VDD 0.07268f
C1499 sg13g2_buf_16_2.A a_18123_14495# 0.01303f
C1500 a_19120_14726# a_19530_14484# 0.05221f
C1501 a_16760_15238# sg13g2_a21oi_1_0.Y 0.23186f
C1502 sg13g2_dfrbpq_1_2.RESET_B sg13g2_a21oi_1_0.Y 0.01245f
C1503 sg13g2_buf_1_0.X enable_i 0.02769f
C1504 a_2540_15960# sg13g2_dlygate4sd3_1_3.A 0.16437f
C1505 sg13g2_dlygate4sd3_1_1.A a_7888_14726# 0.01445f
C1506 a_17604_14488# a_17892_14909# 0.22255f
C1507 a_2490_14447# sg13g2_buf_1_0.X 0.07216f
C1508 counter_value_o[5] VDD 0.11349f
C1509 sg13g2_dfrbpq_1_2.Q a_19054_15423# 0.03619f
C1510 sg13g2_dlygate4sd3_1_8.X a_7680_15549# 0.10539f
C1511 a_25670_14922# a_26373_14495# 0.02432f
C1512 sg13g2_dfrbpq_1_2.CLK sg13g2_dlygate4sd3_1_0.X 0.03781f
C1513 a_4842_15532# sg13g2_dlygate4sd3_1_3.A 0.11616f
C1514 a_27617_15424# VDD 0.19613f
C1515 a_21166_16263# sg13g2_dfrbpq_1_6.RESET_B 0.02076f
C1516 sg13g2_or3_1_2.B a_17030_15238# 0.02338f
C1517 sg13g2_a21oi_1_3.A1 sg13g2_dfrbpq_1_7.D 0.06727f
C1518 sg13g2_a21oi_1_3.Y a_25930_14452# 0.04526f
C1519 sg13g2_o21ai_1_2.B1 sg13g2_a21oi_1_0.B1 0.01843f
C1520 a_4175_15311# VDD 0.1793f
C1521 sg13g2_dfrbpq_1_6.D sg13g2_a21oi_1_0.B1 0.04061f
C1522 sg13g2_dlygate4sd3_1_0.X sg13g2_xnor2_1_2.B 0.09015f
C1523 sg13g2_a21oi_1_0.B1 a_17604_14488# 0.01633f
C1524 a_6286_13911# sg13g2_dlygate4sd3_1_0.A 0.021f
C1525 sg13g2_dlygate4sd3_1_1.A a_8685_14832# 0.04541f
C1526 sg13g2_a21oi_1_0.B1 sg13g2_dfrbpq_1_7.RESET_B 0.03092f
C1527 a_17578_14452# VDD 0.09887f
C1528 a_21827_13690# a_22036_14020# 0.01473f
C1529 sg13g2_dfrbpq_1_5.RESET_B a_26148_14040# 0.2384f
C1530 sg13g2_and2_1_0.B a_2516_14484# 0.05178f
C1531 a_16356_13735# a_16485_13701# 0.01562f
C1532 sg13g2_buf_1_0.X a_4175_15311# 0.01373f
C1533 sg13g2_dfrbpq_1_2.Q sg13g2_or3_1_2.B 0.17856f
C1534 a_38720_13058# VDD 0.0803f
C1535 sg13g2_o21ai_1_2.Y sg13g2_o21ai_1_3.Y 0.06434f
C1536 a_6540_13238# VDD 0.1749f
C1537 sg13g2_dfrbpq_1_6.RESET_B a_21466_15202# 0.01464f
C1538 sg13g2_or3_1_1.B a_17030_15238# 0.01124f
C1539 a_5886_15486# VDD 0.09484f
C1540 a_6202_15238# sg13g2_xnor2_1_2.B 0.01833f
C1541 a_18298_16237# sg13g2_dfrbpq_1_3.RESET_B 0.03978f
C1542 a_17327_13799# a_17584_13942# 0.20069f
C1543 sg13g2_or3_1_1.X a_25206_14508# 0.02512f
C1544 a_25109_12972# sg13g2_a21oi_1_3.Y 0.08658f
C1545 sg13g2_dfrbpq_1_7.Q a_26373_14495# 0.0107f
C1546 a_10618_14448# VDD 0.26808f
C1547 a_32200_16082# counter_value_o[6] 0.02118f
C1548 sg13g2_dfrbpq_1_2.Q sg13g2_or3_1_1.B 0.03527f
C1549 sg13g2_dlygate4sd3_1_4.X a_17219_16265# 0.0163f
C1550 sg13g2_a21oi_1_0.B1 a_16068_14040# 0.0203f
C1551 sg13g2_buf_1_10.X a_14344_14570# 0.02139f
C1552 a_9861_15213# a_10609_15311# 0.01058f
C1553 a_28074_14020# VDD 0.24417f
C1554 counter_value_o[7] VSS 2.2765f
C1555 counter_value_o[6] VSS 2.0145f
C1556 counter_value_o[5] VSS 1.86644f
C1557 counter_value_o[4] VSS 1.55051f
C1558 counter_value_o[3] VSS 1.66873f
C1559 counter_value_o[2] VSS 1.71622f
C1560 counter_value_o[1] VSS 1.55762f
C1561 counter_value_o[0] VSS 1.87814f
C1562 a_38720_3986# VSS 0.07631f ; **FLOATING
C1563 a_38536_3986# VSS 0.0891f ; **FLOATING
C1564 a_38720_10034# VSS 0.07628f ; **FLOATING
C1565 a_38536_10034# VSS 0.0891f ; **FLOATING
C1566 a_38720_13058# VSS 0.08186f ; **FLOATING
C1567 a_25109_12972# VSS 0.45705f
C1568 a_25203_13320# VSS 0.14658f
C1569 a_16955_12972# VSS 0.11273f
C1570 a_17057_13320# VSS 0.47646f
C1571 a_16648_13058# VSS 0.09445f ; **FLOATING
C1572 a_6575_13342# VSS 0.17903f
C1573 a_6280_13058# VSS 0.08809f ; **FLOATING
C1574 a_38720_13854# VSS 0.07453f ; **FLOATING
C1575 a_38536_13854# VSS 0.09103f ; **FLOATING
C1576 a_27313_13799# VSS 0.05794f
C1577 a_26374_13735# VSS 0.7285f
C1578 a_26436_13735# VSS 0.5826f
C1579 a_27609_14037# VSS 0.13818f
C1580 a_25956_13722# VSS 0.0572f
C1581 a_26505_14113# VSS 0.3179f
C1582 a_25862_13722# VSS 0.27582f
C1583 a_25037_14020# VSS 0.05686f
C1584 a_24841_13726# VSS 0.0918f
C1585 a_22125_14020# VSS 0.27696f
C1586 a_22036_14020# VSS 0.22388f
C1587 a_19232_13854# VSS 0.04404f ; **FLOATING
C1588 a_17233_13799# VSS 0.05788f
C1589 a_16356_13735# VSS 0.13281f
C1590 a_17529_14037# VSS 0.07313f
C1591 a_15876_13722# VSS 0.07324f
C1592 a_16425_14113# VSS 0.46839f
C1593 a_15782_13722# VSS 0.92298f
C1594 a_15680_13854# VSS 0.0408f ; **FLOATING
C1595 a_16042_13945# VSS 0.31931f
C1596 a_6080_13854# VSS 0.03938f ; **FLOATING
C1597 a_5896_13854# VSS 0.09276f ; **FLOATING
C1598 a_6286_13911# VSS 0.0686f
C1599 a_38720_14570# VSS 0.08096f ; **FLOATING
C1600 a_27417_14607# VSS 0.12259f
C1601 a_26313_14531# VSS 0.26891f
C1602 a_27634_14922# VSS 0.1489f
C1603 a_27121_14845# VSS 0.12957f
C1604 a_27215_14845# VSS 0.05726f
C1605 a_26244_14909# VSS 0.56055f
C1606 a_26182_14909# VSS 0.79475f
C1607 a_24263_14508# VSS 0.26053f
C1608 a_23736_14464# VSS 0.03999f
C1609 a_25764_14922# VSS 0.15561f
C1610 a_25670_14922# VSS 0.548f
C1611 a_25094_14484# VSS 0.17496f
C1612 sg13g2_a21oi_1_3.A2 VSS 0.01941f
C1613 a_23552_14570# VSS 0.03584f ; **FLOATING
C1614 a_23368_14570# VSS 0.07808f ; **FLOATING
C1615 a_23638_14862# VSS 1.23862f
C1616 a_21417_14531# VSS 0.07311f
C1617 a_22225_14845# VSS 0.28218f
C1618 a_21348_14909# VSS 0.48806f
C1619 a_21286_14909# VSS 0.45083f
C1620 a_20868_14922# VSS 0.17922f
C1621 a_20774_14922# VSS 0.50128f
C1622 a_20278_14862# VSS 0.16652f
C1623 a_17961_14531# VSS 0.12923f
C1624 a_19282_14922# VSS 0.01933f
C1625 a_18769_14845# VSS 0.13095f
C1626 a_17892_14909# VSS 0.48505f
C1627 a_17830_14909# VSS 0.44833f
C1628 a_17412_14922# VSS 0.42493f
C1629 a_17318_14922# VSS 0.73688f
C1630 a_14816_14570# VSS 0.0433f ; **FLOATING
C1631 a_14344_14570# VSS 0.09551f ; **FLOATING
C1632 a_10016_14570# VSS 0.03932f ; **FLOATING
C1633 a_10618_14448# VSS 0.05722f
C1634 a_10222_14751# VSS 0.14637f
C1635 a_9536_14570# VSS 0.0441f ; **FLOATING
C1636 a_7833_14607# VSS 0.22733f
C1637 a_9658_14725# VSS 0.07811f
C1638 a_8779_14832# VSS 0.09327f
C1639 a_6729_14531# VSS 0.45013f
C1640 a_8050_14922# VSS 0.45796f
C1641 a_7537_14845# VSS 0.1302f
C1642 a_6660_14909# VSS 0.3807f
C1643 a_6598_14909# VSS 0.34383f
C1644 a_6180_14922# VSS 0.18046f
C1645 a_5707_14832# VSS 0.04504f
C1646 a_5504_14570# VSS 0.05371f ; **FLOATING
C1647 a_6086_14922# VSS 0.59032f
C1648 sg13g2_dlygate4sd3_1_0.X VSS 0.07345f
C1649 a_3872_14570# VSS 0.05491f ; **FLOATING
C1650 a_2516_14484# VSS 0.21471f
C1651 a_2646_14842# VSS 0.04488f
C1652 a_2059_14832# VSS 0.60576f
C1653 a_1856_14570# VSS 0.054f ; **FLOATING
C1654 sg13g2_buf_1_10.X VSS 0.14295f
C1655 a_38720_15366# VSS 0.08189f ; **FLOATING
C1656 a_27617_15424# VSS 0.15258f
C1657 a_24310_15230# VSS 0.12554f
C1658 a_24062_15242# VSS 0.07425f
C1659 a_23858_15242# VSS 0.01185f
C1660 a_23480_15242# VSS 0.08485f
C1661 a_23378_15242# VSS 0.04496f
C1662 a_25094_15238# VSS 0.13868f
C1663 sg13g2_o21ai_1_2.Y VSS 0.03999f
C1664 a_24408_15552# VSS 0.23646f
C1665 a_23168_15366# VSS 0.04381f ; **FLOATING
C1666 a_21824_15366# VSS 0.04441f ; **FLOATING
C1667 a_20705_15260# VSS 0.0115f
C1668 a_20218_15238# VSS 0.01306f
C1669 sg13g2_or3_1_2.A VSS 0.07239f
C1670 a_20603_15532# VSS 0.48429f
C1671 a_20000_15366# VSS 0.03774f ; **FLOATING
C1672 a_19816_15366# VSS 0.08179f ; **FLOATING
C1673 a_18454_15230# VSS 0.2308f
C1674 sg13g2_dlygate4sd3_1_11.X VSS 0.04885f
C1675 a_18552_15552# VSS 0.35869f
C1676 a_16079_15238# VSS 0.08111f
C1677 sg13g2_dlygate4sd3_1_5.A VSS 0.46222f
C1678 sg13g2_a21oi_1_0.A1 VSS 0.06939f
C1679 sg13g2_dfrbpq_1_3.D VSS 0.06915f
C1680 a_17710_15423# VSS 0.02046f
C1681 a_15722_15532# VSS 0.14548f
C1682 a_15488_15366# VSS 0.04427f ; **FLOATING
C1683 a_11752_15366# VSS 0.08373f ; **FLOATING
C1684 a_11122_15234# VSS 0.24551f
C1685 a_10609_15311# VSS 0.058f
C1686 a_9670_15247# VSS 0.02063f
C1687 a_9732_15247# VSS 0.05734f
C1688 a_10905_15549# VSS 0.2927f
C1689 a_9252_15234# VSS 0.49929f
C1690 a_7829_15238# VSS 0.08113f
C1691 a_9801_15625# VSS 0.56029f
C1692 a_9158_15234# VSS 0.38715f
C1693 a_9418_15457# VSS 0.01697f
C1694 a_8582_15238# VSS 0.14182f
C1695 a_7058_15242# VSS 0.464f
C1696 a_6578_15242# VSS 0.01219f
C1697 a_7923_15532# VSS 0.61533f
C1698 a_5600_15366# VSS 0.04045f ; **FLOATING
C1699 a_5886_15486# VSS 0.08166f
C1700 a_4081_15311# VSS 0.13282f
C1701 a_3142_15247# VSS 0.62548f
C1702 a_3204_15247# VSS 0.64588f
C1703 a_3273_15625# VSS 0.08304f
C1704 a_2630_15234# VSS 0.81349f
C1705 sg13g2_and2_1_0.X VSS 0.08738f
C1706 a_2528_15366# VSS 0.05013f ; **FLOATING
C1707 a_37192_16082# VSS 0.08963f ; **FLOATING
C1708 a_32200_16082# VSS 0.09113f ; **FLOATING
C1709 a_32492_15960# VSS 0.04579f
C1710 a_27296_16082# VSS 0.04651f ; **FLOATING
C1711 sg13g2_dfrbpq_1_5.RESET_B VSS 0.05806f
C1712 a_24923_15996# VSS 0.20557f
C1713 a_26170_16237# VSS 0.07968f
C1714 a_25025_16344# VSS 0.29069f
C1715 sg13g2_dlygate4sd3_1_17.A VSS 0.15295f
C1716 a_26633_16334# VSS 0.06155f
C1717 a_25786_15960# VSS 0.33617f
C1718 a_25390_16263# VSS 0.06167f
C1719 a_22304_16082# VSS 0.04037f ; **FLOATING
C1720 a_21946_16237# VSS 0.05549f
C1721 sg13g2_dfrbpq_1_6.D VSS 0.18308f
C1722 a_22025_16334# VSS 0.04892f
C1723 a_18176_16082# VSS 0.04354f ; **FLOATING
C1724 a_17517_16020# VSS 0.41166f
C1725 a_17428_16020# VSS 0.70093f
C1726 sg13g2_dfrbpq_1_2.RESET_B VSS 0.07032f
C1727 a_18298_16237# VSS 0.0891f
C1728 a_17219_16265# VSS 0.02447f
C1729 a_15880_16082# VSS 0.08473f ; **FLOATING
C1730 a_12232_16082# VSS 0.08821f ; **FLOATING
C1731 sg13g2_dlygate4sd3_1_1.A VSS 0.08881f
C1732 a_7240_16082# VSS 0.08925f ; **FLOATING
C1733 a_3008_16082# VSS 0.03902f ; **FLOATING
C1734 a_2824_16082# VSS 0.07954f ; **FLOATING
C1735 a_3130_16237# VSS 0.08869f
C1736 a_2248_16082# VSS 0.09051f ; **FLOATING
C1737 VSS.t547 VSS 0.23142f
C1738 VSS.t3 VSS 0.45225f
C1739 VSS.t302 VSS 0.0686f
C1740 VSS.t33 VSS 3.92348f
C1741 VSS.t255 VSS 1.47714f
C1742 VSS.t519 VSS 0.11905f
C1743 VSS.t3060 VSS 0.71738f
C1744 VSS.t3065 VSS 0.18571f
C1745 VSS.t3085 VSS 0.15255f
C1746 VSS.t3105 VSS 0.15876f
C1747 VSS.t3135 VSS 0.32213f
C1748 VSS.t3140 VSS 0.07764f
C1749 VSS.t3160 VSS 0.03882f
C1750 VSS.t3165 VSS 0.0789f
C1751 VSS.t2751 VSS 0.05953f
C1752 VSS.t2762 VSS 0.05726f
C1753 VSS.t2772 VSS 0.46224f
C1754 VSS.t2779 VSS 0.15675f
C1755 VSS.t2778 VSS 0.0229f
C1756 VSS.t2782 VSS 0.15014f
C1757 VSS.t2780 VSS 0.03458f
C1758 VSS.t2783 VSS 0.11556f
C1759 VSS.t2785 VSS 0.06825f
C1760 VSS.t2796 VSS 0.56811f
C1761 VSS.t2797 VSS 0.56811f
C1762 VSS.t2807 VSS 0.02454f
C1763 VSS.t2806 VSS 0.02454f
C1764 VSS.t2812 VSS 0.04579f
C1765 VSS.t2817 VSS 0.10846f
C1766 VSS.t2816 VSS 0.10846f
C1767 VSS.t2823 VSS 0.0425f
C1768 VSS.t2825 VSS 0.45301f
C1769 VSS.t2959 VSS 0.64427f
C1770 VSS.t2498 VSS 0.60605f
C1771 VSS.t2488 VSS 0.14411f
C1772 VSS.t2473 VSS 0.03664f
C1773 VSS.t2468 VSS 0.34588f
C1774 VSS.t2443 VSS 0.05937f
C1775 VSS.t2433 VSS 0.15657f
C1776 VSS.t2427 VSS 0.07628f
C1777 VSS.t2428 VSS 0.07628f
C1778 VSS.t2418 VSS 0.03469f
C1779 VSS.t2405 VSS 0.04202f
C1780 VSS.t2403 VSS 0.04202f
C1781 VSS.t2398 VSS 0.25789f
C1782 VSS.t1995 VSS 0.11282f
C1783 VSS.t1991 VSS 0.0662f
C1784 VSS.t1996 VSS 0.51015f
C1785 VSS.t1998 VSS 0.39733f
C1786 VSS.t2006 VSS 0.06952f
C1787 VSS.t2011 VSS 0.02622f
C1788 VSS.t2015 VSS 0.03896f
C1789 VSS.t2016 VSS 0.03896f
C1790 VSS.t2021 VSS 0.13817f
C1791 VSS.t2026 VSS 0.06612f
C1792 VSS.t2028 VSS 0.06612f
C1793 VSS.t2041 VSS 0.05602f
C1794 VSS.t2051 VSS 0.02968f
C1795 VSS.t2050 VSS 0.02968f
C1796 VSS.t2061 VSS 0.01738f
C1797 VSS.t2060 VSS 0.01738f
C1798 VSS.t2081 VSS 0.09079f
C1799 VSS.t2080 VSS 0.07417f
C1800 VSS.t2086 VSS 0.0229f
C1801 VSS.t2091 VSS 0.03151f
C1802 VSS.t2116 VSS 0.15895f
C1803 VSS.t2118 VSS 0.15895f
C1804 VSS.t2125 VSS 0.08647f
C1805 VSS.t2126 VSS 0.1939f
C1806 VSS.t2131 VSS 0.17487f
C1807 VSS.t2141 VSS 0.08813f
C1808 VSS.t2140 VSS 0.01049f
C1809 VSS.t2145 VSS 0.06962f
C1810 VSS.t2146 VSS 0.10543f
C1811 VSS.t2156 VSS 0.36633f
C1812 VSS.t2161 VSS 0.07574f
C1813 VSS.t2171 VSS 0.04064f
C1814 VSS.t2176 VSS 0.06235f
C1815 VSS.t2181 VSS 0.05595f
C1816 VSS.t2186 VSS 0.01452f
C1817 VSS.t2188 VSS 0.01452f
C1818 VSS.t2201 VSS 0.0686f
C1819 VSS.t2200 VSS 0.0686f
C1820 VSS.t2206 VSS 0.13224f
C1821 VSS.t2211 VSS 0.29556f
C1822 VSS.t2216 VSS 0.01903f
C1823 VSS.t1824 VSS 0.14928f
C1824 VSS.t1819 VSS 0.07239f
C1825 VSS.t1814 VSS 0.05573f
C1826 VSS.t1809 VSS 0.16808f
C1827 VSS.t1804 VSS 0.49993f
C1828 VSS.t1794 VSS 0.02054f
C1829 VSS.t1784 VSS 0.09154f
C1830 VSS.t1779 VSS 0.03843f
C1831 VSS.t1774 VSS 0.11681f
C1832 VSS.t1764 VSS 0.1125f
C1833 VSS.t1754 VSS 0.53085f
C1834 VSS.t1739 VSS 0.03968f
C1835 VSS.t1731 VSS 0.0186f
C1836 VSS.t1729 VSS 0.37025f
C1837 VSS.t1723 VSS 0.05236f
C1838 VSS.t1724 VSS 0.12175f
C1839 VSS.t1716 VSS 0.03574f
C1840 VSS.t1714 VSS 0.18408f
C1841 VSS.t1361 VSS 0.06057f
C1842 VSS.t1382 VSS 0.01494f
C1843 VSS.t1385 VSS 0.03806f
C1844 VSS.t1387 VSS 0.38666f
C1845 VSS.t1388 VSS 0.38666f
C1846 VSS.t1396 VSS 0.1555f
C1847 VSS.t1414 VSS 0.09561f
C1848 VSS.t1425 VSS 0.15394f
C1849 VSS.t1424 VSS 0.04451f
C1850 VSS.t1427 VSS 0.03725f
C1851 VSS.t1428 VSS 0.90602f
C1852 VSS.t1434 VSS 0.02903f
C1853 VSS.t1435 VSS 0.02903f
C1854 VSS.t1439 VSS 0.23362f
C1855 VSS.t1568 VSS 0.13931f
C1856 VSS.t1443 VSS 0.04451f
C1857 VSS.t1444 VSS 0.04451f
C1858 VSS.t1574 VSS 0.03084f
C1859 VSS.t1584 VSS 0.24351f
C1860 VSS.t1589 VSS 0.29819f
C1861 VSS.t1594 VSS 0.10331f
C1862 VSS.t1599 VSS 0.27223f
C1863 VSS.t1614 VSS 0.0744f
C1864 VSS.t1619 VSS 0.01706f
C1865 VSS.t1624 VSS 0.12602f
C1866 VSS.t1629 VSS 0.07852f
C1867 VSS.t1639 VSS 0.55503f
C1868 VSS.t1649 VSS 0.11905f
C1869 VSS.t1659 VSS 0.08957f
C1870 VSS.t1664 VSS 0.62142f
C1871 VSS.t1668 VSS 0.04178f
C1872 VSS.t1669 VSS 0.04178f
C1873 VSS.t1674 VSS 0.05726f
C1874 VSS.t1678 VSS 0.06732f
C1875 VSS.t1679 VSS 0.21195f
C1876 VSS.t1684 VSS 0.36411f
C1877 VSS.t1681 VSS 0.14463f
C1878 VSS.t1694 VSS 1.18744f
C1879 VSS.t1699 VSS 0.48942f
C1880 VSS.t1709 VSS 70.58116f
C1881 VSS.t1711 VSS 70.40556f
C1882 VSS.t1696 VSS 0.58028f
C1883 VSS.t1686 VSS 0.12992f
C1884 VSS.t1966 VSS 0.02099f
C1885 VSS.t1971 VSS 0.0789f
C1886 VSS.t1976 VSS 0.03274f
C1887 VSS.t1981 VSS 0.2004f
C1888 VSS.t1978 VSS 0.03274f
C1889 VSS.t1284 VSS 0.1367f
C1890 VSS.t1283 VSS 0.06236f
C1891 VSS.t1285 VSS 0.07434f
C1892 VSS.t1290 VSS 0.0259f
C1893 VSS.t1295 VSS 0.3378f
C1894 VSS.t1296 VSS 0.3378f
C1895 VSS.t1302 VSS 0.73267f
C1896 VSS.t1300 VSS 0.04091f
C1897 VSS.t1307 VSS 0.05472f
C1898 VSS.t1308 VSS 0.05472f
C1899 VSS.t1473 VSS 0.04197f
C1900 VSS.t1319 VSS 0.71156f
C1901 VSS.t1321 VSS 0.04232f
C1902 VSS.t1476 VSS 0.08687f
C1903 VSS.t1320 VSS 0.08687f
C1904 VSS.t1322 VSS 0.04232f
C1905 VSS.t1485 VSS 0.53629f
C1906 VSS.t1351 VSS 0.03094f
C1907 VSS.t1355 VSS 0.12655f
C1908 VSS.t1360 VSS 0.06057f
C1909 VSS.t912 VSS 0.07091f
C1910 VSS.t910 VSS 0.07091f
C1911 VSS.t905 VSS 0.56319p
C1912 VSS.t900 VSS 0.05625f
C1913 VSS.t895 VSS 0.08902f
C1914 VSS.t890 VSS 0.31442f
C1915 VSS.t925 VSS 0.22501f
C1916 VSS.t930 VSS 0.01311f
C1917 VSS.t935 VSS 0.04196f
C1918 VSS.t932 VSS 0.01311f
C1919 VSS.t939 VSS 0.13002f
C1920 VSS.t940 VSS 0.13002f
C1921 VSS.t945 VSS 0.06845f
C1922 VSS.t950 VSS 0.28159p
C1923 VSS.t959 VSS 0.14305f
C1924 VSS.t960 VSS 0.14305f
C1925 VSS.t965 VSS 0.03113f
C1926 VSS.t975 VSS 0.11874f
C1927 VSS.t980 VSS 0.13821f
C1928 VSS.t982 VSS 0.07612f
C1929 VSS.t995 VSS 1.27025f
C1930 VSS.t1000 VSS 70.81197f
C1931 VSS.t1005 VSS 0.31966f
C1932 VSS.t1002 VSS 70.81197f
C1933 VSS.t1004 VSS 0.11325f
C1934 VSS.t1010 VSS 0.92448f
C1935 VSS.t1035 VSS 0.08104f
C1936 VSS.t1034 VSS 0.08104f
C1937 VSS.t1040 VSS 0.26427f
C1938 VSS.t1045 VSS 0.30408f
C1939 VSS.t1050 VSS 1.16871f
C1940 VSS.t1055 VSS 0.03728f
C1941 VSS.t1052 VSS 1.16871f
C1942 VSS.t1065 VSS 0.30612f
C1943 VSS.t1070 VSS 0.14295f
C1944 VSS.t1072 VSS 0.14295f
C1945 VSS.t1085 VSS 0.16331f
C1946 VSS.t1084 VSS 0.13213f
C1947 VSS.t1095 VSS 0.1779f
C1948 VSS.t1115 VSS 0.16257f
C1949 VSS.t1120 VSS 0.03469f
C1950 VSS.t1125 VSS 0.06521f
C1951 VSS.t1135 VSS 0.03728f
C1952 VSS.t1139 VSS 0.04152f
C1953 VSS.t1140 VSS 0.10731f
C1954 VSS.t1150 VSS 0.223f
C1955 VSS.t1160 VSS 0.93612f
C1956 VSS.t1165 VSS 0.11736f
C1957 VSS.t756 VSS 0.29754f
C1958 VSS.t755 VSS 0.25983f
C1959 VSS.t758 VSS 0.02576f
C1960 VSS.t14 VSS 0.4714f
C1961 VSS.t183 VSS 0.1499f
C1962 VSS.t826 VSS 0.04782f
C1963 VSS.t88 VSS 0.29609f
C1964 VSS.t202 VSS 0.19895f
C1965 VSS.t24 VSS 1.16049f
C1966 VSS.t16 VSS 0.10089f
C1967 VSS.t246 VSS 0.4305f
C1968 VSS.t46 VSS 0.04594f
C1969 VSS.t631 VSS 0.02297f
C1970 VSS.t164 VSS 0.30994f
C1971 VSS.t19 VSS 0.03504f
C1972 VSS.t82 VSS 0.52444f
C1973 VSS.t106 VSS 0.44256f
C1974 VSS.t95 VSS 0.20683f
C1975 VSS.t454 VSS 0.04908f
C1976 VSS.t131 VSS 0.15775f
C1977 VSS.t150 VSS 0.14877f
C1978 VSS.t1 VSS 0.38288f
C1979 VSS.t12 VSS 0.11274f
C1980 VSS.t90 VSS 0.18823f
C1981 VSS.t515 VSS 0.63506f
C1982 VSS.t214 VSS 0.71204f
C1983 VSS.t540 VSS 0.17176f
C1984 VSS.t520 VSS 0.11905f
C1985 VSS.t510 VSS 0.11274f
C1986 VSS.t444 VSS 0.15163f
C1987 VSS.t446 VSS 0.01828f
C1988 VSS.t439 VSS 0.01295f
C1989 VSS.t186 VSS 0.66897f
C1990 VSS.t189 VSS 0.07005f
C1991 VSS.t35 VSS 0.27441f
C1992 VSS.t686 VSS 0.02976f
C1993 VSS.t700 VSS 0.02046f
C1994 VSS.t369 VSS 0.06579f
C1995 VSS.t438 VSS 0.01295f
C1996 VSS.t6 VSS 0.27521f
C1997 VSS.t29 VSS 0.22424f
C1998 VSS.t287 VSS 0.07239f
C1999 VSS.t143 VSS 0.14356f
C2000 VSS.t576 VSS 0.1171f
C2001 VSS.t142 VSS 0.1171f
C2002 VSS.t78 VSS 0.29185f
C2003 VSS.t181 VSS 0.30941f
C2004 VSS.t137 VSS 0.8083f
C2005 VSS.t31 VSS 0.0329f
C2006 VSS.t594 VSS 0.03324f
C2007 VSS.t600 VSS 0.01766f
C2008 VSS.t603 VSS 0.02125f
C2009 VSS.t602 VSS 0.02125f
C2010 VSS.t612 VSS 0.04169f
C2011 VSS.t621 VSS 0.0518f
C2012 VSS.t613 VSS 0.04169f
C2013 VSS.t595 VSS 0.03324f
C2014 VSS.t763 VSS 0.01662f
C2015 VSS.t887 VSS 0.03516f
C2016 VSS.t1097 VSS 0.05372f
C2017 VSS.t1087 VSS 0.03118f
C2018 VSS.t1047 VSS 0.30408f
C2019 VSS.t997 VSS 0.01603f
C2020 VSS.t947 VSS 0.05913f
C2021 VSS.t1829 VSS 0.09576f
C2022 VSS.t1849 VSS 0.05332f
C2023 VSS.t1851 VSS 0.05332f
C2024 VSS.t2163 VSS 0.01027f
C2025 VSS.t2093 VSS 0.03151f
C2026 VSS.t2083 VSS 0.01662f
C2027 VSS.t2043 VSS 0.05602f
C2028 VSS.t1993 VSS 0.0662f
C2029 VSS.t2382 VSS 0.05243f
C2030 VSS.t2383 VSS 0.05243f
C2031 VSS.t2377 VSS 0.01808f
C2032 VSS.t2378 VSS 0.01808f
C2033 VSS.t2357 VSS 0.04781f
C2034 VSS.t2358 VSS 0.04781f
C2035 VSS.t2493 VSS 0.31658f
C2036 VSS.t2548 VSS 0.15838f
C2037 VSS.t2553 VSS 0.36214f
C2038 VSS.t2550 VSS 0.15838f
C2039 VSS.t2552 VSS 0.31193f
C2040 VSS.t2558 VSS 0.06862f
C2041 VSS.t2563 VSS 0.20898f
C2042 VSS.t2568 VSS 0.12469f
C2043 VSS.t2583 VSS 0.03431f
C2044 VSS.t2588 VSS 0.20525f
C2045 VSS.t2593 VSS 0.06301f
C2046 VSS.t2590 VSS 0.20525f
C2047 VSS.t2598 VSS 0.01662f
C2048 VSS.t2603 VSS 0.09158f
C2049 VSS.t2602 VSS 0.09158f
C2050 VSS.t2613 VSS 0.46806f
C2051 VSS.t2612 VSS 0.46806f
C2052 VSS.t2618 VSS 0.41409f
C2053 VSS.t2623 VSS 0.29715f
C2054 VSS.t2622 VSS 0.02944f
C2055 VSS.t2628 VSS 0.35869f
C2056 VSS.t2630 VSS 0.35869f
C2057 VSS.t2565 VSS 0.20898f
C2058 VSS.t2831 VSS 0.10485f
C2059 VSS.t2833 VSS 0.05841f
C2060 VSS.t2834 VSS 0.05841f
C2061 VSS.t2966 VSS 0.06178f
C2062 VSS.t2839 VSS 0.02391f
C2063 VSS.t2973 VSS 0.45113f
C2064 VSS.t2846 VSS 0.61666f
C2065 VSS.t2847 VSS 0.61666f
C2066 VSS.t2987 VSS 0.07455f
C2067 VSS.t2864 VSS 0.04325f
C2068 VSS.t2865 VSS 0.04325f
C2069 VSS.t2994 VSS 0.03105f
C2070 VSS.t2866 VSS 0.03105f
C2071 VSS.t2870 VSS 0.05699f
C2072 VSS.t2871 VSS 0.05699f
C2073 VSS.t3001 VSS 0.27087f
C2074 VSS.t2876 VSS 0.27087f
C2075 VSS.t2881 VSS 0.12894f
C2076 VSS.t3008 VSS 0.22497f
C2077 VSS.t2882 VSS 0.35391f
C2078 VSS.t2887 VSS 0.0329f
C2079 VSS.t2886 VSS 0.0329f
C2080 VSS.t3164 VSS 0.0789f
C2081 VSS.t3162 VSS 0.03882f
C2082 VSS.t3137 VSS 0.32213f
C2083 VSS.t3107 VSS 0.15876f
.ends

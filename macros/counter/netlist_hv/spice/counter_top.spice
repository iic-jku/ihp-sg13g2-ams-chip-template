* NGSPICE file created from counter_top.ext - technology: ihp-sg13g2

* Black-box entry subcircuit for sg13g2_hv_fill_8 abstract view
.subckt sg13g2_hv_fill_8 VDD VSS
.ends

* Black-box entry subcircuit for sg13g2_hv_nand2b_1 abstract view
.subckt sg13g2_hv_nand2b_1 Y A_N B VDD VSS
.ends

* Black-box entry subcircuit for sg13g2_hv_xor2_1 abstract view
.subckt sg13g2_hv_xor2_1 X A B VDD VSS
.ends

* Black-box entry subcircuit for sg13g2_hv_buf_1 abstract view
.subckt sg13g2_hv_buf_1 X A VDD VSS
.ends

* Black-box entry subcircuit for sg13g2_hv_decap_4 abstract view
.subckt sg13g2_hv_decap_4 VDD VSS
.ends

* Black-box entry subcircuit for sg13g2_hv_fill_1 abstract view
.subckt sg13g2_hv_fill_1 VDD VSS
.ends

* Black-box entry subcircuit for sg13g2_hv_nand4_1 abstract view
.subckt sg13g2_hv_nand4_1 Y A B C D VDD VSS
.ends

* Black-box entry subcircuit for sg13g2_hv_dfrbpq_1 abstract view
.subckt sg13g2_hv_dfrbpq_1 Q CLK D RESET_B VDD VSS
.ends

* Black-box entry subcircuit for sg13g2_hv_tiehi abstract view
.subckt sg13g2_hv_tiehi L_HI VDD VSS
.ends

* Black-box entry subcircuit for sg13g2_hv_inv_1 abstract view
.subckt sg13g2_hv_inv_1 Y A VDD VSS
.ends

* Black-box entry subcircuit for sg13g2_hv_fill_2 abstract view
.subckt sg13g2_hv_fill_2 VDD VSS
.ends

* Black-box entry subcircuit for sg13g2_hv_decap_8 abstract view
.subckt sg13g2_hv_decap_8 VDD VSS
.ends

* Black-box entry subcircuit for sg13g2_hv_a21oi_1 abstract view
.subckt sg13g2_hv_a21oi_1 Y A1 A2 B1 VDD VSS
.ends

* Black-box entry subcircuit for sg13g2_hv_nand2_1 abstract view
.subckt sg13g2_hv_nand2_1 Y A B VDD VSS
.ends

* Black-box entry subcircuit for sg13g2_hv_and2_1 abstract view
.subckt sg13g2_hv_and2_1 X A B VDD VSS
.ends

* Black-box entry subcircuit for sg13g2_hv_and4_1 abstract view
.subckt sg13g2_hv_and4_1 X A B C D VDD VSS
.ends

* Black-box entry subcircuit for sg13g2_hv_buf_8 abstract view
.subckt sg13g2_hv_buf_8 X A VDD VSS
.ends

* Black-box entry subcircuit for sg13g2_hv_buf_16 abstract view
.subckt sg13g2_hv_buf_16 X A VDD VSS
.ends

* Black-box entry subcircuit for sg13g2_hv_mux2_1 abstract view
.subckt sg13g2_hv_mux2_1 X A0 A1 S VDD VSS
.ends

* Black-box entry subcircuit for sg13g2_hv_nand3_1 abstract view
.subckt sg13g2_hv_nand3_1 Y A B C VDD VSS
.ends

* Black-box entry subcircuit for sg13g2_hv_nor2b_1 abstract view
.subckt sg13g2_hv_nor2b_1 Y A B_N VDD VSS
.ends

* Black-box entry subcircuit for sg13g2_hv_xnor2_1 abstract view
.subckt sg13g2_hv_xnor2_1 Y A B VDD VSS
.ends

* Black-box entry subcircuit for sg13g2_hv_and2_2 abstract view
.subckt sg13g2_hv_and2_2 X A B VDD VSS
.ends

.subckt counter_top VDD VSS clock_i counter_value_o[0] counter_value_o[1] counter_value_o[2]
+ counter_value_o[3] counter_value_o[4] counter_value_o[5] counter_value_o[6] counter_value_o[7]
+ enable_i reset_n_i
XFILLER_3_89 VDD VSS sg13g2_hv_fill_8
XFILLER_2_302 VDD VSS sg13g2_hv_fill_8
X_49_ _81_/D _46_/Y _49_/B VDD VSS sg13g2_hv_nand2b_1
XFILLER_2_176 VDD VSS sg13g2_hv_fill_8
X_66_ _67_/B _71_/A _77_/Q VDD VSS sg13g2_hv_xor2_1
XFILLER_5_355 VDD VSS sg13g2_hv_fill_8
Xoutput7 counter_value_o[4] _81_/Q VDD VSS sg13g2_hv_buf_1
XFILLER_0_252 VDD VSS sg13g2_hv_fill_8
XFILLER_0_296 VDD VSS sg13g2_hv_fill_8
XFILLER_5_163 VDD VSS sg13g2_hv_decap_4
X_65_ _76_/D _62_/Y _65_/B VDD VSS sg13g2_hv_nand2b_1
XFILLER_2_358 VDD VSS sg13g2_hv_fill_8
XFILLER_1_391 VDD VSS sg13g2_hv_fill_1
X_48_ _49_/B _48_/A _80_/Q _73_/A _64_/C VDD VSS sg13g2_hv_nand4_1
XFILLER_2_144 VDD VSS sg13g2_hv_fill_8
XFILLER_0_14 VDD VSS sg13g2_hv_fill_8
XFILLER_0_58 VDD VSS sg13g2_hv_fill_8
Xoutput10 counter_value_o[7] _76_/Q VDD VSS sg13g2_hv_buf_1
Xoutput8 counter_value_o[5] _74_/Q VDD VSS sg13g2_hv_buf_1
XFILLER_0_220 VDD VSS sg13g2_hv_fill_8
XFILLER_5_301 VDD VSS sg13g2_hv_fill_8
X_81_ _81_/Q _81_/CLK _81_/D _81__11/L_HI VDD VSS sg13g2_hv_dfrbpq_1
XFILLER_3_47 VDD VSS sg13g2_hv_fill_8
XFILLER_2_326 VDD VSS sg13g2_hv_fill_8
X_75__15 _75__15/L_HI VDD VSS sg13g2_hv_tiehi
XFILLER_5_197 VDD VSS sg13g2_hv_fill_8
XFILLER_5_175 VDD VSS sg13g2_hv_fill_8
XFILLER_5_131 VDD VSS sg13g2_hv_fill_8
X_64_ _65_/B _64_/A _73_/A _64_/C _64_/D VDD VSS sg13g2_hv_nand4_1
X_47_ _48_/A _81_/Q VDD VSS sg13g2_hv_inv_1
XFILLER_2_112 VDD VSS sg13g2_hv_fill_2
XFILLER_1_381 VDD VSS sg13g2_hv_fill_8
XFILLER_1_0 VDD VSS sg13g2_hv_fill_8
XFILLER_1_80 VDD VSS sg13g2_hv_fill_8
Xoutput9 counter_value_o[6] _75_/Q VDD VSS sg13g2_hv_buf_1
XFILLER_5_110 VDD VSS sg13g2_hv_decap_8
X_63_ _64_/A _76_/Q VDD VSS sg13g2_hv_inv_1
X_80_ _80_/Q _80_/CLK _80_/D _80__12/L_HI VDD VSS sg13g2_hv_dfrbpq_1
X_46_ _46_/Y _80_/Q _64_/C _45_/Y VDD VSS sg13g2_hv_a21oi_1
XFILLER_2_168 VDD VSS sg13g2_hv_fill_8
XFILLER_0_38 VDD VSS sg13g2_hv_fill_8
X_78__14 _78__14/L_HI VDD VSS sg13g2_hv_tiehi
XFILLER_4_219 VDD VSS sg13g2_hv_fill_2
XFILLER_0_244 VDD VSS sg13g2_hv_fill_8
XFILLER_0_288 VDD VSS sg13g2_hv_fill_8
XFILLER_5_347 VDD VSS sg13g2_hv_fill_8
XFILLER_4_380 VDD VSS sg13g2_hv_fill_8
XFILLER_5_155 VDD VSS sg13g2_hv_fill_8
XFILLER_5_8 VDD VSS sg13g2_hv_decap_4
X_62_ _62_/Y _64_/C _64_/D _61_/Y VDD VSS sg13g2_hv_a21oi_1
XFILLER_2_136 VDD VSS sg13g2_hv_fill_8
XFILLER_2_114 VDD VSS sg13g2_hv_fill_1
X_45_ _45_/Y _81_/Q _73_/A VDD VSS sg13g2_hv_nand2_1
XFILLER_3_297 VDD VSS sg13g2_hv_fill_8
XFILLER_3_231 VDD VSS sg13g2_hv_fill_8
XFILLER_0_212 VDD VSS sg13g2_hv_fill_8
XFILLER_5_189 VDD VSS sg13g2_hv_fill_8
XFILLER_5_167 VDD VSS sg13g2_hv_fill_2
XFILLER_5_123 VDD VSS sg13g2_hv_fill_8
X_61_ _61_/Y _76_/Q _73_/A VDD VSS sg13g2_hv_nand2_1
XFILLER_3_39 VDD VSS sg13g2_hv_fill_8
XFILLER_2_318 VDD VSS sg13g2_hv_fill_8
XFILLER_1_373 VDD VSS sg13g2_hv_fill_8
XFILLER_3_6 VDD VSS sg13g2_hv_fill_2
XFILLER_2_104 VDD VSS sg13g2_hv_fill_8
X_44_ _80_/D _73_/A _44_/B VDD VSS sg13g2_hv_and2_1
XFILLER_0_268 VDD VSS sg13g2_hv_decap_4
XFILLER_5_102 VDD VSS sg13g2_hv_fill_8
X_60_ _64_/D _75_/Q _74_/Q _81_/Q _80_/Q VDD VSS sg13g2_hv_and4_1
XFILLER_1_341 VDD VSS sg13g2_hv_fill_8
X_43_ _44_/B _80_/Q _64_/C VDD VSS sg13g2_hv_xor2_1
XFILLER_0_236 VDD VSS sg13g2_hv_fill_8
XFILLER_5_339 VDD VSS sg13g2_hv_fill_8
XFILLER_5_317 VDD VSS sg13g2_hv_fill_8
XFILLER_5_147 VDD VSS sg13g2_hv_fill_8
XFILLER_4_372 VDD VSS sg13g2_hv_fill_8
X_80__12 _80__12/L_HI VDD VSS sg13g2_hv_tiehi
XFILLER_3_8 VDD VSS sg13g2_hv_fill_1
X_42_ _64_/C _42_/A VDD VSS sg13g2_hv_buf_8
XFILLER_3_289 VDD VSS sg13g2_hv_fill_8
XFILLER_3_223 VDD VSS sg13g2_hv_fill_8
XFILLER_1_96 VDD VSS sg13g2_hv_fill_8
XFILLER_0_204 VDD VSS sg13g2_hv_fill_8
XFILLER_4_340 VDD VSS sg13g2_hv_fill_8
XFILLER_4_85 VDD VSS sg13g2_hv_decap_4
XFILLER_1_365 VDD VSS sg13g2_hv_fill_8
X_41_ _42_/A _79_/Q _71_/A _78_/Q _77_/Q VDD VSS sg13g2_hv_and4_1
XFILLER_1_195 VDD VSS sg13g2_hv_fill_8
XFILLER_1_333 VDD VSS sg13g2_hv_fill_8
XFILLER_3_247 VDD VSS sg13g2_hv_fill_2
XFILLER_5_309 VDD VSS sg13g2_hv_fill_8
XFILLER_2_291 VDD VSS sg13g2_hv_decap_8
XFILLER_0_228 VDD VSS sg13g2_hv_fill_8
XFILLER_5_139 VDD VSS sg13g2_hv_fill_8
XFILLER_4_364 VDD VSS sg13g2_hv_fill_8
XFILLER_1_389 VDD VSS sg13g2_hv_fill_2
XFILLER_1_8 VDD VSS sg13g2_hv_decap_4
XFILLER_1_88 VDD VSS sg13g2_hv_fill_8
XFILLER_1_120 VDD VSS sg13g2_hv_fill_8
XFILLER_3_215 VDD VSS sg13g2_hv_fill_8
XFILLER_4_332 VDD VSS sg13g2_hv_fill_8
Xclkbuf_1_1__f_clock_i _81_/CLK clkbuf_0_clock_i/X VDD VSS sg13g2_hv_buf_16
XFILLER_1_357 VDD VSS sg13g2_hv_fill_8
XFILLER_4_388 VDD VSS sg13g2_hv_decap_4
XFILLER_4_141 VDD VSS sg13g2_hv_decap_4
XFILLER_4_89 VDD VSS sg13g2_hv_fill_1
XFILLER_4_67 VDD VSS sg13g2_hv_fill_2
XFILLER_3_239 VDD VSS sg13g2_hv_fill_8
XFILLER_2_283 VDD VSS sg13g2_hv_fill_8
Xinput1 _71_/A enable_i VDD VSS sg13g2_hv_buf_1
XFILLER_1_35 VDD VSS sg13g2_hv_fill_2
XFILLER_4_356 VDD VSS sg13g2_hv_fill_8
XFILLER_1_112 VDD VSS sg13g2_hv_fill_8
X_79_ _79_/Q _80_/CLK _79_/D _79__16/L_HI VDD VSS sg13g2_hv_dfrbpq_1
Xinput2 _73_/A reset_n_i VDD VSS sg13g2_hv_buf_1
XFILLER_1_349 VDD VSS sg13g2_hv_fill_8
Xclkbuf_1_0__f_clock_i _80_/CLK clkbuf_0_clock_i/X VDD VSS sg13g2_hv_buf_16
XFILLER_0_360 VDD VSS sg13g2_hv_fill_8
XFILLER_5_271 VDD VSS sg13g2_hv_fill_2
X_78_ _78_/Q _80_/CLK _78_/D _78__14/L_HI VDD VSS sg13g2_hv_dfrbpq_1
XFILLER_2_80 VDD VSS sg13g2_hv_fill_8
X_74__17 _74__17/L_HI VDD VSS sg13g2_hv_tiehi
XFILLER_4_133 VDD VSS sg13g2_hv_fill_8
XFILLER_4_59 VDD VSS sg13g2_hv_fill_8
X_77_ _77_/Q _80_/CLK _77_/D _77__18/L_HI VDD VSS sg13g2_hv_dfrbpq_1
XFILLER_0_180 VDD VSS sg13g2_hv_fill_8
XFILLER_4_0 VDD VSS sg13g2_hv_fill_8
XFILLER_2_275 VDD VSS sg13g2_hv_fill_8
XFILLER_4_348 VDD VSS sg13g2_hv_fill_8
XFILLER_4_145 VDD VSS sg13g2_hv_fill_2
XFILLER_1_104 VDD VSS sg13g2_hv_fill_8
XFILLER_0_384 VDD VSS sg13g2_hv_fill_8
XFILLER_5_295 VDD VSS sg13g2_hv_fill_2
XFILLER_5_251 VDD VSS sg13g2_hv_fill_8
X_76_ _76_/Q _81_/CLK _76_/D _76__13/L_HI VDD VSS sg13g2_hv_dfrbpq_1
X_59_ _75_/D _56_/Y _57_/X _59_/S VDD VSS sg13g2_hv_mux2_1
XFILLER_0_352 VDD VSS sg13g2_hv_fill_8
XFILLER_5_71 VDD VSS sg13g2_hv_fill_8
X_58_ _59_/S _74_/Q _64_/C _58_/C VDD VSS sg13g2_hv_nand3_1
XFILLER_2_244 VDD VSS sg13g2_hv_fill_8
XFILLER_2_200 VDD VSS sg13g2_hv_fill_1
XFILLER_2_72 VDD VSS sg13g2_hv_fill_8
X_75_ _75_/Q _81_/CLK _75_/D _75__15/L_HI VDD VSS sg13g2_hv_dfrbpq_1
XFILLER_3_361 VDD VSS sg13g2_hv_fill_8
XFILLER_1_128 VDD VSS sg13g2_hv_fill_8
XFILLER_0_172 VDD VSS sg13g2_hv_fill_8
XFILLER_0_320 VDD VSS sg13g2_hv_fill_8
XFILLER_5_94 VDD VSS sg13g2_hv_decap_4
XFILLER_5_61 VDD VSS sg13g2_hv_decap_4
XFILLER_2_267 VDD VSS sg13g2_hv_fill_8
X_74_ _74_/Q _81_/CLK _74_/D _74__17/L_HI VDD VSS sg13g2_hv_dfrbpq_1
X_77__18 _77__18/L_HI VDD VSS sg13g2_hv_tiehi
X_57_ _57_/X _75_/Q _73_/A VDD VSS sg13g2_hv_and2_1
XFILLER_2_0 VDD VSS sg13g2_hv_fill_8
XFILLER_2_40 VDD VSS sg13g2_hv_fill_8
XFILLER_0_376 VDD VSS sg13g2_hv_fill_8
XFILLER_5_287 VDD VSS sg13g2_hv_fill_8
XFILLER_5_243 VDD VSS sg13g2_hv_fill_8
X_73_ _79_/D _73_/A _73_/B VDD VSS sg13g2_hv_and2_1
XFILLER_2_96 VDD VSS sg13g2_hv_fill_8
X_56_ _56_/Y _75_/Q _73_/A VDD VSS sg13g2_hv_nor2b_1
XFILLER_3_385 VDD VSS sg13g2_hv_decap_8
XFILLER_3_160 VDD VSS sg13g2_hv_fill_1
XFILLER_0_130 VDD VSS sg13g2_hv_fill_8
XFILLER_0_196 VDD VSS sg13g2_hv_fill_8
XFILLER_0_344 VDD VSS sg13g2_hv_fill_8
X_72_ _73_/B _79_/Q _72_/B VDD VSS sg13g2_hv_xnor2_1
XFILLER_2_236 VDD VSS sg13g2_hv_fill_8
X_55_ _74_/D _52_/Y _55_/B VDD VSS sg13g2_hv_nand2b_1
XFILLER_2_64 VDD VSS sg13g2_hv_fill_8
XFILLER_3_353 VDD VSS sg13g2_hv_fill_8
XFILLER_0_312 VDD VSS sg13g2_hv_fill_8
XFILLER_5_86 VDD VSS sg13g2_hv_fill_8
XFILLER_5_53 VDD VSS sg13g2_hv_fill_8
XFILLER_0_164 VDD VSS sg13g2_hv_fill_8
XFILLER_5_267 VDD VSS sg13g2_hv_decap_4
X_71_ _72_/B _71_/A _78_/Q _77_/Q VDD VSS sg13g2_hv_nand3_1
XFILLER_2_259 VDD VSS sg13g2_hv_fill_8
X_54_ _55_/B _54_/A _73_/A _64_/C _58_/C VDD VSS sg13g2_hv_nand4_1
XFILLER_2_32 VDD VSS sg13g2_hv_fill_8
XFILLER_3_321 VDD VSS sg13g2_hv_fill_8
XFILLER_3_173 VDD VSS sg13g2_hv_fill_2
XFILLER_3_140 VDD VSS sg13g2_hv_fill_8
XFILLER_0_368 VDD VSS sg13g2_hv_fill_8
XFILLER_5_279 VDD VSS sg13g2_hv_fill_8
XFILLER_5_235 VDD VSS sg13g2_hv_fill_8
XFILLER_5_213 VDD VSS sg13g2_hv_fill_8
X_70_ _78_/D _73_/A _70_/B VDD VSS sg13g2_hv_and2_1
X_53_ _54_/A _74_/Q VDD VSS sg13g2_hv_inv_1
XFILLER_2_88 VDD VSS sg13g2_hv_fill_8
XFILLER_1_260 VDD VSS sg13g2_hv_fill_1
XFILLER_3_377 VDD VSS sg13g2_hv_fill_8
XFILLER_0_336 VDD VSS sg13g2_hv_fill_8
XFILLER_0_122 VDD VSS sg13g2_hv_fill_8
XFILLER_0_155 VDD VSS sg13g2_hv_decap_4
XFILLER_0_188 VDD VSS sg13g2_hv_fill_8
XFILLER_4_8 VDD VSS sg13g2_hv_fill_1
X_52_ _52_/Y _64_/C _58_/C _51_/Y VDD VSS sg13g2_hv_a21oi_1
XFILLER_2_228 VDD VSS sg13g2_hv_fill_8
XFILLER_2_56 VDD VSS sg13g2_hv_fill_8
XFILLER_3_345 VDD VSS sg13g2_hv_fill_8
XFILLER_0_304 VDD VSS sg13g2_hv_fill_8
XFILLER_5_259 VDD VSS sg13g2_hv_fill_8
XFILLER_5_45 VDD VSS sg13g2_hv_fill_8
XFILLER_5_23 VDD VSS sg13g2_hv_fill_2
XFILLER_5_12 VDD VSS sg13g2_hv_fill_1
X_76__13 _76__13/L_HI VDD VSS sg13g2_hv_tiehi
X_51_ _51_/Y _74_/Q _73_/A VDD VSS sg13g2_hv_nand2_1
XFILLER_2_24 VDD VSS sg13g2_hv_fill_8
XFILLER_3_313 VDD VSS sg13g2_hv_fill_8
XFILLER_2_390 VDD VSS sg13g2_hv_fill_2
XFILLER_3_165 VDD VSS sg13g2_hv_fill_8
XFILLER_0_90 VDD VSS sg13g2_hv_fill_8
XFILLER_0_146 VDD VSS sg13g2_hv_fill_2
XFILLER_5_227 VDD VSS sg13g2_hv_fill_8
XFILLER_5_205 VDD VSS sg13g2_hv_fill_8
X_50_ _58_/C _81_/Q _80_/Q VDD VSS sg13g2_hv_and2_2
XFILLER_3_369 VDD VSS sg13g2_hv_fill_8
XFILLER_0_328 VDD VSS sg13g2_hv_fill_8
XFILLER_0_114 VDD VSS sg13g2_hv_fill_8
XFILLER_1_286 VDD VSS sg13g2_hv_decap_4
XFILLER_2_48 VDD VSS sg13g2_hv_fill_8
XFILLER_3_337 VDD VSS sg13g2_hv_fill_8
XFILLER_2_8 VDD VSS sg13g2_hv_fill_8
XFILLER_5_37 VDD VSS sg13g2_hv_fill_8
XFILLER_3_156 VDD VSS sg13g2_hv_decap_4
XFILLER_0_159 VDD VSS sg13g2_hv_fill_1
XFILLER_4_251 VDD VSS sg13g2_hv_decap_4
XFILLER_2_16 VDD VSS sg13g2_hv_fill_8
XFILLER_3_305 VDD VSS sg13g2_hv_fill_8
XFILLER_3_81 VDD VSS sg13g2_hv_fill_8
XFILLER_2_382 VDD VSS sg13g2_hv_fill_8
XFILLER_0_6 VDD VSS sg13g2_hv_fill_8
XFILLER_0_82 VDD VSS sg13g2_hv_fill_8
XFILLER_0_138 VDD VSS sg13g2_hv_fill_8
XFILLER_5_391 VDD VSS sg13g2_hv_fill_1
XFILLER_2_350 VDD VSS sg13g2_hv_fill_8
XFILLER_0_50 VDD VSS sg13g2_hv_fill_8
XFILLER_0_106 VDD VSS sg13g2_hv_fill_8
XFILLER_3_329 VDD VSS sg13g2_hv_fill_8
XFILLER_3_148 VDD VSS sg13g2_hv_fill_8
XFILLER_5_29 VDD VSS sg13g2_hv_fill_8
XFILLER_2_192 VDD VSS sg13g2_hv_fill_8
X_79__16 _79__16/L_HI VDD VSS sg13g2_hv_tiehi
XFILLER_4_243 VDD VSS sg13g2_hv_fill_8
XFILLER_4_221 VDD VSS sg13g2_hv_fill_1
XFILLER_5_371 VDD VSS sg13g2_hv_decap_4
X_81__11 _81__11/L_HI VDD VSS sg13g2_hv_tiehi
XFILLER_2_374 VDD VSS sg13g2_hv_fill_8
XFILLER_2_160 VDD VSS sg13g2_hv_fill_8
XFILLER_0_30 VDD VSS sg13g2_hv_fill_8
XFILLER_0_74 VDD VSS sg13g2_hv_fill_8
XFILLER_5_19 VDD VSS sg13g2_hv_decap_4
XFILLER_4_288 VDD VSS sg13g2_hv_fill_1
XFILLER_1_203 VDD VSS sg13g2_hv_decap_4
XFILLER_0_280 VDD VSS sg13g2_hv_fill_8
XFILLER_5_383 VDD VSS sg13g2_hv_fill_8
XFILLER_5_0 VDD VSS sg13g2_hv_fill_8
XFILLER_2_342 VDD VSS sg13g2_hv_fill_8
Xoutput3 counter_value_o[0] _77_/Q VDD VSS sg13g2_hv_buf_1
XFILLER_3_97 VDD VSS sg13g2_hv_fill_2
XFILLER_3_31 VDD VSS sg13g2_hv_fill_8
X_69_ _70_/B _78_/Q _69_/B VDD VSS sg13g2_hv_xnor2_1
XFILLER_2_310 VDD VSS sg13g2_hv_fill_8
XFILLER_2_184 VDD VSS sg13g2_hv_fill_8
XFILLER_0_98 VDD VSS sg13g2_hv_fill_8
Xoutput4 counter_value_o[1] _78_/Q VDD VSS sg13g2_hv_buf_1
XFILLER_0_260 VDD VSS sg13g2_hv_fill_8
XFILLER_5_363 VDD VSS sg13g2_hv_fill_8
XFILLER_2_366 VDD VSS sg13g2_hv_fill_8
X_68_ _69_/B _71_/A _77_/Q VDD VSS sg13g2_hv_nand2_1
XFILLER_2_152 VDD VSS sg13g2_hv_fill_8
XFILLER_0_22 VDD VSS sg13g2_hv_fill_8
XFILLER_0_66 VDD VSS sg13g2_hv_fill_8
Xclkbuf_0_clock_i clkbuf_0_clock_i/X clock_i VDD VSS sg13g2_hv_buf_16
XFILLER_5_375 VDD VSS sg13g2_hv_fill_2
XFILLER_5_331 VDD VSS sg13g2_hv_fill_8
Xoutput5 counter_value_o[2] _79_/Q VDD VSS sg13g2_hv_buf_1
XFILLER_3_99 VDD VSS sg13g2_hv_fill_1
XFILLER_3_55 VDD VSS sg13g2_hv_decap_8
XFILLER_0_272 VDD VSS sg13g2_hv_fill_1
XFILLER_5_183 VDD VSS sg13g2_hv_fill_2
XFILLER_2_334 VDD VSS sg13g2_hv_fill_8
X_67_ _77_/D _73_/A _67_/B VDD VSS sg13g2_hv_and2_1
Xoutput6 counter_value_o[3] _80_/Q VDD VSS sg13g2_hv_buf_1
.ends

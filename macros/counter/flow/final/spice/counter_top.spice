* NGSPICE file created from counter_top.ext - technology: ihp-sg13g2

* Black-box entry subcircuit for sg13g2_decap_8 abstract view
.subckt sg13g2_decap_8 VDD VSS
.ends

* Black-box entry subcircuit for sg13g2_or3_1 abstract view
.subckt sg13g2_or3_1 X A B C VDD VSS
.ends

* Black-box entry subcircuit for sg13g2_mux2_1 abstract view
.subckt sg13g2_mux2_1 X A0 A1 S VDD VSS
.ends

* Black-box entry subcircuit for sg13g2_dlygate4sd3_1 abstract view
.subckt sg13g2_dlygate4sd3_1 X A VDD VSS
.ends

* Black-box entry subcircuit for sg13g2_buf_1 abstract view
.subckt sg13g2_buf_1 X A VDD VSS
.ends

* Black-box entry subcircuit for sg13g2_tiehi abstract view
.subckt sg13g2_tiehi L_HI VDD VSS
.ends

* Black-box entry subcircuit for sg13g2_o21ai_1 abstract view
.subckt sg13g2_o21ai_1 Y A1 A2 B1 VDD VSS
.ends

* Black-box entry subcircuit for sg13g2_nor3_2 abstract view
.subckt sg13g2_nor3_2 Y A B C VDD VSS
.ends

* Black-box entry subcircuit for sg13g2_fill_2 abstract view
.subckt sg13g2_fill_2 VDD VSS
.ends

* Black-box entry subcircuit for sg13g2_fill_1 abstract view
.subckt sg13g2_fill_1 VDD VSS
.ends

* Black-box entry subcircuit for sg13g2_nand3_1 abstract view
.subckt sg13g2_nand3_1 Y A B C VDD VSS
.ends

* Black-box entry subcircuit for sg13g2_inv_1 abstract view
.subckt sg13g2_inv_1 Y A VDD VSS
.ends

* Black-box entry subcircuit for sg13g2_decap_4 abstract view
.subckt sg13g2_decap_4 VDD VSS
.ends

* Black-box entry subcircuit for sg13g2_a21oi_1 abstract view
.subckt sg13g2_a21oi_1 Y A1 A2 B1 VDD VSS
.ends

* Black-box entry subcircuit for sg13g2_nor2_1 abstract view
.subckt sg13g2_nor2_1 Y A B VDD VSS
.ends

* Black-box entry subcircuit for sg13g2_and2_1 abstract view
.subckt sg13g2_and2_1 X A B VDD VSS
.ends

* Black-box entry subcircuit for sg13g2_nand2_1 abstract view
.subckt sg13g2_nand2_1 Y A B VDD VSS
.ends

* Black-box entry subcircuit for sg13g2_nand4_1 abstract view
.subckt sg13g2_nand4_1 Y A B C D VDD VSS
.ends

* Black-box entry subcircuit for sg13g2_buf_16 abstract view
.subckt sg13g2_buf_16 X A VDD VSS
.ends

* Black-box entry subcircuit for sg13g2_dfrbpq_1 abstract view
.subckt sg13g2_dfrbpq_1 Q CLK D RESET_B VDD VSS
.ends

* Black-box entry subcircuit for sg13g2_xor2_1 abstract view
.subckt sg13g2_xor2_1 X A B VDD VSS
.ends

* Black-box entry subcircuit for sg13g2_buf_4 abstract view
.subckt sg13g2_buf_4 X A VDD VSS
.ends

* Black-box entry subcircuit for sg13g2_xnor2_1 abstract view
.subckt sg13g2_xnor2_1 Y A B VDD VSS
.ends

.subckt counter_top VDD VSS clock_i counter_value_o[0] counter_value_o[1] counter_value_o[2]
+ counter_value_o[3] counter_value_o[4] counter_value_o[5] counter_value_o[6] counter_value_o[7]
+ enable_i reset_n_i
XFILLER_39_266 VDD VSS sg13g2_decap_8
XFILLER_22_144 VDD VSS sg13g2_decap_8
XFILLER_7_7 VDD VSS sg13g2_decap_8
XFILLER_13_133 VDD VSS sg13g2_decap_8
XFILLER_26_63 VDD VSS sg13g2_decap_8
XFILLER_9_126 VDD VSS sg13g2_decap_8
XFILLER_42_84 VDD VSS sg13g2_decap_8
XFILLER_5_354 VDD VSS sg13g2_decap_8
XFILLER_3_56 VDD VSS sg13g2_decap_8
XFILLER_36_203 VDD VSS sg13g2_decap_8
XFILLER_42_217 VDD VSS sg13g2_decap_8
XFILLER_35_280 VDD VSS sg13g2_decap_8
XFILLER_27_203 VDD VSS sg13g2_decap_8
XFILLER_10_147 VDD VSS sg13g2_decap_8
XFILLER_12_21 VDD VSS sg13g2_decap_8
XFILLER_12_98 VDD VSS sg13g2_decap_8
XFILLER_5_4 VDD VSS sg13g2_decap_8
XFILLER_2_357 VDD VSS sg13g2_decap_8
XFILLER_18_203 VDD VSS sg13g2_decap_8
XFILLER_37_84 VDD VSS sg13g2_decap_8
XFILLER_33_217 VDD VSS sg13g2_decap_8
XFILLER_26_280 VDD VSS sg13g2_decap_8
XFILLER_5_151 VDD VSS sg13g2_decap_8
XFILLER_41_294 VDD VSS sg13g2_decap_8
XFILLER_17_280 VDD VSS sg13g2_decap_8
XFILLER_24_217 VDD VSS sg13g2_decap_8
X_66_ _66_/X _66_/A _66_/B _66_/C VDD VSS sg13g2_or3_1
XFILLER_32_294 VDD VSS sg13g2_decap_8
XFILLER_15_217 VDD VSS sg13g2_decap_8
XFILLER_23_294 VDD VSS sg13g2_decap_8
XFILLER_23_42 VDD VSS sg13g2_decap_8
XFILLER_2_154 VDD VSS sg13g2_decap_8
XFILLER_0_35 VDD VSS sg13g2_decap_8
XFILLER_14_294 VDD VSS sg13g2_decap_8
XFILLER_9_77 VDD VSS sg13g2_decap_8
XFILLER_29_0 VDD VSS sg13g2_decap_8
X_49_ _75_/D _45_/X _46_/Y _49_/S VDD VSS sg13g2_mux2_1
XFILLER_37_364 VDD VSS sg13g2_decap_8
XFILLER_20_231 VDD VSS sg13g2_decap_8
XFILLER_18_42 VDD VSS sg13g2_decap_8
XFILLER_43_301 VDD VSS sg13g2_decap_8
XFILLER_11_231 VDD VSS sg13g2_decap_8
XFILLER_43_378 VDD VSS sg13g2_decap_8
XFILLER_34_63 VDD VSS sg13g2_decap_8
XFILLER_7_224 VDD VSS sg13g2_decap_8
XFILLER_34_378 VDD VSS sg13g2_decap_8
XFILLER_34_301 VDD VSS sg13g2_decap_8
XFILLER_25_301 VDD VSS sg13g2_decap_8
XFILLER_37_161 VDD VSS sg13g2_decap_8
XFILLER_40_315 VDD VSS sg13g2_decap_8
XFILLER_20_21 VDD VSS sg13g2_decap_8
XFILLER_4_238 VDD VSS sg13g2_decap_8
XFILLER_20_98 VDD VSS sg13g2_decap_8
Xhold30 _58_/A _71_/Q VDD VSS sg13g2_dlygate4sd3_1
XFILLER_29_63 VDD VSS sg13g2_decap_8
XFILLER_16_301 VDD VSS sg13g2_decap_8
XFILLER_43_175 VDD VSS sg13g2_decap_8
XFILLER_31_315 VDD VSS sg13g2_decap_8
XFILLER_28_161 VDD VSS sg13g2_decap_8
XFILLER_6_56 VDD VSS sg13g2_decap_8
XFILLER_19_161 VDD VSS sg13g2_decap_8
XFILLER_22_326 VDD VSS sg13g2_decap_8
XFILLER_34_175 VDD VSS sg13g2_decap_8
XFILLER_30_381 VDD VSS sg13g2_decap_8
XFILLER_13_315 VDD VSS sg13g2_decap_8
XFILLER_15_21 VDD VSS sg13g2_decap_8
XFILLER_25_175 VDD VSS sg13g2_decap_8
XFILLER_15_98 VDD VSS sg13g2_decap_8
XFILLER_9_308 VDD VSS sg13g2_decap_8
XFILLER_40_189 VDD VSS sg13g2_decap_8
XFILLER_40_112 VDD VSS sg13g2_decap_8
XFILLER_31_42 VDD VSS sg13g2_decap_8
Xoutput7 counter_value_o[4] _72_/Q VDD VSS sg13g2_buf_1
XFILLER_0_252 VDD VSS sg13g2_decap_8
XFILLER_16_175 VDD VSS sg13g2_decap_8
XFILLER_31_112 VDD VSS sg13g2_decap_8
XFILLER_8_385 VDD VSS sg13g2_decap_8
XFILLER_31_189 VDD VSS sg13g2_decap_8
XFILLER_11_0 VDD VSS sg13g2_decap_8
XFILLER_39_245 VDD VSS sg13g2_decap_8
XFILLER_10_329 VDD VSS sg13g2_decap_8
XFILLER_22_123 VDD VSS sg13g2_decap_8
X_75__14 _75__14/L_HI VDD VSS sg13g2_tiehi
XFILLER_13_112 VDD VSS sg13g2_decap_8
XFILLER_9_105 VDD VSS sg13g2_decap_8
XFILLER_26_42 VDD VSS sg13g2_decap_8
XFILLER_13_189 VDD VSS sg13g2_decap_8
XFILLER_5_333 VDD VSS sg13g2_decap_8
XFILLER_42_63 VDD VSS sg13g2_decap_8
XFILLER_3_35 VDD VSS sg13g2_decap_8
XFILLER_36_259 VDD VSS sg13g2_decap_8
XFILLER_8_182 VDD VSS sg13g2_decap_8
X_72__17 _72__17/L_HI VDD VSS sg13g2_tiehi
XFILLER_27_259 VDD VSS sg13g2_decap_8
XFILLER_10_126 VDD VSS sg13g2_decap_8
XFILLER_12_77 VDD VSS sg13g2_decap_8
XFILLER_6_119 VDD VSS sg13g2_decap_8
XFILLER_2_336 VDD VSS sg13g2_decap_8
XFILLER_18_259 VDD VSS sg13g2_decap_8
XFILLER_37_63 VDD VSS sg13g2_decap_8
XFILLER_41_273 VDD VSS sg13g2_decap_8
XFILLER_5_130 VDD VSS sg13g2_decap_8
X_65_ _65_/Y _66_/B _66_/C _66_/A VDD VSS sg13g2_o21ai_1
XFILLER_32_273 VDD VSS sg13g2_decap_8
XFILLER_23_21 VDD VSS sg13g2_decap_8
XFILLER_23_273 VDD VSS sg13g2_decap_8
XFILLER_23_98 VDD VSS sg13g2_decap_8
XFILLER_2_133 VDD VSS sg13g2_decap_8
XFILLER_0_14 VDD VSS sg13g2_decap_8
XFILLER_14_273 VDD VSS sg13g2_decap_8
XFILLER_9_56 VDD VSS sg13g2_decap_8
X_48_ _49_/S _48_/A _66_/B _48_/C VDD VSS sg13g2_nor3_2
XFILLER_37_343 VDD VSS sg13g2_decap_8
XFILLER_20_210 VDD VSS sg13g2_decap_8
XFILLER_20_287 VDD VSS sg13g2_decap_8
XFILLER_18_21 VDD VSS sg13g2_decap_8
XFILLER_18_98 VDD VSS sg13g2_decap_8
XFILLER_43_357 VDD VSS sg13g2_decap_8
XFILLER_11_210 VDD VSS sg13g2_decap_8
XFILLER_11_287 VDD VSS sg13g2_decap_8
XFILLER_7_203 VDD VSS sg13g2_decap_8
XFILLER_34_42 VDD VSS sg13g2_decap_8
XFILLER_15_7 VDD VSS sg13g2_decap_8
XFILLER_19_343 VDD VSS sg13g2_decap_8
XFILLER_19_354 VDD VSS sg13g2_fill_2
XFILLER_19_387 VDD VSS sg13g2_fill_1
XFILLER_34_357 VDD VSS sg13g2_decap_8
XFILLER_6_280 VDD VSS sg13g2_decap_8
XFILLER_41_0 VDD VSS sg13g2_decap_8
XFILLER_37_140 VDD VSS sg13g2_decap_8
XFILLER_25_357 VDD VSS sg13g2_fill_2
XFILLER_20_77 VDD VSS sg13g2_decap_8
XFILLER_4_217 VDD VSS sg13g2_decap_8
Xhold31 _59_/B _58_/X VDD VSS sg13g2_dlygate4sd3_1
Xhold20 _67_/A1 _65_/Y VDD VSS sg13g2_dlygate4sd3_1
XFILLER_29_42 VDD VSS sg13g2_decap_8
XFILLER_28_140 VDD VSS sg13g2_decap_8
XFILLER_16_357 VDD VSS sg13g2_fill_2
XFILLER_43_154 VDD VSS sg13g2_decap_8
XFILLER_6_35 VDD VSS sg13g2_decap_8
XFILLER_3_294 VDD VSS sg13g2_decap_8
XFILLER_19_140 VDD VSS sg13g2_decap_8
XFILLER_22_305 VDD VSS sg13g2_decap_8
XFILLER_22_349 VDD VSS sg13g2_fill_1
XFILLER_34_154 VDD VSS sg13g2_decap_8
XFILLER_25_154 VDD VSS sg13g2_decap_8
XFILLER_15_77 VDD VSS sg13g2_decap_8
XFILLER_40_168 VDD VSS sg13g2_decap_8
XFILLER_31_21 VDD VSS sg13g2_decap_8
XFILLER_0_231 VDD VSS sg13g2_decap_8
Xoutput8 counter_value_o[5] _73_/Q VDD VSS sg13g2_buf_1
Xoutput10 counter_value_o[7] _75_/Q VDD VSS sg13g2_buf_1
XFILLER_31_98 VDD VSS sg13g2_decap_8
XFILLER_16_154 VDD VSS sg13g2_decap_8
XFILLER_31_168 VDD VSS sg13g2_decap_8
XFILLER_8_364 VDD VSS sg13g2_decap_8
XFILLER_39_224 VDD VSS sg13g2_decap_8
XFILLER_22_102 VDD VSS sg13g2_decap_8
XFILLER_10_308 VDD VSS sg13g2_decap_8
XFILLER_22_179 VDD VSS sg13g2_decap_8
XFILLER_26_21 VDD VSS sg13g2_decap_8
XFILLER_13_168 VDD VSS sg13g2_decap_8
XFILLER_42_42 VDD VSS sg13g2_decap_8
XFILLER_26_98 VDD VSS sg13g2_decap_8
XFILLER_5_312 VDD VSS sg13g2_decap_8
XFILLER_5_389 VDD VSS sg13g2_fill_2
XFILLER_3_14 VDD VSS sg13g2_decap_8
XFILLER_36_238 VDD VSS sg13g2_decap_8
XFILLER_8_161 VDD VSS sg13g2_decap_8
XFILLER_27_238 VDD VSS sg13g2_decap_8
XFILLER_10_105 VDD VSS sg13g2_decap_8
XFILLER_12_56 VDD VSS sg13g2_decap_8
XFILLER_2_315 VDD VSS sg13g2_decap_8
XFILLER_18_238 VDD VSS sg13g2_decap_8
XFILLER_37_42 VDD VSS sg13g2_decap_8
XFILLER_41_252 VDD VSS sg13g2_decap_8
XFILLER_5_186 VDD VSS sg13g2_decap_8
X_64_ _66_/C _72_/Q _71_/Q _70_/Q VDD VSS sg13g2_nand3_1
XFILLER_32_252 VDD VSS sg13g2_decap_8
XFILLER_23_252 VDD VSS sg13g2_decap_8
XFILLER_23_77 VDD VSS sg13g2_decap_8
XFILLER_2_112 VDD VSS sg13g2_decap_8
XFILLER_2_189 VDD VSS sg13g2_decap_8
XFILLER_14_252 VDD VSS sg13g2_decap_8
XFILLER_9_35 VDD VSS sg13g2_decap_8
X_47_ _48_/A _47_/A VDD VSS sg13g2_inv_1
XFILLER_37_322 VDD VSS sg13g2_decap_8
XFILLER_20_266 VDD VSS sg13g2_decap_8
XFILLER_28_322 VDD VSS sg13g2_decap_8
XFILLER_18_77 VDD VSS sg13g2_decap_8
XFILLER_43_336 VDD VSS sg13g2_decap_8
XFILLER_34_21 VDD VSS sg13g2_decap_8
XFILLER_11_266 VDD VSS sg13g2_decap_8
XFILLER_7_259 VDD VSS sg13g2_decap_8
XFILLER_34_98 VDD VSS sg13g2_decap_8
XFILLER_1_0 VDD VSS sg13g2_decap_8
XFILLER_19_322 VDD VSS sg13g2_decap_8
XFILLER_38_119 VDD VSS sg13g2_decap_8
XFILLER_34_336 VDD VSS sg13g2_decap_8
XFILLER_34_0 VDD VSS sg13g2_decap_8
XFILLER_29_119 VDD VSS sg13g2_decap_8
XFILLER_1_91 VDD VSS sg13g2_decap_8
XFILLER_25_336 VDD VSS sg13g2_decap_8
XFILLER_37_196 VDD VSS sg13g2_decap_8
XFILLER_20_56 VDD VSS sg13g2_decap_8
Xhold32 _50_/B _68_/Q VDD VSS sg13g2_dlygate4sd3_1
Xhold21 _73_/D _67_/Y VDD VSS sg13g2_dlygate4sd3_1
XFILLER_29_98 VDD VSS sg13g2_decap_8
XFILLER_29_21 VDD VSS sg13g2_decap_8
XFILLER_16_336 VDD VSS sg13g2_decap_8
XFILLER_24_391 VDD VSS sg13g2_fill_1
XFILLER_43_133 VDD VSS sg13g2_decap_8
XFILLER_28_196 VDD VSS sg13g2_decap_8
XFILLER_6_14 VDD VSS sg13g2_decap_8
XFILLER_3_273 VDD VSS sg13g2_decap_8
XFILLER_19_196 VDD VSS sg13g2_decap_8
XFILLER_34_133 VDD VSS sg13g2_decap_8
XFILLER_30_350 VDD VSS sg13g2_decap_4
XFILLER_15_56 VDD VSS sg13g2_decap_8
XFILLER_25_133 VDD VSS sg13g2_decap_8
XFILLER_40_147 VDD VSS sg13g2_decap_8
XFILLER_21_350 VDD VSS sg13g2_decap_4
XFILLER_31_77 VDD VSS sg13g2_decap_8
XFILLER_0_210 VDD VSS sg13g2_decap_8
XFILLER_0_287 VDD VSS sg13g2_decap_8
Xoutput9 counter_value_o[6] _74_/Q VDD VSS sg13g2_buf_1
XFILLER_16_133 VDD VSS sg13g2_decap_8
XFILLER_8_343 VDD VSS sg13g2_decap_8
XFILLER_31_147 VDD VSS sg13g2_decap_8
XFILLER_39_203 VDD VSS sg13g2_decap_8
XFILLER_22_158 VDD VSS sg13g2_decap_8
XFILLER_38_280 VDD VSS sg13g2_decap_8
XFILLER_13_147 VDD VSS sg13g2_decap_8
XFILLER_42_21 VDD VSS sg13g2_decap_8
XFILLER_26_77 VDD VSS sg13g2_decap_8
XFILLER_5_368 VDD VSS sg13g2_decap_8
XFILLER_42_98 VDD VSS sg13g2_decap_8
XFILLER_36_217 VDD VSS sg13g2_decap_8
XFILLER_29_280 VDD VSS sg13g2_decap_8
XFILLER_8_140 VDD VSS sg13g2_decap_8
XFILLER_27_217 VDD VSS sg13g2_decap_8
XFILLER_35_294 VDD VSS sg13g2_decap_8
XFILLER_12_35 VDD VSS sg13g2_decap_8
XFILLER_37_21 VDD VSS sg13g2_decap_8
XFILLER_18_217 VDD VSS sg13g2_decap_8
XFILLER_41_231 VDD VSS sg13g2_decap_8
XFILLER_37_98 VDD VSS sg13g2_decap_8
XFILLER_26_294 VDD VSS sg13g2_decap_8
XFILLER_1_371 VDD VSS sg13g2_decap_8
XFILLER_5_165 VDD VSS sg13g2_decap_8
XFILLER_38_7 VDD VSS sg13g2_decap_8
X_63_ _63_/Y _63_/A1 _62_/X _59_/A VDD VSS sg13g2_a21oi_1
XFILLER_17_294 VDD VSS sg13g2_decap_8
XFILLER_32_231 VDD VSS sg13g2_decap_8
XFILLER_4_91 VDD VSS sg13g2_decap_8
XFILLER_23_231 VDD VSS sg13g2_decap_8
XFILLER_23_56 VDD VSS sg13g2_decap_8
XFILLER_2_168 VDD VSS sg13g2_decap_8
XFILLER_0_49 VDD VSS sg13g2_decap_8
XFILLER_14_231 VDD VSS sg13g2_decap_8
XFILLER_9_14 VDD VSS sg13g2_decap_8
X_46_ _46_/Y _46_/A _59_/A VDD VSS sg13g2_nor2_1
XFILLER_37_378 VDD VSS sg13g2_decap_8
XFILLER_37_301 VDD VSS sg13g2_decap_8
XFILLER_20_245 VDD VSS sg13g2_decap_8
XFILLER_18_56 VDD VSS sg13g2_decap_8
XFILLER_28_301 VDD VSS sg13g2_decap_8
XFILLER_43_315 VDD VSS sg13g2_decap_8
XFILLER_34_77 VDD VSS sg13g2_decap_8
XFILLER_28_389 VDD VSS sg13g2_fill_2
XFILLER_11_245 VDD VSS sg13g2_decap_8
XFILLER_7_238 VDD VSS sg13g2_decap_8
XFILLER_19_301 VDD VSS sg13g2_decap_8
XFILLER_34_315 VDD VSS sg13g2_decap_8
XFILLER_27_0 VDD VSS sg13g2_decap_8
XFILLER_1_70 VDD VSS sg13g2_decap_8
XFILLER_25_315 VDD VSS sg13g2_decap_8
XFILLER_40_329 VDD VSS sg13g2_decap_8
XFILLER_37_175 VDD VSS sg13g2_decap_8
XFILLER_25_359 VDD VSS sg13g2_fill_1
XFILLER_20_35 VDD VSS sg13g2_decap_8
Xhold22 _47_/A _74_/Q VDD VSS sg13g2_dlygate4sd3_1
XFILLER_16_315 VDD VSS sg13g2_decap_8
Xhold33 _55_/A _70_/Q VDD VSS sg13g2_dlygate4sd3_1
XFILLER_43_112 VDD VSS sg13g2_decap_8
XFILLER_29_77 VDD VSS sg13g2_decap_8
XFILLER_28_175 VDD VSS sg13g2_decap_8
XFILLER_43_189 VDD VSS sg13g2_decap_8
XFILLER_31_329 VDD VSS sg13g2_decap_8
XFILLER_3_252 VDD VSS sg13g2_decap_8
XFILLER_20_7 VDD VSS sg13g2_decap_8
XFILLER_19_175 VDD VSS sg13g2_decap_8
XFILLER_34_189 VDD VSS sg13g2_decap_8
XFILLER_34_112 VDD VSS sg13g2_decap_8
XFILLER_25_112 VDD VSS sg13g2_decap_8
XFILLER_13_329 VDD VSS sg13g2_decap_8
XFILLER_15_35 VDD VSS sg13g2_decap_8
XFILLER_25_189 VDD VSS sg13g2_decap_8
XFILLER_40_126 VDD VSS sg13g2_decap_8
XFILLER_31_56 VDD VSS sg13g2_decap_8
XFILLER_0_266 VDD VSS sg13g2_decap_8
XFILLER_16_112 VDD VSS sg13g2_decap_8
XFILLER_16_189 VDD VSS sg13g2_decap_8
XFILLER_8_322 VDD VSS sg13g2_decap_8
XFILLER_31_126 VDD VSS sg13g2_decap_8
XFILLER_39_259 VDD VSS sg13g2_decap_8
XFILLER_22_137 VDD VSS sg13g2_decap_8
XFILLER_7_91 VDD VSS sg13g2_decap_8
XFILLER_26_56 VDD VSS sg13g2_decap_8
XFILLER_13_126 VDD VSS sg13g2_decap_8
XFILLER_9_119 VDD VSS sg13g2_decap_8
XFILLER_42_77 VDD VSS sg13g2_decap_8
XFILLER_5_347 VDD VSS sg13g2_decap_8
XFILLER_3_49 VDD VSS sg13g2_decap_8
XFILLER_8_196 VDD VSS sg13g2_decap_8
XFILLER_35_273 VDD VSS sg13g2_decap_8
XFILLER_12_14 VDD VSS sg13g2_decap_8
XFILLER_41_210 VDD VSS sg13g2_decap_8
XFILLER_37_77 VDD VSS sg13g2_decap_8
XFILLER_26_273 VDD VSS sg13g2_decap_8
XFILLER_5_144 VDD VSS sg13g2_decap_8
XFILLER_41_287 VDD VSS sg13g2_decap_8
XFILLER_1_350 VDD VSS sg13g2_decap_8
XFILLER_17_273 VDD VSS sg13g2_decap_8
X_62_ _62_/X _62_/A _66_/B _62_/C VDD VSS sg13g2_or3_1
XFILLER_32_287 VDD VSS sg13g2_decap_8
XFILLER_32_210 VDD VSS sg13g2_decap_8
XFILLER_4_70 VDD VSS sg13g2_decap_8
XFILLER_23_210 VDD VSS sg13g2_decap_8
XFILLER_23_287 VDD VSS sg13g2_decap_8
XFILLER_23_35 VDD VSS sg13g2_decap_8
XFILLER_2_147 VDD VSS sg13g2_decap_8
XFILLER_0_28 VDD VSS sg13g2_decap_8
XFILLER_14_210 VDD VSS sg13g2_decap_8
XFILLER_14_287 VDD VSS sg13g2_decap_8
X_45_ _45_/X _46_/A _45_/B VDD VSS sg13g2_and2_1
XFILLER_37_357 VDD VSS sg13g2_decap_8
XFILLER_20_224 VDD VSS sg13g2_decap_8
XFILLER_9_280 VDD VSS sg13g2_decap_8
XFILLER_18_35 VDD VSS sg13g2_decap_8
XFILLER_11_224 VDD VSS sg13g2_decap_8
XFILLER_34_56 VDD VSS sg13g2_decap_8
XFILLER_7_217 VDD VSS sg13g2_decap_8
XFILLER_19_368 VDD VSS sg13g2_fill_2
XFILLER_42_371 VDD VSS sg13g2_decap_8
XFILLER_6_294 VDD VSS sg13g2_decap_8
XFILLER_37_154 VDD VSS sg13g2_decap_8
XFILLER_40_308 VDD VSS sg13g2_decap_8
XFILLER_33_371 VDD VSS sg13g2_decap_8
XFILLER_20_14 VDD VSS sg13g2_decap_8
Xhold34 _46_/A _75_/Q VDD VSS sg13g2_dlygate4sd3_1
Xhold23 _44_/A1 _41_/Y VDD VSS sg13g2_dlygate4sd3_1
XFILLER_29_56 VDD VSS sg13g2_decap_8
XFILLER_43_168 VDD VSS sg13g2_decap_8
XFILLER_31_308 VDD VSS sg13g2_decap_8
XFILLER_28_154 VDD VSS sg13g2_decap_8
XFILLER_10_91 VDD VSS sg13g2_decap_8
XFILLER_6_49 VDD VSS sg13g2_decap_8
XFILLER_3_231 VDD VSS sg13g2_decap_8
XFILLER_13_7 VDD VSS sg13g2_decap_8
XFILLER_19_154 VDD VSS sg13g2_decap_8
XFILLER_22_319 VDD VSS sg13g2_decap_8
XFILLER_34_168 VDD VSS sg13g2_decap_8
XFILLER_15_14 VDD VSS sg13g2_decap_8
XFILLER_13_308 VDD VSS sg13g2_decap_8
XFILLER_25_168 VDD VSS sg13g2_decap_8
XFILLER_40_105 VDD VSS sg13g2_decap_8
XFILLER_31_35 VDD VSS sg13g2_decap_8
XFILLER_0_245 VDD VSS sg13g2_decap_8
XFILLER_16_168 VDD VSS sg13g2_decap_8
XFILLER_31_105 VDD VSS sg13g2_decap_8
XFILLER_12_385 VDD VSS sg13g2_decap_8
XFILLER_8_301 VDD VSS sg13g2_decap_8
XFILLER_8_378 VDD VSS sg13g2_decap_8
XFILLER_39_238 VDD VSS sg13g2_decap_8
XFILLER_22_116 VDD VSS sg13g2_decap_8
XFILLER_30_182 VDD VSS sg13g2_decap_8
XFILLER_7_70 VDD VSS sg13g2_decap_8
XFILLER_13_105 VDD VSS sg13g2_decap_8
XFILLER_26_35 VDD VSS sg13g2_decap_8
XFILLER_21_182 VDD VSS sg13g2_decap_8
XFILLER_5_326 VDD VSS sg13g2_decap_8
XFILLER_42_56 VDD VSS sg13g2_decap_8
XFILLER_3_28 VDD VSS sg13g2_decap_8
XFILLER_12_182 VDD VSS sg13g2_decap_8
XFILLER_8_175 VDD VSS sg13g2_decap_8
XFILLER_35_252 VDD VSS sg13g2_decap_8
XFILLER_10_119 VDD VSS sg13g2_decap_8
XFILLER_2_329 VDD VSS sg13g2_decap_8
XFILLER_37_56 VDD VSS sg13g2_decap_8
XFILLER_41_266 VDD VSS sg13g2_decap_8
XFILLER_26_252 VDD VSS sg13g2_decap_8
XFILLER_5_123 VDD VSS sg13g2_decap_8
X_61_ _61_/Y _66_/B _62_/C _62_/A VDD VSS sg13g2_o21ai_1
XFILLER_17_252 VDD VSS sg13g2_decap_8
XFILLER_32_266 VDD VSS sg13g2_decap_8
XFILLER_23_14 VDD VSS sg13g2_decap_8
XFILLER_23_266 VDD VSS sg13g2_decap_8
XFILLER_2_126 VDD VSS sg13g2_decap_8
XFILLER_14_266 VDD VSS sg13g2_decap_8
XFILLER_9_49 VDD VSS sg13g2_decap_8
XFILLER_13_91 VDD VSS sg13g2_decap_8
XFILLER_43_7 VDD VSS sg13g2_decap_8
X_44_ _44_/Y _44_/A1 _42_/X _59_/A VDD VSS sg13g2_a21oi_1
XFILLER_37_336 VDD VSS sg13g2_decap_8
XFILLER_20_203 VDD VSS sg13g2_decap_8
XFILLER_18_14 VDD VSS sg13g2_decap_8
XFILLER_28_336 VDD VSS sg13g2_decap_4
XFILLER_11_203 VDD VSS sg13g2_decap_8
XFILLER_34_35 VDD VSS sg13g2_decap_8
XFILLER_19_336 VDD VSS sg13g2_decap_8
XFILLER_42_350 VDD VSS sg13g2_decap_8
XFILLER_27_391 VDD VSS sg13g2_fill_1
XFILLER_10_280 VDD VSS sg13g2_decap_8
XFILLER_6_273 VDD VSS sg13g2_decap_8
XFILLER_37_133 VDD VSS sg13g2_decap_8
XFILLER_18_391 VDD VSS sg13g2_fill_1
XFILLER_33_350 VDD VSS sg13g2_decap_8
Xhold24 _74_/D _44_/Y VDD VSS sg13g2_dlygate4sd3_1
XFILLER_29_35 VDD VSS sg13g2_decap_8
XFILLER_43_147 VDD VSS sg13g2_decap_8
XFILLER_28_133 VDD VSS sg13g2_decap_8
XFILLER_6_28 VDD VSS sg13g2_decap_8
XFILLER_10_70 VDD VSS sg13g2_decap_8
XFILLER_3_287 VDD VSS sg13g2_decap_8
XFILLER_3_210 VDD VSS sg13g2_decap_8
XFILLER_19_133 VDD VSS sg13g2_decap_8
XFILLER_15_350 VDD VSS sg13g2_decap_4
XFILLER_34_147 VDD VSS sg13g2_decap_8
XFILLER_32_0 VDD VSS sg13g2_decap_8
XFILLER_25_147 VDD VSS sg13g2_decap_8
XFILLER_31_14 VDD VSS sg13g2_decap_8
XFILLER_0_224 VDD VSS sg13g2_decap_8
XFILLER_16_147 VDD VSS sg13g2_decap_8
XFILLER_21_91 VDD VSS sg13g2_decap_8
XFILLER_8_357 VDD VSS sg13g2_decap_8
XFILLER_39_217 VDD VSS sg13g2_decap_8
XFILLER_30_161 VDD VSS sg13g2_decap_8
XFILLER_26_14 VDD VSS sg13g2_decap_8
XFILLER_42_35 VDD VSS sg13g2_decap_8
XFILLER_38_294 VDD VSS sg13g2_decap_8
XFILLER_21_161 VDD VSS sg13g2_decap_8
XFILLER_5_305 VDD VSS sg13g2_decap_8
XFILLER_29_294 VDD VSS sg13g2_decap_8
XFILLER_12_161 VDD VSS sg13g2_decap_8
XFILLER_16_91 VDD VSS sg13g2_decap_8
XFILLER_8_154 VDD VSS sg13g2_decap_8
XFILLER_4_371 VDD VSS sg13g2_decap_8
XFILLER_35_231 VDD VSS sg13g2_decap_8
XFILLER_12_49 VDD VSS sg13g2_decap_8
XFILLER_2_308 VDD VSS sg13g2_decap_8
XFILLER_37_35 VDD VSS sg13g2_decap_8
XFILLER_26_231 VDD VSS sg13g2_decap_8
XFILLER_41_245 VDD VSS sg13g2_decap_8
XFILLER_5_102 VDD VSS sg13g2_decap_8
XFILLER_5_179 VDD VSS sg13g2_decap_8
XFILLER_1_385 VDD VSS sg13g2_decap_8
X_60_ _62_/C _71_/Q _70_/Q VDD VSS sg13g2_nand2_1
XFILLER_17_231 VDD VSS sg13g2_decap_8
XFILLER_32_245 VDD VSS sg13g2_decap_8
XFILLER_23_245 VDD VSS sg13g2_decap_8
XFILLER_3_7 VDD VSS sg13g2_decap_8
XFILLER_2_105 VDD VSS sg13g2_decap_8
XFILLER_14_245 VDD VSS sg13g2_decap_8
XFILLER_13_70 VDD VSS sg13g2_decap_8
XFILLER_9_28 VDD VSS sg13g2_decap_8
XFILLER_36_7 VDD VSS sg13g2_decap_8
XFILLER_1_182 VDD VSS sg13g2_decap_8
X_43_ _59_/A _45_/B VDD VSS sg13g2_inv_1
XFILLER_37_315 VDD VSS sg13g2_decap_8
XFILLER_20_259 VDD VSS sg13g2_decap_8
XFILLER_28_315 VDD VSS sg13g2_decap_8
XFILLER_43_329 VDD VSS sg13g2_decap_8
XFILLER_34_14 VDD VSS sg13g2_decap_8
XFILLER_11_259 VDD VSS sg13g2_decap_8
XFILLER_19_315 VDD VSS sg13g2_decap_8
XFILLER_34_329 VDD VSS sg13g2_decap_8
XFILLER_24_91 VDD VSS sg13g2_decap_8
XFILLER_6_252 VDD VSS sg13g2_decap_8
XFILLER_1_84 VDD VSS sg13g2_decap_8
XFILLER_25_329 VDD VSS sg13g2_decap_8
XFILLER_37_189 VDD VSS sg13g2_decap_8
XFILLER_37_112 VDD VSS sg13g2_decap_8
XFILLER_20_49 VDD VSS sg13g2_decap_8
Xhold25 _62_/A _72_/Q VDD VSS sg13g2_dlygate4sd3_1
XFILLER_29_14 VDD VSS sg13g2_decap_8
XFILLER_28_112 VDD VSS sg13g2_decap_8
XFILLER_16_329 VDD VSS sg13g2_decap_8
XFILLER_43_126 VDD VSS sg13g2_decap_8
XFILLER_28_189 VDD VSS sg13g2_decap_8
XFILLER_3_266 VDD VSS sg13g2_decap_8
XFILLER_19_112 VDD VSS sg13g2_decap_8
XFILLER_19_189 VDD VSS sg13g2_decap_8
XFILLER_19_91 VDD VSS sg13g2_decap_8
XFILLER_34_126 VDD VSS sg13g2_decap_8
XFILLER_30_343 VDD VSS sg13g2_decap_8
XFILLER_25_0 VDD VSS sg13g2_decap_8
XFILLER_15_49 VDD VSS sg13g2_decap_8
XFILLER_25_126 VDD VSS sg13g2_decap_8
XFILLER_21_343 VDD VSS sg13g2_decap_8
XFILLER_21_354 VDD VSS sg13g2_fill_1
XFILLER_0_203 VDD VSS sg13g2_decap_8
XFILLER_16_126 VDD VSS sg13g2_decap_8
XFILLER_12_343 VDD VSS sg13g2_decap_8
XFILLER_8_336 VDD VSS sg13g2_decap_8
XFILLER_21_70 VDD VSS sg13g2_decap_8
XFILLER_30_140 VDD VSS sg13g2_decap_8
XFILLER_38_273 VDD VSS sg13g2_decap_8
XFILLER_21_140 VDD VSS sg13g2_decap_8
XFILLER_42_14 VDD VSS sg13g2_decap_8
XFILLER_16_70 VDD VSS sg13g2_decap_8
XFILLER_29_273 VDD VSS sg13g2_decap_8
XFILLER_12_140 VDD VSS sg13g2_decap_8
XFILLER_8_133 VDD VSS sg13g2_decap_8
XFILLER_32_91 VDD VSS sg13g2_decap_8
XFILLER_4_350 VDD VSS sg13g2_decap_8
XFILLER_35_210 VDD VSS sg13g2_decap_8
XFILLER_35_287 VDD VSS sg13g2_decap_8
XFILLER_12_28 VDD VSS sg13g2_decap_8
XFILLER_37_14 VDD VSS sg13g2_decap_8
XFILLER_41_224 VDD VSS sg13g2_decap_8
XFILLER_26_287 VDD VSS sg13g2_decap_8
XFILLER_26_210 VDD VSS sg13g2_decap_8
XFILLER_5_158 VDD VSS sg13g2_decap_8
XFILLER_17_210 VDD VSS sg13g2_decap_8
XFILLER_1_364 VDD VSS sg13g2_decap_8
XFILLER_17_287 VDD VSS sg13g2_decap_8
XFILLER_32_224 VDD VSS sg13g2_decap_8
XFILLER_27_91 VDD VSS sg13g2_decap_8
XFILLER_4_84 VDD VSS sg13g2_decap_8
XFILLER_23_224 VDD VSS sg13g2_decap_8
XFILLER_23_49 VDD VSS sg13g2_decap_8
XFILLER_14_224 VDD VSS sg13g2_decap_8
XFILLER_1_161 VDD VSS sg13g2_decap_8
XFILLER_29_7 VDD VSS sg13g2_decap_8
X_42_ _42_/X _47_/A _66_/B _48_/C VDD VSS sg13g2_or3_1
XFILLER_20_238 VDD VSS sg13g2_decap_8
XFILLER_9_294 VDD VSS sg13g2_decap_8
XFILLER_18_49 VDD VSS sg13g2_decap_8
XFILLER_43_308 VDD VSS sg13g2_decap_8
XFILLER_36_371 VDD VSS sg13g2_decap_8
XFILLER_11_238 VDD VSS sg13g2_decap_8
XFILLER_34_308 VDD VSS sg13g2_decap_8
XFILLER_24_70 VDD VSS sg13g2_decap_8
XFILLER_42_385 VDD VSS sg13g2_decap_8
XFILLER_27_382 VDD VSS sg13g2_decap_8
XFILLER_6_231 VDD VSS sg13g2_decap_8
XFILLER_40_91 VDD VSS sg13g2_decap_8
XFILLER_1_63 VDD VSS sg13g2_decap_8
XFILLER_25_308 VDD VSS sg13g2_decap_8
XFILLER_37_168 VDD VSS sg13g2_decap_8
XFILLER_33_385 VDD VSS sg13g2_decap_8
XFILLER_20_28 VDD VSS sg13g2_decap_8
XFILLER_16_308 VDD VSS sg13g2_decap_8
Xhold26 _63_/A1 _61_/Y VDD VSS sg13g2_dlygate4sd3_1
XFILLER_43_105 VDD VSS sg13g2_decap_8
XFILLER_28_168 VDD VSS sg13g2_decap_8
XFILLER_3_245 VDD VSS sg13g2_decap_8
XFILLER_19_168 VDD VSS sg13g2_decap_8
XFILLER_19_70 VDD VSS sg13g2_decap_8
XFILLER_34_105 VDD VSS sg13g2_decap_8
XFILLER_15_385 VDD VSS sg13g2_decap_8
XFILLER_42_182 VDD VSS sg13g2_decap_8
XFILLER_35_91 VDD VSS sg13g2_decap_8
XFILLER_30_388 VDD VSS sg13g2_decap_4
XFILLER_30_322 VDD VSS sg13g2_decap_8
XFILLER_18_0 VDD VSS sg13g2_decap_8
XFILLER_25_105 VDD VSS sg13g2_decap_8
XFILLER_15_28 VDD VSS sg13g2_decap_8
XFILLER_21_322 VDD VSS sg13g2_decap_8
XFILLER_40_119 VDD VSS sg13g2_decap_8
XFILLER_33_182 VDD VSS sg13g2_decap_8
XFILLER_21_366 VDD VSS sg13g2_fill_1
XFILLER_31_49 VDD VSS sg13g2_decap_8
XFILLER_0_259 VDD VSS sg13g2_decap_8
XFILLER_16_105 VDD VSS sg13g2_decap_8
XFILLER_12_322 VDD VSS sg13g2_decap_8
XFILLER_24_182 VDD VSS sg13g2_decap_8
XFILLER_8_315 VDD VSS sg13g2_decap_8
X_69__18 _69__18/L_HI VDD VSS sg13g2_tiehi
XFILLER_31_119 VDD VSS sg13g2_decap_8
XFILLER_11_7 VDD VSS sg13g2_decap_8
XFILLER_15_182 VDD VSS sg13g2_decap_8
XFILLER_7_84 VDD VSS sg13g2_decap_8
XFILLER_30_196 VDD VSS sg13g2_decap_8
XFILLER_38_252 VDD VSS sg13g2_decap_8
XFILLER_26_49 VDD VSS sg13g2_decap_8
XFILLER_13_119 VDD VSS sg13g2_decap_8
XFILLER_21_196 VDD VSS sg13g2_decap_8
XFILLER_29_252 VDD VSS sg13g2_decap_8
XFILLER_12_196 VDD VSS sg13g2_decap_8
XFILLER_8_112 VDD VSS sg13g2_decap_8
XFILLER_8_189 VDD VSS sg13g2_decap_8
XFILLER_32_70 VDD VSS sg13g2_decap_8
XFILLER_35_266 VDD VSS sg13g2_decap_8
X_71__13 _71__13/L_HI VDD VSS sg13g2_tiehi
XFILLER_41_203 VDD VSS sg13g2_decap_8
XFILLER_26_266 VDD VSS sg13g2_decap_8
XFILLER_5_137 VDD VSS sg13g2_decap_8
XFILLER_1_343 VDD VSS sg13g2_decap_8
XFILLER_27_70 VDD VSS sg13g2_decap_8
XFILLER_17_266 VDD VSS sg13g2_decap_8
XFILLER_43_91 VDD VSS sg13g2_decap_8
XFILLER_40_280 VDD VSS sg13g2_decap_8
XFILLER_32_203 VDD VSS sg13g2_decap_8
XFILLER_4_63 VDD VSS sg13g2_decap_8
XFILLER_23_203 VDD VSS sg13g2_decap_8
XFILLER_23_28 VDD VSS sg13g2_decap_8
XFILLER_31_280 VDD VSS sg13g2_decap_8
XFILLER_14_203 VDD VSS sg13g2_decap_8
XFILLER_22_291 VDD VSS sg13g2_decap_8
XFILLER_1_140 VDD VSS sg13g2_decap_8
X_41_ _41_/Y _66_/B _48_/C _47_/A VDD VSS sg13g2_o21ai_1
XFILLER_38_91 VDD VSS sg13g2_decap_8
XFILLER_13_280 VDD VSS sg13g2_decap_8
XFILLER_20_217 VDD VSS sg13g2_decap_8
XFILLER_9_273 VDD VSS sg13g2_decap_8
XFILLER_18_28 VDD VSS sg13g2_decap_8
XFILLER_11_217 VDD VSS sg13g2_decap_8
XFILLER_36_350 VDD VSS sg13g2_decap_8
XFILLER_34_49 VDD VSS sg13g2_decap_8
XFILLER_27_372 VDD VSS sg13g2_fill_1
XFILLER_6_210 VDD VSS sg13g2_decap_8
XFILLER_42_364 VDD VSS sg13g2_decap_8
XFILLER_10_294 VDD VSS sg13g2_decap_8
XFILLER_6_287 VDD VSS sg13g2_decap_8
XFILLER_41_7 VDD VSS sg13g2_decap_8
XFILLER_40_70 VDD VSS sg13g2_decap_8
XFILLER_1_42 VDD VSS sg13g2_decap_8
XFILLER_37_147 VDD VSS sg13g2_decap_8
XFILLER_33_364 VDD VSS sg13g2_decap_8
Xhold27 _72_/D _63_/Y VDD VSS sg13g2_dlygate4sd3_1
XFILLER_29_49 VDD VSS sg13g2_decap_8
XFILLER_28_147 VDD VSS sg13g2_decap_8
XFILLER_3_224 VDD VSS sg13g2_decap_8
XFILLER_10_84 VDD VSS sg13g2_decap_8
XFILLER_19_147 VDD VSS sg13g2_decap_8
XFILLER_42_161 VDD VSS sg13g2_decap_8
XFILLER_35_70 VDD VSS sg13g2_decap_8
XFILLER_30_301 VDD VSS sg13g2_decap_8
XFILLER_21_301 VDD VSS sg13g2_decap_8
XFILLER_33_161 VDD VSS sg13g2_decap_8
XFILLER_31_28 VDD VSS sg13g2_decap_8
XFILLER_0_238 VDD VSS sg13g2_decap_8
XFILLER_12_301 VDD VSS sg13g2_decap_8
XFILLER_24_161 VDD VSS sg13g2_decap_8
XFILLER_15_161 VDD VSS sg13g2_decap_8
XFILLER_22_109 VDD VSS sg13g2_decap_8
XFILLER_7_371 VDD VSS sg13g2_decap_8
XFILLER_7_63 VDD VSS sg13g2_decap_8
XFILLER_30_175 VDD VSS sg13g2_decap_8
XFILLER_30_0 VDD VSS sg13g2_decap_8
XFILLER_38_231 VDD VSS sg13g2_decap_8
XFILLER_26_28 VDD VSS sg13g2_decap_8
XFILLER_21_175 VDD VSS sg13g2_decap_8
XFILLER_5_319 VDD VSS sg13g2_decap_8
XFILLER_42_49 VDD VSS sg13g2_decap_8
XFILLER_29_231 VDD VSS sg13g2_decap_8
XFILLER_12_175 VDD VSS sg13g2_decap_8
XFILLER_8_168 VDD VSS sg13g2_decap_8
XFILLER_4_385 VDD VSS sg13g2_decap_8
XFILLER_35_245 VDD VSS sg13g2_decap_8
XFILLER_37_49 VDD VSS sg13g2_decap_8
XFILLER_41_259 VDD VSS sg13g2_decap_8
XFILLER_26_245 VDD VSS sg13g2_decap_8
XFILLER_5_116 VDD VSS sg13g2_decap_8
XFILLER_1_322 VDD VSS sg13g2_decap_8
XFILLER_17_245 VDD VSS sg13g2_decap_8
XFILLER_43_70 VDD VSS sg13g2_decap_8
XFILLER_32_259 VDD VSS sg13g2_decap_8
XFILLER_4_42 VDD VSS sg13g2_decap_8
XFILLER_4_182 VDD VSS sg13g2_decap_8
XFILLER_23_259 VDD VSS sg13g2_decap_8
XFILLER_2_119 VDD VSS sg13g2_decap_8
XFILLER_14_259 VDD VSS sg13g2_decap_8
XFILLER_22_270 VDD VSS sg13g2_decap_8
XFILLER_13_84 VDD VSS sg13g2_decap_8
XFILLER_8_0 VDD VSS sg13g2_decap_8
XFILLER_1_196 VDD VSS sg13g2_decap_8
X_40_ _48_/C _66_/A _62_/A _58_/A _55_/A VDD VSS sg13g2_nand4_1
XFILLER_38_70 VDD VSS sg13g2_decap_8
XFILLER_37_329 VDD VSS sg13g2_decap_8
XFILLER_9_252 VDD VSS sg13g2_decap_8
XFILLER_28_329 VDD VSS sg13g2_decap_8
XFILLER_34_28 VDD VSS sg13g2_decap_8
XFILLER_19_329 VDD VSS sg13g2_decap_8
XFILLER_1_7 VDD VSS sg13g2_decap_8
XFILLER_42_343 VDD VSS sg13g2_decap_8
XFILLER_10_273 VDD VSS sg13g2_decap_8
XFILLER_6_266 VDD VSS sg13g2_decap_8
XFILLER_34_7 VDD VSS sg13g2_decap_8
XFILLER_1_21 VDD VSS sg13g2_decap_8
XFILLER_1_98 VDD VSS sg13g2_decap_8
XFILLER_37_126 VDD VSS sg13g2_decap_8
XFILLER_33_343 VDD VSS sg13g2_decap_8
Xhold28 _57_/C _69_/Q VDD VSS sg13g2_dlygate4sd3_1
XFILLER_29_28 VDD VSS sg13g2_decap_8
XFILLER_24_343 VDD VSS sg13g2_decap_4
XFILLER_28_126 VDD VSS sg13g2_decap_8
XFILLER_24_387 VDD VSS sg13g2_decap_4
XFILLER_10_63 VDD VSS sg13g2_decap_8
XFILLER_3_203 VDD VSS sg13g2_decap_8
XFILLER_19_126 VDD VSS sg13g2_decap_8
XFILLER_15_343 VDD VSS sg13g2_decap_8
XFILLER_15_354 VDD VSS sg13g2_fill_1
XFILLER_42_140 VDD VSS sg13g2_decap_8
XFILLER_2_280 VDD VSS sg13g2_decap_8
XFILLER_33_140 VDD VSS sg13g2_decap_8
XFILLER_0_217 VDD VSS sg13g2_decap_8
XFILLER_24_140 VDD VSS sg13g2_decap_8
XFILLER_21_84 VDD VSS sg13g2_decap_8
XFILLER_15_140 VDD VSS sg13g2_decap_8
XFILLER_30_154 VDD VSS sg13g2_decap_8
XFILLER_7_350 VDD VSS sg13g2_decap_8
XFILLER_7_42 VDD VSS sg13g2_decap_8
XFILLER_23_0 VDD VSS sg13g2_decap_8
XFILLER_38_210 VDD VSS sg13g2_decap_8
XFILLER_38_287 VDD VSS sg13g2_decap_8
XFILLER_21_154 VDD VSS sg13g2_decap_8
XFILLER_42_28 VDD VSS sg13g2_decap_8
XFILLER_29_287 VDD VSS sg13g2_decap_8
XFILLER_29_210 VDD VSS sg13g2_decap_8
XFILLER_12_154 VDD VSS sg13g2_decap_8
XFILLER_16_84 VDD VSS sg13g2_decap_8
XFILLER_4_364 VDD VSS sg13g2_decap_8
XFILLER_8_147 VDD VSS sg13g2_decap_8
XFILLER_35_224 VDD VSS sg13g2_decap_8
XFILLER_37_28 VDD VSS sg13g2_decap_8
XFILLER_26_224 VDD VSS sg13g2_decap_8
XFILLER_41_238 VDD VSS sg13g2_decap_8
XFILLER_1_301 VDD VSS sg13g2_decap_8
XFILLER_1_378 VDD VSS sg13g2_decap_8
XFILLER_17_224 VDD VSS sg13g2_decap_8
XFILLER_32_238 VDD VSS sg13g2_decap_8
XFILLER_4_21 VDD VSS sg13g2_decap_8
XFILLER_4_161 VDD VSS sg13g2_decap_8
XFILLER_4_98 VDD VSS sg13g2_decap_8
XFILLER_23_238 VDD VSS sg13g2_decap_8
XFILLER_14_238 VDD VSS sg13g2_decap_8
XFILLER_39_371 VDD VSS sg13g2_decap_8
XFILLER_13_63 VDD VSS sg13g2_decap_8
XFILLER_1_175 VDD VSS sg13g2_decap_8
XFILLER_37_308 VDD VSS sg13g2_decap_8
XFILLER_9_231 VDD VSS sg13g2_decap_8
XFILLER_36_385 VDD VSS sg13g2_decap_8
XFILLER_28_308 VDD VSS sg13g2_decap_8
XFILLER_19_308 VDD VSS sg13g2_decap_8
XFILLER_42_322 VDD VSS sg13g2_decap_8
XFILLER_10_252 VDD VSS sg13g2_decap_8
XFILLER_24_84 VDD VSS sg13g2_decap_8
XFILLER_6_245 VDD VSS sg13g2_decap_8
XFILLER_27_7 VDD VSS sg13g2_decap_8
XFILLER_1_77 VDD VSS sg13g2_decap_8
XFILLER_37_105 VDD VSS sg13g2_decap_8
XFILLER_33_322 VDD VSS sg13g2_decap_8
Xhold29 _54_/B _53_/X VDD VSS sg13g2_dlygate4sd3_1
XFILLER_28_105 VDD VSS sg13g2_decap_8
XFILLER_24_322 VDD VSS sg13g2_decap_8
XFILLER_43_119 VDD VSS sg13g2_decap_8
XFILLER_36_182 VDD VSS sg13g2_decap_8
XFILLER_10_42 VDD VSS sg13g2_decap_8
XFILLER_3_259 VDD VSS sg13g2_decap_8
XFILLER_19_105 VDD VSS sg13g2_decap_8
XFILLER_19_84 VDD VSS sg13g2_decap_8
XFILLER_34_119 VDD VSS sg13g2_decap_8
XFILLER_15_322 VDD VSS sg13g2_decap_8
XFILLER_42_196 VDD VSS sg13g2_decap_8
XFILLER_30_336 VDD VSS sg13g2_decap_8
XFILLER_27_182 VDD VSS sg13g2_decap_8
XFILLER_18_182 VDD VSS sg13g2_decap_8
XFILLER_25_119 VDD VSS sg13g2_decap_8
XFILLER_21_336 VDD VSS sg13g2_decap_8
XFILLER_33_196 VDD VSS sg13g2_decap_8
XFILLER_16_119 VDD VSS sg13g2_decap_8
XFILLER_12_336 VDD VSS sg13g2_decap_8
XFILLER_24_196 VDD VSS sg13g2_decap_8
XFILLER_21_63 VDD VSS sg13g2_decap_8
XFILLER_8_329 VDD VSS sg13g2_decap_8
XFILLER_15_196 VDD VSS sg13g2_decap_8
XFILLER_7_21 VDD VSS sg13g2_decap_8
XFILLER_30_133 VDD VSS sg13g2_decap_8
XFILLER_7_98 VDD VSS sg13g2_decap_8
XFILLER_16_0 VDD VSS sg13g2_decap_8
XFILLER_38_266 VDD VSS sg13g2_decap_8
XFILLER_21_133 VDD VSS sg13g2_decap_8
Xclkbuf_1_1__f_clock_i _75_/CLK clkbuf_0_clock_i/X VDD VSS sg13g2_buf_16
XFILLER_29_266 VDD VSS sg13g2_decap_8
XFILLER_12_133 VDD VSS sg13g2_decap_8
XFILLER_16_63 VDD VSS sg13g2_decap_8
XFILLER_8_126 VDD VSS sg13g2_decap_8
XFILLER_4_343 VDD VSS sg13g2_decap_8
XFILLER_32_84 VDD VSS sg13g2_decap_8
XFILLER_35_203 VDD VSS sg13g2_decap_8
XFILLER_43_280 VDD VSS sg13g2_decap_8
XFILLER_26_203 VDD VSS sg13g2_decap_8
XFILLER_41_217 VDD VSS sg13g2_decap_8
XFILLER_34_280 VDD VSS sg13g2_decap_8
XFILLER_17_203 VDD VSS sg13g2_decap_8
XFILLER_1_357 VDD VSS sg13g2_decap_8
XFILLER_25_280 VDD VSS sg13g2_decap_8
XFILLER_32_217 VDD VSS sg13g2_decap_8
XFILLER_27_84 VDD VSS sg13g2_decap_8
XFILLER_40_294 VDD VSS sg13g2_decap_8
XFILLER_4_77 VDD VSS sg13g2_decap_8
XFILLER_4_140 VDD VSS sg13g2_decap_8
XFILLER_16_280 VDD VSS sg13g2_decap_8
XFILLER_23_217 VDD VSS sg13g2_decap_8
XFILLER_31_294 VDD VSS sg13g2_decap_8
XFILLER_39_350 VDD VSS sg13g2_decap_8
XFILLER_14_217 VDD VSS sg13g2_decap_8
XFILLER_13_42 VDD VSS sg13g2_decap_8
XFILLER_1_154 VDD VSS sg13g2_decap_8
XFILLER_13_294 VDD VSS sg13g2_decap_8
XFILLER_9_210 VDD VSS sg13g2_decap_8
XFILLER_9_287 VDD VSS sg13g2_decap_8
XFILLER_36_364 VDD VSS sg13g2_decap_8
XFILLER_27_353 VDD VSS sg13g2_fill_2
XFILLER_24_63 VDD VSS sg13g2_decap_8
XFILLER_42_378 VDD VSS sg13g2_decap_8
XFILLER_42_301 VDD VSS sg13g2_decap_8
XFILLER_10_231 VDD VSS sg13g2_decap_8
XFILLER_6_224 VDD VSS sg13g2_decap_8
XFILLER_40_84 VDD VSS sg13g2_decap_8
XFILLER_1_56 VDD VSS sg13g2_decap_8
XFILLER_33_301 VDD VSS sg13g2_decap_8
XFILLER_33_378 VDD VSS sg13g2_decap_8
Xhold19 _66_/A _73_/Q VDD VSS sg13g2_dlygate4sd3_1
XFILLER_24_301 VDD VSS sg13g2_decap_8
XFILLER_36_161 VDD VSS sg13g2_decap_8
XFILLER_10_21 VDD VSS sg13g2_decap_8
XFILLER_10_98 VDD VSS sg13g2_decap_8
XFILLER_3_238 VDD VSS sg13g2_decap_8
XFILLER_15_301 VDD VSS sg13g2_decap_8
XFILLER_19_63 VDD VSS sg13g2_decap_8
XFILLER_27_161 VDD VSS sg13g2_decap_8
XFILLER_15_367 VDD VSS sg13g2_decap_8
XFILLER_15_378 VDD VSS sg13g2_decap_8
XFILLER_42_175 VDD VSS sg13g2_decap_8
XFILLER_35_84 VDD VSS sg13g2_decap_8
XFILLER_30_315 VDD VSS sg13g2_decap_8
XFILLER_18_161 VDD VSS sg13g2_decap_8
XFILLER_21_315 VDD VSS sg13g2_decap_8
XFILLER_33_175 VDD VSS sg13g2_decap_8
XFILLER_12_315 VDD VSS sg13g2_decap_8
XFILLER_24_175 VDD VSS sg13g2_decap_8
XFILLER_8_308 VDD VSS sg13g2_decap_8
XFILLER_20_381 VDD VSS sg13g2_decap_8
XFILLER_21_42 VDD VSS sg13g2_decap_8
XFILLER_15_175 VDD VSS sg13g2_decap_8
XFILLER_30_112 VDD VSS sg13g2_decap_8
XFILLER_7_77 VDD VSS sg13g2_decap_8
XFILLER_30_189 VDD VSS sg13g2_decap_8
XFILLER_7_385 VDD VSS sg13g2_decap_8
XFILLER_38_245 VDD VSS sg13g2_decap_8
XFILLER_21_112 VDD VSS sg13g2_decap_8
XFILLER_21_189 VDD VSS sg13g2_decap_8
XFILLER_29_245 VDD VSS sg13g2_decap_8
XFILLER_16_42 VDD VSS sg13g2_decap_8
XFILLER_12_112 VDD VSS sg13g2_decap_8
XFILLER_12_189 VDD VSS sg13g2_decap_8
XFILLER_8_105 VDD VSS sg13g2_decap_8
XFILLER_32_63 VDD VSS sg13g2_decap_8
XFILLER_4_322 VDD VSS sg13g2_decap_8
XFILLER_35_259 VDD VSS sg13g2_decap_8
XFILLER_7_182 VDD VSS sg13g2_decap_8
XFILLER_26_259 VDD VSS sg13g2_decap_8
XFILLER_1_336 VDD VSS sg13g2_decap_8
XFILLER_27_63 VDD VSS sg13g2_decap_8
XFILLER_17_259 VDD VSS sg13g2_decap_8
XFILLER_43_84 VDD VSS sg13g2_decap_8
XFILLER_40_273 VDD VSS sg13g2_decap_8
XFILLER_4_56 VDD VSS sg13g2_decap_8
XFILLER_4_196 VDD VSS sg13g2_decap_8
XFILLER_31_273 VDD VSS sg13g2_decap_8
XFILLER_13_21 VDD VSS sg13g2_decap_8
XFILLER_13_98 VDD VSS sg13g2_decap_8
XFILLER_22_284 VDD VSS sg13g2_decap_8
XFILLER_1_133 VDD VSS sg13g2_decap_8
XFILLER_38_84 VDD VSS sg13g2_decap_8
XFILLER_13_273 VDD VSS sg13g2_decap_8
XFILLER_9_266 VDD VSS sg13g2_decap_8
XFILLER_36_343 VDD VSS sg13g2_decap_8
XFILLER_27_343 VDD VSS sg13g2_decap_4
XFILLER_10_210 VDD VSS sg13g2_decap_8
XFILLER_24_42 VDD VSS sg13g2_decap_8
XFILLER_42_357 VDD VSS sg13g2_decap_8
XFILLER_10_287 VDD VSS sg13g2_decap_8
XFILLER_6_0 VDD VSS sg13g2_decap_8
XFILLER_6_203 VDD VSS sg13g2_decap_8
XFILLER_40_63 VDD VSS sg13g2_decap_8
XFILLER_1_35 VDD VSS sg13g2_decap_8
XFILLER_18_343 VDD VSS sg13g2_decap_4
XFILLER_33_357 VDD VSS sg13g2_decap_8
XFILLER_5_291 VDD VSS sg13g2_decap_8
XFILLER_39_0 VDD VSS sg13g2_decap_8
Xinput1 _57_/A enable_i VDD VSS sg13g2_buf_1
XFILLER_36_140 VDD VSS sg13g2_decap_8
XFILLER_3_217 VDD VSS sg13g2_decap_8
XFILLER_10_77 VDD VSS sg13g2_decap_8
XFILLER_19_42 VDD VSS sg13g2_decap_8
XFILLER_42_154 VDD VSS sg13g2_decap_8
XFILLER_35_63 VDD VSS sg13g2_decap_8
XFILLER_27_140 VDD VSS sg13g2_decap_8
XFILLER_32_7 VDD VSS sg13g2_decap_8
XFILLER_18_140 VDD VSS sg13g2_decap_8
XFILLER_2_294 VDD VSS sg13g2_decap_8
XFILLER_14_390 VDD VSS sg13g2_fill_2
XFILLER_33_154 VDD VSS sg13g2_decap_8
XFILLER_21_21 VDD VSS sg13g2_decap_8
XFILLER_24_154 VDD VSS sg13g2_decap_8
XFILLER_21_98 VDD VSS sg13g2_decap_8
XFILLER_15_154 VDD VSS sg13g2_decap_8
X_68__12 _68__12/L_HI VDD VSS sg13g2_tiehi
XFILLER_7_364 VDD VSS sg13g2_decap_8
XFILLER_7_56 VDD VSS sg13g2_decap_8
XFILLER_30_168 VDD VSS sg13g2_decap_8
XFILLER_38_224 VDD VSS sg13g2_decap_8
XFILLER_21_168 VDD VSS sg13g2_decap_8
X_74__15 _74__15/L_HI VDD VSS sg13g2_tiehi
XFILLER_29_224 VDD VSS sg13g2_decap_8
XFILLER_16_21 VDD VSS sg13g2_decap_8
XFILLER_16_98 VDD VSS sg13g2_decap_8
XFILLER_12_168 VDD VSS sg13g2_decap_8
XFILLER_4_301 VDD VSS sg13g2_decap_8
XFILLER_32_42 VDD VSS sg13g2_decap_8
XFILLER_4_378 VDD VSS sg13g2_decap_8
XFILLER_35_238 VDD VSS sg13g2_decap_8
XFILLER_7_161 VDD VSS sg13g2_decap_8
XFILLER_21_0 VDD VSS sg13g2_decap_8
XFILLER_26_238 VDD VSS sg13g2_decap_8
XFILLER_5_109 VDD VSS sg13g2_decap_8
XFILLER_1_315 VDD VSS sg13g2_decap_8
XFILLER_17_238 VDD VSS sg13g2_decap_8
XFILLER_27_42 VDD VSS sg13g2_decap_8
XFILLER_43_63 VDD VSS sg13g2_decap_8
XFILLER_40_252 VDD VSS sg13g2_decap_8
XFILLER_4_175 VDD VSS sg13g2_decap_8
XFILLER_4_35 VDD VSS sg13g2_decap_8
XFILLER_31_252 VDD VSS sg13g2_decap_8
XFILLER_39_385 VDD VSS sg13g2_fill_2
XFILLER_22_263 VDD VSS sg13g2_decap_8
XFILLER_13_77 VDD VSS sg13g2_decap_8
XFILLER_1_112 VDD VSS sg13g2_decap_8
XFILLER_1_189 VDD VSS sg13g2_decap_8
XFILLER_38_63 VDD VSS sg13g2_decap_8
XFILLER_13_252 VDD VSS sg13g2_decap_8
XFILLER_9_245 VDD VSS sg13g2_decap_8
XFILLER_36_322 VDD VSS sg13g2_decap_8
XFILLER_42_336 VDD VSS sg13g2_decap_8
XFILLER_39_182 VDD VSS sg13g2_decap_8
XFILLER_27_322 VDD VSS sg13g2_decap_8
XFILLER_10_266 VDD VSS sg13g2_decap_8
XFILLER_24_21 VDD VSS sg13g2_decap_8
XFILLER_24_98 VDD VSS sg13g2_decap_8
XFILLER_6_259 VDD VSS sg13g2_decap_8
XFILLER_40_42 VDD VSS sg13g2_decap_8
XFILLER_18_322 VDD VSS sg13g2_decap_8
XFILLER_1_14 VDD VSS sg13g2_decap_8
XFILLER_37_119 VDD VSS sg13g2_decap_8
XFILLER_33_336 VDD VSS sg13g2_decap_8
XFILLER_5_270 VDD VSS sg13g2_decap_8
XFILLER_24_336 VDD VSS sg13g2_decap_8
Xinput2 _45_/B reset_n_i VDD VSS sg13g2_buf_1
XFILLER_36_196 VDD VSS sg13g2_decap_8
XFILLER_28_119 VDD VSS sg13g2_decap_8
XFILLER_24_347 VDD VSS sg13g2_fill_1
XFILLER_10_56 VDD VSS sg13g2_decap_8
XFILLER_19_119 VDD VSS sg13g2_decap_8
XFILLER_19_21 VDD VSS sg13g2_decap_8
XFILLER_19_98 VDD VSS sg13g2_decap_8
XFILLER_15_336 VDD VSS sg13g2_decap_8
XFILLER_42_133 VDD VSS sg13g2_decap_8
XFILLER_35_42 VDD VSS sg13g2_decap_8
XFILLER_27_196 VDD VSS sg13g2_decap_8
XFILLER_23_391 VDD VSS sg13g2_fill_1
XFILLER_2_273 VDD VSS sg13g2_decap_8
XFILLER_25_7 VDD VSS sg13g2_decap_8
XFILLER_18_196 VDD VSS sg13g2_decap_8
XFILLER_33_133 VDD VSS sg13g2_decap_8
XFILLER_24_133 VDD VSS sg13g2_decap_8
XFILLER_20_350 VDD VSS sg13g2_decap_8
XFILLER_21_77 VDD VSS sg13g2_decap_8
XFILLER_11_350 VDD VSS sg13g2_decap_8
XFILLER_15_133 VDD VSS sg13g2_decap_8
XFILLER_30_147 VDD VSS sg13g2_decap_8
XFILLER_7_343 VDD VSS sg13g2_decap_8
XFILLER_7_35 VDD VSS sg13g2_decap_8
XFILLER_38_203 VDD VSS sg13g2_decap_8
XFILLER_21_147 VDD VSS sg13g2_decap_8
XFILLER_29_203 VDD VSS sg13g2_decap_8
XFILLER_12_147 VDD VSS sg13g2_decap_8
XFILLER_16_77 VDD VSS sg13g2_decap_8
XFILLER_37_280 VDD VSS sg13g2_decap_8
XFILLER_32_21 VDD VSS sg13g2_decap_8
XFILLER_4_357 VDD VSS sg13g2_decap_8
XFILLER_32_98 VDD VSS sg13g2_decap_8
XFILLER_35_217 VDD VSS sg13g2_decap_8
XFILLER_28_280 VDD VSS sg13g2_decap_8
XFILLER_7_140 VDD VSS sg13g2_decap_8
XFILLER_43_294 VDD VSS sg13g2_decap_8
XFILLER_14_0 VDD VSS sg13g2_decap_8
XFILLER_26_217 VDD VSS sg13g2_decap_8
XFILLER_19_280 VDD VSS sg13g2_decap_8
XFILLER_34_294 VDD VSS sg13g2_decap_8
XFILLER_17_217 VDD VSS sg13g2_decap_8
XFILLER_27_98 VDD VSS sg13g2_decap_8
XFILLER_27_21 VDD VSS sg13g2_decap_8
XFILLER_25_294 VDD VSS sg13g2_decap_8
XFILLER_43_42 VDD VSS sg13g2_decap_8
XFILLER_40_231 VDD VSS sg13g2_decap_8
XFILLER_4_154 VDD VSS sg13g2_decap_8
XFILLER_4_14 VDD VSS sg13g2_decap_8
XFILLER_0_371 VDD VSS sg13g2_decap_8
XFILLER_16_294 VDD VSS sg13g2_decap_8
Xclkbuf_1_0__f_clock_i _71_/CLK clkbuf_0_clock_i/X VDD VSS sg13g2_buf_16
XFILLER_31_231 VDD VSS sg13g2_decap_8
XFILLER_39_364 VDD VSS sg13g2_decap_8
XFILLER_13_56 VDD VSS sg13g2_decap_8
XFILLER_22_242 VDD VSS sg13g2_decap_8
XFILLER_1_168 VDD VSS sg13g2_decap_8
XFILLER_38_42 VDD VSS sg13g2_decap_8
XFILLER_13_231 VDD VSS sg13g2_decap_8
XFILLER_9_224 VDD VSS sg13g2_decap_8
XFILLER_36_378 VDD VSS sg13g2_decap_8
XFILLER_36_301 VDD VSS sg13g2_decap_8
XFILLER_39_161 VDD VSS sg13g2_decap_8
XFILLER_27_301 VDD VSS sg13g2_decap_8
XFILLER_42_315 VDD VSS sg13g2_decap_8
XFILLER_27_389 VDD VSS sg13g2_fill_2
XFILLER_10_245 VDD VSS sg13g2_decap_8
XFILLER_24_77 VDD VSS sg13g2_decap_8
XFILLER_6_238 VDD VSS sg13g2_decap_8
XFILLER_40_21 VDD VSS sg13g2_decap_8
XFILLER_40_98 VDD VSS sg13g2_decap_8
XFILLER_18_301 VDD VSS sg13g2_decap_8
XFILLER_18_389 VDD VSS sg13g2_fill_2
XFILLER_33_315 VDD VSS sg13g2_decap_8
XFILLER_24_315 VDD VSS sg13g2_decap_8
XFILLER_36_175 VDD VSS sg13g2_decap_8
XFILLER_10_35 VDD VSS sg13g2_decap_8
XFILLER_19_77 VDD VSS sg13g2_decap_8
XFILLER_15_315 VDD VSS sg13g2_decap_8
XFILLER_42_189 VDD VSS sg13g2_decap_8
XFILLER_42_112 VDD VSS sg13g2_decap_8
XFILLER_35_98 VDD VSS sg13g2_decap_8
XFILLER_35_21 VDD VSS sg13g2_decap_8
XFILLER_30_329 VDD VSS sg13g2_decap_8
XFILLER_27_175 VDD VSS sg13g2_decap_8
XFILLER_2_252 VDD VSS sg13g2_decap_8
XFILLER_18_175 VDD VSS sg13g2_decap_8
XFILLER_18_7 VDD VSS sg13g2_decap_8
XFILLER_33_112 VDD VSS sg13g2_decap_8
XFILLER_21_329 VDD VSS sg13g2_decap_8
XFILLER_33_189 VDD VSS sg13g2_decap_8
XFILLER_2_91 VDD VSS sg13g2_decap_8
XFILLER_12_329 VDD VSS sg13g2_decap_8
XFILLER_24_112 VDD VSS sg13g2_decap_8
XFILLER_24_189 VDD VSS sg13g2_decap_8
XFILLER_21_56 VDD VSS sg13g2_decap_8
XFILLER_15_112 VDD VSS sg13g2_decap_8
XFILLER_15_189 VDD VSS sg13g2_decap_8
XFILLER_7_14 VDD VSS sg13g2_decap_8
XFILLER_7_322 VDD VSS sg13g2_decap_8
XFILLER_30_126 VDD VSS sg13g2_decap_8
XFILLER_38_259 VDD VSS sg13g2_decap_8
XFILLER_21_126 VDD VSS sg13g2_decap_8
XFILLER_29_259 VDD VSS sg13g2_decap_8
XFILLER_12_126 VDD VSS sg13g2_decap_8
XFILLER_16_56 VDD VSS sg13g2_decap_8
XFILLER_8_119 VDD VSS sg13g2_decap_8
XFILLER_4_336 VDD VSS sg13g2_decap_8
XFILLER_32_77 VDD VSS sg13g2_decap_8
XFILLER_43_273 VDD VSS sg13g2_decap_8
XFILLER_7_196 VDD VSS sg13g2_decap_8
XFILLER_34_273 VDD VSS sg13g2_decap_8
XFILLER_25_273 VDD VSS sg13g2_decap_8
XFILLER_43_21 VDD VSS sg13g2_decap_8
XFILLER_40_210 VDD VSS sg13g2_decap_8
XFILLER_27_77 VDD VSS sg13g2_decap_8
XFILLER_43_98 VDD VSS sg13g2_decap_8
XFILLER_40_287 VDD VSS sg13g2_decap_8
XFILLER_4_133 VDD VSS sg13g2_decap_8
XFILLER_0_350 VDD VSS sg13g2_decap_8
XFILLER_16_273 VDD VSS sg13g2_decap_8
XFILLER_31_210 VDD VSS sg13g2_decap_8
XFILLER_31_287 VDD VSS sg13g2_decap_8
XFILLER_39_343 VDD VSS sg13g2_decap_8
XFILLER_39_387 VDD VSS sg13g2_fill_1
XFILLER_13_35 VDD VSS sg13g2_decap_8
XFILLER_22_221 VDD VSS sg13g2_decap_8
XFILLER_22_298 VDD VSS sg13g2_decap_8
XFILLER_1_147 VDD VSS sg13g2_decap_8
XFILLER_38_98 VDD VSS sg13g2_decap_8
XFILLER_38_21 VDD VSS sg13g2_decap_8
XFILLER_13_210 VDD VSS sg13g2_decap_8
XFILLER_9_203 VDD VSS sg13g2_decap_8
XFILLER_13_287 VDD VSS sg13g2_decap_8
XFILLER_36_357 VDD VSS sg13g2_decap_8
XFILLER_8_280 VDD VSS sg13g2_decap_8
XFILLER_39_140 VDD VSS sg13g2_decap_8
XFILLER_24_56 VDD VSS sg13g2_decap_8
XFILLER_10_224 VDD VSS sg13g2_decap_8
XFILLER_6_217 VDD VSS sg13g2_decap_8
XFILLER_40_77 VDD VSS sg13g2_decap_8
XFILLER_1_49 VDD VSS sg13g2_decap_8
XFILLER_41_371 VDD VSS sg13g2_decap_8
XFILLER_36_154 VDD VSS sg13g2_decap_8
XFILLER_32_371 VDD VSS sg13g2_decap_8
XFILLER_10_14 VDD VSS sg13g2_decap_8
XFILLER_19_56 VDD VSS sg13g2_decap_8
XFILLER_27_154 VDD VSS sg13g2_decap_8
XFILLER_42_168 VDD VSS sg13g2_decap_8
XFILLER_35_77 VDD VSS sg13g2_decap_8
XFILLER_30_308 VDD VSS sg13g2_decap_8
XFILLER_4_0 VDD VSS sg13g2_decap_8
XFILLER_2_231 VDD VSS sg13g2_decap_8
XFILLER_18_154 VDD VSS sg13g2_decap_8
XFILLER_21_308 VDD VSS sg13g2_decap_8
XFILLER_33_168 VDD VSS sg13g2_decap_8
XFILLER_37_0 VDD VSS sg13g2_decap_8
XFILLER_2_70 VDD VSS sg13g2_decap_8
XFILLER_12_308 VDD VSS sg13g2_decap_8
XFILLER_24_168 VDD VSS sg13g2_decap_8
XFILLER_20_374 VDD VSS sg13g2_decap_8
XFILLER_21_35 VDD VSS sg13g2_decap_8
XFILLER_15_168 VDD VSS sg13g2_decap_8
XFILLER_11_385 VDD VSS sg13g2_decap_8
XFILLER_7_301 VDD VSS sg13g2_decap_8
XFILLER_30_105 VDD VSS sg13g2_decap_8
XFILLER_7_378 VDD VSS sg13g2_decap_8
XFILLER_30_7 VDD VSS sg13g2_decap_8
XFILLER_38_238 VDD VSS sg13g2_decap_8
XFILLER_21_105 VDD VSS sg13g2_decap_8
XFILLER_16_35 VDD VSS sg13g2_decap_8
XFILLER_29_238 VDD VSS sg13g2_decap_8
XFILLER_12_105 VDD VSS sg13g2_decap_8
XFILLER_20_182 VDD VSS sg13g2_decap_8
XFILLER_32_56 VDD VSS sg13g2_decap_8
XFILLER_4_315 VDD VSS sg13g2_decap_8
XFILLER_43_252 VDD VSS sg13g2_decap_8
XFILLER_11_182 VDD VSS sg13g2_decap_8
XFILLER_7_175 VDD VSS sg13g2_decap_8
XFILLER_34_252 VDD VSS sg13g2_decap_8
XFILLER_1_329 VDD VSS sg13g2_decap_8
XFILLER_8_91 VDD VSS sg13g2_decap_8
XFILLER_25_252 VDD VSS sg13g2_decap_8
XFILLER_27_56 VDD VSS sg13g2_decap_8
XFILLER_4_112 VDD VSS sg13g2_decap_8
XFILLER_43_77 VDD VSS sg13g2_decap_8
XFILLER_40_266 VDD VSS sg13g2_decap_8
XFILLER_4_49 VDD VSS sg13g2_decap_8
XFILLER_4_189 VDD VSS sg13g2_decap_8
XFILLER_16_252 VDD VSS sg13g2_decap_8
XFILLER_31_266 VDD VSS sg13g2_decap_8
XFILLER_39_322 VDD VSS sg13g2_decap_8
XFILLER_22_200 VDD VSS sg13g2_decap_8
XFILLER_13_14 VDD VSS sg13g2_decap_8
XFILLER_22_277 VDD VSS sg13g2_decap_8
XFILLER_1_126 VDD VSS sg13g2_decap_8
XFILLER_8_7 VDD VSS sg13g2_decap_8
XFILLER_38_77 VDD VSS sg13g2_decap_8
XFILLER_13_266 VDD VSS sg13g2_decap_8
XFILLER_9_259 VDD VSS sg13g2_decap_8
XFILLER_36_336 VDD VSS sg13g2_decap_8
XFILLER_5_81 VDD VSS sg13g2_decap_8
XFILLER_39_196 VDD VSS sg13g2_decap_8
XFILLER_27_347 VDD VSS sg13g2_fill_2
XFILLER_27_336 VDD VSS sg13g2_decap_8
XFILLER_10_203 VDD VSS sg13g2_decap_8
XFILLER_24_35 VDD VSS sg13g2_decap_8
XFILLER_40_56 VDD VSS sg13g2_decap_8
XFILLER_1_28 VDD VSS sg13g2_decap_8
XFILLER_18_336 VDD VSS sg13g2_decap_8
XFILLER_18_347 VDD VSS sg13g2_fill_2
XFILLER_41_350 VDD VSS sg13g2_decap_8
XFILLER_5_284 VDD VSS sg13g2_decap_8
XFILLER_36_133 VDD VSS sg13g2_decap_8
XFILLER_17_391 VDD VSS sg13g2_fill_1
XFILLER_32_350 VDD VSS sg13g2_decap_8
XFILLER_19_35 VDD VSS sg13g2_decap_8
XFILLER_35_56 VDD VSS sg13g2_decap_8
XFILLER_27_133 VDD VSS sg13g2_decap_8
XFILLER_42_147 VDD VSS sg13g2_decap_8
XFILLER_2_210 VDD VSS sg13g2_decap_8
XFILLER_18_133 VDD VSS sg13g2_decap_8
XFILLER_2_287 VDD VSS sg13g2_decap_8
XFILLER_33_147 VDD VSS sg13g2_decap_8
X_59_ _71_/D _59_/A _59_/B VDD VSS sg13g2_nor2_1
XFILLER_20_364 VDD VSS sg13g2_fill_2
XFILLER_24_147 VDD VSS sg13g2_decap_8
XFILLER_21_14 VDD VSS sg13g2_decap_8
XFILLER_15_147 VDD VSS sg13g2_decap_8
XFILLER_7_357 VDD VSS sg13g2_decap_8
XFILLER_7_49 VDD VSS sg13g2_decap_8
XFILLER_11_91 VDD VSS sg13g2_decap_8
XFILLER_23_7 VDD VSS sg13g2_decap_8
XFILLER_38_217 VDD VSS sg13g2_decap_8
XFILLER_29_217 VDD VSS sg13g2_decap_8
XFILLER_16_14 VDD VSS sg13g2_decap_8
XFILLER_37_294 VDD VSS sg13g2_decap_8
XFILLER_20_161 VDD VSS sg13g2_decap_8
XFILLER_32_35 VDD VSS sg13g2_decap_8
XFILLER_43_231 VDD VSS sg13g2_decap_8
XFILLER_28_294 VDD VSS sg13g2_decap_8
XFILLER_11_161 VDD VSS sg13g2_decap_8
XFILLER_7_154 VDD VSS sg13g2_decap_8
XFILLER_3_371 VDD VSS sg13g2_decap_8
XFILLER_19_294 VDD VSS sg13g2_decap_8
XFILLER_34_231 VDD VSS sg13g2_decap_8
XFILLER_8_70 VDD VSS sg13g2_decap_8
XFILLER_1_308 VDD VSS sg13g2_decap_8
XFILLER_27_35 VDD VSS sg13g2_decap_8
XFILLER_25_231 VDD VSS sg13g2_decap_8
XFILLER_43_56 VDD VSS sg13g2_decap_8
XFILLER_40_245 VDD VSS sg13g2_decap_8
XFILLER_0_385 VDD VSS sg13g2_fill_2
XFILLER_4_28 VDD VSS sg13g2_decap_8
XFILLER_4_168 VDD VSS sg13g2_decap_8
XFILLER_16_231 VDD VSS sg13g2_decap_8
XFILLER_31_245 VDD VSS sg13g2_decap_8
XFILLER_12_0 VDD VSS sg13g2_decap_8
XFILLER_39_378 VDD VSS sg13g2_decap_8
XFILLER_39_301 VDD VSS sg13g2_decap_8
XFILLER_22_256 VDD VSS sg13g2_decap_8
XFILLER_1_105 VDD VSS sg13g2_decap_8
XFILLER_38_56 VDD VSS sg13g2_decap_8
XFILLER_13_245 VDD VSS sg13g2_decap_8
XFILLER_9_238 VDD VSS sg13g2_decap_8
XFILLER_0_182 VDD VSS sg13g2_decap_8
XFILLER_36_315 VDD VSS sg13g2_decap_8
XFILLER_5_60 VDD VSS sg13g2_decap_8
XFILLER_39_175 VDD VSS sg13g2_decap_8
XFILLER_27_315 VDD VSS sg13g2_decap_8
XFILLER_10_259 VDD VSS sg13g2_decap_8
XFILLER_24_14 VDD VSS sg13g2_decap_8
XFILLER_42_329 VDD VSS sg13g2_decap_8
XFILLER_40_35 VDD VSS sg13g2_decap_8
XFILLER_18_315 VDD VSS sg13g2_decap_8
XFILLER_33_329 VDD VSS sg13g2_decap_8
XFILLER_14_91 VDD VSS sg13g2_decap_8
XFILLER_5_263 VDD VSS sg13g2_decap_8
X_75_ _75_/Q _75_/CLK _75_/D _75__14/L_HI VDD VSS sg13g2_dfrbpq_1
XFILLER_36_112 VDD VSS sg13g2_decap_8
XFILLER_24_329 VDD VSS sg13g2_decap_8
XFILLER_36_189 VDD VSS sg13g2_decap_8
XFILLER_10_49 VDD VSS sg13g2_decap_8
XFILLER_19_14 VDD VSS sg13g2_decap_8
XFILLER_15_329 VDD VSS sg13g2_decap_8
XFILLER_42_126 VDD VSS sg13g2_decap_8
XFILLER_35_35 VDD VSS sg13g2_decap_8
XFILLER_27_189 VDD VSS sg13g2_decap_8
XFILLER_27_112 VDD VSS sg13g2_decap_8
XFILLER_2_266 VDD VSS sg13g2_decap_8
XFILLER_18_112 VDD VSS sg13g2_decap_8
XFILLER_18_189 VDD VSS sg13g2_decap_8
XFILLER_33_126 VDD VSS sg13g2_decap_8
XFILLER_24_126 VDD VSS sg13g2_decap_8
X_58_ _58_/X _58_/A _58_/B VDD VSS sg13g2_xor2_1
XFILLER_20_343 VDD VSS sg13g2_decap_8
XFILLER_15_126 VDD VSS sg13g2_decap_8
XFILLER_11_343 VDD VSS sg13g2_decap_8
XFILLER_7_28 VDD VSS sg13g2_decap_8
XFILLER_7_336 VDD VSS sg13g2_decap_8
XFILLER_11_70 VDD VSS sg13g2_decap_8
XFILLER_16_7 VDD VSS sg13g2_decap_8
XFILLER_42_0 VDD VSS sg13g2_decap_8
XFILLER_37_273 VDD VSS sg13g2_decap_8
XFILLER_20_140 VDD VSS sg13g2_decap_8
XFILLER_32_14 VDD VSS sg13g2_decap_8
XFILLER_43_210 VDD VSS sg13g2_decap_8
XFILLER_28_273 VDD VSS sg13g2_decap_8
XFILLER_11_140 VDD VSS sg13g2_decap_8
XFILLER_43_287 VDD VSS sg13g2_decap_8
XFILLER_7_133 VDD VSS sg13g2_decap_8
XFILLER_3_350 VDD VSS sg13g2_decap_8
XFILLER_19_273 VDD VSS sg13g2_decap_8
XFILLER_34_287 VDD VSS sg13g2_decap_8
XFILLER_34_210 VDD VSS sg13g2_decap_8
XFILLER_25_210 VDD VSS sg13g2_decap_8
XFILLER_27_14 VDD VSS sg13g2_decap_8
XFILLER_25_287 VDD VSS sg13g2_decap_8
XFILLER_43_35 VDD VSS sg13g2_decap_8
XFILLER_40_224 VDD VSS sg13g2_decap_8
XFILLER_4_147 VDD VSS sg13g2_decap_8
XFILLER_0_364 VDD VSS sg13g2_decap_8
XFILLER_16_210 VDD VSS sg13g2_decap_8
XFILLER_16_287 VDD VSS sg13g2_decap_8
XFILLER_17_91 VDD VSS sg13g2_decap_8
XFILLER_31_224 VDD VSS sg13g2_decap_8
XFILLER_39_357 VDD VSS sg13g2_decap_8
XFILLER_22_235 VDD VSS sg13g2_decap_8
XFILLER_13_49 VDD VSS sg13g2_decap_8
XFILLER_38_35 VDD VSS sg13g2_decap_8
XFILLER_13_224 VDD VSS sg13g2_decap_8
XFILLER_9_217 VDD VSS sg13g2_decap_8
XFILLER_0_161 VDD VSS sg13g2_decap_8
XFILLER_8_294 VDD VSS sg13g2_decap_8
XFILLER_42_308 VDD VSS sg13g2_decap_8
XFILLER_39_154 VDD VSS sg13g2_decap_8
XFILLER_35_371 VDD VSS sg13g2_decap_8
XFILLER_10_238 VDD VSS sg13g2_decap_8
XFILLER_40_14 VDD VSS sg13g2_decap_8
XFILLER_41_385 VDD VSS sg13g2_decap_8
XFILLER_33_308 VDD VSS sg13g2_decap_8
XFILLER_14_70 VDD VSS sg13g2_decap_8
XFILLER_5_242 VDD VSS sg13g2_decap_8
XFILLER_30_91 VDD VSS sg13g2_decap_8
XFILLER_24_308 VDD VSS sg13g2_decap_8
X_74_ _74_/Q _75_/CLK _74_/D _74__15/L_HI VDD VSS sg13g2_dfrbpq_1
XFILLER_36_168 VDD VSS sg13g2_decap_8
XFILLER_32_385 VDD VSS sg13g2_fill_2
XFILLER_10_28 VDD VSS sg13g2_decap_8
XFILLER_15_308 VDD VSS sg13g2_decap_8
XFILLER_42_105 VDD VSS sg13g2_decap_8
XFILLER_35_14 VDD VSS sg13g2_decap_8
XFILLER_27_168 VDD VSS sg13g2_decap_8
XFILLER_2_245 VDD VSS sg13g2_decap_8
XFILLER_18_168 VDD VSS sg13g2_decap_8
XFILLER_33_105 VDD VSS sg13g2_decap_8
XFILLER_41_182 VDD VSS sg13g2_decap_8
XFILLER_25_91 VDD VSS sg13g2_decap_8
XFILLER_2_84 VDD VSS sg13g2_decap_8
XFILLER_24_105 VDD VSS sg13g2_decap_8
X_57_ _58_/B _57_/A _70_/Q _57_/C _68_/Q VDD VSS sg13g2_nand4_1
XFILLER_20_322 VDD VSS sg13g2_decap_8
XFILLER_20_388 VDD VSS sg13g2_decap_4
XFILLER_21_49 VDD VSS sg13g2_decap_8
XFILLER_32_182 VDD VSS sg13g2_decap_8
XFILLER_15_105 VDD VSS sg13g2_decap_8
XFILLER_11_322 VDD VSS sg13g2_decap_8
XFILLER_23_182 VDD VSS sg13g2_decap_8
XFILLER_7_315 VDD VSS sg13g2_decap_8
XFILLER_30_119 VDD VSS sg13g2_decap_8
XFILLER_2_0 VDD VSS sg13g2_decap_8
XFILLER_14_182 VDD VSS sg13g2_decap_8
XFILLER_21_119 VDD VSS sg13g2_decap_8
XFILLER_35_0 VDD VSS sg13g2_decap_8
XFILLER_37_252 VDD VSS sg13g2_decap_8
XFILLER_12_119 VDD VSS sg13g2_decap_8
XFILLER_16_49 VDD VSS sg13g2_decap_8
XFILLER_20_196 VDD VSS sg13g2_decap_8
XFILLER_4_329 VDD VSS sg13g2_decap_8
XFILLER_43_266 VDD VSS sg13g2_decap_8
XFILLER_28_252 VDD VSS sg13g2_decap_8
XFILLER_11_196 VDD VSS sg13g2_decap_8
XFILLER_7_112 VDD VSS sg13g2_decap_8
XFILLER_22_81 VDD VSS sg13g2_decap_8
XFILLER_7_189 VDD VSS sg13g2_decap_8
XFILLER_19_252 VDD VSS sg13g2_decap_8
XFILLER_34_266 VDD VSS sg13g2_decap_8
XFILLER_25_266 VDD VSS sg13g2_decap_8
XFILLER_43_14 VDD VSS sg13g2_decap_8
XFILLER_40_203 VDD VSS sg13g2_decap_8
XFILLER_4_126 VDD VSS sg13g2_decap_8
XFILLER_0_343 VDD VSS sg13g2_decap_8
XFILLER_0_387 VDD VSS sg13g2_fill_1
XFILLER_16_266 VDD VSS sg13g2_decap_8
XFILLER_17_70 VDD VSS sg13g2_decap_8
XFILLER_31_203 VDD VSS sg13g2_decap_8
XFILLER_33_91 VDD VSS sg13g2_decap_8
XFILLER_39_336 VDD VSS sg13g2_decap_8
XFILLER_13_28 VDD VSS sg13g2_decap_8
XFILLER_22_214 VDD VSS sg13g2_decap_8
XFILLER_30_280 VDD VSS sg13g2_decap_8
XFILLER_38_14 VDD VSS sg13g2_decap_8
XFILLER_13_203 VDD VSS sg13g2_decap_8
XFILLER_21_280 VDD VSS sg13g2_decap_8
XFILLER_0_140 VDD VSS sg13g2_decap_8
XFILLER_29_391 VDD VSS sg13g2_fill_1
XFILLER_28_91 VDD VSS sg13g2_decap_8
XFILLER_12_280 VDD VSS sg13g2_decap_8
XFILLER_8_273 VDD VSS sg13g2_decap_8
XFILLER_5_95 VDD VSS sg13g2_decap_8
XFILLER_39_133 VDD VSS sg13g2_decap_8
XFILLER_24_49 VDD VSS sg13g2_decap_8
XFILLER_35_350 VDD VSS sg13g2_decap_8
XFILLER_10_217 VDD VSS sg13g2_decap_8
XFILLER_6_7 VDD VSS sg13g2_decap_8
XFILLER_41_364 VDD VSS sg13g2_decap_8
XFILLER_26_361 VDD VSS sg13g2_fill_2
XFILLER_5_221 VDD VSS sg13g2_decap_8
XFILLER_5_298 VDD VSS sg13g2_decap_8
XFILLER_30_70 VDD VSS sg13g2_decap_8
X_73_ _73_/Q _75_/CLK _73_/D _73__11/L_HI VDD VSS sg13g2_dfrbpq_1
XFILLER_39_7 VDD VSS sg13g2_decap_8
XFILLER_36_147 VDD VSS sg13g2_decap_8
XFILLER_32_364 VDD VSS sg13g2_decap_8
XFILLER_19_49 VDD VSS sg13g2_decap_8
XFILLER_27_147 VDD VSS sg13g2_decap_8
XFILLER_2_224 VDD VSS sg13g2_decap_8
XFILLER_18_147 VDD VSS sg13g2_decap_8
XFILLER_14_386 VDD VSS sg13g2_decap_4
XFILLER_41_161 VDD VSS sg13g2_decap_8
XFILLER_25_70 VDD VSS sg13g2_decap_8
XFILLER_41_91 VDD VSS sg13g2_decap_8
X_56_ _70_/D _59_/A _56_/B VDD VSS sg13g2_nor2_1
XFILLER_2_63 VDD VSS sg13g2_decap_8
XFILLER_20_301 VDD VSS sg13g2_decap_8
XFILLER_32_161 VDD VSS sg13g2_decap_8
XFILLER_21_28 VDD VSS sg13g2_decap_8
XFILLER_11_301 VDD VSS sg13g2_decap_8
XFILLER_11_367 VDD VSS sg13g2_fill_2
XFILLER_11_378 VDD VSS sg13g2_decap_8
XFILLER_23_161 VDD VSS sg13g2_decap_8
XFILLER_14_161 VDD VSS sg13g2_decap_8
XFILLER_36_91 VDD VSS sg13g2_decap_8
XFILLER_6_371 VDD VSS sg13g2_decap_8
XFILLER_28_0 VDD VSS sg13g2_decap_8
XFILLER_16_28 VDD VSS sg13g2_decap_8
X_39_ _66_/B _39_/A VDD VSS sg13g2_buf_4
XFILLER_37_231 VDD VSS sg13g2_decap_8
XFILLER_20_175 VDD VSS sg13g2_decap_8
XFILLER_32_49 VDD VSS sg13g2_decap_8
XFILLER_4_308 VDD VSS sg13g2_decap_8
X_73__11 _73__11/L_HI VDD VSS sg13g2_tiehi
XFILLER_28_231 VDD VSS sg13g2_decap_8
XFILLER_43_245 VDD VSS sg13g2_decap_8
XFILLER_11_175 VDD VSS sg13g2_decap_8
XFILLER_22_60 VDD VSS sg13g2_decap_8
XFILLER_7_168 VDD VSS sg13g2_decap_8
XFILLER_3_385 VDD VSS sg13g2_decap_8
XFILLER_19_231 VDD VSS sg13g2_decap_8
XFILLER_21_7 VDD VSS sg13g2_decap_8
XFILLER_34_245 VDD VSS sg13g2_decap_8
XFILLER_8_84 VDD VSS sg13g2_decap_8
XFILLER_25_245 VDD VSS sg13g2_decap_8
XFILLER_27_49 VDD VSS sg13g2_decap_8
XFILLER_4_105 VDD VSS sg13g2_decap_8
XFILLER_40_259 VDD VSS sg13g2_decap_8
XFILLER_0_322 VDD VSS sg13g2_decap_8
XFILLER_16_245 VDD VSS sg13g2_decap_8
XFILLER_33_70 VDD VSS sg13g2_decap_8
XFILLER_31_259 VDD VSS sg13g2_decap_8
XFILLER_3_182 VDD VSS sg13g2_decap_8
XFILLER_39_315 VDD VSS sg13g2_decap_8
XFILLER_1_119 VDD VSS sg13g2_decap_8
XFILLER_13_259 VDD VSS sg13g2_decap_8
XFILLER_0_196 VDD VSS sg13g2_decap_8
XFILLER_36_329 VDD VSS sg13g2_decap_8
XFILLER_28_70 VDD VSS sg13g2_decap_8
XFILLER_8_252 VDD VSS sg13g2_decap_8
XFILLER_5_74 VDD VSS sg13g2_decap_8
XFILLER_10_0 VDD VSS sg13g2_decap_8
XFILLER_39_189 VDD VSS sg13g2_decap_8
XFILLER_39_112 VDD VSS sg13g2_decap_8
XFILLER_27_329 VDD VSS sg13g2_decap_8
XFILLER_24_28 VDD VSS sg13g2_decap_8
XFILLER_40_49 VDD VSS sg13g2_decap_8
XFILLER_18_329 VDD VSS sg13g2_decap_8
XFILLER_41_343 VDD VSS sg13g2_decap_8
XFILLER_5_200 VDD VSS sg13g2_decap_8
XFILLER_5_277 VDD VSS sg13g2_decap_8
X_72_ _72_/Q _75_/CLK _72_/D _72__17/L_HI VDD VSS sg13g2_dfrbpq_1
XFILLER_39_91 VDD VSS sg13g2_decap_8
XFILLER_36_126 VDD VSS sg13g2_decap_8
XFILLER_32_343 VDD VSS sg13g2_decap_8
XFILLER_32_387 VDD VSS sg13g2_fill_1
XFILLER_19_28 VDD VSS sg13g2_decap_8
XFILLER_35_49 VDD VSS sg13g2_decap_8
XFILLER_27_126 VDD VSS sg13g2_decap_8
XFILLER_23_343 VDD VSS sg13g2_fill_2
XFILLER_2_203 VDD VSS sg13g2_decap_8
XFILLER_14_343 VDD VSS sg13g2_decap_8
XFILLER_18_126 VDD VSS sg13g2_decap_8
XFILLER_41_140 VDD VSS sg13g2_decap_8
XFILLER_14_376 VDD VSS sg13g2_fill_1
XFILLER_41_70 VDD VSS sg13g2_decap_8
XFILLER_1_280 VDD VSS sg13g2_decap_8
X_55_ _56_/B _55_/A _66_/B VDD VSS sg13g2_xor2_1
XFILLER_2_42 VDD VSS sg13g2_decap_8
XFILLER_20_357 VDD VSS sg13g2_decap_8
XFILLER_32_140 VDD VSS sg13g2_decap_8
XFILLER_23_140 VDD VSS sg13g2_decap_8
XFILLER_11_357 VDD VSS sg13g2_fill_2
XFILLER_11_84 VDD VSS sg13g2_decap_8
XFILLER_14_140 VDD VSS sg13g2_decap_8
XFILLER_36_70 VDD VSS sg13g2_decap_8
XFILLER_6_350 VDD VSS sg13g2_decap_8
X_38_ _39_/A _57_/A _57_/C _50_/B VDD VSS sg13g2_nand3_1
XFILLER_37_287 VDD VSS sg13g2_decap_8
XFILLER_37_210 VDD VSS sg13g2_decap_8
XFILLER_20_154 VDD VSS sg13g2_decap_8
XFILLER_32_28 VDD VSS sg13g2_decap_8
XFILLER_28_210 VDD VSS sg13g2_decap_8
XFILLER_43_224 VDD VSS sg13g2_decap_8
XFILLER_28_287 VDD VSS sg13g2_decap_8
XFILLER_11_154 VDD VSS sg13g2_decap_8
XFILLER_7_147 VDD VSS sg13g2_decap_8
XFILLER_3_364 VDD VSS sg13g2_decap_8
XFILLER_14_7 VDD VSS sg13g2_decap_8
XFILLER_19_210 VDD VSS sg13g2_decap_8
XFILLER_19_287 VDD VSS sg13g2_decap_8
XFILLER_34_224 VDD VSS sg13g2_decap_8
XFILLER_8_63 VDD VSS sg13g2_decap_8
XFILLER_40_0 VDD VSS sg13g2_decap_8
XFILLER_27_28 VDD VSS sg13g2_decap_8
XFILLER_25_224 VDD VSS sg13g2_decap_8
XFILLER_43_49 VDD VSS sg13g2_decap_8
XFILLER_40_238 VDD VSS sg13g2_decap_8
XFILLER_0_301 VDD VSS sg13g2_decap_8
XFILLER_0_378 VDD VSS sg13g2_decap_8
XFILLER_16_224 VDD VSS sg13g2_decap_8
XFILLER_31_238 VDD VSS sg13g2_decap_8
XFILLER_3_161 VDD VSS sg13g2_decap_8
XFILLER_22_249 VDD VSS sg13g2_decap_8
XFILLER_38_49 VDD VSS sg13g2_decap_8
XFILLER_38_371 VDD VSS sg13g2_decap_8
XFILLER_13_238 VDD VSS sg13g2_decap_8
XFILLER_0_175 VDD VSS sg13g2_decap_8
XFILLER_36_308 VDD VSS sg13g2_decap_8
XFILLER_8_231 VDD VSS sg13g2_decap_8
XFILLER_5_53 VDD VSS sg13g2_decap_8
XFILLER_39_168 VDD VSS sg13g2_decap_8
XFILLER_27_308 VDD VSS sg13g2_decap_8
XFILLER_35_385 VDD VSS sg13g2_decap_8
XFILLER_40_28 VDD VSS sg13g2_decap_8
XFILLER_18_308 VDD VSS sg13g2_decap_8
XFILLER_41_322 VDD VSS sg13g2_decap_8
XFILLER_14_84 VDD VSS sg13g2_decap_8
XFILLER_5_256 VDD VSS sg13g2_decap_8
X_71_ _71_/Q _71_/CLK _71_/D _71__13/L_HI VDD VSS sg13g2_dfrbpq_1
XFILLER_39_70 VDD VSS sg13g2_decap_8
XFILLER_36_105 VDD VSS sg13g2_decap_8
XFILLER_32_322 VDD VSS sg13g2_decap_8
XFILLER_23_322 VDD VSS sg13g2_decap_8
XFILLER_42_119 VDD VSS sg13g2_decap_8
XFILLER_35_28 VDD VSS sg13g2_decap_8
XFILLER_35_182 VDD VSS sg13g2_decap_8
XFILLER_27_105 VDD VSS sg13g2_decap_8
XFILLER_2_259 VDD VSS sg13g2_decap_8
XFILLER_18_105 VDD VSS sg13g2_decap_8
XFILLER_14_322 VDD VSS sg13g2_decap_8
XFILLER_33_119 VDD VSS sg13g2_decap_8
XFILLER_26_182 VDD VSS sg13g2_decap_8
XFILLER_41_196 VDD VSS sg13g2_decap_8
XFILLER_2_21 VDD VSS sg13g2_decap_8
XFILLER_17_182 VDD VSS sg13g2_decap_8
XFILLER_24_119 VDD VSS sg13g2_decap_8
X_54_ _69_/D _59_/A _54_/B VDD VSS sg13g2_nor2_1
XFILLER_2_98 VDD VSS sg13g2_decap_8
XFILLER_20_336 VDD VSS sg13g2_decap_8
XFILLER_32_196 VDD VSS sg13g2_decap_8
XFILLER_15_119 VDD VSS sg13g2_decap_8
XFILLER_11_336 VDD VSS sg13g2_decap_8
XFILLER_23_196 VDD VSS sg13g2_decap_8
XFILLER_7_329 VDD VSS sg13g2_decap_8
XFILLER_11_63 VDD VSS sg13g2_decap_8
XFILLER_14_196 VDD VSS sg13g2_decap_8
XFILLER_37_266 VDD VSS sg13g2_decap_8
XFILLER_20_133 VDD VSS sg13g2_decap_8
XFILLER_43_203 VDD VSS sg13g2_decap_8
XFILLER_28_266 VDD VSS sg13g2_decap_8
XFILLER_11_133 VDD VSS sg13g2_decap_8
XFILLER_22_95 VDD VSS sg13g2_decap_8
XFILLER_7_126 VDD VSS sg13g2_decap_8
XFILLER_3_343 VDD VSS sg13g2_decap_8
XFILLER_0_0 VDD VSS sg13g2_decap_8
XFILLER_19_266 VDD VSS sg13g2_decap_8
XFILLER_34_203 VDD VSS sg13g2_decap_8
XFILLER_8_42 VDD VSS sg13g2_decap_8
XFILLER_42_280 VDD VSS sg13g2_decap_8
X_70__16 _70__16/L_HI VDD VSS sg13g2_tiehi
XFILLER_33_0 VDD VSS sg13g2_decap_8
XFILLER_25_203 VDD VSS sg13g2_decap_8
XFILLER_43_28 VDD VSS sg13g2_decap_8
XFILLER_40_217 VDD VSS sg13g2_decap_8
XFILLER_33_280 VDD VSS sg13g2_decap_8
XFILLER_0_357 VDD VSS sg13g2_decap_8
XFILLER_16_203 VDD VSS sg13g2_decap_8
XFILLER_17_84 VDD VSS sg13g2_decap_8
XFILLER_31_217 VDD VSS sg13g2_decap_8
XFILLER_24_280 VDD VSS sg13g2_decap_8
XFILLER_3_140 VDD VSS sg13g2_decap_8
XFILLER_15_280 VDD VSS sg13g2_decap_8
XFILLER_22_228 VDD VSS sg13g2_decap_8
XFILLER_30_294 VDD VSS sg13g2_decap_8
XFILLER_38_28 VDD VSS sg13g2_decap_8
XFILLER_38_350 VDD VSS sg13g2_decap_8
XFILLER_13_217 VDD VSS sg13g2_decap_8
XFILLER_21_294 VDD VSS sg13g2_decap_8
XFILLER_0_154 VDD VSS sg13g2_decap_8
XFILLER_12_294 VDD VSS sg13g2_decap_8
XFILLER_8_210 VDD VSS sg13g2_decap_8
XFILLER_8_287 VDD VSS sg13g2_decap_8
XFILLER_5_32 VDD VSS sg13g2_decap_8
XFILLER_39_147 VDD VSS sg13g2_decap_8
XFILLER_35_364 VDD VSS sg13g2_decap_8
XFILLER_41_301 VDD VSS sg13g2_decap_8
XFILLER_14_63 VDD VSS sg13g2_decap_8
XFILLER_5_235 VDD VSS sg13g2_decap_8
XFILLER_41_378 VDD VSS sg13g2_decap_8
XFILLER_30_84 VDD VSS sg13g2_decap_8
X_70_ _70_/Q _71_/CLK _70_/D _70__16/L_HI VDD VSS sg13g2_dfrbpq_1
XFILLER_32_378 VDD VSS sg13g2_decap_8
XFILLER_32_301 VDD VSS sg13g2_decap_8
XFILLER_23_301 VDD VSS sg13g2_decap_8
XFILLER_23_345 VDD VSS sg13g2_fill_1
XFILLER_35_161 VDD VSS sg13g2_decap_8
XFILLER_23_389 VDD VSS sg13g2_fill_2
XFILLER_4_7 VDD VSS sg13g2_decap_8
XFILLER_2_238 VDD VSS sg13g2_decap_8
XFILLER_14_301 VDD VSS sg13g2_decap_8
XFILLER_41_175 VDD VSS sg13g2_decap_8
XFILLER_26_161 VDD VSS sg13g2_decap_8
XFILLER_25_84 VDD VSS sg13g2_decap_8
X_53_ _53_/X _57_/C _53_/B VDD VSS sg13g2_xor2_1
XFILLER_37_7 VDD VSS sg13g2_decap_8
XFILLER_2_77 VDD VSS sg13g2_decap_8
XFILLER_17_161 VDD VSS sg13g2_decap_8
XFILLER_20_315 VDD VSS sg13g2_decap_8
XFILLER_9_371 VDD VSS sg13g2_decap_8
XFILLER_32_175 VDD VSS sg13g2_decap_8
XFILLER_11_315 VDD VSS sg13g2_decap_8
XFILLER_23_175 VDD VSS sg13g2_decap_8
XFILLER_11_42 VDD VSS sg13g2_decap_8
XFILLER_7_308 VDD VSS sg13g2_decap_8
XFILLER_14_175 VDD VSS sg13g2_decap_8
XFILLER_6_385 VDD VSS sg13g2_fill_2
XFILLER_37_245 VDD VSS sg13g2_decap_8
XFILLER_20_112 VDD VSS sg13g2_decap_8
XFILLER_20_189 VDD VSS sg13g2_decap_8
XFILLER_43_259 VDD VSS sg13g2_decap_8
XFILLER_28_245 VDD VSS sg13g2_decap_8
XFILLER_11_112 VDD VSS sg13g2_decap_8
XFILLER_11_189 VDD VSS sg13g2_decap_8
XFILLER_7_105 VDD VSS sg13g2_decap_8
XFILLER_22_74 VDD VSS sg13g2_decap_8
XFILLER_3_322 VDD VSS sg13g2_decap_8
XFILLER_19_245 VDD VSS sg13g2_decap_8
XFILLER_34_259 VDD VSS sg13g2_decap_8
XFILLER_8_21 VDD VSS sg13g2_decap_8
XFILLER_8_98 VDD VSS sg13g2_decap_8
XFILLER_6_182 VDD VSS sg13g2_decap_8
XFILLER_26_0 VDD VSS sg13g2_decap_8
XFILLER_25_259 VDD VSS sg13g2_decap_8
XFILLER_4_119 VDD VSS sg13g2_decap_8
XFILLER_0_336 VDD VSS sg13g2_decap_8
XFILLER_16_259 VDD VSS sg13g2_decap_8
XFILLER_17_63 VDD VSS sg13g2_decap_8
XFILLER_33_84 VDD VSS sg13g2_decap_8
XFILLER_3_196 VDD VSS sg13g2_decap_8
XFILLER_39_329 VDD VSS sg13g2_decap_8
XFILLER_22_207 VDD VSS sg13g2_decap_8
XFILLER_30_273 VDD VSS sg13g2_decap_8
XFILLER_21_273 VDD VSS sg13g2_decap_8
XFILLER_0_133 VDD VSS sg13g2_decap_8
XFILLER_28_84 VDD VSS sg13g2_decap_8
XFILLER_12_273 VDD VSS sg13g2_decap_8
XFILLER_5_11 VDD VSS sg13g2_decap_8
XFILLER_8_266 VDD VSS sg13g2_decap_8
XFILLER_5_88 VDD VSS sg13g2_decap_8
XFILLER_39_126 VDD VSS sg13g2_decap_8
XFILLER_35_343 VDD VSS sg13g2_decap_8
XFILLER_14_42 VDD VSS sg13g2_decap_8
XFILLER_41_357 VDD VSS sg13g2_decap_8
XFILLER_26_354 VDD VSS sg13g2_decap_8
XFILLER_26_343 VDD VSS sg13g2_fill_1
XFILLER_5_214 VDD VSS sg13g2_decap_8
XFILLER_30_63 VDD VSS sg13g2_decap_8
XFILLER_17_343 VDD VSS sg13g2_decap_4
XFILLER_32_357 VDD VSS sg13g2_decap_8
XFILLER_4_280 VDD VSS sg13g2_decap_8
XFILLER_35_140 VDD VSS sg13g2_decap_8
XFILLER_2_217 VDD VSS sg13g2_decap_8
XFILLER_26_140 VDD VSS sg13g2_decap_8
XFILLER_41_154 VDD VSS sg13g2_decap_8
XFILLER_25_63 VDD VSS sg13g2_decap_8
XFILLER_41_84 VDD VSS sg13g2_decap_8
XFILLER_1_294 VDD VSS sg13g2_decap_8
X_52_ _53_/B _57_/A _68_/Q VDD VSS sg13g2_nand2_1
XFILLER_2_56 VDD VSS sg13g2_decap_8
XFILLER_17_140 VDD VSS sg13g2_decap_8
XFILLER_32_154 VDD VSS sg13g2_decap_8
XFILLER_9_350 VDD VSS sg13g2_decap_8
XFILLER_23_154 VDD VSS sg13g2_decap_8
XFILLER_11_21 VDD VSS sg13g2_decap_8
XFILLER_11_98 VDD VSS sg13g2_decap_8
XFILLER_14_154 VDD VSS sg13g2_decap_8
XFILLER_36_84 VDD VSS sg13g2_decap_8
XFILLER_10_371 VDD VSS sg13g2_decap_8
XFILLER_6_364 VDD VSS sg13g2_decap_8
XFILLER_37_224 VDD VSS sg13g2_decap_8
XFILLER_20_168 VDD VSS sg13g2_decap_8
XFILLER_43_238 VDD VSS sg13g2_decap_8
XFILLER_28_224 VDD VSS sg13g2_decap_8
XFILLER_11_168 VDD VSS sg13g2_decap_8
XFILLER_22_53 VDD VSS sg13g2_decap_8
XFILLER_3_378 VDD VSS sg13g2_decap_8
XFILLER_3_301 VDD VSS sg13g2_decap_8
XFILLER_19_224 VDD VSS sg13g2_decap_8
XFILLER_34_238 VDD VSS sg13g2_decap_8
XFILLER_6_161 VDD VSS sg13g2_decap_8
XFILLER_8_77 VDD VSS sg13g2_decap_8
XFILLER_19_0 VDD VSS sg13g2_decap_8
XFILLER_25_238 VDD VSS sg13g2_decap_8
XFILLER_0_315 VDD VSS sg13g2_decap_8
XFILLER_16_238 VDD VSS sg13g2_decap_8
XFILLER_17_42 VDD VSS sg13g2_decap_8
XFILLER_33_63 VDD VSS sg13g2_decap_8
XFILLER_3_175 VDD VSS sg13g2_decap_8
XFILLER_39_308 VDD VSS sg13g2_decap_8
XFILLER_12_7 VDD VSS sg13g2_decap_8
XFILLER_30_252 VDD VSS sg13g2_decap_8
XFILLER_38_385 VDD VSS sg13g2_decap_8
XFILLER_21_252 VDD VSS sg13g2_decap_8
XFILLER_0_112 VDD VSS sg13g2_decap_8
XFILLER_0_189 VDD VSS sg13g2_decap_8
XFILLER_28_63 VDD VSS sg13g2_decap_8
XFILLER_12_252 VDD VSS sg13g2_decap_8
XFILLER_8_245 VDD VSS sg13g2_decap_8
XFILLER_5_67 VDD VSS sg13g2_decap_8
XFILLER_39_105 VDD VSS sg13g2_decap_8
XFILLER_35_322 VDD VSS sg13g2_decap_8
XFILLER_38_182 VDD VSS sg13g2_decap_8
XFILLER_26_322 VDD VSS sg13g2_decap_8
XFILLER_14_21 VDD VSS sg13g2_decap_8
XFILLER_41_336 VDD VSS sg13g2_decap_8
XFILLER_14_98 VDD VSS sg13g2_decap_8
XFILLER_30_42 VDD VSS sg13g2_decap_8
XFILLER_39_84 VDD VSS sg13g2_decap_8
XFILLER_17_322 VDD VSS sg13g2_decap_8
XFILLER_36_119 VDD VSS sg13g2_decap_8
XFILLER_32_336 VDD VSS sg13g2_decap_8
XFILLER_29_182 VDD VSS sg13g2_decap_8
XFILLER_27_119 VDD VSS sg13g2_decap_8
XFILLER_23_336 VDD VSS sg13g2_decap_8
XFILLER_35_196 VDD VSS sg13g2_decap_8
XFILLER_14_336 VDD VSS sg13g2_decap_8
XFILLER_18_119 VDD VSS sg13g2_decap_8
XFILLER_26_196 VDD VSS sg13g2_decap_8
XFILLER_25_42 VDD VSS sg13g2_decap_8
XFILLER_22_391 VDD VSS sg13g2_fill_1
XFILLER_41_63 VDD VSS sg13g2_decap_8
XFILLER_41_133 VDD VSS sg13g2_decap_8
XFILLER_1_273 VDD VSS sg13g2_decap_8
X_51_ _68_/D _59_/A _51_/B VDD VSS sg13g2_nor2_1
XFILLER_2_35 VDD VSS sg13g2_decap_8
XFILLER_17_196 VDD VSS sg13g2_decap_8
XFILLER_32_133 VDD VSS sg13g2_decap_8
XFILLER_23_133 VDD VSS sg13g2_decap_8
XFILLER_11_77 VDD VSS sg13g2_decap_8
XFILLER_14_133 VDD VSS sg13g2_decap_8
XFILLER_36_63 VDD VSS sg13g2_decap_8
XFILLER_10_350 VDD VSS sg13g2_decap_8
XFILLER_6_343 VDD VSS sg13g2_decap_8
XFILLER_6_387 VDD VSS sg13g2_fill_1
XFILLER_42_7 VDD VSS sg13g2_decap_8
XFILLER_37_203 VDD VSS sg13g2_decap_8
XFILLER_20_147 VDD VSS sg13g2_decap_8
XFILLER_28_203 VDD VSS sg13g2_decap_8
XFILLER_43_217 VDD VSS sg13g2_decap_8
XFILLER_36_280 VDD VSS sg13g2_decap_8
XFILLER_11_147 VDD VSS sg13g2_decap_8
XFILLER_22_32 VDD VSS sg13g2_decap_8
XFILLER_3_357 VDD VSS sg13g2_decap_8
XFILLER_19_203 VDD VSS sg13g2_decap_8
XFILLER_34_217 VDD VSS sg13g2_decap_8
XFILLER_27_280 VDD VSS sg13g2_decap_8
XFILLER_8_56 VDD VSS sg13g2_decap_8
XFILLER_42_294 VDD VSS sg13g2_decap_8
XFILLER_6_140 VDD VSS sg13g2_decap_8
XFILLER_18_280 VDD VSS sg13g2_decap_8
XFILLER_25_217 VDD VSS sg13g2_decap_8
XFILLER_33_294 VDD VSS sg13g2_decap_8
XFILLER_16_217 VDD VSS sg13g2_decap_8
XFILLER_17_21 VDD VSS sg13g2_decap_8
XFILLER_17_98 VDD VSS sg13g2_decap_8
XFILLER_24_294 VDD VSS sg13g2_decap_8
XFILLER_33_42 VDD VSS sg13g2_decap_8
XFILLER_3_154 VDD VSS sg13g2_decap_8
XFILLER_15_294 VDD VSS sg13g2_decap_8
XFILLER_30_231 VDD VSS sg13g2_decap_8
XFILLER_31_0 VDD VSS sg13g2_decap_8
XFILLER_38_364 VDD VSS sg13g2_decap_8
XFILLER_21_231 VDD VSS sg13g2_decap_8
XFILLER_0_168 VDD VSS sg13g2_decap_8
XFILLER_28_42 VDD VSS sg13g2_decap_8
XFILLER_12_231 VDD VSS sg13g2_decap_8
XFILLER_8_224 VDD VSS sg13g2_decap_8
XFILLER_5_46 VDD VSS sg13g2_decap_8
XFILLER_35_301 VDD VSS sg13g2_decap_8
XFILLER_35_378 VDD VSS sg13g2_decap_8
XFILLER_41_315 VDD VSS sg13g2_decap_8
XFILLER_38_161 VDD VSS sg13g2_decap_8
XFILLER_26_301 VDD VSS sg13g2_decap_8
XFILLER_14_77 VDD VSS sg13g2_decap_8
XFILLER_5_249 VDD VSS sg13g2_decap_8
XFILLER_30_98 VDD VSS sg13g2_decap_8
XFILLER_30_21 VDD VSS sg13g2_decap_8
XFILLER_17_301 VDD VSS sg13g2_decap_8
XFILLER_39_63 VDD VSS sg13g2_decap_8
XFILLER_29_161 VDD VSS sg13g2_decap_8
XFILLER_17_389 VDD VSS sg13g2_fill_2
XFILLER_32_315 VDD VSS sg13g2_decap_8
XFILLER_23_315 VDD VSS sg13g2_decap_8
XFILLER_35_175 VDD VSS sg13g2_decap_8
XFILLER_14_315 VDD VSS sg13g2_decap_8
XFILLER_25_21 VDD VSS sg13g2_decap_8
XFILLER_41_112 VDD VSS sg13g2_decap_8
XFILLER_26_175 VDD VSS sg13g2_decap_8
XFILLER_41_42 VDD VSS sg13g2_decap_8
XFILLER_41_189 VDD VSS sg13g2_decap_8
XFILLER_25_98 VDD VSS sg13g2_decap_8
XFILLER_1_252 VDD VSS sg13g2_decap_8
XFILLER_9_0 VDD VSS sg13g2_decap_8
XFILLER_2_14 VDD VSS sg13g2_decap_8
X_50_ _51_/B _57_/A _50_/B VDD VSS sg13g2_xnor2_1
XFILLER_17_175 VDD VSS sg13g2_decap_8
XFILLER_20_329 VDD VSS sg13g2_decap_8
XFILLER_32_189 VDD VSS sg13g2_decap_8
XFILLER_32_112 VDD VSS sg13g2_decap_8
XFILLER_9_385 VDD VSS sg13g2_decap_8
XFILLER_23_112 VDD VSS sg13g2_decap_8
XFILLER_11_329 VDD VSS sg13g2_decap_8
XFILLER_23_189 VDD VSS sg13g2_decap_8
XFILLER_11_56 VDD VSS sg13g2_decap_8
XFILLER_2_7 VDD VSS sg13g2_decap_8
XFILLER_36_42 VDD VSS sg13g2_decap_8
XFILLER_14_112 VDD VSS sg13g2_decap_8
XFILLER_14_189 VDD VSS sg13g2_decap_8
XFILLER_6_322 VDD VSS sg13g2_decap_8
XFILLER_35_7 VDD VSS sg13g2_decap_8
XFILLER_37_259 VDD VSS sg13g2_decap_8
XFILLER_20_126 VDD VSS sg13g2_decap_8
XFILLER_9_182 VDD VSS sg13g2_decap_8
XFILLER_28_259 VDD VSS sg13g2_decap_8
XFILLER_11_126 VDD VSS sg13g2_decap_8
XFILLER_22_11 VDD VSS sg13g2_decap_8
XFILLER_22_88 VDD VSS sg13g2_decap_8
XFILLER_7_119 VDD VSS sg13g2_decap_8
XFILLER_3_336 VDD VSS sg13g2_decap_8
XFILLER_19_259 VDD VSS sg13g2_decap_8
XFILLER_8_35 VDD VSS sg13g2_decap_8
XFILLER_42_273 VDD VSS sg13g2_decap_8
XFILLER_6_196 VDD VSS sg13g2_decap_8
XFILLER_33_273 VDD VSS sg13g2_decap_8
XFILLER_17_77 VDD VSS sg13g2_decap_8
XFILLER_24_273 VDD VSS sg13g2_decap_8
XFILLER_33_98 VDD VSS sg13g2_decap_8
XFILLER_33_21 VDD VSS sg13g2_decap_8
XFILLER_3_133 VDD VSS sg13g2_decap_8
XFILLER_15_273 VDD VSS sg13g2_decap_8
XFILLER_30_210 VDD VSS sg13g2_decap_8
XFILLER_30_287 VDD VSS sg13g2_decap_8
XFILLER_24_0 VDD VSS sg13g2_decap_8
XFILLER_38_343 VDD VSS sg13g2_decap_8
XFILLER_0_91 VDD VSS sg13g2_decap_8
XFILLER_21_210 VDD VSS sg13g2_decap_8
XFILLER_21_287 VDD VSS sg13g2_decap_8
XFILLER_0_147 VDD VSS sg13g2_decap_8
XFILLER_29_343 VDD VSS sg13g2_decap_8
XFILLER_28_21 VDD VSS sg13g2_decap_8
XFILLER_12_210 VDD VSS sg13g2_decap_8
XFILLER_28_98 VDD VSS sg13g2_decap_8
XFILLER_12_287 VDD VSS sg13g2_decap_8
XFILLER_8_203 VDD VSS sg13g2_decap_8
XFILLER_5_25 VDD VSS sg13g2_decap_8
XFILLER_35_357 VDD VSS sg13g2_decap_8
XFILLER_7_280 VDD VSS sg13g2_decap_8
XFILLER_38_140 VDD VSS sg13g2_decap_8
XFILLER_14_56 VDD VSS sg13g2_decap_8
XFILLER_5_228 VDD VSS sg13g2_decap_8
XFILLER_39_42 VDD VSS sg13g2_decap_8
XFILLER_30_77 VDD VSS sg13g2_decap_8
XFILLER_29_140 VDD VSS sg13g2_decap_8
XFILLER_40_371 VDD VSS sg13g2_decap_8
XFILLER_4_294 VDD VSS sg13g2_decap_8
XFILLER_35_154 VDD VSS sg13g2_decap_8
XFILLER_31_371 VDD VSS sg13g2_decap_8
XFILLER_41_168 VDD VSS sg13g2_decap_8
XFILLER_26_154 VDD VSS sg13g2_decap_8
XFILLER_25_77 VDD VSS sg13g2_decap_8
XFILLER_41_98 VDD VSS sg13g2_decap_8
XFILLER_41_21 VDD VSS sg13g2_decap_8
XFILLER_1_231 VDD VSS sg13g2_decap_8
XFILLER_17_154 VDD VSS sg13g2_decap_8
XFILLER_20_308 VDD VSS sg13g2_decap_8
XFILLER_9_364 VDD VSS sg13g2_decap_8
XFILLER_32_168 VDD VSS sg13g2_decap_8
XFILLER_11_308 VDD VSS sg13g2_decap_8
XFILLER_23_168 VDD VSS sg13g2_decap_8
XFILLER_11_35 VDD VSS sg13g2_decap_8
XFILLER_36_21 VDD VSS sg13g2_decap_8
XFILLER_14_168 VDD VSS sg13g2_decap_8
XFILLER_6_301 VDD VSS sg13g2_decap_8
XFILLER_36_98 VDD VSS sg13g2_decap_8
XFILLER_10_385 VDD VSS sg13g2_decap_8
XFILLER_6_378 VDD VSS sg13g2_decap_8
XFILLER_37_238 VDD VSS sg13g2_decap_8
XFILLER_28_7 VDD VSS sg13g2_decap_8
XFILLER_20_105 VDD VSS sg13g2_decap_8
XFILLER_9_161 VDD VSS sg13g2_decap_8
XFILLER_3_91 VDD VSS sg13g2_decap_8
XFILLER_28_238 VDD VSS sg13g2_decap_8
XFILLER_11_105 VDD VSS sg13g2_decap_8
XFILLER_22_67 VDD VSS sg13g2_decap_8
XFILLER_3_315 VDD VSS sg13g2_decap_8
XFILLER_19_238 VDD VSS sg13g2_decap_8
XFILLER_42_252 VDD VSS sg13g2_decap_8
XFILLER_10_182 VDD VSS sg13g2_decap_8
XFILLER_8_14 VDD VSS sg13g2_decap_8
XFILLER_6_175 VDD VSS sg13g2_decap_8
XFILLER_33_252 VDD VSS sg13g2_decap_8
XFILLER_0_329 VDD VSS sg13g2_decap_8
XFILLER_17_56 VDD VSS sg13g2_decap_8
XFILLER_24_252 VDD VSS sg13g2_decap_8
XFILLER_33_77 VDD VSS sg13g2_decap_8
XFILLER_3_189 VDD VSS sg13g2_decap_8
XFILLER_3_112 VDD VSS sg13g2_decap_8
XFILLER_15_252 VDD VSS sg13g2_decap_8
XFILLER_30_266 VDD VSS sg13g2_decap_8
XFILLER_38_322 VDD VSS sg13g2_decap_8
XFILLER_0_70 VDD VSS sg13g2_decap_8
XFILLER_17_0 VDD VSS sg13g2_decap_8
XFILLER_21_266 VDD VSS sg13g2_decap_8
XFILLER_0_126 VDD VSS sg13g2_decap_8
XFILLER_29_322 VDD VSS sg13g2_decap_8
XFILLER_28_77 VDD VSS sg13g2_decap_8
XFILLER_12_266 VDD VSS sg13g2_decap_8
XFILLER_8_259 VDD VSS sg13g2_decap_8
XFILLER_39_119 VDD VSS sg13g2_decap_8
XFILLER_10_7 VDD VSS sg13g2_decap_8
XFILLER_35_336 VDD VSS sg13g2_decap_8
XFILLER_14_35 VDD VSS sg13g2_decap_8
XFILLER_38_196 VDD VSS sg13g2_decap_8
XFILLER_26_347 VDD VSS sg13g2_decap_8
XFILLER_26_336 VDD VSS sg13g2_decap_8
XFILLER_5_207 VDD VSS sg13g2_decap_8
XFILLER_30_56 VDD VSS sg13g2_decap_8
XFILLER_39_21 VDD VSS sg13g2_decap_8
XFILLER_17_336 VDD VSS sg13g2_decap_8
XFILLER_17_347 VDD VSS sg13g2_fill_2
XFILLER_39_98 VDD VSS sg13g2_decap_8
XFILLER_29_196 VDD VSS sg13g2_decap_8
XFILLER_40_350 VDD VSS sg13g2_decap_8
XFILLER_4_273 VDD VSS sg13g2_decap_8
XFILLER_35_133 VDD VSS sg13g2_decap_8
XFILLER_31_350 VDD VSS sg13g2_decap_8
XFILLER_6_91 VDD VSS sg13g2_decap_8
XFILLER_26_133 VDD VSS sg13g2_decap_8
XFILLER_41_147 VDD VSS sg13g2_decap_8
XFILLER_25_56 VDD VSS sg13g2_decap_8
XFILLER_1_210 VDD VSS sg13g2_decap_8
XFILLER_41_77 VDD VSS sg13g2_decap_8
XFILLER_1_287 VDD VSS sg13g2_decap_8
XFILLER_2_49 VDD VSS sg13g2_decap_8
XFILLER_17_133 VDD VSS sg13g2_decap_8
XFILLER_32_147 VDD VSS sg13g2_decap_8
XFILLER_13_350 VDD VSS sg13g2_fill_2
XFILLER_9_343 VDD VSS sg13g2_decap_8
XFILLER_23_147 VDD VSS sg13g2_decap_8
XFILLER_11_14 VDD VSS sg13g2_decap_8
XFILLER_39_280 VDD VSS sg13g2_decap_8
XFILLER_36_77 VDD VSS sg13g2_decap_8
XFILLER_10_364 VDD VSS sg13g2_decap_8
XFILLER_14_147 VDD VSS sg13g2_decap_8
XFILLER_6_357 VDD VSS sg13g2_decap_8
XFILLER_37_217 VDD VSS sg13g2_decap_8
XFILLER_9_140 VDD VSS sg13g2_decap_8
XFILLER_3_70 VDD VSS sg13g2_decap_8
XFILLER_36_294 VDD VSS sg13g2_decap_8
XFILLER_28_217 VDD VSS sg13g2_decap_8
XFILLER_22_46 VDD VSS sg13g2_decap_8
XFILLER_19_217 VDD VSS sg13g2_decap_8
XFILLER_42_231 VDD VSS sg13g2_decap_8
XFILLER_27_294 VDD VSS sg13g2_decap_8
XFILLER_10_161 VDD VSS sg13g2_decap_8
XFILLER_6_154 VDD VSS sg13g2_decap_8
XFILLER_40_7 VDD VSS sg13g2_decap_8
XFILLER_2_371 VDD VSS sg13g2_decap_8
XFILLER_18_294 VDD VSS sg13g2_decap_8
XFILLER_33_231 VDD VSS sg13g2_decap_8
XFILLER_0_308 VDD VSS sg13g2_decap_8
XFILLER_17_35 VDD VSS sg13g2_decap_8
XFILLER_24_231 VDD VSS sg13g2_decap_8
XFILLER_33_56 VDD VSS sg13g2_decap_8
XFILLER_3_168 VDD VSS sg13g2_decap_8
XFILLER_15_231 VDD VSS sg13g2_decap_8
XFILLER_30_245 VDD VSS sg13g2_decap_8
XFILLER_38_301 VDD VSS sg13g2_decap_8
XFILLER_38_378 VDD VSS sg13g2_decap_8
XFILLER_21_245 VDD VSS sg13g2_decap_8
XFILLER_9_91 VDD VSS sg13g2_decap_8
XFILLER_0_105 VDD VSS sg13g2_decap_8
XFILLER_29_389 VDD VSS sg13g2_fill_2
XFILLER_29_301 VDD VSS sg13g2_decap_8
XFILLER_28_56 VDD VSS sg13g2_decap_8
XFILLER_12_245 VDD VSS sg13g2_decap_8
XFILLER_8_238 VDD VSS sg13g2_decap_8
XFILLER_35_315 VDD VSS sg13g2_decap_8
XFILLER_38_175 VDD VSS sg13g2_decap_8
XFILLER_26_315 VDD VSS sg13g2_decap_8
XFILLER_14_14 VDD VSS sg13g2_decap_8
XFILLER_41_329 VDD VSS sg13g2_decap_8
XFILLER_30_35 VDD VSS sg13g2_decap_8
XFILLER_39_77 VDD VSS sg13g2_decap_8
XFILLER_17_315 VDD VSS sg13g2_decap_8
XFILLER_32_329 VDD VSS sg13g2_decap_8
XFILLER_29_175 VDD VSS sg13g2_decap_8
XFILLER_4_252 VDD VSS sg13g2_decap_8
XFILLER_35_112 VDD VSS sg13g2_decap_8
XFILLER_23_329 VDD VSS sg13g2_decap_8
XFILLER_35_189 VDD VSS sg13g2_decap_8
XFILLER_6_70 VDD VSS sg13g2_decap_8
XFILLER_14_329 VDD VSS sg13g2_decap_8
XFILLER_25_35 VDD VSS sg13g2_decap_8
XFILLER_26_189 VDD VSS sg13g2_decap_8
XFILLER_26_112 VDD VSS sg13g2_decap_8
XFILLER_22_340 VDD VSS sg13g2_decap_8
XFILLER_41_56 VDD VSS sg13g2_decap_8
XFILLER_41_126 VDD VSS sg13g2_decap_8
XFILLER_17_112 VDD VSS sg13g2_decap_8
XFILLER_1_266 VDD VSS sg13g2_decap_8
XFILLER_2_28 VDD VSS sg13g2_decap_8
XFILLER_17_189 VDD VSS sg13g2_decap_8
XFILLER_32_126 VDD VSS sg13g2_decap_8
XFILLER_9_322 VDD VSS sg13g2_decap_8
XFILLER_23_126 VDD VSS sg13g2_decap_8
XFILLER_14_126 VDD VSS sg13g2_decap_8
XFILLER_36_56 VDD VSS sg13g2_decap_8
XFILLER_10_343 VDD VSS sg13g2_decap_8
XFILLER_6_336 VDD VSS sg13g2_decap_8
XFILLER_7_0 VDD VSS sg13g2_decap_8
XFILLER_5_391 VDD VSS sg13g2_fill_1
XFILLER_9_196 VDD VSS sg13g2_decap_8
XFILLER_36_273 VDD VSS sg13g2_decap_8
XFILLER_22_25 VDD VSS sg13g2_decap_8
XFILLER_0_7 VDD VSS sg13g2_decap_8
XFILLER_8_49 VDD VSS sg13g2_decap_8
XFILLER_42_287 VDD VSS sg13g2_decap_8
XFILLER_42_210 VDD VSS sg13g2_decap_8
XFILLER_27_273 VDD VSS sg13g2_decap_8
XFILLER_10_140 VDD VSS sg13g2_decap_8
XFILLER_12_91 VDD VSS sg13g2_decap_8
XFILLER_6_133 VDD VSS sg13g2_decap_8
XFILLER_33_7 VDD VSS sg13g2_decap_8
XFILLER_2_350 VDD VSS sg13g2_decap_8
XFILLER_18_273 VDD VSS sg13g2_decap_8
XFILLER_33_210 VDD VSS sg13g2_decap_8
XFILLER_33_287 VDD VSS sg13g2_decap_8
XFILLER_17_14 VDD VSS sg13g2_decap_8
XFILLER_24_210 VDD VSS sg13g2_decap_8
XFILLER_24_287 VDD VSS sg13g2_decap_8
XFILLER_33_35 VDD VSS sg13g2_decap_8
XFILLER_3_147 VDD VSS sg13g2_decap_8
XFILLER_15_210 VDD VSS sg13g2_decap_8
XFILLER_15_287 VDD VSS sg13g2_decap_8
XFILLER_30_224 VDD VSS sg13g2_decap_8
XFILLER_38_357 VDD VSS sg13g2_decap_8
XFILLER_21_224 VDD VSS sg13g2_decap_8
XFILLER_9_70 VDD VSS sg13g2_decap_8
XFILLER_28_35 VDD VSS sg13g2_decap_8
XFILLER_12_224 VDD VSS sg13g2_decap_8
XFILLER_8_217 VDD VSS sg13g2_decap_8
XFILLER_5_39 VDD VSS sg13g2_decap_8
XFILLER_43_371 VDD VSS sg13g2_decap_8
XFILLER_7_294 VDD VSS sg13g2_decap_8
XFILLER_38_154 VDD VSS sg13g2_decap_8
XFILLER_41_308 VDD VSS sg13g2_decap_8
XFILLER_34_371 VDD VSS sg13g2_decap_8
XFILLER_30_14 VDD VSS sg13g2_decap_8
XFILLER_39_56 VDD VSS sg13g2_decap_8
XFILLER_29_154 VDD VSS sg13g2_decap_8
XFILLER_32_308 VDD VSS sg13g2_decap_8
XFILLER_40_385 VDD VSS sg13g2_decap_8
XFILLER_20_91 VDD VSS sg13g2_decap_8
XFILLER_4_231 VDD VSS sg13g2_decap_8
XFILLER_23_308 VDD VSS sg13g2_decap_8
XFILLER_35_168 VDD VSS sg13g2_decap_8
XFILLER_31_385 VDD VSS sg13g2_decap_8
XFILLER_31_363 VDD VSS sg13g2_decap_4
XFILLER_14_308 VDD VSS sg13g2_decap_8
XFILLER_25_14 VDD VSS sg13g2_decap_8
XFILLER_41_105 VDD VSS sg13g2_decap_8
XFILLER_26_168 VDD VSS sg13g2_decap_8
XFILLER_41_35 VDD VSS sg13g2_decap_8
XFILLER_1_245 VDD VSS sg13g2_decap_8
XFILLER_13_352 VDD VSS sg13g2_fill_1
XFILLER_15_91 VDD VSS sg13g2_decap_8
XFILLER_17_168 VDD VSS sg13g2_decap_8
XFILLER_9_301 VDD VSS sg13g2_decap_8
XFILLER_32_105 VDD VSS sg13g2_decap_8
XFILLER_9_378 VDD VSS sg13g2_decap_8
XFILLER_40_182 VDD VSS sg13g2_decap_8
XFILLER_23_105 VDD VSS sg13g2_decap_8
XFILLER_31_182 VDD VSS sg13g2_decap_8
XFILLER_11_49 VDD VSS sg13g2_decap_8
XFILLER_36_35 VDD VSS sg13g2_decap_8
XFILLER_14_105 VDD VSS sg13g2_decap_8
XFILLER_10_322 VDD VSS sg13g2_decap_8
XFILLER_22_193 VDD VSS sg13g2_decap_8
XFILLER_6_315 VDD VSS sg13g2_decap_8
XFILLER_13_182 VDD VSS sg13g2_decap_8
XFILLER_20_119 VDD VSS sg13g2_decap_8
XFILLER_9_175 VDD VSS sg13g2_decap_8
XFILLER_11_119 VDD VSS sg13g2_decap_8
XFILLER_36_252 VDD VSS sg13g2_decap_8
XFILLER_3_329 VDD VSS sg13g2_decap_8
XFILLER_27_252 VDD VSS sg13g2_decap_8
XFILLER_8_28 VDD VSS sg13g2_decap_8
XFILLER_42_266 VDD VSS sg13g2_decap_8
XFILLER_10_196 VDD VSS sg13g2_decap_8
XFILLER_12_70 VDD VSS sg13g2_decap_8
XFILLER_6_112 VDD VSS sg13g2_decap_8
XFILLER_6_189 VDD VSS sg13g2_decap_8
XFILLER_26_7 VDD VSS sg13g2_decap_8
XFILLER_18_252 VDD VSS sg13g2_decap_8
XFILLER_33_266 VDD VSS sg13g2_decap_8
XFILLER_24_266 VDD VSS sg13g2_decap_8
XFILLER_33_14 VDD VSS sg13g2_decap_8
XFILLER_3_126 VDD VSS sg13g2_decap_8
XFILLER_15_266 VDD VSS sg13g2_decap_8
XFILLER_30_203 VDD VSS sg13g2_decap_8
XFILLER_23_91 VDD VSS sg13g2_decap_8
XFILLER_38_336 VDD VSS sg13g2_decap_8
XFILLER_0_84 VDD VSS sg13g2_decap_8
XFILLER_21_203 VDD VSS sg13g2_decap_8
XFILLER_29_336 VDD VSS sg13g2_decap_8
XFILLER_28_14 VDD VSS sg13g2_decap_8
XFILLER_12_203 VDD VSS sg13g2_decap_8
XFILLER_20_280 VDD VSS sg13g2_decap_8
XFILLER_5_18 VDD VSS sg13g2_decap_8
XFILLER_18_91 VDD VSS sg13g2_decap_8
XFILLER_43_350 VDD VSS sg13g2_decap_8
XFILLER_28_391 VDD VSS sg13g2_fill_1
XFILLER_11_280 VDD VSS sg13g2_decap_8
XFILLER_7_273 VDD VSS sg13g2_decap_8
XFILLER_15_0 VDD VSS sg13g2_decap_8
XFILLER_19_380 VDD VSS sg13g2_decap_8
XFILLER_38_133 VDD VSS sg13g2_decap_8
XFILLER_34_350 VDD VSS sg13g2_decap_8
XFILLER_14_49 VDD VSS sg13g2_decap_8
XFILLER_39_35 VDD VSS sg13g2_decap_8
XFILLER_29_133 VDD VSS sg13g2_decap_8
XFILLER_25_350 VDD VSS sg13g2_decap_8
XFILLER_4_210 VDD VSS sg13g2_decap_8
XFILLER_40_364 VDD VSS sg13g2_decap_8
XFILLER_20_70 VDD VSS sg13g2_decap_8
XFILLER_4_287 VDD VSS sg13g2_decap_8
XFILLER_16_350 VDD VSS sg13g2_decap_8
XFILLER_35_147 VDD VSS sg13g2_decap_8
XFILLER_26_147 VDD VSS sg13g2_decap_8
XFILLER_41_14 VDD VSS sg13g2_decap_8
XFILLER_1_224 VDD VSS sg13g2_decap_8
XFILLER_17_147 VDD VSS sg13g2_decap_8
XFILLER_13_386 VDD VSS sg13g2_fill_2
XFILLER_15_70 VDD VSS sg13g2_decap_8
XFILLER_9_357 VDD VSS sg13g2_decap_8
XFILLER_40_161 VDD VSS sg13g2_decap_8
XFILLER_31_91 VDD VSS sg13g2_decap_8
XFILLER_11_28 VDD VSS sg13g2_decap_8
XFILLER_31_161 VDD VSS sg13g2_decap_8
XFILLER_39_294 VDD VSS sg13g2_decap_8
XFILLER_36_14 VDD VSS sg13g2_decap_8
XFILLER_10_301 VDD VSS sg13g2_decap_8
XFILLER_22_172 VDD VSS sg13g2_decap_8
XFILLER_10_378 VDD VSS sg13g2_decap_8
XFILLER_26_91 VDD VSS sg13g2_decap_8
XFILLER_13_161 VDD VSS sg13g2_decap_8
XFILLER_9_154 VDD VSS sg13g2_decap_8
XFILLER_5_382 VDD VSS sg13g2_decap_8
XFILLER_3_84 VDD VSS sg13g2_decap_8
XFILLER_36_231 VDD VSS sg13g2_decap_8
XFILLER_3_308 VDD VSS sg13g2_decap_8
XFILLER_42_245 VDD VSS sg13g2_decap_8
XFILLER_27_231 VDD VSS sg13g2_decap_8
XFILLER_10_175 VDD VSS sg13g2_decap_8
XFILLER_6_168 VDD VSS sg13g2_decap_8
XFILLER_18_231 VDD VSS sg13g2_decap_8
XFILLER_19_7 VDD VSS sg13g2_decap_8
XFILLER_2_385 VDD VSS sg13g2_decap_8
XFILLER_33_245 VDD VSS sg13g2_decap_8
XFILLER_17_49 VDD VSS sg13g2_decap_8
XFILLER_24_245 VDD VSS sg13g2_decap_8
XFILLER_3_105 VDD VSS sg13g2_decap_8
XFILLER_15_245 VDD VSS sg13g2_decap_8
XFILLER_23_70 VDD VSS sg13g2_decap_8
XFILLER_30_259 VDD VSS sg13g2_decap_8
XFILLER_2_182 VDD VSS sg13g2_decap_8
XFILLER_0_63 VDD VSS sg13g2_decap_8
XFILLER_38_315 VDD VSS sg13g2_decap_8
XFILLER_21_259 VDD VSS sg13g2_decap_8
XFILLER_0_119 VDD VSS sg13g2_decap_8
XFILLER_29_315 VDD VSS sg13g2_decap_8
XFILLER_12_259 VDD VSS sg13g2_decap_8
XFILLER_18_70 VDD VSS sg13g2_decap_8
XFILLER_35_329 VDD VSS sg13g2_decap_8
XFILLER_34_91 VDD VSS sg13g2_decap_8
XFILLER_7_252 VDD VSS sg13g2_decap_8
XFILLER_38_112 VDD VSS sg13g2_decap_8
XFILLER_19_370 VDD VSS sg13g2_fill_1
XFILLER_38_189 VDD VSS sg13g2_decap_8
XFILLER_26_329 VDD VSS sg13g2_decap_8
XFILLER_14_28 VDD VSS sg13g2_decap_8
XFILLER_39_14 VDD VSS sg13g2_decap_8
XFILLER_30_49 VDD VSS sg13g2_decap_8
XFILLER_17_329 VDD VSS sg13g2_decap_8
XFILLER_29_189 VDD VSS sg13g2_decap_8
XFILLER_29_112 VDD VSS sg13g2_decap_8
XFILLER_40_343 VDD VSS sg13g2_decap_8
XFILLER_4_266 VDD VSS sg13g2_decap_8
XFILLER_35_126 VDD VSS sg13g2_decap_8
XFILLER_29_91 VDD VSS sg13g2_decap_8
XFILLER_31_343 VDD VSS sg13g2_decap_8
XFILLER_6_84 VDD VSS sg13g2_decap_8
XFILLER_26_126 VDD VSS sg13g2_decap_8
XFILLER_25_49 VDD VSS sg13g2_decap_8
XFILLER_22_387 VDD VSS sg13g2_decap_4
XFILLER_1_203 VDD VSS sg13g2_decap_8
XFILLER_17_126 VDD VSS sg13g2_decap_8
XFILLER_13_343 VDD VSS sg13g2_decap_8
XFILLER_9_336 VDD VSS sg13g2_decap_8
XFILLER_40_140 VDD VSS sg13g2_decap_8
XFILLER_31_70 VDD VSS sg13g2_decap_8
XFILLER_0_280 VDD VSS sg13g2_decap_8
XFILLER_31_140 VDD VSS sg13g2_decap_8
XFILLER_39_273 VDD VSS sg13g2_decap_8
XFILLER_10_357 VDD VSS sg13g2_decap_8
XFILLER_22_151 VDD VSS sg13g2_decap_8
XFILLER_13_140 VDD VSS sg13g2_decap_8
XFILLER_26_70 VDD VSS sg13g2_decap_8
XFILLER_9_133 VDD VSS sg13g2_decap_8
XFILLER_42_91 VDD VSS sg13g2_decap_8
XFILLER_5_361 VDD VSS sg13g2_decap_8
XFILLER_3_63 VDD VSS sg13g2_decap_8
XFILLER_36_287 VDD VSS sg13g2_decap_8
XFILLER_36_210 VDD VSS sg13g2_decap_8
XFILLER_22_39 VDD VSS sg13g2_decap_8
XFILLER_27_210 VDD VSS sg13g2_decap_8
XFILLER_42_224 VDD VSS sg13g2_decap_8
XFILLER_27_287 VDD VSS sg13g2_decap_8
XFILLER_10_154 VDD VSS sg13g2_decap_8
XFILLER_6_147 VDD VSS sg13g2_decap_8
XFILLER_2_364 VDD VSS sg13g2_decap_8
XFILLER_18_210 VDD VSS sg13g2_decap_8
XFILLER_37_91 VDD VSS sg13g2_decap_8
XFILLER_18_287 VDD VSS sg13g2_decap_8
XFILLER_33_224 VDD VSS sg13g2_decap_8
XFILLER_38_0 VDD VSS sg13g2_decap_8
XFILLER_17_28 VDD VSS sg13g2_decap_8
XFILLER_24_224 VDD VSS sg13g2_decap_8
XFILLER_33_49 VDD VSS sg13g2_decap_8
XFILLER_15_224 VDD VSS sg13g2_decap_8
XFILLER_30_238 VDD VSS sg13g2_decap_8
XFILLER_31_7 VDD VSS sg13g2_decap_8
XFILLER_2_161 VDD VSS sg13g2_decap_8
XFILLER_0_42 VDD VSS sg13g2_decap_8
XFILLER_21_238 VDD VSS sg13g2_decap_8
XFILLER_9_84 VDD VSS sg13g2_decap_8
XFILLER_28_49 VDD VSS sg13g2_decap_8
XFILLER_12_238 VDD VSS sg13g2_decap_8
XFILLER_37_371 VDD VSS sg13g2_decap_8
XFILLER_35_308 VDD VSS sg13g2_decap_8
XFILLER_28_382 VDD VSS sg13g2_decap_8
XFILLER_7_231 VDD VSS sg13g2_decap_8
XFILLER_43_385 VDD VSS sg13g2_fill_2
XFILLER_34_70 VDD VSS sg13g2_decap_8
XFILLER_38_168 VDD VSS sg13g2_decap_8
XFILLER_26_308 VDD VSS sg13g2_decap_8
XFILLER_34_385 VDD VSS sg13g2_decap_8
XFILLER_30_28 VDD VSS sg13g2_decap_8
XFILLER_17_308 VDD VSS sg13g2_decap_8
XFILLER_29_168 VDD VSS sg13g2_decap_8
XFILLER_40_322 VDD VSS sg13g2_decap_8
XFILLER_4_245 VDD VSS sg13g2_decap_8
XFILLER_29_70 VDD VSS sg13g2_decap_8
XFILLER_43_182 VDD VSS sg13g2_decap_8
XFILLER_35_105 VDD VSS sg13g2_decap_8
XFILLER_31_322 VDD VSS sg13g2_decap_8
XFILLER_6_63 VDD VSS sg13g2_decap_8
XFILLER_20_0 VDD VSS sg13g2_decap_8
XFILLER_26_105 VDD VSS sg13g2_decap_8
XFILLER_22_333 VDD VSS sg13g2_decap_8
XFILLER_25_28 VDD VSS sg13g2_decap_8
XFILLER_41_119 VDD VSS sg13g2_decap_8
XFILLER_34_182 VDD VSS sg13g2_decap_8
XFILLER_9_7 VDD VSS sg13g2_decap_8
XFILLER_41_49 VDD VSS sg13g2_decap_8
XFILLER_1_259 VDD VSS sg13g2_decap_8
XFILLER_13_322 VDD VSS sg13g2_decap_8
XFILLER_17_105 VDD VSS sg13g2_decap_8
XFILLER_25_182 VDD VSS sg13g2_decap_8
XFILLER_32_119 VDD VSS sg13g2_decap_8
XFILLER_9_315 VDD VSS sg13g2_decap_8
XFILLER_40_196 VDD VSS sg13g2_decap_8
Xoutput3 counter_value_o[0] _68_/Q VDD VSS sg13g2_buf_1
XFILLER_16_182 VDD VSS sg13g2_decap_8
XFILLER_23_119 VDD VSS sg13g2_decap_8
XFILLER_31_196 VDD VSS sg13g2_decap_8
XFILLER_39_252 VDD VSS sg13g2_decap_8
XFILLER_14_119 VDD VSS sg13g2_decap_8
XFILLER_36_49 VDD VSS sg13g2_decap_8
XFILLER_10_336 VDD VSS sg13g2_decap_8
XFILLER_22_130 VDD VSS sg13g2_decap_8
XFILLER_6_329 VDD VSS sg13g2_decap_8
XFILLER_9_112 VDD VSS sg13g2_decap_8
XFILLER_13_196 VDD VSS sg13g2_decap_8
XFILLER_5_340 VDD VSS sg13g2_decap_8
XFILLER_9_189 VDD VSS sg13g2_decap_8
XFILLER_42_70 VDD VSS sg13g2_decap_8
XFILLER_3_42 VDD VSS sg13g2_decap_8
XFILLER_36_266 VDD VSS sg13g2_decap_8
XFILLER_22_18 VDD VSS sg13g2_decap_8
XFILLER_42_203 VDD VSS sg13g2_decap_8
XFILLER_27_266 VDD VSS sg13g2_decap_8
XFILLER_10_133 VDD VSS sg13g2_decap_8
XFILLER_12_84 VDD VSS sg13g2_decap_8
XFILLER_6_126 VDD VSS sg13g2_decap_8
XFILLER_2_343 VDD VSS sg13g2_decap_8
XFILLER_18_266 VDD VSS sg13g2_decap_8
XFILLER_37_70 VDD VSS sg13g2_decap_8
XFILLER_33_203 VDD VSS sg13g2_decap_8
XFILLER_41_280 VDD VSS sg13g2_decap_8
XFILLER_24_203 VDD VSS sg13g2_decap_8
X_69_ _69_/Q _71_/CLK _69_/D _69__18/L_HI VDD VSS sg13g2_dfrbpq_1
XFILLER_33_28 VDD VSS sg13g2_decap_8
XFILLER_32_280 VDD VSS sg13g2_decap_8
XFILLER_15_203 VDD VSS sg13g2_decap_8
XFILLER_23_280 VDD VSS sg13g2_decap_8
XFILLER_30_217 VDD VSS sg13g2_decap_8
XFILLER_2_140 VDD VSS sg13g2_decap_8
XFILLER_24_7 VDD VSS sg13g2_decap_8
XFILLER_0_21 VDD VSS sg13g2_decap_8
XFILLER_0_98 VDD VSS sg13g2_decap_8
XFILLER_21_217 VDD VSS sg13g2_decap_8
XFILLER_14_280 VDD VSS sg13g2_decap_8
XFILLER_9_63 VDD VSS sg13g2_decap_8
XFILLER_37_350 VDD VSS sg13g2_decap_8
XFILLER_28_28 VDD VSS sg13g2_decap_8
XFILLER_12_217 VDD VSS sg13g2_decap_8
XFILLER_20_294 VDD VSS sg13g2_decap_8
XFILLER_43_364 VDD VSS sg13g2_decap_8
XFILLER_11_294 VDD VSS sg13g2_decap_8
XFILLER_7_210 VDD VSS sg13g2_decap_8
XFILLER_7_287 VDD VSS sg13g2_decap_8
XFILLER_19_350 VDD VSS sg13g2_decap_4
XFILLER_22_4 VDD VSS sg13g2_decap_8
XFILLER_38_147 VDD VSS sg13g2_decap_8
XFILLER_34_364 VDD VSS sg13g2_decap_8
XFILLER_39_49 VDD VSS sg13g2_decap_8
XFILLER_40_301 VDD VSS sg13g2_decap_8
XFILLER_29_147 VDD VSS sg13g2_decap_8
XFILLER_40_378 VDD VSS sg13g2_decap_8
XFILLER_20_84 VDD VSS sg13g2_decap_8
XFILLER_4_224 VDD VSS sg13g2_decap_8
XFILLER_43_161 VDD VSS sg13g2_decap_8
XFILLER_31_378 VDD VSS sg13g2_decap_8
XFILLER_31_301 VDD VSS sg13g2_decap_8
XFILLER_6_42 VDD VSS sg13g2_decap_8
XFILLER_13_0 VDD VSS sg13g2_decap_8
XFILLER_34_161 VDD VSS sg13g2_decap_8
XFILLER_22_312 VDD VSS sg13g2_decap_8
XFILLER_41_28 VDD VSS sg13g2_decap_8
XFILLER_1_238 VDD VSS sg13g2_decap_8
XFILLER_13_301 VDD VSS sg13g2_decap_8
XFILLER_15_84 VDD VSS sg13g2_decap_8
XFILLER_25_161 VDD VSS sg13g2_decap_8
XFILLER_40_175 VDD VSS sg13g2_decap_8
Xoutput4 counter_value_o[1] _69_/Q VDD VSS sg13g2_buf_1
XFILLER_16_161 VDD VSS sg13g2_decap_8
XFILLER_31_175 VDD VSS sg13g2_decap_8
XFILLER_8_371 VDD VSS sg13g2_decap_8
XFILLER_39_231 VDD VSS sg13g2_decap_8
XFILLER_36_28 VDD VSS sg13g2_decap_8
XFILLER_10_315 VDD VSS sg13g2_decap_8
XFILLER_22_186 VDD VSS sg13g2_decap_8
XFILLER_6_308 VDD VSS sg13g2_decap_8
XFILLER_13_175 VDD VSS sg13g2_decap_8
XFILLER_9_168 VDD VSS sg13g2_decap_8
XFILLER_3_98 VDD VSS sg13g2_decap_8
XFILLER_3_21 VDD VSS sg13g2_decap_8
XFILLER_36_245 VDD VSS sg13g2_decap_8
XFILLER_27_245 VDD VSS sg13g2_decap_8
XFILLER_10_112 VDD VSS sg13g2_decap_8
XFILLER_42_259 VDD VSS sg13g2_decap_8
XFILLER_10_189 VDD VSS sg13g2_decap_8
XFILLER_12_63 VDD VSS sg13g2_decap_8
XFILLER_6_105 VDD VSS sg13g2_decap_8
XFILLER_2_322 VDD VSS sg13g2_decap_8
XFILLER_18_245 VDD VSS sg13g2_decap_8
XFILLER_33_259 VDD VSS sg13g2_decap_8
XFILLER_5_193 VDD VSS sg13g2_decap_8
X_68_ _68_/Q _71_/CLK _68_/D _68__12/L_HI VDD VSS sg13g2_dfrbpq_1
XFILLER_24_259 VDD VSS sg13g2_decap_8
XFILLER_3_119 VDD VSS sg13g2_decap_8
XFILLER_15_259 VDD VSS sg13g2_decap_8
XFILLER_23_84 VDD VSS sg13g2_decap_8
XFILLER_17_7 VDD VSS sg13g2_decap_8
XFILLER_38_329 VDD VSS sg13g2_decap_8
XFILLER_2_196 VDD VSS sg13g2_decap_8
XFILLER_0_77 VDD VSS sg13g2_decap_8
XFILLER_9_42 VDD VSS sg13g2_decap_8
XFILLER_43_0 VDD VSS sg13g2_decap_8
XFILLER_29_329 VDD VSS sg13g2_decap_8
XFILLER_20_273 VDD VSS sg13g2_decap_8
XFILLER_18_84 VDD VSS sg13g2_decap_8
XFILLER_43_387 VDD VSS sg13g2_fill_1
XFILLER_43_343 VDD VSS sg13g2_decap_8
XFILLER_11_273 VDD VSS sg13g2_decap_8
XFILLER_7_266 VDD VSS sg13g2_decap_8
XFILLER_38_126 VDD VSS sg13g2_decap_8
XFILLER_34_343 VDD VSS sg13g2_decap_8
XFILLER_39_28 VDD VSS sg13g2_decap_8
XFILLER_29_126 VDD VSS sg13g2_decap_8
XFILLER_25_343 VDD VSS sg13g2_decap_8
XFILLER_25_387 VDD VSS sg13g2_fill_1
XFILLER_4_203 VDD VSS sg13g2_decap_8
XFILLER_40_357 VDD VSS sg13g2_decap_8
XFILLER_20_63 VDD VSS sg13g2_decap_8
XFILLER_16_343 VDD VSS sg13g2_decap_8
XFILLER_43_140 VDD VSS sg13g2_decap_8
XFILLER_31_357 VDD VSS sg13g2_fill_2
XFILLER_6_21 VDD VSS sg13g2_decap_8
XFILLER_6_98 VDD VSS sg13g2_decap_8
XFILLER_3_280 VDD VSS sg13g2_decap_8
XFILLER_34_140 VDD VSS sg13g2_decap_8
XFILLER_1_217 VDD VSS sg13g2_decap_8
Xclkbuf_0_clock_i clkbuf_0_clock_i/X clock_i VDD VSS sg13g2_buf_16
XFILLER_15_63 VDD VSS sg13g2_decap_8
XFILLER_25_140 VDD VSS sg13g2_decap_8
XFILLER_40_154 VDD VSS sg13g2_decap_8
Xoutput5 counter_value_o[2] _70_/Q VDD VSS sg13g2_buf_1
XFILLER_31_84 VDD VSS sg13g2_decap_8
XFILLER_0_294 VDD VSS sg13g2_decap_8
XFILLER_16_140 VDD VSS sg13g2_decap_8
XFILLER_8_350 VDD VSS sg13g2_decap_8
XFILLER_31_154 VDD VSS sg13g2_decap_8
XFILLER_39_287 VDD VSS sg13g2_decap_8
XFILLER_39_210 VDD VSS sg13g2_decap_8
XFILLER_22_165 VDD VSS sg13g2_decap_8
XFILLER_26_84 VDD VSS sg13g2_decap_8
XFILLER_13_154 VDD VSS sg13g2_decap_8
XFILLER_9_147 VDD VSS sg13g2_decap_8
XFILLER_5_375 VDD VSS sg13g2_decap_8
XFILLER_3_77 VDD VSS sg13g2_decap_8
XFILLER_36_224 VDD VSS sg13g2_decap_8
XFILLER_27_224 VDD VSS sg13g2_decap_8
XFILLER_10_168 VDD VSS sg13g2_decap_8
XFILLER_42_238 VDD VSS sg13g2_decap_8
XFILLER_12_42 VDD VSS sg13g2_decap_8
XFILLER_2_301 VDD VSS sg13g2_decap_8
XFILLER_18_224 VDD VSS sg13g2_decap_8
XFILLER_2_378 VDD VSS sg13g2_decap_8
XFILLER_33_238 VDD VSS sg13g2_decap_8
XFILLER_5_172 VDD VSS sg13g2_decap_8
X_67_ _67_/Y _67_/A1 _66_/X _59_/A VDD VSS sg13g2_a21oi_1
XFILLER_24_238 VDD VSS sg13g2_decap_8
XFILLER_15_238 VDD VSS sg13g2_decap_8
XFILLER_23_63 VDD VSS sg13g2_decap_8
XFILLER_3_0 VDD VSS sg13g2_decap_8
XFILLER_2_175 VDD VSS sg13g2_decap_8
XFILLER_0_56 VDD VSS sg13g2_decap_8
XFILLER_38_308 VDD VSS sg13g2_decap_8
XFILLER_9_21 VDD VSS sg13g2_decap_8
XFILLER_9_98 VDD VSS sg13g2_decap_8
XFILLER_36_0 VDD VSS sg13g2_decap_8
XFILLER_29_308 VDD VSS sg13g2_decap_8
XFILLER_37_385 VDD VSS sg13g2_decap_8
XFILLER_20_252 VDD VSS sg13g2_decap_8
XFILLER_18_63 VDD VSS sg13g2_decap_8
XFILLER_43_322 VDD VSS sg13g2_decap_8
XFILLER_34_84 VDD VSS sg13g2_decap_8
XFILLER_11_252 VDD VSS sg13g2_decap_8
XFILLER_7_245 VDD VSS sg13g2_decap_8
XFILLER_38_105 VDD VSS sg13g2_decap_8
XFILLER_34_322 VDD VSS sg13g2_decap_8
XFILLER_29_105 VDD VSS sg13g2_decap_8
XFILLER_25_322 VDD VSS sg13g2_decap_8
XFILLER_40_336 VDD VSS sg13g2_decap_8
XFILLER_37_182 VDD VSS sg13g2_decap_8
XFILLER_20_42 VDD VSS sg13g2_decap_8
XFILLER_4_259 VDD VSS sg13g2_decap_8
XFILLER_16_322 VDD VSS sg13g2_decap_8
XFILLER_35_119 VDD VSS sg13g2_decap_8
XFILLER_29_84 VDD VSS sg13g2_decap_8
XFILLER_28_182 VDD VSS sg13g2_decap_8
XFILLER_43_196 VDD VSS sg13g2_decap_8
XFILLER_31_336 VDD VSS sg13g2_decap_8
XFILLER_6_77 VDD VSS sg13g2_decap_8
XFILLER_26_119 VDD VSS sg13g2_decap_8
XFILLER_19_182 VDD VSS sg13g2_decap_8
XFILLER_22_347 VDD VSS sg13g2_fill_2
XFILLER_34_196 VDD VSS sg13g2_decap_8
XFILLER_17_119 VDD VSS sg13g2_decap_8
XFILLER_13_336 VDD VSS sg13g2_decap_8
XFILLER_15_42 VDD VSS sg13g2_decap_8
XFILLER_25_196 VDD VSS sg13g2_decap_8
XFILLER_9_329 VDD VSS sg13g2_decap_8
XFILLER_40_133 VDD VSS sg13g2_decap_8
Xoutput6 counter_value_o[3] _71_/Q VDD VSS sg13g2_buf_1
XFILLER_31_63 VDD VSS sg13g2_decap_8
XFILLER_0_273 VDD VSS sg13g2_decap_8
XFILLER_16_196 VDD VSS sg13g2_decap_8
XFILLER_31_133 VDD VSS sg13g2_decap_8
.ends

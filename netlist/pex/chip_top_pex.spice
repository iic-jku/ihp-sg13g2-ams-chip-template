* PEX produced on Tue Mar 24 05:00:16 PM CET 2026 using /foss/tools/sak/sak-pex.sh with m=2 and s=1
* NGSPICE file created from chip_top_pex.ext - technology: ihp-sg13g2

.subckt chip_top_pex bidir_PAD[1] bidir_PAD[0] bidir_PAD[3] bidir_PAD[2]
+ bidir_PAD[8] bidir_PAD[6] bidir_PAD[5] bidir_PAD[4] bidir_PAD[7] input_PAD[3]
+ analog_PAD[6] IOVDD input_PAD[0] input_PAD[2] input_PAD[1] VDD analog_PAD[7]
+ clk_PAD rst_n_PAD input_PAD[5] output_PAD[8] output_PAD[7] analog_PAD[5]
+ output_PAD[6] analog_PAD[4] analog_PAD[3] analog_PAD[2] output_PAD[5]
+ input_PAD[4] output_PAD[4] analog_PAD[1] analog_PAD[0] output_PAD[0]
+ output_PAD[1] output_PAD[2] output_PAD[3] VSS

.ends
